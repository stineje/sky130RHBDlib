* HSPICE file created from NAND2X1.ext - technology: sky130A

.option scale=5m

.subckt NAND2X1 Y A B VDD GND
X0 GND A x1/a_0_0 GND sky130_fd_pr__nfet_01v8 ad=2.39n pd=0.111m as=15.7n ps=0.599m w=602 l=30
X2 Y B x1/a_0_0 GND sky130_fd_pr__nfet_01v8 ad=2.39n pd=0.111m as=15.8n ps=0.594m w=602 l=30
X3 VDD A Y VDD sky130_fd_pr__pfet_01v8 ad=21.6n pd=0.908m as=11.6n ps=0.458m w=400 l=30
X4 Y A VDD VDD sky130_fd_pr__pfet_01v8 ad=11.6n pd=0.458m as=22.4n ps=0.912m w=400 l=30
X5 VDD B Y VDD sky130_fd_pr__pfet_01v8 ad=67.2n pd=2.74m as=46.4n ps=1.83m w=400 l=30
X6 Y B VDD VDD sky130_fd_pr__pfet_01v8 ad=0 pd=0 as=0 ps=0 w=400 l=30
.ends

** hspice subcircuit dictionary
* x1	nand2x_pcell_0/nmos_bottom_0
