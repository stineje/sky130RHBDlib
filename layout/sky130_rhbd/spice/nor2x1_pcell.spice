* HSPICE file created from nor2x1_pcell.ext - technology: sky130A

.option scale=5m

.subckt nor2x1_pcell
X0 w_87_786 a_168_375 a_317_1331 w_87_786 sky130_fd_pr__pfet_01v8 ad=11.6n pd=0.458m as=22.4n ps=0.912m w=400 l=30
X1 a_317_1331 a_168_375 w_87_786 w_87_786 sky130_fd_pr__pfet_01v8 ad=21.6n pd=0.908m as=11.6n ps=0.458m w=400 l=30
X2 a_405_1059 a_362_382 a_317_1331 w_87_786 sky130_fd_pr__pfet_01v8 ad=23.2n pd=0.917m as=67.2n ps=2.74m w=400 l=30
X3 a_317_1331 a_362_382 a_405_1059 w_87_786 sky130_fd_pr__pfet_01v8 ad=0 pd=0 as=0 ps=0 w=400 l=30
X4 a_405_1059 a_168_375 x5/VSUBS x5/VSUBS sky130_fd_pr__nfet_01v8 ad=2.39n pd=0.111m as=15.8n ps=0.594m w=602 l=30
X6 a_405_1059 a_362_382 x5/VSUBS x5/VSUBS sky130_fd_pr__nfet_01v8 ad=2.4n pd=0.112m as=15.8n ps=0.594m w=602 l=30
.ends

** hspice subcircuit dictionary
* x5	pmos2_1_1
