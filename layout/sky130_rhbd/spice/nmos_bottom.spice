* HSPICE file created from nmos_bottom.ext - technology: sky130A

.option scale=5m

.subckt nmos_bottom
X0 a_86_84 a_56_54 a_0_0 VSUBS sky130_fd_pr__nfet_01v8 ad=2.39n pd=0.111m as=15.7n ps=0.599m w=602 l=30
.ends

** hspice subcircuit dictionary
