* HSPICE file created from VOTERN3X1.ext - technology: sky130A

.option scale=5m

.subckt VOTERN3X1 YN A B C VDD GND
X0 x1/VSUBS B x2/a_0_0 x1/VSUBS sky130_fd_pr__nfet_01v8 ad=2.39n pd=0.111m as=15.7n ps=0.599m w=602 l=30
X3 x1/VSUBS B x4/a_0_0 x1/VSUBS sky130_fd_pr__nfet_01v8 ad=43n pd=2.68m as=77.2n ps=2.61m w=602 l=30
X5 x1/VSUBS C x6/a_0_0 x1/VSUBS sky130_fd_pr__nfet_01v8 ad=0 pd=0 as=77.2n ps=2.61m w=602 l=30
X7 x8/a_805_1331 B VDD VDD sky130_fd_pr__pfet_01v8 ad=11.6n pd=0.458m as=22.4n ps=0.912m w=400 l=30
X9 VDD B x8/a_805_1331 VDD sky130_fd_pr__pfet_01v8 ad=21.6n pd=0.908m as=11.6n ps=0.458m w=400 l=30
X10 YN C x4/a_0_0 x1/VSUBS sky130_fd_pr__nfet_01v8 ad=2.39n pd=0.111m as=15.8n ps=0.594m w=602 l=30
X11 x8/a_805_1331 A VDD VDD sky130_fd_pr__pfet_01v8 ad=0.114u pd=4.57m as=67.2n ps=2.74m w=400 l=30
X12 VDD A x8/a_805_1331 VDD sky130_fd_pr__pfet_01v8 ad=0 pd=0 as=0 ps=0 w=400 l=30
X13 x8/a_893_1059 C x8/a_805_1331 VDD sky130_fd_pr__pfet_01v8 ad=0.114u pd=4.57m as=0 ps=0 w=400 l=30
X14 x8/a_805_1331 C x8/a_893_1059 VDD sky130_fd_pr__pfet_01v8 ad=0 pd=0 as=0 ps=0 w=400 l=30
X15 x8/a_893_1059 B x8/a_805_1331 VDD sky130_fd_pr__pfet_01v8 ad=0 pd=0 as=0 ps=0 w=400 l=30
X16 x8/a_805_1331 B x8/a_893_1059 VDD sky130_fd_pr__pfet_01v8 ad=0 pd=0 as=0 ps=0 w=400 l=30
X17 YN C x8/a_893_1059 VDD sky130_fd_pr__pfet_01v8 ad=46.4n pd=1.83m as=0 ps=0 w=400 l=30
X18 x8/a_893_1059 C YN VDD sky130_fd_pr__pfet_01v8 ad=0 pd=0 as=0 ps=0 w=400 l=30
X19 YN A x8/a_893_1059 VDD sky130_fd_pr__pfet_01v8 ad=0 pd=0 as=0 ps=0 w=400 l=30
X20 x8/a_893_1059 A YN VDD sky130_fd_pr__pfet_01v8 ad=0 pd=0 as=0 ps=0 w=400 l=30
X21 YN A x2/a_0_0 x1/VSUBS sky130_fd_pr__nfet_01v8 ad=2.39n pd=0.111m as=15.6n ps=0.592m w=602 l=30
X22 YN A x6/a_0_0 x1/VSUBS sky130_fd_pr__nfet_01v8 ad=2.4n pd=0.112m as=15.8n ps=0.594m w=602 l=30
.ends

** hspice subcircuit dictionary
* x1	votern3x1_pcell_0/pmos2_1_5
* x2	votern3x1_pcell_0/nmos_top_0
* x4	votern3x1_pcell_0/nmos_bottom_1
* x6	votern3x1_pcell_0/nmos_bottom_2
* x8	votern3x1_pcell_0
