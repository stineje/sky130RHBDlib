* HSPICE file created from INVX1.ext - technology: sky130A

.option scale=5m

.subckt INVX1 Y A VDD GND
X0 Y A GND GND sky130_fd_pr__nfet_01v8 ad=2.39n pd=0.111m as=15.6n ps=0.592m w=602 l=30
X1 VDD A Y VDD sky130_fd_pr__pfet_01v8 ad=21.6n pd=0.908m as=11.6n ps=0.458m w=400 l=30
X2 Y A VDD VDD sky130_fd_pr__pfet_01v8 ad=11.6n pd=0.458m as=22.4n ps=0.912m w=400 l=30
.ends

** hspice subcircuit dictionary
