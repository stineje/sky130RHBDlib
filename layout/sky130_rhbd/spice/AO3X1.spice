* HSPICE file created from AO3X1.ext - technology: sky130A

.option scale=5m

.subckt AO3X1 Y A B C VDD GND
X0 Y x1/m1_1201_501 GND GND sky130_fd_pr__nfet_01v8 ad=2.39n pd=0.111m as=15.6n ps=0.592m w=602 l=30
X2 VDD x1/m1_1201_501 Y VDD sky130_fd_pr__pfet_01v8 ad=21.6n pd=0.908m as=11.6n ps=0.458m w=400 l=30
X3 Y x1/m1_1201_501 VDD VDD sky130_fd_pr__pfet_01v8 ad=11.6n pd=0.458m as=22.4n ps=0.912m w=400 l=30
X4 GND A x5/a_0_0 GND sky130_fd_pr__nfet_01v8 ad=2.39n pd=0.111m as=15.7n ps=0.599m w=602 l=30
X6 x7/m1_537_501 B x5/a_0_0 GND sky130_fd_pr__nfet_01v8 ad=2.39n pd=0.111m as=15.8n ps=0.594m w=602 l=30
X8 VDD A x7/m1_537_501 VDD sky130_fd_pr__pfet_01v8 ad=0.134u pd=5.47m as=46.4n ps=1.83m w=400 l=30
X9 x7/m1_537_501 A VDD VDD sky130_fd_pr__pfet_01v8 ad=0 pd=0 as=0 ps=0 w=400 l=30
X10 VDD B x7/m1_537_501 VDD sky130_fd_pr__pfet_01v8 ad=0 pd=0 as=0 ps=0 w=400 l=30
X11 x7/m1_537_501 B VDD VDD sky130_fd_pr__pfet_01v8 ad=0 pd=0 as=0 ps=0 w=400 l=30
X12 VDD x7/m1_537_501 x13/a_317_1331 VDD sky130_fd_pr__pfet_01v8 ad=11.6n pd=0.458m as=22.4n ps=0.912m w=400 l=30
X14 x13/a_317_1331 x7/m1_537_501 VDD VDD sky130_fd_pr__pfet_01v8 ad=21.6n pd=0.908m as=11.6n ps=0.458m w=400 l=30
X15 x1/m1_1201_501 C x13/a_317_1331 VDD sky130_fd_pr__pfet_01v8 ad=23.2n pd=0.917m as=67.2n ps=2.74m w=400 l=30
X16 x13/a_317_1331 C x1/m1_1201_501 VDD sky130_fd_pr__pfet_01v8 ad=0 pd=0 as=0 ps=0 w=400 l=30
X17 x1/m1_1201_501 x7/m1_537_501 GND GND sky130_fd_pr__nfet_01v8 ad=14.3n pd=0.63m as=0.137u ps=4.93m w=602 l=30
X18 x1/m1_1201_501 C GND GND sky130_fd_pr__nfet_01v8 ad=2.4n pd=0.112m as=15.8n ps=0.594m w=602 l=30
.ends

** hspice subcircuit dictionary
* x1	ao3x1_pcell_0
* x5	ao3x1_pcell_0/aoi3x1_pcell_0/nand2x1_pcell_0/nmos_bottom_0
* x7	ao3x1_pcell_0/aoi3x1_pcell_0
* x13	ao3x1_pcell_0/aoi3x1_pcell_0/nor2x1_pcell_0
