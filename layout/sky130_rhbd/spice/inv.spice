* HSPICE file created from inv.ext - technology: sky130A

.option scale=5m

.subckt inv Y A GND VDD
X0 Y A a_n73_n41 a_n73_n41 sky130_fd_pr__nfet_01v8 ad=5.12n pd=0.29m as=6.13n ps=0.314m w=84 l=30
X1 Y A w_n100_161 w_n100_161 sky130_fd_pr__pfet_01v8 ad=4.79n pd=0.282m as=4.79n ps=0.282m w=84 l=30
.ends

** hspice subcircuit dictionary
