* HSPICE file created from TIEHI.ext - technology: sky130A

.option scale=5m

.subckt TIEHI Y VDD GND
X0 a_253_417 a_253_417 GND GND sky130_fd_pr__nfet_01v8 ad=2.39n pd=0.111m as=15.6n ps=0.592m w=602 l=30
X1 VDD a_253_417 Y VDD sky130_fd_pr__pfet_01v8 ad=21.6n pd=0.908m as=11.6n ps=0.458m w=400 l=30
X2 Y a_253_417 VDD VDD sky130_fd_pr__pfet_01v8 ad=11.6n pd=0.458m as=22.4n ps=0.912m w=400 l=30
.ends

** hspice subcircuit dictionary
