* HSPICE file created from FILL1.ext - technology: sky130A

.option scale=5m

.subckt FILL1 VDD GND
.ends

** hspice subcircuit dictionary
