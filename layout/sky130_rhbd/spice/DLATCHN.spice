* HSPICE file created from DLATCHN.ext - technology: sky130A

.option scale=5m

.subckt DLATCHN Q D GATE_N VDD GND
X0 m1_891_759 D x1/VSUBS x1/VSUBS sky130_fd_pr__nfet_01v8 ad=2.39n pd=0.111m as=15.6n ps=0.592m w=602 l=30
X2 VDD D m1_891_759 VDD sky130_fd_pr__pfet_01v8 ad=21.6n pd=0.908m as=11.6n ps=0.458m w=400 l=30
X3 m1_891_759 D VDD VDD sky130_fd_pr__pfet_01v8 ad=11.6n pd=0.458m as=22.4n ps=0.912m w=400 l=30
X4 m1_447_611 GATE_N x5/VSUBS x5/VSUBS sky130_fd_pr__nfet_01v8 ad=1p pd=-87u as=45.6n ps=1.62m w=602 l=30
X6 VDD GATE_N m1_447_611 VDD sky130_fd_pr__pfet_01v8 ad=0.357u pd=0.0146 as=23.2n ps=0.917m w=400 l=30
X7 m1_447_611 GATE_N VDD VDD sky130_fd_pr__pfet_01v8 ad=0 pd=0 as=0 ps=0 w=400 l=30
X8 m1_2001_759 x9/m1_547_649 GND GND sky130_fd_pr__nfet_01v8 ad=7.16n pd=0.314m as=60n ps=2.34m w=602 l=30
X10 VDD x9/m1_547_649 m1_2001_759 VDD sky130_fd_pr__pfet_01v8 ad=0 pd=0 as=23.2n ps=0.917m w=400 l=30
X11 m1_2001_759 x9/m1_547_649 VDD VDD sky130_fd_pr__pfet_01v8 ad=0 pd=0 as=0 ps=0 w=400 l=30
X12 GND m1_891_759 x13/a_0_0 GND sky130_fd_pr__nfet_01v8 ad=2.39n pd=0.111m as=15.7n ps=0.599m w=602 l=30
X14 x9/m1_547_649 m1_447_611 x13/a_0_0 GND sky130_fd_pr__nfet_01v8 ad=2.39n pd=0.111m as=15.8n ps=0.594m w=602 l=30
X15 VDD m1_891_759 x9/m1_547_649 VDD sky130_fd_pr__pfet_01v8 ad=0 pd=0 as=46.4n ps=1.83m w=400 l=30
X16 x9/m1_547_649 m1_891_759 VDD VDD sky130_fd_pr__pfet_01v8 ad=0 pd=0 as=0 ps=0 w=400 l=30
X17 VDD m1_447_611 x9/m1_547_649 VDD sky130_fd_pr__pfet_01v8 ad=0 pd=0 as=0 ps=0 w=400 l=30
X18 x9/m1_547_649 m1_447_611 VDD VDD sky130_fd_pr__pfet_01v8 ad=0 pd=0 as=0 ps=0 w=400 l=30
X19 m1_3111_833 x20/m1_547_649 x20/VSUBS x20/VSUBS sky130_fd_pr__nfet_01v8 ad=7.16n pd=0.314m as=60n ps=2.34m w=602 l=30
X21 VDD x20/m1_547_649 m1_3111_833 VDD sky130_fd_pr__pfet_01v8 ad=0 pd=0 as=23.2n ps=0.917m w=400 l=30
X22 m1_3111_833 x20/m1_547_649 VDD VDD sky130_fd_pr__pfet_01v8 ad=0 pd=0 as=0 ps=0 w=400 l=30
X23 x20/VSUBS m1_447_611 x24/a_0_0 x20/VSUBS sky130_fd_pr__nfet_01v8 ad=0 pd=0 as=77.2n ps=2.61m w=602 l=30
X25 x20/m1_547_649 D x24/a_0_0 x20/VSUBS sky130_fd_pr__nfet_01v8 ad=7.16n pd=0.314m as=0 ps=0 w=602 l=30
X26 VDD m1_447_611 x20/m1_547_649 VDD sky130_fd_pr__pfet_01v8 ad=0 pd=0 as=46.4n ps=1.83m w=400 l=30
X27 x20/m1_547_649 m1_447_611 VDD VDD sky130_fd_pr__pfet_01v8 ad=0 pd=0 as=0 ps=0 w=400 l=30
X28 VDD D x20/m1_547_649 VDD sky130_fd_pr__pfet_01v8 ad=0 pd=0 as=0 ps=0 w=400 l=30
X29 x20/m1_547_649 D VDD VDD sky130_fd_pr__pfet_01v8 ad=0 pd=0 as=0 ps=0 w=400 l=30
X30 VDD m1_2001_759 x31/a_317_1331 VDD sky130_fd_pr__pfet_01v8 ad=11.6n pd=0.458m as=22.4n ps=0.912m w=400 l=30
X32 x31/a_317_1331 m1_2001_759 VDD VDD sky130_fd_pr__pfet_01v8 ad=21.6n pd=0.908m as=11.6n ps=0.458m w=400 l=30
X33 Q m1_3629_759 x31/a_317_1331 VDD sky130_fd_pr__pfet_01v8 ad=2p pd=2u as=67.2n ps=2.74m w=400 l=30
X34 x31/a_317_1331 m1_3629_759 Q VDD sky130_fd_pr__pfet_01v8 ad=0 pd=0 as=0 ps=0 w=400 l=30
X35 Q m1_2001_759 x36/VSUBS x36/VSUBS sky130_fd_pr__nfet_01v8 ad=1p pd=-0.869m as=77.5n ps=2.59m w=602 l=30
X37 Q m1_3629_759 x36/VSUBS x36/VSUBS sky130_fd_pr__nfet_01v8 ad=2.4n pd=0.112m as=15.8n ps=0.594m w=602 l=30
X38 VDD Q x39/a_317_1331 VDD sky130_fd_pr__pfet_01v8 ad=0 pd=0 as=67.2n ps=2.74m w=400 l=30
X40 x39/a_317_1331 Q VDD VDD sky130_fd_pr__pfet_01v8 ad=0 pd=0 as=0 ps=0 w=400 l=30
X41 m1_3629_759 m1_3111_833 x39/a_317_1331 VDD sky130_fd_pr__pfet_01v8 ad=46.4n pd=1.83m as=0 ps=0 w=400 l=30
X42 x39/a_317_1331 m1_3111_833 m1_3629_759 VDD sky130_fd_pr__pfet_01v8 ad=0 pd=0 as=0 ps=0 w=400 l=30
X43 m1_3629_759 Q x44/VSUBS x44/VSUBS sky130_fd_pr__nfet_01v8 ad=28.7n pd=2.13m as=77.5n ps=2.59m w=602 l=30
X45 m1_3629_759 m1_3111_833 x44/VSUBS x44/VSUBS sky130_fd_pr__nfet_01v8 ad=0 pd=0 as=0 ps=0 w=602 l=30
.ends

** hspice subcircuit dictionary
* x1	invx1_pcell_0/pmos2_0
* x5	li1_M1_contact_5
* x9	and2x1_pcell_0
* x13	and2x1_pcell_0/nand2x1_pcell_0/nmos_bottom_0
* x20	and2x1_pcell_1
* x24	and2x1_pcell_1/nand2x1_pcell_0/nmos_bottom_0
* x31	nor2x1_pcell_0
* x36	nor2x1_pcell_0/pmos2_1_1
* x39	nor2x1_pcell_1
* x44	li1_M1_contact_8
