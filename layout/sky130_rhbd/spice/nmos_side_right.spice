* HSPICE file created from nmos_side_right.ext - technology: sky130A

.option scale=5m

.subckt nmos_side_right
X0 a_87_91 a_57_61 a_0_0 VSUBS sky130_fd_pr__nfet_01v8 ad=2.18n pd=0.106m as=16.2n ps=0.604m w=600 l=30
.ends

** hspice subcircuit dictionary
