* HSPICE file created from aoai4x1_pcell.ext - technology: sky130A

.option scale=5m

.subckt aoai4x1_pcell
X0 VSUBS x1/a_168_375 x2/a_0_0 VSUBS sky130_fd_pr__nfet_01v8 ad=2.39n pd=0.111m as=15.7n ps=0.599m w=602 l=30
X3 m1_537_501 x1/a_362_382 x2/a_0_0 VSUBS sky130_fd_pr__nfet_01v8 ad=2.39n pd=0.111m as=15.8n ps=0.594m w=602 l=30
X4 x5/w_87_786 x1/a_168_375 m1_537_501 x5/w_87_786 sky130_fd_pr__pfet_01v8 ad=21.6n pd=0.908m as=11.6n ps=0.458m w=400 l=30
X6 m1_537_501 x1/a_168_375 x5/w_87_786 x5/w_87_786 sky130_fd_pr__pfet_01v8 ad=11.6n pd=0.458m as=22.4n ps=0.912m w=400 l=30
X7 x5/w_87_786 x1/a_362_382 m1_537_501 x5/w_87_786 sky130_fd_pr__pfet_01v8 ad=0.158u pd=6.39m as=46.4n ps=1.83m w=400 l=30
X8 m1_537_501 x1/a_362_382 x5/w_87_786 x5/w_87_786 sky130_fd_pr__pfet_01v8 ad=0 pd=0 as=0 ps=0 w=400 l=30
X9 x5/w_87_786 m1_537_501 x5/a_317_1331 x5/w_87_786 sky130_fd_pr__pfet_01v8 ad=11.6n pd=0.458m as=22.4n ps=0.912m w=400 l=30
X10 x5/a_317_1331 m1_537_501 x5/w_87_786 x5/w_87_786 sky130_fd_pr__pfet_01v8 ad=21.6n pd=0.908m as=11.6n ps=0.458m w=400 l=30
X11 m1_1203_501 x5/a_362_382 x5/a_317_1331 x5/w_87_786 sky130_fd_pr__pfet_01v8 ad=23.2n pd=0.917m as=67.2n ps=2.74m w=400 l=30
X12 x5/a_317_1331 x5/a_362_382 m1_1203_501 x5/w_87_786 sky130_fd_pr__pfet_01v8 ad=0 pd=0 as=0 ps=0 w=400 l=30
X13 m1_1203_501 m1_537_501 VSUBS VSUBS sky130_fd_pr__nfet_01v8 ad=7.16n pd=0.229m as=0.106u ps=4.02m w=602 l=30
X14 m1_1203_501 x5/a_362_382 VSUBS VSUBS sky130_fd_pr__nfet_01v8 ad=2.4n pd=0.112m as=15.8n ps=0.594m w=602 l=30
X15 VSUBS m1_1203_501 x16/a_0_0 VSUBS sky130_fd_pr__nfet_01v8 ad=0 pd=0 as=77.2n ps=2.61m w=602 l=30
X17 x18/a_229_1059 x18/a_362_382 x16/a_0_0 VSUBS sky130_fd_pr__nfet_01v8 ad=7.16n pd=0.314m as=0 ps=0 w=602 l=30
X19 x5/w_87_786 m1_1203_501 x18/a_229_1059 x5/w_87_786 sky130_fd_pr__pfet_01v8 ad=0 pd=0 as=46.4n ps=1.83m w=400 l=30
X20 x18/a_229_1059 m1_1203_501 x5/w_87_786 x5/w_87_786 sky130_fd_pr__pfet_01v8 ad=0 pd=0 as=0 ps=0 w=400 l=30
X21 x5/w_87_786 x18/a_362_382 x18/a_229_1059 x5/w_87_786 sky130_fd_pr__pfet_01v8 ad=0 pd=0 as=0 ps=0 w=400 l=30
X22 x18/a_229_1059 x18/a_362_382 x5/w_87_786 x5/w_87_786 sky130_fd_pr__pfet_01v8 ad=0 pd=0 as=0 ps=0 w=400 l=30
.ends

** hspice subcircuit dictionary
* x1	nand2x1_pcell_0
* x2	nand2x1_pcell_0/nmos_bottom_0
* x5	nor2x1_pcell_0
* x16	nand2x1_pcell_1/nmos_bottom_0
* x18	nand2x1_pcell_1
