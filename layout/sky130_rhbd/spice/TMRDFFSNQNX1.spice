* HSPICE file created from TMRDFFSNQNX1.ext - technology: sky130A

.option scale=5m

.subckt TMRDFFSNQNX1 QN D CLK SN VDD GND
X0 GND m1_13659_907 x1/a_0_0 GND sky130_fd_pr__nfet_01v8 ad=2.39n pd=0.111m as=15.7n ps=0.599m w=602 l=30
X2 GND m1_13659_907 x3/a_0_0 GND sky130_fd_pr__nfet_01v8 ad=0.301u pd=0.0156 as=77.2n ps=2.61m w=602 l=30
X4 GND m1_4250_685 x5/a_0_0 GND sky130_fd_pr__nfet_01v8 ad=0 pd=0 as=77.2n ps=2.61m w=602 l=30
X6 x7/a_805_1331 m1_13659_907 VDD VDD sky130_fd_pr__pfet_01v8 ad=11.6n pd=0.458m as=22.4n ps=0.912m w=400 l=30
X8 VDD m1_13659_907 x7/a_805_1331 VDD sky130_fd_pr__pfet_01v8 ad=21.6n pd=0.908m as=11.6n ps=0.458m w=400 l=30
X9 QN m1_4250_685 x3/a_0_0 GND sky130_fd_pr__nfet_01v8 ad=2.39n pd=0.111m as=15.8n ps=0.594m w=602 l=30
X10 x7/a_805_1331 m1_9154_537 VDD VDD sky130_fd_pr__pfet_01v8 ad=0.114u pd=4.57m as=1.49u ps=0.0602 w=400 l=30
X11 VDD m1_9154_537 x7/a_805_1331 VDD sky130_fd_pr__pfet_01v8 ad=0 pd=0 as=0 ps=0 w=400 l=30
X12 x7/a_893_1059 m1_4250_685 x7/a_805_1331 VDD sky130_fd_pr__pfet_01v8 ad=0.114u pd=4.57m as=0 ps=0 w=400 l=30
X13 x7/a_805_1331 m1_4250_685 x7/a_893_1059 VDD sky130_fd_pr__pfet_01v8 ad=0 pd=0 as=0 ps=0 w=400 l=30
X14 x7/a_893_1059 m1_13659_907 x7/a_805_1331 VDD sky130_fd_pr__pfet_01v8 ad=0 pd=0 as=0 ps=0 w=400 l=30
X15 x7/a_805_1331 m1_13659_907 x7/a_893_1059 VDD sky130_fd_pr__pfet_01v8 ad=0 pd=0 as=0 ps=0 w=400 l=30
X16 QN m1_4250_685 x7/a_893_1059 VDD sky130_fd_pr__pfet_01v8 ad=46.4n pd=1.83m as=0 ps=0 w=400 l=30
X17 x7/a_893_1059 m1_4250_685 QN VDD sky130_fd_pr__pfet_01v8 ad=0 pd=0 as=0 ps=0 w=400 l=30
X18 QN m1_9154_537 x7/a_893_1059 VDD sky130_fd_pr__pfet_01v8 ad=0 pd=0 as=0 ps=0 w=400 l=30
X19 x7/a_893_1059 m1_9154_537 QN VDD sky130_fd_pr__pfet_01v8 ad=0 pd=0 as=0 ps=0 w=400 l=30
X20 QN m1_9154_537 x1/a_0_0 GND sky130_fd_pr__nfet_01v8 ad=2.39n pd=0.111m as=15.6n ps=0.592m w=602 l=30
X21 QN m1_9154_537 x5/a_0_0 GND sky130_fd_pr__nfet_01v8 ad=2.4n pd=0.112m as=15.8n ps=0.594m w=602 l=30
X22 GND x23/m1_406_797 x24/a_0_0 GND sky130_fd_pr__nfet_01v8 ad=0 pd=0 as=77.2n ps=2.61m w=602 l=30
X25 m1_4250_685 m1_3704_833 x24/a_0_0 GND sky130_fd_pr__nfet_01v8 ad=-7.16n pd=-0.664m as=0 ps=0 w=602 l=30
X26 VDD x23/m1_406_797 m1_4250_685 VDD sky130_fd_pr__pfet_01v8 ad=21.6n pd=0.908m as=11.6n ps=0.458m w=400 l=30
X27 m1_4250_685 x23/m1_406_797 VDD VDD sky130_fd_pr__pfet_01v8 ad=11.6n pd=0.458m as=22.4n ps=0.912m w=400 l=30
X28 VDD m1_3704_833 m1_4250_685 VDD sky130_fd_pr__pfet_01v8 ad=0 pd=0 as=46.4n ps=1.83m w=400 l=30
X29 m1_4250_685 m1_3704_833 VDD VDD sky130_fd_pr__pfet_01v8 ad=0 pd=0 as=0 ps=0 w=400 l=30
X30 GND D x31/a_0_0 GND sky130_fd_pr__nfet_01v8 ad=0 pd=0 as=77.2n ps=2.61m w=602 l=30
X32 x23/m1_537_501 x23/m1_406_797 x31/a_0_0 GND sky130_fd_pr__nfet_01v8 ad=-7.16n pd=-0.488m as=0 ps=0 w=602 l=30
X33 VDD D x23/m1_537_501 VDD sky130_fd_pr__pfet_01v8 ad=0 pd=0 as=46.4n ps=1.83m w=400 l=30
X34 x23/m1_537_501 D VDD VDD sky130_fd_pr__pfet_01v8 ad=0 pd=0 as=0 ps=0 w=400 l=30
X35 VDD x23/m1_406_797 x23/m1_537_501 VDD sky130_fd_pr__pfet_01v8 ad=0 pd=0 as=0 ps=0 w=400 l=30
X36 x23/m1_537_501 x23/m1_406_797 VDD VDD sky130_fd_pr__pfet_01v8 ad=0 pd=0 as=0 ps=0 w=400 l=30
X37 GND x23/m1_537_501 x38/a_0_0 GND sky130_fd_pr__nfet_01v8 ad=0 pd=0 as=78.2n ps=2.61m w=602 l=30
X39 x23/m1_406_797 x23/m1_1351_723 x40/li_393_182 GND sky130_fd_pr__nfet_01v8 ad=1p pd=-87u as=52.7n ps=1.92m w=602 l=30
X41 x40/li_393_182 CLK x38/a_0_0 GND sky130_fd_pr__nfet_01v8 ad=2.18n pd=0.106m as=16.2n ps=0.604m w=600 l=30
X42 VDD x23/m1_537_501 x23/m1_406_797 VDD sky130_fd_pr__pfet_01v8 ad=0 pd=0 as=69.6n ps=2.75m w=400 l=30
X43 x23/m1_406_797 x23/m1_537_501 VDD VDD sky130_fd_pr__pfet_01v8 ad=0 pd=0 as=0 ps=0 w=400 l=30
X44 VDD CLK x23/m1_406_797 VDD sky130_fd_pr__pfet_01v8 ad=0 pd=0 as=0 ps=0 w=400 l=30
X45 x23/m1_406_797 CLK VDD VDD sky130_fd_pr__pfet_01v8 ad=0 pd=0 as=0 ps=0 w=400 l=30
X46 VDD x23/m1_1351_723 x23/m1_406_797 VDD sky130_fd_pr__pfet_01v8 ad=0 pd=0 as=0 ps=0 w=400 l=30
X47 x23/m1_406_797 x23/m1_1351_723 VDD VDD sky130_fd_pr__pfet_01v8 ad=0 pd=0 as=0 ps=0 w=400 l=30
X48 GND m1_4250_685 x49/a_0_0 GND sky130_fd_pr__nfet_01v8 ad=0 pd=0 as=78.2n ps=2.61m w=602 l=30
X50 m1_3704_833 x23/m1_1351_723 x51/li_393_182 GND sky130_fd_pr__nfet_01v8 ad=7.16n pd=0.314m as=52.7n ps=1.92m w=602 l=30
X52 x51/li_393_182 SN x49/a_0_0 GND sky130_fd_pr__nfet_01v8 ad=0 pd=0 as=0 ps=0 w=600 l=30
X53 VDD m1_4250_685 m1_3704_833 VDD sky130_fd_pr__pfet_01v8 ad=0 pd=0 as=69.6n ps=2.75m w=400 l=30
X54 m1_3704_833 m1_4250_685 VDD VDD sky130_fd_pr__pfet_01v8 ad=0 pd=0 as=0 ps=0 w=400 l=30
X55 VDD SN m1_3704_833 VDD sky130_fd_pr__pfet_01v8 ad=0 pd=0 as=0 ps=0 w=400 l=30
X56 m1_3704_833 SN VDD VDD sky130_fd_pr__pfet_01v8 ad=0 pd=0 as=0 ps=0 w=400 l=30
X57 VDD x23/m1_1351_723 m1_3704_833 VDD sky130_fd_pr__pfet_01v8 ad=0 pd=0 as=0 ps=0 w=400 l=30
X58 m1_3704_833 x23/m1_1351_723 VDD VDD sky130_fd_pr__pfet_01v8 ad=0 pd=0 as=0 ps=0 w=400 l=30
X59 GND x23/m1_537_501 x60/a_0_0 GND sky130_fd_pr__nfet_01v8 ad=0 pd=0 as=78.2n ps=2.61m w=602 l=30
X61 x23/m1_2461_501 x23/m1_1351_723 x62/li_393_182 GND sky130_fd_pr__nfet_01v8 ad=1p pd=-87u as=52.7n ps=1.92m w=602 l=30
X63 x62/li_393_182 SN x60/a_0_0 GND sky130_fd_pr__nfet_01v8 ad=0 pd=0 as=0 ps=0 w=600 l=30
X64 VDD x23/m1_537_501 x23/m1_2461_501 VDD sky130_fd_pr__pfet_01v8 ad=0 pd=0 as=69.6n ps=2.75m w=400 l=30
X65 x23/m1_2461_501 x23/m1_537_501 VDD VDD sky130_fd_pr__pfet_01v8 ad=0 pd=0 as=0 ps=0 w=400 l=30
X66 VDD SN x23/m1_2461_501 VDD sky130_fd_pr__pfet_01v8 ad=0 pd=0 as=0 ps=0 w=400 l=30
X67 x23/m1_2461_501 SN VDD VDD sky130_fd_pr__pfet_01v8 ad=0 pd=0 as=0 ps=0 w=400 l=30
X68 VDD x23/m1_1351_723 x23/m1_2461_501 VDD sky130_fd_pr__pfet_01v8 ad=0 pd=0 as=0 ps=0 w=400 l=30
X69 x23/m1_2461_501 x23/m1_1351_723 VDD VDD sky130_fd_pr__pfet_01v8 ad=0 pd=0 as=0 ps=0 w=400 l=30
X70 GND x23/m1_2461_501 x71/a_0_0 GND sky130_fd_pr__nfet_01v8 ad=0 pd=0 as=77.2n ps=2.61m w=602 l=30
X72 x23/m1_1351_723 CLK x71/a_0_0 GND sky130_fd_pr__nfet_01v8 ad=7.16n pd=0.314m as=0 ps=0 w=602 l=30
X73 VDD x23/m1_2461_501 x23/m1_1351_723 VDD sky130_fd_pr__pfet_01v8 ad=0 pd=0 as=46.4n ps=1.83m w=400 l=30
X74 x23/m1_1351_723 x23/m1_2461_501 VDD VDD sky130_fd_pr__pfet_01v8 ad=0 pd=0 as=0 ps=0 w=400 l=30
X75 VDD CLK x23/m1_1351_723 VDD sky130_fd_pr__pfet_01v8 ad=0 pd=0 as=0 ps=0 w=400 l=30
X76 x23/m1_1351_723 CLK VDD VDD sky130_fd_pr__pfet_01v8 ad=0 pd=0 as=0 ps=0 w=400 l=30
X77 GND x78/m1_406_797 x79/a_0_0 GND sky130_fd_pr__nfet_01v8 ad=0 pd=0 as=77.2n ps=2.61m w=602 l=30
X80 m1_9154_537 m1_8620_833 x79/a_0_0 GND sky130_fd_pr__nfet_01v8 ad=1p pd=-87u as=0 ps=0 w=602 l=30
X81 VDD x78/m1_406_797 m1_9154_537 VDD sky130_fd_pr__pfet_01v8 ad=0 pd=0 as=46.4n ps=1.83m w=400 l=30
X82 m1_9154_537 x78/m1_406_797 VDD VDD sky130_fd_pr__pfet_01v8 ad=0 pd=0 as=0 ps=0 w=400 l=30
X83 VDD m1_8620_833 m1_9154_537 VDD sky130_fd_pr__pfet_01v8 ad=0 pd=0 as=0 ps=0 w=400 l=30
X84 m1_9154_537 m1_8620_833 VDD VDD sky130_fd_pr__pfet_01v8 ad=0 pd=0 as=0 ps=0 w=400 l=30
X85 GND D x86/a_0_0 GND sky130_fd_pr__nfet_01v8 ad=0 pd=0 as=77.2n ps=2.61m w=602 l=30
X87 x78/m1_537_501 x78/m1_406_797 x86/a_0_0 GND sky130_fd_pr__nfet_01v8 ad=-7.16n pd=-0.488m as=0 ps=0 w=602 l=30
X88 VDD D x78/m1_537_501 VDD sky130_fd_pr__pfet_01v8 ad=0 pd=0 as=46.4n ps=1.83m w=400 l=30
X89 x78/m1_537_501 D VDD VDD sky130_fd_pr__pfet_01v8 ad=0 pd=0 as=0 ps=0 w=400 l=30
X90 VDD x78/m1_406_797 x78/m1_537_501 VDD sky130_fd_pr__pfet_01v8 ad=0 pd=0 as=0 ps=0 w=400 l=30
X91 x78/m1_537_501 x78/m1_406_797 VDD VDD sky130_fd_pr__pfet_01v8 ad=0 pd=0 as=0 ps=0 w=400 l=30
X92 GND x78/m1_537_501 x93/a_0_0 GND sky130_fd_pr__nfet_01v8 ad=0 pd=0 as=78.2n ps=2.61m w=602 l=30
X94 x78/m1_406_797 x78/m1_1351_723 x95/li_393_182 GND sky130_fd_pr__nfet_01v8 ad=1p pd=-87u as=52.7n ps=1.92m w=602 l=30
X96 x95/li_393_182 CLK x93/a_0_0 GND sky130_fd_pr__nfet_01v8 ad=0 pd=0 as=0 ps=0 w=600 l=30
X97 VDD x78/m1_537_501 x78/m1_406_797 VDD sky130_fd_pr__pfet_01v8 ad=0 pd=0 as=69.6n ps=2.75m w=400 l=30
X98 x78/m1_406_797 x78/m1_537_501 VDD VDD sky130_fd_pr__pfet_01v8 ad=0 pd=0 as=0 ps=0 w=400 l=30
X99 VDD CLK x78/m1_406_797 VDD sky130_fd_pr__pfet_01v8 ad=0 pd=0 as=0 ps=0 w=400 l=30
X100 x78/m1_406_797 CLK VDD VDD sky130_fd_pr__pfet_01v8 ad=0 pd=0 as=0 ps=0 w=400 l=30
X101 VDD x78/m1_1351_723 x78/m1_406_797 VDD sky130_fd_pr__pfet_01v8 ad=0 pd=0 as=0 ps=0 w=400 l=30
X102 x78/m1_406_797 x78/m1_1351_723 VDD VDD sky130_fd_pr__pfet_01v8 ad=0 pd=0 as=0 ps=0 w=400 l=30
X103 GND m1_9154_537 x104/a_0_0 GND sky130_fd_pr__nfet_01v8 ad=0 pd=0 as=78.2n ps=2.61m w=602 l=30
X105 m1_8620_833 x78/m1_1351_723 x106/li_393_182 GND sky130_fd_pr__nfet_01v8 ad=7.16n pd=0.314m as=52.7n ps=1.92m w=602 l=30
X107 x106/li_393_182 SN x104/a_0_0 GND sky130_fd_pr__nfet_01v8 ad=0 pd=0 as=0 ps=0 w=600 l=30
X108 VDD m1_9154_537 m1_8620_833 VDD sky130_fd_pr__pfet_01v8 ad=0 pd=0 as=69.6n ps=2.75m w=400 l=30
X109 m1_8620_833 m1_9154_537 VDD VDD sky130_fd_pr__pfet_01v8 ad=0 pd=0 as=0 ps=0 w=400 l=30
X110 VDD SN m1_8620_833 VDD sky130_fd_pr__pfet_01v8 ad=0 pd=0 as=0 ps=0 w=400 l=30
X111 m1_8620_833 SN VDD VDD sky130_fd_pr__pfet_01v8 ad=0 pd=0 as=0 ps=0 w=400 l=30
X112 VDD x78/m1_1351_723 m1_8620_833 VDD sky130_fd_pr__pfet_01v8 ad=0 pd=0 as=0 ps=0 w=400 l=30
X113 m1_8620_833 x78/m1_1351_723 VDD VDD sky130_fd_pr__pfet_01v8 ad=0 pd=0 as=0 ps=0 w=400 l=30
X114 GND x78/m1_537_501 x115/a_0_0 GND sky130_fd_pr__nfet_01v8 ad=0 pd=0 as=78.2n ps=2.61m w=602 l=30
X116 x78/m1_2461_501 x78/m1_1351_723 x117/li_393_182 GND sky130_fd_pr__nfet_01v8 ad=1p pd=-87u as=52.7n ps=1.92m w=602 l=30
X118 x117/li_393_182 SN x115/a_0_0 GND sky130_fd_pr__nfet_01v8 ad=0 pd=0 as=0 ps=0 w=600 l=30
X119 VDD x78/m1_537_501 x78/m1_2461_501 VDD sky130_fd_pr__pfet_01v8 ad=0 pd=0 as=69.6n ps=2.75m w=400 l=30
X120 x78/m1_2461_501 x78/m1_537_501 VDD VDD sky130_fd_pr__pfet_01v8 ad=0 pd=0 as=0 ps=0 w=400 l=30
X121 VDD SN x78/m1_2461_501 VDD sky130_fd_pr__pfet_01v8 ad=0 pd=0 as=0 ps=0 w=400 l=30
X122 x78/m1_2461_501 SN VDD VDD sky130_fd_pr__pfet_01v8 ad=0 pd=0 as=0 ps=0 w=400 l=30
X123 VDD x78/m1_1351_723 x78/m1_2461_501 VDD sky130_fd_pr__pfet_01v8 ad=0 pd=0 as=0 ps=0 w=400 l=30
X124 x78/m1_2461_501 x78/m1_1351_723 VDD VDD sky130_fd_pr__pfet_01v8 ad=0 pd=0 as=0 ps=0 w=400 l=30
X125 GND x78/m1_2461_501 x126/a_0_0 GND sky130_fd_pr__nfet_01v8 ad=0 pd=0 as=77.2n ps=2.61m w=602 l=30
X127 x78/m1_1351_723 CLK x126/a_0_0 GND sky130_fd_pr__nfet_01v8 ad=7.16n pd=0.314m as=0 ps=0 w=602 l=30
X128 VDD x78/m1_2461_501 x78/m1_1351_723 VDD sky130_fd_pr__pfet_01v8 ad=0 pd=0 as=46.4n ps=1.83m w=400 l=30
X129 x78/m1_1351_723 x78/m1_2461_501 VDD VDD sky130_fd_pr__pfet_01v8 ad=0 pd=0 as=0 ps=0 w=400 l=30
X130 VDD CLK x78/m1_1351_723 VDD sky130_fd_pr__pfet_01v8 ad=0 pd=0 as=0 ps=0 w=400 l=30
X131 x78/m1_1351_723 CLK VDD VDD sky130_fd_pr__pfet_01v8 ad=0 pd=0 as=0 ps=0 w=400 l=30
X132 GND x133/m1_406_797 x134/a_0_0 GND sky130_fd_pr__nfet_01v8 ad=0 pd=0 as=77.2n ps=2.61m w=602 l=30
X135 m1_13659_907 m1_13511_833 x134/a_0_0 GND sky130_fd_pr__nfet_01v8 ad=-14.3n pd=-1.24m as=0 ps=0 w=602 l=30
X136 VDD x133/m1_406_797 m1_13659_907 VDD sky130_fd_pr__pfet_01v8 ad=0 pd=0 as=46.4n ps=1.83m w=400 l=30
X137 m1_13659_907 x133/m1_406_797 VDD VDD sky130_fd_pr__pfet_01v8 ad=0 pd=0 as=0 ps=0 w=400 l=30
X138 VDD m1_13511_833 m1_13659_907 VDD sky130_fd_pr__pfet_01v8 ad=0 pd=0 as=0 ps=0 w=400 l=30
X139 m1_13659_907 m1_13511_833 VDD VDD sky130_fd_pr__pfet_01v8 ad=0 pd=0 as=0 ps=0 w=400 l=30
X140 GND D x141/a_0_0 GND sky130_fd_pr__nfet_01v8 ad=0 pd=0 as=77.2n ps=2.61m w=602 l=30
X142 x133/m1_537_501 x133/m1_406_797 x141/a_0_0 GND sky130_fd_pr__nfet_01v8 ad=-7.16n pd=-0.488m as=0 ps=0 w=602 l=30
X143 VDD D x133/m1_537_501 VDD sky130_fd_pr__pfet_01v8 ad=0 pd=0 as=46.4n ps=1.83m w=400 l=30
X144 x133/m1_537_501 D VDD VDD sky130_fd_pr__pfet_01v8 ad=0 pd=0 as=0 ps=0 w=400 l=30
X145 VDD x133/m1_406_797 x133/m1_537_501 VDD sky130_fd_pr__pfet_01v8 ad=0 pd=0 as=0 ps=0 w=400 l=30
X146 x133/m1_537_501 x133/m1_406_797 VDD VDD sky130_fd_pr__pfet_01v8 ad=0 pd=0 as=0 ps=0 w=400 l=30
X147 GND x133/m1_537_501 x148/a_0_0 GND sky130_fd_pr__nfet_01v8 ad=0 pd=0 as=78.2n ps=2.61m w=602 l=30
X149 x133/m1_406_797 z@10 x150/li_393_182 GND sky130_fd_pr__nfet_01v8 ad=1p pd=-87u as=52.7n ps=1.92m w=602 l=30
X151 x150/li_393_182 CLK x148/a_0_0 GND sky130_fd_pr__nfet_01v8 ad=0 pd=0 as=0 ps=0 w=600 l=30
X152 VDD x133/m1_537_501 x133/m1_406_797 VDD sky130_fd_pr__pfet_01v8 ad=0 pd=0 as=69.6n ps=2.75m w=400 l=30
X153 x133/m1_406_797 x133/m1_537_501 VDD VDD sky130_fd_pr__pfet_01v8 ad=0 pd=0 as=0 ps=0 w=400 l=30
X154 VDD CLK x133/m1_406_797 VDD sky130_fd_pr__pfet_01v8 ad=0 pd=0 as=0 ps=0 w=400 l=30
X155 x133/m1_406_797 CLK VDD VDD sky130_fd_pr__pfet_01v8 ad=0 pd=0 as=0 ps=0 w=400 l=30
X156 VDD z@10 x133/m1_406_797 VDD sky130_fd_pr__pfet_01v8 ad=0 pd=0 as=0 ps=0 w=400 l=30
X157 x133/m1_406_797 z@10 VDD VDD sky130_fd_pr__pfet_01v8 ad=0 pd=0 as=0 ps=0 w=400 l=30
X158 GND m1_13659_907 x159/a_0_0 GND sky130_fd_pr__nfet_01v8 ad=0 pd=0 as=78.2n ps=2.61m w=602 l=30
X160 m1_13511_833 z@10 x161/li_393_182 GND sky130_fd_pr__nfet_01v8 ad=7.16n pd=0.314m as=52.7n ps=1.92m w=602 l=30
X162 x161/li_393_182 SN x159/a_0_0 GND sky130_fd_pr__nfet_01v8 ad=0 pd=0 as=0 ps=0 w=600 l=30
X163 VDD m1_13659_907 m1_13511_833 VDD sky130_fd_pr__pfet_01v8 ad=0 pd=0 as=69.6n ps=2.75m w=400 l=30
X164 m1_13511_833 m1_13659_907 VDD VDD sky130_fd_pr__pfet_01v8 ad=0 pd=0 as=0 ps=0 w=400 l=30
X165 VDD SN m1_13511_833 VDD sky130_fd_pr__pfet_01v8 ad=0 pd=0 as=0 ps=0 w=400 l=30
X166 m1_13511_833 SN VDD VDD sky130_fd_pr__pfet_01v8 ad=0 pd=0 as=0 ps=0 w=400 l=30
X167 VDD z@10 m1_13511_833 VDD sky130_fd_pr__pfet_01v8 ad=0 pd=0 as=0 ps=0 w=400 l=30
X168 m1_13511_833 z@10 VDD VDD sky130_fd_pr__pfet_01v8 ad=0 pd=0 as=0 ps=0 w=400 l=30
X169 GND x133/m1_537_501 x170/a_0_0 GND sky130_fd_pr__nfet_01v8 ad=0 pd=0 as=78.2n ps=2.61m w=602 l=30
X171 z@11 z@10 x172/li_393_182 GND sky130_fd_pr__nfet_01v8 ad=1p pd=-87u as=52.7n ps=1.92m w=602 l=30
X173 x172/li_393_182 SN x170/a_0_0 GND sky130_fd_pr__nfet_01v8 ad=0 pd=0 as=0 ps=0 w=600 l=30
X174 VDD x133/m1_537_501 z@11 VDD sky130_fd_pr__pfet_01v8 ad=0 pd=0 as=69.6n ps=2.75m w=400 l=30
X175 z@11 x133/m1_537_501 VDD VDD sky130_fd_pr__pfet_01v8 ad=0 pd=0 as=0 ps=0 w=400 l=30
X176 VDD SN z@11 VDD sky130_fd_pr__pfet_01v8 ad=0 pd=0 as=0 ps=0 w=400 l=30
X177 z@11 SN VDD VDD sky130_fd_pr__pfet_01v8 ad=0 pd=0 as=0 ps=0 w=400 l=30
X178 VDD z@10 z@11 VDD sky130_fd_pr__pfet_01v8 ad=0 pd=0 as=0 ps=0 w=400 l=30
X179 z@11 z@10 VDD VDD sky130_fd_pr__pfet_01v8 ad=0 pd=0 as=0 ps=0 w=400 l=30
X180 GND z@11 x181/a_0_0 GND sky130_fd_pr__nfet_01v8 ad=0 pd=0 as=77.2n ps=2.61m w=602 l=30
X182 z@10 CLK x181/a_0_0 GND sky130_fd_pr__nfet_01v8 ad=7.16n pd=0.314m as=0 ps=0 w=602 l=30
X183 VDD z@11 z@10 VDD sky130_fd_pr__pfet_01v8 ad=0 pd=0 as=46.4n ps=1.83m w=400 l=30
X184 z@10 z@11 VDD VDD sky130_fd_pr__pfet_01v8 ad=0 pd=0 as=0 ps=0 w=400 l=30
X185 VDD CLK z@10 VDD sky130_fd_pr__pfet_01v8 ad=0 pd=0 as=0 ps=0 w=400 l=30
X186 z@10 CLK VDD VDD sky130_fd_pr__pfet_01v8 ad=0 pd=0 as=0 ps=0 w=400 l=30
C0 D m1_4250_685 3.16f
C1 VDD CLK 3.65f
C2 m1_9154_537 m1_4250_685 2.95f
.ends

** hspice subcircuit dictionary
* x1	votern3x1_pcell_0/nmos_top_0
* x3	votern3x1_pcell_0/nmos_bottom_1
* x5	votern3x1_pcell_0/nmos_bottom_2
* x7	votern3x1_pcell_0
* x23	dffsnx1_pcell_0
* x24	dffsnx1_pcell_0/nand2x1_pcell_2/nmos_bottom_0
* x31	dffsnx1_pcell_0/nand2x1_pcell_5/nmos_bottom_0
* x38	dffsnx1_pcell_0/nand3x1_pcell_0/nmos_bottom_0
* x40	dffsnx1_pcell_0/nand3x1_pcell_0
* x49	dffsnx1_pcell_0/nand3x1_pcell_1/nmos_bottom_0
* x51	dffsnx1_pcell_0/nand3x1_pcell_1
* x60	dffsnx1_pcell_0/nand3x1_pcell_2/nmos_bottom_0
* x62	dffsnx1_pcell_0/nand3x1_pcell_2
* x71	dffsnx1_pcell_0/nand2x1_pcell_0/nmos_bottom_0
* x78	dffsnx1_pcell_1
* x79	dffsnx1_pcell_1/nand2x1_pcell_2/nmos_bottom_0
* x86	dffsnx1_pcell_1/nand2x1_pcell_5/nmos_bottom_0
* x93	dffsnx1_pcell_1/nand3x1_pcell_0/nmos_bottom_0
* x95	dffsnx1_pcell_1/nand3x1_pcell_0
* x104	dffsnx1_pcell_1/nand3x1_pcell_1/nmos_bottom_0
* x106	dffsnx1_pcell_1/nand3x1_pcell_1
* x115	dffsnx1_pcell_1/nand3x1_pcell_2/nmos_bottom_0
* x117	dffsnx1_pcell_1/nand3x1_pcell_2
* x126	dffsnx1_pcell_1/nand2x1_pcell_0/nmos_bottom_0
* x133	dffsnx1_pcell_2
* x134	dffsnx1_pcell_2/nand2x1_pcell_2/nmos_bottom_0
* x141	dffsnx1_pcell_2/nand2x1_pcell_5/nmos_bottom_0
* x148	dffsnx1_pcell_2/nand3x1_pcell_0/nmos_bottom_0
* x150	dffsnx1_pcell_2/nand3x1_pcell_0
* x159	dffsnx1_pcell_2/nand3x1_pcell_1/nmos_bottom_0
* x161	dffsnx1_pcell_2/nand3x1_pcell_1
* x170	dffsnx1_pcell_2/nand3x1_pcell_2/nmos_bottom_0
* x172	dffsnx1_pcell_2/nand3x1_pcell_2
* x181	dffsnx1_pcell_2/nand2x1_pcell_0/nmos_bottom_0
