* HSPICE file created from DFFQX1.ext - technology: sky130A

.option scale=5m

.subckt DFFQX1 Q D CLK VDD GND
X0 GND x1/m1_2165_649 x2/a_0_0 GND sky130_fd_pr__nfet_01v8 ad=2.39n pd=0.111m as=15.7n ps=0.599m w=602 l=30
X3 x1/m1_258_797 CLK x2/a_0_0 GND sky130_fd_pr__nfet_01v8 ad=2.39n pd=0.111m as=15.8n ps=0.594m w=602 l=30
X4 VDD x1/m1_2165_649 x1/m1_258_797 VDD sky130_fd_pr__pfet_01v8 ad=21.6n pd=0.908m as=11.6n ps=0.458m w=400 l=30
X5 x1/m1_258_797 x1/m1_2165_649 VDD VDD sky130_fd_pr__pfet_01v8 ad=11.6n pd=0.458m as=22.4n ps=0.912m w=400 l=30
X6 VDD CLK x1/m1_258_797 VDD sky130_fd_pr__pfet_01v8 ad=0.27u pd=0.011 as=46.4n ps=1.83m w=400 l=30
X7 x1/m1_258_797 CLK VDD VDD sky130_fd_pr__pfet_01v8 ad=0 pd=0 as=0 ps=0 w=400 l=30
X8 GND x1/m1_833_723 x9/a_0_0 GND sky130_fd_pr__nfet_01v8 ad=71.6n pd=2.52m as=77.2n ps=2.61m w=602 l=30
X10 x11/li_n17_n33 x12/li_n17_n33 x9/a_0_0 GND sky130_fd_pr__nfet_01v8 ad=7.16n pd=0.314m as=0 ps=0 w=602 l=30
X13 VDD x1/m1_833_723 x11/li_n17_n33 VDD sky130_fd_pr__pfet_01v8 ad=0 pd=0 as=46.4n ps=1.83m w=400 l=30
X14 x11/li_n17_n33 x1/m1_833_723 VDD VDD sky130_fd_pr__pfet_01v8 ad=0 pd=0 as=0 ps=0 w=400 l=30
X15 VDD x12/li_n17_n33 x11/li_n17_n33 VDD sky130_fd_pr__pfet_01v8 ad=0 pd=0 as=0 ps=0 w=400 l=30
X16 x11/li_n17_n33 x12/li_n17_n33 VDD VDD sky130_fd_pr__pfet_01v8 ad=0 pd=0 as=0 ps=0 w=400 l=30
X17 GND m1_3629_685 x18/a_0_0 GND sky130_fd_pr__nfet_01v8 ad=0 pd=0 as=77.2n ps=2.61m w=602 l=30
X19 Q x1/m1_258_797 x18/a_0_0 GND sky130_fd_pr__nfet_01v8 ad=7.16n pd=0.314m as=0 ps=0 w=602 l=30
X20 VDD m1_3629_685 Q VDD sky130_fd_pr__pfet_01v8 ad=0 pd=0 as=46.4n ps=1.83m w=400 l=30
X21 Q m1_3629_685 VDD VDD sky130_fd_pr__pfet_01v8 ad=0 pd=0 as=0 ps=0 w=400 l=30
X22 VDD x1/m1_258_797 Q VDD sky130_fd_pr__pfet_01v8 ad=0 pd=0 as=0 ps=0 w=400 l=30
X23 Q x1/m1_258_797 VDD VDD sky130_fd_pr__pfet_01v8 ad=0 pd=0 as=0 ps=0 w=400 l=30
X24 GND x1/m1_258_797 x25/a_0_0 GND sky130_fd_pr__nfet_01v8 ad=0 pd=0 as=78.2n ps=2.61m w=602 l=30
X26 x1/m1_833_723 x1/m1_685_649 x27/li_393_182 GND sky130_fd_pr__nfet_01v8 ad=-7.16n pd=-0.488m as=52.7n ps=1.92m w=602 l=30
X28 x27/li_393_182 CLK x25/a_0_0 GND sky130_fd_pr__nfet_01v8 ad=2.18n pd=0.106m as=16.2n ps=0.604m w=600 l=30
X29 VDD x1/m1_258_797 x1/m1_833_723 VDD sky130_fd_pr__pfet_01v8 ad=0 pd=0 as=69.6n ps=2.75m w=400 l=30
X30 x1/m1_833_723 x1/m1_258_797 VDD VDD sky130_fd_pr__pfet_01v8 ad=0 pd=0 as=0 ps=0 w=400 l=30
X31 VDD CLK x1/m1_833_723 VDD sky130_fd_pr__pfet_01v8 ad=0 pd=0 as=0 ps=0 w=400 l=30
X32 x1/m1_833_723 CLK VDD VDD sky130_fd_pr__pfet_01v8 ad=0 pd=0 as=0 ps=0 w=400 l=30
X33 VDD x1/m1_685_649 x1/m1_833_723 VDD sky130_fd_pr__pfet_01v8 ad=0 pd=0 as=0 ps=0 w=400 l=30
X34 x1/m1_833_723 x1/m1_685_649 VDD VDD sky130_fd_pr__pfet_01v8 ad=0 pd=0 as=0 ps=0 w=400 l=30
X35 GND x1/m1_833_723 x36/a_0_0 GND sky130_fd_pr__nfet_01v8 ad=0 pd=0 as=77.2n ps=2.61m w=602 l=30
X37 x1/m1_685_649 D x36/a_0_0 GND sky130_fd_pr__nfet_01v8 ad=1p pd=-87u as=0 ps=0 w=602 l=30
X38 VDD x1/m1_833_723 x1/m1_685_649 VDD sky130_fd_pr__pfet_01v8 ad=0 pd=0 as=46.4n ps=1.83m w=400 l=30
X39 x1/m1_685_649 x1/m1_833_723 VDD VDD sky130_fd_pr__pfet_01v8 ad=0 pd=0 as=0 ps=0 w=400 l=30
X40 VDD D x1/m1_685_649 VDD sky130_fd_pr__pfet_01v8 ad=0 pd=0 as=0 ps=0 w=400 l=30
X41 x1/m1_685_649 D VDD VDD sky130_fd_pr__pfet_01v8 ad=0 pd=0 as=0 ps=0 w=400 l=30
X42 GND x1/m1_685_649 x43/a_0_0 GND sky130_fd_pr__nfet_01v8 ad=0 pd=0 as=77.2n ps=2.61m w=602 l=30
X44 x1/m1_2165_649 x1/m1_258_797 x43/a_0_0 GND sky130_fd_pr__nfet_01v8 ad=1p pd=-87u as=0 ps=0 w=602 l=30
X45 VDD x1/m1_685_649 x1/m1_2165_649 VDD sky130_fd_pr__pfet_01v8 ad=0 pd=0 as=46.4n ps=1.83m w=400 l=30
X46 x1/m1_2165_649 x1/m1_685_649 VDD VDD sky130_fd_pr__pfet_01v8 ad=0 pd=0 as=0 ps=0 w=400 l=30
X47 VDD x1/m1_258_797 x1/m1_2165_649 VDD sky130_fd_pr__pfet_01v8 ad=0 pd=0 as=0 ps=0 w=400 l=30
X48 x1/m1_2165_649 x1/m1_258_797 VDD VDD sky130_fd_pr__pfet_01v8 ad=0 pd=0 as=0 ps=0 w=400 l=30
.ends

** hspice subcircuit dictionary
* x1	dffx1_pcell_0
* x2	dffx1_pcell_0/nand2x1_pcell_2/nmos_bottom_0
* x9	dffx1_pcell_0/nand2x1_pcell_3/nmos_bottom_0
* x11	li1_M1_contact_0
* x12	li1_M1_contact_8
* x18	dffx1_pcell_0/nand2x1_pcell_4/nmos_bottom_0
* x25	dffx1_pcell_0/nand3x1_pcell_0/nmos_bottom_0
* x27	dffx1_pcell_0/nand3x1_pcell_0
* x36	dffx1_pcell_0/nand2x1_pcell_0/nmos_bottom_0
* x43	dffx1_pcell_0/nand2x1_pcell_1/nmos_bottom_0
