* HSPICE file created from TMRDFFQNX1.ext - technology: sky130A

.option scale=5m

.subckt TMRDFFQNX1 QN D CLK VDD GND
X0 GND x1/m1_2165_649 x2/a_0_0 GND sky130_fd_pr__nfet_01v8 ad=2.39n pd=0.111m as=15.7n ps=0.599m w=602 l=30
X3 x1/m1_258_797 CLK x2/a_0_0 GND sky130_fd_pr__nfet_01v8 ad=2.39n pd=0.111m as=15.8n ps=0.594m w=602 l=30
X4 VDD x1/m1_2165_649 x1/m1_258_797 VDD sky130_fd_pr__pfet_01v8 ad=21.6n pd=0.908m as=11.6n ps=0.458m w=400 l=30
X5 x1/m1_258_797 x1/m1_2165_649 VDD VDD sky130_fd_pr__pfet_01v8 ad=11.6n pd=0.458m as=22.4n ps=0.912m w=400 l=30
X6 VDD CLK x1/m1_258_797 VDD sky130_fd_pr__pfet_01v8 ad=1.35u pd=0.0548 as=46.4n ps=1.83m w=400 l=30
X7 x1/m1_258_797 CLK VDD VDD sky130_fd_pr__pfet_01v8 ad=0 pd=0 as=0 ps=0 w=400 l=30
X8 GND x1/m1_833_723 x9/a_0_0 GND sky130_fd_pr__nfet_01v8 ad=0.301u pd=0.0156 as=77.2n ps=2.61m w=602 l=30
X10 m1_3593_759 m1_3446_611 x9/a_0_0 GND sky130_fd_pr__nfet_01v8 ad=1p pd=-87u as=0 ps=0 w=602 l=30
X11 VDD x1/m1_833_723 m1_3593_759 VDD sky130_fd_pr__pfet_01v8 ad=0 pd=0 as=46.4n ps=1.83m w=400 l=30
X12 m1_3593_759 x1/m1_833_723 VDD VDD sky130_fd_pr__pfet_01v8 ad=0 pd=0 as=0 ps=0 w=400 l=30
X13 VDD m1_3446_611 m1_3593_759 VDD sky130_fd_pr__pfet_01v8 ad=0 pd=0 as=0 ps=0 w=400 l=30
X14 m1_3593_759 m1_3446_611 VDD VDD sky130_fd_pr__pfet_01v8 ad=0 pd=0 as=0 ps=0 w=400 l=30
X15 GND m1_3593_759 x16/a_0_0 GND sky130_fd_pr__nfet_01v8 ad=0 pd=0 as=77.2n ps=2.61m w=602 l=30
X17 m1_3446_611 x1/m1_258_797 x16/a_0_0 GND sky130_fd_pr__nfet_01v8 ad=1p pd=-0.263m as=0 ps=0 w=602 l=30
X18 VDD m1_3593_759 m1_3446_611 VDD sky130_fd_pr__pfet_01v8 ad=0 pd=0 as=46.4n ps=1.83m w=400 l=30
X19 m1_3446_611 m1_3593_759 VDD VDD sky130_fd_pr__pfet_01v8 ad=0 pd=0 as=0 ps=0 w=400 l=30
X20 VDD x1/m1_258_797 m1_3446_611 VDD sky130_fd_pr__pfet_01v8 ad=0 pd=0 as=0 ps=0 w=400 l=30
X21 m1_3446_611 x1/m1_258_797 VDD VDD sky130_fd_pr__pfet_01v8 ad=0 pd=0 as=0 ps=0 w=400 l=30
X22 GND x1/m1_258_797 x23/a_0_0 GND sky130_fd_pr__nfet_01v8 ad=0 pd=0 as=78.2n ps=2.61m w=602 l=30
X24 x1/m1_833_723 x1/m1_685_649 x25/li_393_182 GND sky130_fd_pr__nfet_01v8 ad=-7.16n pd=-0.488m as=52.7n ps=1.92m w=602 l=30
X26 x25/li_393_182 CLK x23/a_0_0 GND sky130_fd_pr__nfet_01v8 ad=2.18n pd=0.106m as=16.2n ps=0.604m w=600 l=30
X27 VDD x1/m1_258_797 x1/m1_833_723 VDD sky130_fd_pr__pfet_01v8 ad=0 pd=0 as=69.6n ps=2.75m w=400 l=30
X28 x1/m1_833_723 x1/m1_258_797 VDD VDD sky130_fd_pr__pfet_01v8 ad=0 pd=0 as=0 ps=0 w=400 l=30
X29 VDD CLK x1/m1_833_723 VDD sky130_fd_pr__pfet_01v8 ad=0 pd=0 as=0 ps=0 w=400 l=30
X30 x1/m1_833_723 CLK VDD VDD sky130_fd_pr__pfet_01v8 ad=0 pd=0 as=0 ps=0 w=400 l=30
X31 VDD x1/m1_685_649 x1/m1_833_723 VDD sky130_fd_pr__pfet_01v8 ad=0 pd=0 as=0 ps=0 w=400 l=30
X32 x1/m1_833_723 x1/m1_685_649 VDD VDD sky130_fd_pr__pfet_01v8 ad=0 pd=0 as=0 ps=0 w=400 l=30
X33 GND x1/m1_833_723 x34/a_0_0 GND sky130_fd_pr__nfet_01v8 ad=0 pd=0 as=77.2n ps=2.61m w=602 l=30
X35 x1/m1_685_649 D x34/a_0_0 GND sky130_fd_pr__nfet_01v8 ad=1p pd=-87u as=0 ps=0 w=602 l=30
X36 VDD x1/m1_833_723 x1/m1_685_649 VDD sky130_fd_pr__pfet_01v8 ad=0 pd=0 as=46.4n ps=1.83m w=400 l=30
X37 x1/m1_685_649 x1/m1_833_723 VDD VDD sky130_fd_pr__pfet_01v8 ad=0 pd=0 as=0 ps=0 w=400 l=30
X38 VDD D x1/m1_685_649 VDD sky130_fd_pr__pfet_01v8 ad=0 pd=0 as=0 ps=0 w=400 l=30
X39 x1/m1_685_649 D VDD VDD sky130_fd_pr__pfet_01v8 ad=0 pd=0 as=0 ps=0 w=400 l=30
X40 GND x1/m1_685_649 x41/a_0_0 GND sky130_fd_pr__nfet_01v8 ad=0 pd=0 as=77.2n ps=2.61m w=602 l=30
X42 x1/m1_2165_649 x1/m1_258_797 x41/a_0_0 GND sky130_fd_pr__nfet_01v8 ad=1p pd=-87u as=0 ps=0 w=602 l=30
X43 VDD x1/m1_685_649 x1/m1_2165_649 VDD sky130_fd_pr__pfet_01v8 ad=0 pd=0 as=46.4n ps=1.83m w=400 l=30
X44 x1/m1_2165_649 x1/m1_685_649 VDD VDD sky130_fd_pr__pfet_01v8 ad=0 pd=0 as=0 ps=0 w=400 l=30
X45 VDD x1/m1_258_797 x1/m1_2165_649 VDD sky130_fd_pr__pfet_01v8 ad=0 pd=0 as=0 ps=0 w=400 l=30
X46 x1/m1_2165_649 x1/m1_258_797 VDD VDD sky130_fd_pr__pfet_01v8 ad=0 pd=0 as=0 ps=0 w=400 l=30
X47 GND x48/m1_2165_649 x49/a_0_0 GND sky130_fd_pr__nfet_01v8 ad=0 pd=0 as=77.2n ps=2.61m w=602 l=30
X50 x48/m1_258_797 CLK x49/a_0_0 GND sky130_fd_pr__nfet_01v8 ad=1p pd=-87u as=0 ps=0 w=602 l=30
X51 VDD x48/m1_2165_649 x48/m1_258_797 VDD sky130_fd_pr__pfet_01v8 ad=0 pd=0 as=46.4n ps=1.83m w=400 l=30
X52 x48/m1_258_797 x48/m1_2165_649 VDD VDD sky130_fd_pr__pfet_01v8 ad=0 pd=0 as=0 ps=0 w=400 l=30
X53 VDD CLK x48/m1_258_797 VDD sky130_fd_pr__pfet_01v8 ad=0 pd=0 as=0 ps=0 w=400 l=30
X54 x48/m1_258_797 CLK VDD VDD sky130_fd_pr__pfet_01v8 ad=0 pd=0 as=0 ps=0 w=400 l=30
X55 GND x48/m1_833_723 x56/a_0_0 GND sky130_fd_pr__nfet_01v8 ad=0 pd=0 as=77.2n ps=2.61m w=602 l=30
X57 m1_7839_759 m1_7737_463 x56/a_0_0 GND sky130_fd_pr__nfet_01v8 ad=1p pd=-87u as=0 ps=0 w=602 l=30
X58 VDD x48/m1_833_723 m1_7839_759 VDD sky130_fd_pr__pfet_01v8 ad=0 pd=0 as=46.4n ps=1.83m w=400 l=30
X59 m1_7839_759 x48/m1_833_723 VDD VDD sky130_fd_pr__pfet_01v8 ad=0 pd=0 as=0 ps=0 w=400 l=30
X60 VDD m1_7737_463 m1_7839_759 VDD sky130_fd_pr__pfet_01v8 ad=0 pd=0 as=0 ps=0 w=400 l=30
X61 m1_7839_759 m1_7737_463 VDD VDD sky130_fd_pr__pfet_01v8 ad=0 pd=0 as=0 ps=0 w=400 l=30
X62 GND m1_7839_759 x63/a_0_0 GND sky130_fd_pr__nfet_01v8 ad=0 pd=0 as=77.2n ps=2.61m w=602 l=30
X64 m1_7737_463 x48/m1_258_797 x63/a_0_0 GND sky130_fd_pr__nfet_01v8 ad=7.16n pd=0.314m as=0 ps=0 w=602 l=30
X65 VDD m1_7839_759 m1_7737_463 VDD sky130_fd_pr__pfet_01v8 ad=0 pd=0 as=46.4n ps=1.83m w=400 l=30
X66 m1_7737_463 m1_7839_759 VDD VDD sky130_fd_pr__pfet_01v8 ad=0 pd=0 as=0 ps=0 w=400 l=30
X67 VDD x48/m1_258_797 m1_7737_463 VDD sky130_fd_pr__pfet_01v8 ad=0 pd=0 as=0 ps=0 w=400 l=30
X68 m1_7737_463 x48/m1_258_797 VDD VDD sky130_fd_pr__pfet_01v8 ad=0 pd=0 as=0 ps=0 w=400 l=30
X69 GND x48/m1_258_797 x70/a_0_0 GND sky130_fd_pr__nfet_01v8 ad=0 pd=0 as=78.2n ps=2.61m w=602 l=30
X71 x48/m1_833_723 x48/m1_685_649 x72/li_393_182 GND sky130_fd_pr__nfet_01v8 ad=-7.16n pd=-0.488m as=52.7n ps=1.92m w=602 l=30
X73 x72/li_393_182 CLK x70/a_0_0 GND sky130_fd_pr__nfet_01v8 ad=0 pd=0 as=0 ps=0 w=600 l=30
X74 VDD x48/m1_258_797 x48/m1_833_723 VDD sky130_fd_pr__pfet_01v8 ad=0 pd=0 as=69.6n ps=2.75m w=400 l=30
X75 x48/m1_833_723 x48/m1_258_797 VDD VDD sky130_fd_pr__pfet_01v8 ad=0 pd=0 as=0 ps=0 w=400 l=30
X76 VDD CLK x48/m1_833_723 VDD sky130_fd_pr__pfet_01v8 ad=0 pd=0 as=0 ps=0 w=400 l=30
X77 x48/m1_833_723 CLK VDD VDD sky130_fd_pr__pfet_01v8 ad=0 pd=0 as=0 ps=0 w=400 l=30
X78 VDD x48/m1_685_649 x48/m1_833_723 VDD sky130_fd_pr__pfet_01v8 ad=0 pd=0 as=0 ps=0 w=400 l=30
X79 x48/m1_833_723 x48/m1_685_649 VDD VDD sky130_fd_pr__pfet_01v8 ad=0 pd=0 as=0 ps=0 w=400 l=30
X80 GND x48/m1_833_723 x81/a_0_0 GND sky130_fd_pr__nfet_01v8 ad=0 pd=0 as=77.2n ps=2.61m w=602 l=30
X82 x48/m1_685_649 D x81/a_0_0 GND sky130_fd_pr__nfet_01v8 ad=1p pd=-87u as=0 ps=0 w=602 l=30
X83 VDD x48/m1_833_723 x48/m1_685_649 VDD sky130_fd_pr__pfet_01v8 ad=0 pd=0 as=46.4n ps=1.83m w=400 l=30
X84 x48/m1_685_649 x48/m1_833_723 VDD VDD sky130_fd_pr__pfet_01v8 ad=0 pd=0 as=0 ps=0 w=400 l=30
X85 VDD D x48/m1_685_649 VDD sky130_fd_pr__pfet_01v8 ad=0 pd=0 as=0 ps=0 w=400 l=30
X86 x48/m1_685_649 D VDD VDD sky130_fd_pr__pfet_01v8 ad=0 pd=0 as=0 ps=0 w=400 l=30
X87 GND x48/m1_685_649 x88/a_0_0 GND sky130_fd_pr__nfet_01v8 ad=0 pd=0 as=77.2n ps=2.61m w=602 l=30
X89 x48/m1_2165_649 x48/m1_258_797 x88/a_0_0 GND sky130_fd_pr__nfet_01v8 ad=1p pd=-87u as=0 ps=0 w=602 l=30
X90 VDD x48/m1_685_649 x48/m1_2165_649 VDD sky130_fd_pr__pfet_01v8 ad=0 pd=0 as=46.4n ps=1.83m w=400 l=30
X91 x48/m1_2165_649 x48/m1_685_649 VDD VDD sky130_fd_pr__pfet_01v8 ad=0 pd=0 as=0 ps=0 w=400 l=30
X92 VDD x48/m1_258_797 x48/m1_2165_649 VDD sky130_fd_pr__pfet_01v8 ad=0 pd=0 as=0 ps=0 w=400 l=30
X93 x48/m1_2165_649 x48/m1_258_797 VDD VDD sky130_fd_pr__pfet_01v8 ad=0 pd=0 as=0 ps=0 w=400 l=30
X94 GND m1_12029_759 x95/a_0_0 GND sky130_fd_pr__nfet_01v8 ad=0 pd=0 as=76.7n ps=2.6m w=602 l=30
X96 GND m1_12029_759 x97/a_0_0 GND sky130_fd_pr__nfet_01v8 ad=0 pd=0 as=77.2n ps=2.61m w=602 l=30
X98 GND m1_3446_611 x99/a_0_0 GND sky130_fd_pr__nfet_01v8 ad=0 pd=0 as=77.2n ps=2.61m w=602 l=30
X100 x101/a_805_1331 m1_12029_759 VDD VDD sky130_fd_pr__pfet_01v8 ad=11.6n pd=0.458m as=22.4n ps=0.912m w=400 l=30
X102 VDD m1_12029_759 x101/a_805_1331 VDD sky130_fd_pr__pfet_01v8 ad=21.6n pd=0.908m as=11.6n ps=0.458m w=400 l=30
X103 QN m1_3446_611 x97/a_0_0 GND sky130_fd_pr__nfet_01v8 ad=21.5n pd=0.944m as=0 ps=0 w=602 l=30
X104 x101/a_805_1331 m1_7737_463 VDD VDD sky130_fd_pr__pfet_01v8 ad=0.114u pd=4.57m as=0 ps=0 w=400 l=30
X105 VDD m1_7737_463 x101/a_805_1331 VDD sky130_fd_pr__pfet_01v8 ad=0 pd=0 as=0 ps=0 w=400 l=30
X106 x101/a_893_1059 m1_3446_611 x101/a_805_1331 VDD sky130_fd_pr__pfet_01v8 ad=0.114u pd=4.57m as=0 ps=0 w=400 l=30
X107 x101/a_805_1331 m1_3446_611 x101/a_893_1059 VDD sky130_fd_pr__pfet_01v8 ad=0 pd=0 as=0 ps=0 w=400 l=30
X108 x101/a_893_1059 m1_12029_759 x101/a_805_1331 VDD sky130_fd_pr__pfet_01v8 ad=0 pd=0 as=0 ps=0 w=400 l=30
X109 x101/a_805_1331 m1_12029_759 x101/a_893_1059 VDD sky130_fd_pr__pfet_01v8 ad=0 pd=0 as=0 ps=0 w=400 l=30
X110 QN m1_3446_611 x101/a_893_1059 VDD sky130_fd_pr__pfet_01v8 ad=46.4n pd=1.83m as=0 ps=0 w=400 l=30
X111 x101/a_893_1059 m1_3446_611 QN VDD sky130_fd_pr__pfet_01v8 ad=0 pd=0 as=0 ps=0 w=400 l=30
X112 QN m1_7737_463 x101/a_893_1059 VDD sky130_fd_pr__pfet_01v8 ad=0 pd=0 as=0 ps=0 w=400 l=30
X113 x101/a_893_1059 m1_7737_463 QN VDD sky130_fd_pr__pfet_01v8 ad=0 pd=0 as=0 ps=0 w=400 l=30
X114 QN m1_7737_463 x95/a_0_0 GND sky130_fd_pr__nfet_01v8 ad=2.39n pd=0.111m as=15.6n ps=0.592m w=602 l=30
X115 QN m1_7737_463 x99/a_0_0 GND sky130_fd_pr__nfet_01v8 ad=2.4n pd=0.112m as=15.8n ps=0.594m w=602 l=30
X116 GND z@10 x118/a_0_0 GND sky130_fd_pr__nfet_01v8 ad=0 pd=0 as=77.2n ps=2.61m w=602 l=30
X119 x117/m1_258_797 CLK x118/a_0_0 GND sky130_fd_pr__nfet_01v8 ad=1p pd=-87u as=0 ps=0 w=602 l=30
X120 VDD z@10 x117/m1_258_797 VDD sky130_fd_pr__pfet_01v8 ad=0 pd=0 as=46.4n ps=1.83m w=400 l=30
X121 x117/m1_258_797 z@10 VDD VDD sky130_fd_pr__pfet_01v8 ad=0 pd=0 as=0 ps=0 w=400 l=30
X122 VDD CLK x117/m1_258_797 VDD sky130_fd_pr__pfet_01v8 ad=0 pd=0 as=0 ps=0 w=400 l=30
X123 x117/m1_258_797 CLK VDD VDD sky130_fd_pr__pfet_01v8 ad=0 pd=0 as=0 ps=0 w=400 l=30
X124 GND x117/m1_833_723 x125/a_0_0 GND sky130_fd_pr__nfet_01v8 ad=0 pd=0 as=77.2n ps=2.61m w=602 l=30
X126 m1_12177_907 m1_12029_759 x125/a_0_0 GND sky130_fd_pr__nfet_01v8 ad=1p pd=-87u as=0 ps=0 w=602 l=30
X127 VDD x117/m1_833_723 m1_12177_907 VDD sky130_fd_pr__pfet_01v8 ad=0 pd=0 as=46.4n ps=1.83m w=400 l=30
X128 m1_12177_907 x117/m1_833_723 VDD VDD sky130_fd_pr__pfet_01v8 ad=0 pd=0 as=0 ps=0 w=400 l=30
X129 VDD m1_12029_759 m1_12177_907 VDD sky130_fd_pr__pfet_01v8 ad=0 pd=0 as=0 ps=0 w=400 l=30
X130 m1_12177_907 m1_12029_759 VDD VDD sky130_fd_pr__pfet_01v8 ad=0 pd=0 as=0 ps=0 w=400 l=30
X131 GND m1_12177_907 x132/a_0_0 GND sky130_fd_pr__nfet_01v8 ad=0 pd=0 as=77.2n ps=2.61m w=602 l=30
X133 m1_12029_759 x117/m1_258_797 x132/a_0_0 GND sky130_fd_pr__nfet_01v8 ad=-7.16n pd=-0.841m as=0 ps=0 w=602 l=30
X134 VDD m1_12177_907 m1_12029_759 VDD sky130_fd_pr__pfet_01v8 ad=0 pd=0 as=46.4n ps=1.83m w=400 l=30
X135 m1_12029_759 m1_12177_907 VDD VDD sky130_fd_pr__pfet_01v8 ad=0 pd=0 as=0 ps=0 w=400 l=30
X136 VDD x117/m1_258_797 m1_12029_759 VDD sky130_fd_pr__pfet_01v8 ad=0 pd=0 as=0 ps=0 w=400 l=30
X137 m1_12029_759 x117/m1_258_797 VDD VDD sky130_fd_pr__pfet_01v8 ad=0 pd=0 as=0 ps=0 w=400 l=30
X138 GND x117/m1_258_797 x139/a_0_0 GND sky130_fd_pr__nfet_01v8 ad=0 pd=0 as=78.2n ps=2.61m w=602 l=30
X140 x117/m1_833_723 x117/m1_685_649 x141/li_393_182 GND sky130_fd_pr__nfet_01v8 ad=-7.16n pd=-0.488m as=52.7n ps=1.92m w=602 l=30
X142 x141/li_393_182 CLK x139/a_0_0 GND sky130_fd_pr__nfet_01v8 ad=0 pd=0 as=0 ps=0 w=600 l=30
X143 VDD x117/m1_258_797 x117/m1_833_723 VDD sky130_fd_pr__pfet_01v8 ad=0 pd=0 as=69.6n ps=2.75m w=400 l=30
X144 x117/m1_833_723 x117/m1_258_797 VDD VDD sky130_fd_pr__pfet_01v8 ad=0 pd=0 as=0 ps=0 w=400 l=30
X145 VDD CLK x117/m1_833_723 VDD sky130_fd_pr__pfet_01v8 ad=0 pd=0 as=0 ps=0 w=400 l=30
X146 x117/m1_833_723 CLK VDD VDD sky130_fd_pr__pfet_01v8 ad=0 pd=0 as=0 ps=0 w=400 l=30
X147 VDD x117/m1_685_649 x117/m1_833_723 VDD sky130_fd_pr__pfet_01v8 ad=0 pd=0 as=0 ps=0 w=400 l=30
X148 x117/m1_833_723 x117/m1_685_649 VDD VDD sky130_fd_pr__pfet_01v8 ad=0 pd=0 as=0 ps=0 w=400 l=30
X149 GND x117/m1_833_723 x150/a_0_0 GND sky130_fd_pr__nfet_01v8 ad=0 pd=0 as=77.2n ps=2.61m w=602 l=30
X151 x117/m1_685_649 D x150/a_0_0 GND sky130_fd_pr__nfet_01v8 ad=1p pd=-87u as=0 ps=0 w=602 l=30
X152 VDD x117/m1_833_723 x117/m1_685_649 VDD sky130_fd_pr__pfet_01v8 ad=0 pd=0 as=46.4n ps=1.83m w=400 l=30
X153 x117/m1_685_649 x117/m1_833_723 VDD VDD sky130_fd_pr__pfet_01v8 ad=0 pd=0 as=0 ps=0 w=400 l=30
X154 VDD D x117/m1_685_649 VDD sky130_fd_pr__pfet_01v8 ad=0 pd=0 as=0 ps=0 w=400 l=30
X155 x117/m1_685_649 D VDD VDD sky130_fd_pr__pfet_01v8 ad=0 pd=0 as=0 ps=0 w=400 l=30
X156 GND x117/m1_685_649 x157/a_0_0 GND sky130_fd_pr__nfet_01v8 ad=0 pd=0 as=77.2n ps=2.61m w=602 l=30
X158 z@10 x117/m1_258_797 x157/a_0_0 GND sky130_fd_pr__nfet_01v8 ad=1p pd=-87u as=0 ps=0 w=602 l=30
X159 VDD x117/m1_685_649 z@10 VDD sky130_fd_pr__pfet_01v8 ad=0 pd=0 as=46.4n ps=1.83m w=400 l=30
X160 z@10 x117/m1_685_649 VDD VDD sky130_fd_pr__pfet_01v8 ad=0 pd=0 as=0 ps=0 w=400 l=30
X161 VDD x117/m1_258_797 z@10 VDD sky130_fd_pr__pfet_01v8 ad=0 pd=0 as=0 ps=0 w=400 l=30
X162 z@10 x117/m1_258_797 VDD VDD sky130_fd_pr__pfet_01v8 ad=0 pd=0 as=0 ps=0 w=400 l=30
C0 m1_3446_611 D 3.33f
C1 VDD CLK 4.27f
C2 CLK x1/m1_258_797 2.04f
C3 x48/m1_258_797 CLK 2.05f
.ends

** hspice subcircuit dictionary
* x1	dffx1_pcell_0
* x2	dffx1_pcell_0/nand2x1_pcell_2/nmos_bottom_0
* x9	dffx1_pcell_0/nand2x1_pcell_3/nmos_bottom_0
* x16	dffx1_pcell_0/nand2x1_pcell_4/nmos_bottom_0
* x23	dffx1_pcell_0/nand3x1_pcell_0/nmos_bottom_0
* x25	dffx1_pcell_0/nand3x1_pcell_0
* x34	dffx1_pcell_0/nand2x1_pcell_0/nmos_bottom_0
* x41	dffx1_pcell_0/nand2x1_pcell_1/nmos_bottom_0
* x48	dffx1_pcell_1
* x49	dffx1_pcell_1/nand2x1_pcell_2/nmos_bottom_0
* x56	dffx1_pcell_1/nand2x1_pcell_3/nmos_bottom_0
* x63	dffx1_pcell_1/nand2x1_pcell_4/nmos_bottom_0
* x70	dffx1_pcell_1/nand3x1_pcell_0/nmos_bottom_0
* x72	dffx1_pcell_1/nand3x1_pcell_0
* x81	dffx1_pcell_1/nand2x1_pcell_0/nmos_bottom_0
* x88	dffx1_pcell_1/nand2x1_pcell_1/nmos_bottom_0
* x95	votern3x1_pcell_0/nmos_top_0
* x97	votern3x1_pcell_0/nmos_bottom_1
* x99	votern3x1_pcell_0/nmos_bottom_2
* x101	votern3x1_pcell_0
* x117	dffx1_pcell_2
* x118	dffx1_pcell_2/nand2x1_pcell_2/nmos_bottom_0
* x125	dffx1_pcell_2/nand2x1_pcell_3/nmos_bottom_0
* x132	dffx1_pcell_2/nand2x1_pcell_4/nmos_bottom_0
* x139	dffx1_pcell_2/nand3x1_pcell_0/nmos_bottom_0
* x141	dffx1_pcell_2/nand3x1_pcell_0
* x150	dffx1_pcell_2/nand2x1_pcell_0/nmos_bottom_0
* x157	dffx1_pcell_2/nand2x1_pcell_1/nmos_bottom_0
