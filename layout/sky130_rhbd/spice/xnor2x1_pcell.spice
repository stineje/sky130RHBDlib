* HSPICE file created from xnor2x1_pcell.ext - technology: sky130A

.option scale=5m

.subckt xnor2x1_pcell
X0 x1/VSUBS a_612_375 x2/a_0_0 x1/VSUBS sky130_fd_pr__nfet_01v8 ad=2.39n pd=0.111m as=15.7n ps=0.599m w=602 l=30
X3 x1/VSUBS m1_939_797 x4/a_0_0 x1/VSUBS sky130_fd_pr__nfet_01v8 ad=60n pd=2.25m as=77.2n ps=2.61m w=602 l=30
X5 w_585_1330 a_612_375 a_761_1330 w_585_1330 sky130_fd_pr__pfet_01v8 ad=11.6n pd=0.458m as=22.4n ps=0.912m w=400 l=30
X6 a_761_1330 a_612_375 w_585_1330 w_585_1330 sky130_fd_pr__pfet_01v8 ad=21.6n pd=0.908m as=11.6n ps=0.458m w=400 l=30
X7 m1_981_723 m1_315_501 x4/a_0_0 x1/VSUBS sky130_fd_pr__nfet_01v8 ad=2.39n pd=0.111m as=15.8n ps=0.594m w=602 l=30
X8 m1_981_723 a_806_382 x2/a_0_0 x1/VSUBS sky130_fd_pr__nfet_01v8 ad=21.5n pd=1.21m as=77.2n ps=2.61m w=602 l=30
X9 m1_981_723 m1_939_797 a_761_1330 w_585_1330 sky130_fd_pr__pfet_01v8 ad=46.4n pd=1.83m as=67.2n ps=2.74m w=400 l=30
X10 a_761_1330 m1_939_797 m1_981_723 w_585_1330 sky130_fd_pr__pfet_01v8 ad=0 pd=0 as=0 ps=0 w=400 l=30
X11 w_585_1330 a_806_382 a_1427_1330 w_585_1330 sky130_fd_pr__pfet_01v8 ad=0.134u pd=5.47m as=67.2n ps=2.74m w=400 l=30
X12 a_1427_1330 a_806_382 w_585_1330 w_585_1330 sky130_fd_pr__pfet_01v8 ad=0 pd=0 as=0 ps=0 w=400 l=30
X13 m1_981_723 m1_315_501 a_1427_1330 w_585_1330 sky130_fd_pr__pfet_01v8 ad=0 pd=0 as=0 ps=0 w=400 l=30
X14 a_1427_1330 m1_315_501 m1_981_723 w_585_1330 sky130_fd_pr__pfet_01v8 ad=0 pd=0 as=0 ps=0 w=400 l=30
X15 m1_315_501 a_612_375 x1/VSUBS x1/VSUBS sky130_fd_pr__nfet_01v8 ad=2.39n pd=0.111m as=15.6n ps=0.592m w=602 l=30
X16 w_585_1330 a_612_375 m1_315_501 w_585_1330 sky130_fd_pr__pfet_01v8 ad=21.6n pd=0.908m as=11.6n ps=0.458m w=400 l=30
X17 m1_315_501 a_612_375 w_585_1330 w_585_1330 sky130_fd_pr__pfet_01v8 ad=11.6n pd=0.458m as=22.4n ps=0.912m w=400 l=30
X18 a_806_382 m1_939_797 x19/VSUBS x19/VSUBS sky130_fd_pr__nfet_01v8 ad=1p pd=-0.263m as=60n ps=2.78m w=602 l=30
X20 w_585_1330 m1_939_797 a_806_382 w_585_1330 sky130_fd_pr__pfet_01v8 ad=0 pd=0 as=23.2n ps=0.917m w=400 l=30
X21 a_806_382 m1_939_797 w_585_1330 w_585_1330 sky130_fd_pr__pfet_01v8 ad=0 pd=0 as=0 ps=0 w=400 l=30
.ends

** hspice subcircuit dictionary
* x1	pmos2_1_3
* x2	nmos_bottom_0
* x4	nmos_bottom_1
* x19	li1_M1_contact_2
