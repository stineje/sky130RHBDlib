* HSPICE file created from TMRDFFSNQX1.ext - technology: sky130A

.option scale=5m

.subckt TMRDFFSNQX1 Q D CLK SN VDD GND
X0 GND m1_13511_907 x1/a_0_0 GND sky130_fd_pr__nfet_01v8 ad=2.39n pd=0.111m as=15.7n ps=0.599m w=602 l=30
X2 GND m1_13511_907 x3/a_0_0 GND sky130_fd_pr__nfet_01v8 ad=0.347u pd=0.0172 as=77.2n ps=2.61m w=602 l=30
X4 GND m1_3704_685 x5/a_0_0 GND sky130_fd_pr__nfet_01v8 ad=0 pd=0 as=77.2n ps=2.61m w=602 l=30
X6 x7/a_805_1331 m1_13511_907 VDD VDD sky130_fd_pr__pfet_01v8 ad=11.6n pd=0.458m as=22.4n ps=0.912m w=400 l=30
X8 VDD m1_13511_907 x7/a_805_1331 VDD sky130_fd_pr__pfet_01v8 ad=21.6n pd=0.908m as=11.6n ps=0.458m w=400 l=30
X9 x10/m1_1867_797 m1_3704_685 x3/a_0_0 GND sky130_fd_pr__nfet_01v8 ad=2.39n pd=0.111m as=15.8n ps=0.594m w=602 l=30
X11 x7/a_805_1331 m1_9737_537 VDD VDD sky130_fd_pr__pfet_01v8 ad=0.114u pd=4.57m as=1.53u ps=0.0621 w=400 l=30
X12 VDD m1_9737_537 x7/a_805_1331 VDD sky130_fd_pr__pfet_01v8 ad=0 pd=0 as=0 ps=0 w=400 l=30
X13 x7/a_893_1059 m1_3704_685 x7/a_805_1331 VDD sky130_fd_pr__pfet_01v8 ad=0.114u pd=4.57m as=0 ps=0 w=400 l=30
X14 x7/a_805_1331 m1_3704_685 x7/a_893_1059 VDD sky130_fd_pr__pfet_01v8 ad=0 pd=0 as=0 ps=0 w=400 l=30
X15 x7/a_893_1059 m1_13511_907 x7/a_805_1331 VDD sky130_fd_pr__pfet_01v8 ad=0 pd=0 as=0 ps=0 w=400 l=30
X16 x7/a_805_1331 m1_13511_907 x7/a_893_1059 VDD sky130_fd_pr__pfet_01v8 ad=0 pd=0 as=0 ps=0 w=400 l=30
X17 x10/m1_1867_797 m1_3704_685 x7/a_893_1059 VDD sky130_fd_pr__pfet_01v8 ad=46.4n pd=1.83m as=0 ps=0 w=400 l=30
X18 x7/a_893_1059 m1_3704_685 x10/m1_1867_797 VDD sky130_fd_pr__pfet_01v8 ad=0 pd=0 as=0 ps=0 w=400 l=30
X19 x10/m1_1867_797 m1_9737_537 x7/a_893_1059 VDD sky130_fd_pr__pfet_01v8 ad=0 pd=0 as=0 ps=0 w=400 l=30
X20 x7/a_893_1059 m1_9737_537 x10/m1_1867_797 VDD sky130_fd_pr__pfet_01v8 ad=0 pd=0 as=0 ps=0 w=400 l=30
X21 x10/m1_1867_797 m1_9737_537 x1/a_0_0 GND sky130_fd_pr__nfet_01v8 ad=2.39n pd=0.111m as=15.6n ps=0.592m w=602 l=30
X22 x10/m1_1867_797 m1_9737_537 x5/a_0_0 GND sky130_fd_pr__nfet_01v8 ad=2.4n pd=0.112m as=15.8n ps=0.594m w=602 l=30
X23 Q x10/m1_1867_797 GND GND sky130_fd_pr__nfet_01v8 ad=7.16n pd=0.314m as=0 ps=0 w=602 l=30
X24 VDD x10/m1_1867_797 Q VDD sky130_fd_pr__pfet_01v8 ad=21.6n pd=0.908m as=11.6n ps=0.458m w=400 l=30
X25 Q x10/m1_1867_797 VDD VDD sky130_fd_pr__pfet_01v8 ad=11.6n pd=0.458m as=22.4n ps=0.912m w=400 l=30
X26 GND x27/m1_406_797 x28/a_0_0 GND sky130_fd_pr__nfet_01v8 ad=0 pd=0 as=77.2n ps=2.61m w=602 l=30
X29 m1_3911_833 m1_3704_685 x28/a_0_0 GND sky130_fd_pr__nfet_01v8 ad=1p pd=-87u as=0 ps=0 w=602 l=30
X30 VDD x27/m1_406_797 m1_3911_833 VDD sky130_fd_pr__pfet_01v8 ad=0 pd=0 as=46.4n ps=1.83m w=400 l=30
X31 m1_3911_833 x27/m1_406_797 VDD VDD sky130_fd_pr__pfet_01v8 ad=0 pd=0 as=0 ps=0 w=400 l=30
X32 VDD m1_3704_685 m1_3911_833 VDD sky130_fd_pr__pfet_01v8 ad=0 pd=0 as=0 ps=0 w=400 l=30
X33 m1_3911_833 m1_3704_685 VDD VDD sky130_fd_pr__pfet_01v8 ad=0 pd=0 as=0 ps=0 w=400 l=30
X34 GND D x35/a_0_0 GND sky130_fd_pr__nfet_01v8 ad=0 pd=0 as=77.2n ps=2.61m w=602 l=30
X36 x27/m1_537_501 x27/m1_406_797 x35/a_0_0 GND sky130_fd_pr__nfet_01v8 ad=-7.16n pd=-0.488m as=0 ps=0 w=602 l=30
X37 VDD D x27/m1_537_501 VDD sky130_fd_pr__pfet_01v8 ad=0 pd=0 as=46.4n ps=1.83m w=400 l=30
X38 x27/m1_537_501 D VDD VDD sky130_fd_pr__pfet_01v8 ad=0 pd=0 as=0 ps=0 w=400 l=30
X39 VDD x27/m1_406_797 x27/m1_537_501 VDD sky130_fd_pr__pfet_01v8 ad=0 pd=0 as=0 ps=0 w=400 l=30
X40 x27/m1_537_501 x27/m1_406_797 VDD VDD sky130_fd_pr__pfet_01v8 ad=0 pd=0 as=0 ps=0 w=400 l=30
X41 GND x27/m1_537_501 x42/a_0_0 GND sky130_fd_pr__nfet_01v8 ad=0 pd=0 as=78.2n ps=2.61m w=602 l=30
X43 x27/m1_406_797 x27/m1_1351_723 x44/li_393_182 GND sky130_fd_pr__nfet_01v8 ad=1p pd=-87u as=52.7n ps=1.92m w=602 l=30
X45 x44/li_393_182 CLK x42/a_0_0 GND sky130_fd_pr__nfet_01v8 ad=2.18n pd=0.106m as=16.2n ps=0.604m w=600 l=30
X46 VDD x27/m1_537_501 x27/m1_406_797 VDD sky130_fd_pr__pfet_01v8 ad=0 pd=0 as=69.6n ps=2.75m w=400 l=30
X47 x27/m1_406_797 x27/m1_537_501 VDD VDD sky130_fd_pr__pfet_01v8 ad=0 pd=0 as=0 ps=0 w=400 l=30
X48 VDD CLK x27/m1_406_797 VDD sky130_fd_pr__pfet_01v8 ad=0 pd=0 as=0 ps=0 w=400 l=30
X49 x27/m1_406_797 CLK VDD VDD sky130_fd_pr__pfet_01v8 ad=0 pd=0 as=0 ps=0 w=400 l=30
X50 VDD x27/m1_1351_723 x27/m1_406_797 VDD sky130_fd_pr__pfet_01v8 ad=0 pd=0 as=0 ps=0 w=400 l=30
X51 x27/m1_406_797 x27/m1_1351_723 VDD VDD sky130_fd_pr__pfet_01v8 ad=0 pd=0 as=0 ps=0 w=400 l=30
X52 GND m1_3911_833 x53/a_0_0 GND sky130_fd_pr__nfet_01v8 ad=0 pd=0 as=78.2n ps=2.61m w=602 l=30
X54 m1_3704_685 x27/m1_1351_723 x55/li_393_182 GND sky130_fd_pr__nfet_01v8 ad=1p pd=-0.263m as=52.7n ps=1.92m w=602 l=30
X56 x55/li_393_182 SN x53/a_0_0 GND sky130_fd_pr__nfet_01v8 ad=0 pd=0 as=0 ps=0 w=600 l=30
X57 VDD m1_3911_833 m1_3704_685 VDD sky130_fd_pr__pfet_01v8 ad=0 pd=0 as=69.6n ps=2.75m w=400 l=30
X58 m1_3704_685 m1_3911_833 VDD VDD sky130_fd_pr__pfet_01v8 ad=0 pd=0 as=0 ps=0 w=400 l=30
X59 VDD SN m1_3704_685 VDD sky130_fd_pr__pfet_01v8 ad=0 pd=0 as=0 ps=0 w=400 l=30
X60 m1_3704_685 SN VDD VDD sky130_fd_pr__pfet_01v8 ad=0 pd=0 as=0 ps=0 w=400 l=30
X61 VDD x27/m1_1351_723 m1_3704_685 VDD sky130_fd_pr__pfet_01v8 ad=0 pd=0 as=0 ps=0 w=400 l=30
X62 m1_3704_685 x27/m1_1351_723 VDD VDD sky130_fd_pr__pfet_01v8 ad=0 pd=0 as=0 ps=0 w=400 l=30
X63 GND x27/m1_537_501 x64/a_0_0 GND sky130_fd_pr__nfet_01v8 ad=0 pd=0 as=78.2n ps=2.61m w=602 l=30
X65 x27/m1_2461_501 x27/m1_1351_723 x66/li_393_182 GND sky130_fd_pr__nfet_01v8 ad=1p pd=-87u as=52.7n ps=1.92m w=602 l=30
X67 x66/li_393_182 SN x64/a_0_0 GND sky130_fd_pr__nfet_01v8 ad=0 pd=0 as=0 ps=0 w=600 l=30
X68 VDD x27/m1_537_501 x27/m1_2461_501 VDD sky130_fd_pr__pfet_01v8 ad=0 pd=0 as=69.6n ps=2.75m w=400 l=30
X69 x27/m1_2461_501 x27/m1_537_501 VDD VDD sky130_fd_pr__pfet_01v8 ad=0 pd=0 as=0 ps=0 w=400 l=30
X70 VDD SN x27/m1_2461_501 VDD sky130_fd_pr__pfet_01v8 ad=0 pd=0 as=0 ps=0 w=400 l=30
X71 x27/m1_2461_501 SN VDD VDD sky130_fd_pr__pfet_01v8 ad=0 pd=0 as=0 ps=0 w=400 l=30
X72 VDD x27/m1_1351_723 x27/m1_2461_501 VDD sky130_fd_pr__pfet_01v8 ad=0 pd=0 as=0 ps=0 w=400 l=30
X73 x27/m1_2461_501 x27/m1_1351_723 VDD VDD sky130_fd_pr__pfet_01v8 ad=0 pd=0 as=0 ps=0 w=400 l=30
X74 GND x27/m1_2461_501 x75/a_0_0 GND sky130_fd_pr__nfet_01v8 ad=0 pd=0 as=77.2n ps=2.61m w=602 l=30
X76 x27/m1_1351_723 CLK x75/a_0_0 GND sky130_fd_pr__nfet_01v8 ad=7.16n pd=0.314m as=0 ps=0 w=602 l=30
X77 VDD x27/m1_2461_501 x27/m1_1351_723 VDD sky130_fd_pr__pfet_01v8 ad=0 pd=0 as=46.4n ps=1.83m w=400 l=30
X78 x27/m1_1351_723 x27/m1_2461_501 VDD VDD sky130_fd_pr__pfet_01v8 ad=0 pd=0 as=0 ps=0 w=400 l=30
X79 VDD CLK x27/m1_1351_723 VDD sky130_fd_pr__pfet_01v8 ad=0 pd=0 as=0 ps=0 w=400 l=30
X80 x27/m1_1351_723 CLK VDD VDD sky130_fd_pr__pfet_01v8 ad=0 pd=0 as=0 ps=0 w=400 l=30
X81 GND x82/m1_406_797 x83/a_0_0 GND sky130_fd_pr__nfet_01v8 ad=0 pd=0 as=77.2n ps=2.61m w=602 l=30
X84 m1_8727_537 m1_9737_537 x83/a_0_0 GND sky130_fd_pr__nfet_01v8 ad=1p pd=-87u as=0 ps=0 w=602 l=30
X85 VDD x82/m1_406_797 m1_8727_537 VDD sky130_fd_pr__pfet_01v8 ad=0 pd=0 as=46.4n ps=1.83m w=400 l=30
X86 m1_8727_537 x82/m1_406_797 VDD VDD sky130_fd_pr__pfet_01v8 ad=0 pd=0 as=0 ps=0 w=400 l=30
X87 VDD m1_9737_537 m1_8727_537 VDD sky130_fd_pr__pfet_01v8 ad=0 pd=0 as=0 ps=0 w=400 l=30
X88 m1_8727_537 m1_9737_537 VDD VDD sky130_fd_pr__pfet_01v8 ad=0 pd=0 as=0 ps=0 w=400 l=30
X89 GND D x90/a_0_0 GND sky130_fd_pr__nfet_01v8 ad=0 pd=0 as=77.2n ps=2.61m w=602 l=30
X91 x82/m1_537_501 x82/m1_406_797 x90/a_0_0 GND sky130_fd_pr__nfet_01v8 ad=-7.16n pd=-0.488m as=0 ps=0 w=602 l=30
X92 VDD D x82/m1_537_501 VDD sky130_fd_pr__pfet_01v8 ad=0 pd=0 as=46.4n ps=1.83m w=400 l=30
X93 x82/m1_537_501 D VDD VDD sky130_fd_pr__pfet_01v8 ad=0 pd=0 as=0 ps=0 w=400 l=30
X94 VDD x82/m1_406_797 x82/m1_537_501 VDD sky130_fd_pr__pfet_01v8 ad=0 pd=0 as=0 ps=0 w=400 l=30
X95 x82/m1_537_501 x82/m1_406_797 VDD VDD sky130_fd_pr__pfet_01v8 ad=0 pd=0 as=0 ps=0 w=400 l=30
X96 GND x82/m1_537_501 x97/a_0_0 GND sky130_fd_pr__nfet_01v8 ad=0 pd=0 as=78.2n ps=2.61m w=602 l=30
X98 x82/m1_406_797 x82/m1_1351_723 x99/li_393_182 GND sky130_fd_pr__nfet_01v8 ad=1p pd=-87u as=52.7n ps=1.92m w=602 l=30
X100 x99/li_393_182 CLK x97/a_0_0 GND sky130_fd_pr__nfet_01v8 ad=0 pd=0 as=0 ps=0 w=600 l=30
X101 VDD x82/m1_537_501 x82/m1_406_797 VDD sky130_fd_pr__pfet_01v8 ad=0 pd=0 as=69.6n ps=2.75m w=400 l=30
X102 x82/m1_406_797 x82/m1_537_501 VDD VDD sky130_fd_pr__pfet_01v8 ad=0 pd=0 as=0 ps=0 w=400 l=30
X103 VDD CLK x82/m1_406_797 VDD sky130_fd_pr__pfet_01v8 ad=0 pd=0 as=0 ps=0 w=400 l=30
X104 x82/m1_406_797 CLK VDD VDD sky130_fd_pr__pfet_01v8 ad=0 pd=0 as=0 ps=0 w=400 l=30
X105 VDD x82/m1_1351_723 x82/m1_406_797 VDD sky130_fd_pr__pfet_01v8 ad=0 pd=0 as=0 ps=0 w=400 l=30
X106 x82/m1_406_797 x82/m1_1351_723 VDD VDD sky130_fd_pr__pfet_01v8 ad=0 pd=0 as=0 ps=0 w=400 l=30
X107 GND m1_8727_537 x108/a_0_0 GND sky130_fd_pr__nfet_01v8 ad=0 pd=0 as=78.2n ps=2.61m w=602 l=30
X109 m1_9737_537 x82/m1_1351_723 x110/li_393_182 GND sky130_fd_pr__nfet_01v8 ad=7.16n pd=0.314m as=52.7n ps=1.92m w=602 l=30
X111 x110/li_393_182 SN x108/a_0_0 GND sky130_fd_pr__nfet_01v8 ad=0 pd=0 as=0 ps=0 w=600 l=30
X112 VDD m1_8727_537 m1_9737_537 VDD sky130_fd_pr__pfet_01v8 ad=0 pd=0 as=69.6n ps=2.75m w=400 l=30
X113 m1_9737_537 m1_8727_537 VDD VDD sky130_fd_pr__pfet_01v8 ad=0 pd=0 as=0 ps=0 w=400 l=30
X114 VDD SN m1_9737_537 VDD sky130_fd_pr__pfet_01v8 ad=0 pd=0 as=0 ps=0 w=400 l=30
X115 m1_9737_537 SN VDD VDD sky130_fd_pr__pfet_01v8 ad=0 pd=0 as=0 ps=0 w=400 l=30
X116 VDD x82/m1_1351_723 m1_9737_537 VDD sky130_fd_pr__pfet_01v8 ad=0 pd=0 as=0 ps=0 w=400 l=30
X117 m1_9737_537 x82/m1_1351_723 VDD VDD sky130_fd_pr__pfet_01v8 ad=0 pd=0 as=0 ps=0 w=400 l=30
X118 GND x82/m1_537_501 x119/a_0_0 GND sky130_fd_pr__nfet_01v8 ad=0 pd=0 as=78.2n ps=2.61m w=602 l=30
X120 x82/m1_2461_501 x82/m1_1351_723 x121/li_393_182 GND sky130_fd_pr__nfet_01v8 ad=1p pd=-87u as=52.7n ps=1.92m w=602 l=30
X122 x121/li_393_182 SN x119/a_0_0 GND sky130_fd_pr__nfet_01v8 ad=0 pd=0 as=0 ps=0 w=600 l=30
X123 VDD x82/m1_537_501 x82/m1_2461_501 VDD sky130_fd_pr__pfet_01v8 ad=0 pd=0 as=69.6n ps=2.75m w=400 l=30
X124 x82/m1_2461_501 x82/m1_537_501 VDD VDD sky130_fd_pr__pfet_01v8 ad=0 pd=0 as=0 ps=0 w=400 l=30
X125 VDD SN x82/m1_2461_501 VDD sky130_fd_pr__pfet_01v8 ad=0 pd=0 as=0 ps=0 w=400 l=30
X126 x82/m1_2461_501 SN VDD VDD sky130_fd_pr__pfet_01v8 ad=0 pd=0 as=0 ps=0 w=400 l=30
X127 VDD x82/m1_1351_723 x82/m1_2461_501 VDD sky130_fd_pr__pfet_01v8 ad=0 pd=0 as=0 ps=0 w=400 l=30
X128 x82/m1_2461_501 x82/m1_1351_723 VDD VDD sky130_fd_pr__pfet_01v8 ad=0 pd=0 as=0 ps=0 w=400 l=30
X129 GND x82/m1_2461_501 x130/a_0_0 GND sky130_fd_pr__nfet_01v8 ad=0 pd=0 as=77.2n ps=2.61m w=602 l=30
X131 x82/m1_1351_723 CLK x130/a_0_0 GND sky130_fd_pr__nfet_01v8 ad=7.16n pd=0.314m as=0 ps=0 w=602 l=30
X132 VDD x82/m1_2461_501 x82/m1_1351_723 VDD sky130_fd_pr__pfet_01v8 ad=0 pd=0 as=46.4n ps=1.83m w=400 l=30
X133 x82/m1_1351_723 x82/m1_2461_501 VDD VDD sky130_fd_pr__pfet_01v8 ad=0 pd=0 as=0 ps=0 w=400 l=30
X134 VDD CLK x82/m1_1351_723 VDD sky130_fd_pr__pfet_01v8 ad=0 pd=0 as=0 ps=0 w=400 l=30
X135 x82/m1_1351_723 CLK VDD VDD sky130_fd_pr__pfet_01v8 ad=0 pd=0 as=0 ps=0 w=400 l=30
X136 GND x137/m1_406_797 x138/a_0_0 GND sky130_fd_pr__nfet_01v8 ad=0 pd=0 as=77.2n ps=2.61m w=602 l=30
X139 m1_13659_981 m1_13511_907 x138/a_0_0 GND sky130_fd_pr__nfet_01v8 ad=1p pd=-87u as=0 ps=0 w=602 l=30
X140 VDD x137/m1_406_797 m1_13659_981 VDD sky130_fd_pr__pfet_01v8 ad=0 pd=0 as=46.4n ps=1.83m w=400 l=30
X141 m1_13659_981 x137/m1_406_797 VDD VDD sky130_fd_pr__pfet_01v8 ad=0 pd=0 as=0 ps=0 w=400 l=30
X142 VDD m1_13511_907 m1_13659_981 VDD sky130_fd_pr__pfet_01v8 ad=0 pd=0 as=0 ps=0 w=400 l=30
X143 m1_13659_981 m1_13511_907 VDD VDD sky130_fd_pr__pfet_01v8 ad=0 pd=0 as=0 ps=0 w=400 l=30
X144 GND D x145/a_0_0 GND sky130_fd_pr__nfet_01v8 ad=0 pd=0 as=77.2n ps=2.61m w=602 l=30
X146 x137/m1_537_501 x137/m1_406_797 x145/a_0_0 GND sky130_fd_pr__nfet_01v8 ad=-7.16n pd=-0.488m as=0 ps=0 w=602 l=30
X147 VDD D x137/m1_537_501 VDD sky130_fd_pr__pfet_01v8 ad=0 pd=0 as=46.4n ps=1.83m w=400 l=30
X148 x137/m1_537_501 D VDD VDD sky130_fd_pr__pfet_01v8 ad=0 pd=0 as=0 ps=0 w=400 l=30
X149 VDD x137/m1_406_797 x137/m1_537_501 VDD sky130_fd_pr__pfet_01v8 ad=0 pd=0 as=0 ps=0 w=400 l=30
X150 x137/m1_537_501 x137/m1_406_797 VDD VDD sky130_fd_pr__pfet_01v8 ad=0 pd=0 as=0 ps=0 w=400 l=30
X151 GND x137/m1_537_501 x152/a_0_0 GND sky130_fd_pr__nfet_01v8 ad=0 pd=0 as=78.2n ps=2.61m w=602 l=30
X153 x137/m1_406_797 z@10 x154/li_393_182 GND sky130_fd_pr__nfet_01v8 ad=1p pd=-87u as=52.7n ps=1.92m w=602 l=30
X155 x154/li_393_182 CLK x152/a_0_0 GND sky130_fd_pr__nfet_01v8 ad=0 pd=0 as=0 ps=0 w=600 l=30
X156 VDD x137/m1_537_501 x137/m1_406_797 VDD sky130_fd_pr__pfet_01v8 ad=0 pd=0 as=69.6n ps=2.75m w=400 l=30
X157 x137/m1_406_797 x137/m1_537_501 VDD VDD sky130_fd_pr__pfet_01v8 ad=0 pd=0 as=0 ps=0 w=400 l=30
X158 VDD CLK x137/m1_406_797 VDD sky130_fd_pr__pfet_01v8 ad=0 pd=0 as=0 ps=0 w=400 l=30
X159 x137/m1_406_797 CLK VDD VDD sky130_fd_pr__pfet_01v8 ad=0 pd=0 as=0 ps=0 w=400 l=30
X160 VDD z@10 x137/m1_406_797 VDD sky130_fd_pr__pfet_01v8 ad=0 pd=0 as=0 ps=0 w=400 l=30
X161 x137/m1_406_797 z@10 VDD VDD sky130_fd_pr__pfet_01v8 ad=0 pd=0 as=0 ps=0 w=400 l=30
X162 GND m1_13659_981 x163/a_0_0 GND sky130_fd_pr__nfet_01v8 ad=0 pd=0 as=78.2n ps=2.61m w=602 l=30
X164 m1_13511_907 z@10 x165/li_393_182 GND sky130_fd_pr__nfet_01v8 ad=-7.16n pd=-0.841m as=52.7n ps=1.92m w=602 l=30
X166 x165/li_393_182 SN x163/a_0_0 GND sky130_fd_pr__nfet_01v8 ad=0 pd=0 as=0 ps=0 w=600 l=30
X167 VDD m1_13659_981 m1_13511_907 VDD sky130_fd_pr__pfet_01v8 ad=0 pd=0 as=69.6n ps=2.75m w=400 l=30
X168 m1_13511_907 m1_13659_981 VDD VDD sky130_fd_pr__pfet_01v8 ad=0 pd=0 as=0 ps=0 w=400 l=30
X169 VDD SN m1_13511_907 VDD sky130_fd_pr__pfet_01v8 ad=0 pd=0 as=0 ps=0 w=400 l=30
X170 m1_13511_907 SN VDD VDD sky130_fd_pr__pfet_01v8 ad=0 pd=0 as=0 ps=0 w=400 l=30
X171 VDD z@10 m1_13511_907 VDD sky130_fd_pr__pfet_01v8 ad=0 pd=0 as=0 ps=0 w=400 l=30
X172 m1_13511_907 z@10 VDD VDD sky130_fd_pr__pfet_01v8 ad=0 pd=0 as=0 ps=0 w=400 l=30
X173 GND x137/m1_537_501 x174/a_0_0 GND sky130_fd_pr__nfet_01v8 ad=0 pd=0 as=78.2n ps=2.61m w=602 l=30
X175 z@11 z@10 x176/li_393_182 GND sky130_fd_pr__nfet_01v8 ad=1p pd=-87u as=52.7n ps=1.92m w=602 l=30
X177 x176/li_393_182 SN x174/a_0_0 GND sky130_fd_pr__nfet_01v8 ad=0 pd=0 as=0 ps=0 w=600 l=30
X178 VDD x137/m1_537_501 z@11 VDD sky130_fd_pr__pfet_01v8 ad=0 pd=0 as=69.6n ps=2.75m w=400 l=30
X179 z@11 x137/m1_537_501 VDD VDD sky130_fd_pr__pfet_01v8 ad=0 pd=0 as=0 ps=0 w=400 l=30
X180 VDD SN z@11 VDD sky130_fd_pr__pfet_01v8 ad=0 pd=0 as=0 ps=0 w=400 l=30
X181 z@11 SN VDD VDD sky130_fd_pr__pfet_01v8 ad=0 pd=0 as=0 ps=0 w=400 l=30
X182 VDD z@10 z@11 VDD sky130_fd_pr__pfet_01v8 ad=0 pd=0 as=0 ps=0 w=400 l=30
X183 z@11 z@10 VDD VDD sky130_fd_pr__pfet_01v8 ad=0 pd=0 as=0 ps=0 w=400 l=30
X184 GND z@11 x185/a_0_0 GND sky130_fd_pr__nfet_01v8 ad=0 pd=0 as=77.2n ps=2.61m w=602 l=30
X186 z@10 CLK x185/a_0_0 GND sky130_fd_pr__nfet_01v8 ad=7.16n pd=0.314m as=0 ps=0 w=602 l=30
X187 VDD z@11 z@10 VDD sky130_fd_pr__pfet_01v8 ad=0 pd=0 as=46.4n ps=1.83m w=400 l=30
X188 z@10 z@11 VDD VDD sky130_fd_pr__pfet_01v8 ad=0 pd=0 as=0 ps=0 w=400 l=30
X189 VDD CLK z@10 VDD sky130_fd_pr__pfet_01v8 ad=0 pd=0 as=0 ps=0 w=400 l=30
X190 z@10 CLK VDD VDD sky130_fd_pr__pfet_01v8 ad=0 pd=0 as=0 ps=0 w=400 l=30
C0 m1_3704_685 m1_9737_537 2.99f
C1 m1_3704_685 D 3.09f
C2 CLK VDD 3.34f
.ends

** hspice subcircuit dictionary
* x1	voter3x1_pcell_0/votern3x1_pcell_0/nmos_top_0
* x3	voter3x1_pcell_0/votern3x1_pcell_0/nmos_bottom_1
* x5	voter3x1_pcell_0/votern3x1_pcell_0/nmos_bottom_2
* x7	voter3x1_pcell_0/votern3x1_pcell_0
* x10	voter3x1_pcell_0
* x27	dffsnx1_pcell_0
* x28	dffsnx1_pcell_0/nand2x1_pcell_2/nmos_bottom_0
* x35	dffsnx1_pcell_0/nand2x1_pcell_5/nmos_bottom_0
* x42	dffsnx1_pcell_0/nand3x1_pcell_0/nmos_bottom_0
* x44	dffsnx1_pcell_0/nand3x1_pcell_0
* x53	dffsnx1_pcell_0/nand3x1_pcell_1/nmos_bottom_0
* x55	dffsnx1_pcell_0/nand3x1_pcell_1
* x64	dffsnx1_pcell_0/nand3x1_pcell_2/nmos_bottom_0
* x66	dffsnx1_pcell_0/nand3x1_pcell_2
* x75	dffsnx1_pcell_0/nand2x1_pcell_0/nmos_bottom_0
* x82	dffsnx1_pcell_1
* x83	dffsnx1_pcell_1/nand2x1_pcell_2/nmos_bottom_0
* x90	dffsnx1_pcell_1/nand2x1_pcell_5/nmos_bottom_0
* x97	dffsnx1_pcell_1/nand3x1_pcell_0/nmos_bottom_0
* x99	dffsnx1_pcell_1/nand3x1_pcell_0
* x108	dffsnx1_pcell_1/nand3x1_pcell_1/nmos_bottom_0
* x110	dffsnx1_pcell_1/nand3x1_pcell_1
* x119	dffsnx1_pcell_1/nand3x1_pcell_2/nmos_bottom_0
* x121	dffsnx1_pcell_1/nand3x1_pcell_2
* x130	dffsnx1_pcell_1/nand2x1_pcell_0/nmos_bottom_0
* x137	dffsnx1_pcell_2
* x138	dffsnx1_pcell_2/nand2x1_pcell_2/nmos_bottom_0
* x145	dffsnx1_pcell_2/nand2x1_pcell_5/nmos_bottom_0
* x152	dffsnx1_pcell_2/nand3x1_pcell_0/nmos_bottom_0
* x154	dffsnx1_pcell_2/nand3x1_pcell_0
* x163	dffsnx1_pcell_2/nand3x1_pcell_1/nmos_bottom_0
* x165	dffsnx1_pcell_2/nand3x1_pcell_1
* x174	dffsnx1_pcell_2/nand3x1_pcell_2/nmos_bottom_0
* x176	dffsnx1_pcell_2/nand3x1_pcell_2
* x185	dffsnx1_pcell_2/nand2x1_pcell_0/nmos_bottom_0
