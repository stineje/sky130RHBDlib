* HSPICE file created from DFFRNQNX1.ext - technology: sky130A

.option scale=5m

.subckt DFFRNQNX1 QN D CLK RN VDD GND
X0 GND x1/m1_241_797 x2/a_0_0 GND sky130_fd_pr__nfet_01v8 ad=2.39n pd=0.111m as=15.7n ps=0.599m w=602 l=30
X3 x1/m1_867_723 x1/m1_689_649 x4/li_393_182 GND sky130_fd_pr__nfet_01v8 ad=2.39n pd=0.111m as=15.8n ps=0.594m w=602 l=30
X5 x4/li_393_182 CLK x2/a_0_0 GND sky130_fd_pr__nfet_01v8 ad=2.18n pd=0.106m as=16.2n ps=0.604m w=600 l=30
X6 VDD x1/m1_241_797 x1/m1_867_723 VDD sky130_fd_pr__pfet_01v8 ad=21.6n pd=0.908m as=11.6n ps=0.458m w=400 l=30
X7 x1/m1_867_723 x1/m1_241_797 VDD VDD sky130_fd_pr__pfet_01v8 ad=11.6n pd=0.458m as=22.4n ps=0.912m w=400 l=30
X8 VDD CLK x1/m1_867_723 VDD sky130_fd_pr__pfet_01v8 ad=0.392u pd=0.016 as=69.6n ps=2.75m w=400 l=30
X9 x1/m1_867_723 CLK VDD VDD sky130_fd_pr__pfet_01v8 ad=0 pd=0 as=0 ps=0 w=400 l=30
X10 VDD x1/m1_689_649 x1/m1_867_723 VDD sky130_fd_pr__pfet_01v8 ad=0 pd=0 as=0 ps=0 w=400 l=30
X11 x1/m1_867_723 x1/m1_689_649 VDD VDD sky130_fd_pr__pfet_01v8 ad=0 pd=0 as=0 ps=0 w=400 l=30
X12 GND x1/m1_867_723 x13/a_0_0 GND sky130_fd_pr__nfet_01v8 ad=64.5n pd=2.21m as=78.2n ps=2.61m w=602 l=30
X14 x1/m1_689_649 RN x15/li_393_182 GND sky130_fd_pr__nfet_01v8 ad=1p pd=-87u as=52.7n ps=1.92m w=602 l=30
X16 x15/li_393_182 D x13/a_0_0 GND sky130_fd_pr__nfet_01v8 ad=0 pd=0 as=0 ps=0 w=600 l=30
X17 VDD x1/m1_867_723 x1/m1_689_649 VDD sky130_fd_pr__pfet_01v8 ad=0 pd=0 as=69.6n ps=2.75m w=400 l=30
X18 x1/m1_689_649 x1/m1_867_723 VDD VDD sky130_fd_pr__pfet_01v8 ad=0 pd=0 as=0 ps=0 w=400 l=30
X19 VDD D x1/m1_689_649 VDD sky130_fd_pr__pfet_01v8 ad=0 pd=0 as=0 ps=0 w=400 l=30
X20 x1/m1_689_649 D VDD VDD sky130_fd_pr__pfet_01v8 ad=0 pd=0 as=0 ps=0 w=400 l=30
X21 VDD RN x1/m1_689_649 VDD sky130_fd_pr__pfet_01v8 ad=0 pd=0 as=0 ps=0 w=400 l=30
X22 x1/m1_689_649 RN VDD VDD sky130_fd_pr__pfet_01v8 ad=0 pd=0 as=0 ps=0 w=400 l=30
X23 GND x1/m1_2461_649 x24/a_0_0 GND sky130_fd_pr__nfet_01v8 ad=0 pd=0 as=78.2n ps=2.61m w=602 l=30
X25 x1/m1_241_797 RN x26/li_393_182 GND sky130_fd_pr__nfet_01v8 ad=1p pd=-87u as=52.7n ps=1.92m w=602 l=30
X27 x26/li_393_182 CLK x24/a_0_0 GND sky130_fd_pr__nfet_01v8 ad=0 pd=0 as=0 ps=0 w=600 l=30
X28 VDD x1/m1_2461_649 x1/m1_241_797 VDD sky130_fd_pr__pfet_01v8 ad=0 pd=0 as=69.6n ps=2.75m w=400 l=30
X29 x1/m1_241_797 x1/m1_2461_649 VDD VDD sky130_fd_pr__pfet_01v8 ad=0 pd=0 as=0 ps=0 w=400 l=30
X30 VDD CLK x1/m1_241_797 VDD sky130_fd_pr__pfet_01v8 ad=0 pd=0 as=0 ps=0 w=400 l=30
X31 x1/m1_241_797 CLK VDD VDD sky130_fd_pr__pfet_01v8 ad=0 pd=0 as=0 ps=0 w=400 l=30
X32 VDD RN x1/m1_241_797 VDD sky130_fd_pr__pfet_01v8 ad=0 pd=0 as=0 ps=0 w=400 l=30
X33 x1/m1_241_797 RN VDD VDD sky130_fd_pr__pfet_01v8 ad=0 pd=0 as=0 ps=0 w=400 l=30
X34 GND x1/m1_867_723 x35/a_0_0 GND sky130_fd_pr__nfet_01v8 ad=0 pd=0 as=78.2n ps=2.61m w=602 l=30
X36 QN x37/li_n17_n33 x38/li_393_182 GND sky130_fd_pr__nfet_01v8 ad=1p pd=-87u as=52.7n ps=1.92m w=602 l=30
X39 x38/li_393_182 RN x35/a_0_0 GND sky130_fd_pr__nfet_01v8 ad=0 pd=0 as=0 ps=0 w=600 l=30
X40 VDD x1/m1_867_723 QN VDD sky130_fd_pr__pfet_01v8 ad=0 pd=0 as=69.6n ps=2.75m w=400 l=30
X41 QN x1/m1_867_723 VDD VDD sky130_fd_pr__pfet_01v8 ad=0 pd=0 as=0 ps=0 w=400 l=30
X42 VDD RN QN VDD sky130_fd_pr__pfet_01v8 ad=0 pd=0 as=0 ps=0 w=400 l=30
X43 QN RN VDD VDD sky130_fd_pr__pfet_01v8 ad=0 pd=0 as=0 ps=0 w=400 l=30
X44 VDD x37/li_n17_n33 QN VDD sky130_fd_pr__pfet_01v8 ad=0 pd=0 as=0 ps=0 w=400 l=30
X45 QN x37/li_n17_n33 VDD VDD sky130_fd_pr__pfet_01v8 ad=0 pd=0 as=0 ps=0 w=400 l=30
X46 GND x1/m1_689_649 x47/a_0_0 GND sky130_fd_pr__nfet_01v8 ad=0 pd=0 as=77.2n ps=2.61m w=602 l=30
X48 x1/m1_2461_649 x1/m1_241_797 x47/a_0_0 GND sky130_fd_pr__nfet_01v8 ad=1p pd=-87u as=0 ps=0 w=602 l=30
X49 VDD x1/m1_689_649 x1/m1_2461_649 VDD sky130_fd_pr__pfet_01v8 ad=0 pd=0 as=46.4n ps=1.83m w=400 l=30
X50 x1/m1_2461_649 x1/m1_689_649 VDD VDD sky130_fd_pr__pfet_01v8 ad=0 pd=0 as=0 ps=0 w=400 l=30
X51 VDD x1/m1_241_797 x1/m1_2461_649 VDD sky130_fd_pr__pfet_01v8 ad=0 pd=0 as=0 ps=0 w=400 l=30
X52 x1/m1_2461_649 x1/m1_241_797 VDD VDD sky130_fd_pr__pfet_01v8 ad=0 pd=0 as=0 ps=0 w=400 l=30
X53 GND QN x54/a_0_0 GND sky130_fd_pr__nfet_01v8 ad=0 pd=0 as=77.2n ps=2.61m w=602 l=30
X55 m1_4369_759 x1/m1_241_797 x54/a_0_0 GND sky130_fd_pr__nfet_01v8 ad=7.16n pd=0.314m as=0 ps=0 w=602 l=30
X56 VDD QN m1_4369_759 VDD sky130_fd_pr__pfet_01v8 ad=0 pd=0 as=46.4n ps=1.83m w=400 l=30
X57 m1_4369_759 QN VDD VDD sky130_fd_pr__pfet_01v8 ad=0 pd=0 as=0 ps=0 w=400 l=30
X58 VDD x1/m1_241_797 m1_4369_759 VDD sky130_fd_pr__pfet_01v8 ad=0 pd=0 as=0 ps=0 w=400 l=30
X59 m1_4369_759 x1/m1_241_797 VDD VDD sky130_fd_pr__pfet_01v8 ad=0 pd=0 as=0 ps=0 w=400 l=30
.ends

** hspice subcircuit dictionary
* x1	dffrnx1_pcell_0
* x2	dffrnx1_pcell_0/nand3x1_pcell_0/nmos_bottom_0
* x4	dffrnx1_pcell_0/nand3x1_pcell_0
* x13	dffrnx1_pcell_0/nand3x1_pcell_1/nmos_bottom_0
* x15	dffrnx1_pcell_0/nand3x1_pcell_1
* x24	dffrnx1_pcell_0/nand3x1_pcell_3/nmos_bottom_0
* x26	dffrnx1_pcell_0/nand3x1_pcell_3
* x35	dffrnx1_pcell_0/nand3x1_pcell_4/nmos_bottom_0
* x37	li1_M1_contact_0
* x38	dffrnx1_pcell_0/nand3x1_pcell_4
* x47	dffrnx1_pcell_0/nand2x1_pcell_0/nmos_bottom_0
* x54	dffrnx1_pcell_0/nand2x1_pcell_1/nmos_bottom_0
