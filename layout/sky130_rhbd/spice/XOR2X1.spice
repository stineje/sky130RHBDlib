* HSPICE file created from XOR2X1.ext - technology: sky130A

.option scale=5m

.subckt XOR2X1 Y A B VDD GND
X0 x1/VSUBS A x2/a_0_0 x1/VSUBS sky130_fd_pr__nfet_01v8 ad=2.39n pd=0.111m as=15.7n ps=0.599m w=602 l=30
X3 x1/VSUBS x4/m1_939_797 x5/a_0_0 x1/VSUBS sky130_fd_pr__nfet_01v8 ad=60n pd=2.25m as=77.2n ps=2.61m w=602 l=30
X6 VDD A x4/a_761_1330 VDD sky130_fd_pr__pfet_01v8 ad=11.6n pd=0.458m as=22.4n ps=0.912m w=400 l=30
X7 x4/a_761_1330 A VDD VDD sky130_fd_pr__pfet_01v8 ad=21.6n pd=0.908m as=11.6n ps=0.458m w=400 l=30
X8 Y x4/m1_315_501 x5/a_0_0 x1/VSUBS sky130_fd_pr__nfet_01v8 ad=2.39n pd=0.111m as=15.8n ps=0.594m w=602 l=30
X9 Y B x2/a_0_0 x1/VSUBS sky130_fd_pr__nfet_01v8 ad=35.8n pd=2.36m as=77.2n ps=2.61m w=602 l=30
X10 Y x4/m1_939_797 x4/a_761_1330 VDD sky130_fd_pr__pfet_01v8 ad=92.8n pd=3.66m as=67.2n ps=2.74m w=400 l=30
X11 x4/a_761_1330 x4/m1_939_797 Y VDD sky130_fd_pr__pfet_01v8 ad=0 pd=0 as=0 ps=0 w=400 l=30
X12 VDD B x4/a_1427_1330 VDD sky130_fd_pr__pfet_01v8 ad=0.134u pd=5.47m as=67.2n ps=2.74m w=400 l=30
X13 x4/a_1427_1330 B VDD VDD sky130_fd_pr__pfet_01v8 ad=0 pd=0 as=0 ps=0 w=400 l=30
X14 Y x4/m1_315_501 x4/a_1427_1330 VDD sky130_fd_pr__pfet_01v8 ad=0 pd=0 as=0 ps=0 w=400 l=30
X15 x4/a_1427_1330 x4/m1_315_501 Y VDD sky130_fd_pr__pfet_01v8 ad=0 pd=0 as=0 ps=0 w=400 l=30
X16 x4/m1_315_501 A x1/VSUBS x1/VSUBS sky130_fd_pr__nfet_01v8 ad=2.39n pd=0.111m as=15.6n ps=0.592m w=602 l=30
X17 VDD A x4/m1_315_501 VDD sky130_fd_pr__pfet_01v8 ad=21.6n pd=0.908m as=11.6n ps=0.458m w=400 l=30
X18 x4/m1_315_501 A VDD VDD sky130_fd_pr__pfet_01v8 ad=11.6n pd=0.458m as=22.4n ps=0.912m w=400 l=30
X19 x4/m1_939_797 B x20/VSUBS x20/VSUBS sky130_fd_pr__nfet_01v8 ad=7.16n pd=0.314m as=60n ps=2.78m w=602 l=30
X21 VDD B x4/m1_939_797 VDD sky130_fd_pr__pfet_01v8 ad=0 pd=0 as=46.4n ps=1.83m w=400 l=30
X22 x4/m1_939_797 B VDD VDD sky130_fd_pr__pfet_01v8 ad=0 pd=0 as=0 ps=0 w=400 l=30
.ends

** hspice subcircuit dictionary
* x1	xor2X1_pcell_0/pmos2_1_3
* x2	xor2X1_pcell_0/nmos_bottom_0
* x4	xor2X1_pcell_0
* x5	xor2X1_pcell_0/nmos_bottom_1
* x20	xor2X1_pcell_0/li1_M1_contact_2
