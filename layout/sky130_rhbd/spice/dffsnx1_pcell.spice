* HSPICE file created from dffsnx1_pcell.ext - technology: sky130A

.option scale=5m

.subckt dffsnx1_pcell
X0 VSUBS m1_406_797 x1/a_0_0 VSUBS sky130_fd_pr__nfet_01v8 ad=2.39n pd=0.111m as=15.7n ps=0.599m w=602 l=30
X2 x3/a_229_1059 x3/a_362_382 x1/a_0_0 VSUBS sky130_fd_pr__nfet_01v8 ad=2.39n pd=0.111m as=15.8n ps=0.594m w=602 l=30
X4 x5/w_87_786 m1_406_797 x3/a_229_1059 x5/w_87_786 sky130_fd_pr__pfet_01v8 ad=21.6n pd=0.908m as=11.6n ps=0.458m w=400 l=30
X6 x3/a_229_1059 m1_406_797 x5/w_87_786 x5/w_87_786 sky130_fd_pr__pfet_01v8 ad=11.6n pd=0.458m as=22.4n ps=0.912m w=400 l=30
X7 x5/w_87_786 x3/a_362_382 x3/a_229_1059 x5/w_87_786 sky130_fd_pr__pfet_01v8 ad=0.473u pd=0.0192 as=46.4n ps=1.83m w=400 l=30
X8 x3/a_229_1059 x3/a_362_382 x5/w_87_786 x5/w_87_786 sky130_fd_pr__pfet_01v8 ad=0 pd=0 as=0 ps=0 w=400 l=30
X9 VSUBS x10/a_168_375 x11/a_0_0 VSUBS sky130_fd_pr__nfet_01v8 ad=86n pd=4.3m as=77.2n ps=2.61m w=602 l=30
X12 m1_537_501 m1_406_797 x11/a_0_0 VSUBS sky130_fd_pr__nfet_01v8 ad=-7.16n pd=-0.488m as=0 ps=0 w=602 l=30
X13 x5/w_87_786 x10/a_168_375 m1_537_501 x5/w_87_786 sky130_fd_pr__pfet_01v8 ad=0 pd=0 as=46.4n ps=1.83m w=400 l=30
X14 m1_537_501 x10/a_168_375 x5/w_87_786 x5/w_87_786 sky130_fd_pr__pfet_01v8 ad=0 pd=0 as=0 ps=0 w=400 l=30
X15 x5/w_87_786 m1_406_797 m1_537_501 x5/w_87_786 sky130_fd_pr__pfet_01v8 ad=0 pd=0 as=0 ps=0 w=400 l=30
X16 m1_537_501 m1_406_797 x5/w_87_786 x5/w_87_786 sky130_fd_pr__pfet_01v8 ad=0 pd=0 as=0 ps=0 w=400 l=30
X17 VSUBS m1_537_501 x18/a_0_0 VSUBS sky130_fd_pr__nfet_01v8 ad=0 pd=0 as=78.2n ps=2.61m w=602 l=30
X19 m1_406_797 m1_1351_723 x20/li_393_182 VSUBS sky130_fd_pr__nfet_01v8 ad=1p pd=-87u as=52.7n ps=1.92m w=602 l=30
X21 x20/li_393_182 m1_1093_871 x18/a_0_0 VSUBS sky130_fd_pr__nfet_01v8 ad=2.18n pd=0.106m as=16.2n ps=0.604m w=600 l=30
X22 x5/w_87_786 m1_537_501 m1_406_797 x5/w_87_786 sky130_fd_pr__pfet_01v8 ad=0 pd=0 as=69.6n ps=2.75m w=400 l=30
X23 m1_406_797 m1_537_501 x5/w_87_786 x5/w_87_786 sky130_fd_pr__pfet_01v8 ad=0 pd=0 as=0 ps=0 w=400 l=30
X24 x5/w_87_786 m1_1093_871 m1_406_797 x5/w_87_786 sky130_fd_pr__pfet_01v8 ad=0 pd=0 as=0 ps=0 w=400 l=30
X25 m1_406_797 m1_1093_871 x5/w_87_786 x5/w_87_786 sky130_fd_pr__pfet_01v8 ad=0 pd=0 as=0 ps=0 w=400 l=30
X26 x5/w_87_786 m1_1351_723 m1_406_797 x5/w_87_786 sky130_fd_pr__pfet_01v8 ad=0 pd=0 as=0 ps=0 w=400 l=30
X27 m1_406_797 m1_1351_723 x5/w_87_786 x5/w_87_786 sky130_fd_pr__pfet_01v8 ad=0 pd=0 as=0 ps=0 w=400 l=30
X28 VSUBS x29/a_147_377 x30/a_0_0 VSUBS sky130_fd_pr__nfet_01v8 ad=0 pd=0 as=78.2n ps=2.61m w=602 l=30
X31 x29/a_289_1059 m1_1351_723 x29/li_393_182 VSUBS sky130_fd_pr__nfet_01v8 ad=7.16n pd=0.314m as=52.7n ps=1.92m w=602 l=30
X32 x29/li_393_182 m1_2055_427 x30/a_0_0 VSUBS sky130_fd_pr__nfet_01v8 ad=0 pd=0 as=0 ps=0 w=600 l=30
X33 x5/w_87_786 x29/a_147_377 x29/a_289_1059 x5/w_87_786 sky130_fd_pr__pfet_01v8 ad=0 pd=0 as=69.6n ps=2.75m w=400 l=30
X34 x29/a_289_1059 x29/a_147_377 x5/w_87_786 x5/w_87_786 sky130_fd_pr__pfet_01v8 ad=0 pd=0 as=0 ps=0 w=400 l=30
X35 x5/w_87_786 m1_2055_427 x29/a_289_1059 x5/w_87_786 sky130_fd_pr__pfet_01v8 ad=0 pd=0 as=0 ps=0 w=400 l=30
X36 x29/a_289_1059 m1_2055_427 x5/w_87_786 x5/w_87_786 sky130_fd_pr__pfet_01v8 ad=0 pd=0 as=0 ps=0 w=400 l=30
X37 x5/w_87_786 m1_1351_723 x29/a_289_1059 x5/w_87_786 sky130_fd_pr__pfet_01v8 ad=0 pd=0 as=0 ps=0 w=400 l=30
X38 x29/a_289_1059 m1_1351_723 x5/w_87_786 x5/w_87_786 sky130_fd_pr__pfet_01v8 ad=0 pd=0 as=0 ps=0 w=400 l=30
X39 VSUBS m1_537_501 x40/a_0_0 VSUBS sky130_fd_pr__nfet_01v8 ad=0 pd=0 as=78.2n ps=2.61m w=602 l=30
X41 m1_2461_501 m1_1351_723 x5/li_393_182 VSUBS sky130_fd_pr__nfet_01v8 ad=1p pd=-87u as=52.7n ps=1.92m w=602 l=30
X42 x5/li_393_182 m1_2055_427 x40/a_0_0 VSUBS sky130_fd_pr__nfet_01v8 ad=0 pd=0 as=0 ps=0 w=600 l=30
X43 x5/w_87_786 m1_537_501 m1_2461_501 x5/w_87_786 sky130_fd_pr__pfet_01v8 ad=0 pd=0 as=69.6n ps=2.75m w=400 l=30
X44 m1_2461_501 m1_537_501 x5/w_87_786 x5/w_87_786 sky130_fd_pr__pfet_01v8 ad=0 pd=0 as=0 ps=0 w=400 l=30
X45 x5/w_87_786 m1_2055_427 m1_2461_501 x5/w_87_786 sky130_fd_pr__pfet_01v8 ad=0 pd=0 as=0 ps=0 w=400 l=30
X46 m1_2461_501 m1_2055_427 x5/w_87_786 x5/w_87_786 sky130_fd_pr__pfet_01v8 ad=0 pd=0 as=0 ps=0 w=400 l=30
X47 x5/w_87_786 m1_1351_723 m1_2461_501 x5/w_87_786 sky130_fd_pr__pfet_01v8 ad=0 pd=0 as=0 ps=0 w=400 l=30
X48 m1_2461_501 m1_1351_723 x5/w_87_786 x5/w_87_786 sky130_fd_pr__pfet_01v8 ad=0 pd=0 as=0 ps=0 w=400 l=30
X49 VSUBS m1_2461_501 x50/a_0_0 VSUBS sky130_fd_pr__nfet_01v8 ad=0 pd=0 as=77.2n ps=2.61m w=602 l=30
X51 m1_1351_723 m1_1093_871 x50/a_0_0 VSUBS sky130_fd_pr__nfet_01v8 ad=7.16n pd=0.314m as=0 ps=0 w=602 l=30
X52 x5/w_87_786 m1_2461_501 m1_1351_723 x5/w_87_786 sky130_fd_pr__pfet_01v8 ad=0 pd=0 as=46.4n ps=1.83m w=400 l=30
X53 m1_1351_723 m1_2461_501 x5/w_87_786 x5/w_87_786 sky130_fd_pr__pfet_01v8 ad=0 pd=0 as=0 ps=0 w=400 l=30
X54 x5/w_87_786 m1_1093_871 m1_1351_723 x5/w_87_786 sky130_fd_pr__pfet_01v8 ad=0 pd=0 as=0 ps=0 w=400 l=30
X55 m1_1351_723 m1_1093_871 x5/w_87_786 x5/w_87_786 sky130_fd_pr__pfet_01v8 ad=0 pd=0 as=0 ps=0 w=400 l=30
.ends

** hspice subcircuit dictionary
* x1	nand2x1_pcell_2/nmos_bottom_0
* x3	nand2x1_pcell_2
* x5	nand3x1_pcell_2
* x10	nand2x1_pcell_5
* x11	nand2x1_pcell_5/nmos_bottom_0
* x18	nand3x1_pcell_0/nmos_bottom_0
* x20	nand3x1_pcell_0
* x29	nand3x1_pcell_1
* x30	nand3x1_pcell_1/nmos_bottom_0
* x40	nand3x1_pcell_2/nmos_bottom_0
* x50	nand2x1_pcell_0/nmos_bottom_0
