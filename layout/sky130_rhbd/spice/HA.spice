* HSPICE file created from HA.ext - technology: sky130A

.option scale=5m

.subckt HA SUM COUT A B VDD GND
X0 x1/VSUBS A x2/a_0_0 x1/VSUBS sky130_fd_pr__nfet_01v8 ad=2.39n pd=0.111m as=15.7n ps=0.599m w=602 l=30
X3 x1/VSUBS x4/m1_939_797 x5/a_0_0 x1/VSUBS sky130_fd_pr__nfet_01v8 ad=60n pd=2.25m as=77.2n ps=2.61m w=602 l=30
X6 VDD A x4/a_761_1330 VDD sky130_fd_pr__pfet_01v8 ad=11.6n pd=0.458m as=22.4n ps=0.912m w=400 l=30
X7 x4/a_761_1330 A VDD VDD sky130_fd_pr__pfet_01v8 ad=21.6n pd=0.908m as=11.6n ps=0.458m w=400 l=30
X8 SUM x4/m1_315_501 x5/a_0_0 x1/VSUBS sky130_fd_pr__nfet_01v8 ad=2.39n pd=0.111m as=15.8n ps=0.594m w=602 l=30
X9 SUM B x2/a_0_0 x1/VSUBS sky130_fd_pr__nfet_01v8 ad=21.5n pd=1.91m as=77.2n ps=2.61m w=602 l=30
X10 SUM x4/m1_939_797 x4/a_761_1330 VDD sky130_fd_pr__pfet_01v8 ad=46.4n pd=1.83m as=67.2n ps=2.74m w=400 l=30
X11 x4/a_761_1330 x4/m1_939_797 SUM VDD sky130_fd_pr__pfet_01v8 ad=0 pd=0 as=0 ps=0 w=400 l=30
X12 VDD B x4/a_1427_1330 VDD sky130_fd_pr__pfet_01v8 ad=0.246u pd=0.01 as=67.2n ps=2.74m w=400 l=30
X13 x4/a_1427_1330 B VDD VDD sky130_fd_pr__pfet_01v8 ad=0 pd=0 as=0 ps=0 w=400 l=30
X14 SUM x4/m1_315_501 x4/a_1427_1330 VDD sky130_fd_pr__pfet_01v8 ad=0 pd=0 as=0 ps=0 w=400 l=30
X15 x4/a_1427_1330 x4/m1_315_501 SUM VDD sky130_fd_pr__pfet_01v8 ad=0 pd=0 as=0 ps=0 w=400 l=30
X16 x4/m1_315_501 A x1/VSUBS x1/VSUBS sky130_fd_pr__nfet_01v8 ad=2.39n pd=0.111m as=15.6n ps=0.592m w=602 l=30
X17 VDD A x4/m1_315_501 VDD sky130_fd_pr__pfet_01v8 ad=21.6n pd=0.908m as=11.6n ps=0.458m w=400 l=30
X18 x4/m1_315_501 A VDD VDD sky130_fd_pr__pfet_01v8 ad=11.6n pd=0.458m as=22.4n ps=0.912m w=400 l=30
X19 x4/m1_939_797 B x20/VSUBS x20/VSUBS sky130_fd_pr__nfet_01v8 ad=7.16n pd=0.314m as=60n ps=2.78m w=602 l=30
X21 VDD B x4/m1_939_797 VDD sky130_fd_pr__pfet_01v8 ad=0 pd=0 as=46.4n ps=1.83m w=400 l=30
X22 x4/m1_939_797 B VDD VDD sky130_fd_pr__pfet_01v8 ad=0 pd=0 as=0 ps=0 w=400 l=30
X23 COUT x24/m1_547_649 x24/VSUBS x24/VSUBS sky130_fd_pr__nfet_01v8 ad=7.16n pd=0.314m as=60n ps=2.34m w=602 l=30
X25 VDD x24/m1_547_649 COUT VDD sky130_fd_pr__pfet_01v8 ad=0 pd=0 as=23.2n ps=0.917m w=400 l=30
X26 COUT x24/m1_547_649 VDD VDD sky130_fd_pr__pfet_01v8 ad=0 pd=0 as=0 ps=0 w=400 l=30
X27 x24/VSUBS A x28/a_0_0 x24/VSUBS sky130_fd_pr__nfet_01v8 ad=0 pd=0 as=77.2n ps=2.61m w=602 l=30
X29 x24/m1_547_649 B x28/a_0_0 x24/VSUBS sky130_fd_pr__nfet_01v8 ad=7.16n pd=0.314m as=0 ps=0 w=602 l=30
X30 VDD A x24/m1_547_649 VDD sky130_fd_pr__pfet_01v8 ad=0 pd=0 as=46.4n ps=1.83m w=400 l=30
X31 x24/m1_547_649 A VDD VDD sky130_fd_pr__pfet_01v8 ad=0 pd=0 as=0 ps=0 w=400 l=30
X32 VDD B x24/m1_547_649 VDD sky130_fd_pr__pfet_01v8 ad=0 pd=0 as=0 ps=0 w=400 l=30
X33 x24/m1_547_649 B VDD VDD sky130_fd_pr__pfet_01v8 ad=0 pd=0 as=0 ps=0 w=400 l=30
C0 GND x24/VSUBS 2.74f
.ends

** hspice subcircuit dictionary
* x1	xor2X1_pcell_0/pmos2_1_3
* x2	xor2X1_pcell_0/nmos_bottom_0
* x4	xor2X1_pcell_0
* x5	xor2X1_pcell_0/nmos_bottom_1
* x20	xor2X1_pcell_0/li1_M1_contact_2
* x24	and2x1_pcell_0
* x28	and2x1_pcell_0/nand2x1_pcell_0/nmos_bottom_0
