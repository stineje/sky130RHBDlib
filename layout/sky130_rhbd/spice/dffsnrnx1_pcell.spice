* HSPICE file created from dffsnrnx1_pcell.ext - technology: sky130A

.option scale=5m

.subckt dffsnrnx1_pcell
X0 VSUBS x1/a_147_377 x2/a_0_0 VSUBS sky130_fd_pr__nfet_01v8 ad=2.39n pd=0.111m as=15.7n ps=0.599m w=602 l=30
X3 m1_831_501 m1_716_649 x1/li_393_182 VSUBS sky130_fd_pr__nfet_01v8 ad=2.39n pd=0.111m as=15.8n ps=0.594m w=602 l=30
X4 x1/li_393_182 m1_426_427 x2/a_0_0 VSUBS sky130_fd_pr__nfet_01v8 ad=2.18n pd=0.106m as=16.2n ps=0.604m w=600 l=30
X5 x6/w_87_786 x1/a_147_377 m1_831_501 x6/w_87_786 sky130_fd_pr__pfet_01v8 ad=21.6n pd=0.908m as=11.6n ps=0.458m w=400 l=30
X7 m1_831_501 x1/a_147_377 x6/w_87_786 x6/w_87_786 sky130_fd_pr__pfet_01v8 ad=11.6n pd=0.458m as=22.4n ps=0.912m w=400 l=30
X8 x6/w_87_786 m1_426_427 m1_831_501 x6/w_87_786 sky130_fd_pr__pfet_01v8 ad=0.542u pd=0.0219 as=69.6n ps=2.75m w=400 l=30
X9 m1_831_501 m1_426_427 x6/w_87_786 x6/w_87_786 sky130_fd_pr__pfet_01v8 ad=0 pd=0 as=0 ps=0 w=400 l=30
X10 x6/w_87_786 m1_716_649 m1_831_501 x6/w_87_786 sky130_fd_pr__pfet_01v8 ad=0 pd=0 as=0 ps=0 w=400 l=30
X11 m1_831_501 m1_716_649 x6/w_87_786 x6/w_87_786 sky130_fd_pr__pfet_01v8 ad=0 pd=0 as=0 ps=0 w=400 l=30
X12 VSUBS m1_831_501 x13/a_0_0 VSUBS sky130_fd_pr__nfet_01v8 ad=86n pd=4.3m as=78.2n ps=2.61m w=602 l=30
X14 m1_716_649 m1_1660_723 x15/li_393_182 VSUBS sky130_fd_pr__nfet_01v8 ad=1p pd=-87u as=52.7n ps=1.92m w=602 l=30
X16 x15/li_393_182 m1_1377_871 x13/a_0_0 VSUBS sky130_fd_pr__nfet_01v8 ad=0 pd=0 as=0 ps=0 w=600 l=30
X17 x6/w_87_786 m1_831_501 m1_716_649 x6/w_87_786 sky130_fd_pr__pfet_01v8 ad=0 pd=0 as=69.6n ps=2.75m w=400 l=30
X18 m1_716_649 m1_831_501 x6/w_87_786 x6/w_87_786 sky130_fd_pr__pfet_01v8 ad=0 pd=0 as=0 ps=0 w=400 l=30
X19 x6/w_87_786 m1_1377_871 m1_716_649 x6/w_87_786 sky130_fd_pr__pfet_01v8 ad=0 pd=0 as=0 ps=0 w=400 l=30
X20 m1_716_649 m1_1377_871 x6/w_87_786 x6/w_87_786 sky130_fd_pr__pfet_01v8 ad=0 pd=0 as=0 ps=0 w=400 l=30
X21 x6/w_87_786 m1_1660_723 m1_716_649 x6/w_87_786 sky130_fd_pr__pfet_01v8 ad=0 pd=0 as=0 ps=0 w=400 l=30
X22 m1_716_649 m1_1660_723 x6/w_87_786 x6/w_87_786 sky130_fd_pr__pfet_01v8 ad=0 pd=0 as=0 ps=0 w=400 l=30
X23 VSUBS m1_831_501 x24/a_0_0 VSUBS sky130_fd_pr__nfet_01v8 ad=0 pd=0 as=78.2n ps=2.61m w=602 l=30
X25 m1_2757_501 m1_1660_723 x26/li_393_182 VSUBS sky130_fd_pr__nfet_01v8 ad=1p pd=-87u as=52.7n ps=1.92m w=602 l=30
X27 x26/li_393_182 m1_2351_575 x24/a_0_0 VSUBS sky130_fd_pr__nfet_01v8 ad=0 pd=0 as=0 ps=0 w=600 l=30
X28 x6/w_87_786 m1_831_501 m1_2757_501 x6/w_87_786 sky130_fd_pr__pfet_01v8 ad=0 pd=0 as=69.6n ps=2.75m w=400 l=30
X29 m1_2757_501 m1_831_501 x6/w_87_786 x6/w_87_786 sky130_fd_pr__pfet_01v8 ad=0 pd=0 as=0 ps=0 w=400 l=30
X30 x6/w_87_786 m1_2351_575 m1_2757_501 x6/w_87_786 sky130_fd_pr__pfet_01v8 ad=0 pd=0 as=0 ps=0 w=400 l=30
X31 m1_2757_501 m1_2351_575 x6/w_87_786 x6/w_87_786 sky130_fd_pr__pfet_01v8 ad=0 pd=0 as=0 ps=0 w=400 l=30
X32 x6/w_87_786 m1_1660_723 m1_2757_501 x6/w_87_786 sky130_fd_pr__pfet_01v8 ad=0 pd=0 as=0 ps=0 w=400 l=30
X33 m1_2757_501 m1_1660_723 x6/w_87_786 x6/w_87_786 sky130_fd_pr__pfet_01v8 ad=0 pd=0 as=0 ps=0 w=400 l=30
X34 VSUBS m1_2757_501 x35/a_0_0 VSUBS sky130_fd_pr__nfet_01v8 ad=0 pd=0 as=78.2n ps=2.61m w=602 l=30
X36 m1_1660_723 m1_426_427 x37/li_393_182 VSUBS sky130_fd_pr__nfet_01v8 ad=7.16n pd=0.314m as=52.7n ps=1.92m w=602 l=30
X38 x37/li_393_182 m1_1377_871 x35/a_0_0 VSUBS sky130_fd_pr__nfet_01v8 ad=0 pd=0 as=0 ps=0 w=600 l=30
X39 x6/w_87_786 m1_2757_501 m1_1660_723 x6/w_87_786 sky130_fd_pr__pfet_01v8 ad=0 pd=0 as=69.6n ps=2.75m w=400 l=30
X40 m1_1660_723 m1_2757_501 x6/w_87_786 x6/w_87_786 sky130_fd_pr__pfet_01v8 ad=0 pd=0 as=0 ps=0 w=400 l=30
X41 x6/w_87_786 m1_1377_871 m1_1660_723 x6/w_87_786 sky130_fd_pr__pfet_01v8 ad=0 pd=0 as=0 ps=0 w=400 l=30
X42 m1_1660_723 m1_1377_871 x6/w_87_786 x6/w_87_786 sky130_fd_pr__pfet_01v8 ad=0 pd=0 as=0 ps=0 w=400 l=30
X43 x6/w_87_786 m1_426_427 m1_1660_723 x6/w_87_786 sky130_fd_pr__pfet_01v8 ad=0 pd=0 as=0 ps=0 w=400 l=30
X44 m1_1660_723 m1_426_427 x6/w_87_786 x6/w_87_786 sky130_fd_pr__pfet_01v8 ad=0 pd=0 as=0 ps=0 w=400 l=30
X45 VSUBS m1_716_649 x46/a_0_0 VSUBS sky130_fd_pr__nfet_01v8 ad=0 pd=0 as=78.2n ps=2.61m w=602 l=30
X47 x48/a_289_1059 x48/li_649_449 x48/li_393_182 VSUBS sky130_fd_pr__nfet_01v8 ad=7.16n pd=0.314m as=52.7n ps=1.92m w=602 l=30
X49 x48/li_393_182 m1_426_427 x46/a_0_0 VSUBS sky130_fd_pr__nfet_01v8 ad=0 pd=0 as=0 ps=0 w=600 l=30
X50 x6/w_87_786 m1_716_649 x48/a_289_1059 x6/w_87_786 sky130_fd_pr__pfet_01v8 ad=0 pd=0 as=69.6n ps=2.75m w=400 l=30
X51 x48/a_289_1059 m1_716_649 x6/w_87_786 x6/w_87_786 sky130_fd_pr__pfet_01v8 ad=0 pd=0 as=0 ps=0 w=400 l=30
X52 x6/w_87_786 m1_426_427 x48/a_289_1059 x6/w_87_786 sky130_fd_pr__pfet_01v8 ad=0 pd=0 as=0 ps=0 w=400 l=30
X53 x48/a_289_1059 m1_426_427 x6/w_87_786 x6/w_87_786 sky130_fd_pr__pfet_01v8 ad=0 pd=0 as=0 ps=0 w=400 l=30
X54 x6/w_87_786 x48/li_649_449 x48/a_289_1059 x6/w_87_786 sky130_fd_pr__pfet_01v8 ad=0 pd=0 as=0 ps=0 w=400 l=30
X55 x48/a_289_1059 x48/li_649_449 x6/w_87_786 x6/w_87_786 sky130_fd_pr__pfet_01v8 ad=0 pd=0 as=0 ps=0 w=400 l=30
X56 VSUBS x6/a_147_377 x57/a_0_0 VSUBS sky130_fd_pr__nfet_01v8 ad=0 pd=0 as=78.2n ps=2.61m w=602 l=30
X58 x6/a_289_1059 m1_1660_723 x6/li_393_182 VSUBS sky130_fd_pr__nfet_01v8 ad=7.16n pd=0.314m as=52.7n ps=1.92m w=602 l=30
X59 x6/li_393_182 m1_2351_575 x57/a_0_0 VSUBS sky130_fd_pr__nfet_01v8 ad=0 pd=0 as=0 ps=0 w=600 l=30
X60 x6/w_87_786 x6/a_147_377 x6/a_289_1059 x6/w_87_786 sky130_fd_pr__pfet_01v8 ad=0 pd=0 as=69.6n ps=2.75m w=400 l=30
X61 x6/a_289_1059 x6/a_147_377 x6/w_87_786 x6/w_87_786 sky130_fd_pr__pfet_01v8 ad=0 pd=0 as=0 ps=0 w=400 l=30
X62 x6/w_87_786 m1_2351_575 x6/a_289_1059 x6/w_87_786 sky130_fd_pr__pfet_01v8 ad=0 pd=0 as=0 ps=0 w=400 l=30
X63 x6/a_289_1059 m1_2351_575 x6/w_87_786 x6/w_87_786 sky130_fd_pr__pfet_01v8 ad=0 pd=0 as=0 ps=0 w=400 l=30
X64 x6/w_87_786 m1_1660_723 x6/a_289_1059 x6/w_87_786 sky130_fd_pr__pfet_01v8 ad=0 pd=0 as=0 ps=0 w=400 l=30
X65 x6/a_289_1059 m1_1660_723 x6/w_87_786 x6/w_87_786 sky130_fd_pr__pfet_01v8 ad=0 pd=0 as=0 ps=0 w=400 l=30
.ends

** hspice subcircuit dictionary
* x1	nand3x1_pcell_0
* x2	nand3x1_pcell_0/nmos_bottom_0
* x6	nand3x1_pcell_5
* x13	nand3x1_pcell_1/nmos_bottom_0
* x15	nand3x1_pcell_1
* x24	nand3x1_pcell_2/nmos_bottom_0
* x26	nand3x1_pcell_2
* x35	nand3x1_pcell_3/nmos_bottom_0
* x37	nand3x1_pcell_3
* x46	nand3x1_pcell_4/nmos_bottom_0
* x48	nand3x1_pcell_4
* x57	nand3x1_pcell_5/nmos_bottom_0
