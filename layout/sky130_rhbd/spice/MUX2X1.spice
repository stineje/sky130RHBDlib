* HSPICE file created from MUX2X1.ext - technology: sky130A

.option scale=5m

.subckt MUX2X1 Y A0 A1 S VDD GND
X0 GND x1/m1_981_575 x2/a_0_0 GND sky130_fd_pr__nfet_01v8 ad=2.39n pd=0.111m as=15.7n ps=0.599m w=602 l=30
X3 Y x1/m1_1647_649 x2/a_0_0 GND sky130_fd_pr__nfet_01v8 ad=2.39n pd=0.111m as=15.8n ps=0.594m w=602 l=30
X4 VDD x1/m1_981_575 Y VDD sky130_fd_pr__pfet_01v8 ad=21.6n pd=0.908m as=11.6n ps=0.458m w=400 l=30
X5 Y x1/m1_981_575 VDD VDD sky130_fd_pr__pfet_01v8 ad=11.6n pd=0.458m as=22.4n ps=0.912m w=400 l=30
X6 VDD x1/m1_1647_649 Y VDD sky130_fd_pr__pfet_01v8 ad=0.246u pd=0.01 as=46.4n ps=1.83m w=400 l=30
X7 Y x1/m1_1647_649 VDD VDD sky130_fd_pr__pfet_01v8 ad=0 pd=0 as=0 ps=0 w=400 l=30
X8 x1/m1_315_649 S GND GND sky130_fd_pr__nfet_01v8 ad=2.39n pd=0.111m as=15.6n ps=0.592m w=602 l=30
X9 VDD S x1/m1_315_649 VDD sky130_fd_pr__pfet_01v8 ad=0 pd=0 as=23.2n ps=0.917m w=400 l=30
X10 x1/m1_315_649 S VDD VDD sky130_fd_pr__pfet_01v8 ad=0 pd=0 as=0 ps=0 w=400 l=30
X11 GND S x12/a_0_0 GND sky130_fd_pr__nfet_01v8 ad=88.6n pd=3.77m as=77.2n ps=2.61m w=602 l=30
X13 x1/m1_981_575 A0 x12/a_0_0 GND sky130_fd_pr__nfet_01v8 ad=1p pd=-87u as=0 ps=0 w=602 l=30
X14 VDD S x1/m1_981_575 VDD sky130_fd_pr__pfet_01v8 ad=0 pd=0 as=46.4n ps=1.83m w=400 l=30
X15 x1/m1_981_575 S VDD VDD sky130_fd_pr__pfet_01v8 ad=0 pd=0 as=0 ps=0 w=400 l=30
X16 VDD A0 x1/m1_981_575 VDD sky130_fd_pr__pfet_01v8 ad=0 pd=0 as=0 ps=0 w=400 l=30
X17 x1/m1_981_575 A0 VDD VDD sky130_fd_pr__pfet_01v8 ad=0 pd=0 as=0 ps=0 w=400 l=30
X18 GND x1/m1_315_649 x19/a_0_0 GND sky130_fd_pr__nfet_01v8 ad=0 pd=0 as=77.2n ps=2.61m w=602 l=30
X20 x1/m1_1647_649 A1 x19/a_0_0 GND sky130_fd_pr__nfet_01v8 ad=7.16n pd=0.314m as=0 ps=0 w=602 l=30
X21 VDD x1/m1_315_649 x1/m1_1647_649 VDD sky130_fd_pr__pfet_01v8 ad=0 pd=0 as=46.4n ps=1.83m w=400 l=30
X22 x1/m1_1647_649 x1/m1_315_649 VDD VDD sky130_fd_pr__pfet_01v8 ad=0 pd=0 as=0 ps=0 w=400 l=30
X23 VDD A1 x1/m1_1647_649 VDD sky130_fd_pr__pfet_01v8 ad=0 pd=0 as=0 ps=0 w=400 l=30
X24 x1/m1_1647_649 A1 VDD VDD sky130_fd_pr__pfet_01v8 ad=0 pd=0 as=0 ps=0 w=400 l=30
.ends

** hspice subcircuit dictionary
* x1	mux2x1_pcell_0
* x2	mux2x1_pcell_0/nand2x1_pcell_2/nmos_bottom_0
* x12	mux2x1_pcell_0/nand2x1_pcell_0/nmos_bottom_0
* x19	mux2x1_pcell_0/nand2x1_pcell_1/nmos_bottom_0
