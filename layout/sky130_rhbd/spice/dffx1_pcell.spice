* HSPICE file created from dffx1_pcell.ext - technology: sky130A

.option scale=5m

.subckt dffx1_pcell
X0 VSUBS m1_2165_649 x1/a_0_0 VSUBS sky130_fd_pr__nfet_01v8 ad=2.39n pd=0.111m as=15.7n ps=0.599m w=602 l=30
X2 m1_258_797 m1_427_871 x1/a_0_0 VSUBS sky130_fd_pr__nfet_01v8 ad=2.39n pd=0.111m as=15.8n ps=0.594m w=602 l=30
X3 x4/w_87_786 m1_2165_649 m1_258_797 x4/w_87_786 sky130_fd_pr__pfet_01v8 ad=21.6n pd=0.908m as=11.6n ps=0.458m w=400 l=30
X5 m1_258_797 m1_2165_649 x4/w_87_786 x4/w_87_786 sky130_fd_pr__pfet_01v8 ad=11.6n pd=0.458m as=22.4n ps=0.912m w=400 l=30
X6 x4/w_87_786 m1_427_871 m1_258_797 x4/w_87_786 sky130_fd_pr__pfet_01v8 ad=0.426u pd=0.0173 as=46.4n ps=1.83m w=400 l=30
X7 m1_258_797 m1_427_871 x4/w_87_786 x4/w_87_786 sky130_fd_pr__pfet_01v8 ad=0 pd=0 as=0 ps=0 w=400 l=30
X8 VSUBS m1_833_723 x9/a_0_0 VSUBS sky130_fd_pr__nfet_01v8 ad=86n pd=4.3m as=77.2n ps=2.61m w=602 l=30
X10 x11/a_229_1059 x11/a_362_382 x9/a_0_0 VSUBS sky130_fd_pr__nfet_01v8 ad=7.16n pd=0.314m as=0 ps=0 w=602 l=30
X12 x4/w_87_786 m1_833_723 x11/a_229_1059 x4/w_87_786 sky130_fd_pr__pfet_01v8 ad=0 pd=0 as=46.4n ps=1.83m w=400 l=30
X13 x11/a_229_1059 m1_833_723 x4/w_87_786 x4/w_87_786 sky130_fd_pr__pfet_01v8 ad=0 pd=0 as=0 ps=0 w=400 l=30
X14 x4/w_87_786 x11/a_362_382 x11/a_229_1059 x4/w_87_786 sky130_fd_pr__pfet_01v8 ad=0 pd=0 as=0 ps=0 w=400 l=30
X15 x11/a_229_1059 x11/a_362_382 x4/w_87_786 x4/w_87_786 sky130_fd_pr__pfet_01v8 ad=0 pd=0 as=0 ps=0 w=400 l=30
X16 VSUBS x17/a_168_375 x18/a_0_0 VSUBS sky130_fd_pr__nfet_01v8 ad=0 pd=0 as=77.2n ps=2.61m w=602 l=30
X19 x17/a_229_1059 m1_258_797 x18/a_0_0 VSUBS sky130_fd_pr__nfet_01v8 ad=7.16n pd=0.314m as=0 ps=0 w=602 l=30
X20 x4/w_87_786 x17/a_168_375 x17/a_229_1059 x4/w_87_786 sky130_fd_pr__pfet_01v8 ad=0 pd=0 as=46.4n ps=1.83m w=400 l=30
X21 x17/a_229_1059 x17/a_168_375 x4/w_87_786 x4/w_87_786 sky130_fd_pr__pfet_01v8 ad=0 pd=0 as=0 ps=0 w=400 l=30
X22 x4/w_87_786 m1_258_797 x17/a_229_1059 x4/w_87_786 sky130_fd_pr__pfet_01v8 ad=0 pd=0 as=0 ps=0 w=400 l=30
X23 x17/a_229_1059 m1_258_797 x4/w_87_786 x4/w_87_786 sky130_fd_pr__pfet_01v8 ad=0 pd=0 as=0 ps=0 w=400 l=30
X24 VSUBS m1_258_797 x25/a_0_0 VSUBS sky130_fd_pr__nfet_01v8 ad=0 pd=0 as=78.2n ps=2.61m w=602 l=30
X26 m1_833_723 m1_685_649 x4/li_393_182 VSUBS sky130_fd_pr__nfet_01v8 ad=-7.16n pd=-0.488m as=52.7n ps=1.92m w=602 l=30
X27 x4/li_393_182 m1_427_871 x25/a_0_0 VSUBS sky130_fd_pr__nfet_01v8 ad=2.18n pd=0.106m as=16.2n ps=0.604m w=600 l=30
X28 x4/w_87_786 m1_258_797 m1_833_723 x4/w_87_786 sky130_fd_pr__pfet_01v8 ad=0 pd=0 as=69.6n ps=2.75m w=400 l=30
X29 m1_833_723 m1_258_797 x4/w_87_786 x4/w_87_786 sky130_fd_pr__pfet_01v8 ad=0 pd=0 as=0 ps=0 w=400 l=30
X30 x4/w_87_786 m1_427_871 m1_833_723 x4/w_87_786 sky130_fd_pr__pfet_01v8 ad=0 pd=0 as=0 ps=0 w=400 l=30
X31 m1_833_723 m1_427_871 x4/w_87_786 x4/w_87_786 sky130_fd_pr__pfet_01v8 ad=0 pd=0 as=0 ps=0 w=400 l=30
X32 x4/w_87_786 m1_685_649 m1_833_723 x4/w_87_786 sky130_fd_pr__pfet_01v8 ad=0 pd=0 as=0 ps=0 w=400 l=30
X33 m1_833_723 m1_685_649 x4/w_87_786 x4/w_87_786 sky130_fd_pr__pfet_01v8 ad=0 pd=0 as=0 ps=0 w=400 l=30
X34 VSUBS m1_833_723 x35/a_0_0 VSUBS sky130_fd_pr__nfet_01v8 ad=0 pd=0 as=77.2n ps=2.61m w=602 l=30
X36 m1_685_649 x37/a_362_382 x35/a_0_0 VSUBS sky130_fd_pr__nfet_01v8 ad=1p pd=-87u as=0 ps=0 w=602 l=30
X38 x4/w_87_786 m1_833_723 m1_685_649 x4/w_87_786 sky130_fd_pr__pfet_01v8 ad=0 pd=0 as=46.4n ps=1.83m w=400 l=30
X39 m1_685_649 m1_833_723 x4/w_87_786 x4/w_87_786 sky130_fd_pr__pfet_01v8 ad=0 pd=0 as=0 ps=0 w=400 l=30
X40 x4/w_87_786 x37/a_362_382 m1_685_649 x4/w_87_786 sky130_fd_pr__pfet_01v8 ad=0 pd=0 as=0 ps=0 w=400 l=30
X41 m1_685_649 x37/a_362_382 x4/w_87_786 x4/w_87_786 sky130_fd_pr__pfet_01v8 ad=0 pd=0 as=0 ps=0 w=400 l=30
X42 VSUBS m1_685_649 x43/a_0_0 VSUBS sky130_fd_pr__nfet_01v8 ad=0 pd=0 as=77.2n ps=2.61m w=602 l=30
X44 m1_2165_649 m1_258_797 x43/a_0_0 VSUBS sky130_fd_pr__nfet_01v8 ad=1p pd=-87u as=0 ps=0 w=602 l=30
X45 x4/w_87_786 m1_685_649 m1_2165_649 x4/w_87_786 sky130_fd_pr__pfet_01v8 ad=0 pd=0 as=46.4n ps=1.83m w=400 l=30
X46 m1_2165_649 m1_685_649 x4/w_87_786 x4/w_87_786 sky130_fd_pr__pfet_01v8 ad=0 pd=0 as=0 ps=0 w=400 l=30
X47 x4/w_87_786 m1_258_797 m1_2165_649 x4/w_87_786 sky130_fd_pr__pfet_01v8 ad=0 pd=0 as=0 ps=0 w=400 l=30
X48 m1_2165_649 m1_258_797 x4/w_87_786 x4/w_87_786 sky130_fd_pr__pfet_01v8 ad=0 pd=0 as=0 ps=0 w=400 l=30
C0 x4/w_87_786 m1_258_797 2.02f
.ends

** hspice subcircuit dictionary
* x1	nand2x1_pcell_2/nmos_bottom_0
* x4	nand3x1_pcell_0
* x9	nand2x1_pcell_3/nmos_bottom_0
* x11	nand2x1_pcell_3
* x17	nand2x1_pcell_4
* x18	nand2x1_pcell_4/nmos_bottom_0
* x25	nand3x1_pcell_0/nmos_bottom_0
* x35	nand2x1_pcell_0/nmos_bottom_0
* x37	nand2x1_pcell_0
* x43	nand2x1_pcell_1/nmos_bottom_0
