* NGSPICE file created from XOR2X1.ext - technology: sky130A

.subckt nmos_bottom a_56_54# a_86_84# a_0_0# VSUBS
X0 a_86_84# a_56_54# a_0_0# VSUBS sky130_fd_pr__nfet_01v8 ad=0.0597 pd=0.555 as=0.393 ps=2.99 w=3.01 l=0.15
.ends

.subckt pmos2_1 a_144_n460# a_262_n399# a_88_n399# w_52_n435# a_174_n399#
X0 a_174_n399# a_144_n460# a_88_n399# w_52_n435# sky130_fd_pr__pfet_01v8 ad=0.29 pd=2.29 as=0.56 ps=4.56 w=2 l=0.15
X1 a_262_n399# a_144_n460# a_174_n399# w_52_n435# sky130_fd_pr__pfet_01v8 ad=0.54 pd=4.54 as=0.29 ps=2.29 w=2 l=0.15
.ends

.subckt nmos_top_trim1 a_86_92# a_56_62# a_0_0# VSUBS
X0 a_86_92# a_56_62# a_0_0# VSUBS sky130_fd_pr__nfet_01v8 ad=0.0597 pd=0.555 as=0.395 ps=2.97 w=3.01 l=0.15
.ends

.subckt nmos_top a_84_92# a_0_0# a_54_62# VSUBS
X0 a_84_92# a_54_62# a_0_0# VSUBS sky130_fd_pr__nfet_01v8 ad=0.0597 pd=0.555 as=0.39 ps=2.96 w=3.01 l=0.15
.ends

.subckt pmos2 a_88_n400# a_144_n461# a_174_n400# a_262_n400# w_52_n436#
X0 a_262_n400# a_144_n461# a_174_n400# w_52_n436# sky130_fd_pr__pfet_01v8 ad=0.54 pd=4.54 as=0.29 ps=2.29 w=2 l=0.15
X1 a_174_n400# a_144_n461# a_88_n400# w_52_n436# sky130_fd_pr__pfet_01v8 ad=0.29 pd=2.29 as=0.56 ps=4.56 w=2 l=0.15
.ends

.subckt invx1_pcell a_34_482# a_155_381# a_206_1059# w_n87_786# pmos2_0/VSUBS
Xnmos_top_0 a_206_1059# pmos2_0/VSUBS a_155_381# pmos2_0/VSUBS nmos_top
Xpmos2_0 w_n87_786# a_155_381# a_206_1059# w_n87_786# w_n87_786# pmos2
.ends

.subckt xor2X1_pcell a_806_383# pmos2_1_3/VSUBS m1_981_723# a_612_376# a_1141_n17#
+ w_585_1330#
Xnmos_bottom_0 a_612_376# pmos2_1_3/VSUBS nmos_bottom_0/a_0_0# pmos2_1_3/VSUBS nmos_bottom
Xnmos_bottom_1 m1_939_797# pmos2_1_3/VSUBS nmos_bottom_1/a_0_0# pmos2_1_3/VSUBS nmos_bottom
Xpmos2_1_0 a_612_376# a_761_1330# a_761_1330# w_585_1330# w_585_1330# pmos2_1
Xnmos_top_trim1_1 m1_981_723# m1_315_501# nmos_bottom_1/a_0_0# pmos2_1_3/VSUBS nmos_top_trim1
Xnmos_top_trim1_0 m1_981_723# a_806_383# nmos_bottom_0/a_0_0# pmos2_1_3/VSUBS nmos_top_trim1
Xpmos2_1_1 m1_939_797# a_761_1330# a_761_1330# w_585_1330# m1_981_723# pmos2_1
Xpmos2_1_2 a_806_383# a_1427_1330# a_1427_1330# w_585_1330# w_585_1330# pmos2_1
Xpmos2_1_3 m1_315_501# a_1427_1330# a_1427_1330# w_585_1330# m1_981_723# pmos2_1
Xinvx1_pcell_0 pmos2_1_3/VSUBS a_612_376# m1_315_501# w_585_1330# pmos2_1_3/VSUBS
+ invx1_pcell
Xinvx1_pcell_1 pmos2_1_3/VSUBS a_806_383# m1_939_797# w_585_1330# pmos2_1_3/VSUBS
+ invx1_pcell
.ends

.subckt XOR2X1 Y A B VDD GND
Xxor2X1_pcell_0 B GND Y A GND VDD xor2X1_pcell
.ends
