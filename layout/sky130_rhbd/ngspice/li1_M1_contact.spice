* NGSPICE file created from li1_M1_contact.ext - technology: sky130A

* Top level circuit li1_M1_contact

.end
