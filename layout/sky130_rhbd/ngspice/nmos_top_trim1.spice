* NGSPICE file created from nmos_top_trim1.ext - technology: sky130A

.subckt nmos_top_trim1
X0 a_86_92# a_56_62# a_0_0# VSUBS sky130_fd_pr__nfet_01v8 ad=0.0597 pd=0.555 as=0.395 ps=2.97 w=3.01 l=0.15
.ends
