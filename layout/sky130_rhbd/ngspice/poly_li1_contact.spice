* NGSPICE file created from poly_li1_contact.ext - technology: sky130A

* Top level circuit poly_li1_contact

.end
