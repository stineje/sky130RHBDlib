* NGSPICE file created from AND3X1.ext - technology: sky130A

.subckt nmos_top a_84_92# a_0_0# a_54_62# VSUBS
X0 a_84_92# a_54_62# a_0_0# VSUBS sky130_fd_pr__nfet_01v8 ad=0.0597 pd=0.555 as=0.39 ps=2.96 w=3.01 l=0.15
.ends

.subckt pmos2 a_88_n400# a_144_n461# a_174_n400# a_262_n400# w_52_n436#
X0 a_262_n400# a_144_n461# a_174_n400# w_52_n436# sky130_fd_pr__pfet_01v8 ad=0.54 pd=4.54 as=0.29 ps=2.29 w=2 l=0.15
X1 a_174_n400# a_144_n461# a_88_n400# w_52_n436# sky130_fd_pr__pfet_01v8 ad=0.29 pd=2.29 as=0.56 ps=4.56 w=2 l=0.15
.ends

.subckt invx1_pcell a_34_482# a_155_381# a_206_1059# w_n87_786# pmos2_0/VSUBS
Xnmos_top_0 a_206_1059# pmos2_0/VSUBS a_155_381# pmos2_0/VSUBS nmos_top
Xpmos2_0 w_n87_786# a_155_381# a_206_1059# w_n87_786# w_n87_786# pmos2
.ends

.subckt nmos_bottom a_56_54# a_86_84# a_0_0# VSUBS
X0 a_86_84# a_56_54# a_0_0# VSUBS sky130_fd_pr__nfet_01v8 ad=0.0597 pd=0.555 as=0.393 ps=2.99 w=3.01 l=0.15
.ends

.subckt nmos_top_trim1 a_86_92# a_56_62# a_0_0# VSUBS
X0 a_86_92# a_56_62# a_0_0# VSUBS sky130_fd_pr__nfet_01v8 ad=0.0597 pd=0.555 as=0.395 ps=2.97 w=3.01 l=0.15
.ends

.subckt nmos_side_left a_87_91# a_0_0# a_57_61# VSUBS
X0 a_87_91# a_57_61# a_0_0# VSUBS sky130_fd_pr__nfet_01v8 ad=0.0545 pd=0.53 as=0.404 ps=3.02 w=3 l=0.15
.ends

.subckt nand3x1_pcell a_447_377# a_34_482# li_649_449# a_289_1059# w_87_786# pmos2_2/VSUBS
+ a_147_377#
Xnmos_bottom_0 a_147_377# pmos2_2/VSUBS nmos_bottom_0/a_0_0# pmos2_2/VSUBS nmos_bottom
Xnmos_top_trim1_0 a_289_1059# li_649_449# li_393_182# pmos2_2/VSUBS nmos_top_trim1
Xnmos_side_left_0 li_393_182# nmos_bottom_0/a_0_0# a_447_377# pmos2_2/VSUBS nmos_side_left
Xpmos2_0 w_87_786# a_147_377# a_289_1059# w_87_786# w_87_786# pmos2
Xpmos2_1 w_87_786# a_447_377# a_289_1059# w_87_786# w_87_786# pmos2
Xpmos2_2 w_87_786# li_649_449# a_289_1059# w_87_786# w_87_786# pmos2
.ends

.subckt and3x1_pcell invx1_pcell_0/w_n87_786# invx1_pcell_0/a_206_1059# nand3x1_pcell_0/a_147_377#
+ nand3x1_pcell_0/a_447_377# VSUBS nand3x1_pcell_0/li_649_449#
Xinvx1_pcell_0 invx1_pcell_0/a_34_482# m1_867_649# invx1_pcell_0/a_206_1059# invx1_pcell_0/w_n87_786#
+ VSUBS invx1_pcell
Xnand3x1_pcell_0 nand3x1_pcell_0/a_447_377# invx1_pcell_0/a_34_482# nand3x1_pcell_0/li_649_449#
+ m1_867_649# invx1_pcell_0/w_n87_786# VSUBS nand3x1_pcell_0/a_147_377# nand3x1_pcell
.ends

.subckt AND3X1 Y A B C VDD GND
Xand3x1_pcell_0 VDD Y A B GND C and3x1_pcell
.ends
