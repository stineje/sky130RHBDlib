* NGSPICE file created from dffsnx1_pcell.ext - technology: sky130A

.subckt nmos_bottom a_56_54# a_86_84# a_0_0# VSUBS
X0 a_86_84# a_56_54# a_0_0# VSUBS sky130_fd_pr__nfet_01v8 ad=0.0597 pd=0.555 as=0.393 ps=2.99 w=3.01 l=0.15
.ends

.subckt nmos_top_trim1 a_86_92# a_56_62# a_0_0# VSUBS
X0 a_86_92# a_56_62# a_0_0# VSUBS sky130_fd_pr__nfet_01v8 ad=0.0597 pd=0.555 as=0.395 ps=2.97 w=3.01 l=0.15
.ends

.subckt pmos2 a_88_n400# a_144_n461# a_174_n400# a_262_n400# w_52_n436#
X0 a_262_n400# a_144_n461# a_174_n400# w_52_n436# sky130_fd_pr__pfet_01v8 ad=0.54 pd=4.54 as=0.29 ps=2.29 w=2 l=0.15
X1 a_174_n400# a_144_n461# a_88_n400# w_52_n436# sky130_fd_pr__pfet_01v8 ad=0.29 pd=2.29 as=0.56 ps=4.56 w=2 l=0.15
.ends

.subckt nand2x1_pcell a_31_480# a_362_382# a_229_1059# pmos2_1/VSUBS a_168_375# w_87_786#
Xnmos_bottom_0 a_168_375# pmos2_1/VSUBS nmos_bottom_0/a_0_0# pmos2_1/VSUBS nmos_bottom
Xnmos_top_trim1_0 a_229_1059# a_362_382# nmos_bottom_0/a_0_0# pmos2_1/VSUBS nmos_top_trim1
Xpmos2_0 w_87_786# a_168_375# a_229_1059# w_87_786# w_87_786# pmos2
Xpmos2_1 w_87_786# a_362_382# a_229_1059# w_87_786# w_87_786# pmos2
.ends

.subckt nmos_side_left a_87_91# a_0_0# a_57_61# VSUBS
X0 a_87_91# a_57_61# a_0_0# VSUBS sky130_fd_pr__nfet_01v8 ad=0.0545 pd=0.53 as=0.404 ps=3.02 w=3 l=0.15
.ends

.subckt nand3x1_pcell a_34_482# a_447_377# li_649_449# a_289_1059# pmos2_2/VSUBS a_147_377#
+ w_87_786#
Xnmos_bottom_0 a_147_377# pmos2_2/VSUBS nmos_bottom_0/a_0_0# pmos2_2/VSUBS nmos_bottom
Xnmos_top_trim1_0 a_289_1059# li_649_449# li_393_182# pmos2_2/VSUBS nmos_top_trim1
Xnmos_side_left_0 li_393_182# nmos_bottom_0/a_0_0# a_447_377# pmos2_2/VSUBS nmos_side_left
Xpmos2_0 w_87_786# a_147_377# a_289_1059# w_87_786# w_87_786# pmos2
Xpmos2_1 w_87_786# a_447_377# a_289_1059# w_87_786# w_87_786# pmos2
Xpmos2_2 w_87_786# li_649_449# a_289_1059# w_87_786# w_87_786# pmos2
.ends

.subckt dffsnx1_pcell
Xnand2x1_pcell_2 nand3x1_pcell_2/a_34_482# nand2x1_pcell_2/a_362_382# nand2x1_pcell_2/a_229_1059#
+ VSUBS m1_406_797# nand3x1_pcell_2/w_87_786# nand2x1_pcell
Xnand2x1_pcell_5 nand3x1_pcell_2/a_34_482# m1_406_797# m1_537_501# VSUBS nand2x1_pcell_5/a_168_375#
+ nand3x1_pcell_2/w_87_786# nand2x1_pcell
Xnand3x1_pcell_0 nand3x1_pcell_2/a_34_482# m1_1093_871# m1_1351_723# m1_406_797# VSUBS
+ m1_537_501# nand3x1_pcell_2/w_87_786# nand3x1_pcell
Xnand3x1_pcell_1 nand3x1_pcell_2/a_34_482# m1_2055_427# m1_1351_723# nand3x1_pcell_1/a_289_1059#
+ VSUBS nand3x1_pcell_1/a_147_377# nand3x1_pcell_2/w_87_786# nand3x1_pcell
Xnand3x1_pcell_2 nand3x1_pcell_2/a_34_482# m1_2055_427# m1_1351_723# m1_2461_501#
+ VSUBS m1_537_501# nand3x1_pcell_2/w_87_786# nand3x1_pcell
Xnand2x1_pcell_0 nand3x1_pcell_2/a_34_482# m1_1093_871# m1_1351_723# VSUBS m1_2461_501#
+ nand3x1_pcell_2/w_87_786# nand2x1_pcell
.ends
