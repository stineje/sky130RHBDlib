* NGSPICE file created from MUX2X1.ext - technology: sky130A

.subckt nmos_bottom a_56_54# a_86_84# a_0_0# VSUBS
X0 a_86_84# a_56_54# a_0_0# VSUBS sky130_fd_pr__nfet_01v8 ad=0.0597 pd=0.555 as=0.393 ps=2.99 w=3.01 l=0.15
.ends

.subckt nmos_top_trim1 a_86_92# a_56_62# a_0_0# VSUBS
X0 a_86_92# a_56_62# a_0_0# VSUBS sky130_fd_pr__nfet_01v8 ad=0.0597 pd=0.555 as=0.395 ps=2.97 w=3.01 l=0.15
.ends

.subckt pmos2 a_88_n400# a_144_n461# a_174_n400# a_262_n400# w_52_n436#
X0 a_262_n400# a_144_n461# a_174_n400# w_52_n436# sky130_fd_pr__pfet_01v8 ad=0.54 pd=4.54 as=0.29 ps=2.29 w=2 l=0.15
X1 a_174_n400# a_144_n461# a_88_n400# w_52_n436# sky130_fd_pr__pfet_01v8 ad=0.29 pd=2.29 as=0.56 ps=4.56 w=2 l=0.15
.ends

.subckt nand2x1_pcell a_31_480# a_362_382# a_229_1059# pmos2_1/VSUBS a_168_375# w_87_786#
Xnmos_bottom_0 a_168_375# pmos2_1/VSUBS nmos_bottom_0/a_0_0# pmos2_1/VSUBS nmos_bottom
Xnmos_top_trim1_0 a_229_1059# a_362_382# nmos_bottom_0/a_0_0# pmos2_1/VSUBS nmos_top_trim1
Xpmos2_0 w_87_786# a_168_375# a_229_1059# w_87_786# w_87_786# pmos2
Xpmos2_1 w_87_786# a_362_382# a_229_1059# w_87_786# w_87_786# pmos2
.ends

.subckt nmos_top a_84_92# a_0_0# a_54_62# VSUBS
X0 a_84_92# a_54_62# a_0_0# VSUBS sky130_fd_pr__nfet_01v8 ad=0.0597 pd=0.555 as=0.39 ps=2.96 w=3.01 l=0.15
.ends

.subckt invx1_pcell a_34_482# a_155_381# a_206_1059# w_n87_786# pmos2_0/VSUBS
Xnmos_top_0 a_206_1059# pmos2_0/VSUBS a_155_381# pmos2_0/VSUBS nmos_top
Xpmos2_0 w_n87_786# a_155_381# a_206_1059# w_n87_786# w_n87_786# pmos2
.ends

.subckt mux2x1_pcell nand2x1_pcell_0/a_362_382# nand2x1_pcell_1/a_362_382# m1_120_575#
+ nand2x1_pcell_2/a_229_1059# invx1_pcell_0/w_n87_786# VSUBS
Xnand2x1_pcell_2 invx1_pcell_0/a_34_482# m1_1647_649# nand2x1_pcell_2/a_229_1059#
+ VSUBS m1_981_575# invx1_pcell_0/w_n87_786# nand2x1_pcell
Xinvx1_pcell_0 invx1_pcell_0/a_34_482# m1_120_575# m1_315_649# invx1_pcell_0/w_n87_786#
+ VSUBS invx1_pcell
Xnand2x1_pcell_0 invx1_pcell_0/a_34_482# nand2x1_pcell_0/a_362_382# m1_981_575# VSUBS
+ m1_120_575# invx1_pcell_0/w_n87_786# nand2x1_pcell
Xnand2x1_pcell_1 invx1_pcell_0/a_34_482# nand2x1_pcell_1/a_362_382# m1_1647_649# VSUBS
+ m1_315_649# invx1_pcell_0/w_n87_786# nand2x1_pcell
.ends

.subckt MUX2X1 Y A0 A1 S VDD GND
Xmux2x1_pcell_0 A0 A1 S Y VDD GND mux2x1_pcell
.ends
