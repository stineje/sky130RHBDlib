* NGSPICE file created from diff_ring_side.ext - technology: sky130A

* Top level circuit diff_ring_side

.end
