****BOF - AND2X1.spice

* NGSPICE file created from AND2X1.ext - technology: sky130A

.subckt nmos_top a_84_92# a_0_0# a_54_62# VSUBS
X0 a_84_92# a_54_62# a_0_0# VSUBS sky130_fd_pr__nfet_01v8 ad=0.0597 pd=0.555 as=0.39 ps=2.96 w=3.01 l=0.15
.ends

.subckt pmos2 a_88_n400# a_144_n461# a_174_n400# a_262_n400# w_52_n436#
X0 a_262_n400# a_144_n461# a_174_n400# w_52_n436# sky130_fd_pr__pfet_01v8 ad=0.54 pd=4.54 as=0.29 ps=2.29 w=2 l=0.15
X1 a_174_n400# a_144_n461# a_88_n400# w_52_n436# sky130_fd_pr__pfet_01v8 ad=0.29 pd=2.29 as=0.56 ps=4.56 w=2 l=0.15
.ends

.subckt invx1_pcell a_34_482# a_155_381# a_206_1059# w_n87_786# pmos2_0/VSUBS
Xnmos_top_0 a_206_1059# pmos2_0/VSUBS a_155_381# pmos2_0/VSUBS nmos_top
Xpmos2_0 w_n87_786# a_155_381# a_206_1059# w_n87_786# w_n87_786# pmos2
.ends

.subckt nmos_bottom a_56_54# a_86_84# a_0_0# VSUBS
X0 a_86_84# a_56_54# a_0_0# VSUBS sky130_fd_pr__nfet_01v8 ad=0.0597 pd=0.555 as=0.393 ps=2.99 w=3.01 l=0.15
.ends

.subckt nmos_top_trim1 a_86_92# a_56_62# a_0_0# VSUBS
X0 a_86_92# a_56_62# a_0_0# VSUBS sky130_fd_pr__nfet_01v8 ad=0.0597 pd=0.555 as=0.395 ps=2.97 w=3.01 l=0.15
.ends

.subckt nand2x1_pcell a_362_382# a_31_480# a_229_1059# pmos2_1/VSUBS w_87_786# a_168_375#
Xnmos_bottom_0 a_168_375# pmos2_1/VSUBS nmos_bottom_0/a_0_0# pmos2_1/VSUBS nmos_bottom
Xnmos_top_trim1_0 a_229_1059# a_362_382# nmos_bottom_0/a_0_0# pmos2_1/VSUBS nmos_top_trim1
Xpmos2_0 w_87_786# a_168_375# a_229_1059# w_87_786# w_87_786# pmos2
Xpmos2_1 w_87_786# a_362_382# a_229_1059# w_87_786# w_87_786# pmos2
.ends

.subckt and2x1_pcell nand2x1_pcell_0/a_168_375# nand2x1_pcell_0/a_362_382# invx1_pcell_0/a_206_1059#
+ invx1_pcell_0/w_n87_786# VSUBS
Xinvx1_pcell_0 invx1_pcell_0/a_34_482# m1_547_649# invx1_pcell_0/a_206_1059# invx1_pcell_0/w_n87_786#
+ VSUBS invx1_pcell
Xnand2x1_pcell_0 nand2x1_pcell_0/a_362_382# invx1_pcell_0/a_34_482# m1_547_649# VSUBS
+ invx1_pcell_0/w_n87_786# nand2x1_pcell_0/a_168_375# nand2x1_pcell
.ends

.subckt AND2X1 Y A B VDD GND
Xand2x1_pcell_0 A B Y VDD GND and2x1_pcell
.ends

****EOF - AND2X1.spice
****BOF - AND3X1.spice

* NGSPICE file created from AND3X1.ext - technology: sky130A

.subckt nmos_top a_84_92# a_0_0# a_54_62# VSUBS
X0 a_84_92# a_54_62# a_0_0# VSUBS sky130_fd_pr__nfet_01v8 ad=0.0597 pd=0.555 as=0.39 ps=2.96 w=3.01 l=0.15
.ends

.subckt pmos2 a_88_n400# a_144_n461# a_174_n400# a_262_n400# w_52_n436#
X0 a_262_n400# a_144_n461# a_174_n400# w_52_n436# sky130_fd_pr__pfet_01v8 ad=0.54 pd=4.54 as=0.29 ps=2.29 w=2 l=0.15
X1 a_174_n400# a_144_n461# a_88_n400# w_52_n436# sky130_fd_pr__pfet_01v8 ad=0.29 pd=2.29 as=0.56 ps=4.56 w=2 l=0.15
.ends

.subckt invx1_pcell a_34_482# a_155_381# a_206_1059# w_n87_786# pmos2_0/VSUBS
Xnmos_top_0 a_206_1059# pmos2_0/VSUBS a_155_381# pmos2_0/VSUBS nmos_top
Xpmos2_0 w_n87_786# a_155_381# a_206_1059# w_n87_786# w_n87_786# pmos2
.ends

.subckt nmos_bottom a_56_54# a_86_84# a_0_0# VSUBS
X0 a_86_84# a_56_54# a_0_0# VSUBS sky130_fd_pr__nfet_01v8 ad=0.0597 pd=0.555 as=0.393 ps=2.99 w=3.01 l=0.15
.ends

.subckt nmos_top_trim1 a_86_92# a_56_62# a_0_0# VSUBS
X0 a_86_92# a_56_62# a_0_0# VSUBS sky130_fd_pr__nfet_01v8 ad=0.0597 pd=0.555 as=0.395 ps=2.97 w=3.01 l=0.15
.ends

.subckt nmos_side_left a_87_91# a_0_0# a_57_61# VSUBS
X0 a_87_91# a_57_61# a_0_0# VSUBS sky130_fd_pr__nfet_01v8 ad=0.0545 pd=0.53 as=0.404 ps=3.02 w=3 l=0.15
.ends

.subckt nand3x1_pcell a_447_377# a_34_482# li_649_449# a_289_1059# w_87_786# pmos2_2/VSUBS
+ a_147_377#
Xnmos_bottom_0 a_147_377# pmos2_2/VSUBS nmos_bottom_0/a_0_0# pmos2_2/VSUBS nmos_bottom
Xnmos_top_trim1_0 a_289_1059# li_649_449# li_393_182# pmos2_2/VSUBS nmos_top_trim1
Xnmos_side_left_0 li_393_182# nmos_bottom_0/a_0_0# a_447_377# pmos2_2/VSUBS nmos_side_left
Xpmos2_0 w_87_786# a_147_377# a_289_1059# w_87_786# w_87_786# pmos2
Xpmos2_1 w_87_786# a_447_377# a_289_1059# w_87_786# w_87_786# pmos2
Xpmos2_2 w_87_786# li_649_449# a_289_1059# w_87_786# w_87_786# pmos2
.ends

.subckt and3x1_pcell invx1_pcell_0/w_n87_786# invx1_pcell_0/a_206_1059# nand3x1_pcell_0/a_147_377#
+ nand3x1_pcell_0/a_447_377# VSUBS nand3x1_pcell_0/li_649_449#
Xinvx1_pcell_0 invx1_pcell_0/a_34_482# m1_867_649# invx1_pcell_0/a_206_1059# invx1_pcell_0/w_n87_786#
+ VSUBS invx1_pcell
Xnand3x1_pcell_0 nand3x1_pcell_0/a_447_377# invx1_pcell_0/a_34_482# nand3x1_pcell_0/li_649_449#
+ m1_867_649# invx1_pcell_0/w_n87_786# VSUBS nand3x1_pcell_0/a_147_377# nand3x1_pcell
.ends

.subckt AND3X1 Y A B C VDD GND
Xand3x1_pcell_0 VDD Y A B GND C and3x1_pcell
.ends

****EOF - AND3X1.spice
****BOF - AO3X1.spice

* NGSPICE file created from AO3X1.ext - technology: sky130A

.subckt nmos_top a_84_92# a_0_0# a_54_62# VSUBS
X0 a_84_92# a_54_62# a_0_0# VSUBS sky130_fd_pr__nfet_01v8 ad=0.0597 pd=0.555 as=0.39 ps=2.96 w=3.01 l=0.15
.ends

.subckt pmos2 a_88_n400# a_144_n461# a_174_n400# a_262_n400# w_52_n436#
X0 a_262_n400# a_144_n461# a_174_n400# w_52_n436# sky130_fd_pr__pfet_01v8 ad=0.54 pd=4.54 as=0.29 ps=2.29 w=2 l=0.15
X1 a_174_n400# a_144_n461# a_88_n400# w_52_n436# sky130_fd_pr__pfet_01v8 ad=0.29 pd=2.29 as=0.56 ps=4.56 w=2 l=0.15
.ends

.subckt invx1_pcell a_34_482# a_155_381# a_206_1059# w_n87_786# pmos2_0/VSUBS
Xnmos_top_0 a_206_1059# pmos2_0/VSUBS a_155_381# pmos2_0/VSUBS nmos_top
Xpmos2_0 w_n87_786# a_155_381# a_206_1059# w_n87_786# w_n87_786# pmos2
.ends

.subckt nmos_bottom a_56_54# a_86_84# a_0_0# VSUBS
X0 a_86_84# a_56_54# a_0_0# VSUBS sky130_fd_pr__nfet_01v8 ad=0.0597 pd=0.555 as=0.393 ps=2.99 w=3.01 l=0.15
.ends

.subckt nmos_top_trim1 a_86_92# a_56_62# a_0_0# VSUBS
X0 a_86_92# a_56_62# a_0_0# VSUBS sky130_fd_pr__nfet_01v8 ad=0.0597 pd=0.555 as=0.395 ps=2.97 w=3.01 l=0.15
.ends

.subckt nand2x1_pcell a_362_382# a_31_480# a_229_1059# pmos2_1/VSUBS w_87_786# a_168_375#
Xnmos_bottom_0 a_168_375# pmos2_1/VSUBS nmos_bottom_0/a_0_0# pmos2_1/VSUBS nmos_bottom
Xnmos_top_trim1_0 a_229_1059# a_362_382# nmos_bottom_0/a_0_0# pmos2_1/VSUBS nmos_top_trim1
Xpmos2_0 w_87_786# a_168_375# a_229_1059# w_87_786# w_87_786# pmos2
Xpmos2_1 w_87_786# a_362_382# a_229_1059# w_87_786# w_87_786# pmos2
.ends

.subckt pmos2_1 a_144_n460# a_262_n399# a_88_n399# w_52_n435# a_174_n399#
X0 a_174_n399# a_144_n460# a_88_n399# w_52_n435# sky130_fd_pr__pfet_01v8 ad=0.29 pd=2.29 as=0.56 ps=4.56 w=2 l=0.15
X1 a_262_n399# a_144_n460# a_174_n399# w_52_n435# sky130_fd_pr__pfet_01v8 ad=0.54 pd=4.54 as=0.29 ps=2.29 w=2 l=0.15
.ends

.subckt nmos_top_trim2 a_86_92# a_56_62# a_0_0# VSUBS
X0 a_86_92# a_56_62# a_0_0# VSUBS sky130_fd_pr__nfet_01v8 ad=0.06 pd=0.56 as=0.395 ps=2.97 w=3.01 l=0.15
.ends

.subckt nor2x1_pcell a_362_382# a_405_1059# a_34_482# pmos2_1_1/VSUBS a_168_375# w_87_786#
Xpmos2_1_0 a_168_375# a_317_1331# a_317_1331# w_87_786# w_87_786# pmos2_1
Xpmos2_1_1 a_362_382# a_317_1331# a_317_1331# w_87_786# a_405_1059# pmos2_1
Xnmos_top_trim1_1 a_405_1059# a_168_375# pmos2_1_1/VSUBS pmos2_1_1/VSUBS nmos_top_trim1
Xnmos_top_trim2_0 a_405_1059# a_362_382# pmos2_1_1/VSUBS pmos2_1_1/VSUBS nmos_top_trim2
.ends

.subckt aoi3x1_pcell nor2x1_pcell_0/w_87_786# nor2x1_pcell_0/a_362_382# nor2x1_pcell_0/a_405_1059#
+ nand2x1_pcell_0/a_168_375# nor2x1_pcell_0/a_34_482# nand2x1_pcell_0/a_362_382# VSUBS
Xnand2x1_pcell_0 nand2x1_pcell_0/a_362_382# nor2x1_pcell_0/a_34_482# m1_537_501# VSUBS
+ nor2x1_pcell_0/w_87_786# nand2x1_pcell_0/a_168_375# nand2x1_pcell
Xnor2x1_pcell_0 nor2x1_pcell_0/a_362_382# nor2x1_pcell_0/a_405_1059# nor2x1_pcell_0/a_34_482#
+ VSUBS m1_537_501# nor2x1_pcell_0/w_87_786# nor2x1_pcell
.ends

.subckt ao3x1_pcell aoi3x1_pcell_0/nand2x1_pcell_0/a_168_375# aoi3x1_pcell_0/nor2x1_pcell_0/a_362_382#
+ aoi3x1_pcell_0/nand2x1_pcell_0/a_362_382# invx1_pcell_0/a_206_1059# invx1_pcell_0/w_n87_786#
+ VSUBS
Xinvx1_pcell_0 invx1_pcell_0/a_34_482# m1_1201_501# invx1_pcell_0/a_206_1059# invx1_pcell_0/w_n87_786#
+ VSUBS invx1_pcell
Xaoi3x1_pcell_0 invx1_pcell_0/w_n87_786# aoi3x1_pcell_0/nor2x1_pcell_0/a_362_382#
+ m1_1201_501# aoi3x1_pcell_0/nand2x1_pcell_0/a_168_375# invx1_pcell_0/a_34_482# aoi3x1_pcell_0/nand2x1_pcell_0/a_362_382#
+ VSUBS aoi3x1_pcell
.ends

.subckt AO3X1 Y A B C VDD GND
Xao3x1_pcell_0 A C B Y VDD GND ao3x1_pcell
.ends

****EOF - AO3X1.spice
****BOF - AOA4X1.spice

* NGSPICE file created from AOA4X1.ext - technology: sky130A

.subckt nmos_top a_84_92# a_0_0# a_54_62# VSUBS
X0 a_84_92# a_54_62# a_0_0# VSUBS sky130_fd_pr__nfet_01v8 ad=0.0597 pd=0.555 as=0.39 ps=2.96 w=3.01 l=0.15
.ends

.subckt pmos2 a_88_n400# a_144_n461# a_174_n400# a_262_n400# w_52_n436#
X0 a_262_n400# a_144_n461# a_174_n400# w_52_n436# sky130_fd_pr__pfet_01v8 ad=0.54 pd=4.54 as=0.29 ps=2.29 w=2 l=0.15
X1 a_174_n400# a_144_n461# a_88_n400# w_52_n436# sky130_fd_pr__pfet_01v8 ad=0.29 pd=2.29 as=0.56 ps=4.56 w=2 l=0.15
.ends

.subckt invx1_pcell a_34_482# a_155_381# a_206_1059# w_n87_786# pmos2_0/VSUBS
Xnmos_top_0 a_206_1059# pmos2_0/VSUBS a_155_381# pmos2_0/VSUBS nmos_top
Xpmos2_0 w_n87_786# a_155_381# a_206_1059# w_n87_786# w_n87_786# pmos2
.ends

.subckt nmos_bottom a_56_54# a_86_84# a_0_0# VSUBS
X0 a_86_84# a_56_54# a_0_0# VSUBS sky130_fd_pr__nfet_01v8 ad=0.0597 pd=0.555 as=0.393 ps=2.99 w=3.01 l=0.15
.ends

.subckt nmos_top_trim1 a_86_92# a_56_62# a_0_0# VSUBS
X0 a_86_92# a_56_62# a_0_0# VSUBS sky130_fd_pr__nfet_01v8 ad=0.0597 pd=0.555 as=0.395 ps=2.97 w=3.01 l=0.15
.ends

.subckt nand2x1_pcell a_362_382# a_31_480# a_229_1059# pmos2_1/VSUBS w_87_786# a_168_375#
Xnmos_bottom_0 a_168_375# pmos2_1/VSUBS nmos_bottom_0/a_0_0# pmos2_1/VSUBS nmos_bottom
Xnmos_top_trim1_0 a_229_1059# a_362_382# nmos_bottom_0/a_0_0# pmos2_1/VSUBS nmos_top_trim1
Xpmos2_0 w_87_786# a_168_375# a_229_1059# w_87_786# w_87_786# pmos2
Xpmos2_1 w_87_786# a_362_382# a_229_1059# w_87_786# w_87_786# pmos2
.ends

.subckt pmos2_1 a_144_n460# a_262_n399# a_88_n399# w_52_n435# a_174_n399#
X0 a_174_n399# a_144_n460# a_88_n399# w_52_n435# sky130_fd_pr__pfet_01v8 ad=0.29 pd=2.29 as=0.56 ps=4.56 w=2 l=0.15
X1 a_262_n399# a_144_n460# a_174_n399# w_52_n435# sky130_fd_pr__pfet_01v8 ad=0.54 pd=4.54 as=0.29 ps=2.29 w=2 l=0.15
.ends

.subckt nmos_top_trim2 a_86_92# a_56_62# a_0_0# VSUBS
X0 a_86_92# a_56_62# a_0_0# VSUBS sky130_fd_pr__nfet_01v8 ad=0.06 pd=0.56 as=0.395 ps=2.97 w=3.01 l=0.15
.ends

.subckt nor2x1_pcell a_362_382# a_405_1059# a_34_482# pmos2_1_1/VSUBS a_168_375# w_87_786#
Xpmos2_1_0 a_168_375# a_317_1331# a_317_1331# w_87_786# w_87_786# pmos2_1
Xpmos2_1_1 a_362_382# a_317_1331# a_317_1331# w_87_786# a_405_1059# pmos2_1
Xnmos_top_trim1_1 a_405_1059# a_168_375# pmos2_1_1/VSUBS pmos2_1_1/VSUBS nmos_top_trim1
Xnmos_top_trim2_0 a_405_1059# a_362_382# pmos2_1_1/VSUBS pmos2_1_1/VSUBS nmos_top_trim2
.ends

.subckt aoai4x1_pcell nor2x1_pcell_0/w_87_786# nor2x1_pcell_0/a_362_382# nand2x1_pcell_0/a_168_375#
+ nor2x1_pcell_0/a_34_482# nand2x1_pcell_0/a_362_382# nand2x1_pcell_1/a_362_382# nand2x1_pcell_1/a_229_1059#
+ VSUBS
Xnand2x1_pcell_0 nand2x1_pcell_0/a_362_382# nor2x1_pcell_0/a_34_482# m1_537_501# VSUBS
+ nor2x1_pcell_0/w_87_786# nand2x1_pcell_0/a_168_375# nand2x1_pcell
Xnor2x1_pcell_0 nor2x1_pcell_0/a_362_382# m1_1203_501# nor2x1_pcell_0/a_34_482# VSUBS
+ m1_537_501# nor2x1_pcell_0/w_87_786# nor2x1_pcell
Xnand2x1_pcell_1 nand2x1_pcell_1/a_362_382# nor2x1_pcell_0/a_34_482# nand2x1_pcell_1/a_229_1059#
+ VSUBS nor2x1_pcell_0/w_87_786# m1_1203_501# nand2x1_pcell
.ends

.subckt aoa4x1_pcell aoai4x1_pcell_0/nand2x1_pcell_0/a_168_375# aoai4x1_pcell_0/nor2x1_pcell_0/a_362_382#
+ aoai4x1_pcell_0/nand2x1_pcell_0/a_362_382# aoai4x1_pcell_0/nand2x1_pcell_1/a_362_382#
+ invx1_pcell_0/a_206_1059# invx1_pcell_0/w_n87_786# VSUBS
Xinvx1_pcell_0 invx1_pcell_0/a_34_482# m1_1869_501# invx1_pcell_0/a_206_1059# invx1_pcell_0/w_n87_786#
+ VSUBS invx1_pcell
Xaoai4x1_pcell_0 invx1_pcell_0/w_n87_786# aoai4x1_pcell_0/nor2x1_pcell_0/a_362_382#
+ aoai4x1_pcell_0/nand2x1_pcell_0/a_168_375# invx1_pcell_0/a_34_482# aoai4x1_pcell_0/nand2x1_pcell_0/a_362_382#
+ aoai4x1_pcell_0/nand2x1_pcell_1/a_362_382# m1_1869_501# VSUBS aoai4x1_pcell
.ends

.subckt AOA4X1 Y A B C D VDD GND
Xaoa4x1_pcell_0 A C B D Y VDD GND aoa4x1_pcell
.ends

****EOF - AOA4X1.spice
****BOF - AOAI4X1.spice

* NGSPICE file created from AOAI4X1.ext - technology: sky130A

.subckt nmos_bottom a_56_54# a_86_84# a_0_0# VSUBS
X0 a_86_84# a_56_54# a_0_0# VSUBS sky130_fd_pr__nfet_01v8 ad=0.0597 pd=0.555 as=0.393 ps=2.99 w=3.01 l=0.15
.ends

.subckt nmos_top_trim1 a_86_92# a_56_62# a_0_0# VSUBS
X0 a_86_92# a_56_62# a_0_0# VSUBS sky130_fd_pr__nfet_01v8 ad=0.0597 pd=0.555 as=0.395 ps=2.97 w=3.01 l=0.15
.ends

.subckt pmos2 a_88_n400# a_144_n461# a_174_n400# a_262_n400# w_52_n436#
X0 a_262_n400# a_144_n461# a_174_n400# w_52_n436# sky130_fd_pr__pfet_01v8 ad=0.54 pd=4.54 as=0.29 ps=2.29 w=2 l=0.15
X1 a_174_n400# a_144_n461# a_88_n400# w_52_n436# sky130_fd_pr__pfet_01v8 ad=0.29 pd=2.29 as=0.56 ps=4.56 w=2 l=0.15
.ends

.subckt nand2x1_pcell a_362_382# a_31_480# a_229_1059# pmos2_1/VSUBS w_87_786# a_168_375#
Xnmos_bottom_0 a_168_375# pmos2_1/VSUBS nmos_bottom_0/a_0_0# pmos2_1/VSUBS nmos_bottom
Xnmos_top_trim1_0 a_229_1059# a_362_382# nmos_bottom_0/a_0_0# pmos2_1/VSUBS nmos_top_trim1
Xpmos2_0 w_87_786# a_168_375# a_229_1059# w_87_786# w_87_786# pmos2
Xpmos2_1 w_87_786# a_362_382# a_229_1059# w_87_786# w_87_786# pmos2
.ends

.subckt pmos2_1 a_144_n460# a_262_n399# a_88_n399# w_52_n435# a_174_n399#
X0 a_174_n399# a_144_n460# a_88_n399# w_52_n435# sky130_fd_pr__pfet_01v8 ad=0.29 pd=2.29 as=0.56 ps=4.56 w=2 l=0.15
X1 a_262_n399# a_144_n460# a_174_n399# w_52_n435# sky130_fd_pr__pfet_01v8 ad=0.54 pd=4.54 as=0.29 ps=2.29 w=2 l=0.15
.ends

.subckt nmos_top_trim2 a_86_92# a_56_62# a_0_0# VSUBS
X0 a_86_92# a_56_62# a_0_0# VSUBS sky130_fd_pr__nfet_01v8 ad=0.06 pd=0.56 as=0.395 ps=2.97 w=3.01 l=0.15
.ends

.subckt nor2x1_pcell a_362_382# a_405_1059# a_34_482# pmos2_1_1/VSUBS a_168_375# w_87_786#
Xpmos2_1_0 a_168_375# a_317_1331# a_317_1331# w_87_786# w_87_786# pmos2_1
Xpmos2_1_1 a_362_382# a_317_1331# a_317_1331# w_87_786# a_405_1059# pmos2_1
Xnmos_top_trim1_1 a_405_1059# a_168_375# pmos2_1_1/VSUBS pmos2_1_1/VSUBS nmos_top_trim1
Xnmos_top_trim2_0 a_405_1059# a_362_382# pmos2_1_1/VSUBS pmos2_1_1/VSUBS nmos_top_trim2
.ends

.subckt aoai4x1_pcell nor2x1_pcell_0/w_87_786# nor2x1_pcell_0/a_362_382# nand2x1_pcell_0/a_168_375#
+ nand2x1_pcell_0/a_362_382# nand2x1_pcell_1/a_362_382# nand2x1_pcell_1/a_229_1059#
+ VSUBS
Xnand2x1_pcell_0 nand2x1_pcell_0/a_362_382# nor2x1_pcell_0/a_34_482# m1_537_501# VSUBS
+ nor2x1_pcell_0/w_87_786# nand2x1_pcell_0/a_168_375# nand2x1_pcell
Xnor2x1_pcell_0 nor2x1_pcell_0/a_362_382# m1_1203_501# nor2x1_pcell_0/a_34_482# VSUBS
+ m1_537_501# nor2x1_pcell_0/w_87_786# nor2x1_pcell
Xnand2x1_pcell_1 nand2x1_pcell_1/a_362_382# nor2x1_pcell_0/a_34_482# nand2x1_pcell_1/a_229_1059#
+ VSUBS nor2x1_pcell_0/w_87_786# m1_1203_501# nand2x1_pcell
.ends

.subckt AOAI4X1 YN A B C D VDD GND
Xaoai4x1_pcell_0 VDD C A B D YN GND aoai4x1_pcell
.ends

****EOF - AOAI4X1.spice
****BOF - AOI3X1.spice

* NGSPICE file created from AOI3X1.ext - technology: sky130A

.subckt nmos_bottom a_56_54# a_86_84# a_0_0# VSUBS
X0 a_86_84# a_56_54# a_0_0# VSUBS sky130_fd_pr__nfet_01v8 ad=0.0597 pd=0.555 as=0.393 ps=2.99 w=3.01 l=0.15
.ends

.subckt nmos_top_trim1 a_86_92# a_56_62# a_0_0# VSUBS
X0 a_86_92# a_56_62# a_0_0# VSUBS sky130_fd_pr__nfet_01v8 ad=0.0597 pd=0.555 as=0.395 ps=2.97 w=3.01 l=0.15
.ends

.subckt pmos2 a_88_n400# a_144_n461# a_174_n400# a_262_n400# w_52_n436#
X0 a_262_n400# a_144_n461# a_174_n400# w_52_n436# sky130_fd_pr__pfet_01v8 ad=0.54 pd=4.54 as=0.29 ps=2.29 w=2 l=0.15
X1 a_174_n400# a_144_n461# a_88_n400# w_52_n436# sky130_fd_pr__pfet_01v8 ad=0.29 pd=2.29 as=0.56 ps=4.56 w=2 l=0.15
.ends

.subckt nand2x1_pcell a_362_382# a_31_480# a_229_1059# pmos2_1/VSUBS w_87_786# a_168_375#
Xnmos_bottom_0 a_168_375# pmos2_1/VSUBS nmos_bottom_0/a_0_0# pmos2_1/VSUBS nmos_bottom
Xnmos_top_trim1_0 a_229_1059# a_362_382# nmos_bottom_0/a_0_0# pmos2_1/VSUBS nmos_top_trim1
Xpmos2_0 w_87_786# a_168_375# a_229_1059# w_87_786# w_87_786# pmos2
Xpmos2_1 w_87_786# a_362_382# a_229_1059# w_87_786# w_87_786# pmos2
.ends

.subckt pmos2_1 a_144_n460# a_262_n399# a_88_n399# w_52_n435# a_174_n399#
X0 a_174_n399# a_144_n460# a_88_n399# w_52_n435# sky130_fd_pr__pfet_01v8 ad=0.29 pd=2.29 as=0.56 ps=4.56 w=2 l=0.15
X1 a_262_n399# a_144_n460# a_174_n399# w_52_n435# sky130_fd_pr__pfet_01v8 ad=0.54 pd=4.54 as=0.29 ps=2.29 w=2 l=0.15
.ends

.subckt nmos_top_trim2 a_86_92# a_56_62# a_0_0# VSUBS
X0 a_86_92# a_56_62# a_0_0# VSUBS sky130_fd_pr__nfet_01v8 ad=0.06 pd=0.56 as=0.395 ps=2.97 w=3.01 l=0.15
.ends

.subckt nor2x1_pcell a_362_382# a_405_1059# a_34_482# pmos2_1_1/VSUBS a_168_375# w_87_786#
Xpmos2_1_0 a_168_375# a_317_1331# a_317_1331# w_87_786# w_87_786# pmos2_1
Xpmos2_1_1 a_362_382# a_317_1331# a_317_1331# w_87_786# a_405_1059# pmos2_1
Xnmos_top_trim1_1 a_405_1059# a_168_375# pmos2_1_1/VSUBS pmos2_1_1/VSUBS nmos_top_trim1
Xnmos_top_trim2_0 a_405_1059# a_362_382# pmos2_1_1/VSUBS pmos2_1_1/VSUBS nmos_top_trim2
.ends

.subckt aoi3x1_pcell nor2x1_pcell_0/w_87_786# nor2x1_pcell_0/a_362_382# nand2x1_pcell_0/a_168_375#
+ nor2x1_pcell_0/a_405_1059# nand2x1_pcell_0/a_362_382# VSUBS
Xnand2x1_pcell_0 nand2x1_pcell_0/a_362_382# nor2x1_pcell_0/a_34_482# m1_537_501# VSUBS
+ nor2x1_pcell_0/w_87_786# nand2x1_pcell_0/a_168_375# nand2x1_pcell
Xnor2x1_pcell_0 nor2x1_pcell_0/a_362_382# nor2x1_pcell_0/a_405_1059# nor2x1_pcell_0/a_34_482#
+ VSUBS m1_537_501# nor2x1_pcell_0/w_87_786# nor2x1_pcell
.ends

.subckt AOI3X1 YN A B C VDD GND
Xaoi3x1_pcell_0 VDD C A YN B GND aoi3x1_pcell
.ends

****EOF - AOI3X1.spice
****BOF - BUFX1.spice

* NGSPICE file created from BUFX1.ext - technology: sky130A

.subckt nmos_top a_84_92# a_0_0# a_54_62# VSUBS
X0 a_84_92# a_54_62# a_0_0# VSUBS sky130_fd_pr__nfet_01v8 ad=0.0597 pd=0.555 as=0.39 ps=2.96 w=3.01 l=0.15
.ends

.subckt pmos2 a_88_n400# a_144_n461# a_174_n400# a_262_n400# w_52_n436#
X0 a_262_n400# a_144_n461# a_174_n400# w_52_n436# sky130_fd_pr__pfet_01v8 ad=0.54 pd=4.54 as=0.29 ps=2.29 w=2 l=0.15
X1 a_174_n400# a_144_n461# a_88_n400# w_52_n436# sky130_fd_pr__pfet_01v8 ad=0.29 pd=2.29 as=0.56 ps=4.56 w=2 l=0.15
.ends

.subckt invx1_pcell a_34_482# a_155_381# a_206_1059# w_n87_786# pmos2_0/VSUBS
Xnmos_top_0 a_206_1059# pmos2_0/VSUBS a_155_381# pmos2_0/VSUBS nmos_top
Xpmos2_0 w_n87_786# a_155_381# a_206_1059# w_n87_786# w_n87_786# pmos2
.ends

.subckt bufx1 invx1_pcell_1/w_n87_786# invx1_pcell_0/a_155_381# invx1_pcell_1/a_206_1059#
+ VSUBS
Xinvx1_pcell_0 invx1_pcell_1/a_34_482# invx1_pcell_0/a_155_381# m1_315_501# invx1_pcell_1/w_n87_786#
+ VSUBS invx1_pcell
Xinvx1_pcell_1 invx1_pcell_1/a_34_482# m1_315_501# invx1_pcell_1/a_206_1059# invx1_pcell_1/w_n87_786#
+ VSUBS invx1_pcell
.ends

.subckt BUFX1 Y A VDD GND
Xbufx1_0 VDD A Y GND bufx1
.ends

****EOF - BUFX1.spice
****BOF - DFFQNX1.spice

* NGSPICE file created from DFFQNX1.ext - technology: sky130A

.subckt nmos_bottom a_56_54# a_86_84# a_0_0# VSUBS
X0 a_86_84# a_56_54# a_0_0# VSUBS sky130_fd_pr__nfet_01v8 ad=0.0597 pd=0.555 as=0.393 ps=2.99 w=3.01 l=0.15
.ends

.subckt nmos_top_trim1 a_86_92# a_56_62# a_0_0# VSUBS
X0 a_86_92# a_56_62# a_0_0# VSUBS sky130_fd_pr__nfet_01v8 ad=0.0597 pd=0.555 as=0.395 ps=2.97 w=3.01 l=0.15
.ends

.subckt pmos2 a_88_n400# a_144_n461# a_174_n400# a_262_n400# w_52_n436#
X0 a_262_n400# a_144_n461# a_174_n400# w_52_n436# sky130_fd_pr__pfet_01v8 ad=0.54 pd=4.54 as=0.29 ps=2.29 w=2 l=0.15
X1 a_174_n400# a_144_n461# a_88_n400# w_52_n436# sky130_fd_pr__pfet_01v8 ad=0.29 pd=2.29 as=0.56 ps=4.56 w=2 l=0.15
.ends

.subckt nand2x1_pcell a_31_480# a_362_382# a_229_1059# pmos2_1/VSUBS a_168_375# w_87_786#
Xnmos_bottom_0 a_168_375# pmos2_1/VSUBS nmos_bottom_0/a_0_0# pmos2_1/VSUBS nmos_bottom
Xnmos_top_trim1_0 a_229_1059# a_362_382# nmos_bottom_0/a_0_0# pmos2_1/VSUBS nmos_top_trim1
Xpmos2_0 w_87_786# a_168_375# a_229_1059# w_87_786# w_87_786# pmos2
Xpmos2_1 w_87_786# a_362_382# a_229_1059# w_87_786# w_87_786# pmos2
.ends

.subckt nmos_side_left a_87_91# a_0_0# a_57_61# VSUBS
X0 a_87_91# a_57_61# a_0_0# VSUBS sky130_fd_pr__nfet_01v8 ad=0.0545 pd=0.53 as=0.404 ps=3.02 w=3 l=0.15
.ends

.subckt nand3x1_pcell a_34_482# a_447_377# li_649_449# a_289_1059# w_87_786# pmos2_2/VSUBS
+ a_147_377#
Xnmos_bottom_0 a_147_377# pmos2_2/VSUBS nmos_bottom_0/a_0_0# pmos2_2/VSUBS nmos_bottom
Xnmos_top_trim1_0 a_289_1059# li_649_449# li_393_182# pmos2_2/VSUBS nmos_top_trim1
Xnmos_side_left_0 li_393_182# nmos_bottom_0/a_0_0# a_447_377# pmos2_2/VSUBS nmos_side_left
Xpmos2_0 w_87_786# a_147_377# a_289_1059# w_87_786# w_87_786# pmos2
Xpmos2_1 w_87_786# a_447_377# a_289_1059# w_87_786# w_87_786# pmos2
Xpmos2_2 w_87_786# li_649_449# a_289_1059# w_87_786# w_87_786# pmos2
.ends

.subckt dffx1_pcell nand2x1_pcell_4/a_168_375# nand2x1_pcell_0/a_362_382# nand2x1_pcell_3/a_362_382#
+ m1_427_871# nand3x1_pcell_0/w_87_786# nand2x1_pcell_3/a_229_1059# nand2x1_pcell_4/a_229_1059#
+ VSUBS
Xnand2x1_pcell_2 nand3x1_pcell_0/a_34_482# m1_427_871# m1_258_797# VSUBS m1_2165_649#
+ nand3x1_pcell_0/w_87_786# nand2x1_pcell
Xnand2x1_pcell_3 nand3x1_pcell_0/a_34_482# nand2x1_pcell_3/a_362_382# nand2x1_pcell_3/a_229_1059#
+ VSUBS m1_833_723# nand3x1_pcell_0/w_87_786# nand2x1_pcell
Xnand2x1_pcell_4 nand3x1_pcell_0/a_34_482# m1_258_797# nand2x1_pcell_4/a_229_1059#
+ VSUBS nand2x1_pcell_4/a_168_375# nand3x1_pcell_0/w_87_786# nand2x1_pcell
Xnand3x1_pcell_0 nand3x1_pcell_0/a_34_482# m1_427_871# m1_685_649# m1_833_723# nand3x1_pcell_0/w_87_786#
+ VSUBS m1_258_797# nand3x1_pcell
Xnand2x1_pcell_0 nand3x1_pcell_0/a_34_482# nand2x1_pcell_0/a_362_382# m1_685_649#
+ VSUBS m1_833_723# nand3x1_pcell_0/w_87_786# nand2x1_pcell
Xnand2x1_pcell_1 nand3x1_pcell_0/a_34_482# m1_258_797# m1_2165_649# VSUBS m1_685_649#
+ nand3x1_pcell_0/w_87_786# nand2x1_pcell
.ends

.subckt DFFQNX1 QN D CLK VDD GND
Xdffx1_pcell_0 QN D m1_3481_759# CLK VDD QN m1_3481_759# GND dffx1_pcell
.ends

****EOF - DFFQNX1.spice
****BOF - DFFQX1.spice

* NGSPICE file created from DFFQX1.ext - technology: sky130A

.subckt nmos_bottom a_56_54# a_86_84# a_0_0# VSUBS
X0 a_86_84# a_56_54# a_0_0# VSUBS sky130_fd_pr__nfet_01v8 ad=0.0597 pd=0.555 as=0.393 ps=2.99 w=3.01 l=0.15
.ends

.subckt nmos_top_trim1 a_86_92# a_56_62# a_0_0# VSUBS
X0 a_86_92# a_56_62# a_0_0# VSUBS sky130_fd_pr__nfet_01v8 ad=0.0597 pd=0.555 as=0.395 ps=2.97 w=3.01 l=0.15
.ends

.subckt pmos2 a_88_n400# a_144_n461# a_174_n400# a_262_n400# w_52_n436#
X0 a_262_n400# a_144_n461# a_174_n400# w_52_n436# sky130_fd_pr__pfet_01v8 ad=0.54 pd=4.54 as=0.29 ps=2.29 w=2 l=0.15
X1 a_174_n400# a_144_n461# a_88_n400# w_52_n436# sky130_fd_pr__pfet_01v8 ad=0.29 pd=2.29 as=0.56 ps=4.56 w=2 l=0.15
.ends

.subckt nand2x1_pcell a_31_480# a_362_382# a_229_1059# pmos2_1/VSUBS a_168_375# w_87_786#
Xnmos_bottom_0 a_168_375# pmos2_1/VSUBS nmos_bottom_0/a_0_0# pmos2_1/VSUBS nmos_bottom
Xnmos_top_trim1_0 a_229_1059# a_362_382# nmos_bottom_0/a_0_0# pmos2_1/VSUBS nmos_top_trim1
Xpmos2_0 w_87_786# a_168_375# a_229_1059# w_87_786# w_87_786# pmos2
Xpmos2_1 w_87_786# a_362_382# a_229_1059# w_87_786# w_87_786# pmos2
.ends

.subckt nmos_side_left a_87_91# a_0_0# a_57_61# VSUBS
X0 a_87_91# a_57_61# a_0_0# VSUBS sky130_fd_pr__nfet_01v8 ad=0.0545 pd=0.53 as=0.404 ps=3.02 w=3 l=0.15
.ends

.subckt nand3x1_pcell a_34_482# a_447_377# li_649_449# a_289_1059# w_87_786# pmos2_2/VSUBS
+ a_147_377#
Xnmos_bottom_0 a_147_377# pmos2_2/VSUBS nmos_bottom_0/a_0_0# pmos2_2/VSUBS nmos_bottom
Xnmos_top_trim1_0 a_289_1059# li_649_449# li_393_182# pmos2_2/VSUBS nmos_top_trim1
Xnmos_side_left_0 li_393_182# nmos_bottom_0/a_0_0# a_447_377# pmos2_2/VSUBS nmos_side_left
Xpmos2_0 w_87_786# a_147_377# a_289_1059# w_87_786# w_87_786# pmos2
Xpmos2_1 w_87_786# a_447_377# a_289_1059# w_87_786# w_87_786# pmos2
Xpmos2_2 w_87_786# li_649_449# a_289_1059# w_87_786# w_87_786# pmos2
.ends

.subckt dffx1_pcell nand2x1_pcell_4/a_168_375# nand2x1_pcell_0/a_362_382# nand2x1_pcell_3/a_362_382#
+ m1_427_871# nand3x1_pcell_0/w_87_786# nand2x1_pcell_3/a_229_1059# nand2x1_pcell_4/a_229_1059#
+ VSUBS
Xnand2x1_pcell_2 nand3x1_pcell_0/a_34_482# m1_427_871# m1_258_797# VSUBS m1_2165_649#
+ nand3x1_pcell_0/w_87_786# nand2x1_pcell
Xnand2x1_pcell_3 nand3x1_pcell_0/a_34_482# nand2x1_pcell_3/a_362_382# nand2x1_pcell_3/a_229_1059#
+ VSUBS m1_833_723# nand3x1_pcell_0/w_87_786# nand2x1_pcell
Xnand2x1_pcell_4 nand3x1_pcell_0/a_34_482# m1_258_797# nand2x1_pcell_4/a_229_1059#
+ VSUBS nand2x1_pcell_4/a_168_375# nand3x1_pcell_0/w_87_786# nand2x1_pcell
Xnand3x1_pcell_0 nand3x1_pcell_0/a_34_482# m1_427_871# m1_685_649# m1_833_723# nand3x1_pcell_0/w_87_786#
+ VSUBS m1_258_797# nand3x1_pcell
Xnand2x1_pcell_0 nand3x1_pcell_0/a_34_482# nand2x1_pcell_0/a_362_382# m1_685_649#
+ VSUBS m1_833_723# nand3x1_pcell_0/w_87_786# nand2x1_pcell
Xnand2x1_pcell_1 nand3x1_pcell_0/a_34_482# m1_258_797# m1_2165_649# VSUBS m1_685_649#
+ nand3x1_pcell_0/w_87_786# nand2x1_pcell
.ends

.subckt DFFQX1 Q D CLK VDD GND
Xdffx1_pcell_0 m1_3629_685# D li1_M1_contact_8/li_n17_n33# CLK VDD li1_M1_contact_0/li_n17_n33#
+ Q GND dffx1_pcell
.ends

****EOF - DFFQX1.spice
****BOF - DFFRNQNX1.spice

* NGSPICE file created from DFFRNQNX1.ext - technology: sky130A

.subckt nmos_bottom a_56_54# a_86_84# a_0_0# VSUBS
X0 a_86_84# a_56_54# a_0_0# VSUBS sky130_fd_pr__nfet_01v8 ad=0.0597 pd=0.555 as=0.393 ps=2.99 w=3.01 l=0.15
.ends

.subckt nmos_top_trim1 a_86_92# a_56_62# a_0_0# VSUBS
X0 a_86_92# a_56_62# a_0_0# VSUBS sky130_fd_pr__nfet_01v8 ad=0.0597 pd=0.555 as=0.395 ps=2.97 w=3.01 l=0.15
.ends

.subckt nmos_side_left a_87_91# a_0_0# a_57_61# VSUBS
X0 a_87_91# a_57_61# a_0_0# VSUBS sky130_fd_pr__nfet_01v8 ad=0.0545 pd=0.53 as=0.404 ps=3.02 w=3 l=0.15
.ends

.subckt pmos2 a_88_n400# a_144_n461# a_174_n400# a_262_n400# w_52_n436#
X0 a_262_n400# a_144_n461# a_174_n400# w_52_n436# sky130_fd_pr__pfet_01v8 ad=0.54 pd=4.54 as=0.29 ps=2.29 w=2 l=0.15
X1 a_174_n400# a_144_n461# a_88_n400# w_52_n436# sky130_fd_pr__pfet_01v8 ad=0.29 pd=2.29 as=0.56 ps=4.56 w=2 l=0.15
.ends

.subckt nand3x1_pcell a_34_482# a_447_377# li_649_449# a_289_1059# w_87_786# pmos2_2/VSUBS
+ a_147_377#
Xnmos_bottom_0 a_147_377# pmos2_2/VSUBS nmos_bottom_0/a_0_0# pmos2_2/VSUBS nmos_bottom
Xnmos_top_trim1_0 a_289_1059# li_649_449# li_393_182# pmos2_2/VSUBS nmos_top_trim1
Xnmos_side_left_0 li_393_182# nmos_bottom_0/a_0_0# a_447_377# pmos2_2/VSUBS nmos_side_left
Xpmos2_0 w_87_786# a_147_377# a_289_1059# w_87_786# w_87_786# pmos2
Xpmos2_1 w_87_786# a_447_377# a_289_1059# w_87_786# w_87_786# pmos2
Xpmos2_2 w_87_786# li_649_449# a_289_1059# w_87_786# w_87_786# pmos2
.ends

.subckt nand2x1_pcell a_31_480# a_362_382# a_229_1059# pmos2_1/VSUBS w_87_786# a_168_375#
Xnmos_bottom_0 a_168_375# pmos2_1/VSUBS nmos_bottom_0/a_0_0# pmos2_1/VSUBS nmos_bottom
Xnmos_top_trim1_0 a_229_1059# a_362_382# nmos_bottom_0/a_0_0# pmos2_1/VSUBS nmos_top_trim1
Xpmos2_0 w_87_786# a_168_375# a_229_1059# w_87_786# w_87_786# pmos2
Xpmos2_1 w_87_786# a_362_382# a_229_1059# w_87_786# w_87_786# pmos2
.ends

.subckt dffrnx1_pcell m1_426_871# m1_1607_427# nand2x1_pcell_1/a_168_375# nand3x1_pcell_1/a_447_377#
+ nand2x1_pcell_1/a_229_1059# nand3x1_pcell_4/li_649_449# nand3x1_pcell_4/w_87_786#
+ nand3x1_pcell_4/a_289_1059# VSUBS
Xnand3x1_pcell_0 nand3x1_pcell_4/a_34_482# m1_426_871# m1_689_649# m1_867_723# nand3x1_pcell_4/w_87_786#
+ VSUBS m1_241_797# nand3x1_pcell
Xnand3x1_pcell_1 nand3x1_pcell_4/a_34_482# nand3x1_pcell_1/a_447_377# m1_1607_427#
+ m1_689_649# nand3x1_pcell_4/w_87_786# VSUBS m1_867_723# nand3x1_pcell
Xnand3x1_pcell_3 nand3x1_pcell_4/a_34_482# m1_426_871# m1_1607_427# m1_241_797# nand3x1_pcell_4/w_87_786#
+ VSUBS m1_2461_649# nand3x1_pcell
Xnand3x1_pcell_4 nand3x1_pcell_4/a_34_482# m1_1607_427# nand3x1_pcell_4/li_649_449#
+ nand3x1_pcell_4/a_289_1059# nand3x1_pcell_4/w_87_786# VSUBS m1_867_723# nand3x1_pcell
Xnand2x1_pcell_0 nand3x1_pcell_4/a_34_482# m1_241_797# m1_2461_649# VSUBS nand3x1_pcell_4/w_87_786#
+ m1_689_649# nand2x1_pcell
Xnand2x1_pcell_1 nand3x1_pcell_4/a_34_482# m1_241_797# nand2x1_pcell_1/a_229_1059#
+ VSUBS nand3x1_pcell_4/w_87_786# nand2x1_pcell_1/a_168_375# nand2x1_pcell
.ends

.subckt DFFRNQNX1 QN D CLK RN VDD GND
Xdffrnx1_pcell_0 CLK RN QN D m1_4369_759# li1_M1_contact_0/li_n17_n33# VDD QN GND
+ dffrnx1_pcell
.ends

****EOF - DFFRNQNX1.spice
****BOF - DFFRNQX1.spice

* NGSPICE file created from DFFRNQX1.ext - technology: sky130A

.subckt nmos_bottom a_56_54# a_86_84# a_0_0# VSUBS
X0 a_86_84# a_56_54# a_0_0# VSUBS sky130_fd_pr__nfet_01v8 ad=0.0597 pd=0.555 as=0.393 ps=2.99 w=3.01 l=0.15
.ends

.subckt nmos_top_trim1 a_86_92# a_56_62# a_0_0# VSUBS
X0 a_86_92# a_56_62# a_0_0# VSUBS sky130_fd_pr__nfet_01v8 ad=0.0597 pd=0.555 as=0.395 ps=2.97 w=3.01 l=0.15
.ends

.subckt nmos_side_left a_87_91# a_0_0# a_57_61# VSUBS
X0 a_87_91# a_57_61# a_0_0# VSUBS sky130_fd_pr__nfet_01v8 ad=0.0545 pd=0.53 as=0.404 ps=3.02 w=3 l=0.15
.ends

.subckt pmos2 a_88_n400# a_144_n461# a_174_n400# a_262_n400# w_52_n436#
X0 a_262_n400# a_144_n461# a_174_n400# w_52_n436# sky130_fd_pr__pfet_01v8 ad=0.54 pd=4.54 as=0.29 ps=2.29 w=2 l=0.15
X1 a_174_n400# a_144_n461# a_88_n400# w_52_n436# sky130_fd_pr__pfet_01v8 ad=0.29 pd=2.29 as=0.56 ps=4.56 w=2 l=0.15
.ends

.subckt nand3x1_pcell a_34_482# a_447_377# li_649_449# a_289_1059# w_87_786# pmos2_2/VSUBS
+ a_147_377#
Xnmos_bottom_0 a_147_377# pmos2_2/VSUBS nmos_bottom_0/a_0_0# pmos2_2/VSUBS nmos_bottom
Xnmos_top_trim1_0 a_289_1059# li_649_449# li_393_182# pmos2_2/VSUBS nmos_top_trim1
Xnmos_side_left_0 li_393_182# nmos_bottom_0/a_0_0# a_447_377# pmos2_2/VSUBS nmos_side_left
Xpmos2_0 w_87_786# a_147_377# a_289_1059# w_87_786# w_87_786# pmos2
Xpmos2_1 w_87_786# a_447_377# a_289_1059# w_87_786# w_87_786# pmos2
Xpmos2_2 w_87_786# li_649_449# a_289_1059# w_87_786# w_87_786# pmos2
.ends

.subckt nand2x1_pcell a_31_480# a_362_382# a_229_1059# pmos2_1/VSUBS a_168_375# w_87_786#
Xnmos_bottom_0 a_168_375# pmos2_1/VSUBS nmos_bottom_0/a_0_0# pmos2_1/VSUBS nmos_bottom
Xnmos_top_trim1_0 a_229_1059# a_362_382# nmos_bottom_0/a_0_0# pmos2_1/VSUBS nmos_top_trim1
Xpmos2_0 w_87_786# a_168_375# a_229_1059# w_87_786# w_87_786# pmos2
Xpmos2_1 w_87_786# a_362_382# a_229_1059# w_87_786# w_87_786# pmos2
.ends

.subckt dffrnx1_pcell nand2x1_pcell_1/a_168_375# m1_426_871# m1_1607_427# nand3x1_pcell_1/a_447_377#
+ nand2x1_pcell_1/a_229_1059# nand3x1_pcell_4/li_649_449# nand3x1_pcell_4/w_87_786#
+ nand3x1_pcell_4/a_289_1059# VSUBS
Xnand3x1_pcell_0 nand3x1_pcell_4/a_34_482# m1_426_871# m1_689_649# m1_867_723# nand3x1_pcell_4/w_87_786#
+ VSUBS m1_241_797# nand3x1_pcell
Xnand3x1_pcell_1 nand3x1_pcell_4/a_34_482# nand3x1_pcell_1/a_447_377# m1_1607_427#
+ m1_689_649# nand3x1_pcell_4/w_87_786# VSUBS m1_867_723# nand3x1_pcell
Xnand3x1_pcell_3 nand3x1_pcell_4/a_34_482# m1_426_871# m1_1607_427# m1_241_797# nand3x1_pcell_4/w_87_786#
+ VSUBS m1_2461_649# nand3x1_pcell
Xnand3x1_pcell_4 nand3x1_pcell_4/a_34_482# m1_1607_427# nand3x1_pcell_4/li_649_449#
+ nand3x1_pcell_4/a_289_1059# nand3x1_pcell_4/w_87_786# VSUBS m1_867_723# nand3x1_pcell
Xnand2x1_pcell_0 nand3x1_pcell_4/a_34_482# m1_241_797# m1_2461_649# VSUBS m1_689_649#
+ nand3x1_pcell_4/w_87_786# nand2x1_pcell
Xnand2x1_pcell_1 nand3x1_pcell_4/a_34_482# m1_241_797# nand2x1_pcell_1/a_229_1059#
+ VSUBS nand2x1_pcell_1/a_168_375# nand3x1_pcell_4/w_87_786# nand2x1_pcell
.ends

.subckt DFFRNQX1 Q D CLK RN VDD GND
Xdffrnx1_pcell_0 m1_4517_685# CLK RN D Q Q VDD li1_M1_contact_2/li_n17_n33# GND dffrnx1_pcell
.ends

****EOF - DFFRNQX1.spice
****BOF - DFFRNX1.spice

* NGSPICE file created from DFFRNX1.ext - technology: sky130A

.subckt nmos_bottom a_56_54# a_86_84# a_0_0# VSUBS
X0 a_86_84# a_56_54# a_0_0# VSUBS sky130_fd_pr__nfet_01v8 ad=0.0597 pd=0.555 as=0.393 ps=2.99 w=3.01 l=0.15
.ends

.subckt nmos_top_trim1 a_86_92# a_56_62# a_0_0# VSUBS
X0 a_86_92# a_56_62# a_0_0# VSUBS sky130_fd_pr__nfet_01v8 ad=0.0597 pd=0.555 as=0.395 ps=2.97 w=3.01 l=0.15
.ends

.subckt nmos_side_left a_87_91# a_0_0# a_57_61# VSUBS
X0 a_87_91# a_57_61# a_0_0# VSUBS sky130_fd_pr__nfet_01v8 ad=0.0545 pd=0.53 as=0.404 ps=3.02 w=3 l=0.15
.ends

.subckt pmos2 a_88_n400# a_144_n461# a_174_n400# a_262_n400# w_52_n436#
X0 a_262_n400# a_144_n461# a_174_n400# w_52_n436# sky130_fd_pr__pfet_01v8 ad=0.54 pd=4.54 as=0.29 ps=2.29 w=2 l=0.15
X1 a_174_n400# a_144_n461# a_88_n400# w_52_n436# sky130_fd_pr__pfet_01v8 ad=0.29 pd=2.29 as=0.56 ps=4.56 w=2 l=0.15
.ends

.subckt nand3x1_pcell a_34_482# a_447_377# li_649_449# a_289_1059# w_87_786# pmos2_2/VSUBS
+ a_147_377#
Xnmos_bottom_0 a_147_377# pmos2_2/VSUBS nmos_bottom_0/a_0_0# pmos2_2/VSUBS nmos_bottom
Xnmos_top_trim1_0 a_289_1059# li_649_449# li_393_182# pmos2_2/VSUBS nmos_top_trim1
Xnmos_side_left_0 li_393_182# nmos_bottom_0/a_0_0# a_447_377# pmos2_2/VSUBS nmos_side_left
Xpmos2_0 w_87_786# a_147_377# a_289_1059# w_87_786# w_87_786# pmos2
Xpmos2_1 w_87_786# a_447_377# a_289_1059# w_87_786# w_87_786# pmos2
Xpmos2_2 w_87_786# li_649_449# a_289_1059# w_87_786# w_87_786# pmos2
.ends

.subckt nand2x1_pcell a_31_480# a_362_382# a_229_1059# pmos2_1/VSUBS a_168_375# w_87_786#
Xnmos_bottom_0 a_168_375# pmos2_1/VSUBS nmos_bottom_0/a_0_0# pmos2_1/VSUBS nmos_bottom
Xnmos_top_trim1_0 a_229_1059# a_362_382# nmos_bottom_0/a_0_0# pmos2_1/VSUBS nmos_top_trim1
Xpmos2_0 w_87_786# a_168_375# a_229_1059# w_87_786# w_87_786# pmos2
Xpmos2_1 w_87_786# a_362_382# a_229_1059# w_87_786# w_87_786# pmos2
.ends

.subckt dffrnx1_pcell nand2x1_pcell_1/a_168_375# m1_1607_427# nand3x1_pcell_4/li_649_449#
+ nand3x1_pcell_4/w_87_786# nand2x1_pcell_1/a_229_1059# m1_426_871# nand3x1_pcell_1/a_447_377#
+ nand3x1_pcell_4/a_289_1059# VSUBS
Xnand3x1_pcell_0 nand3x1_pcell_4/a_34_482# m1_426_871# m1_689_649# m1_867_723# nand3x1_pcell_4/w_87_786#
+ VSUBS m1_241_797# nand3x1_pcell
Xnand3x1_pcell_1 nand3x1_pcell_4/a_34_482# nand3x1_pcell_1/a_447_377# m1_1607_427#
+ m1_689_649# nand3x1_pcell_4/w_87_786# VSUBS m1_867_723# nand3x1_pcell
Xnand3x1_pcell_3 nand3x1_pcell_4/a_34_482# m1_426_871# m1_1607_427# m1_241_797# nand3x1_pcell_4/w_87_786#
+ VSUBS m1_2461_649# nand3x1_pcell
Xnand3x1_pcell_4 nand3x1_pcell_4/a_34_482# m1_1607_427# nand3x1_pcell_4/li_649_449#
+ nand3x1_pcell_4/a_289_1059# nand3x1_pcell_4/w_87_786# VSUBS m1_867_723# nand3x1_pcell
Xnand2x1_pcell_0 nand3x1_pcell_4/a_34_482# m1_241_797# m1_2461_649# VSUBS m1_689_649#
+ nand3x1_pcell_4/w_87_786# nand2x1_pcell
Xnand2x1_pcell_1 nand3x1_pcell_4/a_34_482# m1_241_797# nand2x1_pcell_1/a_229_1059#
+ VSUBS nand2x1_pcell_1/a_168_375# nand3x1_pcell_4/w_87_786# nand2x1_pcell
.ends

.subckt DFFRNX1 Q QN D CLK RN GND
Xdffrnx1_pcell_0 QN RN Q VDD Q CLK D QN GND dffrnx1_pcell
.ends

****EOF - DFFRNX1.spice
****BOF - DFFSNQNX1.spice

* NGSPICE file created from DFFSNQNX1.ext - technology: sky130A

.subckt nmos_bottom a_56_54# a_86_84# a_0_0# VSUBS
X0 a_86_84# a_56_54# a_0_0# VSUBS sky130_fd_pr__nfet_01v8 ad=0.0597 pd=0.555 as=0.393 ps=2.99 w=3.01 l=0.15
.ends

.subckt nmos_top_trim1 a_86_92# a_56_62# a_0_0# VSUBS
X0 a_86_92# a_56_62# a_0_0# VSUBS sky130_fd_pr__nfet_01v8 ad=0.0597 pd=0.555 as=0.395 ps=2.97 w=3.01 l=0.15
.ends

.subckt pmos2 a_88_n400# a_144_n461# a_174_n400# a_262_n400# w_52_n436#
X0 a_262_n400# a_144_n461# a_174_n400# w_52_n436# sky130_fd_pr__pfet_01v8 ad=0.54 pd=4.54 as=0.29 ps=2.29 w=2 l=0.15
X1 a_174_n400# a_144_n461# a_88_n400# w_52_n436# sky130_fd_pr__pfet_01v8 ad=0.29 pd=2.29 as=0.56 ps=4.56 w=2 l=0.15
.ends

.subckt nand2x1_pcell a_31_480# a_362_382# a_229_1059# pmos2_1/VSUBS w_87_786# a_168_375#
Xnmos_bottom_0 a_168_375# pmos2_1/VSUBS nmos_bottom_0/a_0_0# pmos2_1/VSUBS nmos_bottom
Xnmos_top_trim1_0 a_229_1059# a_362_382# nmos_bottom_0/a_0_0# pmos2_1/VSUBS nmos_top_trim1
Xpmos2_0 w_87_786# a_168_375# a_229_1059# w_87_786# w_87_786# pmos2
Xpmos2_1 w_87_786# a_362_382# a_229_1059# w_87_786# w_87_786# pmos2
.ends

.subckt nmos_side_left a_87_91# a_0_0# a_57_61# VSUBS
X0 a_87_91# a_57_61# a_0_0# VSUBS sky130_fd_pr__nfet_01v8 ad=0.0545 pd=0.53 as=0.404 ps=3.02 w=3 l=0.15
.ends

.subckt nand3x1_pcell a_34_482# a_447_377# li_649_449# a_289_1059# pmos2_2/VSUBS a_147_377#
+ w_87_786#
Xnmos_bottom_0 a_147_377# pmos2_2/VSUBS nmos_bottom_0/a_0_0# pmos2_2/VSUBS nmos_bottom
Xnmos_top_trim1_0 a_289_1059# li_649_449# li_393_182# pmos2_2/VSUBS nmos_top_trim1
Xnmos_side_left_0 li_393_182# nmos_bottom_0/a_0_0# a_447_377# pmos2_2/VSUBS nmos_side_left
Xpmos2_0 w_87_786# a_147_377# a_289_1059# w_87_786# w_87_786# pmos2
Xpmos2_1 w_87_786# a_447_377# a_289_1059# w_87_786# w_87_786# pmos2
Xpmos2_2 w_87_786# li_649_449# a_289_1059# w_87_786# w_87_786# pmos2
.ends

.subckt dffsnx1_pcell nand2x1_pcell_5/a_168_375# nand3x1_pcell_1/a_147_377# nand2x1_pcell_2/a_362_382#
+ m1_1093_871# nand2x1_pcell_2/a_229_1059# nand3x1_pcell_1/a_289_1059# m1_2055_427#
+ VSUBS nand3x1_pcell_2/w_87_786#
Xnand2x1_pcell_2 nand3x1_pcell_2/a_34_482# nand2x1_pcell_2/a_362_382# nand2x1_pcell_2/a_229_1059#
+ VSUBS nand3x1_pcell_2/w_87_786# m1_406_797# nand2x1_pcell
Xnand2x1_pcell_5 nand3x1_pcell_2/a_34_482# m1_406_797# m1_537_501# VSUBS nand3x1_pcell_2/w_87_786#
+ nand2x1_pcell_5/a_168_375# nand2x1_pcell
Xnand3x1_pcell_0 nand3x1_pcell_2/a_34_482# m1_1093_871# m1_1351_723# m1_406_797# VSUBS
+ m1_537_501# nand3x1_pcell_2/w_87_786# nand3x1_pcell
Xnand3x1_pcell_1 nand3x1_pcell_2/a_34_482# m1_2055_427# m1_1351_723# nand3x1_pcell_1/a_289_1059#
+ VSUBS nand3x1_pcell_1/a_147_377# nand3x1_pcell_2/w_87_786# nand3x1_pcell
Xnand3x1_pcell_2 nand3x1_pcell_2/a_34_482# m1_2055_427# m1_1351_723# m1_2461_501#
+ VSUBS m1_537_501# nand3x1_pcell_2/w_87_786# nand3x1_pcell
Xnand2x1_pcell_0 nand3x1_pcell_2/a_34_482# m1_1093_871# m1_1351_723# VSUBS nand3x1_pcell_2/w_87_786#
+ m1_2461_501# nand2x1_pcell
.ends

.subckt DFFSNQNX1 QN D CLK SN VDD GND
Xdffsnx1_pcell_0 D QN li1_M1_contact_2/li_n17_n33# CLK QN m1_3777_685# SN GND VDD
+ dffsnx1_pcell
.ends

****EOF - DFFSNQNX1.spice
****BOF - DFFSNQX1.spice

* NGSPICE file created from DFFSNQX1.ext - technology: sky130A

.subckt nmos_bottom a_56_54# a_86_84# a_0_0# VSUBS
X0 a_86_84# a_56_54# a_0_0# VSUBS sky130_fd_pr__nfet_01v8 ad=0.0597 pd=0.555 as=0.393 ps=2.99 w=3.01 l=0.15
.ends

.subckt nmos_top_trim1 a_86_92# a_56_62# a_0_0# VSUBS
X0 a_86_92# a_56_62# a_0_0# VSUBS sky130_fd_pr__nfet_01v8 ad=0.0597 pd=0.555 as=0.395 ps=2.97 w=3.01 l=0.15
.ends

.subckt pmos2 a_88_n400# a_144_n461# a_174_n400# a_262_n400# w_52_n436#
X0 a_262_n400# a_144_n461# a_174_n400# w_52_n436# sky130_fd_pr__pfet_01v8 ad=0.54 pd=4.54 as=0.29 ps=2.29 w=2 l=0.15
X1 a_174_n400# a_144_n461# a_88_n400# w_52_n436# sky130_fd_pr__pfet_01v8 ad=0.29 pd=2.29 as=0.56 ps=4.56 w=2 l=0.15
.ends

.subckt nand2x1_pcell a_31_480# a_362_382# a_229_1059# pmos2_1/VSUBS a_168_375# w_87_786#
Xnmos_bottom_0 a_168_375# pmos2_1/VSUBS nmos_bottom_0/a_0_0# pmos2_1/VSUBS nmos_bottom
Xnmos_top_trim1_0 a_229_1059# a_362_382# nmos_bottom_0/a_0_0# pmos2_1/VSUBS nmos_top_trim1
Xpmos2_0 w_87_786# a_168_375# a_229_1059# w_87_786# w_87_786# pmos2
Xpmos2_1 w_87_786# a_362_382# a_229_1059# w_87_786# w_87_786# pmos2
.ends

.subckt nmos_side_left a_87_91# a_0_0# a_57_61# VSUBS
X0 a_87_91# a_57_61# a_0_0# VSUBS sky130_fd_pr__nfet_01v8 ad=0.0545 pd=0.53 as=0.404 ps=3.02 w=3 l=0.15
.ends

.subckt nand3x1_pcell a_34_482# a_447_377# li_649_449# a_289_1059# pmos2_2/VSUBS a_147_377#
+ w_87_786#
Xnmos_bottom_0 a_147_377# pmos2_2/VSUBS nmos_bottom_0/a_0_0# pmos2_2/VSUBS nmos_bottom
Xnmos_top_trim1_0 a_289_1059# li_649_449# li_393_182# pmos2_2/VSUBS nmos_top_trim1
Xnmos_side_left_0 li_393_182# nmos_bottom_0/a_0_0# a_447_377# pmos2_2/VSUBS nmos_side_left
Xpmos2_0 w_87_786# a_147_377# a_289_1059# w_87_786# w_87_786# pmos2
Xpmos2_1 w_87_786# a_447_377# a_289_1059# w_87_786# w_87_786# pmos2
Xpmos2_2 w_87_786# li_649_449# a_289_1059# w_87_786# w_87_786# pmos2
.ends

.subckt dffsnx1_pcell nand2x1_pcell_5/a_168_375# nand3x1_pcell_1/a_147_377# nand2x1_pcell_2/a_362_382#
+ m1_1093_871# nand2x1_pcell_2/a_229_1059# nand3x1_pcell_1/a_289_1059# m1_2055_427#
+ VSUBS nand3x1_pcell_2/w_87_786#
Xnand2x1_pcell_2 nand3x1_pcell_2/a_34_482# nand2x1_pcell_2/a_362_382# nand2x1_pcell_2/a_229_1059#
+ VSUBS m1_406_797# nand3x1_pcell_2/w_87_786# nand2x1_pcell
Xnand2x1_pcell_5 nand3x1_pcell_2/a_34_482# m1_406_797# m1_537_501# VSUBS nand2x1_pcell_5/a_168_375#
+ nand3x1_pcell_2/w_87_786# nand2x1_pcell
Xnand3x1_pcell_0 nand3x1_pcell_2/a_34_482# m1_1093_871# m1_1351_723# m1_406_797# VSUBS
+ m1_537_501# nand3x1_pcell_2/w_87_786# nand3x1_pcell
Xnand3x1_pcell_1 nand3x1_pcell_2/a_34_482# m1_2055_427# m1_1351_723# nand3x1_pcell_1/a_289_1059#
+ VSUBS nand3x1_pcell_1/a_147_377# nand3x1_pcell_2/w_87_786# nand3x1_pcell
Xnand3x1_pcell_2 nand3x1_pcell_2/a_34_482# m1_2055_427# m1_1351_723# m1_2461_501#
+ VSUBS m1_537_501# nand3x1_pcell_2/w_87_786# nand3x1_pcell
Xnand2x1_pcell_0 nand3x1_pcell_2/a_34_482# m1_1093_871# m1_1351_723# VSUBS m1_2461_501#
+ nand3x1_pcell_2/w_87_786# nand2x1_pcell
.ends

.subckt DFFSNQX1 Q D CLK SN VDD GND
Xdffsnx1_pcell_0 D m1_3925_611# Q CLK m1_3925_611# Q SN GND VDD dffsnx1_pcell
.ends

****EOF - DFFSNQX1.spice
****BOF - DFFSNRNQNX1.spice

* NGSPICE file created from DFFSNRNQNX1.ext - technology: sky130A

.subckt nmos_bottom a_56_54# a_86_84# a_0_0# VSUBS
X0 a_86_84# a_56_54# a_0_0# VSUBS sky130_fd_pr__nfet_01v8 ad=0.0597 pd=0.555 as=0.393 ps=2.99 w=3.01 l=0.15
.ends

.subckt nmos_top_trim1 a_86_92# a_56_62# a_0_0# VSUBS
X0 a_86_92# a_56_62# a_0_0# VSUBS sky130_fd_pr__nfet_01v8 ad=0.0597 pd=0.555 as=0.395 ps=2.97 w=3.01 l=0.15
.ends

.subckt nmos_side_left a_87_91# a_0_0# a_57_61# VSUBS
X0 a_87_91# a_57_61# a_0_0# VSUBS sky130_fd_pr__nfet_01v8 ad=0.0545 pd=0.53 as=0.404 ps=3.02 w=3 l=0.15
.ends

.subckt pmos2 a_88_n400# a_144_n461# a_174_n400# a_262_n400# w_52_n436#
X0 a_262_n400# a_144_n461# a_174_n400# w_52_n436# sky130_fd_pr__pfet_01v8 ad=0.54 pd=4.54 as=0.29 ps=2.29 w=2 l=0.15
X1 a_174_n400# a_144_n461# a_88_n400# w_52_n436# sky130_fd_pr__pfet_01v8 ad=0.29 pd=2.29 as=0.56 ps=4.56 w=2 l=0.15
.ends

.subckt nand3x1_pcell a_34_482# a_447_377# li_649_449# a_289_1059# pmos2_2/VSUBS w_87_786#
+ a_147_377#
Xnmos_bottom_0 a_147_377# pmos2_2/VSUBS nmos_bottom_0/a_0_0# pmos2_2/VSUBS nmos_bottom
Xnmos_top_trim1_0 a_289_1059# li_649_449# li_393_182# pmos2_2/VSUBS nmos_top_trim1
Xnmos_side_left_0 li_393_182# nmos_bottom_0/a_0_0# a_447_377# pmos2_2/VSUBS nmos_side_left
Xpmos2_0 w_87_786# a_147_377# a_289_1059# w_87_786# w_87_786# pmos2
Xpmos2_1 w_87_786# a_447_377# a_289_1059# w_87_786# w_87_786# pmos2
Xpmos2_2 w_87_786# li_649_449# a_289_1059# w_87_786# w_87_786# pmos2
.ends

.subckt DFFSNRNQNX1 QN D CLK SN RN VDD GND
Xnand3x1_pcell_0 nand3x1_pcell_0/a_34_482# RN m1_814_759# m1_965_612# GND VDD D nand3x1_pcell
Xnand3x1_pcell_1 GND CLK m1_1778_833# m1_814_759# GND VDD m1_965_612# nand3x1_pcell
Xnand3x1_pcell_2 GND SN m1_1778_833# m1_2889_611# GND VDD m1_965_612# nand3x1_pcell
Xnand3x1_pcell_3 GND CLK RN m1_1778_833# GND VDD m1_2889_611# nand3x1_pcell
Xnand3x1_pcell_4 GND RN m1_4665_759# QN GND VDD m1_814_759# nand3x1_pcell
Xnand3x1_pcell_5 GND SN m1_1778_833# m1_4665_759# GND VDD QN nand3x1_pcell
.ends

****EOF - DFFSNRNQNX1.spice
****BOF - DFFSNRNQX1.spice

* NGSPICE file created from DFFSNRNQX1.ext - technology: sky130A

.subckt nmos_bottom a_56_54# a_86_84# a_0_0# VSUBS
X0 a_86_84# a_56_54# a_0_0# VSUBS sky130_fd_pr__nfet_01v8 ad=0.0597 pd=0.555 as=0.393 ps=2.99 w=3.01 l=0.15
.ends

.subckt nmos_top_trim1 a_86_92# a_56_62# a_0_0# VSUBS
X0 a_86_92# a_56_62# a_0_0# VSUBS sky130_fd_pr__nfet_01v8 ad=0.0597 pd=0.555 as=0.395 ps=2.97 w=3.01 l=0.15
.ends

.subckt nmos_side_left a_87_91# a_0_0# a_57_61# VSUBS
X0 a_87_91# a_57_61# a_0_0# VSUBS sky130_fd_pr__nfet_01v8 ad=0.0545 pd=0.53 as=0.404 ps=3.02 w=3 l=0.15
.ends

.subckt pmos2 a_88_n400# a_144_n461# a_174_n400# a_262_n400# w_52_n436#
X0 a_262_n400# a_144_n461# a_174_n400# w_52_n436# sky130_fd_pr__pfet_01v8 ad=0.54 pd=4.54 as=0.29 ps=2.29 w=2 l=0.15
X1 a_174_n400# a_144_n461# a_88_n400# w_52_n436# sky130_fd_pr__pfet_01v8 ad=0.29 pd=2.29 as=0.56 ps=4.56 w=2 l=0.15
.ends

.subckt nand3x1_pcell a_34_482# a_447_377# li_649_449# a_289_1059# a_147_377# pmos2_2/VSUBS
+ w_87_786#
Xnmos_bottom_0 a_147_377# pmos2_2/VSUBS nmos_bottom_0/a_0_0# pmos2_2/VSUBS nmos_bottom
Xnmos_top_trim1_0 a_289_1059# li_649_449# li_393_182# pmos2_2/VSUBS nmos_top_trim1
Xnmos_side_left_0 li_393_182# nmos_bottom_0/a_0_0# a_447_377# pmos2_2/VSUBS nmos_side_left
Xpmos2_0 w_87_786# a_147_377# a_289_1059# w_87_786# w_87_786# pmos2
Xpmos2_1 w_87_786# a_447_377# a_289_1059# w_87_786# w_87_786# pmos2
Xpmos2_2 w_87_786# li_649_449# a_289_1059# w_87_786# w_87_786# pmos2
.ends

.subckt DFFSNRNQX1 Q D CLK SN RN VDD GND
Xnand3x1_pcell_0 nand3x1_pcell_0/a_34_482# RN m1_814_759# m1_929_612# D GND VDD nand3x1_pcell
Xnand3x1_pcell_1 GND CLK m1_1758_833# m1_814_759# m1_929_612# GND VDD nand3x1_pcell
Xnand3x1_pcell_2 GND SN m1_1758_833# m1_2855_611# m1_929_612# GND VDD nand3x1_pcell
Xnand3x1_pcell_3 GND CLK RN m1_1758_833# m1_2855_611# GND VDD nand3x1_pcell
Xnand3x1_pcell_4 GND RN Q m1_4743_685# m1_814_759# GND VDD nand3x1_pcell
Xnand3x1_pcell_5 GND SN m1_1758_833# Q m1_4743_685# GND VDD nand3x1_pcell
.ends

****EOF - DFFSNRNQX1.spice
****BOF - DFFSNRNX1.spice

* NGSPICE file created from DFFSNRNX1.ext - technology: sky130A

.subckt nmos_bottom a_56_54# a_86_84# a_0_0# VSUBS
X0 a_86_84# a_56_54# a_0_0# VSUBS sky130_fd_pr__nfet_01v8 ad=0.0597 pd=0.555 as=0.393 ps=2.99 w=3.01 l=0.15
.ends

.subckt nmos_top_trim1 a_86_92# a_56_62# a_0_0# VSUBS
X0 a_86_92# a_56_62# a_0_0# VSUBS sky130_fd_pr__nfet_01v8 ad=0.0597 pd=0.555 as=0.395 ps=2.97 w=3.01 l=0.15
.ends

.subckt nmos_side_left a_87_91# a_0_0# a_57_61# VSUBS
X0 a_87_91# a_57_61# a_0_0# VSUBS sky130_fd_pr__nfet_01v8 ad=0.0545 pd=0.53 as=0.404 ps=3.02 w=3 l=0.15
.ends

.subckt pmos2 a_88_n400# a_144_n461# a_174_n400# a_262_n400# w_52_n436#
X0 a_262_n400# a_144_n461# a_174_n400# w_52_n436# sky130_fd_pr__pfet_01v8 ad=0.54 pd=4.54 as=0.29 ps=2.29 w=2 l=0.15
X1 a_174_n400# a_144_n461# a_88_n400# w_52_n436# sky130_fd_pr__pfet_01v8 ad=0.29 pd=2.29 as=0.56 ps=4.56 w=2 l=0.15
.ends

.subckt nand3x1_pcell a_34_482# a_447_377# li_649_449# a_289_1059# pmos2_2/VSUBS w_87_786#
+ a_147_377#
Xnmos_bottom_0 a_147_377# pmos2_2/VSUBS nmos_bottom_0/a_0_0# pmos2_2/VSUBS nmos_bottom
Xnmos_top_trim1_0 a_289_1059# li_649_449# li_393_182# pmos2_2/VSUBS nmos_top_trim1
Xnmos_side_left_0 li_393_182# nmos_bottom_0/a_0_0# a_447_377# pmos2_2/VSUBS nmos_side_left
Xpmos2_0 w_87_786# a_147_377# a_289_1059# w_87_786# w_87_786# pmos2
Xpmos2_1 w_87_786# a_447_377# a_289_1059# w_87_786# w_87_786# pmos2
Xpmos2_2 w_87_786# li_649_449# a_289_1059# w_87_786# w_87_786# pmos2
.ends

.subckt DFFSNRNX1 Q QN D CLK SN RN VDD GND
Xnand3x1_pcell_0 nand3x1_pcell_0/a_34_482# RN m1_814_759# m1_929_612# GND VDD D nand3x1_pcell
Xnand3x1_pcell_1 GND CLK m1_1758_833# m1_814_759# GND VDD m1_929_612# nand3x1_pcell
Xnand3x1_pcell_2 GND SN m1_1758_833# m1_2855_611# GND VDD m1_929_612# nand3x1_pcell
Xnand3x1_pcell_3 GND CLK RN m1_1758_833# GND VDD m1_2855_611# nand3x1_pcell
Xnand3x1_pcell_4 GND RN Q QN GND VDD m1_814_759# nand3x1_pcell
Xnand3x1_pcell_5 GND SN m1_1758_833# Q GND VDD QN nand3x1_pcell
.ends

****EOF - DFFSNRNX1.spice
****BOF - DFFSNX1.spice

* NGSPICE file created from DFFSNX1.ext - technology: sky130A

.subckt nmos_bottom a_56_54# a_86_84# a_0_0# VSUBS
X0 a_86_84# a_56_54# a_0_0# VSUBS sky130_fd_pr__nfet_01v8 ad=0.0597 pd=0.555 as=0.393 ps=2.99 w=3.01 l=0.15
.ends

.subckt nmos_top_trim1 a_86_92# a_56_62# a_0_0# VSUBS
X0 a_86_92# a_56_62# a_0_0# VSUBS sky130_fd_pr__nfet_01v8 ad=0.0597 pd=0.555 as=0.395 ps=2.97 w=3.01 l=0.15
.ends

.subckt pmos2 a_88_n400# a_144_n461# a_174_n400# a_262_n400# w_52_n436#
X0 a_262_n400# a_144_n461# a_174_n400# w_52_n436# sky130_fd_pr__pfet_01v8 ad=0.54 pd=4.54 as=0.29 ps=2.29 w=2 l=0.15
X1 a_174_n400# a_144_n461# a_88_n400# w_52_n436# sky130_fd_pr__pfet_01v8 ad=0.29 pd=2.29 as=0.56 ps=4.56 w=2 l=0.15
.ends

.subckt nand2x1_pcell a_31_480# a_362_382# a_229_1059# pmos2_1/VSUBS a_168_375# w_87_786#
Xnmos_bottom_0 a_168_375# pmos2_1/VSUBS nmos_bottom_0/a_0_0# pmos2_1/VSUBS nmos_bottom
Xnmos_top_trim1_0 a_229_1059# a_362_382# nmos_bottom_0/a_0_0# pmos2_1/VSUBS nmos_top_trim1
Xpmos2_0 w_87_786# a_168_375# a_229_1059# w_87_786# w_87_786# pmos2
Xpmos2_1 w_87_786# a_362_382# a_229_1059# w_87_786# w_87_786# pmos2
.ends

.subckt nmos_side_left a_87_91# a_0_0# a_57_61# VSUBS
X0 a_87_91# a_57_61# a_0_0# VSUBS sky130_fd_pr__nfet_01v8 ad=0.0545 pd=0.53 as=0.404 ps=3.02 w=3 l=0.15
.ends

.subckt nand3x1_pcell a_34_482# a_447_377# li_649_449# a_289_1059# pmos2_2/VSUBS a_147_377#
+ w_87_786#
Xnmos_bottom_0 a_147_377# pmos2_2/VSUBS nmos_bottom_0/a_0_0# pmos2_2/VSUBS nmos_bottom
Xnmos_top_trim1_0 a_289_1059# li_649_449# li_393_182# pmos2_2/VSUBS nmos_top_trim1
Xnmos_side_left_0 li_393_182# nmos_bottom_0/a_0_0# a_447_377# pmos2_2/VSUBS nmos_side_left
Xpmos2_0 w_87_786# a_147_377# a_289_1059# w_87_786# w_87_786# pmos2
Xpmos2_1 w_87_786# a_447_377# a_289_1059# w_87_786# w_87_786# pmos2
Xpmos2_2 w_87_786# li_649_449# a_289_1059# w_87_786# w_87_786# pmos2
.ends

.subckt dffsnx1_pcell m1_2055_427# nand2x1_pcell_5/a_168_375# nand3x1_pcell_1/a_147_377#
+ nand2x1_pcell_2/a_362_382# m1_1093_871# nand2x1_pcell_2/a_229_1059# nand3x1_pcell_1/a_289_1059#
+ VSUBS nand3x1_pcell_2/w_87_786#
Xnand2x1_pcell_2 nand3x1_pcell_2/a_34_482# nand2x1_pcell_2/a_362_382# nand2x1_pcell_2/a_229_1059#
+ VSUBS m1_406_797# nand3x1_pcell_2/w_87_786# nand2x1_pcell
Xnand2x1_pcell_5 nand3x1_pcell_2/a_34_482# m1_406_797# m1_537_501# VSUBS nand2x1_pcell_5/a_168_375#
+ nand3x1_pcell_2/w_87_786# nand2x1_pcell
Xnand3x1_pcell_0 nand3x1_pcell_2/a_34_482# m1_1093_871# m1_1351_723# m1_406_797# VSUBS
+ m1_537_501# nand3x1_pcell_2/w_87_786# nand3x1_pcell
Xnand3x1_pcell_1 nand3x1_pcell_2/a_34_482# m1_2055_427# m1_1351_723# nand3x1_pcell_1/a_289_1059#
+ VSUBS nand3x1_pcell_1/a_147_377# nand3x1_pcell_2/w_87_786# nand3x1_pcell
Xnand3x1_pcell_2 nand3x1_pcell_2/a_34_482# m1_2055_427# m1_1351_723# m1_2461_501#
+ VSUBS m1_537_501# nand3x1_pcell_2/w_87_786# nand3x1_pcell
Xnand2x1_pcell_0 nand3x1_pcell_2/a_34_482# m1_1093_871# m1_1351_723# VSUBS m1_2461_501#
+ nand3x1_pcell_2/w_87_786# nand2x1_pcell
.ends

.subckt DFFSNX1 Q QN D CLK SN VDD GND
Xdffsnx1_pcell_0 SN D QN Q CLK QN Q GND VDD dffsnx1_pcell
.ends

****EOF - DFFSNX1.spice
****BOF - DFFX1.spice

* NGSPICE file created from DFFX1.ext - technology: sky130A

.subckt nmos_bottom a_56_54# a_86_84# a_0_0# VSUBS
X0 a_86_84# a_56_54# a_0_0# VSUBS sky130_fd_pr__nfet_01v8 ad=0.0597 pd=0.555 as=0.393 ps=2.99 w=3.01 l=0.15
.ends

.subckt nmos_top_trim1 a_86_92# a_56_62# a_0_0# VSUBS
X0 a_86_92# a_56_62# a_0_0# VSUBS sky130_fd_pr__nfet_01v8 ad=0.0597 pd=0.555 as=0.395 ps=2.97 w=3.01 l=0.15
.ends

.subckt pmos2 a_88_n400# a_144_n461# a_174_n400# a_262_n400# w_52_n436#
X0 a_262_n400# a_144_n461# a_174_n400# w_52_n436# sky130_fd_pr__pfet_01v8 ad=0.54 pd=4.54 as=0.29 ps=2.29 w=2 l=0.15
X1 a_174_n400# a_144_n461# a_88_n400# w_52_n436# sky130_fd_pr__pfet_01v8 ad=0.29 pd=2.29 as=0.56 ps=4.56 w=2 l=0.15
.ends

.subckt nand2x1_pcell a_31_480# a_362_382# a_229_1059# pmos2_1/VSUBS w_87_786# a_168_375#
Xnmos_bottom_0 a_168_375# pmos2_1/VSUBS nmos_bottom_0/a_0_0# pmos2_1/VSUBS nmos_bottom
Xnmos_top_trim1_0 a_229_1059# a_362_382# nmos_bottom_0/a_0_0# pmos2_1/VSUBS nmos_top_trim1
Xpmos2_0 w_87_786# a_168_375# a_229_1059# w_87_786# w_87_786# pmos2
Xpmos2_1 w_87_786# a_362_382# a_229_1059# w_87_786# w_87_786# pmos2
.ends

.subckt nmos_side_left a_87_91# a_0_0# a_57_61# VSUBS
X0 a_87_91# a_57_61# a_0_0# VSUBS sky130_fd_pr__nfet_01v8 ad=0.0545 pd=0.53 as=0.404 ps=3.02 w=3 l=0.15
.ends

.subckt nand3x1_pcell a_34_482# a_447_377# li_649_449# a_289_1059# w_87_786# pmos2_2/VSUBS
+ a_147_377#
Xnmos_bottom_0 a_147_377# pmos2_2/VSUBS nmos_bottom_0/a_0_0# pmos2_2/VSUBS nmos_bottom
Xnmos_top_trim1_0 a_289_1059# li_649_449# li_393_182# pmos2_2/VSUBS nmos_top_trim1
Xnmos_side_left_0 li_393_182# nmos_bottom_0/a_0_0# a_447_377# pmos2_2/VSUBS nmos_side_left
Xpmos2_0 w_87_786# a_147_377# a_289_1059# w_87_786# w_87_786# pmos2
Xpmos2_1 w_87_786# a_447_377# a_289_1059# w_87_786# w_87_786# pmos2
Xpmos2_2 w_87_786# li_649_449# a_289_1059# w_87_786# w_87_786# pmos2
.ends

.subckt dffx1_pcell nand2x1_pcell_0/a_362_382# nand3x1_pcell_0/w_87_786# m1_427_871#
+ nand2x1_pcell_3/a_229_1059# nand2x1_pcell_3/a_362_382# nand2x1_pcell_4/a_229_1059#
+ nand2x1_pcell_4/a_168_375# VSUBS
Xnand2x1_pcell_2 nand3x1_pcell_0/a_34_482# m1_427_871# m1_258_797# VSUBS nand3x1_pcell_0/w_87_786#
+ m1_2165_649# nand2x1_pcell
Xnand2x1_pcell_3 nand3x1_pcell_0/a_34_482# nand2x1_pcell_3/a_362_382# nand2x1_pcell_3/a_229_1059#
+ VSUBS nand3x1_pcell_0/w_87_786# m1_833_723# nand2x1_pcell
Xnand2x1_pcell_4 nand3x1_pcell_0/a_34_482# m1_258_797# nand2x1_pcell_4/a_229_1059#
+ VSUBS nand3x1_pcell_0/w_87_786# nand2x1_pcell_4/a_168_375# nand2x1_pcell
Xnand3x1_pcell_0 nand3x1_pcell_0/a_34_482# m1_427_871# m1_685_649# m1_833_723# nand3x1_pcell_0/w_87_786#
+ VSUBS m1_258_797# nand3x1_pcell
Xnand2x1_pcell_0 nand3x1_pcell_0/a_34_482# nand2x1_pcell_0/a_362_382# m1_685_649#
+ VSUBS nand3x1_pcell_0/w_87_786# m1_833_723# nand2x1_pcell
Xnand2x1_pcell_1 nand3x1_pcell_0/a_34_482# m1_258_797# m1_2165_649# VSUBS nand3x1_pcell_0/w_87_786#
+ m1_685_649# nand2x1_pcell
.ends

.subckt DFFX1 Q QN D CLK VDD GND
Xdffx1_pcell_0 D VDD CLK QN Q Q QN GND dffx1_pcell
.ends

****EOF - DFFX1.spice
****BOF - DLATCH.spice

* NGSPICE file created from DLATCH.ext - technology: sky130A

.subckt nmos_top a_84_92# a_0_0# a_54_62# VSUBS
X0 a_84_92# a_54_62# a_0_0# VSUBS sky130_fd_pr__nfet_01v8 ad=0.0597 pd=0.555 as=0.39 ps=2.96 w=3.01 l=0.15
.ends

.subckt pmos2 a_88_n400# a_144_n461# a_174_n400# a_262_n400# w_52_n436#
X0 a_262_n400# a_144_n461# a_174_n400# w_52_n436# sky130_fd_pr__pfet_01v8 ad=0.54 pd=4.54 as=0.29 ps=2.29 w=2 l=0.15
X1 a_174_n400# a_144_n461# a_88_n400# w_52_n436# sky130_fd_pr__pfet_01v8 ad=0.29 pd=2.29 as=0.56 ps=4.56 w=2 l=0.15
.ends

.subckt invx1_pcell a_34_482# a_155_381# a_206_1059# w_n87_786# pmos2_0/VSUBS
Xnmos_top_0 a_206_1059# pmos2_0/VSUBS a_155_381# pmos2_0/VSUBS nmos_top
Xpmos2_0 w_n87_786# a_155_381# a_206_1059# w_n87_786# w_n87_786# pmos2
.ends

.subckt nmos_bottom a_56_54# a_86_84# a_0_0# VSUBS
X0 a_86_84# a_56_54# a_0_0# VSUBS sky130_fd_pr__nfet_01v8 ad=0.0597 pd=0.555 as=0.393 ps=2.99 w=3.01 l=0.15
.ends

.subckt nmos_top_trim1 a_86_92# a_56_62# a_0_0# VSUBS
X0 a_86_92# a_56_62# a_0_0# VSUBS sky130_fd_pr__nfet_01v8 ad=0.0597 pd=0.555 as=0.395 ps=2.97 w=3.01 l=0.15
.ends

.subckt nand2x1_pcell a_31_480# a_362_382# a_229_1059# pmos2_1/VSUBS a_168_375# w_87_786#
Xnmos_bottom_0 a_168_375# pmos2_1/VSUBS nmos_bottom_0/a_0_0# pmos2_1/VSUBS nmos_bottom
Xnmos_top_trim1_0 a_229_1059# a_362_382# nmos_bottom_0/a_0_0# pmos2_1/VSUBS nmos_top_trim1
Xpmos2_0 w_87_786# a_168_375# a_229_1059# w_87_786# w_87_786# pmos2
Xpmos2_1 w_87_786# a_362_382# a_229_1059# w_87_786# w_87_786# pmos2
.ends

.subckt and2x1_pcell nand2x1_pcell_0/a_168_375# nand2x1_pcell_0/a_362_382# invx1_pcell_0/a_206_1059#
+ invx1_pcell_0/w_n87_786# VSUBS invx1_pcell_0/a_34_482#
Xinvx1_pcell_0 invx1_pcell_0/a_34_482# m1_547_649# invx1_pcell_0/a_206_1059# invx1_pcell_0/w_n87_786#
+ VSUBS invx1_pcell
Xnand2x1_pcell_0 invx1_pcell_0/a_34_482# nand2x1_pcell_0/a_362_382# m1_547_649# VSUBS
+ nand2x1_pcell_0/a_168_375# invx1_pcell_0/w_n87_786# nand2x1_pcell
.ends

.subckt pmos2_1 a_144_n460# a_262_n399# a_88_n399# w_52_n435# a_174_n399#
X0 a_174_n399# a_144_n460# a_88_n399# w_52_n435# sky130_fd_pr__pfet_01v8 ad=0.29 pd=2.29 as=0.56 ps=4.56 w=2 l=0.15
X1 a_262_n399# a_144_n460# a_174_n399# w_52_n435# sky130_fd_pr__pfet_01v8 ad=0.54 pd=4.54 as=0.29 ps=2.29 w=2 l=0.15
.ends

.subckt nmos_top_trim2 a_86_92# a_56_62# a_0_0# VSUBS
X0 a_86_92# a_56_62# a_0_0# VSUBS sky130_fd_pr__nfet_01v8 ad=0.06 pd=0.56 as=0.395 ps=2.97 w=3.01 l=0.15
.ends

.subckt nor2x1_pcell a_405_1059# a_34_482# a_362_382# pmos2_1_1/VSUBS w_87_786# a_168_375#
Xpmos2_1_0 a_168_375# a_317_1331# a_317_1331# w_87_786# w_87_786# pmos2_1
Xpmos2_1_1 a_362_382# a_317_1331# a_317_1331# w_87_786# a_405_1059# pmos2_1
Xnmos_top_trim1_1 a_405_1059# a_168_375# pmos2_1_1/VSUBS pmos2_1_1/VSUBS nmos_top_trim1
Xnmos_top_trim2_0 a_405_1059# a_362_382# pmos2_1_1/VSUBS pmos2_1_1/VSUBS nmos_top_trim2
.ends

.subckt DLATCH Q D GATE VDD GND
Xinvx1_pcell_0 GND D m1_447_759# VDD GND invx1_pcell
Xand2x1_pcell_0 m1_447_759# GATE m1_1557_759# VDD GND and2x1_pcell_0/invx1_pcell_0/a_34_482#
+ and2x1_pcell
Xand2x1_pcell_1 GATE D m1_2667_833# VDD GND GND and2x1_pcell
Xnor2x1_pcell_0 Q GND m1_3185_759# GND VDD m1_1557_759# nor2x1_pcell
Xnor2x1_pcell_1 m1_3185_759# GND m1_2667_833# GND VDD Q nor2x1_pcell
.ends

****EOF - DLATCH.spice
****BOF - DLATCHN.spice

* NGSPICE file created from DLATCHN.ext - technology: sky130A

.subckt nmos_top a_84_92# a_0_0# a_54_62# VSUBS
X0 a_84_92# a_54_62# a_0_0# VSUBS sky130_fd_pr__nfet_01v8 ad=0.0597 pd=0.555 as=0.39 ps=2.96 w=3.01 l=0.15
.ends

.subckt pmos2 a_88_n400# a_144_n461# a_174_n400# a_262_n400# w_52_n436#
X0 a_262_n400# a_144_n461# a_174_n400# w_52_n436# sky130_fd_pr__pfet_01v8 ad=0.54 pd=4.54 as=0.29 ps=2.29 w=2 l=0.15
X1 a_174_n400# a_144_n461# a_88_n400# w_52_n436# sky130_fd_pr__pfet_01v8 ad=0.29 pd=2.29 as=0.56 ps=4.56 w=2 l=0.15
.ends

.subckt invx1_pcell a_34_482# a_155_381# a_206_1059# w_n87_786# pmos2_0/VSUBS
Xnmos_top_0 a_206_1059# pmos2_0/VSUBS a_155_381# pmos2_0/VSUBS nmos_top
Xpmos2_0 w_n87_786# a_155_381# a_206_1059# w_n87_786# w_n87_786# pmos2
.ends

.subckt nmos_bottom a_56_54# a_86_84# a_0_0# VSUBS
X0 a_86_84# a_56_54# a_0_0# VSUBS sky130_fd_pr__nfet_01v8 ad=0.0597 pd=0.555 as=0.393 ps=2.99 w=3.01 l=0.15
.ends

.subckt nmos_top_trim1 a_86_92# a_56_62# a_0_0# VSUBS
X0 a_86_92# a_56_62# a_0_0# VSUBS sky130_fd_pr__nfet_01v8 ad=0.0597 pd=0.555 as=0.395 ps=2.97 w=3.01 l=0.15
.ends

.subckt nand2x1_pcell a_31_480# a_362_382# a_229_1059# pmos2_1/VSUBS a_168_375# w_87_786#
Xnmos_bottom_0 a_168_375# pmos2_1/VSUBS nmos_bottom_0/a_0_0# pmos2_1/VSUBS nmos_bottom
Xnmos_top_trim1_0 a_229_1059# a_362_382# nmos_bottom_0/a_0_0# pmos2_1/VSUBS nmos_top_trim1
Xpmos2_0 w_87_786# a_168_375# a_229_1059# w_87_786# w_87_786# pmos2
Xpmos2_1 w_87_786# a_362_382# a_229_1059# w_87_786# w_87_786# pmos2
.ends

.subckt and2x1_pcell nand2x1_pcell_0/a_168_375# nand2x1_pcell_0/a_362_382# invx1_pcell_0/a_206_1059#
+ invx1_pcell_0/w_n87_786# VSUBS invx1_pcell_0/a_34_482#
Xinvx1_pcell_0 invx1_pcell_0/a_34_482# m1_547_649# invx1_pcell_0/a_206_1059# invx1_pcell_0/w_n87_786#
+ VSUBS invx1_pcell
Xnand2x1_pcell_0 invx1_pcell_0/a_34_482# nand2x1_pcell_0/a_362_382# m1_547_649# VSUBS
+ nand2x1_pcell_0/a_168_375# invx1_pcell_0/w_n87_786# nand2x1_pcell
.ends

.subckt pmos2_1 a_144_n460# a_262_n399# a_88_n399# w_52_n435# a_174_n399#
X0 a_174_n399# a_144_n460# a_88_n399# w_52_n435# sky130_fd_pr__pfet_01v8 ad=0.29 pd=2.29 as=0.56 ps=4.56 w=2 l=0.15
X1 a_262_n399# a_144_n460# a_174_n399# w_52_n435# sky130_fd_pr__pfet_01v8 ad=0.54 pd=4.54 as=0.29 ps=2.29 w=2 l=0.15
.ends

.subckt nmos_top_trim2 a_86_92# a_56_62# a_0_0# VSUBS
X0 a_86_92# a_56_62# a_0_0# VSUBS sky130_fd_pr__nfet_01v8 ad=0.06 pd=0.56 as=0.395 ps=2.97 w=3.01 l=0.15
.ends

.subckt nor2x1_pcell a_405_1059# a_34_482# a_362_382# pmos2_1_1/VSUBS w_87_786# a_168_375#
Xpmos2_1_0 a_168_375# a_317_1331# a_317_1331# w_87_786# w_87_786# pmos2_1
Xpmos2_1_1 a_362_382# a_317_1331# a_317_1331# w_87_786# a_405_1059# pmos2_1
Xnmos_top_trim1_1 a_405_1059# a_168_375# pmos2_1_1/VSUBS pmos2_1_1/VSUBS nmos_top_trim1
Xnmos_top_trim2_0 a_405_1059# a_362_382# pmos2_1_1/VSUBS pmos2_1_1/VSUBS nmos_top_trim2
.ends

.subckt DLATCHN Q D GATE_N VDD GND
Xinvx1_pcell_0 GND D m1_891_759# VDD GND invx1_pcell
Xinvx1_pcell_1 GND GATE_N m1_447_611# VDD GND invx1_pcell
Xand2x1_pcell_0 m1_891_759# m1_447_611# m1_2001_759# VDD GND GND and2x1_pcell
Xand2x1_pcell_1 m1_447_611# D m1_3111_833# VDD GND GND and2x1_pcell
Xnor2x1_pcell_0 Q GND m1_3629_759# GND VDD m1_2001_759# nor2x1_pcell
Xnor2x1_pcell_1 m1_3629_759# GND m1_3111_833# GND VDD Q nor2x1_pcell
.ends

****EOF - DLATCHN.spice
****BOF - FA.spice

* NGSPICE file created from FA.ext - technology: sky130A

.subckt nmos_top a_84_92# a_0_0# a_54_62# VSUBS
X0 a_84_92# a_54_62# a_0_0# VSUBS sky130_fd_pr__nfet_01v8 ad=0.0597 pd=0.555 as=0.39 ps=2.96 w=3.01 l=0.15
.ends

.subckt pmos2 a_88_n400# a_144_n461# a_174_n400# a_262_n400# w_52_n436#
X0 a_262_n400# a_144_n461# a_174_n400# w_52_n436# sky130_fd_pr__pfet_01v8 ad=0.54 pd=4.54 as=0.29 ps=2.29 w=2 l=0.15
X1 a_174_n400# a_144_n461# a_88_n400# w_52_n436# sky130_fd_pr__pfet_01v8 ad=0.29 pd=2.29 as=0.56 ps=4.56 w=2 l=0.15
.ends

.subckt invx1_pcell a_34_482# a_206_1059# w_n87_786# pmos2_0/VSUBS a_155_381#
Xnmos_top_0 a_206_1059# pmos2_0/VSUBS a_155_381# pmos2_0/VSUBS nmos_top
Xpmos2_0 w_n87_786# a_155_381# a_206_1059# w_n87_786# w_n87_786# pmos2
.ends

.subckt pmos2_1 a_144_n460# a_262_n399# a_88_n399# w_52_n435# a_174_n399#
X0 a_174_n399# a_144_n460# a_88_n399# w_52_n435# sky130_fd_pr__pfet_01v8 ad=0.29 pd=2.29 as=0.56 ps=4.56 w=2 l=0.15
X1 a_262_n399# a_144_n460# a_174_n399# w_52_n435# sky130_fd_pr__pfet_01v8 ad=0.54 pd=4.54 as=0.29 ps=2.29 w=2 l=0.15
.ends

.subckt nmos_top_trim1 a_86_92# a_56_62# a_0_0# VSUBS
X0 a_86_92# a_56_62# a_0_0# VSUBS sky130_fd_pr__nfet_01v8 ad=0.0597 pd=0.555 as=0.395 ps=2.97 w=3.01 l=0.15
.ends

.subckt nmos_top_trim2 a_86_92# a_56_62# a_0_0# VSUBS
X0 a_86_92# a_56_62# a_0_0# VSUBS sky130_fd_pr__nfet_01v8 ad=0.06 pd=0.56 as=0.395 ps=2.97 w=3.01 l=0.15
.ends

.subckt nor2x1_pcell a_405_1059# a_34_482# a_362_382# pmos2_1_1/VSUBS a_168_375# w_87_786#
Xpmos2_1_0 a_168_375# a_317_1331# a_317_1331# w_87_786# w_87_786# pmos2_1
Xpmos2_1_1 a_362_382# a_317_1331# a_317_1331# w_87_786# a_405_1059# pmos2_1
Xnmos_top_trim1_1 a_405_1059# a_168_375# pmos2_1_1/VSUBS pmos2_1_1/VSUBS nmos_top_trim1
Xnmos_top_trim2_0 a_405_1059# a_362_382# pmos2_1_1/VSUBS pmos2_1_1/VSUBS nmos_top_trim2
.ends

.subckt or2x1_pcell nor2x1_pcell_0/a_168_375# nor2x1_pcell_0/w_87_786# invx1_pcell_0/a_34_482#
+ nor2x1_pcell_0/a_362_382# invx1_pcell_0/a_206_1059# VSUBS
Xinvx1_pcell_0 invx1_pcell_0/a_34_482# invx1_pcell_0/a_206_1059# nor2x1_pcell_0/w_87_786#
+ VSUBS m1_547_649# invx1_pcell
Xnor2x1_pcell_0 m1_547_649# invx1_pcell_0/a_34_482# nor2x1_pcell_0/a_362_382# VSUBS
+ nor2x1_pcell_0/a_168_375# nor2x1_pcell_0/w_87_786# nor2x1_pcell
.ends

.subckt nmos_bottom a_56_54# a_86_84# a_0_0# VSUBS
X0 a_86_84# a_56_54# a_0_0# VSUBS sky130_fd_pr__nfet_01v8 ad=0.0597 pd=0.555 as=0.393 ps=2.99 w=3.01 l=0.15
.ends

.subckt xor2X1_pcell a_1141_482# pmos2_1_3/VSUBS m1_981_723# a_806_383# a_478_482#
+ a_1141_n17# a_612_376# w_585_1330#
Xnmos_bottom_0 a_612_376# pmos2_1_3/VSUBS nmos_bottom_0/a_0_0# pmos2_1_3/VSUBS nmos_bottom
Xnmos_bottom_1 m1_939_797# pmos2_1_3/VSUBS nmos_bottom_1/a_0_0# pmos2_1_3/VSUBS nmos_bottom
Xpmos2_1_0 a_612_376# a_761_1330# a_761_1330# w_585_1330# w_585_1330# pmos2_1
Xnmos_top_trim1_1 m1_981_723# m1_315_501# nmos_bottom_1/a_0_0# pmos2_1_3/VSUBS nmos_top_trim1
Xnmos_top_trim1_0 m1_981_723# a_806_383# nmos_bottom_0/a_0_0# pmos2_1_3/VSUBS nmos_top_trim1
Xpmos2_1_1 m1_939_797# a_761_1330# a_761_1330# w_585_1330# m1_981_723# pmos2_1
Xpmos2_1_2 a_806_383# a_1427_1330# a_1427_1330# w_585_1330# w_585_1330# pmos2_1
Xpmos2_1_3 m1_315_501# a_1427_1330# a_1427_1330# w_585_1330# m1_981_723# pmos2_1
Xinvx1_pcell_0 pmos2_1_3/VSUBS m1_315_501# w_585_1330# pmos2_1_3/VSUBS a_612_376#
+ invx1_pcell
Xinvx1_pcell_1 pmos2_1_3/VSUBS m1_939_797# w_585_1330# pmos2_1_3/VSUBS a_806_383#
+ invx1_pcell
.ends

.subckt nand2x1_pcell a_31_480# a_362_382# a_229_1059# pmos2_1/VSUBS a_168_375# w_87_786#
Xnmos_bottom_0 a_168_375# pmos2_1/VSUBS nmos_bottom_0/a_0_0# pmos2_1/VSUBS nmos_bottom
Xnmos_top_trim1_0 a_229_1059# a_362_382# nmos_bottom_0/a_0_0# pmos2_1/VSUBS nmos_top_trim1
Xpmos2_0 w_87_786# a_168_375# a_229_1059# w_87_786# w_87_786# pmos2
Xpmos2_1 w_87_786# a_362_382# a_229_1059# w_87_786# w_87_786# pmos2
.ends

.subckt and2x1_pcell nand2x1_pcell_0/a_168_375# nand2x1_pcell_0/a_362_382# invx1_pcell_0/a_206_1059#
+ invx1_pcell_0/w_n87_786# VSUBS invx1_pcell_0/a_34_482#
Xinvx1_pcell_0 invx1_pcell_0/a_34_482# invx1_pcell_0/a_206_1059# invx1_pcell_0/w_n87_786#
+ VSUBS m1_547_649# invx1_pcell
Xnand2x1_pcell_0 invx1_pcell_0/a_34_482# nand2x1_pcell_0/a_362_382# m1_547_649# VSUBS
+ nand2x1_pcell_0/a_168_375# invx1_pcell_0/w_n87_786# nand2x1_pcell
.ends

.subckt FA SUM COUT A B CIN VDD GND
Xor2x1_pcell_0 m1_5553_611# VDD GND m1_6663_685# COUT GND or2x1_pcell
Xxor2X1_pcell_0 xor2X1_pcell_0/a_1141_482# GND m1_2519_463# B xor2X1_pcell_0/a_478_482#
+ GND A VDD xor2X1_pcell
Xand2x1_pcell_0 CIN m1_2519_463# m1_5553_611# VDD GND GND and2x1_pcell
Xxor2X1_pcell_1 GND GND SUM CIN GND GND m1_2519_463# VDD xor2X1_pcell
Xand2x1_pcell_1 B A m1_6663_685# VDD GND GND and2x1_pcell
.ends

****EOF - FA.spice
****BOF - FILL1.spice

* NGSPICE file created from FILL1.ext - technology: sky130A

.subckt FILL1 VDD GND
.ends

****EOF - FILL1.spice
****BOF - HA.spice

* NGSPICE file created from HA.ext - technology: sky130A

.subckt nmos_bottom a_56_54# a_86_84# a_0_0# VSUBS
X0 a_86_84# a_56_54# a_0_0# VSUBS sky130_fd_pr__nfet_01v8 ad=0.0597 pd=0.555 as=0.393 ps=2.99 w=3.01 l=0.15
.ends

.subckt pmos2_1 a_144_n460# a_262_n399# a_88_n399# w_52_n435# a_174_n399#
X0 a_174_n399# a_144_n460# a_88_n399# w_52_n435# sky130_fd_pr__pfet_01v8 ad=0.29 pd=2.29 as=0.56 ps=4.56 w=2 l=0.15
X1 a_262_n399# a_144_n460# a_174_n399# w_52_n435# sky130_fd_pr__pfet_01v8 ad=0.54 pd=4.54 as=0.29 ps=2.29 w=2 l=0.15
.ends

.subckt nmos_top_trim1 a_86_92# a_56_62# a_0_0# VSUBS
X0 a_86_92# a_56_62# a_0_0# VSUBS sky130_fd_pr__nfet_01v8 ad=0.0597 pd=0.555 as=0.395 ps=2.97 w=3.01 l=0.15
.ends

.subckt nmos_top a_84_92# a_0_0# a_54_62# VSUBS
X0 a_84_92# a_54_62# a_0_0# VSUBS sky130_fd_pr__nfet_01v8 ad=0.0597 pd=0.555 as=0.39 ps=2.96 w=3.01 l=0.15
.ends

.subckt pmos2 a_88_n400# a_144_n461# a_174_n400# a_262_n400# w_52_n436#
X0 a_262_n400# a_144_n461# a_174_n400# w_52_n436# sky130_fd_pr__pfet_01v8 ad=0.54 pd=4.54 as=0.29 ps=2.29 w=2 l=0.15
X1 a_174_n400# a_144_n461# a_88_n400# w_52_n436# sky130_fd_pr__pfet_01v8 ad=0.29 pd=2.29 as=0.56 ps=4.56 w=2 l=0.15
.ends

.subckt invx1_pcell a_34_482# a_155_381# a_206_1059# w_n87_786# pmos2_0/VSUBS
Xnmos_top_0 a_206_1059# pmos2_0/VSUBS a_155_381# pmos2_0/VSUBS nmos_top
Xpmos2_0 w_n87_786# a_155_381# a_206_1059# w_n87_786# w_n87_786# pmos2
.ends

.subckt xor2X1_pcell pmos2_1_3/VSUBS m1_981_723# a_612_376# a_806_383# a_1141_n17#
+ w_585_1330#
Xnmos_bottom_0 a_612_376# pmos2_1_3/VSUBS nmos_bottom_0/a_0_0# pmos2_1_3/VSUBS nmos_bottom
Xnmos_bottom_1 m1_939_797# pmos2_1_3/VSUBS nmos_bottom_1/a_0_0# pmos2_1_3/VSUBS nmos_bottom
Xpmos2_1_0 a_612_376# a_761_1330# a_761_1330# w_585_1330# w_585_1330# pmos2_1
Xnmos_top_trim1_1 m1_981_723# m1_315_501# nmos_bottom_1/a_0_0# pmos2_1_3/VSUBS nmos_top_trim1
Xnmos_top_trim1_0 m1_981_723# a_806_383# nmos_bottom_0/a_0_0# pmos2_1_3/VSUBS nmos_top_trim1
Xpmos2_1_1 m1_939_797# a_761_1330# a_761_1330# w_585_1330# m1_981_723# pmos2_1
Xpmos2_1_2 a_806_383# a_1427_1330# a_1427_1330# w_585_1330# w_585_1330# pmos2_1
Xpmos2_1_3 m1_315_501# a_1427_1330# a_1427_1330# w_585_1330# m1_981_723# pmos2_1
Xinvx1_pcell_0 pmos2_1_3/VSUBS a_612_376# m1_315_501# w_585_1330# pmos2_1_3/VSUBS
+ invx1_pcell
Xinvx1_pcell_1 pmos2_1_3/VSUBS a_806_383# m1_939_797# w_585_1330# pmos2_1_3/VSUBS
+ invx1_pcell
.ends

.subckt nand2x1_pcell a_31_480# a_362_382# a_229_1059# pmos2_1/VSUBS a_168_375# w_87_786#
Xnmos_bottom_0 a_168_375# pmos2_1/VSUBS nmos_bottom_0/a_0_0# pmos2_1/VSUBS nmos_bottom
Xnmos_top_trim1_0 a_229_1059# a_362_382# nmos_bottom_0/a_0_0# pmos2_1/VSUBS nmos_top_trim1
Xpmos2_0 w_87_786# a_168_375# a_229_1059# w_87_786# w_87_786# pmos2
Xpmos2_1 w_87_786# a_362_382# a_229_1059# w_87_786# w_87_786# pmos2
.ends

.subckt and2x1_pcell nand2x1_pcell_0/a_168_375# nand2x1_pcell_0/a_362_382# invx1_pcell_0/a_206_1059#
+ invx1_pcell_0/w_n87_786# VSUBS invx1_pcell_0/a_34_482#
Xinvx1_pcell_0 invx1_pcell_0/a_34_482# m1_547_649# invx1_pcell_0/a_206_1059# invx1_pcell_0/w_n87_786#
+ VSUBS invx1_pcell
Xnand2x1_pcell_0 invx1_pcell_0/a_34_482# nand2x1_pcell_0/a_362_382# m1_547_649# VSUBS
+ nand2x1_pcell_0/a_168_375# invx1_pcell_0/w_n87_786# nand2x1_pcell
.ends

.subckt HA SUM COUT A B VDD GND
Xxor2X1_pcell_0 GND SUM A B GND VDD xor2X1_pcell
Xand2x1_pcell_0 A B COUT VDD GND GND and2x1_pcell
.ends

****EOF - HA.spice
****BOF - INVX1.spice

* NGSPICE file created from INVX1.ext - technology: sky130A

.subckt nmos_top a_84_92# a_0_0# a_54_62# VSUBS
X0 a_84_92# a_54_62# a_0_0# VSUBS sky130_fd_pr__nfet_01v8 ad=0.0597 pd=0.555 as=0.39 ps=2.96 w=3.01 l=0.15
.ends

.subckt pmos2 a_88_n400# a_144_n461# a_174_n400# a_262_n400# w_52_n436#
X0 a_262_n400# a_144_n461# a_174_n400# w_52_n436# sky130_fd_pr__pfet_01v8 ad=0.54 pd=4.54 as=0.29 ps=2.29 w=2 l=0.15
X1 a_174_n400# a_144_n461# a_88_n400# w_52_n436# sky130_fd_pr__pfet_01v8 ad=0.29 pd=2.29 as=0.56 ps=4.56 w=2 l=0.15
.ends

.subckt invx1_pcell a_155_381# a_206_1059# w_n87_786# pmos2_0/VSUBS
Xnmos_top_0 a_206_1059# pmos2_0/VSUBS a_155_381# pmos2_0/VSUBS nmos_top
Xpmos2_0 w_n87_786# a_155_381# a_206_1059# w_n87_786# w_n87_786# pmos2
.ends

.subckt INVX1 Y A VDD GND
Xinvx1_pcell_0 A Y VDD GND invx1_pcell
.ends

****EOF - INVX1.spice
****BOF - MUX2X1.spice

* NGSPICE file created from MUX2X1.ext - technology: sky130A

.subckt nmos_bottom a_56_54# a_86_84# a_0_0# VSUBS
X0 a_86_84# a_56_54# a_0_0# VSUBS sky130_fd_pr__nfet_01v8 ad=0.0597 pd=0.555 as=0.393 ps=2.99 w=3.01 l=0.15
.ends

.subckt nmos_top_trim1 a_86_92# a_56_62# a_0_0# VSUBS
X0 a_86_92# a_56_62# a_0_0# VSUBS sky130_fd_pr__nfet_01v8 ad=0.0597 pd=0.555 as=0.395 ps=2.97 w=3.01 l=0.15
.ends

.subckt pmos2 a_88_n400# a_144_n461# a_174_n400# a_262_n400# w_52_n436#
X0 a_262_n400# a_144_n461# a_174_n400# w_52_n436# sky130_fd_pr__pfet_01v8 ad=0.54 pd=4.54 as=0.29 ps=2.29 w=2 l=0.15
X1 a_174_n400# a_144_n461# a_88_n400# w_52_n436# sky130_fd_pr__pfet_01v8 ad=0.29 pd=2.29 as=0.56 ps=4.56 w=2 l=0.15
.ends

.subckt nand2x1_pcell a_31_480# a_362_382# a_229_1059# pmos2_1/VSUBS a_168_375# w_87_786#
Xnmos_bottom_0 a_168_375# pmos2_1/VSUBS nmos_bottom_0/a_0_0# pmos2_1/VSUBS nmos_bottom
Xnmos_top_trim1_0 a_229_1059# a_362_382# nmos_bottom_0/a_0_0# pmos2_1/VSUBS nmos_top_trim1
Xpmos2_0 w_87_786# a_168_375# a_229_1059# w_87_786# w_87_786# pmos2
Xpmos2_1 w_87_786# a_362_382# a_229_1059# w_87_786# w_87_786# pmos2
.ends

.subckt nmos_top a_84_92# a_0_0# a_54_62# VSUBS
X0 a_84_92# a_54_62# a_0_0# VSUBS sky130_fd_pr__nfet_01v8 ad=0.0597 pd=0.555 as=0.39 ps=2.96 w=3.01 l=0.15
.ends

.subckt invx1_pcell a_34_482# a_155_381# a_206_1059# w_n87_786# pmos2_0/VSUBS
Xnmos_top_0 a_206_1059# pmos2_0/VSUBS a_155_381# pmos2_0/VSUBS nmos_top
Xpmos2_0 w_n87_786# a_155_381# a_206_1059# w_n87_786# w_n87_786# pmos2
.ends

.subckt mux2x1_pcell nand2x1_pcell_0/a_362_382# nand2x1_pcell_1/a_362_382# m1_120_575#
+ nand2x1_pcell_2/a_229_1059# invx1_pcell_0/w_n87_786# VSUBS
Xnand2x1_pcell_2 invx1_pcell_0/a_34_482# m1_1647_649# nand2x1_pcell_2/a_229_1059#
+ VSUBS m1_981_575# invx1_pcell_0/w_n87_786# nand2x1_pcell
Xinvx1_pcell_0 invx1_pcell_0/a_34_482# m1_120_575# m1_315_649# invx1_pcell_0/w_n87_786#
+ VSUBS invx1_pcell
Xnand2x1_pcell_0 invx1_pcell_0/a_34_482# nand2x1_pcell_0/a_362_382# m1_981_575# VSUBS
+ m1_120_575# invx1_pcell_0/w_n87_786# nand2x1_pcell
Xnand2x1_pcell_1 invx1_pcell_0/a_34_482# nand2x1_pcell_1/a_362_382# m1_1647_649# VSUBS
+ m1_315_649# invx1_pcell_0/w_n87_786# nand2x1_pcell
.ends

.subckt MUX2X1 Y A0 A1 S VDD GND
Xmux2x1_pcell_0 A0 A1 S Y VDD GND mux2x1_pcell
.ends

****EOF - MUX2X1.spice
****BOF - NAND2X1.spice

* NGSPICE file created from NAND2X1.ext - technology: sky130A

.subckt nmos_bottom a_56_54# a_86_84# a_0_0# VSUBS
X0 a_86_84# a_56_54# a_0_0# VSUBS sky130_fd_pr__nfet_01v8 ad=0.0597 pd=0.555 as=0.393 ps=2.99 w=3.01 l=0.15
.ends

.subckt nmos_top_trim1 a_86_92# a_56_62# a_0_0# VSUBS
X0 a_86_92# a_56_62# a_0_0# VSUBS sky130_fd_pr__nfet_01v8 ad=0.0597 pd=0.555 as=0.395 ps=2.97 w=3.01 l=0.15
.ends

.subckt pmos2 a_88_n400# a_144_n461# a_174_n400# a_262_n400# w_52_n436#
X0 a_262_n400# a_144_n461# a_174_n400# w_52_n436# sky130_fd_pr__pfet_01v8 ad=0.54 pd=4.54 as=0.29 ps=2.29 w=2 l=0.15
X1 a_174_n400# a_144_n461# a_88_n400# w_52_n436# sky130_fd_pr__pfet_01v8 ad=0.29 pd=2.29 as=0.56 ps=4.56 w=2 l=0.15
.ends

.subckt nand2x1_pcell a_362_382# a_229_1059# pmos2_1/VSUBS w_87_786# a_168_375#
Xnmos_bottom_0 a_168_375# pmos2_1/VSUBS nmos_bottom_0/a_0_0# pmos2_1/VSUBS nmos_bottom
Xnmos_top_trim1_0 a_229_1059# a_362_382# nmos_bottom_0/a_0_0# pmos2_1/VSUBS nmos_top_trim1
Xpmos2_0 w_87_786# a_168_375# a_229_1059# w_87_786# w_87_786# pmos2
Xpmos2_1 w_87_786# a_362_382# a_229_1059# w_87_786# w_87_786# pmos2
.ends

.subckt NAND2X1 Y A B VDD GND
Xnand2x_pcell_0 B Y GND VDD A nand2x1_pcell
.ends

****EOF - NAND2X1.spice
****BOF - NAND3X1.spice

* NGSPICE file created from NAND3X1.ext - technology: sky130A

.subckt nmos_bottom a_56_54# a_86_84# a_0_0# VSUBS
X0 a_86_84# a_56_54# a_0_0# VSUBS sky130_fd_pr__nfet_01v8 ad=0.0597 pd=0.555 as=0.393 ps=2.99 w=3.01 l=0.15
.ends

.subckt nmos_top_trim1 a_86_92# a_56_62# a_0_0# VSUBS
X0 a_86_92# a_56_62# a_0_0# VSUBS sky130_fd_pr__nfet_01v8 ad=0.0597 pd=0.555 as=0.395 ps=2.97 w=3.01 l=0.15
.ends

.subckt nmos_side_left a_87_91# a_0_0# a_57_61# VSUBS
X0 a_87_91# a_57_61# a_0_0# VSUBS sky130_fd_pr__nfet_01v8 ad=0.0545 pd=0.53 as=0.404 ps=3.02 w=3 l=0.15
.ends

.subckt pmos2 a_88_n400# a_144_n461# a_174_n400# a_262_n400# w_52_n436#
X0 a_262_n400# a_144_n461# a_174_n400# w_52_n436# sky130_fd_pr__pfet_01v8 ad=0.54 pd=4.54 as=0.29 ps=2.29 w=2 l=0.15
X1 a_174_n400# a_144_n461# a_88_n400# w_52_n436# sky130_fd_pr__pfet_01v8 ad=0.29 pd=2.29 as=0.56 ps=4.56 w=2 l=0.15
.ends

.subckt nand3x1_pcell a_447_377# li_649_449# a_289_1059# w_87_786# pmos2_2/VSUBS a_147_377#
Xnmos_bottom_0 a_147_377# pmos2_2/VSUBS nmos_bottom_0/a_0_0# pmos2_2/VSUBS nmos_bottom
Xnmos_top_trim1_0 a_289_1059# li_649_449# li_393_182# pmos2_2/VSUBS nmos_top_trim1
Xnmos_side_left_0 li_393_182# nmos_bottom_0/a_0_0# a_447_377# pmos2_2/VSUBS nmos_side_left
Xpmos2_0 w_87_786# a_147_377# a_289_1059# w_87_786# w_87_786# pmos2
Xpmos2_1 w_87_786# a_447_377# a_289_1059# w_87_786# w_87_786# pmos2
Xpmos2_2 w_87_786# li_649_449# a_289_1059# w_87_786# w_87_786# pmos2
.ends

.subckt NAND3X1 Y A B C VDD GND
Xnand3x1_pcell_0 B C Y VDD GND A nand3x1_pcell
.ends

****EOF - NAND3X1.spice
****BOF - NOR2X1.spice

* NGSPICE file created from NOR2X1.ext - technology: sky130A

.subckt pmos2_1 a_144_n460# a_262_n399# a_88_n399# w_52_n435# a_174_n399#
X0 a_174_n399# a_144_n460# a_88_n399# w_52_n435# sky130_fd_pr__pfet_01v8 ad=0.29 pd=2.29 as=0.56 ps=4.56 w=2 l=0.15
X1 a_262_n399# a_144_n460# a_174_n399# w_52_n435# sky130_fd_pr__pfet_01v8 ad=0.54 pd=4.54 as=0.29 ps=2.29 w=2 l=0.15
.ends

.subckt nmos_top_trim1 a_86_92# a_56_62# a_0_0# VSUBS
X0 a_86_92# a_56_62# a_0_0# VSUBS sky130_fd_pr__nfet_01v8 ad=0.0597 pd=0.555 as=0.395 ps=2.97 w=3.01 l=0.15
.ends

.subckt nmos_top_trim2 a_86_92# a_56_62# a_0_0# VSUBS
X0 a_86_92# a_56_62# a_0_0# VSUBS sky130_fd_pr__nfet_01v8 ad=0.06 pd=0.56 as=0.395 ps=2.97 w=3.01 l=0.15
.ends

.subckt nor2x1_pcell a_362_382# a_405_1059# pmos2_1_1/VSUBS w_87_786# a_168_375#
Xpmos2_1_0 a_168_375# a_317_1331# a_317_1331# w_87_786# w_87_786# pmos2_1
Xpmos2_1_1 a_362_382# a_317_1331# a_317_1331# w_87_786# a_405_1059# pmos2_1
Xnmos_top_trim1_1 a_405_1059# a_168_375# pmos2_1_1/VSUBS pmos2_1_1/VSUBS nmos_top_trim1
Xnmos_top_trim2_0 a_405_1059# a_362_382# pmos2_1_1/VSUBS pmos2_1_1/VSUBS nmos_top_trim2
.ends

.subckt NOR2X1 Y A B VDD GND
Xnor2x1_pcell_0 B Y GND VDD A nor2x1_pcell
.ends

****EOF - NOR2X1.spice
****BOF - NOR3X1.spice

* NGSPICE file created from NOR3X1.ext - technology: sky130A

.subckt pmos2_1 a_144_n460# a_262_n399# a_88_n399# w_52_n435# a_174_n399#
X0 a_174_n399# a_144_n460# a_88_n399# w_52_n435# sky130_fd_pr__pfet_01v8 ad=0.29 pd=2.29 as=0.56 ps=4.56 w=2 l=0.15
X1 a_262_n399# a_144_n460# a_174_n399# w_52_n435# sky130_fd_pr__pfet_01v8 ad=0.54 pd=4.54 as=0.29 ps=2.29 w=2 l=0.15
.ends

.subckt nmos_top_trim1 a_86_92# a_56_62# a_0_0# VSUBS
X0 a_86_92# a_56_62# a_0_0# VSUBS sky130_fd_pr__nfet_01v8 ad=0.0597 pd=0.555 as=0.395 ps=2.97 w=3.01 l=0.15
.ends

.subckt nmos_top_trim2 a_86_92# a_56_62# a_0_0# VSUBS
X0 a_86_92# a_56_62# a_0_0# VSUBS sky130_fd_pr__nfet_01v8 ad=0.06 pd=0.56 as=0.395 ps=2.97 w=3.01 l=0.15
.ends

.subckt nor3x1_pcell a_362_382# a_619_944# li_219_233# pmos2_1_2/VSUBS w_87_786# a_168_375#
Xpmos2_1_0 a_168_375# a_317_1331# a_317_1331# w_87_786# w_87_786# pmos2_1
Xpmos2_1_1 a_362_382# a_317_1331# a_317_1331# w_87_786# a_613_1331# pmos2_1
Xnmos_top_trim1_1 li_219_233# a_168_375# pmos2_1_2/VSUBS pmos2_1_2/VSUBS nmos_top_trim1
Xpmos2_1_2 a_619_944# a_613_1331# a_613_1331# w_87_786# li_219_233# pmos2_1
Xnmos_top_trim2_0 li_219_233# a_362_382# pmos2_1_2/VSUBS pmos2_1_2/VSUBS nmos_top_trim2
Xnmos_top_trim2_1 li_219_233# a_619_944# pmos2_1_2/VSUBS pmos2_1_2/VSUBS nmos_top_trim2
.ends

.subckt NOR3X1 Y A B C VDD GND
Xnor3x1_pcell_0 B C Y GND VDD A nor3x1_pcell
.ends

****EOF - NOR3X1.spice
****BOF - OR2X1.spice

* NGSPICE file created from OR2X1.ext - technology: sky130A

.subckt nmos_top a_84_92# a_0_0# a_54_62# VSUBS
X0 a_84_92# a_54_62# a_0_0# VSUBS sky130_fd_pr__nfet_01v8 ad=0.0597 pd=0.555 as=0.39 ps=2.96 w=3.01 l=0.15
.ends

.subckt pmos2 a_88_n400# a_144_n461# a_174_n400# a_262_n400# w_52_n436#
X0 a_262_n400# a_144_n461# a_174_n400# w_52_n436# sky130_fd_pr__pfet_01v8 ad=0.54 pd=4.54 as=0.29 ps=2.29 w=2 l=0.15
X1 a_174_n400# a_144_n461# a_88_n400# w_52_n436# sky130_fd_pr__pfet_01v8 ad=0.29 pd=2.29 as=0.56 ps=4.56 w=2 l=0.15
.ends

.subckt invx1_pcell a_34_482# a_155_381# a_206_1059# w_n87_786# pmos2_0/VSUBS
Xnmos_top_0 a_206_1059# pmos2_0/VSUBS a_155_381# pmos2_0/VSUBS nmos_top
Xpmos2_0 w_n87_786# a_155_381# a_206_1059# w_n87_786# w_n87_786# pmos2
.ends

.subckt pmos2_1 a_144_n460# a_262_n399# a_88_n399# w_52_n435# a_174_n399#
X0 a_174_n399# a_144_n460# a_88_n399# w_52_n435# sky130_fd_pr__pfet_01v8 ad=0.29 pd=2.29 as=0.56 ps=4.56 w=2 l=0.15
X1 a_262_n399# a_144_n460# a_174_n399# w_52_n435# sky130_fd_pr__pfet_01v8 ad=0.54 pd=4.54 as=0.29 ps=2.29 w=2 l=0.15
.ends

.subckt nmos_top_trim1 a_86_92# a_56_62# a_0_0# VSUBS
X0 a_86_92# a_56_62# a_0_0# VSUBS sky130_fd_pr__nfet_01v8 ad=0.0597 pd=0.555 as=0.395 ps=2.97 w=3.01 l=0.15
.ends

.subckt nmos_top_trim2 a_86_92# a_56_62# a_0_0# VSUBS
X0 a_86_92# a_56_62# a_0_0# VSUBS sky130_fd_pr__nfet_01v8 ad=0.06 pd=0.56 as=0.395 ps=2.97 w=3.01 l=0.15
.ends

.subckt nor2x1_pcell a_362_382# a_405_1059# a_34_482# pmos2_1_1/VSUBS w_87_786# a_168_375#
Xpmos2_1_0 a_168_375# a_317_1331# a_317_1331# w_87_786# w_87_786# pmos2_1
Xpmos2_1_1 a_362_382# a_317_1331# a_317_1331# w_87_786# a_405_1059# pmos2_1
Xnmos_top_trim1_1 a_405_1059# a_168_375# pmos2_1_1/VSUBS pmos2_1_1/VSUBS nmos_top_trim1
Xnmos_top_trim2_0 a_405_1059# a_362_382# pmos2_1_1/VSUBS pmos2_1_1/VSUBS nmos_top_trim2
.ends

.subckt or2x1_pcell nor2x1_pcell_0/a_168_375# nor2x1_pcell_0/w_87_786# nor2x1_pcell_0/a_362_382#
+ invx1_pcell_0/a_206_1059# VSUBS
Xinvx1_pcell_0 invx1_pcell_0/a_34_482# m1_547_649# invx1_pcell_0/a_206_1059# nor2x1_pcell_0/w_87_786#
+ VSUBS invx1_pcell
Xnor2x1_pcell_0 nor2x1_pcell_0/a_362_382# m1_547_649# invx1_pcell_0/a_34_482# VSUBS
+ nor2x1_pcell_0/w_87_786# nor2x1_pcell_0/a_168_375# nor2x1_pcell
.ends

.subckt OR2X1 Y A B VDD GND
Xor2x1_pcell_0 A VDD B Y GND or2x1_pcell
.ends

****EOF - OR2X1.spice
****BOF - OR3X1.spice

* NGSPICE file created from OR3X1.ext - technology: sky130A

.subckt nmos_top a_84_92# a_0_0# a_54_62# VSUBS
X0 a_84_92# a_54_62# a_0_0# VSUBS sky130_fd_pr__nfet_01v8 ad=0.0597 pd=0.555 as=0.39 ps=2.96 w=3.01 l=0.15
.ends

.subckt pmos2 a_88_n400# a_144_n461# a_174_n400# a_262_n400# w_52_n436#
X0 a_262_n400# a_144_n461# a_174_n400# w_52_n436# sky130_fd_pr__pfet_01v8 ad=0.54 pd=4.54 as=0.29 ps=2.29 w=2 l=0.15
X1 a_174_n400# a_144_n461# a_88_n400# w_52_n436# sky130_fd_pr__pfet_01v8 ad=0.29 pd=2.29 as=0.56 ps=4.56 w=2 l=0.15
.ends

.subckt invx1_pcell a_34_482# a_155_381# a_206_1059# w_n87_786# pmos2_0/VSUBS
Xnmos_top_0 a_206_1059# pmos2_0/VSUBS a_155_381# pmos2_0/VSUBS nmos_top
Xpmos2_0 w_n87_786# a_155_381# a_206_1059# w_n87_786# w_n87_786# pmos2
.ends

.subckt pmos2_1 a_144_n460# a_262_n399# a_88_n399# w_52_n435# a_174_n399#
X0 a_174_n399# a_144_n460# a_88_n399# w_52_n435# sky130_fd_pr__pfet_01v8 ad=0.29 pd=2.29 as=0.56 ps=4.56 w=2 l=0.15
X1 a_262_n399# a_144_n460# a_174_n399# w_52_n435# sky130_fd_pr__pfet_01v8 ad=0.54 pd=4.54 as=0.29 ps=2.29 w=2 l=0.15
.ends

.subckt nmos_top_trim1 a_86_92# a_56_62# a_0_0# VSUBS
X0 a_86_92# a_56_62# a_0_0# VSUBS sky130_fd_pr__nfet_01v8 ad=0.0597 pd=0.555 as=0.395 ps=2.97 w=3.01 l=0.15
.ends

.subckt nmos_top_trim2 a_86_92# a_56_62# a_0_0# VSUBS
X0 a_86_92# a_56_62# a_0_0# VSUBS sky130_fd_pr__nfet_01v8 ad=0.06 pd=0.56 as=0.395 ps=2.97 w=3.01 l=0.15
.ends

.subckt nor3x1_pcell a_362_382# a_34_482# a_619_944# li_219_233# pmos2_1_2/VSUBS w_87_786#
+ a_168_375#
Xpmos2_1_0 a_168_375# a_317_1331# a_317_1331# w_87_786# w_87_786# pmos2_1
Xpmos2_1_1 a_362_382# a_317_1331# a_317_1331# w_87_786# a_613_1331# pmos2_1
Xnmos_top_trim1_1 li_219_233# a_168_375# pmos2_1_2/VSUBS pmos2_1_2/VSUBS nmos_top_trim1
Xpmos2_1_2 a_619_944# a_613_1331# a_613_1331# w_87_786# li_219_233# pmos2_1
Xnmos_top_trim2_0 li_219_233# a_362_382# pmos2_1_2/VSUBS pmos2_1_2/VSUBS nmos_top_trim2
Xnmos_top_trim2_1 li_219_233# a_619_944# pmos2_1_2/VSUBS pmos2_1_2/VSUBS nmos_top_trim2
.ends

.subckt or3x1_pcell nor3x1_pcell_0/w_87_786# nor3x1_pcell_0/a_619_944# nor3x1_pcell_0/a_168_375#
+ nor3x1_pcell_0/a_362_382# invx1_pcell_0/a_206_1059# VSUBS
Xinvx1_pcell_0 invx1_pcell_0/a_34_482# m1_491_649# invx1_pcell_0/a_206_1059# nor3x1_pcell_0/w_87_786#
+ VSUBS invx1_pcell
Xnor3x1_pcell_0 nor3x1_pcell_0/a_362_382# invx1_pcell_0/a_34_482# nor3x1_pcell_0/a_619_944#
+ m1_491_649# VSUBS nor3x1_pcell_0/w_87_786# nor3x1_pcell_0/a_168_375# nor3x1_pcell
.ends

.subckt OR3X1 Y A B C VDD GND
Xor3x1_pcell_0 w_0_822# C A B Y or3x1_pcell_0/VSUBS or3x1_pcell
.ends

****EOF - OR3X1.spice
****BOF - TIEHI.spice

* NGSPICE file created from TIEHI.ext - technology: sky130A

.subckt nmos_top a_84_92# a_0_0# a_54_62# VSUBS
X0 a_84_92# a_54_62# a_0_0# VSUBS sky130_fd_pr__nfet_01v8 ad=0.0597 pd=0.555 as=0.39 ps=2.96 w=3.01 l=0.15
.ends

.subckt pmos2 a_88_n400# a_144_n461# a_174_n400# a_262_n400# w_52_n436#
X0 a_262_n400# a_144_n461# a_174_n400# w_52_n436# sky130_fd_pr__pfet_01v8 ad=0.54 pd=4.54 as=0.29 ps=2.29 w=2 l=0.15
X1 a_174_n400# a_144_n461# a_88_n400# w_52_n436# sky130_fd_pr__pfet_01v8 ad=0.29 pd=2.29 as=0.56 ps=4.56 w=2 l=0.15
.ends

.subckt TIEHI Y VDD GND
Xnmos_top_0 a_253_417# GND a_253_417# GND nmos_top
Xpmos2_0 VDD a_253_417# Y VDD VDD pmos2
.ends

****EOF - TIEHI.spice
****BOF - TIELO.spice

* NGSPICE file created from TIELO.ext - technology: sky130A

.subckt nmos_top a_84_92# a_0_0# a_54_62# VSUBS
X0 a_84_92# a_54_62# a_0_0# VSUBS sky130_fd_pr__nfet_01v8 ad=0.0597 pd=0.555 as=0.39 ps=2.96 w=3.01 l=0.15
.ends

.subckt pmos2 a_88_n400# a_144_n461# a_174_n400# a_262_n400# w_52_n436#
X0 a_262_n400# a_144_n461# a_174_n400# w_52_n436# sky130_fd_pr__pfet_01v8 ad=0.54 pd=4.54 as=0.29 ps=2.29 w=2 l=0.15
X1 a_174_n400# a_144_n461# a_88_n400# w_52_n436# sky130_fd_pr__pfet_01v8 ad=0.29 pd=2.29 as=0.56 ps=4.56 w=2 l=0.15
.ends

.subckt TIELO YN VDD GND
Xnmos_top_0 YN GND a_253_417# GND nmos_top
Xpmos2_0 VDD a_253_417# a_253_417# VDD VDD pmos2
.ends

****EOF - TIELO.spice
****BOF - TMRDFFQNX1.spice

* NGSPICE file created from TMRDFFQNX1.ext - technology: sky130A

.subckt nmos_bottom a_56_54# a_86_84# a_0_0# VSUBS
X0 a_86_84# a_56_54# a_0_0# VSUBS sky130_fd_pr__nfet_01v8 ad=0.0597 pd=0.555 as=0.393 ps=2.99 w=3.01 l=0.15
.ends

.subckt nmos_top_trim1 a_86_92# a_56_62# a_0_0# VSUBS
X0 a_86_92# a_56_62# a_0_0# VSUBS sky130_fd_pr__nfet_01v8 ad=0.0597 pd=0.555 as=0.395 ps=2.97 w=3.01 l=0.15
.ends

.subckt pmos2 a_88_n400# a_144_n461# a_174_n400# a_262_n400# w_52_n436#
X0 a_262_n400# a_144_n461# a_174_n400# w_52_n436# sky130_fd_pr__pfet_01v8 ad=0.54 pd=4.54 as=0.29 ps=2.29 w=2 l=0.15
X1 a_174_n400# a_144_n461# a_88_n400# w_52_n436# sky130_fd_pr__pfet_01v8 ad=0.29 pd=2.29 as=0.56 ps=4.56 w=2 l=0.15
.ends

.subckt nand2x1_pcell a_31_480# a_362_382# a_229_1059# pmos2_1/VSUBS a_168_375# w_87_786#
Xnmos_bottom_0 a_168_375# pmos2_1/VSUBS nmos_bottom_0/a_0_0# pmos2_1/VSUBS nmos_bottom
Xnmos_top_trim1_0 a_229_1059# a_362_382# nmos_bottom_0/a_0_0# pmos2_1/VSUBS nmos_top_trim1
Xpmos2_0 w_87_786# a_168_375# a_229_1059# w_87_786# w_87_786# pmos2
Xpmos2_1 w_87_786# a_362_382# a_229_1059# w_87_786# w_87_786# pmos2
.ends

.subckt nmos_side_left a_87_91# a_0_0# a_57_61# VSUBS
X0 a_87_91# a_57_61# a_0_0# VSUBS sky130_fd_pr__nfet_01v8 ad=0.0545 pd=0.53 as=0.404 ps=3.02 w=3 l=0.15
.ends

.subckt nand3x1_pcell a_34_482# a_447_377# li_649_449# a_289_1059# a_147_377# w_87_786#
+ pmos2_2/VSUBS
Xnmos_bottom_0 a_147_377# pmos2_2/VSUBS nmos_bottom_0/a_0_0# pmos2_2/VSUBS nmos_bottom
Xnmos_top_trim1_0 a_289_1059# li_649_449# li_393_182# pmos2_2/VSUBS nmos_top_trim1
Xnmos_side_left_0 li_393_182# nmos_bottom_0/a_0_0# a_447_377# pmos2_2/VSUBS nmos_side_left
Xpmos2_0 w_87_786# a_147_377# a_289_1059# w_87_786# w_87_786# pmos2
Xpmos2_1 w_87_786# a_447_377# a_289_1059# w_87_786# w_87_786# pmos2
Xpmos2_2 w_87_786# li_649_449# a_289_1059# w_87_786# w_87_786# pmos2
.ends

.subckt dffx1_pcell nand2x1_pcell_4/a_168_375# nand2x1_pcell_0/a_362_382# nand2x1_pcell_3/a_362_382#
+ m1_427_871# nand3x1_pcell_0/w_87_786# nand2x1_pcell_3/a_229_1059# nand2x1_pcell_4/a_229_1059#
+ VSUBS nand3x1_pcell_0/a_34_482#
Xnand2x1_pcell_2 nand3x1_pcell_0/a_34_482# m1_427_871# m1_258_797# VSUBS m1_2165_649#
+ nand3x1_pcell_0/w_87_786# nand2x1_pcell
Xnand2x1_pcell_3 nand3x1_pcell_0/a_34_482# nand2x1_pcell_3/a_362_382# nand2x1_pcell_3/a_229_1059#
+ VSUBS m1_833_723# nand3x1_pcell_0/w_87_786# nand2x1_pcell
Xnand2x1_pcell_4 nand3x1_pcell_0/a_34_482# m1_258_797# nand2x1_pcell_4/a_229_1059#
+ VSUBS nand2x1_pcell_4/a_168_375# nand3x1_pcell_0/w_87_786# nand2x1_pcell
Xnand3x1_pcell_0 nand3x1_pcell_0/a_34_482# m1_427_871# m1_685_649# m1_833_723# m1_258_797#
+ nand3x1_pcell_0/w_87_786# VSUBS nand3x1_pcell
Xnand2x1_pcell_0 nand3x1_pcell_0/a_34_482# nand2x1_pcell_0/a_362_382# m1_685_649#
+ VSUBS m1_833_723# nand3x1_pcell_0/w_87_786# nand2x1_pcell
Xnand2x1_pcell_1 nand3x1_pcell_0/a_34_482# m1_258_797# m1_2165_649# VSUBS m1_685_649#
+ nand3x1_pcell_0/w_87_786# nand2x1_pcell
.ends

.subckt pmos2_1 a_144_n460# a_262_n399# a_88_n399# w_52_n435# a_174_n399#
X0 a_174_n399# a_144_n460# a_88_n399# w_52_n435# sky130_fd_pr__pfet_01v8 ad=0.29 pd=2.29 as=0.56 ps=4.56 w=2 l=0.15
X1 a_262_n399# a_144_n460# a_174_n399# w_52_n435# sky130_fd_pr__pfet_01v8 ad=0.54 pd=4.54 as=0.29 ps=2.29 w=2 l=0.15
.ends

.subckt nmos_top a_84_92# a_0_0# a_54_62# VSUBS
X0 a_84_92# a_54_62# a_0_0# VSUBS sky130_fd_pr__nfet_01v8 ad=0.0597 pd=0.555 as=0.39 ps=2.96 w=3.01 l=0.15
.ends

.subckt nmos_top_trim2 a_86_92# a_56_62# a_0_0# VSUBS
X0 a_86_92# a_56_62# a_0_0# VSUBS sky130_fd_pr__nfet_01v8 ad=0.06 pd=0.56 as=0.395 ps=2.97 w=3.01 l=0.15
.ends

.subckt votern3x1_pcell a_362_381# a_1507_944# a_1366_482# a_700_482# w_750_786# m1_449_219#
+ pmos2_1_5/VSUBS a_834_375#
Xnmos_bottom_0 a_834_375# pmos2_1_5/VSUBS nmos_top_0/a_0_0# pmos2_1_5/VSUBS nmos_bottom
Xnmos_bottom_1 a_834_375# pmos2_1_5/VSUBS nmos_bottom_1/a_0_0# pmos2_1_5/VSUBS nmos_bottom
Xnmos_bottom_2 a_1507_944# pmos2_1_5/VSUBS nmos_bottom_2/a_0_0# pmos2_1_5/VSUBS nmos_bottom
Xpmos2_1_0 a_834_375# w_750_786# w_750_786# w_750_786# a_805_1331# pmos2_1
Xnmos_top_trim1_0 m1_449_219# a_1507_944# nmos_bottom_1/a_0_0# pmos2_1_5/VSUBS nmos_top_trim1
Xpmos2_1_1 a_362_381# w_750_786# w_750_786# w_750_786# a_805_1331# pmos2_1
Xpmos2_1_2 a_1507_944# a_805_1331# a_805_1331# w_750_786# a_893_1059# pmos2_1
Xpmos2_1_3 a_834_375# a_805_1331# a_805_1331# w_750_786# a_893_1059# pmos2_1
Xpmos2_1_4 a_1507_944# a_893_1059# a_893_1059# w_750_786# m1_449_219# pmos2_1
Xpmos2_1_5 a_362_381# a_893_1059# a_893_1059# w_750_786# m1_449_219# pmos2_1
Xnmos_top_0 m1_449_219# nmos_top_0/a_0_0# a_362_381# pmos2_1_5/VSUBS nmos_top
Xnmos_top_trim2_2 m1_449_219# a_362_381# nmos_bottom_2/a_0_0# pmos2_1_5/VSUBS nmos_top_trim2
.ends

.subckt TMRDFFQNX1 QN D CLK VDD GND
Xdffx1_pcell_0 m1_3593_759# D m1_3446_611# CLK VDD m1_3593_759# m1_3446_611# GND GND
+ dffx1_pcell
Xdffx1_pcell_1 m1_7839_759# D m1_7737_463# CLK VDD m1_7839_759# m1_7737_463# GND GND
+ dffx1_pcell
Xvotern3x1_pcell_0 m1_7737_463# m1_3446_611# GND GND VDD QN GND m1_12029_759# votern3x1_pcell
Xdffx1_pcell_2 m1_12177_907# D m1_12029_759# CLK VDD m1_12177_907# m1_12029_759# GND
+ GND dffx1_pcell
.ends

****EOF - TMRDFFQNX1.spice
****BOF - TMRDFFQX1.spice

* NGSPICE file created from TMRDFFQX1.ext - technology: sky130A

.subckt nmos_bottom a_56_54# a_86_84# a_0_0# VSUBS
X0 a_86_84# a_56_54# a_0_0# VSUBS sky130_fd_pr__nfet_01v8 ad=0.0597 pd=0.555 as=0.393 ps=2.99 w=3.01 l=0.15
.ends

.subckt nmos_top_trim1 a_86_92# a_56_62# a_0_0# VSUBS
X0 a_86_92# a_56_62# a_0_0# VSUBS sky130_fd_pr__nfet_01v8 ad=0.0597 pd=0.555 as=0.395 ps=2.97 w=3.01 l=0.15
.ends

.subckt pmos2 a_88_n400# a_144_n461# a_174_n400# a_262_n400# w_52_n436#
X0 a_262_n400# a_144_n461# a_174_n400# w_52_n436# sky130_fd_pr__pfet_01v8 ad=0.54 pd=4.54 as=0.29 ps=2.29 w=2 l=0.15
X1 a_174_n400# a_144_n461# a_88_n400# w_52_n436# sky130_fd_pr__pfet_01v8 ad=0.29 pd=2.29 as=0.56 ps=4.56 w=2 l=0.15
.ends

.subckt nand2x1_pcell a_31_480# a_362_382# a_229_1059# pmos2_1/VSUBS a_168_375# w_87_786#
Xnmos_bottom_0 a_168_375# pmos2_1/VSUBS nmos_bottom_0/a_0_0# pmos2_1/VSUBS nmos_bottom
Xnmos_top_trim1_0 a_229_1059# a_362_382# nmos_bottom_0/a_0_0# pmos2_1/VSUBS nmos_top_trim1
Xpmos2_0 w_87_786# a_168_375# a_229_1059# w_87_786# w_87_786# pmos2
Xpmos2_1 w_87_786# a_362_382# a_229_1059# w_87_786# w_87_786# pmos2
.ends

.subckt nmos_side_left a_87_91# a_0_0# a_57_61# VSUBS
X0 a_87_91# a_57_61# a_0_0# VSUBS sky130_fd_pr__nfet_01v8 ad=0.0545 pd=0.53 as=0.404 ps=3.02 w=3 l=0.15
.ends

.subckt nand3x1_pcell a_34_482# a_447_377# li_649_449# a_289_1059# a_147_377# w_87_786#
+ pmos2_2/VSUBS
Xnmos_bottom_0 a_147_377# pmos2_2/VSUBS nmos_bottom_0/a_0_0# pmos2_2/VSUBS nmos_bottom
Xnmos_top_trim1_0 a_289_1059# li_649_449# li_393_182# pmos2_2/VSUBS nmos_top_trim1
Xnmos_side_left_0 li_393_182# nmos_bottom_0/a_0_0# a_447_377# pmos2_2/VSUBS nmos_side_left
Xpmos2_0 w_87_786# a_147_377# a_289_1059# w_87_786# w_87_786# pmos2
Xpmos2_1 w_87_786# a_447_377# a_289_1059# w_87_786# w_87_786# pmos2
Xpmos2_2 w_87_786# li_649_449# a_289_1059# w_87_786# w_87_786# pmos2
.ends

.subckt dffx1_pcell nand2x1_pcell_4/a_168_375# nand2x1_pcell_0/a_362_382# nand2x1_pcell_3/a_362_382#
+ m1_427_871# nand3x1_pcell_0/w_87_786# nand2x1_pcell_3/a_229_1059# nand2x1_pcell_4/a_229_1059#
+ VSUBS nand3x1_pcell_0/a_34_482#
Xnand2x1_pcell_2 nand3x1_pcell_0/a_34_482# m1_427_871# m1_258_797# VSUBS m1_2165_649#
+ nand3x1_pcell_0/w_87_786# nand2x1_pcell
Xnand2x1_pcell_3 nand3x1_pcell_0/a_34_482# nand2x1_pcell_3/a_362_382# nand2x1_pcell_3/a_229_1059#
+ VSUBS m1_833_723# nand3x1_pcell_0/w_87_786# nand2x1_pcell
Xnand2x1_pcell_4 nand3x1_pcell_0/a_34_482# m1_258_797# nand2x1_pcell_4/a_229_1059#
+ VSUBS nand2x1_pcell_4/a_168_375# nand3x1_pcell_0/w_87_786# nand2x1_pcell
Xnand3x1_pcell_0 nand3x1_pcell_0/a_34_482# m1_427_871# m1_685_649# m1_833_723# m1_258_797#
+ nand3x1_pcell_0/w_87_786# VSUBS nand3x1_pcell
Xnand2x1_pcell_0 nand3x1_pcell_0/a_34_482# nand2x1_pcell_0/a_362_382# m1_685_649#
+ VSUBS m1_833_723# nand3x1_pcell_0/w_87_786# nand2x1_pcell
Xnand2x1_pcell_1 nand3x1_pcell_0/a_34_482# m1_258_797# m1_2165_649# VSUBS m1_685_649#
+ nand3x1_pcell_0/w_87_786# nand2x1_pcell
.ends

.subckt pmos2_1 a_144_n460# a_262_n399# a_88_n399# w_52_n435# a_174_n399#
X0 a_174_n399# a_144_n460# a_88_n399# w_52_n435# sky130_fd_pr__pfet_01v8 ad=0.29 pd=2.29 as=0.56 ps=4.56 w=2 l=0.15
X1 a_262_n399# a_144_n460# a_174_n399# w_52_n435# sky130_fd_pr__pfet_01v8 ad=0.54 pd=4.54 as=0.29 ps=2.29 w=2 l=0.15
.ends

.subckt nmos_top a_84_92# a_0_0# a_54_62# VSUBS
X0 a_84_92# a_54_62# a_0_0# VSUBS sky130_fd_pr__nfet_01v8 ad=0.0597 pd=0.555 as=0.39 ps=2.96 w=3.01 l=0.15
.ends

.subckt nmos_top_trim2 a_86_92# a_56_62# a_0_0# VSUBS
X0 a_86_92# a_56_62# a_0_0# VSUBS sky130_fd_pr__nfet_01v8 ad=0.06 pd=0.56 as=0.395 ps=2.97 w=3.01 l=0.15
.ends

.subckt votern3x1_pcell a_362_381# a_1366_n34# a_1507_944# a_1366_482# a_700_482#
+ w_750_786# m1_449_219# pmos2_1_5/VSUBS a_834_375#
Xnmos_bottom_0 a_834_375# pmos2_1_5/VSUBS nmos_top_0/a_0_0# pmos2_1_5/VSUBS nmos_bottom
Xnmos_bottom_1 a_834_375# pmos2_1_5/VSUBS nmos_bottom_1/a_0_0# pmos2_1_5/VSUBS nmos_bottom
Xnmos_bottom_2 a_1507_944# pmos2_1_5/VSUBS nmos_bottom_2/a_0_0# pmos2_1_5/VSUBS nmos_bottom
Xpmos2_1_0 a_834_375# w_750_786# w_750_786# w_750_786# a_805_1331# pmos2_1
Xnmos_top_trim1_0 m1_449_219# a_1507_944# nmos_bottom_1/a_0_0# pmos2_1_5/VSUBS nmos_top_trim1
Xpmos2_1_1 a_362_381# w_750_786# w_750_786# w_750_786# a_805_1331# pmos2_1
Xpmos2_1_2 a_1507_944# a_805_1331# a_805_1331# w_750_786# a_893_1059# pmos2_1
Xpmos2_1_3 a_834_375# a_805_1331# a_805_1331# w_750_786# a_893_1059# pmos2_1
Xpmos2_1_4 a_1507_944# a_893_1059# a_893_1059# w_750_786# m1_449_219# pmos2_1
Xpmos2_1_5 a_362_381# a_893_1059# a_893_1059# w_750_786# m1_449_219# pmos2_1
Xnmos_top_0 m1_449_219# nmos_top_0/a_0_0# a_362_381# pmos2_1_5/VSUBS nmos_top
Xnmos_top_trim2_2 m1_449_219# a_362_381# nmos_bottom_2/a_0_0# pmos2_1_5/VSUBS nmos_top_trim2
.ends

.subckt invx1_pcell a_34_482# a_155_381# a_206_1059# w_n87_786# pmos2_0/VSUBS
Xnmos_top_0 a_206_1059# pmos2_0/VSUBS a_155_381# pmos2_0/VSUBS nmos_top
Xpmos2_0 w_n87_786# a_155_381# a_206_1059# w_n87_786# w_n87_786# pmos2
.ends

.subckt voter3x1_pcell votern3x1_pcell_0/a_1366_n34# votern3x1_pcell_0/a_1507_944#
+ votern3x1_pcell_0/a_700_482# invx1_pcell_0/a_34_482# votern3x1_pcell_0/a_362_381#
+ invx1_pcell_0/w_n87_786# invx1_pcell_0/a_206_1059# VSUBS votern3x1_pcell_0/a_834_375#
Xvotern3x1_pcell_0 votern3x1_pcell_0/a_362_381# votern3x1_pcell_0/a_1366_n34# votern3x1_pcell_0/a_1507_944#
+ invx1_pcell_0/a_34_482# votern3x1_pcell_0/a_700_482# invx1_pcell_0/w_n87_786# m1_1867_797#
+ VSUBS votern3x1_pcell_0/a_834_375# votern3x1_pcell
Xinvx1_pcell_0 invx1_pcell_0/a_34_482# m1_1867_797# invx1_pcell_0/a_206_1059# invx1_pcell_0/w_n87_786#
+ VSUBS invx1_pcell
.ends

.subckt TMRDFFQX1 Q D CLK VDD GND
Xdffx1_pcell_0 m1_3593_759# D m1_3446_611# CLK VDD m1_3593_759# m1_3446_611# GND GND
+ dffx1_pcell
Xdffx1_pcell_1 m1_7839_759# D m1_7737_463# CLK VDD m1_7839_759# m1_7737_463# GND GND
+ dffx1_pcell
Xdffx1_pcell_2 m1_12177_907# D m1_12029_759# CLK VDD m1_12177_907# m1_12029_759# GND
+ GND dffx1_pcell
Xvoter3x1_pcell_0 GND m1_3446_611# GND GND m1_7737_463# VDD Q GND m1_12029_759# voter3x1_pcell
.ends

****EOF - TMRDFFQX1.spice
****BOF - TMRDFFRNQNX1.spice

* NGSPICE file created from TMRDFFRNQNX1.ext - technology: sky130A

.subckt nmos_bottom a_56_54# a_86_84# a_0_0# VSUBS
X0 a_86_84# a_56_54# a_0_0# VSUBS sky130_fd_pr__nfet_01v8 ad=0.0597 pd=0.555 as=0.393 ps=2.99 w=3.01 l=0.15
.ends

.subckt nmos_top_trim1 a_86_92# a_56_62# a_0_0# VSUBS
X0 a_86_92# a_56_62# a_0_0# VSUBS sky130_fd_pr__nfet_01v8 ad=0.0597 pd=0.555 as=0.395 ps=2.97 w=3.01 l=0.15
.ends

.subckt nmos_side_left a_87_91# a_0_0# a_57_61# VSUBS
X0 a_87_91# a_57_61# a_0_0# VSUBS sky130_fd_pr__nfet_01v8 ad=0.0545 pd=0.53 as=0.404 ps=3.02 w=3 l=0.15
.ends

.subckt pmos2 a_88_n400# a_144_n461# a_174_n400# a_262_n400# w_52_n436#
X0 a_262_n400# a_144_n461# a_174_n400# w_52_n436# sky130_fd_pr__pfet_01v8 ad=0.54 pd=4.54 as=0.29 ps=2.29 w=2 l=0.15
X1 a_174_n400# a_144_n461# a_88_n400# w_52_n436# sky130_fd_pr__pfet_01v8 ad=0.29 pd=2.29 as=0.56 ps=4.56 w=2 l=0.15
.ends

.subckt nand3x1_pcell a_34_482# a_447_377# li_649_449# a_289_1059# pmos2_2/VSUBS a_147_377#
+ w_87_786#
Xnmos_bottom_0 a_147_377# pmos2_2/VSUBS nmos_bottom_0/a_0_0# pmos2_2/VSUBS nmos_bottom
Xnmos_top_trim1_0 a_289_1059# li_649_449# li_393_182# pmos2_2/VSUBS nmos_top_trim1
Xnmos_side_left_0 li_393_182# nmos_bottom_0/a_0_0# a_447_377# pmos2_2/VSUBS nmos_side_left
Xpmos2_0 w_87_786# a_147_377# a_289_1059# w_87_786# w_87_786# pmos2
Xpmos2_1 w_87_786# a_447_377# a_289_1059# w_87_786# w_87_786# pmos2
Xpmos2_2 w_87_786# li_649_449# a_289_1059# w_87_786# w_87_786# pmos2
.ends

.subckt nand2x1_pcell a_31_480# a_362_382# a_229_1059# pmos2_1/VSUBS a_168_375# w_87_786#
Xnmos_bottom_0 a_168_375# pmos2_1/VSUBS nmos_bottom_0/a_0_0# pmos2_1/VSUBS nmos_bottom
Xnmos_top_trim1_0 a_229_1059# a_362_382# nmos_bottom_0/a_0_0# pmos2_1/VSUBS nmos_top_trim1
Xpmos2_0 w_87_786# a_168_375# a_229_1059# w_87_786# w_87_786# pmos2
Xpmos2_1 w_87_786# a_362_382# a_229_1059# w_87_786# w_87_786# pmos2
.ends

.subckt dffrnx1_pcell nand2x1_pcell_1/a_168_375# m1_689_649# m1_426_871# m1_241_797#
+ nand3x1_pcell_1/a_447_377# m1_1607_427# m1_2461_649# nand2x1_pcell_1/a_229_1059#
+ nand3x1_pcell_4/li_649_449# nand3x1_pcell_4/w_87_786# nand3x1_pcell_4/a_289_1059#
+ VSUBS nand3x1_pcell_4/a_34_482#
Xnand3x1_pcell_0 nand3x1_pcell_4/a_34_482# m1_426_871# m1_689_649# m1_867_723# VSUBS
+ m1_241_797# nand3x1_pcell_4/w_87_786# nand3x1_pcell
Xnand3x1_pcell_1 nand3x1_pcell_4/a_34_482# nand3x1_pcell_1/a_447_377# m1_1607_427#
+ m1_689_649# VSUBS m1_867_723# nand3x1_pcell_4/w_87_786# nand3x1_pcell
Xnand3x1_pcell_3 nand3x1_pcell_4/a_34_482# m1_426_871# m1_1607_427# m1_241_797# VSUBS
+ m1_2461_649# nand3x1_pcell_4/w_87_786# nand3x1_pcell
Xnand3x1_pcell_4 nand3x1_pcell_4/a_34_482# m1_1607_427# nand3x1_pcell_4/li_649_449#
+ nand3x1_pcell_4/a_289_1059# VSUBS m1_867_723# nand3x1_pcell_4/w_87_786# nand3x1_pcell
Xnand2x1_pcell_0 nand3x1_pcell_4/a_34_482# m1_241_797# m1_2461_649# VSUBS m1_689_649#
+ nand3x1_pcell_4/w_87_786# nand2x1_pcell
Xnand2x1_pcell_1 nand3x1_pcell_4/a_34_482# m1_241_797# nand2x1_pcell_1/a_229_1059#
+ VSUBS nand2x1_pcell_1/a_168_375# nand3x1_pcell_4/w_87_786# nand2x1_pcell
.ends

.subckt pmos2_1 a_144_n460# a_262_n399# a_88_n399# w_52_n435# a_174_n399#
X0 a_174_n399# a_144_n460# a_88_n399# w_52_n435# sky130_fd_pr__pfet_01v8 ad=0.29 pd=2.29 as=0.56 ps=4.56 w=2 l=0.15
X1 a_262_n399# a_144_n460# a_174_n399# w_52_n435# sky130_fd_pr__pfet_01v8 ad=0.54 pd=4.54 as=0.29 ps=2.29 w=2 l=0.15
.ends

.subckt nmos_top a_84_92# a_0_0# a_54_62# VSUBS
X0 a_84_92# a_54_62# a_0_0# VSUBS sky130_fd_pr__nfet_01v8 ad=0.0597 pd=0.555 as=0.39 ps=2.96 w=3.01 l=0.15
.ends

.subckt nmos_top_trim2 a_86_92# a_56_62# a_0_0# VSUBS
X0 a_86_92# a_56_62# a_0_0# VSUBS sky130_fd_pr__nfet_01v8 ad=0.06 pd=0.56 as=0.395 ps=2.97 w=3.01 l=0.15
.ends

.subckt votern3x1_pcell a_1507_944# a_362_381# a_1366_482# a_700_482# w_750_786# m1_449_219#
+ pmos2_1_5/VSUBS a_834_375#
Xnmos_bottom_0 a_834_375# pmos2_1_5/VSUBS nmos_top_0/a_0_0# pmos2_1_5/VSUBS nmos_bottom
Xnmos_bottom_1 a_834_375# pmos2_1_5/VSUBS nmos_bottom_1/a_0_0# pmos2_1_5/VSUBS nmos_bottom
Xnmos_bottom_2 a_1507_944# pmos2_1_5/VSUBS nmos_bottom_2/a_0_0# pmos2_1_5/VSUBS nmos_bottom
Xpmos2_1_0 a_834_375# w_750_786# w_750_786# w_750_786# a_805_1331# pmos2_1
Xnmos_top_trim1_0 m1_449_219# a_1507_944# nmos_bottom_1/a_0_0# pmos2_1_5/VSUBS nmos_top_trim1
Xpmos2_1_1 a_362_381# w_750_786# w_750_786# w_750_786# a_805_1331# pmos2_1
Xpmos2_1_2 a_1507_944# a_805_1331# a_805_1331# w_750_786# a_893_1059# pmos2_1
Xpmos2_1_3 a_834_375# a_805_1331# a_805_1331# w_750_786# a_893_1059# pmos2_1
Xpmos2_1_4 a_1507_944# a_893_1059# a_893_1059# w_750_786# m1_449_219# pmos2_1
Xpmos2_1_5 a_362_381# a_893_1059# a_893_1059# w_750_786# m1_449_219# pmos2_1
Xnmos_top_0 m1_449_219# nmos_top_0/a_0_0# a_362_381# pmos2_1_5/VSUBS nmos_top
Xnmos_top_trim2_2 m1_449_219# a_362_381# nmos_bottom_2/a_0_0# pmos2_1_5/VSUBS nmos_top_trim2
.ends

.subckt TMRDFFRNQNX1 QN D CLK RN VDD GND
Xdffrnx1_pcell_0 m1_4517_833# dffrnx1_pcell_0/m1_689_649# CLK m1_4517_833# D RN dffrnx1_pcell_0/m1_2461_649#
+ m1_5159_611# m1_5159_611# VDD m1_4517_833# GND GND dffrnx1_pcell
Xdffrnx1_pcell_1 m1_9697_759# dffrnx1_pcell_1/m1_689_649# CLK dffrnx1_pcell_1/m1_241_797#
+ D RN dffrnx1_pcell_1/m1_2461_649# m1_9549_685# m1_9549_685# VDD m1_9697_759# GND
+ GND dffrnx1_pcell
Xdffrnx1_pcell_2 m1_14877_833# m1_9549_685# CLK m1_14877_833# D RN m1_9549_685# m1_15519_759#
+ m1_15519_759# VDD m1_14877_833# GND GND dffrnx1_pcell
Xvotern3x1_pcell_0 m1_5159_611# m1_15519_759# GND GND VDD QN GND m1_9549_685# votern3x1_pcell
.ends

****EOF - TMRDFFRNQNX1.spice
****BOF - TMRDFFRNQX1.spice

* NGSPICE file created from TMRDFFRNQX1.ext - technology: sky130A

.subckt nmos_bottom a_56_54# a_86_84# a_0_0# VSUBS
X0 a_86_84# a_56_54# a_0_0# VSUBS sky130_fd_pr__nfet_01v8 ad=0.0597 pd=0.555 as=0.393 ps=2.99 w=3.01 l=0.15
.ends

.subckt nmos_top_trim1 a_86_92# a_56_62# a_0_0# VSUBS
X0 a_86_92# a_56_62# a_0_0# VSUBS sky130_fd_pr__nfet_01v8 ad=0.0597 pd=0.555 as=0.395 ps=2.97 w=3.01 l=0.15
.ends

.subckt nmos_side_left a_87_91# a_0_0# a_57_61# VSUBS
X0 a_87_91# a_57_61# a_0_0# VSUBS sky130_fd_pr__nfet_01v8 ad=0.0545 pd=0.53 as=0.404 ps=3.02 w=3 l=0.15
.ends

.subckt pmos2 a_88_n400# a_144_n461# a_174_n400# a_262_n400# w_52_n436#
X0 a_262_n400# a_144_n461# a_174_n400# w_52_n436# sky130_fd_pr__pfet_01v8 ad=0.54 pd=4.54 as=0.29 ps=2.29 w=2 l=0.15
X1 a_174_n400# a_144_n461# a_88_n400# w_52_n436# sky130_fd_pr__pfet_01v8 ad=0.29 pd=2.29 as=0.56 ps=4.56 w=2 l=0.15
.ends

.subckt nand3x1_pcell a_34_482# a_447_377# li_649_449# a_289_1059# pmos2_2/VSUBS a_147_377#
+ w_87_786#
Xnmos_bottom_0 a_147_377# pmos2_2/VSUBS nmos_bottom_0/a_0_0# pmos2_2/VSUBS nmos_bottom
Xnmos_top_trim1_0 a_289_1059# li_649_449# li_393_182# pmos2_2/VSUBS nmos_top_trim1
Xnmos_side_left_0 li_393_182# nmos_bottom_0/a_0_0# a_447_377# pmos2_2/VSUBS nmos_side_left
Xpmos2_0 w_87_786# a_147_377# a_289_1059# w_87_786# w_87_786# pmos2
Xpmos2_1 w_87_786# a_447_377# a_289_1059# w_87_786# w_87_786# pmos2
Xpmos2_2 w_87_786# li_649_449# a_289_1059# w_87_786# w_87_786# pmos2
.ends

.subckt nand2x1_pcell a_31_480# a_362_382# a_229_1059# pmos2_1/VSUBS a_168_375# w_87_786#
Xnmos_bottom_0 a_168_375# pmos2_1/VSUBS nmos_bottom_0/a_0_0# pmos2_1/VSUBS nmos_bottom
Xnmos_top_trim1_0 a_229_1059# a_362_382# nmos_bottom_0/a_0_0# pmos2_1/VSUBS nmos_top_trim1
Xpmos2_0 w_87_786# a_168_375# a_229_1059# w_87_786# w_87_786# pmos2
Xpmos2_1 w_87_786# a_362_382# a_229_1059# w_87_786# w_87_786# pmos2
.ends

.subckt dffrnx1_pcell nand2x1_pcell_1/a_168_375# m1_689_649# m1_426_871# m1_241_797#
+ nand3x1_pcell_1/a_447_377# m1_2461_649# m1_1607_427# nand2x1_pcell_1/a_229_1059#
+ nand3x1_pcell_4/li_649_449# nand3x1_pcell_4/w_87_786# nand3x1_pcell_4/a_289_1059#
+ VSUBS nand3x1_pcell_4/a_34_482#
Xnand3x1_pcell_0 nand3x1_pcell_4/a_34_482# m1_426_871# m1_689_649# m1_867_723# VSUBS
+ m1_241_797# nand3x1_pcell_4/w_87_786# nand3x1_pcell
Xnand3x1_pcell_1 nand3x1_pcell_4/a_34_482# nand3x1_pcell_1/a_447_377# m1_1607_427#
+ m1_689_649# VSUBS m1_867_723# nand3x1_pcell_4/w_87_786# nand3x1_pcell
Xnand3x1_pcell_3 nand3x1_pcell_4/a_34_482# m1_426_871# m1_1607_427# m1_241_797# VSUBS
+ m1_2461_649# nand3x1_pcell_4/w_87_786# nand3x1_pcell
Xnand3x1_pcell_4 nand3x1_pcell_4/a_34_482# m1_1607_427# nand3x1_pcell_4/li_649_449#
+ nand3x1_pcell_4/a_289_1059# VSUBS m1_867_723# nand3x1_pcell_4/w_87_786# nand3x1_pcell
Xnand2x1_pcell_0 nand3x1_pcell_4/a_34_482# m1_241_797# m1_2461_649# VSUBS m1_689_649#
+ nand3x1_pcell_4/w_87_786# nand2x1_pcell
Xnand2x1_pcell_1 nand3x1_pcell_4/a_34_482# m1_241_797# nand2x1_pcell_1/a_229_1059#
+ VSUBS nand2x1_pcell_1/a_168_375# nand3x1_pcell_4/w_87_786# nand2x1_pcell
.ends

.subckt pmos2_1 a_144_n460# a_262_n399# a_88_n399# w_52_n435# a_174_n399#
X0 a_174_n399# a_144_n460# a_88_n399# w_52_n435# sky130_fd_pr__pfet_01v8 ad=0.29 pd=2.29 as=0.56 ps=4.56 w=2 l=0.15
X1 a_262_n399# a_144_n460# a_174_n399# w_52_n435# sky130_fd_pr__pfet_01v8 ad=0.54 pd=4.54 as=0.29 ps=2.29 w=2 l=0.15
.ends

.subckt nmos_top a_84_92# a_0_0# a_54_62# VSUBS
X0 a_84_92# a_54_62# a_0_0# VSUBS sky130_fd_pr__nfet_01v8 ad=0.0597 pd=0.555 as=0.39 ps=2.96 w=3.01 l=0.15
.ends

.subckt nmos_top_trim2 a_86_92# a_56_62# a_0_0# VSUBS
X0 a_86_92# a_56_62# a_0_0# VSUBS sky130_fd_pr__nfet_01v8 ad=0.06 pd=0.56 as=0.395 ps=2.97 w=3.01 l=0.15
.ends

.subckt votern3x1_pcell a_1507_944# a_362_381# a_1366_482# a_700_482# w_750_786# m1_449_219#
+ pmos2_1_5/VSUBS a_834_375#
Xnmos_bottom_0 a_834_375# pmos2_1_5/VSUBS nmos_top_0/a_0_0# pmos2_1_5/VSUBS nmos_bottom
Xnmos_bottom_1 a_834_375# pmos2_1_5/VSUBS nmos_bottom_1/a_0_0# pmos2_1_5/VSUBS nmos_bottom
Xnmos_bottom_2 a_1507_944# pmos2_1_5/VSUBS nmos_bottom_2/a_0_0# pmos2_1_5/VSUBS nmos_bottom
Xpmos2_1_0 a_834_375# w_750_786# w_750_786# w_750_786# a_805_1331# pmos2_1
Xnmos_top_trim1_0 m1_449_219# a_1507_944# nmos_bottom_1/a_0_0# pmos2_1_5/VSUBS nmos_top_trim1
Xpmos2_1_1 a_362_381# w_750_786# w_750_786# w_750_786# a_805_1331# pmos2_1
Xpmos2_1_2 a_1507_944# a_805_1331# a_805_1331# w_750_786# a_893_1059# pmos2_1
Xpmos2_1_3 a_834_375# a_805_1331# a_805_1331# w_750_786# a_893_1059# pmos2_1
Xpmos2_1_4 a_1507_944# a_893_1059# a_893_1059# w_750_786# m1_449_219# pmos2_1
Xpmos2_1_5 a_362_381# a_893_1059# a_893_1059# w_750_786# m1_449_219# pmos2_1
Xnmos_top_0 m1_449_219# nmos_top_0/a_0_0# a_362_381# pmos2_1_5/VSUBS nmos_top
Xnmos_top_trim2_2 m1_449_219# a_362_381# nmos_bottom_2/a_0_0# pmos2_1_5/VSUBS nmos_top_trim2
.ends

.subckt invx1_pcell a_34_482# a_155_381# a_206_1059# w_n87_786# pmos2_0/VSUBS
Xnmos_top_0 a_206_1059# pmos2_0/VSUBS a_155_381# pmos2_0/VSUBS nmos_top
Xpmos2_0 w_n87_786# a_155_381# a_206_1059# w_n87_786# w_n87_786# pmos2
.ends

.subckt voter3x1_pcell votern3x1_pcell_0/a_362_381# votern3x1_pcell_0/a_1507_944#
+ votern3x1_pcell_0/a_700_482# invx1_pcell_0/a_34_482# invx1_pcell_0/w_n87_786# invx1_pcell_0/a_206_1059#
+ VSUBS votern3x1_pcell_0/a_834_375#
Xvotern3x1_pcell_0 votern3x1_pcell_0/a_1507_944# votern3x1_pcell_0/a_362_381# invx1_pcell_0/a_34_482#
+ votern3x1_pcell_0/a_700_482# invx1_pcell_0/w_n87_786# m1_1867_797# VSUBS votern3x1_pcell_0/a_834_375#
+ votern3x1_pcell
Xinvx1_pcell_0 invx1_pcell_0/a_34_482# m1_1867_797# invx1_pcell_0/a_206_1059# invx1_pcell_0/w_n87_786#
+ VSUBS invx1_pcell
.ends

.subckt TMRDFFRNQX1 Q D CLK RN VDD GND
Xdffrnx1_pcell_0 m1_4517_833# dffrnx1_pcell_0/m1_689_649# CLK m1_4517_833# D dffrnx1_pcell_0/m1_2461_649#
+ RN m1_5159_611# m1_5159_611# VDD m1_4517_833# GND GND dffrnx1_pcell
Xdffrnx1_pcell_1 m1_9697_759# dffrnx1_pcell_1/m1_689_649# CLK dffrnx1_pcell_1/m1_241_797#
+ D dffrnx1_pcell_1/m1_2461_649# RN m1_9549_685# m1_9549_685# VDD m1_9697_759# GND
+ GND dffrnx1_pcell
Xdffrnx1_pcell_2 m1_14877_833# m1_9549_685# CLK m1_14877_833# D m1_9549_685# RN m1_15519_759#
+ m1_15519_759# VDD m1_14877_833# GND GND dffrnx1_pcell
Xvoter3x1_pcell_0 m1_15519_759# m1_5159_611# GND GND VDD Q GND m1_9549_685# voter3x1_pcell
.ends

****EOF - TMRDFFRNQX1.spice
****BOF - TMRDFFSNQNX1.spice

* NGSPICE file created from TMRDFFSNQNX1.ext - technology: sky130A

.subckt nmos_bottom a_56_54# a_86_84# a_0_0# VSUBS
X0 a_86_84# a_56_54# a_0_0# VSUBS sky130_fd_pr__nfet_01v8 ad=0.0597 pd=0.555 as=0.393 ps=2.99 w=3.01 l=0.15
.ends

.subckt pmos2_1 a_144_n460# a_262_n399# a_88_n399# w_52_n435# a_174_n399#
X0 a_174_n399# a_144_n460# a_88_n399# w_52_n435# sky130_fd_pr__pfet_01v8 ad=0.29 pd=2.29 as=0.56 ps=4.56 w=2 l=0.15
X1 a_262_n399# a_144_n460# a_174_n399# w_52_n435# sky130_fd_pr__pfet_01v8 ad=0.54 pd=4.54 as=0.29 ps=2.29 w=2 l=0.15
.ends

.subckt nmos_top_trim1 a_86_92# a_56_62# a_0_0# VSUBS
X0 a_86_92# a_56_62# a_0_0# VSUBS sky130_fd_pr__nfet_01v8 ad=0.0597 pd=0.555 as=0.395 ps=2.97 w=3.01 l=0.15
.ends

.subckt nmos_top a_84_92# a_0_0# a_54_62# VSUBS
X0 a_84_92# a_54_62# a_0_0# VSUBS sky130_fd_pr__nfet_01v8 ad=0.0597 pd=0.555 as=0.39 ps=2.96 w=3.01 l=0.15
.ends

.subckt nmos_top_trim2 a_86_92# a_56_62# a_0_0# VSUBS
X0 a_86_92# a_56_62# a_0_0# VSUBS sky130_fd_pr__nfet_01v8 ad=0.06 pd=0.56 as=0.395 ps=2.97 w=3.01 l=0.15
.ends

.subckt votern3x1_pcell a_1366_n34# a_1507_944# a_362_381# a_1366_482# a_700_482#
+ w_750_786# m1_449_219# pmos2_1_5/VSUBS a_834_375#
Xnmos_bottom_0 a_834_375# pmos2_1_5/VSUBS nmos_top_0/a_0_0# pmos2_1_5/VSUBS nmos_bottom
Xnmos_bottom_1 a_834_375# pmos2_1_5/VSUBS nmos_bottom_1/a_0_0# pmos2_1_5/VSUBS nmos_bottom
Xnmos_bottom_2 a_1507_944# pmos2_1_5/VSUBS nmos_bottom_2/a_0_0# pmos2_1_5/VSUBS nmos_bottom
Xpmos2_1_0 a_834_375# w_750_786# w_750_786# w_750_786# a_805_1331# pmos2_1
Xnmos_top_trim1_0 m1_449_219# a_1507_944# nmos_bottom_1/a_0_0# pmos2_1_5/VSUBS nmos_top_trim1
Xpmos2_1_1 a_362_381# w_750_786# w_750_786# w_750_786# a_805_1331# pmos2_1
Xpmos2_1_2 a_1507_944# a_805_1331# a_805_1331# w_750_786# a_893_1059# pmos2_1
Xpmos2_1_3 a_834_375# a_805_1331# a_805_1331# w_750_786# a_893_1059# pmos2_1
Xpmos2_1_4 a_1507_944# a_893_1059# a_893_1059# w_750_786# m1_449_219# pmos2_1
Xpmos2_1_5 a_362_381# a_893_1059# a_893_1059# w_750_786# m1_449_219# pmos2_1
Xnmos_top_0 m1_449_219# nmos_top_0/a_0_0# a_362_381# pmos2_1_5/VSUBS nmos_top
Xnmos_top_trim2_2 m1_449_219# a_362_381# nmos_bottom_2/a_0_0# pmos2_1_5/VSUBS nmos_top_trim2
.ends

.subckt pmos2 a_88_n400# a_144_n461# a_174_n400# a_262_n400# w_52_n436#
X0 a_262_n400# a_144_n461# a_174_n400# w_52_n436# sky130_fd_pr__pfet_01v8 ad=0.54 pd=4.54 as=0.29 ps=2.29 w=2 l=0.15
X1 a_174_n400# a_144_n461# a_88_n400# w_52_n436# sky130_fd_pr__pfet_01v8 ad=0.29 pd=2.29 as=0.56 ps=4.56 w=2 l=0.15
.ends

.subckt nand2x1_pcell a_31_480# a_362_382# a_229_1059# pmos2_1/VSUBS a_168_375# w_87_786#
Xnmos_bottom_0 a_168_375# pmos2_1/VSUBS nmos_bottom_0/a_0_0# pmos2_1/VSUBS nmos_bottom
Xnmos_top_trim1_0 a_229_1059# a_362_382# nmos_bottom_0/a_0_0# pmos2_1/VSUBS nmos_top_trim1
Xpmos2_0 w_87_786# a_168_375# a_229_1059# w_87_786# w_87_786# pmos2
Xpmos2_1 w_87_786# a_362_382# a_229_1059# w_87_786# w_87_786# pmos2
.ends

.subckt nmos_side_left a_87_91# a_0_0# a_57_61# VSUBS
X0 a_87_91# a_57_61# a_0_0# VSUBS sky130_fd_pr__nfet_01v8 ad=0.0545 pd=0.53 as=0.404 ps=3.02 w=3 l=0.15
.ends

.subckt nand3x1_pcell a_34_482# a_447_377# li_649_449# a_289_1059# pmos2_2/VSUBS a_147_377#
+ w_87_786#
Xnmos_bottom_0 a_147_377# pmos2_2/VSUBS nmos_bottom_0/a_0_0# pmos2_2/VSUBS nmos_bottom
Xnmos_top_trim1_0 a_289_1059# li_649_449# li_393_182# pmos2_2/VSUBS nmos_top_trim1
Xnmos_side_left_0 li_393_182# nmos_bottom_0/a_0_0# a_447_377# pmos2_2/VSUBS nmos_side_left
Xpmos2_0 w_87_786# a_147_377# a_289_1059# w_87_786# w_87_786# pmos2
Xpmos2_1 w_87_786# a_447_377# a_289_1059# w_87_786# w_87_786# pmos2
Xpmos2_2 w_87_786# li_649_449# a_289_1059# w_87_786# w_87_786# pmos2
.ends

.subckt dffsnx1_pcell nand2x1_pcell_5/a_168_375# nand3x1_pcell_1/a_147_377# nand2x1_pcell_2/a_362_382#
+ nand2x1_pcell_2/a_229_1059# m1_1093_871# nand3x1_pcell_1/a_289_1059# m1_2055_427#
+ VSUBS nand3x1_pcell_2/w_87_786# nand3x1_pcell_2/a_34_482#
Xnand2x1_pcell_2 nand3x1_pcell_2/a_34_482# nand2x1_pcell_2/a_362_382# nand2x1_pcell_2/a_229_1059#
+ VSUBS m1_406_797# nand3x1_pcell_2/w_87_786# nand2x1_pcell
Xnand2x1_pcell_5 nand3x1_pcell_2/a_34_482# m1_406_797# m1_537_501# VSUBS nand2x1_pcell_5/a_168_375#
+ nand3x1_pcell_2/w_87_786# nand2x1_pcell
Xnand3x1_pcell_0 nand3x1_pcell_2/a_34_482# m1_1093_871# m1_1351_723# m1_406_797# VSUBS
+ m1_537_501# nand3x1_pcell_2/w_87_786# nand3x1_pcell
Xnand3x1_pcell_1 nand3x1_pcell_2/a_34_482# m1_2055_427# m1_1351_723# nand3x1_pcell_1/a_289_1059#
+ VSUBS nand3x1_pcell_1/a_147_377# nand3x1_pcell_2/w_87_786# nand3x1_pcell
Xnand3x1_pcell_2 nand3x1_pcell_2/a_34_482# m1_2055_427# m1_1351_723# m1_2461_501#
+ VSUBS m1_537_501# nand3x1_pcell_2/w_87_786# nand3x1_pcell
Xnand2x1_pcell_0 nand3x1_pcell_2/a_34_482# m1_1093_871# m1_1351_723# VSUBS m1_2461_501#
+ nand3x1_pcell_2/w_87_786# nand2x1_pcell
.ends

.subckt TMRDFFSNQNX1 QN D CLK SN VDD GND
Xvotern3x1_pcell_0 GND m1_4250_685# m1_9154_537# GND GND VDD QN GND m1_13659_907#
+ votern3x1_pcell
Xdffsnx1_pcell_0 D m1_4250_685# m1_3704_833# m1_4250_685# CLK m1_3704_833# SN GND
+ VDD GND dffsnx1_pcell
Xdffsnx1_pcell_1 D m1_9154_537# m1_8620_833# m1_9154_537# CLK m1_8620_833# SN GND
+ VDD GND dffsnx1_pcell
Xdffsnx1_pcell_2 D m1_13659_907# m1_13511_833# m1_13659_907# CLK m1_13511_833# SN
+ GND VDD GND dffsnx1_pcell
.ends

****EOF - TMRDFFSNQNX1.spice
****BOF - TMRDFFSNQX1.spice

* NGSPICE file created from TMRDFFSNQX1.ext - technology: sky130A

.subckt nmos_bottom a_56_54# a_86_84# a_0_0# VSUBS
X0 a_86_84# a_56_54# a_0_0# VSUBS sky130_fd_pr__nfet_01v8 ad=0.0597 pd=0.555 as=0.393 ps=2.99 w=3.01 l=0.15
.ends

.subckt pmos2_1 a_144_n460# a_262_n399# a_88_n399# w_52_n435# a_174_n399#
X0 a_174_n399# a_144_n460# a_88_n399# w_52_n435# sky130_fd_pr__pfet_01v8 ad=0.29 pd=2.29 as=0.56 ps=4.56 w=2 l=0.15
X1 a_262_n399# a_144_n460# a_174_n399# w_52_n435# sky130_fd_pr__pfet_01v8 ad=0.54 pd=4.54 as=0.29 ps=2.29 w=2 l=0.15
.ends

.subckt nmos_top_trim1 a_86_92# a_56_62# a_0_0# VSUBS
X0 a_86_92# a_56_62# a_0_0# VSUBS sky130_fd_pr__nfet_01v8 ad=0.0597 pd=0.555 as=0.395 ps=2.97 w=3.01 l=0.15
.ends

.subckt nmos_top a_84_92# a_0_0# a_54_62# VSUBS
X0 a_84_92# a_54_62# a_0_0# VSUBS sky130_fd_pr__nfet_01v8 ad=0.0597 pd=0.555 as=0.39 ps=2.96 w=3.01 l=0.15
.ends

.subckt nmos_top_trim2 a_86_92# a_56_62# a_0_0# VSUBS
X0 a_86_92# a_56_62# a_0_0# VSUBS sky130_fd_pr__nfet_01v8 ad=0.06 pd=0.56 as=0.395 ps=2.97 w=3.01 l=0.15
.ends

.subckt votern3x1_pcell a_1366_n34# a_1507_944# a_362_381# a_1366_482# a_700_482#
+ w_750_786# m1_449_219# pmos2_1_5/VSUBS a_834_375#
Xnmos_bottom_0 a_834_375# pmos2_1_5/VSUBS nmos_top_0/a_0_0# pmos2_1_5/VSUBS nmos_bottom
Xnmos_bottom_1 a_834_375# pmos2_1_5/VSUBS nmos_bottom_1/a_0_0# pmos2_1_5/VSUBS nmos_bottom
Xnmos_bottom_2 a_1507_944# pmos2_1_5/VSUBS nmos_bottom_2/a_0_0# pmos2_1_5/VSUBS nmos_bottom
Xpmos2_1_0 a_834_375# w_750_786# w_750_786# w_750_786# a_805_1331# pmos2_1
Xnmos_top_trim1_0 m1_449_219# a_1507_944# nmos_bottom_1/a_0_0# pmos2_1_5/VSUBS nmos_top_trim1
Xpmos2_1_1 a_362_381# w_750_786# w_750_786# w_750_786# a_805_1331# pmos2_1
Xpmos2_1_2 a_1507_944# a_805_1331# a_805_1331# w_750_786# a_893_1059# pmos2_1
Xpmos2_1_3 a_834_375# a_805_1331# a_805_1331# w_750_786# a_893_1059# pmos2_1
Xpmos2_1_4 a_1507_944# a_893_1059# a_893_1059# w_750_786# m1_449_219# pmos2_1
Xpmos2_1_5 a_362_381# a_893_1059# a_893_1059# w_750_786# m1_449_219# pmos2_1
Xnmos_top_0 m1_449_219# nmos_top_0/a_0_0# a_362_381# pmos2_1_5/VSUBS nmos_top
Xnmos_top_trim2_2 m1_449_219# a_362_381# nmos_bottom_2/a_0_0# pmos2_1_5/VSUBS nmos_top_trim2
.ends

.subckt pmos2 a_88_n400# a_144_n461# a_174_n400# a_262_n400# w_52_n436#
X0 a_262_n400# a_144_n461# a_174_n400# w_52_n436# sky130_fd_pr__pfet_01v8 ad=0.54 pd=4.54 as=0.29 ps=2.29 w=2 l=0.15
X1 a_174_n400# a_144_n461# a_88_n400# w_52_n436# sky130_fd_pr__pfet_01v8 ad=0.29 pd=2.29 as=0.56 ps=4.56 w=2 l=0.15
.ends

.subckt invx1_pcell a_34_482# a_155_381# a_206_1059# w_n87_786# pmos2_0/VSUBS
Xnmos_top_0 a_206_1059# pmos2_0/VSUBS a_155_381# pmos2_0/VSUBS nmos_top
Xpmos2_0 w_n87_786# a_155_381# a_206_1059# w_n87_786# w_n87_786# pmos2
.ends

.subckt voter3x1_pcell votern3x1_pcell_0/a_1366_n34# votern3x1_pcell_0/a_362_381#
+ votern3x1_pcell_0/a_1507_944# votern3x1_pcell_0/a_700_482# invx1_pcell_0/a_34_482#
+ invx1_pcell_0/w_n87_786# invx1_pcell_0/a_206_1059# VSUBS votern3x1_pcell_0/a_834_375#
Xvotern3x1_pcell_0 votern3x1_pcell_0/a_1366_n34# votern3x1_pcell_0/a_1507_944# votern3x1_pcell_0/a_362_381#
+ invx1_pcell_0/a_34_482# votern3x1_pcell_0/a_700_482# invx1_pcell_0/w_n87_786# m1_1867_797#
+ VSUBS votern3x1_pcell_0/a_834_375# votern3x1_pcell
Xinvx1_pcell_0 invx1_pcell_0/a_34_482# m1_1867_797# invx1_pcell_0/a_206_1059# invx1_pcell_0/w_n87_786#
+ VSUBS invx1_pcell
.ends

.subckt nand2x1_pcell a_31_480# a_362_382# a_229_1059# pmos2_1/VSUBS a_168_375# w_87_786#
Xnmos_bottom_0 a_168_375# pmos2_1/VSUBS nmos_bottom_0/a_0_0# pmos2_1/VSUBS nmos_bottom
Xnmos_top_trim1_0 a_229_1059# a_362_382# nmos_bottom_0/a_0_0# pmos2_1/VSUBS nmos_top_trim1
Xpmos2_0 w_87_786# a_168_375# a_229_1059# w_87_786# w_87_786# pmos2
Xpmos2_1 w_87_786# a_362_382# a_229_1059# w_87_786# w_87_786# pmos2
.ends

.subckt nmos_side_left a_87_91# a_0_0# a_57_61# VSUBS
X0 a_87_91# a_57_61# a_0_0# VSUBS sky130_fd_pr__nfet_01v8 ad=0.0545 pd=0.53 as=0.404 ps=3.02 w=3 l=0.15
.ends

.subckt nand3x1_pcell a_34_482# a_447_377# li_649_449# a_289_1059# pmos2_2/VSUBS a_147_377#
+ w_87_786#
Xnmos_bottom_0 a_147_377# pmos2_2/VSUBS nmos_bottom_0/a_0_0# pmos2_2/VSUBS nmos_bottom
Xnmos_top_trim1_0 a_289_1059# li_649_449# li_393_182# pmos2_2/VSUBS nmos_top_trim1
Xnmos_side_left_0 li_393_182# nmos_bottom_0/a_0_0# a_447_377# pmos2_2/VSUBS nmos_side_left
Xpmos2_0 w_87_786# a_147_377# a_289_1059# w_87_786# w_87_786# pmos2
Xpmos2_1 w_87_786# a_447_377# a_289_1059# w_87_786# w_87_786# pmos2
Xpmos2_2 w_87_786# li_649_449# a_289_1059# w_87_786# w_87_786# pmos2
.ends

.subckt dffsnx1_pcell nand2x1_pcell_5/a_168_375# nand2x1_pcell_2/a_362_382# nand3x1_pcell_1/a_147_377#
+ nand2x1_pcell_2/a_229_1059# m1_1093_871# nand3x1_pcell_1/a_289_1059# m1_2055_427#
+ VSUBS nand3x1_pcell_2/w_87_786# nand3x1_pcell_2/a_34_482#
Xnand2x1_pcell_2 nand3x1_pcell_2/a_34_482# nand2x1_pcell_2/a_362_382# nand2x1_pcell_2/a_229_1059#
+ VSUBS m1_406_797# nand3x1_pcell_2/w_87_786# nand2x1_pcell
Xnand2x1_pcell_5 nand3x1_pcell_2/a_34_482# m1_406_797# m1_537_501# VSUBS nand2x1_pcell_5/a_168_375#
+ nand3x1_pcell_2/w_87_786# nand2x1_pcell
Xnand3x1_pcell_0 nand3x1_pcell_2/a_34_482# m1_1093_871# m1_1351_723# m1_406_797# VSUBS
+ m1_537_501# nand3x1_pcell_2/w_87_786# nand3x1_pcell
Xnand3x1_pcell_1 nand3x1_pcell_2/a_34_482# m1_2055_427# m1_1351_723# nand3x1_pcell_1/a_289_1059#
+ VSUBS nand3x1_pcell_1/a_147_377# nand3x1_pcell_2/w_87_786# nand3x1_pcell
Xnand3x1_pcell_2 nand3x1_pcell_2/a_34_482# m1_2055_427# m1_1351_723# m1_2461_501#
+ VSUBS m1_537_501# nand3x1_pcell_2/w_87_786# nand3x1_pcell
Xnand2x1_pcell_0 nand3x1_pcell_2/a_34_482# m1_1093_871# m1_1351_723# VSUBS m1_2461_501#
+ nand3x1_pcell_2/w_87_786# nand2x1_pcell
.ends

.subckt TMRDFFSNQX1 Q D CLK SN VDD GND
Xvoter3x1_pcell_0 GND m1_9737_537# m1_3704_685# GND GND VDD Q GND m1_13511_907# voter3x1_pcell
Xdffsnx1_pcell_0 D m1_3704_685# m1_3911_833# m1_3911_833# CLK m1_3704_685# SN GND
+ VDD GND dffsnx1_pcell
Xdffsnx1_pcell_1 D m1_9737_537# m1_8727_537# m1_8727_537# CLK m1_9737_537# SN GND
+ VDD GND dffsnx1_pcell
Xdffsnx1_pcell_2 D m1_13511_907# m1_13659_981# m1_13659_981# CLK m1_13511_907# SN
+ GND VDD GND dffsnx1_pcell
.ends

****EOF - TMRDFFSNQX1.spice
****BOF - TMRDFFSNRNQNX1.spice

* NGSPICE file created from TMRDFFSNRNQNX1.ext - technology: sky130A

.subckt nmos_bottom a_56_54# a_86_84# a_0_0# VSUBS
X0 a_86_84# a_56_54# a_0_0# VSUBS sky130_fd_pr__nfet_01v8 ad=0.0597 pd=0.555 as=0.393 ps=2.99 w=3.01 l=0.15
.ends

.subckt pmos2_1 a_144_n460# a_262_n399# a_88_n399# w_52_n435# a_174_n399#
X0 a_174_n399# a_144_n460# a_88_n399# w_52_n435# sky130_fd_pr__pfet_01v8 ad=0.29 pd=2.29 as=0.56 ps=4.56 w=2 l=0.15
X1 a_262_n399# a_144_n460# a_174_n399# w_52_n435# sky130_fd_pr__pfet_01v8 ad=0.54 pd=4.54 as=0.29 ps=2.29 w=2 l=0.15
.ends

.subckt nmos_top_trim1 a_86_92# a_56_62# a_0_0# VSUBS
X0 a_86_92# a_56_62# a_0_0# VSUBS sky130_fd_pr__nfet_01v8 ad=0.0597 pd=0.555 as=0.395 ps=2.97 w=3.01 l=0.15
.ends

.subckt nmos_top a_84_92# a_0_0# a_54_62# VSUBS
X0 a_84_92# a_54_62# a_0_0# VSUBS sky130_fd_pr__nfet_01v8 ad=0.0597 pd=0.555 as=0.39 ps=2.96 w=3.01 l=0.15
.ends

.subckt nmos_top_trim2 a_86_92# a_56_62# a_0_0# VSUBS
X0 a_86_92# a_56_62# a_0_0# VSUBS sky130_fd_pr__nfet_01v8 ad=0.06 pd=0.56 as=0.395 ps=2.97 w=3.01 l=0.15
.ends

.subckt votern3x1_pcell a_362_381# a_1366_482# a_700_482# w_750_786# a_1507_944# a_834_375#
+ m1_449_219# pmos2_1_5/VSUBS
Xnmos_bottom_0 a_834_375# pmos2_1_5/VSUBS nmos_top_0/a_0_0# pmos2_1_5/VSUBS nmos_bottom
Xnmos_bottom_1 a_834_375# pmos2_1_5/VSUBS nmos_bottom_1/a_0_0# pmos2_1_5/VSUBS nmos_bottom
Xnmos_bottom_2 a_1507_944# pmos2_1_5/VSUBS nmos_bottom_2/a_0_0# pmos2_1_5/VSUBS nmos_bottom
Xpmos2_1_0 a_834_375# w_750_786# w_750_786# w_750_786# a_805_1331# pmos2_1
Xnmos_top_trim1_0 m1_449_219# a_1507_944# nmos_bottom_1/a_0_0# pmos2_1_5/VSUBS nmos_top_trim1
Xpmos2_1_1 a_362_381# w_750_786# w_750_786# w_750_786# a_805_1331# pmos2_1
Xpmos2_1_2 a_1507_944# a_805_1331# a_805_1331# w_750_786# a_893_1059# pmos2_1
Xpmos2_1_3 a_834_375# a_805_1331# a_805_1331# w_750_786# a_893_1059# pmos2_1
Xpmos2_1_4 a_1507_944# a_893_1059# a_893_1059# w_750_786# m1_449_219# pmos2_1
Xpmos2_1_5 a_362_381# a_893_1059# a_893_1059# w_750_786# m1_449_219# pmos2_1
Xnmos_top_0 m1_449_219# nmos_top_0/a_0_0# a_362_381# pmos2_1_5/VSUBS nmos_top
Xnmos_top_trim2_2 m1_449_219# a_362_381# nmos_bottom_2/a_0_0# pmos2_1_5/VSUBS nmos_top_trim2
.ends

.subckt nmos_side_left a_87_91# a_0_0# a_57_61# VSUBS
X0 a_87_91# a_57_61# a_0_0# VSUBS sky130_fd_pr__nfet_01v8 ad=0.0545 pd=0.53 as=0.404 ps=3.02 w=3 l=0.15
.ends

.subckt pmos2 a_88_n400# a_144_n461# a_174_n400# a_262_n400# w_52_n436#
X0 a_262_n400# a_144_n461# a_174_n400# w_52_n436# sky130_fd_pr__pfet_01v8 ad=0.54 pd=4.54 as=0.29 ps=2.29 w=2 l=0.15
X1 a_174_n400# a_144_n461# a_88_n400# w_52_n436# sky130_fd_pr__pfet_01v8 ad=0.29 pd=2.29 as=0.56 ps=4.56 w=2 l=0.15
.ends

.subckt nand3x1_pcell a_34_482# a_447_377# li_649_449# a_289_1059# pmos2_2/VSUBS w_87_786#
+ a_147_377#
Xnmos_bottom_0 a_147_377# pmos2_2/VSUBS nmos_bottom_0/a_0_0# pmos2_2/VSUBS nmos_bottom
Xnmos_top_trim1_0 a_289_1059# li_649_449# li_393_182# pmos2_2/VSUBS nmos_top_trim1
Xnmos_side_left_0 li_393_182# nmos_bottom_0/a_0_0# a_447_377# pmos2_2/VSUBS nmos_side_left
Xpmos2_0 w_87_786# a_147_377# a_289_1059# w_87_786# w_87_786# pmos2
Xpmos2_1 w_87_786# a_447_377# a_289_1059# w_87_786# w_87_786# pmos2
Xpmos2_2 w_87_786# li_649_449# a_289_1059# w_87_786# w_87_786# pmos2
.ends

.subckt dffsnrnx1_pcell nand3x1_pcell_5/a_147_377# nand3x1_pcell_0/a_147_377# m1_1377_871#
+ m1_2351_575# nand3x1_pcell_4/li_649_449# m1_426_427# nand3x1_pcell_5/w_87_786# nand3x1_pcell_4/a_289_1059#
+ VSUBS nand3x1_pcell_5/a_289_1059#
Xnand3x1_pcell_0 VSUBS m1_426_427# m1_716_649# m1_831_501# VSUBS nand3x1_pcell_5/w_87_786#
+ nand3x1_pcell_0/a_147_377# nand3x1_pcell
Xnand3x1_pcell_1 VSUBS m1_1377_871# m1_1660_723# m1_716_649# VSUBS nand3x1_pcell_5/w_87_786#
+ m1_831_501# nand3x1_pcell
Xnand3x1_pcell_2 VSUBS m1_2351_575# m1_1660_723# m1_2757_501# VSUBS nand3x1_pcell_5/w_87_786#
+ m1_831_501# nand3x1_pcell
Xnand3x1_pcell_3 VSUBS m1_1377_871# m1_426_427# m1_1660_723# VSUBS nand3x1_pcell_5/w_87_786#
+ m1_2757_501# nand3x1_pcell
Xnand3x1_pcell_4 VSUBS m1_426_427# nand3x1_pcell_4/li_649_449# nand3x1_pcell_4/a_289_1059#
+ VSUBS nand3x1_pcell_5/w_87_786# m1_716_649# nand3x1_pcell
Xnand3x1_pcell_5 VSUBS m1_2351_575# m1_1660_723# nand3x1_pcell_5/a_289_1059# VSUBS
+ nand3x1_pcell_5/w_87_786# nand3x1_pcell_5/a_147_377# nand3x1_pcell
.ends

.subckt TMRDFFSNRNQNX1 Q D CLK SN RN VDD GND
Xvotern3x1_pcell_0 m1_10551_685# GND GND VDD m1_16357_463# m1_4813_537# Q GND votern3x1_pcell
Xdffsnrnx1_pcell_0 m1_4813_537# D CLK SN m1_4665_685# RN VDD m1_4813_537# GND m1_4665_685#
+ dffsnrnx1_pcell
Xdffsnrnx1_pcell_1 m1_10551_685# D CLK SN m1_10437_537# RN VDD m1_10551_685# GND m1_10437_537#
+ dffsnrnx1_pcell
Xdffsnrnx1_pcell_2 m1_16357_463# D CLK SN m1_16209_537# RN VDD m1_16357_463# GND m1_16209_537#
+ dffsnrnx1_pcell
.ends

****EOF - TMRDFFSNRNQNX1.spice
****BOF - TMRDFFSNRNQX1.spice

* NGSPICE file created from TMRDFFSNRNQX1.ext - technology: sky130A

.subckt nmos_bottom a_56_54# a_86_84# a_0_0# VSUBS
X0 a_86_84# a_56_54# a_0_0# VSUBS sky130_fd_pr__nfet_01v8 ad=0.0597 pd=0.555 as=0.393 ps=2.99 w=3.01 l=0.15
.ends

.subckt nmos_top_trim1 a_86_92# a_56_62# a_0_0# VSUBS
X0 a_86_92# a_56_62# a_0_0# VSUBS sky130_fd_pr__nfet_01v8 ad=0.0597 pd=0.555 as=0.395 ps=2.97 w=3.01 l=0.15
.ends

.subckt nmos_side_left a_87_91# a_0_0# a_57_61# VSUBS
X0 a_87_91# a_57_61# a_0_0# VSUBS sky130_fd_pr__nfet_01v8 ad=0.0545 pd=0.53 as=0.404 ps=3.02 w=3 l=0.15
.ends

.subckt pmos2 a_88_n400# a_144_n461# a_174_n400# a_262_n400# w_52_n436#
X0 a_262_n400# a_144_n461# a_174_n400# w_52_n436# sky130_fd_pr__pfet_01v8 ad=0.54 pd=4.54 as=0.29 ps=2.29 w=2 l=0.15
X1 a_174_n400# a_144_n461# a_88_n400# w_52_n436# sky130_fd_pr__pfet_01v8 ad=0.29 pd=2.29 as=0.56 ps=4.56 w=2 l=0.15
.ends

.subckt nand3x1_pcell a_34_482# a_447_377# li_649_449# a_289_1059# pmos2_2/VSUBS w_87_786#
+ a_147_377#
Xnmos_bottom_0 a_147_377# pmos2_2/VSUBS nmos_bottom_0/a_0_0# pmos2_2/VSUBS nmos_bottom
Xnmos_top_trim1_0 a_289_1059# li_649_449# li_393_182# pmos2_2/VSUBS nmos_top_trim1
Xnmos_side_left_0 li_393_182# nmos_bottom_0/a_0_0# a_447_377# pmos2_2/VSUBS nmos_side_left
Xpmos2_0 w_87_786# a_147_377# a_289_1059# w_87_786# w_87_786# pmos2
Xpmos2_1 w_87_786# a_447_377# a_289_1059# w_87_786# w_87_786# pmos2
Xpmos2_2 w_87_786# li_649_449# a_289_1059# w_87_786# w_87_786# pmos2
.ends

.subckt dffsnrnx1_pcell nand3x1_pcell_5/a_147_377# nand3x1_pcell_0/a_147_377# m1_1377_871#
+ m1_2351_575# nand3x1_pcell_4/li_649_449# m1_426_427# nand3x1_pcell_5/w_87_786# nand3x1_pcell_4/a_289_1059#
+ nand3x1_pcell_5/a_289_1059# VSUBS
Xnand3x1_pcell_0 VSUBS m1_426_427# m1_716_649# m1_831_501# VSUBS nand3x1_pcell_5/w_87_786#
+ nand3x1_pcell_0/a_147_377# nand3x1_pcell
Xnand3x1_pcell_1 VSUBS m1_1377_871# m1_1660_723# m1_716_649# VSUBS nand3x1_pcell_5/w_87_786#
+ m1_831_501# nand3x1_pcell
Xnand3x1_pcell_2 VSUBS m1_2351_575# m1_1660_723# m1_2757_501# VSUBS nand3x1_pcell_5/w_87_786#
+ m1_831_501# nand3x1_pcell
Xnand3x1_pcell_3 VSUBS m1_1377_871# m1_426_427# m1_1660_723# VSUBS nand3x1_pcell_5/w_87_786#
+ m1_2757_501# nand3x1_pcell
Xnand3x1_pcell_4 VSUBS m1_426_427# nand3x1_pcell_4/li_649_449# nand3x1_pcell_4/a_289_1059#
+ VSUBS nand3x1_pcell_5/w_87_786# m1_716_649# nand3x1_pcell
Xnand3x1_pcell_5 VSUBS m1_2351_575# m1_1660_723# nand3x1_pcell_5/a_289_1059# VSUBS
+ nand3x1_pcell_5/w_87_786# nand3x1_pcell_5/a_147_377# nand3x1_pcell
.ends

.subckt pmos2_1 a_144_n460# a_262_n399# a_88_n399# w_52_n435# a_174_n399#
X0 a_174_n399# a_144_n460# a_88_n399# w_52_n435# sky130_fd_pr__pfet_01v8 ad=0.29 pd=2.29 as=0.56 ps=4.56 w=2 l=0.15
X1 a_262_n399# a_144_n460# a_174_n399# w_52_n435# sky130_fd_pr__pfet_01v8 ad=0.54 pd=4.54 as=0.29 ps=2.29 w=2 l=0.15
.ends

.subckt nmos_top a_84_92# a_0_0# a_54_62# VSUBS
X0 a_84_92# a_54_62# a_0_0# VSUBS sky130_fd_pr__nfet_01v8 ad=0.0597 pd=0.555 as=0.39 ps=2.96 w=3.01 l=0.15
.ends

.subckt nmos_top_trim2 a_86_92# a_56_62# a_0_0# VSUBS
X0 a_86_92# a_56_62# a_0_0# VSUBS sky130_fd_pr__nfet_01v8 ad=0.06 pd=0.56 as=0.395 ps=2.97 w=3.01 l=0.15
.ends

.subckt votern3x1_pcell a_1366_n34# a_362_381# a_1366_482# a_700_482# w_750_786# a_1507_944#
+ a_834_375# m1_449_219# pmos2_1_5/VSUBS
Xnmos_bottom_0 a_834_375# pmos2_1_5/VSUBS nmos_top_0/a_0_0# pmos2_1_5/VSUBS nmos_bottom
Xnmos_bottom_1 a_834_375# pmos2_1_5/VSUBS nmos_bottom_1/a_0_0# pmos2_1_5/VSUBS nmos_bottom
Xnmos_bottom_2 a_1507_944# pmos2_1_5/VSUBS nmos_bottom_2/a_0_0# pmos2_1_5/VSUBS nmos_bottom
Xpmos2_1_0 a_834_375# w_750_786# w_750_786# w_750_786# a_805_1331# pmos2_1
Xnmos_top_trim1_0 m1_449_219# a_1507_944# nmos_bottom_1/a_0_0# pmos2_1_5/VSUBS nmos_top_trim1
Xpmos2_1_1 a_362_381# w_750_786# w_750_786# w_750_786# a_805_1331# pmos2_1
Xpmos2_1_2 a_1507_944# a_805_1331# a_805_1331# w_750_786# a_893_1059# pmos2_1
Xpmos2_1_3 a_834_375# a_805_1331# a_805_1331# w_750_786# a_893_1059# pmos2_1
Xpmos2_1_4 a_1507_944# a_893_1059# a_893_1059# w_750_786# m1_449_219# pmos2_1
Xpmos2_1_5 a_362_381# a_893_1059# a_893_1059# w_750_786# m1_449_219# pmos2_1
Xnmos_top_0 m1_449_219# nmos_top_0/a_0_0# a_362_381# pmos2_1_5/VSUBS nmos_top
Xnmos_top_trim2_2 m1_449_219# a_362_381# nmos_bottom_2/a_0_0# pmos2_1_5/VSUBS nmos_top_trim2
.ends

.subckt invx1_pcell a_34_482# a_155_381# a_206_1059# w_n87_786# pmos2_0/VSUBS
Xnmos_top_0 a_206_1059# pmos2_0/VSUBS a_155_381# pmos2_0/VSUBS nmos_top
Xpmos2_0 w_n87_786# a_155_381# a_206_1059# w_n87_786# w_n87_786# pmos2
.ends

.subckt voter3x1_pcell votern3x1_pcell_0/a_1507_944# votern3x1_pcell_0/a_834_375#
+ votern3x1_pcell_0/a_1366_n34# votern3x1_pcell_0/a_362_381# votern3x1_pcell_0/a_700_482#
+ invx1_pcell_0/a_34_482# invx1_pcell_0/w_n87_786# invx1_pcell_0/a_206_1059# VSUBS
Xvotern3x1_pcell_0 votern3x1_pcell_0/a_1366_n34# votern3x1_pcell_0/a_362_381# invx1_pcell_0/a_34_482#
+ votern3x1_pcell_0/a_700_482# invx1_pcell_0/w_n87_786# votern3x1_pcell_0/a_1507_944#
+ votern3x1_pcell_0/a_834_375# m1_1867_797# VSUBS votern3x1_pcell
Xinvx1_pcell_0 invx1_pcell_0/a_34_482# m1_1867_797# invx1_pcell_0/a_206_1059# invx1_pcell_0/w_n87_786#
+ VSUBS invx1_pcell
.ends

.subckt TMRDFFSNRNQX1 Q D CLK SN RN VDD GND
Xdffsnrnx1_pcell_0 m1_4813_537# D CLK SN m1_5741_981# RN VDD m1_4813_537# m1_5741_981#
+ GND dffsnrnx1_pcell
Xdffsnrnx1_pcell_1 m1_10585_537# D CLK SN m1_11547_759# RN VDD m1_10585_537# m1_11547_759#
+ GND dffsnrnx1_pcell
Xdffsnrnx1_pcell_2 m1_16357_537# D CLK SN m1_16209_463# RN VDD m1_16357_537# m1_16209_463#
+ GND dffsnrnx1_pcell
Xvoter3x1_pcell_0 m1_16209_463# m1_5741_981# GND m1_11547_759# GND GND VDD Q GND voter3x1_pcell
.ends

****EOF - TMRDFFSNRNQX1.spice
****BOF - VOTER3X1.spice

* NGSPICE file created from VOTER3X1.ext - technology: sky130A

.subckt nmos_bottom a_56_54# a_86_84# a_0_0# VSUBS
X0 a_86_84# a_56_54# a_0_0# VSUBS sky130_fd_pr__nfet_01v8 ad=0.0597 pd=0.555 as=0.393 ps=2.99 w=3.01 l=0.15
.ends

.subckt pmos2_1 a_144_n460# a_262_n399# a_88_n399# w_52_n435# a_174_n399#
X0 a_174_n399# a_144_n460# a_88_n399# w_52_n435# sky130_fd_pr__pfet_01v8 ad=0.29 pd=2.29 as=0.56 ps=4.56 w=2 l=0.15
X1 a_262_n399# a_144_n460# a_174_n399# w_52_n435# sky130_fd_pr__pfet_01v8 ad=0.54 pd=4.54 as=0.29 ps=2.29 w=2 l=0.15
.ends

.subckt nmos_top_trim1 a_86_92# a_56_62# a_0_0# VSUBS
X0 a_86_92# a_56_62# a_0_0# VSUBS sky130_fd_pr__nfet_01v8 ad=0.0597 pd=0.555 as=0.395 ps=2.97 w=3.01 l=0.15
.ends

.subckt nmos_top a_84_92# a_0_0# a_54_62# VSUBS
X0 a_84_92# a_54_62# a_0_0# VSUBS sky130_fd_pr__nfet_01v8 ad=0.0597 pd=0.555 as=0.39 ps=2.96 w=3.01 l=0.15
.ends

.subckt nmos_top_trim2 a_86_92# a_56_62# a_0_0# VSUBS
X0 a_86_92# a_56_62# a_0_0# VSUBS sky130_fd_pr__nfet_01v8 ad=0.06 pd=0.56 as=0.395 ps=2.97 w=3.01 l=0.15
.ends

.subckt votern3x1_pcell a_1366_n34# a_1507_944# a_362_381# a_1366_482# w_750_786#
+ m1_449_219# pmos2_1_5/VSUBS a_834_375#
Xnmos_bottom_0 a_834_375# pmos2_1_5/VSUBS nmos_top_0/a_0_0# pmos2_1_5/VSUBS nmos_bottom
Xnmos_bottom_1 a_834_375# pmos2_1_5/VSUBS nmos_bottom_1/a_0_0# pmos2_1_5/VSUBS nmos_bottom
Xnmos_bottom_2 a_1507_944# pmos2_1_5/VSUBS nmos_bottom_2/a_0_0# pmos2_1_5/VSUBS nmos_bottom
Xpmos2_1_0 a_834_375# w_750_786# w_750_786# w_750_786# a_805_1331# pmos2_1
Xnmos_top_trim1_0 m1_449_219# a_1507_944# nmos_bottom_1/a_0_0# pmos2_1_5/VSUBS nmos_top_trim1
Xpmos2_1_1 a_362_381# w_750_786# w_750_786# w_750_786# a_805_1331# pmos2_1
Xpmos2_1_2 a_1507_944# a_805_1331# a_805_1331# w_750_786# a_893_1059# pmos2_1
Xpmos2_1_3 a_834_375# a_805_1331# a_805_1331# w_750_786# a_893_1059# pmos2_1
Xpmos2_1_4 a_1507_944# a_893_1059# a_893_1059# w_750_786# m1_449_219# pmos2_1
Xpmos2_1_5 a_362_381# a_893_1059# a_893_1059# w_750_786# m1_449_219# pmos2_1
Xnmos_top_0 m1_449_219# nmos_top_0/a_0_0# a_362_381# pmos2_1_5/VSUBS nmos_top
Xnmos_top_trim2_2 m1_449_219# a_362_381# nmos_bottom_2/a_0_0# pmos2_1_5/VSUBS nmos_top_trim2
.ends

.subckt pmos2 a_88_n400# a_144_n461# a_174_n400# a_262_n400# w_52_n436#
X0 a_262_n400# a_144_n461# a_174_n400# w_52_n436# sky130_fd_pr__pfet_01v8 ad=0.54 pd=4.54 as=0.29 ps=2.29 w=2 l=0.15
X1 a_174_n400# a_144_n461# a_88_n400# w_52_n436# sky130_fd_pr__pfet_01v8 ad=0.29 pd=2.29 as=0.56 ps=4.56 w=2 l=0.15
.ends

.subckt invx1_pcell a_34_482# a_155_381# a_206_1059# w_n87_786# pmos2_0/VSUBS
Xnmos_top_0 a_206_1059# pmos2_0/VSUBS a_155_381# pmos2_0/VSUBS nmos_top
Xpmos2_0 w_n87_786# a_155_381# a_206_1059# w_n87_786# w_n87_786# pmos2
.ends

.subckt voter3x1_pcell votern3x1_pcell_0/a_1366_n34# votern3x1_pcell_0/a_362_381#
+ votern3x1_pcell_0/a_1507_944# invx1_pcell_0/w_n87_786# invx1_pcell_0/a_206_1059#
+ VSUBS votern3x1_pcell_0/a_834_375#
Xvotern3x1_pcell_0 votern3x1_pcell_0/a_1366_n34# votern3x1_pcell_0/a_1507_944# votern3x1_pcell_0/a_362_381#
+ invx1_pcell_0/a_34_482# invx1_pcell_0/w_n87_786# m1_1867_797# VSUBS votern3x1_pcell_0/a_834_375#
+ votern3x1_pcell
Xinvx1_pcell_0 invx1_pcell_0/a_34_482# m1_1867_797# invx1_pcell_0/a_206_1059# invx1_pcell_0/w_n87_786#
+ VSUBS invx1_pcell
.ends

.subckt VOTER3X1 Y A B C VDD GND
Xvoter3x1_pcell_0 GND A C VDD Y GND B voter3x1_pcell
.ends

****EOF - VOTER3X1.spice
****BOF - VOTERN3X1.spice

* NGSPICE file created from VOTERN3X1.ext - technology: sky130A

.subckt nmos_bottom a_56_54# a_86_84# a_0_0# VSUBS
X0 a_86_84# a_56_54# a_0_0# VSUBS sky130_fd_pr__nfet_01v8 ad=0.0597 pd=0.555 as=0.393 ps=2.99 w=3.01 l=0.15
.ends

.subckt pmos2_1 a_144_n460# a_262_n399# a_88_n399# w_52_n435# a_174_n399#
X0 a_174_n399# a_144_n460# a_88_n399# w_52_n435# sky130_fd_pr__pfet_01v8 ad=0.29 pd=2.29 as=0.56 ps=4.56 w=2 l=0.15
X1 a_262_n399# a_144_n460# a_174_n399# w_52_n435# sky130_fd_pr__pfet_01v8 ad=0.54 pd=4.54 as=0.29 ps=2.29 w=2 l=0.15
.ends

.subckt nmos_top_trim1 a_86_92# a_56_62# a_0_0# VSUBS
X0 a_86_92# a_56_62# a_0_0# VSUBS sky130_fd_pr__nfet_01v8 ad=0.0597 pd=0.555 as=0.395 ps=2.97 w=3.01 l=0.15
.ends

.subckt nmos_top a_84_92# a_0_0# a_54_62# VSUBS
X0 a_84_92# a_54_62# a_0_0# VSUBS sky130_fd_pr__nfet_01v8 ad=0.0597 pd=0.555 as=0.39 ps=2.96 w=3.01 l=0.15
.ends

.subckt nmos_top_trim2 a_86_92# a_56_62# a_0_0# VSUBS
X0 a_86_92# a_56_62# a_0_0# VSUBS sky130_fd_pr__nfet_01v8 ad=0.06 pd=0.56 as=0.395 ps=2.97 w=3.01 l=0.15
.ends

.subckt votern3x1_pcell a_1366_n34# a_1507_944# a_362_381# w_750_786# m1_449_219#
+ pmos2_1_5/VSUBS a_834_375#
Xnmos_bottom_0 a_834_375# pmos2_1_5/VSUBS nmos_top_0/a_0_0# pmos2_1_5/VSUBS nmos_bottom
Xnmos_bottom_1 a_834_375# pmos2_1_5/VSUBS nmos_bottom_1/a_0_0# pmos2_1_5/VSUBS nmos_bottom
Xnmos_bottom_2 a_1507_944# pmos2_1_5/VSUBS nmos_bottom_2/a_0_0# pmos2_1_5/VSUBS nmos_bottom
Xpmos2_1_0 a_834_375# w_750_786# w_750_786# w_750_786# a_805_1331# pmos2_1
Xnmos_top_trim1_0 m1_449_219# a_1507_944# nmos_bottom_1/a_0_0# pmos2_1_5/VSUBS nmos_top_trim1
Xpmos2_1_1 a_362_381# w_750_786# w_750_786# w_750_786# a_805_1331# pmos2_1
Xpmos2_1_2 a_1507_944# a_805_1331# a_805_1331# w_750_786# a_893_1059# pmos2_1
Xpmos2_1_3 a_834_375# a_805_1331# a_805_1331# w_750_786# a_893_1059# pmos2_1
Xpmos2_1_4 a_1507_944# a_893_1059# a_893_1059# w_750_786# m1_449_219# pmos2_1
Xpmos2_1_5 a_362_381# a_893_1059# a_893_1059# w_750_786# m1_449_219# pmos2_1
Xnmos_top_0 m1_449_219# nmos_top_0/a_0_0# a_362_381# pmos2_1_5/VSUBS nmos_top
Xnmos_top_trim2_2 m1_449_219# a_362_381# nmos_bottom_2/a_0_0# pmos2_1_5/VSUBS nmos_top_trim2
.ends

.subckt VOTERN3X1 YN A B C VDD GND
Xvotern3x1_pcell_0 GND C A VDD YN GND B votern3x1_pcell
.ends

****EOF - VOTERN3X1.spice
****BOF - XNOR2X1.spice

* NGSPICE file created from XNOR2X1.ext - technology: sky130A

.subckt nmos_bottom a_56_54# a_86_84# a_0_0# VSUBS
X0 a_86_84# a_56_54# a_0_0# VSUBS sky130_fd_pr__nfet_01v8 ad=0.0597 pd=0.555 as=0.393 ps=2.99 w=3.01 l=0.15
.ends

.subckt pmos2_1 a_144_n460# a_262_n399# a_88_n399# w_52_n435# a_174_n399#
X0 a_174_n399# a_144_n460# a_88_n399# w_52_n435# sky130_fd_pr__pfet_01v8 ad=0.29 pd=2.29 as=0.56 ps=4.56 w=2 l=0.15
X1 a_262_n399# a_144_n460# a_174_n399# w_52_n435# sky130_fd_pr__pfet_01v8 ad=0.54 pd=4.54 as=0.29 ps=2.29 w=2 l=0.15
.ends

.subckt nmos_top_trim1 a_86_92# a_56_62# a_0_0# VSUBS
X0 a_86_92# a_56_62# a_0_0# VSUBS sky130_fd_pr__nfet_01v8 ad=0.0597 pd=0.555 as=0.395 ps=2.97 w=3.01 l=0.15
.ends

.subckt nmos_top a_84_92# a_0_0# a_54_62# VSUBS
X0 a_84_92# a_54_62# a_0_0# VSUBS sky130_fd_pr__nfet_01v8 ad=0.0597 pd=0.555 as=0.39 ps=2.96 w=3.01 l=0.15
.ends

.subckt pmos2 a_88_n400# a_144_n461# a_174_n400# a_262_n400# w_52_n436#
X0 a_262_n400# a_144_n461# a_174_n400# w_52_n436# sky130_fd_pr__pfet_01v8 ad=0.54 pd=4.54 as=0.29 ps=2.29 w=2 l=0.15
X1 a_174_n400# a_144_n461# a_88_n400# w_52_n436# sky130_fd_pr__pfet_01v8 ad=0.29 pd=2.29 as=0.56 ps=4.56 w=2 l=0.15
.ends

.subckt invx1_pcell a_34_482# a_155_381# a_206_1059# w_n87_786# pmos2_0/VSUBS
Xnmos_top_0 a_206_1059# pmos2_0/VSUBS a_155_381# pmos2_0/VSUBS nmos_top
Xpmos2_0 w_n87_786# a_155_381# a_206_1059# w_n87_786# w_n87_786# pmos2
.ends

.subckt xnor2x1_pcell m1_939_797# pmos2_1_3/VSUBS m1_981_723# a_612_375# a_1144_n34#
+ w_585_1330#
Xnmos_bottom_0 a_612_375# pmos2_1_3/VSUBS nmos_bottom_0/a_0_0# pmos2_1_3/VSUBS nmos_bottom
Xnmos_bottom_1 m1_939_797# pmos2_1_3/VSUBS nmos_bottom_1/a_0_0# pmos2_1_3/VSUBS nmos_bottom
Xpmos2_1_0 a_612_375# a_761_1330# a_761_1330# w_585_1330# w_585_1330# pmos2_1
Xnmos_top_trim1_1 m1_981_723# m1_315_501# nmos_bottom_1/a_0_0# pmos2_1_3/VSUBS nmos_top_trim1
Xnmos_top_trim1_0 m1_981_723# a_806_382# nmos_bottom_0/a_0_0# pmos2_1_3/VSUBS nmos_top_trim1
Xpmos2_1_1 m1_939_797# a_761_1330# a_761_1330# w_585_1330# m1_981_723# pmos2_1
Xpmos2_1_2 a_806_382# a_1427_1330# a_1427_1330# w_585_1330# w_585_1330# pmos2_1
Xpmos2_1_3 m1_315_501# a_1427_1330# a_1427_1330# w_585_1330# m1_981_723# pmos2_1
Xinvx1_pcell_0 pmos2_1_3/VSUBS a_612_375# m1_315_501# w_585_1330# pmos2_1_3/VSUBS
+ invx1_pcell
Xinvx1_pcell_1 pmos2_1_3/VSUBS m1_939_797# a_806_382# w_585_1330# pmos2_1_3/VSUBS
+ invx1_pcell
.ends

.subckt XNOR2X1 Y A B VDD GND
Xxnor2x1_pcell_0 B GND Y A GND VDD xnor2x1_pcell
.ends

****EOF - XNOR2X1.spice
****BOF - XOR2X1.spice

* NGSPICE file created from XOR2X1.ext - technology: sky130A

.subckt nmos_bottom a_56_54# a_86_84# a_0_0# VSUBS
X0 a_86_84# a_56_54# a_0_0# VSUBS sky130_fd_pr__nfet_01v8 ad=0.0597 pd=0.555 as=0.393 ps=2.99 w=3.01 l=0.15
.ends

.subckt pmos2_1 a_144_n460# a_262_n399# a_88_n399# w_52_n435# a_174_n399#
X0 a_174_n399# a_144_n460# a_88_n399# w_52_n435# sky130_fd_pr__pfet_01v8 ad=0.29 pd=2.29 as=0.56 ps=4.56 w=2 l=0.15
X1 a_262_n399# a_144_n460# a_174_n399# w_52_n435# sky130_fd_pr__pfet_01v8 ad=0.54 pd=4.54 as=0.29 ps=2.29 w=2 l=0.15
.ends

.subckt nmos_top_trim1 a_86_92# a_56_62# a_0_0# VSUBS
X0 a_86_92# a_56_62# a_0_0# VSUBS sky130_fd_pr__nfet_01v8 ad=0.0597 pd=0.555 as=0.395 ps=2.97 w=3.01 l=0.15
.ends

.subckt nmos_top a_84_92# a_0_0# a_54_62# VSUBS
X0 a_84_92# a_54_62# a_0_0# VSUBS sky130_fd_pr__nfet_01v8 ad=0.0597 pd=0.555 as=0.39 ps=2.96 w=3.01 l=0.15
.ends

.subckt pmos2 a_88_n400# a_144_n461# a_174_n400# a_262_n400# w_52_n436#
X0 a_262_n400# a_144_n461# a_174_n400# w_52_n436# sky130_fd_pr__pfet_01v8 ad=0.54 pd=4.54 as=0.29 ps=2.29 w=2 l=0.15
X1 a_174_n400# a_144_n461# a_88_n400# w_52_n436# sky130_fd_pr__pfet_01v8 ad=0.29 pd=2.29 as=0.56 ps=4.56 w=2 l=0.15
.ends

.subckt invx1_pcell a_34_482# a_155_381# a_206_1059# w_n87_786# pmos2_0/VSUBS
Xnmos_top_0 a_206_1059# pmos2_0/VSUBS a_155_381# pmos2_0/VSUBS nmos_top
Xpmos2_0 w_n87_786# a_155_381# a_206_1059# w_n87_786# w_n87_786# pmos2
.ends

.subckt xor2X1_pcell a_806_383# pmos2_1_3/VSUBS m1_981_723# a_612_376# a_1141_n17#
+ w_585_1330#
Xnmos_bottom_0 a_612_376# pmos2_1_3/VSUBS nmos_bottom_0/a_0_0# pmos2_1_3/VSUBS nmos_bottom
Xnmos_bottom_1 m1_939_797# pmos2_1_3/VSUBS nmos_bottom_1/a_0_0# pmos2_1_3/VSUBS nmos_bottom
Xpmos2_1_0 a_612_376# a_761_1330# a_761_1330# w_585_1330# w_585_1330# pmos2_1
Xnmos_top_trim1_1 m1_981_723# m1_315_501# nmos_bottom_1/a_0_0# pmos2_1_3/VSUBS nmos_top_trim1
Xnmos_top_trim1_0 m1_981_723# a_806_383# nmos_bottom_0/a_0_0# pmos2_1_3/VSUBS nmos_top_trim1
Xpmos2_1_1 m1_939_797# a_761_1330# a_761_1330# w_585_1330# m1_981_723# pmos2_1
Xpmos2_1_2 a_806_383# a_1427_1330# a_1427_1330# w_585_1330# w_585_1330# pmos2_1
Xpmos2_1_3 m1_315_501# a_1427_1330# a_1427_1330# w_585_1330# m1_981_723# pmos2_1
Xinvx1_pcell_0 pmos2_1_3/VSUBS a_612_376# m1_315_501# w_585_1330# pmos2_1_3/VSUBS
+ invx1_pcell
Xinvx1_pcell_1 pmos2_1_3/VSUBS a_806_383# m1_939_797# w_585_1330# pmos2_1_3/VSUBS
+ invx1_pcell
.ends

.subckt XOR2X1 Y A B VDD GND
Xxor2X1_pcell_0 B GND Y A GND VDD xor2X1_pcell
.ends

****EOF - XOR2X1.spice
****BOF - and2x1_pcell.spice

* NGSPICE file created from and2x1_pcell.ext - technology: sky130A

.subckt nmos_top a_84_92# a_0_0# a_54_62# VSUBS
X0 a_84_92# a_54_62# a_0_0# VSUBS sky130_fd_pr__nfet_01v8 ad=0.0597 pd=0.555 as=0.39 ps=2.96 w=3.01 l=0.15
.ends

.subckt pmos2 a_88_n400# a_144_n461# a_174_n400# a_262_n400# w_52_n436#
X0 a_262_n400# a_144_n461# a_174_n400# w_52_n436# sky130_fd_pr__pfet_01v8 ad=0.54 pd=4.54 as=0.29 ps=2.29 w=2 l=0.15
X1 a_174_n400# a_144_n461# a_88_n400# w_52_n436# sky130_fd_pr__pfet_01v8 ad=0.29 pd=2.29 as=0.56 ps=4.56 w=2 l=0.15
.ends

.subckt invx1_pcell a_34_482# a_155_381# w_n87_786# pmos2_0/VSUBS
Xnmos_top_0 a_206_1059# pmos2_0/VSUBS a_155_381# pmos2_0/VSUBS nmos_top
Xpmos2_0 w_n87_786# a_155_381# a_206_1059# w_n87_786# w_n87_786# pmos2
.ends

.subckt nmos_bottom a_56_54# a_86_84# a_0_0# VSUBS
X0 a_86_84# a_56_54# a_0_0# VSUBS sky130_fd_pr__nfet_01v8 ad=0.0597 pd=0.555 as=0.393 ps=2.99 w=3.01 l=0.15
.ends

.subckt nmos_top_trim1 a_86_92# a_56_62# a_0_0# VSUBS
X0 a_86_92# a_56_62# a_0_0# VSUBS sky130_fd_pr__nfet_01v8 ad=0.0597 pd=0.555 as=0.395 ps=2.97 w=3.01 l=0.15
.ends

.subckt nand2x1_pcell a_31_480# a_229_1059# pmos2_1/VSUBS w_87_786#
Xnmos_bottom_0 a_168_375# pmos2_1/VSUBS nmos_bottom_0/a_0_0# pmos2_1/VSUBS nmos_bottom
Xnmos_top_trim1_0 a_229_1059# a_362_382# nmos_bottom_0/a_0_0# pmos2_1/VSUBS nmos_top_trim1
Xpmos2_0 w_87_786# a_168_375# a_229_1059# w_87_786# w_87_786# pmos2
Xpmos2_1 w_87_786# a_362_382# a_229_1059# w_87_786# w_87_786# pmos2
.ends

.subckt and2x1_pcell
Xinvx1_pcell_0 invx1_pcell_0/a_34_482# m1_547_649# invx1_pcell_0/w_n87_786# VSUBS
+ invx1_pcell
Xnand2x1_pcell_0 invx1_pcell_0/a_34_482# m1_547_649# VSUBS invx1_pcell_0/w_n87_786#
+ nand2x1_pcell
.ends

****EOF - and2x1_pcell.spice
****BOF - and3x1_pcell.spice

* NGSPICE file created from and3x1_pcell.ext - technology: sky130A

.subckt nmos_top a_84_92# a_0_0# a_54_62# VSUBS
X0 a_84_92# a_54_62# a_0_0# VSUBS sky130_fd_pr__nfet_01v8 ad=0.0597 pd=0.555 as=0.39 ps=2.96 w=3.01 l=0.15
.ends

.subckt pmos2 a_88_n400# a_144_n461# a_174_n400# a_262_n400# w_52_n436#
X0 a_262_n400# a_144_n461# a_174_n400# w_52_n436# sky130_fd_pr__pfet_01v8 ad=0.54 pd=4.54 as=0.29 ps=2.29 w=2 l=0.15
X1 a_174_n400# a_144_n461# a_88_n400# w_52_n436# sky130_fd_pr__pfet_01v8 ad=0.29 pd=2.29 as=0.56 ps=4.56 w=2 l=0.15
.ends

.subckt invx1_pcell a_34_482# a_155_381# w_n87_786# pmos2_0/VSUBS
Xnmos_top_0 a_206_1059# pmos2_0/VSUBS a_155_381# pmos2_0/VSUBS nmos_top
Xpmos2_0 w_n87_786# a_155_381# a_206_1059# w_n87_786# w_n87_786# pmos2
.ends

.subckt nmos_bottom a_56_54# a_86_84# a_0_0# VSUBS
X0 a_86_84# a_56_54# a_0_0# VSUBS sky130_fd_pr__nfet_01v8 ad=0.0597 pd=0.555 as=0.393 ps=2.99 w=3.01 l=0.15
.ends

.subckt nmos_top_trim1 a_86_92# a_56_62# a_0_0# VSUBS
X0 a_86_92# a_56_62# a_0_0# VSUBS sky130_fd_pr__nfet_01v8 ad=0.0597 pd=0.555 as=0.395 ps=2.97 w=3.01 l=0.15
.ends

.subckt nmos_side_left a_87_91# a_0_0# a_57_61# VSUBS
X0 a_87_91# a_57_61# a_0_0# VSUBS sky130_fd_pr__nfet_01v8 ad=0.0545 pd=0.53 as=0.404 ps=3.02 w=3 l=0.15
.ends

.subckt nand3x1_pcell a_34_482# a_289_1059# w_87_786# pmos2_2/VSUBS
Xnmos_bottom_0 a_147_377# pmos2_2/VSUBS nmos_bottom_0/a_0_0# pmos2_2/VSUBS nmos_bottom
Xnmos_top_trim1_0 a_289_1059# li_649_449# li_393_182# pmos2_2/VSUBS nmos_top_trim1
Xnmos_side_left_0 li_393_182# nmos_bottom_0/a_0_0# a_447_377# pmos2_2/VSUBS nmos_side_left
Xpmos2_0 w_87_786# a_147_377# a_289_1059# w_87_786# w_87_786# pmos2
Xpmos2_1 w_87_786# a_447_377# a_289_1059# w_87_786# w_87_786# pmos2
Xpmos2_2 w_87_786# li_649_449# a_289_1059# w_87_786# w_87_786# pmos2
.ends

.subckt and3x1_pcell
Xinvx1_pcell_0 invx1_pcell_0/a_34_482# m1_867_649# invx1_pcell_0/w_n87_786# VSUBS
+ invx1_pcell
Xnand3x1_pcell_0 invx1_pcell_0/a_34_482# m1_867_649# invx1_pcell_0/w_n87_786# VSUBS
+ nand3x1_pcell
.ends

****EOF - and3x1_pcell.spice
****BOF - ao3x1_pcell.spice

* NGSPICE file created from ao3x1_pcell.ext - technology: sky130A

.subckt nmos_top a_84_92# a_0_0# a_54_62# VSUBS
X0 a_84_92# a_54_62# a_0_0# VSUBS sky130_fd_pr__nfet_01v8 ad=0.0597 pd=0.555 as=0.39 ps=2.96 w=3.01 l=0.15
.ends

.subckt pmos2 a_88_n400# a_144_n461# a_174_n400# a_262_n400# w_52_n436#
X0 a_262_n400# a_144_n461# a_174_n400# w_52_n436# sky130_fd_pr__pfet_01v8 ad=0.54 pd=4.54 as=0.29 ps=2.29 w=2 l=0.15
X1 a_174_n400# a_144_n461# a_88_n400# w_52_n436# sky130_fd_pr__pfet_01v8 ad=0.29 pd=2.29 as=0.56 ps=4.56 w=2 l=0.15
.ends

.subckt invx1_pcell a_34_482# a_155_381# w_n87_786# pmos2_0/VSUBS
Xnmos_top_0 a_206_1059# pmos2_0/VSUBS a_155_381# pmos2_0/VSUBS nmos_top
Xpmos2_0 w_n87_786# a_155_381# a_206_1059# w_n87_786# w_n87_786# pmos2
.ends

.subckt nmos_bottom a_56_54# a_86_84# a_0_0# VSUBS
X0 a_86_84# a_56_54# a_0_0# VSUBS sky130_fd_pr__nfet_01v8 ad=0.0597 pd=0.555 as=0.393 ps=2.99 w=3.01 l=0.15
.ends

.subckt nmos_top_trim1 a_86_92# a_56_62# a_0_0# VSUBS
X0 a_86_92# a_56_62# a_0_0# VSUBS sky130_fd_pr__nfet_01v8 ad=0.0597 pd=0.555 as=0.395 ps=2.97 w=3.01 l=0.15
.ends

.subckt nand2x1_pcell a_31_480# a_229_1059# pmos2_1/VSUBS w_87_786#
Xnmos_bottom_0 a_168_375# pmos2_1/VSUBS nmos_bottom_0/a_0_0# pmos2_1/VSUBS nmos_bottom
Xnmos_top_trim1_0 a_229_1059# a_362_382# nmos_bottom_0/a_0_0# pmos2_1/VSUBS nmos_top_trim1
Xpmos2_0 w_87_786# a_168_375# a_229_1059# w_87_786# w_87_786# pmos2
Xpmos2_1 w_87_786# a_362_382# a_229_1059# w_87_786# w_87_786# pmos2
.ends

.subckt pmos2_1 a_144_n460# a_262_n399# a_88_n399# w_52_n435# a_174_n399#
X0 a_174_n399# a_144_n460# a_88_n399# w_52_n435# sky130_fd_pr__pfet_01v8 ad=0.29 pd=2.29 as=0.56 ps=4.56 w=2 l=0.15
X1 a_262_n399# a_144_n460# a_174_n399# w_52_n435# sky130_fd_pr__pfet_01v8 ad=0.54 pd=4.54 as=0.29 ps=2.29 w=2 l=0.15
.ends

.subckt nmos_top_trim2 a_86_92# a_56_62# a_0_0# VSUBS
X0 a_86_92# a_56_62# a_0_0# VSUBS sky130_fd_pr__nfet_01v8 ad=0.06 pd=0.56 as=0.395 ps=2.97 w=3.01 l=0.15
.ends

.subckt nor2x1_pcell a_405_1059# a_34_482# pmos2_1_1/VSUBS a_168_375# w_87_786#
Xpmos2_1_0 a_168_375# a_317_1331# a_317_1331# w_87_786# w_87_786# pmos2_1
Xpmos2_1_1 a_362_382# a_317_1331# a_317_1331# w_87_786# a_405_1059# pmos2_1
Xnmos_top_trim1_1 a_405_1059# a_168_375# pmos2_1_1/VSUBS pmos2_1_1/VSUBS nmos_top_trim1
Xnmos_top_trim2_0 a_405_1059# a_362_382# pmos2_1_1/VSUBS pmos2_1_1/VSUBS nmos_top_trim2
.ends

.subckt aoi3x1_pcell nor2x1_pcell_0/w_87_786# nor2x1_pcell_0/a_405_1059# nor2x1_pcell_0/a_34_482#
+ VSUBS
Xnand2x1_pcell_0 nor2x1_pcell_0/a_34_482# m1_537_501# VSUBS nor2x1_pcell_0/w_87_786#
+ nand2x1_pcell
Xnor2x1_pcell_0 nor2x1_pcell_0/a_405_1059# nor2x1_pcell_0/a_34_482# VSUBS m1_537_501#
+ nor2x1_pcell_0/w_87_786# nor2x1_pcell
.ends

.subckt ao3x1_pcell
Xinvx1_pcell_0 invx1_pcell_0/a_34_482# m1_1201_501# invx1_pcell_0/w_n87_786# VSUBS
+ invx1_pcell
Xaoi3x1_pcell_0 invx1_pcell_0/w_n87_786# m1_1201_501# invx1_pcell_0/a_34_482# VSUBS
+ aoi3x1_pcell
.ends

****EOF - ao3x1_pcell.spice
****BOF - aoa4x1_pcell.spice

* NGSPICE file created from aoa4x1_pcell.ext - technology: sky130A

.subckt nmos_top a_84_92# a_0_0# a_54_62# VSUBS
X0 a_84_92# a_54_62# a_0_0# VSUBS sky130_fd_pr__nfet_01v8 ad=0.0597 pd=0.555 as=0.39 ps=2.96 w=3.01 l=0.15
.ends

.subckt pmos2 a_88_n400# a_144_n461# a_174_n400# a_262_n400# w_52_n436#
X0 a_262_n400# a_144_n461# a_174_n400# w_52_n436# sky130_fd_pr__pfet_01v8 ad=0.54 pd=4.54 as=0.29 ps=2.29 w=2 l=0.15
X1 a_174_n400# a_144_n461# a_88_n400# w_52_n436# sky130_fd_pr__pfet_01v8 ad=0.29 pd=2.29 as=0.56 ps=4.56 w=2 l=0.15
.ends

.subckt invx1_pcell a_34_482# a_155_381# w_n87_786# pmos2_0/VSUBS
Xnmos_top_0 a_206_1059# pmos2_0/VSUBS a_155_381# pmos2_0/VSUBS nmos_top
Xpmos2_0 w_n87_786# a_155_381# a_206_1059# w_n87_786# w_n87_786# pmos2
.ends

.subckt nmos_bottom a_56_54# a_86_84# a_0_0# VSUBS
X0 a_86_84# a_56_54# a_0_0# VSUBS sky130_fd_pr__nfet_01v8 ad=0.0597 pd=0.555 as=0.393 ps=2.99 w=3.01 l=0.15
.ends

.subckt nmos_top_trim1 a_86_92# a_56_62# a_0_0# VSUBS
X0 a_86_92# a_56_62# a_0_0# VSUBS sky130_fd_pr__nfet_01v8 ad=0.0597 pd=0.555 as=0.395 ps=2.97 w=3.01 l=0.15
.ends

.subckt nand2x1_pcell a_31_480# a_229_1059# pmos2_1/VSUBS a_168_375# w_87_786#
Xnmos_bottom_0 a_168_375# pmos2_1/VSUBS nmos_bottom_0/a_0_0# pmos2_1/VSUBS nmos_bottom
Xnmos_top_trim1_0 a_229_1059# a_362_382# nmos_bottom_0/a_0_0# pmos2_1/VSUBS nmos_top_trim1
Xpmos2_0 w_87_786# a_168_375# a_229_1059# w_87_786# w_87_786# pmos2
Xpmos2_1 w_87_786# a_362_382# a_229_1059# w_87_786# w_87_786# pmos2
.ends

.subckt pmos2_1 a_144_n460# a_262_n399# a_88_n399# w_52_n435# a_174_n399#
X0 a_174_n399# a_144_n460# a_88_n399# w_52_n435# sky130_fd_pr__pfet_01v8 ad=0.29 pd=2.29 as=0.56 ps=4.56 w=2 l=0.15
X1 a_262_n399# a_144_n460# a_174_n399# w_52_n435# sky130_fd_pr__pfet_01v8 ad=0.54 pd=4.54 as=0.29 ps=2.29 w=2 l=0.15
.ends

.subckt nmos_top_trim2 a_86_92# a_56_62# a_0_0# VSUBS
X0 a_86_92# a_56_62# a_0_0# VSUBS sky130_fd_pr__nfet_01v8 ad=0.06 pd=0.56 as=0.395 ps=2.97 w=3.01 l=0.15
.ends

.subckt nor2x1_pcell a_405_1059# a_34_482# pmos2_1_1/VSUBS a_168_375# w_87_786#
Xpmos2_1_0 a_168_375# a_317_1331# a_317_1331# w_87_786# w_87_786# pmos2_1
Xpmos2_1_1 a_362_382# a_317_1331# a_317_1331# w_87_786# a_405_1059# pmos2_1
Xnmos_top_trim1_1 a_405_1059# a_168_375# pmos2_1_1/VSUBS pmos2_1_1/VSUBS nmos_top_trim1
Xnmos_top_trim2_0 a_405_1059# a_362_382# pmos2_1_1/VSUBS pmos2_1_1/VSUBS nmos_top_trim2
.ends

.subckt aoai4x1_pcell nor2x1_pcell_0/w_87_786# nor2x1_pcell_0/a_34_482# nand2x1_pcell_1/a_229_1059#
+ VSUBS
Xnand2x1_pcell_0 nor2x1_pcell_0/a_34_482# m1_537_501# VSUBS nand2x1_pcell_0/a_168_375#
+ nor2x1_pcell_0/w_87_786# nand2x1_pcell
Xnor2x1_pcell_0 m1_1203_501# nor2x1_pcell_0/a_34_482# VSUBS m1_537_501# nor2x1_pcell_0/w_87_786#
+ nor2x1_pcell
Xnand2x1_pcell_1 nor2x1_pcell_0/a_34_482# nand2x1_pcell_1/a_229_1059# VSUBS m1_1203_501#
+ nor2x1_pcell_0/w_87_786# nand2x1_pcell
.ends

.subckt aoa4x1_pcell
Xinvx1_pcell_0 invx1_pcell_0/a_34_482# m1_1869_501# invx1_pcell_0/w_n87_786# VSUBS
+ invx1_pcell
Xaoai4x1_pcell_0 invx1_pcell_0/w_n87_786# invx1_pcell_0/a_34_482# m1_1869_501# VSUBS
+ aoai4x1_pcell
.ends

****EOF - aoa4x1_pcell.spice
****BOF - aoai4x1_pcell.spice

* NGSPICE file created from aoai4x1_pcell.ext - technology: sky130A

.subckt nmos_bottom a_56_54# a_86_84# a_0_0# VSUBS
X0 a_86_84# a_56_54# a_0_0# VSUBS sky130_fd_pr__nfet_01v8 ad=0.0597 pd=0.555 as=0.393 ps=2.99 w=3.01 l=0.15
.ends

.subckt nmos_top_trim1 a_86_92# a_56_62# a_0_0# VSUBS
X0 a_86_92# a_56_62# a_0_0# VSUBS sky130_fd_pr__nfet_01v8 ad=0.0597 pd=0.555 as=0.395 ps=2.97 w=3.01 l=0.15
.ends

.subckt pmos2 a_88_n400# a_144_n461# a_174_n400# a_262_n400# w_52_n436#
X0 a_262_n400# a_144_n461# a_174_n400# w_52_n436# sky130_fd_pr__pfet_01v8 ad=0.54 pd=4.54 as=0.29 ps=2.29 w=2 l=0.15
X1 a_174_n400# a_144_n461# a_88_n400# w_52_n436# sky130_fd_pr__pfet_01v8 ad=0.29 pd=2.29 as=0.56 ps=4.56 w=2 l=0.15
.ends

.subckt nand2x1_pcell a_31_480# a_229_1059# pmos2_1/VSUBS a_168_375# w_87_786#
Xnmos_bottom_0 a_168_375# pmos2_1/VSUBS nmos_bottom_0/a_0_0# pmos2_1/VSUBS nmos_bottom
Xnmos_top_trim1_0 a_229_1059# a_362_382# nmos_bottom_0/a_0_0# pmos2_1/VSUBS nmos_top_trim1
Xpmos2_0 w_87_786# a_168_375# a_229_1059# w_87_786# w_87_786# pmos2
Xpmos2_1 w_87_786# a_362_382# a_229_1059# w_87_786# w_87_786# pmos2
.ends

.subckt pmos2_1 a_144_n460# a_262_n399# a_88_n399# w_52_n435# a_174_n399#
X0 a_174_n399# a_144_n460# a_88_n399# w_52_n435# sky130_fd_pr__pfet_01v8 ad=0.29 pd=2.29 as=0.56 ps=4.56 w=2 l=0.15
X1 a_262_n399# a_144_n460# a_174_n399# w_52_n435# sky130_fd_pr__pfet_01v8 ad=0.54 pd=4.54 as=0.29 ps=2.29 w=2 l=0.15
.ends

.subckt nmos_top_trim2 a_86_92# a_56_62# a_0_0# VSUBS
X0 a_86_92# a_56_62# a_0_0# VSUBS sky130_fd_pr__nfet_01v8 ad=0.06 pd=0.56 as=0.395 ps=2.97 w=3.01 l=0.15
.ends

.subckt nor2x1_pcell a_405_1059# a_34_482# pmos2_1_1/VSUBS a_168_375# w_87_786#
Xpmos2_1_0 a_168_375# a_317_1331# a_317_1331# w_87_786# w_87_786# pmos2_1
Xpmos2_1_1 a_362_382# a_317_1331# a_317_1331# w_87_786# a_405_1059# pmos2_1
Xnmos_top_trim1_1 a_405_1059# a_168_375# pmos2_1_1/VSUBS pmos2_1_1/VSUBS nmos_top_trim1
Xnmos_top_trim2_0 a_405_1059# a_362_382# pmos2_1_1/VSUBS pmos2_1_1/VSUBS nmos_top_trim2
.ends

.subckt aoai4x1_pcell
Xnand2x1_pcell_0 nor2x1_pcell_0/a_34_482# m1_537_501# VSUBS nand2x1_pcell_0/a_168_375#
+ nor2x1_pcell_0/w_87_786# nand2x1_pcell
Xnor2x1_pcell_0 m1_1203_501# nor2x1_pcell_0/a_34_482# VSUBS m1_537_501# nor2x1_pcell_0/w_87_786#
+ nor2x1_pcell
Xnand2x1_pcell_1 nor2x1_pcell_0/a_34_482# nand2x1_pcell_1/a_229_1059# VSUBS m1_1203_501#
+ nor2x1_pcell_0/w_87_786# nand2x1_pcell
.ends

****EOF - aoai4x1_pcell.spice
****BOF - aoi3x1_pcell.spice

* NGSPICE file created from aoi3x1_pcell.ext - technology: sky130A

.subckt nmos_bottom a_56_54# a_86_84# a_0_0# VSUBS
X0 a_86_84# a_56_54# a_0_0# VSUBS sky130_fd_pr__nfet_01v8 ad=0.0597 pd=0.555 as=0.393 ps=2.99 w=3.01 l=0.15
.ends

.subckt nmos_top_trim1 a_86_92# a_56_62# a_0_0# VSUBS
X0 a_86_92# a_56_62# a_0_0# VSUBS sky130_fd_pr__nfet_01v8 ad=0.0597 pd=0.555 as=0.395 ps=2.97 w=3.01 l=0.15
.ends

.subckt pmos2 a_88_n400# a_144_n461# a_174_n400# a_262_n400# w_52_n436#
X0 a_262_n400# a_144_n461# a_174_n400# w_52_n436# sky130_fd_pr__pfet_01v8 ad=0.54 pd=4.54 as=0.29 ps=2.29 w=2 l=0.15
X1 a_174_n400# a_144_n461# a_88_n400# w_52_n436# sky130_fd_pr__pfet_01v8 ad=0.29 pd=2.29 as=0.56 ps=4.56 w=2 l=0.15
.ends

.subckt nand2x1_pcell a_31_480# a_229_1059# pmos2_1/VSUBS w_87_786#
Xnmos_bottom_0 a_168_375# pmos2_1/VSUBS nmos_bottom_0/a_0_0# pmos2_1/VSUBS nmos_bottom
Xnmos_top_trim1_0 a_229_1059# a_362_382# nmos_bottom_0/a_0_0# pmos2_1/VSUBS nmos_top_trim1
Xpmos2_0 w_87_786# a_168_375# a_229_1059# w_87_786# w_87_786# pmos2
Xpmos2_1 w_87_786# a_362_382# a_229_1059# w_87_786# w_87_786# pmos2
.ends

.subckt pmos2_1 a_144_n460# a_262_n399# a_88_n399# w_52_n435# a_174_n399#
X0 a_174_n399# a_144_n460# a_88_n399# w_52_n435# sky130_fd_pr__pfet_01v8 ad=0.29 pd=2.29 as=0.56 ps=4.56 w=2 l=0.15
X1 a_262_n399# a_144_n460# a_174_n399# w_52_n435# sky130_fd_pr__pfet_01v8 ad=0.54 pd=4.54 as=0.29 ps=2.29 w=2 l=0.15
.ends

.subckt nmos_top_trim2 a_86_92# a_56_62# a_0_0# VSUBS
X0 a_86_92# a_56_62# a_0_0# VSUBS sky130_fd_pr__nfet_01v8 ad=0.06 pd=0.56 as=0.395 ps=2.97 w=3.01 l=0.15
.ends

.subckt nor2x1_pcell a_34_482# pmos2_1_1/VSUBS a_168_375# w_87_786#
Xpmos2_1_0 a_168_375# a_317_1331# a_317_1331# w_87_786# w_87_786# pmos2_1
Xpmos2_1_1 a_362_382# a_317_1331# a_317_1331# w_87_786# a_405_1059# pmos2_1
Xnmos_top_trim1_1 a_405_1059# a_168_375# pmos2_1_1/VSUBS pmos2_1_1/VSUBS nmos_top_trim1
Xnmos_top_trim2_0 a_405_1059# a_362_382# pmos2_1_1/VSUBS pmos2_1_1/VSUBS nmos_top_trim2
.ends

.subckt aoi3x1_pcell
Xnand2x1_pcell_0 nor2x1_pcell_0/a_34_482# m1_537_501# VSUBS nor2x1_pcell_0/w_87_786#
+ nand2x1_pcell
Xnor2x1_pcell_0 nor2x1_pcell_0/a_34_482# VSUBS m1_537_501# nor2x1_pcell_0/w_87_786#
+ nor2x1_pcell
.ends

****EOF - aoi3x1_pcell.spice
****BOF - bufx1.spice

* NGSPICE file created from bufx1.ext - technology: sky130A

.subckt nmos_top a_84_92# a_0_0# a_54_62# VSUBS
X0 a_84_92# a_54_62# a_0_0# VSUBS sky130_fd_pr__nfet_01v8 ad=0.0597 pd=0.555 as=0.39 ps=2.96 w=3.01 l=0.15
.ends

.subckt pmos2 a_88_n400# a_144_n461# a_174_n400# a_262_n400# w_52_n436#
X0 a_262_n400# a_144_n461# a_174_n400# w_52_n436# sky130_fd_pr__pfet_01v8 ad=0.54 pd=4.54 as=0.29 ps=2.29 w=2 l=0.15
X1 a_174_n400# a_144_n461# a_88_n400# w_52_n436# sky130_fd_pr__pfet_01v8 ad=0.29 pd=2.29 as=0.56 ps=4.56 w=2 l=0.15
.ends

.subckt invx1_pcell a_34_482# a_155_381# a_206_1059# w_n87_786# pmos2_0/VSUBS
Xnmos_top_0 a_206_1059# pmos2_0/VSUBS a_155_381# pmos2_0/VSUBS nmos_top
Xpmos2_0 w_n87_786# a_155_381# a_206_1059# w_n87_786# w_n87_786# pmos2
.ends

.subckt bufx1
Xinvx1_pcell_0 invx1_pcell_1/a_34_482# invx1_pcell_0/a_155_381# m1_315_501# invx1_pcell_1/w_n87_786#
+ VSUBS invx1_pcell
Xinvx1_pcell_1 invx1_pcell_1/a_34_482# m1_315_501# invx1_pcell_1/a_206_1059# invx1_pcell_1/w_n87_786#
+ VSUBS invx1_pcell
.ends

****EOF - bufx1.spice
****BOF - dffrnx1_pcell.spice

* NGSPICE file created from dffrnx1_pcell.ext - technology: sky130A

.subckt nmos_bottom a_56_54# a_86_84# a_0_0# VSUBS
X0 a_86_84# a_56_54# a_0_0# VSUBS sky130_fd_pr__nfet_01v8 ad=0.0597 pd=0.555 as=0.393 ps=2.99 w=3.01 l=0.15
.ends

.subckt nmos_top_trim1 a_86_92# a_56_62# a_0_0# VSUBS
X0 a_86_92# a_56_62# a_0_0# VSUBS sky130_fd_pr__nfet_01v8 ad=0.0597 pd=0.555 as=0.395 ps=2.97 w=3.01 l=0.15
.ends

.subckt nmos_side_left a_87_91# a_0_0# a_57_61# VSUBS
X0 a_87_91# a_57_61# a_0_0# VSUBS sky130_fd_pr__nfet_01v8 ad=0.0545 pd=0.53 as=0.404 ps=3.02 w=3 l=0.15
.ends

.subckt pmos2 a_88_n400# a_144_n461# a_174_n400# a_262_n400# w_52_n436#
X0 a_262_n400# a_144_n461# a_174_n400# w_52_n436# sky130_fd_pr__pfet_01v8 ad=0.54 pd=4.54 as=0.29 ps=2.29 w=2 l=0.15
X1 a_174_n400# a_144_n461# a_88_n400# w_52_n436# sky130_fd_pr__pfet_01v8 ad=0.29 pd=2.29 as=0.56 ps=4.56 w=2 l=0.15
.ends

.subckt nand3x1_pcell a_34_482# a_447_377# li_649_449# a_289_1059# w_87_786# pmos2_2/VSUBS
+ a_147_377#
Xnmos_bottom_0 a_147_377# pmos2_2/VSUBS nmos_bottom_0/a_0_0# pmos2_2/VSUBS nmos_bottom
Xnmos_top_trim1_0 a_289_1059# li_649_449# li_393_182# pmos2_2/VSUBS nmos_top_trim1
Xnmos_side_left_0 li_393_182# nmos_bottom_0/a_0_0# a_447_377# pmos2_2/VSUBS nmos_side_left
Xpmos2_0 w_87_786# a_147_377# a_289_1059# w_87_786# w_87_786# pmos2
Xpmos2_1 w_87_786# a_447_377# a_289_1059# w_87_786# w_87_786# pmos2
Xpmos2_2 w_87_786# li_649_449# a_289_1059# w_87_786# w_87_786# pmos2
.ends

.subckt nand2x1_pcell a_31_480# a_362_382# a_229_1059# pmos2_1/VSUBS a_168_375# w_87_786#
Xnmos_bottom_0 a_168_375# pmos2_1/VSUBS nmos_bottom_0/a_0_0# pmos2_1/VSUBS nmos_bottom
Xnmos_top_trim1_0 a_229_1059# a_362_382# nmos_bottom_0/a_0_0# pmos2_1/VSUBS nmos_top_trim1
Xpmos2_0 w_87_786# a_168_375# a_229_1059# w_87_786# w_87_786# pmos2
Xpmos2_1 w_87_786# a_362_382# a_229_1059# w_87_786# w_87_786# pmos2
.ends

.subckt dffrnx1_pcell
Xnand3x1_pcell_0 nand3x1_pcell_4/a_34_482# m1_426_871# m1_689_649# m1_867_723# nand3x1_pcell_4/w_87_786#
+ VSUBS m1_241_797# nand3x1_pcell
Xnand3x1_pcell_1 nand3x1_pcell_4/a_34_482# nand3x1_pcell_1/a_447_377# m1_1607_427#
+ m1_689_649# nand3x1_pcell_4/w_87_786# VSUBS m1_867_723# nand3x1_pcell
Xnand3x1_pcell_3 nand3x1_pcell_4/a_34_482# m1_426_871# m1_1607_427# m1_241_797# nand3x1_pcell_4/w_87_786#
+ VSUBS m1_2461_649# nand3x1_pcell
Xnand3x1_pcell_4 nand3x1_pcell_4/a_34_482# m1_1607_427# nand3x1_pcell_4/li_649_449#
+ nand3x1_pcell_4/a_289_1059# nand3x1_pcell_4/w_87_786# VSUBS m1_867_723# nand3x1_pcell
Xnand2x1_pcell_0 nand3x1_pcell_4/a_34_482# m1_241_797# m1_2461_649# VSUBS m1_689_649#
+ nand3x1_pcell_4/w_87_786# nand2x1_pcell
Xnand2x1_pcell_1 nand3x1_pcell_4/a_34_482# m1_241_797# nand2x1_pcell_1/a_229_1059#
+ VSUBS nand2x1_pcell_1/a_168_375# nand3x1_pcell_4/w_87_786# nand2x1_pcell
.ends

****EOF - dffrnx1_pcell.spice
****BOF - dffsnrnx1_pcell.spice

* NGSPICE file created from dffsnrnx1_pcell.ext - technology: sky130A

.subckt nmos_bottom a_56_54# a_86_84# a_0_0# VSUBS
X0 a_86_84# a_56_54# a_0_0# VSUBS sky130_fd_pr__nfet_01v8 ad=0.0597 pd=0.555 as=0.393 ps=2.99 w=3.01 l=0.15
.ends

.subckt nmos_top_trim1 a_86_92# a_56_62# a_0_0# VSUBS
X0 a_86_92# a_56_62# a_0_0# VSUBS sky130_fd_pr__nfet_01v8 ad=0.0597 pd=0.555 as=0.395 ps=2.97 w=3.01 l=0.15
.ends

.subckt nmos_side_left a_87_91# a_0_0# a_57_61# VSUBS
X0 a_87_91# a_57_61# a_0_0# VSUBS sky130_fd_pr__nfet_01v8 ad=0.0545 pd=0.53 as=0.404 ps=3.02 w=3 l=0.15
.ends

.subckt pmos2 a_88_n400# a_144_n461# a_174_n400# a_262_n400# w_52_n436#
X0 a_262_n400# a_144_n461# a_174_n400# w_52_n436# sky130_fd_pr__pfet_01v8 ad=0.54 pd=4.54 as=0.29 ps=2.29 w=2 l=0.15
X1 a_174_n400# a_144_n461# a_88_n400# w_52_n436# sky130_fd_pr__pfet_01v8 ad=0.29 pd=2.29 as=0.56 ps=4.56 w=2 l=0.15
.ends

.subckt nand3x1_pcell a_34_482# a_447_377# li_649_449# a_289_1059# a_147_377# pmos2_2/VSUBS
+ w_87_786#
Xnmos_bottom_0 a_147_377# pmos2_2/VSUBS nmos_bottom_0/a_0_0# pmos2_2/VSUBS nmos_bottom
Xnmos_top_trim1_0 a_289_1059# li_649_449# li_393_182# pmos2_2/VSUBS nmos_top_trim1
Xnmos_side_left_0 li_393_182# nmos_bottom_0/a_0_0# a_447_377# pmos2_2/VSUBS nmos_side_left
Xpmos2_0 w_87_786# a_147_377# a_289_1059# w_87_786# w_87_786# pmos2
Xpmos2_1 w_87_786# a_447_377# a_289_1059# w_87_786# w_87_786# pmos2
Xpmos2_2 w_87_786# li_649_449# a_289_1059# w_87_786# w_87_786# pmos2
.ends

.subckt dffsnrnx1_pcell
Xnand3x1_pcell_0 VSUBS m1_426_427# m1_716_649# m1_831_501# nand3x1_pcell_0/a_147_377#
+ VSUBS nand3x1_pcell_5/w_87_786# nand3x1_pcell
Xnand3x1_pcell_1 VSUBS m1_1377_871# m1_1660_723# m1_716_649# m1_831_501# VSUBS nand3x1_pcell_5/w_87_786#
+ nand3x1_pcell
Xnand3x1_pcell_2 VSUBS m1_2351_575# m1_1660_723# m1_2757_501# m1_831_501# VSUBS nand3x1_pcell_5/w_87_786#
+ nand3x1_pcell
Xnand3x1_pcell_3 VSUBS m1_1377_871# m1_426_427# m1_1660_723# m1_2757_501# VSUBS nand3x1_pcell_5/w_87_786#
+ nand3x1_pcell
Xnand3x1_pcell_4 VSUBS m1_426_427# nand3x1_pcell_4/li_649_449# nand3x1_pcell_4/a_289_1059#
+ m1_716_649# VSUBS nand3x1_pcell_5/w_87_786# nand3x1_pcell
Xnand3x1_pcell_5 VSUBS m1_2351_575# m1_1660_723# nand3x1_pcell_5/a_289_1059# nand3x1_pcell_5/a_147_377#
+ VSUBS nand3x1_pcell_5/w_87_786# nand3x1_pcell
.ends

****EOF - dffsnrnx1_pcell.spice
****BOF - dffsnx1_pcell.spice

* NGSPICE file created from dffsnx1_pcell.ext - technology: sky130A

.subckt nmos_bottom a_56_54# a_86_84# a_0_0# VSUBS
X0 a_86_84# a_56_54# a_0_0# VSUBS sky130_fd_pr__nfet_01v8 ad=0.0597 pd=0.555 as=0.393 ps=2.99 w=3.01 l=0.15
.ends

.subckt nmos_top_trim1 a_86_92# a_56_62# a_0_0# VSUBS
X0 a_86_92# a_56_62# a_0_0# VSUBS sky130_fd_pr__nfet_01v8 ad=0.0597 pd=0.555 as=0.395 ps=2.97 w=3.01 l=0.15
.ends

.subckt pmos2 a_88_n400# a_144_n461# a_174_n400# a_262_n400# w_52_n436#
X0 a_262_n400# a_144_n461# a_174_n400# w_52_n436# sky130_fd_pr__pfet_01v8 ad=0.54 pd=4.54 as=0.29 ps=2.29 w=2 l=0.15
X1 a_174_n400# a_144_n461# a_88_n400# w_52_n436# sky130_fd_pr__pfet_01v8 ad=0.29 pd=2.29 as=0.56 ps=4.56 w=2 l=0.15
.ends

.subckt nand2x1_pcell a_31_480# a_362_382# a_229_1059# pmos2_1/VSUBS a_168_375# w_87_786#
Xnmos_bottom_0 a_168_375# pmos2_1/VSUBS nmos_bottom_0/a_0_0# pmos2_1/VSUBS nmos_bottom
Xnmos_top_trim1_0 a_229_1059# a_362_382# nmos_bottom_0/a_0_0# pmos2_1/VSUBS nmos_top_trim1
Xpmos2_0 w_87_786# a_168_375# a_229_1059# w_87_786# w_87_786# pmos2
Xpmos2_1 w_87_786# a_362_382# a_229_1059# w_87_786# w_87_786# pmos2
.ends

.subckt nmos_side_left a_87_91# a_0_0# a_57_61# VSUBS
X0 a_87_91# a_57_61# a_0_0# VSUBS sky130_fd_pr__nfet_01v8 ad=0.0545 pd=0.53 as=0.404 ps=3.02 w=3 l=0.15
.ends

.subckt nand3x1_pcell a_34_482# a_447_377# li_649_449# a_289_1059# pmos2_2/VSUBS a_147_377#
+ w_87_786#
Xnmos_bottom_0 a_147_377# pmos2_2/VSUBS nmos_bottom_0/a_0_0# pmos2_2/VSUBS nmos_bottom
Xnmos_top_trim1_0 a_289_1059# li_649_449# li_393_182# pmos2_2/VSUBS nmos_top_trim1
Xnmos_side_left_0 li_393_182# nmos_bottom_0/a_0_0# a_447_377# pmos2_2/VSUBS nmos_side_left
Xpmos2_0 w_87_786# a_147_377# a_289_1059# w_87_786# w_87_786# pmos2
Xpmos2_1 w_87_786# a_447_377# a_289_1059# w_87_786# w_87_786# pmos2
Xpmos2_2 w_87_786# li_649_449# a_289_1059# w_87_786# w_87_786# pmos2
.ends

.subckt dffsnx1_pcell
Xnand2x1_pcell_2 nand3x1_pcell_2/a_34_482# nand2x1_pcell_2/a_362_382# nand2x1_pcell_2/a_229_1059#
+ VSUBS m1_406_797# nand3x1_pcell_2/w_87_786# nand2x1_pcell
Xnand2x1_pcell_5 nand3x1_pcell_2/a_34_482# m1_406_797# m1_537_501# VSUBS nand2x1_pcell_5/a_168_375#
+ nand3x1_pcell_2/w_87_786# nand2x1_pcell
Xnand3x1_pcell_0 nand3x1_pcell_2/a_34_482# m1_1093_871# m1_1351_723# m1_406_797# VSUBS
+ m1_537_501# nand3x1_pcell_2/w_87_786# nand3x1_pcell
Xnand3x1_pcell_1 nand3x1_pcell_2/a_34_482# m1_2055_427# m1_1351_723# nand3x1_pcell_1/a_289_1059#
+ VSUBS nand3x1_pcell_1/a_147_377# nand3x1_pcell_2/w_87_786# nand3x1_pcell
Xnand3x1_pcell_2 nand3x1_pcell_2/a_34_482# m1_2055_427# m1_1351_723# m1_2461_501#
+ VSUBS m1_537_501# nand3x1_pcell_2/w_87_786# nand3x1_pcell
Xnand2x1_pcell_0 nand3x1_pcell_2/a_34_482# m1_1093_871# m1_1351_723# VSUBS m1_2461_501#
+ nand3x1_pcell_2/w_87_786# nand2x1_pcell
.ends

****EOF - dffsnx1_pcell.spice
****BOF - dffx1_pcell.spice

* NGSPICE file created from dffx1_pcell.ext - technology: sky130A

.subckt nmos_bottom a_56_54# a_86_84# a_0_0# VSUBS
X0 a_86_84# a_56_54# a_0_0# VSUBS sky130_fd_pr__nfet_01v8 ad=0.0597 pd=0.555 as=0.393 ps=2.99 w=3.01 l=0.15
.ends

.subckt nmos_top_trim1 a_86_92# a_56_62# a_0_0# VSUBS
X0 a_86_92# a_56_62# a_0_0# VSUBS sky130_fd_pr__nfet_01v8 ad=0.0597 pd=0.555 as=0.395 ps=2.97 w=3.01 l=0.15
.ends

.subckt pmos2 a_88_n400# a_144_n461# a_174_n400# a_262_n400# w_52_n436#
X0 a_262_n400# a_144_n461# a_174_n400# w_52_n436# sky130_fd_pr__pfet_01v8 ad=0.54 pd=4.54 as=0.29 ps=2.29 w=2 l=0.15
X1 a_174_n400# a_144_n461# a_88_n400# w_52_n436# sky130_fd_pr__pfet_01v8 ad=0.29 pd=2.29 as=0.56 ps=4.56 w=2 l=0.15
.ends

.subckt nand2x1_pcell a_31_480# a_362_382# a_229_1059# pmos2_1/VSUBS a_168_375# w_87_786#
Xnmos_bottom_0 a_168_375# pmos2_1/VSUBS nmos_bottom_0/a_0_0# pmos2_1/VSUBS nmos_bottom
Xnmos_top_trim1_0 a_229_1059# a_362_382# nmos_bottom_0/a_0_0# pmos2_1/VSUBS nmos_top_trim1
Xpmos2_0 w_87_786# a_168_375# a_229_1059# w_87_786# w_87_786# pmos2
Xpmos2_1 w_87_786# a_362_382# a_229_1059# w_87_786# w_87_786# pmos2
.ends

.subckt nmos_side_left a_87_91# a_0_0# a_57_61# VSUBS
X0 a_87_91# a_57_61# a_0_0# VSUBS sky130_fd_pr__nfet_01v8 ad=0.0545 pd=0.53 as=0.404 ps=3.02 w=3 l=0.15
.ends

.subckt nand3x1_pcell a_34_482# a_447_377# li_649_449# a_289_1059# w_87_786# pmos2_2/VSUBS
+ a_147_377#
Xnmos_bottom_0 a_147_377# pmos2_2/VSUBS nmos_bottom_0/a_0_0# pmos2_2/VSUBS nmos_bottom
Xnmos_top_trim1_0 a_289_1059# li_649_449# li_393_182# pmos2_2/VSUBS nmos_top_trim1
Xnmos_side_left_0 li_393_182# nmos_bottom_0/a_0_0# a_447_377# pmos2_2/VSUBS nmos_side_left
Xpmos2_0 w_87_786# a_147_377# a_289_1059# w_87_786# w_87_786# pmos2
Xpmos2_1 w_87_786# a_447_377# a_289_1059# w_87_786# w_87_786# pmos2
Xpmos2_2 w_87_786# li_649_449# a_289_1059# w_87_786# w_87_786# pmos2
.ends

.subckt dffx1_pcell
Xnand2x1_pcell_2 nand3x1_pcell_0/a_34_482# m1_427_871# m1_258_797# VSUBS m1_2165_649#
+ nand3x1_pcell_0/w_87_786# nand2x1_pcell
Xnand2x1_pcell_3 nand3x1_pcell_0/a_34_482# nand2x1_pcell_3/a_362_382# nand2x1_pcell_3/a_229_1059#
+ VSUBS m1_833_723# nand3x1_pcell_0/w_87_786# nand2x1_pcell
Xnand2x1_pcell_4 nand3x1_pcell_0/a_34_482# m1_258_797# nand2x1_pcell_4/a_229_1059#
+ VSUBS nand2x1_pcell_4/a_168_375# nand3x1_pcell_0/w_87_786# nand2x1_pcell
Xnand3x1_pcell_0 nand3x1_pcell_0/a_34_482# m1_427_871# m1_685_649# m1_833_723# nand3x1_pcell_0/w_87_786#
+ VSUBS m1_258_797# nand3x1_pcell
Xnand2x1_pcell_0 nand3x1_pcell_0/a_34_482# nand2x1_pcell_0/a_362_382# m1_685_649#
+ VSUBS m1_833_723# nand3x1_pcell_0/w_87_786# nand2x1_pcell
Xnand2x1_pcell_1 nand3x1_pcell_0/a_34_482# m1_258_797# m1_2165_649# VSUBS m1_685_649#
+ nand3x1_pcell_0/w_87_786# nand2x1_pcell
.ends

****EOF - dffx1_pcell.spice
****BOF - diff_ring_side.spice

* NGSPICE file created from diff_ring_side.ext - technology: sky130A

* Top level circuit diff_ring_side

.end

****EOF - diff_ring_side.spice
****BOF - inv.spice

* NGSPICE file created from inv.ext - technology: sky130A

.subckt inv Y A GND VDD
X0 Y A a_n73_n41# a_n73_n41# sky130_fd_pr__nfet_01v8 ad=0.128 pd=1.45 as=0.153 ps=1.57 w=0.42 l=0.15
X1 Y A w_n100_161# w_n100_161# sky130_fd_pr__pfet_01v8 ad=0.12 pd=1.41 as=0.12 ps=1.41 w=0.42 l=0.15
.ends

****EOF - inv.spice
****BOF - invx1_pcell.spice

* NGSPICE file created from invx1_pcell.ext - technology: sky130A

.subckt nmos_top a_84_92# a_0_0# a_54_62# VSUBS
X0 a_84_92# a_54_62# a_0_0# VSUBS sky130_fd_pr__nfet_01v8 ad=0.0597 pd=0.555 as=0.39 ps=2.96 w=3.01 l=0.15
.ends

.subckt pmos2 a_88_n400# a_144_n461# a_174_n400# a_262_n400# w_52_n436#
X0 a_262_n400# a_144_n461# a_174_n400# w_52_n436# sky130_fd_pr__pfet_01v8 ad=0.54 pd=4.54 as=0.29 ps=2.29 w=2 l=0.15
X1 a_174_n400# a_144_n461# a_88_n400# w_52_n436# sky130_fd_pr__pfet_01v8 ad=0.29 pd=2.29 as=0.56 ps=4.56 w=2 l=0.15
.ends

.subckt invx1_pcell
Xnmos_top_0 a_206_1059# pmos2_0/VSUBS a_155_381# pmos2_0/VSUBS nmos_top
Xpmos2_0 w_n87_786# a_155_381# a_206_1059# w_n87_786# w_n87_786# pmos2
.ends

****EOF - invx1_pcell.spice
****BOF - li1_M1_contact.spice

* NGSPICE file created from li1_M1_contact.ext - technology: sky130A

* Top level circuit li1_M1_contact

.end

****EOF - li1_M1_contact.spice
****BOF - mux2x1_pcell.spice

* NGSPICE file created from mux2x1_pcell.ext - technology: sky130A

.subckt nmos_bottom a_56_54# a_86_84# a_0_0# VSUBS
X0 a_86_84# a_56_54# a_0_0# VSUBS sky130_fd_pr__nfet_01v8 ad=0.0597 pd=0.555 as=0.393 ps=2.99 w=3.01 l=0.15
.ends

.subckt nmos_top_trim1 a_86_92# a_56_62# a_0_0# VSUBS
X0 a_86_92# a_56_62# a_0_0# VSUBS sky130_fd_pr__nfet_01v8 ad=0.0597 pd=0.555 as=0.395 ps=2.97 w=3.01 l=0.15
.ends

.subckt pmos2 a_88_n400# a_144_n461# a_174_n400# a_262_n400# w_52_n436#
X0 a_262_n400# a_144_n461# a_174_n400# w_52_n436# sky130_fd_pr__pfet_01v8 ad=0.54 pd=4.54 as=0.29 ps=2.29 w=2 l=0.15
X1 a_174_n400# a_144_n461# a_88_n400# w_52_n436# sky130_fd_pr__pfet_01v8 ad=0.29 pd=2.29 as=0.56 ps=4.56 w=2 l=0.15
.ends

.subckt nand2x1_pcell a_31_480# a_362_382# a_229_1059# pmos2_1/VSUBS a_168_375# w_87_786#
Xnmos_bottom_0 a_168_375# pmos2_1/VSUBS nmos_bottom_0/a_0_0# pmos2_1/VSUBS nmos_bottom
Xnmos_top_trim1_0 a_229_1059# a_362_382# nmos_bottom_0/a_0_0# pmos2_1/VSUBS nmos_top_trim1
Xpmos2_0 w_87_786# a_168_375# a_229_1059# w_87_786# w_87_786# pmos2
Xpmos2_1 w_87_786# a_362_382# a_229_1059# w_87_786# w_87_786# pmos2
.ends

.subckt nmos_top a_84_92# a_0_0# a_54_62# VSUBS
X0 a_84_92# a_54_62# a_0_0# VSUBS sky130_fd_pr__nfet_01v8 ad=0.0597 pd=0.555 as=0.39 ps=2.96 w=3.01 l=0.15
.ends

.subckt invx1_pcell a_34_482# a_155_381# a_206_1059# w_n87_786# pmos2_0/VSUBS
Xnmos_top_0 a_206_1059# pmos2_0/VSUBS a_155_381# pmos2_0/VSUBS nmos_top
Xpmos2_0 w_n87_786# a_155_381# a_206_1059# w_n87_786# w_n87_786# pmos2
.ends

.subckt mux2x1_pcell
Xnand2x1_pcell_2 invx1_pcell_0/a_34_482# m1_1647_649# nand2x1_pcell_2/a_229_1059#
+ VSUBS m1_981_575# invx1_pcell_0/w_n87_786# nand2x1_pcell
Xinvx1_pcell_0 invx1_pcell_0/a_34_482# m1_120_575# m1_315_649# invx1_pcell_0/w_n87_786#
+ VSUBS invx1_pcell
Xnand2x1_pcell_0 invx1_pcell_0/a_34_482# nand2x1_pcell_0/a_362_382# m1_981_575# VSUBS
+ m1_120_575# invx1_pcell_0/w_n87_786# nand2x1_pcell
Xnand2x1_pcell_1 invx1_pcell_0/a_34_482# nand2x1_pcell_1/a_362_382# m1_1647_649# VSUBS
+ m1_315_649# invx1_pcell_0/w_n87_786# nand2x1_pcell
.ends

****EOF - mux2x1_pcell.spice
****BOF - nand2x1_pcell.spice

* NGSPICE file created from nand2x1_pcell.ext - technology: sky130A

.subckt nmos_bottom a_56_54# a_86_84# a_0_0# VSUBS
X0 a_86_84# a_56_54# a_0_0# VSUBS sky130_fd_pr__nfet_01v8 ad=0.0597 pd=0.555 as=0.393 ps=2.99 w=3.01 l=0.15
.ends

.subckt nmos_top_trim1 a_86_92# a_56_62# a_0_0# VSUBS
X0 a_86_92# a_56_62# a_0_0# VSUBS sky130_fd_pr__nfet_01v8 ad=0.0597 pd=0.555 as=0.395 ps=2.97 w=3.01 l=0.15
.ends

.subckt pmos2 a_88_n400# a_144_n461# a_174_n400# a_262_n400# w_52_n436#
X0 a_262_n400# a_144_n461# a_174_n400# w_52_n436# sky130_fd_pr__pfet_01v8 ad=0.54 pd=4.54 as=0.29 ps=2.29 w=2 l=0.15
X1 a_174_n400# a_144_n461# a_88_n400# w_52_n436# sky130_fd_pr__pfet_01v8 ad=0.29 pd=2.29 as=0.56 ps=4.56 w=2 l=0.15
.ends

.subckt nand2x1_pcell
Xnmos_bottom_0 a_168_375# pmos2_1/VSUBS nmos_bottom_0/a_0_0# pmos2_1/VSUBS nmos_bottom
Xnmos_top_trim1_0 a_229_1059# a_362_382# nmos_bottom_0/a_0_0# pmos2_1/VSUBS nmos_top_trim1
Xpmos2_0 w_87_786# a_168_375# a_229_1059# w_87_786# w_87_786# pmos2
Xpmos2_1 w_87_786# a_362_382# a_229_1059# w_87_786# w_87_786# pmos2
.ends

****EOF - nand2x1_pcell.spice
****BOF - nand3x1_pcell.spice

* NGSPICE file created from nand3x1_pcell.ext - technology: sky130A

.subckt nmos_bottom a_56_54# a_86_84# a_0_0# VSUBS
X0 a_86_84# a_56_54# a_0_0# VSUBS sky130_fd_pr__nfet_01v8 ad=0.0597 pd=0.555 as=0.393 ps=2.99 w=3.01 l=0.15
.ends

.subckt nmos_top_trim1 a_86_92# a_56_62# a_0_0# VSUBS
X0 a_86_92# a_56_62# a_0_0# VSUBS sky130_fd_pr__nfet_01v8 ad=0.0597 pd=0.555 as=0.395 ps=2.97 w=3.01 l=0.15
.ends

.subckt nmos_side_left a_87_91# a_0_0# a_57_61# VSUBS
X0 a_87_91# a_57_61# a_0_0# VSUBS sky130_fd_pr__nfet_01v8 ad=0.0545 pd=0.53 as=0.404 ps=3.02 w=3 l=0.15
.ends

.subckt pmos2 a_88_n400# a_144_n461# a_174_n400# a_262_n400# w_52_n436#
X0 a_262_n400# a_144_n461# a_174_n400# w_52_n436# sky130_fd_pr__pfet_01v8 ad=0.54 pd=4.54 as=0.29 ps=2.29 w=2 l=0.15
X1 a_174_n400# a_144_n461# a_88_n400# w_52_n436# sky130_fd_pr__pfet_01v8 ad=0.29 pd=2.29 as=0.56 ps=4.56 w=2 l=0.15
.ends

.subckt nand3x1_pcell
Xnmos_bottom_0 a_147_377# pmos2_2/VSUBS nmos_bottom_0/a_0_0# pmos2_2/VSUBS nmos_bottom
Xnmos_top_trim1_0 a_289_1059# li_649_449# li_393_182# pmos2_2/VSUBS nmos_top_trim1
Xnmos_side_left_0 li_393_182# nmos_bottom_0/a_0_0# a_447_377# pmos2_2/VSUBS nmos_side_left
Xpmos2_0 w_87_786# a_147_377# a_289_1059# w_87_786# w_87_786# pmos2
Xpmos2_1 w_87_786# a_447_377# a_289_1059# w_87_786# w_87_786# pmos2
Xpmos2_2 w_87_786# li_649_449# a_289_1059# w_87_786# w_87_786# pmos2
.ends

****EOF - nand3x1_pcell.spice
****BOF - nmos_bottom.spice

* NGSPICE file created from nmos_bottom.ext - technology: sky130A

.subckt nmos_bottom
X0 a_86_84# a_56_54# a_0_0# VSUBS sky130_fd_pr__nfet_01v8 ad=0.0597 pd=0.555 as=0.393 ps=2.99 w=3.01 l=0.15
.ends

****EOF - nmos_bottom.spice
****BOF - nmos_side_left.spice

* NGSPICE file created from nmos_side_left.ext - technology: sky130A

.subckt nmos_side_left
X0 a_87_91# a_57_61# a_0_0# VSUBS sky130_fd_pr__nfet_01v8 ad=0.0545 pd=0.53 as=0.404 ps=3.02 w=3 l=0.15
.ends

****EOF - nmos_side_left.spice
****BOF - nmos_side_right.spice

* NGSPICE file created from nmos_side_right.ext - technology: sky130A

.subckt nmos_side_right
X0 a_87_91# a_57_61# a_0_0# VSUBS sky130_fd_pr__nfet_01v8 ad=0.0545 pd=0.53 as=0.404 ps=3.02 w=3 l=0.15
.ends

****EOF - nmos_side_right.spice
****BOF - nmos_top.spice

* NGSPICE file created from nmos_top.ext - technology: sky130A

.subckt nmos_top
X0 a_84_92# a_54_62# a_0_0# VSUBS sky130_fd_pr__nfet_01v8 ad=0.0597 pd=0.555 as=0.39 ps=2.96 w=3.01 l=0.15
.ends

****EOF - nmos_top.spice
****BOF - nmos_top_trim1.spice

* NGSPICE file created from nmos_top_trim1.ext - technology: sky130A

.subckt nmos_top_trim1
X0 a_86_92# a_56_62# a_0_0# VSUBS sky130_fd_pr__nfet_01v8 ad=0.0597 pd=0.555 as=0.395 ps=2.97 w=3.01 l=0.15
.ends

****EOF - nmos_top_trim1.spice
****BOF - nmos_top_trim2.spice

* NGSPICE file created from nmos_top_trim2.ext - technology: sky130A

.subckt nmos_top_trim2
X0 a_86_92# a_56_62# a_0_0# VSUBS sky130_fd_pr__nfet_01v8 ad=0.06 pd=0.56 as=0.395 ps=2.97 w=3.01 l=0.15
.ends

****EOF - nmos_top_trim2.spice
****BOF - nor2x1_pcell.spice

* NGSPICE file created from nor2x1_pcell.ext - technology: sky130A

.subckt pmos2_1 a_144_n460# a_262_n399# a_88_n399# w_52_n435# a_174_n399#
X0 a_174_n399# a_144_n460# a_88_n399# w_52_n435# sky130_fd_pr__pfet_01v8 ad=0.29 pd=2.29 as=0.56 ps=4.56 w=2 l=0.15
X1 a_262_n399# a_144_n460# a_174_n399# w_52_n435# sky130_fd_pr__pfet_01v8 ad=0.54 pd=4.54 as=0.29 ps=2.29 w=2 l=0.15
.ends

.subckt nmos_top_trim1 a_86_92# a_56_62# a_0_0# VSUBS
X0 a_86_92# a_56_62# a_0_0# VSUBS sky130_fd_pr__nfet_01v8 ad=0.0597 pd=0.555 as=0.395 ps=2.97 w=3.01 l=0.15
.ends

.subckt nmos_top_trim2 a_86_92# a_56_62# a_0_0# VSUBS
X0 a_86_92# a_56_62# a_0_0# VSUBS sky130_fd_pr__nfet_01v8 ad=0.06 pd=0.56 as=0.395 ps=2.97 w=3.01 l=0.15
.ends

.subckt nor2x1_pcell
Xpmos2_1_0 a_168_375# a_317_1331# a_317_1331# w_87_786# w_87_786# pmos2_1
Xpmos2_1_1 a_362_382# a_317_1331# a_317_1331# w_87_786# a_405_1059# pmos2_1
Xnmos_top_trim1_1 a_405_1059# a_168_375# pmos2_1_1/VSUBS pmos2_1_1/VSUBS nmos_top_trim1
Xnmos_top_trim2_0 a_405_1059# a_362_382# pmos2_1_1/VSUBS pmos2_1_1/VSUBS nmos_top_trim2
.ends

****EOF - nor2x1_pcell.spice
****BOF - nor3x1_pcell.spice

* NGSPICE file created from nor3x1_pcell.ext - technology: sky130A

.subckt pmos2_1 a_144_n460# a_262_n399# a_88_n399# w_52_n435# a_174_n399#
X0 a_174_n399# a_144_n460# a_88_n399# w_52_n435# sky130_fd_pr__pfet_01v8 ad=0.29 pd=2.29 as=0.56 ps=4.56 w=2 l=0.15
X1 a_262_n399# a_144_n460# a_174_n399# w_52_n435# sky130_fd_pr__pfet_01v8 ad=0.54 pd=4.54 as=0.29 ps=2.29 w=2 l=0.15
.ends

.subckt nmos_top_trim1 a_86_92# a_56_62# a_0_0# VSUBS
X0 a_86_92# a_56_62# a_0_0# VSUBS sky130_fd_pr__nfet_01v8 ad=0.0597 pd=0.555 as=0.395 ps=2.97 w=3.01 l=0.15
.ends

.subckt nmos_top_trim2 a_86_92# a_56_62# a_0_0# VSUBS
X0 a_86_92# a_56_62# a_0_0# VSUBS sky130_fd_pr__nfet_01v8 ad=0.06 pd=0.56 as=0.395 ps=2.97 w=3.01 l=0.15
.ends

.subckt nor3x1_pcell
Xpmos2_1_0 a_168_375# a_317_1331# a_317_1331# w_87_786# w_87_786# pmos2_1
Xpmos2_1_1 a_362_382# a_317_1331# a_317_1331# w_87_786# a_613_1331# pmos2_1
Xnmos_top_trim1_1 li_219_233# a_168_375# pmos2_1_2/VSUBS pmos2_1_2/VSUBS nmos_top_trim1
Xpmos2_1_2 a_619_944# a_613_1331# a_613_1331# w_87_786# li_219_233# pmos2_1
Xnmos_top_trim2_0 li_219_233# a_362_382# pmos2_1_2/VSUBS pmos2_1_2/VSUBS nmos_top_trim2
Xnmos_top_trim2_1 li_219_233# a_619_944# pmos2_1_2/VSUBS pmos2_1_2/VSUBS nmos_top_trim2
.ends

****EOF - nor3x1_pcell.spice
****BOF - or2x1_pcell.spice

* NGSPICE file created from or2x1_pcell.ext - technology: sky130A

.subckt nmos_top a_84_92# a_0_0# a_54_62# VSUBS
X0 a_84_92# a_54_62# a_0_0# VSUBS sky130_fd_pr__nfet_01v8 ad=0.0597 pd=0.555 as=0.39 ps=2.96 w=3.01 l=0.15
.ends

.subckt pmos2 a_88_n400# a_144_n461# a_174_n400# a_262_n400# w_52_n436#
X0 a_262_n400# a_144_n461# a_174_n400# w_52_n436# sky130_fd_pr__pfet_01v8 ad=0.54 pd=4.54 as=0.29 ps=2.29 w=2 l=0.15
X1 a_174_n400# a_144_n461# a_88_n400# w_52_n436# sky130_fd_pr__pfet_01v8 ad=0.29 pd=2.29 as=0.56 ps=4.56 w=2 l=0.15
.ends

.subckt invx1_pcell a_34_482# a_155_381# w_n87_786# pmos2_0/VSUBS
Xnmos_top_0 a_206_1059# pmos2_0/VSUBS a_155_381# pmos2_0/VSUBS nmos_top
Xpmos2_0 w_n87_786# a_155_381# a_206_1059# w_n87_786# w_n87_786# pmos2
.ends

.subckt pmos2_1 a_144_n460# a_262_n399# a_88_n399# w_52_n435# a_174_n399#
X0 a_174_n399# a_144_n460# a_88_n399# w_52_n435# sky130_fd_pr__pfet_01v8 ad=0.29 pd=2.29 as=0.56 ps=4.56 w=2 l=0.15
X1 a_262_n399# a_144_n460# a_174_n399# w_52_n435# sky130_fd_pr__pfet_01v8 ad=0.54 pd=4.54 as=0.29 ps=2.29 w=2 l=0.15
.ends

.subckt nmos_top_trim1 a_86_92# a_56_62# a_0_0# VSUBS
X0 a_86_92# a_56_62# a_0_0# VSUBS sky130_fd_pr__nfet_01v8 ad=0.0597 pd=0.555 as=0.395 ps=2.97 w=3.01 l=0.15
.ends

.subckt nmos_top_trim2 a_86_92# a_56_62# a_0_0# VSUBS
X0 a_86_92# a_56_62# a_0_0# VSUBS sky130_fd_pr__nfet_01v8 ad=0.06 pd=0.56 as=0.395 ps=2.97 w=3.01 l=0.15
.ends

.subckt nor2x1_pcell a_405_1059# a_34_482# pmos2_1_1/VSUBS w_87_786#
Xpmos2_1_0 a_168_375# a_317_1331# a_317_1331# w_87_786# w_87_786# pmos2_1
Xpmos2_1_1 a_362_382# a_317_1331# a_317_1331# w_87_786# a_405_1059# pmos2_1
Xnmos_top_trim1_1 a_405_1059# a_168_375# pmos2_1_1/VSUBS pmos2_1_1/VSUBS nmos_top_trim1
Xnmos_top_trim2_0 a_405_1059# a_362_382# pmos2_1_1/VSUBS pmos2_1_1/VSUBS nmos_top_trim2
.ends

.subckt or2x1_pcell
Xinvx1_pcell_0 invx1_pcell_0/a_34_482# m1_547_649# nor2x1_pcell_0/w_87_786# VSUBS
+ invx1_pcell
Xnor2x1_pcell_0 m1_547_649# invx1_pcell_0/a_34_482# VSUBS nor2x1_pcell_0/w_87_786#
+ nor2x1_pcell
.ends

****EOF - or2x1_pcell.spice
****BOF - or3x1_pcell.spice

* NGSPICE file created from or3x1_pcell.ext - technology: sky130A

.subckt nmos_top a_84_92# a_0_0# a_54_62# VSUBS
X0 a_84_92# a_54_62# a_0_0# VSUBS sky130_fd_pr__nfet_01v8 ad=0.0597 pd=0.555 as=0.39 ps=2.96 w=3.01 l=0.15
.ends

.subckt pmos2 a_88_n400# a_144_n461# a_174_n400# a_262_n400# w_52_n436#
X0 a_262_n400# a_144_n461# a_174_n400# w_52_n436# sky130_fd_pr__pfet_01v8 ad=0.54 pd=4.54 as=0.29 ps=2.29 w=2 l=0.15
X1 a_174_n400# a_144_n461# a_88_n400# w_52_n436# sky130_fd_pr__pfet_01v8 ad=0.29 pd=2.29 as=0.56 ps=4.56 w=2 l=0.15
.ends

.subckt invx1_pcell a_34_482# a_155_381# w_n87_786# pmos2_0/VSUBS
Xnmos_top_0 a_206_1059# pmos2_0/VSUBS a_155_381# pmos2_0/VSUBS nmos_top
Xpmos2_0 w_n87_786# a_155_381# a_206_1059# w_n87_786# w_n87_786# pmos2
.ends

.subckt pmos2_1 a_144_n460# a_262_n399# a_88_n399# w_52_n435# a_174_n399#
X0 a_174_n399# a_144_n460# a_88_n399# w_52_n435# sky130_fd_pr__pfet_01v8 ad=0.29 pd=2.29 as=0.56 ps=4.56 w=2 l=0.15
X1 a_262_n399# a_144_n460# a_174_n399# w_52_n435# sky130_fd_pr__pfet_01v8 ad=0.54 pd=4.54 as=0.29 ps=2.29 w=2 l=0.15
.ends

.subckt nmos_top_trim1 a_86_92# a_56_62# a_0_0# VSUBS
X0 a_86_92# a_56_62# a_0_0# VSUBS sky130_fd_pr__nfet_01v8 ad=0.0597 pd=0.555 as=0.395 ps=2.97 w=3.01 l=0.15
.ends

.subckt nmos_top_trim2 a_86_92# a_56_62# a_0_0# VSUBS
X0 a_86_92# a_56_62# a_0_0# VSUBS sky130_fd_pr__nfet_01v8 ad=0.06 pd=0.56 as=0.395 ps=2.97 w=3.01 l=0.15
.ends

.subckt nor3x1_pcell a_34_482# li_219_233# pmos2_1_2/VSUBS w_87_786#
Xpmos2_1_0 a_168_375# a_317_1331# a_317_1331# w_87_786# w_87_786# pmos2_1
Xpmos2_1_1 a_362_382# a_317_1331# a_317_1331# w_87_786# a_613_1331# pmos2_1
Xnmos_top_trim1_1 li_219_233# a_168_375# pmos2_1_2/VSUBS pmos2_1_2/VSUBS nmos_top_trim1
Xpmos2_1_2 a_619_944# a_613_1331# a_613_1331# w_87_786# li_219_233# pmos2_1
Xnmos_top_trim2_0 li_219_233# a_362_382# pmos2_1_2/VSUBS pmos2_1_2/VSUBS nmos_top_trim2
Xnmos_top_trim2_1 li_219_233# a_619_944# pmos2_1_2/VSUBS pmos2_1_2/VSUBS nmos_top_trim2
.ends

.subckt or3x1_pcell
Xinvx1_pcell_0 invx1_pcell_0/a_34_482# m1_491_649# nor3x1_pcell_0/w_87_786# VSUBS
+ invx1_pcell
Xnor3x1_pcell_0 invx1_pcell_0/a_34_482# m1_491_649# VSUBS nor3x1_pcell_0/w_87_786#
+ nor3x1_pcell
.ends

****EOF - or3x1_pcell.spice
****BOF - pmos2.spice

* NGSPICE file created from pmos2.ext - technology: sky130A

.subckt pmos2
X0 a_262_n400# a_144_n461# a_174_n400# w_52_n436# sky130_fd_pr__pfet_01v8 ad=0.54 pd=4.54 as=0.29 ps=2.29 w=2 l=0.15
X1 a_174_n400# a_144_n461# a_88_n400# w_52_n436# sky130_fd_pr__pfet_01v8 ad=0.29 pd=2.29 as=0.56 ps=4.56 w=2 l=0.15
.ends

****EOF - pmos2.spice
****BOF - pmos2_1.spice

* NGSPICE file created from pmos2_1.ext - technology: sky130A

.subckt pmos2_1
X0 a_174_n399# a_144_n460# a_88_n399# w_52_n435# sky130_fd_pr__pfet_01v8 ad=0.29 pd=2.29 as=0.56 ps=4.56 w=2 l=0.15
X1 a_262_n399# a_144_n460# a_174_n399# w_52_n435# sky130_fd_pr__pfet_01v8 ad=0.54 pd=4.54 as=0.29 ps=2.29 w=2 l=0.15
.ends

****EOF - pmos2_1.spice
****BOF - poly_li1_contact.spice

* NGSPICE file created from poly_li1_contact.ext - technology: sky130A

* Top level circuit poly_li1_contact

.end

****EOF - poly_li1_contact.spice
****BOF - voter3x1_pcell.spice

* NGSPICE file created from voter3x1_pcell.ext - technology: sky130A

.subckt nmos_bottom a_56_54# a_86_84# a_0_0# VSUBS
X0 a_86_84# a_56_54# a_0_0# VSUBS sky130_fd_pr__nfet_01v8 ad=0.0597 pd=0.555 as=0.393 ps=2.99 w=3.01 l=0.15
.ends

.subckt pmos2_1 a_144_n460# a_262_n399# a_88_n399# w_52_n435# a_174_n399#
X0 a_174_n399# a_144_n460# a_88_n399# w_52_n435# sky130_fd_pr__pfet_01v8 ad=0.29 pd=2.29 as=0.56 ps=4.56 w=2 l=0.15
X1 a_262_n399# a_144_n460# a_174_n399# w_52_n435# sky130_fd_pr__pfet_01v8 ad=0.54 pd=4.54 as=0.29 ps=2.29 w=2 l=0.15
.ends

.subckt nmos_top_trim1 a_86_92# a_56_62# a_0_0# VSUBS
X0 a_86_92# a_56_62# a_0_0# VSUBS sky130_fd_pr__nfet_01v8 ad=0.0597 pd=0.555 as=0.395 ps=2.97 w=3.01 l=0.15
.ends

.subckt nmos_top a_84_92# a_0_0# a_54_62# VSUBS
X0 a_84_92# a_54_62# a_0_0# VSUBS sky130_fd_pr__nfet_01v8 ad=0.0597 pd=0.555 as=0.39 ps=2.96 w=3.01 l=0.15
.ends

.subckt nmos_top_trim2 a_86_92# a_56_62# a_0_0# VSUBS
X0 a_86_92# a_56_62# a_0_0# VSUBS sky130_fd_pr__nfet_01v8 ad=0.06 pd=0.56 as=0.395 ps=2.97 w=3.01 l=0.15
.ends

.subckt votern3x1_pcell a_1366_482# w_750_786# m1_449_219# pmos2_1_5/VSUBS
Xnmos_bottom_0 a_834_375# pmos2_1_5/VSUBS nmos_top_0/a_0_0# pmos2_1_5/VSUBS nmos_bottom
Xnmos_bottom_1 a_834_375# pmos2_1_5/VSUBS nmos_bottom_1/a_0_0# pmos2_1_5/VSUBS nmos_bottom
Xnmos_bottom_2 a_1507_944# pmos2_1_5/VSUBS nmos_bottom_2/a_0_0# pmos2_1_5/VSUBS nmos_bottom
Xpmos2_1_0 a_834_375# w_750_786# w_750_786# w_750_786# a_805_1331# pmos2_1
Xnmos_top_trim1_0 m1_449_219# a_1507_944# nmos_bottom_1/a_0_0# pmos2_1_5/VSUBS nmos_top_trim1
Xpmos2_1_1 a_362_381# w_750_786# w_750_786# w_750_786# a_805_1331# pmos2_1
Xpmos2_1_2 a_1507_944# a_805_1331# a_805_1331# w_750_786# a_893_1059# pmos2_1
Xpmos2_1_3 a_834_375# a_805_1331# a_805_1331# w_750_786# a_893_1059# pmos2_1
Xpmos2_1_4 a_1507_944# a_893_1059# a_893_1059# w_750_786# m1_449_219# pmos2_1
Xpmos2_1_5 a_362_381# a_893_1059# a_893_1059# w_750_786# m1_449_219# pmos2_1
Xnmos_top_0 m1_449_219# nmos_top_0/a_0_0# a_362_381# pmos2_1_5/VSUBS nmos_top
Xnmos_top_trim2_2 m1_449_219# a_362_381# nmos_bottom_2/a_0_0# pmos2_1_5/VSUBS nmos_top_trim2
.ends

.subckt pmos2 a_88_n400# a_144_n461# a_174_n400# a_262_n400# w_52_n436#
X0 a_262_n400# a_144_n461# a_174_n400# w_52_n436# sky130_fd_pr__pfet_01v8 ad=0.54 pd=4.54 as=0.29 ps=2.29 w=2 l=0.15
X1 a_174_n400# a_144_n461# a_88_n400# w_52_n436# sky130_fd_pr__pfet_01v8 ad=0.29 pd=2.29 as=0.56 ps=4.56 w=2 l=0.15
.ends

.subckt invx1_pcell a_34_482# a_155_381# w_n87_786# pmos2_0/VSUBS
Xnmos_top_0 a_206_1059# pmos2_0/VSUBS a_155_381# pmos2_0/VSUBS nmos_top
Xpmos2_0 w_n87_786# a_155_381# a_206_1059# w_n87_786# w_n87_786# pmos2
.ends

.subckt voter3x1_pcell
Xvotern3x1_pcell_0 invx1_pcell_0/a_34_482# invx1_pcell_0/w_n87_786# m1_1867_797# VSUBS
+ votern3x1_pcell
Xinvx1_pcell_0 invx1_pcell_0/a_34_482# m1_1867_797# invx1_pcell_0/w_n87_786# VSUBS
+ invx1_pcell
.ends

****EOF - voter3x1_pcell.spice
****BOF - votern3x1_pcell.spice

* NGSPICE file created from votern3x1_pcell.ext - technology: sky130A

.subckt nmos_bottom a_56_54# a_86_84# a_0_0# VSUBS
X0 a_86_84# a_56_54# a_0_0# VSUBS sky130_fd_pr__nfet_01v8 ad=0.0597 pd=0.555 as=0.393 ps=2.99 w=3.01 l=0.15
.ends

.subckt pmos2_1 a_144_n460# a_262_n399# a_88_n399# w_52_n435# a_174_n399#
X0 a_174_n399# a_144_n460# a_88_n399# w_52_n435# sky130_fd_pr__pfet_01v8 ad=0.29 pd=2.29 as=0.56 ps=4.56 w=2 l=0.15
X1 a_262_n399# a_144_n460# a_174_n399# w_52_n435# sky130_fd_pr__pfet_01v8 ad=0.54 pd=4.54 as=0.29 ps=2.29 w=2 l=0.15
.ends

.subckt nmos_top_trim1 a_86_92# a_56_62# a_0_0# VSUBS
X0 a_86_92# a_56_62# a_0_0# VSUBS sky130_fd_pr__nfet_01v8 ad=0.0597 pd=0.555 as=0.395 ps=2.97 w=3.01 l=0.15
.ends

.subckt nmos_top a_84_92# a_0_0# a_54_62# VSUBS
X0 a_84_92# a_54_62# a_0_0# VSUBS sky130_fd_pr__nfet_01v8 ad=0.0597 pd=0.555 as=0.39 ps=2.96 w=3.01 l=0.15
.ends

.subckt nmos_top_trim2 a_86_92# a_56_62# a_0_0# VSUBS
X0 a_86_92# a_56_62# a_0_0# VSUBS sky130_fd_pr__nfet_01v8 ad=0.06 pd=0.56 as=0.395 ps=2.97 w=3.01 l=0.15
.ends

.subckt votern3x1_pcell
Xnmos_bottom_0 a_834_375# pmos2_1_5/VSUBS nmos_top_0/a_0_0# pmos2_1_5/VSUBS nmos_bottom
Xnmos_bottom_1 a_834_375# pmos2_1_5/VSUBS nmos_bottom_1/a_0_0# pmos2_1_5/VSUBS nmos_bottom
Xnmos_bottom_2 a_1507_944# pmos2_1_5/VSUBS nmos_bottom_2/a_0_0# pmos2_1_5/VSUBS nmos_bottom
Xpmos2_1_0 a_834_375# w_750_786# w_750_786# w_750_786# a_805_1331# pmos2_1
Xnmos_top_trim1_0 m1_449_219# a_1507_944# nmos_bottom_1/a_0_0# pmos2_1_5/VSUBS nmos_top_trim1
Xpmos2_1_1 a_362_381# w_750_786# w_750_786# w_750_786# a_805_1331# pmos2_1
Xpmos2_1_2 a_1507_944# a_805_1331# a_805_1331# w_750_786# a_893_1059# pmos2_1
Xpmos2_1_3 a_834_375# a_805_1331# a_805_1331# w_750_786# a_893_1059# pmos2_1
Xpmos2_1_4 a_1507_944# a_893_1059# a_893_1059# w_750_786# m1_449_219# pmos2_1
Xpmos2_1_5 a_362_381# a_893_1059# a_893_1059# w_750_786# m1_449_219# pmos2_1
Xnmos_top_0 m1_449_219# nmos_top_0/a_0_0# a_362_381# pmos2_1_5/VSUBS nmos_top
Xnmos_top_trim2_2 m1_449_219# a_362_381# nmos_bottom_2/a_0_0# pmos2_1_5/VSUBS nmos_top_trim2
.ends

****EOF - votern3x1_pcell.spice
****BOF - xnor2x1_pcell.spice

* NGSPICE file created from xnor2x1_pcell.ext - technology: sky130A

.subckt nmos_bottom a_56_54# a_86_84# a_0_0# VSUBS
X0 a_86_84# a_56_54# a_0_0# VSUBS sky130_fd_pr__nfet_01v8 ad=0.0597 pd=0.555 as=0.393 ps=2.99 w=3.01 l=0.15
.ends

.subckt pmos2_1 a_144_n460# a_262_n399# a_88_n399# w_52_n435# a_174_n399#
X0 a_174_n399# a_144_n460# a_88_n399# w_52_n435# sky130_fd_pr__pfet_01v8 ad=0.29 pd=2.29 as=0.56 ps=4.56 w=2 l=0.15
X1 a_262_n399# a_144_n460# a_174_n399# w_52_n435# sky130_fd_pr__pfet_01v8 ad=0.54 pd=4.54 as=0.29 ps=2.29 w=2 l=0.15
.ends

.subckt nmos_top_trim1 a_86_92# a_56_62# a_0_0# VSUBS
X0 a_86_92# a_56_62# a_0_0# VSUBS sky130_fd_pr__nfet_01v8 ad=0.0597 pd=0.555 as=0.395 ps=2.97 w=3.01 l=0.15
.ends

.subckt nmos_top a_84_92# a_0_0# a_54_62# VSUBS
X0 a_84_92# a_54_62# a_0_0# VSUBS sky130_fd_pr__nfet_01v8 ad=0.0597 pd=0.555 as=0.39 ps=2.96 w=3.01 l=0.15
.ends

.subckt pmos2 a_88_n400# a_144_n461# a_174_n400# a_262_n400# w_52_n436#
X0 a_262_n400# a_144_n461# a_174_n400# w_52_n436# sky130_fd_pr__pfet_01v8 ad=0.54 pd=4.54 as=0.29 ps=2.29 w=2 l=0.15
X1 a_174_n400# a_144_n461# a_88_n400# w_52_n436# sky130_fd_pr__pfet_01v8 ad=0.29 pd=2.29 as=0.56 ps=4.56 w=2 l=0.15
.ends

.subckt invx1_pcell a_34_482# a_155_381# a_206_1059# w_n87_786# pmos2_0/VSUBS
Xnmos_top_0 a_206_1059# pmos2_0/VSUBS a_155_381# pmos2_0/VSUBS nmos_top
Xpmos2_0 w_n87_786# a_155_381# a_206_1059# w_n87_786# w_n87_786# pmos2
.ends

.subckt xnor2x1_pcell
Xnmos_bottom_0 a_612_375# pmos2_1_3/VSUBS nmos_bottom_0/a_0_0# pmos2_1_3/VSUBS nmos_bottom
Xnmos_bottom_1 m1_939_797# pmos2_1_3/VSUBS nmos_bottom_1/a_0_0# pmos2_1_3/VSUBS nmos_bottom
Xpmos2_1_0 a_612_375# a_761_1330# a_761_1330# w_585_1330# w_585_1330# pmos2_1
Xnmos_top_trim1_1 m1_981_723# m1_315_501# nmos_bottom_1/a_0_0# pmos2_1_3/VSUBS nmos_top_trim1
Xnmos_top_trim1_0 m1_981_723# a_806_382# nmos_bottom_0/a_0_0# pmos2_1_3/VSUBS nmos_top_trim1
Xpmos2_1_1 m1_939_797# a_761_1330# a_761_1330# w_585_1330# m1_981_723# pmos2_1
Xpmos2_1_2 a_806_382# a_1427_1330# a_1427_1330# w_585_1330# w_585_1330# pmos2_1
Xpmos2_1_3 m1_315_501# a_1427_1330# a_1427_1330# w_585_1330# m1_981_723# pmos2_1
Xinvx1_pcell_0 pmos2_1_3/VSUBS a_612_375# m1_315_501# w_585_1330# pmos2_1_3/VSUBS
+ invx1_pcell
Xinvx1_pcell_1 pmos2_1_3/VSUBS m1_939_797# a_806_382# w_585_1330# pmos2_1_3/VSUBS
+ invx1_pcell
.ends

****EOF - xnor2x1_pcell.spice
****BOF - xor2X1_pcell.spice

* NGSPICE file created from xor2X1_pcell.ext - technology: sky130A

.subckt nmos_bottom a_56_54# a_86_84# a_0_0# VSUBS
X0 a_86_84# a_56_54# a_0_0# VSUBS sky130_fd_pr__nfet_01v8 ad=0.0597 pd=0.555 as=0.393 ps=2.99 w=3.01 l=0.15
.ends

.subckt pmos2_1 a_144_n460# a_262_n399# a_88_n399# w_52_n435# a_174_n399#
X0 a_174_n399# a_144_n460# a_88_n399# w_52_n435# sky130_fd_pr__pfet_01v8 ad=0.29 pd=2.29 as=0.56 ps=4.56 w=2 l=0.15
X1 a_262_n399# a_144_n460# a_174_n399# w_52_n435# sky130_fd_pr__pfet_01v8 ad=0.54 pd=4.54 as=0.29 ps=2.29 w=2 l=0.15
.ends

.subckt nmos_top_trim1 a_86_92# a_56_62# a_0_0# VSUBS
X0 a_86_92# a_56_62# a_0_0# VSUBS sky130_fd_pr__nfet_01v8 ad=0.0597 pd=0.555 as=0.395 ps=2.97 w=3.01 l=0.15
.ends

.subckt nmos_top a_84_92# a_0_0# a_54_62# VSUBS
X0 a_84_92# a_54_62# a_0_0# VSUBS sky130_fd_pr__nfet_01v8 ad=0.0597 pd=0.555 as=0.39 ps=2.96 w=3.01 l=0.15
.ends

.subckt pmos2 a_88_n400# a_144_n461# a_174_n400# a_262_n400# w_52_n436#
X0 a_262_n400# a_144_n461# a_174_n400# w_52_n436# sky130_fd_pr__pfet_01v8 ad=0.54 pd=4.54 as=0.29 ps=2.29 w=2 l=0.15
X1 a_174_n400# a_144_n461# a_88_n400# w_52_n436# sky130_fd_pr__pfet_01v8 ad=0.29 pd=2.29 as=0.56 ps=4.56 w=2 l=0.15
.ends

.subckt invx1_pcell a_34_482# a_155_381# a_206_1059# w_n87_786# pmos2_0/VSUBS
Xnmos_top_0 a_206_1059# pmos2_0/VSUBS a_155_381# pmos2_0/VSUBS nmos_top
Xpmos2_0 w_n87_786# a_155_381# a_206_1059# w_n87_786# w_n87_786# pmos2
.ends

.subckt xor2X1_pcell
Xnmos_bottom_0 a_612_376# pmos2_1_3/VSUBS nmos_bottom_0/a_0_0# pmos2_1_3/VSUBS nmos_bottom
Xnmos_bottom_1 m1_939_797# pmos2_1_3/VSUBS nmos_bottom_1/a_0_0# pmos2_1_3/VSUBS nmos_bottom
Xpmos2_1_0 a_612_376# a_761_1330# a_761_1330# w_585_1330# w_585_1330# pmos2_1
Xnmos_top_trim1_1 m1_981_723# m1_315_501# nmos_bottom_1/a_0_0# pmos2_1_3/VSUBS nmos_top_trim1
Xnmos_top_trim1_0 m1_981_723# a_806_383# nmos_bottom_0/a_0_0# pmos2_1_3/VSUBS nmos_top_trim1
Xpmos2_1_1 m1_939_797# a_761_1330# a_761_1330# w_585_1330# m1_981_723# pmos2_1
Xpmos2_1_2 a_806_383# a_1427_1330# a_1427_1330# w_585_1330# w_585_1330# pmos2_1
Xpmos2_1_3 m1_315_501# a_1427_1330# a_1427_1330# w_585_1330# m1_981_723# pmos2_1
Xinvx1_pcell_0 pmos2_1_3/VSUBS a_612_376# m1_315_501# w_585_1330# pmos2_1_3/VSUBS
+ invx1_pcell
Xinvx1_pcell_1 pmos2_1_3/VSUBS a_806_383# m1_939_797# w_585_1330# pmos2_1_3/VSUBS
+ invx1_pcell
.ends

****EOF - xor2X1_pcell.spice
