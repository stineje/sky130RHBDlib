* NGSPICE file created from VOTER3X1.ext - technology: sky130A

.subckt nmos_bottom a_56_54# a_86_84# a_0_0# VSUBS
X0 a_86_84# a_56_54# a_0_0# VSUBS sky130_fd_pr__nfet_01v8 ad=0.0597 pd=0.555 as=0.393 ps=2.99 w=3.01 l=0.15
.ends

.subckt pmos2_1 a_144_n460# a_262_n399# a_88_n399# w_52_n435# a_174_n399#
X0 a_174_n399# a_144_n460# a_88_n399# w_52_n435# sky130_fd_pr__pfet_01v8 ad=0.29 pd=2.29 as=0.56 ps=4.56 w=2 l=0.15
X1 a_262_n399# a_144_n460# a_174_n399# w_52_n435# sky130_fd_pr__pfet_01v8 ad=0.54 pd=4.54 as=0.29 ps=2.29 w=2 l=0.15
.ends

.subckt nmos_top_trim1 a_86_92# a_56_62# a_0_0# VSUBS
X0 a_86_92# a_56_62# a_0_0# VSUBS sky130_fd_pr__nfet_01v8 ad=0.0597 pd=0.555 as=0.395 ps=2.97 w=3.01 l=0.15
.ends

.subckt nmos_top a_84_92# a_0_0# a_54_62# VSUBS
X0 a_84_92# a_54_62# a_0_0# VSUBS sky130_fd_pr__nfet_01v8 ad=0.0597 pd=0.555 as=0.39 ps=2.96 w=3.01 l=0.15
.ends

.subckt nmos_top_trim2 a_86_92# a_56_62# a_0_0# VSUBS
X0 a_86_92# a_56_62# a_0_0# VSUBS sky130_fd_pr__nfet_01v8 ad=0.06 pd=0.56 as=0.395 ps=2.97 w=3.01 l=0.15
.ends

.subckt votern3x1_pcell a_1366_n34# a_1507_944# a_362_381# a_1366_482# w_750_786#
+ m1_449_219# pmos2_1_5/VSUBS a_834_375#
Xnmos_bottom_0 a_834_375# pmos2_1_5/VSUBS nmos_top_0/a_0_0# pmos2_1_5/VSUBS nmos_bottom
Xnmos_bottom_1 a_834_375# pmos2_1_5/VSUBS nmos_bottom_1/a_0_0# pmos2_1_5/VSUBS nmos_bottom
Xnmos_bottom_2 a_1507_944# pmos2_1_5/VSUBS nmos_bottom_2/a_0_0# pmos2_1_5/VSUBS nmos_bottom
Xpmos2_1_0 a_834_375# w_750_786# w_750_786# w_750_786# a_805_1331# pmos2_1
Xnmos_top_trim1_0 m1_449_219# a_1507_944# nmos_bottom_1/a_0_0# pmos2_1_5/VSUBS nmos_top_trim1
Xpmos2_1_1 a_362_381# w_750_786# w_750_786# w_750_786# a_805_1331# pmos2_1
Xpmos2_1_2 a_1507_944# a_805_1331# a_805_1331# w_750_786# a_893_1059# pmos2_1
Xpmos2_1_3 a_834_375# a_805_1331# a_805_1331# w_750_786# a_893_1059# pmos2_1
Xpmos2_1_4 a_1507_944# a_893_1059# a_893_1059# w_750_786# m1_449_219# pmos2_1
Xpmos2_1_5 a_362_381# a_893_1059# a_893_1059# w_750_786# m1_449_219# pmos2_1
Xnmos_top_0 m1_449_219# nmos_top_0/a_0_0# a_362_381# pmos2_1_5/VSUBS nmos_top
Xnmos_top_trim2_2 m1_449_219# a_362_381# nmos_bottom_2/a_0_0# pmos2_1_5/VSUBS nmos_top_trim2
.ends

.subckt pmos2 a_88_n400# a_144_n461# a_174_n400# a_262_n400# w_52_n436#
X0 a_262_n400# a_144_n461# a_174_n400# w_52_n436# sky130_fd_pr__pfet_01v8 ad=0.54 pd=4.54 as=0.29 ps=2.29 w=2 l=0.15
X1 a_174_n400# a_144_n461# a_88_n400# w_52_n436# sky130_fd_pr__pfet_01v8 ad=0.29 pd=2.29 as=0.56 ps=4.56 w=2 l=0.15
.ends

.subckt invx1_pcell a_34_482# a_155_381# a_206_1059# w_n87_786# pmos2_0/VSUBS
Xnmos_top_0 a_206_1059# pmos2_0/VSUBS a_155_381# pmos2_0/VSUBS nmos_top
Xpmos2_0 w_n87_786# a_155_381# a_206_1059# w_n87_786# w_n87_786# pmos2
.ends

.subckt voter3x1_pcell votern3x1_pcell_0/a_1366_n34# votern3x1_pcell_0/a_362_381#
+ votern3x1_pcell_0/a_1507_944# invx1_pcell_0/w_n87_786# invx1_pcell_0/a_206_1059#
+ VSUBS votern3x1_pcell_0/a_834_375#
Xvotern3x1_pcell_0 votern3x1_pcell_0/a_1366_n34# votern3x1_pcell_0/a_1507_944# votern3x1_pcell_0/a_362_381#
+ invx1_pcell_0/a_34_482# invx1_pcell_0/w_n87_786# m1_1867_797# VSUBS votern3x1_pcell_0/a_834_375#
+ votern3x1_pcell
Xinvx1_pcell_0 invx1_pcell_0/a_34_482# m1_1867_797# invx1_pcell_0/a_206_1059# invx1_pcell_0/w_n87_786#
+ VSUBS invx1_pcell
.ends

.subckt VOTER3X1 Y A B C VDD GND
Xvoter3x1_pcell_0 GND A C VDD Y GND B voter3x1_pcell
.ends
