* NGSPICE file created from aoa4x1_pcell.ext - technology: sky130A

.subckt nmos_top a_84_92# a_0_0# a_54_62# VSUBS
X0 a_84_92# a_54_62# a_0_0# VSUBS sky130_fd_pr__nfet_01v8 ad=0.0597 pd=0.555 as=0.39 ps=2.96 w=3.01 l=0.15
.ends

.subckt pmos2 a_88_n400# a_144_n461# a_174_n400# a_262_n400# w_52_n436#
X0 a_262_n400# a_144_n461# a_174_n400# w_52_n436# sky130_fd_pr__pfet_01v8 ad=0.54 pd=4.54 as=0.29 ps=2.29 w=2 l=0.15
X1 a_174_n400# a_144_n461# a_88_n400# w_52_n436# sky130_fd_pr__pfet_01v8 ad=0.29 pd=2.29 as=0.56 ps=4.56 w=2 l=0.15
.ends

.subckt invx1_pcell a_34_482# a_155_381# w_n87_786# pmos2_0/VSUBS
Xnmos_top_0 a_206_1059# pmos2_0/VSUBS a_155_381# pmos2_0/VSUBS nmos_top
Xpmos2_0 w_n87_786# a_155_381# a_206_1059# w_n87_786# w_n87_786# pmos2
.ends

.subckt nmos_bottom a_56_54# a_86_84# a_0_0# VSUBS
X0 a_86_84# a_56_54# a_0_0# VSUBS sky130_fd_pr__nfet_01v8 ad=0.0597 pd=0.555 as=0.393 ps=2.99 w=3.01 l=0.15
.ends

.subckt nmos_top_trim1 a_86_92# a_56_62# a_0_0# VSUBS
X0 a_86_92# a_56_62# a_0_0# VSUBS sky130_fd_pr__nfet_01v8 ad=0.0597 pd=0.555 as=0.395 ps=2.97 w=3.01 l=0.15
.ends

.subckt nand2x1_pcell a_31_480# a_229_1059# pmos2_1/VSUBS a_168_375# w_87_786#
Xnmos_bottom_0 a_168_375# pmos2_1/VSUBS nmos_bottom_0/a_0_0# pmos2_1/VSUBS nmos_bottom
Xnmos_top_trim1_0 a_229_1059# a_362_382# nmos_bottom_0/a_0_0# pmos2_1/VSUBS nmos_top_trim1
Xpmos2_0 w_87_786# a_168_375# a_229_1059# w_87_786# w_87_786# pmos2
Xpmos2_1 w_87_786# a_362_382# a_229_1059# w_87_786# w_87_786# pmos2
.ends

.subckt pmos2_1 a_144_n460# a_262_n399# a_88_n399# w_52_n435# a_174_n399#
X0 a_174_n399# a_144_n460# a_88_n399# w_52_n435# sky130_fd_pr__pfet_01v8 ad=0.29 pd=2.29 as=0.56 ps=4.56 w=2 l=0.15
X1 a_262_n399# a_144_n460# a_174_n399# w_52_n435# sky130_fd_pr__pfet_01v8 ad=0.54 pd=4.54 as=0.29 ps=2.29 w=2 l=0.15
.ends

.subckt nmos_top_trim2 a_86_92# a_56_62# a_0_0# VSUBS
X0 a_86_92# a_56_62# a_0_0# VSUBS sky130_fd_pr__nfet_01v8 ad=0.06 pd=0.56 as=0.395 ps=2.97 w=3.01 l=0.15
.ends

.subckt nor2x1_pcell a_405_1059# a_34_482# pmos2_1_1/VSUBS a_168_375# w_87_786#
Xpmos2_1_0 a_168_375# a_317_1331# a_317_1331# w_87_786# w_87_786# pmos2_1
Xpmos2_1_1 a_362_382# a_317_1331# a_317_1331# w_87_786# a_405_1059# pmos2_1
Xnmos_top_trim1_1 a_405_1059# a_168_375# pmos2_1_1/VSUBS pmos2_1_1/VSUBS nmos_top_trim1
Xnmos_top_trim2_0 a_405_1059# a_362_382# pmos2_1_1/VSUBS pmos2_1_1/VSUBS nmos_top_trim2
.ends

.subckt aoai4x1_pcell nor2x1_pcell_0/w_87_786# nor2x1_pcell_0/a_34_482# nand2x1_pcell_1/a_229_1059#
+ VSUBS
Xnand2x1_pcell_0 nor2x1_pcell_0/a_34_482# m1_537_501# VSUBS nand2x1_pcell_0/a_168_375#
+ nor2x1_pcell_0/w_87_786# nand2x1_pcell
Xnor2x1_pcell_0 m1_1203_501# nor2x1_pcell_0/a_34_482# VSUBS m1_537_501# nor2x1_pcell_0/w_87_786#
+ nor2x1_pcell
Xnand2x1_pcell_1 nor2x1_pcell_0/a_34_482# nand2x1_pcell_1/a_229_1059# VSUBS m1_1203_501#
+ nor2x1_pcell_0/w_87_786# nand2x1_pcell
.ends

.subckt aoa4x1_pcell
Xinvx1_pcell_0 invx1_pcell_0/a_34_482# m1_1869_501# invx1_pcell_0/w_n87_786# VSUBS
+ invx1_pcell
Xaoai4x1_pcell_0 invx1_pcell_0/w_n87_786# invx1_pcell_0/a_34_482# m1_1869_501# VSUBS
+ aoai4x1_pcell
.ends
