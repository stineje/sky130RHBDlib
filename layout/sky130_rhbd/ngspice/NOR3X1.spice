* NGSPICE file created from NOR3X1.ext - technology: sky130A

.subckt pmos2_1 a_144_n460# a_262_n399# a_88_n399# w_52_n435# a_174_n399#
X0 a_174_n399# a_144_n460# a_88_n399# w_52_n435# sky130_fd_pr__pfet_01v8 ad=0.29 pd=2.29 as=0.56 ps=4.56 w=2 l=0.15
X1 a_262_n399# a_144_n460# a_174_n399# w_52_n435# sky130_fd_pr__pfet_01v8 ad=0.54 pd=4.54 as=0.29 ps=2.29 w=2 l=0.15
.ends

.subckt nmos_top_trim1 a_86_92# a_56_62# a_0_0# VSUBS
X0 a_86_92# a_56_62# a_0_0# VSUBS sky130_fd_pr__nfet_01v8 ad=0.0597 pd=0.555 as=0.395 ps=2.97 w=3.01 l=0.15
.ends

.subckt nmos_top_trim2 a_86_92# a_56_62# a_0_0# VSUBS
X0 a_86_92# a_56_62# a_0_0# VSUBS sky130_fd_pr__nfet_01v8 ad=0.06 pd=0.56 as=0.395 ps=2.97 w=3.01 l=0.15
.ends

.subckt nor3x1_pcell a_362_382# a_619_944# li_219_233# pmos2_1_2/VSUBS w_87_786# a_168_375#
Xpmos2_1_0 a_168_375# a_317_1331# a_317_1331# w_87_786# w_87_786# pmos2_1
Xpmos2_1_1 a_362_382# a_317_1331# a_317_1331# w_87_786# a_613_1331# pmos2_1
Xnmos_top_trim1_1 li_219_233# a_168_375# pmos2_1_2/VSUBS pmos2_1_2/VSUBS nmos_top_trim1
Xpmos2_1_2 a_619_944# a_613_1331# a_613_1331# w_87_786# li_219_233# pmos2_1
Xnmos_top_trim2_0 li_219_233# a_362_382# pmos2_1_2/VSUBS pmos2_1_2/VSUBS nmos_top_trim2
Xnmos_top_trim2_1 li_219_233# a_619_944# pmos2_1_2/VSUBS pmos2_1_2/VSUBS nmos_top_trim2
.ends

.subckt NOR3X1 Y A B C VDD GND
Xnor3x1_pcell_0 B C Y GND VDD A nor3x1_pcell
.ends
