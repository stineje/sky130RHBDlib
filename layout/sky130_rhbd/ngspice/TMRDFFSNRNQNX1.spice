* NGSPICE file created from TMRDFFSNRNQNX1.ext - technology: sky130A

.subckt nmos_bottom a_56_54# a_86_84# a_0_0# VSUBS
X0 a_86_84# a_56_54# a_0_0# VSUBS sky130_fd_pr__nfet_01v8 ad=0.0597 pd=0.555 as=0.393 ps=2.99 w=3.01 l=0.15
.ends

.subckt pmos2_1 a_144_n460# a_262_n399# a_88_n399# w_52_n435# a_174_n399#
X0 a_174_n399# a_144_n460# a_88_n399# w_52_n435# sky130_fd_pr__pfet_01v8 ad=0.29 pd=2.29 as=0.56 ps=4.56 w=2 l=0.15
X1 a_262_n399# a_144_n460# a_174_n399# w_52_n435# sky130_fd_pr__pfet_01v8 ad=0.54 pd=4.54 as=0.29 ps=2.29 w=2 l=0.15
.ends

.subckt nmos_top_trim1 a_86_92# a_56_62# a_0_0# VSUBS
X0 a_86_92# a_56_62# a_0_0# VSUBS sky130_fd_pr__nfet_01v8 ad=0.0597 pd=0.555 as=0.395 ps=2.97 w=3.01 l=0.15
.ends

.subckt nmos_top a_84_92# a_0_0# a_54_62# VSUBS
X0 a_84_92# a_54_62# a_0_0# VSUBS sky130_fd_pr__nfet_01v8 ad=0.0597 pd=0.555 as=0.39 ps=2.96 w=3.01 l=0.15
.ends

.subckt nmos_top_trim2 a_86_92# a_56_62# a_0_0# VSUBS
X0 a_86_92# a_56_62# a_0_0# VSUBS sky130_fd_pr__nfet_01v8 ad=0.06 pd=0.56 as=0.395 ps=2.97 w=3.01 l=0.15
.ends

.subckt votern3x1_pcell a_362_381# a_1366_482# a_700_482# w_750_786# a_1507_944# a_834_375#
+ m1_449_219# pmos2_1_5/VSUBS
Xnmos_bottom_0 a_834_375# pmos2_1_5/VSUBS nmos_top_0/a_0_0# pmos2_1_5/VSUBS nmos_bottom
Xnmos_bottom_1 a_834_375# pmos2_1_5/VSUBS nmos_bottom_1/a_0_0# pmos2_1_5/VSUBS nmos_bottom
Xnmos_bottom_2 a_1507_944# pmos2_1_5/VSUBS nmos_bottom_2/a_0_0# pmos2_1_5/VSUBS nmos_bottom
Xpmos2_1_0 a_834_375# w_750_786# w_750_786# w_750_786# a_805_1331# pmos2_1
Xnmos_top_trim1_0 m1_449_219# a_1507_944# nmos_bottom_1/a_0_0# pmos2_1_5/VSUBS nmos_top_trim1
Xpmos2_1_1 a_362_381# w_750_786# w_750_786# w_750_786# a_805_1331# pmos2_1
Xpmos2_1_2 a_1507_944# a_805_1331# a_805_1331# w_750_786# a_893_1059# pmos2_1
Xpmos2_1_3 a_834_375# a_805_1331# a_805_1331# w_750_786# a_893_1059# pmos2_1
Xpmos2_1_4 a_1507_944# a_893_1059# a_893_1059# w_750_786# m1_449_219# pmos2_1
Xpmos2_1_5 a_362_381# a_893_1059# a_893_1059# w_750_786# m1_449_219# pmos2_1
Xnmos_top_0 m1_449_219# nmos_top_0/a_0_0# a_362_381# pmos2_1_5/VSUBS nmos_top
Xnmos_top_trim2_2 m1_449_219# a_362_381# nmos_bottom_2/a_0_0# pmos2_1_5/VSUBS nmos_top_trim2
.ends

.subckt nmos_side_left a_87_91# a_0_0# a_57_61# VSUBS
X0 a_87_91# a_57_61# a_0_0# VSUBS sky130_fd_pr__nfet_01v8 ad=0.0545 pd=0.53 as=0.404 ps=3.02 w=3 l=0.15
.ends

.subckt pmos2 a_88_n400# a_144_n461# a_174_n400# a_262_n400# w_52_n436#
X0 a_262_n400# a_144_n461# a_174_n400# w_52_n436# sky130_fd_pr__pfet_01v8 ad=0.54 pd=4.54 as=0.29 ps=2.29 w=2 l=0.15
X1 a_174_n400# a_144_n461# a_88_n400# w_52_n436# sky130_fd_pr__pfet_01v8 ad=0.29 pd=2.29 as=0.56 ps=4.56 w=2 l=0.15
.ends

.subckt nand3x1_pcell a_34_482# a_447_377# li_649_449# a_289_1059# pmos2_2/VSUBS w_87_786#
+ a_147_377#
Xnmos_bottom_0 a_147_377# pmos2_2/VSUBS nmos_bottom_0/a_0_0# pmos2_2/VSUBS nmos_bottom
Xnmos_top_trim1_0 a_289_1059# li_649_449# li_393_182# pmos2_2/VSUBS nmos_top_trim1
Xnmos_side_left_0 li_393_182# nmos_bottom_0/a_0_0# a_447_377# pmos2_2/VSUBS nmos_side_left
Xpmos2_0 w_87_786# a_147_377# a_289_1059# w_87_786# w_87_786# pmos2
Xpmos2_1 w_87_786# a_447_377# a_289_1059# w_87_786# w_87_786# pmos2
Xpmos2_2 w_87_786# li_649_449# a_289_1059# w_87_786# w_87_786# pmos2
.ends

.subckt dffsnrnx1_pcell nand3x1_pcell_5/a_147_377# nand3x1_pcell_0/a_147_377# m1_1377_871#
+ m1_2351_575# nand3x1_pcell_4/li_649_449# m1_426_427# nand3x1_pcell_5/w_87_786# nand3x1_pcell_4/a_289_1059#
+ VSUBS nand3x1_pcell_5/a_289_1059#
Xnand3x1_pcell_0 VSUBS m1_426_427# m1_716_649# m1_831_501# VSUBS nand3x1_pcell_5/w_87_786#
+ nand3x1_pcell_0/a_147_377# nand3x1_pcell
Xnand3x1_pcell_1 VSUBS m1_1377_871# m1_1660_723# m1_716_649# VSUBS nand3x1_pcell_5/w_87_786#
+ m1_831_501# nand3x1_pcell
Xnand3x1_pcell_2 VSUBS m1_2351_575# m1_1660_723# m1_2757_501# VSUBS nand3x1_pcell_5/w_87_786#
+ m1_831_501# nand3x1_pcell
Xnand3x1_pcell_3 VSUBS m1_1377_871# m1_426_427# m1_1660_723# VSUBS nand3x1_pcell_5/w_87_786#
+ m1_2757_501# nand3x1_pcell
Xnand3x1_pcell_4 VSUBS m1_426_427# nand3x1_pcell_4/li_649_449# nand3x1_pcell_4/a_289_1059#
+ VSUBS nand3x1_pcell_5/w_87_786# m1_716_649# nand3x1_pcell
Xnand3x1_pcell_5 VSUBS m1_2351_575# m1_1660_723# nand3x1_pcell_5/a_289_1059# VSUBS
+ nand3x1_pcell_5/w_87_786# nand3x1_pcell_5/a_147_377# nand3x1_pcell
.ends

.subckt TMRDFFSNRNQNX1 Q D CLK SN RN VDD GND
Xvotern3x1_pcell_0 m1_10551_685# GND GND VDD m1_16357_463# m1_4813_537# Q GND votern3x1_pcell
Xdffsnrnx1_pcell_0 m1_4813_537# D CLK SN m1_4665_685# RN VDD m1_4813_537# GND m1_4665_685#
+ dffsnrnx1_pcell
Xdffsnrnx1_pcell_1 m1_10551_685# D CLK SN m1_10437_537# RN VDD m1_10551_685# GND m1_10437_537#
+ dffsnrnx1_pcell
Xdffsnrnx1_pcell_2 m1_16357_463# D CLK SN m1_16209_537# RN VDD m1_16357_463# GND m1_16209_537#
+ dffsnrnx1_pcell
.ends
