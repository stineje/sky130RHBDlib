* NGSPICE file created from DFFQNX1.ext - technology: sky130A

.subckt nmos_bottom a_56_54# a_86_84# a_0_0# VSUBS
X0 a_86_84# a_56_54# a_0_0# VSUBS sky130_fd_pr__nfet_01v8 ad=0.0597 pd=0.555 as=0.393 ps=2.99 w=3.01 l=0.15
.ends

.subckt nmos_top_trim1 a_86_92# a_56_62# a_0_0# VSUBS
X0 a_86_92# a_56_62# a_0_0# VSUBS sky130_fd_pr__nfet_01v8 ad=0.0597 pd=0.555 as=0.395 ps=2.97 w=3.01 l=0.15
.ends

.subckt pmos2 a_88_n400# a_144_n461# a_174_n400# a_262_n400# w_52_n436#
X0 a_262_n400# a_144_n461# a_174_n400# w_52_n436# sky130_fd_pr__pfet_01v8 ad=0.54 pd=4.54 as=0.29 ps=2.29 w=2 l=0.15
X1 a_174_n400# a_144_n461# a_88_n400# w_52_n436# sky130_fd_pr__pfet_01v8 ad=0.29 pd=2.29 as=0.56 ps=4.56 w=2 l=0.15
.ends

.subckt nand2x1_pcell a_31_480# a_362_382# a_229_1059# pmos2_1/VSUBS a_168_375# w_87_786#
Xnmos_bottom_0 a_168_375# pmos2_1/VSUBS nmos_bottom_0/a_0_0# pmos2_1/VSUBS nmos_bottom
Xnmos_top_trim1_0 a_229_1059# a_362_382# nmos_bottom_0/a_0_0# pmos2_1/VSUBS nmos_top_trim1
Xpmos2_0 w_87_786# a_168_375# a_229_1059# w_87_786# w_87_786# pmos2
Xpmos2_1 w_87_786# a_362_382# a_229_1059# w_87_786# w_87_786# pmos2
.ends

.subckt nmos_side_left a_87_91# a_0_0# a_57_61# VSUBS
X0 a_87_91# a_57_61# a_0_0# VSUBS sky130_fd_pr__nfet_01v8 ad=0.0545 pd=0.53 as=0.404 ps=3.02 w=3 l=0.15
.ends

.subckt nand3x1_pcell a_34_482# a_447_377# li_649_449# a_289_1059# w_87_786# pmos2_2/VSUBS
+ a_147_377#
Xnmos_bottom_0 a_147_377# pmos2_2/VSUBS nmos_bottom_0/a_0_0# pmos2_2/VSUBS nmos_bottom
Xnmos_top_trim1_0 a_289_1059# li_649_449# li_393_182# pmos2_2/VSUBS nmos_top_trim1
Xnmos_side_left_0 li_393_182# nmos_bottom_0/a_0_0# a_447_377# pmos2_2/VSUBS nmos_side_left
Xpmos2_0 w_87_786# a_147_377# a_289_1059# w_87_786# w_87_786# pmos2
Xpmos2_1 w_87_786# a_447_377# a_289_1059# w_87_786# w_87_786# pmos2
Xpmos2_2 w_87_786# li_649_449# a_289_1059# w_87_786# w_87_786# pmos2
.ends

.subckt dffx1_pcell nand2x1_pcell_4/a_168_375# nand2x1_pcell_0/a_362_382# nand2x1_pcell_3/a_362_382#
+ m1_427_871# nand3x1_pcell_0/w_87_786# nand2x1_pcell_3/a_229_1059# nand2x1_pcell_4/a_229_1059#
+ VSUBS
Xnand2x1_pcell_2 nand3x1_pcell_0/a_34_482# m1_427_871# m1_258_797# VSUBS m1_2165_649#
+ nand3x1_pcell_0/w_87_786# nand2x1_pcell
Xnand2x1_pcell_3 nand3x1_pcell_0/a_34_482# nand2x1_pcell_3/a_362_382# nand2x1_pcell_3/a_229_1059#
+ VSUBS m1_833_723# nand3x1_pcell_0/w_87_786# nand2x1_pcell
Xnand2x1_pcell_4 nand3x1_pcell_0/a_34_482# m1_258_797# nand2x1_pcell_4/a_229_1059#
+ VSUBS nand2x1_pcell_4/a_168_375# nand3x1_pcell_0/w_87_786# nand2x1_pcell
Xnand3x1_pcell_0 nand3x1_pcell_0/a_34_482# m1_427_871# m1_685_649# m1_833_723# nand3x1_pcell_0/w_87_786#
+ VSUBS m1_258_797# nand3x1_pcell
Xnand2x1_pcell_0 nand3x1_pcell_0/a_34_482# nand2x1_pcell_0/a_362_382# m1_685_649#
+ VSUBS m1_833_723# nand3x1_pcell_0/w_87_786# nand2x1_pcell
Xnand2x1_pcell_1 nand3x1_pcell_0/a_34_482# m1_258_797# m1_2165_649# VSUBS m1_685_649#
+ nand3x1_pcell_0/w_87_786# nand2x1_pcell
.ends

.subckt DFFQNX1 QN D CLK VDD GND
Xdffx1_pcell_0 QN D m1_3481_759# CLK VDD QN m1_3481_759# GND dffx1_pcell
.ends
