// File: inv.spi.INV.pxi
// Created: Tue Apr 29 10:49:49 2025
//
simulator lang=spectre
x_PM_INV\%A ( A N_A_c_1_p N_A_M0_noxref_g N_A_M1_noxref_g N_A_c_3_p )  PM_INV\%A
x_PM_INV\%Y ( Y N_Y_M0_noxref_d N_Y_M1_noxref_d )  PM_INV\%Y
cc_1 ( N_A_c_1_p noxref_2 ) capacitor c=0.0147639f //x=-0.119 //y=0.56 \
 //x2=-0.365 //y2=-0.205
cc_2 ( N_A_M0_noxref_g noxref_2 ) capacitor c=0.0258672f //x=0.075 //y=0.005 \
 //x2=-0.365 //y2=-0.205
cc_3 ( N_A_c_3_p noxref_2 ) capacitor c=0.00993373f //x=-0.119 //y=0.56 \
 //x2=-0.365 //y2=-0.205
cc_4 ( N_A_c_1_p noxref_3 ) capacitor c=0.0123588f //x=-0.119 //y=0.56 \
 //x2=-0.285 //y2=0.985
cc_5 ( N_A_M1_noxref_g noxref_3 ) capacitor c=0.0292754f //x=0.075 //y=1.195 \
 //x2=-0.285 //y2=0.985
cc_6 ( N_A_c_3_p noxref_3 ) capacitor c=0.00887245f //x=-0.119 //y=0.56 \
 //x2=-0.285 //y2=0.985
cc_7 ( N_A_c_1_p N_Y_M0_noxref_d ) capacitor c=0.0263512f //x=-0.119 //y=0.56 \
 //x2=0.15 //y2=-0.205
cc_8 ( N_A_M0_noxref_g N_Y_M0_noxref_d ) capacitor c=0.0693365f //x=0.075 \
 //y=0.005 //x2=0.15 //y2=-0.205
cc_9 ( N_A_c_3_p N_Y_M0_noxref_d ) capacitor c=0.00255784f //x=-0.119 //y=0.56 \
 //x2=0.15 //y2=-0.205
cc_10 ( noxref_2 noxref_3 ) capacitor c=0.0119054f //x=-0.365 //y=-0.205 \
 //x2=-0.285 //y2=0.985
cc_11 ( noxref_2 N_Y_M0_noxref_d ) capacitor c=0.0379397f //x=-0.365 \
 //y=-0.205 //x2=0.15 //y2=-0.205
cc_12 ( noxref_3 N_Y_M0_noxref_d ) capacitor c=0.0387862f //x=-0.285 //y=0.985 \
 //x2=0.15 //y2=-0.205
