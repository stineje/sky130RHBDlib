// File: VOTER3X1.spi.pex
// Created: Fri Feb 20 10:17:04 2026
// Program "Calibre xRC"
// Version "v2023.2_27.15"
// Nominal Temperature: 30C
// Circuit Temperature: 30C
//
simulator lang=spectre
subckt PM_VOTER3X1\%B ( 1 2 3 4 5 6 7 8 9 10 11 12 19 37 42 43 46 51 57 62 67 \
 68 69 70 71 72 73 74 75 76 80 82 85 86 87 88 92 93 94 95 99 101 107 108 110 \
 123 )
c239 ( 123 0 ) capacitor c=0.0692896f //x=4.93 //y=4.885
c240 ( 110 0 ) capacitor c=0.0603371f //x=1.23 //y=2.26
c241 ( 108 0 ) capacitor c=0.0344584f //x=5.265 //y=1.39
c242 ( 107 0 ) capacitor c=0.0186809f //x=5.265 //y=1.045
c243 ( 101 0 ) capacitor c=0.0141797f //x=5.11 //y=1.545
c244 ( 99 0 ) capacitor c=0.0158553f //x=5.11 //y=0.89
c245 ( 95 0 ) capacitor c=0.103881f //x=4.735 //y=2.095
c246 ( 94 0 ) capacitor c=0.0227978f //x=4.735 //y=1.7
c247 ( 93 0 ) capacitor c=0.0234352f //x=4.735 //y=1.39
c248 ( 92 0 ) capacitor c=0.0198759f //x=4.735 //y=1.045
c249 ( 88 0 ) capacitor c=0.0318956f //x=1.935 //y=1.39
c250 ( 87 0 ) capacitor c=0.0186809f //x=1.935 //y=1.045
c251 ( 86 0 ) capacitor c=0.0624333f //x=1.575 //y=4.975
c252 ( 85 0 ) capacitor c=0.0375163f //x=1.865 //y=4.975
c253 ( 82 0 ) capacitor c=0.0157936f //x=1.78 //y=1.545
c254 ( 80 0 ) capacitor c=0.0158553f //x=1.78 //y=0.89
c255 ( 76 0 ) capacitor c=0.0302441f //x=1.405 //y=2.095
c256 ( 75 0 ) capacitor c=0.0238107f //x=1.405 //y=1.7
c257 ( 74 0 ) capacitor c=0.0234359f //x=1.405 //y=1.39
c258 ( 73 0 ) capacitor c=0.0199332f //x=1.405 //y=1.045
c259 ( 72 0 ) capacitor c=0.111167f //x=5.26 //y=6.205
c260 ( 71 0 ) capacitor c=0.154978f //x=4.82 //y=6.205
c261 ( 70 0 ) capacitor c=0.110282f //x=1.94 //y=6.205
c262 ( 69 0 ) capacitor c=0.155219f //x=1.5 //y=6.205
c263 ( 62 0 ) capacitor c=0.0156727f //x=4.93 //y=4.62
c264 ( 57 0 ) capacitor c=0.00126053f //x=4.93 //y=2.26
c265 ( 51 0 ) capacitor c=0.0125733f //x=1.23 //y=4.62
c266 ( 46 0 ) capacitor c=7.43216e-19 //x=1.23 //y=2.26
c267 ( 43 0 ) capacitor c=0.0876578f //x=4.775 //y=4.64
c268 ( 42 0 ) capacitor c=0.00642399f //x=4.935 //y=4.64
c269 ( 37 0 ) capacitor c=0.00920482f //x=1.395 //y=4.62
c270 ( 19 0 ) capacitor c=0.00888199f //x=4.93 //y=2.385
c271 ( 12 0 ) capacitor c=0.0100386f //x=1.23 //y=2.375
c272 ( 11 0 ) capacitor c=0.0127992f //x=4.93 //y=4.62
c273 ( 10 0 ) capacitor c=0.0139929f //x=1.23 //y=4.62
c274 ( 6 0 ) capacitor c=0.0851523f //x=4.93 //y=2.77
c275 ( 1 0 ) capacitor c=0.0996103f //x=1.23 //y=2.77
r276 (  121 123 ) resistor r=22.7554 //w=0.233 //l=0.11 //layer=ply \
 //thickness=0.18 //x=4.82 //y=4.885 //x2=4.93 //y2=4.885
r277 (  108 125 ) resistor r=45.1352 //w=0.168 //l=0.173853 //layer=ply \
 //thickness=0.18 //x=5.265 //y=1.39 //x2=5.225 //y2=1.545
r278 (  107 124 ) resistor r=45.1352 //w=0.168 //l=0.173853 //layer=ply \
 //thickness=0.18 //x=5.265 //y=1.045 //x2=5.225 //y2=0.89
r279 (  107 108 ) resistor r=176.904 //w=0.094 //l=0.345 //layer=ply \
 //thickness=0.18 //x=5.265 //y=1.045 //x2=5.265 //y2=1.39
r280 (  104 123 ) resistor r=68.2661 //w=0.233 //l=0.404166 //layer=ply \
 //thickness=0.18 //x=5.26 //y=5.05 //x2=4.93 //y2=4.885
r281 (  102 120 ) resistor r=10.701 //w=0.21 //l=0.115 //layer=ply \
 //thickness=0.18 //x=4.89 //y=1.545 //x2=4.775 //y2=1.545
r282 (  101 125 ) resistor r=5.52526 //w=0.168 //l=0.115 //layer=ply \
 //thickness=0.18 //x=5.11 //y=1.545 //x2=5.225 //y2=1.545
r283 (  100 119 ) resistor r=5.52526 //w=0.168 //l=0.115 //layer=ply \
 //thickness=0.18 //x=4.89 //y=0.89 //x2=4.775 //y2=0.89
r284 (  99 124 ) resistor r=5.52526 //w=0.168 //l=0.115 //layer=ply \
 //thickness=0.18 //x=5.11 //y=0.89 //x2=5.225 //y2=0.89
r285 (  99 100 ) resistor r=112.809 //w=0.094 //l=0.22 //layer=ply \
 //thickness=0.18 //x=5.11 //y=0.89 //x2=4.89 //y2=0.89
r286 (  96 121 ) resistor r=13.0941 //w=0.233 //l=0.165 //layer=ply \
 //thickness=0.18 //x=4.82 //y=5.05 //x2=4.82 //y2=4.885
r287 (  95 118 ) resistor r=34.8111 //w=0.27 //l=0.264953 //layer=ply \
 //thickness=0.18 //x=4.735 //y=2.095 //x2=4.93 //y2=2.26
r288 (  94 120 ) resistor r=39.5823 //w=0.21 //l=0.173853 //layer=ply \
 //thickness=0.18 //x=4.735 //y=1.7 //x2=4.775 //y2=1.545
r289 (  94 95 ) resistor r=202.543 //w=0.094 //l=0.395 //layer=ply \
 //thickness=0.18 //x=4.735 //y=1.7 //x2=4.735 //y2=2.095
r290 (  93 120 ) resistor r=39.5823 //w=0.21 //l=0.173853 //layer=ply \
 //thickness=0.18 //x=4.735 //y=1.39 //x2=4.775 //y2=1.545
r291 (  92 119 ) resistor r=45.1352 //w=0.168 //l=0.173853 //layer=ply \
 //thickness=0.18 //x=4.735 //y=1.045 //x2=4.775 //y2=0.89
r292 (  92 93 ) resistor r=176.904 //w=0.094 //l=0.345 //layer=ply \
 //thickness=0.18 //x=4.735 //y=1.045 //x2=4.735 //y2=1.39
r293 (  88 116 ) resistor r=45.1352 //w=0.168 //l=0.173853 //layer=ply \
 //thickness=0.18 //x=1.935 //y=1.39 //x2=1.895 //y2=1.545
r294 (  87 115 ) resistor r=45.1352 //w=0.168 //l=0.173853 //layer=ply \
 //thickness=0.18 //x=1.935 //y=1.045 //x2=1.895 //y2=0.89
r295 (  87 88 ) resistor r=176.904 //w=0.094 //l=0.345 //layer=ply \
 //thickness=0.18 //x=1.935 //y=1.045 //x2=1.935 //y2=1.39
r296 (  85 89 ) resistor r=26.9307 //w=0.15 //l=0.106066 //layer=ply \
 //thickness=0.18 //x=1.865 //y=4.975 //x2=1.94 //y2=5.05
r297 (  85 86 ) resistor r=148.702 //w=0.094 //l=0.29 //layer=ply \
 //thickness=0.18 //x=1.865 //y=4.975 //x2=1.575 //y2=4.975
r298 (  83 114 ) resistor r=10.701 //w=0.21 //l=0.115 //layer=ply \
 //thickness=0.18 //x=1.56 //y=1.545 //x2=1.445 //y2=1.545
r299 (  82 116 ) resistor r=5.52526 //w=0.168 //l=0.115 //layer=ply \
 //thickness=0.18 //x=1.78 //y=1.545 //x2=1.895 //y2=1.545
r300 (  81 113 ) resistor r=5.52526 //w=0.168 //l=0.115 //layer=ply \
 //thickness=0.18 //x=1.56 //y=0.89 //x2=1.445 //y2=0.89
r301 (  80 115 ) resistor r=5.52526 //w=0.168 //l=0.115 //layer=ply \
 //thickness=0.18 //x=1.78 //y=0.89 //x2=1.895 //y2=0.89
r302 (  80 81 ) resistor r=112.809 //w=0.094 //l=0.22 //layer=ply \
 //thickness=0.18 //x=1.78 //y=0.89 //x2=1.56 //y2=0.89
r303 (  77 86 ) resistor r=22.1787 //w=0.252 //l=0.106066 //layer=ply \
 //thickness=0.18 //x=1.5 //y=5.05 //x2=1.575 //y2=4.975
r304 (  77 112 ) resistor r=51.6429 //w=0.252 //l=0.34271 //layer=ply \
 //thickness=0.18 //x=1.5 //y=5.05 //x2=1.23 //y2=4.885
r305 (  76 110 ) resistor r=30.4513 //w=0.277 //l=0.243926 //layer=ply \
 //thickness=0.18 //x=1.405 //y=2.095 //x2=1.23 //y2=2.26
r306 (  75 114 ) resistor r=39.5823 //w=0.21 //l=0.173853 //layer=ply \
 //thickness=0.18 //x=1.405 //y=1.7 //x2=1.445 //y2=1.545
r307 (  75 76 ) resistor r=202.543 //w=0.094 //l=0.395 //layer=ply \
 //thickness=0.18 //x=1.405 //y=1.7 //x2=1.405 //y2=2.095
r308 (  74 114 ) resistor r=39.5823 //w=0.21 //l=0.173853 //layer=ply \
 //thickness=0.18 //x=1.405 //y=1.39 //x2=1.445 //y2=1.545
r309 (  73 113 ) resistor r=45.1352 //w=0.168 //l=0.173853 //layer=ply \
 //thickness=0.18 //x=1.405 //y=1.045 //x2=1.445 //y2=0.89
r310 (  73 74 ) resistor r=176.904 //w=0.094 //l=0.345 //layer=ply \
 //thickness=0.18 //x=1.405 //y=1.045 //x2=1.405 //y2=1.39
r311 (  72 104 ) resistor r=592.245 //w=0.094 //l=1.155 //layer=ply \
 //thickness=0.18 //x=5.26 //y=6.205 //x2=5.26 //y2=5.05
r312 (  71 96 ) resistor r=592.245 //w=0.094 //l=1.155 //layer=ply \
 //thickness=0.18 //x=4.82 //y=6.205 //x2=4.82 //y2=5.05
r313 (  70 89 ) resistor r=592.245 //w=0.094 //l=1.155 //layer=ply \
 //thickness=0.18 //x=1.94 //y=6.205 //x2=1.94 //y2=5.05
r314 (  69 77 ) resistor r=592.245 //w=0.094 //l=1.155 //layer=ply \
 //thickness=0.18 //x=1.5 //y=6.205 //x2=1.5 //y2=5.05
r315 (  68 101 ) resistor r=56.4043 //w=0.094 //l=0.11 //layer=ply \
 //thickness=0.18 //x=5 //y=1.545 //x2=5.11 //y2=1.545
r316 (  68 102 ) resistor r=56.4043 //w=0.094 //l=0.11 //layer=ply \
 //thickness=0.18 //x=5 //y=1.545 //x2=4.89 //y2=1.545
r317 (  67 82 ) resistor r=56.4043 //w=0.094 //l=0.11 //layer=ply \
 //thickness=0.18 //x=1.67 //y=1.545 //x2=1.78 //y2=1.545
r318 (  67 83 ) resistor r=56.4043 //w=0.094 //l=0.11 //layer=ply \
 //thickness=0.18 //x=1.67 //y=1.545 //x2=1.56 //y2=1.545
r319 (  65 123 ) resistor r=152 //w=0.17 //l=0.17 //layer=licon //count=1 \
 //x=4.93 //y=4.885 //x2=4.93 //y2=4.885
r320 (  62 65 ) resistor r=18.139 //w=0.187 //l=0.265 //layer=li \
 //thickness=0.1 //x=4.93 //y=4.62 //x2=4.93 //y2=4.885
r321 (  57 118 ) resistor r=152 //w=0.17 //l=0.17 //layer=licon //count=1 \
 //x=4.93 //y=2.26 //x2=4.93 //y2=2.26
r322 (  54 112 ) resistor r=152 //w=0.17 //l=0.17 //layer=licon //count=1 \
 //x=1.23 //y=4.885 //x2=1.23 //y2=4.885
r323 (  51 54 ) resistor r=18.139 //w=0.187 //l=0.265 //layer=li \
 //thickness=0.1 //x=1.23 //y=4.62 //x2=1.23 //y2=4.885
r324 (  46 110 ) resistor r=152 //w=0.17 //l=0.17 //layer=licon //count=1 \
 //x=1.23 //y=2.26 //x2=1.23 //y2=2.26
r325 (  42 43 ) resistor r=0.10734 //w=0.281 //l=0.16 //layer=m2 \
 //thickness=0.36 //x=4.935 //y=4.64 //x2=4.775 //y2=4.64
r326 (  37 39 ) resistor r=0.10734 //w=0.281 //l=0.16 //layer=m2 \
 //thickness=0.36 //x=1.395 //y=4.62 //x2=1.235 //y2=4.62
r327 (  37 43 ) resistor r=3.22519 //w=0.131 //l=3.38 //layer=m2 \
 //thickness=0.36 //x=1.395 //y=4.62 //x2=4.775 //y2=4.62
r328 (  35 57 ) resistor r=9.3 //w=0.17 //l=0.17 //layer=mcon //count=1 \
 //x=4.93 //y=2.26 //x2=4.93 //y2=2.26
r329 (  33 42 ) resistor r=4.5 //w=0.15 //l=0.15 //layer=via1 //count=1 \
 //x=4.935 //y=4.64 //x2=4.935 //y2=4.64
r330 (  26 46 ) resistor r=9.3 //w=0.17 //l=0.17 //layer=mcon //count=1 \
 //x=1.23 //y=2.26 //x2=1.23 //y2=2.26
r331 (  19 35 ) resistor r=0.0761125 //w=0.237 //l=0.126491 //layer=m1 \
 //thickness=0.36 //x=4.93 //y=2.385 //x2=4.927 //y2=2.26
r332 (  12 26 ) resistor r=0.0717383 //w=0.224 //l=0.115 //layer=m1 \
 //thickness=0.36 //x=1.23 //y=2.375 //x2=1.23 //y2=2.26
r333 (  11 62 ) resistor r=9.3 //w=0.17 //l=0.17 //layer=mcon //count=1 \
 //x=4.93 //y=4.62 //x2=4.93 //y2=4.62
r334 (  11 33 ) resistor r=0.00659631 //w=0.379 //l=0.02 //layer=m1 \
 //thickness=0.36 //x=4.88 //y=4.62 //x2=4.88 //y2=4.64
r335 (  11 20 ) resistor r=0.0863342 //w=0.379 //l=0.168152 //layer=m1 \
 //thickness=0.36 //x=4.88 //y=4.62 //x2=4.93 //y2=4.475
r336 (  10 51 ) resistor r=9.3 //w=0.17 //l=0.17 //layer=mcon //count=1 \
 //x=1.23 //y=4.62 //x2=1.23 //y2=4.62
r337 (  10 39 ) resistor r=4.5 //w=0.15 //l=0.15 //layer=via1 //count=1 \
 //x=1.235 //y=4.62 //x2=1.235 //y2=4.62
r338 (  10 13 ) resistor r=0.0898201 //w=0.322 //l=0.185472 //layer=m1 \
 //thickness=0.36 //x=1.285 //y=4.62 //x2=1.23 //y2=4.46
r339 (  9 20 ) resistor r=0.567748 //w=0.131 //l=0.595 //layer=m1 \
 //thickness=0.36 //x=4.93 //y=3.88 //x2=4.93 //y2=4.475
r340 (  8 9 ) resistor r=0.353053 //w=0.131 //l=0.37 //layer=m1 \
 //thickness=0.36 //x=4.93 //y=3.51 //x2=4.93 //y2=3.88
r341 (  7 8 ) resistor r=0.353053 //w=0.131 //l=0.37 //layer=m1 \
 //thickness=0.36 //x=4.93 //y=3.14 //x2=4.93 //y2=3.51
r342 (  6 7 ) resistor r=0.353053 //w=0.131 //l=0.37 //layer=m1 \
 //thickness=0.36 //x=4.93 //y=2.77 //x2=4.93 //y2=3.14
r343 (  6 19 ) resistor r=0.367366 //w=0.131 //l=0.385 //layer=m1 \
 //thickness=0.36 //x=4.93 //y=2.77 //x2=4.93 //y2=2.385
r344 (  5 13 ) resistor r=0.200382 //w=0.131 //l=0.21 //layer=m1 \
 //thickness=0.36 //x=1.23 //y=4.25 //x2=1.23 //y2=4.46
r345 (  4 5 ) resistor r=0.353053 //w=0.131 //l=0.37 //layer=m1 \
 //thickness=0.36 //x=1.23 //y=3.88 //x2=1.23 //y2=4.25
r346 (  3 4 ) resistor r=0.353053 //w=0.131 //l=0.37 //layer=m1 \
 //thickness=0.36 //x=1.23 //y=3.51 //x2=1.23 //y2=3.88
r347 (  2 3 ) resistor r=0.353053 //w=0.131 //l=0.37 //layer=m1 \
 //thickness=0.36 //x=1.23 //y=3.14 //x2=1.23 //y2=3.51
r348 (  1 2 ) resistor r=0.353053 //w=0.131 //l=0.37 //layer=m1 \
 //thickness=0.36 //x=1.23 //y=2.77 //x2=1.23 //y2=3.14
r349 (  1 12 ) resistor r=0.376908 //w=0.131 //l=0.395 //layer=m1 \
 //thickness=0.36 //x=1.23 //y=2.77 //x2=1.23 //y2=2.375
ends PM_VOTER3X1\%B

subckt PM_VOTER3X1\%C ( 1 2 3 4 5 6 7 8 9 10 11 12 18 19 42 44 45 48 53 58 63 \
 67 68 69 70 71 72 76 77 78 79 80 82 85 88 89 90 91 92 93 94 95 99 101 104 105 \
 106 107 120 )
c238 ( 120 0 ) capacitor c=0.0586737f //x=7.89 //y=2.26
c239 ( 107 0 ) capacitor c=0.0318956f //x=8.595 //y=1.39
c240 ( 106 0 ) capacitor c=0.0186809f //x=8.595 //y=1.045
c241 ( 105 0 ) capacitor c=0.0659968f //x=8.235 //y=4.975
c242 ( 104 0 ) capacitor c=0.0373387f //x=8.525 //y=4.975
c243 ( 101 0 ) capacitor c=0.0157936f //x=8.44 //y=1.545
c244 ( 99 0 ) capacitor c=0.0158553f //x=8.44 //y=0.89
c245 ( 95 0 ) capacitor c=0.0302441f //x=8.065 //y=2.095
c246 ( 94 0 ) capacitor c=0.0238107f //x=8.065 //y=1.7
c247 ( 93 0 ) capacitor c=0.0234359f //x=8.065 //y=1.39
c248 ( 92 0 ) capacitor c=0.0199332f //x=8.065 //y=1.045
c249 ( 91 0 ) capacitor c=0.0972519f //x=6.235 //y=2.095
c250 ( 90 0 ) capacitor c=0.0251353f //x=6.235 //y=1.74
c251 ( 89 0 ) capacitor c=0.0234318f //x=6.235 //y=1.43
c252 ( 88 0 ) capacitor c=0.0192547f //x=6.235 //y=1.085
c253 ( 85 0 ) capacitor c=0.0714656f //x=6.14 //y=5.05
c254 ( 82 0 ) capacitor c=0.0186579f //x=6.08 //y=1.585
c255 ( 80 0 ) capacitor c=0.0157803f //x=6.08 //y=0.93
c256 ( 79 0 ) capacitor c=0.0134011f //x=5.775 //y=4.975
c257 ( 78 0 ) capacitor c=0.0243282f //x=6.065 //y=4.975
c258 ( 77 0 ) capacitor c=0.0364928f //x=5.705 //y=1.43
c259 ( 76 0 ) capacitor c=0.0174823f //x=5.705 //y=1.085
c260 ( 72 0 ) capacitor c=0.11081f //x=8.6 //y=6.205
c261 ( 71 0 ) capacitor c=0.154997f //x=8.16 //y=6.205
c262 ( 70 0 ) capacitor c=0.155934f //x=6.14 //y=6.205
c263 ( 69 0 ) capacitor c=0.110594f //x=5.7 //y=6.205
c264 ( 63 0 ) capacitor c=7.7962e-19 //x=7.89 //y=4.885
c265 ( 58 0 ) capacitor c=7.89145e-19 //x=7.89 //y=2.26
c266 ( 53 0 ) capacitor c=7.79163e-19 //x=6.41 //y=4.885
c267 ( 48 0 ) capacitor c=7.43216e-19 //x=6.41 //y=2.26
c268 ( 45 0 ) capacitor c=0.0208859f //x=7.725 //y=2.27
c269 ( 44 0 ) capacitor c=0.00247225f //x=7.885 //y=2.27
c270 ( 42 0 ) capacitor c=0.0031771f //x=6.575 //y=2.27
c271 ( 19 0 ) capacitor c=0.00623797f //x=7.89 //y=4.755
c272 ( 18 0 ) capacitor c=0.00995077f //x=7.89 //y=2.43
c273 ( 12 0 ) capacitor c=0.00859821f //x=6.41 //y=4.76
c274 ( 11 0 ) capacitor c=0.0102822f //x=6.41 //y=2.43
c275 ( 6 0 ) capacitor c=0.0720757f //x=7.89 //y=2.77
c276 ( 1 0 ) capacitor c=0.0779094f //x=6.41 //y=2.77
r277 (  107 126 ) resistor r=45.1352 //w=0.168 //l=0.173853 //layer=ply \
 //thickness=0.18 //x=8.595 //y=1.39 //x2=8.555 //y2=1.545
r278 (  106 125 ) resistor r=45.1352 //w=0.168 //l=0.173853 //layer=ply \
 //thickness=0.18 //x=8.595 //y=1.045 //x2=8.555 //y2=0.89
r279 (  106 107 ) resistor r=176.904 //w=0.094 //l=0.345 //layer=ply \
 //thickness=0.18 //x=8.595 //y=1.045 //x2=8.595 //y2=1.39
r280 (  104 108 ) resistor r=26.9307 //w=0.15 //l=0.106066 //layer=ply \
 //thickness=0.18 //x=8.525 //y=4.975 //x2=8.6 //y2=5.05
r281 (  104 105 ) resistor r=148.702 //w=0.094 //l=0.29 //layer=ply \
 //thickness=0.18 //x=8.525 //y=4.975 //x2=8.235 //y2=4.975
r282 (  102 124 ) resistor r=10.701 //w=0.21 //l=0.115 //layer=ply \
 //thickness=0.18 //x=8.22 //y=1.545 //x2=8.105 //y2=1.545
r283 (  101 126 ) resistor r=5.52526 //w=0.168 //l=0.115 //layer=ply \
 //thickness=0.18 //x=8.44 //y=1.545 //x2=8.555 //y2=1.545
r284 (  100 123 ) resistor r=5.52526 //w=0.168 //l=0.115 //layer=ply \
 //thickness=0.18 //x=8.22 //y=0.89 //x2=8.105 //y2=0.89
r285 (  99 125 ) resistor r=5.52526 //w=0.168 //l=0.115 //layer=ply \
 //thickness=0.18 //x=8.44 //y=0.89 //x2=8.555 //y2=0.89
r286 (  99 100 ) resistor r=112.809 //w=0.094 //l=0.22 //layer=ply \
 //thickness=0.18 //x=8.44 //y=0.89 //x2=8.22 //y2=0.89
r287 (  96 105 ) resistor r=22.1787 //w=0.252 //l=0.106066 //layer=ply \
 //thickness=0.18 //x=8.16 //y=5.05 //x2=8.235 //y2=4.975
r288 (  96 122 ) resistor r=51.6429 //w=0.252 //l=0.34271 //layer=ply \
 //thickness=0.18 //x=8.16 //y=5.05 //x2=7.89 //y2=4.885
r289 (  95 120 ) resistor r=30.4513 //w=0.277 //l=0.243926 //layer=ply \
 //thickness=0.18 //x=8.065 //y=2.095 //x2=7.89 //y2=2.26
r290 (  94 124 ) resistor r=39.5823 //w=0.21 //l=0.173853 //layer=ply \
 //thickness=0.18 //x=8.065 //y=1.7 //x2=8.105 //y2=1.545
r291 (  94 95 ) resistor r=202.543 //w=0.094 //l=0.395 //layer=ply \
 //thickness=0.18 //x=8.065 //y=1.7 //x2=8.065 //y2=2.095
r292 (  93 124 ) resistor r=39.5823 //w=0.21 //l=0.173853 //layer=ply \
 //thickness=0.18 //x=8.065 //y=1.39 //x2=8.105 //y2=1.545
r293 (  92 123 ) resistor r=45.1352 //w=0.168 //l=0.173853 //layer=ply \
 //thickness=0.18 //x=8.065 //y=1.045 //x2=8.105 //y2=0.89
r294 (  92 93 ) resistor r=176.904 //w=0.094 //l=0.345 //layer=ply \
 //thickness=0.18 //x=8.065 //y=1.045 //x2=8.065 //y2=1.39
r295 (  91 116 ) resistor r=30.4513 //w=0.277 //l=0.243926 //layer=ply \
 //thickness=0.18 //x=6.235 //y=2.095 //x2=6.41 //y2=2.26
r296 (  90 114 ) resistor r=39.5823 //w=0.21 //l=0.173853 //layer=ply \
 //thickness=0.18 //x=6.235 //y=1.74 //x2=6.195 //y2=1.585
r297 (  90 91 ) resistor r=182.032 //w=0.094 //l=0.355 //layer=ply \
 //thickness=0.18 //x=6.235 //y=1.74 //x2=6.235 //y2=2.095
r298 (  89 114 ) resistor r=39.5823 //w=0.21 //l=0.173853 //layer=ply \
 //thickness=0.18 //x=6.235 //y=1.43 //x2=6.195 //y2=1.585
r299 (  88 113 ) resistor r=45.1352 //w=0.168 //l=0.173853 //layer=ply \
 //thickness=0.18 //x=6.235 //y=1.085 //x2=6.195 //y2=0.93
r300 (  88 89 ) resistor r=176.904 //w=0.094 //l=0.345 //layer=ply \
 //thickness=0.18 //x=6.235 //y=1.085 //x2=6.235 //y2=1.43
r301 (  85 118 ) resistor r=51.6429 //w=0.252 //l=0.34271 //layer=ply \
 //thickness=0.18 //x=6.14 //y=5.05 //x2=6.41 //y2=4.885
r302 (  83 112 ) resistor r=5.52526 //w=0.168 //l=0.115 //layer=ply \
 //thickness=0.18 //x=5.86 //y=1.585 //x2=5.745 //y2=1.585
r303 (  82 114 ) resistor r=10.701 //w=0.21 //l=0.115 //layer=ply \
 //thickness=0.18 //x=6.08 //y=1.585 //x2=6.195 //y2=1.585
r304 (  81 111 ) resistor r=5.52526 //w=0.168 //l=0.115 //layer=ply \
 //thickness=0.18 //x=5.86 //y=0.93 //x2=5.745 //y2=0.93
r305 (  80 113 ) resistor r=5.52526 //w=0.168 //l=0.115 //layer=ply \
 //thickness=0.18 //x=6.08 //y=0.93 //x2=6.195 //y2=0.93
r306 (  80 81 ) resistor r=112.809 //w=0.094 //l=0.22 //layer=ply \
 //thickness=0.18 //x=6.08 //y=0.93 //x2=5.86 //y2=0.93
r307 (  78 85 ) resistor r=22.1787 //w=0.252 //l=0.106066 //layer=ply \
 //thickness=0.18 //x=6.065 //y=4.975 //x2=6.14 //y2=5.05
r308 (  78 79 ) resistor r=148.702 //w=0.094 //l=0.29 //layer=ply \
 //thickness=0.18 //x=6.065 //y=4.975 //x2=5.775 //y2=4.975
r309 (  77 112 ) resistor r=45.1352 //w=0.168 //l=0.173853 //layer=ply \
 //thickness=0.18 //x=5.705 //y=1.43 //x2=5.745 //y2=1.585
r310 (  76 111 ) resistor r=45.1352 //w=0.168 //l=0.173853 //layer=ply \
 //thickness=0.18 //x=5.705 //y=1.085 //x2=5.745 //y2=0.93
r311 (  76 77 ) resistor r=176.904 //w=0.094 //l=0.345 //layer=ply \
 //thickness=0.18 //x=5.705 //y=1.085 //x2=5.705 //y2=1.43
r312 (  73 79 ) resistor r=26.9307 //w=0.15 //l=0.106066 //layer=ply \
 //thickness=0.18 //x=5.7 //y=5.05 //x2=5.775 //y2=4.975
r313 (  72 108 ) resistor r=592.245 //w=0.094 //l=1.155 //layer=ply \
 //thickness=0.18 //x=8.6 //y=6.205 //x2=8.6 //y2=5.05
r314 (  71 96 ) resistor r=592.245 //w=0.094 //l=1.155 //layer=ply \
 //thickness=0.18 //x=8.16 //y=6.205 //x2=8.16 //y2=5.05
r315 (  70 85 ) resistor r=592.245 //w=0.094 //l=1.155 //layer=ply \
 //thickness=0.18 //x=6.14 //y=6.205 //x2=6.14 //y2=5.05
r316 (  69 73 ) resistor r=592.245 //w=0.094 //l=1.155 //layer=ply \
 //thickness=0.18 //x=5.7 //y=6.205 //x2=5.7 //y2=5.05
r317 (  68 101 ) resistor r=56.4043 //w=0.094 //l=0.11 //layer=ply \
 //thickness=0.18 //x=8.33 //y=1.545 //x2=8.44 //y2=1.545
r318 (  68 102 ) resistor r=56.4043 //w=0.094 //l=0.11 //layer=ply \
 //thickness=0.18 //x=8.33 //y=1.545 //x2=8.22 //y2=1.545
r319 (  67 82 ) resistor r=56.4043 //w=0.094 //l=0.11 //layer=ply \
 //thickness=0.18 //x=5.97 //y=1.585 //x2=6.08 //y2=1.585
r320 (  67 83 ) resistor r=56.4043 //w=0.094 //l=0.11 //layer=ply \
 //thickness=0.18 //x=5.97 //y=1.585 //x2=5.86 //y2=1.585
r321 (  63 122 ) resistor r=152 //w=0.17 //l=0.17 //layer=licon //count=1 \
 //x=7.89 //y=4.885 //x2=7.89 //y2=4.885
r322 (  58 120 ) resistor r=152 //w=0.17 //l=0.17 //layer=licon //count=1 \
 //x=7.89 //y=2.26 //x2=7.89 //y2=2.26
r323 (  53 118 ) resistor r=152 //w=0.17 //l=0.17 //layer=licon //count=1 \
 //x=6.41 //y=4.885 //x2=6.41 //y2=4.885
r324 (  48 116 ) resistor r=152 //w=0.17 //l=0.17 //layer=licon //count=1 \
 //x=6.41 //y=2.26 //x2=6.41 //y2=2.26
r325 (  44 45 ) resistor r=0.10734 //w=0.281 //l=0.16 //layer=m2 \
 //thickness=0.36 //x=7.885 //y=2.27 //x2=7.725 //y2=2.27
r326 (  42 45 ) resistor r=1.09733 //w=0.131 //l=1.15 //layer=m2 \
 //thickness=0.36 //x=6.575 //y=2.26 //x2=7.725 //y2=2.26
r327 (  40 42 ) resistor r=0.10734 //w=0.281 //l=0.16 //layer=m2 \
 //thickness=0.36 //x=6.415 //y=2.27 //x2=6.575 //y2=2.27
r328 (  36 63 ) resistor r=9.3 //w=0.17 //l=0.17 //layer=mcon //count=1 \
 //x=7.89 //y=4.885 //x2=7.89 //y2=4.885
r329 (  34 44 ) resistor r=4.5 //w=0.15 //l=0.15 //layer=via1 //count=1 \
 //x=7.885 //y=2.27 //x2=7.885 //y2=2.27
r330 (  32 58 ) resistor r=9.3 //w=0.17 //l=0.17 //layer=mcon //count=1 \
 //x=7.89 //y=2.26 //x2=7.89 //y2=2.26
r331 (  32 34 ) resistor r=0.00334225 //w=0.374 //l=0.01 //layer=m1 \
 //thickness=0.36 //x=7.835 //y=2.26 //x2=7.835 //y2=2.27
r332 (  30 40 ) resistor r=4.5 //w=0.15 //l=0.15 //layer=via1 //count=1 \
 //x=6.415 //y=2.27 //x2=6.415 //y2=2.27
r333 (  28 48 ) resistor r=9.3 //w=0.17 //l=0.17 //layer=mcon //count=1 \
 //x=6.41 //y=2.26 //x2=6.41 //y2=2.26
r334 (  28 30 ) resistor r=0.00334225 //w=0.374 //l=0.01 //layer=m1 \
 //thickness=0.36 //x=6.465 //y=2.26 //x2=6.465 //y2=2.27
r335 (  26 53 ) resistor r=9.3 //w=0.17 //l=0.17 //layer=mcon //count=1 \
 //x=6.41 //y=4.885 //x2=6.41 //y2=4.885
r336 (  19 36 ) resistor r=0.0777782 //w=0.252 //l=0.131491 //layer=m1 \
 //thickness=0.36 //x=7.89 //y=4.755 //x2=7.887 //y2=4.885
r337 (  18 34 ) resistor r=0.0910802 //w=0.374 //l=0.185472 //layer=m1 \
 //thickness=0.36 //x=7.89 //y=2.43 //x2=7.835 //y2=2.27
r338 (  12 26 ) resistor r=0.075298 //w=0.252 //l=0.125 //layer=m1 \
 //thickness=0.36 //x=6.41 //y=4.76 //x2=6.41 //y2=4.885
r339 (  11 30 ) resistor r=0.0910802 //w=0.374 //l=0.185472 //layer=m1 \
 //thickness=0.36 //x=6.41 //y=2.43 //x2=6.465 //y2=2.27
r340 (  10 19 ) resistor r=0.128817 //w=0.131 //l=0.135 //layer=m1 \
 //thickness=0.36 //x=7.89 //y=4.62 //x2=7.89 //y2=4.755
r341 (  9 10 ) resistor r=0.706107 //w=0.131 //l=0.74 //layer=m1 \
 //thickness=0.36 //x=7.89 //y=3.88 //x2=7.89 //y2=4.62
r342 (  8 9 ) resistor r=0.353053 //w=0.131 //l=0.37 //layer=m1 \
 //thickness=0.36 //x=7.89 //y=3.51 //x2=7.89 //y2=3.88
r343 (  7 8 ) resistor r=0.353053 //w=0.131 //l=0.37 //layer=m1 \
 //thickness=0.36 //x=7.89 //y=3.14 //x2=7.89 //y2=3.51
r344 (  6 7 ) resistor r=0.353053 //w=0.131 //l=0.37 //layer=m1 \
 //thickness=0.36 //x=7.89 //y=2.77 //x2=7.89 //y2=3.14
r345 (  6 18 ) resistor r=0.324427 //w=0.131 //l=0.34 //layer=m1 \
 //thickness=0.36 //x=7.89 //y=2.77 //x2=7.89 //y2=2.43
r346 (  5 12 ) resistor r=0.133588 //w=0.131 //l=0.14 //layer=m1 \
 //thickness=0.36 //x=6.41 //y=4.62 //x2=6.41 //y2=4.76
r347 (  4 5 ) resistor r=0.706107 //w=0.131 //l=0.74 //layer=m1 \
 //thickness=0.36 //x=6.41 //y=3.88 //x2=6.41 //y2=4.62
r348 (  3 4 ) resistor r=0.353053 //w=0.131 //l=0.37 //layer=m1 \
 //thickness=0.36 //x=6.41 //y=3.51 //x2=6.41 //y2=3.88
r349 (  2 3 ) resistor r=0.353053 //w=0.131 //l=0.37 //layer=m1 \
 //thickness=0.36 //x=6.41 //y=3.14 //x2=6.41 //y2=3.51
r350 (  1 2 ) resistor r=0.353053 //w=0.131 //l=0.37 //layer=m1 \
 //thickness=0.36 //x=6.41 //y=2.77 //x2=6.41 //y2=3.14
r351 (  1 11 ) resistor r=0.324427 //w=0.131 //l=0.34 //layer=m1 \
 //thickness=0.36 //x=6.41 //y=2.77 //x2=6.41 //y2=2.43
ends PM_VOTER3X1\%C

subckt PM_VOTER3X1\%A ( 1 2 3 4 5 6 7 8 9 10 11 12 18 19 20 26 27 50 52 53 56 \
 65 70 79 83 84 85 86 87 88 89 90 91 96 98 100 106 107 108 109 110 115 117 119 \
 125 126 128 129 132 140 141 144 )
c295 ( 144 0 ) capacitor c=0.0370698f //x=9.02 //y=4.885
c296 ( 141 0 ) capacitor c=0.028421f //x=9 //y=2.095
c297 ( 140 0 ) capacitor c=0.0512002f //x=9 //y=2.26
c298 ( 132 0 ) capacitor c=0.0387879f //x=2.38 //y=4.885
c299 ( 129 0 ) capacitor c=0.0300885f //x=2.34 //y=2.095
c300 ( 128 0 ) capacitor c=0.0554483f //x=2.34 //y=2.26
c301 ( 126 0 ) capacitor c=0.0237734f //x=9.565 //y=1.435
c302 ( 125 0 ) capacitor c=0.0191782f //x=9.565 //y=1.085
c303 ( 119 0 ) capacitor c=0.0361171f //x=9.41 //y=1.585
c304 ( 117 0 ) capacitor c=0.0157803f //x=9.41 //y=0.93
c305 ( 115 0 ) capacitor c=0.0377178f //x=9.405 //y=4.975
c306 ( 110 0 ) capacitor c=0.020493f //x=9.035 //y=1.74
c307 ( 109 0 ) capacitor c=0.0167049f //x=9.035 //y=1.435
c308 ( 108 0 ) capacitor c=0.0174993f //x=9.035 //y=1.085
c309 ( 107 0 ) capacitor c=0.0443648f //x=2.905 //y=1.43
c310 ( 106 0 ) capacitor c=0.0192211f //x=2.905 //y=1.085
c311 ( 100 0 ) capacitor c=0.0186579f //x=2.75 //y=1.585
c312 ( 98 0 ) capacitor c=0.0157795f //x=2.75 //y=0.93
c313 ( 96 0 ) capacitor c=0.0351351f //x=2.745 //y=4.975
c314 ( 91 0 ) capacitor c=0.0209124f //x=2.375 //y=1.74
c315 ( 90 0 ) capacitor c=0.016848f //x=2.375 //y=1.43
c316 ( 89 0 ) capacitor c=0.0174777f //x=2.375 //y=1.085
c317 ( 88 0 ) capacitor c=0.155887f //x=9.48 //y=6.205
c318 ( 87 0 ) capacitor c=0.1106f //x=9.04 //y=6.205
c319 ( 86 0 ) capacitor c=0.154859f //x=2.82 //y=6.205
c320 ( 85 0 ) capacitor c=0.110573f //x=2.38 //y=6.205
c321 ( 79 0 ) capacitor c=8.10734e-19 //x=9.02 //y=4.885
c322 ( 70 0 ) capacitor c=0.00105273f //x=9 //y=2.26
c323 ( 65 0 ) capacitor c=0.00155312f //x=2.38 //y=4.885
c324 ( 56 0 ) capacitor c=0.00152737f //x=2.34 //y=2.26
c325 ( 53 0 ) capacitor c=0.208122f //x=8.855 //y=4.21
c326 ( 52 0 ) capacitor c=0.00479868f //x=9.015 //y=4.21
c327 ( 50 0 ) capacitor c=0.00579767f //x=2.5 //y=4.205
c328 ( 27 0 ) capacitor c=0.00541423f //x=9 //y=4.74
c329 ( 26 0 ) capacitor c=0.0108569f //x=9 //y=4.37
c330 ( 20 0 ) capacitor c=0.00651439f //x=9 //y=2.38
c331 ( 19 0 ) capacitor c=0.0189667f //x=2.34 //y=4.71
c332 ( 18 0 ) capacitor c=0.0126228f //x=2.34 //y=4.365
c333 ( 12 0 ) capacitor c=0.00920415f //x=2.34 //y=2.375
c334 ( 11 0 ) capacitor c=0.0138506f //x=9 //y=4.25
c335 ( 10 0 ) capacitor c=0.0153807f //x=2.34 //y=4.25
c336 ( 9 0 ) capacitor c=0.00702155f //x=9 //y=4.62
c337 ( 5 0 ) capacitor c=0.0499737f //x=9 //y=2.77
c338 ( 1 0 ) capacitor c=0.0685407f //x=2.34 //y=2.77
r339 (  146 147 ) resistor r=32.4568 //w=0.214 //l=0.075 //layer=ply \
 //thickness=0.18 //x=9.02 //y=4.975 //x2=9.02 //y2=5.05
r340 (  144 146 ) resistor r=20.271 //w=0.214 //l=0.09 //layer=ply \
 //thickness=0.18 //x=9.02 //y=4.885 //x2=9.02 //y2=4.975
r341 (  140 141 ) resistor r=52.7279 //w=0.214 //l=0.165 //layer=ply \
 //thickness=0.18 //x=9 //y=2.26 //x2=9 //y2=2.095
r342 (  132 134 ) resistor r=20.271 //w=0.214 //l=0.09 //layer=ply \
 //thickness=0.18 //x=2.38 //y=4.885 //x2=2.38 //y2=4.975
r343 (  128 129 ) resistor r=52.7279 //w=0.214 //l=0.165 //layer=ply \
 //thickness=0.18 //x=2.34 //y=2.26 //x2=2.34 //y2=2.095
r344 (  126 151 ) resistor r=4.95774 //w=0.164 //l=0.112 //layer=ply \
 //thickness=0.18 //x=9.565 //y=1.435 //x2=9.565 //y2=1.547
r345 (  125 150 ) resistor r=45.1352 //w=0.168 //l=0.173853 //layer=ply \
 //thickness=0.18 //x=9.565 //y=1.085 //x2=9.525 //y2=0.93
r346 (  125 126 ) resistor r=179.468 //w=0.094 //l=0.35 //layer=ply \
 //thickness=0.18 //x=9.565 //y=1.085 //x2=9.565 //y2=1.435
r347 (  120 149 ) resistor r=10.8103 //w=0.211 //l=0.115 //layer=ply \
 //thickness=0.18 //x=9.19 //y=1.585 //x2=9.075 //y2=1.585
r348 (  119 151 ) resistor r=45.9962 //w=0.164 //l=0.17296 //layer=ply \
 //thickness=0.18 //x=9.41 //y=1.585 //x2=9.565 //y2=1.547
r349 (  118 148 ) resistor r=5.52526 //w=0.168 //l=0.115 //layer=ply \
 //thickness=0.18 //x=9.19 //y=0.93 //x2=9.075 //y2=0.93
r350 (  117 150 ) resistor r=5.52526 //w=0.168 //l=0.115 //layer=ply \
 //thickness=0.18 //x=9.41 //y=0.93 //x2=9.525 //y2=0.93
r351 (  117 118 ) resistor r=112.809 //w=0.094 //l=0.22 //layer=ply \
 //thickness=0.18 //x=9.41 //y=0.93 //x2=9.19 //y2=0.93
r352 (  116 146 ) resistor r=16.5046 //w=0.27 //l=0.135 //layer=ply \
 //thickness=0.18 //x=9.155 //y=4.975 //x2=9.02 //y2=4.975
r353 (  115 122 ) resistor r=26.9307 //w=0.15 //l=0.106066 //layer=ply \
 //thickness=0.18 //x=9.405 //y=4.975 //x2=9.48 //y2=5.05
r354 (  115 116 ) resistor r=128.191 //w=0.094 //l=0.25 //layer=ply \
 //thickness=0.18 //x=9.405 //y=4.975 //x2=9.155 //y2=4.975
r355 (  110 149 ) resistor r=39.5036 //w=0.211 //l=0.173853 //layer=ply \
 //thickness=0.18 //x=9.035 //y=1.74 //x2=9.075 //y2=1.585
r356 (  110 141 ) resistor r=182.032 //w=0.094 //l=0.355 //layer=ply \
 //thickness=0.18 //x=9.035 //y=1.74 //x2=9.035 //y2=2.095
r357 (  109 149 ) resistor r=38.3614 //w=0.211 //l=0.168819 //layer=ply \
 //thickness=0.18 //x=9.035 //y=1.435 //x2=9.075 //y2=1.585
r358 (  108 148 ) resistor r=45.1352 //w=0.168 //l=0.173853 //layer=ply \
 //thickness=0.18 //x=9.035 //y=1.085 //x2=9.075 //y2=0.93
r359 (  108 109 ) resistor r=179.468 //w=0.094 //l=0.35 //layer=ply \
 //thickness=0.18 //x=9.035 //y=1.085 //x2=9.035 //y2=1.435
r360 (  107 138 ) resistor r=45.1352 //w=0.168 //l=0.173853 //layer=ply \
 //thickness=0.18 //x=2.905 //y=1.43 //x2=2.865 //y2=1.585
r361 (  106 137 ) resistor r=45.1352 //w=0.168 //l=0.173853 //layer=ply \
 //thickness=0.18 //x=2.905 //y=1.085 //x2=2.865 //y2=0.93
r362 (  106 107 ) resistor r=176.904 //w=0.094 //l=0.345 //layer=ply \
 //thickness=0.18 //x=2.905 //y=1.085 //x2=2.905 //y2=1.43
r363 (  101 136 ) resistor r=10.701 //w=0.21 //l=0.115 //layer=ply \
 //thickness=0.18 //x=2.53 //y=1.585 //x2=2.415 //y2=1.585
r364 (  100 138 ) resistor r=5.52526 //w=0.168 //l=0.115 //layer=ply \
 //thickness=0.18 //x=2.75 //y=1.585 //x2=2.865 //y2=1.585
r365 (  99 135 ) resistor r=5.52526 //w=0.168 //l=0.115 //layer=ply \
 //thickness=0.18 //x=2.53 //y=0.93 //x2=2.415 //y2=0.93
r366 (  98 137 ) resistor r=5.52526 //w=0.168 //l=0.115 //layer=ply \
 //thickness=0.18 //x=2.75 //y=0.93 //x2=2.865 //y2=0.93
r367 (  98 99 ) resistor r=112.809 //w=0.094 //l=0.22 //layer=ply \
 //thickness=0.18 //x=2.75 //y=0.93 //x2=2.53 //y2=0.93
r368 (  97 134 ) resistor r=16.5046 //w=0.27 //l=0.135 //layer=ply \
 //thickness=0.18 //x=2.515 //y=4.975 //x2=2.38 //y2=4.975
r369 (  96 103 ) resistor r=26.9307 //w=0.15 //l=0.106066 //layer=ply \
 //thickness=0.18 //x=2.745 //y=4.975 //x2=2.82 //y2=5.05
r370 (  96 97 ) resistor r=117.936 //w=0.094 //l=0.23 //layer=ply \
 //thickness=0.18 //x=2.745 //y=4.975 //x2=2.515 //y2=4.975
r371 (  93 134 ) resistor r=32.4568 //w=0.214 //l=0.075 //layer=ply \
 //thickness=0.18 //x=2.38 //y=5.05 //x2=2.38 //y2=4.975
r372 (  91 136 ) resistor r=39.5823 //w=0.21 //l=0.173853 //layer=ply \
 //thickness=0.18 //x=2.375 //y=1.74 //x2=2.415 //y2=1.585
r373 (  91 129 ) resistor r=182.032 //w=0.094 //l=0.355 //layer=ply \
 //thickness=0.18 //x=2.375 //y=1.74 //x2=2.375 //y2=2.095
r374 (  90 136 ) resistor r=39.5823 //w=0.21 //l=0.173853 //layer=ply \
 //thickness=0.18 //x=2.375 //y=1.43 //x2=2.415 //y2=1.585
r375 (  89 135 ) resistor r=45.1352 //w=0.168 //l=0.173853 //layer=ply \
 //thickness=0.18 //x=2.375 //y=1.085 //x2=2.415 //y2=0.93
r376 (  89 90 ) resistor r=176.904 //w=0.094 //l=0.345 //layer=ply \
 //thickness=0.18 //x=2.375 //y=1.085 //x2=2.375 //y2=1.43
r377 (  88 122 ) resistor r=592.245 //w=0.094 //l=1.155 //layer=ply \
 //thickness=0.18 //x=9.48 //y=6.205 //x2=9.48 //y2=5.05
r378 (  87 147 ) resistor r=592.245 //w=0.094 //l=1.155 //layer=ply \
 //thickness=0.18 //x=9.04 //y=6.205 //x2=9.04 //y2=5.05
r379 (  86 103 ) resistor r=592.245 //w=0.094 //l=1.155 //layer=ply \
 //thickness=0.18 //x=2.82 //y=6.205 //x2=2.82 //y2=5.05
r380 (  85 93 ) resistor r=592.245 //w=0.094 //l=1.155 //layer=ply \
 //thickness=0.18 //x=2.38 //y=6.205 //x2=2.38 //y2=5.05
r381 (  84 119 ) resistor r=56.4043 //w=0.094 //l=0.11 //layer=ply \
 //thickness=0.18 //x=9.3 //y=1.585 //x2=9.41 //y2=1.585
r382 (  84 120 ) resistor r=56.4043 //w=0.094 //l=0.11 //layer=ply \
 //thickness=0.18 //x=9.3 //y=1.585 //x2=9.19 //y2=1.585
r383 (  83 100 ) resistor r=56.4043 //w=0.094 //l=0.11 //layer=ply \
 //thickness=0.18 //x=2.64 //y=1.585 //x2=2.75 //y2=1.585
r384 (  83 101 ) resistor r=56.4043 //w=0.094 //l=0.11 //layer=ply \
 //thickness=0.18 //x=2.64 //y=1.585 //x2=2.53 //y2=1.585
r385 (  79 144 ) resistor r=152 //w=0.17 //l=0.17 //layer=licon //count=1 \
 //x=9.02 //y=4.885 //x2=9.02 //y2=4.885
r386 (  70 140 ) resistor r=152 //w=0.17 //l=0.17 //layer=licon //count=1 \
 //x=9 //y=2.26 //x2=9 //y2=2.26
r387 (  65 132 ) resistor r=152 //w=0.17 //l=0.17 //layer=licon //count=1 \
 //x=2.38 //y=4.885 //x2=2.38 //y2=4.885
r388 (  56 128 ) resistor r=152 //w=0.17 //l=0.17 //layer=licon //count=1 \
 //x=2.34 //y=2.26 //x2=2.34 //y2=2.26
r389 (  52 53 ) resistor r=0.104807 //w=0.281 //l=0.16 //layer=m2 \
 //thickness=0.36 //x=9.015 //y=4.21 //x2=8.855 //y2=4.21
r390 (  50 53 ) resistor r=5.84099 //w=0.136 //l=6.355 //layer=m2 \
 //thickness=0.36 //x=2.5 //y=4.252 //x2=8.855 //y2=4.252
r391 (  48 50 ) resistor r=0.104807 //w=0.281 //l=0.16 //layer=m2 \
 //thickness=0.36 //x=2.34 //y=4.205 //x2=2.5 //y2=4.205
r392 (  44 79 ) resistor r=9.3 //w=0.17 //l=0.17 //layer=mcon //count=1 \
 //x=9.02 //y=4.885 //x2=9.02 //y2=4.885
r393 (  42 70 ) resistor r=9.3 //w=0.17 //l=0.17 //layer=mcon //count=1 //x=9 \
 //y=2.26 //x2=9 //y2=2.26
r394 (  38 52 ) resistor r=4.5 //w=0.15 //l=0.15 //layer=via1 //count=1 \
 //x=9.015 //y=4.21 //x2=9.015 //y2=4.21
r395 (  34 48 ) resistor r=4.5 //w=0.15 //l=0.15 //layer=via1 //count=1 \
 //x=2.34 //y=4.205 //x2=2.34 //y2=4.205
r396 (  32 65 ) resistor r=9.3 //w=0.17 //l=0.17 //layer=mcon //count=1 \
 //x=2.38 //y=4.885 //x2=2.38 //y2=4.885
r397 (  30 56 ) resistor r=9.3 //w=0.17 //l=0.17 //layer=mcon //count=1 \
 //x=2.34 //y=2.26 //x2=2.34 //y2=2.26
r398 (  27 44 ) resistor r=0.0893515 //w=0.219 //l=0.154677 //layer=m1 \
 //thickness=0.36 //x=9 //y=4.74 //x2=9.02 //y2=4.885
r399 (  21 38 ) resistor r=0.0914932 //w=0.384 //l=0.181108 //layer=m1 \
 //thickness=0.36 //x=9 //y=4.05 //x2=8.955 //y2=4.21
r400 (  20 42 ) resistor r=0.0744285 //w=0.225 //l=0.12 //layer=m1 \
 //thickness=0.36 //x=9 //y=2.38 //x2=9 //y2=2.26
r401 (  19 32 ) resistor r=0.100665 //w=0.248 //l=0.193972 //layer=m1 \
 //thickness=0.36 //x=2.34 //y=4.71 //x2=2.38 //y2=4.885
r402 (  18 19 ) resistor r=0.329198 //w=0.131 //l=0.345 //layer=m1 \
 //thickness=0.36 //x=2.34 //y=4.365 //x2=2.34 //y2=4.71
r403 (  13 34 ) resistor r=0.0911593 //w=0.376 //l=0.184174 //layer=m1 \
 //thickness=0.36 //x=2.34 //y=4.045 //x2=2.392 //y2=4.205
r404 (  12 30 ) resistor r=0.0717383 //w=0.224 //l=0.115 //layer=m1 \
 //thickness=0.36 //x=2.34 //y=2.375 //x2=2.34 //y2=2.26
r405 (  11 26 ) resistor r=0.0784723 //w=0.384 //l=0.140712 //layer=m1 \
 //thickness=0.36 //x=8.955 //y=4.25 //x2=9 //y2=4.37
r406 (  11 38 ) resistor r=0.0130208 //w=0.384 //l=0.04 //layer=m1 \
 //thickness=0.36 //x=8.955 //y=4.25 //x2=8.955 //y2=4.21
r407 (  10 18 ) resistor r=0.0761992 //w=0.376 //l=0.138582 //layer=m1 \
 //thickness=0.36 //x=2.392 //y=4.25 //x2=2.34 //y2=4.365
r408 (  10 34 ) resistor r=0.0149601 //w=0.376 //l=0.045 //layer=m1 \
 //thickness=0.36 //x=2.392 //y=4.25 //x2=2.392 //y2=4.205
r409 (  9 27 ) resistor r=0.114504 //w=0.131 //l=0.12 //layer=m1 \
 //thickness=0.36 //x=9 //y=4.62 //x2=9 //y2=4.74
r410 (  9 26 ) resistor r=0.23855 //w=0.131 //l=0.25 //layer=m1 \
 //thickness=0.36 //x=9 //y=4.62 //x2=9 //y2=4.37
r411 (  8 21 ) resistor r=0.162214 //w=0.131 //l=0.17 //layer=m1 \
 //thickness=0.36 //x=9 //y=3.88 //x2=9 //y2=4.05
r412 (  7 8 ) resistor r=0.353053 //w=0.131 //l=0.37 //layer=m1 \
 //thickness=0.36 //x=9 //y=3.51 //x2=9 //y2=3.88
r413 (  6 7 ) resistor r=0.353053 //w=0.131 //l=0.37 //layer=m1 \
 //thickness=0.36 //x=9 //y=3.14 //x2=9 //y2=3.51
r414 (  5 6 ) resistor r=0.353053 //w=0.131 //l=0.37 //layer=m1 \
 //thickness=0.36 //x=9 //y=2.77 //x2=9 //y2=3.14
r415 (  5 20 ) resistor r=0.372137 //w=0.131 //l=0.39 //layer=m1 \
 //thickness=0.36 //x=9 //y=2.77 //x2=9 //y2=2.38
r416 (  4 13 ) resistor r=0.157443 //w=0.131 //l=0.165 //layer=m1 \
 //thickness=0.36 //x=2.34 //y=3.88 //x2=2.34 //y2=4.045
r417 (  3 4 ) resistor r=0.353053 //w=0.131 //l=0.37 //layer=m1 \
 //thickness=0.36 //x=2.34 //y=3.51 //x2=2.34 //y2=3.88
r418 (  2 3 ) resistor r=0.353053 //w=0.131 //l=0.37 //layer=m1 \
 //thickness=0.36 //x=2.34 //y=3.14 //x2=2.34 //y2=3.51
r419 (  1 2 ) resistor r=0.353053 //w=0.131 //l=0.37 //layer=m1 \
 //thickness=0.36 //x=2.34 //y=2.77 //x2=2.34 //y2=3.14
r420 (  1 12 ) resistor r=0.376908 //w=0.131 //l=0.395 //layer=m1 \
 //thickness=0.36 //x=2.34 //y=2.77 //x2=2.34 //y2=2.375
ends PM_VOTER3X1\%A

subckt PM_VOTER3X1\%noxref_4 ( 1 3 4 5 7 8 10 11 12 14 15 16 18 22 25 28 36 40 \
 44 57 60 61 63 64 69 71 72 81 89 107 116 124 125 126 127 128 129 130 134 135 \
 136 138 144 145 147 155 156 157 161 162 )
c334 ( 157 0 ) capacitor c=0.00985497f //x=9.11 //y=1.085
c335 ( 156 0 ) capacitor c=0.0108944f //x=5.78 //y=1.085
c336 ( 155 0 ) capacitor c=0.0110396f //x=2.45 //y=1.085
c337 ( 147 0 ) capacitor c=0.0588117f //x=11.22 //y=2.265
c338 ( 145 0 ) capacitor c=0.0439576f //x=11.86 //y=1.435
c339 ( 144 0 ) capacitor c=0.0201087f //x=11.86 //y=1.09
c340 ( 138 0 ) capacitor c=0.0161986f //x=11.705 //y=1.59
c341 ( 136 0 ) capacitor c=0.0157807f //x=11.705 //y=0.935
c342 ( 135 0 ) capacitor c=0.051364f //x=11.45 //y=4.97
c343 ( 134 0 ) capacitor c=0.0406047f //x=11.74 //y=4.97
c344 ( 130 0 ) capacitor c=0.0301471f //x=11.33 //y=2.1
c345 ( 129 0 ) capacitor c=0.0255349f //x=11.33 //y=1.745
c346 ( 128 0 ) capacitor c=0.0234346f //x=11.33 //y=1.435
c347 ( 127 0 ) capacitor c=0.02013f //x=11.33 //y=1.09
c348 ( 126 0 ) capacitor c=0.153839f //x=11.815 //y=6.2
c349 ( 125 0 ) capacitor c=0.15434f //x=11.375 //y=6.2
c350 ( 116 0 ) capacitor c=6.76693e-19 //x=11.22 //y=4.88
c351 ( 107 0 ) capacitor c=9.11699e-19 //x=11.22 //y=2.265
c352 ( 89 0 ) capacitor c=0.0265472f //x=9.26 //y=5.56
c353 ( 81 0 ) capacitor c=0.0232072f //x=8.38 //y=5.56
c354 ( 72 0 ) capacitor c=0.0554023f //x=11.06 //y=4.255
c355 ( 71 0 ) capacitor c=0.00507699f //x=11.22 //y=4.255
c356 ( 69 0 ) capacitor c=0.00713729f //x=9.9 //y=4.255
c357 ( 64 0 ) capacitor c=0.0866731f //x=9.135 //y=1.405
c358 ( 63 0 ) capacitor c=0.0257508f //x=9.295 //y=1.405
c359 ( 61 0 ) capacitor c=0.0121686f //x=6.1 //y=1.405
c360 ( 60 0 ) capacitor c=0.125391f //x=5.84 //y=1.405
c361 ( 57 0 ) capacitor c=0.00933361f //x=2.805 //y=1.405
c362 ( 44 0 ) capacitor c=0.0116317f //x=11.22 //y=2.265
c363 ( 40 0 ) capacitor c=0.0139687f //x=11.22 //y=4.25
c364 ( 36 0 ) capacitor c=0.0138558f //x=9.74 //y=4.25
c365 ( 28 0 ) capacitor c=0.0126021f //x=9.257 //y=5.39
c366 ( 25 0 ) capacitor c=0.0156957f //x=8.38 //y=5.39
c367 ( 22 0 ) capacitor c=0.00887677f //x=5.97 //y=1.36
c368 ( 18 0 ) capacitor c=0.00746851f //x=2.64 //y=1.36
c369 ( 16 0 ) capacitor c=0.010406f //x=11.22 //y=4.76
c370 ( 15 0 ) capacitor c=0.0112315f //x=11.22 //y=4.415
c371 ( 14 0 ) capacitor c=0.0499188f //x=11.22 //y=4.095
c372 ( 12 0 ) capacitor c=0.0203608f //x=9.74 //y=5.305
c373 ( 11 0 ) capacitor c=0.0114995f //x=9.74 //y=4.415
c374 ( 10 0 ) capacitor c=0.0636522f //x=9.74 //y=4.095
c375 ( 8 0 ) capacitor c=0.00834076f //x=9.385 //y=1.825
c376 ( 7 0 ) capacitor c=0.014154f //x=9.655 //y=1.825
c377 ( 5 0 ) capacitor c=0.00996583f //x=9.655 //y=5.39
c378 ( 4 0 ) capacitor c=0.00638645f //x=9.3 //y=1.74
c379 ( 3 0 ) capacitor c=0.00623208f //x=9.3 //y=1.535
c380 ( 1 0 ) capacitor c=0.0116295f //x=9.135 //y=5.39
r381 (  147 148 ) resistor r=17.5563 //w=0.302 //l=0.11 //layer=ply \
 //thickness=0.18 //x=11.22 //y=2.265 //x2=11.33 //y2=2.265
r382 (  145 154 ) resistor r=45.1352 //w=0.168 //l=0.173853 //layer=ply \
 //thickness=0.18 //x=11.86 //y=1.435 //x2=11.82 //y2=1.59
r383 (  144 153 ) resistor r=45.1352 //w=0.168 //l=0.173853 //layer=ply \
 //thickness=0.18 //x=11.86 //y=1.09 //x2=11.82 //y2=0.935
r384 (  144 145 ) resistor r=176.904 //w=0.094 //l=0.345 //layer=ply \
 //thickness=0.18 //x=11.86 //y=1.09 //x2=11.86 //y2=1.435
r385 (  139 152 ) resistor r=10.701 //w=0.21 //l=0.115 //layer=ply \
 //thickness=0.18 //x=11.485 //y=1.59 //x2=11.37 //y2=1.59
r386 (  138 154 ) resistor r=5.52526 //w=0.168 //l=0.115 //layer=ply \
 //thickness=0.18 //x=11.705 //y=1.59 //x2=11.82 //y2=1.59
r387 (  137 151 ) resistor r=5.52526 //w=0.168 //l=0.115 //layer=ply \
 //thickness=0.18 //x=11.485 //y=0.935 //x2=11.37 //y2=0.935
r388 (  136 153 ) resistor r=5.52526 //w=0.168 //l=0.115 //layer=ply \
 //thickness=0.18 //x=11.705 //y=0.935 //x2=11.82 //y2=0.935
r389 (  136 137 ) resistor r=112.809 //w=0.094 //l=0.22 //layer=ply \
 //thickness=0.18 //x=11.705 //y=0.935 //x2=11.485 //y2=0.935
r390 (  134 141 ) resistor r=26.9307 //w=0.15 //l=0.106066 //layer=ply \
 //thickness=0.18 //x=11.74 //y=4.97 //x2=11.815 //y2=5.045
r391 (  134 135 ) resistor r=148.702 //w=0.094 //l=0.29 //layer=ply \
 //thickness=0.18 //x=11.74 //y=4.97 //x2=11.45 //y2=4.97
r392 (  131 135 ) resistor r=23.403 //w=0.284 //l=0.106066 //layer=ply \
 //thickness=0.18 //x=11.375 //y=5.045 //x2=11.45 //y2=4.97
r393 (  131 150 ) resistor r=26.3063 //w=0.284 //l=0.229783 //layer=ply \
 //thickness=0.18 //x=11.375 //y=5.045 //x2=11.22 //y2=4.88
r394 (  130 148 ) resistor r=19.1248 //w=0.302 //l=0.165 //layer=ply \
 //thickness=0.18 //x=11.33 //y=2.1 //x2=11.33 //y2=2.265
r395 (  129 152 ) resistor r=39.5823 //w=0.21 //l=0.173853 //layer=ply \
 //thickness=0.18 //x=11.33 //y=1.745 //x2=11.37 //y2=1.59
r396 (  129 130 ) resistor r=182.032 //w=0.094 //l=0.355 //layer=ply \
 //thickness=0.18 //x=11.33 //y=1.745 //x2=11.33 //y2=2.1
r397 (  128 152 ) resistor r=39.5823 //w=0.21 //l=0.173853 //layer=ply \
 //thickness=0.18 //x=11.33 //y=1.435 //x2=11.37 //y2=1.59
r398 (  127 151 ) resistor r=45.1352 //w=0.168 //l=0.173853 //layer=ply \
 //thickness=0.18 //x=11.33 //y=1.09 //x2=11.37 //y2=0.935
r399 (  127 128 ) resistor r=176.904 //w=0.094 //l=0.345 //layer=ply \
 //thickness=0.18 //x=11.33 //y=1.09 //x2=11.33 //y2=1.435
r400 (  126 141 ) resistor r=592.245 //w=0.094 //l=1.155 //layer=ply \
 //thickness=0.18 //x=11.815 //y=6.2 //x2=11.815 //y2=5.045
r401 (  125 131 ) resistor r=592.245 //w=0.094 //l=1.155 //layer=ply \
 //thickness=0.18 //x=11.375 //y=6.2 //x2=11.375 //y2=5.045
r402 (  124 138 ) resistor r=56.4043 //w=0.094 //l=0.11 //layer=ply \
 //thickness=0.18 //x=11.595 //y=1.59 //x2=11.705 //y2=1.59
r403 (  124 139 ) resistor r=56.4043 //w=0.094 //l=0.11 //layer=ply \
 //thickness=0.18 //x=11.595 //y=1.59 //x2=11.485 //y2=1.59
r404 (  123 155 ) resistor r=13.3953 //w=0.172 //l=0.18 //layer=li \
 //thickness=0.1 //x=2.637 //y=1.36 //x2=2.637 //y2=1.18
r405 (  116 150 ) resistor r=152 //w=0.17 //l=0.17 //layer=licon //count=1 \
 //x=11.22 //y=4.88 //x2=11.22 //y2=4.88
r406 (  107 147 ) resistor r=152 //w=0.17 //l=0.17 //layer=licon //count=1 \
 //x=11.22 //y=2.265 //x2=11.22 //y2=2.265
r407 (  100 157 ) resistor r=12.3209 //w=0.187 //l=0.18 //layer=li \
 //thickness=0.1 //x=9.3 //y=1.36 //x2=9.3 //y2=1.18
r408 (  89 162 ) resistor r=23.2727 //w=0.187 //l=0.34 //layer=li \
 //thickness=0.1 //x=9.26 //y=5.56 //x2=9.26 //y2=5.9
r409 (  81 161 ) resistor r=23.2727 //w=0.187 //l=0.34 //layer=li \
 //thickness=0.1 //x=8.38 //y=5.56 //x2=8.38 //y2=5.9
r410 (  78 156 ) resistor r=12.3209 //w=0.187 //l=0.18 //layer=li \
 //thickness=0.1 //x=5.97 //y=1.36 //x2=5.97 //y2=1.18
r411 (  71 72 ) resistor r=0.10734 //w=0.281 //l=0.16 //layer=m2 \
 //thickness=0.36 //x=11.22 //y=4.255 //x2=11.06 //y2=4.255
r412 (  69 72 ) resistor r=1.10687 //w=0.131 //l=1.16 //layer=m2 \
 //thickness=0.36 //x=9.9 //y=4.25 //x2=11.06 //y2=4.25
r413 (  67 69 ) resistor r=0.10734 //w=0.281 //l=0.16 //layer=m2 \
 //thickness=0.36 //x=9.74 //y=4.255 //x2=9.9 //y2=4.255
r414 (  63 64 ) resistor r=0.10734 //w=0.281 //l=0.16 //layer=m2 \
 //thickness=0.36 //x=9.295 //y=1.405 //x2=9.135 //y2=1.405
r415 (  61 64 ) resistor r=2.89599 //w=0.131 //l=3.035 //layer=m2 \
 //thickness=0.36 //x=6.1 //y=1.36 //x2=9.135 //y2=1.36
r416 (  59 61 ) resistor r=0.0942778 //w=0.221 //l=0.13 //layer=m2 \
 //thickness=0.36 //x=5.97 //y=1.405 //x2=6.1 //y2=1.405
r417 (  59 60 ) resistor r=0.0942778 //w=0.221 //l=0.13 //layer=m2 \
 //thickness=0.36 //x=5.97 //y=1.405 //x2=5.84 //y2=1.405
r418 (  57 60 ) resistor r=2.89599 //w=0.131 //l=3.035 //layer=m2 \
 //thickness=0.36 //x=2.805 //y=1.36 //x2=5.84 //y2=1.36
r419 (  55 57 ) resistor r=0.10734 //w=0.281 //l=0.16 //layer=m2 \
 //thickness=0.36 //x=2.645 //y=1.405 //x2=2.805 //y2=1.405
r420 (  47 116 ) resistor r=9.3 //w=0.17 //l=0.17 //layer=mcon //count=1 \
 //x=11.22 //y=4.88 //x2=11.22 //y2=4.88
r421 (  44 107 ) resistor r=9.3 //w=0.17 //l=0.17 //layer=mcon //count=1 \
 //x=11.22 //y=2.265 //x2=11.22 //y2=2.265
r422 (  42 71 ) resistor r=4.5 //w=0.15 //l=0.15 //layer=via1 //count=1 \
 //x=11.22 //y=4.255 //x2=11.22 //y2=4.255
r423 (  40 42 ) resistor r=0.00166223 //w=0.376 //l=0.005 //layer=m1 \
 //thickness=0.36 //x=11.167 //y=4.25 //x2=11.167 //y2=4.255
r424 (  38 67 ) resistor r=4.5 //w=0.15 //l=0.15 //layer=via1 //count=1 \
 //x=9.74 //y=4.255 //x2=9.74 //y2=4.255
r425 (  36 38 ) resistor r=0.00166223 //w=0.376 //l=0.005 //layer=m1 \
 //thickness=0.36 //x=9.792 //y=4.25 //x2=9.792 //y2=4.255
r426 (  34 63 ) resistor r=4.5 //w=0.15 //l=0.15 //layer=via1 //count=1 \
 //x=9.295 //y=1.405 //x2=9.295 //y2=1.405
r427 (  32 100 ) resistor r=9.3 //w=0.17 //l=0.17 //layer=mcon //count=1 \
 //x=9.3 //y=1.36 //x2=9.3 //y2=1.36
r428 (  32 34 ) resistor r=0.0163043 //w=0.345 //l=0.045 //layer=m1 \
 //thickness=0.36 //x=9.24 //y=1.36 //x2=9.24 //y2=1.405
r429 (  30 89 ) resistor r=9.3 //w=0.17 //l=0.17 //layer=mcon //count=1 \
 //x=9.26 //y=5.56 //x2=9.26 //y2=5.56
r430 (  28 30 ) resistor r=0.0944444 //w=0.225 //l=0.17 //layer=m1 \
 //thickness=0.36 //x=9.257 //y=5.39 //x2=9.257 //y2=5.56
r431 (  27 81 ) resistor r=9.3 //w=0.17 //l=0.17 //layer=mcon //count=1 \
 //x=8.38 //y=5.56 //x2=8.38 //y2=5.56
r432 (  25 27 ) resistor r=0.0936123 //w=0.227 //l=0.17 //layer=m1 \
 //thickness=0.36 //x=8.38 //y=5.39 //x2=8.38 //y2=5.56
r433 (  24 59 ) resistor r=4.5 //w=0.15 //l=0.15 //layer=via1 //count=1 \
 //x=5.97 //y=1.405 //x2=5.97 //y2=1.405
r434 (  22 78 ) resistor r=9.3 //w=0.17 //l=0.17 //layer=mcon //count=1 \
 //x=5.97 //y=1.36 //x2=5.97 //y2=1.36
r435 (  22 24 ) resistor r=0.0163043 //w=0.345 //l=0.045 //layer=m1 \
 //thickness=0.36 //x=5.91 //y=1.36 //x2=5.91 //y2=1.405
r436 (  20 55 ) resistor r=4.5 //w=0.15 //l=0.15 //layer=via1 //count=1 \
 //x=2.645 //y=1.405 //x2=2.645 //y2=1.405
r437 (  18 123 ) resistor r=9.3 //w=0.17 //l=0.17 //layer=mcon //count=1 \
 //x=2.64 //y=1.36 //x2=2.64 //y2=1.36
r438 (  18 20 ) resistor r=0.0150401 //w=0.374 //l=0.045 //layer=m1 \
 //thickness=0.36 //x=2.695 //y=1.36 //x2=2.695 //y2=1.405
r439 (  16 47 ) resistor r=0.0732479 //w=0.241 //l=0.122474 //layer=m1 \
 //thickness=0.36 //x=11.22 //y=4.76 //x2=11.225 //y2=4.88
r440 (  15 42 ) resistor r=0.0911593 //w=0.376 //l=0.184608 //layer=m1 \
 //thickness=0.36 //x=11.22 //y=4.415 //x2=11.167 //y2=4.255
r441 (  15 16 ) resistor r=0.329198 //w=0.131 //l=0.345 //layer=m1 \
 //thickness=0.36 //x=11.22 //y=4.415 //x2=11.22 //y2=4.76
r442 (  14 40 ) resistor r=0.0894971 //w=0.376 //l=0.179555 //layer=m1 \
 //thickness=0.36 //x=11.22 //y=4.095 //x2=11.167 //y2=4.25
r443 (  13 44 ) resistor r=0.116051 //w=0.211 //l=0.165 //layer=m1 \
 //thickness=0.36 //x=11.22 //y=2.43 //x2=11.22 //y2=2.265
r444 (  13 14 ) resistor r=1.58874 //w=0.131 //l=1.665 //layer=m1 \
 //thickness=0.36 //x=11.22 //y=2.43 //x2=11.22 //y2=4.095
r445 (  11 38 ) resistor r=0.0911593 //w=0.376 //l=0.184174 //layer=m1 \
 //thickness=0.36 //x=9.74 //y=4.415 //x2=9.792 //y2=4.255
r446 (  11 12 ) resistor r=0.849237 //w=0.131 //l=0.89 //layer=m1 \
 //thickness=0.36 //x=9.74 //y=4.415 //x2=9.74 //y2=5.305
r447 (  10 36 ) resistor r=0.0894971 //w=0.376 //l=0.179123 //layer=m1 \
 //thickness=0.36 //x=9.74 //y=4.095 //x2=9.792 //y2=4.25
r448 (  9 10 ) resistor r=2.08492 //w=0.131 //l=2.185 //layer=m1 \
 //thickness=0.36 //x=9.74 //y=1.91 //x2=9.74 //y2=4.095
r449 (  7 9 ) resistor r=0.0698411 //w=0.17 //l=0.120208 //layer=m1 \
 //thickness=0.36 //x=9.655 //y=1.825 //x2=9.74 //y2=1.91
r450 (  7 8 ) resistor r=0.257634 //w=0.131 //l=0.27 //layer=m1 \
 //thickness=0.36 //x=9.655 //y=1.825 //x2=9.385 //y2=1.825
r451 (  6 28 ) resistor r=0.0243946 //w=0.225 //l=0.123 //layer=m1 \
 //thickness=0.36 //x=9.38 //y=5.39 //x2=9.257 //y2=5.39
r452 (  5 12 ) resistor r=0.0698411 //w=0.17 //l=0.120208 //layer=m1 \
 //thickness=0.36 //x=9.655 //y=5.39 //x2=9.74 //y2=5.305
r453 (  5 6 ) resistor r=0.262405 //w=0.131 //l=0.275 //layer=m1 \
 //thickness=0.36 //x=9.655 //y=5.39 //x2=9.38 //y2=5.39
r454 (  4 8 ) resistor r=0.0698411 //w=0.17 //l=0.120208 //layer=m1 \
 //thickness=0.36 //x=9.3 //y=1.74 //x2=9.385 //y2=1.825
r455 (  3 34 ) resistor r=0.0792909 //w=0.345 //l=0.157162 //layer=m1 \
 //thickness=0.36 //x=9.3 //y=1.535 //x2=9.24 //y2=1.405
r456 (  3 4 ) resistor r=0.195611 //w=0.131 //l=0.205 //layer=m1 \
 //thickness=0.36 //x=9.3 //y=1.535 //x2=9.3 //y2=1.74
r457 (  2 25 ) resistor r=0.0249239 //w=0.227 //l=0.125 //layer=m1 \
 //thickness=0.36 //x=8.505 //y=5.39 //x2=8.38 //y2=5.39
r458 (  1 28 ) resistor r=0.0243946 //w=0.225 //l=0.122 //layer=m1 \
 //thickness=0.36 //x=9.135 //y=5.39 //x2=9.257 //y2=5.39
r459 (  1 2 ) resistor r=0.601145 //w=0.131 //l=0.63 //layer=m1 \
 //thickness=0.36 //x=9.135 //y=5.39 //x2=8.505 //y2=5.39
ends PM_VOTER3X1\%noxref_4

subckt PM_VOTER3X1\%VDD ( 1 4 5 6 8 9 10 14 15 33 36 53 56 88 96 116 130 131 \
 132 136 137 138 139 140 141 )
c253 ( 141 0 ) capacitor c=0.0632648f //x=11.89 //y=5.2
c254 ( 140 0 ) capacitor c=0.0575062f //x=11.02 //y=5.2
c255 ( 139 0 ) capacitor c=0.0424825f //x=2.895 //y=5.205
c256 ( 138 0 ) capacitor c=0.0224071f //x=2.015 //y=5.205
c257 ( 137 0 ) capacitor c=0.0512787f //x=1.145 //y=5.205
c258 ( 136 0 ) capacitor c=0.258867f //x=11.96 //y=7.58
c259 ( 134 0 ) capacitor c=0.00597439f //x=11.22 //y=7.58
c260 ( 132 0 ) capacitor c=0.117824f //x=10.48 //y=7.585
c261 ( 131 0 ) capacitor c=0.121201f //x=7.15 //y=7.585
c262 ( 130 0 ) capacitor c=0.126253f //x=3.82 //y=7.585
c263 ( 116 0 ) capacitor c=0.0290604f //x=11.95 //y=7.585
c264 ( 106 0 ) capacitor c=0.021306f //x=11.07 //y=7.585
c265 ( 96 0 ) capacitor c=0.134506f //x=10.31 //y=7.585
c266 ( 88 0 ) capacitor c=0.131873f //x=6.98 //y=7.585
c267 ( 56 0 ) capacitor c=0.23158f //x=1.23 //y=7.58
c268 ( 53 0 ) capacitor c=0.133054f //x=3.65 //y=7.585
c269 ( 44 0 ) capacitor c=0.00499323f //x=3.04 //y=7.585
c270 ( 41 0 ) capacitor c=0.00499323f //x=2.16 //y=7.585
c271 ( 36 0 ) capacitor c=0.0700507f //x=1.23 //y=7.58
c272 ( 33 0 ) capacitor c=0.348083f //x=11.96 //y=7.58
c273 ( 15 0 ) capacitor c=0.00657976f //x=3.04 //y=7.41
c274 ( 14 0 ) capacitor c=0.00827249f //x=3.04 //y=7.035
c275 ( 10 0 ) capacitor c=0.0220779f //x=2.955 //y=7.585
c276 ( 9 0 ) capacitor c=0.00369726f //x=2.16 //y=7.41
c277 ( 8 0 ) capacitor c=0.00650208f //x=2.16 //y=7.035
c278 ( 6 0 ) capacitor c=0.02242f //x=2.075 //y=7.585
c279 ( 5 0 ) capacitor c=0.0090067f //x=1.28 //y=7.41
c280 ( 4 0 ) capacitor c=0.0125184f //x=1.28 //y=7.035
r281 (  118 136 ) resistor r=4.23183 //w=0.7 //l=0.175 //layer=li \
 //thickness=0.1 //x=12.035 //y=7.41 //x2=12.035 //y2=7.585
r282 (  118 141 ) resistor r=56.4706 //w=0.187 //l=0.825 //layer=li \
 //thickness=0.1 //x=12.035 //y=7.41 //x2=12.035 //y2=6.585
r283 (  117 134 ) resistor r=2.87058 //w=0.35 //l=0.085 //layer=li \
 //thickness=0.1 //x=11.24 //y=7.585 //x2=11.155 //y2=7.585
r284 (  116 136 ) resistor r=2.87058 //w=0.35 //l=0.085 //layer=li \
 //thickness=0.1 //x=11.95 //y=7.585 //x2=12.035 //y2=7.585
r285 (  116 117 ) resistor r=24.7629 //w=0.367 //l=0.71 //layer=li \
 //thickness=0.1 //x=11.95 //y=7.585 //x2=11.24 //y2=7.585
r286 (  108 134 ) resistor r=4.23183 //w=0.7 //l=0.175 //layer=li \
 //thickness=0.1 //x=11.155 //y=7.41 //x2=11.155 //y2=7.585
r287 (  108 140 ) resistor r=56.4706 //w=0.187 //l=0.825 //layer=li \
 //thickness=0.1 //x=11.155 //y=7.41 //x2=11.155 //y2=6.585
r288 (  107 132 ) resistor r=5.29055 //w=0.35 //l=0.17 //layer=li \
 //thickness=0.1 //x=10.65 //y=7.585 //x2=10.48 //y2=7.585
r289 (  106 134 ) resistor r=2.87058 //w=0.35 //l=0.085 //layer=li \
 //thickness=0.1 //x=11.07 //y=7.585 //x2=11.155 //y2=7.585
r290 (  106 107 ) resistor r=14.6485 //w=0.367 //l=0.42 //layer=li \
 //thickness=0.1 //x=11.07 //y=7.585 //x2=10.65 //y2=7.585
r291 (  101 103 ) resistor r=38.7139 //w=0.367 //l=1.11 //layer=li \
 //thickness=0.1 //x=8.63 //y=7.585 //x2=9.74 //y2=7.585
r292 (  99 101 ) resistor r=38.7139 //w=0.367 //l=1.11 //layer=li \
 //thickness=0.1 //x=7.52 //y=7.585 //x2=8.63 //y2=7.585
r293 (  97 131 ) resistor r=5.29055 //w=0.35 //l=0.17 //layer=li \
 //thickness=0.1 //x=7.32 //y=7.585 //x2=7.15 //y2=7.585
r294 (  97 99 ) resistor r=6.97548 //w=0.367 //l=0.2 //layer=li \
 //thickness=0.1 //x=7.32 //y=7.585 //x2=7.52 //y2=7.585
r295 (  96 132 ) resistor r=5.29055 //w=0.35 //l=0.17 //layer=li \
 //thickness=0.1 //x=10.31 //y=7.585 //x2=10.48 //y2=7.585
r296 (  96 103 ) resistor r=19.8801 //w=0.367 //l=0.57 //layer=li \
 //thickness=0.1 //x=10.31 //y=7.585 //x2=9.74 //y2=7.585
r297 (  91 93 ) resistor r=38.7139 //w=0.367 //l=1.11 //layer=li \
 //thickness=0.1 //x=4.93 //y=7.585 //x2=6.04 //y2=7.585
r298 (  89 130 ) resistor r=5.29055 //w=0.35 //l=0.17 //layer=li \
 //thickness=0.1 //x=3.99 //y=7.585 //x2=3.82 //y2=7.585
r299 (  89 91 ) resistor r=32.7847 //w=0.367 //l=0.94 //layer=li \
 //thickness=0.1 //x=3.99 //y=7.585 //x2=4.93 //y2=7.585
r300 (  88 131 ) resistor r=5.29055 //w=0.35 //l=0.17 //layer=li \
 //thickness=0.1 //x=6.98 //y=7.585 //x2=7.15 //y2=7.585
r301 (  88 93 ) resistor r=32.7847 //w=0.367 //l=0.94 //layer=li \
 //thickness=0.1 //x=6.98 //y=7.585 //x2=6.04 //y2=7.585
r302 (  84 139 ) resistor r=23.2727 //w=0.187 //l=0.34 //layer=li \
 //thickness=0.1 //x=3.04 //y=6.92 //x2=3.04 //y2=6.58
r303 (  69 137 ) resistor r=23.2727 //w=0.187 //l=0.34 //layer=li \
 //thickness=0.1 //x=1.28 //y=6.92 //x2=1.28 //y2=6.58
r304 (  58 60 ) resistor r=38.7139 //w=0.367 //l=1.11 //layer=li \
 //thickness=0.1 //x=2.34 //y=7.585 //x2=3.45 //y2=7.585
r305 (  56 58 ) resistor r=38.7139 //w=0.367 //l=1.11 //layer=li \
 //thickness=0.1 //x=1.23 //y=7.585 //x2=2.34 //y2=7.585
r306 (  53 130 ) resistor r=5.29055 //w=0.35 //l=0.17 //layer=li \
 //thickness=0.1 //x=3.65 //y=7.585 //x2=3.82 //y2=7.585
r307 (  53 60 ) resistor r=6.97548 //w=0.367 //l=0.2 //layer=li \
 //thickness=0.1 //x=3.65 //y=7.585 //x2=3.45 //y2=7.585
r308 (  46 84 ) resistor r=9.3 //w=0.17 //l=0.17 //layer=mcon //count=1 \
 //x=3.04 //y=6.92 //x2=3.04 //y2=6.92
r309 (  43 138 ) resistor r=9.3 //w=0.17 //l=0.17 //layer=mcon //count=1 \
 //x=2.16 //y=6.92 //x2=2.16 //y2=6.92
r310 (  40 69 ) resistor r=9.3 //w=0.17 //l=0.17 //layer=mcon //count=1 \
 //x=1.28 //y=6.92 //x2=1.28 //y2=6.92
r311 (  36 56 ) resistor r=3.1 //w=0.17 //l=0.51 //layer=mcon //count=3 \
 //x=1.23 //y=7.58 //x2=1.23 //y2=7.58
r312 (  33 136 ) resistor r=4.65 //w=0.17 //l=0.34 //layer=mcon //count=2 \
 //x=11.96 //y=7.58 //x2=11.96 //y2=7.58
r313 (  31 134 ) resistor r=3.1 //w=0.17 //l=0.51 //layer=mcon //count=3 \
 //x=11.22 //y=7.58 //x2=11.22 //y2=7.58
r314 (  31 33 ) resistor r=0.297428 //w=0.311 //l=0.74 //layer=m1 \
 //thickness=0.36 //x=11.22 //y=7.585 //x2=11.96 //y2=7.585
r315 (  29 103 ) resistor r=3.1 //w=0.17 //l=0.51 //layer=mcon //count=3 \
 //x=9.74 //y=7.58 //x2=9.74 //y2=7.58
r316 (  29 31 ) resistor r=0.594855 //w=0.311 //l=1.48 //layer=m1 \
 //thickness=0.36 //x=9.74 //y=7.585 //x2=11.22 //y2=7.585
r317 (  27 101 ) resistor r=3.1 //w=0.17 //l=0.51 //layer=mcon //count=3 \
 //x=8.63 //y=7.58 //x2=8.63 //y2=7.58
r318 (  27 29 ) resistor r=0.446141 //w=0.311 //l=1.11 //layer=m1 \
 //thickness=0.36 //x=8.63 //y=7.585 //x2=9.74 //y2=7.585
r319 (  25 99 ) resistor r=3.1 //w=0.17 //l=0.51 //layer=mcon //count=3 \
 //x=7.52 //y=7.58 //x2=7.52 //y2=7.58
r320 (  25 27 ) resistor r=0.446141 //w=0.311 //l=1.11 //layer=m1 \
 //thickness=0.36 //x=7.52 //y=7.585 //x2=8.63 //y2=7.585
r321 (  22 93 ) resistor r=3.1 //w=0.17 //l=0.51 //layer=mcon //count=3 \
 //x=6.04 //y=7.58 //x2=6.04 //y2=7.58
r322 (  20 91 ) resistor r=3.1 //w=0.17 //l=0.51 //layer=mcon //count=3 \
 //x=4.93 //y=7.58 //x2=4.93 //y2=7.58
r323 (  20 22 ) resistor r=0.446141 //w=0.311 //l=1.11 //layer=m1 \
 //thickness=0.36 //x=4.93 //y=7.585 //x2=6.04 //y2=7.585
r324 (  18 60 ) resistor r=3.1 //w=0.17 //l=0.51 //layer=mcon //count=3 \
 //x=3.45 //y=7.58 //x2=3.45 //y2=7.58
r325 (  18 20 ) resistor r=0.594855 //w=0.311 //l=1.48 //layer=m1 \
 //thickness=0.36 //x=3.45 //y=7.585 //x2=4.93 //y2=7.585
r326 (  16 44 ) resistor r=0.028033 //w=0.35 //l=0.085 //layer=m1 \
 //thickness=0.36 //x=3.125 //y=7.585 //x2=3.04 //y2=7.585
r327 (  16 18 ) resistor r=0.130627 //w=0.311 //l=0.325 //layer=m1 \
 //thickness=0.36 //x=3.125 //y=7.585 //x2=3.45 //y2=7.585
r328 (  15 44 ) resistor r=0.0413265 //w=0.7 //l=0.175 //layer=m1 \
 //thickness=0.36 //x=3.04 //y=7.41 //x2=3.04 //y2=7.585
r329 (  14 46 ) resistor r=0.0715665 //w=0.226 //l=0.115 //layer=m1 \
 //thickness=0.36 //x=3.04 //y=7.035 //x2=3.04 //y2=6.92
r330 (  14 15 ) resistor r=0.357824 //w=0.131 //l=0.375 //layer=m1 \
 //thickness=0.36 //x=3.04 //y=7.035 //x2=3.04 //y2=7.41
r331 (  13 58 ) resistor r=3.1 //w=0.17 //l=0.51 //layer=mcon //count=3 \
 //x=2.34 //y=7.58 //x2=2.34 //y2=7.58
r332 (  11 41 ) resistor r=0.028033 //w=0.35 //l=0.085 //layer=m1 \
 //thickness=0.36 //x=2.245 //y=7.585 //x2=2.16 //y2=7.585
r333 (  11 13 ) resistor r=0.0381833 //w=0.311 //l=0.095 //layer=m1 \
 //thickness=0.36 //x=2.245 //y=7.585 //x2=2.34 //y2=7.585
r334 (  10 44 ) resistor r=0.028033 //w=0.35 //l=0.085 //layer=m1 \
 //thickness=0.36 //x=2.955 //y=7.585 //x2=3.04 //y2=7.585
r335 (  10 13 ) resistor r=0.247186 //w=0.311 //l=0.615 //layer=m1 \
 //thickness=0.36 //x=2.955 //y=7.585 //x2=2.34 //y2=7.585
r336 (  9 41 ) resistor r=0.0413265 //w=0.7 //l=0.175 //layer=m1 \
 //thickness=0.36 //x=2.16 //y=7.41 //x2=2.16 //y2=7.585
r337 (  8 43 ) resistor r=0.0715665 //w=0.226 //l=0.117473 //layer=m1 \
 //thickness=0.36 //x=2.16 //y=7.035 //x2=2.165 //y2=6.92
r338 (  8 9 ) resistor r=0.357824 //w=0.131 //l=0.375 //layer=m1 \
 //thickness=0.36 //x=2.16 //y=7.035 //x2=2.16 //y2=7.41
r339 (  7 36 ) resistor r=0.028033 //w=0.35 //l=0.085 //layer=m1 \
 //thickness=0.36 //x=1.365 //y=7.585 //x2=1.28 //y2=7.585
r340 (  6 41 ) resistor r=0.028033 //w=0.35 //l=0.085 //layer=m1 \
 //thickness=0.36 //x=2.075 //y=7.585 //x2=2.16 //y2=7.585
r341 (  6 7 ) resistor r=0.28537 //w=0.311 //l=0.71 //layer=m1 \
 //thickness=0.36 //x=2.075 //y=7.585 //x2=1.365 //y2=7.585
r342 (  5 36 ) resistor r=0.0413265 //w=0.7 //l=0.175 //layer=m1 \
 //thickness=0.36 //x=1.28 //y=7.41 //x2=1.28 //y2=7.585
r343 (  4 40 ) resistor r=0.0712609 //w=0.23 //l=0.11649 //layer=m1 \
 //thickness=0.36 //x=1.28 //y=7.035 //x2=1.277 //y2=6.92
r344 (  4 5 ) resistor r=0.357824 //w=0.131 //l=0.375 //layer=m1 \
 //thickness=0.36 //x=1.28 //y=7.035 //x2=1.28 //y2=7.41
r345 (  1 25 ) resistor r=0.371785 //w=0.311 //l=0.925 //layer=m1 \
 //thickness=0.36 //x=6.595 //y=7.585 //x2=7.52 //y2=7.585
r346 (  1 22 ) resistor r=0.223071 //w=0.311 //l=0.555 //layer=m1 \
 //thickness=0.36 //x=6.595 //y=7.585 //x2=6.04 //y2=7.585
ends PM_VOTER3X1\%VDD

subckt PM_VOTER3X1\%noxref_6 ( 1 3 4 5 7 9 19 25 27 30 40 49 71 72 73 74 75 )
c166 ( 75 0 ) capacitor c=0.0354016f //x=6.215 //y=5.205
c167 ( 74 0 ) capacitor c=0.0241107f //x=5.335 //y=5.205
c168 ( 72 0 ) capacitor c=0.00544792f //x=2.455 //y=5.205
c169 ( 71 0 ) capacitor c=0.00516996f //x=1.575 //y=5.205
c170 ( 49 0 ) capacitor c=0.0508454f //x=4.6 //y=5.39
c171 ( 40 0 ) capacitor c=0.0363371f //x=2.6 //y=5.39
c172 ( 30 0 ) capacitor c=0.0294643f //x=1.72 //y=5.56
c173 ( 27 0 ) capacitor c=0.00984489f //x=6.36 //y=6.92
c174 ( 25 0 ) capacitor c=0.0059844f //x=5.477 //y=7.09
c175 ( 19 0 ) capacitor c=0.00975753f //x=4.6 //y=6.92
c176 ( 9 0 ) capacitor c=0.014892f //x=1.722 //y=5.39
c177 ( 7 0 ) capacitor c=0.00787288f //x=6.245 //y=7.09
c178 ( 5 0 ) capacitor c=0.00659042f //x=5.36 //y=7.09
c179 ( 4 0 ) capacitor c=0.00573286f //x=2.715 //y=5.39
c180 ( 3 0 ) capacitor c=0.0636102f //x=4.485 //y=5.39
c181 ( 1 0 ) capacitor c=0.0145996f //x=2.485 //y=5.39
r182 (  49 73 ) resistor r=58.1818 //w=0.187 //l=0.85 //layer=li \
 //thickness=0.1 //x=4.6 //y=5.39 //x2=4.6 //y2=6.24
r183 (  40 72 ) resistor r=58.1818 //w=0.187 //l=0.85 //layer=li \
 //thickness=0.1 //x=2.6 //y=5.39 //x2=2.6 //y2=6.24
r184 (  30 71 ) resistor r=23.2727 //w=0.187 //l=0.34 //layer=li \
 //thickness=0.1 //x=1.72 //y=5.56 //x2=1.72 //y2=5.9
r185 (  27 75 ) resistor r=9.3 //w=0.17 //l=0.17 //layer=mcon //count=1 \
 //x=6.36 //y=6.92 //x2=6.36 //y2=6.92
r186 (  27 28 ) resistor r=0.0988372 //w=0.215 //l=0.17 //layer=m1 \
 //thickness=0.36 //x=6.362 //y=6.92 //x2=6.362 //y2=7.09
r187 (  24 74 ) resistor r=9.3 //w=0.17 //l=0.17 //layer=mcon //count=1 \
 //x=5.48 //y=6.92 //x2=5.48 //y2=6.92
r188 (  24 25 ) resistor r=0.0940266 //w=0.226 //l=0.17 //layer=m1 \
 //thickness=0.36 //x=5.477 //y=6.92 //x2=5.477 //y2=7.09
r189 (  22 49 ) resistor r=9.3 //w=0.17 //l=0.17 //layer=mcon //count=1 \
 //x=4.6 //y=5.39 //x2=4.6 //y2=5.39
r190 (  19 73 ) resistor r=9.3 //w=0.17 //l=0.17 //layer=mcon //count=1 \
 //x=4.6 //y=6.92 //x2=4.6 //y2=6.92
r191 (  19 20 ) resistor r=0.0979263 //w=0.217 //l=0.17 //layer=m1 \
 //thickness=0.36 //x=4.602 //y=6.92 //x2=4.602 //y2=7.09
r192 (  15 40 ) resistor r=9.3 //w=0.17 //l=0.17 //layer=mcon //count=1 \
 //x=2.6 //y=5.39 //x2=2.6 //y2=5.39
r193 (  11 30 ) resistor r=9.3 //w=0.17 //l=0.17 //layer=mcon //count=1 \
 //x=1.72 //y=5.56 //x2=1.72 //y2=5.56
r194 (  9 11 ) resistor r=0.0944444 //w=0.225 //l=0.17 //layer=m1 \
 //thickness=0.36 //x=1.722 //y=5.39 //x2=1.722 //y2=5.56
r195 (  8 25 ) resistor r=0.0246599 //w=0.226 //l=0.118 //layer=m1 \
 //thickness=0.36 //x=5.595 //y=7.09 //x2=5.477 //y2=7.09
r196 (  7 28 ) resistor r=0.0216707 //w=0.215 //l=0.117 //layer=m1 \
 //thickness=0.36 //x=6.245 //y=7.09 //x2=6.362 //y2=7.09
r197 (  7 8 ) resistor r=0.620229 //w=0.131 //l=0.65 //layer=m1 \
 //thickness=0.36 //x=6.245 //y=7.09 //x2=5.595 //y2=7.09
r198 (  6 20 ) resistor r=0.0222262 //w=0.217 //l=0.118 //layer=m1 \
 //thickness=0.36 //x=4.72 //y=7.09 //x2=4.602 //y2=7.09
r199 (  5 25 ) resistor r=0.0246599 //w=0.226 //l=0.117 //layer=m1 \
 //thickness=0.36 //x=5.36 //y=7.09 //x2=5.477 //y2=7.09
r200 (  5 6 ) resistor r=0.610687 //w=0.131 //l=0.64 //layer=m1 \
 //thickness=0.36 //x=5.36 //y=7.09 //x2=4.72 //y2=7.09
r201 (  4 15 ) resistor r=0.0880901 //w=0.191 //l=0.115 //layer=m1 \
 //thickness=0.36 //x=2.715 //y=5.39 //x2=2.6 //y2=5.39
r202 (  3 22 ) resistor r=0.0717383 //w=0.224 //l=0.115 //layer=m1 \
 //thickness=0.36 //x=4.485 //y=5.39 //x2=4.6 //y2=5.39
r203 (  3 4 ) resistor r=1.68893 //w=0.131 //l=1.77 //layer=m1 \
 //thickness=0.36 //x=4.485 //y=5.39 //x2=2.715 //y2=5.39
r204 (  2 9 ) resistor r=0.0243946 //w=0.225 //l=0.123 //layer=m1 \
 //thickness=0.36 //x=1.845 //y=5.39 //x2=1.722 //y2=5.39
r205 (  1 15 ) resistor r=0.0880901 //w=0.191 //l=0.115 //layer=m1 \
 //thickness=0.36 //x=2.485 //y=5.39 //x2=2.6 //y2=5.39
r206 (  1 2 ) resistor r=0.610687 //w=0.131 //l=0.64 //layer=m1 \
 //thickness=0.36 //x=2.485 //y=5.39 //x2=1.845 //y2=5.39
ends PM_VOTER3X1\%noxref_6

subckt PM_VOTER3X1\%noxref_7 ( 1 3 4 5 7 9 13 15 21 23 26 38 60 61 62 63 )
c137 ( 63 0 ) capacitor c=0.0343252f //x=9.555 //y=5.205
c138 ( 62 0 ) capacitor c=0.0239063f //x=8.675 //y=5.205
c139 ( 38 0 ) capacitor c=0.0496553f //x=7.94 //y=5.39
c140 ( 26 0 ) capacitor c=0.0229521f //x=5.04 //y=5.56
c141 ( 23 0 ) capacitor c=0.0155899f //x=9.7 //y=6.92
c142 ( 21 0 ) capacitor c=0.00566376f //x=8.82 //y=7.09
c143 ( 15 0 ) capacitor c=0.00945187f //x=7.94 //y=6.92
c144 ( 13 0 ) capacitor c=0.0163615f //x=5.92 //y=5.39
c145 ( 9 0 ) capacitor c=0.0152859f //x=5.04 //y=5.39
c146 ( 7 0 ) capacitor c=0.0068287f //x=9.57 //y=7.09
c147 ( 5 0 ) capacitor c=0.00878908f //x=8.705 //y=7.09
c148 ( 4 0 ) capacitor c=0.00826388f //x=6.035 //y=5.39
c149 ( 3 0 ) capacitor c=0.0573672f //x=7.825 //y=5.39
c150 ( 1 0 ) capacitor c=0.018311f //x=5.805 //y=5.39
r151 (  38 61 ) resistor r=58.1818 //w=0.187 //l=0.85 //layer=li \
 //thickness=0.1 //x=7.94 //y=5.39 //x2=7.94 //y2=6.24
r152 (  26 60 ) resistor r=23.2727 //w=0.187 //l=0.34 //layer=li \
 //thickness=0.1 //x=5.04 //y=5.56 //x2=5.04 //y2=5.9
r153 (  23 63 ) resistor r=9.3 //w=0.17 //l=0.17 //layer=mcon //count=1 \
 //x=9.7 //y=6.92 //x2=9.7 //y2=6.92
r154 (  23 24 ) resistor r=0.0923913 //w=0.23 //l=0.17 //layer=m1 \
 //thickness=0.36 //x=9.695 //y=6.92 //x2=9.695 //y2=7.09
r155 (  20 62 ) resistor r=9.3 //w=0.17 //l=0.17 //layer=mcon //count=1 \
 //x=8.82 //y=6.92 //x2=8.82 //y2=6.92
r156 (  20 21 ) resistor r=0.0957207 //w=0.222 //l=0.17 //layer=m1 \
 //thickness=0.36 //x=8.82 //y=6.92 //x2=8.82 //y2=7.09
r157 (  18 38 ) resistor r=9.3 //w=0.17 //l=0.17 //layer=mcon //count=1 \
 //x=7.94 //y=5.39 //x2=7.94 //y2=5.39
r158 (  15 61 ) resistor r=9.3 //w=0.17 //l=0.17 //layer=mcon //count=1 \
 //x=7.94 //y=6.92 //x2=7.94 //y2=6.92
r159 (  15 16 ) resistor r=0.100236 //w=0.212 //l=0.17 //layer=m1 \
 //thickness=0.36 //x=7.94 //y=6.92 //x2=7.94 //y2=7.09
r160 (  11 26 ) resistor r=9.3 //w=0.17 //l=0.17 //layer=mcon //count=1 \
 //x=5.04 //y=5.56 //x2=5.04 //y2=5.56
r161 (  9 11 ) resistor r=0.100236 //w=0.212 //l=0.17 //layer=m1 \
 //thickness=0.36 //x=5.04 //y=5.39 //x2=5.04 //y2=5.56
r162 (  8 21 ) resistor r=0.0235912 //w=0.222 //l=0.115 //layer=m1 \
 //thickness=0.36 //x=8.935 //y=7.09 //x2=8.82 //y2=7.09
r163 (  7 24 ) resistor r=0.0257089 //w=0.23 //l=0.125 //layer=m1 \
 //thickness=0.36 //x=9.57 //y=7.09 //x2=9.695 //y2=7.09
r164 (  7 8 ) resistor r=0.605916 //w=0.131 //l=0.635 //layer=m1 \
 //thickness=0.36 //x=9.57 //y=7.09 //x2=8.935 //y2=7.09
r165 (  6 16 ) resistor r=0.0208269 //w=0.212 //l=0.115 //layer=m1 \
 //thickness=0.36 //x=8.055 //y=7.09 //x2=7.94 //y2=7.09
r166 (  5 21 ) resistor r=0.0235912 //w=0.222 //l=0.115 //layer=m1 \
 //thickness=0.36 //x=8.705 //y=7.09 //x2=8.82 //y2=7.09
r167 (  5 6 ) resistor r=0.620229 //w=0.131 //l=0.65 //layer=m1 \
 //thickness=0.36 //x=8.705 //y=7.09 //x2=8.055 //y2=7.09
r168 (  4 13 ) resistor r=0.0880901 //w=0.191 //l=0.115 //layer=m1 \
 //thickness=0.36 //x=6.035 //y=5.39 //x2=5.92 //y2=5.39
r169 (  3 18 ) resistor r=0.0717383 //w=0.224 //l=0.115 //layer=m1 \
 //thickness=0.36 //x=7.825 //y=5.39 //x2=7.94 //y2=5.39
r170 (  3 4 ) resistor r=1.70802 //w=0.131 //l=1.79 //layer=m1 \
 //thickness=0.36 //x=7.825 //y=5.39 //x2=6.035 //y2=5.39
r171 (  2 9 ) resistor r=0.0208269 //w=0.212 //l=0.115 //layer=m1 \
 //thickness=0.36 //x=5.155 //y=5.39 //x2=5.04 //y2=5.39
r172 (  1 13 ) resistor r=0.0880901 //w=0.191 //l=0.115 //layer=m1 \
 //thickness=0.36 //x=5.805 //y=5.39 //x2=5.92 //y2=5.39
r173 (  1 2 ) resistor r=0.620229 //w=0.131 //l=0.65 //layer=m1 \
 //thickness=0.36 //x=5.805 //y=5.39 //x2=5.155 //y2=5.39
ends PM_VOTER3X1\%noxref_7

subckt PM_VOTER3X1\%GND ( 1 2 7 8 15 16 24 33 47 50 62 75 93 98 102 114 115 \
 116 123 130 131 132 133 )
c258 ( 133 0 ) capacitor c=0.0654471f //x=10.975 //y=0.55
c259 ( 132 0 ) capacitor c=0.00828027f //x=8.14 //y=1.045
c260 ( 131 0 ) capacitor c=0.00867576f //x=4.81 //y=1.045
c261 ( 130 0 ) capacitor c=0.0083251f //x=1.48 //y=1.045
c262 ( 123 0 ) capacitor c=0.258769f //x=12.08 //y=0.175
c263 ( 116 0 ) capacitor c=0.11347f //x=10.48 //y=0.175
c264 ( 115 0 ) capacitor c=0.110242f //x=7.15 //y=0.175
c265 ( 114 0 ) capacitor c=0.124285f //x=3.82 //y=0.175
c266 ( 105 0 ) capacitor c=0.00585268f //x=12.08 //y=0.63
c267 ( 102 0 ) capacitor c=0.00625302f //x=11.995 //y=0.715
c268 ( 101 0 ) capacitor c=0.00479851f //x=11.59 //y=0.63
c269 ( 98 0 ) capacitor c=0.00645299f //x=11.505 //y=0.715
c270 ( 93 0 ) capacitor c=0.00586769f //x=11.11 //y=0.63
c271 ( 90 0 ) capacitor c=0.0191899f //x=11.025 //y=0.175
c272 ( 75 0 ) capacitor c=0.122563f //x=10.31 //y=0.175
c273 ( 62 0 ) capacitor c=0.118812f //x=6.98 //y=0.175
c274 ( 50 0 ) capacitor c=0.199174f //x=1.23 //y=0.18
c275 ( 47 0 ) capacitor c=0.122869f //x=3.65 //y=0.175
c276 ( 42 0 ) capacitor c=0.00509083f //x=8.33 //y=0.175
c277 ( 39 0 ) capacitor c=0.00510068f //x=4.93 //y=0.18
c278 ( 35 0 ) capacitor c=0.00509083f //x=1.67 //y=0.175
c279 ( 33 0 ) capacitor c=0.179237f //x=11.96 //y=0.18
c280 ( 24 0 ) capacitor c=0.0350931f //x=8.33 //y=1.02
c281 ( 16 0 ) capacitor c=0.107366f //x=8.245 //y=0.175
c282 ( 15 0 ) capacitor c=0.0274205f //x=5 //y=1.015
c283 ( 8 0 ) capacitor c=0.112424f //x=4.915 //y=0.175
c284 ( 7 0 ) capacitor c=0.0375179f //x=1.67 //y=1.015
c285 ( 2 0 ) capacitor c=0.0754302f //x=1.585 //y=0.175
r286 (  122 123 ) resistor r=4.18529 //w=0.367 //l=0.12 //layer=li \
 //thickness=0.1 //x=11.96 //y=0.175 //x2=12.08 //y2=0.175
r287 (  120 122 ) resistor r=12.9046 //w=0.367 //l=0.37 //layer=li \
 //thickness=0.1 //x=11.59 //y=0.175 //x2=11.96 //y2=0.175
r288 (  119 120 ) resistor r=12.9046 //w=0.367 //l=0.37 //layer=li \
 //thickness=0.1 //x=11.22 //y=0.175 //x2=11.59 //y2=0.175
r289 (  117 119 ) resistor r=3.83651 //w=0.367 //l=0.11 //layer=li \
 //thickness=0.1 //x=11.11 //y=0.175 //x2=11.22 //y2=0.175
r290 (  106 133 ) resistor r=5.4201 //w=0.17 //l=0.085 //layer=li \
 //thickness=0.1 //x=12.08 //y=0.8 //x2=12.08 //y2=0.715
r291 (  106 133 ) resistor r=41.4118 //w=0.187 //l=0.605 //layer=li \
 //thickness=0.1 //x=12.08 //y=0.8 //x2=12.08 //y2=1.405
r292 (  105 133 ) resistor r=5.4201 //w=0.17 //l=0.085 //layer=li \
 //thickness=0.1 //x=12.08 //y=0.63 //x2=12.08 //y2=0.715
r293 (  104 123 ) resistor r=5.21862 //w=0.35 //l=0.175 //layer=li \
 //thickness=0.1 //x=12.08 //y=0.35 //x2=12.08 //y2=0.175
r294 (  104 105 ) resistor r=19.1658 //w=0.187 //l=0.28 //layer=li \
 //thickness=0.1 //x=12.08 //y=0.35 //x2=12.08 //y2=0.63
r295 (  103 133 ) resistor r=5.4201 //w=0.17 //l=0.085 //layer=li \
 //thickness=0.1 //x=11.675 //y=0.715 //x2=11.59 //y2=0.715
r296 (  102 133 ) resistor r=1.40859 //w=0.34 //l=0.085 //layer=li \
 //thickness=0.1 //x=11.995 //y=0.715 //x2=12.08 //y2=0.715
r297 (  102 103 ) resistor r=21.9037 //w=0.187 //l=0.32 //layer=li \
 //thickness=0.1 //x=11.995 //y=0.715 //x2=11.675 //y2=0.715
r298 (  101 133 ) resistor r=1.40859 //w=0.34 //l=0.085 //layer=li \
 //thickness=0.1 //x=11.59 //y=0.63 //x2=11.59 //y2=0.715
r299 (  100 120 ) resistor r=5.21862 //w=0.35 //l=0.175 //layer=li \
 //thickness=0.1 //x=11.59 //y=0.35 //x2=11.59 //y2=0.175
r300 (  100 101 ) resistor r=19.1658 //w=0.187 //l=0.28 //layer=li \
 //thickness=0.1 //x=11.59 //y=0.35 //x2=11.59 //y2=0.63
r301 (  99 133 ) resistor r=1.40859 //w=0.34 //l=0.085 //layer=li \
 //thickness=0.1 //x=11.195 //y=0.715 //x2=11.11 //y2=0.715
r302 (  98 133 ) resistor r=5.4201 //w=0.17 //l=0.085 //layer=li \
 //thickness=0.1 //x=11.505 //y=0.715 //x2=11.59 //y2=0.715
r303 (  98 99 ) resistor r=21.2193 //w=0.187 //l=0.31 //layer=li \
 //thickness=0.1 //x=11.505 //y=0.715 //x2=11.195 //y2=0.715
r304 (  94 133 ) resistor r=5.4201 //w=0.17 //l=0.085 //layer=li \
 //thickness=0.1 //x=11.11 //y=0.8 //x2=11.11 //y2=0.715
r305 (  94 133 ) resistor r=41.4118 //w=0.187 //l=0.605 //layer=li \
 //thickness=0.1 //x=11.11 //y=0.8 //x2=11.11 //y2=1.405
r306 (  93 133 ) resistor r=5.4201 //w=0.17 //l=0.085 //layer=li \
 //thickness=0.1 //x=11.11 //y=0.63 //x2=11.11 //y2=0.715
r307 (  92 117 ) resistor r=5.21862 //w=0.35 //l=0.175 //layer=li \
 //thickness=0.1 //x=11.11 //y=0.35 //x2=11.11 //y2=0.175
r308 (  92 93 ) resistor r=19.1658 //w=0.187 //l=0.28 //layer=li \
 //thickness=0.1 //x=11.11 //y=0.35 //x2=11.11 //y2=0.63
r309 (  91 116 ) resistor r=5.29055 //w=0.35 //l=0.17 //layer=li \
 //thickness=0.1 //x=10.65 //y=0.175 //x2=10.48 //y2=0.175
r310 (  90 117 ) resistor r=2.96458 //w=0.367 //l=0.085 //layer=li \
 //thickness=0.1 //x=11.025 //y=0.175 //x2=11.11 //y2=0.175
r311 (  90 91 ) resistor r=13.079 //w=0.367 //l=0.375 //layer=li \
 //thickness=0.1 //x=11.025 //y=0.175 //x2=10.65 //y2=0.175
r312 (  80 82 ) resistor r=38.7139 //w=0.367 //l=1.11 //layer=li \
 //thickness=0.1 //x=8.63 //y=0.175 //x2=9.74 //y2=0.175
r313 (  78 80 ) resistor r=38.7139 //w=0.367 //l=1.11 //layer=li \
 //thickness=0.1 //x=7.52 //y=0.175 //x2=8.63 //y2=0.175
r314 (  76 115 ) resistor r=5.29055 //w=0.35 //l=0.17 //layer=li \
 //thickness=0.1 //x=7.32 //y=0.175 //x2=7.15 //y2=0.175
r315 (  76 78 ) resistor r=6.97548 //w=0.367 //l=0.2 //layer=li \
 //thickness=0.1 //x=7.32 //y=0.175 //x2=7.52 //y2=0.175
r316 (  75 116 ) resistor r=5.29055 //w=0.35 //l=0.17 //layer=li \
 //thickness=0.1 //x=10.31 //y=0.175 //x2=10.48 //y2=0.175
r317 (  75 82 ) resistor r=19.8801 //w=0.367 //l=0.57 //layer=li \
 //thickness=0.1 //x=10.31 //y=0.175 //x2=9.74 //y2=0.175
r318 (  65 67 ) resistor r=38.7139 //w=0.367 //l=1.11 //layer=li \
 //thickness=0.1 //x=4.93 //y=0.175 //x2=6.04 //y2=0.175
r319 (  63 114 ) resistor r=5.29055 //w=0.35 //l=0.17 //layer=li \
 //thickness=0.1 //x=3.99 //y=0.175 //x2=3.82 //y2=0.175
r320 (  63 65 ) resistor r=32.7847 //w=0.367 //l=0.94 //layer=li \
 //thickness=0.1 //x=3.99 //y=0.175 //x2=4.93 //y2=0.175
r321 (  62 115 ) resistor r=5.29055 //w=0.35 //l=0.17 //layer=li \
 //thickness=0.1 //x=6.98 //y=0.175 //x2=7.15 //y2=0.175
r322 (  62 67 ) resistor r=32.7847 //w=0.367 //l=0.94 //layer=li \
 //thickness=0.1 //x=6.98 //y=0.175 //x2=6.04 //y2=0.175
r323 (  52 54 ) resistor r=38.7139 //w=0.367 //l=1.11 //layer=li \
 //thickness=0.1 //x=2.34 //y=0.175 //x2=3.45 //y2=0.175
r324 (  50 52 ) resistor r=38.7139 //w=0.367 //l=1.11 //layer=li \
 //thickness=0.1 //x=1.23 //y=0.175 //x2=2.34 //y2=0.175
r325 (  47 114 ) resistor r=5.29055 //w=0.35 //l=0.17 //layer=li \
 //thickness=0.1 //x=3.65 //y=0.175 //x2=3.82 //y2=0.175
r326 (  47 54 ) resistor r=6.97548 //w=0.367 //l=0.2 //layer=li \
 //thickness=0.1 //x=3.65 //y=0.175 //x2=3.45 //y2=0.175
r327 (  44 132 ) resistor r=9.3 //w=0.17 //l=0.17 //layer=mcon //count=1 \
 //x=8.33 //y=1.135 //x2=8.33 //y2=1.135
r328 (  41 131 ) resistor r=9.3 //w=0.17 //l=0.17 //layer=mcon //count=1 //x=5 \
 //y=1.135 //x2=5 //y2=1.135
r329 (  39 65 ) resistor r=3.1 //w=0.17 //l=0.51 //layer=mcon //count=3 \
 //x=4.93 //y=0.18 //x2=4.93 //y2=0.18
r330 (  37 130 ) resistor r=9.3 //w=0.17 //l=0.17 //layer=mcon //count=1 \
 //x=1.67 //y=1.135 //x2=1.67 //y2=1.135
r331 (  33 122 ) resistor r=4.65 //w=0.17 //l=0.34 //layer=mcon //count=2 \
 //x=11.96 //y=0.18 //x2=11.96 //y2=0.18
r332 (  31 119 ) resistor r=3.1 //w=0.17 //l=0.51 //layer=mcon //count=3 \
 //x=11.22 //y=0.18 //x2=11.22 //y2=0.18
r333 (  31 33 ) resistor r=0.297428 //w=0.311 //l=0.74 //layer=m1 \
 //thickness=0.36 //x=11.22 //y=0.175 //x2=11.96 //y2=0.175
r334 (  29 82 ) resistor r=3.1 //w=0.17 //l=0.51 //layer=mcon //count=3 \
 //x=9.74 //y=0.18 //x2=9.74 //y2=0.18
r335 (  29 31 ) resistor r=0.594855 //w=0.311 //l=1.48 //layer=m1 \
 //thickness=0.36 //x=9.74 //y=0.175 //x2=11.22 //y2=0.175
r336 (  27 80 ) resistor r=3.1 //w=0.17 //l=0.51 //layer=mcon //count=3 \
 //x=8.63 //y=0.18 //x2=8.63 //y2=0.18
r337 (  27 29 ) resistor r=0.446141 //w=0.311 //l=1.11 //layer=m1 \
 //thickness=0.36 //x=8.63 //y=0.175 //x2=9.74 //y2=0.175
r338 (  25 42 ) resistor r=0.028033 //w=0.35 //l=0.085 //layer=m1 \
 //thickness=0.36 //x=8.415 //y=0.175 //x2=8.33 //y2=0.175
r339 (  25 27 ) resistor r=0.0864148 //w=0.311 //l=0.215 //layer=m1 \
 //thickness=0.36 //x=8.415 //y=0.175 //x2=8.63 //y2=0.175
r340 (  24 44 ) resistor r=0.0703067 //w=0.254 //l=0.11649 //layer=m1 \
 //thickness=0.36 //x=8.33 //y=1.02 //x2=8.327 //y2=1.135
r341 (  23 42 ) resistor r=0.0413265 //w=0.7 //l=0.175 //layer=m1 \
 //thickness=0.36 //x=8.33 //y=0.35 //x2=8.33 //y2=0.175
r342 (  23 24 ) resistor r=0.639313 //w=0.131 //l=0.67 //layer=m1 \
 //thickness=0.36 //x=8.33 //y=0.35 //x2=8.33 //y2=1.02
r343 (  22 78 ) resistor r=3.1 //w=0.17 //l=0.51 //layer=mcon //count=3 \
 //x=7.52 //y=0.18 //x2=7.52 //y2=0.18
r344 (  19 67 ) resistor r=3.1 //w=0.17 //l=0.51 //layer=mcon //count=3 \
 //x=6.04 //y=0.18 //x2=6.04 //y2=0.18
r345 (  17 39 ) resistor r=0.028033 //w=0.35 //l=0.085 //layer=m1 \
 //thickness=0.36 //x=5.085 //y=0.175 //x2=5 //y2=0.175
r346 (  17 19 ) resistor r=0.383842 //w=0.311 //l=0.955 //layer=m1 \
 //thickness=0.36 //x=5.085 //y=0.175 //x2=6.04 //y2=0.175
r347 (  16 42 ) resistor r=0.028033 //w=0.35 //l=0.085 //layer=m1 \
 //thickness=0.36 //x=8.245 //y=0.175 //x2=8.33 //y2=0.175
r348 (  16 22 ) resistor r=0.291399 //w=0.311 //l=0.725 //layer=m1 \
 //thickness=0.36 //x=8.245 //y=0.175 //x2=7.52 //y2=0.175
r349 (  15 41 ) resistor r=0.0738201 //w=0.232 //l=0.121491 //layer=m1 \
 //thickness=0.36 //x=5 //y=1.015 //x2=4.997 //y2=1.135
r350 (  14 39 ) resistor r=0.0413265 //w=0.7 //l=0.175 //layer=m1 \
 //thickness=0.36 //x=5 //y=0.35 //x2=5 //y2=0.175
r351 (  14 15 ) resistor r=0.634542 //w=0.131 //l=0.665 //layer=m1 \
 //thickness=0.36 //x=5 //y=0.35 //x2=5 //y2=1.015
r352 (  13 54 ) resistor r=3.1 //w=0.17 //l=0.51 //layer=mcon //count=3 \
 //x=3.45 //y=0.18 //x2=3.45 //y2=0.18
r353 (  11 52 ) resistor r=3.1 //w=0.17 //l=0.51 //layer=mcon //count=3 \
 //x=2.34 //y=0.18 //x2=2.34 //y2=0.18
r354 (  11 13 ) resistor r=0.446141 //w=0.311 //l=1.11 //layer=m1 \
 //thickness=0.36 //x=2.34 //y=0.175 //x2=3.45 //y2=0.175
r355 (  9 35 ) resistor r=0.028033 //w=0.35 //l=0.085 //layer=m1 \
 //thickness=0.36 //x=1.755 //y=0.175 //x2=1.67 //y2=0.175
r356 (  9 11 ) resistor r=0.235129 //w=0.311 //l=0.585 //layer=m1 \
 //thickness=0.36 //x=1.755 //y=0.175 //x2=2.34 //y2=0.175
r357 (  8 39 ) resistor r=0.028033 //w=0.35 //l=0.085 //layer=m1 \
 //thickness=0.36 //x=4.915 //y=0.175 //x2=5 //y2=0.175
r358 (  8 13 ) resistor r=0.588826 //w=0.311 //l=1.465 //layer=m1 \
 //thickness=0.36 //x=4.915 //y=0.175 //x2=3.45 //y2=0.175
r359 (  7 37 ) resistor r=0.0729089 //w=0.249 //l=0.120996 //layer=m1 \
 //thickness=0.36 //x=1.67 //y=1.015 //x2=1.672 //y2=1.135
r360 (  6 35 ) resistor r=0.0413265 //w=0.7 //l=0.175 //layer=m1 \
 //thickness=0.36 //x=1.67 //y=0.35 //x2=1.67 //y2=0.175
r361 (  6 7 ) resistor r=0.634542 //w=0.131 //l=0.665 //layer=m1 \
 //thickness=0.36 //x=1.67 //y=0.35 //x2=1.67 //y2=1.015
r362 (  4 50 ) resistor r=3.1 //w=0.17 //l=0.51 //layer=mcon //count=3 \
 //x=1.23 //y=0.18 //x2=1.23 //y2=0.18
r363 (  2 35 ) resistor r=0.028033 //w=0.35 //l=0.085 //layer=m1 \
 //thickness=0.36 //x=1.585 //y=0.175 //x2=1.67 //y2=0.175
r364 (  2 4 ) resistor r=0.142685 //w=0.311 //l=0.355 //layer=m1 \
 //thickness=0.36 //x=1.585 //y=0.175 //x2=1.23 //y2=0.175
r365 (  1 22 ) resistor r=0.371785 //w=0.311 //l=0.925 //layer=m1 \
 //thickness=0.36 //x=6.595 //y=0.175 //x2=7.52 //y2=0.175
r366 (  1 19 ) resistor r=0.223071 //w=0.311 //l=0.555 //layer=m1 \
 //thickness=0.36 //x=6.595 //y=0.175 //x2=6.04 //y2=0.175
ends PM_VOTER3X1\%GND

subckt PM_VOTER3X1\%Y ( 1 2 3 4 5 6 7 9 11 12 13 14 15 26 36 43 45 )
c82 ( 43 0 ) capacitor c=0.00869746f //x=11.405 //y=1.09
c83 ( 36 0 ) capacitor c=0.0261871f //x=11.595 //y=5.56
c84 ( 26 0 ) capacitor c=0.0196817f //x=11.59 //y=1.185
c85 ( 15 0 ) capacitor c=0.00557311f //x=11.68 //y=5.14
c86 ( 14 0 ) capacitor c=0.00944012f //x=11.875 //y=5.14
c87 ( 13 0 ) capacitor c=0.00724565f //x=11.675 //y=2.02
c88 ( 12 0 ) capacitor c=0.0145753f //x=11.875 //y=2.02
c89 ( 11 0 ) capacitor c=0.0117946f //x=11.595 //y=5.42
c90 ( 9 0 ) capacitor c=0.0166561f //x=11.59 //y=1.935
c91 ( 1 0 ) capacitor c=0.116158f //x=11.96 //y=2.405
r92 (  36 45 ) resistor r=23.615 //w=0.187 //l=0.345 //layer=li \
 //thickness=0.1 //x=11.595 //y=5.56 //x2=11.595 //y2=5.905
r93 (  29 36 ) resistor r=9.3 //w=0.17 //l=0.17 //layer=mcon //count=1 \
 //x=11.595 //y=5.56 //x2=11.595 //y2=5.56
r94 (  26 43 ) resistor r=9.3 //w=0.17 //l=0.17 //layer=mcon //count=1 \
 //x=11.59 //y=1.185 //x2=11.59 //y2=1.185
r95 (  14 17 ) resistor r=0.0698411 //w=0.17 //l=0.120208 //layer=m1 \
 //thickness=0.36 //x=11.875 //y=5.14 //x2=11.96 //y2=5.055
r96 (  14 15 ) resistor r=0.186069 //w=0.131 //l=0.195 //layer=m1 \
 //thickness=0.36 //x=11.875 //y=5.14 //x2=11.68 //y2=5.14
r97 (  12 16 ) resistor r=0.0698411 //w=0.17 //l=0.120208 //layer=m1 \
 //thickness=0.36 //x=11.875 //y=2.02 //x2=11.96 //y2=2.105
r98 (  12 13 ) resistor r=0.19084 //w=0.131 //l=0.2 //layer=m1 \
 //thickness=0.36 //x=11.875 //y=2.02 //x2=11.675 //y2=2.02
r99 (  11 29 ) resistor r=0.086672 //w=0.218 //l=0.14 //layer=m1 \
 //thickness=0.36 //x=11.595 //y=5.42 //x2=11.595 //y2=5.56
r100 (  10 15 ) resistor r=0.0698411 //w=0.17 //l=0.120208 //layer=m1 \
 //thickness=0.36 //x=11.595 //y=5.225 //x2=11.68 //y2=5.14
r101 (  10 11 ) resistor r=0.186069 //w=0.131 //l=0.195 //layer=m1 \
 //thickness=0.36 //x=11.595 //y=5.225 //x2=11.595 //y2=5.42
r102 (  9 13 ) resistor r=0.0698411 //w=0.17 //l=0.120208 //layer=m1 \
 //thickness=0.36 //x=11.59 //y=1.935 //x2=11.675 //y2=2.02
r103 (  8 26 ) resistor r=0.105739 //w=0.201 //l=0.145 //layer=m1 \
 //thickness=0.36 //x=11.59 //y=1.33 //x2=11.59 //y2=1.185
r104 (  8 9 ) resistor r=0.57729 //w=0.131 //l=0.605 //layer=m1 \
 //thickness=0.36 //x=11.59 //y=1.33 //x2=11.59 //y2=1.935
r105 (  7 17 ) resistor r=0.410305 //w=0.131 //l=0.43 //layer=m1 \
 //thickness=0.36 //x=11.96 //y=4.625 //x2=11.96 //y2=5.055
r106 (  6 7 ) resistor r=0.353053 //w=0.131 //l=0.37 //layer=m1 \
 //thickness=0.36 //x=11.96 //y=4.255 //x2=11.96 //y2=4.625
r107 (  5 6 ) resistor r=0.353053 //w=0.131 //l=0.37 //layer=m1 \
 //thickness=0.36 //x=11.96 //y=3.885 //x2=11.96 //y2=4.255
r108 (  4 5 ) resistor r=0.353053 //w=0.131 //l=0.37 //layer=m1 \
 //thickness=0.36 //x=11.96 //y=3.515 //x2=11.96 //y2=3.885
r109 (  3 4 ) resistor r=0.353053 //w=0.131 //l=0.37 //layer=m1 \
 //thickness=0.36 //x=11.96 //y=3.145 //x2=11.96 //y2=3.515
r110 (  2 3 ) resistor r=0.353053 //w=0.131 //l=0.37 //layer=m1 \
 //thickness=0.36 //x=11.96 //y=2.775 //x2=11.96 //y2=3.145
r111 (  1 2 ) resistor r=0.353053 //w=0.131 //l=0.37 //layer=m1 \
 //thickness=0.36 //x=11.96 //y=2.405 //x2=11.96 //y2=2.775
r112 (  1 16 ) resistor r=0.28626 //w=0.131 //l=0.3 //layer=m1 \
 //thickness=0.36 //x=11.96 //y=2.405 //x2=11.96 //y2=2.105
ends PM_VOTER3X1\%Y

subckt PM_VOTER3X1\%noxref_10 ( 1 5 9 10 13 17 29 )
c65 ( 29 0 ) capacitor c=0.0782322f //x=1.05 //y=0.545
c66 ( 17 0 ) capacitor c=0.00678917f //x=3.125 //y=0.795
c67 ( 13 0 ) capacitor c=0.0154169f //x=3.04 //y=0.71
c68 ( 10 0 ) capacitor c=0.00990031f //x=2.155 //y=1.675
c69 ( 9 0 ) capacitor c=0.00770028f //x=2.155 //y=0.795
c70 ( 5 0 ) capacitor c=0.028994f //x=2.07 //y=1.76
c71 ( 1 0 ) capacitor c=0.0049595f //x=1.185 //y=1.675
r72 (  17 29 ) resistor r=3.57586 //w=0.17 //l=0.125 //layer=li \
 //thickness=0.1 //x=3.125 //y=0.795 //x2=3.125 //y2=0.67
r73 (  17 29 ) resistor r=41.4118 //w=0.187 //l=0.605 //layer=li \
 //thickness=0.1 //x=3.125 //y=0.795 //x2=3.125 //y2=1.4
r74 (  14 29 ) resistor r=3.57586 //w=0.17 //l=0.103078 //layer=li \
 //thickness=0.1 //x=2.24 //y=0.71 //x2=2.155 //y2=0.67
r75 (  14 29 ) resistor r=27.0374 //w=0.187 //l=0.395 //layer=li \
 //thickness=0.1 //x=2.24 //y=0.71 //x2=2.635 //y2=0.71
r76 (  13 29 ) resistor r=3.57586 //w=0.17 //l=0.103078 //layer=li \
 //thickness=0.1 //x=3.04 //y=0.71 //x2=3.125 //y2=0.67
r77 (  13 29 ) resistor r=27.7219 //w=0.187 //l=0.405 //layer=li \
 //thickness=0.1 //x=3.04 //y=0.71 //x2=2.635 //y2=0.71
r78 (  10 29 ) resistor r=3.57586 //w=0.17 //l=0.125 //layer=li \
 //thickness=0.1 //x=2.155 //y=1.675 //x2=2.155 //y2=1.8
r79 (  10 29 ) resistor r=42.0963 //w=0.187 //l=0.615 //layer=li \
 //thickness=0.1 //x=2.155 //y=1.675 //x2=2.155 //y2=1.06
r80 (  9 29 ) resistor r=3.57586 //w=0.17 //l=0.125 //layer=li //thickness=0.1 \
 //x=2.155 //y=0.795 //x2=2.155 //y2=0.67
r81 (  9 29 ) resistor r=18.139 //w=0.187 //l=0.265 //layer=li //thickness=0.1 \
 //x=2.155 //y=0.795 //x2=2.155 //y2=1.06
r82 (  6 29 ) resistor r=3.57586 //w=0.17 //l=0.103078 //layer=li \
 //thickness=0.1 //x=1.27 //y=1.76 //x2=1.185 //y2=1.8
r83 (  6 29 ) resistor r=27.3797 //w=0.187 //l=0.4 //layer=li //thickness=0.1 \
 //x=1.27 //y=1.76 //x2=1.67 //y2=1.76
r84 (  5 29 ) resistor r=3.57586 //w=0.17 //l=0.103078 //layer=li \
 //thickness=0.1 //x=2.07 //y=1.76 //x2=2.155 //y2=1.8
r85 (  5 29 ) resistor r=27.3797 //w=0.187 //l=0.4 //layer=li //thickness=0.1 \
 //x=2.07 //y=1.76 //x2=1.67 //y2=1.76
r86 (  1 29 ) resistor r=3.57586 //w=0.17 //l=0.125 //layer=li //thickness=0.1 \
 //x=1.185 //y=1.675 //x2=1.185 //y2=1.8
r87 (  1 29 ) resistor r=42.0963 //w=0.187 //l=0.615 //layer=li \
 //thickness=0.1 //x=1.185 //y=1.675 //x2=1.185 //y2=1.06
ends PM_VOTER3X1\%noxref_10

subckt PM_VOTER3X1\%noxref_12 ( 1 5 9 10 13 17 29 )
c66 ( 29 0 ) capacitor c=0.073823f //x=4.38 //y=0.545
c67 ( 17 0 ) capacitor c=0.00678917f //x=6.455 //y=0.795
c68 ( 13 0 ) capacitor c=0.0158009f //x=6.37 //y=0.71
c69 ( 10 0 ) capacitor c=0.009705f //x=5.485 //y=1.675
c70 ( 9 0 ) capacitor c=0.00770028f //x=5.485 //y=0.795
c71 ( 5 0 ) capacitor c=0.0201517f //x=5.4 //y=1.76
c72 ( 1 0 ) capacitor c=0.00935657f //x=4.515 //y=1.675
r73 (  17 29 ) resistor r=3.57586 //w=0.17 //l=0.125 //layer=li \
 //thickness=0.1 //x=6.455 //y=0.795 //x2=6.455 //y2=0.67
r74 (  17 29 ) resistor r=41.4118 //w=0.187 //l=0.605 //layer=li \
 //thickness=0.1 //x=6.455 //y=0.795 //x2=6.455 //y2=1.4
r75 (  14 29 ) resistor r=3.57586 //w=0.17 //l=0.103078 //layer=li \
 //thickness=0.1 //x=5.57 //y=0.71 //x2=5.485 //y2=0.67
r76 (  14 29 ) resistor r=27.3797 //w=0.187 //l=0.4 //layer=li //thickness=0.1 \
 //x=5.57 //y=0.71 //x2=5.97 //y2=0.71
r77 (  13 29 ) resistor r=3.57586 //w=0.17 //l=0.103078 //layer=li \
 //thickness=0.1 //x=6.37 //y=0.71 //x2=6.455 //y2=0.67
r78 (  13 29 ) resistor r=27.3797 //w=0.187 //l=0.4 //layer=li //thickness=0.1 \
 //x=6.37 //y=0.71 //x2=5.97 //y2=0.71
r79 (  10 29 ) resistor r=3.57586 //w=0.17 //l=0.125 //layer=li \
 //thickness=0.1 //x=5.485 //y=1.675 //x2=5.485 //y2=1.8
r80 (  10 29 ) resistor r=42.0963 //w=0.187 //l=0.615 //layer=li \
 //thickness=0.1 //x=5.485 //y=1.675 //x2=5.485 //y2=1.06
r81 (  9 29 ) resistor r=3.57586 //w=0.17 //l=0.125 //layer=li //thickness=0.1 \
 //x=5.485 //y=0.795 //x2=5.485 //y2=0.67
r82 (  9 29 ) resistor r=18.139 //w=0.187 //l=0.265 //layer=li //thickness=0.1 \
 //x=5.485 //y=0.795 //x2=5.485 //y2=1.06
r83 (  6 29 ) resistor r=3.57586 //w=0.17 //l=0.103078 //layer=li \
 //thickness=0.1 //x=4.6 //y=1.76 //x2=4.515 //y2=1.8
r84 (  6 29 ) resistor r=27.3797 //w=0.187 //l=0.4 //layer=li //thickness=0.1 \
 //x=4.6 //y=1.76 //x2=5 //y2=1.76
r85 (  5 29 ) resistor r=3.57586 //w=0.17 //l=0.103078 //layer=li \
 //thickness=0.1 //x=5.4 //y=1.76 //x2=5.485 //y2=1.8
r86 (  5 29 ) resistor r=27.3797 //w=0.187 //l=0.4 //layer=li //thickness=0.1 \
 //x=5.4 //y=1.76 //x2=5 //y2=1.76
r87 (  1 29 ) resistor r=3.57586 //w=0.17 //l=0.125 //layer=li //thickness=0.1 \
 //x=4.515 //y=1.675 //x2=4.515 //y2=1.8
r88 (  1 29 ) resistor r=42.0963 //w=0.187 //l=0.615 //layer=li \
 //thickness=0.1 //x=4.515 //y=1.675 //x2=4.515 //y2=1.06
ends PM_VOTER3X1\%noxref_12

subckt PM_VOTER3X1\%noxref_13 ( 1 5 9 10 13 17 29 )
c73 ( 29 0 ) capacitor c=0.0677185f //x=7.71 //y=0.545
c74 ( 17 0 ) capacitor c=0.00709795f //x=9.785 //y=0.795
c75 ( 13 0 ) capacitor c=0.0152565f //x=9.7 //y=0.71
c76 ( 10 0 ) capacitor c=0.00749806f //x=8.815 //y=1.675
c77 ( 9 0 ) capacitor c=0.00770028f //x=8.815 //y=0.795
c78 ( 5 0 ) capacitor c=0.0236235f //x=8.73 //y=1.76
c79 ( 1 0 ) capacitor c=0.00498238f //x=7.845 //y=1.675
r80 (  17 29 ) resistor r=3.57586 //w=0.17 //l=0.125 //layer=li \
 //thickness=0.1 //x=9.785 //y=0.795 //x2=9.785 //y2=0.67
r81 (  17 29 ) resistor r=18.139 //w=0.187 //l=0.265 //layer=li \
 //thickness=0.1 //x=9.785 //y=0.795 //x2=9.785 //y2=1.06
r82 (  14 29 ) resistor r=3.57586 //w=0.17 //l=0.103078 //layer=li \
 //thickness=0.1 //x=8.9 //y=0.71 //x2=8.815 //y2=0.67
r83 (  14 29 ) resistor r=27.3797 //w=0.187 //l=0.4 //layer=li //thickness=0.1 \
 //x=8.9 //y=0.71 //x2=9.3 //y2=0.71
r84 (  13 29 ) resistor r=3.57586 //w=0.17 //l=0.103078 //layer=li \
 //thickness=0.1 //x=9.7 //y=0.71 //x2=9.785 //y2=0.67
r85 (  13 29 ) resistor r=27.3797 //w=0.187 //l=0.4 //layer=li //thickness=0.1 \
 //x=9.7 //y=0.71 //x2=9.3 //y2=0.71
r86 (  10 29 ) resistor r=3.57586 //w=0.17 //l=0.125 //layer=li \
 //thickness=0.1 //x=8.815 //y=1.675 //x2=8.815 //y2=1.8
r87 (  10 29 ) resistor r=42.0963 //w=0.187 //l=0.615 //layer=li \
 //thickness=0.1 //x=8.815 //y=1.675 //x2=8.815 //y2=1.06
r88 (  9 29 ) resistor r=3.57586 //w=0.17 //l=0.125 //layer=li //thickness=0.1 \
 //x=8.815 //y=0.795 //x2=8.815 //y2=0.67
r89 (  9 29 ) resistor r=18.139 //w=0.187 //l=0.265 //layer=li //thickness=0.1 \
 //x=8.815 //y=0.795 //x2=8.815 //y2=1.06
r90 (  6 29 ) resistor r=3.57586 //w=0.17 //l=0.103078 //layer=li \
 //thickness=0.1 //x=7.93 //y=1.76 //x2=7.845 //y2=1.8
r91 (  6 29 ) resistor r=27.3797 //w=0.187 //l=0.4 //layer=li //thickness=0.1 \
 //x=7.93 //y=1.76 //x2=8.33 //y2=1.76
r92 (  5 29 ) resistor r=3.57586 //w=0.17 //l=0.103078 //layer=li \
 //thickness=0.1 //x=8.73 //y=1.76 //x2=8.815 //y2=1.8
r93 (  5 29 ) resistor r=27.3797 //w=0.187 //l=0.4 //layer=li //thickness=0.1 \
 //x=8.73 //y=1.76 //x2=8.33 //y2=1.76
r94 (  1 29 ) resistor r=3.57586 //w=0.17 //l=0.125 //layer=li //thickness=0.1 \
 //x=7.845 //y=1.675 //x2=7.845 //y2=1.8
r95 (  1 29 ) resistor r=42.0963 //w=0.187 //l=0.615 //layer=li \
 //thickness=0.1 //x=7.845 //y=1.675 //x2=7.845 //y2=1.06
ends PM_VOTER3X1\%noxref_13
