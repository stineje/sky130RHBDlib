// File: VOTER3X1.spi.pex
// Created: Tue Apr 29 10:46:39 2025
// Program "Calibre xRC"
// Version "v2023.2_27.15"
// Nominal Temperature: 30C
// Circuit Temperature: 30C
//
simulator lang=spectre
subckt PM_VOTER3X1\%GND ( 1 23 27 30 35 43 49 55 63 74 79 83 96 99 101 108 115 \
 116 117 118 )
c173 ( 118 0 ) capacitor c=0.0616463f //x=10.975 //y=0.55
c174 ( 117 0 ) capacitor c=0.0215071f //x=8.14 //y=1.045
c175 ( 116 0 ) capacitor c=0.0215071f //x=4.81 //y=1.045
c176 ( 115 0 ) capacitor c=0.0208055f //x=1.48 //y=1.045
c177 ( 108 0 ) capacitor c=0.254128f //x=12.08 //y=0.175
c178 ( 101 0 ) capacitor c=0.10225f //x=10.48 //y=0.175
c179 ( 100 0 ) capacitor c=0.00446416f //x=8.33 //y=0.175
c180 ( 99 0 ) capacitor c=0.101602f //x=7.15 //y=0.175
c181 ( 98 0 ) capacitor c=0.00446416f //x=4.93 //y=0.18
c182 ( 96 0 ) capacitor c=0.11818f //x=3.82 //y=0.175
c183 ( 95 0 ) capacitor c=0.00446416f //x=1.67 //y=0.175
c184 ( 86 0 ) capacitor c=0.00583665f //x=12.08 //y=0.63
c185 ( 83 0 ) capacitor c=0.00542565f //x=11.995 //y=0.715
c186 ( 82 0 ) capacitor c=0.00479856f //x=11.595 //y=0.63
c187 ( 79 0 ) capacitor c=0.00707849f //x=11.51 //y=0.715
c188 ( 74 0 ) capacitor c=0.00588377f //x=11.11 //y=0.63
c189 ( 71 0 ) capacitor c=0.0191899f //x=11.025 //y=0.175
c190 ( 63 0 ) capacitor c=0.0758845f //x=10.31 //y=0.175
c191 ( 55 0 ) capacitor c=0.0393378f //x=8.245 //y=0.175
c192 ( 49 0 ) capacitor c=0.0725462f //x=6.98 //y=0.175
c193 ( 43 0 ) capacitor c=0.0391794f //x=4.915 //y=0.175
c194 ( 35 0 ) capacitor c=0.0726871f //x=3.65 //y=0.175
c195 ( 30 0 ) capacitor c=0.195706f //x=1.23 //y=0.18
c196 ( 27 0 ) capacitor c=0.0425937f //x=1.585 //y=0.175
c197 ( 23 0 ) capacitor c=0.453876f //x=11.96 //y=0.18
r198 (  107 108 ) resistor r=4.18529 //w=0.367 //l=0.12 //layer=li \
 //thickness=0.1 //x=11.96 //y=0.175 //x2=12.08 //y2=0.175
r199 (  105 107 ) resistor r=12.7302 //w=0.367 //l=0.365 //layer=li \
 //thickness=0.1 //x=11.595 //y=0.175 //x2=11.96 //y2=0.175
r200 (  104 105 ) resistor r=13.079 //w=0.367 //l=0.375 //layer=li \
 //thickness=0.1 //x=11.22 //y=0.175 //x2=11.595 //y2=0.175
r201 (  102 104 ) resistor r=3.83651 //w=0.367 //l=0.11 //layer=li \
 //thickness=0.1 //x=11.11 //y=0.175 //x2=11.22 //y2=0.175
r202 (  87 118 ) resistor r=5.4201 //w=0.17 //l=0.085 //layer=li \
 //thickness=0.1 //x=12.08 //y=0.8 //x2=12.08 //y2=0.715
r203 (  87 118 ) resistor r=41.4118 //w=0.187 //l=0.605 //layer=li \
 //thickness=0.1 //x=12.08 //y=0.8 //x2=12.08 //y2=1.405
r204 (  86 118 ) resistor r=5.4201 //w=0.17 //l=0.085 //layer=li \
 //thickness=0.1 //x=12.08 //y=0.63 //x2=12.08 //y2=0.715
r205 (  85 108 ) resistor r=5.21862 //w=0.35 //l=0.175 //layer=li \
 //thickness=0.1 //x=12.08 //y=0.35 //x2=12.08 //y2=0.175
r206 (  85 86 ) resistor r=19.1658 //w=0.187 //l=0.28 //layer=li \
 //thickness=0.1 //x=12.08 //y=0.35 //x2=12.08 //y2=0.63
r207 (  84 118 ) resistor r=5.4201 //w=0.17 //l=0.085 //layer=li \
 //thickness=0.1 //x=11.68 //y=0.715 //x2=11.595 //y2=0.715
r208 (  83 118 ) resistor r=1.40859 //w=0.34 //l=0.085 //layer=li \
 //thickness=0.1 //x=11.995 //y=0.715 //x2=12.08 //y2=0.715
r209 (  83 84 ) resistor r=21.5615 //w=0.187 //l=0.315 //layer=li \
 //thickness=0.1 //x=11.995 //y=0.715 //x2=11.68 //y2=0.715
r210 (  82 118 ) resistor r=1.40859 //w=0.34 //l=0.085 //layer=li \
 //thickness=0.1 //x=11.595 //y=0.63 //x2=11.595 //y2=0.715
r211 (  81 105 ) resistor r=5.21862 //w=0.35 //l=0.175 //layer=li \
 //thickness=0.1 //x=11.595 //y=0.35 //x2=11.595 //y2=0.175
r212 (  81 82 ) resistor r=19.1658 //w=0.187 //l=0.28 //layer=li \
 //thickness=0.1 //x=11.595 //y=0.35 //x2=11.595 //y2=0.63
r213 (  80 118 ) resistor r=1.40859 //w=0.34 //l=0.085 //layer=li \
 //thickness=0.1 //x=11.195 //y=0.715 //x2=11.11 //y2=0.715
r214 (  79 118 ) resistor r=5.4201 //w=0.17 //l=0.085 //layer=li \
 //thickness=0.1 //x=11.51 //y=0.715 //x2=11.595 //y2=0.715
r215 (  79 80 ) resistor r=21.5615 //w=0.187 //l=0.315 //layer=li \
 //thickness=0.1 //x=11.51 //y=0.715 //x2=11.195 //y2=0.715
r216 (  75 118 ) resistor r=5.4201 //w=0.17 //l=0.085 //layer=li \
 //thickness=0.1 //x=11.11 //y=0.8 //x2=11.11 //y2=0.715
r217 (  75 118 ) resistor r=41.4118 //w=0.187 //l=0.605 //layer=li \
 //thickness=0.1 //x=11.11 //y=0.8 //x2=11.11 //y2=1.405
r218 (  74 118 ) resistor r=5.4201 //w=0.17 //l=0.085 //layer=li \
 //thickness=0.1 //x=11.11 //y=0.63 //x2=11.11 //y2=0.715
r219 (  73 102 ) resistor r=5.21862 //w=0.35 //l=0.175 //layer=li \
 //thickness=0.1 //x=11.11 //y=0.35 //x2=11.11 //y2=0.175
r220 (  73 74 ) resistor r=19.1658 //w=0.187 //l=0.28 //layer=li \
 //thickness=0.1 //x=11.11 //y=0.35 //x2=11.11 //y2=0.63
r221 (  72 101 ) resistor r=5.29055 //w=0.35 //l=0.17 //layer=li \
 //thickness=0.1 //x=10.65 //y=0.175 //x2=10.48 //y2=0.175
r222 (  71 102 ) resistor r=2.96458 //w=0.367 //l=0.085 //layer=li \
 //thickness=0.1 //x=11.025 //y=0.175 //x2=11.11 //y2=0.175
r223 (  71 72 ) resistor r=13.079 //w=0.367 //l=0.375 //layer=li \
 //thickness=0.1 //x=11.025 //y=0.175 //x2=10.65 //y2=0.175
r224 (  66 68 ) resistor r=38.7139 //w=0.367 //l=1.11 //layer=li \
 //thickness=0.1 //x=8.63 //y=0.175 //x2=9.74 //y2=0.175
r225 (  64 100 ) resistor r=2.87058 //w=0.35 //l=0.085 //layer=li \
 //thickness=0.1 //x=8.415 //y=0.175 //x2=8.33 //y2=0.175
r226 (  64 66 ) resistor r=7.49864 //w=0.367 //l=0.215 //layer=li \
 //thickness=0.1 //x=8.415 //y=0.175 //x2=8.63 //y2=0.175
r227 (  63 101 ) resistor r=5.29055 //w=0.35 //l=0.17 //layer=li \
 //thickness=0.1 //x=10.31 //y=0.175 //x2=10.48 //y2=0.175
r228 (  63 68 ) resistor r=19.8801 //w=0.367 //l=0.57 //layer=li \
 //thickness=0.1 //x=10.31 //y=0.175 //x2=9.74 //y2=0.175
r229 (  59 100 ) resistor r=4.23183 //w=0.7 //l=0.175 //layer=li \
 //thickness=0.1 //x=8.33 //y=0.35 //x2=8.33 //y2=0.175
r230 (  59 117 ) resistor r=53.7326 //w=0.187 //l=0.785 //layer=li \
 //thickness=0.1 //x=8.33 //y=0.35 //x2=8.33 //y2=1.135
r231 (  56 99 ) resistor r=5.29055 //w=0.35 //l=0.17 //layer=li \
 //thickness=0.1 //x=7.32 //y=0.175 //x2=7.15 //y2=0.175
r232 (  56 58 ) resistor r=6.97548 //w=0.367 //l=0.2 //layer=li \
 //thickness=0.1 //x=7.32 //y=0.175 //x2=7.52 //y2=0.175
r233 (  55 100 ) resistor r=2.87058 //w=0.35 //l=0.085 //layer=li \
 //thickness=0.1 //x=8.245 //y=0.175 //x2=8.33 //y2=0.175
r234 (  55 58 ) resistor r=25.2861 //w=0.367 //l=0.725 //layer=li \
 //thickness=0.1 //x=8.245 //y=0.175 //x2=7.52 //y2=0.175
r235 (  50 98 ) resistor r=2.87058 //w=0.35 //l=0.085 //layer=li \
 //thickness=0.1 //x=5.085 //y=0.175 //x2=5 //y2=0.175
r236 (  50 52 ) resistor r=33.3079 //w=0.367 //l=0.955 //layer=li \
 //thickness=0.1 //x=5.085 //y=0.175 //x2=6.04 //y2=0.175
r237 (  49 99 ) resistor r=5.29055 //w=0.35 //l=0.17 //layer=li \
 //thickness=0.1 //x=6.98 //y=0.175 //x2=7.15 //y2=0.175
r238 (  49 52 ) resistor r=32.7847 //w=0.367 //l=0.94 //layer=li \
 //thickness=0.1 //x=6.98 //y=0.175 //x2=6.04 //y2=0.175
r239 (  45 98 ) resistor r=4.23183 //w=0.7 //l=0.175 //layer=li \
 //thickness=0.1 //x=5 //y=0.35 //x2=5 //y2=0.175
r240 (  45 116 ) resistor r=53.7326 //w=0.187 //l=0.785 //layer=li \
 //thickness=0.1 //x=5 //y=0.35 //x2=5 //y2=1.135
r241 (  44 96 ) resistor r=5.29055 //w=0.35 //l=0.17 //layer=li \
 //thickness=0.1 //x=3.99 //y=0.175 //x2=3.82 //y2=0.175
r242 (  43 98 ) resistor r=2.87058 //w=0.35 //l=0.085 //layer=li \
 //thickness=0.1 //x=4.915 //y=0.175 //x2=5 //y2=0.175
r243 (  43 44 ) resistor r=32.2616 //w=0.367 //l=0.925 //layer=li \
 //thickness=0.1 //x=4.915 //y=0.175 //x2=3.99 //y2=0.175
r244 (  38 40 ) resistor r=38.7139 //w=0.367 //l=1.11 //layer=li \
 //thickness=0.1 //x=2.34 //y=0.175 //x2=3.45 //y2=0.175
r245 (  36 95 ) resistor r=2.87058 //w=0.35 //l=0.085 //layer=li \
 //thickness=0.1 //x=1.755 //y=0.175 //x2=1.67 //y2=0.175
r246 (  36 38 ) resistor r=20.4033 //w=0.367 //l=0.585 //layer=li \
 //thickness=0.1 //x=1.755 //y=0.175 //x2=2.34 //y2=0.175
r247 (  35 96 ) resistor r=5.29055 //w=0.35 //l=0.17 //layer=li \
 //thickness=0.1 //x=3.65 //y=0.175 //x2=3.82 //y2=0.175
r248 (  35 40 ) resistor r=6.97548 //w=0.367 //l=0.2 //layer=li \
 //thickness=0.1 //x=3.65 //y=0.175 //x2=3.45 //y2=0.175
r249 (  31 95 ) resistor r=4.23183 //w=0.7 //l=0.175 //layer=li \
 //thickness=0.1 //x=1.67 //y=0.35 //x2=1.67 //y2=0.175
r250 (  31 115 ) resistor r=53.7326 //w=0.187 //l=0.785 //layer=li \
 //thickness=0.1 //x=1.67 //y=0.35 //x2=1.67 //y2=1.135
r251 (  27 95 ) resistor r=2.87058 //w=0.35 //l=0.085 //layer=li \
 //thickness=0.1 //x=1.585 //y=0.175 //x2=1.67 //y2=0.175
r252 (  27 30 ) resistor r=12.3815 //w=0.367 //l=0.355 //layer=li \
 //thickness=0.1 //x=1.585 //y=0.175 //x2=1.23 //y2=0.175
r253 (  23 107 ) resistor r=4.65 //w=0.17 //l=0.34 //layer=mcon //count=2 \
 //x=11.96 //y=0.18 //x2=11.96 //y2=0.18
r254 (  21 104 ) resistor r=3.1 //w=0.17 //l=0.51 //layer=mcon //count=3 \
 //x=11.22 //y=0.18 //x2=11.22 //y2=0.18
r255 (  21 23 ) resistor r=0.297428 //w=0.311 //l=0.74 //layer=m1 \
 //thickness=0.36 //x=11.22 //y=0.175 //x2=11.96 //y2=0.175
r256 (  19 68 ) resistor r=3.1 //w=0.17 //l=0.51 //layer=mcon //count=3 \
 //x=9.74 //y=0.18 //x2=9.74 //y2=0.18
r257 (  19 21 ) resistor r=0.594855 //w=0.311 //l=1.48 //layer=m1 \
 //thickness=0.36 //x=9.74 //y=0.175 //x2=11.22 //y2=0.175
r258 (  17 66 ) resistor r=3.1 //w=0.17 //l=0.51 //layer=mcon //count=3 \
 //x=8.63 //y=0.18 //x2=8.63 //y2=0.18
r259 (  17 19 ) resistor r=0.446141 //w=0.311 //l=1.11 //layer=m1 \
 //thickness=0.36 //x=8.63 //y=0.175 //x2=9.74 //y2=0.175
r260 (  15 58 ) resistor r=3.1 //w=0.17 //l=0.51 //layer=mcon //count=3 \
 //x=7.52 //y=0.18 //x2=7.52 //y2=0.18
r261 (  15 17 ) resistor r=0.446141 //w=0.311 //l=1.11 //layer=m1 \
 //thickness=0.36 //x=7.52 //y=0.175 //x2=8.63 //y2=0.175
r262 (  12 52 ) resistor r=3.1 //w=0.17 //l=0.51 //layer=mcon //count=3 \
 //x=6.04 //y=0.18 //x2=6.04 //y2=0.18
r263 (  10 98 ) resistor r=3.1 //w=0.17 //l=0.51 //layer=mcon //count=3 \
 //x=4.93 //y=0.18 //x2=4.93 //y2=0.18
r264 (  10 12 ) resistor r=0.446141 //w=0.311 //l=1.11 //layer=m1 \
 //thickness=0.36 //x=4.93 //y=0.175 //x2=6.04 //y2=0.175
r265 (  8 40 ) resistor r=3.1 //w=0.17 //l=0.51 //layer=mcon //count=3 \
 //x=3.45 //y=0.18 //x2=3.45 //y2=0.18
r266 (  8 10 ) resistor r=0.594855 //w=0.311 //l=1.48 //layer=m1 \
 //thickness=0.36 //x=3.45 //y=0.175 //x2=4.93 //y2=0.175
r267 (  6 38 ) resistor r=3.1 //w=0.17 //l=0.51 //layer=mcon //count=3 \
 //x=2.34 //y=0.18 //x2=2.34 //y2=0.18
r268 (  6 8 ) resistor r=0.446141 //w=0.311 //l=1.11 //layer=m1 \
 //thickness=0.36 //x=2.34 //y=0.175 //x2=3.45 //y2=0.175
r269 (  3 30 ) resistor r=3.1 //w=0.17 //l=0.51 //layer=mcon //count=3 \
 //x=1.23 //y=0.18 //x2=1.23 //y2=0.18
r270 (  3 6 ) resistor r=0.446141 //w=0.311 //l=1.11 //layer=m1 \
 //thickness=0.36 //x=1.23 //y=0.175 //x2=2.34 //y2=0.175
r271 (  1 15 ) resistor r=0.371785 //w=0.311 //l=0.925 //layer=m1 \
 //thickness=0.36 //x=6.595 //y=0.175 //x2=7.52 //y2=0.175
r272 (  1 12 ) resistor r=0.223071 //w=0.311 //l=0.555 //layer=m1 \
 //thickness=0.36 //x=6.595 //y=0.175 //x2=6.04 //y2=0.175
ends PM_VOTER3X1\%GND

subckt PM_VOTER3X1\%VDD ( 1 23 35 43 59 67 85 98 101 102 103 107 108 109 110 \
 111 112 )
c136 ( 112 0 ) capacitor c=0.0451938f //x=11.89 //y=5.2
c137 ( 111 0 ) capacitor c=0.0420334f //x=11.02 //y=5.2
c138 ( 110 0 ) capacitor c=0.0476809f //x=2.895 //y=5.205
c139 ( 109 0 ) capacitor c=0.0241715f //x=2.015 //y=5.205
c140 ( 108 0 ) capacitor c=0.0467094f //x=1.145 //y=5.205
c141 ( 107 0 ) capacitor c=0.253514f //x=11.96 //y=7.58
c142 ( 105 0 ) capacitor c=0.00597439f //x=11.22 //y=7.58
c143 ( 103 0 ) capacitor c=0.107874f //x=10.48 //y=7.585
c144 ( 102 0 ) capacitor c=0.113266f //x=7.15 //y=7.585
c145 ( 101 0 ) capacitor c=0.121189f //x=3.82 //y=7.585
c146 ( 100 0 ) capacitor c=0.00597439f //x=3.04 //y=7.585
c147 ( 99 0 ) capacitor c=0.00597439f //x=2.16 //y=7.585
c148 ( 98 0 ) capacitor c=0.264173f //x=1.23 //y=7.58
c149 ( 85 0 ) capacitor c=0.029016f //x=11.95 //y=7.585
c150 ( 77 0 ) capacitor c=0.0217664f //x=11.07 //y=7.585
c151 ( 67 0 ) capacitor c=0.128258f //x=10.31 //y=7.585
c152 ( 59 0 ) capacitor c=0.12864f //x=6.98 //y=7.585
c153 ( 53 0 ) capacitor c=0.0277785f //x=3.65 //y=7.585
c154 ( 43 0 ) capacitor c=0.0295446f //x=2.955 //y=7.585
c155 ( 35 0 ) capacitor c=0.029367f //x=2.075 //y=7.585
c156 ( 23 0 ) capacitor c=0.498608f //x=11.96 //y=7.58
r157 (  87 107 ) resistor r=4.23183 //w=0.7 //l=0.175 //layer=li \
 //thickness=0.1 //x=12.035 //y=7.41 //x2=12.035 //y2=7.585
r158 (  87 112 ) resistor r=56.4706 //w=0.187 //l=0.825 //layer=li \
 //thickness=0.1 //x=12.035 //y=7.41 //x2=12.035 //y2=6.585
r159 (  86 105 ) resistor r=2.87058 //w=0.35 //l=0.085 //layer=li \
 //thickness=0.1 //x=11.24 //y=7.585 //x2=11.155 //y2=7.585
r160 (  85 107 ) resistor r=2.87058 //w=0.35 //l=0.085 //layer=li \
 //thickness=0.1 //x=11.95 //y=7.585 //x2=12.035 //y2=7.585
r161 (  85 86 ) resistor r=24.7629 //w=0.367 //l=0.71 //layer=li \
 //thickness=0.1 //x=11.95 //y=7.585 //x2=11.24 //y2=7.585
r162 (  79 105 ) resistor r=4.23183 //w=0.7 //l=0.175 //layer=li \
 //thickness=0.1 //x=11.155 //y=7.41 //x2=11.155 //y2=7.585
r163 (  79 111 ) resistor r=56.4706 //w=0.187 //l=0.825 //layer=li \
 //thickness=0.1 //x=11.155 //y=7.41 //x2=11.155 //y2=6.585
r164 (  78 103 ) resistor r=5.29055 //w=0.35 //l=0.17 //layer=li \
 //thickness=0.1 //x=10.65 //y=7.585 //x2=10.48 //y2=7.585
r165 (  77 105 ) resistor r=2.87058 //w=0.35 //l=0.085 //layer=li \
 //thickness=0.1 //x=11.07 //y=7.585 //x2=11.155 //y2=7.585
r166 (  77 78 ) resistor r=14.6485 //w=0.367 //l=0.42 //layer=li \
 //thickness=0.1 //x=11.07 //y=7.585 //x2=10.65 //y2=7.585
r167 (  72 74 ) resistor r=38.7139 //w=0.367 //l=1.11 //layer=li \
 //thickness=0.1 //x=8.63 //y=7.585 //x2=9.74 //y2=7.585
r168 (  70 72 ) resistor r=38.7139 //w=0.367 //l=1.11 //layer=li \
 //thickness=0.1 //x=7.52 //y=7.585 //x2=8.63 //y2=7.585
r169 (  68 102 ) resistor r=5.29055 //w=0.35 //l=0.17 //layer=li \
 //thickness=0.1 //x=7.32 //y=7.585 //x2=7.15 //y2=7.585
r170 (  68 70 ) resistor r=6.97548 //w=0.367 //l=0.2 //layer=li \
 //thickness=0.1 //x=7.32 //y=7.585 //x2=7.52 //y2=7.585
r171 (  67 103 ) resistor r=5.29055 //w=0.35 //l=0.17 //layer=li \
 //thickness=0.1 //x=10.31 //y=7.585 //x2=10.48 //y2=7.585
r172 (  67 74 ) resistor r=19.8801 //w=0.367 //l=0.57 //layer=li \
 //thickness=0.1 //x=10.31 //y=7.585 //x2=9.74 //y2=7.585
r173 (  62 64 ) resistor r=38.7139 //w=0.367 //l=1.11 //layer=li \
 //thickness=0.1 //x=4.93 //y=7.585 //x2=6.04 //y2=7.585
r174 (  60 101 ) resistor r=5.29055 //w=0.35 //l=0.17 //layer=li \
 //thickness=0.1 //x=3.99 //y=7.585 //x2=3.82 //y2=7.585
r175 (  60 62 ) resistor r=32.7847 //w=0.367 //l=0.94 //layer=li \
 //thickness=0.1 //x=3.99 //y=7.585 //x2=4.93 //y2=7.585
r176 (  59 102 ) resistor r=5.29055 //w=0.35 //l=0.17 //layer=li \
 //thickness=0.1 //x=6.98 //y=7.585 //x2=7.15 //y2=7.585
r177 (  59 64 ) resistor r=32.7847 //w=0.367 //l=0.94 //layer=li \
 //thickness=0.1 //x=6.98 //y=7.585 //x2=6.04 //y2=7.585
r178 (  54 100 ) resistor r=2.87058 //w=0.35 //l=0.085 //layer=li \
 //thickness=0.1 //x=3.125 //y=7.585 //x2=3.04 //y2=7.585
r179 (  54 56 ) resistor r=11.3351 //w=0.367 //l=0.325 //layer=li \
 //thickness=0.1 //x=3.125 //y=7.585 //x2=3.45 //y2=7.585
r180 (  53 101 ) resistor r=5.29055 //w=0.35 //l=0.17 //layer=li \
 //thickness=0.1 //x=3.65 //y=7.585 //x2=3.82 //y2=7.585
r181 (  53 56 ) resistor r=6.97548 //w=0.367 //l=0.2 //layer=li \
 //thickness=0.1 //x=3.65 //y=7.585 //x2=3.45 //y2=7.585
r182 (  47 100 ) resistor r=4.23183 //w=0.7 //l=0.175 //layer=li \
 //thickness=0.1 //x=3.04 //y=7.41 //x2=3.04 //y2=7.585
r183 (  47 110 ) resistor r=56.8128 //w=0.187 //l=0.83 //layer=li \
 //thickness=0.1 //x=3.04 //y=7.41 //x2=3.04 //y2=6.58
r184 (  44 99 ) resistor r=2.87058 //w=0.35 //l=0.085 //layer=li \
 //thickness=0.1 //x=2.245 //y=7.585 //x2=2.16 //y2=7.585
r185 (  44 46 ) resistor r=3.31335 //w=0.367 //l=0.095 //layer=li \
 //thickness=0.1 //x=2.245 //y=7.585 //x2=2.34 //y2=7.585
r186 (  43 100 ) resistor r=2.87058 //w=0.35 //l=0.085 //layer=li \
 //thickness=0.1 //x=2.955 //y=7.585 //x2=3.04 //y2=7.585
r187 (  43 46 ) resistor r=21.4496 //w=0.367 //l=0.615 //layer=li \
 //thickness=0.1 //x=2.955 //y=7.585 //x2=2.34 //y2=7.585
r188 (  37 99 ) resistor r=4.23183 //w=0.7 //l=0.175 //layer=li \
 //thickness=0.1 //x=2.16 //y=7.41 //x2=2.16 //y2=7.585
r189 (  37 109 ) resistor r=33.5401 //w=0.187 //l=0.49 //layer=li \
 //thickness=0.1 //x=2.16 //y=7.41 //x2=2.16 //y2=6.92
r190 (  36 98 ) resistor r=2.87058 //w=0.35 //l=0.085 //layer=li \
 //thickness=0.1 //x=1.365 //y=7.585 //x2=1.28 //y2=7.585
r191 (  35 99 ) resistor r=2.87058 //w=0.35 //l=0.085 //layer=li \
 //thickness=0.1 //x=2.075 //y=7.585 //x2=2.16 //y2=7.585
r192 (  35 36 ) resistor r=24.7629 //w=0.367 //l=0.71 //layer=li \
 //thickness=0.1 //x=2.075 //y=7.585 //x2=1.365 //y2=7.585
r193 (  29 98 ) resistor r=4.23183 //w=0.7 //l=0.175 //layer=li \
 //thickness=0.1 //x=1.28 //y=7.41 //x2=1.28 //y2=7.585
r194 (  29 108 ) resistor r=56.8128 //w=0.187 //l=0.83 //layer=li \
 //thickness=0.1 //x=1.28 //y=7.41 //x2=1.28 //y2=6.58
r195 (  23 107 ) resistor r=4.65 //w=0.17 //l=0.34 //layer=mcon //count=2 \
 //x=11.96 //y=7.58 //x2=11.96 //y2=7.58
r196 (  21 105 ) resistor r=3.1 //w=0.17 //l=0.51 //layer=mcon //count=3 \
 //x=11.22 //y=7.58 //x2=11.22 //y2=7.58
r197 (  21 23 ) resistor r=0.297428 //w=0.311 //l=0.74 //layer=m1 \
 //thickness=0.36 //x=11.22 //y=7.585 //x2=11.96 //y2=7.585
r198 (  19 74 ) resistor r=3.1 //w=0.17 //l=0.51 //layer=mcon //count=3 \
 //x=9.74 //y=7.58 //x2=9.74 //y2=7.58
r199 (  19 21 ) resistor r=0.594855 //w=0.311 //l=1.48 //layer=m1 \
 //thickness=0.36 //x=9.74 //y=7.585 //x2=11.22 //y2=7.585
r200 (  17 72 ) resistor r=3.1 //w=0.17 //l=0.51 //layer=mcon //count=3 \
 //x=8.63 //y=7.58 //x2=8.63 //y2=7.58
r201 (  17 19 ) resistor r=0.446141 //w=0.311 //l=1.11 //layer=m1 \
 //thickness=0.36 //x=8.63 //y=7.585 //x2=9.74 //y2=7.585
r202 (  15 70 ) resistor r=3.1 //w=0.17 //l=0.51 //layer=mcon //count=3 \
 //x=7.52 //y=7.58 //x2=7.52 //y2=7.58
r203 (  15 17 ) resistor r=0.446141 //w=0.311 //l=1.11 //layer=m1 \
 //thickness=0.36 //x=7.52 //y=7.585 //x2=8.63 //y2=7.585
r204 (  12 64 ) resistor r=3.1 //w=0.17 //l=0.51 //layer=mcon //count=3 \
 //x=6.04 //y=7.58 //x2=6.04 //y2=7.58
r205 (  10 62 ) resistor r=3.1 //w=0.17 //l=0.51 //layer=mcon //count=3 \
 //x=4.93 //y=7.58 //x2=4.93 //y2=7.58
r206 (  10 12 ) resistor r=0.446141 //w=0.311 //l=1.11 //layer=m1 \
 //thickness=0.36 //x=4.93 //y=7.585 //x2=6.04 //y2=7.585
r207 (  8 56 ) resistor r=3.1 //w=0.17 //l=0.51 //layer=mcon //count=3 \
 //x=3.45 //y=7.58 //x2=3.45 //y2=7.58
r208 (  8 10 ) resistor r=0.594855 //w=0.311 //l=1.48 //layer=m1 \
 //thickness=0.36 //x=3.45 //y=7.585 //x2=4.93 //y2=7.585
r209 (  6 46 ) resistor r=3.1 //w=0.17 //l=0.51 //layer=mcon //count=3 \
 //x=2.34 //y=7.58 //x2=2.34 //y2=7.58
r210 (  6 8 ) resistor r=0.446141 //w=0.311 //l=1.11 //layer=m1 \
 //thickness=0.36 //x=2.34 //y=7.585 //x2=3.45 //y2=7.585
r211 (  3 98 ) resistor r=3.1 //w=0.17 //l=0.51 //layer=mcon //count=3 \
 //x=1.23 //y=7.58 //x2=1.23 //y2=7.58
r212 (  3 6 ) resistor r=0.446141 //w=0.311 //l=1.11 //layer=m1 \
 //thickness=0.36 //x=1.23 //y=7.585 //x2=2.34 //y2=7.585
r213 (  1 15 ) resistor r=0.371785 //w=0.311 //l=0.925 //layer=m1 \
 //thickness=0.36 //x=6.595 //y=7.585 //x2=7.52 //y2=7.585
r214 (  1 12 ) resistor r=0.223071 //w=0.311 //l=0.555 //layer=m1 \
 //thickness=0.36 //x=6.595 //y=7.585 //x2=6.04 //y2=7.585
ends PM_VOTER3X1\%VDD

subckt PM_VOTER3X1\%noxref_3 ( 1 2 13 14 15 23 29 30 37 49 50 51 52 53 54 )
c91 ( 54 0 ) capacitor c=0.034295f //x=6.215 //y=5.205
c92 ( 53 0 ) capacitor c=0.0174957f //x=5.335 //y=5.205
c93 ( 51 0 ) capacitor c=0.0214849f //x=2.455 //y=5.205
c94 ( 50 0 ) capacitor c=0.0218033f //x=1.575 //y=5.205
c95 ( 49 0 ) capacitor c=0.00115294f //x=5.48 //y=7.09
c96 ( 37 0 ) capacitor c=0.0131338f //x=6.275 //y=7.09
c97 ( 30 0 ) capacitor c=0.00386507f //x=4.685 //y=7.09
c98 ( 29 0 ) capacitor c=0.0100992f //x=5.395 //y=7.09
c99 ( 23 0 ) capacitor c=0.0453878f //x=4.6 //y=5.39
c100 ( 15 0 ) capacitor c=0.00855201f //x=2.6 //y=5.475
c101 ( 14 0 ) capacitor c=0.00290434f //x=1.805 //y=5.39
c102 ( 13 0 ) capacitor c=0.0150963f //x=2.515 //y=5.39
c103 ( 2 0 ) capacitor c=0.0111402f //x=2.715 //y=5.39
c104 ( 1 0 ) capacitor c=0.0706872f //x=4.485 //y=5.39
r105 (  39 54 ) resistor r=5.81818 //w=0.187 //l=0.085 //layer=li \
 //thickness=0.1 //x=6.36 //y=7.005 //x2=6.36 //y2=6.92
r106 (  38 49 ) resistor r=5.4201 //w=0.17 //l=0.085 //layer=li \
 //thickness=0.1 //x=5.565 //y=7.09 //x2=5.48 //y2=7.09
r107 (  37 39 ) resistor r=7.15173 //w=0.17 //l=0.120208 //layer=li \
 //thickness=0.1 //x=6.275 //y=7.09 //x2=6.36 //y2=7.005
r108 (  37 38 ) resistor r=48.5989 //w=0.187 //l=0.71 //layer=li \
 //thickness=0.1 //x=6.275 //y=7.09 //x2=5.565 //y2=7.09
r109 (  31 49 ) resistor r=1.40859 //w=0.34 //l=0.085 //layer=li \
 //thickness=0.1 //x=5.48 //y=7.005 //x2=5.48 //y2=7.09
r110 (  31 53 ) resistor r=5.81818 //w=0.187 //l=0.085 //layer=li \
 //thickness=0.1 //x=5.48 //y=7.005 //x2=5.48 //y2=6.92
r111 (  29 49 ) resistor r=5.4201 //w=0.17 //l=0.085 //layer=li \
 //thickness=0.1 //x=5.395 //y=7.09 //x2=5.48 //y2=7.09
r112 (  29 30 ) resistor r=48.5989 //w=0.187 //l=0.71 //layer=li \
 //thickness=0.1 //x=5.395 //y=7.09 //x2=4.685 //y2=7.09
r113 (  23 52 ) resistor r=58.1818 //w=0.187 //l=0.85 //layer=li \
 //thickness=0.1 //x=4.6 //y=5.39 //x2=4.6 //y2=6.24
r114 (  21 30 ) resistor r=7.15173 //w=0.17 //l=0.120208 //layer=li \
 //thickness=0.1 //x=4.6 //y=7.005 //x2=4.685 //y2=7.09
r115 (  21 52 ) resistor r=5.81818 //w=0.187 //l=0.085 //layer=li \
 //thickness=0.1 //x=4.6 //y=7.005 //x2=4.6 //y2=6.92
r116 (  15 48 ) resistor r=3.57586 //w=0.17 //l=0.125 //layer=li \
 //thickness=0.1 //x=2.6 //y=5.475 //x2=2.6 //y2=5.35
r117 (  15 51 ) resistor r=52.3636 //w=0.187 //l=0.765 //layer=li \
 //thickness=0.1 //x=2.6 //y=5.475 //x2=2.6 //y2=6.24
r118 (  13 48 ) resistor r=3.57586 //w=0.17 //l=0.103078 //layer=li \
 //thickness=0.1 //x=2.515 //y=5.39 //x2=2.6 //y2=5.35
r119 (  13 14 ) resistor r=48.5989 //w=0.187 //l=0.71 //layer=li \
 //thickness=0.1 //x=2.515 //y=5.39 //x2=1.805 //y2=5.39
r120 (  7 14 ) resistor r=7.15173 //w=0.17 //l=0.120208 //layer=li \
 //thickness=0.1 //x=1.72 //y=5.475 //x2=1.805 //y2=5.39
r121 (  7 50 ) resistor r=29.0909 //w=0.187 //l=0.425 //layer=li \
 //thickness=0.1 //x=1.72 //y=5.475 //x2=1.72 //y2=5.9
r122 (  6 23 ) resistor r=9.3 //w=0.17 //l=0.17 //layer=mcon //count=1 //x=4.6 \
 //y=5.39 //x2=4.6 //y2=5.39
r123 (  4 48 ) resistor r=9.3 //w=0.17 //l=0.17 //layer=mcon //count=1 //x=2.6 \
 //y=5.39 //x2=2.6 //y2=5.39
r124 (  2 4 ) resistor r=0.0717383 //w=0.224 //l=0.115 //layer=m1 \
 //thickness=0.36 //x=2.715 //y=5.39 //x2=2.6 //y2=5.39
r125 (  1 6 ) resistor r=0.0717383 //w=0.224 //l=0.115 //layer=m1 \
 //thickness=0.36 //x=4.485 //y=5.39 //x2=4.6 //y2=5.39
r126 (  1 2 ) resistor r=1.68893 //w=0.131 //l=1.77 //layer=m1 \
 //thickness=0.36 //x=4.485 //y=5.39 //x2=2.715 //y2=5.39
ends PM_VOTER3X1\%noxref_3

subckt PM_VOTER3X1\%B ( 1 2 7 8 9 10 11 12 13 14 15 16 17 19 32 43 44 45 46 47 \
 48 49 50 51 52 56 58 61 62 63 64 68 69 70 71 75 77 83 84 86 99 )
c153 ( 99 0 ) capacitor c=0.0655948f //x=4.93 //y=4.885
c154 ( 86 0 ) capacitor c=0.0582862f //x=1.23 //y=2.26
c155 ( 84 0 ) capacitor c=0.0342409f //x=5.265 //y=1.39
c156 ( 83 0 ) capacitor c=0.0187384f //x=5.265 //y=1.045
c157 ( 77 0 ) capacitor c=0.0141797f //x=5.11 //y=1.545
c158 ( 75 0 ) capacitor c=0.0149844f //x=5.11 //y=0.89
c159 ( 71 0 ) capacitor c=0.10193f //x=4.735 //y=2.095
c160 ( 70 0 ) capacitor c=0.0225105f //x=4.735 //y=1.7
c161 ( 69 0 ) capacitor c=0.0234376f //x=4.735 //y=1.39
c162 ( 68 0 ) capacitor c=0.0199343f //x=4.735 //y=1.045
c163 ( 64 0 ) capacitor c=0.0318948f //x=1.935 //y=1.39
c164 ( 63 0 ) capacitor c=0.0187384f //x=1.935 //y=1.045
c165 ( 62 0 ) capacitor c=0.0607141f //x=1.575 //y=4.975
c166 ( 61 0 ) capacitor c=0.0292043f //x=1.865 //y=4.975
c167 ( 58 0 ) capacitor c=0.0157913f //x=1.78 //y=1.545
c168 ( 56 0 ) capacitor c=0.0149844f //x=1.78 //y=0.89
c169 ( 52 0 ) capacitor c=0.0302441f //x=1.405 //y=2.095
c170 ( 51 0 ) capacitor c=0.0238107f //x=1.405 //y=1.7
c171 ( 50 0 ) capacitor c=0.0234352f //x=1.405 //y=1.39
c172 ( 49 0 ) capacitor c=0.0199931f //x=1.405 //y=1.045
c173 ( 48 0 ) capacitor c=0.110336f //x=5.26 //y=6.205
c174 ( 47 0 ) capacitor c=0.154049f //x=4.82 //y=6.205
c175 ( 46 0 ) capacitor c=0.110003f //x=1.94 //y=6.205
c176 ( 45 0 ) capacitor c=0.15424f //x=1.5 //y=6.205
c177 ( 32 0 ) capacitor c=0.122411f //x=4.93 //y=2.26
c178 ( 19 0 ) capacitor c=0.12196f //x=1.23 //y=2.26
c179 ( 2 0 ) capacitor c=0.0208472f //x=1.345 //y=4.62
c180 ( 1 0 ) capacitor c=0.119494f //x=4.815 //y=4.62
r181 (  97 99 ) resistor r=22.7554 //w=0.233 //l=0.11 //layer=ply \
 //thickness=0.18 //x=4.82 //y=4.885 //x2=4.93 //y2=4.885
r182 (  84 101 ) resistor r=45.1352 //w=0.168 //l=0.173853 //layer=ply \
 //thickness=0.18 //x=5.265 //y=1.39 //x2=5.225 //y2=1.545
r183 (  83 100 ) resistor r=45.1352 //w=0.168 //l=0.173853 //layer=ply \
 //thickness=0.18 //x=5.265 //y=1.045 //x2=5.225 //y2=0.89
r184 (  83 84 ) resistor r=176.904 //w=0.094 //l=0.345 //layer=ply \
 //thickness=0.18 //x=5.265 //y=1.045 //x2=5.265 //y2=1.39
r185 (  80 99 ) resistor r=68.2661 //w=0.233 //l=0.404166 //layer=ply \
 //thickness=0.18 //x=5.26 //y=5.05 //x2=4.93 //y2=4.885
r186 (  78 96 ) resistor r=10.701 //w=0.21 //l=0.115 //layer=ply \
 //thickness=0.18 //x=4.89 //y=1.545 //x2=4.775 //y2=1.545
r187 (  77 101 ) resistor r=5.52526 //w=0.168 //l=0.115 //layer=ply \
 //thickness=0.18 //x=5.11 //y=1.545 //x2=5.225 //y2=1.545
r188 (  76 95 ) resistor r=5.52526 //w=0.168 //l=0.115 //layer=ply \
 //thickness=0.18 //x=4.89 //y=0.89 //x2=4.775 //y2=0.89
r189 (  75 100 ) resistor r=5.52526 //w=0.168 //l=0.115 //layer=ply \
 //thickness=0.18 //x=5.11 //y=0.89 //x2=5.225 //y2=0.89
r190 (  75 76 ) resistor r=112.809 //w=0.094 //l=0.22 //layer=ply \
 //thickness=0.18 //x=5.11 //y=0.89 //x2=4.89 //y2=0.89
r191 (  72 97 ) resistor r=13.0941 //w=0.233 //l=0.165 //layer=ply \
 //thickness=0.18 //x=4.82 //y=5.05 //x2=4.82 //y2=4.885
r192 (  71 94 ) resistor r=34.8111 //w=0.27 //l=0.264953 //layer=ply \
 //thickness=0.18 //x=4.735 //y=2.095 //x2=4.93 //y2=2.26
r193 (  70 96 ) resistor r=39.5823 //w=0.21 //l=0.173853 //layer=ply \
 //thickness=0.18 //x=4.735 //y=1.7 //x2=4.775 //y2=1.545
r194 (  70 71 ) resistor r=202.543 //w=0.094 //l=0.395 //layer=ply \
 //thickness=0.18 //x=4.735 //y=1.7 //x2=4.735 //y2=2.095
r195 (  69 96 ) resistor r=39.5823 //w=0.21 //l=0.173853 //layer=ply \
 //thickness=0.18 //x=4.735 //y=1.39 //x2=4.775 //y2=1.545
r196 (  68 95 ) resistor r=45.1352 //w=0.168 //l=0.173853 //layer=ply \
 //thickness=0.18 //x=4.735 //y=1.045 //x2=4.775 //y2=0.89
r197 (  68 69 ) resistor r=176.904 //w=0.094 //l=0.345 //layer=ply \
 //thickness=0.18 //x=4.735 //y=1.045 //x2=4.735 //y2=1.39
r198 (  64 92 ) resistor r=45.1352 //w=0.168 //l=0.173853 //layer=ply \
 //thickness=0.18 //x=1.935 //y=1.39 //x2=1.895 //y2=1.545
r199 (  63 91 ) resistor r=45.1352 //w=0.168 //l=0.173853 //layer=ply \
 //thickness=0.18 //x=1.935 //y=1.045 //x2=1.895 //y2=0.89
r200 (  63 64 ) resistor r=176.904 //w=0.094 //l=0.345 //layer=ply \
 //thickness=0.18 //x=1.935 //y=1.045 //x2=1.935 //y2=1.39
r201 (  61 65 ) resistor r=26.9307 //w=0.15 //l=0.106066 //layer=ply \
 //thickness=0.18 //x=1.865 //y=4.975 //x2=1.94 //y2=5.05
r202 (  61 62 ) resistor r=148.702 //w=0.094 //l=0.29 //layer=ply \
 //thickness=0.18 //x=1.865 //y=4.975 //x2=1.575 //y2=4.975
r203 (  59 90 ) resistor r=10.701 //w=0.21 //l=0.115 //layer=ply \
 //thickness=0.18 //x=1.56 //y=1.545 //x2=1.445 //y2=1.545
r204 (  58 92 ) resistor r=5.52526 //w=0.168 //l=0.115 //layer=ply \
 //thickness=0.18 //x=1.78 //y=1.545 //x2=1.895 //y2=1.545
r205 (  57 89 ) resistor r=5.52526 //w=0.168 //l=0.115 //layer=ply \
 //thickness=0.18 //x=1.56 //y=0.89 //x2=1.445 //y2=0.89
r206 (  56 91 ) resistor r=5.52526 //w=0.168 //l=0.115 //layer=ply \
 //thickness=0.18 //x=1.78 //y=0.89 //x2=1.895 //y2=0.89
r207 (  56 57 ) resistor r=112.809 //w=0.094 //l=0.22 //layer=ply \
 //thickness=0.18 //x=1.78 //y=0.89 //x2=1.56 //y2=0.89
r208 (  53 62 ) resistor r=22.1787 //w=0.252 //l=0.106066 //layer=ply \
 //thickness=0.18 //x=1.5 //y=5.05 //x2=1.575 //y2=4.975
r209 (  53 88 ) resistor r=51.6429 //w=0.252 //l=0.34271 //layer=ply \
 //thickness=0.18 //x=1.5 //y=5.05 //x2=1.23 //y2=4.885
r210 (  52 86 ) resistor r=30.4513 //w=0.277 //l=0.243926 //layer=ply \
 //thickness=0.18 //x=1.405 //y=2.095 //x2=1.23 //y2=2.26
r211 (  51 90 ) resistor r=39.5823 //w=0.21 //l=0.173853 //layer=ply \
 //thickness=0.18 //x=1.405 //y=1.7 //x2=1.445 //y2=1.545
r212 (  51 52 ) resistor r=202.543 //w=0.094 //l=0.395 //layer=ply \
 //thickness=0.18 //x=1.405 //y=1.7 //x2=1.405 //y2=2.095
r213 (  50 90 ) resistor r=39.5823 //w=0.21 //l=0.173853 //layer=ply \
 //thickness=0.18 //x=1.405 //y=1.39 //x2=1.445 //y2=1.545
r214 (  49 89 ) resistor r=45.1352 //w=0.168 //l=0.173853 //layer=ply \
 //thickness=0.18 //x=1.405 //y=1.045 //x2=1.445 //y2=0.89
r215 (  49 50 ) resistor r=176.904 //w=0.094 //l=0.345 //layer=ply \
 //thickness=0.18 //x=1.405 //y=1.045 //x2=1.405 //y2=1.39
r216 (  48 80 ) resistor r=592.245 //w=0.094 //l=1.155 //layer=ply \
 //thickness=0.18 //x=5.26 //y=6.205 //x2=5.26 //y2=5.05
r217 (  47 72 ) resistor r=592.245 //w=0.094 //l=1.155 //layer=ply \
 //thickness=0.18 //x=4.82 //y=6.205 //x2=4.82 //y2=5.05
r218 (  46 65 ) resistor r=592.245 //w=0.094 //l=1.155 //layer=ply \
 //thickness=0.18 //x=1.94 //y=6.205 //x2=1.94 //y2=5.05
r219 (  45 53 ) resistor r=592.245 //w=0.094 //l=1.155 //layer=ply \
 //thickness=0.18 //x=1.5 //y=6.205 //x2=1.5 //y2=5.05
r220 (  44 77 ) resistor r=56.4043 //w=0.094 //l=0.11 //layer=ply \
 //thickness=0.18 //x=5 //y=1.545 //x2=5.11 //y2=1.545
r221 (  44 78 ) resistor r=56.4043 //w=0.094 //l=0.11 //layer=ply \
 //thickness=0.18 //x=5 //y=1.545 //x2=4.89 //y2=1.545
r222 (  43 58 ) resistor r=56.4043 //w=0.094 //l=0.11 //layer=ply \
 //thickness=0.18 //x=1.67 //y=1.545 //x2=1.78 //y2=1.545
r223 (  43 59 ) resistor r=56.4043 //w=0.094 //l=0.11 //layer=ply \
 //thickness=0.18 //x=1.67 //y=1.545 //x2=1.56 //y2=1.545
r224 (  41 99 ) resistor r=152 //w=0.17 //l=0.17 //layer=licon //count=1 \
 //x=4.93 //y=4.885 //x2=4.93 //y2=4.885
r225 (  32 94 ) resistor r=152 //w=0.17 //l=0.17 //layer=licon //count=1 \
 //x=4.93 //y=2.26 //x2=4.93 //y2=2.26
r226 (  29 88 ) resistor r=152 //w=0.17 //l=0.17 //layer=licon //count=1 \
 //x=1.23 //y=4.885 //x2=1.23 //y2=4.885
r227 (  19 86 ) resistor r=152 //w=0.17 //l=0.17 //layer=licon //count=1 \
 //x=1.23 //y=2.26 //x2=1.23 //y2=2.26
r228 (  17 41 ) resistor r=18.139 //w=0.187 //l=0.265 //layer=li \
 //thickness=0.1 //x=4.93 //y=4.62 //x2=4.93 //y2=4.885
r229 (  16 17 ) resistor r=50.6524 //w=0.187 //l=0.74 //layer=li \
 //thickness=0.1 //x=4.93 //y=3.88 //x2=4.93 //y2=4.62
r230 (  15 16 ) resistor r=25.3262 //w=0.187 //l=0.37 //layer=li \
 //thickness=0.1 //x=4.93 //y=3.51 //x2=4.93 //y2=3.88
r231 (  14 15 ) resistor r=25.3262 //w=0.187 //l=0.37 //layer=li \
 //thickness=0.1 //x=4.93 //y=3.14 //x2=4.93 //y2=3.51
r232 (  13 14 ) resistor r=25.3262 //w=0.187 //l=0.37 //layer=li \
 //thickness=0.1 //x=4.93 //y=2.77 //x2=4.93 //y2=3.14
r233 (  13 32 ) resistor r=34.9091 //w=0.187 //l=0.51 //layer=li \
 //thickness=0.1 //x=4.93 //y=2.77 //x2=4.93 //y2=2.26
r234 (  12 29 ) resistor r=18.139 //w=0.187 //l=0.265 //layer=li \
 //thickness=0.1 //x=1.23 //y=4.62 //x2=1.23 //y2=4.885
r235 (  11 12 ) resistor r=25.3262 //w=0.187 //l=0.37 //layer=li \
 //thickness=0.1 //x=1.23 //y=4.25 //x2=1.23 //y2=4.62
r236 (  10 11 ) resistor r=25.3262 //w=0.187 //l=0.37 //layer=li \
 //thickness=0.1 //x=1.23 //y=3.88 //x2=1.23 //y2=4.25
r237 (  9 10 ) resistor r=25.3262 //w=0.187 //l=0.37 //layer=li \
 //thickness=0.1 //x=1.23 //y=3.51 //x2=1.23 //y2=3.88
r238 (  8 9 ) resistor r=25.3262 //w=0.187 //l=0.37 //layer=li //thickness=0.1 \
 //x=1.23 //y=3.14 //x2=1.23 //y2=3.51
r239 (  7 8 ) resistor r=25.3262 //w=0.187 //l=0.37 //layer=li //thickness=0.1 \
 //x=1.23 //y=2.77 //x2=1.23 //y2=3.14
r240 (  7 19 ) resistor r=34.9091 //w=0.187 //l=0.51 //layer=li \
 //thickness=0.1 //x=1.23 //y=2.77 //x2=1.23 //y2=2.26
r241 (  6 17 ) resistor r=9.3 //w=0.17 //l=0.17 //layer=mcon //count=1 \
 //x=4.93 //y=4.62 //x2=4.93 //y2=4.62
r242 (  4 12 ) resistor r=9.3 //w=0.17 //l=0.17 //layer=mcon //count=1 \
 //x=1.23 //y=4.62 //x2=1.23 //y2=4.62
r243 (  2 4 ) resistor r=0.0717383 //w=0.224 //l=0.115 //layer=m1 \
 //thickness=0.36 //x=1.345 //y=4.62 //x2=1.23 //y2=4.62
r244 (  1 6 ) resistor r=0.0717383 //w=0.224 //l=0.115 //layer=m1 \
 //thickness=0.36 //x=4.815 //y=4.62 //x2=4.93 //y2=4.62
r245 (  1 2 ) resistor r=3.31107 //w=0.131 //l=3.47 //layer=m1 \
 //thickness=0.36 //x=4.815 //y=4.62 //x2=1.345 //y2=4.62
ends PM_VOTER3X1\%B

subckt PM_VOTER3X1\%C ( 1 2 7 8 9 10 11 12 13 14 15 16 18 30 41 42 43 44 45 46 \
 50 51 52 53 54 56 59 62 63 64 65 66 67 68 69 73 75 78 79 80 81 94 )
c165 ( 94 0 ) capacitor c=0.0583848f //x=7.89 //y=2.26
c166 ( 81 0 ) capacitor c=0.0316774f //x=8.595 //y=1.39
c167 ( 80 0 ) capacitor c=0.0187384f //x=8.595 //y=1.045
c168 ( 79 0 ) capacitor c=0.0590362f //x=8.235 //y=4.975
c169 ( 78 0 ) capacitor c=0.0296075f //x=8.525 //y=4.975
c170 ( 75 0 ) capacitor c=0.0157912f //x=8.44 //y=1.545
c171 ( 73 0 ) capacitor c=0.0149844f //x=8.44 //y=0.89
c172 ( 69 0 ) capacitor c=0.0302441f //x=8.065 //y=2.095
c173 ( 68 0 ) capacitor c=0.0234157f //x=8.065 //y=1.7
c174 ( 67 0 ) capacitor c=0.0234376f //x=8.065 //y=1.39
c175 ( 66 0 ) capacitor c=0.0199931f //x=8.065 //y=1.045
c176 ( 65 0 ) capacitor c=0.0970773f //x=6.235 //y=2.095
c177 ( 64 0 ) capacitor c=0.0249466f //x=6.235 //y=1.74
c178 ( 63 0 ) capacitor c=0.0234397f //x=6.235 //y=1.43
c179 ( 62 0 ) capacitor c=0.0193195f //x=6.235 //y=1.085
c180 ( 59 0 ) capacitor c=0.0631944f //x=6.14 //y=5.05
c181 ( 56 0 ) capacitor c=0.0187941f //x=6.08 //y=1.585
c182 ( 54 0 ) capacitor c=0.0157803f //x=6.08 //y=0.93
c183 ( 53 0 ) capacitor c=0.010629f //x=5.775 //y=4.975
c184 ( 52 0 ) capacitor c=0.0194269f //x=6.065 //y=4.975
c185 ( 51 0 ) capacitor c=0.0365717f //x=5.705 //y=1.43
c186 ( 50 0 ) capacitor c=0.0175988f //x=5.705 //y=1.085
c187 ( 46 0 ) capacitor c=0.110622f //x=8.6 //y=6.205
c188 ( 45 0 ) capacitor c=0.154068f //x=8.16 //y=6.205
c189 ( 44 0 ) capacitor c=0.154291f //x=6.14 //y=6.205
c190 ( 43 0 ) capacitor c=0.110404f //x=5.7 //y=6.205
c191 ( 30 0 ) capacitor c=0.100999f //x=7.89 //y=2.26
c192 ( 18 0 ) capacitor c=0.109253f //x=6.41 //y=2.26
c193 ( 2 0 ) capacitor c=0.011507f //x=6.525 //y=2.26
c194 ( 1 0 ) capacitor c=0.0463146f //x=7.775 //y=2.26
r195 (  81 100 ) resistor r=45.1352 //w=0.168 //l=0.173853 //layer=ply \
 //thickness=0.18 //x=8.595 //y=1.39 //x2=8.555 //y2=1.545
r196 (  80 99 ) resistor r=45.1352 //w=0.168 //l=0.173853 //layer=ply \
 //thickness=0.18 //x=8.595 //y=1.045 //x2=8.555 //y2=0.89
r197 (  80 81 ) resistor r=176.904 //w=0.094 //l=0.345 //layer=ply \
 //thickness=0.18 //x=8.595 //y=1.045 //x2=8.595 //y2=1.39
r198 (  78 82 ) resistor r=26.9307 //w=0.15 //l=0.106066 //layer=ply \
 //thickness=0.18 //x=8.525 //y=4.975 //x2=8.6 //y2=5.05
r199 (  78 79 ) resistor r=148.702 //w=0.094 //l=0.29 //layer=ply \
 //thickness=0.18 //x=8.525 //y=4.975 //x2=8.235 //y2=4.975
r200 (  76 98 ) resistor r=10.701 //w=0.21 //l=0.115 //layer=ply \
 //thickness=0.18 //x=8.22 //y=1.545 //x2=8.105 //y2=1.545
r201 (  75 100 ) resistor r=5.52526 //w=0.168 //l=0.115 //layer=ply \
 //thickness=0.18 //x=8.44 //y=1.545 //x2=8.555 //y2=1.545
r202 (  74 97 ) resistor r=5.52526 //w=0.168 //l=0.115 //layer=ply \
 //thickness=0.18 //x=8.22 //y=0.89 //x2=8.105 //y2=0.89
r203 (  73 99 ) resistor r=5.52526 //w=0.168 //l=0.115 //layer=ply \
 //thickness=0.18 //x=8.44 //y=0.89 //x2=8.555 //y2=0.89
r204 (  73 74 ) resistor r=112.809 //w=0.094 //l=0.22 //layer=ply \
 //thickness=0.18 //x=8.44 //y=0.89 //x2=8.22 //y2=0.89
r205 (  70 79 ) resistor r=22.1787 //w=0.252 //l=0.106066 //layer=ply \
 //thickness=0.18 //x=8.16 //y=5.05 //x2=8.235 //y2=4.975
r206 (  70 96 ) resistor r=51.6429 //w=0.252 //l=0.34271 //layer=ply \
 //thickness=0.18 //x=8.16 //y=5.05 //x2=7.89 //y2=4.885
r207 (  69 94 ) resistor r=30.4513 //w=0.277 //l=0.243926 //layer=ply \
 //thickness=0.18 //x=8.065 //y=2.095 //x2=7.89 //y2=2.26
r208 (  68 98 ) resistor r=39.5823 //w=0.21 //l=0.173853 //layer=ply \
 //thickness=0.18 //x=8.065 //y=1.7 //x2=8.105 //y2=1.545
r209 (  68 69 ) resistor r=202.543 //w=0.094 //l=0.395 //layer=ply \
 //thickness=0.18 //x=8.065 //y=1.7 //x2=8.065 //y2=2.095
r210 (  67 98 ) resistor r=39.5823 //w=0.21 //l=0.173853 //layer=ply \
 //thickness=0.18 //x=8.065 //y=1.39 //x2=8.105 //y2=1.545
r211 (  66 97 ) resistor r=45.1352 //w=0.168 //l=0.173853 //layer=ply \
 //thickness=0.18 //x=8.065 //y=1.045 //x2=8.105 //y2=0.89
r212 (  66 67 ) resistor r=176.904 //w=0.094 //l=0.345 //layer=ply \
 //thickness=0.18 //x=8.065 //y=1.045 //x2=8.065 //y2=1.39
r213 (  65 90 ) resistor r=30.4513 //w=0.277 //l=0.243926 //layer=ply \
 //thickness=0.18 //x=6.235 //y=2.095 //x2=6.41 //y2=2.26
r214 (  64 88 ) resistor r=39.5823 //w=0.21 //l=0.173853 //layer=ply \
 //thickness=0.18 //x=6.235 //y=1.74 //x2=6.195 //y2=1.585
r215 (  64 65 ) resistor r=182.032 //w=0.094 //l=0.355 //layer=ply \
 //thickness=0.18 //x=6.235 //y=1.74 //x2=6.235 //y2=2.095
r216 (  63 88 ) resistor r=39.5823 //w=0.21 //l=0.173853 //layer=ply \
 //thickness=0.18 //x=6.235 //y=1.43 //x2=6.195 //y2=1.585
r217 (  62 87 ) resistor r=45.1352 //w=0.168 //l=0.173853 //layer=ply \
 //thickness=0.18 //x=6.235 //y=1.085 //x2=6.195 //y2=0.93
r218 (  62 63 ) resistor r=176.904 //w=0.094 //l=0.345 //layer=ply \
 //thickness=0.18 //x=6.235 //y=1.085 //x2=6.235 //y2=1.43
r219 (  59 92 ) resistor r=51.6429 //w=0.252 //l=0.34271 //layer=ply \
 //thickness=0.18 //x=6.14 //y=5.05 //x2=6.41 //y2=4.885
r220 (  57 86 ) resistor r=5.52526 //w=0.168 //l=0.115 //layer=ply \
 //thickness=0.18 //x=5.86 //y=1.585 //x2=5.745 //y2=1.585
r221 (  56 88 ) resistor r=10.701 //w=0.21 //l=0.115 //layer=ply \
 //thickness=0.18 //x=6.08 //y=1.585 //x2=6.195 //y2=1.585
r222 (  55 85 ) resistor r=5.52526 //w=0.168 //l=0.115 //layer=ply \
 //thickness=0.18 //x=5.86 //y=0.93 //x2=5.745 //y2=0.93
r223 (  54 87 ) resistor r=5.52526 //w=0.168 //l=0.115 //layer=ply \
 //thickness=0.18 //x=6.08 //y=0.93 //x2=6.195 //y2=0.93
r224 (  54 55 ) resistor r=112.809 //w=0.094 //l=0.22 //layer=ply \
 //thickness=0.18 //x=6.08 //y=0.93 //x2=5.86 //y2=0.93
r225 (  52 59 ) resistor r=22.1787 //w=0.252 //l=0.106066 //layer=ply \
 //thickness=0.18 //x=6.065 //y=4.975 //x2=6.14 //y2=5.05
r226 (  52 53 ) resistor r=148.702 //w=0.094 //l=0.29 //layer=ply \
 //thickness=0.18 //x=6.065 //y=4.975 //x2=5.775 //y2=4.975
r227 (  51 86 ) resistor r=45.1352 //w=0.168 //l=0.173853 //layer=ply \
 //thickness=0.18 //x=5.705 //y=1.43 //x2=5.745 //y2=1.585
r228 (  50 85 ) resistor r=45.1352 //w=0.168 //l=0.173853 //layer=ply \
 //thickness=0.18 //x=5.705 //y=1.085 //x2=5.745 //y2=0.93
r229 (  50 51 ) resistor r=176.904 //w=0.094 //l=0.345 //layer=ply \
 //thickness=0.18 //x=5.705 //y=1.085 //x2=5.705 //y2=1.43
r230 (  47 53 ) resistor r=26.9307 //w=0.15 //l=0.106066 //layer=ply \
 //thickness=0.18 //x=5.7 //y=5.05 //x2=5.775 //y2=4.975
r231 (  46 82 ) resistor r=592.245 //w=0.094 //l=1.155 //layer=ply \
 //thickness=0.18 //x=8.6 //y=6.205 //x2=8.6 //y2=5.05
r232 (  45 70 ) resistor r=592.245 //w=0.094 //l=1.155 //layer=ply \
 //thickness=0.18 //x=8.16 //y=6.205 //x2=8.16 //y2=5.05
r233 (  44 59 ) resistor r=592.245 //w=0.094 //l=1.155 //layer=ply \
 //thickness=0.18 //x=6.14 //y=6.205 //x2=6.14 //y2=5.05
r234 (  43 47 ) resistor r=592.245 //w=0.094 //l=1.155 //layer=ply \
 //thickness=0.18 //x=5.7 //y=6.205 //x2=5.7 //y2=5.05
r235 (  42 75 ) resistor r=56.4043 //w=0.094 //l=0.11 //layer=ply \
 //thickness=0.18 //x=8.33 //y=1.545 //x2=8.44 //y2=1.545
r236 (  42 76 ) resistor r=56.4043 //w=0.094 //l=0.11 //layer=ply \
 //thickness=0.18 //x=8.33 //y=1.545 //x2=8.22 //y2=1.545
r237 (  41 56 ) resistor r=56.4043 //w=0.094 //l=0.11 //layer=ply \
 //thickness=0.18 //x=5.97 //y=1.585 //x2=6.08 //y2=1.585
r238 (  41 57 ) resistor r=56.4043 //w=0.094 //l=0.11 //layer=ply \
 //thickness=0.18 //x=5.97 //y=1.585 //x2=5.86 //y2=1.585
r239 (  39 96 ) resistor r=152 //w=0.17 //l=0.17 //layer=licon //count=1 \
 //x=7.89 //y=4.885 //x2=7.89 //y2=4.885
r240 (  30 94 ) resistor r=152 //w=0.17 //l=0.17 //layer=licon //count=1 \
 //x=7.89 //y=2.26 //x2=7.89 //y2=2.26
r241 (  27 92 ) resistor r=152 //w=0.17 //l=0.17 //layer=licon //count=1 \
 //x=6.41 //y=4.885 //x2=6.41 //y2=4.885
r242 (  18 90 ) resistor r=152 //w=0.17 //l=0.17 //layer=licon //count=1 \
 //x=6.41 //y=2.26 //x2=6.41 //y2=2.26
r243 (  16 39 ) resistor r=18.139 //w=0.187 //l=0.265 //layer=li \
 //thickness=0.1 //x=7.89 //y=4.62 //x2=7.89 //y2=4.885
r244 (  15 16 ) resistor r=50.6524 //w=0.187 //l=0.74 //layer=li \
 //thickness=0.1 //x=7.89 //y=3.88 //x2=7.89 //y2=4.62
r245 (  14 15 ) resistor r=25.3262 //w=0.187 //l=0.37 //layer=li \
 //thickness=0.1 //x=7.89 //y=3.51 //x2=7.89 //y2=3.88
r246 (  13 14 ) resistor r=25.3262 //w=0.187 //l=0.37 //layer=li \
 //thickness=0.1 //x=7.89 //y=3.14 //x2=7.89 //y2=3.51
r247 (  12 13 ) resistor r=25.3262 //w=0.187 //l=0.37 //layer=li \
 //thickness=0.1 //x=7.89 //y=2.77 //x2=7.89 //y2=3.14
r248 (  12 30 ) resistor r=34.9091 //w=0.187 //l=0.51 //layer=li \
 //thickness=0.1 //x=7.89 //y=2.77 //x2=7.89 //y2=2.26
r249 (  11 27 ) resistor r=18.139 //w=0.187 //l=0.265 //layer=li \
 //thickness=0.1 //x=6.41 //y=4.62 //x2=6.41 //y2=4.885
r250 (  10 11 ) resistor r=50.6524 //w=0.187 //l=0.74 //layer=li \
 //thickness=0.1 //x=6.41 //y=3.88 //x2=6.41 //y2=4.62
r251 (  9 10 ) resistor r=25.3262 //w=0.187 //l=0.37 //layer=li \
 //thickness=0.1 //x=6.41 //y=3.51 //x2=6.41 //y2=3.88
r252 (  8 9 ) resistor r=25.3262 //w=0.187 //l=0.37 //layer=li //thickness=0.1 \
 //x=6.41 //y=3.14 //x2=6.41 //y2=3.51
r253 (  7 8 ) resistor r=25.3262 //w=0.187 //l=0.37 //layer=li //thickness=0.1 \
 //x=6.41 //y=2.77 //x2=6.41 //y2=3.14
r254 (  7 18 ) resistor r=34.9091 //w=0.187 //l=0.51 //layer=li \
 //thickness=0.1 //x=6.41 //y=2.77 //x2=6.41 //y2=2.26
r255 (  6 30 ) resistor r=9.3 //w=0.17 //l=0.17 //layer=mcon //count=1 \
 //x=7.89 //y=2.26 //x2=7.89 //y2=2.26
r256 (  4 18 ) resistor r=9.3 //w=0.17 //l=0.17 //layer=mcon //count=1 \
 //x=6.41 //y=2.26 //x2=6.41 //y2=2.26
r257 (  2 4 ) resistor r=0.0717383 //w=0.224 //l=0.115 //layer=m1 \
 //thickness=0.36 //x=6.525 //y=2.26 //x2=6.41 //y2=2.26
r258 (  1 6 ) resistor r=0.0717383 //w=0.224 //l=0.115 //layer=m1 \
 //thickness=0.36 //x=7.775 //y=2.26 //x2=7.89 //y2=2.26
r259 (  1 2 ) resistor r=1.19275 //w=0.131 //l=1.25 //layer=m1 \
 //thickness=0.36 //x=7.775 //y=2.26 //x2=6.525 //y2=2.26
ends PM_VOTER3X1\%C

subckt PM_VOTER3X1\%noxref_6 ( 1 2 13 14 15 21 27 28 35 45 46 47 48 49 50 )
c88 ( 50 0 ) capacitor c=0.0306574f //x=9.555 //y=5.205
c89 ( 49 0 ) capacitor c=0.0173945f //x=8.675 //y=5.205
c90 ( 47 0 ) capacitor c=0.0169278f //x=5.775 //y=5.205
c91 ( 46 0 ) capacitor c=0.0166762f //x=4.895 //y=5.205
c92 ( 45 0 ) capacitor c=0.00115294f //x=8.82 //y=7.09
c93 ( 35 0 ) capacitor c=0.0134683f //x=9.615 //y=7.09
c94 ( 28 0 ) capacitor c=0.00388794f //x=8.025 //y=7.09
c95 ( 27 0 ) capacitor c=0.0107731f //x=8.735 //y=7.09
c96 ( 21 0 ) capacitor c=0.0442221f //x=7.94 //y=5.39
c97 ( 15 0 ) capacitor c=0.0103611f //x=5.92 //y=5.475
c98 ( 14 0 ) capacitor c=0.00227812f //x=5.125 //y=5.39
c99 ( 13 0 ) capacitor c=0.0177888f //x=5.835 //y=5.39
c100 ( 2 0 ) capacitor c=0.00818801f //x=6.035 //y=5.39
c101 ( 1 0 ) capacitor c=0.0820623f //x=7.825 //y=5.39
r102 (  37 50 ) resistor r=5.81818 //w=0.187 //l=0.085 //layer=li \
 //thickness=0.1 //x=9.7 //y=7.005 //x2=9.7 //y2=6.92
r103 (  36 45 ) resistor r=5.4201 //w=0.17 //l=0.085 //layer=li \
 //thickness=0.1 //x=8.905 //y=7.09 //x2=8.82 //y2=7.09
r104 (  35 37 ) resistor r=7.15173 //w=0.17 //l=0.120208 //layer=li \
 //thickness=0.1 //x=9.615 //y=7.09 //x2=9.7 //y2=7.005
r105 (  35 36 ) resistor r=48.5989 //w=0.187 //l=0.71 //layer=li \
 //thickness=0.1 //x=9.615 //y=7.09 //x2=8.905 //y2=7.09
r106 (  29 45 ) resistor r=1.40859 //w=0.34 //l=0.085 //layer=li \
 //thickness=0.1 //x=8.82 //y=7.005 //x2=8.82 //y2=7.09
r107 (  29 49 ) resistor r=5.81818 //w=0.187 //l=0.085 //layer=li \
 //thickness=0.1 //x=8.82 //y=7.005 //x2=8.82 //y2=6.92
r108 (  27 45 ) resistor r=5.4201 //w=0.17 //l=0.085 //layer=li \
 //thickness=0.1 //x=8.735 //y=7.09 //x2=8.82 //y2=7.09
r109 (  27 28 ) resistor r=48.5989 //w=0.187 //l=0.71 //layer=li \
 //thickness=0.1 //x=8.735 //y=7.09 //x2=8.025 //y2=7.09
r110 (  21 48 ) resistor r=58.1818 //w=0.187 //l=0.85 //layer=li \
 //thickness=0.1 //x=7.94 //y=5.39 //x2=7.94 //y2=6.24
r111 (  19 28 ) resistor r=7.15173 //w=0.17 //l=0.120208 //layer=li \
 //thickness=0.1 //x=7.94 //y=7.005 //x2=8.025 //y2=7.09
r112 (  19 48 ) resistor r=5.81818 //w=0.187 //l=0.085 //layer=li \
 //thickness=0.1 //x=7.94 //y=7.005 //x2=7.94 //y2=6.92
r113 (  15 44 ) resistor r=3.57586 //w=0.17 //l=0.125 //layer=li \
 //thickness=0.1 //x=5.92 //y=5.475 //x2=5.92 //y2=5.35
r114 (  15 47 ) resistor r=52.3636 //w=0.187 //l=0.765 //layer=li \
 //thickness=0.1 //x=5.92 //y=5.475 //x2=5.92 //y2=6.24
r115 (  13 44 ) resistor r=3.57586 //w=0.17 //l=0.103078 //layer=li \
 //thickness=0.1 //x=5.835 //y=5.39 //x2=5.92 //y2=5.35
r116 (  13 14 ) resistor r=48.5989 //w=0.187 //l=0.71 //layer=li \
 //thickness=0.1 //x=5.835 //y=5.39 //x2=5.125 //y2=5.39
r117 (  7 14 ) resistor r=7.15173 //w=0.17 //l=0.120208 //layer=li \
 //thickness=0.1 //x=5.04 //y=5.475 //x2=5.125 //y2=5.39
r118 (  7 46 ) resistor r=29.0909 //w=0.187 //l=0.425 //layer=li \
 //thickness=0.1 //x=5.04 //y=5.475 //x2=5.04 //y2=5.9
r119 (  6 21 ) resistor r=9.3 //w=0.17 //l=0.17 //layer=mcon //count=1 \
 //x=7.94 //y=5.39 //x2=7.94 //y2=5.39
r120 (  4 44 ) resistor r=9.3 //w=0.17 //l=0.17 //layer=mcon //count=1 \
 //x=5.92 //y=5.39 //x2=5.92 //y2=5.39
r121 (  2 4 ) resistor r=0.0717383 //w=0.224 //l=0.115 //layer=m1 \
 //thickness=0.36 //x=6.035 //y=5.39 //x2=5.92 //y2=5.39
r122 (  1 6 ) resistor r=0.0717383 //w=0.224 //l=0.115 //layer=m1 \
 //thickness=0.36 //x=7.825 //y=5.39 //x2=7.94 //y2=5.39
r123 (  1 2 ) resistor r=1.70802 //w=0.131 //l=1.79 //layer=m1 \
 //thickness=0.36 //x=7.825 //y=5.39 //x2=6.035 //y2=5.39
ends PM_VOTER3X1\%noxref_6

subckt PM_VOTER3X1\%A ( 1 2 7 8 9 10 11 12 13 14 15 16 17 18 20 30 42 45 46 47 \
 48 49 50 51 52 53 58 60 62 68 69 70 71 72 77 79 81 87 88 90 91 94 102 103 106 )
c184 ( 106 0 ) capacitor c=0.0352016f //x=9.02 //y=4.885
c185 ( 103 0 ) capacitor c=0.0279733f //x=9 //y=2.095
c186 ( 102 0 ) capacitor c=0.0467621f //x=9 //y=2.26
c187 ( 94 0 ) capacitor c=0.0384604f //x=2.38 //y=4.885
c188 ( 91 0 ) capacitor c=0.0300885f //x=2.34 //y=2.095
c189 ( 90 0 ) capacitor c=0.053505f //x=2.34 //y=2.26
c190 ( 88 0 ) capacitor c=0.0237734f //x=9.565 //y=1.435
c191 ( 87 0 ) capacitor c=0.0191782f //x=9.565 //y=1.085
c192 ( 81 0 ) capacitor c=0.0351663f //x=9.41 //y=1.585
c193 ( 79 0 ) capacitor c=0.0157803f //x=9.41 //y=0.93
c194 ( 77 0 ) capacitor c=0.0374703f //x=9.405 //y=4.975
c195 ( 72 0 ) capacitor c=0.0200628f //x=9.035 //y=1.74
c196 ( 71 0 ) capacitor c=0.0168575f //x=9.035 //y=1.435
c197 ( 70 0 ) capacitor c=0.0174993f //x=9.035 //y=1.085
c198 ( 69 0 ) capacitor c=0.0447087f //x=2.905 //y=1.43
c199 ( 68 0 ) capacitor c=0.019286f //x=2.905 //y=1.085
c200 ( 62 0 ) capacitor c=0.0187932f //x=2.75 //y=1.585
c201 ( 60 0 ) capacitor c=0.0157795f //x=2.75 //y=0.93
c202 ( 58 0 ) capacitor c=0.029531f //x=2.745 //y=4.975
c203 ( 53 0 ) capacitor c=0.0206178f //x=2.375 //y=1.74
c204 ( 52 0 ) capacitor c=0.016848f //x=2.375 //y=1.43
c205 ( 51 0 ) capacitor c=0.0174777f //x=2.375 //y=1.085
c206 ( 50 0 ) capacitor c=0.15325f //x=9.48 //y=6.205
c207 ( 49 0 ) capacitor c=0.110411f //x=9.04 //y=6.205
c208 ( 48 0 ) capacitor c=0.154236f //x=2.82 //y=6.205
c209 ( 47 0 ) capacitor c=0.110294f //x=2.38 //y=6.205
c210 ( 42 0 ) capacitor c=0.00501304f //x=9.02 //y=4.885
c211 ( 30 0 ) capacitor c=0.0903633f //x=9 //y=2.26
c212 ( 20 0 ) capacitor c=0.11342f //x=2.34 //y=2.26
c213 ( 18 0 ) capacitor c=0.00669947f //x=2.34 //y=4.72
c214 ( 2 0 ) capacitor c=0.0161064f //x=2.455 //y=4.25
c215 ( 1 0 ) capacitor c=0.297355f //x=8.885 //y=4.25
r216 (  108 109 ) resistor r=32.4568 //w=0.214 //l=0.075 //layer=ply \
 //thickness=0.18 //x=9.02 //y=4.975 //x2=9.02 //y2=5.05
r217 (  106 108 ) resistor r=20.271 //w=0.214 //l=0.09 //layer=ply \
 //thickness=0.18 //x=9.02 //y=4.885 //x2=9.02 //y2=4.975
r218 (  102 103 ) resistor r=52.7279 //w=0.214 //l=0.165 //layer=ply \
 //thickness=0.18 //x=9 //y=2.26 //x2=9 //y2=2.095
r219 (  94 96 ) resistor r=20.271 //w=0.214 //l=0.09 //layer=ply \
 //thickness=0.18 //x=2.38 //y=4.885 //x2=2.38 //y2=4.975
r220 (  90 91 ) resistor r=52.7279 //w=0.214 //l=0.165 //layer=ply \
 //thickness=0.18 //x=2.34 //y=2.26 //x2=2.34 //y2=2.095
r221 (  88 113 ) resistor r=4.95774 //w=0.164 //l=0.112 //layer=ply \
 //thickness=0.18 //x=9.565 //y=1.435 //x2=9.565 //y2=1.547
r222 (  87 112 ) resistor r=45.1352 //w=0.168 //l=0.173853 //layer=ply \
 //thickness=0.18 //x=9.565 //y=1.085 //x2=9.525 //y2=0.93
r223 (  87 88 ) resistor r=179.468 //w=0.094 //l=0.35 //layer=ply \
 //thickness=0.18 //x=9.565 //y=1.085 //x2=9.565 //y2=1.435
r224 (  82 111 ) resistor r=10.8103 //w=0.211 //l=0.115 //layer=ply \
 //thickness=0.18 //x=9.19 //y=1.585 //x2=9.075 //y2=1.585
r225 (  81 113 ) resistor r=45.9962 //w=0.164 //l=0.17296 //layer=ply \
 //thickness=0.18 //x=9.41 //y=1.585 //x2=9.565 //y2=1.547
r226 (  80 110 ) resistor r=5.52526 //w=0.168 //l=0.115 //layer=ply \
 //thickness=0.18 //x=9.19 //y=0.93 //x2=9.075 //y2=0.93
r227 (  79 112 ) resistor r=5.52526 //w=0.168 //l=0.115 //layer=ply \
 //thickness=0.18 //x=9.41 //y=0.93 //x2=9.525 //y2=0.93
r228 (  79 80 ) resistor r=112.809 //w=0.094 //l=0.22 //layer=ply \
 //thickness=0.18 //x=9.41 //y=0.93 //x2=9.19 //y2=0.93
r229 (  78 108 ) resistor r=16.5046 //w=0.27 //l=0.135 //layer=ply \
 //thickness=0.18 //x=9.155 //y=4.975 //x2=9.02 //y2=4.975
r230 (  77 84 ) resistor r=26.9307 //w=0.15 //l=0.106066 //layer=ply \
 //thickness=0.18 //x=9.405 //y=4.975 //x2=9.48 //y2=5.05
r231 (  77 78 ) resistor r=128.191 //w=0.094 //l=0.25 //layer=ply \
 //thickness=0.18 //x=9.405 //y=4.975 //x2=9.155 //y2=4.975
r232 (  72 111 ) resistor r=39.5036 //w=0.211 //l=0.173853 //layer=ply \
 //thickness=0.18 //x=9.035 //y=1.74 //x2=9.075 //y2=1.585
r233 (  72 103 ) resistor r=182.032 //w=0.094 //l=0.355 //layer=ply \
 //thickness=0.18 //x=9.035 //y=1.74 //x2=9.035 //y2=2.095
r234 (  71 111 ) resistor r=38.3614 //w=0.211 //l=0.168819 //layer=ply \
 //thickness=0.18 //x=9.035 //y=1.435 //x2=9.075 //y2=1.585
r235 (  70 110 ) resistor r=45.1352 //w=0.168 //l=0.173853 //layer=ply \
 //thickness=0.18 //x=9.035 //y=1.085 //x2=9.075 //y2=0.93
r236 (  70 71 ) resistor r=179.468 //w=0.094 //l=0.35 //layer=ply \
 //thickness=0.18 //x=9.035 //y=1.085 //x2=9.035 //y2=1.435
r237 (  69 100 ) resistor r=45.1352 //w=0.168 //l=0.173853 //layer=ply \
 //thickness=0.18 //x=2.905 //y=1.43 //x2=2.865 //y2=1.585
r238 (  68 99 ) resistor r=45.1352 //w=0.168 //l=0.173853 //layer=ply \
 //thickness=0.18 //x=2.905 //y=1.085 //x2=2.865 //y2=0.93
r239 (  68 69 ) resistor r=176.904 //w=0.094 //l=0.345 //layer=ply \
 //thickness=0.18 //x=2.905 //y=1.085 //x2=2.905 //y2=1.43
r240 (  63 98 ) resistor r=10.701 //w=0.21 //l=0.115 //layer=ply \
 //thickness=0.18 //x=2.53 //y=1.585 //x2=2.415 //y2=1.585
r241 (  62 100 ) resistor r=5.52526 //w=0.168 //l=0.115 //layer=ply \
 //thickness=0.18 //x=2.75 //y=1.585 //x2=2.865 //y2=1.585
r242 (  61 97 ) resistor r=5.52526 //w=0.168 //l=0.115 //layer=ply \
 //thickness=0.18 //x=2.53 //y=0.93 //x2=2.415 //y2=0.93
r243 (  60 99 ) resistor r=5.52526 //w=0.168 //l=0.115 //layer=ply \
 //thickness=0.18 //x=2.75 //y=0.93 //x2=2.865 //y2=0.93
r244 (  60 61 ) resistor r=112.809 //w=0.094 //l=0.22 //layer=ply \
 //thickness=0.18 //x=2.75 //y=0.93 //x2=2.53 //y2=0.93
r245 (  59 96 ) resistor r=16.5046 //w=0.27 //l=0.135 //layer=ply \
 //thickness=0.18 //x=2.515 //y=4.975 //x2=2.38 //y2=4.975
r246 (  58 65 ) resistor r=26.9307 //w=0.15 //l=0.106066 //layer=ply \
 //thickness=0.18 //x=2.745 //y=4.975 //x2=2.82 //y2=5.05
r247 (  58 59 ) resistor r=117.936 //w=0.094 //l=0.23 //layer=ply \
 //thickness=0.18 //x=2.745 //y=4.975 //x2=2.515 //y2=4.975
r248 (  55 96 ) resistor r=32.4568 //w=0.214 //l=0.075 //layer=ply \
 //thickness=0.18 //x=2.38 //y=5.05 //x2=2.38 //y2=4.975
r249 (  53 98 ) resistor r=39.5823 //w=0.21 //l=0.173853 //layer=ply \
 //thickness=0.18 //x=2.375 //y=1.74 //x2=2.415 //y2=1.585
r250 (  53 91 ) resistor r=182.032 //w=0.094 //l=0.355 //layer=ply \
 //thickness=0.18 //x=2.375 //y=1.74 //x2=2.375 //y2=2.095
r251 (  52 98 ) resistor r=39.5823 //w=0.21 //l=0.173853 //layer=ply \
 //thickness=0.18 //x=2.375 //y=1.43 //x2=2.415 //y2=1.585
r252 (  51 97 ) resistor r=45.1352 //w=0.168 //l=0.173853 //layer=ply \
 //thickness=0.18 //x=2.375 //y=1.085 //x2=2.415 //y2=0.93
r253 (  51 52 ) resistor r=176.904 //w=0.094 //l=0.345 //layer=ply \
 //thickness=0.18 //x=2.375 //y=1.085 //x2=2.375 //y2=1.43
r254 (  50 84 ) resistor r=592.245 //w=0.094 //l=1.155 //layer=ply \
 //thickness=0.18 //x=9.48 //y=6.205 //x2=9.48 //y2=5.05
r255 (  49 109 ) resistor r=592.245 //w=0.094 //l=1.155 //layer=ply \
 //thickness=0.18 //x=9.04 //y=6.205 //x2=9.04 //y2=5.05
r256 (  48 65 ) resistor r=592.245 //w=0.094 //l=1.155 //layer=ply \
 //thickness=0.18 //x=2.82 //y=6.205 //x2=2.82 //y2=5.05
r257 (  47 55 ) resistor r=592.245 //w=0.094 //l=1.155 //layer=ply \
 //thickness=0.18 //x=2.38 //y=6.205 //x2=2.38 //y2=5.05
r258 (  46 81 ) resistor r=56.4043 //w=0.094 //l=0.11 //layer=ply \
 //thickness=0.18 //x=9.3 //y=1.585 //x2=9.41 //y2=1.585
r259 (  46 82 ) resistor r=56.4043 //w=0.094 //l=0.11 //layer=ply \
 //thickness=0.18 //x=9.3 //y=1.585 //x2=9.19 //y2=1.585
r260 (  45 62 ) resistor r=56.4043 //w=0.094 //l=0.11 //layer=ply \
 //thickness=0.18 //x=2.64 //y=1.585 //x2=2.75 //y2=1.585
r261 (  45 63 ) resistor r=56.4043 //w=0.094 //l=0.11 //layer=ply \
 //thickness=0.18 //x=2.64 //y=1.585 //x2=2.53 //y2=1.585
r262 (  42 106 ) resistor r=152 //w=0.17 //l=0.17 //layer=licon //count=1 \
 //x=9.02 //y=4.885 //x2=9.02 //y2=4.885
r263 (  42 43 ) resistor r=10.3507 //w=0.207 //l=0.165 //layer=li \
 //thickness=0.1 //x=9.01 //y=4.885 //x2=9.01 //y2=4.72
r264 (  40 94 ) resistor r=152 //w=0.17 //l=0.17 //layer=licon //count=1 \
 //x=2.38 //y=4.885 //x2=2.38 //y2=4.885
r265 (  30 102 ) resistor r=152 //w=0.17 //l=0.17 //layer=licon //count=1 \
 //x=9 //y=2.26 //x2=9 //y2=2.26
r266 (  20 90 ) resistor r=152 //w=0.17 //l=0.17 //layer=licon //count=1 \
 //x=2.34 //y=2.26 //x2=2.34 //y2=2.26
r267 (  18 40 ) resistor r=11.2426 //w=0.191 //l=0.174714 //layer=li \
 //thickness=0.1 //x=2.34 //y=4.72 //x2=2.36 //y2=4.885
r268 (  17 43 ) resistor r=6.84492 //w=0.187 //l=0.1 //layer=li \
 //thickness=0.1 //x=9 //y=4.62 //x2=9 //y2=4.72
r269 (  16 17 ) resistor r=25.3262 //w=0.187 //l=0.37 //layer=li \
 //thickness=0.1 //x=9 //y=4.25 //x2=9 //y2=4.62
r270 (  15 16 ) resistor r=25.3262 //w=0.187 //l=0.37 //layer=li \
 //thickness=0.1 //x=9 //y=3.88 //x2=9 //y2=4.25
r271 (  14 15 ) resistor r=25.3262 //w=0.187 //l=0.37 //layer=li \
 //thickness=0.1 //x=9 //y=3.51 //x2=9 //y2=3.88
r272 (  13 14 ) resistor r=25.3262 //w=0.187 //l=0.37 //layer=li \
 //thickness=0.1 //x=9 //y=3.14 //x2=9 //y2=3.51
r273 (  12 13 ) resistor r=25.3262 //w=0.187 //l=0.37 //layer=li \
 //thickness=0.1 //x=9 //y=2.77 //x2=9 //y2=3.14
r274 (  12 30 ) resistor r=34.9091 //w=0.187 //l=0.51 //layer=li \
 //thickness=0.1 //x=9 //y=2.77 //x2=9 //y2=2.26
r275 (  11 18 ) resistor r=32.1711 //w=0.187 //l=0.47 //layer=li \
 //thickness=0.1 //x=2.34 //y=4.25 //x2=2.34 //y2=4.72
r276 (  10 11 ) resistor r=25.3262 //w=0.187 //l=0.37 //layer=li \
 //thickness=0.1 //x=2.34 //y=3.88 //x2=2.34 //y2=4.25
r277 (  9 10 ) resistor r=25.3262 //w=0.187 //l=0.37 //layer=li \
 //thickness=0.1 //x=2.34 //y=3.51 //x2=2.34 //y2=3.88
r278 (  8 9 ) resistor r=25.3262 //w=0.187 //l=0.37 //layer=li //thickness=0.1 \
 //x=2.34 //y=3.14 //x2=2.34 //y2=3.51
r279 (  7 8 ) resistor r=25.3262 //w=0.187 //l=0.37 //layer=li //thickness=0.1 \
 //x=2.34 //y=2.77 //x2=2.34 //y2=3.14
r280 (  7 20 ) resistor r=34.9091 //w=0.187 //l=0.51 //layer=li \
 //thickness=0.1 //x=2.34 //y=2.77 //x2=2.34 //y2=2.26
r281 (  6 16 ) resistor r=9.3 //w=0.17 //l=0.17 //layer=mcon //count=1 //x=9 \
 //y=4.25 //x2=9 //y2=4.25
r282 (  4 11 ) resistor r=9.3 //w=0.17 //l=0.17 //layer=mcon //count=1 \
 //x=2.34 //y=4.25 //x2=2.34 //y2=4.25
r283 (  2 4 ) resistor r=0.0717383 //w=0.224 //l=0.115 //layer=m1 \
 //thickness=0.36 //x=2.455 //y=4.25 //x2=2.34 //y2=4.25
r284 (  1 6 ) resistor r=0.0717383 //w=0.224 //l=0.115 //layer=m1 \
 //thickness=0.36 //x=8.885 //y=4.25 //x2=9 //y2=4.25
r285 (  1 2 ) resistor r=6.1355 //w=0.131 //l=6.43 //layer=m1 //thickness=0.36 \
 //x=8.885 //y=4.25 //x2=2.455 //y2=4.25
ends PM_VOTER3X1\%A

subckt PM_VOTER3X1\%noxref_8 ( 1 2 3 4 5 6 29 30 43 45 46 50 52 63 64 65 66 67 \
 68 69 70 74 75 76 78 84 85 87 95 96 97 101 102 )
c219 ( 102 0 ) capacitor c=0.0167617f //x=9.115 //y=5.205
c220 ( 101 0 ) capacitor c=0.0164812f //x=8.235 //y=5.205
c221 ( 97 0 ) capacitor c=0.0110092f //x=9.11 //y=1.085
c222 ( 96 0 ) capacitor c=0.0131637f //x=5.78 //y=1.085
c223 ( 95 0 ) capacitor c=0.0131367f //x=2.45 //y=1.085
c224 ( 87 0 ) capacitor c=0.0537799f //x=11.22 //y=2.265
c225 ( 85 0 ) capacitor c=0.0435629f //x=11.86 //y=1.435
c226 ( 84 0 ) capacitor c=0.0200386f //x=11.86 //y=1.09
c227 ( 78 0 ) capacitor c=0.0152946f //x=11.705 //y=1.59
c228 ( 76 0 ) capacitor c=0.0157804f //x=11.705 //y=0.935
c229 ( 75 0 ) capacitor c=0.05065f //x=11.45 //y=4.97
c230 ( 74 0 ) capacitor c=0.0322983f //x=11.74 //y=4.97
c231 ( 70 0 ) capacitor c=0.0290017f //x=11.33 //y=2.1
c232 ( 69 0 ) capacitor c=0.0250027f //x=11.33 //y=1.745
c233 ( 68 0 ) capacitor c=0.0234316f //x=11.33 //y=1.435
c234 ( 67 0 ) capacitor c=0.0200596f //x=11.33 //y=1.09
c235 ( 66 0 ) capacitor c=0.154218f //x=11.815 //y=6.2
c236 ( 65 0 ) capacitor c=0.154243f //x=11.375 //y=6.2
c237 ( 63 0 ) capacitor c=0.00421476f //x=9.26 //y=5.39
c238 ( 52 0 ) capacitor c=0.0942764f //x=11.22 //y=2.265
c239 ( 50 0 ) capacitor c=0.11306f //x=9.74 //y=4.25
c240 ( 46 0 ) capacitor c=0.00775877f //x=9.385 //y=1.825
c241 ( 45 0 ) capacitor c=0.0165978f //x=9.655 //y=1.825
c242 ( 43 0 ) capacitor c=0.0156286f //x=9.655 //y=5.39
c243 ( 30 0 ) capacitor c=0.0029383f //x=8.465 //y=5.39
c244 ( 29 0 ) capacitor c=0.0159694f //x=9.175 //y=5.39
c245 ( 6 0 ) capacitor c=0.0105828f //x=9.855 //y=4.25
c246 ( 5 0 ) capacitor c=0.0989094f //x=11.105 //y=4.25
c247 ( 4 0 ) capacitor c=0.0117447f //x=6.085 //y=1.36
c248 ( 3 0 ) capacitor c=0.0835197f //x=9.185 //y=1.36
c249 ( 2 0 ) capacitor c=0.0203114f //x=2.755 //y=1.36
c250 ( 1 0 ) capacitor c=0.0989941f //x=5.855 //y=1.36
r251 (  87 88 ) resistor r=17.5563 //w=0.302 //l=0.11 //layer=ply \
 //thickness=0.18 //x=11.22 //y=2.265 //x2=11.33 //y2=2.265
r252 (  85 94 ) resistor r=45.1352 //w=0.168 //l=0.173853 //layer=ply \
 //thickness=0.18 //x=11.86 //y=1.435 //x2=11.82 //y2=1.59
r253 (  84 93 ) resistor r=45.1352 //w=0.168 //l=0.173853 //layer=ply \
 //thickness=0.18 //x=11.86 //y=1.09 //x2=11.82 //y2=0.935
r254 (  84 85 ) resistor r=176.904 //w=0.094 //l=0.345 //layer=ply \
 //thickness=0.18 //x=11.86 //y=1.09 //x2=11.86 //y2=1.435
r255 (  79 92 ) resistor r=10.701 //w=0.21 //l=0.115 //layer=ply \
 //thickness=0.18 //x=11.485 //y=1.59 //x2=11.37 //y2=1.59
r256 (  78 94 ) resistor r=5.52526 //w=0.168 //l=0.115 //layer=ply \
 //thickness=0.18 //x=11.705 //y=1.59 //x2=11.82 //y2=1.59
r257 (  77 91 ) resistor r=5.52526 //w=0.168 //l=0.115 //layer=ply \
 //thickness=0.18 //x=11.485 //y=0.935 //x2=11.37 //y2=0.935
r258 (  76 93 ) resistor r=5.52526 //w=0.168 //l=0.115 //layer=ply \
 //thickness=0.18 //x=11.705 //y=0.935 //x2=11.82 //y2=0.935
r259 (  76 77 ) resistor r=112.809 //w=0.094 //l=0.22 //layer=ply \
 //thickness=0.18 //x=11.705 //y=0.935 //x2=11.485 //y2=0.935
r260 (  74 81 ) resistor r=26.9307 //w=0.15 //l=0.106066 //layer=ply \
 //thickness=0.18 //x=11.74 //y=4.97 //x2=11.815 //y2=5.045
r261 (  74 75 ) resistor r=148.702 //w=0.094 //l=0.29 //layer=ply \
 //thickness=0.18 //x=11.74 //y=4.97 //x2=11.45 //y2=4.97
r262 (  71 75 ) resistor r=23.403 //w=0.284 //l=0.106066 //layer=ply \
 //thickness=0.18 //x=11.375 //y=5.045 //x2=11.45 //y2=4.97
r263 (  71 90 ) resistor r=26.3063 //w=0.284 //l=0.229783 //layer=ply \
 //thickness=0.18 //x=11.375 //y=5.045 //x2=11.22 //y2=4.88
r264 (  70 88 ) resistor r=19.1248 //w=0.302 //l=0.165 //layer=ply \
 //thickness=0.18 //x=11.33 //y=2.1 //x2=11.33 //y2=2.265
r265 (  69 92 ) resistor r=39.5823 //w=0.21 //l=0.173853 //layer=ply \
 //thickness=0.18 //x=11.33 //y=1.745 //x2=11.37 //y2=1.59
r266 (  69 70 ) resistor r=182.032 //w=0.094 //l=0.355 //layer=ply \
 //thickness=0.18 //x=11.33 //y=1.745 //x2=11.33 //y2=2.1
r267 (  68 92 ) resistor r=39.5823 //w=0.21 //l=0.173853 //layer=ply \
 //thickness=0.18 //x=11.33 //y=1.435 //x2=11.37 //y2=1.59
r268 (  67 91 ) resistor r=45.1352 //w=0.168 //l=0.173853 //layer=ply \
 //thickness=0.18 //x=11.33 //y=1.09 //x2=11.37 //y2=0.935
r269 (  67 68 ) resistor r=176.904 //w=0.094 //l=0.345 //layer=ply \
 //thickness=0.18 //x=11.33 //y=1.09 //x2=11.33 //y2=1.435
r270 (  66 81 ) resistor r=592.245 //w=0.094 //l=1.155 //layer=ply \
 //thickness=0.18 //x=11.815 //y=6.2 //x2=11.815 //y2=5.045
r271 (  65 71 ) resistor r=592.245 //w=0.094 //l=1.155 //layer=ply \
 //thickness=0.18 //x=11.375 //y=6.2 //x2=11.375 //y2=5.045
r272 (  64 78 ) resistor r=56.4043 //w=0.094 //l=0.11 //layer=ply \
 //thickness=0.18 //x=11.595 //y=1.59 //x2=11.705 //y2=1.59
r273 (  64 79 ) resistor r=56.4043 //w=0.094 //l=0.11 //layer=ply \
 //thickness=0.18 //x=11.595 //y=1.59 //x2=11.485 //y2=1.59
r274 (  62 95 ) resistor r=13.3953 //w=0.172 //l=0.18 //layer=li \
 //thickness=0.1 //x=2.637 //y=1.36 //x2=2.637 //y2=1.18
r275 (  57 90 ) resistor r=152 //w=0.17 //l=0.17 //layer=licon //count=1 \
 //x=11.22 //y=4.88 //x2=11.22 //y2=4.88
r276 (  55 57 ) resistor r=43.123 //w=0.187 //l=0.63 //layer=li \
 //thickness=0.1 //x=11.22 //y=4.25 //x2=11.22 //y2=4.88
r277 (  52 87 ) resistor r=152 //w=0.17 //l=0.17 //layer=licon //count=1 \
 //x=11.22 //y=2.265 //x2=11.22 //y2=2.265
r278 (  52 55 ) resistor r=135.872 //w=0.187 //l=1.985 //layer=li \
 //thickness=0.1 //x=11.22 //y=2.265 //x2=11.22 //y2=4.25
r279 (  48 50 ) resistor r=72.2139 //w=0.187 //l=1.055 //layer=li \
 //thickness=0.1 //x=9.74 //y=5.305 //x2=9.74 //y2=4.25
r280 (  47 50 ) resistor r=160.171 //w=0.187 //l=2.34 //layer=li \
 //thickness=0.1 //x=9.74 //y=1.91 //x2=9.74 //y2=4.25
r281 (  45 47 ) resistor r=7.15173 //w=0.17 //l=0.120208 //layer=li \
 //thickness=0.1 //x=9.655 //y=1.825 //x2=9.74 //y2=1.91
r282 (  45 46 ) resistor r=18.4813 //w=0.187 //l=0.27 //layer=li \
 //thickness=0.1 //x=9.655 //y=1.825 //x2=9.385 //y2=1.825
r283 (  44 63 ) resistor r=5.4201 //w=0.17 //l=0.085 //layer=li \
 //thickness=0.1 //x=9.345 //y=5.39 //x2=9.26 //y2=5.39
r284 (  43 48 ) resistor r=7.15173 //w=0.17 //l=0.120208 //layer=li \
 //thickness=0.1 //x=9.655 //y=5.39 //x2=9.74 //y2=5.305
r285 (  43 44 ) resistor r=21.2193 //w=0.187 //l=0.31 //layer=li \
 //thickness=0.1 //x=9.655 //y=5.39 //x2=9.345 //y2=5.39
r286 (  42 97 ) resistor r=12.3209 //w=0.187 //l=0.18 //layer=li \
 //thickness=0.1 //x=9.3 //y=1.36 //x2=9.3 //y2=1.18
r287 (  37 46 ) resistor r=7.15173 //w=0.17 //l=0.120208 //layer=li \
 //thickness=0.1 //x=9.3 //y=1.74 //x2=9.385 //y2=1.825
r288 (  37 42 ) resistor r=26.0107 //w=0.187 //l=0.38 //layer=li \
 //thickness=0.1 //x=9.3 //y=1.74 //x2=9.3 //y2=1.36
r289 (  31 63 ) resistor r=1.40859 //w=0.34 //l=0.085 //layer=li \
 //thickness=0.1 //x=9.26 //y=5.475 //x2=9.26 //y2=5.39
r290 (  31 102 ) resistor r=29.0909 //w=0.187 //l=0.425 //layer=li \
 //thickness=0.1 //x=9.26 //y=5.475 //x2=9.26 //y2=5.9
r291 (  29 63 ) resistor r=5.4201 //w=0.17 //l=0.085 //layer=li \
 //thickness=0.1 //x=9.175 //y=5.39 //x2=9.26 //y2=5.39
r292 (  29 30 ) resistor r=48.5989 //w=0.187 //l=0.71 //layer=li \
 //thickness=0.1 //x=9.175 //y=5.39 //x2=8.465 //y2=5.39
r293 (  23 30 ) resistor r=7.15173 //w=0.17 //l=0.120208 //layer=li \
 //thickness=0.1 //x=8.38 //y=5.475 //x2=8.465 //y2=5.39
r294 (  23 101 ) resistor r=29.0909 //w=0.187 //l=0.425 //layer=li \
 //thickness=0.1 //x=8.38 //y=5.475 //x2=8.38 //y2=5.9
r295 (  21 96 ) resistor r=12.3209 //w=0.187 //l=0.18 //layer=li \
 //thickness=0.1 //x=5.97 //y=1.36 //x2=5.97 //y2=1.18
r296 (  16 55 ) resistor r=9.3 //w=0.17 //l=0.17 //layer=mcon //count=1 \
 //x=11.22 //y=4.25 //x2=11.22 //y2=4.25
r297 (  14 50 ) resistor r=9.3 //w=0.17 //l=0.17 //layer=mcon //count=1 \
 //x=9.74 //y=4.25 //x2=9.74 //y2=4.25
r298 (  12 42 ) resistor r=9.3 //w=0.17 //l=0.17 //layer=mcon //count=1 \
 //x=9.3 //y=1.36 //x2=9.3 //y2=1.36
r299 (  10 21 ) resistor r=9.3 //w=0.17 //l=0.17 //layer=mcon //count=1 \
 //x=5.97 //y=1.36 //x2=5.97 //y2=1.36
r300 (  8 62 ) resistor r=9.3 //w=0.17 //l=0.17 //layer=mcon //count=1 \
 //x=2.64 //y=1.36 //x2=2.64 //y2=1.36
r301 (  6 14 ) resistor r=0.0717383 //w=0.224 //l=0.115 //layer=m1 \
 //thickness=0.36 //x=9.855 //y=4.25 //x2=9.74 //y2=4.25
r302 (  5 16 ) resistor r=0.0717383 //w=0.224 //l=0.115 //layer=m1 \
 //thickness=0.36 //x=11.105 //y=4.25 //x2=11.22 //y2=4.25
r303 (  5 6 ) resistor r=1.19275 //w=0.131 //l=1.25 //layer=m1 \
 //thickness=0.36 //x=11.105 //y=4.25 //x2=9.855 //y2=4.25
r304 (  4 10 ) resistor r=0.0880901 //w=0.191 //l=0.115 //layer=m1 \
 //thickness=0.36 //x=6.085 //y=1.36 //x2=5.97 //y2=1.36
r305 (  3 12 ) resistor r=0.0717383 //w=0.224 //l=0.115 //layer=m1 \
 //thickness=0.36 //x=9.185 //y=1.36 //x2=9.3 //y2=1.36
r306 (  3 4 ) resistor r=2.95802 //w=0.131 //l=3.1 //layer=m1 //thickness=0.36 \
 //x=9.185 //y=1.36 //x2=6.085 //y2=1.36
r307 (  2 8 ) resistor r=0.0717383 //w=0.224 //l=0.115 //layer=m1 \
 //thickness=0.36 //x=2.755 //y=1.36 //x2=2.64 //y2=1.36
r308 (  1 10 ) resistor r=0.0880901 //w=0.191 //l=0.115 //layer=m1 \
 //thickness=0.36 //x=5.855 //y=1.36 //x2=5.97 //y2=1.36
r309 (  1 2 ) resistor r=2.95802 //w=0.131 //l=3.1 //layer=m1 //thickness=0.36 \
 //x=5.855 //y=1.36 //x2=2.755 //y2=1.36
ends PM_VOTER3X1\%noxref_8

subckt PM_VOTER3X1\%noxref_9 ( 1 5 9 10 13 17 29 )
c54 ( 29 0 ) capacitor c=0.0790202f //x=1.05 //y=0.545
c55 ( 17 0 ) capacitor c=0.0072249f //x=3.125 //y=0.795
c56 ( 13 0 ) capacitor c=0.0156987f //x=3.04 //y=0.71
c57 ( 10 0 ) capacitor c=0.0104129f //x=2.155 //y=1.675
c58 ( 9 0 ) capacitor c=0.006761f //x=2.155 //y=0.795
c59 ( 5 0 ) capacitor c=0.029726f //x=2.07 //y=1.76
c60 ( 1 0 ) capacitor c=0.00522395f //x=1.185 //y=1.675
r61 (  17 29 ) resistor r=3.57586 //w=0.17 //l=0.125 //layer=li \
 //thickness=0.1 //x=3.125 //y=0.795 //x2=3.125 //y2=0.67
r62 (  17 29 ) resistor r=41.4118 //w=0.187 //l=0.605 //layer=li \
 //thickness=0.1 //x=3.125 //y=0.795 //x2=3.125 //y2=1.4
r63 (  14 29 ) resistor r=3.57586 //w=0.17 //l=0.103078 //layer=li \
 //thickness=0.1 //x=2.24 //y=0.71 //x2=2.155 //y2=0.67
r64 (  14 29 ) resistor r=27.0374 //w=0.187 //l=0.395 //layer=li \
 //thickness=0.1 //x=2.24 //y=0.71 //x2=2.635 //y2=0.71
r65 (  13 29 ) resistor r=3.57586 //w=0.17 //l=0.103078 //layer=li \
 //thickness=0.1 //x=3.04 //y=0.71 //x2=3.125 //y2=0.67
r66 (  13 29 ) resistor r=27.7219 //w=0.187 //l=0.405 //layer=li \
 //thickness=0.1 //x=3.04 //y=0.71 //x2=2.635 //y2=0.71
r67 (  10 29 ) resistor r=3.57586 //w=0.17 //l=0.125 //layer=li \
 //thickness=0.1 //x=2.155 //y=1.675 //x2=2.155 //y2=1.8
r68 (  10 29 ) resistor r=42.0963 //w=0.187 //l=0.615 //layer=li \
 //thickness=0.1 //x=2.155 //y=1.675 //x2=2.155 //y2=1.06
r69 (  9 29 ) resistor r=3.57586 //w=0.17 //l=0.125 //layer=li //thickness=0.1 \
 //x=2.155 //y=0.795 //x2=2.155 //y2=0.67
r70 (  9 29 ) resistor r=18.139 //w=0.187 //l=0.265 //layer=li //thickness=0.1 \
 //x=2.155 //y=0.795 //x2=2.155 //y2=1.06
r71 (  6 29 ) resistor r=3.57586 //w=0.17 //l=0.103078 //layer=li \
 //thickness=0.1 //x=1.27 //y=1.76 //x2=1.185 //y2=1.8
r72 (  6 29 ) resistor r=27.3797 //w=0.187 //l=0.4 //layer=li //thickness=0.1 \
 //x=1.27 //y=1.76 //x2=1.67 //y2=1.76
r73 (  5 29 ) resistor r=3.57586 //w=0.17 //l=0.103078 //layer=li \
 //thickness=0.1 //x=2.07 //y=1.76 //x2=2.155 //y2=1.8
r74 (  5 29 ) resistor r=27.3797 //w=0.187 //l=0.4 //layer=li //thickness=0.1 \
 //x=2.07 //y=1.76 //x2=1.67 //y2=1.76
r75 (  1 29 ) resistor r=3.57586 //w=0.17 //l=0.125 //layer=li //thickness=0.1 \
 //x=1.185 //y=1.675 //x2=1.185 //y2=1.8
r76 (  1 29 ) resistor r=42.0963 //w=0.187 //l=0.615 //layer=li \
 //thickness=0.1 //x=1.185 //y=1.675 //x2=1.185 //y2=1.06
ends PM_VOTER3X1\%noxref_9

subckt PM_VOTER3X1\%noxref_10 ( 1 5 9 10 13 17 29 )
c56 ( 29 0 ) capacitor c=0.0723467f //x=4.38 //y=0.545
c57 ( 17 0 ) capacitor c=0.0072249f //x=6.455 //y=0.795
c58 ( 13 0 ) capacitor c=0.0155051f //x=6.37 //y=0.71
c59 ( 10 0 ) capacitor c=0.0121386f //x=5.485 //y=1.675
c60 ( 9 0 ) capacitor c=0.006761f //x=5.485 //y=0.795
c61 ( 5 0 ) capacitor c=0.0249342f //x=5.4 //y=1.76
c62 ( 1 0 ) capacitor c=0.0107269f //x=4.515 //y=1.675
r63 (  17 29 ) resistor r=3.57586 //w=0.17 //l=0.125 //layer=li \
 //thickness=0.1 //x=6.455 //y=0.795 //x2=6.455 //y2=0.67
r64 (  17 29 ) resistor r=41.4118 //w=0.187 //l=0.605 //layer=li \
 //thickness=0.1 //x=6.455 //y=0.795 //x2=6.455 //y2=1.4
r65 (  14 29 ) resistor r=3.57586 //w=0.17 //l=0.103078 //layer=li \
 //thickness=0.1 //x=5.57 //y=0.71 //x2=5.485 //y2=0.67
r66 (  14 29 ) resistor r=27.3797 //w=0.187 //l=0.4 //layer=li //thickness=0.1 \
 //x=5.57 //y=0.71 //x2=5.97 //y2=0.71
r67 (  13 29 ) resistor r=3.57586 //w=0.17 //l=0.103078 //layer=li \
 //thickness=0.1 //x=6.37 //y=0.71 //x2=6.455 //y2=0.67
r68 (  13 29 ) resistor r=27.3797 //w=0.187 //l=0.4 //layer=li //thickness=0.1 \
 //x=6.37 //y=0.71 //x2=5.97 //y2=0.71
r69 (  10 29 ) resistor r=3.57586 //w=0.17 //l=0.125 //layer=li \
 //thickness=0.1 //x=5.485 //y=1.675 //x2=5.485 //y2=1.8
r70 (  10 29 ) resistor r=42.0963 //w=0.187 //l=0.615 //layer=li \
 //thickness=0.1 //x=5.485 //y=1.675 //x2=5.485 //y2=1.06
r71 (  9 29 ) resistor r=3.57586 //w=0.17 //l=0.125 //layer=li //thickness=0.1 \
 //x=5.485 //y=0.795 //x2=5.485 //y2=0.67
r72 (  9 29 ) resistor r=18.139 //w=0.187 //l=0.265 //layer=li //thickness=0.1 \
 //x=5.485 //y=0.795 //x2=5.485 //y2=1.06
r73 (  6 29 ) resistor r=3.57586 //w=0.17 //l=0.103078 //layer=li \
 //thickness=0.1 //x=4.6 //y=1.76 //x2=4.515 //y2=1.8
r74 (  6 29 ) resistor r=27.3797 //w=0.187 //l=0.4 //layer=li //thickness=0.1 \
 //x=4.6 //y=1.76 //x2=5 //y2=1.76
r75 (  5 29 ) resistor r=3.57586 //w=0.17 //l=0.103078 //layer=li \
 //thickness=0.1 //x=5.4 //y=1.76 //x2=5.485 //y2=1.8
r76 (  5 29 ) resistor r=27.3797 //w=0.187 //l=0.4 //layer=li //thickness=0.1 \
 //x=5.4 //y=1.76 //x2=5 //y2=1.76
r77 (  1 29 ) resistor r=3.57586 //w=0.17 //l=0.125 //layer=li //thickness=0.1 \
 //x=4.515 //y=1.675 //x2=4.515 //y2=1.8
r78 (  1 29 ) resistor r=42.0963 //w=0.187 //l=0.615 //layer=li \
 //thickness=0.1 //x=4.515 //y=1.675 //x2=4.515 //y2=1.06
ends PM_VOTER3X1\%noxref_10

subckt PM_VOTER3X1\%noxref_11 ( 1 5 9 10 13 17 29 )
c58 ( 29 0 ) capacitor c=0.0641554f //x=7.71 //y=0.545
c59 ( 17 0 ) capacitor c=0.00722228f //x=9.785 //y=0.795
c60 ( 13 0 ) capacitor c=0.0141607f //x=9.7 //y=0.71
c61 ( 10 0 ) capacitor c=0.00928228f //x=8.815 //y=1.675
c62 ( 9 0 ) capacitor c=0.006761f //x=8.815 //y=0.795
c63 ( 5 0 ) capacitor c=0.0289528f //x=8.73 //y=1.76
c64 ( 1 0 ) capacitor c=0.00481264f //x=7.845 //y=1.675
r65 (  17 29 ) resistor r=3.57586 //w=0.17 //l=0.125 //layer=li \
 //thickness=0.1 //x=9.785 //y=0.795 //x2=9.785 //y2=0.67
r66 (  17 29 ) resistor r=18.139 //w=0.187 //l=0.265 //layer=li \
 //thickness=0.1 //x=9.785 //y=0.795 //x2=9.785 //y2=1.06
r67 (  14 29 ) resistor r=3.57586 //w=0.17 //l=0.103078 //layer=li \
 //thickness=0.1 //x=8.9 //y=0.71 //x2=8.815 //y2=0.67
r68 (  14 29 ) resistor r=27.3797 //w=0.187 //l=0.4 //layer=li //thickness=0.1 \
 //x=8.9 //y=0.71 //x2=9.3 //y2=0.71
r69 (  13 29 ) resistor r=3.57586 //w=0.17 //l=0.103078 //layer=li \
 //thickness=0.1 //x=9.7 //y=0.71 //x2=9.785 //y2=0.67
r70 (  13 29 ) resistor r=27.3797 //w=0.187 //l=0.4 //layer=li //thickness=0.1 \
 //x=9.7 //y=0.71 //x2=9.3 //y2=0.71
r71 (  10 29 ) resistor r=3.57586 //w=0.17 //l=0.125 //layer=li \
 //thickness=0.1 //x=8.815 //y=1.675 //x2=8.815 //y2=1.8
r72 (  10 29 ) resistor r=42.0963 //w=0.187 //l=0.615 //layer=li \
 //thickness=0.1 //x=8.815 //y=1.675 //x2=8.815 //y2=1.06
r73 (  9 29 ) resistor r=3.57586 //w=0.17 //l=0.125 //layer=li //thickness=0.1 \
 //x=8.815 //y=0.795 //x2=8.815 //y2=0.67
r74 (  9 29 ) resistor r=18.139 //w=0.187 //l=0.265 //layer=li //thickness=0.1 \
 //x=8.815 //y=0.795 //x2=8.815 //y2=1.06
r75 (  6 29 ) resistor r=3.57586 //w=0.17 //l=0.103078 //layer=li \
 //thickness=0.1 //x=7.93 //y=1.76 //x2=7.845 //y2=1.8
r76 (  6 29 ) resistor r=27.3797 //w=0.187 //l=0.4 //layer=li //thickness=0.1 \
 //x=7.93 //y=1.76 //x2=8.33 //y2=1.76
r77 (  5 29 ) resistor r=3.57586 //w=0.17 //l=0.103078 //layer=li \
 //thickness=0.1 //x=8.73 //y=1.76 //x2=8.815 //y2=1.8
r78 (  5 29 ) resistor r=27.3797 //w=0.187 //l=0.4 //layer=li //thickness=0.1 \
 //x=8.73 //y=1.76 //x2=8.33 //y2=1.76
r79 (  1 29 ) resistor r=3.57586 //w=0.17 //l=0.125 //layer=li //thickness=0.1 \
 //x=7.845 //y=1.675 //x2=7.845 //y2=1.8
r80 (  1 29 ) resistor r=42.0963 //w=0.187 //l=0.615 //layer=li \
 //thickness=0.1 //x=7.845 //y=1.675 //x2=7.845 //y2=1.06
ends PM_VOTER3X1\%noxref_11

subckt PM_VOTER3X1\%Y ( 1 2 3 4 5 6 7 18 19 20 21 31 33 )
c43 ( 33 0 ) capacitor c=0.028734f //x=11.45 //y=5.2
c44 ( 31 0 ) capacitor c=0.0173218f //x=11.405 //y=1.09
c45 ( 21 0 ) capacitor c=0.00575887f //x=11.68 //y=4.76
c46 ( 20 0 ) capacitor c=0.0146395f //x=11.875 //y=4.76
c47 ( 19 0 ) capacitor c=0.00636159f //x=11.675 //y=2.26
c48 ( 18 0 ) capacitor c=0.0141837f //x=11.875 //y=2.26
c49 ( 1 0 ) capacitor c=0.105613f //x=11.96 //y=2.405
r50 (  20 23 ) resistor r=7.15173 //w=0.17 //l=0.120208 //layer=li \
 //thickness=0.1 //x=11.875 //y=4.76 //x2=11.96 //y2=4.675
r51 (  20 21 ) resistor r=13.3476 //w=0.187 //l=0.195 //layer=li \
 //thickness=0.1 //x=11.875 //y=4.76 //x2=11.68 //y2=4.76
r52 (  18 22 ) resistor r=7.15173 //w=0.17 //l=0.120208 //layer=li \
 //thickness=0.1 //x=11.875 //y=2.26 //x2=11.96 //y2=2.345
r53 (  18 19 ) resistor r=13.6898 //w=0.187 //l=0.2 //layer=li //thickness=0.1 \
 //x=11.875 //y=2.26 //x2=11.675 //y2=2.26
r54 (  12 21 ) resistor r=7.15173 //w=0.17 //l=0.120208 //layer=li \
 //thickness=0.1 //x=11.595 //y=4.845 //x2=11.68 //y2=4.76
r55 (  12 33 ) resistor r=72.5562 //w=0.187 //l=1.06 //layer=li \
 //thickness=0.1 //x=11.595 //y=4.845 //x2=11.595 //y2=5.905
r56 (  8 19 ) resistor r=7.15173 //w=0.17 //l=0.120208 //layer=li \
 //thickness=0.1 //x=11.59 //y=2.175 //x2=11.675 //y2=2.26
r57 (  8 31 ) resistor r=67.7647 //w=0.187 //l=0.99 //layer=li //thickness=0.1 \
 //x=11.59 //y=2.175 //x2=11.59 //y2=1.185
r58 (  7 23 ) resistor r=3.42246 //w=0.187 //l=0.05 //layer=li //thickness=0.1 \
 //x=11.96 //y=4.625 //x2=11.96 //y2=4.675
r59 (  6 7 ) resistor r=25.3262 //w=0.187 //l=0.37 //layer=li //thickness=0.1 \
 //x=11.96 //y=4.255 //x2=11.96 //y2=4.625
r60 (  5 6 ) resistor r=25.3262 //w=0.187 //l=0.37 //layer=li //thickness=0.1 \
 //x=11.96 //y=3.885 //x2=11.96 //y2=4.255
r61 (  4 5 ) resistor r=25.3262 //w=0.187 //l=0.37 //layer=li //thickness=0.1 \
 //x=11.96 //y=3.515 //x2=11.96 //y2=3.885
r62 (  3 4 ) resistor r=25.3262 //w=0.187 //l=0.37 //layer=li //thickness=0.1 \
 //x=11.96 //y=3.145 //x2=11.96 //y2=3.515
r63 (  2 3 ) resistor r=25.3262 //w=0.187 //l=0.37 //layer=li //thickness=0.1 \
 //x=11.96 //y=2.775 //x2=11.96 //y2=3.145
r64 (  1 2 ) resistor r=25.3262 //w=0.187 //l=0.37 //layer=li //thickness=0.1 \
 //x=11.96 //y=2.405 //x2=11.96 //y2=2.775
r65 (  1 22 ) resistor r=4.10695 //w=0.187 //l=0.06 //layer=li //thickness=0.1 \
 //x=11.96 //y=2.405 //x2=11.96 //y2=2.345
ends PM_VOTER3X1\%Y
