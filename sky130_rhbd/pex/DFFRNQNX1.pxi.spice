// File: DFFRNQNX1.spi.DFFRNQNX1.pxi
// Created: Tue Apr 29 10:39:49 2025
//
simulator lang=spectre
x_PM_DFFRNQNX1\%GND ( GND N_GND_c_8_p N_GND_c_128_p N_GND_c_1_p N_GND_c_9_p \
 N_GND_c_10_p N_GND_c_58_p N_GND_c_17_p N_GND_c_24_p N_GND_c_32_p N_GND_c_39_p \
 N_GND_c_61_p N_GND_c_68_p N_GND_c_102_p N_GND_c_2_p N_GND_c_3_p N_GND_c_4_p \
 N_GND_c_5_p N_GND_c_6_p N_GND_c_7_p N_GND_M0_noxref_d N_GND_M3_noxref_d \
 N_GND_M6_noxref_d N_GND_M8_noxref_d N_GND_M11_noxref_d N_GND_M14_noxref_d )  \
 PM_DFFRNQNX1\%GND
x_PM_DFFRNQNX1\%VDD ( VDD N_VDD_c_310_p N_VDD_c_302_n N_VDD_c_414_p \
 N_VDD_c_405_p N_VDD_c_328_p N_VDD_c_384_p N_VDD_c_385_p N_VDD_c_311_p \
 N_VDD_c_312_p N_VDD_c_318_p N_VDD_c_322_p N_VDD_c_388_p N_VDD_c_326_p \
 N_VDD_c_354_p N_VDD_c_390_p N_VDD_c_391_p N_VDD_c_366_p N_VDD_c_409_p \
 N_VDD_c_471_p N_VDD_c_538_p N_VDD_c_539_p N_VDD_c_438_p N_VDD_c_475_p \
 N_VDD_c_480_p N_VDD_c_486_p N_VDD_c_542_p N_VDD_c_504_p N_VDD_c_582_p \
 N_VDD_c_303_n N_VDD_c_304_n N_VDD_c_305_n N_VDD_c_306_n N_VDD_c_307_n \
 N_VDD_c_308_n N_VDD_M16_noxref_s N_VDD_M17_noxref_d N_VDD_M19_noxref_d \
 N_VDD_M21_noxref_d N_VDD_M22_noxref_s N_VDD_M23_noxref_d N_VDD_M25_noxref_d \
 N_VDD_M27_noxref_d N_VDD_M28_noxref_s N_VDD_M29_noxref_d N_VDD_M31_noxref_d \
 N_VDD_M32_noxref_s N_VDD_M33_noxref_d N_VDD_M35_noxref_d N_VDD_M37_noxref_d \
 N_VDD_M38_noxref_s N_VDD_M39_noxref_d N_VDD_M41_noxref_d N_VDD_M43_noxref_d \
 N_VDD_M44_noxref_s N_VDD_M45_noxref_d N_VDD_M47_noxref_d )  PM_DFFRNQNX1\%VDD
x_PM_DFFRNQNX1\%noxref_3 ( N_noxref_3_c_633_n N_noxref_3_c_637_n \
 N_noxref_3_c_638_n N_noxref_3_c_748_p N_noxref_3_c_639_n N_noxref_3_c_654_n \
 N_noxref_3_c_658_n N_noxref_3_c_660_n N_noxref_3_c_664_n N_noxref_3_c_640_n \
 N_noxref_3_c_786_p N_noxref_3_c_668_n N_noxref_3_c_641_n N_noxref_3_c_876_p \
 N_noxref_3_c_801_p N_noxref_3_M2_noxref_g N_noxref_3_M6_noxref_g \
 N_noxref_3_M20_noxref_g N_noxref_3_M21_noxref_g N_noxref_3_M28_noxref_g \
 N_noxref_3_M29_noxref_g N_noxref_3_c_734_p N_noxref_3_c_735_p \
 N_noxref_3_c_736_p N_noxref_3_c_776_p N_noxref_3_c_756_p N_noxref_3_c_778_p \
 N_noxref_3_c_757_p N_noxref_3_c_642_n N_noxref_3_c_644_n N_noxref_3_c_645_n \
 N_noxref_3_c_646_n N_noxref_3_c_647_n N_noxref_3_c_648_n N_noxref_3_c_649_n \
 N_noxref_3_c_651_n N_noxref_3_c_722_p N_noxref_3_c_739_p N_noxref_3_c_712_p \
 N_noxref_3_c_680_n N_noxref_3_M5_noxref_d N_noxref_3_M22_noxref_d \
 N_noxref_3_M24_noxref_d N_noxref_3_M26_noxref_d )  PM_DFFRNQNX1\%noxref_3
x_PM_DFFRNQNX1\%noxref_4 ( N_noxref_4_c_902_n N_noxref_4_c_950_n \
 N_noxref_4_c_919_n N_noxref_4_c_923_n N_noxref_4_c_925_n N_noxref_4_c_903_n \
 N_noxref_4_c_993_p N_noxref_4_c_904_n N_noxref_4_c_905_n N_noxref_4_c_1020_p \
 N_noxref_4_M8_noxref_g N_noxref_4_M32_noxref_g N_noxref_4_M33_noxref_g \
 N_noxref_4_c_906_n N_noxref_4_c_908_n N_noxref_4_c_909_n N_noxref_4_c_910_n \
 N_noxref_4_c_911_n N_noxref_4_c_912_n N_noxref_4_c_913_n N_noxref_4_c_915_n \
 N_noxref_4_c_966_p N_noxref_4_c_937_n N_noxref_4_M7_noxref_d \
 N_noxref_4_M28_noxref_d N_noxref_4_M30_noxref_d )  PM_DFFRNQNX1\%noxref_4
x_PM_DFFRNQNX1\%CLK ( N_CLK_c_1053_n N_CLK_c_1070_n CLK CLK CLK CLK CLK CLK \
 CLK CLK CLK N_CLK_c_1051_n N_CLK_c_1071_n N_CLK_c_1052_n N_CLK_c_1072_n \
 N_CLK_c_1104_n N_CLK_c_1105_n N_CLK_c_1107_n N_CLK_c_1073_n N_CLK_c_1132_n \
 N_CLK_c_1133_n N_CLK_c_1074_n N_CLK_M1_noxref_g N_CLK_M9_noxref_g \
 N_CLK_M18_noxref_g N_CLK_M19_noxref_g N_CLK_M34_noxref_g N_CLK_M35_noxref_g \
 N_CLK_c_1242_p N_CLK_c_1244_p N_CLK_c_1269_p N_CLK_c_1276_p N_CLK_c_1113_n \
 N_CLK_c_1114_n N_CLK_c_1115_n N_CLK_c_1116_n N_CLK_c_1119_n N_CLK_c_1138_n \
 N_CLK_c_1141_n N_CLK_c_1293_p N_CLK_c_1300_p N_CLK_c_1143_n N_CLK_c_1144_n \
 N_CLK_c_1145_n N_CLK_c_1146_n N_CLK_c_1206_p N_CLK_c_1120_n N_CLK_c_1148_n )  \
 PM_DFFRNQNX1\%CLK
x_PM_DFFRNQNX1\%noxref_6 ( N_noxref_6_c_1378_n N_noxref_6_c_1379_n \
 N_noxref_6_c_1305_n N_noxref_6_c_1386_n N_noxref_6_c_1330_n \
 N_noxref_6_c_1334_n N_noxref_6_c_1336_n N_noxref_6_c_1340_n \
 N_noxref_6_c_1306_n N_noxref_6_c_1393_n N_noxref_6_c_1344_n \
 N_noxref_6_c_1307_n N_noxref_6_c_1308_n N_noxref_6_c_1441_n \
 N_noxref_6_c_1402_n N_noxref_6_M3_noxref_g N_noxref_6_M11_noxref_g \
 N_noxref_6_M22_noxref_g N_noxref_6_M23_noxref_g N_noxref_6_M38_noxref_g \
 N_noxref_6_M39_noxref_g N_noxref_6_c_1309_n N_noxref_6_c_1311_n \
 N_noxref_6_c_1312_n N_noxref_6_c_1313_n N_noxref_6_c_1314_n \
 N_noxref_6_c_1315_n N_noxref_6_c_1316_n N_noxref_6_c_1318_n \
 N_noxref_6_c_1407_n N_noxref_6_c_1359_n N_noxref_6_c_1319_n \
 N_noxref_6_c_1321_n N_noxref_6_c_1322_n N_noxref_6_c_1323_n \
 N_noxref_6_c_1324_n N_noxref_6_c_1325_n N_noxref_6_c_1326_n \
 N_noxref_6_c_1328_n N_noxref_6_c_1457_p N_noxref_6_c_1361_n \
 N_noxref_6_M2_noxref_d N_noxref_6_M16_noxref_d N_noxref_6_M18_noxref_d \
 N_noxref_6_M20_noxref_d )  PM_DFFRNQNX1\%noxref_6
x_PM_DFFRNQNX1\%RN ( N_RN_c_1560_n N_RN_c_1568_n N_RN_c_1570_n N_RN_c_1574_n \
 RN RN RN RN RN RN RN RN RN RN RN RN RN RN N_RN_c_1611_n N_RN_c_1581_n \
 N_RN_c_1656_n N_RN_c_1582_n N_RN_c_1687_n N_RN_c_1583_n N_RN_c_1577_n \
 N_RN_c_1618_n N_RN_c_1578_n N_RN_c_1661_n N_RN_c_1662_n N_RN_c_1584_n \
 N_RN_c_1579_n N_RN_c_1721_p N_RN_c_1722_p N_RN_c_1694_n N_RN_c_1585_n \
 N_RN_M5_noxref_g N_RN_M10_noxref_g N_RN_M12_noxref_g N_RN_M26_noxref_g \
 N_RN_M27_noxref_g N_RN_M36_noxref_g N_RN_M37_noxref_g N_RN_M40_noxref_g \
 N_RN_M41_noxref_g N_RN_c_1623_n N_RN_c_1624_n N_RN_c_1625_n N_RN_c_1626_n \
 N_RN_c_1627_n N_RN_c_1629_n N_RN_c_1630_n N_RN_c_1668_n N_RN_c_1669_n \
 N_RN_c_1670_n N_RN_c_1804_p N_RN_c_1778_p N_RN_c_1806_p N_RN_c_1779_p \
 N_RN_c_1699_n N_RN_c_1702_n N_RN_c_1877_p N_RN_c_1884_p N_RN_c_1704_n \
 N_RN_c_1705_n N_RN_c_1706_n N_RN_c_1707_n N_RN_c_1741_p N_RN_c_1632_n \
 N_RN_c_1633_n N_RN_c_1635_n N_RN_c_1672_n N_RN_c_1674_n N_RN_c_1675_n \
 N_RN_c_1709_n )  PM_DFFRNQNX1\%RN
x_PM_DFFRNQNX1\%noxref_8 ( N_noxref_8_c_1889_n N_noxref_8_c_1890_n \
 N_noxref_8_M13_noxref_g N_noxref_8_M42_noxref_g N_noxref_8_M43_noxref_g \
 N_noxref_8_c_1919_n N_noxref_8_c_1920_n N_noxref_8_c_1921_n \
 N_noxref_8_c_1951_p N_noxref_8_c_1936_p N_noxref_8_c_1953_p \
 N_noxref_8_c_1937_p N_noxref_8_c_1922_n N_noxref_8_c_1925_n \
 N_noxref_8_c_1926_n )  PM_DFFRNQNX1\%noxref_8
x_PM_DFFRNQNX1\%QN ( QN QN QN QN QN QN QN QN QN QN QN N_QN_c_2002_n \
 N_QN_c_2006_n N_QN_c_2008_n N_QN_c_2012_n N_QN_c_1983_n N_QN_c_2068_n \
 N_QN_c_2016_n N_QN_c_1984_n N_QN_c_2017_n N_QN_c_2052_n N_QN_c_2069_n \
 N_QN_c_2071_n N_QN_c_1985_n N_QN_c_1986_n N_QN_c_2019_n N_QN_c_2020_n \
 N_QN_c_2109_p N_QN_c_2077_n N_QN_c_2111_p N_QN_c_2021_n N_QN_M14_noxref_g \
 N_QN_M44_noxref_g N_QN_M45_noxref_g N_QN_c_1987_n N_QN_c_1989_n N_QN_c_1990_n \
 N_QN_c_1991_n N_QN_c_1992_n N_QN_c_1993_n N_QN_c_1994_n N_QN_c_1996_n \
 N_QN_c_2026_n N_QN_M13_noxref_d N_QN_M38_noxref_d N_QN_M40_noxref_d \
 N_QN_M42_noxref_d )  PM_DFFRNQNX1\%QN
x_PM_DFFRNQNX1\%noxref_10 ( N_noxref_10_c_2170_n N_noxref_10_c_2171_n \
 N_noxref_10_c_2197_n N_noxref_10_c_2273_n N_noxref_10_c_2172_n \
 N_noxref_10_c_2210_n N_noxref_10_c_2173_n N_noxref_10_c_2275_n \
 N_noxref_10_c_2174_n N_noxref_10_c_2218_n N_noxref_10_c_2222_n \
 N_noxref_10_c_2224_n N_noxref_10_c_2228_n N_noxref_10_c_2176_n \
 N_noxref_10_c_2430_n N_noxref_10_c_2232_n N_noxref_10_c_2476_n \
 N_noxref_10_c_2177_n N_noxref_10_c_2362_n N_noxref_10_c_2447_n \
 N_noxref_10_M0_noxref_g N_noxref_10_M7_noxref_g N_noxref_10_M15_noxref_g \
 N_noxref_10_M16_noxref_g N_noxref_10_M17_noxref_g N_noxref_10_M30_noxref_g \
 N_noxref_10_M31_noxref_g N_noxref_10_M46_noxref_g N_noxref_10_M47_noxref_g \
 N_noxref_10_c_2179_n N_noxref_10_c_2181_n N_noxref_10_c_2182_n \
 N_noxref_10_c_2183_n N_noxref_10_c_2184_n N_noxref_10_c_2185_n \
 N_noxref_10_c_2186_n N_noxref_10_c_2188_n N_noxref_10_c_2377_n \
 N_noxref_10_c_2249_n N_noxref_10_c_2284_n N_noxref_10_c_2287_n \
 N_noxref_10_c_2289_n N_noxref_10_c_2319_n N_noxref_10_c_2321_n \
 N_noxref_10_c_2322_n N_noxref_10_c_2292_n N_noxref_10_c_2293_n \
 N_noxref_10_c_2493_n N_noxref_10_c_2496_n N_noxref_10_c_2498_n \
 N_noxref_10_c_2518_p N_noxref_10_c_2526_p N_noxref_10_c_2513_p \
 N_noxref_10_c_2501_n N_noxref_10_c_2502_n N_noxref_10_c_2294_n \
 N_noxref_10_c_2328_n N_noxref_10_c_2296_n N_noxref_10_c_2503_n \
 N_noxref_10_c_2520_p N_noxref_10_c_2505_n N_noxref_10_M10_noxref_d \
 N_noxref_10_M32_noxref_d N_noxref_10_M34_noxref_d N_noxref_10_M36_noxref_d )  \
 PM_DFFRNQNX1\%noxref_10
x_PM_DFFRNQNX1\%noxref_11 ( N_noxref_11_c_2587_n N_noxref_11_c_2591_n \
 N_noxref_11_c_2593_n N_noxref_11_c_2581_n N_noxref_11_c_2657_p \
 N_noxref_11_c_2582_n N_noxref_11_c_2646_n N_noxref_11_M15_noxref_d \
 N_noxref_11_M44_noxref_d N_noxref_11_M46_noxref_d )  PM_DFFRNQNX1\%noxref_11
x_PM_DFFRNQNX1\%noxref_12 ( N_noxref_12_c_2693_n N_noxref_12_c_2667_n \
 N_noxref_12_c_2671_n N_noxref_12_c_2674_n N_noxref_12_c_2685_n \
 N_noxref_12_M0_noxref_s )  PM_DFFRNQNX1\%noxref_12
x_PM_DFFRNQNX1\%noxref_13 ( N_noxref_13_c_2715_n N_noxref_13_c_2717_n \
 N_noxref_13_c_2720_n N_noxref_13_c_2723_n N_noxref_13_c_2734_n \
 N_noxref_13_M1_noxref_d N_noxref_13_M2_noxref_s )  PM_DFFRNQNX1\%noxref_13
x_PM_DFFRNQNX1\%D ( D D N_D_c_2768_n N_D_c_2769_n N_D_c_2797_n N_D_M4_noxref_g \
 N_D_M24_noxref_g N_D_M25_noxref_g N_D_c_2801_n N_D_c_2804_n N_D_c_2845_p \
 N_D_c_2852_p N_D_c_2806_n N_D_c_2807_n N_D_c_2808_n N_D_c_2809_n N_D_c_2786_n \
 N_D_c_2787_n )  PM_DFFRNQNX1\%D
x_PM_DFFRNQNX1\%noxref_15 ( N_noxref_15_c_2873_n N_noxref_15_c_2857_n \
 N_noxref_15_c_2861_n N_noxref_15_c_2864_n N_noxref_15_c_2875_n \
 N_noxref_15_M3_noxref_s )  PM_DFFRNQNX1\%noxref_15
x_PM_DFFRNQNX1\%noxref_16 ( N_noxref_16_c_2908_n N_noxref_16_c_2910_n \
 N_noxref_16_c_2913_n N_noxref_16_c_2916_n N_noxref_16_c_2925_n \
 N_noxref_16_M4_noxref_d N_noxref_16_M5_noxref_s )  PM_DFFRNQNX1\%noxref_16
x_PM_DFFRNQNX1\%noxref_17 ( N_noxref_17_c_2981_n N_noxref_17_c_2962_n \
 N_noxref_17_c_2966_n N_noxref_17_c_2969_n N_noxref_17_c_2970_n \
 N_noxref_17_c_2973_n N_noxref_17_M6_noxref_s )  PM_DFFRNQNX1\%noxref_17
x_PM_DFFRNQNX1\%noxref_18 ( N_noxref_18_c_3030_n N_noxref_18_c_3014_n \
 N_noxref_18_c_3018_n N_noxref_18_c_3021_n N_noxref_18_c_3044_n \
 N_noxref_18_M8_noxref_s )  PM_DFFRNQNX1\%noxref_18
x_PM_DFFRNQNX1\%noxref_19 ( N_noxref_19_c_3065_n N_noxref_19_c_3067_n \
 N_noxref_19_c_3070_n N_noxref_19_c_3073_n N_noxref_19_c_3098_n \
 N_noxref_19_M9_noxref_d N_noxref_19_M10_noxref_s )  PM_DFFRNQNX1\%noxref_19
x_PM_DFFRNQNX1\%noxref_20 ( N_noxref_20_c_3135_n N_noxref_20_c_3119_n \
 N_noxref_20_c_3123_n N_noxref_20_c_3126_n N_noxref_20_c_3149_n \
 N_noxref_20_M11_noxref_s )  PM_DFFRNQNX1\%noxref_20
x_PM_DFFRNQNX1\%noxref_21 ( N_noxref_21_c_3171_n N_noxref_21_c_3173_n \
 N_noxref_21_c_3176_n N_noxref_21_c_3179_n N_noxref_21_c_3202_n \
 N_noxref_21_M12_noxref_d N_noxref_21_M13_noxref_s )  PM_DFFRNQNX1\%noxref_21
x_PM_DFFRNQNX1\%noxref_22 ( N_noxref_22_c_3241_n N_noxref_22_c_3224_n \
 N_noxref_22_c_3228_n N_noxref_22_c_3231_n N_noxref_22_c_3232_n \
 N_noxref_22_c_3234_n N_noxref_22_M14_noxref_s )  PM_DFFRNQNX1\%noxref_22
cc_1 ( N_GND_c_1_p N_VDD_c_302_n ) capacitor c=0.00989514f //x=1.175 //y=0.18 \
 //x2=1.175 //y2=7.58
cc_2 ( N_GND_c_2_p N_VDD_c_303_n ) capacitor c=0.00989514f //x=25.965 //y=0.18 \
 //x2=25.965 //y2=7.58
cc_3 ( N_GND_c_3_p N_VDD_c_304_n ) capacitor c=0.00500791f //x=5.245 //y=0.175 \
 //x2=5.245 //y2=7.585
cc_4 ( N_GND_c_4_p N_VDD_c_305_n ) capacitor c=0.00500791f //x=10.055 \
 //y=0.175 //x2=10.055 //y2=7.585
cc_5 ( N_GND_c_5_p N_VDD_c_306_n ) capacitor c=0.00500791f //x=13.385 \
 //y=0.175 //x2=13.385 //y2=7.585
cc_6 ( N_GND_c_6_p N_VDD_c_307_n ) capacitor c=0.00524733f //x=18.195 \
 //y=0.175 //x2=18.195 //y2=7.585
cc_7 ( N_GND_c_7_p N_VDD_c_308_n ) capacitor c=0.00500791f //x=23.005 \
 //y=0.175 //x2=23.005 //y2=7.585
cc_8 ( N_GND_c_8_p N_noxref_3_c_633_n ) capacitor c=0.0324965f //x=25.965 \
 //y=0.18 //x2=9.2 //y2=3.51
cc_9 ( N_GND_c_9_p N_noxref_3_c_633_n ) capacitor c=0.00174454f //x=5.075 \
 //y=0.175 //x2=9.2 //y2=3.51
cc_10 ( N_GND_c_10_p N_noxref_3_c_633_n ) capacitor c=0.00152439f //x=6.235 \
 //y=0.175 //x2=9.2 //y2=3.51
cc_11 ( N_GND_c_3_p N_noxref_3_c_633_n ) capacitor c=0.00820859f //x=5.245 \
 //y=0.175 //x2=9.2 //y2=3.51
cc_12 ( N_GND_c_8_p N_noxref_3_c_637_n ) capacitor c=0.00172486f //x=25.965 \
 //y=0.18 //x2=3.88 //y2=3.51
cc_13 ( N_GND_c_4_p N_noxref_3_c_638_n ) capacitor c=0.0058231f //x=10.055 \
 //y=0.175 //x2=11.05 //y2=3.51
cc_14 ( N_GND_c_3_p N_noxref_3_c_639_n ) capacitor c=9.53263e-19 //x=5.245 \
 //y=0.175 //x2=3.765 //y2=2.26
cc_15 ( N_GND_c_4_p N_noxref_3_c_640_n ) capacitor c=0.0432238f //x=10.055 \
 //y=0.175 //x2=9.23 //y2=1.845
cc_16 ( N_GND_c_4_p N_noxref_3_c_641_n ) capacitor c=0.0156446f //x=10.055 \
 //y=0.175 //x2=11.165 //y2=2.26
cc_17 ( N_GND_c_17_p N_noxref_3_c_642_n ) capacitor c=0.00135783f //x=11.15 \
 //y=0.175 //x2=10.97 //y2=1.045
cc_18 ( N_GND_M6_noxref_d N_noxref_3_c_642_n ) capacitor c=0.00220047f \
 //x=11.045 //y=1.045 //x2=10.97 //y2=1.045
cc_19 ( N_GND_M6_noxref_d N_noxref_3_c_644_n ) capacitor c=0.00255985f \
 //x=11.045 //y=1.045 //x2=10.97 //y2=1.39
cc_20 ( N_GND_c_4_p N_noxref_3_c_645_n ) capacitor c=0.00189421f //x=10.055 \
 //y=0.175 //x2=10.97 //y2=1.7
cc_21 ( N_GND_c_4_p N_noxref_3_c_646_n ) capacitor c=0.00992619f //x=10.055 \
 //y=0.175 //x2=10.97 //y2=2.095
cc_22 ( N_GND_M6_noxref_d N_noxref_3_c_647_n ) capacitor c=0.0131374f \
 //x=11.045 //y=1.045 //x2=11.345 //y2=0.89
cc_23 ( N_GND_M6_noxref_d N_noxref_3_c_648_n ) capacitor c=0.00193146f \
 //x=11.045 //y=1.045 //x2=11.345 //y2=1.545
cc_24 ( N_GND_c_24_p N_noxref_3_c_649_n ) capacitor c=0.00131234f //x=13.215 \
 //y=0.175 //x2=11.5 //y2=1.045
cc_25 ( N_GND_M6_noxref_d N_noxref_3_c_649_n ) capacitor c=0.00257848f \
 //x=11.045 //y=1.045 //x2=11.5 //y2=1.045
cc_26 ( N_GND_M6_noxref_d N_noxref_3_c_651_n ) capacitor c=0.00255985f \
 //x=11.045 //y=1.045 //x2=11.5 //y2=1.39
cc_27 ( N_GND_c_4_p N_noxref_3_M5_noxref_d ) capacitor c=0.00591582f \
 //x=10.055 //y=0.175 //x2=8.64 //y2=1.095
cc_28 ( N_GND_c_5_p N_noxref_4_c_902_n ) capacitor c=0.0058231f //x=13.385 \
 //y=0.175 //x2=14.38 //y2=3.51
cc_29 ( N_GND_c_5_p N_noxref_4_c_903_n ) capacitor c=0.0436242f //x=13.385 \
 //y=0.175 //x2=12.56 //y2=1.835
cc_30 ( N_GND_c_4_p N_noxref_4_c_904_n ) capacitor c=9.64732e-19 //x=10.055 \
 //y=0.175 //x2=12.645 //y2=3.51
cc_31 ( N_GND_c_5_p N_noxref_4_c_905_n ) capacitor c=0.0156442f //x=13.385 \
 //y=0.175 //x2=14.495 //y2=2.26
cc_32 ( N_GND_c_32_p N_noxref_4_c_906_n ) capacitor c=0.00133465f //x=14.375 \
 //y=0.175 //x2=14.195 //y2=1.055
cc_33 ( N_GND_M8_noxref_d N_noxref_4_c_906_n ) capacitor c=0.00211996f \
 //x=14.27 //y=1.055 //x2=14.195 //y2=1.055
cc_34 ( N_GND_M8_noxref_d N_noxref_4_c_908_n ) capacitor c=0.00255985f \
 //x=14.27 //y=1.055 //x2=14.195 //y2=1.4
cc_35 ( N_GND_c_5_p N_noxref_4_c_909_n ) capacitor c=0.00195164f //x=13.385 \
 //y=0.175 //x2=14.195 //y2=1.71
cc_36 ( N_GND_c_5_p N_noxref_4_c_910_n ) capacitor c=0.0110952f //x=13.385 \
 //y=0.175 //x2=14.195 //y2=2.095
cc_37 ( N_GND_M8_noxref_d N_noxref_4_c_911_n ) capacitor c=0.0131387f \
 //x=14.27 //y=1.055 //x2=14.57 //y2=0.9
cc_38 ( N_GND_M8_noxref_d N_noxref_4_c_912_n ) capacitor c=0.00193165f \
 //x=14.27 //y=1.055 //x2=14.57 //y2=1.555
cc_39 ( N_GND_c_39_p N_noxref_4_c_913_n ) capacitor c=0.00129623f //x=18.025 \
 //y=0.175 //x2=14.725 //y2=1.055
cc_40 ( N_GND_M8_noxref_d N_noxref_4_c_913_n ) capacitor c=0.00257848f \
 //x=14.27 //y=1.055 //x2=14.725 //y2=1.055
cc_41 ( N_GND_M8_noxref_d N_noxref_4_c_915_n ) capacitor c=0.00255985f \
 //x=14.27 //y=1.055 //x2=14.725 //y2=1.4
cc_42 ( N_GND_c_4_p N_noxref_4_M7_noxref_d ) capacitor c=8.58106e-19 \
 //x=10.055 //y=0.175 //x2=12.015 //y2=1.085
cc_43 ( N_GND_c_5_p N_noxref_4_M7_noxref_d ) capacitor c=0.00616547f \
 //x=13.385 //y=0.175 //x2=12.015 //y2=1.085
cc_44 ( N_GND_M6_noxref_d N_noxref_4_M7_noxref_d ) capacitor c=0.00143464f \
 //x=11.045 //y=1.045 //x2=12.015 //y2=1.085
cc_45 ( N_GND_c_1_p N_CLK_c_1051_n ) capacitor c=7.65588e-19 //x=1.175 \
 //y=0.18 //x2=2.655 //y2=2.26
cc_46 ( N_GND_c_5_p N_CLK_c_1052_n ) capacitor c=6.06131e-19 //x=13.385 \
 //y=0.175 //x2=15.605 //y2=2.26
cc_47 ( N_GND_c_6_p N_noxref_6_c_1305_n ) capacitor c=0.00390258f //x=18.195 \
 //y=0.175 //x2=19.19 //y2=3.88
cc_48 ( N_GND_c_3_p N_noxref_6_c_1306_n ) capacitor c=0.0459494f //x=5.245 \
 //y=0.175 //x2=4.42 //y2=1.845
cc_49 ( N_GND_c_3_p N_noxref_6_c_1307_n ) capacitor c=0.0178133f //x=5.245 \
 //y=0.175 //x2=6.355 //y2=2.26
cc_50 ( N_GND_c_6_p N_noxref_6_c_1308_n ) capacitor c=0.0155796f //x=18.195 \
 //y=0.175 //x2=19.305 //y2=2.26
cc_51 ( N_GND_c_10_p N_noxref_6_c_1309_n ) capacitor c=0.00133465f //x=6.235 \
 //y=0.175 //x2=6.055 //y2=1.055
cc_52 ( N_GND_M3_noxref_d N_noxref_6_c_1309_n ) capacitor c=0.00211996f \
 //x=6.13 //y=1.055 //x2=6.055 //y2=1.055
cc_53 ( N_GND_M3_noxref_d N_noxref_6_c_1311_n ) capacitor c=0.00255985f \
 //x=6.13 //y=1.055 //x2=6.055 //y2=1.4
cc_54 ( N_GND_c_3_p N_noxref_6_c_1312_n ) capacitor c=0.00204716f //x=5.245 \
 //y=0.175 //x2=6.055 //y2=1.71
cc_55 ( N_GND_c_3_p N_noxref_6_c_1313_n ) capacitor c=0.0118433f //x=5.245 \
 //y=0.175 //x2=6.055 //y2=2.095
cc_56 ( N_GND_M3_noxref_d N_noxref_6_c_1314_n ) capacitor c=0.0131387f \
 //x=6.13 //y=1.055 //x2=6.43 //y2=0.9
cc_57 ( N_GND_M3_noxref_d N_noxref_6_c_1315_n ) capacitor c=0.00193165f \
 //x=6.13 //y=1.055 //x2=6.43 //y2=1.555
cc_58 ( N_GND_c_58_p N_noxref_6_c_1316_n ) capacitor c=0.00129623f //x=9.885 \
 //y=0.175 //x2=6.585 //y2=1.055
cc_59 ( N_GND_M3_noxref_d N_noxref_6_c_1316_n ) capacitor c=0.00257848f \
 //x=6.13 //y=1.055 //x2=6.585 //y2=1.055
cc_60 ( N_GND_M3_noxref_d N_noxref_6_c_1318_n ) capacitor c=0.00255985f \
 //x=6.13 //y=1.055 //x2=6.585 //y2=1.4
cc_61 ( N_GND_c_61_p N_noxref_6_c_1319_n ) capacitor c=0.00133465f //x=19.185 \
 //y=0.175 //x2=19.005 //y2=1.055
cc_62 ( N_GND_M11_noxref_d N_noxref_6_c_1319_n ) capacitor c=0.00211996f \
 //x=19.08 //y=1.055 //x2=19.005 //y2=1.055
cc_63 ( N_GND_M11_noxref_d N_noxref_6_c_1321_n ) capacitor c=0.00255985f \
 //x=19.08 //y=1.055 //x2=19.005 //y2=1.4
cc_64 ( N_GND_c_6_p N_noxref_6_c_1322_n ) capacitor c=0.00204716f //x=18.195 \
 //y=0.175 //x2=19.005 //y2=1.71
cc_65 ( N_GND_c_6_p N_noxref_6_c_1323_n ) capacitor c=0.0110952f //x=18.195 \
 //y=0.175 //x2=19.005 //y2=2.095
cc_66 ( N_GND_M11_noxref_d N_noxref_6_c_1324_n ) capacitor c=0.0131387f \
 //x=19.08 //y=1.055 //x2=19.38 //y2=0.9
cc_67 ( N_GND_M11_noxref_d N_noxref_6_c_1325_n ) capacitor c=0.00193165f \
 //x=19.08 //y=1.055 //x2=19.38 //y2=1.555
cc_68 ( N_GND_c_68_p N_noxref_6_c_1326_n ) capacitor c=0.00129623f //x=22.835 \
 //y=0.175 //x2=19.535 //y2=1.055
cc_69 ( N_GND_M11_noxref_d N_noxref_6_c_1326_n ) capacitor c=0.00257848f \
 //x=19.08 //y=1.055 //x2=19.535 //y2=1.055
cc_70 ( N_GND_M11_noxref_d N_noxref_6_c_1328_n ) capacitor c=0.00255985f \
 //x=19.08 //y=1.055 //x2=19.535 //y2=1.4
cc_71 ( N_GND_c_3_p N_noxref_6_M2_noxref_d ) capacitor c=0.00591582f //x=5.245 \
 //y=0.175 //x2=3.83 //y2=1.095
cc_72 ( N_GND_c_8_p N_RN_c_1560_n ) capacitor c=0.0754923f //x=25.965 //y=0.18 \
 //x2=16.6 //y2=2.4
cc_73 ( N_GND_c_58_p N_RN_c_1560_n ) capacitor c=0.00318809f //x=9.885 \
 //y=0.175 //x2=16.6 //y2=2.4
cc_74 ( N_GND_c_17_p N_RN_c_1560_n ) capacitor c=0.00347867f //x=11.15 \
 //y=0.175 //x2=16.6 //y2=2.4
cc_75 ( N_GND_c_24_p N_RN_c_1560_n ) capacitor c=0.00412122f //x=13.215 \
 //y=0.175 //x2=16.6 //y2=2.4
cc_76 ( N_GND_c_32_p N_RN_c_1560_n ) capacitor c=0.00274395f //x=14.375 \
 //y=0.175 //x2=16.6 //y2=2.4
cc_77 ( N_GND_c_39_p N_RN_c_1560_n ) capacitor c=0.00111248f //x=18.025 \
 //y=0.175 //x2=16.6 //y2=2.4
cc_78 ( N_GND_c_4_p N_RN_c_1560_n ) capacitor c=0.0418918f //x=10.055 \
 //y=0.175 //x2=16.6 //y2=2.4
cc_79 ( N_GND_c_5_p N_RN_c_1560_n ) capacitor c=0.0418918f //x=13.385 \
 //y=0.175 //x2=16.6 //y2=2.4
cc_80 ( N_GND_c_8_p N_RN_c_1568_n ) capacitor c=0.0022131f //x=25.965 //y=0.18 \
 //x2=8.69 //y2=2.4
cc_81 ( N_GND_c_58_p N_RN_c_1568_n ) capacitor c=4.18994e-19 //x=9.885 \
 //y=0.175 //x2=8.69 //y2=2.4
cc_82 ( N_GND_c_8_p N_RN_c_1570_n ) capacitor c=0.0354995f //x=25.965 //y=0.18 \
 //x2=20.3 //y2=2.4
cc_83 ( N_GND_c_39_p N_RN_c_1570_n ) capacitor c=0.0031881f //x=18.025 \
 //y=0.175 //x2=20.3 //y2=2.4
cc_84 ( N_GND_c_61_p N_RN_c_1570_n ) capacitor c=0.00274395f //x=19.185 \
 //y=0.175 //x2=20.3 //y2=2.4
cc_85 ( N_GND_c_6_p N_RN_c_1570_n ) capacitor c=0.0430854f //x=18.195 \
 //y=0.175 //x2=20.3 //y2=2.4
cc_86 ( N_GND_c_8_p N_RN_c_1574_n ) capacitor c=0.00195474f //x=25.965 \
 //y=0.18 //x2=16.83 //y2=2.4
cc_87 ( N_GND_c_4_p RN ) capacitor c=2.6258e-19 //x=10.055 //y=0.175 //x2=8.63 \
 //y2=2.77
cc_88 ( N_GND_c_6_p RN ) capacitor c=2.6258e-19 //x=18.195 //y=0.175 \
 //x2=16.77 //y2=2.77
cc_89 ( N_GND_c_4_p N_RN_c_1577_n ) capacitor c=3.07601e-19 //x=10.055 \
 //y=0.175 //x2=8.602 //y2=2.685
cc_90 ( N_GND_c_6_p N_RN_c_1578_n ) capacitor c=3.07601e-19 //x=18.195 \
 //y=0.175 //x2=16.742 //y2=2.685
cc_91 ( N_GND_c_6_p N_RN_c_1579_n ) capacitor c=5.95501e-19 //x=18.195 \
 //y=0.175 //x2=20.442 //y2=2.685
cc_92 ( N_GND_c_7_p N_noxref_8_c_1889_n ) capacitor c=0.00133749f //x=23.005 \
 //y=0.175 //x2=21.525 //y2=2.26
cc_93 ( N_GND_c_8_p N_noxref_8_c_1890_n ) capacitor c=0.00250254f //x=25.965 \
 //y=0.18 //x2=21.525 //y2=3.88
cc_94 ( N_GND_c_8_p QN ) capacitor c=2.49867e-19 //x=25.965 //y=0.18 \
 //x2=22.32 //y2=2.4
cc_95 ( N_GND_c_68_p QN ) capacitor c=3.58527e-19 //x=22.835 //y=0.175 \
 //x2=22.32 //y2=2.4
cc_96 ( N_GND_c_7_p QN ) capacitor c=0.00895661f //x=23.005 //y=0.175 \
 //x2=22.32 //y2=2.4
cc_97 ( N_GND_c_7_p QN ) capacitor c=0.00926924f //x=23.005 //y=0.175 \
 //x2=22.32 //y2=2.77
cc_98 ( N_GND_c_8_p QN ) capacitor c=0.00283431f //x=25.965 //y=0.18 \
 //x2=22.32 //y2=3.51
cc_99 ( N_GND_c_68_p QN ) capacitor c=5.01306e-19 //x=22.835 //y=0.175 \
 //x2=22.32 //y2=3.51
cc_100 ( N_GND_c_8_p QN ) capacitor c=0.0126046f //x=25.965 //y=0.18 \
 //x2=24.17 //y2=3.51
cc_101 ( N_GND_c_68_p QN ) capacitor c=8.02089e-19 //x=22.835 //y=0.175 \
 //x2=24.17 //y2=3.51
cc_102 ( N_GND_c_102_p QN ) capacitor c=0.00189777f //x=24.1 //y=0.175 \
 //x2=24.17 //y2=3.51
cc_103 ( N_GND_c_7_p QN ) capacitor c=0.00820859f //x=23.005 //y=0.175 \
 //x2=24.17 //y2=3.51
cc_104 ( N_GND_c_7_p N_QN_c_1983_n ) capacitor c=0.0224176f //x=23.005 \
 //y=0.175 //x2=22.18 //y2=1.845
cc_105 ( N_GND_c_7_p N_QN_c_1984_n ) capacitor c=0.0181093f //x=23.005 \
 //y=0.175 //x2=24.115 //y2=2.485
cc_106 ( N_GND_c_7_p N_QN_c_1985_n ) capacitor c=0.00761025f //x=23.005 \
 //y=0.175 //x2=22.292 //y2=2.685
cc_107 ( N_GND_c_7_p N_QN_c_1986_n ) capacitor c=0.00171326f //x=23.005 \
 //y=0.175 //x2=22.292 //y2=3.055
cc_108 ( N_GND_c_102_p N_QN_c_1987_n ) capacitor c=0.00135783f //x=24.1 \
 //y=0.175 //x2=23.92 //y2=1.045
cc_109 ( N_GND_M14_noxref_d N_QN_c_1987_n ) capacitor c=0.00220047f //x=23.995 \
 //y=1.045 //x2=23.92 //y2=1.045
cc_110 ( N_GND_M14_noxref_d N_QN_c_1989_n ) capacitor c=0.00255985f //x=23.995 \
 //y=1.045 //x2=23.92 //y2=1.39
cc_111 ( N_GND_c_7_p N_QN_c_1990_n ) capacitor c=0.00189421f //x=23.005 \
 //y=0.175 //x2=23.92 //y2=1.7
cc_112 ( N_GND_c_7_p N_QN_c_1991_n ) capacitor c=0.0106743f //x=23.005 \
 //y=0.175 //x2=23.92 //y2=2.095
cc_113 ( N_GND_M14_noxref_d N_QN_c_1992_n ) capacitor c=0.0131374f //x=23.995 \
 //y=1.045 //x2=24.295 //y2=0.89
cc_114 ( N_GND_M14_noxref_d N_QN_c_1993_n ) capacitor c=0.00193146f //x=23.995 \
 //y=1.045 //x2=24.295 //y2=1.545
cc_115 ( N_GND_c_2_p N_QN_c_1994_n ) capacitor c=0.00131234f //x=25.965 \
 //y=0.18 //x2=24.45 //y2=1.045
cc_116 ( N_GND_M14_noxref_d N_QN_c_1994_n ) capacitor c=0.00257848f //x=23.995 \
 //y=1.045 //x2=24.45 //y2=1.045
cc_117 ( N_GND_M14_noxref_d N_QN_c_1996_n ) capacitor c=0.00255985f //x=23.995 \
 //y=1.045 //x2=24.45 //y2=1.39
cc_118 ( N_GND_c_7_p N_QN_M13_noxref_d ) capacitor c=0.00591582f //x=23.005 \
 //y=0.175 //x2=21.59 //y2=1.095
cc_119 ( N_GND_c_8_p N_noxref_10_c_2170_n ) capacitor c=0.0122542f //x=25.965 \
 //y=0.18 //x2=11.79 //y2=4.25
cc_120 ( N_GND_c_8_p N_noxref_10_c_2171_n ) capacitor c=0.0015897f //x=25.965 \
 //y=0.18 //x2=1.66 //y2=4.25
cc_121 ( N_GND_c_8_p N_noxref_10_c_2172_n ) capacitor c=0.0110603f //x=25.965 \
 //y=0.18 //x2=24.74 //y2=4.25
cc_122 ( N_GND_c_1_p N_noxref_10_c_2173_n ) capacitor c=0.0180363f //x=1.175 \
 //y=0.18 //x2=1.545 //y2=2.26
cc_123 ( N_GND_c_4_p N_noxref_10_c_2174_n ) capacitor c=7.4738e-19 //x=10.055 \
 //y=0.175 //x2=11.905 //y2=2.26
cc_124 ( N_GND_c_5_p N_noxref_10_c_2174_n ) capacitor c=7.76678e-19 //x=13.385 \
 //y=0.175 //x2=11.905 //y2=2.26
cc_125 ( N_GND_c_6_p N_noxref_10_c_2176_n ) capacitor c=0.0430857f //x=18.195 \
 //y=0.175 //x2=17.37 //y2=1.845
cc_126 ( N_GND_c_2_p N_noxref_10_c_2177_n ) capacitor c=9.53263e-19 //x=25.965 \
 //y=0.18 //x2=24.855 //y2=2.26
cc_127 ( N_GND_c_7_p N_noxref_10_c_2177_n ) capacitor c=9.39053e-19 //x=23.005 \
 //y=0.175 //x2=24.855 //y2=2.26
cc_128 ( N_GND_c_128_p N_noxref_10_c_2179_n ) capacitor c=0.00133465f \
 //x=1.425 //y=0.175 //x2=1.245 //y2=1.055
cc_129 ( N_GND_M0_noxref_d N_noxref_10_c_2179_n ) capacitor c=0.00211996f \
 //x=1.32 //y=1.055 //x2=1.245 //y2=1.055
cc_130 ( N_GND_M0_noxref_d N_noxref_10_c_2181_n ) capacitor c=0.00255985f \
 //x=1.32 //y=1.055 //x2=1.245 //y2=1.4
cc_131 ( N_GND_c_1_p N_noxref_10_c_2182_n ) capacitor c=0.00295461f //x=1.175 \
 //y=0.18 //x2=1.245 //y2=1.71
cc_132 ( N_GND_c_1_p N_noxref_10_c_2183_n ) capacitor c=0.0134214f //x=1.175 \
 //y=0.18 //x2=1.245 //y2=2.095
cc_133 ( N_GND_M0_noxref_d N_noxref_10_c_2184_n ) capacitor c=0.0131387f \
 //x=1.32 //y=1.055 //x2=1.62 //y2=0.9
cc_134 ( N_GND_M0_noxref_d N_noxref_10_c_2185_n ) capacitor c=0.00193165f \
 //x=1.32 //y=1.055 //x2=1.62 //y2=1.555
cc_135 ( N_GND_c_9_p N_noxref_10_c_2186_n ) capacitor c=0.00129623f //x=5.075 \
 //y=0.175 //x2=1.775 //y2=1.055
cc_136 ( N_GND_M0_noxref_d N_noxref_10_c_2186_n ) capacitor c=0.00257848f \
 //x=1.32 //y=1.055 //x2=1.775 //y2=1.055
cc_137 ( N_GND_M0_noxref_d N_noxref_10_c_2188_n ) capacitor c=0.00255985f \
 //x=1.32 //y=1.055 //x2=1.775 //y2=1.4
cc_138 ( N_GND_c_6_p N_noxref_10_M10_noxref_d ) capacitor c=0.00591582f \
 //x=18.195 //y=0.175 //x2=16.78 //y2=1.095
cc_139 ( N_GND_c_2_p N_noxref_11_c_2581_n ) capacitor c=0.0468439f //x=25.965 \
 //y=0.18 //x2=25.51 //y2=1.835
cc_140 ( N_GND_c_8_p N_noxref_11_c_2582_n ) capacitor c=0.0176502f //x=25.965 \
 //y=0.18 //x2=25.595 //y2=3.88
cc_141 ( N_GND_c_7_p N_noxref_11_c_2582_n ) capacitor c=9.64732e-19 //x=23.005 \
 //y=0.175 //x2=25.595 //y2=3.88
cc_142 ( N_GND_c_2_p N_noxref_11_M15_noxref_d ) capacitor c=0.00618259f \
 //x=25.965 //y=0.18 //x2=24.965 //y2=1.085
cc_143 ( N_GND_c_7_p N_noxref_11_M15_noxref_d ) capacitor c=8.58106e-19 \
 //x=23.005 //y=0.175 //x2=24.965 //y2=1.085
cc_144 ( N_GND_M14_noxref_d N_noxref_11_M15_noxref_d ) capacitor c=0.00143464f \
 //x=23.995 //y=1.045 //x2=24.965 //y2=1.085
cc_145 ( N_GND_c_8_p N_noxref_12_c_2667_n ) capacitor c=0.00618966f //x=25.965 \
 //y=0.18 //x2=1.91 //y2=1.77
cc_146 ( N_GND_c_128_p N_noxref_12_c_2667_n ) capacitor c=0.00110148f \
 //x=1.425 //y=0.175 //x2=1.91 //y2=1.77
cc_147 ( N_GND_c_9_p N_noxref_12_c_2667_n ) capacitor c=0.0017942f //x=5.075 \
 //y=0.175 //x2=1.91 //y2=1.77
cc_148 ( N_GND_M0_noxref_d N_noxref_12_c_2667_n ) capacitor c=0.0089491f \
 //x=1.32 //y=1.055 //x2=1.91 //y2=1.77
cc_149 ( N_GND_c_8_p N_noxref_12_c_2671_n ) capacitor c=0.00576803f //x=25.965 \
 //y=0.18 //x2=1.995 //y2=0.805
cc_150 ( N_GND_c_9_p N_noxref_12_c_2671_n ) capacitor c=0.0140604f //x=5.075 \
 //y=0.175 //x2=1.995 //y2=0.805
cc_151 ( N_GND_M0_noxref_d N_noxref_12_c_2671_n ) capacitor c=0.033954f \
 //x=1.32 //y=1.055 //x2=1.995 //y2=0.805
cc_152 ( N_GND_c_8_p N_noxref_12_c_2674_n ) capacitor c=0.0139064f //x=25.965 \
 //y=0.18 //x2=2.88 //y2=0.72
cc_153 ( N_GND_c_9_p N_noxref_12_c_2674_n ) capacitor c=0.0356451f //x=5.075 \
 //y=0.175 //x2=2.88 //y2=0.72
cc_154 ( N_GND_c_2_p N_noxref_12_c_2674_n ) capacitor c=0.00177266f //x=25.965 \
 //y=0.18 //x2=2.88 //y2=0.72
cc_155 ( N_GND_c_8_p N_noxref_12_M0_noxref_s ) capacitor c=0.012556f \
 //x=25.965 //y=0.18 //x2=0.89 //y2=0.555
cc_156 ( N_GND_c_128_p N_noxref_12_M0_noxref_s ) capacitor c=0.0140604f \
 //x=1.425 //y=0.175 //x2=0.89 //y2=0.555
cc_157 ( N_GND_c_1_p N_noxref_12_M0_noxref_s ) capacitor c=0.0712607f \
 //x=1.175 //y=0.18 //x2=0.89 //y2=0.555
cc_158 ( N_GND_c_9_p N_noxref_12_M0_noxref_s ) capacitor c=0.0131642f \
 //x=5.075 //y=0.175 //x2=0.89 //y2=0.555
cc_159 ( N_GND_c_3_p N_noxref_12_M0_noxref_s ) capacitor c=3.31601e-19 \
 //x=5.245 //y=0.175 //x2=0.89 //y2=0.555
cc_160 ( N_GND_M0_noxref_d N_noxref_12_M0_noxref_s ) capacitor c=0.033718f \
 //x=1.32 //y=1.055 //x2=0.89 //y2=0.555
cc_161 ( N_GND_c_8_p N_noxref_13_c_2715_n ) capacitor c=0.00403022f //x=25.965 \
 //y=0.18 //x2=3.45 //y2=1.175
cc_162 ( N_GND_c_9_p N_noxref_13_c_2715_n ) capacitor c=0.00830851f //x=5.075 \
 //y=0.175 //x2=3.45 //y2=1.175
cc_163 ( N_GND_c_8_p N_noxref_13_c_2717_n ) capacitor c=0.00576803f //x=25.965 \
 //y=0.18 //x2=3.535 //y2=0.805
cc_164 ( N_GND_c_9_p N_noxref_13_c_2717_n ) capacitor c=0.0140604f //x=5.075 \
 //y=0.175 //x2=3.535 //y2=0.805
cc_165 ( N_GND_M0_noxref_d N_noxref_13_c_2717_n ) capacitor c=6.21394e-19 \
 //x=1.32 //y=1.055 //x2=3.535 //y2=0.805
cc_166 ( N_GND_c_8_p N_noxref_13_c_2720_n ) capacitor c=0.0118394f //x=25.965 \
 //y=0.18 //x2=4.42 //y2=0.72
cc_167 ( N_GND_c_9_p N_noxref_13_c_2720_n ) capacitor c=0.0365819f //x=5.075 \
 //y=0.175 //x2=4.42 //y2=0.72
cc_168 ( N_GND_c_2_p N_noxref_13_c_2720_n ) capacitor c=0.00189358f //x=25.965 \
 //y=0.18 //x2=4.42 //y2=0.72
cc_169 ( N_GND_c_8_p N_noxref_13_c_2723_n ) capacitor c=0.00287576f //x=25.965 \
 //y=0.18 //x2=4.505 //y2=0.805
cc_170 ( N_GND_c_9_p N_noxref_13_c_2723_n ) capacitor c=0.0142854f //x=5.075 \
 //y=0.175 //x2=4.505 //y2=0.805
cc_171 ( N_GND_c_3_p N_noxref_13_c_2723_n ) capacitor c=0.0404137f //x=5.245 \
 //y=0.175 //x2=4.505 //y2=0.805
cc_172 ( N_GND_M0_noxref_d N_noxref_13_M1_noxref_d ) capacitor c=0.00162435f \
 //x=1.32 //y=1.055 //x2=2.295 //y2=1.09
cc_173 ( N_GND_c_1_p N_noxref_13_M2_noxref_s ) capacitor c=8.16352e-19 \
 //x=1.175 //y=0.18 //x2=3.4 //y2=0.555
cc_174 ( N_GND_c_3_p N_noxref_13_M2_noxref_s ) capacitor c=0.00183204f \
 //x=5.245 //y=0.175 //x2=3.4 //y2=0.555
cc_175 ( N_GND_c_3_p N_D_c_2768_n ) capacitor c=8.55471e-19 //x=5.245 \
 //y=0.175 //x2=7.465 //y2=2.26
cc_176 ( N_GND_c_8_p N_noxref_15_c_2857_n ) capacitor c=0.00551257f //x=25.965 \
 //y=0.18 //x2=6.72 //y2=1.77
cc_177 ( N_GND_c_10_p N_noxref_15_c_2857_n ) capacitor c=0.00111699f //x=6.235 \
 //y=0.175 //x2=6.72 //y2=1.77
cc_178 ( N_GND_c_58_p N_noxref_15_c_2857_n ) capacitor c=0.00180972f //x=9.885 \
 //y=0.175 //x2=6.72 //y2=1.77
cc_179 ( N_GND_M3_noxref_d N_noxref_15_c_2857_n ) capacitor c=0.0088767f \
 //x=6.13 //y=1.055 //x2=6.72 //y2=1.77
cc_180 ( N_GND_c_8_p N_noxref_15_c_2861_n ) capacitor c=0.00287676f //x=25.965 \
 //y=0.18 //x2=6.805 //y2=0.805
cc_181 ( N_GND_c_58_p N_noxref_15_c_2861_n ) capacitor c=0.0143483f //x=9.885 \
 //y=0.175 //x2=6.805 //y2=0.805
cc_182 ( N_GND_M3_noxref_d N_noxref_15_c_2861_n ) capacitor c=0.033954f \
 //x=6.13 //y=1.055 //x2=6.805 //y2=0.805
cc_183 ( N_GND_c_8_p N_noxref_15_c_2864_n ) capacitor c=0.0117699f //x=25.965 \
 //y=0.18 //x2=7.69 //y2=0.72
cc_184 ( N_GND_c_58_p N_noxref_15_c_2864_n ) capacitor c=0.0362407f //x=9.885 \
 //y=0.175 //x2=7.69 //y2=0.72
cc_185 ( N_GND_c_2_p N_noxref_15_c_2864_n ) capacitor c=0.00177266f //x=25.965 \
 //y=0.18 //x2=7.69 //y2=0.72
cc_186 ( N_GND_c_8_p N_noxref_15_M3_noxref_s ) capacitor c=0.00575129f \
 //x=25.965 //y=0.18 //x2=5.7 //y2=0.555
cc_187 ( N_GND_c_10_p N_noxref_15_M3_noxref_s ) capacitor c=0.0143483f \
 //x=6.235 //y=0.175 //x2=5.7 //y2=0.555
cc_188 ( N_GND_c_58_p N_noxref_15_M3_noxref_s ) capacitor c=0.0133967f \
 //x=9.885 //y=0.175 //x2=5.7 //y2=0.555
cc_189 ( N_GND_c_3_p N_noxref_15_M3_noxref_s ) capacitor c=0.0696963f \
 //x=5.245 //y=0.175 //x2=5.7 //y2=0.555
cc_190 ( N_GND_c_4_p N_noxref_15_M3_noxref_s ) capacitor c=3.31601e-19 \
 //x=10.055 //y=0.175 //x2=5.7 //y2=0.555
cc_191 ( N_GND_M3_noxref_d N_noxref_15_M3_noxref_s ) capacitor c=0.033718f \
 //x=6.13 //y=1.055 //x2=5.7 //y2=0.555
cc_192 ( N_GND_c_8_p N_noxref_16_c_2908_n ) capacitor c=0.00385483f //x=25.965 \
 //y=0.18 //x2=8.26 //y2=1.175
cc_193 ( N_GND_c_58_p N_noxref_16_c_2908_n ) capacitor c=0.00949615f //x=9.885 \
 //y=0.175 //x2=8.26 //y2=1.175
cc_194 ( N_GND_c_8_p N_noxref_16_c_2910_n ) capacitor c=0.00287676f //x=25.965 \
 //y=0.18 //x2=8.345 //y2=0.805
cc_195 ( N_GND_c_58_p N_noxref_16_c_2910_n ) capacitor c=0.0143483f //x=9.885 \
 //y=0.175 //x2=8.345 //y2=0.805
cc_196 ( N_GND_M3_noxref_d N_noxref_16_c_2910_n ) capacitor c=6.21394e-19 \
 //x=6.13 //y=1.055 //x2=8.345 //y2=0.805
cc_197 ( N_GND_c_8_p N_noxref_16_c_2913_n ) capacitor c=0.0105236f //x=25.965 \
 //y=0.18 //x2=9.23 //y2=0.72
cc_198 ( N_GND_c_58_p N_noxref_16_c_2913_n ) capacitor c=0.0363935f //x=9.885 \
 //y=0.175 //x2=9.23 //y2=0.72
cc_199 ( N_GND_c_2_p N_noxref_16_c_2913_n ) capacitor c=0.00189358f //x=25.965 \
 //y=0.18 //x2=9.23 //y2=0.72
cc_200 ( N_GND_c_8_p N_noxref_16_c_2916_n ) capacitor c=0.00254308f //x=25.965 \
 //y=0.18 //x2=9.315 //y2=0.805
cc_201 ( N_GND_c_58_p N_noxref_16_c_2916_n ) capacitor c=0.0140503f //x=9.885 \
 //y=0.175 //x2=9.315 //y2=0.805
cc_202 ( N_GND_c_4_p N_noxref_16_c_2916_n ) capacitor c=0.0404137f //x=10.055 \
 //y=0.175 //x2=9.315 //y2=0.805
cc_203 ( N_GND_M3_noxref_d N_noxref_16_M4_noxref_d ) capacitor c=0.00162435f \
 //x=6.13 //y=1.055 //x2=7.105 //y2=1.09
cc_204 ( N_GND_c_3_p N_noxref_16_M5_noxref_s ) capacitor c=8.16352e-19 \
 //x=5.245 //y=0.175 //x2=8.21 //y2=0.555
cc_205 ( N_GND_c_4_p N_noxref_16_M5_noxref_s ) capacitor c=0.00183576f \
 //x=10.055 //y=0.175 //x2=8.21 //y2=0.555
cc_206 ( N_GND_c_8_p N_noxref_17_c_2962_n ) capacitor c=0.00517479f //x=25.965 \
 //y=0.18 //x2=11.635 //y2=1.76
cc_207 ( N_GND_c_17_p N_noxref_17_c_2962_n ) capacitor c=0.00112996f //x=11.15 \
 //y=0.175 //x2=11.635 //y2=1.76
cc_208 ( N_GND_c_24_p N_noxref_17_c_2962_n ) capacitor c=0.00182524f \
 //x=13.215 //y=0.175 //x2=11.635 //y2=1.76
cc_209 ( N_GND_M6_noxref_d N_noxref_17_c_2962_n ) capacitor c=0.00862619f \
 //x=11.045 //y=1.045 //x2=11.635 //y2=1.76
cc_210 ( N_GND_c_8_p N_noxref_17_c_2966_n ) capacitor c=0.00259097f //x=25.965 \
 //y=0.18 //x2=11.72 //y2=0.795
cc_211 ( N_GND_c_24_p N_noxref_17_c_2966_n ) capacitor c=0.0147125f //x=13.215 \
 //y=0.175 //x2=11.72 //y2=0.795
cc_212 ( N_GND_M6_noxref_d N_noxref_17_c_2966_n ) capacitor c=0.033812f \
 //x=11.045 //y=1.045 //x2=11.72 //y2=0.795
cc_213 ( N_GND_c_4_p N_noxref_17_c_2969_n ) capacitor c=2.91423e-19 //x=10.055 \
 //y=0.175 //x2=11.72 //y2=1.675
cc_214 ( N_GND_c_8_p N_noxref_17_c_2970_n ) capacitor c=0.0106959f //x=25.965 \
 //y=0.18 //x2=12.605 //y2=0.71
cc_215 ( N_GND_c_24_p N_noxref_17_c_2970_n ) capacitor c=0.0374662f //x=13.215 \
 //y=0.175 //x2=12.605 //y2=0.71
cc_216 ( N_GND_c_2_p N_noxref_17_c_2970_n ) capacitor c=0.00198372f //x=25.965 \
 //y=0.18 //x2=12.605 //y2=0.71
cc_217 ( N_GND_c_8_p N_noxref_17_c_2973_n ) capacitor c=0.00258902f //x=25.965 \
 //y=0.18 //x2=12.69 //y2=0.795
cc_218 ( N_GND_c_24_p N_noxref_17_c_2973_n ) capacitor c=0.0146462f //x=13.215 \
 //y=0.175 //x2=12.69 //y2=0.795
cc_219 ( N_GND_c_5_p N_noxref_17_c_2973_n ) capacitor c=0.0431718f //x=13.385 \
 //y=0.175 //x2=12.69 //y2=0.795
cc_220 ( N_GND_c_8_p N_noxref_17_M6_noxref_s ) capacitor c=0.00259097f \
 //x=25.965 //y=0.18 //x2=10.615 //y2=0.545
cc_221 ( N_GND_c_17_p N_noxref_17_M6_noxref_s ) capacitor c=0.0147125f \
 //x=11.15 //y=0.175 //x2=10.615 //y2=0.545
cc_222 ( N_GND_c_4_p N_noxref_17_M6_noxref_s ) capacitor c=0.0583534f \
 //x=10.055 //y=0.175 //x2=10.615 //y2=0.545
cc_223 ( N_GND_c_5_p N_noxref_17_M6_noxref_s ) capacitor c=0.00198098f \
 //x=13.385 //y=0.175 //x2=10.615 //y2=0.545
cc_224 ( N_GND_M6_noxref_d N_noxref_17_M6_noxref_s ) capacitor c=0.0334197f \
 //x=11.045 //y=1.045 //x2=10.615 //y2=0.545
cc_225 ( N_GND_c_8_p N_noxref_18_c_3014_n ) capacitor c=0.00517803f //x=25.965 \
 //y=0.18 //x2=14.86 //y2=1.77
cc_226 ( N_GND_c_32_p N_noxref_18_c_3014_n ) capacitor c=0.00111572f \
 //x=14.375 //y=0.175 //x2=14.86 //y2=1.77
cc_227 ( N_GND_c_39_p N_noxref_18_c_3014_n ) capacitor c=0.00180844f \
 //x=18.025 //y=0.175 //x2=14.86 //y2=1.77
cc_228 ( N_GND_M8_noxref_d N_noxref_18_c_3014_n ) capacitor c=0.00853195f \
 //x=14.27 //y=1.055 //x2=14.86 //y2=1.77
cc_229 ( N_GND_c_8_p N_noxref_18_c_3018_n ) capacitor c=0.00254564f //x=25.965 \
 //y=0.18 //x2=14.945 //y2=0.805
cc_230 ( N_GND_c_39_p N_noxref_18_c_3018_n ) capacitor c=0.0141145f //x=18.025 \
 //y=0.175 //x2=14.945 //y2=0.805
cc_231 ( N_GND_M8_noxref_d N_noxref_18_c_3018_n ) capacitor c=0.033954f \
 //x=14.27 //y=1.055 //x2=14.945 //y2=0.805
cc_232 ( N_GND_c_8_p N_noxref_18_c_3021_n ) capacitor c=0.0104527f //x=25.965 \
 //y=0.18 //x2=15.83 //y2=0.72
cc_233 ( N_GND_c_39_p N_noxref_18_c_3021_n ) capacitor c=0.0361062f //x=18.025 \
 //y=0.175 //x2=15.83 //y2=0.72
cc_234 ( N_GND_c_2_p N_noxref_18_c_3021_n ) capacitor c=0.00177266f //x=25.965 \
 //y=0.18 //x2=15.83 //y2=0.72
cc_235 ( N_GND_c_8_p N_noxref_18_M8_noxref_s ) capacitor c=0.00507768f \
 //x=25.965 //y=0.18 //x2=13.84 //y2=0.555
cc_236 ( N_GND_c_32_p N_noxref_18_M8_noxref_s ) capacitor c=0.0141145f \
 //x=14.375 //y=0.175 //x2=13.84 //y2=0.555
cc_237 ( N_GND_c_39_p N_noxref_18_M8_noxref_s ) capacitor c=0.0131542f \
 //x=18.025 //y=0.175 //x2=13.84 //y2=0.555
cc_238 ( N_GND_c_5_p N_noxref_18_M8_noxref_s ) capacitor c=0.0696963f \
 //x=13.385 //y=0.175 //x2=13.84 //y2=0.555
cc_239 ( N_GND_c_6_p N_noxref_18_M8_noxref_s ) capacitor c=3.31601e-19 \
 //x=18.195 //y=0.175 //x2=13.84 //y2=0.555
cc_240 ( N_GND_M8_noxref_d N_noxref_18_M8_noxref_s ) capacitor c=0.033718f \
 //x=14.27 //y=1.055 //x2=13.84 //y2=0.555
cc_241 ( N_GND_c_8_p N_noxref_19_c_3065_n ) capacitor c=0.00353223f //x=25.965 \
 //y=0.18 //x2=16.4 //y2=1.175
cc_242 ( N_GND_c_39_p N_noxref_19_c_3065_n ) capacitor c=0.00935019f \
 //x=18.025 //y=0.175 //x2=16.4 //y2=1.175
cc_243 ( N_GND_c_8_p N_noxref_19_c_3067_n ) capacitor c=0.00254564f //x=25.965 \
 //y=0.18 //x2=16.485 //y2=0.805
cc_244 ( N_GND_c_39_p N_noxref_19_c_3067_n ) capacitor c=0.0141145f //x=18.025 \
 //y=0.175 //x2=16.485 //y2=0.805
cc_245 ( N_GND_M8_noxref_d N_noxref_19_c_3067_n ) capacitor c=6.21394e-19 \
 //x=14.27 //y=1.055 //x2=16.485 //y2=0.805
cc_246 ( N_GND_c_8_p N_noxref_19_c_3070_n ) capacitor c=0.0105236f //x=25.965 \
 //y=0.18 //x2=17.37 //y2=0.72
cc_247 ( N_GND_c_39_p N_noxref_19_c_3070_n ) capacitor c=0.0364401f //x=18.025 \
 //y=0.175 //x2=17.37 //y2=0.72
cc_248 ( N_GND_c_2_p N_noxref_19_c_3070_n ) capacitor c=0.00189358f //x=25.965 \
 //y=0.18 //x2=17.37 //y2=0.72
cc_249 ( N_GND_c_8_p N_noxref_19_c_3073_n ) capacitor c=0.00254308f //x=25.965 \
 //y=0.18 //x2=17.455 //y2=0.805
cc_250 ( N_GND_c_39_p N_noxref_19_c_3073_n ) capacitor c=0.0140503f //x=18.025 \
 //y=0.175 //x2=17.455 //y2=0.805
cc_251 ( N_GND_c_6_p N_noxref_19_c_3073_n ) capacitor c=0.0404137f //x=18.195 \
 //y=0.175 //x2=17.455 //y2=0.805
cc_252 ( N_GND_M8_noxref_d N_noxref_19_M9_noxref_d ) capacitor c=0.00162435f \
 //x=14.27 //y=1.055 //x2=15.245 //y2=1.09
cc_253 ( N_GND_c_5_p N_noxref_19_M10_noxref_s ) capacitor c=8.16352e-19 \
 //x=13.385 //y=0.175 //x2=16.35 //y2=0.555
cc_254 ( N_GND_c_6_p N_noxref_19_M10_noxref_s ) capacitor c=0.00183204f \
 //x=18.195 //y=0.175 //x2=16.35 //y2=0.555
cc_255 ( N_GND_c_8_p N_noxref_20_c_3119_n ) capacitor c=0.00517803f //x=25.965 \
 //y=0.18 //x2=19.67 //y2=1.77
cc_256 ( N_GND_c_61_p N_noxref_20_c_3119_n ) capacitor c=0.00111572f \
 //x=19.185 //y=0.175 //x2=19.67 //y2=1.77
cc_257 ( N_GND_c_68_p N_noxref_20_c_3119_n ) capacitor c=0.00180844f \
 //x=22.835 //y=0.175 //x2=19.67 //y2=1.77
cc_258 ( N_GND_M11_noxref_d N_noxref_20_c_3119_n ) capacitor c=0.00853195f \
 //x=19.08 //y=1.055 //x2=19.67 //y2=1.77
cc_259 ( N_GND_c_8_p N_noxref_20_c_3123_n ) capacitor c=0.00254564f //x=25.965 \
 //y=0.18 //x2=19.755 //y2=0.805
cc_260 ( N_GND_c_68_p N_noxref_20_c_3123_n ) capacitor c=0.0141145f //x=22.835 \
 //y=0.175 //x2=19.755 //y2=0.805
cc_261 ( N_GND_M11_noxref_d N_noxref_20_c_3123_n ) capacitor c=0.033954f \
 //x=19.08 //y=1.055 //x2=19.755 //y2=0.805
cc_262 ( N_GND_c_8_p N_noxref_20_c_3126_n ) capacitor c=0.0113382f //x=25.965 \
 //y=0.18 //x2=20.64 //y2=0.72
cc_263 ( N_GND_c_68_p N_noxref_20_c_3126_n ) capacitor c=0.0358849f //x=22.835 \
 //y=0.175 //x2=20.64 //y2=0.72
cc_264 ( N_GND_c_2_p N_noxref_20_c_3126_n ) capacitor c=0.00177266f //x=25.965 \
 //y=0.18 //x2=20.64 //y2=0.72
cc_265 ( N_GND_c_8_p N_noxref_20_M11_noxref_s ) capacitor c=0.00799255f \
 //x=25.965 //y=0.18 //x2=18.65 //y2=0.555
cc_266 ( N_GND_c_61_p N_noxref_20_M11_noxref_s ) capacitor c=0.0141145f \
 //x=19.185 //y=0.175 //x2=18.65 //y2=0.555
cc_267 ( N_GND_c_68_p N_noxref_20_M11_noxref_s ) capacitor c=0.0131642f \
 //x=22.835 //y=0.175 //x2=18.65 //y2=0.555
cc_268 ( N_GND_c_6_p N_noxref_20_M11_noxref_s ) capacitor c=0.0696963f \
 //x=18.195 //y=0.175 //x2=18.65 //y2=0.555
cc_269 ( N_GND_c_7_p N_noxref_20_M11_noxref_s ) capacitor c=3.31601e-19 \
 //x=23.005 //y=0.175 //x2=18.65 //y2=0.555
cc_270 ( N_GND_M11_noxref_d N_noxref_20_M11_noxref_s ) capacitor c=0.033718f \
 //x=19.08 //y=1.055 //x2=18.65 //y2=0.555
cc_271 ( N_GND_c_8_p N_noxref_21_c_3171_n ) capacitor c=0.00403022f //x=25.965 \
 //y=0.18 //x2=21.21 //y2=1.175
cc_272 ( N_GND_c_68_p N_noxref_21_c_3171_n ) capacitor c=0.00830851f \
 //x=22.835 //y=0.175 //x2=21.21 //y2=1.175
cc_273 ( N_GND_c_8_p N_noxref_21_c_3173_n ) capacitor c=0.00576803f //x=25.965 \
 //y=0.18 //x2=21.295 //y2=0.805
cc_274 ( N_GND_c_68_p N_noxref_21_c_3173_n ) capacitor c=0.0140604f //x=22.835 \
 //y=0.175 //x2=21.295 //y2=0.805
cc_275 ( N_GND_M11_noxref_d N_noxref_21_c_3173_n ) capacitor c=6.21394e-19 \
 //x=19.08 //y=1.055 //x2=21.295 //y2=0.805
cc_276 ( N_GND_c_8_p N_noxref_21_c_3176_n ) capacitor c=0.0122047f //x=25.965 \
 //y=0.18 //x2=22.18 //y2=0.72
cc_277 ( N_GND_c_68_p N_noxref_21_c_3176_n ) capacitor c=0.0363189f //x=22.835 \
 //y=0.175 //x2=22.18 //y2=0.72
cc_278 ( N_GND_c_2_p N_noxref_21_c_3176_n ) capacitor c=0.00189358f //x=25.965 \
 //y=0.18 //x2=22.18 //y2=0.72
cc_279 ( N_GND_c_8_p N_noxref_21_c_3179_n ) capacitor c=0.00286787f //x=25.965 \
 //y=0.18 //x2=22.265 //y2=0.805
cc_280 ( N_GND_c_68_p N_noxref_21_c_3179_n ) capacitor c=0.0142801f //x=22.835 \
 //y=0.175 //x2=22.265 //y2=0.805
cc_281 ( N_GND_c_7_p N_noxref_21_c_3179_n ) capacitor c=0.0404137f //x=23.005 \
 //y=0.175 //x2=22.265 //y2=0.805
cc_282 ( N_GND_M11_noxref_d N_noxref_21_M12_noxref_d ) capacitor c=0.00162435f \
 //x=19.08 //y=1.055 //x2=20.055 //y2=1.09
cc_283 ( N_GND_c_6_p N_noxref_21_M13_noxref_s ) capacitor c=8.16352e-19 \
 //x=18.195 //y=0.175 //x2=21.16 //y2=0.555
cc_284 ( N_GND_c_7_p N_noxref_21_M13_noxref_s ) capacitor c=0.00183576f \
 //x=23.005 //y=0.175 //x2=21.16 //y2=0.555
cc_285 ( N_GND_c_8_p N_noxref_22_c_3224_n ) capacitor c=0.00550345f //x=25.965 \
 //y=0.18 //x2=24.585 //y2=1.76
cc_286 ( N_GND_c_102_p N_noxref_22_c_3224_n ) capacitor c=0.00113126f //x=24.1 \
 //y=0.175 //x2=24.585 //y2=1.76
cc_287 ( N_GND_c_2_p N_noxref_22_c_3224_n ) capacitor c=0.00181083f //x=25.965 \
 //y=0.18 //x2=24.585 //y2=1.76
cc_288 ( N_GND_M14_noxref_d N_noxref_22_c_3224_n ) capacitor c=0.00878836f \
 //x=23.995 //y=1.045 //x2=24.585 //y2=1.76
cc_289 ( N_GND_c_8_p N_noxref_22_c_3228_n ) capacitor c=0.00302993f //x=25.965 \
 //y=0.18 //x2=24.67 //y2=0.795
cc_290 ( N_GND_c_2_p N_noxref_22_c_3228_n ) capacitor c=0.014661f //x=25.965 \
 //y=0.18 //x2=24.67 //y2=0.795
cc_291 ( N_GND_M14_noxref_d N_noxref_22_c_3228_n ) capacitor c=0.033812f \
 //x=23.995 //y=1.045 //x2=24.67 //y2=0.795
cc_292 ( N_GND_c_7_p N_noxref_22_c_3231_n ) capacitor c=2.91423e-19 //x=23.005 \
 //y=0.175 //x2=24.67 //y2=1.675
cc_293 ( N_GND_c_8_p N_noxref_22_c_3232_n ) capacitor c=0.0124224f //x=25.965 \
 //y=0.18 //x2=25.555 //y2=0.71
cc_294 ( N_GND_c_2_p N_noxref_22_c_3232_n ) capacitor c=0.0391339f //x=25.965 \
 //y=0.18 //x2=25.555 //y2=0.71
cc_295 ( N_GND_c_8_p N_noxref_22_c_3234_n ) capacitor c=0.00302312f //x=25.965 \
 //y=0.18 //x2=25.64 //y2=0.795
cc_296 ( N_GND_c_2_p N_noxref_22_c_3234_n ) capacitor c=0.058445f //x=25.965 \
 //y=0.18 //x2=25.64 //y2=0.795
cc_297 ( N_GND_c_8_p N_noxref_22_M14_noxref_s ) capacitor c=0.00293362f \
 //x=25.965 //y=0.18 //x2=23.565 //y2=0.545
cc_298 ( N_GND_c_102_p N_noxref_22_M14_noxref_s ) capacitor c=0.0149577f \
 //x=24.1 //y=0.175 //x2=23.565 //y2=0.545
cc_299 ( N_GND_c_2_p N_noxref_22_M14_noxref_s ) capacitor c=0.00198482f \
 //x=25.965 //y=0.18 //x2=23.565 //y2=0.545
cc_300 ( N_GND_c_7_p N_noxref_22_M14_noxref_s ) capacitor c=0.0583534f \
 //x=23.005 //y=0.175 //x2=23.565 //y2=0.545
cc_301 ( N_GND_M14_noxref_d N_noxref_22_M14_noxref_s ) capacitor c=0.0334197f \
 //x=23.995 //y=1.045 //x2=23.565 //y2=0.545
cc_302 ( N_VDD_c_304_n N_noxref_3_c_639_n ) capacitor c=6.58823e-19 //x=5.245 \
 //y=7.585 //x2=3.765 //y2=2.26
cc_303 ( N_VDD_c_310_p N_noxref_3_c_654_n ) capacitor c=0.00444939f //x=25.965 \
 //y=7.58 //x2=7.57 //y2=5.335
cc_304 ( N_VDD_c_311_p N_noxref_3_c_654_n ) capacitor c=4.32416e-19 //x=7.13 \
 //y=7.585 //x2=7.57 //y2=5.335
cc_305 ( N_VDD_c_312_p N_noxref_3_c_654_n ) capacitor c=4.32416e-19 //x=8.01 \
 //y=7.585 //x2=7.57 //y2=5.335
cc_306 ( N_VDD_M23_noxref_d N_noxref_3_c_654_n ) capacitor c=0.0112992f \
 //x=7.07 //y=5.2 //x2=7.57 //y2=5.335
cc_307 ( N_VDD_c_304_n N_noxref_3_c_658_n ) capacitor c=0.00863585f //x=5.245 \
 //y=7.585 //x2=6.86 //y2=5.335
cc_308 ( N_VDD_M22_noxref_s N_noxref_3_c_658_n ) capacitor c=0.0831083f \
 //x=6.2 //y=5.2 //x2=6.86 //y2=5.335
cc_309 ( N_VDD_c_310_p N_noxref_3_c_660_n ) capacitor c=0.00442256f //x=25.965 \
 //y=7.58 //x2=8.45 //y2=5.335
cc_310 ( N_VDD_c_312_p N_noxref_3_c_660_n ) capacitor c=4.32416e-19 //x=8.01 \
 //y=7.585 //x2=8.45 //y2=5.335
cc_311 ( N_VDD_c_318_p N_noxref_3_c_660_n ) capacitor c=4.32416e-19 //x=8.89 \
 //y=7.585 //x2=8.45 //y2=5.335
cc_312 ( N_VDD_M25_noxref_d N_noxref_3_c_660_n ) capacitor c=0.0112992f \
 //x=7.95 //y=5.2 //x2=8.45 //y2=5.335
cc_313 ( N_VDD_c_310_p N_noxref_3_c_664_n ) capacitor c=0.00434594f //x=25.965 \
 //y=7.58 //x2=9.23 //y2=5.335
cc_314 ( N_VDD_c_318_p N_noxref_3_c_664_n ) capacitor c=7.47443e-19 //x=8.89 \
 //y=7.585 //x2=9.23 //y2=5.335
cc_315 ( N_VDD_c_322_p N_noxref_3_c_664_n ) capacitor c=0.00199034f //x=9.885 \
 //y=7.585 //x2=9.23 //y2=5.335
cc_316 ( N_VDD_M27_noxref_d N_noxref_3_c_664_n ) capacitor c=0.0112992f \
 //x=8.83 //y=5.2 //x2=9.23 //y2=5.335
cc_317 ( N_VDD_c_305_n N_noxref_3_c_668_n ) capacitor c=0.0426864f //x=10.055 \
 //y=7.585 //x2=9.315 //y2=3.51
cc_318 ( N_VDD_c_310_p N_noxref_3_c_641_n ) capacitor c=0.00125241f //x=25.965 \
 //y=7.58 //x2=11.165 //y2=2.26
cc_319 ( N_VDD_c_326_p N_noxref_3_c_641_n ) capacitor c=2.88017e-19 //x=11.64 \
 //y=7.585 //x2=11.165 //y2=2.26
cc_320 ( N_VDD_c_305_n N_noxref_3_c_641_n ) capacitor c=0.0134208f //x=10.055 \
 //y=7.585 //x2=11.165 //y2=2.26
cc_321 ( N_VDD_c_328_p N_noxref_3_M20_noxref_g ) capacitor c=0.00679791f \
 //x=4.08 //y=7.585 //x2=3.505 //y2=6.2
cc_322 ( N_VDD_M19_noxref_d N_noxref_3_M20_noxref_g ) capacitor c=0.015318f \
 //x=3.14 //y=5.2 //x2=3.505 //y2=6.2
cc_323 ( N_VDD_c_328_p N_noxref_3_M21_noxref_g ) capacitor c=0.00680002f \
 //x=4.08 //y=7.585 //x2=3.945 //y2=6.2
cc_324 ( N_VDD_M21_noxref_d N_noxref_3_M21_noxref_g ) capacitor c=0.0394719f \
 //x=4.02 //y=5.2 //x2=3.945 //y2=6.2
cc_325 ( N_VDD_c_326_p N_noxref_3_M28_noxref_g ) capacitor c=0.00732332f \
 //x=11.64 //y=7.585 //x2=11.065 //y2=6.2
cc_326 ( N_VDD_M28_noxref_s N_noxref_3_M28_noxref_g ) capacitor c=0.054195f \
 //x=10.71 //y=5.2 //x2=11.065 //y2=6.2
cc_327 ( N_VDD_c_326_p N_noxref_3_M29_noxref_g ) capacitor c=0.00677553f \
 //x=11.64 //y=7.585 //x2=11.505 //y2=6.2
cc_328 ( N_VDD_M29_noxref_d N_noxref_3_M29_noxref_g ) capacitor c=0.015318f \
 //x=11.58 //y=5.2 //x2=11.505 //y2=6.2
cc_329 ( N_VDD_c_305_n N_noxref_3_c_680_n ) capacitor c=0.0154093f //x=10.055 \
 //y=7.585 //x2=11.165 //y2=4.88
cc_330 ( N_VDD_c_310_p N_noxref_3_M22_noxref_d ) capacitor c=0.00275309f \
 //x=25.965 //y=7.58 //x2=6.63 //y2=5.2
cc_331 ( N_VDD_c_311_p N_noxref_3_M22_noxref_d ) capacitor c=0.0140577f \
 //x=7.13 //y=7.585 //x2=6.63 //y2=5.2
cc_332 ( N_VDD_M23_noxref_d N_noxref_3_M22_noxref_d ) capacitor c=0.0664752f \
 //x=7.07 //y=5.2 //x2=6.63 //y2=5.2
cc_333 ( N_VDD_c_310_p N_noxref_3_M24_noxref_d ) capacitor c=0.00275309f \
 //x=25.965 //y=7.58 //x2=7.51 //y2=5.2
cc_334 ( N_VDD_c_312_p N_noxref_3_M24_noxref_d ) capacitor c=0.0140577f \
 //x=8.01 //y=7.585 //x2=7.51 //y2=5.2
cc_335 ( N_VDD_c_305_n N_noxref_3_M24_noxref_d ) capacitor c=4.9285e-19 \
 //x=10.055 //y=7.585 //x2=7.51 //y2=5.2
cc_336 ( N_VDD_M22_noxref_s N_noxref_3_M24_noxref_d ) capacitor c=0.00130656f \
 //x=6.2 //y=5.2 //x2=7.51 //y2=5.2
cc_337 ( N_VDD_M23_noxref_d N_noxref_3_M24_noxref_d ) capacitor c=0.0664752f \
 //x=7.07 //y=5.2 //x2=7.51 //y2=5.2
cc_338 ( N_VDD_M25_noxref_d N_noxref_3_M24_noxref_d ) capacitor c=0.0664752f \
 //x=7.95 //y=5.2 //x2=7.51 //y2=5.2
cc_339 ( N_VDD_c_310_p N_noxref_3_M26_noxref_d ) capacitor c=0.00275309f \
 //x=25.965 //y=7.58 //x2=8.39 //y2=5.2
cc_340 ( N_VDD_c_318_p N_noxref_3_M26_noxref_d ) capacitor c=0.0140577f \
 //x=8.89 //y=7.585 //x2=8.39 //y2=5.2
cc_341 ( N_VDD_c_305_n N_noxref_3_M26_noxref_d ) capacitor c=0.00939849f \
 //x=10.055 //y=7.585 //x2=8.39 //y2=5.2
cc_342 ( N_VDD_M25_noxref_d N_noxref_3_M26_noxref_d ) capacitor c=0.0664752f \
 //x=7.95 //y=5.2 //x2=8.39 //y2=5.2
cc_343 ( N_VDD_M27_noxref_d N_noxref_3_M26_noxref_d ) capacitor c=0.0664752f \
 //x=8.83 //y=5.2 //x2=8.39 //y2=5.2
cc_344 ( N_VDD_M28_noxref_s N_noxref_3_M26_noxref_d ) capacitor c=4.52683e-19 \
 //x=10.71 //y=5.2 //x2=8.39 //y2=5.2
cc_345 ( N_VDD_c_310_p N_noxref_4_c_919_n ) capacitor c=0.00453712f //x=25.965 \
 //y=7.58 //x2=12.08 //y2=5.38
cc_346 ( N_VDD_c_326_p N_noxref_4_c_919_n ) capacitor c=4.48891e-19 //x=11.64 \
 //y=7.585 //x2=12.08 //y2=5.38
cc_347 ( N_VDD_c_354_p N_noxref_4_c_919_n ) capacitor c=4.48891e-19 //x=12.52 \
 //y=7.585 //x2=12.08 //y2=5.38
cc_348 ( N_VDD_M29_noxref_d N_noxref_4_c_919_n ) capacitor c=0.012455f \
 //x=11.58 //y=5.2 //x2=12.08 //y2=5.38
cc_349 ( N_VDD_c_305_n N_noxref_4_c_923_n ) capacitor c=0.00985474f //x=10.055 \
 //y=7.585 //x2=11.37 //y2=5.38
cc_350 ( N_VDD_M28_noxref_s N_noxref_4_c_923_n ) capacitor c=0.087833f \
 //x=10.71 //y=5.2 //x2=11.37 //y2=5.38
cc_351 ( N_VDD_c_310_p N_noxref_4_c_925_n ) capacitor c=0.00301812f //x=25.965 \
 //y=7.58 //x2=12.56 //y2=5.38
cc_352 ( N_VDD_c_354_p N_noxref_4_c_925_n ) capacitor c=7.72907e-19 //x=12.52 \
 //y=7.585 //x2=12.56 //y2=5.38
cc_353 ( N_VDD_M31_noxref_d N_noxref_4_c_925_n ) capacitor c=0.0158576f \
 //x=12.46 //y=5.2 //x2=12.56 //y2=5.38
cc_354 ( N_VDD_c_305_n N_noxref_4_c_904_n ) capacitor c=0.00151618f //x=10.055 \
 //y=7.585 //x2=12.645 //y2=3.51
cc_355 ( N_VDD_c_306_n N_noxref_4_c_904_n ) capacitor c=0.0428942f //x=13.385 \
 //y=7.585 //x2=12.645 //y2=3.51
cc_356 ( N_VDD_c_310_p N_noxref_4_c_905_n ) capacitor c=9.09811e-19 //x=25.965 \
 //y=7.58 //x2=14.495 //y2=2.26
cc_357 ( N_VDD_c_306_n N_noxref_4_c_905_n ) capacitor c=0.0133749f //x=13.385 \
 //y=7.585 //x2=14.495 //y2=2.26
cc_358 ( N_VDD_M32_noxref_s N_noxref_4_c_905_n ) capacitor c=0.0125365f \
 //x=14.34 //y=5.2 //x2=14.495 //y2=2.26
cc_359 ( N_VDD_c_366_p N_noxref_4_M32_noxref_g ) capacitor c=0.00755614f \
 //x=15.27 //y=7.585 //x2=14.695 //y2=6.2
cc_360 ( N_VDD_M32_noxref_s N_noxref_4_M32_noxref_g ) capacitor c=0.0477201f \
 //x=14.34 //y=5.2 //x2=14.695 //y2=6.2
cc_361 ( N_VDD_c_366_p N_noxref_4_M33_noxref_g ) capacitor c=0.00679791f \
 //x=15.27 //y=7.585 //x2=15.135 //y2=6.2
cc_362 ( N_VDD_M33_noxref_d N_noxref_4_M33_noxref_g ) capacitor c=0.015318f \
 //x=15.21 //y=5.2 //x2=15.135 //y2=6.2
cc_363 ( N_VDD_c_306_n N_noxref_4_c_937_n ) capacitor c=0.00757682f //x=13.385 \
 //y=7.585 //x2=14.77 //y2=4.97
cc_364 ( N_VDD_M32_noxref_s N_noxref_4_c_937_n ) capacitor c=0.00444941f \
 //x=14.34 //y=5.2 //x2=14.77 //y2=4.97
cc_365 ( N_VDD_c_310_p N_noxref_4_M28_noxref_d ) capacitor c=0.00275298f \
 //x=25.965 //y=7.58 //x2=11.14 //y2=5.2
cc_366 ( N_VDD_c_326_p N_noxref_4_M28_noxref_d ) capacitor c=0.0140544f \
 //x=11.64 //y=7.585 //x2=11.14 //y2=5.2
cc_367 ( N_VDD_c_306_n N_noxref_4_M28_noxref_d ) capacitor c=6.94454e-19 \
 //x=13.385 //y=7.585 //x2=11.14 //y2=5.2
cc_368 ( N_VDD_M29_noxref_d N_noxref_4_M28_noxref_d ) capacitor c=0.0664752f \
 //x=11.58 //y=5.2 //x2=11.14 //y2=5.2
cc_369 ( N_VDD_c_310_p N_noxref_4_M30_noxref_d ) capacitor c=0.00275298f \
 //x=25.965 //y=7.58 //x2=12.02 //y2=5.2
cc_370 ( N_VDD_c_354_p N_noxref_4_M30_noxref_d ) capacitor c=0.0140544f \
 //x=12.52 //y=7.585 //x2=12.02 //y2=5.2
cc_371 ( N_VDD_c_306_n N_noxref_4_M30_noxref_d ) capacitor c=0.0120541f \
 //x=13.385 //y=7.585 //x2=12.02 //y2=5.2
cc_372 ( N_VDD_M28_noxref_s N_noxref_4_M30_noxref_d ) capacitor c=0.00111971f \
 //x=10.71 //y=5.2 //x2=12.02 //y2=5.2
cc_373 ( N_VDD_M29_noxref_d N_noxref_4_M30_noxref_d ) capacitor c=0.0664752f \
 //x=11.58 //y=5.2 //x2=12.02 //y2=5.2
cc_374 ( N_VDD_M31_noxref_d N_noxref_4_M30_noxref_d ) capacitor c=0.0664752f \
 //x=12.46 //y=5.2 //x2=12.02 //y2=5.2
cc_375 ( N_VDD_M32_noxref_s N_noxref_4_M30_noxref_d ) capacitor c=3.73257e-19 \
 //x=14.34 //y=5.2 //x2=12.02 //y2=5.2
cc_376 ( N_VDD_c_310_p N_CLK_c_1053_n ) capacitor c=0.0969802f //x=25.965 \
 //y=7.58 //x2=15.49 //y2=4.62
cc_377 ( N_VDD_c_384_p N_CLK_c_1053_n ) capacitor c=0.00258661f //x=5.075 \
 //y=7.585 //x2=15.49 //y2=4.62
cc_378 ( N_VDD_c_385_p N_CLK_c_1053_n ) capacitor c=0.00329211f //x=6.25 \
 //y=7.585 //x2=15.49 //y2=4.62
cc_379 ( N_VDD_c_311_p N_CLK_c_1053_n ) capacitor c=0.00135946f //x=7.13 \
 //y=7.585 //x2=15.49 //y2=4.62
cc_380 ( N_VDD_c_322_p N_CLK_c_1053_n ) capacitor c=0.00258661f //x=9.885 \
 //y=7.585 //x2=15.49 //y2=4.62
cc_381 ( N_VDD_c_388_p N_CLK_c_1053_n ) capacitor c=0.0020986f //x=10.76 \
 //y=7.585 //x2=15.49 //y2=4.62
cc_382 ( N_VDD_c_326_p N_CLK_c_1053_n ) capacitor c=7.81825e-19 //x=11.64 \
 //y=7.585 //x2=15.49 //y2=4.62
cc_383 ( N_VDD_c_390_p N_CLK_c_1053_n ) capacitor c=0.00205644f //x=13.215 \
 //y=7.585 //x2=15.49 //y2=4.62
cc_384 ( N_VDD_c_391_p N_CLK_c_1053_n ) capacitor c=0.00329211f //x=14.39 \
 //y=7.585 //x2=15.49 //y2=4.62
cc_385 ( N_VDD_c_366_p N_CLK_c_1053_n ) capacitor c=0.00135946f //x=15.27 \
 //y=7.585 //x2=15.49 //y2=4.62
cc_386 ( N_VDD_c_304_n N_CLK_c_1053_n ) capacitor c=0.0389825f //x=5.245 \
 //y=7.585 //x2=15.49 //y2=4.62
cc_387 ( N_VDD_c_305_n N_CLK_c_1053_n ) capacitor c=0.0389825f //x=10.055 \
 //y=7.585 //x2=15.49 //y2=4.62
cc_388 ( N_VDD_c_306_n N_CLK_c_1053_n ) capacitor c=0.0389825f //x=13.385 \
 //y=7.585 //x2=15.49 //y2=4.62
cc_389 ( N_VDD_M22_noxref_s N_CLK_c_1053_n ) capacitor c=0.00179503f //x=6.2 \
 //y=5.2 //x2=15.49 //y2=4.62
cc_390 ( N_VDD_M28_noxref_s N_CLK_c_1053_n ) capacitor c=0.00541087f //x=10.71 \
 //y=5.2 //x2=15.49 //y2=4.62
cc_391 ( N_VDD_M31_noxref_d N_CLK_c_1053_n ) capacitor c=6.71664e-19 //x=12.46 \
 //y=5.2 //x2=15.49 //y2=4.62
cc_392 ( N_VDD_M32_noxref_s N_CLK_c_1053_n ) capacitor c=0.00179503f //x=14.34 \
 //y=5.2 //x2=15.49 //y2=4.62
cc_393 ( N_VDD_c_310_p N_CLK_c_1070_n ) capacitor c=0.00146219f //x=25.965 \
 //y=7.58 //x2=2.77 //y2=4.62
cc_394 ( N_VDD_c_310_p N_CLK_c_1071_n ) capacitor c=2.03193e-19 //x=25.965 \
 //y=7.58 //x2=2.655 //y2=4.88
cc_395 ( N_VDD_c_310_p N_CLK_c_1072_n ) capacitor c=2.03193e-19 //x=25.965 \
 //y=7.58 //x2=15.605 //y2=4.88
cc_396 ( N_VDD_c_302_n N_CLK_c_1073_n ) capacitor c=9.53425e-19 //x=1.175 \
 //y=7.58 //x2=2.682 //y2=4.535
cc_397 ( N_VDD_c_306_n N_CLK_c_1074_n ) capacitor c=6.15921e-19 //x=13.385 \
 //y=7.585 //x2=15.632 //y2=4.535
cc_398 ( N_VDD_c_405_p N_CLK_M18_noxref_g ) capacitor c=0.00680845f //x=3.2 \
 //y=7.585 //x2=2.625 //y2=6.2
cc_399 ( N_VDD_M17_noxref_d N_CLK_M18_noxref_g ) capacitor c=0.015318f \
 //x=2.26 //y=5.2 //x2=2.625 //y2=6.2
cc_400 ( N_VDD_c_405_p N_CLK_M19_noxref_g ) capacitor c=0.00679791f //x=3.2 \
 //y=7.585 //x2=3.065 //y2=6.2
cc_401 ( N_VDD_M19_noxref_d N_CLK_M19_noxref_g ) capacitor c=0.015318f \
 //x=3.14 //y=5.2 //x2=3.065 //y2=6.2
cc_402 ( N_VDD_c_409_p N_CLK_M34_noxref_g ) capacitor c=0.00680845f //x=16.15 \
 //y=7.585 //x2=15.575 //y2=6.2
cc_403 ( N_VDD_M33_noxref_d N_CLK_M34_noxref_g ) capacitor c=0.015318f \
 //x=15.21 //y=5.2 //x2=15.575 //y2=6.2
cc_404 ( N_VDD_c_409_p N_CLK_M35_noxref_g ) capacitor c=0.00679791f //x=16.15 \
 //y=7.585 //x2=16.015 //y2=6.2
cc_405 ( N_VDD_M35_noxref_d N_CLK_M35_noxref_g ) capacitor c=0.015318f \
 //x=16.09 //y=5.2 //x2=16.015 //y2=6.2
cc_406 ( N_VDD_c_310_p N_noxref_6_c_1330_n ) capacitor c=0.00449361f \
 //x=25.965 //y=7.58 //x2=2.76 //y2=5.335
cc_407 ( N_VDD_c_414_p N_noxref_6_c_1330_n ) capacitor c=4.32713e-19 //x=2.32 \
 //y=7.585 //x2=2.76 //y2=5.335
cc_408 ( N_VDD_c_405_p N_noxref_6_c_1330_n ) capacitor c=4.3239e-19 //x=3.2 \
 //y=7.585 //x2=2.76 //y2=5.335
cc_409 ( N_VDD_M17_noxref_d N_noxref_6_c_1330_n ) capacitor c=0.0115154f \
 //x=2.26 //y=5.2 //x2=2.76 //y2=5.335
cc_410 ( N_VDD_c_302_n N_noxref_6_c_1334_n ) capacitor c=0.00880189f //x=1.175 \
 //y=7.58 //x2=2.05 //y2=5.335
cc_411 ( N_VDD_M16_noxref_s N_noxref_6_c_1334_n ) capacitor c=0.0831083f \
 //x=1.39 //y=5.2 //x2=2.05 //y2=5.335
cc_412 ( N_VDD_c_310_p N_noxref_6_c_1336_n ) capacitor c=0.00442256f \
 //x=25.965 //y=7.58 //x2=3.64 //y2=5.335
cc_413 ( N_VDD_c_405_p N_noxref_6_c_1336_n ) capacitor c=4.32416e-19 //x=3.2 \
 //y=7.585 //x2=3.64 //y2=5.335
cc_414 ( N_VDD_c_328_p N_noxref_6_c_1336_n ) capacitor c=4.32416e-19 //x=4.08 \
 //y=7.585 //x2=3.64 //y2=5.335
cc_415 ( N_VDD_M19_noxref_d N_noxref_6_c_1336_n ) capacitor c=0.0112992f \
 //x=3.14 //y=5.2 //x2=3.64 //y2=5.335
cc_416 ( N_VDD_c_310_p N_noxref_6_c_1340_n ) capacitor c=0.00434594f \
 //x=25.965 //y=7.58 //x2=4.42 //y2=5.335
cc_417 ( N_VDD_c_328_p N_noxref_6_c_1340_n ) capacitor c=7.47443e-19 //x=4.08 \
 //y=7.585 //x2=4.42 //y2=5.335
cc_418 ( N_VDD_c_384_p N_noxref_6_c_1340_n ) capacitor c=0.00199034f //x=5.075 \
 //y=7.585 //x2=4.42 //y2=5.335
cc_419 ( N_VDD_M21_noxref_d N_noxref_6_c_1340_n ) capacitor c=0.0112992f \
 //x=4.02 //y=5.2 //x2=4.42 //y2=5.335
cc_420 ( N_VDD_c_304_n N_noxref_6_c_1344_n ) capacitor c=0.0427116f //x=5.245 \
 //y=7.585 //x2=4.505 //y2=3.88
cc_421 ( N_VDD_c_310_p N_noxref_6_c_1307_n ) capacitor c=9.09811e-19 \
 //x=25.965 //y=7.58 //x2=6.355 //y2=2.26
cc_422 ( N_VDD_c_304_n N_noxref_6_c_1307_n ) capacitor c=0.0134711f //x=5.245 \
 //y=7.585 //x2=6.355 //y2=2.26
cc_423 ( N_VDD_M22_noxref_s N_noxref_6_c_1307_n ) capacitor c=0.0120369f \
 //x=6.2 //y=5.2 //x2=6.355 //y2=2.26
cc_424 ( N_VDD_c_310_p N_noxref_6_c_1308_n ) capacitor c=9.22979e-19 \
 //x=25.965 //y=7.58 //x2=19.305 //y2=2.26
cc_425 ( N_VDD_c_307_n N_noxref_6_c_1308_n ) capacitor c=0.0160182f //x=18.195 \
 //y=7.585 //x2=19.305 //y2=2.26
cc_426 ( N_VDD_M38_noxref_s N_noxref_6_c_1308_n ) capacitor c=0.0123185f \
 //x=19.15 //y=5.2 //x2=19.305 //y2=2.26
cc_427 ( N_VDD_c_311_p N_noxref_6_M22_noxref_g ) capacitor c=0.00755614f \
 //x=7.13 //y=7.585 //x2=6.555 //y2=6.2
cc_428 ( N_VDD_M22_noxref_s N_noxref_6_M22_noxref_g ) capacitor c=0.0477201f \
 //x=6.2 //y=5.2 //x2=6.555 //y2=6.2
cc_429 ( N_VDD_c_311_p N_noxref_6_M23_noxref_g ) capacitor c=0.00679791f \
 //x=7.13 //y=7.585 //x2=6.995 //y2=6.2
cc_430 ( N_VDD_M23_noxref_d N_noxref_6_M23_noxref_g ) capacitor c=0.015318f \
 //x=7.07 //y=5.2 //x2=6.995 //y2=6.2
cc_431 ( N_VDD_c_438_p N_noxref_6_M38_noxref_g ) capacitor c=0.00755614f \
 //x=20.08 //y=7.585 //x2=19.505 //y2=6.2
cc_432 ( N_VDD_M38_noxref_s N_noxref_6_M38_noxref_g ) capacitor c=0.0477201f \
 //x=19.15 //y=5.2 //x2=19.505 //y2=6.2
cc_433 ( N_VDD_c_438_p N_noxref_6_M39_noxref_g ) capacitor c=0.00679791f \
 //x=20.08 //y=7.585 //x2=19.945 //y2=6.2
cc_434 ( N_VDD_M39_noxref_d N_noxref_6_M39_noxref_g ) capacitor c=0.015318f \
 //x=20.02 //y=5.2 //x2=19.945 //y2=6.2
cc_435 ( N_VDD_c_304_n N_noxref_6_c_1359_n ) capacitor c=0.00757682f //x=5.245 \
 //y=7.585 //x2=6.63 //y2=4.97
cc_436 ( N_VDD_M22_noxref_s N_noxref_6_c_1359_n ) capacitor c=0.00444941f \
 //x=6.2 //y=5.2 //x2=6.63 //y2=4.97
cc_437 ( N_VDD_c_307_n N_noxref_6_c_1361_n ) capacitor c=0.00757682f \
 //x=18.195 //y=7.585 //x2=19.58 //y2=4.97
cc_438 ( N_VDD_M38_noxref_s N_noxref_6_c_1361_n ) capacitor c=0.0044516f \
 //x=19.15 //y=5.2 //x2=19.58 //y2=4.97
cc_439 ( N_VDD_c_310_p N_noxref_6_M16_noxref_d ) capacitor c=0.00285148f \
 //x=25.965 //y=7.58 //x2=1.82 //y2=5.2
cc_440 ( N_VDD_c_414_p N_noxref_6_M16_noxref_d ) capacitor c=0.0141242f \
 //x=2.32 //y=7.585 //x2=1.82 //y2=5.2
cc_441 ( N_VDD_M17_noxref_d N_noxref_6_M16_noxref_d ) capacitor c=0.0664752f \
 //x=2.26 //y=5.2 //x2=1.82 //y2=5.2
cc_442 ( N_VDD_c_310_p N_noxref_6_M18_noxref_d ) capacitor c=0.0027526f \
 //x=25.965 //y=7.58 //x2=2.7 //y2=5.2
cc_443 ( N_VDD_c_405_p N_noxref_6_M18_noxref_d ) capacitor c=0.0140573f \
 //x=3.2 //y=7.585 //x2=2.7 //y2=5.2
cc_444 ( N_VDD_c_304_n N_noxref_6_M18_noxref_d ) capacitor c=4.9285e-19 \
 //x=5.245 //y=7.585 //x2=2.7 //y2=5.2
cc_445 ( N_VDD_M16_noxref_s N_noxref_6_M18_noxref_d ) capacitor c=0.00130656f \
 //x=1.39 //y=5.2 //x2=2.7 //y2=5.2
cc_446 ( N_VDD_M17_noxref_d N_noxref_6_M18_noxref_d ) capacitor c=0.0664752f \
 //x=2.26 //y=5.2 //x2=2.7 //y2=5.2
cc_447 ( N_VDD_M19_noxref_d N_noxref_6_M18_noxref_d ) capacitor c=0.0664752f \
 //x=3.14 //y=5.2 //x2=2.7 //y2=5.2
cc_448 ( N_VDD_c_310_p N_noxref_6_M20_noxref_d ) capacitor c=0.00275309f \
 //x=25.965 //y=7.58 //x2=3.58 //y2=5.2
cc_449 ( N_VDD_c_328_p N_noxref_6_M20_noxref_d ) capacitor c=0.01376f //x=4.08 \
 //y=7.585 //x2=3.58 //y2=5.2
cc_450 ( N_VDD_c_304_n N_noxref_6_M20_noxref_d ) capacitor c=0.00939849f \
 //x=5.245 //y=7.585 //x2=3.58 //y2=5.2
cc_451 ( N_VDD_M19_noxref_d N_noxref_6_M20_noxref_d ) capacitor c=0.0664752f \
 //x=3.14 //y=5.2 //x2=3.58 //y2=5.2
cc_452 ( N_VDD_M21_noxref_d N_noxref_6_M20_noxref_d ) capacitor c=0.0664752f \
 //x=4.02 //y=5.2 //x2=3.58 //y2=5.2
cc_453 ( N_VDD_M22_noxref_s N_noxref_6_M20_noxref_d ) capacitor c=3.57641e-19 \
 //x=6.2 //y=5.2 //x2=3.58 //y2=5.2
cc_454 ( N_VDD_c_307_n RN ) capacitor c=5.06164e-19 //x=18.195 //y=7.585 \
 //x2=16.77 //y2=4.62
cc_455 ( N_VDD_c_305_n N_RN_c_1581_n ) capacitor c=6.09414e-19 //x=10.055 \
 //y=7.585 //x2=8.575 //y2=4.88
cc_456 ( N_VDD_c_307_n N_RN_c_1582_n ) capacitor c=3.28085e-19 //x=18.195 \
 //y=7.585 //x2=16.715 //y2=4.88
cc_457 ( N_VDD_c_310_p N_RN_c_1583_n ) capacitor c=2.05728e-19 //x=25.965 \
 //y=7.58 //x2=20.415 //y2=4.88
cc_458 ( N_VDD_c_307_n N_RN_c_1584_n ) capacitor c=3.91834e-19 //x=18.195 \
 //y=7.585 //x2=16.742 //y2=4.535
cc_459 ( N_VDD_c_307_n N_RN_c_1585_n ) capacitor c=7.31405e-19 //x=18.195 \
 //y=7.585 //x2=20.442 //y2=4.535
cc_460 ( N_VDD_c_318_p N_RN_M26_noxref_g ) capacitor c=0.00679791f //x=8.89 \
 //y=7.585 //x2=8.315 //y2=6.2
cc_461 ( N_VDD_M25_noxref_d N_RN_M26_noxref_g ) capacitor c=0.015318f //x=7.95 \
 //y=5.2 //x2=8.315 //y2=6.2
cc_462 ( N_VDD_c_318_p N_RN_M27_noxref_g ) capacitor c=0.00680002f //x=8.89 \
 //y=7.585 //x2=8.755 //y2=6.2
cc_463 ( N_VDD_M27_noxref_d N_RN_M27_noxref_g ) capacitor c=0.0394719f \
 //x=8.83 //y=5.2 //x2=8.755 //y2=6.2
cc_464 ( N_VDD_c_471_p N_RN_M36_noxref_g ) capacitor c=0.00679791f //x=17.03 \
 //y=7.585 //x2=16.455 //y2=6.2
cc_465 ( N_VDD_M35_noxref_d N_RN_M36_noxref_g ) capacitor c=0.015318f \
 //x=16.09 //y=5.2 //x2=16.455 //y2=6.2
cc_466 ( N_VDD_c_471_p N_RN_M37_noxref_g ) capacitor c=0.00680002f //x=17.03 \
 //y=7.585 //x2=16.895 //y2=6.2
cc_467 ( N_VDD_M37_noxref_d N_RN_M37_noxref_g ) capacitor c=0.0394719f \
 //x=16.97 //y=5.2 //x2=16.895 //y2=6.2
cc_468 ( N_VDD_c_475_p N_RN_M40_noxref_g ) capacitor c=0.00680845f //x=20.96 \
 //y=7.585 //x2=20.385 //y2=6.2
cc_469 ( N_VDD_M39_noxref_d N_RN_M40_noxref_g ) capacitor c=0.015318f \
 //x=20.02 //y=5.2 //x2=20.385 //y2=6.2
cc_470 ( N_VDD_c_475_p N_RN_M41_noxref_g ) capacitor c=0.00679791f //x=20.96 \
 //y=7.585 //x2=20.825 //y2=6.2
cc_471 ( N_VDD_M41_noxref_d N_RN_M41_noxref_g ) capacitor c=0.015318f //x=20.9 \
 //y=5.2 //x2=20.825 //y2=6.2
cc_472 ( N_VDD_c_308_n N_noxref_8_c_1889_n ) capacitor c=8.91112e-19 \
 //x=23.005 //y=7.585 //x2=21.525 //y2=2.26
cc_473 ( N_VDD_c_480_p N_noxref_8_M42_noxref_g ) capacitor c=0.00679791f \
 //x=21.84 //y=7.585 //x2=21.265 //y2=6.2
cc_474 ( N_VDD_M41_noxref_d N_noxref_8_M42_noxref_g ) capacitor c=0.015318f \
 //x=20.9 //y=5.2 //x2=21.265 //y2=6.2
cc_475 ( N_VDD_c_480_p N_noxref_8_M43_noxref_g ) capacitor c=0.00680002f \
 //x=21.84 //y=7.585 //x2=21.705 //y2=6.2
cc_476 ( N_VDD_M43_noxref_d N_noxref_8_M43_noxref_g ) capacitor c=0.0394719f \
 //x=21.78 //y=5.2 //x2=21.705 //y2=6.2
cc_477 ( N_VDD_c_308_n QN ) capacitor c=0.00926924f //x=23.005 //y=7.585 \
 //x2=22.32 //y2=4.62
cc_478 ( N_VDD_c_310_p QN ) capacitor c=2.07739e-19 //x=25.965 //y=7.58 \
 //x2=22.32 //y2=4.99
cc_479 ( N_VDD_c_486_p QN ) capacitor c=2.91288e-19 //x=22.835 //y=7.585 \
 //x2=22.32 //y2=4.99
cc_480 ( N_VDD_c_308_n QN ) capacitor c=0.00929208f //x=23.005 //y=7.585 \
 //x2=22.32 //y2=4.99
cc_481 ( N_VDD_c_310_p N_QN_c_2002_n ) capacitor c=0.00451543f //x=25.965 \
 //y=7.58 //x2=20.52 //y2=5.335
cc_482 ( N_VDD_c_438_p N_QN_c_2002_n ) capacitor c=4.32713e-19 //x=20.08 \
 //y=7.585 //x2=20.52 //y2=5.335
cc_483 ( N_VDD_c_475_p N_QN_c_2002_n ) capacitor c=4.32713e-19 //x=20.96 \
 //y=7.585 //x2=20.52 //y2=5.335
cc_484 ( N_VDD_M39_noxref_d N_QN_c_2002_n ) capacitor c=0.0115154f //x=20.02 \
 //y=5.2 //x2=20.52 //y2=5.335
cc_485 ( N_VDD_c_307_n N_QN_c_2006_n ) capacitor c=0.00863585f //x=18.195 \
 //y=7.585 //x2=19.81 //y2=5.335
cc_486 ( N_VDD_M38_noxref_s N_QN_c_2006_n ) capacitor c=0.0831083f //x=19.15 \
 //y=5.2 //x2=19.81 //y2=5.335
cc_487 ( N_VDD_c_310_p N_QN_c_2008_n ) capacitor c=0.00449039f //x=25.965 \
 //y=7.58 //x2=21.4 //y2=5.335
cc_488 ( N_VDD_c_475_p N_QN_c_2008_n ) capacitor c=4.32713e-19 //x=20.96 \
 //y=7.585 //x2=21.4 //y2=5.335
cc_489 ( N_VDD_c_480_p N_QN_c_2008_n ) capacitor c=4.32713e-19 //x=21.84 \
 //y=7.585 //x2=21.4 //y2=5.335
cc_490 ( N_VDD_M41_noxref_d N_QN_c_2008_n ) capacitor c=0.0115154f //x=20.9 \
 //y=5.2 //x2=21.4 //y2=5.335
cc_491 ( N_VDD_c_310_p N_QN_c_2012_n ) capacitor c=0.00443036f //x=25.965 \
 //y=7.58 //x2=22.18 //y2=5.335
cc_492 ( N_VDD_c_480_p N_QN_c_2012_n ) capacitor c=7.48482e-19 //x=21.84 \
 //y=7.585 //x2=22.18 //y2=5.335
cc_493 ( N_VDD_c_486_p N_QN_c_2012_n ) capacitor c=0.00199449f //x=22.835 \
 //y=7.585 //x2=22.18 //y2=5.335
cc_494 ( N_VDD_M43_noxref_d N_QN_c_2012_n ) capacitor c=0.0115154f //x=21.78 \
 //y=5.2 //x2=22.18 //y2=5.335
cc_495 ( N_VDD_c_308_n N_QN_c_2016_n ) capacitor c=0.0147515f //x=23.005 \
 //y=7.585 //x2=22.265 //y2=5.25
cc_496 ( N_VDD_c_310_p N_QN_c_2017_n ) capacitor c=0.00126176f //x=25.965 \
 //y=7.58 //x2=24.115 //y2=4.88
cc_497 ( N_VDD_c_504_p N_QN_c_2017_n ) capacitor c=2.88573e-19 //x=24.59 \
 //y=7.585 //x2=24.115 //y2=4.88
cc_498 ( N_VDD_c_308_n N_QN_c_2019_n ) capacitor c=0.00867149f //x=23.005 \
 //y=7.585 //x2=22.292 //y2=4.535
cc_499 ( N_VDD_c_308_n N_QN_c_2020_n ) capacitor c=0.00766155f //x=23.005 \
 //y=7.585 //x2=22.292 //y2=4.905
cc_500 ( N_VDD_c_308_n N_QN_c_2021_n ) capacitor c=0.0161024f //x=23.005 \
 //y=7.585 //x2=24.142 //y2=4.535
cc_501 ( N_VDD_c_504_p N_QN_M44_noxref_g ) capacitor c=0.00732332f //x=24.59 \
 //y=7.585 //x2=24.015 //y2=6.2
cc_502 ( N_VDD_M44_noxref_s N_QN_M44_noxref_g ) capacitor c=0.054195f \
 //x=23.66 //y=5.2 //x2=24.015 //y2=6.2
cc_503 ( N_VDD_c_504_p N_QN_M45_noxref_g ) capacitor c=0.00677553f //x=24.59 \
 //y=7.585 //x2=24.455 //y2=6.2
cc_504 ( N_VDD_M45_noxref_d N_QN_M45_noxref_g ) capacitor c=0.015318f \
 //x=24.53 //y=5.2 //x2=24.455 //y2=6.2
cc_505 ( N_VDD_c_308_n N_QN_c_2026_n ) capacitor c=0.0154093f //x=23.005 \
 //y=7.585 //x2=24.115 //y2=4.88
cc_506 ( N_VDD_c_310_p N_QN_M38_noxref_d ) capacitor c=0.00285148f //x=25.965 \
 //y=7.58 //x2=19.58 //y2=5.2
cc_507 ( N_VDD_c_438_p N_QN_M38_noxref_d ) capacitor c=0.0141242f //x=20.08 \
 //y=7.585 //x2=19.58 //y2=5.2
cc_508 ( N_VDD_M39_noxref_d N_QN_M38_noxref_d ) capacitor c=0.0664752f \
 //x=20.02 //y=5.2 //x2=19.58 //y2=5.2
cc_509 ( N_VDD_c_310_p N_QN_M40_noxref_d ) capacitor c=0.00285148f //x=25.965 \
 //y=7.58 //x2=20.46 //y2=5.2
cc_510 ( N_VDD_c_475_p N_QN_M40_noxref_d ) capacitor c=0.0141242f //x=20.96 \
 //y=7.585 //x2=20.46 //y2=5.2
cc_511 ( N_VDD_c_308_n N_QN_M40_noxref_d ) capacitor c=4.9285e-19 //x=23.005 \
 //y=7.585 //x2=20.46 //y2=5.2
cc_512 ( N_VDD_M38_noxref_s N_QN_M40_noxref_d ) capacitor c=0.00130656f \
 //x=19.15 //y=5.2 //x2=20.46 //y2=5.2
cc_513 ( N_VDD_M39_noxref_d N_QN_M40_noxref_d ) capacitor c=0.0664752f \
 //x=20.02 //y=5.2 //x2=20.46 //y2=5.2
cc_514 ( N_VDD_M41_noxref_d N_QN_M40_noxref_d ) capacitor c=0.0664752f \
 //x=20.9 //y=5.2 //x2=20.46 //y2=5.2
cc_515 ( N_VDD_c_310_p N_QN_M42_noxref_d ) capacitor c=0.00285148f //x=25.965 \
 //y=7.58 //x2=21.34 //y2=5.2
cc_516 ( N_VDD_c_480_p N_QN_M42_noxref_d ) capacitor c=0.0138265f //x=21.84 \
 //y=7.585 //x2=21.34 //y2=5.2
cc_517 ( N_VDD_c_308_n N_QN_M42_noxref_d ) capacitor c=0.00939849f //x=23.005 \
 //y=7.585 //x2=21.34 //y2=5.2
cc_518 ( N_VDD_M41_noxref_d N_QN_M42_noxref_d ) capacitor c=0.0664752f \
 //x=20.9 //y=5.2 //x2=21.34 //y2=5.2
cc_519 ( N_VDD_M43_noxref_d N_QN_M42_noxref_d ) capacitor c=0.0664752f \
 //x=21.78 //y=5.2 //x2=21.34 //y2=5.2
cc_520 ( N_VDD_M44_noxref_s N_QN_M42_noxref_d ) capacitor c=4.52683e-19 \
 //x=23.66 //y=5.2 //x2=21.34 //y2=5.2
cc_521 ( N_VDD_c_310_p N_noxref_10_c_2170_n ) capacitor c=0.0425624f \
 //x=25.965 //y=7.58 //x2=11.79 //y2=4.25
cc_522 ( N_VDD_c_414_p N_noxref_10_c_2170_n ) capacitor c=0.00113267f //x=2.32 \
 //y=7.585 //x2=11.79 //y2=4.25
cc_523 ( N_VDD_c_304_n N_noxref_10_c_2170_n ) capacitor c=0.0140577f //x=5.245 \
 //y=7.585 //x2=11.79 //y2=4.25
cc_524 ( N_VDD_c_305_n N_noxref_10_c_2170_n ) capacitor c=0.0140577f \
 //x=10.055 //y=7.585 //x2=11.79 //y2=4.25
cc_525 ( N_VDD_c_310_p N_noxref_10_c_2171_n ) capacitor c=0.00189506f \
 //x=25.965 //y=7.58 //x2=1.66 //y2=4.25
cc_526 ( N_VDD_c_302_n N_noxref_10_c_2171_n ) capacitor c=0.0017219f //x=1.175 \
 //y=7.58 //x2=1.66 //y2=4.25
cc_527 ( N_VDD_M16_noxref_s N_noxref_10_c_2171_n ) capacitor c=0.00128247f \
 //x=1.39 //y=5.2 //x2=1.66 //y2=4.25
cc_528 ( N_VDD_c_310_p N_noxref_10_c_2197_n ) capacitor c=0.0256313f \
 //x=25.965 //y=7.58 //x2=17.34 //y2=4.25
cc_529 ( N_VDD_c_306_n N_noxref_10_c_2197_n ) capacitor c=0.0140577f \
 //x=13.385 //y=7.585 //x2=17.34 //y2=4.25
cc_530 ( N_VDD_c_310_p N_noxref_10_c_2172_n ) capacitor c=0.0508824f \
 //x=25.965 //y=7.58 //x2=24.74 //y2=4.25
cc_531 ( N_VDD_c_538_p N_noxref_10_c_2172_n ) capacitor c=0.00162234f \
 //x=18.025 //y=7.585 //x2=24.74 //y2=4.25
cc_532 ( N_VDD_c_539_p N_noxref_10_c_2172_n ) capacitor c=0.00271488f //x=19.2 \
 //y=7.585 //x2=24.74 //y2=4.25
cc_533 ( N_VDD_c_438_p N_noxref_10_c_2172_n ) capacitor c=0.00113405f \
 //x=20.08 //y=7.585 //x2=24.74 //y2=4.25
cc_534 ( N_VDD_c_486_p N_noxref_10_c_2172_n ) capacitor c=0.00198312f \
 //x=22.835 //y=7.585 //x2=24.74 //y2=4.25
cc_535 ( N_VDD_c_542_p N_noxref_10_c_2172_n ) capacitor c=0.00172127f \
 //x=23.71 //y=7.585 //x2=24.74 //y2=4.25
cc_536 ( N_VDD_c_504_p N_noxref_10_c_2172_n ) capacitor c=6.61227e-19 \
 //x=24.59 //y=7.585 //x2=24.74 //y2=4.25
cc_537 ( N_VDD_c_307_n N_noxref_10_c_2172_n ) capacitor c=0.0269493f \
 //x=18.195 //y=7.585 //x2=24.74 //y2=4.25
cc_538 ( N_VDD_c_308_n N_noxref_10_c_2172_n ) capacitor c=0.0269493f \
 //x=23.005 //y=7.585 //x2=24.74 //y2=4.25
cc_539 ( N_VDD_M38_noxref_s N_noxref_10_c_2172_n ) capacitor c=0.00122829f \
 //x=19.15 //y=5.2 //x2=24.74 //y2=4.25
cc_540 ( N_VDD_M44_noxref_s N_noxref_10_c_2172_n ) capacitor c=0.00363045f \
 //x=23.66 //y=5.2 //x2=24.74 //y2=4.25
cc_541 ( N_VDD_c_310_p N_noxref_10_c_2210_n ) capacitor c=0.0017556f \
 //x=25.965 //y=7.58 //x2=17.57 //y2=4.25
cc_542 ( N_VDD_c_538_p N_noxref_10_c_2210_n ) capacitor c=5.20321e-19 \
 //x=18.025 //y=7.585 //x2=17.57 //y2=4.25
cc_543 ( N_VDD_c_307_n N_noxref_10_c_2210_n ) capacitor c=0.00104972f \
 //x=18.195 //y=7.585 //x2=17.57 //y2=4.25
cc_544 ( N_VDD_c_310_p N_noxref_10_c_2173_n ) capacitor c=9.2195e-19 \
 //x=25.965 //y=7.58 //x2=1.545 //y2=2.26
cc_545 ( N_VDD_c_302_n N_noxref_10_c_2173_n ) capacitor c=0.0159723f //x=1.175 \
 //y=7.58 //x2=1.545 //y2=2.26
cc_546 ( N_VDD_M16_noxref_s N_noxref_10_c_2173_n ) capacitor c=0.0122994f \
 //x=1.39 //y=5.2 //x2=1.545 //y2=2.26
cc_547 ( N_VDD_c_305_n N_noxref_10_c_2174_n ) capacitor c=4.57806e-19 \
 //x=10.055 //y=7.585 //x2=11.905 //y2=2.26
cc_548 ( N_VDD_c_306_n N_noxref_10_c_2174_n ) capacitor c=3.21957e-19 \
 //x=13.385 //y=7.585 //x2=11.905 //y2=2.26
cc_549 ( N_VDD_c_310_p N_noxref_10_c_2218_n ) capacitor c=0.00444798f \
 //x=25.965 //y=7.58 //x2=15.71 //y2=5.335
cc_550 ( N_VDD_c_366_p N_noxref_10_c_2218_n ) capacitor c=4.32416e-19 \
 //x=15.27 //y=7.585 //x2=15.71 //y2=5.335
cc_551 ( N_VDD_c_409_p N_noxref_10_c_2218_n ) capacitor c=4.3239e-19 //x=16.15 \
 //y=7.585 //x2=15.71 //y2=5.335
cc_552 ( N_VDD_M33_noxref_d N_noxref_10_c_2218_n ) capacitor c=0.0112992f \
 //x=15.21 //y=5.2 //x2=15.71 //y2=5.335
cc_553 ( N_VDD_c_306_n N_noxref_10_c_2222_n ) capacitor c=0.00863585f \
 //x=13.385 //y=7.585 //x2=15 //y2=5.335
cc_554 ( N_VDD_M32_noxref_s N_noxref_10_c_2222_n ) capacitor c=0.0831083f \
 //x=14.34 //y=5.2 //x2=15 //y2=5.335
cc_555 ( N_VDD_c_310_p N_noxref_10_c_2224_n ) capacitor c=0.00449039f \
 //x=25.965 //y=7.58 //x2=16.59 //y2=5.335
cc_556 ( N_VDD_c_409_p N_noxref_10_c_2224_n ) capacitor c=4.32713e-19 \
 //x=16.15 //y=7.585 //x2=16.59 //y2=5.335
cc_557 ( N_VDD_c_471_p N_noxref_10_c_2224_n ) capacitor c=4.32713e-19 \
 //x=17.03 //y=7.585 //x2=16.59 //y2=5.335
cc_558 ( N_VDD_M35_noxref_d N_noxref_10_c_2224_n ) capacitor c=0.0115154f \
 //x=16.09 //y=5.2 //x2=16.59 //y2=5.335
cc_559 ( N_VDD_c_310_p N_noxref_10_c_2228_n ) capacitor c=0.00442884f \
 //x=25.965 //y=7.58 //x2=17.37 //y2=5.335
cc_560 ( N_VDD_c_471_p N_noxref_10_c_2228_n ) capacitor c=7.48482e-19 \
 //x=17.03 //y=7.585 //x2=17.37 //y2=5.335
cc_561 ( N_VDD_c_538_p N_noxref_10_c_2228_n ) capacitor c=0.00199428f \
 //x=18.025 //y=7.585 //x2=17.37 //y2=5.335
cc_562 ( N_VDD_M37_noxref_d N_noxref_10_c_2228_n ) capacitor c=0.0115154f \
 //x=16.97 //y=5.2 //x2=17.37 //y2=5.335
cc_563 ( N_VDD_c_307_n N_noxref_10_c_2232_n ) capacitor c=0.0452317f \
 //x=18.195 //y=7.585 //x2=17.455 //y2=4.25
cc_564 ( N_VDD_c_303_n N_noxref_10_c_2177_n ) capacitor c=6.61994e-19 \
 //x=25.965 //y=7.58 //x2=24.855 //y2=2.26
cc_565 ( N_VDD_c_308_n N_noxref_10_c_2177_n ) capacitor c=6.40569e-19 \
 //x=23.005 //y=7.585 //x2=24.855 //y2=2.26
cc_566 ( N_VDD_c_414_p N_noxref_10_M16_noxref_g ) capacitor c=0.00755614f \
 //x=2.32 //y=7.585 //x2=1.745 //y2=6.2
cc_567 ( N_VDD_M16_noxref_s N_noxref_10_M16_noxref_g ) capacitor c=0.0477201f \
 //x=1.39 //y=5.2 //x2=1.745 //y2=6.2
cc_568 ( N_VDD_c_414_p N_noxref_10_M17_noxref_g ) capacitor c=0.00679791f \
 //x=2.32 //y=7.585 //x2=2.185 //y2=6.2
cc_569 ( N_VDD_M17_noxref_d N_noxref_10_M17_noxref_g ) capacitor c=0.015318f \
 //x=2.26 //y=5.2 //x2=2.185 //y2=6.2
cc_570 ( N_VDD_c_354_p N_noxref_10_M30_noxref_g ) capacitor c=0.00678607f \
 //x=12.52 //y=7.585 //x2=11.945 //y2=6.2
cc_571 ( N_VDD_M29_noxref_d N_noxref_10_M30_noxref_g ) capacitor c=0.015318f \
 //x=11.58 //y=5.2 //x2=11.945 //y2=6.2
cc_572 ( N_VDD_c_354_p N_noxref_10_M31_noxref_g ) capacitor c=0.00677553f \
 //x=12.52 //y=7.585 //x2=12.385 //y2=6.2
cc_573 ( N_VDD_c_306_n N_noxref_10_M31_noxref_g ) capacitor c=0.00928743f \
 //x=13.385 //y=7.585 //x2=12.385 //y2=6.2
cc_574 ( N_VDD_M31_noxref_d N_noxref_10_M31_noxref_g ) capacitor c=0.0430452f \
 //x=12.46 //y=5.2 //x2=12.385 //y2=6.2
cc_575 ( N_VDD_c_582_p N_noxref_10_M46_noxref_g ) capacitor c=0.00678607f \
 //x=25.47 //y=7.585 //x2=24.895 //y2=6.2
cc_576 ( N_VDD_M45_noxref_d N_noxref_10_M46_noxref_g ) capacitor c=0.015318f \
 //x=24.53 //y=5.2 //x2=24.895 //y2=6.2
cc_577 ( N_VDD_c_582_p N_noxref_10_M47_noxref_g ) capacitor c=0.00677553f \
 //x=25.47 //y=7.585 //x2=25.335 //y2=6.2
cc_578 ( N_VDD_c_303_n N_noxref_10_M47_noxref_g ) capacitor c=0.024326f \
 //x=25.965 //y=7.58 //x2=25.335 //y2=6.2
cc_579 ( N_VDD_M47_noxref_d N_noxref_10_M47_noxref_g ) capacitor c=0.0430452f \
 //x=25.41 //y=5.2 //x2=25.335 //y2=6.2
cc_580 ( N_VDD_c_302_n N_noxref_10_c_2249_n ) capacitor c=0.00757682f \
 //x=1.175 //y=7.58 //x2=1.82 //y2=4.97
cc_581 ( N_VDD_M16_noxref_s N_noxref_10_c_2249_n ) capacitor c=0.00445143f \
 //x=1.39 //y=5.2 //x2=1.82 //y2=4.97
cc_582 ( N_VDD_c_310_p N_noxref_10_M32_noxref_d ) capacitor c=0.00275309f \
 //x=25.965 //y=7.58 //x2=14.77 //y2=5.2
cc_583 ( N_VDD_c_366_p N_noxref_10_M32_noxref_d ) capacitor c=0.0140577f \
 //x=15.27 //y=7.585 //x2=14.77 //y2=5.2
cc_584 ( N_VDD_M33_noxref_d N_noxref_10_M32_noxref_d ) capacitor c=0.0664752f \
 //x=15.21 //y=5.2 //x2=14.77 //y2=5.2
cc_585 ( N_VDD_c_310_p N_noxref_10_M34_noxref_d ) capacitor c=0.00283073f \
 //x=25.965 //y=7.58 //x2=15.65 //y2=5.2
cc_586 ( N_VDD_c_409_p N_noxref_10_M34_noxref_d ) capacitor c=0.0141102f \
 //x=16.15 //y=7.585 //x2=15.65 //y2=5.2
cc_587 ( N_VDD_c_307_n N_noxref_10_M34_noxref_d ) capacitor c=4.9285e-19 \
 //x=18.195 //y=7.585 //x2=15.65 //y2=5.2
cc_588 ( N_VDD_M32_noxref_s N_noxref_10_M34_noxref_d ) capacitor c=0.00130656f \
 //x=14.34 //y=5.2 //x2=15.65 //y2=5.2
cc_589 ( N_VDD_M33_noxref_d N_noxref_10_M34_noxref_d ) capacitor c=0.0664752f \
 //x=15.21 //y=5.2 //x2=15.65 //y2=5.2
cc_590 ( N_VDD_M35_noxref_d N_noxref_10_M34_noxref_d ) capacitor c=0.0664752f \
 //x=16.09 //y=5.2 //x2=15.65 //y2=5.2
cc_591 ( N_VDD_c_310_p N_noxref_10_M36_noxref_d ) capacitor c=0.00285148f \
 //x=25.965 //y=7.58 //x2=16.53 //y2=5.2
cc_592 ( N_VDD_c_471_p N_noxref_10_M36_noxref_d ) capacitor c=0.0138265f \
 //x=17.03 //y=7.585 //x2=16.53 //y2=5.2
cc_593 ( N_VDD_c_307_n N_noxref_10_M36_noxref_d ) capacitor c=0.00939849f \
 //x=18.195 //y=7.585 //x2=16.53 //y2=5.2
cc_594 ( N_VDD_M35_noxref_d N_noxref_10_M36_noxref_d ) capacitor c=0.0664752f \
 //x=16.09 //y=5.2 //x2=16.53 //y2=5.2
cc_595 ( N_VDD_M37_noxref_d N_noxref_10_M36_noxref_d ) capacitor c=0.0664752f \
 //x=16.97 //y=5.2 //x2=16.53 //y2=5.2
cc_596 ( N_VDD_M38_noxref_s N_noxref_10_M36_noxref_d ) capacitor c=3.57641e-19 \
 //x=19.15 //y=5.2 //x2=16.53 //y2=5.2
cc_597 ( N_VDD_c_310_p N_noxref_11_c_2587_n ) capacitor c=0.00459998f \
 //x=25.965 //y=7.58 //x2=25.03 //y2=5.38
cc_598 ( N_VDD_c_504_p N_noxref_11_c_2587_n ) capacitor c=4.49205e-19 \
 //x=24.59 //y=7.585 //x2=25.03 //y2=5.38
cc_599 ( N_VDD_c_582_p N_noxref_11_c_2587_n ) capacitor c=4.49193e-19 \
 //x=25.47 //y=7.585 //x2=25.03 //y2=5.38
cc_600 ( N_VDD_M45_noxref_d N_noxref_11_c_2587_n ) capacitor c=0.0126907f \
 //x=24.53 //y=5.2 //x2=25.03 //y2=5.38
cc_601 ( N_VDD_c_308_n N_noxref_11_c_2591_n ) capacitor c=0.00985474f \
 //x=23.005 //y=7.585 //x2=24.32 //y2=5.38
cc_602 ( N_VDD_M44_noxref_s N_noxref_11_c_2591_n ) capacitor c=0.087833f \
 //x=23.66 //y=5.2 //x2=24.32 //y2=5.38
cc_603 ( N_VDD_c_310_p N_noxref_11_c_2593_n ) capacitor c=0.00312108f \
 //x=25.965 //y=7.58 //x2=25.51 //y2=5.38
cc_604 ( N_VDD_c_582_p N_noxref_11_c_2593_n ) capacitor c=7.22416e-19 \
 //x=25.47 //y=7.585 //x2=25.51 //y2=5.38
cc_605 ( N_VDD_M47_noxref_d N_noxref_11_c_2593_n ) capacitor c=0.0163426f \
 //x=25.41 //y=5.2 //x2=25.51 //y2=5.38
cc_606 ( N_VDD_c_310_p N_noxref_11_c_2582_n ) capacitor c=0.0154544f \
 //x=25.965 //y=7.58 //x2=25.595 //y2=3.88
cc_607 ( N_VDD_c_303_n N_noxref_11_c_2582_n ) capacitor c=0.0466813f \
 //x=25.965 //y=7.58 //x2=25.595 //y2=3.88
cc_608 ( N_VDD_c_308_n N_noxref_11_c_2582_n ) capacitor c=0.00151618f \
 //x=23.005 //y=7.585 //x2=25.595 //y2=3.88
cc_609 ( N_VDD_M47_noxref_d N_noxref_11_c_2582_n ) capacitor c=4.05367e-19 \
 //x=25.41 //y=5.2 //x2=25.595 //y2=3.88
cc_610 ( N_VDD_c_310_p N_noxref_11_M44_noxref_d ) capacitor c=0.00285139f \
 //x=25.965 //y=7.58 //x2=24.09 //y2=5.2
cc_611 ( N_VDD_c_504_p N_noxref_11_M44_noxref_d ) capacitor c=0.0141209f \
 //x=24.59 //y=7.585 //x2=24.09 //y2=5.2
cc_612 ( N_VDD_c_303_n N_noxref_11_M44_noxref_d ) capacitor c=6.94454e-19 \
 //x=25.965 //y=7.58 //x2=24.09 //y2=5.2
cc_613 ( N_VDD_M45_noxref_d N_noxref_11_M44_noxref_d ) capacitor c=0.0664752f \
 //x=24.53 //y=5.2 //x2=24.09 //y2=5.2
cc_614 ( N_VDD_c_310_p N_noxref_11_M46_noxref_d ) capacitor c=0.00294258f \
 //x=25.965 //y=7.58 //x2=24.97 //y2=5.2
cc_615 ( N_VDD_c_582_p N_noxref_11_M46_noxref_d ) capacitor c=0.0138783f \
 //x=25.47 //y=7.585 //x2=24.97 //y2=5.2
cc_616 ( N_VDD_c_303_n N_noxref_11_M46_noxref_d ) capacitor c=0.0123189f \
 //x=25.965 //y=7.58 //x2=24.97 //y2=5.2
cc_617 ( N_VDD_M44_noxref_s N_noxref_11_M46_noxref_d ) capacitor c=0.00111971f \
 //x=23.66 //y=5.2 //x2=24.97 //y2=5.2
cc_618 ( N_VDD_M45_noxref_d N_noxref_11_M46_noxref_d ) capacitor c=0.0664752f \
 //x=24.53 //y=5.2 //x2=24.97 //y2=5.2
cc_619 ( N_VDD_M47_noxref_d N_noxref_11_M46_noxref_d ) capacitor c=0.0664752f \
 //x=25.41 //y=5.2 //x2=24.97 //y2=5.2
cc_620 ( N_VDD_c_310_p N_D_c_2769_n ) capacitor c=2.03391e-19 //x=25.965 \
 //y=7.58 //x2=7.465 //y2=4.88
cc_621 ( N_VDD_c_304_n N_D_c_2769_n ) capacitor c=5.89117e-19 //x=5.245 \
 //y=7.585 //x2=7.465 //y2=4.88
cc_622 ( N_VDD_c_312_p N_D_M24_noxref_g ) capacitor c=0.00680845f //x=8.01 \
 //y=7.585 //x2=7.435 //y2=6.2
cc_623 ( N_VDD_M23_noxref_d N_D_M24_noxref_g ) capacitor c=0.015318f //x=7.07 \
 //y=5.2 //x2=7.435 //y2=6.2
cc_624 ( N_VDD_c_312_p N_D_M25_noxref_g ) capacitor c=0.00679791f //x=8.01 \
 //y=7.585 //x2=7.875 //y2=6.2
cc_625 ( N_VDD_M25_noxref_d N_D_M25_noxref_g ) capacitor c=0.015318f //x=7.95 \
 //y=5.2 //x2=7.875 //y2=6.2
cc_626 ( N_noxref_3_c_638_n N_noxref_4_c_950_n ) capacitor c=0.011463f \
 //x=11.05 //y=3.51 //x2=12.76 //y2=3.51
cc_627 ( N_noxref_3_M29_noxref_g N_noxref_4_c_919_n ) capacitor c=0.0169521f \
 //x=11.505 //y=6.2 //x2=12.08 //y2=5.38
cc_628 ( N_noxref_3_c_641_n N_noxref_4_c_923_n ) capacitor c=0.00539951f \
 //x=11.165 //y=2.26 //x2=11.37 //y2=5.38
cc_629 ( N_noxref_3_M28_noxref_g N_noxref_4_c_923_n ) capacitor c=0.0177326f \
 //x=11.065 //y=6.2 //x2=11.37 //y2=5.38
cc_630 ( N_noxref_3_c_680_n N_noxref_4_c_923_n ) capacitor c=0.00581252f \
 //x=11.165 //y=4.88 //x2=11.37 //y2=5.38
cc_631 ( N_noxref_3_c_668_n N_noxref_4_c_904_n ) capacitor c=3.52729e-19 \
 //x=9.315 //y=3.51 //x2=12.645 //y2=3.51
cc_632 ( N_noxref_3_c_641_n N_noxref_4_c_904_n ) capacitor c=0.00292364f \
 //x=11.165 //y=2.26 //x2=12.645 //y2=3.51
cc_633 ( N_noxref_3_M29_noxref_g N_noxref_4_M28_noxref_d ) capacitor \
 c=0.0173476f //x=11.505 //y=6.2 //x2=11.14 //y2=5.2
cc_634 ( N_noxref_3_c_633_n N_CLK_c_1053_n ) capacitor c=0.00360213f //x=9.2 \
 //y=3.51 //x2=15.49 //y2=4.62
cc_635 ( N_noxref_3_c_637_n N_CLK_c_1053_n ) capacitor c=4.49102e-19 //x=3.88 \
 //y=3.51 //x2=15.49 //y2=4.62
cc_636 ( N_noxref_3_c_639_n N_CLK_c_1053_n ) capacitor c=0.0198958f //x=3.765 \
 //y=2.26 //x2=15.49 //y2=4.62
cc_637 ( N_noxref_3_c_654_n N_CLK_c_1053_n ) capacitor c=0.0317819f //x=7.57 \
 //y=5.335 //x2=15.49 //y2=4.62
cc_638 ( N_noxref_3_c_658_n N_CLK_c_1053_n ) capacitor c=0.0230136f //x=6.86 \
 //y=5.335 //x2=15.49 //y2=4.62
cc_639 ( N_noxref_3_c_664_n N_CLK_c_1053_n ) capacitor c=0.0178724f //x=9.23 \
 //y=5.335 //x2=15.49 //y2=4.62
cc_640 ( N_noxref_3_c_668_n N_CLK_c_1053_n ) capacitor c=0.0210274f //x=9.315 \
 //y=3.51 //x2=15.49 //y2=4.62
cc_641 ( N_noxref_3_c_641_n N_CLK_c_1053_n ) capacitor c=0.0198304f //x=11.165 \
 //y=2.26 //x2=15.49 //y2=4.62
cc_642 ( N_noxref_3_c_712_p N_CLK_c_1053_n ) capacitor c=0.0111881f //x=3.765 \
 //y=4.88 //x2=15.49 //y2=4.62
cc_643 ( N_noxref_3_c_680_n N_CLK_c_1053_n ) capacitor c=0.0107057f //x=11.165 \
 //y=4.88 //x2=15.49 //y2=4.62
cc_644 ( N_noxref_3_c_639_n N_CLK_c_1070_n ) capacitor c=0.00153281f //x=3.765 \
 //y=2.26 //x2=2.77 //y2=4.62
cc_645 ( N_noxref_3_c_639_n CLK ) capacitor c=0.00493712f //x=3.765 //y=2.26 \
 //x2=2.71 //y2=2.77
cc_646 ( N_noxref_3_c_639_n CLK ) capacitor c=0.00493712f //x=3.765 //y=2.26 \
 //x2=2.71 //y2=3.14
cc_647 ( N_noxref_3_c_637_n CLK ) capacitor c=0.00446435f //x=3.88 //y=3.51 \
 //x2=2.71 //y2=3.51
cc_648 ( N_noxref_3_c_639_n CLK ) capacitor c=0.00329813f //x=3.765 //y=2.26 \
 //x2=2.71 //y2=3.51
cc_649 ( N_noxref_3_c_639_n CLK ) capacitor c=0.00455774f //x=3.765 //y=2.26 \
 //x2=2.71 //y2=3.88
cc_650 ( N_noxref_3_c_639_n CLK ) capacitor c=0.00190929f //x=3.765 //y=2.26 \
 //x2=2.71 //y2=4.62
cc_651 ( N_noxref_3_c_639_n N_CLK_c_1051_n ) capacitor c=0.0102353f //x=3.765 \
 //y=2.26 //x2=2.655 //y2=2.26
cc_652 ( N_noxref_3_c_722_p N_CLK_c_1051_n ) capacitor c=0.00228632f //x=3.765 \
 //y=2.26 //x2=2.655 //y2=2.26
cc_653 ( N_noxref_3_c_639_n N_CLK_c_1071_n ) capacitor c=0.00467264f //x=3.765 \
 //y=2.26 //x2=2.655 //y2=4.88
cc_654 ( N_noxref_3_c_712_p N_CLK_c_1071_n ) capacitor c=0.00218014f //x=3.765 \
 //y=4.88 //x2=2.655 //y2=4.88
cc_655 ( N_noxref_3_c_639_n N_CLK_c_1104_n ) capacitor c=0.0042159f //x=3.765 \
 //y=2.26 //x2=2.682 //y2=3.055
cc_656 ( N_noxref_3_c_637_n N_CLK_c_1105_n ) capacitor c=6.33859e-19 //x=3.88 \
 //y=3.51 //x2=2.682 //y2=3.425
cc_657 ( N_noxref_3_c_639_n N_CLK_c_1105_n ) capacitor c=0.00395201f //x=3.765 \
 //y=2.26 //x2=2.682 //y2=3.425
cc_658 ( N_noxref_3_c_637_n N_CLK_c_1107_n ) capacitor c=6.33859e-19 //x=3.88 \
 //y=3.51 //x2=2.682 //y2=3.795
cc_659 ( N_noxref_3_c_639_n N_CLK_c_1107_n ) capacitor c=0.00391381f //x=3.765 \
 //y=2.26 //x2=2.682 //y2=3.795
cc_660 ( N_noxref_3_c_639_n N_CLK_c_1073_n ) capacitor c=0.00930728f //x=3.765 \
 //y=2.26 //x2=2.682 //y2=4.535
cc_661 ( N_noxref_3_M20_noxref_g N_CLK_M18_noxref_g ) capacitor c=0.0101598f \
 //x=3.505 //y=6.2 //x2=2.625 //y2=6.2
cc_662 ( N_noxref_3_M20_noxref_g N_CLK_M19_noxref_g ) capacitor c=0.0602553f \
 //x=3.505 //y=6.2 //x2=3.065 //y2=6.2
cc_663 ( N_noxref_3_M21_noxref_g N_CLK_M19_noxref_g ) capacitor c=0.0101598f \
 //x=3.945 //y=6.2 //x2=3.065 //y2=6.2
cc_664 ( N_noxref_3_c_734_p N_CLK_c_1113_n ) capacitor c=0.00456962f //x=3.755 \
 //y=1.095 //x2=2.745 //y2=1.09
cc_665 ( N_noxref_3_c_735_p N_CLK_c_1114_n ) capacitor c=0.00438372f //x=3.755 \
 //y=1.44 //x2=2.745 //y2=1.4
cc_666 ( N_noxref_3_c_736_p N_CLK_c_1115_n ) capacitor c=0.00438372f //x=3.755 \
 //y=1.75 //x2=2.745 //y2=1.63
cc_667 ( N_noxref_3_c_639_n N_CLK_c_1116_n ) capacitor c=0.0023343f //x=3.765 \
 //y=2.26 //x2=2.745 //y2=2.095
cc_668 ( N_noxref_3_c_722_p N_CLK_c_1116_n ) capacitor c=0.00933826f //x=3.765 \
 //y=2.26 //x2=2.745 //y2=2.095
cc_669 ( N_noxref_3_c_739_p N_CLK_c_1116_n ) capacitor c=0.00438372f //x=3.765 \
 //y=2.095 //x2=2.745 //y2=2.095
cc_670 ( N_noxref_3_c_712_p N_CLK_c_1119_n ) capacitor c=0.0611812f //x=3.765 \
 //y=4.88 //x2=2.99 //y2=4.97
cc_671 ( N_noxref_3_c_639_n N_CLK_c_1120_n ) capacitor c=0.00142741f //x=3.765 \
 //y=2.26 //x2=2.655 //y2=4.88
cc_672 ( N_noxref_3_c_712_p N_CLK_c_1120_n ) capacitor c=0.00487508f //x=3.765 \
 //y=4.88 //x2=2.655 //y2=4.88
cc_673 ( N_noxref_3_c_633_n N_noxref_6_c_1378_n ) capacitor c=0.146539f \
 //x=9.2 //y=3.51 //x2=6.24 //y2=3.88
cc_674 ( N_noxref_3_c_633_n N_noxref_6_c_1379_n ) capacitor c=0.0294746f \
 //x=9.2 //y=3.51 //x2=4.62 //y2=3.88
cc_675 ( N_noxref_3_c_639_n N_noxref_6_c_1379_n ) capacitor c=0.00687545f \
 //x=3.765 //y=2.26 //x2=4.62 //y2=3.88
cc_676 ( N_noxref_3_c_633_n N_noxref_6_c_1305_n ) capacitor c=0.238127f \
 //x=9.2 //y=3.51 //x2=19.19 //y2=3.88
cc_677 ( N_noxref_3_c_638_n N_noxref_6_c_1305_n ) capacitor c=0.175734f \
 //x=11.05 //y=3.51 //x2=19.19 //y2=3.88
cc_678 ( N_noxref_3_c_748_p N_noxref_6_c_1305_n ) capacitor c=0.0268386f \
 //x=9.43 //y=3.51 //x2=19.19 //y2=3.88
cc_679 ( N_noxref_3_c_668_n N_noxref_6_c_1305_n ) capacitor c=0.0206044f \
 //x=9.315 //y=3.51 //x2=19.19 //y2=3.88
cc_680 ( N_noxref_3_c_641_n N_noxref_6_c_1305_n ) capacitor c=0.0205831f \
 //x=11.165 //y=2.26 //x2=19.19 //y2=3.88
cc_681 ( N_noxref_3_c_633_n N_noxref_6_c_1386_n ) capacitor c=0.0266966f \
 //x=9.2 //y=3.51 //x2=6.47 //y2=3.88
cc_682 ( N_noxref_3_M20_noxref_g N_noxref_6_c_1336_n ) capacitor c=0.01736f \
 //x=3.505 //y=6.2 //x2=3.64 //y2=5.335
cc_683 ( N_noxref_3_c_658_n N_noxref_6_c_1340_n ) capacitor c=3.10026e-19 \
 //x=6.86 //y=5.335 //x2=4.42 //y2=5.335
cc_684 ( N_noxref_3_M21_noxref_g N_noxref_6_c_1340_n ) capacitor c=0.0194981f \
 //x=3.945 //y=6.2 //x2=4.42 //y2=5.335
cc_685 ( N_noxref_3_c_712_p N_noxref_6_c_1340_n ) capacitor c=0.00201851f \
 //x=3.765 //y=4.88 //x2=4.42 //y2=5.335
cc_686 ( N_noxref_3_c_756_p N_noxref_6_c_1306_n ) capacitor c=0.00359704f \
 //x=4.13 //y=1.595 //x2=4.42 //y2=1.845
cc_687 ( N_noxref_3_c_757_p N_noxref_6_c_1306_n ) capacitor c=0.00457401f \
 //x=4.285 //y=1.44 //x2=4.42 //y2=1.845
cc_688 ( N_noxref_3_c_633_n N_noxref_6_c_1393_n ) capacitor c=0.00628992f \
 //x=9.2 //y=3.51 //x2=4.105 //y2=1.845
cc_689 ( N_noxref_3_c_633_n N_noxref_6_c_1344_n ) capacitor c=0.0260398f \
 //x=9.2 //y=3.51 //x2=4.505 //y2=3.88
cc_690 ( N_noxref_3_c_637_n N_noxref_6_c_1344_n ) capacitor c=0.00179385f \
 //x=3.88 //y=3.51 //x2=4.505 //y2=3.88
cc_691 ( N_noxref_3_c_639_n N_noxref_6_c_1344_n ) capacitor c=0.0831612f \
 //x=3.765 //y=2.26 //x2=4.505 //y2=3.88
cc_692 ( N_noxref_3_c_722_p N_noxref_6_c_1344_n ) capacitor c=0.00877984f \
 //x=3.765 //y=2.26 //x2=4.505 //y2=3.88
cc_693 ( N_noxref_3_c_739_p N_noxref_6_c_1344_n ) capacitor c=0.00283672f \
 //x=3.765 //y=2.095 //x2=4.505 //y2=3.88
cc_694 ( N_noxref_3_c_712_p N_noxref_6_c_1344_n ) capacitor c=0.013693f \
 //x=3.765 //y=4.88 //x2=4.505 //y2=3.88
cc_695 ( N_noxref_3_c_633_n N_noxref_6_c_1307_n ) capacitor c=0.0268062f \
 //x=9.2 //y=3.51 //x2=6.355 //y2=2.26
cc_696 ( N_noxref_3_c_639_n N_noxref_6_c_1307_n ) capacitor c=9.66956e-19 \
 //x=3.765 //y=2.26 //x2=6.355 //y2=2.26
cc_697 ( N_noxref_3_c_639_n N_noxref_6_c_1402_n ) capacitor c=0.0171303f \
 //x=3.765 //y=2.26 //x2=3.725 //y2=5.335
cc_698 ( N_noxref_3_c_712_p N_noxref_6_c_1402_n ) capacitor c=0.00475601f \
 //x=3.765 //y=4.88 //x2=3.725 //y2=5.335
cc_699 ( N_noxref_3_c_658_n N_noxref_6_M22_noxref_g ) capacitor c=0.0213876f \
 //x=6.86 //y=5.335 //x2=6.555 //y2=6.2
cc_700 ( N_noxref_3_c_654_n N_noxref_6_M23_noxref_g ) capacitor c=0.0168349f \
 //x=7.57 //y=5.335 //x2=6.995 //y2=6.2
cc_701 ( N_noxref_3_M22_noxref_d N_noxref_6_M23_noxref_g ) capacitor \
 c=0.0180032f //x=6.63 //y=5.2 //x2=6.995 //y2=6.2
cc_702 ( N_noxref_3_c_658_n N_noxref_6_c_1407_n ) capacitor c=0.00428486f \
 //x=6.86 //y=5.335 //x2=6.92 //y2=4.97
cc_703 ( N_noxref_3_c_734_p N_noxref_6_M2_noxref_d ) capacitor c=0.00217566f \
 //x=3.755 //y=1.095 //x2=3.83 //y2=1.095
cc_704 ( N_noxref_3_c_735_p N_noxref_6_M2_noxref_d ) capacitor c=0.0034598f \
 //x=3.755 //y=1.44 //x2=3.83 //y2=1.095
cc_705 ( N_noxref_3_c_736_p N_noxref_6_M2_noxref_d ) capacitor c=0.00544291f \
 //x=3.755 //y=1.75 //x2=3.83 //y2=1.095
cc_706 ( N_noxref_3_c_776_p N_noxref_6_M2_noxref_d ) capacitor c=0.00241102f \
 //x=4.13 //y=0.94 //x2=3.83 //y2=1.095
cc_707 ( N_noxref_3_c_756_p N_noxref_6_M2_noxref_d ) capacitor c=0.0140297f \
 //x=4.13 //y=1.595 //x2=3.83 //y2=1.095
cc_708 ( N_noxref_3_c_778_p N_noxref_6_M2_noxref_d ) capacitor c=0.00219619f \
 //x=4.285 //y=1.095 //x2=3.83 //y2=1.095
cc_709 ( N_noxref_3_c_757_p N_noxref_6_M2_noxref_d ) capacitor c=0.00603828f \
 //x=4.285 //y=1.44 //x2=3.83 //y2=1.095
cc_710 ( N_noxref_3_c_739_p N_noxref_6_M2_noxref_d ) capacitor c=0.00661782f \
 //x=3.765 //y=2.095 //x2=3.83 //y2=1.095
cc_711 ( N_noxref_3_M20_noxref_g N_noxref_6_M20_noxref_d ) capacitor \
 c=0.0180032f //x=3.505 //y=6.2 //x2=3.58 //y2=5.2
cc_712 ( N_noxref_3_M21_noxref_g N_noxref_6_M20_noxref_d ) capacitor \
 c=0.0194246f //x=3.945 //y=6.2 //x2=3.58 //y2=5.2
cc_713 ( N_noxref_3_c_633_n N_RN_c_1560_n ) capacitor c=0.0139288f //x=9.2 \
 //y=3.51 //x2=16.6 //y2=2.4
cc_714 ( N_noxref_3_c_638_n N_RN_c_1560_n ) capacitor c=0.0541047f //x=11.05 \
 //y=3.51 //x2=16.6 //y2=2.4
cc_715 ( N_noxref_3_c_748_p N_RN_c_1560_n ) capacitor c=0.00680007f //x=9.43 \
 //y=3.51 //x2=16.6 //y2=2.4
cc_716 ( N_noxref_3_c_786_p N_RN_c_1560_n ) capacitor c=0.016327f //x=8.915 \
 //y=1.845 //x2=16.6 //y2=2.4
cc_717 ( N_noxref_3_c_668_n N_RN_c_1560_n ) capacitor c=0.0234656f //x=9.315 \
 //y=3.51 //x2=16.6 //y2=2.4
cc_718 ( N_noxref_3_c_641_n N_RN_c_1560_n ) capacitor c=0.022454f //x=11.165 \
 //y=2.26 //x2=16.6 //y2=2.4
cc_719 ( N_noxref_3_c_646_n N_RN_c_1560_n ) capacitor c=0.00814985f //x=10.97 \
 //y=2.095 //x2=16.6 //y2=2.4
cc_720 ( N_noxref_3_c_633_n N_RN_c_1568_n ) capacitor c=0.00771742f //x=9.2 \
 //y=3.51 //x2=8.69 //y2=2.4
cc_721 ( N_noxref_3_c_668_n N_RN_c_1568_n ) capacitor c=0.00184436f //x=9.315 \
 //y=3.51 //x2=8.69 //y2=2.4
cc_722 ( N_noxref_3_c_668_n RN ) capacitor c=0.00777753f //x=9.315 //y=3.51 \
 //x2=8.63 //y2=2.77
cc_723 ( N_noxref_3_c_633_n RN ) capacitor c=0.00159045f //x=9.2 //y=3.51 \
 //x2=8.63 //y2=3.14
cc_724 ( N_noxref_3_c_664_n RN ) capacitor c=3.18632e-19 //x=9.23 //y=5.335 \
 //x2=8.63 //y2=3.14
cc_725 ( N_noxref_3_c_668_n RN ) capacitor c=0.00777753f //x=9.315 //y=3.51 \
 //x2=8.63 //y2=3.14
cc_726 ( N_noxref_3_c_668_n N_RN_c_1611_n ) capacitor c=0.00952708f //x=9.315 \
 //y=3.51 //x2=8.575 //y2=2.485
cc_727 ( N_noxref_3_c_633_n N_RN_c_1581_n ) capacitor c=0.0217783f //x=9.2 \
 //y=3.51 //x2=8.575 //y2=4.88
cc_728 ( N_noxref_3_c_748_p N_RN_c_1581_n ) capacitor c=0.00131333f //x=9.43 \
 //y=3.51 //x2=8.575 //y2=4.88
cc_729 ( N_noxref_3_c_668_n N_RN_c_1581_n ) capacitor c=0.0468912f //x=9.315 \
 //y=3.51 //x2=8.575 //y2=4.88
cc_730 ( N_noxref_3_c_641_n N_RN_c_1581_n ) capacitor c=5.12611e-19 //x=11.165 \
 //y=2.26 //x2=8.575 //y2=4.88
cc_731 ( N_noxref_3_c_801_p N_RN_c_1581_n ) capacitor c=0.0166016f //x=8.535 \
 //y=5.335 //x2=8.575 //y2=4.88
cc_732 ( N_noxref_3_c_668_n N_RN_c_1577_n ) capacitor c=0.00619366f //x=9.315 \
 //y=3.51 //x2=8.602 //y2=2.685
cc_733 ( N_noxref_3_c_668_n N_RN_c_1618_n ) capacitor c=0.0065098f //x=9.315 \
 //y=3.51 //x2=8.602 //y2=3.055
cc_734 ( N_noxref_3_c_660_n N_RN_M26_noxref_g ) capacitor c=0.01736f //x=8.45 \
 //y=5.335 //x2=8.315 //y2=6.2
cc_735 ( N_noxref_3_M26_noxref_d N_RN_M26_noxref_g ) capacitor c=0.0180032f \
 //x=8.39 //y=5.2 //x2=8.315 //y2=6.2
cc_736 ( N_noxref_3_c_664_n N_RN_M27_noxref_g ) capacitor c=0.0196497f \
 //x=9.23 //y=5.335 //x2=8.755 //y2=6.2
cc_737 ( N_noxref_3_M26_noxref_d N_RN_M27_noxref_g ) capacitor c=0.0194246f \
 //x=8.39 //y=5.2 //x2=8.755 //y2=6.2
cc_738 ( N_noxref_3_M5_noxref_d N_RN_c_1623_n ) capacitor c=0.00217566f \
 //x=8.64 //y=1.095 //x2=8.565 //y2=1.095
cc_739 ( N_noxref_3_M5_noxref_d N_RN_c_1624_n ) capacitor c=0.0034598f \
 //x=8.64 //y=1.095 //x2=8.565 //y2=1.44
cc_740 ( N_noxref_3_M5_noxref_d N_RN_c_1625_n ) capacitor c=0.00546784f \
 //x=8.64 //y=1.095 //x2=8.565 //y2=1.75
cc_741 ( N_noxref_3_M5_noxref_d N_RN_c_1626_n ) capacitor c=0.00241102f \
 //x=8.64 //y=1.095 //x2=8.94 //y2=0.94
cc_742 ( N_noxref_3_c_640_n N_RN_c_1627_n ) capacitor c=0.00371277f //x=9.23 \
 //y=1.845 //x2=8.94 //y2=1.595
cc_743 ( N_noxref_3_M5_noxref_d N_RN_c_1627_n ) capacitor c=0.0138621f \
 //x=8.64 //y=1.095 //x2=8.94 //y2=1.595
cc_744 ( N_noxref_3_M5_noxref_d N_RN_c_1629_n ) capacitor c=0.00219619f \
 //x=8.64 //y=1.095 //x2=9.095 //y2=1.095
cc_745 ( N_noxref_3_c_640_n N_RN_c_1630_n ) capacitor c=0.00457401f //x=9.23 \
 //y=1.845 //x2=9.095 //y2=1.44
cc_746 ( N_noxref_3_M5_noxref_d N_RN_c_1630_n ) capacitor c=0.00603828f \
 //x=8.64 //y=1.095 //x2=9.095 //y2=1.44
cc_747 ( N_noxref_3_c_668_n N_RN_c_1632_n ) capacitor c=0.00780434f //x=9.315 \
 //y=3.51 //x2=8.575 //y2=2.26
cc_748 ( N_noxref_3_c_668_n N_RN_c_1633_n ) capacitor c=0.00283672f //x=9.315 \
 //y=3.51 //x2=8.575 //y2=2.095
cc_749 ( N_noxref_3_M5_noxref_d N_RN_c_1633_n ) capacitor c=0.00661782f \
 //x=8.64 //y=1.095 //x2=8.575 //y2=2.095
cc_750 ( N_noxref_3_c_664_n N_RN_c_1635_n ) capacitor c=0.00201851f //x=9.23 \
 //y=5.335 //x2=8.575 //y2=4.88
cc_751 ( N_noxref_3_c_668_n N_RN_c_1635_n ) capacitor c=0.013844f //x=9.315 \
 //y=3.51 //x2=8.575 //y2=4.88
cc_752 ( N_noxref_3_c_801_p N_RN_c_1635_n ) capacitor c=0.00475601f //x=8.535 \
 //y=5.335 //x2=8.575 //y2=4.88
cc_753 ( N_noxref_3_c_633_n N_noxref_10_c_2170_n ) capacitor c=0.0559995f \
 //x=9.2 //y=3.51 //x2=11.79 //y2=4.25
cc_754 ( N_noxref_3_c_637_n N_noxref_10_c_2170_n ) capacitor c=0.0135672f \
 //x=3.88 //y=3.51 //x2=11.79 //y2=4.25
cc_755 ( N_noxref_3_c_638_n N_noxref_10_c_2170_n ) capacitor c=0.010979f \
 //x=11.05 //y=3.51 //x2=11.79 //y2=4.25
cc_756 ( N_noxref_3_c_748_p N_noxref_10_c_2170_n ) capacitor c=4.80262e-19 \
 //x=9.43 //y=3.51 //x2=11.79 //y2=4.25
cc_757 ( N_noxref_3_c_639_n N_noxref_10_c_2170_n ) capacitor c=0.0206302f \
 //x=3.765 //y=2.26 //x2=11.79 //y2=4.25
cc_758 ( N_noxref_3_c_668_n N_noxref_10_c_2170_n ) capacitor c=0.0181982f \
 //x=9.315 //y=3.51 //x2=11.79 //y2=4.25
cc_759 ( N_noxref_3_c_641_n N_noxref_10_c_2170_n ) capacitor c=0.0184765f \
 //x=11.165 //y=2.26 //x2=11.79 //y2=4.25
cc_760 ( N_noxref_3_c_641_n N_noxref_10_c_2273_n ) capacitor c=0.00179385f \
 //x=11.165 //y=2.26 //x2=12.02 //y2=4.25
cc_761 ( N_noxref_3_c_639_n N_noxref_10_c_2173_n ) capacitor c=0.0017677f \
 //x=3.765 //y=2.26 //x2=1.545 //y2=2.26
cc_762 ( N_noxref_3_c_641_n N_noxref_10_c_2275_n ) capacitor c=0.00400249f \
 //x=11.165 //y=2.26 //x2=11.905 //y2=4.715
cc_763 ( N_noxref_3_c_680_n N_noxref_10_c_2275_n ) capacitor c=0.00417994f \
 //x=11.165 //y=4.88 //x2=11.905 //y2=4.715
cc_764 ( N_noxref_3_c_638_n N_noxref_10_c_2174_n ) capacitor c=0.00318578f \
 //x=11.05 //y=3.51 //x2=11.905 //y2=2.26
cc_765 ( N_noxref_3_c_668_n N_noxref_10_c_2174_n ) capacitor c=9.69022e-19 \
 //x=9.315 //y=3.51 //x2=11.905 //y2=2.26
cc_766 ( N_noxref_3_c_641_n N_noxref_10_c_2174_n ) capacitor c=0.0771626f \
 //x=11.165 //y=2.26 //x2=11.905 //y2=2.26
cc_767 ( N_noxref_3_c_646_n N_noxref_10_c_2174_n ) capacitor c=0.00284029f \
 //x=10.97 //y=2.095 //x2=11.905 //y2=2.26
cc_768 ( N_noxref_3_M28_noxref_g N_noxref_10_M30_noxref_g ) capacitor \
 c=0.0104611f //x=11.065 //y=6.2 //x2=11.945 //y2=6.2
cc_769 ( N_noxref_3_M29_noxref_g N_noxref_10_M30_noxref_g ) capacitor \
 c=0.106811f //x=11.505 //y=6.2 //x2=11.945 //y2=6.2
cc_770 ( N_noxref_3_M29_noxref_g N_noxref_10_M31_noxref_g ) capacitor \
 c=0.0100341f //x=11.505 //y=6.2 //x2=12.385 //y2=6.2
cc_771 ( N_noxref_3_c_642_n N_noxref_10_c_2284_n ) capacitor c=4.86506e-19 \
 //x=10.97 //y=1.045 //x2=11.94 //y2=1.085
cc_772 ( N_noxref_3_c_644_n N_noxref_10_c_2284_n ) capacitor c=0.00152104f \
 //x=10.97 //y=1.39 //x2=11.94 //y2=1.085
cc_773 ( N_noxref_3_c_649_n N_noxref_10_c_2284_n ) capacitor c=0.0151475f \
 //x=11.5 //y=1.045 //x2=11.94 //y2=1.085
cc_774 ( N_noxref_3_c_645_n N_noxref_10_c_2287_n ) capacitor c=0.00109982f \
 //x=10.97 //y=1.7 //x2=11.94 //y2=1.43
cc_775 ( N_noxref_3_c_651_n N_noxref_10_c_2287_n ) capacitor c=0.0111064f \
 //x=11.5 //y=1.39 //x2=11.94 //y2=1.43
cc_776 ( N_noxref_3_c_645_n N_noxref_10_c_2289_n ) capacitor c=9.57794e-19 \
 //x=10.97 //y=1.7 //x2=11.94 //y2=1.74
cc_777 ( N_noxref_3_c_646_n N_noxref_10_c_2289_n ) capacitor c=0.00662747f \
 //x=10.97 //y=2.095 //x2=11.94 //y2=1.74
cc_778 ( N_noxref_3_c_651_n N_noxref_10_c_2289_n ) capacitor c=0.00862358f \
 //x=11.5 //y=1.39 //x2=11.94 //y2=1.74
cc_779 ( N_noxref_3_c_649_n N_noxref_10_c_2292_n ) capacitor c=0.00124821f \
 //x=11.5 //y=1.045 //x2=12.47 //y2=1.085
cc_780 ( N_noxref_3_c_651_n N_noxref_10_c_2293_n ) capacitor c=0.00200715f \
 //x=11.5 //y=1.39 //x2=12.47 //y2=1.43
cc_781 ( N_noxref_3_c_641_n N_noxref_10_c_2294_n ) capacitor c=0.00282278f \
 //x=11.165 //y=2.26 //x2=11.905 //y2=2.26
cc_782 ( N_noxref_3_c_646_n N_noxref_10_c_2294_n ) capacitor c=0.0172771f \
 //x=10.97 //y=2.095 //x2=11.905 //y2=2.26
cc_783 ( N_noxref_3_c_641_n N_noxref_10_c_2296_n ) capacitor c=0.00344981f \
 //x=11.165 //y=2.26 //x2=11.935 //y2=4.88
cc_784 ( N_noxref_3_c_680_n N_noxref_10_c_2296_n ) capacitor c=0.0293367f \
 //x=11.165 //y=4.88 //x2=11.935 //y2=4.88
cc_785 ( N_noxref_3_c_633_n N_noxref_13_c_2720_n ) capacitor c=2.45218e-19 \
 //x=9.2 //y=3.51 //x2=4.42 //y2=0.72
cc_786 ( N_noxref_3_c_639_n N_noxref_13_c_2720_n ) capacitor c=0.00208521f \
 //x=3.765 //y=2.26 //x2=4.42 //y2=0.72
cc_787 ( N_noxref_3_c_734_p N_noxref_13_c_2720_n ) capacitor c=0.0194423f \
 //x=3.755 //y=1.095 //x2=4.42 //y2=0.72
cc_788 ( N_noxref_3_c_778_p N_noxref_13_c_2720_n ) capacitor c=0.00656458f \
 //x=4.285 //y=1.095 //x2=4.42 //y2=0.72
cc_789 ( N_noxref_3_c_722_p N_noxref_13_c_2720_n ) capacitor c=2.20712e-19 \
 //x=3.765 //y=2.26 //x2=4.42 //y2=0.72
cc_790 ( N_noxref_3_c_735_p N_noxref_13_c_2734_n ) capacitor c=0.00538829f \
 //x=3.755 //y=1.44 //x2=3.535 //y2=1.175
cc_791 ( N_noxref_3_c_734_p N_noxref_13_M2_noxref_s ) capacitor c=0.00538829f \
 //x=3.755 //y=1.095 //x2=3.4 //y2=0.555
cc_792 ( N_noxref_3_c_736_p N_noxref_13_M2_noxref_s ) capacitor c=0.00538829f \
 //x=3.755 //y=1.75 //x2=3.4 //y2=0.555
cc_793 ( N_noxref_3_c_778_p N_noxref_13_M2_noxref_s ) capacitor c=0.0143002f \
 //x=4.285 //y=1.095 //x2=3.4 //y2=0.555
cc_794 ( N_noxref_3_c_757_p N_noxref_13_M2_noxref_s ) capacitor c=0.00290153f \
 //x=4.285 //y=1.44 //x2=3.4 //y2=0.555
cc_795 ( N_noxref_3_c_654_n D ) capacitor c=2.11075e-19 //x=7.57 //y=5.335 \
 //x2=7.52 //y2=2.77
cc_796 ( N_noxref_3_c_633_n D ) capacitor c=0.00210908f //x=9.2 //y=3.51 \
 //x2=7.52 //y2=3.14
cc_797 ( N_noxref_3_c_654_n D ) capacitor c=4.68359e-19 //x=7.57 //y=5.335 \
 //x2=7.52 //y2=3.14
cc_798 ( N_noxref_3_c_668_n N_D_c_2768_n ) capacitor c=6.69447e-19 //x=9.315 \
 //y=3.51 //x2=7.465 //y2=2.26
cc_799 ( N_noxref_3_c_633_n N_D_c_2769_n ) capacitor c=0.0242474f //x=9.2 \
 //y=3.51 //x2=7.465 //y2=4.88
cc_800 ( N_noxref_3_c_654_n N_D_c_2769_n ) capacitor c=0.0144268f //x=7.57 \
 //y=5.335 //x2=7.465 //y2=4.88
cc_801 ( N_noxref_3_c_668_n N_D_c_2769_n ) capacitor c=0.00138806f //x=9.315 \
 //y=3.51 //x2=7.465 //y2=4.88
cc_802 ( N_noxref_3_c_654_n N_D_M24_noxref_g ) capacitor c=0.0165266f //x=7.57 \
 //y=5.335 //x2=7.435 //y2=6.2
cc_803 ( N_noxref_3_M24_noxref_d N_D_M24_noxref_g ) capacitor c=0.0180032f \
 //x=7.51 //y=5.2 //x2=7.435 //y2=6.2
cc_804 ( N_noxref_3_c_660_n N_D_M25_noxref_g ) capacitor c=0.01736f //x=8.45 \
 //y=5.335 //x2=7.875 //y2=6.2
cc_805 ( N_noxref_3_M24_noxref_d N_D_M25_noxref_g ) capacitor c=0.0180032f \
 //x=7.51 //y=5.2 //x2=7.875 //y2=6.2
cc_806 ( N_noxref_3_c_876_p N_D_c_2786_n ) capacitor c=0.00424175f //x=7.655 \
 //y=5.335 //x2=7.8 //y2=4.97
cc_807 ( N_noxref_3_c_654_n N_D_c_2787_n ) capacitor c=0.00322054f //x=7.57 \
 //y=5.335 //x2=7.465 //y2=4.88
cc_808 ( N_noxref_3_c_633_n N_noxref_15_c_2873_n ) capacitor c=0.00243521f \
 //x=9.2 //y=3.51 //x2=5.835 //y2=1.685
cc_809 ( N_noxref_3_c_633_n N_noxref_15_c_2857_n ) capacitor c=0.0103731f \
 //x=9.2 //y=3.51 //x2=6.72 //y2=1.77
cc_810 ( N_noxref_3_c_633_n N_noxref_15_c_2875_n ) capacitor c=0.00713063f \
 //x=9.2 //y=3.51 //x2=7.69 //y2=1.77
cc_811 ( N_noxref_3_c_633_n N_noxref_15_M3_noxref_s ) capacitor c=0.00470578f \
 //x=9.2 //y=3.51 //x2=5.7 //y2=0.555
cc_812 ( N_noxref_3_M5_noxref_d N_noxref_15_M3_noxref_s ) capacitor \
 c=0.00309936f //x=8.64 //y=1.095 //x2=5.7 //y2=0.555
cc_813 ( N_noxref_3_c_633_n N_noxref_16_c_2908_n ) capacitor c=0.00306157f \
 //x=9.2 //y=3.51 //x2=8.26 //y2=1.175
cc_814 ( N_noxref_3_c_640_n N_noxref_16_c_2913_n ) capacitor c=0.00457167f \
 //x=9.23 //y=1.845 //x2=9.23 //y2=0.72
cc_815 ( N_noxref_3_M5_noxref_d N_noxref_16_c_2913_n ) capacitor c=0.0115903f \
 //x=8.64 //y=1.095 //x2=9.23 //y2=0.72
cc_816 ( N_noxref_3_c_786_p N_noxref_16_c_2925_n ) capacitor c=0.020048f \
 //x=8.915 //y=1.845 //x2=8.345 //y2=1.175
cc_817 ( N_noxref_3_M5_noxref_d N_noxref_16_M4_noxref_d ) capacitor \
 c=5.27807e-19 //x=8.64 //y=1.095 //x2=7.105 //y2=1.09
cc_818 ( N_noxref_3_c_633_n N_noxref_16_M5_noxref_s ) capacitor c=0.00243521f \
 //x=9.2 //y=3.51 //x2=8.21 //y2=0.555
cc_819 ( N_noxref_3_c_640_n N_noxref_16_M5_noxref_s ) capacitor c=0.0196084f \
 //x=9.23 //y=1.845 //x2=8.21 //y2=0.555
cc_820 ( N_noxref_3_M5_noxref_d N_noxref_16_M5_noxref_s ) capacitor \
 c=0.0426444f //x=8.64 //y=1.095 //x2=8.21 //y2=0.555
cc_821 ( N_noxref_3_c_640_n N_noxref_17_c_2981_n ) capacitor c=3.04182e-19 \
 //x=9.23 //y=1.845 //x2=10.75 //y2=1.675
cc_822 ( N_noxref_3_c_646_n N_noxref_17_c_2981_n ) capacitor c=0.0034165f \
 //x=10.97 //y=2.095 //x2=10.75 //y2=1.675
cc_823 ( N_noxref_3_c_641_n N_noxref_17_c_2962_n ) capacitor c=0.011618f \
 //x=11.165 //y=2.26 //x2=11.635 //y2=1.76
cc_824 ( N_noxref_3_c_645_n N_noxref_17_c_2962_n ) capacitor c=0.00696403f \
 //x=10.97 //y=1.7 //x2=11.635 //y2=1.76
cc_825 ( N_noxref_3_c_646_n N_noxref_17_c_2962_n ) capacitor c=0.0174694f \
 //x=10.97 //y=2.095 //x2=11.635 //y2=1.76
cc_826 ( N_noxref_3_c_648_n N_noxref_17_c_2962_n ) capacitor c=0.00776811f \
 //x=11.345 //y=1.545 //x2=11.635 //y2=1.76
cc_827 ( N_noxref_3_c_651_n N_noxref_17_c_2962_n ) capacitor c=0.00339872f \
 //x=11.5 //y=1.39 //x2=11.635 //y2=1.76
cc_828 ( N_noxref_3_c_646_n N_noxref_17_c_2969_n ) capacitor c=6.71402e-19 \
 //x=10.97 //y=2.095 //x2=11.72 //y2=1.675
cc_829 ( N_noxref_3_c_642_n N_noxref_17_M6_noxref_s ) capacitor c=0.0327502f \
 //x=10.97 //y=1.045 //x2=10.615 //y2=0.545
cc_830 ( N_noxref_3_c_645_n N_noxref_17_M6_noxref_s ) capacitor c=3.48408e-19 \
 //x=10.97 //y=1.7 //x2=10.615 //y2=0.545
cc_831 ( N_noxref_3_c_649_n N_noxref_17_M6_noxref_s ) capacitor c=0.0120759f \
 //x=11.5 //y=1.045 //x2=10.615 //y2=0.545
cc_832 ( N_noxref_4_c_919_n N_CLK_c_1053_n ) capacitor c=0.0185297f //x=12.08 \
 //y=5.38 //x2=15.49 //y2=4.62
cc_833 ( N_noxref_4_c_923_n N_CLK_c_1053_n ) capacitor c=0.018142f //x=11.37 \
 //y=5.38 //x2=15.49 //y2=4.62
cc_834 ( N_noxref_4_c_904_n N_CLK_c_1053_n ) capacitor c=0.0208321f //x=12.645 \
 //y=3.51 //x2=15.49 //y2=4.62
cc_835 ( N_noxref_4_c_905_n N_CLK_c_1053_n ) capacitor c=0.0224037f //x=14.495 \
 //y=2.26 //x2=15.49 //y2=4.62
cc_836 ( N_noxref_4_c_937_n N_CLK_c_1053_n ) capacitor c=0.0168539f //x=14.77 \
 //y=4.97 //x2=15.49 //y2=4.62
cc_837 ( N_noxref_4_c_902_n CLK ) capacitor c=0.00447621f //x=14.38 //y=3.51 \
 //x2=15.66 //y2=3.51
cc_838 ( N_noxref_4_c_905_n N_CLK_c_1052_n ) capacitor c=0.0467784f //x=14.495 \
 //y=2.26 //x2=15.605 //y2=2.26
cc_839 ( N_noxref_4_c_910_n N_CLK_c_1052_n ) capacitor c=0.00210802f \
 //x=14.195 //y=2.095 //x2=15.605 //y2=2.26
cc_840 ( N_noxref_4_c_966_p N_CLK_c_1072_n ) capacitor c=0.00147352f //x=15.06 \
 //y=4.97 //x2=15.605 //y2=4.88
cc_841 ( N_noxref_4_c_937_n N_CLK_c_1072_n ) capacitor c=0.00141297f //x=14.77 \
 //y=4.97 //x2=15.605 //y2=4.88
cc_842 ( N_noxref_4_c_904_n N_CLK_c_1132_n ) capacitor c=5.81655e-19 \
 //x=12.645 //y=3.51 //x2=15.632 //y2=3.055
cc_843 ( N_noxref_4_c_902_n N_CLK_c_1133_n ) capacitor c=4.93861e-19 //x=14.38 \
 //y=3.51 //x2=15.632 //y2=3.425
cc_844 ( N_noxref_4_c_902_n N_CLK_c_1074_n ) capacitor c=4.93861e-19 //x=14.38 \
 //y=3.51 //x2=15.632 //y2=4.535
cc_845 ( N_noxref_4_M32_noxref_g N_CLK_M34_noxref_g ) capacitor c=0.0105869f \
 //x=14.695 //y=6.2 //x2=15.575 //y2=6.2
cc_846 ( N_noxref_4_M33_noxref_g N_CLK_M34_noxref_g ) capacitor c=0.10632f \
 //x=15.135 //y=6.2 //x2=15.575 //y2=6.2
cc_847 ( N_noxref_4_M33_noxref_g N_CLK_M35_noxref_g ) capacitor c=0.0101598f \
 //x=15.135 //y=6.2 //x2=16.015 //y2=6.2
cc_848 ( N_noxref_4_c_906_n N_CLK_c_1138_n ) capacitor c=5.72482e-19 \
 //x=14.195 //y=1.055 //x2=15.17 //y2=1.09
cc_849 ( N_noxref_4_c_908_n N_CLK_c_1138_n ) capacitor c=0.00149976f \
 //x=14.195 //y=1.4 //x2=15.17 //y2=1.09
cc_850 ( N_noxref_4_c_913_n N_CLK_c_1138_n ) capacitor c=0.0160123f //x=14.725 \
 //y=1.055 //x2=15.17 //y2=1.09
cc_851 ( N_noxref_4_c_909_n N_CLK_c_1141_n ) capacitor c=0.00111227f \
 //x=14.195 //y=1.71 //x2=15.17 //y2=1.4
cc_852 ( N_noxref_4_c_915_n N_CLK_c_1141_n ) capacitor c=0.0124075f //x=14.725 \
 //y=1.4 //x2=15.17 //y2=1.4
cc_853 ( N_noxref_4_c_913_n N_CLK_c_1143_n ) capacitor c=0.00103227f \
 //x=14.725 //y=1.055 //x2=15.695 //y2=1.09
cc_854 ( N_noxref_4_c_915_n N_CLK_c_1144_n ) capacitor c=0.0010154f //x=14.725 \
 //y=1.4 //x2=15.695 //y2=1.4
cc_855 ( N_noxref_4_c_915_n N_CLK_c_1145_n ) capacitor c=9.23422e-19 \
 //x=14.725 //y=1.4 //x2=15.695 //y2=1.63
cc_856 ( N_noxref_4_c_905_n N_CLK_c_1146_n ) capacitor c=0.00203769f \
 //x=14.495 //y=2.26 //x2=15.695 //y2=2.095
cc_857 ( N_noxref_4_c_910_n N_CLK_c_1146_n ) capacitor c=0.00834532f \
 //x=14.195 //y=2.095 //x2=15.695 //y2=2.095
cc_858 ( N_noxref_4_c_905_n N_CLK_c_1148_n ) capacitor c=0.00183762f \
 //x=14.495 //y=2.26 //x2=15.605 //y2=4.88
cc_859 ( N_noxref_4_c_966_p N_CLK_c_1148_n ) capacitor c=0.0168581f //x=15.06 \
 //y=4.97 //x2=15.605 //y2=4.88
cc_860 ( N_noxref_4_c_937_n N_CLK_c_1148_n ) capacitor c=0.00484466f //x=14.77 \
 //y=4.97 //x2=15.605 //y2=4.88
cc_861 ( N_noxref_4_c_902_n N_noxref_6_c_1305_n ) capacitor c=0.176049f \
 //x=14.38 //y=3.51 //x2=19.19 //y2=3.88
cc_862 ( N_noxref_4_c_950_n N_noxref_6_c_1305_n ) capacitor c=0.0293967f \
 //x=12.76 //y=3.51 //x2=19.19 //y2=3.88
cc_863 ( N_noxref_4_c_904_n N_noxref_6_c_1305_n ) capacitor c=0.0206034f \
 //x=12.645 //y=3.51 //x2=19.19 //y2=3.88
cc_864 ( N_noxref_4_c_905_n N_noxref_6_c_1305_n ) capacitor c=0.0216236f \
 //x=14.495 //y=2.26 //x2=19.19 //y2=3.88
cc_865 ( N_noxref_4_c_902_n N_RN_c_1560_n ) capacitor c=0.0546488f //x=14.38 \
 //y=3.51 //x2=16.6 //y2=2.4
cc_866 ( N_noxref_4_c_950_n N_RN_c_1560_n ) capacitor c=0.00761783f //x=12.76 \
 //y=3.51 //x2=16.6 //y2=2.4
cc_867 ( N_noxref_4_c_993_p N_RN_c_1560_n ) capacitor c=0.0146822f //x=12.29 \
 //y=1.835 //x2=16.6 //y2=2.4
cc_868 ( N_noxref_4_c_904_n N_RN_c_1560_n ) capacitor c=0.0238578f //x=12.645 \
 //y=3.51 //x2=16.6 //y2=2.4
cc_869 ( N_noxref_4_c_905_n N_RN_c_1560_n ) capacitor c=0.0232222f //x=14.495 \
 //y=2.26 //x2=16.6 //y2=2.4
cc_870 ( N_noxref_4_c_910_n N_RN_c_1560_n ) capacitor c=0.0104117f //x=14.195 \
 //y=2.095 //x2=16.6 //y2=2.4
cc_871 ( N_noxref_4_c_905_n N_RN_c_1578_n ) capacitor c=0.00130162f //x=14.495 \
 //y=2.26 //x2=16.742 //y2=2.685
cc_872 ( N_noxref_4_c_902_n N_noxref_10_c_2197_n ) capacitor c=0.0107156f \
 //x=14.38 //y=3.51 //x2=17.34 //y2=4.25
cc_873 ( N_noxref_4_c_950_n N_noxref_10_c_2197_n ) capacitor c=8.88358e-19 \
 //x=12.76 //y=3.51 //x2=17.34 //y2=4.25
cc_874 ( N_noxref_4_c_904_n N_noxref_10_c_2197_n ) capacitor c=0.0181936f \
 //x=12.645 //y=3.51 //x2=17.34 //y2=4.25
cc_875 ( N_noxref_4_c_905_n N_noxref_10_c_2197_n ) capacitor c=0.019517f \
 //x=14.495 //y=2.26 //x2=17.34 //y2=4.25
cc_876 ( N_noxref_4_c_904_n N_noxref_10_c_2273_n ) capacitor c=0.00179385f \
 //x=12.645 //y=3.51 //x2=12.02 //y2=4.25
cc_877 ( N_noxref_4_c_919_n N_noxref_10_c_2275_n ) capacitor c=0.0127164f \
 //x=12.08 //y=5.38 //x2=11.905 //y2=4.715
cc_878 ( N_noxref_4_c_904_n N_noxref_10_c_2275_n ) capacitor c=0.0101115f \
 //x=12.645 //y=3.51 //x2=11.905 //y2=4.715
cc_879 ( N_noxref_4_c_950_n N_noxref_10_c_2174_n ) capacitor c=0.00329059f \
 //x=12.76 //y=3.51 //x2=11.905 //y2=2.26
cc_880 ( N_noxref_4_c_904_n N_noxref_10_c_2174_n ) capacitor c=0.0721848f \
 //x=12.645 //y=3.51 //x2=11.905 //y2=2.26
cc_881 ( N_noxref_4_c_905_n N_noxref_10_c_2174_n ) capacitor c=9.69022e-19 \
 //x=14.495 //y=2.26 //x2=11.905 //y2=2.26
cc_882 ( N_noxref_4_M33_noxref_g N_noxref_10_c_2218_n ) capacitor c=0.0168349f \
 //x=15.135 //y=6.2 //x2=15.71 //y2=5.335
cc_883 ( N_noxref_4_c_904_n N_noxref_10_c_2222_n ) capacitor c=2.97874e-19 \
 //x=12.645 //y=3.51 //x2=15 //y2=5.335
cc_884 ( N_noxref_4_M32_noxref_g N_noxref_10_c_2222_n ) capacitor c=0.0213876f \
 //x=14.695 //y=6.2 //x2=15 //y2=5.335
cc_885 ( N_noxref_4_c_966_p N_noxref_10_c_2222_n ) capacitor c=0.00428486f \
 //x=15.06 //y=4.97 //x2=15 //y2=5.335
cc_886 ( N_noxref_4_c_919_n N_noxref_10_M30_noxref_g ) capacitor c=0.0166421f \
 //x=12.08 //y=5.38 //x2=11.945 //y2=6.2
cc_887 ( N_noxref_4_M30_noxref_d N_noxref_10_M30_noxref_g ) capacitor \
 c=0.0173476f //x=12.02 //y=5.2 //x2=11.945 //y2=6.2
cc_888 ( N_noxref_4_c_925_n N_noxref_10_M31_noxref_g ) capacitor c=0.018922f \
 //x=12.56 //y=5.38 //x2=12.385 //y2=6.2
cc_889 ( N_noxref_4_M30_noxref_d N_noxref_10_M31_noxref_g ) capacitor \
 c=0.0179769f //x=12.02 //y=5.2 //x2=12.385 //y2=6.2
cc_890 ( N_noxref_4_M7_noxref_d N_noxref_10_c_2284_n ) capacitor c=0.00217566f \
 //x=12.015 //y=1.085 //x2=11.94 //y2=1.085
cc_891 ( N_noxref_4_M7_noxref_d N_noxref_10_c_2287_n ) capacitor c=0.0034598f \
 //x=12.015 //y=1.085 //x2=11.94 //y2=1.43
cc_892 ( N_noxref_4_M7_noxref_d N_noxref_10_c_2289_n ) capacitor c=0.00669531f \
 //x=12.015 //y=1.085 //x2=11.94 //y2=1.74
cc_893 ( N_noxref_4_c_904_n N_noxref_10_c_2319_n ) capacitor c=0.0142673f \
 //x=12.645 //y=3.51 //x2=12.31 //y2=4.97
cc_894 ( N_noxref_4_c_1020_p N_noxref_10_c_2319_n ) capacitor c=0.00407665f \
 //x=12.165 //y=5.38 //x2=12.31 //y2=4.97
cc_895 ( N_noxref_4_M7_noxref_d N_noxref_10_c_2321_n ) capacitor c=0.00241102f \
 //x=12.015 //y=1.085 //x2=12.315 //y2=0.93
cc_896 ( N_noxref_4_c_903_n N_noxref_10_c_2322_n ) capacitor c=0.00371277f \
 //x=12.56 //y=1.835 //x2=12.315 //y2=1.585
cc_897 ( N_noxref_4_M7_noxref_d N_noxref_10_c_2322_n ) capacitor c=0.0137169f \
 //x=12.015 //y=1.085 //x2=12.315 //y2=1.585
cc_898 ( N_noxref_4_M7_noxref_d N_noxref_10_c_2292_n ) capacitor c=0.00132245f \
 //x=12.015 //y=1.085 //x2=12.47 //y2=1.085
cc_899 ( N_noxref_4_c_903_n N_noxref_10_c_2293_n ) capacitor c=0.00457401f \
 //x=12.56 //y=1.835 //x2=12.47 //y2=1.43
cc_900 ( N_noxref_4_M7_noxref_d N_noxref_10_c_2293_n ) capacitor c=0.00566463f \
 //x=12.015 //y=1.085 //x2=12.47 //y2=1.43
cc_901 ( N_noxref_4_c_904_n N_noxref_10_c_2294_n ) capacitor c=0.00731987f \
 //x=12.645 //y=3.51 //x2=11.905 //y2=2.26
cc_902 ( N_noxref_4_c_904_n N_noxref_10_c_2328_n ) capacitor c=0.00306024f \
 //x=12.645 //y=3.51 //x2=11.905 //y2=2.095
cc_903 ( N_noxref_4_M7_noxref_d N_noxref_10_c_2328_n ) capacitor c=0.00660593f \
 //x=12.015 //y=1.085 //x2=11.905 //y2=2.095
cc_904 ( N_noxref_4_c_919_n N_noxref_10_c_2296_n ) capacitor c=0.00346527f \
 //x=12.08 //y=5.38 //x2=11.935 //y2=4.88
cc_905 ( N_noxref_4_c_904_n N_noxref_10_c_2296_n ) capacitor c=0.00517969f \
 //x=12.645 //y=3.51 //x2=11.935 //y2=4.88
cc_906 ( N_noxref_4_M33_noxref_g N_noxref_10_M32_noxref_d ) capacitor \
 c=0.0180032f //x=15.135 //y=6.2 //x2=14.77 //y2=5.2
cc_907 ( N_noxref_4_c_993_p N_noxref_17_c_2981_n ) capacitor c=3.15806e-19 \
 //x=12.29 //y=1.835 //x2=10.75 //y2=1.675
cc_908 ( N_noxref_4_c_993_p N_noxref_17_c_2969_n ) capacitor c=0.020324f \
 //x=12.29 //y=1.835 //x2=11.72 //y2=1.675
cc_909 ( N_noxref_4_c_903_n N_noxref_17_c_2970_n ) capacitor c=0.00457164f \
 //x=12.56 //y=1.835 //x2=12.605 //y2=0.71
cc_910 ( N_noxref_4_M7_noxref_d N_noxref_17_c_2970_n ) capacitor c=0.0115831f \
 //x=12.015 //y=1.085 //x2=12.605 //y2=0.71
cc_911 ( N_noxref_4_c_903_n N_noxref_17_M6_noxref_s ) capacitor c=0.013435f \
 //x=12.56 //y=1.835 //x2=10.615 //y2=0.545
cc_912 ( N_noxref_4_M7_noxref_d N_noxref_17_M6_noxref_s ) capacitor \
 c=0.0439476f //x=12.015 //y=1.085 //x2=10.615 //y2=0.545
cc_913 ( N_noxref_4_c_903_n N_noxref_18_c_3030_n ) capacitor c=4.08644e-19 \
 //x=12.56 //y=1.835 //x2=13.975 //y2=1.685
cc_914 ( N_noxref_4_c_910_n N_noxref_18_c_3030_n ) capacitor c=0.0034165f \
 //x=14.195 //y=2.095 //x2=13.975 //y2=1.685
cc_915 ( N_noxref_4_c_905_n N_noxref_18_c_3014_n ) capacitor c=0.0115578f \
 //x=14.495 //y=2.26 //x2=14.86 //y2=1.77
cc_916 ( N_noxref_4_c_909_n N_noxref_18_c_3014_n ) capacitor c=0.00697148f \
 //x=14.195 //y=1.71 //x2=14.86 //y2=1.77
cc_917 ( N_noxref_4_c_910_n N_noxref_18_c_3014_n ) capacitor c=0.0204849f \
 //x=14.195 //y=2.095 //x2=14.86 //y2=1.77
cc_918 ( N_noxref_4_c_912_n N_noxref_18_c_3014_n ) capacitor c=0.00610316f \
 //x=14.57 //y=1.555 //x2=14.86 //y2=1.77
cc_919 ( N_noxref_4_c_915_n N_noxref_18_c_3014_n ) capacitor c=0.00698822f \
 //x=14.725 //y=1.4 //x2=14.86 //y2=1.77
cc_920 ( N_noxref_4_c_906_n N_noxref_18_M8_noxref_s ) capacitor c=0.0327271f \
 //x=14.195 //y=1.055 //x2=13.84 //y2=0.555
cc_921 ( N_noxref_4_c_909_n N_noxref_18_M8_noxref_s ) capacitor c=7.99997e-19 \
 //x=14.195 //y=1.71 //x2=13.84 //y2=0.555
cc_922 ( N_noxref_4_c_910_n N_noxref_18_M8_noxref_s ) capacitor c=0.00122123f \
 //x=14.195 //y=2.095 //x2=13.84 //y2=0.555
cc_923 ( N_noxref_4_c_913_n N_noxref_18_M8_noxref_s ) capacitor c=0.0121427f \
 //x=14.725 //y=1.055 //x2=13.84 //y2=0.555
cc_924 ( N_noxref_4_M7_noxref_d N_noxref_18_M8_noxref_s ) capacitor \
 c=2.53688e-19 //x=12.015 //y=1.085 //x2=13.84 //y2=0.555
cc_925 ( N_CLK_c_1053_n N_noxref_6_c_1378_n ) capacitor c=0.00910993f \
 //x=15.49 //y=4.62 //x2=6.24 //y2=3.88
cc_926 ( N_CLK_c_1053_n N_noxref_6_c_1379_n ) capacitor c=7.95009e-19 \
 //x=15.49 //y=4.62 //x2=4.62 //y2=3.88
cc_927 ( N_CLK_c_1053_n N_noxref_6_c_1305_n ) capacitor c=0.0665157f //x=15.49 \
 //y=4.62 //x2=19.19 //y2=3.88
cc_928 ( CLK N_noxref_6_c_1305_n ) capacitor c=0.00139768f //x=15.66 //y=3.51 \
 //x2=19.19 //y2=3.88
cc_929 ( N_CLK_c_1074_n N_noxref_6_c_1305_n ) capacitor c=0.0238781f \
 //x=15.632 //y=4.535 //x2=19.19 //y2=3.88
cc_930 ( N_CLK_c_1053_n N_noxref_6_c_1386_n ) capacitor c=6.59178e-19 \
 //x=15.49 //y=4.62 //x2=6.47 //y2=3.88
cc_931 ( N_CLK_c_1070_n N_noxref_6_c_1330_n ) capacitor c=0.00283946f //x=2.77 \
 //y=4.62 //x2=2.76 //y2=5.335
cc_932 ( CLK N_noxref_6_c_1330_n ) capacitor c=0.00132827f //x=2.71 //y=4.62 \
 //x2=2.76 //y2=5.335
cc_933 ( N_CLK_c_1071_n N_noxref_6_c_1330_n ) capacitor c=0.014564f //x=2.655 \
 //y=4.88 //x2=2.76 //y2=5.335
cc_934 ( N_CLK_M18_noxref_g N_noxref_6_c_1330_n ) capacitor c=0.016514f \
 //x=2.625 //y=6.2 //x2=2.76 //y2=5.335
cc_935 ( N_CLK_c_1120_n N_noxref_6_c_1330_n ) capacitor c=0.00322046f \
 //x=2.655 //y=4.88 //x2=2.76 //y2=5.335
cc_936 ( N_CLK_M19_noxref_g N_noxref_6_c_1336_n ) capacitor c=0.01736f \
 //x=3.065 //y=6.2 //x2=3.64 //y2=5.335
cc_937 ( N_CLK_c_1053_n N_noxref_6_c_1340_n ) capacitor c=0.0183122f //x=15.49 \
 //y=4.62 //x2=4.42 //y2=5.335
cc_938 ( N_CLK_c_1053_n N_noxref_6_c_1344_n ) capacitor c=0.0210274f //x=15.49 \
 //y=4.62 //x2=4.505 //y2=3.88
cc_939 ( N_CLK_c_1051_n N_noxref_6_c_1344_n ) capacitor c=8.06137e-19 \
 //x=2.655 //y=2.26 //x2=4.505 //y2=3.88
cc_940 ( N_CLK_c_1105_n N_noxref_6_c_1344_n ) capacitor c=2.32128e-19 \
 //x=2.682 //y=3.425 //x2=4.505 //y2=3.88
cc_941 ( N_CLK_c_1107_n N_noxref_6_c_1344_n ) capacitor c=2.37933e-19 \
 //x=2.682 //y=3.795 //x2=4.505 //y2=3.88
cc_942 ( N_CLK_c_1073_n N_noxref_6_c_1344_n ) capacitor c=4.67028e-19 \
 //x=2.682 //y=4.535 //x2=4.505 //y2=3.88
cc_943 ( N_CLK_c_1053_n N_noxref_6_c_1307_n ) capacitor c=0.0208709f //x=15.49 \
 //y=4.62 //x2=6.355 //y2=2.26
cc_944 ( N_CLK_c_1053_n N_noxref_6_c_1441_n ) capacitor c=0.03056f //x=15.49 \
 //y=4.62 //x2=2.845 //y2=5.335
cc_945 ( N_CLK_c_1119_n N_noxref_6_c_1441_n ) capacitor c=0.00419184f //x=2.99 \
 //y=4.97 //x2=2.845 //y2=5.335
cc_946 ( N_CLK_c_1053_n N_noxref_6_c_1359_n ) capacitor c=0.0166984f //x=15.49 \
 //y=4.62 //x2=6.63 //y2=4.97
cc_947 ( N_CLK_M18_noxref_g N_noxref_6_M18_noxref_d ) capacitor c=0.0180032f \
 //x=2.625 //y=6.2 //x2=2.7 //y2=5.2
cc_948 ( N_CLK_M19_noxref_g N_noxref_6_M18_noxref_d ) capacitor c=0.0180032f \
 //x=3.065 //y=6.2 //x2=2.7 //y2=5.2
cc_949 ( CLK N_RN_c_1560_n ) capacitor c=0.0013444f //x=15.66 //y=2.77 \
 //x2=16.6 //y2=2.4
cc_950 ( N_CLK_c_1052_n N_RN_c_1560_n ) capacitor c=0.0242349f //x=15.605 \
 //y=2.26 //x2=16.6 //y2=2.4
cc_951 ( N_CLK_c_1146_n N_RN_c_1560_n ) capacitor c=0.00565213f //x=15.695 \
 //y=2.095 //x2=16.6 //y2=2.4
cc_952 ( N_CLK_c_1052_n N_RN_c_1574_n ) capacitor c=0.00165648f //x=15.605 \
 //y=2.26 //x2=16.83 //y2=2.4
cc_953 ( N_CLK_c_1146_n N_RN_c_1574_n ) capacitor c=2.3323e-19 //x=15.695 \
 //y=2.095 //x2=16.83 //y2=2.4
cc_954 ( CLK RN ) capacitor c=0.00505269f //x=15.66 //y=2.77 //x2=16.77 \
 //y2=2.77
cc_955 ( CLK RN ) capacitor c=0.00505269f //x=15.66 //y=3.14 //x2=16.77 \
 //y2=3.14
cc_956 ( CLK RN ) capacitor c=0.0048331f //x=15.66 //y=3.51 //x2=16.77 //y2=3.51
cc_957 ( N_CLK_c_1053_n RN ) capacitor c=0.00285792f //x=15.49 //y=4.62 \
 //x2=16.77 //y2=4.62
cc_958 ( CLK RN ) capacitor c=0.00285704f //x=15.66 //y=4.62 //x2=16.77 \
 //y2=4.62
cc_959 ( N_CLK_c_1053_n N_RN_c_1581_n ) capacitor c=0.0200057f //x=15.49 \
 //y=4.62 //x2=8.575 //y2=4.88
cc_960 ( N_CLK_c_1052_n N_RN_c_1656_n ) capacitor c=0.00785277f //x=15.605 \
 //y=2.26 //x2=16.715 //y2=2.485
cc_961 ( N_CLK_c_1146_n N_RN_c_1656_n ) capacitor c=0.00204105f //x=15.695 \
 //y=2.095 //x2=16.715 //y2=2.485
cc_962 ( N_CLK_c_1053_n N_RN_c_1582_n ) capacitor c=8.81198e-19 //x=15.49 \
 //y=4.62 //x2=16.715 //y2=4.88
cc_963 ( N_CLK_c_1072_n N_RN_c_1582_n ) capacitor c=0.00466391f //x=15.605 \
 //y=4.88 //x2=16.715 //y2=4.88
cc_964 ( N_CLK_c_1148_n N_RN_c_1582_n ) capacitor c=0.00142741f //x=15.605 \
 //y=4.88 //x2=16.715 //y2=4.88
cc_965 ( N_CLK_c_1132_n N_RN_c_1661_n ) capacitor c=0.00419471f //x=15.632 \
 //y=3.055 //x2=16.742 //y2=3.055
cc_966 ( N_CLK_c_1133_n N_RN_c_1662_n ) capacitor c=0.00416057f //x=15.632 \
 //y=3.425 //x2=16.742 //y2=3.425
cc_967 ( N_CLK_c_1053_n N_RN_c_1584_n ) capacitor c=6.33859e-19 //x=15.49 \
 //y=4.62 //x2=16.742 //y2=4.535
cc_968 ( N_CLK_c_1074_n N_RN_c_1584_n ) capacitor c=0.0147426f //x=15.632 \
 //y=4.535 //x2=16.742 //y2=4.535
cc_969 ( N_CLK_M34_noxref_g N_RN_M36_noxref_g ) capacitor c=0.0101598f \
 //x=15.575 //y=6.2 //x2=16.455 //y2=6.2
cc_970 ( N_CLK_M35_noxref_g N_RN_M36_noxref_g ) capacitor c=0.0602553f \
 //x=16.015 //y=6.2 //x2=16.455 //y2=6.2
cc_971 ( N_CLK_M35_noxref_g N_RN_M37_noxref_g ) capacitor c=0.0101598f \
 //x=16.015 //y=6.2 //x2=16.895 //y2=6.2
cc_972 ( N_CLK_c_1143_n N_RN_c_1668_n ) capacitor c=0.00456962f //x=15.695 \
 //y=1.09 //x2=16.705 //y2=1.095
cc_973 ( N_CLK_c_1144_n N_RN_c_1669_n ) capacitor c=0.00438372f //x=15.695 \
 //y=1.4 //x2=16.705 //y2=1.44
cc_974 ( N_CLK_c_1145_n N_RN_c_1670_n ) capacitor c=0.00438372f //x=15.695 \
 //y=1.63 //x2=16.705 //y2=1.75
cc_975 ( N_CLK_c_1053_n N_RN_c_1635_n ) capacitor c=0.0111881f //x=15.49 \
 //y=4.62 //x2=8.575 //y2=4.88
cc_976 ( N_CLK_c_1052_n N_RN_c_1672_n ) capacitor c=0.00201097f //x=15.605 \
 //y=2.26 //x2=16.715 //y2=2.26
cc_977 ( N_CLK_c_1146_n N_RN_c_1672_n ) capacitor c=0.00828003f //x=15.695 \
 //y=2.095 //x2=16.715 //y2=2.26
cc_978 ( N_CLK_c_1146_n N_RN_c_1674_n ) capacitor c=0.00438372f //x=15.695 \
 //y=2.095 //x2=16.715 //y2=2.095
cc_979 ( N_CLK_c_1072_n N_RN_c_1675_n ) capacitor c=0.00218014f //x=15.605 \
 //y=4.88 //x2=16.715 //y2=4.88
cc_980 ( N_CLK_c_1206_p N_RN_c_1675_n ) capacitor c=0.0611812f //x=15.94 \
 //y=4.97 //x2=16.715 //y2=4.88
cc_981 ( N_CLK_c_1148_n N_RN_c_1675_n ) capacitor c=0.00487508f //x=15.605 \
 //y=4.88 //x2=16.715 //y2=4.88
cc_982 ( N_CLK_c_1053_n N_noxref_10_c_2170_n ) capacitor c=0.784218f //x=15.49 \
 //y=4.62 //x2=11.79 //y2=4.25
cc_983 ( N_CLK_c_1070_n N_noxref_10_c_2170_n ) capacitor c=0.02921f //x=2.77 \
 //y=4.62 //x2=11.79 //y2=4.25
cc_984 ( CLK N_noxref_10_c_2170_n ) capacitor c=0.00161863f //x=2.71 //y=3.88 \
 //x2=11.79 //y2=4.25
cc_985 ( CLK N_noxref_10_c_2170_n ) capacitor c=0.00263824f //x=2.71 //y=4.62 \
 //x2=11.79 //y2=4.25
cc_986 ( N_CLK_c_1073_n N_noxref_10_c_2170_n ) capacitor c=0.0245142f \
 //x=2.682 //y=4.535 //x2=11.79 //y2=4.25
cc_987 ( N_CLK_c_1120_n N_noxref_10_c_2170_n ) capacitor c=3.07672e-19 \
 //x=2.655 //y=4.88 //x2=11.79 //y2=4.25
cc_988 ( N_CLK_c_1073_n N_noxref_10_c_2171_n ) capacitor c=0.00128547f \
 //x=2.682 //y=4.535 //x2=1.66 //y2=4.25
cc_989 ( N_CLK_c_1053_n N_noxref_10_c_2197_n ) capacitor c=0.331495f //x=15.49 \
 //y=4.62 //x2=17.34 //y2=4.25
cc_990 ( CLK N_noxref_10_c_2197_n ) capacitor c=0.00237739f //x=15.66 //y=4.62 \
 //x2=17.34 //y2=4.25
cc_991 ( N_CLK_c_1074_n N_noxref_10_c_2197_n ) capacitor c=0.0187802f \
 //x=15.632 //y=4.535 //x2=17.34 //y2=4.25
cc_992 ( N_CLK_c_1206_p N_noxref_10_c_2197_n ) capacitor c=0.00669203f \
 //x=15.94 //y=4.97 //x2=17.34 //y2=4.25
cc_993 ( N_CLK_c_1053_n N_noxref_10_c_2273_n ) capacitor c=0.0263375f \
 //x=15.49 //y=4.62 //x2=12.02 //y2=4.25
cc_994 ( N_CLK_c_1070_n N_noxref_10_c_2173_n ) capacitor c=0.00551083f \
 //x=2.77 //y=4.62 //x2=1.545 //y2=2.26
cc_995 ( N_CLK_c_1051_n N_noxref_10_c_2173_n ) capacitor c=0.0534679f \
 //x=2.655 //y=2.26 //x2=1.545 //y2=2.26
cc_996 ( N_CLK_c_1116_n N_noxref_10_c_2173_n ) capacitor c=0.00231304f \
 //x=2.745 //y=2.095 //x2=1.545 //y2=2.26
cc_997 ( N_CLK_c_1120_n N_noxref_10_c_2173_n ) capacitor c=0.00183762f \
 //x=2.655 //y=4.88 //x2=1.545 //y2=2.26
cc_998 ( N_CLK_c_1053_n N_noxref_10_c_2275_n ) capacitor c=0.0016972f \
 //x=15.49 //y=4.62 //x2=11.905 //y2=4.715
cc_999 ( N_CLK_c_1053_n N_noxref_10_c_2174_n ) capacitor c=0.0207534f \
 //x=15.49 //y=4.62 //x2=11.905 //y2=2.26
cc_1000 ( N_CLK_c_1053_n N_noxref_10_c_2218_n ) capacitor c=0.00195615f \
 //x=15.49 //y=4.62 //x2=15.71 //y2=5.335
cc_1001 ( CLK N_noxref_10_c_2218_n ) capacitor c=0.00133827f //x=15.66 \
 //y=4.62 //x2=15.71 //y2=5.335
cc_1002 ( N_CLK_c_1072_n N_noxref_10_c_2218_n ) capacitor c=0.0143918f \
 //x=15.605 //y=4.88 //x2=15.71 //y2=5.335
cc_1003 ( N_CLK_M34_noxref_g N_noxref_10_c_2218_n ) capacitor c=0.016514f \
 //x=15.575 //y=6.2 //x2=15.71 //y2=5.335
cc_1004 ( N_CLK_c_1148_n N_noxref_10_c_2218_n ) capacitor c=0.00322046f \
 //x=15.605 //y=4.88 //x2=15.71 //y2=5.335
cc_1005 ( N_CLK_c_1053_n N_noxref_10_c_2222_n ) capacitor c=0.0219114f \
 //x=15.49 //y=4.62 //x2=15 //y2=5.335
cc_1006 ( N_CLK_M35_noxref_g N_noxref_10_c_2224_n ) capacitor c=0.0184045f \
 //x=16.015 //y=6.2 //x2=16.59 //y2=5.335
cc_1007 ( CLK N_noxref_10_c_2232_n ) capacitor c=3.93055e-19 //x=15.66 \
 //y=3.51 //x2=17.455 //y2=4.25
cc_1008 ( N_CLK_c_1052_n N_noxref_10_c_2232_n ) capacitor c=6.05878e-19 \
 //x=15.605 //y=2.26 //x2=17.455 //y2=4.25
cc_1009 ( N_CLK_c_1133_n N_noxref_10_c_2232_n ) capacitor c=2.17309e-19 \
 //x=15.632 //y=3.425 //x2=17.455 //y2=4.25
cc_1010 ( N_CLK_c_1074_n N_noxref_10_c_2232_n ) capacitor c=6.19878e-19 \
 //x=15.632 //y=4.535 //x2=17.455 //y2=4.25
cc_1011 ( N_CLK_c_1053_n N_noxref_10_c_2362_n ) capacitor c=2.77838e-19 \
 //x=15.49 //y=4.62 //x2=15.795 //y2=5.335
cc_1012 ( N_CLK_c_1206_p N_noxref_10_c_2362_n ) capacitor c=0.00420239f \
 //x=15.94 //y=4.97 //x2=15.795 //y2=5.335
cc_1013 ( N_CLK_M18_noxref_g N_noxref_10_M16_noxref_g ) capacitor c=0.0105869f \
 //x=2.625 //y=6.2 //x2=1.745 //y2=6.2
cc_1014 ( N_CLK_M18_noxref_g N_noxref_10_M17_noxref_g ) capacitor c=0.10632f \
 //x=2.625 //y=6.2 //x2=2.185 //y2=6.2
cc_1015 ( N_CLK_M19_noxref_g N_noxref_10_M17_noxref_g ) capacitor c=0.0101598f \
 //x=3.065 //y=6.2 //x2=2.185 //y2=6.2
cc_1016 ( N_CLK_c_1242_p N_noxref_10_c_2179_n ) capacitor c=5.72482e-19 \
 //x=2.22 //y=1.09 //x2=1.245 //y2=1.055
cc_1017 ( N_CLK_c_1242_p N_noxref_10_c_2181_n ) capacitor c=0.00149976f \
 //x=2.22 //y=1.09 //x2=1.245 //y2=1.4
cc_1018 ( N_CLK_c_1244_p N_noxref_10_c_2182_n ) capacitor c=0.00111227f \
 //x=2.22 //y=1.4 //x2=1.245 //y2=1.71
cc_1019 ( N_CLK_c_1051_n N_noxref_10_c_2183_n ) capacitor c=0.00238338f \
 //x=2.655 //y=2.26 //x2=1.245 //y2=2.095
cc_1020 ( N_CLK_c_1116_n N_noxref_10_c_2183_n ) capacitor c=0.00964411f \
 //x=2.745 //y=2.095 //x2=1.245 //y2=2.095
cc_1021 ( N_CLK_c_1242_p N_noxref_10_c_2186_n ) capacitor c=0.0160123f \
 //x=2.22 //y=1.09 //x2=1.775 //y2=1.055
cc_1022 ( N_CLK_c_1113_n N_noxref_10_c_2186_n ) capacitor c=0.00103227f \
 //x=2.745 //y=1.09 //x2=1.775 //y2=1.055
cc_1023 ( N_CLK_c_1244_p N_noxref_10_c_2188_n ) capacitor c=0.0124075f \
 //x=2.22 //y=1.4 //x2=1.775 //y2=1.4
cc_1024 ( N_CLK_c_1114_n N_noxref_10_c_2188_n ) capacitor c=0.0010154f \
 //x=2.745 //y=1.4 //x2=1.775 //y2=1.4
cc_1025 ( N_CLK_c_1115_n N_noxref_10_c_2188_n ) capacitor c=9.23422e-19 \
 //x=2.745 //y=1.63 //x2=1.775 //y2=1.4
cc_1026 ( N_CLK_c_1071_n N_noxref_10_c_2377_n ) capacitor c=0.00147352f \
 //x=2.655 //y=4.88 //x2=2.11 //y2=4.97
cc_1027 ( N_CLK_c_1120_n N_noxref_10_c_2377_n ) capacitor c=0.0168581f \
 //x=2.655 //y=4.88 //x2=2.11 //y2=4.97
cc_1028 ( N_CLK_c_1071_n N_noxref_10_c_2249_n ) capacitor c=0.00141297f \
 //x=2.655 //y=4.88 //x2=1.82 //y2=4.97
cc_1029 ( N_CLK_c_1120_n N_noxref_10_c_2249_n ) capacitor c=0.00484466f \
 //x=2.655 //y=4.88 //x2=1.82 //y2=4.97
cc_1030 ( N_CLK_c_1053_n N_noxref_10_c_2319_n ) capacitor c=0.00960248f \
 //x=15.49 //y=4.62 //x2=12.31 //y2=4.97
cc_1031 ( N_CLK_c_1053_n N_noxref_10_c_2296_n ) capacitor c=0.00203982f \
 //x=15.49 //y=4.62 //x2=11.935 //y2=4.88
cc_1032 ( N_CLK_M34_noxref_g N_noxref_10_M34_noxref_d ) capacitor c=0.0180032f \
 //x=15.575 //y=6.2 //x2=15.65 //y2=5.2
cc_1033 ( N_CLK_M35_noxref_g N_noxref_10_M34_noxref_d ) capacitor c=0.0180032f \
 //x=16.015 //y=6.2 //x2=15.65 //y2=5.2
cc_1034 ( N_CLK_c_1242_p N_noxref_12_c_2674_n ) capacitor c=0.0167228f \
 //x=2.22 //y=1.09 //x2=2.88 //y2=0.72
cc_1035 ( N_CLK_c_1113_n N_noxref_12_c_2674_n ) capacitor c=0.00534519f \
 //x=2.745 //y=1.09 //x2=2.88 //y2=0.72
cc_1036 ( CLK N_noxref_12_c_2685_n ) capacitor c=9.41371e-19 //x=2.71 //y=2.77 \
 //x2=2.88 //y2=1.77
cc_1037 ( N_CLK_c_1051_n N_noxref_12_c_2685_n ) capacitor c=0.012357f \
 //x=2.655 //y=2.26 //x2=2.88 //y2=1.77
cc_1038 ( N_CLK_c_1244_p N_noxref_12_c_2685_n ) capacitor c=0.0153476f \
 //x=2.22 //y=1.4 //x2=2.88 //y2=1.77
cc_1039 ( N_CLK_c_1116_n N_noxref_12_c_2685_n ) capacitor c=0.0221865f \
 //x=2.745 //y=2.095 //x2=2.88 //y2=1.77
cc_1040 ( N_CLK_c_1242_p N_noxref_12_M0_noxref_s ) capacitor c=0.00798959f \
 //x=2.22 //y=1.09 //x2=0.89 //y2=0.555
cc_1041 ( N_CLK_c_1115_n N_noxref_12_M0_noxref_s ) capacitor c=0.00212176f \
 //x=2.745 //y=1.63 //x2=0.89 //y2=0.555
cc_1042 ( N_CLK_c_1116_n N_noxref_12_M0_noxref_s ) capacitor c=0.00298115f \
 //x=2.745 //y=2.095 //x2=0.89 //y2=0.555
cc_1043 ( N_CLK_c_1269_p N_noxref_13_c_2715_n ) capacitor c=2.14837e-19 \
 //x=2.59 //y=0.935 //x2=3.45 //y2=1.175
cc_1044 ( N_CLK_c_1113_n N_noxref_13_c_2715_n ) capacitor c=0.00123426f \
 //x=2.745 //y=1.09 //x2=3.45 //y2=1.175
cc_1045 ( N_CLK_c_1114_n N_noxref_13_c_2715_n ) capacitor c=0.0129288f \
 //x=2.745 //y=1.4 //x2=3.45 //y2=1.175
cc_1046 ( N_CLK_c_1115_n N_noxref_13_c_2715_n ) capacitor c=0.00142359f \
 //x=2.745 //y=1.63 //x2=3.45 //y2=1.175
cc_1047 ( N_CLK_c_1242_p N_noxref_13_M1_noxref_d ) capacitor c=0.00223875f \
 //x=2.22 //y=1.09 //x2=2.295 //y2=1.09
cc_1048 ( N_CLK_c_1244_p N_noxref_13_M1_noxref_d ) capacitor c=0.00262485f \
 //x=2.22 //y=1.4 //x2=2.295 //y2=1.09
cc_1049 ( N_CLK_c_1269_p N_noxref_13_M1_noxref_d ) capacitor c=0.00220746f \
 //x=2.59 //y=0.935 //x2=2.295 //y2=1.09
cc_1050 ( N_CLK_c_1276_p N_noxref_13_M1_noxref_d ) capacitor c=0.00194798f \
 //x=2.59 //y=1.555 //x2=2.295 //y2=1.09
cc_1051 ( N_CLK_c_1113_n N_noxref_13_M1_noxref_d ) capacitor c=0.00198465f \
 //x=2.745 //y=1.09 //x2=2.295 //y2=1.09
cc_1052 ( N_CLK_c_1114_n N_noxref_13_M1_noxref_d ) capacitor c=0.00128384f \
 //x=2.745 //y=1.4 //x2=2.295 //y2=1.09
cc_1053 ( N_CLK_c_1113_n N_noxref_13_M2_noxref_s ) capacitor c=7.21316e-19 \
 //x=2.745 //y=1.09 //x2=3.4 //y2=0.555
cc_1054 ( N_CLK_c_1114_n N_noxref_13_M2_noxref_s ) capacitor c=0.00348171f \
 //x=2.745 //y=1.4 //x2=3.4 //y2=0.555
cc_1055 ( N_CLK_c_1053_n N_D_c_2769_n ) capacitor c=0.0210462f //x=15.49 \
 //y=4.62 //x2=7.465 //y2=4.88
cc_1056 ( N_CLK_c_1053_n N_D_c_2786_n ) capacitor c=0.0085986f //x=15.49 \
 //y=4.62 //x2=7.8 //y2=4.97
cc_1057 ( N_CLK_c_1053_n N_D_c_2787_n ) capacitor c=0.00293313f //x=15.49 \
 //y=4.62 //x2=7.465 //y2=4.88
cc_1058 ( N_CLK_c_1138_n N_noxref_18_c_3021_n ) capacitor c=0.0167228f \
 //x=15.17 //y=1.09 //x2=15.83 //y2=0.72
cc_1059 ( N_CLK_c_1143_n N_noxref_18_c_3021_n ) capacitor c=0.00534519f \
 //x=15.695 //y=1.09 //x2=15.83 //y2=0.72
cc_1060 ( CLK N_noxref_18_c_3044_n ) capacitor c=6.5012e-19 //x=15.66 //y=2.77 \
 //x2=15.83 //y2=1.77
cc_1061 ( N_CLK_c_1052_n N_noxref_18_c_3044_n ) capacitor c=0.0120267f \
 //x=15.605 //y=2.26 //x2=15.83 //y2=1.77
cc_1062 ( N_CLK_c_1141_n N_noxref_18_c_3044_n ) capacitor c=0.0157358f \
 //x=15.17 //y=1.4 //x2=15.83 //y2=1.77
cc_1063 ( N_CLK_c_1146_n N_noxref_18_c_3044_n ) capacitor c=0.0216136f \
 //x=15.695 //y=2.095 //x2=15.83 //y2=1.77
cc_1064 ( N_CLK_c_1138_n N_noxref_18_M8_noxref_s ) capacitor c=0.00798959f \
 //x=15.17 //y=1.09 //x2=13.84 //y2=0.555
cc_1065 ( N_CLK_c_1145_n N_noxref_18_M8_noxref_s ) capacitor c=0.00212176f \
 //x=15.695 //y=1.63 //x2=13.84 //y2=0.555
cc_1066 ( N_CLK_c_1146_n N_noxref_18_M8_noxref_s ) capacitor c=0.00298115f \
 //x=15.695 //y=2.095 //x2=13.84 //y2=0.555
cc_1067 ( N_CLK_c_1293_p N_noxref_19_c_3065_n ) capacitor c=2.14837e-19 \
 //x=15.54 //y=0.935 //x2=16.4 //y2=1.175
cc_1068 ( N_CLK_c_1143_n N_noxref_19_c_3065_n ) capacitor c=0.00123426f \
 //x=15.695 //y=1.09 //x2=16.4 //y2=1.175
cc_1069 ( N_CLK_c_1144_n N_noxref_19_c_3065_n ) capacitor c=0.0129288f \
 //x=15.695 //y=1.4 //x2=16.4 //y2=1.175
cc_1070 ( N_CLK_c_1145_n N_noxref_19_c_3065_n ) capacitor c=0.00142359f \
 //x=15.695 //y=1.63 //x2=16.4 //y2=1.175
cc_1071 ( N_CLK_c_1138_n N_noxref_19_M9_noxref_d ) capacitor c=0.00223875f \
 //x=15.17 //y=1.09 //x2=15.245 //y2=1.09
cc_1072 ( N_CLK_c_1141_n N_noxref_19_M9_noxref_d ) capacitor c=0.00262485f \
 //x=15.17 //y=1.4 //x2=15.245 //y2=1.09
cc_1073 ( N_CLK_c_1293_p N_noxref_19_M9_noxref_d ) capacitor c=0.00220746f \
 //x=15.54 //y=0.935 //x2=15.245 //y2=1.09
cc_1074 ( N_CLK_c_1300_p N_noxref_19_M9_noxref_d ) capacitor c=0.00194798f \
 //x=15.54 //y=1.555 //x2=15.245 //y2=1.09
cc_1075 ( N_CLK_c_1143_n N_noxref_19_M9_noxref_d ) capacitor c=0.00198465f \
 //x=15.695 //y=1.09 //x2=15.245 //y2=1.09
cc_1076 ( N_CLK_c_1144_n N_noxref_19_M9_noxref_d ) capacitor c=0.00128384f \
 //x=15.695 //y=1.4 //x2=15.245 //y2=1.09
cc_1077 ( N_CLK_c_1143_n N_noxref_19_M10_noxref_s ) capacitor c=7.21316e-19 \
 //x=15.695 //y=1.09 //x2=16.35 //y2=0.555
cc_1078 ( N_CLK_c_1144_n N_noxref_19_M10_noxref_s ) capacitor c=0.00348171f \
 //x=15.695 //y=1.4 //x2=16.35 //y2=0.555
cc_1079 ( N_noxref_6_c_1305_n N_RN_c_1560_n ) capacitor c=0.0822363f //x=19.19 \
 //y=3.88 //x2=16.6 //y2=2.4
cc_1080 ( N_noxref_6_c_1305_n N_RN_c_1568_n ) capacitor c=4.37145e-19 \
 //x=19.19 //y=3.88 //x2=8.69 //y2=2.4
cc_1081 ( N_noxref_6_c_1305_n N_RN_c_1570_n ) capacitor c=0.0555029f //x=19.19 \
 //y=3.88 //x2=20.3 //y2=2.4
cc_1082 ( N_noxref_6_c_1308_n N_RN_c_1570_n ) capacitor c=0.0251492f \
 //x=19.305 //y=2.26 //x2=20.3 //y2=2.4
cc_1083 ( N_noxref_6_c_1323_n N_RN_c_1570_n ) capacitor c=0.0106236f \
 //x=19.005 //y=2.095 //x2=20.3 //y2=2.4
cc_1084 ( N_noxref_6_c_1305_n N_RN_c_1574_n ) capacitor c=0.00455812f \
 //x=19.19 //y=3.88 //x2=16.83 //y2=2.4
cc_1085 ( N_noxref_6_c_1305_n RN ) capacitor c=0.00139176f //x=19.19 //y=3.88 \
 //x2=16.77 //y2=3.51
cc_1086 ( N_noxref_6_c_1305_n RN ) capacitor c=0.00220604f //x=19.19 //y=3.88 \
 //x2=20.47 //y2=3.88
cc_1087 ( N_noxref_6_c_1305_n N_RN_c_1581_n ) capacitor c=0.0179999f //x=19.19 \
 //y=3.88 //x2=8.575 //y2=4.88
cc_1088 ( N_noxref_6_c_1308_n N_RN_c_1687_n ) capacitor c=0.0522096f \
 //x=19.305 //y=2.26 //x2=20.415 //y2=2.485
cc_1089 ( N_noxref_6_c_1323_n N_RN_c_1687_n ) capacitor c=0.00209012f \
 //x=19.005 //y=2.095 //x2=20.415 //y2=2.485
cc_1090 ( N_noxref_6_c_1457_p N_RN_c_1583_n ) capacitor c=0.00147352f \
 //x=19.87 //y=4.97 //x2=20.415 //y2=4.88
cc_1091 ( N_noxref_6_c_1361_n N_RN_c_1583_n ) capacitor c=0.00142741f \
 //x=19.58 //y=4.97 //x2=20.415 //y2=4.88
cc_1092 ( N_noxref_6_c_1307_n N_RN_c_1577_n ) capacitor c=0.00110012f \
 //x=6.355 //y=2.26 //x2=8.602 //y2=2.685
cc_1093 ( N_noxref_6_c_1305_n N_RN_c_1584_n ) capacitor c=0.0227816f //x=19.19 \
 //y=3.88 //x2=16.742 //y2=4.535
cc_1094 ( N_noxref_6_c_1308_n N_RN_c_1584_n ) capacitor c=3.92486e-19 \
 //x=19.305 //y=2.26 //x2=16.742 //y2=4.535
cc_1095 ( N_noxref_6_c_1305_n N_RN_c_1694_n ) capacitor c=3.28865e-19 \
 //x=19.19 //y=3.88 //x2=20.442 //y2=3.795
cc_1096 ( N_noxref_6_c_1305_n N_RN_c_1585_n ) capacitor c=3.28865e-19 \
 //x=19.19 //y=3.88 //x2=20.442 //y2=4.535
cc_1097 ( N_noxref_6_M38_noxref_g N_RN_M40_noxref_g ) capacitor c=0.0105869f \
 //x=19.505 //y=6.2 //x2=20.385 //y2=6.2
cc_1098 ( N_noxref_6_M39_noxref_g N_RN_M40_noxref_g ) capacitor c=0.10632f \
 //x=19.945 //y=6.2 //x2=20.385 //y2=6.2
cc_1099 ( N_noxref_6_M39_noxref_g N_RN_M41_noxref_g ) capacitor c=0.0101598f \
 //x=19.945 //y=6.2 //x2=20.825 //y2=6.2
cc_1100 ( N_noxref_6_c_1319_n N_RN_c_1699_n ) capacitor c=5.72482e-19 \
 //x=19.005 //y=1.055 //x2=19.98 //y2=1.09
cc_1101 ( N_noxref_6_c_1321_n N_RN_c_1699_n ) capacitor c=0.00149976f \
 //x=19.005 //y=1.4 //x2=19.98 //y2=1.09
cc_1102 ( N_noxref_6_c_1326_n N_RN_c_1699_n ) capacitor c=0.0160123f \
 //x=19.535 //y=1.055 //x2=19.98 //y2=1.09
cc_1103 ( N_noxref_6_c_1322_n N_RN_c_1702_n ) capacitor c=0.00111227f \
 //x=19.005 //y=1.71 //x2=19.98 //y2=1.4
cc_1104 ( N_noxref_6_c_1328_n N_RN_c_1702_n ) capacitor c=0.0124075f \
 //x=19.535 //y=1.4 //x2=19.98 //y2=1.4
cc_1105 ( N_noxref_6_c_1326_n N_RN_c_1704_n ) capacitor c=0.00103227f \
 //x=19.535 //y=1.055 //x2=20.505 //y2=1.09
cc_1106 ( N_noxref_6_c_1328_n N_RN_c_1705_n ) capacitor c=0.0010154f \
 //x=19.535 //y=1.4 //x2=20.505 //y2=1.4
cc_1107 ( N_noxref_6_c_1328_n N_RN_c_1706_n ) capacitor c=9.23422e-19 \
 //x=19.535 //y=1.4 //x2=20.505 //y2=1.63
cc_1108 ( N_noxref_6_c_1308_n N_RN_c_1707_n ) capacitor c=0.00203769f \
 //x=19.305 //y=2.26 //x2=20.505 //y2=2.095
cc_1109 ( N_noxref_6_c_1323_n N_RN_c_1707_n ) capacitor c=0.00834532f \
 //x=19.005 //y=2.095 //x2=20.505 //y2=2.095
cc_1110 ( N_noxref_6_c_1308_n N_RN_c_1709_n ) capacitor c=0.00183762f \
 //x=19.305 //y=2.26 //x2=20.415 //y2=4.88
cc_1111 ( N_noxref_6_c_1457_p N_RN_c_1709_n ) capacitor c=0.0168581f //x=19.87 \
 //y=4.97 //x2=20.415 //y2=4.88
cc_1112 ( N_noxref_6_c_1361_n N_RN_c_1709_n ) capacitor c=0.00484466f \
 //x=19.58 //y=4.97 //x2=20.415 //y2=4.88
cc_1113 ( N_noxref_6_c_1308_n N_noxref_8_c_1889_n ) capacitor c=0.00134821f \
 //x=19.305 //y=2.26 //x2=21.525 //y2=2.26
cc_1114 ( N_noxref_6_c_1305_n N_noxref_8_c_1890_n ) capacitor c=0.00738475f \
 //x=19.19 //y=3.88 //x2=21.525 //y2=3.88
cc_1115 ( N_noxref_6_M39_noxref_g N_QN_c_2002_n ) capacitor c=0.0178794f \
 //x=19.945 //y=6.2 //x2=20.52 //y2=5.335
cc_1116 ( N_noxref_6_M38_noxref_g N_QN_c_2006_n ) capacitor c=0.0213876f \
 //x=19.505 //y=6.2 //x2=19.81 //y2=5.335
cc_1117 ( N_noxref_6_c_1457_p N_QN_c_2006_n ) capacitor c=0.00429591f \
 //x=19.87 //y=4.97 //x2=19.81 //y2=5.335
cc_1118 ( N_noxref_6_M39_noxref_g N_QN_M38_noxref_d ) capacitor c=0.0180032f \
 //x=19.945 //y=6.2 //x2=19.58 //y2=5.2
cc_1119 ( N_noxref_6_c_1378_n N_noxref_10_c_2170_n ) capacitor c=0.147447f \
 //x=6.24 //y=3.88 //x2=11.79 //y2=4.25
cc_1120 ( N_noxref_6_c_1379_n N_noxref_10_c_2170_n ) capacitor c=0.0294294f \
 //x=4.62 //y=3.88 //x2=11.79 //y2=4.25
cc_1121 ( N_noxref_6_c_1305_n N_noxref_10_c_2170_n ) capacitor c=0.467229f \
 //x=19.19 //y=3.88 //x2=11.79 //y2=4.25
cc_1122 ( N_noxref_6_c_1386_n N_noxref_10_c_2170_n ) capacitor c=0.0264476f \
 //x=6.47 //y=3.88 //x2=11.79 //y2=4.25
cc_1123 ( N_noxref_6_c_1334_n N_noxref_10_c_2170_n ) capacitor c=0.0154449f \
 //x=2.05 //y=5.335 //x2=11.79 //y2=4.25
cc_1124 ( N_noxref_6_c_1344_n N_noxref_10_c_2170_n ) capacitor c=0.0200328f \
 //x=4.505 //y=3.88 //x2=11.79 //y2=4.25
cc_1125 ( N_noxref_6_c_1307_n N_noxref_10_c_2170_n ) capacitor c=0.0213516f \
 //x=6.355 //y=2.26 //x2=11.79 //y2=4.25
cc_1126 ( N_noxref_6_c_1305_n N_noxref_10_c_2197_n ) capacitor c=0.467439f \
 //x=19.19 //y=3.88 //x2=17.34 //y2=4.25
cc_1127 ( N_noxref_6_c_1305_n N_noxref_10_c_2273_n ) capacitor c=0.0267832f \
 //x=19.19 //y=3.88 //x2=12.02 //y2=4.25
cc_1128 ( N_noxref_6_c_1305_n N_noxref_10_c_2172_n ) capacitor c=0.176507f \
 //x=19.19 //y=3.88 //x2=24.74 //y2=4.25
cc_1129 ( N_noxref_6_c_1308_n N_noxref_10_c_2172_n ) capacitor c=0.0252746f \
 //x=19.305 //y=2.26 //x2=24.74 //y2=4.25
cc_1130 ( N_noxref_6_c_1361_n N_noxref_10_c_2172_n ) capacitor c=0.0115418f \
 //x=19.58 //y=4.97 //x2=24.74 //y2=4.25
cc_1131 ( N_noxref_6_c_1305_n N_noxref_10_c_2210_n ) capacitor c=0.0268461f \
 //x=19.19 //y=3.88 //x2=17.57 //y2=4.25
cc_1132 ( N_noxref_6_c_1308_n N_noxref_10_c_2210_n ) capacitor c=3.50683e-19 \
 //x=19.305 //y=2.26 //x2=17.57 //y2=4.25
cc_1133 ( N_noxref_6_c_1305_n N_noxref_10_c_2174_n ) capacitor c=0.0236433f \
 //x=19.19 //y=3.88 //x2=11.905 //y2=2.26
cc_1134 ( N_noxref_6_c_1305_n N_noxref_10_c_2232_n ) capacitor c=0.0261231f \
 //x=19.19 //y=3.88 //x2=17.455 //y2=4.25
cc_1135 ( N_noxref_6_c_1308_n N_noxref_10_c_2232_n ) capacitor c=0.0144739f \
 //x=19.305 //y=2.26 //x2=17.455 //y2=4.25
cc_1136 ( N_noxref_6_c_1334_n N_noxref_10_M16_noxref_g ) capacitor \
 c=0.0213876f //x=2.05 //y=5.335 //x2=1.745 //y2=6.2
cc_1137 ( N_noxref_6_c_1330_n N_noxref_10_M17_noxref_g ) capacitor \
 c=0.0178794f //x=2.76 //y=5.335 //x2=2.185 //y2=6.2
cc_1138 ( N_noxref_6_M16_noxref_d N_noxref_10_M17_noxref_g ) capacitor \
 c=0.0180032f //x=1.82 //y=5.2 //x2=2.185 //y2=6.2
cc_1139 ( N_noxref_6_c_1334_n N_noxref_10_c_2377_n ) capacitor c=0.00429591f \
 //x=2.05 //y=5.335 //x2=2.11 //y2=4.97
cc_1140 ( N_noxref_6_c_1305_n N_noxref_11_c_2582_n ) capacitor c=0.00124897f \
 //x=19.19 //y=3.88 //x2=25.595 //y2=3.88
cc_1141 ( N_noxref_6_M2_noxref_d N_noxref_12_M0_noxref_s ) capacitor \
 c=0.00309936f //x=3.83 //y=1.095 //x2=0.89 //y2=0.555
cc_1142 ( N_noxref_6_c_1306_n N_noxref_13_c_2720_n ) capacitor c=0.00466084f \
 //x=4.42 //y=1.845 //x2=4.42 //y2=0.72
cc_1143 ( N_noxref_6_M2_noxref_d N_noxref_13_c_2720_n ) capacitor c=0.0117786f \
 //x=3.83 //y=1.095 //x2=4.42 //y2=0.72
cc_1144 ( N_noxref_6_c_1393_n N_noxref_13_c_2734_n ) capacitor c=0.0200405f \
 //x=4.105 //y=1.845 //x2=3.535 //y2=1.175
cc_1145 ( N_noxref_6_M2_noxref_d N_noxref_13_M1_noxref_d ) capacitor \
 c=5.27807e-19 //x=3.83 //y=1.095 //x2=2.295 //y2=1.09
cc_1146 ( N_noxref_6_c_1306_n N_noxref_13_M2_noxref_s ) capacitor c=0.0207678f \
 //x=4.42 //y=1.845 //x2=3.4 //y2=0.555
cc_1147 ( N_noxref_6_M2_noxref_d N_noxref_13_M2_noxref_s ) capacitor \
 c=0.0426368f //x=3.83 //y=1.095 //x2=3.4 //y2=0.555
cc_1148 ( N_noxref_6_c_1307_n N_D_c_2768_n ) capacitor c=0.0482383f //x=6.355 \
 //y=2.26 //x2=7.465 //y2=2.26
cc_1149 ( N_noxref_6_c_1313_n N_D_c_2768_n ) capacitor c=0.00238338f //x=6.055 \
 //y=2.095 //x2=7.465 //y2=2.26
cc_1150 ( N_noxref_6_c_1305_n N_D_c_2769_n ) capacitor c=0.0190398f //x=19.19 \
 //y=3.88 //x2=7.465 //y2=4.88
cc_1151 ( N_noxref_6_c_1386_n N_D_c_2769_n ) capacitor c=9.95819e-19 //x=6.47 \
 //y=3.88 //x2=7.465 //y2=4.88
cc_1152 ( N_noxref_6_c_1407_n N_D_c_2769_n ) capacitor c=0.00147352f //x=6.92 \
 //y=4.97 //x2=7.465 //y2=4.88
cc_1153 ( N_noxref_6_c_1359_n N_D_c_2769_n ) capacitor c=0.00142741f //x=6.63 \
 //y=4.97 //x2=7.465 //y2=4.88
cc_1154 ( N_noxref_6_c_1344_n N_D_c_2797_n ) capacitor c=4.03171e-19 //x=4.505 \
 //y=3.88 //x2=7.492 //y2=3.055
cc_1155 ( N_noxref_6_M22_noxref_g N_D_M24_noxref_g ) capacitor c=0.0105869f \
 //x=6.555 //y=6.2 //x2=7.435 //y2=6.2
cc_1156 ( N_noxref_6_M23_noxref_g N_D_M24_noxref_g ) capacitor c=0.10632f \
 //x=6.995 //y=6.2 //x2=7.435 //y2=6.2
cc_1157 ( N_noxref_6_M23_noxref_g N_D_M25_noxref_g ) capacitor c=0.0101598f \
 //x=6.995 //y=6.2 //x2=7.875 //y2=6.2
cc_1158 ( N_noxref_6_c_1309_n N_D_c_2801_n ) capacitor c=5.72482e-19 //x=6.055 \
 //y=1.055 //x2=7.03 //y2=1.09
cc_1159 ( N_noxref_6_c_1311_n N_D_c_2801_n ) capacitor c=0.00149976f //x=6.055 \
 //y=1.4 //x2=7.03 //y2=1.09
cc_1160 ( N_noxref_6_c_1316_n N_D_c_2801_n ) capacitor c=0.0160123f //x=6.585 \
 //y=1.055 //x2=7.03 //y2=1.09
cc_1161 ( N_noxref_6_c_1312_n N_D_c_2804_n ) capacitor c=0.00111227f //x=6.055 \
 //y=1.71 //x2=7.03 //y2=1.4
cc_1162 ( N_noxref_6_c_1318_n N_D_c_2804_n ) capacitor c=0.0124075f //x=6.585 \
 //y=1.4 //x2=7.03 //y2=1.4
cc_1163 ( N_noxref_6_c_1316_n N_D_c_2806_n ) capacitor c=0.00103227f //x=6.585 \
 //y=1.055 //x2=7.555 //y2=1.09
cc_1164 ( N_noxref_6_c_1318_n N_D_c_2807_n ) capacitor c=0.0010154f //x=6.585 \
 //y=1.4 //x2=7.555 //y2=1.4
cc_1165 ( N_noxref_6_c_1318_n N_D_c_2808_n ) capacitor c=9.23422e-19 //x=6.585 \
 //y=1.4 //x2=7.555 //y2=1.63
cc_1166 ( N_noxref_6_c_1307_n N_D_c_2809_n ) capacitor c=0.00231304f //x=6.355 \
 //y=2.26 //x2=7.555 //y2=2.095
cc_1167 ( N_noxref_6_c_1313_n N_D_c_2809_n ) capacitor c=0.00964411f //x=6.055 \
 //y=2.095 //x2=7.555 //y2=2.095
cc_1168 ( N_noxref_6_c_1307_n N_D_c_2787_n ) capacitor c=0.00183762f //x=6.355 \
 //y=2.26 //x2=7.465 //y2=4.88
cc_1169 ( N_noxref_6_c_1407_n N_D_c_2787_n ) capacitor c=0.0168581f //x=6.92 \
 //y=4.97 //x2=7.465 //y2=4.88
cc_1170 ( N_noxref_6_c_1359_n N_D_c_2787_n ) capacitor c=0.00484466f //x=6.63 \
 //y=4.97 //x2=7.465 //y2=4.88
cc_1171 ( N_noxref_6_c_1306_n N_noxref_15_c_2873_n ) capacitor c=3.84569e-19 \
 //x=4.42 //y=1.845 //x2=5.835 //y2=1.685
cc_1172 ( N_noxref_6_c_1313_n N_noxref_15_c_2873_n ) capacitor c=0.0034165f \
 //x=6.055 //y=2.095 //x2=5.835 //y2=1.685
cc_1173 ( N_noxref_6_c_1307_n N_noxref_15_c_2857_n ) capacitor c=0.0125801f \
 //x=6.355 //y=2.26 //x2=6.72 //y2=1.77
cc_1174 ( N_noxref_6_c_1312_n N_noxref_15_c_2857_n ) capacitor c=0.00703864f \
 //x=6.055 //y=1.71 //x2=6.72 //y2=1.77
cc_1175 ( N_noxref_6_c_1313_n N_noxref_15_c_2857_n ) capacitor c=0.0245895f \
 //x=6.055 //y=2.095 //x2=6.72 //y2=1.77
cc_1176 ( N_noxref_6_c_1315_n N_noxref_15_c_2857_n ) capacitor c=0.00708583f \
 //x=6.43 //y=1.555 //x2=6.72 //y2=1.77
cc_1177 ( N_noxref_6_c_1318_n N_noxref_15_c_2857_n ) capacitor c=0.00698822f \
 //x=6.585 //y=1.4 //x2=6.72 //y2=1.77
cc_1178 ( N_noxref_6_c_1309_n N_noxref_15_M3_noxref_s ) capacitor c=0.0327271f \
 //x=6.055 //y=1.055 //x2=5.7 //y2=0.555
cc_1179 ( N_noxref_6_c_1312_n N_noxref_15_M3_noxref_s ) capacitor \
 c=7.99997e-19 //x=6.055 //y=1.71 //x2=5.7 //y2=0.555
cc_1180 ( N_noxref_6_c_1313_n N_noxref_15_M3_noxref_s ) capacitor \
 c=0.00122123f //x=6.055 //y=2.095 //x2=5.7 //y2=0.555
cc_1181 ( N_noxref_6_c_1316_n N_noxref_15_M3_noxref_s ) capacitor c=0.0121427f \
 //x=6.585 //y=1.055 //x2=5.7 //y2=0.555
cc_1182 ( N_noxref_6_M2_noxref_d N_noxref_15_M3_noxref_s ) capacitor \
 c=2.55333e-19 //x=3.83 //y=1.095 //x2=5.7 //y2=0.555
cc_1183 ( N_noxref_6_c_1323_n N_noxref_20_c_3135_n ) capacitor c=0.0034165f \
 //x=19.005 //y=2.095 //x2=18.785 //y2=1.685
cc_1184 ( N_noxref_6_c_1308_n N_noxref_20_c_3119_n ) capacitor c=0.0119952f \
 //x=19.305 //y=2.26 //x2=19.67 //y2=1.77
cc_1185 ( N_noxref_6_c_1322_n N_noxref_20_c_3119_n ) capacitor c=0.00697148f \
 //x=19.005 //y=1.71 //x2=19.67 //y2=1.77
cc_1186 ( N_noxref_6_c_1323_n N_noxref_20_c_3119_n ) capacitor c=0.0204849f \
 //x=19.005 //y=2.095 //x2=19.67 //y2=1.77
cc_1187 ( N_noxref_6_c_1325_n N_noxref_20_c_3119_n ) capacitor c=0.00610316f \
 //x=19.38 //y=1.555 //x2=19.67 //y2=1.77
cc_1188 ( N_noxref_6_c_1328_n N_noxref_20_c_3119_n ) capacitor c=0.00698822f \
 //x=19.535 //y=1.4 //x2=19.67 //y2=1.77
cc_1189 ( N_noxref_6_c_1319_n N_noxref_20_M11_noxref_s ) capacitor \
 c=0.0327271f //x=19.005 //y=1.055 //x2=18.65 //y2=0.555
cc_1190 ( N_noxref_6_c_1322_n N_noxref_20_M11_noxref_s ) capacitor \
 c=7.99997e-19 //x=19.005 //y=1.71 //x2=18.65 //y2=0.555
cc_1191 ( N_noxref_6_c_1323_n N_noxref_20_M11_noxref_s ) capacitor \
 c=0.00122123f //x=19.005 //y=2.095 //x2=18.65 //y2=0.555
cc_1192 ( N_noxref_6_c_1326_n N_noxref_20_M11_noxref_s ) capacitor \
 c=0.0121427f //x=19.535 //y=1.055 //x2=18.65 //y2=0.555
cc_1193 ( N_RN_c_1570_n N_noxref_8_c_1889_n ) capacitor c=0.00510792f //x=20.3 \
 //y=2.4 //x2=21.525 //y2=2.26
cc_1194 ( RN N_noxref_8_c_1889_n ) capacitor c=0.00493712f //x=20.47 //y=2.77 \
 //x2=21.525 //y2=2.26
cc_1195 ( RN N_noxref_8_c_1889_n ) capacitor c=0.00493712f //x=20.47 //y=3.14 \
 //x2=21.525 //y2=2.26
cc_1196 ( RN N_noxref_8_c_1889_n ) capacitor c=0.00455774f //x=20.47 //y=3.51 \
 //x2=21.525 //y2=2.26
cc_1197 ( RN N_noxref_8_c_1889_n ) capacitor c=0.00371334f //x=20.47 //y=3.88 \
 //x2=21.525 //y2=2.26
cc_1198 ( RN N_noxref_8_c_1889_n ) capacitor c=0.00493712f //x=20.47 //y=4.62 \
 //x2=21.525 //y2=2.26
cc_1199 ( N_RN_c_1687_n N_noxref_8_c_1889_n ) capacitor c=0.00486306f \
 //x=20.415 //y=2.485 //x2=21.525 //y2=2.26
cc_1200 ( N_RN_c_1583_n N_noxref_8_c_1889_n ) capacitor c=0.0049097f \
 //x=20.415 //y=4.88 //x2=21.525 //y2=2.26
cc_1201 ( N_RN_c_1579_n N_noxref_8_c_1889_n ) capacitor c=0.00395715f \
 //x=20.442 //y=2.685 //x2=21.525 //y2=2.26
cc_1202 ( N_RN_c_1721_p N_noxref_8_c_1889_n ) capacitor c=0.0042159f \
 //x=20.442 //y=3.055 //x2=21.525 //y2=2.26
cc_1203 ( N_RN_c_1722_p N_noxref_8_c_1889_n ) capacitor c=0.0041777f \
 //x=20.442 //y=3.425 //x2=21.525 //y2=2.26
cc_1204 ( N_RN_c_1694_n N_noxref_8_c_1889_n ) capacitor c=0.00398594f \
 //x=20.442 //y=3.795 //x2=21.525 //y2=2.26
cc_1205 ( N_RN_c_1585_n N_noxref_8_c_1889_n ) capacitor c=0.00948311f \
 //x=20.442 //y=4.535 //x2=21.525 //y2=2.26
cc_1206 ( N_RN_c_1707_n N_noxref_8_c_1889_n ) capacitor c=0.00265785f \
 //x=20.505 //y=2.095 //x2=21.525 //y2=2.26
cc_1207 ( N_RN_c_1709_n N_noxref_8_c_1889_n ) capacitor c=0.00142741f \
 //x=20.415 //y=4.88 //x2=21.525 //y2=2.26
cc_1208 ( RN N_noxref_8_c_1890_n ) capacitor c=0.00223707f //x=20.47 //y=3.88 \
 //x2=21.525 //y2=3.88
cc_1209 ( N_RN_c_1694_n N_noxref_8_c_1890_n ) capacitor c=3.28865e-19 \
 //x=20.442 //y=3.795 //x2=21.525 //y2=3.88
cc_1210 ( N_RN_c_1585_n N_noxref_8_c_1890_n ) capacitor c=3.28865e-19 \
 //x=20.442 //y=4.535 //x2=21.525 //y2=3.88
cc_1211 ( N_RN_M40_noxref_g N_noxref_8_M42_noxref_g ) capacitor c=0.0101598f \
 //x=20.385 //y=6.2 //x2=21.265 //y2=6.2
cc_1212 ( N_RN_M41_noxref_g N_noxref_8_M42_noxref_g ) capacitor c=0.0602553f \
 //x=20.825 //y=6.2 //x2=21.265 //y2=6.2
cc_1213 ( N_RN_M41_noxref_g N_noxref_8_M43_noxref_g ) capacitor c=0.0101598f \
 //x=20.825 //y=6.2 //x2=21.705 //y2=6.2
cc_1214 ( N_RN_c_1704_n N_noxref_8_c_1919_n ) capacitor c=0.00456962f \
 //x=20.505 //y=1.09 //x2=21.515 //y2=1.095
cc_1215 ( N_RN_c_1705_n N_noxref_8_c_1920_n ) capacitor c=0.00438372f \
 //x=20.505 //y=1.4 //x2=21.515 //y2=1.44
cc_1216 ( N_RN_c_1706_n N_noxref_8_c_1921_n ) capacitor c=0.00438372f \
 //x=20.505 //y=1.63 //x2=21.515 //y2=1.75
cc_1217 ( N_RN_c_1570_n N_noxref_8_c_1922_n ) capacitor c=0.0034041f //x=20.3 \
 //y=2.4 //x2=21.525 //y2=2.26
cc_1218 ( N_RN_c_1687_n N_noxref_8_c_1922_n ) capacitor c=0.00264042f \
 //x=20.415 //y=2.485 //x2=21.525 //y2=2.26
cc_1219 ( N_RN_c_1707_n N_noxref_8_c_1922_n ) capacitor c=0.00872421f \
 //x=20.505 //y=2.095 //x2=21.525 //y2=2.26
cc_1220 ( N_RN_c_1707_n N_noxref_8_c_1925_n ) capacitor c=0.00438372f \
 //x=20.505 //y=2.095 //x2=21.525 //y2=2.095
cc_1221 ( N_RN_c_1583_n N_noxref_8_c_1926_n ) capacitor c=0.00219458f \
 //x=20.415 //y=4.88 //x2=21.525 //y2=4.88
cc_1222 ( N_RN_c_1741_p N_noxref_8_c_1926_n ) capacitor c=0.0611812f //x=20.75 \
 //y=4.97 //x2=21.525 //y2=4.88
cc_1223 ( N_RN_c_1709_n N_noxref_8_c_1926_n ) capacitor c=0.00487508f \
 //x=20.415 //y=4.88 //x2=21.525 //y2=4.88
cc_1224 ( RN N_QN_c_2002_n ) capacitor c=2.03999e-19 //x=20.47 //y=3.88 \
 //x2=20.52 //y2=5.335
cc_1225 ( RN N_QN_c_2002_n ) capacitor c=0.00167542f //x=20.47 //y=4.62 \
 //x2=20.52 //y2=5.335
cc_1226 ( N_RN_c_1583_n N_QN_c_2002_n ) capacitor c=0.0148665f //x=20.415 \
 //y=4.88 //x2=20.52 //y2=5.335
cc_1227 ( N_RN_M40_noxref_g N_QN_c_2002_n ) capacitor c=0.0166659f //x=20.385 \
 //y=6.2 //x2=20.52 //y2=5.335
cc_1228 ( N_RN_c_1709_n N_QN_c_2002_n ) capacitor c=0.00322396f //x=20.415 \
 //y=4.88 //x2=20.52 //y2=5.335
cc_1229 ( N_RN_M41_noxref_g N_QN_c_2008_n ) capacitor c=0.0184045f //x=20.825 \
 //y=6.2 //x2=21.4 //y2=5.335
cc_1230 ( N_RN_c_1741_p N_QN_c_2052_n ) capacitor c=0.00420239f //x=20.75 \
 //y=4.97 //x2=20.605 //y2=5.335
cc_1231 ( N_RN_c_1579_n N_QN_c_1985_n ) capacitor c=2.04682e-19 //x=20.442 \
 //y=2.685 //x2=22.292 //y2=2.685
cc_1232 ( N_RN_c_1694_n N_QN_c_2019_n ) capacitor c=2.37933e-19 //x=20.442 \
 //y=3.795 //x2=22.292 //y2=4.535
cc_1233 ( N_RN_c_1585_n N_QN_c_2019_n ) capacitor c=4.13158e-19 //x=20.442 \
 //y=4.535 //x2=22.292 //y2=4.535
cc_1234 ( N_RN_c_1583_n N_QN_c_2020_n ) capacitor c=5.8277e-19 //x=20.415 \
 //y=4.88 //x2=22.292 //y2=4.905
cc_1235 ( N_RN_M40_noxref_g N_QN_M40_noxref_d ) capacitor c=0.0180032f \
 //x=20.385 //y=6.2 //x2=20.46 //y2=5.2
cc_1236 ( N_RN_M41_noxref_g N_QN_M40_noxref_d ) capacitor c=0.0180032f \
 //x=20.825 //y=6.2 //x2=20.46 //y2=5.2
cc_1237 ( N_RN_c_1560_n N_noxref_10_c_2170_n ) capacitor c=0.00314955f \
 //x=16.6 //y=2.4 //x2=11.79 //y2=4.25
cc_1238 ( N_RN_c_1581_n N_noxref_10_c_2170_n ) capacitor c=0.0179722f \
 //x=8.575 //y=4.88 //x2=11.79 //y2=4.25
cc_1239 ( N_RN_c_1560_n N_noxref_10_c_2197_n ) capacitor c=0.0143182f //x=16.6 \
 //y=2.4 //x2=17.34 //y2=4.25
cc_1240 ( N_RN_c_1570_n N_noxref_10_c_2197_n ) capacitor c=0.00321562f \
 //x=20.3 //y=2.4 //x2=17.34 //y2=4.25
cc_1241 ( N_RN_c_1574_n N_noxref_10_c_2197_n ) capacitor c=2.67586e-19 \
 //x=16.83 //y=2.4 //x2=17.34 //y2=4.25
cc_1242 ( RN N_noxref_10_c_2197_n ) capacitor c=0.00175716f //x=16.77 //y=4.62 \
 //x2=17.34 //y2=4.25
cc_1243 ( N_RN_c_1584_n N_noxref_10_c_2197_n ) capacitor c=0.0219145f \
 //x=16.742 //y=4.535 //x2=17.34 //y2=4.25
cc_1244 ( N_RN_c_1675_n N_noxref_10_c_2197_n ) capacitor c=0.00755801f \
 //x=16.715 //y=4.88 //x2=17.34 //y2=4.25
cc_1245 ( N_RN_c_1560_n N_noxref_10_c_2273_n ) capacitor c=2.80052e-19 \
 //x=16.6 //y=2.4 //x2=12.02 //y2=4.25
cc_1246 ( N_RN_c_1570_n N_noxref_10_c_2172_n ) capacitor c=0.0252231f //x=20.3 \
 //y=2.4 //x2=24.74 //y2=4.25
cc_1247 ( RN N_noxref_10_c_2172_n ) capacitor c=0.0013124f //x=20.47 //y=3.88 \
 //x2=24.74 //y2=4.25
cc_1248 ( RN N_noxref_10_c_2172_n ) capacitor c=0.00156006f //x=20.47 //y=4.62 \
 //x2=24.74 //y2=4.25
cc_1249 ( N_RN_c_1585_n N_noxref_10_c_2172_n ) capacitor c=0.0283962f \
 //x=20.442 //y=4.535 //x2=24.74 //y2=4.25
cc_1250 ( N_RN_c_1741_p N_noxref_10_c_2172_n ) capacitor c=0.00489617f \
 //x=20.75 //y=4.97 //x2=24.74 //y2=4.25
cc_1251 ( N_RN_c_1709_n N_noxref_10_c_2172_n ) capacitor c=9.0988e-19 \
 //x=20.415 //y=4.88 //x2=24.74 //y2=4.25
cc_1252 ( N_RN_c_1570_n N_noxref_10_c_2210_n ) capacitor c=2.98411e-19 \
 //x=20.3 //y=2.4 //x2=17.57 //y2=4.25
cc_1253 ( N_RN_c_1584_n N_noxref_10_c_2210_n ) capacitor c=0.00179385f \
 //x=16.742 //y=4.535 //x2=17.57 //y2=4.25
cc_1254 ( N_RN_c_1560_n N_noxref_10_c_2174_n ) capacitor c=0.0226984f //x=16.6 \
 //y=2.4 //x2=11.905 //y2=2.26
cc_1255 ( N_RN_M36_noxref_g N_noxref_10_c_2224_n ) capacitor c=0.0184045f \
 //x=16.455 //y=6.2 //x2=16.59 //y2=5.335
cc_1256 ( RN N_noxref_10_c_2228_n ) capacitor c=0.00140847f //x=16.77 //y=4.62 \
 //x2=17.37 //y2=5.335
cc_1257 ( N_RN_M37_noxref_g N_noxref_10_c_2228_n ) capacitor c=0.0202764f \
 //x=16.895 //y=6.2 //x2=17.37 //y2=5.335
cc_1258 ( N_RN_c_1675_n N_noxref_10_c_2228_n ) capacitor c=0.00201851f \
 //x=16.715 //y=4.88 //x2=17.37 //y2=5.335
cc_1259 ( N_RN_c_1778_p N_noxref_10_c_2176_n ) capacitor c=0.00371277f \
 //x=17.08 //y=1.595 //x2=17.37 //y2=1.845
cc_1260 ( N_RN_c_1779_p N_noxref_10_c_2176_n ) capacitor c=0.00457401f \
 //x=17.235 //y=1.44 //x2=17.37 //y2=1.845
cc_1261 ( N_RN_c_1570_n N_noxref_10_c_2430_n ) capacitor c=0.016327f //x=20.3 \
 //y=2.4 //x2=17.055 //y2=1.845
cc_1262 ( N_RN_c_1570_n N_noxref_10_c_2232_n ) capacitor c=0.0243598f //x=20.3 \
 //y=2.4 //x2=17.455 //y2=4.25
cc_1263 ( N_RN_c_1574_n N_noxref_10_c_2232_n ) capacitor c=0.0012045f \
 //x=16.83 //y=2.4 //x2=17.455 //y2=4.25
cc_1264 ( RN N_noxref_10_c_2232_n ) capacitor c=0.00777753f //x=16.77 //y=2.77 \
 //x2=17.455 //y2=4.25
cc_1265 ( RN N_noxref_10_c_2232_n ) capacitor c=0.00777753f //x=16.77 //y=3.14 \
 //x2=17.455 //y2=4.25
cc_1266 ( RN N_noxref_10_c_2232_n ) capacitor c=0.00752038f //x=16.77 //y=3.51 \
 //x2=17.455 //y2=4.25
cc_1267 ( RN N_noxref_10_c_2232_n ) capacitor c=0.00743362f //x=16.77 //y=4.62 \
 //x2=17.455 //y2=4.25
cc_1268 ( N_RN_c_1656_n N_noxref_10_c_2232_n ) capacitor c=0.00952708f \
 //x=16.715 //y=2.485 //x2=17.455 //y2=4.25
cc_1269 ( N_RN_c_1582_n N_noxref_10_c_2232_n ) capacitor c=0.00884545f \
 //x=16.715 //y=4.88 //x2=17.455 //y2=4.25
cc_1270 ( N_RN_c_1578_n N_noxref_10_c_2232_n ) capacitor c=0.00619366f \
 //x=16.742 //y=2.685 //x2=17.455 //y2=4.25
cc_1271 ( N_RN_c_1661_n N_noxref_10_c_2232_n ) capacitor c=0.0065098f \
 //x=16.742 //y=3.055 //x2=17.455 //y2=4.25
cc_1272 ( N_RN_c_1662_n N_noxref_10_c_2232_n ) capacitor c=0.00646753f \
 //x=16.742 //y=3.425 //x2=17.455 //y2=4.25
cc_1273 ( N_RN_c_1584_n N_noxref_10_c_2232_n ) capacitor c=0.0252899f \
 //x=16.742 //y=4.535 //x2=17.455 //y2=4.25
cc_1274 ( N_RN_c_1721_p N_noxref_10_c_2232_n ) capacitor c=7.08595e-19 \
 //x=20.442 //y=3.055 //x2=17.455 //y2=4.25
cc_1275 ( N_RN_c_1672_n N_noxref_10_c_2232_n ) capacitor c=0.00780434f \
 //x=16.715 //y=2.26 //x2=17.455 //y2=4.25
cc_1276 ( N_RN_c_1674_n N_noxref_10_c_2232_n ) capacitor c=0.00283672f \
 //x=16.715 //y=2.095 //x2=17.455 //y2=4.25
cc_1277 ( N_RN_c_1675_n N_noxref_10_c_2232_n ) capacitor c=0.013693f \
 //x=16.715 //y=4.88 //x2=17.455 //y2=4.25
cc_1278 ( N_RN_c_1582_n N_noxref_10_c_2447_n ) capacitor c=0.0174995f \
 //x=16.715 //y=4.88 //x2=16.675 //y2=5.335
cc_1279 ( N_RN_c_1675_n N_noxref_10_c_2447_n ) capacitor c=0.00475729f \
 //x=16.715 //y=4.88 //x2=16.675 //y2=5.335
cc_1280 ( N_RN_c_1560_n N_noxref_10_c_2322_n ) capacitor c=3.11115e-19 \
 //x=16.6 //y=2.4 //x2=12.315 //y2=1.585
cc_1281 ( N_RN_c_1560_n N_noxref_10_c_2294_n ) capacitor c=0.00571486f \
 //x=16.6 //y=2.4 //x2=11.905 //y2=2.26
cc_1282 ( N_RN_c_1668_n N_noxref_10_M10_noxref_d ) capacitor c=0.00217566f \
 //x=16.705 //y=1.095 //x2=16.78 //y2=1.095
cc_1283 ( N_RN_c_1669_n N_noxref_10_M10_noxref_d ) capacitor c=0.0034598f \
 //x=16.705 //y=1.44 //x2=16.78 //y2=1.095
cc_1284 ( N_RN_c_1670_n N_noxref_10_M10_noxref_d ) capacitor c=0.00546784f \
 //x=16.705 //y=1.75 //x2=16.78 //y2=1.095
cc_1285 ( N_RN_c_1804_p N_noxref_10_M10_noxref_d ) capacitor c=0.00241102f \
 //x=17.08 //y=0.94 //x2=16.78 //y2=1.095
cc_1286 ( N_RN_c_1778_p N_noxref_10_M10_noxref_d ) capacitor c=0.0138621f \
 //x=17.08 //y=1.595 //x2=16.78 //y2=1.095
cc_1287 ( N_RN_c_1806_p N_noxref_10_M10_noxref_d ) capacitor c=0.00219619f \
 //x=17.235 //y=1.095 //x2=16.78 //y2=1.095
cc_1288 ( N_RN_c_1779_p N_noxref_10_M10_noxref_d ) capacitor c=0.00603828f \
 //x=17.235 //y=1.44 //x2=16.78 //y2=1.095
cc_1289 ( N_RN_c_1674_n N_noxref_10_M10_noxref_d ) capacitor c=0.00661782f \
 //x=16.715 //y=2.095 //x2=16.78 //y2=1.095
cc_1290 ( N_RN_M36_noxref_g N_noxref_10_M36_noxref_d ) capacitor c=0.0180032f \
 //x=16.455 //y=6.2 //x2=16.53 //y2=5.2
cc_1291 ( N_RN_M37_noxref_g N_noxref_10_M36_noxref_d ) capacitor c=0.0194246f \
 //x=16.895 //y=6.2 //x2=16.53 //y2=5.2
cc_1292 ( RN D ) capacitor c=0.00505269f //x=8.63 //y=2.77 //x2=7.52 //y2=2.77
cc_1293 ( RN D ) capacitor c=0.00505269f //x=8.63 //y=3.14 //x2=7.52 //y2=3.14
cc_1294 ( N_RN_c_1568_n N_D_c_2768_n ) capacitor c=0.00558344f //x=8.69 \
 //y=2.4 //x2=7.465 //y2=2.26
cc_1295 ( N_RN_c_1611_n N_D_c_2768_n ) capacitor c=0.00847578f //x=8.575 \
 //y=2.485 //x2=7.465 //y2=2.26
cc_1296 ( N_RN_c_1632_n N_D_c_2768_n ) capacitor c=0.00209043f //x=8.575 \
 //y=2.26 //x2=7.465 //y2=2.26
cc_1297 ( N_RN_c_1581_n N_D_c_2769_n ) capacitor c=0.0265853f //x=8.575 \
 //y=4.88 //x2=7.465 //y2=4.88
cc_1298 ( N_RN_c_1635_n N_D_c_2769_n ) capacitor c=0.00219458f //x=8.575 \
 //y=4.88 //x2=7.465 //y2=4.88
cc_1299 ( N_RN_c_1618_n N_D_c_2797_n ) capacitor c=0.00419471f //x=8.602 \
 //y=3.055 //x2=7.492 //y2=3.055
cc_1300 ( N_RN_M26_noxref_g N_D_M24_noxref_g ) capacitor c=0.0101598f \
 //x=8.315 //y=6.2 //x2=7.435 //y2=6.2
cc_1301 ( N_RN_M26_noxref_g N_D_M25_noxref_g ) capacitor c=0.0602553f \
 //x=8.315 //y=6.2 //x2=7.875 //y2=6.2
cc_1302 ( N_RN_M27_noxref_g N_D_M25_noxref_g ) capacitor c=0.0101598f \
 //x=8.755 //y=6.2 //x2=7.875 //y2=6.2
cc_1303 ( N_RN_c_1623_n N_D_c_2806_n ) capacitor c=0.00456962f //x=8.565 \
 //y=1.095 //x2=7.555 //y2=1.09
cc_1304 ( N_RN_c_1624_n N_D_c_2807_n ) capacitor c=0.00438372f //x=8.565 \
 //y=1.44 //x2=7.555 //y2=1.4
cc_1305 ( N_RN_c_1625_n N_D_c_2808_n ) capacitor c=0.00438372f //x=8.565 \
 //y=1.75 //x2=7.555 //y2=1.63
cc_1306 ( N_RN_c_1568_n N_D_c_2809_n ) capacitor c=0.00341397f //x=8.69 \
 //y=2.4 //x2=7.555 //y2=2.095
cc_1307 ( N_RN_c_1611_n N_D_c_2809_n ) capacitor c=0.00223694f //x=8.575 \
 //y=2.485 //x2=7.555 //y2=2.095
cc_1308 ( N_RN_c_1632_n N_D_c_2809_n ) capacitor c=0.00881982f //x=8.575 \
 //y=2.26 //x2=7.555 //y2=2.095
cc_1309 ( N_RN_c_1633_n N_D_c_2809_n ) capacitor c=0.00438372f //x=8.575 \
 //y=2.095 //x2=7.555 //y2=2.095
cc_1310 ( N_RN_c_1635_n N_D_c_2786_n ) capacitor c=0.0611812f //x=8.575 \
 //y=4.88 //x2=7.8 //y2=4.97
cc_1311 ( N_RN_c_1581_n N_D_c_2787_n ) capacitor c=0.00142741f //x=8.575 \
 //y=4.88 //x2=7.465 //y2=4.88
cc_1312 ( N_RN_c_1635_n N_D_c_2787_n ) capacitor c=0.00487508f //x=8.575 \
 //y=4.88 //x2=7.465 //y2=4.88
cc_1313 ( N_RN_c_1560_n N_noxref_16_c_2913_n ) capacitor c=4.68462e-19 \
 //x=16.6 //y=2.4 //x2=9.23 //y2=0.72
cc_1314 ( N_RN_c_1568_n N_noxref_16_c_2913_n ) capacitor c=4.26424e-19 \
 //x=8.69 //y=2.4 //x2=9.23 //y2=0.72
cc_1315 ( N_RN_c_1611_n N_noxref_16_c_2913_n ) capacitor c=0.00234129f \
 //x=8.575 //y=2.485 //x2=9.23 //y2=0.72
cc_1316 ( N_RN_c_1623_n N_noxref_16_c_2913_n ) capacitor c=0.0190866f \
 //x=8.565 //y=1.095 //x2=9.23 //y2=0.72
cc_1317 ( N_RN_c_1629_n N_noxref_16_c_2913_n ) capacitor c=0.00656458f \
 //x=9.095 //y=1.095 //x2=9.23 //y2=0.72
cc_1318 ( N_RN_c_1632_n N_noxref_16_c_2913_n ) capacitor c=2.20712e-19 \
 //x=8.575 //y=2.26 //x2=9.23 //y2=0.72
cc_1319 ( N_RN_c_1624_n N_noxref_16_c_2925_n ) capacitor c=0.00538829f \
 //x=8.565 //y=1.44 //x2=8.345 //y2=1.175
cc_1320 ( N_RN_c_1623_n N_noxref_16_M5_noxref_s ) capacitor c=0.00538829f \
 //x=8.565 //y=1.095 //x2=8.21 //y2=0.555
cc_1321 ( N_RN_c_1625_n N_noxref_16_M5_noxref_s ) capacitor c=0.00538829f \
 //x=8.565 //y=1.75 //x2=8.21 //y2=0.555
cc_1322 ( N_RN_c_1629_n N_noxref_16_M5_noxref_s ) capacitor c=0.0143002f \
 //x=9.095 //y=1.095 //x2=8.21 //y2=0.555
cc_1323 ( N_RN_c_1630_n N_noxref_16_M5_noxref_s ) capacitor c=0.00290153f \
 //x=9.095 //y=1.44 //x2=8.21 //y2=0.555
cc_1324 ( N_RN_c_1560_n N_noxref_17_c_2981_n ) capacitor c=0.00635755f \
 //x=16.6 //y=2.4 //x2=10.75 //y2=1.675
cc_1325 ( N_RN_c_1560_n N_noxref_17_c_2962_n ) capacitor c=0.0223494f //x=16.6 \
 //y=2.4 //x2=11.635 //y2=1.76
cc_1326 ( N_RN_c_1560_n N_noxref_17_c_2969_n ) capacitor c=0.00649228f \
 //x=16.6 //y=2.4 //x2=11.72 //y2=1.675
cc_1327 ( N_RN_c_1560_n N_noxref_17_c_2970_n ) capacitor c=0.00178534f \
 //x=16.6 //y=2.4 //x2=12.605 //y2=0.71
cc_1328 ( N_RN_c_1560_n N_noxref_17_M6_noxref_s ) capacitor c=0.00113237f \
 //x=16.6 //y=2.4 //x2=10.615 //y2=0.545
cc_1329 ( N_RN_c_1560_n N_noxref_18_c_3030_n ) capacitor c=0.00642985f \
 //x=16.6 //y=2.4 //x2=13.975 //y2=1.685
cc_1330 ( N_RN_c_1560_n N_noxref_18_c_3014_n ) capacitor c=0.0225733f //x=16.6 \
 //y=2.4 //x2=14.86 //y2=1.77
cc_1331 ( N_RN_c_1560_n N_noxref_18_c_3044_n ) capacitor c=0.0193312f //x=16.6 \
 //y=2.4 //x2=15.83 //y2=1.77
cc_1332 ( N_RN_c_1560_n N_noxref_18_M8_noxref_s ) capacitor c=0.012425f \
 //x=16.6 //y=2.4 //x2=13.84 //y2=0.555
cc_1333 ( N_RN_c_1560_n N_noxref_19_c_3065_n ) capacitor c=0.00657782f \
 //x=16.6 //y=2.4 //x2=16.4 //y2=1.175
cc_1334 ( N_RN_c_1570_n N_noxref_19_c_3070_n ) capacitor c=4.68462e-19 \
 //x=20.3 //y=2.4 //x2=17.37 //y2=0.72
cc_1335 ( N_RN_c_1574_n N_noxref_19_c_3070_n ) capacitor c=4.26424e-19 \
 //x=16.83 //y=2.4 //x2=17.37 //y2=0.72
cc_1336 ( N_RN_c_1656_n N_noxref_19_c_3070_n ) capacitor c=0.00234129f \
 //x=16.715 //y=2.485 //x2=17.37 //y2=0.72
cc_1337 ( N_RN_c_1668_n N_noxref_19_c_3070_n ) capacitor c=0.0190866f \
 //x=16.705 //y=1.095 //x2=17.37 //y2=0.72
cc_1338 ( N_RN_c_1806_p N_noxref_19_c_3070_n ) capacitor c=0.00656458f \
 //x=17.235 //y=1.095 //x2=17.37 //y2=0.72
cc_1339 ( N_RN_c_1672_n N_noxref_19_c_3070_n ) capacitor c=2.20712e-19 \
 //x=16.715 //y=2.26 //x2=17.37 //y2=0.72
cc_1340 ( N_RN_c_1669_n N_noxref_19_c_3098_n ) capacitor c=0.00538829f \
 //x=16.705 //y=1.44 //x2=16.485 //y2=1.175
cc_1341 ( N_RN_c_1560_n N_noxref_19_M10_noxref_s ) capacitor c=0.00642985f \
 //x=16.6 //y=2.4 //x2=16.35 //y2=0.555
cc_1342 ( N_RN_c_1668_n N_noxref_19_M10_noxref_s ) capacitor c=0.00538829f \
 //x=16.705 //y=1.095 //x2=16.35 //y2=0.555
cc_1343 ( N_RN_c_1670_n N_noxref_19_M10_noxref_s ) capacitor c=0.00538829f \
 //x=16.705 //y=1.75 //x2=16.35 //y2=0.555
cc_1344 ( N_RN_c_1806_p N_noxref_19_M10_noxref_s ) capacitor c=0.0143002f \
 //x=17.235 //y=1.095 //x2=16.35 //y2=0.555
cc_1345 ( N_RN_c_1779_p N_noxref_19_M10_noxref_s ) capacitor c=0.00290153f \
 //x=17.235 //y=1.44 //x2=16.35 //y2=0.555
cc_1346 ( N_RN_c_1570_n N_noxref_20_c_3135_n ) capacitor c=0.00642985f \
 //x=20.3 //y=2.4 //x2=18.785 //y2=1.685
cc_1347 ( N_RN_c_1570_n N_noxref_20_c_3119_n ) capacitor c=0.0225733f //x=20.3 \
 //y=2.4 //x2=19.67 //y2=1.77
cc_1348 ( N_RN_c_1699_n N_noxref_20_c_3126_n ) capacitor c=0.0167228f \
 //x=19.98 //y=1.09 //x2=20.64 //y2=0.72
cc_1349 ( N_RN_c_1704_n N_noxref_20_c_3126_n ) capacitor c=0.00534519f \
 //x=20.505 //y=1.09 //x2=20.64 //y2=0.72
cc_1350 ( N_RN_c_1570_n N_noxref_20_c_3149_n ) capacitor c=0.0161937f //x=20.3 \
 //y=2.4 //x2=20.64 //y2=1.77
cc_1351 ( N_RN_c_1687_n N_noxref_20_c_3149_n ) capacitor c=0.0127583f \
 //x=20.415 //y=2.485 //x2=20.64 //y2=1.77
cc_1352 ( N_RN_c_1702_n N_noxref_20_c_3149_n ) capacitor c=0.0157358f \
 //x=19.98 //y=1.4 //x2=20.64 //y2=1.77
cc_1353 ( N_RN_c_1707_n N_noxref_20_c_3149_n ) capacitor c=0.0221109f \
 //x=20.505 //y=2.095 //x2=20.64 //y2=1.77
cc_1354 ( N_RN_c_1570_n N_noxref_20_M11_noxref_s ) capacitor c=0.00642985f \
 //x=20.3 //y=2.4 //x2=18.65 //y2=0.555
cc_1355 ( N_RN_c_1699_n N_noxref_20_M11_noxref_s ) capacitor c=0.00798959f \
 //x=19.98 //y=1.09 //x2=18.65 //y2=0.555
cc_1356 ( N_RN_c_1706_n N_noxref_20_M11_noxref_s ) capacitor c=0.00212176f \
 //x=20.505 //y=1.63 //x2=18.65 //y2=0.555
cc_1357 ( N_RN_c_1707_n N_noxref_20_M11_noxref_s ) capacitor c=0.00298115f \
 //x=20.505 //y=2.095 //x2=18.65 //y2=0.555
cc_1358 ( N_RN_c_1877_p N_noxref_21_c_3171_n ) capacitor c=2.14837e-19 \
 //x=20.35 //y=0.935 //x2=21.21 //y2=1.175
cc_1359 ( N_RN_c_1704_n N_noxref_21_c_3171_n ) capacitor c=0.00123426f \
 //x=20.505 //y=1.09 //x2=21.21 //y2=1.175
cc_1360 ( N_RN_c_1705_n N_noxref_21_c_3171_n ) capacitor c=0.0129288f \
 //x=20.505 //y=1.4 //x2=21.21 //y2=1.175
cc_1361 ( N_RN_c_1706_n N_noxref_21_c_3171_n ) capacitor c=0.00142359f \
 //x=20.505 //y=1.63 //x2=21.21 //y2=1.175
cc_1362 ( N_RN_c_1699_n N_noxref_21_M12_noxref_d ) capacitor c=0.00223875f \
 //x=19.98 //y=1.09 //x2=20.055 //y2=1.09
cc_1363 ( N_RN_c_1702_n N_noxref_21_M12_noxref_d ) capacitor c=0.00262485f \
 //x=19.98 //y=1.4 //x2=20.055 //y2=1.09
cc_1364 ( N_RN_c_1877_p N_noxref_21_M12_noxref_d ) capacitor c=0.00220746f \
 //x=20.35 //y=0.935 //x2=20.055 //y2=1.09
cc_1365 ( N_RN_c_1884_p N_noxref_21_M12_noxref_d ) capacitor c=0.00194798f \
 //x=20.35 //y=1.555 //x2=20.055 //y2=1.09
cc_1366 ( N_RN_c_1704_n N_noxref_21_M12_noxref_d ) capacitor c=0.00198465f \
 //x=20.505 //y=1.09 //x2=20.055 //y2=1.09
cc_1367 ( N_RN_c_1705_n N_noxref_21_M12_noxref_d ) capacitor c=0.00128384f \
 //x=20.505 //y=1.4 //x2=20.055 //y2=1.09
cc_1368 ( N_RN_c_1704_n N_noxref_21_M13_noxref_s ) capacitor c=7.21316e-19 \
 //x=20.505 //y=1.09 //x2=21.16 //y2=0.555
cc_1369 ( N_RN_c_1705_n N_noxref_21_M13_noxref_s ) capacitor c=0.00348171f \
 //x=20.505 //y=1.4 //x2=21.16 //y2=0.555
cc_1370 ( N_noxref_8_c_1922_n QN ) capacitor c=7.75607e-19 //x=21.525 //y=2.26 \
 //x2=22.32 //y2=2.4
cc_1371 ( N_noxref_8_c_1889_n QN ) capacitor c=0.005746f //x=21.525 //y=2.26 \
 //x2=22.32 //y2=3.51
cc_1372 ( N_noxref_8_M43_noxref_g QN ) capacitor c=0.00447614f //x=21.705 \
 //y=6.2 //x2=22.32 //y2=4.99
cc_1373 ( N_noxref_8_c_1926_n QN ) capacitor c=7.75607e-19 //x=21.525 //y=4.88 \
 //x2=22.32 //y2=4.99
cc_1374 ( N_noxref_8_M42_noxref_g N_QN_c_2008_n ) capacitor c=0.0184045f \
 //x=21.265 //y=6.2 //x2=21.4 //y2=5.335
cc_1375 ( N_noxref_8_M43_noxref_g N_QN_c_2012_n ) capacitor c=0.0205426f \
 //x=21.705 //y=6.2 //x2=22.18 //y2=5.335
cc_1376 ( N_noxref_8_c_1926_n N_QN_c_2012_n ) capacitor c=0.00201851f \
 //x=21.525 //y=4.88 //x2=22.18 //y2=5.335
cc_1377 ( N_noxref_8_c_1936_p N_QN_c_1983_n ) capacitor c=0.00359704f \
 //x=21.89 //y=1.595 //x2=22.18 //y2=1.845
cc_1378 ( N_noxref_8_c_1937_p N_QN_c_1983_n ) capacitor c=0.00457401f \
 //x=22.045 //y=1.44 //x2=22.18 //y2=1.845
cc_1379 ( N_noxref_8_c_1890_n N_QN_c_2068_n ) capacitor c=0.00103639f \
 //x=21.525 //y=3.88 //x2=21.865 //y2=1.845
cc_1380 ( N_noxref_8_c_1889_n N_QN_c_2069_n ) capacitor c=0.0168082f \
 //x=21.525 //y=2.26 //x2=21.485 //y2=5.335
cc_1381 ( N_noxref_8_c_1926_n N_QN_c_2069_n ) capacitor c=0.00475729f \
 //x=21.525 //y=4.88 //x2=21.485 //y2=5.335
cc_1382 ( N_noxref_8_c_1889_n N_QN_c_2071_n ) capacitor c=0.0853601f \
 //x=21.525 //y=2.26 //x2=22.292 //y2=2.315
cc_1383 ( N_noxref_8_c_1922_n N_QN_c_2071_n ) capacitor c=0.00776757f \
 //x=21.525 //y=2.26 //x2=22.292 //y2=2.315
cc_1384 ( N_noxref_8_c_1925_n N_QN_c_2071_n ) capacitor c=0.00283672f \
 //x=21.525 //y=2.095 //x2=22.292 //y2=2.315
cc_1385 ( N_noxref_8_c_1889_n N_QN_c_2019_n ) capacitor c=4.01795e-19 \
 //x=21.525 //y=2.26 //x2=22.292 //y2=4.535
cc_1386 ( N_noxref_8_c_1890_n N_QN_c_2019_n ) capacitor c=0.00117715f \
 //x=21.525 //y=3.88 //x2=22.292 //y2=4.535
cc_1387 ( N_noxref_8_c_1926_n N_QN_c_2020_n ) capacitor c=0.00961547f \
 //x=21.525 //y=4.88 //x2=22.292 //y2=4.905
cc_1388 ( N_noxref_8_c_1889_n N_QN_c_2077_n ) capacitor c=0.00100485f \
 //x=21.525 //y=2.26 //x2=24.142 //y2=3.055
cc_1389 ( N_noxref_8_c_1919_n N_QN_M13_noxref_d ) capacitor c=0.00217566f \
 //x=21.515 //y=1.095 //x2=21.59 //y2=1.095
cc_1390 ( N_noxref_8_c_1920_n N_QN_M13_noxref_d ) capacitor c=0.0034598f \
 //x=21.515 //y=1.44 //x2=21.59 //y2=1.095
cc_1391 ( N_noxref_8_c_1921_n N_QN_M13_noxref_d ) capacitor c=0.00544291f \
 //x=21.515 //y=1.75 //x2=21.59 //y2=1.095
cc_1392 ( N_noxref_8_c_1951_p N_QN_M13_noxref_d ) capacitor c=0.00241102f \
 //x=21.89 //y=0.94 //x2=21.59 //y2=1.095
cc_1393 ( N_noxref_8_c_1936_p N_QN_M13_noxref_d ) capacitor c=0.0140297f \
 //x=21.89 //y=1.595 //x2=21.59 //y2=1.095
cc_1394 ( N_noxref_8_c_1953_p N_QN_M13_noxref_d ) capacitor c=0.00219619f \
 //x=22.045 //y=1.095 //x2=21.59 //y2=1.095
cc_1395 ( N_noxref_8_c_1937_p N_QN_M13_noxref_d ) capacitor c=0.00603828f \
 //x=22.045 //y=1.44 //x2=21.59 //y2=1.095
cc_1396 ( N_noxref_8_c_1925_n N_QN_M13_noxref_d ) capacitor c=0.00661782f \
 //x=21.525 //y=2.095 //x2=21.59 //y2=1.095
cc_1397 ( N_noxref_8_M42_noxref_g N_QN_M42_noxref_d ) capacitor c=0.0180032f \
 //x=21.265 //y=6.2 //x2=21.34 //y2=5.2
cc_1398 ( N_noxref_8_M43_noxref_g N_QN_M42_noxref_d ) capacitor c=0.0194246f \
 //x=21.705 //y=6.2 //x2=21.34 //y2=5.2
cc_1399 ( N_noxref_8_c_1889_n N_noxref_10_c_2172_n ) capacitor c=0.0237491f \
 //x=21.525 //y=2.26 //x2=24.74 //y2=4.25
cc_1400 ( N_noxref_8_c_1890_n N_noxref_10_c_2172_n ) capacitor c=0.0425064f \
 //x=21.525 //y=3.88 //x2=24.74 //y2=4.25
cc_1401 ( N_noxref_8_c_1926_n N_noxref_10_c_2172_n ) capacitor c=0.00775263f \
 //x=21.525 //y=4.88 //x2=24.74 //y2=4.25
cc_1402 ( N_noxref_8_c_1889_n N_noxref_11_c_2582_n ) capacitor c=0.00339975f \
 //x=21.525 //y=2.26 //x2=25.595 //y2=3.88
cc_1403 ( N_noxref_8_c_1890_n N_noxref_11_c_2582_n ) capacitor c=0.0326551f \
 //x=21.525 //y=3.88 //x2=25.595 //y2=3.88
cc_1404 ( N_noxref_8_c_1889_n N_noxref_21_c_3176_n ) capacitor c=0.00209081f \
 //x=21.525 //y=2.26 //x2=22.18 //y2=0.72
cc_1405 ( N_noxref_8_c_1890_n N_noxref_21_c_3176_n ) capacitor c=3.55246e-19 \
 //x=21.525 //y=3.88 //x2=22.18 //y2=0.72
cc_1406 ( N_noxref_8_c_1919_n N_noxref_21_c_3176_n ) capacitor c=0.0194423f \
 //x=21.515 //y=1.095 //x2=22.18 //y2=0.72
cc_1407 ( N_noxref_8_c_1953_p N_noxref_21_c_3176_n ) capacitor c=0.00656458f \
 //x=22.045 //y=1.095 //x2=22.18 //y2=0.72
cc_1408 ( N_noxref_8_c_1922_n N_noxref_21_c_3176_n ) capacitor c=2.20712e-19 \
 //x=21.525 //y=2.26 //x2=22.18 //y2=0.72
cc_1409 ( N_noxref_8_c_1920_n N_noxref_21_c_3202_n ) capacitor c=0.00538829f \
 //x=21.515 //y=1.44 //x2=21.295 //y2=1.175
cc_1410 ( N_noxref_8_c_1919_n N_noxref_21_M13_noxref_s ) capacitor \
 c=0.00538829f //x=21.515 //y=1.095 //x2=21.16 //y2=0.555
cc_1411 ( N_noxref_8_c_1921_n N_noxref_21_M13_noxref_s ) capacitor \
 c=0.00538829f //x=21.515 //y=1.75 //x2=21.16 //y2=0.555
cc_1412 ( N_noxref_8_c_1953_p N_noxref_21_M13_noxref_s ) capacitor \
 c=0.0143002f //x=22.045 //y=1.095 //x2=21.16 //y2=0.555
cc_1413 ( N_noxref_8_c_1937_p N_noxref_21_M13_noxref_s ) capacitor \
 c=0.00290153f //x=22.045 //y=1.44 //x2=21.16 //y2=0.555
cc_1414 ( QN N_noxref_10_c_2172_n ) capacitor c=0.00158189f //x=22.32 //y=3.51 \
 //x2=24.74 //y2=4.25
cc_1415 ( QN N_noxref_10_c_2172_n ) capacitor c=0.00175716f //x=22.32 //y=4.62 \
 //x2=24.74 //y2=4.25
cc_1416 ( QN N_noxref_10_c_2172_n ) capacitor c=0.00960745f //x=24.17 //y=3.51 \
 //x2=24.74 //y2=4.25
cc_1417 ( QN N_noxref_10_c_2172_n ) capacitor c=0.00175716f //x=24.17 //y=4.62 \
 //x2=24.74 //y2=4.25
cc_1418 ( N_QN_c_2006_n N_noxref_10_c_2172_n ) capacitor c=0.0173f //x=19.81 \
 //y=5.335 //x2=24.74 //y2=4.25
cc_1419 ( N_QN_c_2012_n N_noxref_10_c_2172_n ) capacitor c=0.0138019f \
 //x=22.18 //y=5.335 //x2=24.74 //y2=4.25
cc_1420 ( N_QN_c_2068_n N_noxref_10_c_2172_n ) capacitor c=5.76262e-19 \
 //x=21.865 //y=1.845 //x2=24.74 //y2=4.25
cc_1421 ( N_QN_c_2052_n N_noxref_10_c_2172_n ) capacitor c=0.0226739f \
 //x=20.605 //y=5.335 //x2=24.74 //y2=4.25
cc_1422 ( N_QN_c_2019_n N_noxref_10_c_2172_n ) capacitor c=0.0232727f \
 //x=22.292 //y=4.535 //x2=24.74 //y2=4.25
cc_1423 ( N_QN_c_2021_n N_noxref_10_c_2172_n ) capacitor c=0.0242126f \
 //x=24.142 //y=4.535 //x2=24.74 //y2=4.25
cc_1424 ( N_QN_c_2026_n N_noxref_10_c_2172_n ) capacitor c=0.0072399f \
 //x=24.115 //y=4.88 //x2=24.74 //y2=4.25
cc_1425 ( N_QN_c_2006_n N_noxref_10_c_2228_n ) capacitor c=3.10026e-19 \
 //x=19.81 //y=5.335 //x2=17.37 //y2=5.335
cc_1426 ( N_QN_c_2017_n N_noxref_10_c_2476_n ) capacitor c=0.00348308f \
 //x=24.115 //y=4.88 //x2=24.855 //y2=4.715
cc_1427 ( N_QN_c_2026_n N_noxref_10_c_2476_n ) capacitor c=0.00417994f \
 //x=24.115 //y=4.88 //x2=24.855 //y2=4.715
cc_1428 ( QN N_noxref_10_c_2177_n ) capacitor c=0.00777753f //x=24.17 //y=2.77 \
 //x2=24.855 //y2=2.26
cc_1429 ( QN N_noxref_10_c_2177_n ) capacitor c=0.00777753f //x=24.17 //y=3.14 \
 //x2=24.855 //y2=2.26
cc_1430 ( QN N_noxref_10_c_2177_n ) capacitor c=0.00969682f //x=24.17 //y=3.51 \
 //x2=24.855 //y2=2.26
cc_1431 ( QN N_noxref_10_c_2177_n ) capacitor c=0.00777753f //x=24.17 //y=4.62 \
 //x2=24.855 //y2=2.26
cc_1432 ( N_QN_c_1984_n N_noxref_10_c_2177_n ) capacitor c=0.0117175f \
 //x=24.115 //y=2.485 //x2=24.855 //y2=2.26
cc_1433 ( N_QN_c_2017_n N_noxref_10_c_2177_n ) capacitor c=0.00507077f \
 //x=24.115 //y=4.88 //x2=24.855 //y2=2.26
cc_1434 ( N_QN_c_2019_n N_noxref_10_c_2177_n ) capacitor c=4.12205e-19 \
 //x=22.292 //y=4.535 //x2=24.855 //y2=2.26
cc_1435 ( N_QN_c_2109_p N_noxref_10_c_2177_n ) capacitor c=0.0065098f \
 //x=24.142 //y=2.685 //x2=24.855 //y2=2.26
cc_1436 ( N_QN_c_2077_n N_noxref_10_c_2177_n ) capacitor c=0.0065098f \
 //x=24.142 //y=3.055 //x2=24.855 //y2=2.26
cc_1437 ( N_QN_c_2111_p N_noxref_10_c_2177_n ) capacitor c=0.00619366f \
 //x=24.142 //y=3.425 //x2=24.855 //y2=2.26
cc_1438 ( N_QN_c_2021_n N_noxref_10_c_2177_n ) capacitor c=0.0249489f \
 //x=24.142 //y=4.535 //x2=24.855 //y2=2.26
cc_1439 ( N_QN_c_1991_n N_noxref_10_c_2177_n ) capacitor c=0.00388209f \
 //x=23.92 //y=2.095 //x2=24.855 //y2=2.26
cc_1440 ( N_QN_M44_noxref_g N_noxref_10_M46_noxref_g ) capacitor c=0.0104611f \
 //x=24.015 //y=6.2 //x2=24.895 //y2=6.2
cc_1441 ( N_QN_M45_noxref_g N_noxref_10_M46_noxref_g ) capacitor c=0.106811f \
 //x=24.455 //y=6.2 //x2=24.895 //y2=6.2
cc_1442 ( N_QN_M45_noxref_g N_noxref_10_M47_noxref_g ) capacitor c=0.0100341f \
 //x=24.455 //y=6.2 //x2=25.335 //y2=6.2
cc_1443 ( N_QN_c_1987_n N_noxref_10_c_2493_n ) capacitor c=4.86506e-19 \
 //x=23.92 //y=1.045 //x2=24.89 //y2=1.085
cc_1444 ( N_QN_c_1989_n N_noxref_10_c_2493_n ) capacitor c=0.00152104f \
 //x=23.92 //y=1.39 //x2=24.89 //y2=1.085
cc_1445 ( N_QN_c_1994_n N_noxref_10_c_2493_n ) capacitor c=0.0151475f \
 //x=24.45 //y=1.045 //x2=24.89 //y2=1.085
cc_1446 ( N_QN_c_1990_n N_noxref_10_c_2496_n ) capacitor c=0.00109982f \
 //x=23.92 //y=1.7 //x2=24.89 //y2=1.43
cc_1447 ( N_QN_c_1996_n N_noxref_10_c_2496_n ) capacitor c=0.0111064f \
 //x=24.45 //y=1.39 //x2=24.89 //y2=1.43
cc_1448 ( N_QN_c_1990_n N_noxref_10_c_2498_n ) capacitor c=9.57794e-19 \
 //x=23.92 //y=1.7 //x2=24.89 //y2=1.74
cc_1449 ( N_QN_c_1991_n N_noxref_10_c_2498_n ) capacitor c=0.00662747f \
 //x=23.92 //y=2.095 //x2=24.89 //y2=1.74
cc_1450 ( N_QN_c_1996_n N_noxref_10_c_2498_n ) capacitor c=0.00862358f \
 //x=24.45 //y=1.39 //x2=24.89 //y2=1.74
cc_1451 ( N_QN_c_1994_n N_noxref_10_c_2501_n ) capacitor c=0.00124821f \
 //x=24.45 //y=1.045 //x2=25.42 //y2=1.085
cc_1452 ( N_QN_c_1996_n N_noxref_10_c_2502_n ) capacitor c=0.00200715f \
 //x=24.45 //y=1.39 //x2=25.42 //y2=1.43
cc_1453 ( N_QN_c_1984_n N_noxref_10_c_2503_n ) capacitor c=0.00402155f \
 //x=24.115 //y=2.485 //x2=24.855 //y2=2.26
cc_1454 ( N_QN_c_1991_n N_noxref_10_c_2503_n ) capacitor c=0.0170731f \
 //x=23.92 //y=2.095 //x2=24.855 //y2=2.26
cc_1455 ( N_QN_c_2017_n N_noxref_10_c_2505_n ) capacitor c=0.00344981f \
 //x=24.115 //y=4.88 //x2=24.885 //y2=4.88
cc_1456 ( N_QN_c_2026_n N_noxref_10_c_2505_n ) capacitor c=0.0293367f \
 //x=24.115 //y=4.88 //x2=24.885 //y2=4.88
cc_1457 ( N_QN_M45_noxref_g N_noxref_11_c_2587_n ) capacitor c=0.017965f \
 //x=24.455 //y=6.2 //x2=25.03 //y2=5.38
cc_1458 ( QN N_noxref_11_c_2591_n ) capacitor c=0.00152479f //x=24.17 //y=4.62 \
 //x2=24.32 //y2=5.38
cc_1459 ( N_QN_c_2017_n N_noxref_11_c_2591_n ) capacitor c=0.00549854f \
 //x=24.115 //y=4.88 //x2=24.32 //y2=5.38
cc_1460 ( N_QN_M44_noxref_g N_noxref_11_c_2591_n ) capacitor c=0.0177326f \
 //x=24.015 //y=6.2 //x2=24.32 //y2=5.38
cc_1461 ( N_QN_c_2026_n N_noxref_11_c_2591_n ) capacitor c=0.00493829f \
 //x=24.115 //y=4.88 //x2=24.32 //y2=5.38
cc_1462 ( QN N_noxref_11_c_2582_n ) capacitor c=0.0453081f //x=22.32 //y=3.51 \
 //x2=25.595 //y2=3.88
cc_1463 ( QN N_noxref_11_c_2582_n ) capacitor c=2.26899e-19 //x=24.17 //y=2.77 \
 //x2=25.595 //y2=3.88
cc_1464 ( QN N_noxref_11_c_2582_n ) capacitor c=2.26899e-19 //x=24.17 //y=3.14 \
 //x2=25.595 //y2=3.88
cc_1465 ( QN N_noxref_11_c_2582_n ) capacitor c=0.158506f //x=24.17 //y=3.51 \
 //x2=25.595 //y2=3.88
cc_1466 ( QN N_noxref_11_c_2582_n ) capacitor c=2.26899e-19 //x=24.17 //y=4.62 \
 //x2=25.595 //y2=3.88
cc_1467 ( N_QN_c_2068_n N_noxref_11_c_2582_n ) capacitor c=0.00266554f \
 //x=21.865 //y=1.845 //x2=25.595 //y2=3.88
cc_1468 ( N_QN_c_2017_n N_noxref_11_c_2582_n ) capacitor c=5.9619e-19 \
 //x=24.115 //y=4.88 //x2=25.595 //y2=3.88
cc_1469 ( N_QN_c_2019_n N_noxref_11_c_2582_n ) capacitor c=0.0178272f \
 //x=22.292 //y=4.535 //x2=25.595 //y2=3.88
cc_1470 ( N_QN_c_2109_p N_noxref_11_c_2582_n ) capacitor c=2.44001e-19 \
 //x=24.142 //y=2.685 //x2=25.595 //y2=3.88
cc_1471 ( N_QN_c_2077_n N_noxref_11_c_2582_n ) capacitor c=2.44001e-19 \
 //x=24.142 //y=3.055 //x2=25.595 //y2=3.88
cc_1472 ( N_QN_c_2111_p N_noxref_11_c_2582_n ) capacitor c=2.59702e-19 \
 //x=24.142 //y=3.425 //x2=25.595 //y2=3.88
cc_1473 ( N_QN_c_2021_n N_noxref_11_c_2582_n ) capacitor c=0.0196472f \
 //x=24.142 //y=4.535 //x2=25.595 //y2=3.88
cc_1474 ( N_QN_M45_noxref_g N_noxref_11_M44_noxref_d ) capacitor c=0.0173476f \
 //x=24.455 //y=6.2 //x2=24.09 //y2=5.2
cc_1475 ( N_QN_M13_noxref_d N_noxref_20_M11_noxref_s ) capacitor c=0.00309936f \
 //x=21.59 //y=1.095 //x2=18.65 //y2=0.555
cc_1476 ( N_QN_c_1983_n N_noxref_21_c_3176_n ) capacitor c=0.00467185f \
 //x=22.18 //y=1.845 //x2=22.18 //y2=0.72
cc_1477 ( N_QN_M13_noxref_d N_noxref_21_c_3176_n ) capacitor c=0.0118167f \
 //x=21.59 //y=1.095 //x2=22.18 //y2=0.72
cc_1478 ( N_QN_c_2068_n N_noxref_21_c_3202_n ) capacitor c=0.020048f \
 //x=21.865 //y=1.845 //x2=21.295 //y2=1.175
cc_1479 ( N_QN_M13_noxref_d N_noxref_21_M12_noxref_d ) capacitor c=5.27807e-19 \
 //x=21.59 //y=1.095 //x2=20.055 //y2=1.09
cc_1480 ( N_QN_c_1983_n N_noxref_21_M13_noxref_s ) capacitor c=0.020752f \
 //x=22.18 //y=1.845 //x2=21.16 //y2=0.555
cc_1481 ( N_QN_M13_noxref_d N_noxref_21_M13_noxref_s ) capacitor c=0.0426444f \
 //x=21.59 //y=1.095 //x2=21.16 //y2=0.555
cc_1482 ( QN N_noxref_22_c_3241_n ) capacitor c=0.00241565f //x=24.17 //y=3.51 \
 //x2=23.7 //y2=1.675
cc_1483 ( N_QN_c_1983_n N_noxref_22_c_3241_n ) capacitor c=3.04182e-19 \
 //x=22.18 //y=1.845 //x2=23.7 //y2=1.675
cc_1484 ( N_QN_c_1991_n N_noxref_22_c_3241_n ) capacitor c=0.0034165f \
 //x=23.92 //y=2.095 //x2=23.7 //y2=1.675
cc_1485 ( QN N_noxref_22_c_3224_n ) capacitor c=2.92449e-19 //x=24.17 //y=2.77 \
 //x2=24.585 //y2=1.76
cc_1486 ( QN N_noxref_22_c_3224_n ) capacitor c=0.00577566f //x=24.17 //y=3.51 \
 //x2=24.585 //y2=1.76
cc_1487 ( N_QN_c_1984_n N_noxref_22_c_3224_n ) capacitor c=0.0133079f \
 //x=24.115 //y=2.485 //x2=24.585 //y2=1.76
cc_1488 ( N_QN_c_1990_n N_noxref_22_c_3224_n ) capacitor c=0.00703567f \
 //x=23.92 //y=1.7 //x2=24.585 //y2=1.76
cc_1489 ( N_QN_c_1991_n N_noxref_22_c_3224_n ) capacitor c=0.0196397f \
 //x=23.92 //y=2.095 //x2=24.585 //y2=1.76
cc_1490 ( N_QN_c_1993_n N_noxref_22_c_3224_n ) capacitor c=0.00781703f \
 //x=24.295 //y=1.545 //x2=24.585 //y2=1.76
cc_1491 ( N_QN_c_1996_n N_noxref_22_c_3224_n ) capacitor c=0.00339872f \
 //x=24.45 //y=1.39 //x2=24.585 //y2=1.76
cc_1492 ( N_QN_c_1991_n N_noxref_22_c_3231_n ) capacitor c=6.71402e-19 \
 //x=23.92 //y=2.095 //x2=24.67 //y2=1.675
cc_1493 ( N_QN_c_1987_n N_noxref_22_M14_noxref_s ) capacitor c=0.0327502f \
 //x=23.92 //y=1.045 //x2=23.565 //y2=0.545
cc_1494 ( N_QN_c_1990_n N_noxref_22_M14_noxref_s ) capacitor c=3.48408e-19 \
 //x=23.92 //y=1.7 //x2=23.565 //y2=0.545
cc_1495 ( N_QN_c_1994_n N_noxref_22_M14_noxref_s ) capacitor c=0.0120759f \
 //x=24.45 //y=1.045 //x2=23.565 //y2=0.545
cc_1496 ( N_noxref_10_c_2172_n N_noxref_11_c_2587_n ) capacitor c=0.00208151f \
 //x=24.74 //y=4.25 //x2=25.03 //y2=5.38
cc_1497 ( N_noxref_10_c_2476_n N_noxref_11_c_2587_n ) capacitor c=0.0129205f \
 //x=24.855 //y=4.715 //x2=25.03 //y2=5.38
cc_1498 ( N_noxref_10_M46_noxref_g N_noxref_11_c_2587_n ) capacitor \
 c=0.0166421f //x=24.895 //y=6.2 //x2=25.03 //y2=5.38
cc_1499 ( N_noxref_10_c_2505_n N_noxref_11_c_2587_n ) capacitor c=0.00346627f \
 //x=24.885 //y=4.88 //x2=25.03 //y2=5.38
cc_1500 ( N_noxref_10_c_2172_n N_noxref_11_c_2591_n ) capacitor c=0.011927f \
 //x=24.74 //y=4.25 //x2=24.32 //y2=5.38
cc_1501 ( N_noxref_10_M47_noxref_g N_noxref_11_c_2593_n ) capacitor \
 c=0.0206783f //x=25.335 //y=6.2 //x2=25.51 //y2=5.38
cc_1502 ( N_noxref_10_c_2513_p N_noxref_11_c_2581_n ) capacitor c=0.00359704f \
 //x=25.265 //y=1.585 //x2=25.51 //y2=1.835
cc_1503 ( N_noxref_10_c_2502_n N_noxref_11_c_2581_n ) capacitor c=0.00457401f \
 //x=25.42 //y=1.43 //x2=25.51 //y2=1.835
cc_1504 ( N_noxref_10_c_2172_n N_noxref_11_c_2582_n ) capacitor c=0.292117f \
 //x=24.74 //y=4.25 //x2=25.595 //y2=3.88
cc_1505 ( N_noxref_10_c_2476_n N_noxref_11_c_2582_n ) capacitor c=0.0101115f \
 //x=24.855 //y=4.715 //x2=25.595 //y2=3.88
cc_1506 ( N_noxref_10_c_2177_n N_noxref_11_c_2582_n ) capacitor c=0.10424f \
 //x=24.855 //y=2.26 //x2=25.595 //y2=3.88
cc_1507 ( N_noxref_10_c_2518_p N_noxref_11_c_2582_n ) capacitor c=0.0205159f \
 //x=25.26 //y=4.97 //x2=25.595 //y2=3.88
cc_1508 ( N_noxref_10_c_2503_n N_noxref_11_c_2582_n ) capacitor c=0.00877984f \
 //x=24.855 //y=2.26 //x2=25.595 //y2=3.88
cc_1509 ( N_noxref_10_c_2520_p N_noxref_11_c_2582_n ) capacitor c=0.00306024f \
 //x=24.855 //y=2.095 //x2=25.595 //y2=3.88
cc_1510 ( N_noxref_10_c_2505_n N_noxref_11_c_2582_n ) capacitor c=0.00566398f \
 //x=24.885 //y=4.88 //x2=25.595 //y2=3.88
cc_1511 ( N_noxref_10_c_2518_p N_noxref_11_c_2646_n ) capacitor c=0.00421574f \
 //x=25.26 //y=4.97 //x2=25.115 //y2=5.38
cc_1512 ( N_noxref_10_c_2493_n N_noxref_11_M15_noxref_d ) capacitor \
 c=0.00217566f //x=24.89 //y=1.085 //x2=24.965 //y2=1.085
cc_1513 ( N_noxref_10_c_2496_n N_noxref_11_M15_noxref_d ) capacitor \
 c=0.0034598f //x=24.89 //y=1.43 //x2=24.965 //y2=1.085
cc_1514 ( N_noxref_10_c_2498_n N_noxref_11_M15_noxref_d ) capacitor \
 c=0.0065582f //x=24.89 //y=1.74 //x2=24.965 //y2=1.085
cc_1515 ( N_noxref_10_c_2526_p N_noxref_11_M15_noxref_d ) capacitor \
 c=0.00241102f //x=25.265 //y=0.93 //x2=24.965 //y2=1.085
cc_1516 ( N_noxref_10_c_2513_p N_noxref_11_M15_noxref_d ) capacitor \
 c=0.0138845f //x=25.265 //y=1.585 //x2=24.965 //y2=1.085
cc_1517 ( N_noxref_10_c_2501_n N_noxref_11_M15_noxref_d ) capacitor \
 c=0.00132245f //x=25.42 //y=1.085 //x2=24.965 //y2=1.085
cc_1518 ( N_noxref_10_c_2502_n N_noxref_11_M15_noxref_d ) capacitor \
 c=0.00566463f //x=25.42 //y=1.43 //x2=24.965 //y2=1.085
cc_1519 ( N_noxref_10_c_2520_p N_noxref_11_M15_noxref_d ) capacitor \
 c=0.00660593f //x=24.855 //y=2.095 //x2=24.965 //y2=1.085
cc_1520 ( N_noxref_10_M46_noxref_g N_noxref_11_M46_noxref_d ) capacitor \
 c=0.0173476f //x=24.895 //y=6.2 //x2=24.97 //y2=5.2
cc_1521 ( N_noxref_10_M47_noxref_g N_noxref_11_M46_noxref_d ) capacitor \
 c=0.0179769f //x=25.335 //y=6.2 //x2=24.97 //y2=5.2
cc_1522 ( N_noxref_10_c_2183_n N_noxref_12_c_2693_n ) capacitor c=0.0034165f \
 //x=1.245 //y=2.095 //x2=1.025 //y2=1.685
cc_1523 ( N_noxref_10_c_2170_n N_noxref_12_c_2667_n ) capacitor c=0.00179505f \
 //x=11.79 //y=4.25 //x2=1.91 //y2=1.77
cc_1524 ( N_noxref_10_c_2171_n N_noxref_12_c_2667_n ) capacitor c=0.00102628f \
 //x=1.66 //y=4.25 //x2=1.91 //y2=1.77
cc_1525 ( N_noxref_10_c_2173_n N_noxref_12_c_2667_n ) capacitor c=0.0122033f \
 //x=1.545 //y=2.26 //x2=1.91 //y2=1.77
cc_1526 ( N_noxref_10_c_2182_n N_noxref_12_c_2667_n ) capacitor c=0.00703864f \
 //x=1.245 //y=1.71 //x2=1.91 //y2=1.77
cc_1527 ( N_noxref_10_c_2183_n N_noxref_12_c_2667_n ) capacitor c=0.0259045f \
 //x=1.245 //y=2.095 //x2=1.91 //y2=1.77
cc_1528 ( N_noxref_10_c_2185_n N_noxref_12_c_2667_n ) capacitor c=0.00708583f \
 //x=1.62 //y=1.555 //x2=1.91 //y2=1.77
cc_1529 ( N_noxref_10_c_2188_n N_noxref_12_c_2667_n ) capacitor c=0.00698822f \
 //x=1.775 //y=1.4 //x2=1.91 //y2=1.77
cc_1530 ( N_noxref_10_c_2170_n N_noxref_12_c_2685_n ) capacitor c=0.00453743f \
 //x=11.79 //y=4.25 //x2=2.88 //y2=1.77
cc_1531 ( N_noxref_10_c_2170_n N_noxref_12_M0_noxref_s ) capacitor \
 c=0.00262629f //x=11.79 //y=4.25 //x2=0.89 //y2=0.555
cc_1532 ( N_noxref_10_c_2179_n N_noxref_12_M0_noxref_s ) capacitor \
 c=0.0327271f //x=1.245 //y=1.055 //x2=0.89 //y2=0.555
cc_1533 ( N_noxref_10_c_2182_n N_noxref_12_M0_noxref_s ) capacitor \
 c=7.99997e-19 //x=1.245 //y=1.71 //x2=0.89 //y2=0.555
cc_1534 ( N_noxref_10_c_2183_n N_noxref_12_M0_noxref_s ) capacitor \
 c=0.00122123f //x=1.245 //y=2.095 //x2=0.89 //y2=0.555
cc_1535 ( N_noxref_10_c_2186_n N_noxref_12_M0_noxref_s ) capacitor \
 c=0.0121427f //x=1.775 //y=1.055 //x2=0.89 //y2=0.555
cc_1536 ( N_noxref_10_c_2170_n N_noxref_13_c_2715_n ) capacitor c=0.0020922f \
 //x=11.79 //y=4.25 //x2=3.45 //y2=1.175
cc_1537 ( N_noxref_10_c_2170_n N_noxref_13_M2_noxref_s ) capacitor \
 c=0.00143334f //x=11.79 //y=4.25 //x2=3.4 //y2=0.555
cc_1538 ( N_noxref_10_c_2170_n N_D_c_2769_n ) capacitor c=0.0190126f //x=11.79 \
 //y=4.25 //x2=7.465 //y2=4.88
cc_1539 ( N_noxref_10_c_2289_n N_noxref_17_c_2969_n ) capacitor c=0.00623646f \
 //x=11.94 //y=1.74 //x2=11.72 //y2=1.675
cc_1540 ( N_noxref_10_c_2294_n N_noxref_17_c_2969_n ) capacitor c=0.00173579f \
 //x=11.905 //y=2.26 //x2=11.72 //y2=1.675
cc_1541 ( N_noxref_10_c_2174_n N_noxref_17_c_2970_n ) capacitor c=0.00156605f \
 //x=11.905 //y=2.26 //x2=12.605 //y2=0.71
cc_1542 ( N_noxref_10_c_2284_n N_noxref_17_c_2970_n ) capacitor c=0.0188655f \
 //x=11.94 //y=1.085 //x2=12.605 //y2=0.71
cc_1543 ( N_noxref_10_c_2292_n N_noxref_17_c_2970_n ) capacitor c=0.00656458f \
 //x=12.47 //y=1.085 //x2=12.605 //y2=0.71
cc_1544 ( N_noxref_10_c_2294_n N_noxref_17_c_2970_n ) capacitor c=2.1838e-19 \
 //x=11.905 //y=2.26 //x2=12.605 //y2=0.71
cc_1545 ( N_noxref_10_c_2284_n N_noxref_17_M6_noxref_s ) capacitor \
 c=0.00623646f //x=11.94 //y=1.085 //x2=10.615 //y2=0.545
cc_1546 ( N_noxref_10_c_2292_n N_noxref_17_M6_noxref_s ) capacitor \
 c=0.0143002f //x=12.47 //y=1.085 //x2=10.615 //y2=0.545
cc_1547 ( N_noxref_10_c_2293_n N_noxref_17_M6_noxref_s ) capacitor \
 c=0.00290153f //x=12.47 //y=1.43 //x2=10.615 //y2=0.545
cc_1548 ( N_noxref_10_M10_noxref_d N_noxref_18_M8_noxref_s ) capacitor \
 c=0.00309936f //x=16.78 //y=1.095 //x2=13.84 //y2=0.555
cc_1549 ( N_noxref_10_c_2176_n N_noxref_19_c_3070_n ) capacitor c=0.00457167f \
 //x=17.37 //y=1.845 //x2=17.37 //y2=0.72
cc_1550 ( N_noxref_10_M10_noxref_d N_noxref_19_c_3070_n ) capacitor \
 c=0.0115903f //x=16.78 //y=1.095 //x2=17.37 //y2=0.72
cc_1551 ( N_noxref_10_c_2430_n N_noxref_19_c_3098_n ) capacitor c=0.0200405f \
 //x=17.055 //y=1.845 //x2=16.485 //y2=1.175
cc_1552 ( N_noxref_10_M10_noxref_d N_noxref_19_M9_noxref_d ) capacitor \
 c=5.27807e-19 //x=16.78 //y=1.095 //x2=15.245 //y2=1.09
cc_1553 ( N_noxref_10_c_2176_n N_noxref_19_M10_noxref_s ) capacitor \
 c=0.0196084f //x=17.37 //y=1.845 //x2=16.35 //y2=0.555
cc_1554 ( N_noxref_10_M10_noxref_d N_noxref_19_M10_noxref_s ) capacitor \
 c=0.0426368f //x=16.78 //y=1.095 //x2=16.35 //y2=0.555
cc_1555 ( N_noxref_10_c_2176_n N_noxref_20_c_3135_n ) capacitor c=3.84569e-19 \
 //x=17.37 //y=1.845 //x2=18.785 //y2=1.685
cc_1556 ( N_noxref_10_c_2172_n N_noxref_20_c_3149_n ) capacitor c=9.46602e-19 \
 //x=24.74 //y=4.25 //x2=20.64 //y2=1.77
cc_1557 ( N_noxref_10_c_2172_n N_noxref_20_M11_noxref_s ) capacitor \
 c=0.00119468f //x=24.74 //y=4.25 //x2=18.65 //y2=0.555
cc_1558 ( N_noxref_10_M10_noxref_d N_noxref_20_M11_noxref_s ) capacitor \
 c=2.55333e-19 //x=16.78 //y=1.095 //x2=18.65 //y2=0.555
cc_1559 ( N_noxref_10_c_2172_n N_noxref_21_c_3171_n ) capacitor c=0.00161795f \
 //x=24.74 //y=4.25 //x2=21.21 //y2=1.175
cc_1560 ( N_noxref_10_c_2172_n N_noxref_21_M13_noxref_s ) capacitor \
 c=0.00122424f //x=24.74 //y=4.25 //x2=21.16 //y2=0.555
cc_1561 ( N_noxref_10_c_2498_n N_noxref_22_c_3231_n ) capacitor c=0.00623646f \
 //x=24.89 //y=1.74 //x2=24.67 //y2=1.675
cc_1562 ( N_noxref_10_c_2503_n N_noxref_22_c_3231_n ) capacitor c=0.00176439f \
 //x=24.855 //y=2.26 //x2=24.67 //y2=1.675
cc_1563 ( N_noxref_10_c_2177_n N_noxref_22_c_3232_n ) capacitor c=0.0016032f \
 //x=24.855 //y=2.26 //x2=25.555 //y2=0.71
cc_1564 ( N_noxref_10_c_2493_n N_noxref_22_c_3232_n ) capacitor c=0.0188655f \
 //x=24.89 //y=1.085 //x2=25.555 //y2=0.71
cc_1565 ( N_noxref_10_c_2501_n N_noxref_22_c_3232_n ) capacitor c=0.00656458f \
 //x=25.42 //y=1.085 //x2=25.555 //y2=0.71
cc_1566 ( N_noxref_10_c_2503_n N_noxref_22_c_3232_n ) capacitor c=2.1838e-19 \
 //x=24.855 //y=2.26 //x2=25.555 //y2=0.71
cc_1567 ( N_noxref_10_c_2493_n N_noxref_22_M14_noxref_s ) capacitor \
 c=0.00623646f //x=24.89 //y=1.085 //x2=23.565 //y2=0.545
cc_1568 ( N_noxref_10_c_2501_n N_noxref_22_M14_noxref_s ) capacitor \
 c=0.0143002f //x=25.42 //y=1.085 //x2=23.565 //y2=0.545
cc_1569 ( N_noxref_10_c_2502_n N_noxref_22_M14_noxref_s ) capacitor \
 c=0.00290153f //x=25.42 //y=1.43 //x2=23.565 //y2=0.545
cc_1570 ( N_noxref_11_c_2657_p N_noxref_22_c_3241_n ) capacitor c=3.15806e-19 \
 //x=25.24 //y=1.835 //x2=23.7 //y2=1.675
cc_1571 ( N_noxref_11_c_2582_n N_noxref_22_c_3224_n ) capacitor c=0.00304271f \
 //x=25.595 //y=3.88 //x2=24.585 //y2=1.76
cc_1572 ( N_noxref_11_c_2657_p N_noxref_22_c_3231_n ) capacitor c=0.020324f \
 //x=25.24 //y=1.835 //x2=24.67 //y2=1.675
cc_1573 ( N_noxref_11_c_2582_n N_noxref_22_c_3231_n ) capacitor c=0.00187232f \
 //x=25.595 //y=3.88 //x2=24.67 //y2=1.675
cc_1574 ( N_noxref_11_c_2581_n N_noxref_22_c_3232_n ) capacitor c=0.00467104f \
 //x=25.51 //y=1.835 //x2=25.555 //y2=0.71
cc_1575 ( N_noxref_11_c_2582_n N_noxref_22_c_3232_n ) capacitor c=4.7198e-19 \
 //x=25.595 //y=3.88 //x2=25.555 //y2=0.71
cc_1576 ( N_noxref_11_M15_noxref_d N_noxref_22_c_3232_n ) capacitor \
 c=0.0117932f //x=24.965 //y=1.085 //x2=25.555 //y2=0.71
cc_1577 ( N_noxref_11_c_2581_n N_noxref_22_M14_noxref_s ) capacitor \
 c=0.0142774f //x=25.51 //y=1.835 //x2=23.565 //y2=0.545
cc_1578 ( N_noxref_11_c_2582_n N_noxref_22_M14_noxref_s ) capacitor \
 c=3.61944e-19 //x=25.595 //y=3.88 //x2=23.565 //y2=0.545
cc_1579 ( N_noxref_11_M15_noxref_d N_noxref_22_M14_noxref_s ) capacitor \
 c=0.0439476f //x=24.965 //y=1.085 //x2=23.565 //y2=0.545
cc_1580 ( N_noxref_12_c_2674_n N_noxref_13_c_2715_n ) capacitor c=0.0136048f \
 //x=2.88 //y=0.72 //x2=3.45 //y2=1.175
cc_1581 ( N_noxref_12_c_2685_n N_noxref_13_c_2715_n ) capacitor c=0.0102225f \
 //x=2.88 //y=1.77 //x2=3.45 //y2=1.175
cc_1582 ( N_noxref_12_M0_noxref_s N_noxref_13_c_2715_n ) capacitor \
 c=0.0228676f //x=0.89 //y=0.555 //x2=3.45 //y2=1.175
cc_1583 ( N_noxref_12_M0_noxref_s N_noxref_13_c_2717_n ) capacitor \
 c=0.0180035f //x=0.89 //y=0.555 //x2=3.535 //y2=0.805
cc_1584 ( N_noxref_12_c_2674_n N_noxref_13_M1_noxref_d ) capacitor \
 c=0.0129526f //x=2.88 //y=0.72 //x2=2.295 //y2=1.09
cc_1585 ( N_noxref_12_c_2685_n N_noxref_13_M1_noxref_d ) capacitor \
 c=0.00908243f //x=2.88 //y=1.77 //x2=2.295 //y2=1.09
cc_1586 ( N_noxref_12_M0_noxref_s N_noxref_13_M1_noxref_d ) capacitor \
 c=0.0159202f //x=0.89 //y=0.555 //x2=2.295 //y2=1.09
cc_1587 ( N_noxref_12_M0_noxref_s N_noxref_13_M2_noxref_s ) capacitor \
 c=0.0213553f //x=0.89 //y=0.555 //x2=3.4 //y2=0.555
cc_1588 ( N_noxref_13_c_2723_n N_noxref_15_M3_noxref_s ) capacitor \
 c=0.00191848f //x=4.505 //y=0.805 //x2=5.7 //y2=0.555
cc_1589 ( N_D_c_2801_n N_noxref_15_c_2864_n ) capacitor c=0.0167228f //x=7.03 \
 //y=1.09 //x2=7.69 //y2=0.72
cc_1590 ( N_D_c_2806_n N_noxref_15_c_2864_n ) capacitor c=0.00534519f \
 //x=7.555 //y=1.09 //x2=7.69 //y2=0.72
cc_1591 ( D N_noxref_15_c_2875_n ) capacitor c=9.03008e-19 //x=7.52 //y=2.77 \
 //x2=7.69 //y2=1.77
cc_1592 ( N_D_c_2768_n N_noxref_15_c_2875_n ) capacitor c=0.0125737f //x=7.465 \
 //y=2.26 //x2=7.69 //y2=1.77
cc_1593 ( N_D_c_2804_n N_noxref_15_c_2875_n ) capacitor c=0.0153476f //x=7.03 \
 //y=1.4 //x2=7.69 //y2=1.77
cc_1594 ( N_D_c_2809_n N_noxref_15_c_2875_n ) capacitor c=0.0220703f //x=7.555 \
 //y=2.095 //x2=7.69 //y2=1.77
cc_1595 ( N_D_c_2801_n N_noxref_15_M3_noxref_s ) capacitor c=0.00798959f \
 //x=7.03 //y=1.09 //x2=5.7 //y2=0.555
cc_1596 ( N_D_c_2808_n N_noxref_15_M3_noxref_s ) capacitor c=0.00212176f \
 //x=7.555 //y=1.63 //x2=5.7 //y2=0.555
cc_1597 ( N_D_c_2809_n N_noxref_15_M3_noxref_s ) capacitor c=0.00298115f \
 //x=7.555 //y=2.095 //x2=5.7 //y2=0.555
cc_1598 ( N_D_c_2845_p N_noxref_16_c_2908_n ) capacitor c=2.14837e-19 //x=7.4 \
 //y=0.935 //x2=8.26 //y2=1.175
cc_1599 ( N_D_c_2806_n N_noxref_16_c_2908_n ) capacitor c=0.00123426f \
 //x=7.555 //y=1.09 //x2=8.26 //y2=1.175
cc_1600 ( N_D_c_2807_n N_noxref_16_c_2908_n ) capacitor c=0.0129288f //x=7.555 \
 //y=1.4 //x2=8.26 //y2=1.175
cc_1601 ( N_D_c_2808_n N_noxref_16_c_2908_n ) capacitor c=0.00142359f \
 //x=7.555 //y=1.63 //x2=8.26 //y2=1.175
cc_1602 ( N_D_c_2801_n N_noxref_16_M4_noxref_d ) capacitor c=0.00223875f \
 //x=7.03 //y=1.09 //x2=7.105 //y2=1.09
cc_1603 ( N_D_c_2804_n N_noxref_16_M4_noxref_d ) capacitor c=0.00262485f \
 //x=7.03 //y=1.4 //x2=7.105 //y2=1.09
cc_1604 ( N_D_c_2845_p N_noxref_16_M4_noxref_d ) capacitor c=0.00220746f \
 //x=7.4 //y=0.935 //x2=7.105 //y2=1.09
cc_1605 ( N_D_c_2852_p N_noxref_16_M4_noxref_d ) capacitor c=0.00194798f \
 //x=7.4 //y=1.555 //x2=7.105 //y2=1.09
cc_1606 ( N_D_c_2806_n N_noxref_16_M4_noxref_d ) capacitor c=0.00198465f \
 //x=7.555 //y=1.09 //x2=7.105 //y2=1.09
cc_1607 ( N_D_c_2807_n N_noxref_16_M4_noxref_d ) capacitor c=0.00128384f \
 //x=7.555 //y=1.4 //x2=7.105 //y2=1.09
cc_1608 ( N_D_c_2806_n N_noxref_16_M5_noxref_s ) capacitor c=7.21316e-19 \
 //x=7.555 //y=1.09 //x2=8.21 //y2=0.555
cc_1609 ( N_D_c_2807_n N_noxref_16_M5_noxref_s ) capacitor c=0.00348171f \
 //x=7.555 //y=1.4 //x2=8.21 //y2=0.555
cc_1610 ( N_noxref_15_c_2864_n N_noxref_16_c_2908_n ) capacitor c=0.0134311f \
 //x=7.69 //y=0.72 //x2=8.26 //y2=1.175
cc_1611 ( N_noxref_15_c_2875_n N_noxref_16_c_2908_n ) capacitor c=0.0101712f \
 //x=7.69 //y=1.77 //x2=8.26 //y2=1.175
cc_1612 ( N_noxref_15_M3_noxref_s N_noxref_16_c_2908_n ) capacitor \
 c=0.0227445f //x=5.7 //y=0.555 //x2=8.26 //y2=1.175
cc_1613 ( N_noxref_15_M3_noxref_s N_noxref_16_c_2910_n ) capacitor \
 c=0.0180035f //x=5.7 //y=0.555 //x2=8.345 //y2=0.805
cc_1614 ( N_noxref_15_c_2864_n N_noxref_16_M4_noxref_d ) capacitor \
 c=0.0128913f //x=7.69 //y=0.72 //x2=7.105 //y2=1.09
cc_1615 ( N_noxref_15_c_2875_n N_noxref_16_M4_noxref_d ) capacitor \
 c=0.00899889f //x=7.69 //y=1.77 //x2=7.105 //y2=1.09
cc_1616 ( N_noxref_15_M3_noxref_s N_noxref_16_M4_noxref_d ) capacitor \
 c=0.0159202f //x=5.7 //y=0.555 //x2=7.105 //y2=1.09
cc_1617 ( N_noxref_15_M3_noxref_s N_noxref_16_M5_noxref_s ) capacitor \
 c=0.0213553f //x=5.7 //y=0.555 //x2=8.21 //y2=0.555
cc_1618 ( N_noxref_16_c_2916_n N_noxref_17_M6_noxref_s ) capacitor \
 c=0.00164795f //x=9.315 //y=0.805 //x2=10.615 //y2=0.545
cc_1619 ( N_noxref_17_c_2973_n N_noxref_18_M8_noxref_s ) capacitor \
 c=0.00199452f //x=12.69 //y=0.795 //x2=13.84 //y2=0.555
cc_1620 ( N_noxref_18_c_3021_n N_noxref_19_c_3065_n ) capacitor c=0.0131877f \
 //x=15.83 //y=0.72 //x2=16.4 //y2=1.175
cc_1621 ( N_noxref_18_c_3044_n N_noxref_19_c_3065_n ) capacitor c=0.00981707f \
 //x=15.83 //y=1.77 //x2=16.4 //y2=1.175
cc_1622 ( N_noxref_18_M8_noxref_s N_noxref_19_c_3065_n ) capacitor \
 c=0.0221661f //x=13.84 //y=0.555 //x2=16.4 //y2=1.175
cc_1623 ( N_noxref_18_M8_noxref_s N_noxref_19_c_3067_n ) capacitor \
 c=0.0180035f //x=13.84 //y=0.555 //x2=16.485 //y2=0.805
cc_1624 ( N_noxref_18_c_3021_n N_noxref_19_M9_noxref_d ) capacitor \
 c=0.0127191f //x=15.83 //y=0.72 //x2=15.245 //y2=1.09
cc_1625 ( N_noxref_18_c_3044_n N_noxref_19_M9_noxref_d ) capacitor \
 c=0.00861161f //x=15.83 //y=1.77 //x2=15.245 //y2=1.09
cc_1626 ( N_noxref_18_M8_noxref_s N_noxref_19_M9_noxref_d ) capacitor \
 c=0.0159202f //x=13.84 //y=0.555 //x2=15.245 //y2=1.09
cc_1627 ( N_noxref_18_M8_noxref_s N_noxref_19_M10_noxref_s ) capacitor \
 c=0.0213553f //x=13.84 //y=0.555 //x2=16.35 //y2=0.555
cc_1628 ( N_noxref_19_c_3073_n N_noxref_20_M11_noxref_s ) capacitor \
 c=0.00191848f //x=17.455 //y=0.805 //x2=18.65 //y2=0.555
cc_1629 ( N_noxref_20_c_3126_n N_noxref_21_c_3171_n ) capacitor c=0.0133619f \
 //x=20.64 //y=0.72 //x2=21.21 //y2=1.175
cc_1630 ( N_noxref_20_c_3149_n N_noxref_21_c_3171_n ) capacitor c=0.00992648f \
 //x=20.64 //y=1.77 //x2=21.21 //y2=1.175
cc_1631 ( N_noxref_20_M11_noxref_s N_noxref_21_c_3171_n ) capacitor \
 c=0.0228676f //x=18.65 //y=0.555 //x2=21.21 //y2=1.175
cc_1632 ( N_noxref_20_M11_noxref_s N_noxref_21_c_3173_n ) capacitor \
 c=0.0180035f //x=18.65 //y=0.555 //x2=21.295 //y2=0.805
cc_1633 ( N_noxref_20_c_3126_n N_noxref_21_M12_noxref_d ) capacitor \
 c=0.0127176f //x=20.64 //y=0.72 //x2=20.055 //y2=1.09
cc_1634 ( N_noxref_20_c_3149_n N_noxref_21_M12_noxref_d ) capacitor \
 c=0.0086073f //x=20.64 //y=1.77 //x2=20.055 //y2=1.09
cc_1635 ( N_noxref_20_M11_noxref_s N_noxref_21_M12_noxref_d ) capacitor \
 c=0.0159202f //x=18.65 //y=0.555 //x2=20.055 //y2=1.09
cc_1636 ( N_noxref_20_M11_noxref_s N_noxref_21_M13_noxref_s ) capacitor \
 c=0.0213553f //x=18.65 //y=0.555 //x2=21.16 //y2=0.555
cc_1637 ( N_noxref_21_c_3179_n N_noxref_22_M14_noxref_s ) capacitor \
 c=0.00164795f //x=22.265 //y=0.805 //x2=23.565 //y2=0.545
