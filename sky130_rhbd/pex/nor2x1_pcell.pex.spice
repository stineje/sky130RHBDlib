// File: nor2x1_pcell.spi.pex
// Created: Fri Feb 20 10:22:20 2026
// Program "Calibre xRC"
// Version "v2023.2_27.15"
// Nominal Temperature: 30C
// Circuit Temperature: 30C
//
simulator lang=spectre
subckt PM_NOR2X1_PCELL\%noxref_1 ( 7 21 35 50 57 60 )
c53 ( 60 0 ) capacitor c=0.0786069f //x=0.56 //y=0.365
c54 ( 57 0 ) capacitor c=0.218615f //x=2.59 //y=0
c55 ( 53 0 ) capacitor c=0.00591168f //x=1.665 //y=0
c56 ( 50 0 ) capacitor c=0.212651f //x=0.74 //y=0
c57 ( 40 0 ) capacitor c=0.00739123f //x=2.635 //y=0.445
c58 ( 35 0 ) capacitor c=0.0152893f //x=2.55 //y=0.53
c59 ( 31 0 ) capacitor c=0.0253251f //x=2.55 //y=0
c60 ( 26 0 ) capacitor c=0.00726869f //x=1.665 //y=0.445
c61 ( 21 0 ) capacitor c=0.0171409f //x=1.58 //y=0.53
c62 ( 19 0 ) capacitor c=0.025309f //x=1.58 //y=0
c63 ( 14 0 ) capacitor c=0.00739123f //x=0.695 //y=0.445
c64 ( 7 0 ) capacitor c=0.144698f //x=2.59 //y=0
r65 (  41 60 ) resistor r=5.4201 //w=0.17 //l=0.085 //layer=li //thickness=0.1 \
 //x=2.635 //y=0.615 //x2=2.635 //y2=0.53
r66 (  41 60 ) resistor r=18.139 //w=0.187 //l=0.265 //layer=li \
 //thickness=0.1 //x=2.635 //y=0.615 //x2=2.635 //y2=0.88
r67 (  40 60 ) resistor r=5.4201 //w=0.17 //l=0.085 //layer=li //thickness=0.1 \
 //x=2.635 //y=0.445 //x2=2.635 //y2=0.53
r68 (  39 57 ) resistor r=4.11603 //w=0.68 //l=0.17 //layer=li //thickness=0.1 \
 //x=2.635 //y=0.17 //x2=2.635 //y2=0
r69 (  39 40 ) resistor r=18.8235 //w=0.187 //l=0.275 //layer=li \
 //thickness=0.1 //x=2.635 //y=0.17 //x2=2.635 //y2=0.445
r70 (  36 60 ) resistor r=6.4 //w=0.17 //l=0.085 //layer=li //thickness=0.1 \
 //x=1.75 //y=0.53 //x2=1.665 //y2=0.53
r71 (  36 60 ) resistor r=27.3797 //w=0.187 //l=0.4 //layer=li //thickness=0.1 \
 //x=1.75 //y=0.53 //x2=2.15 //y2=0.53
r72 (  35 60 ) resistor r=1.40859 //w=0.34 //l=0.085 //layer=li \
 //thickness=0.1 //x=2.55 //y=0.53 //x2=2.635 //y2=0.53
r73 (  35 60 ) resistor r=27.3797 //w=0.187 //l=0.4 //layer=li //thickness=0.1 \
 //x=2.55 //y=0.53 //x2=2.15 //y2=0.53
r74 (  32 53 ) resistor r=2.94794 //w=0.34 //l=0.085 //layer=li \
 //thickness=0.1 //x=1.75 //y=0 //x2=1.665 //y2=0
r75 (  32 34 ) resistor r=3.58543 //w=0.357 //l=0.1 //layer=li //thickness=0.1 \
 //x=1.75 //y=0 //x2=1.85 //y2=0
r76 (  31 57 ) resistor r=2.94794 //w=0.34 //l=0.085 //layer=li \
 //thickness=0.1 //x=2.55 //y=0 //x2=2.635 //y2=0
r77 (  31 34 ) resistor r=25.098 //w=0.357 //l=0.7 //layer=li //thickness=0.1 \
 //x=2.55 //y=0 //x2=1.85 //y2=0
r78 (  27 60 ) resistor r=6.4 //w=0.17 //l=0.085 //layer=li //thickness=0.1 \
 //x=1.665 //y=0.615 //x2=1.665 //y2=0.53
r79 (  27 60 ) resistor r=18.139 //w=0.187 //l=0.265 //layer=li \
 //thickness=0.1 //x=1.665 //y=0.615 //x2=1.665 //y2=0.88
r80 (  26 60 ) resistor r=6.4 //w=0.17 //l=0.085 //layer=li //thickness=0.1 \
 //x=1.665 //y=0.445 //x2=1.665 //y2=0.53
r81 (  25 53 ) resistor r=4.11603 //w=0.68 //l=0.17 //layer=li //thickness=0.1 \
 //x=1.665 //y=0.17 //x2=1.665 //y2=0
r82 (  25 26 ) resistor r=18.8235 //w=0.187 //l=0.275 //layer=li \
 //thickness=0.1 //x=1.665 //y=0.17 //x2=1.665 //y2=0.445
r83 (  22 60 ) resistor r=1.40859 //w=0.34 //l=0.085 //layer=li \
 //thickness=0.1 //x=0.78 //y=0.53 //x2=0.695 //y2=0.53
r84 (  22 60 ) resistor r=27.3797 //w=0.187 //l=0.4 //layer=li //thickness=0.1 \
 //x=0.78 //y=0.53 //x2=1.18 //y2=0.53
r85 (  21 60 ) resistor r=6.4 //w=0.17 //l=0.085 //layer=li //thickness=0.1 \
 //x=1.58 //y=0.53 //x2=1.665 //y2=0.53
r86 (  21 60 ) resistor r=27.3797 //w=0.187 //l=0.4 //layer=li //thickness=0.1 \
 //x=1.58 //y=0.53 //x2=1.18 //y2=0.53
r87 (  20 50 ) resistor r=2.94794 //w=0.34 //l=0.085 //layer=li \
 //thickness=0.1 //x=0.78 //y=0 //x2=0.695 //y2=0
r88 (  19 53 ) resistor r=2.94794 //w=0.34 //l=0.085 //layer=li \
 //thickness=0.1 //x=1.58 //y=0 //x2=1.665 //y2=0
r89 (  19 20 ) resistor r=28.6835 //w=0.357 //l=0.8 //layer=li //thickness=0.1 \
 //x=1.58 //y=0 //x2=0.78 //y2=0
r90 (  15 60 ) resistor r=5.4201 //w=0.17 //l=0.085 //layer=li //thickness=0.1 \
 //x=0.695 //y=0.615 //x2=0.695 //y2=0.53
r91 (  15 60 ) resistor r=41.4118 //w=0.187 //l=0.605 //layer=li \
 //thickness=0.1 //x=0.695 //y=0.615 //x2=0.695 //y2=1.22
r92 (  14 60 ) resistor r=5.4201 //w=0.17 //l=0.085 //layer=li //thickness=0.1 \
 //x=0.695 //y=0.445 //x2=0.695 //y2=0.53
r93 (  13 50 ) resistor r=4.11603 //w=0.68 //l=0.17 //layer=li //thickness=0.1 \
 //x=0.695 //y=0.17 //x2=0.695 //y2=0
r94 (  13 14 ) resistor r=18.8235 //w=0.187 //l=0.275 //layer=li \
 //thickness=0.1 //x=0.695 //y=0.17 //x2=0.695 //y2=0.445
r95 (  7 57 ) resistor r=4.65 //w=0.17 //l=0.34 //layer=mcon //count=2 \
 //x=2.59 //y=0 //x2=2.59 //y2=0
r96 (  5 34 ) resistor r=3.1 //w=0.17 //l=0.51 //layer=mcon //count=3 //x=1.85 \
 //y=0 //x2=1.85 //y2=0
r97 (  5 7 ) resistor r=0.307309 //w=0.301 //l=0.74 //layer=m1 \
 //thickness=0.36 //x=1.85 //y=0 //x2=2.59 //y2=0
r98 (  2 50 ) resistor r=3.1 //w=0.17 //l=0.51 //layer=mcon //count=3 //x=0.74 \
 //y=0 //x2=0.74 //y2=0
r99 (  2 5 ) resistor r=0.460963 //w=0.301 //l=1.11 //layer=m1 \
 //thickness=0.36 //x=0.74 //y=0 //x2=1.85 //y2=0
ends PM_NOR2X1_PCELL\%noxref_1

subckt PM_NOR2X1_PCELL\%noxref_2 ( 1 3 5 10 14 17 20 30 46 47 48 )
c77 ( 48 0 ) capacitor c=0.0347532f //x=2.405 //y=5.025
c78 ( 46 0 ) capacitor c=0.0118024f //x=0.655 //y=5.025
c79 ( 30 0 ) capacitor c=0.0303528f //x=1.67 //y=5.38
c80 ( 20 0 ) capacitor c=0.0436664f //x=0.79 //y=5.38
c81 ( 17 0 ) capacitor c=0.0164155f //x=2.55 //y=6.74
c82 ( 14 0 ) capacitor c=0.00604334f //x=1.67 //y=6.74
c83 ( 10 0 ) capacitor c=0.0109996f //x=1.67 //y=5.21
c84 ( 5 0 ) capacitor c=0.0174235f //x=0.79 //y=5.21
c85 ( 3 0 ) capacitor c=0.00694548f //x=2.42 //y=6.91
c86 ( 1 0 ) capacitor c=0.0134808f //x=1.55 //y=5.21
r87 (  37 47 ) resistor r=23.2727 //w=0.187 //l=0.34 //layer=li \
 //thickness=0.1 //x=1.67 //y=6.74 //x2=1.67 //y2=6.4
r88 (  30 47 ) resistor r=23.2727 //w=0.187 //l=0.34 //layer=li \
 //thickness=0.1 //x=1.67 //y=5.38 //x2=1.67 //y2=5.72
r89 (  20 46 ) resistor r=23.2727 //w=0.187 //l=0.34 //layer=li \
 //thickness=0.1 //x=0.79 //y=5.38 //x2=0.79 //y2=5.72
r90 (  17 48 ) resistor r=9.3 //w=0.17 //l=0.17 //layer=mcon //count=1 \
 //x=2.55 //y=6.74 //x2=2.55 //y2=6.74
r91 (  17 18 ) resistor r=0.0932018 //w=0.228 //l=0.17 //layer=m1 \
 //thickness=0.36 //x=2.542 //y=6.74 //x2=2.542 //y2=6.91
r92 (  14 37 ) resistor r=9.3 //w=0.17 //l=0.17 //layer=mcon //count=1 \
 //x=1.67 //y=6.74 //x2=1.67 //y2=6.74
r93 (  14 15 ) resistor r=0.0992991 //w=0.214 //l=0.17 //layer=m1 \
 //thickness=0.36 //x=1.67 //y=6.74 //x2=1.67 //y2=6.91
r94 (  12 30 ) resistor r=9.3 //w=0.17 //l=0.17 //layer=mcon //count=1 \
 //x=1.67 //y=5.38 //x2=1.67 //y2=5.38
r95 (  10 12 ) resistor r=0.097032 //w=0.219 //l=0.17 //layer=m1 \
 //thickness=0.36 //x=1.67 //y=5.21 //x2=1.67 //y2=5.38
r96 (  7 20 ) resistor r=9.3 //w=0.17 //l=0.17 //layer=mcon //count=1 //x=0.79 \
 //y=5.38 //x2=0.79 //y2=5.38
r97 (  5 7 ) resistor r=0.0997653 //w=0.213 //l=0.17 //layer=m1 \
 //thickness=0.36 //x=0.79 //y=5.21 //x2=0.79 //y2=5.38
r98 (  4 15 ) resistor r=0.0213909 //w=0.214 //l=0.115 //layer=m1 \
 //thickness=0.36 //x=1.785 //y=6.91 //x2=1.67 //y2=6.91
r99 (  3 18 ) resistor r=0.0251868 //w=0.228 //l=0.122 //layer=m1 \
 //thickness=0.36 //x=2.42 //y=6.91 //x2=2.542 //y2=6.91
r100 (  3 4 ) resistor r=0.605916 //w=0.131 //l=0.635 //layer=m1 \
 //thickness=0.36 //x=2.42 //y=6.91 //x2=1.785 //y2=6.91
r101 (  2 5 ) resistor r=0.0211096 //w=0.213 //l=0.115 //layer=m1 \
 //thickness=0.36 //x=0.905 //y=5.21 //x2=0.79 //y2=5.21
r102 (  1 10 ) resistor r=0.0227762 //w=0.219 //l=0.12 //layer=m1 \
 //thickness=0.36 //x=1.55 //y=5.21 //x2=1.67 //y2=5.21
r103 (  1 2 ) resistor r=0.615458 //w=0.131 //l=0.645 //layer=m1 \
 //thickness=0.36 //x=1.55 //y=5.21 //x2=0.905 //y2=5.21
ends PM_NOR2X1_PCELL\%noxref_2

subckt PM_NOR2X1_PCELL\%noxref_3 ( 2 4 8 11 16 20 21 22 23 24 25 26 30 32 35 \
 37 38 43 )
c114 ( 43 0 ) capacitor c=0.0426341f //x=0.955 //y=4.705
c115 ( 38 0 ) capacitor c=0.0337825f //x=1.445 //y=1.25
c116 ( 37 0 ) capacitor c=0.0183823f //x=1.445 //y=0.905
c117 ( 35 0 ) capacitor c=0.0350928f //x=1.375 //y=4.795
c118 ( 32 0 ) capacitor c=0.013578f //x=1.29 //y=1.405
c119 ( 30 0 ) capacitor c=0.0157803f //x=1.29 //y=0.75
c120 ( 26 0 ) capacitor c=0.085272f //x=0.915 //y=1.915
c121 ( 25 0 ) capacitor c=0.0230165f //x=0.915 //y=1.56
c122 ( 24 0 ) capacitor c=0.0234348f //x=0.915 //y=1.25
c123 ( 23 0 ) capacitor c=0.019134f //x=0.915 //y=0.905
c124 ( 22 0 ) capacitor c=0.110994f //x=1.45 //y=6.025
c125 ( 21 0 ) capacitor c=0.154777f //x=1.01 //y=6.025
c126 ( 16 0 ) capacitor c=0.00174733f //x=1.11 //y=2.08
c127 ( 11 0 ) capacitor c=0.00705226f //x=0.955 //y=4.705
c128 ( 8 0 ) capacitor c=0.0166604f //x=0.955 //y=4.705
c129 ( 4 0 ) capacitor c=0.0119141f //x=1.11 //y=2.08
c130 ( 2 0 ) capacitor c=0.108576f //x=1.11 //y=4.585
r131 (  45 46 ) resistor r=32.4568 //w=0.214 //l=0.075 //layer=ply \
 //thickness=0.18 //x=0.955 //y=4.795 //x2=0.955 //y2=4.87
r132 (  43 45 ) resistor r=20.271 //w=0.214 //l=0.09 //layer=ply \
 //thickness=0.18 //x=0.955 //y=4.705 //x2=0.955 //y2=4.795
r133 (  38 52 ) resistor r=45.1352 //w=0.168 //l=0.173853 //layer=ply \
 //thickness=0.18 //x=1.445 //y=1.25 //x2=1.405 //y2=1.405
r134 (  37 51 ) resistor r=45.1352 //w=0.168 //l=0.173853 //layer=ply \
 //thickness=0.18 //x=1.445 //y=0.905 //x2=1.405 //y2=0.75
r135 (  37 38 ) resistor r=176.904 //w=0.094 //l=0.345 //layer=ply \
 //thickness=0.18 //x=1.445 //y=0.905 //x2=1.445 //y2=1.25
r136 (  36 45 ) resistor r=16.5046 //w=0.27 //l=0.135 //layer=ply \
 //thickness=0.18 //x=1.09 //y=4.795 //x2=0.955 //y2=4.795
r137 (  35 39 ) resistor r=26.9307 //w=0.15 //l=0.106066 //layer=ply \
 //thickness=0.18 //x=1.375 //y=4.795 //x2=1.45 //y2=4.87
r138 (  35 36 ) resistor r=146.138 //w=0.094 //l=0.285 //layer=ply \
 //thickness=0.18 //x=1.375 //y=4.795 //x2=1.09 //y2=4.795
r139 (  33 50 ) resistor r=10.701 //w=0.21 //l=0.115 //layer=ply \
 //thickness=0.18 //x=1.07 //y=1.405 //x2=0.955 //y2=1.405
r140 (  32 52 ) resistor r=5.52526 //w=0.168 //l=0.115 //layer=ply \
 //thickness=0.18 //x=1.29 //y=1.405 //x2=1.405 //y2=1.405
r141 (  31 49 ) resistor r=5.52526 //w=0.168 //l=0.115 //layer=ply \
 //thickness=0.18 //x=1.07 //y=0.75 //x2=0.955 //y2=0.75
r142 (  30 51 ) resistor r=5.52526 //w=0.168 //l=0.115 //layer=ply \
 //thickness=0.18 //x=1.29 //y=0.75 //x2=1.405 //y2=0.75
r143 (  30 31 ) resistor r=112.809 //w=0.094 //l=0.22 //layer=ply \
 //thickness=0.18 //x=1.29 //y=0.75 //x2=1.07 //y2=0.75
r144 (  26 48 ) resistor r=34.8111 //w=0.27 //l=0.264953 //layer=ply \
 //thickness=0.18 //x=0.915 //y=1.915 //x2=1.11 //y2=2.08
r145 (  25 50 ) resistor r=39.5823 //w=0.21 //l=0.173853 //layer=ply \
 //thickness=0.18 //x=0.915 //y=1.56 //x2=0.955 //y2=1.405
r146 (  25 26 ) resistor r=182.032 //w=0.094 //l=0.355 //layer=ply \
 //thickness=0.18 //x=0.915 //y=1.56 //x2=0.915 //y2=1.915
r147 (  24 50 ) resistor r=39.5823 //w=0.21 //l=0.173853 //layer=ply \
 //thickness=0.18 //x=0.915 //y=1.25 //x2=0.955 //y2=1.405
r148 (  23 49 ) resistor r=45.1352 //w=0.168 //l=0.173853 //layer=ply \
 //thickness=0.18 //x=0.915 //y=0.905 //x2=0.955 //y2=0.75
r149 (  23 24 ) resistor r=176.904 //w=0.094 //l=0.345 //layer=ply \
 //thickness=0.18 //x=0.915 //y=0.905 //x2=0.915 //y2=1.25
r150 (  22 39 ) resistor r=592.245 //w=0.094 //l=1.155 //layer=ply \
 //thickness=0.18 //x=1.45 //y=6.025 //x2=1.45 //y2=4.87
r151 (  21 46 ) resistor r=592.245 //w=0.094 //l=1.155 //layer=ply \
 //thickness=0.18 //x=1.01 //y=6.025 //x2=1.01 //y2=4.87
r152 (  20 32 ) resistor r=56.4043 //w=0.094 //l=0.11 //layer=ply \
 //thickness=0.18 //x=1.18 //y=1.405 //x2=1.29 //y2=1.405
r153 (  20 33 ) resistor r=56.4043 //w=0.094 //l=0.11 //layer=ply \
 //thickness=0.18 //x=1.18 //y=1.405 //x2=1.07 //y2=1.405
r154 (  16 48 ) resistor r=152 //w=0.17 //l=0.17 //layer=licon //count=1 \
 //x=1.11 //y=2.08 //x2=1.11 //y2=2.08
r155 (  11 43 ) resistor r=152 //w=0.17 //l=0.17 //layer=licon //count=1 \
 //x=0.955 //y=4.705 //x2=0.955 //y2=4.705
r156 (  8 11 ) resistor r=9.3 //w=0.17 //l=0.17 //layer=mcon //count=1 \
 //x=0.955 //y=4.705 //x2=0.955 //y2=4.705
r157 (  8 9 ) resistor r=0.0853524 //w=0.227 //l=0.155 //layer=m1 \
 //thickness=0.36 //x=0.955 //y=4.702 //x2=1.11 //y2=4.702
r158 (  4 16 ) resistor r=9.3 //w=0.17 //l=0.17 //layer=mcon //count=1 \
 //x=1.11 //y=2.08 //x2=1.11 //y2=2.08
r159 (  4 6 ) resistor r=0.0985786 //w=0.206 //l=0.135 //layer=m1 \
 //thickness=0.36 //x=1.107 //y=2.08 //x2=1.107 //y2=2.215
r160 (  2 9 ) resistor r=0.0249239 //w=0.227 //l=0.117 //layer=m1 \
 //thickness=0.36 //x=1.11 //y=4.585 //x2=1.11 //y2=4.702
r161 (  2 6 ) resistor r=2.26145 //w=0.131 //l=2.37 //layer=m1 \
 //thickness=0.36 //x=1.11 //y=4.585 //x2=1.11 //y2=2.215
ends PM_NOR2X1_PCELL\%noxref_3

subckt PM_NOR2X1_PCELL\%noxref_4 ( 1 5 6 11 21 25 35 )
c63 ( 35 0 ) capacitor c=0.0229771f //x=1.085 //y=5.025
c64 ( 25 0 ) capacitor c=0.353514f //x=2.59 //y=7.4
c65 ( 21 0 ) capacitor c=0.214642f //x=0.74 //y=7.4
c66 ( 13 0 ) capacitor c=0.00498911f //x=1.23 //y=7.4
c67 ( 11 0 ) capacitor c=0.0850369f //x=2.59 //y=7.4
c68 ( 6 0 ) capacitor c=0.00916089f //x=1.23 //y=7.23
c69 ( 5 0 ) capacitor c=0.00572492f //x=1.23 //y=6.855
c70 ( 1 0 ) capacitor c=0.0610304f //x=1.145 //y=7.4
r71 (  23 25 ) resistor r=26.5322 //w=0.357 //l=0.74 //layer=li \
 //thickness=0.1 //x=1.85 //y=7.4 //x2=2.59 //y2=7.4
r72 (  21 23 ) resistor r=39.7983 //w=0.357 //l=1.11 //layer=li \
 //thickness=0.1 //x=0.74 //y=7.4 //x2=1.85 //y2=7.4
r73 (  15 35 ) resistor r=9.3 //w=0.17 //l=0.17 //layer=mcon //count=1 \
 //x=1.23 //y=6.74 //x2=1.23 //y2=6.74
r74 (  11 25 ) resistor r=4.65 //w=0.17 //l=0.34 //layer=mcon //count=2 \
 //x=2.59 //y=7.4 //x2=2.59 //y2=7.4
r75 (  9 23 ) resistor r=3.1 //w=0.17 //l=0.51 //layer=mcon //count=3 //x=1.85 \
 //y=7.4 //x2=1.85 //y2=7.4
r76 (  9 11 ) resistor r=0.307309 //w=0.301 //l=0.74 //layer=m1 \
 //thickness=0.36 //x=1.85 //y=7.4 //x2=2.59 //y2=7.4
r77 (  7 13 ) resistor r=0.0287885 //w=0.34 //l=0.085 //layer=m1 \
 //thickness=0.36 //x=1.315 //y=7.4 //x2=1.23 //y2=7.4
r78 (  7 9 ) resistor r=0.222176 //w=0.301 //l=0.535 //layer=m1 \
 //thickness=0.36 //x=1.315 //y=7.4 //x2=1.85 //y2=7.4
r79 (  6 13 ) resistor r=0.0401957 //w=0.68 //l=0.17 //layer=m1 \
 //thickness=0.36 //x=1.23 //y=7.23 //x2=1.23 //y2=7.4
r80 (  5 15 ) resistor r=0.0723371 //w=0.218 //l=0.115 //layer=m1 \
 //thickness=0.36 //x=1.23 //y=6.855 //x2=1.23 //y2=6.74
r81 (  5 6 ) resistor r=0.357824 //w=0.131 //l=0.375 //layer=m1 \
 //thickness=0.36 //x=1.23 //y=6.855 //x2=1.23 //y2=7.23
r82 (  3 21 ) resistor r=3.1 //w=0.17 //l=0.51 //layer=mcon //count=3 //x=0.74 \
 //y=7.4 //x2=0.74 //y2=7.4
r83 (  1 13 ) resistor r=0.0287885 //w=0.34 //l=0.085 //layer=m1 \
 //thickness=0.36 //x=1.145 //y=7.4 //x2=1.23 //y2=7.4
r84 (  1 3 ) resistor r=0.168189 //w=0.301 //l=0.405 //layer=m1 \
 //thickness=0.36 //x=1.145 //y=7.4 //x2=0.74 //y2=7.4
ends PM_NOR2X1_PCELL\%noxref_4

subckt PM_NOR2X1_PCELL\%noxref_5 ( 4 8 9 12 17 21 22 23 24 25 26 31 33 35 41 \
 42 44 45 48 )
c107 ( 48 0 ) capacitor c=0.0404287f //x=1.885 //y=4.705
c108 ( 45 0 ) capacitor c=0.0312349f //x=1.85 //y=1.915
c109 ( 44 0 ) capacitor c=0.0469143f //x=1.85 //y=2.08
c110 ( 42 0 ) capacitor c=0.0237765f //x=2.415 //y=1.255
c111 ( 41 0 ) capacitor c=0.0191782f //x=2.415 //y=0.905
c112 ( 35 0 ) capacitor c=0.035988f //x=2.26 //y=1.405
c113 ( 33 0 ) capacitor c=0.0157803f //x=2.26 //y=0.75
c114 ( 31 0 ) capacitor c=0.036638f //x=2.255 //y=4.795
c115 ( 26 0 ) capacitor c=0.0206674f //x=1.885 //y=1.56
c116 ( 25 0 ) capacitor c=0.0169638f //x=1.885 //y=1.255
c117 ( 24 0 ) capacitor c=0.0185462f //x=1.885 //y=0.905
c118 ( 23 0 ) capacitor c=0.155887f //x=2.33 //y=6.025
c119 ( 22 0 ) capacitor c=0.110534f //x=1.89 //y=6.025
c120 ( 17 0 ) capacitor c=0.00113117f //x=1.885 //y=4.705
c121 ( 12 0 ) capacitor c=9.45497e-19 //x=1.85 //y=2.08
c122 ( 9 0 ) capacitor c=0.0608772f //x=1.885 //y=4.56
c123 ( 8 0 ) capacitor c=0.00668188f //x=1.885 //y=4.705
c124 ( 4 0 ) capacitor c=0.00573992f //x=1.85 //y=2.08
r125 (  50 51 ) resistor r=32.4568 //w=0.214 //l=0.075 //layer=ply \
 //thickness=0.18 //x=1.885 //y=4.795 //x2=1.885 //y2=4.87
r126 (  48 50 ) resistor r=20.271 //w=0.214 //l=0.09 //layer=ply \
 //thickness=0.18 //x=1.885 //y=4.705 //x2=1.885 //y2=4.795
r127 (  44 45 ) resistor r=52.7279 //w=0.214 //l=0.165 //layer=ply \
 //thickness=0.18 //x=1.85 //y=2.08 //x2=1.85 //y2=1.915
r128 (  42 55 ) resistor r=4.95774 //w=0.164 //l=0.112 //layer=ply \
 //thickness=0.18 //x=2.415 //y=1.255 //x2=2.415 //y2=1.367
r129 (  41 54 ) resistor r=45.1352 //w=0.168 //l=0.173853 //layer=ply \
 //thickness=0.18 //x=2.415 //y=0.905 //x2=2.375 //y2=0.75
r130 (  41 42 ) resistor r=179.468 //w=0.094 //l=0.35 //layer=ply \
 //thickness=0.18 //x=2.415 //y=0.905 //x2=2.415 //y2=1.255
r131 (  36 53 ) resistor r=10.8103 //w=0.211 //l=0.115 //layer=ply \
 //thickness=0.18 //x=2.04 //y=1.405 //x2=1.925 //y2=1.405
r132 (  35 55 ) resistor r=45.9962 //w=0.164 //l=0.17296 //layer=ply \
 //thickness=0.18 //x=2.26 //y=1.405 //x2=2.415 //y2=1.367
r133 (  34 52 ) resistor r=5.52526 //w=0.168 //l=0.115 //layer=ply \
 //thickness=0.18 //x=2.04 //y=0.75 //x2=1.925 //y2=0.75
r134 (  33 54 ) resistor r=5.52526 //w=0.168 //l=0.115 //layer=ply \
 //thickness=0.18 //x=2.26 //y=0.75 //x2=2.375 //y2=0.75
r135 (  33 34 ) resistor r=112.809 //w=0.094 //l=0.22 //layer=ply \
 //thickness=0.18 //x=2.26 //y=0.75 //x2=2.04 //y2=0.75
r136 (  32 50 ) resistor r=16.5046 //w=0.27 //l=0.135 //layer=ply \
 //thickness=0.18 //x=2.02 //y=4.795 //x2=1.885 //y2=4.795
r137 (  31 38 ) resistor r=26.9307 //w=0.15 //l=0.106066 //layer=ply \
 //thickness=0.18 //x=2.255 //y=4.795 //x2=2.33 //y2=4.87
r138 (  31 32 ) resistor r=120.5 //w=0.094 //l=0.235 //layer=ply \
 //thickness=0.18 //x=2.255 //y=4.795 //x2=2.02 //y2=4.795
r139 (  26 53 ) resistor r=39.5036 //w=0.211 //l=0.173853 //layer=ply \
 //thickness=0.18 //x=1.885 //y=1.56 //x2=1.925 //y2=1.405
r140 (  26 45 ) resistor r=182.032 //w=0.094 //l=0.355 //layer=ply \
 //thickness=0.18 //x=1.885 //y=1.56 //x2=1.885 //y2=1.915
r141 (  25 53 ) resistor r=38.3614 //w=0.211 //l=0.168819 //layer=ply \
 //thickness=0.18 //x=1.885 //y=1.255 //x2=1.925 //y2=1.405
r142 (  24 52 ) resistor r=45.1352 //w=0.168 //l=0.173853 //layer=ply \
 //thickness=0.18 //x=1.885 //y=0.905 //x2=1.925 //y2=0.75
r143 (  24 25 ) resistor r=179.468 //w=0.094 //l=0.35 //layer=ply \
 //thickness=0.18 //x=1.885 //y=0.905 //x2=1.885 //y2=1.255
r144 (  23 38 ) resistor r=592.245 //w=0.094 //l=1.155 //layer=ply \
 //thickness=0.18 //x=2.33 //y=6.025 //x2=2.33 //y2=4.87
r145 (  22 51 ) resistor r=592.245 //w=0.094 //l=1.155 //layer=ply \
 //thickness=0.18 //x=1.89 //y=6.025 //x2=1.89 //y2=4.87
r146 (  21 35 ) resistor r=56.4043 //w=0.094 //l=0.11 //layer=ply \
 //thickness=0.18 //x=2.15 //y=1.405 //x2=2.26 //y2=1.405
r147 (  21 36 ) resistor r=56.4043 //w=0.094 //l=0.11 //layer=ply \
 //thickness=0.18 //x=2.15 //y=1.405 //x2=2.04 //y2=1.405
r148 (  17 48 ) resistor r=152 //w=0.17 //l=0.17 //layer=licon //count=1 \
 //x=1.885 //y=4.705 //x2=1.885 //y2=4.705
r149 (  12 44 ) resistor r=152 //w=0.17 //l=0.17 //layer=licon //count=1 \
 //x=1.85 //y=2.08 //x2=1.85 //y2=2.08
r150 (  8 17 ) resistor r=9.3 //w=0.17 //l=0.17 //layer=mcon //count=1 \
 //x=1.885 //y=4.705 //x2=1.885 //y2=4.705
r151 (  8 9 ) resistor r=0.105739 //w=0.201 //l=0.145 //layer=m1 \
 //thickness=0.36 //x=1.885 //y=4.705 //x2=1.885 //y2=4.56
r152 (  6 9 ) resistor r=2.2376 //w=0.131 //l=2.345 //layer=m1 \
 //thickness=0.36 //x=1.85 //y=2.215 //x2=1.85 //y2=4.56
r153 (  4 12 ) resistor r=9.3 //w=0.17 //l=0.17 //layer=mcon //count=1 \
 //x=1.85 //y=2.08 //x2=1.85 //y2=2.08
r154 (  4 6 ) resistor r=0.0977888 //w=0.216 //l=0.135 //layer=m1 \
 //thickness=0.36 //x=1.847 //y=2.08 //x2=1.847 //y2=2.215
ends PM_NOR2X1_PCELL\%noxref_5

subckt PM_NOR2X1_PCELL\%noxref_6 ( 1 2 3 4 5 6 7 9 12 16 27 39 40 43 )
c114 ( 40 0 ) capacitor c=0.00901091f //x=1.96 //y=0.905
c115 ( 39 0 ) capacitor c=0.00876479f //x=0.99 //y=0.905
c116 ( 27 0 ) capacitor c=0.0246538f //x=2.11 //y=5.38
c117 ( 16 0 ) capacitor c=0.0166626f //x=2.105 //y=5.21
c118 ( 15 0 ) capacitor c=0.00513603f //x=2.15 //y=1.655
c119 ( 12 0 ) capacitor c=0.136161f //x=2.59 //y=5.125
c120 ( 9 0 ) capacitor c=0.0166762f //x=2.505 //y=1.655
c121 ( 7 0 ) capacitor c=0.0133104f //x=2.505 //y=5.21
c122 ( 6 0 ) capacitor c=0.0111615f //x=2.15 //y=1.57
c123 ( 5 0 ) capacitor c=0.0115708f //x=2.15 //y=1.12
c124 ( 4 0 ) capacitor c=0.00472589f //x=1.265 //y=1.655
c125 ( 3 0 ) capacitor c=0.0217217f //x=2.065 //y=1.655
c126 ( 2 0 ) capacitor c=0.0106027f //x=1.18 //y=1.57
c127 ( 1 0 ) capacitor c=0.0114617f //x=1.18 //y=1.125
r128 (  27 43 ) resistor r=23.2727 //w=0.187 //l=0.34 //layer=li \
 //thickness=0.1 //x=2.11 //y=5.38 //x2=2.11 //y2=5.72
r129 (  20 40 ) resistor r=9.3 //w=0.17 //l=0.17 //layer=mcon //count=1 \
 //x=2.15 //y=1 //x2=2.15 //y2=1
r130 (  18 27 ) resistor r=9.3 //w=0.17 //l=0.17 //layer=mcon //count=1 \
 //x=2.11 //y=5.38 //x2=2.11 //y2=5.38
r131 (  16 18 ) resistor r=0.0974771 //w=0.218 //l=0.17 //layer=m1 \
 //thickness=0.36 //x=2.105 //y=5.21 //x2=2.105 //y2=5.38
r132 (  14 39 ) resistor r=9.3 //w=0.17 //l=0.17 //layer=mcon //count=1 \
 //x=1.18 //y=1 //x2=1.18 //y2=1
r133 (  11 12 ) resistor r=3.22996 //w=0.131 //l=3.385 //layer=m1 \
 //thickness=0.36 //x=2.59 //y=1.74 //x2=2.59 //y2=5.125
r134 (  10 15 ) resistor r=0.0529306 //w=0.17 //l=0.085 //layer=m1 \
 //thickness=0.36 //x=2.235 //y=1.655 //x2=2.15 //y2=1.655
r135 (  9 11 ) resistor r=0.0698411 //w=0.17 //l=0.120208 //layer=m1 \
 //thickness=0.36 //x=2.505 //y=1.655 //x2=2.59 //y2=1.74
r136 (  9 10 ) resistor r=0.257634 //w=0.131 //l=0.27 //layer=m1 \
 //thickness=0.36 //x=2.505 //y=1.655 //x2=2.235 //y2=1.655
r137 (  8 16 ) resistor r=0.0225019 //w=0.218 //l=0.12 //layer=m1 \
 //thickness=0.36 //x=2.225 //y=5.21 //x2=2.105 //y2=5.21
r138 (  7 12 ) resistor r=0.0698411 //w=0.17 //l=0.120208 //layer=m1 \
 //thickness=0.36 //x=2.505 //y=5.21 //x2=2.59 //y2=5.125
r139 (  7 8 ) resistor r=0.267176 //w=0.131 //l=0.28 //layer=m1 \
 //thickness=0.36 //x=2.505 //y=5.21 //x2=2.225 //y2=5.21
r140 (  6 15 ) resistor r=0.0137558 //w=0.34 //l=0.085 //layer=m1 \
 //thickness=0.36 //x=2.15 //y=1.57 //x2=2.15 //y2=1.655
r141 (  5 20 ) resistor r=0.0728765 //w=0.25 //l=0.121491 //layer=m1 \
 //thickness=0.36 //x=2.15 //y=1.12 //x2=2.147 //y2=1
r142 (  5 6 ) resistor r=0.429389 //w=0.131 //l=0.45 //layer=m1 \
 //thickness=0.36 //x=2.15 //y=1.12 //x2=2.15 //y2=1.57
r143 (  3 15 ) resistor r=0.0529306 //w=0.17 //l=0.085 //layer=m1 \
 //thickness=0.36 //x=2.065 //y=1.655 //x2=2.15 //y2=1.655
r144 (  3 4 ) resistor r=0.763359 //w=0.131 //l=0.8 //layer=m1 \
 //thickness=0.36 //x=2.065 //y=1.655 //x2=1.265 //y2=1.655
r145 (  2 4 ) resistor r=0.0698411 //w=0.17 //l=0.120208 //layer=m1 \
 //thickness=0.36 //x=1.18 //y=1.57 //x2=1.265 //y2=1.655
r146 (  1 14 ) resistor r=0.0764279 //w=0.233 //l=0.126491 //layer=m1 \
 //thickness=0.36 //x=1.18 //y=1.125 //x2=1.177 //y2=1
r147 (  1 2 ) resistor r=0.424618 //w=0.131 //l=0.445 //layer=m1 \
 //thickness=0.36 //x=1.18 //y=1.125 //x2=1.18 //y2=1.57
ends PM_NOR2X1_PCELL\%noxref_6
