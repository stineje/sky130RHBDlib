// File: inv.spi
// Created: Tue Apr 29 10:49:49 2025
// Program "Calibre xRC"
// Version "v2023.2_27.15"
//
simulator lang=spectre
include "/import/yukari1/lrburle/sky130RHBDlib/sky130_rhbd/pex/inv.pex.spice"
subckt inv (  A Y )
//
// Y	Y
// A	A
M0_noxref ( N_Y_M0_noxref_d N_A_M0_noxref_g noxref_2 noxref_9 ) NMOS l=0.15 \
 w=0.42 m=1
M1_noxref ( N_Y_M1_noxref_d N_A_M1_noxref_g noxref_3 noxref_7 ) PMOS l=0.15 \
 w=0.42 ad=0.1197 as=0.1197 pd=0.99 ps=0.99 nrd=0 nrs=0 m=1
c_15 ( noxref_2 0 ) capacitor c=0.151981f //x=-0.365 //y=-0.205
c_21 ( noxref_3 0 ) capacitor c=0.149421f //x=-0.285 //y=0.985
//
include "/import/yukari1/lrburle/sky130RHBDlib/sky130_rhbd/pex/inv.pxi.spice"
//
ends INV
//
//
