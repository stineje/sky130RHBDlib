// File: AND3X1.spi.AND3X1.pxi
// Created: Sun Apr 12 08:29:40 2026
//
simulator lang=spectre
x_PM_AND3X1\%noxref_1 ( N_noxref_1_c_1_p N_noxref_1_c_2_p N_noxref_1_c_3_p \
 N_noxref_1_c_4_p N_noxref_1_c_65_p N_noxref_1_c_79_p N_noxref_1_c_66_p \
 N_noxref_1_c_118_p N_noxref_1_c_5_p N_noxref_1_c_32_p N_noxref_1_c_81_p \
 N_noxref_1_c_6_p N_noxref_1_c_7_p N_noxref_1_c_8_p N_noxref_1_c_9_p \
 N_noxref_1_c_144_p N_noxref_1_c_116_p N_noxref_1_c_186_p N_noxref_1_c_69_p \
 N_noxref_1_c_34_p N_noxref_1_c_140_p N_noxref_1_c_60_p N_noxref_1_c_10_p \
 N_noxref_1_c_11_p N_noxref_1_c_12_p N_noxref_1_c_70_p N_noxref_1_c_13_p \
 N_noxref_1_M3_noxref_g N_noxref_1_M10_noxref_g N_noxref_1_M11_noxref_g \
 N_noxref_1_c_76_p N_noxref_1_c_196_p N_noxref_1_c_94_p N_noxref_1_c_85_p \
 N_noxref_1_c_43_p N_noxref_1_c_38_p N_noxref_1_c_96_p N_noxref_1_c_199_p \
 N_noxref_1_c_78_p N_noxref_1_c_98_p N_noxref_1_c_77_p N_noxref_1_M2_noxref_d \
 N_noxref_1_M4_noxref_d N_noxref_1_M6_noxref_d N_noxref_1_M8_noxref_d )  \
 PM_AND3X1\%noxref_1
x_PM_AND3X1\%VDD ( VDD N_VDD_c_229_n N_VDD_c_242_n N_VDD_c_244_n N_VDD_c_247_n \
 N_VDD_c_251_n N_VDD_c_255_n N_VDD_c_256_n N_VDD_c_259_n N_VDD_c_267_n \
 N_VDD_M4_noxref_s N_VDD_M5_noxref_d N_VDD_M7_noxref_d N_VDD_M9_noxref_d \
 N_VDD_M10_noxref_s N_VDD_M11_noxref_d )  PM_AND3X1\%VDD
x_PM_AND3X1\%GND ( GND N_GND_c_439_p N_GND_c_379_p N_GND_c_334_n N_GND_c_369_n \
 N_GND_c_341_n N_GND_c_370_n N_GND_c_409_p N_GND_c_343_n N_GND_c_347_n \
 N_GND_c_348_n N_GND_c_356_n N_GND_M0_noxref_d N_GND_M3_noxref_s )  \
 PM_AND3X1\%GND
x_PM_AND3X1\%A ( A A A A A A A N_A_c_480_n N_A_c_469_n N_A_c_483_n N_A_c_471_n \
 N_A_M0_noxref_g N_A_M4_noxref_g N_A_M5_noxref_g N_A_c_485_n N_A_c_489_n \
 N_A_c_491_n N_A_c_493_n N_A_c_494_n N_A_c_497_n N_A_c_499_n N_A_c_502_n \
 N_A_c_466_n N_A_c_477_n )  PM_AND3X1\%A
x_PM_AND3X1\%noxref_5 ( N_noxref_5_c_566_n N_noxref_5_c_569_n \
 N_noxref_5_c_555_n N_noxref_5_c_575_n N_noxref_5_c_558_n \
 N_noxref_5_M1_noxref_d N_noxref_5_M2_noxref_s )  PM_AND3X1\%noxref_5
x_PM_AND3X1\%B ( B B B B B B B N_B_c_641_n N_B_c_623_n N_B_c_653_n N_B_c_626_n \
 N_B_M1_noxref_g N_B_M6_noxref_g N_B_M7_noxref_g N_B_c_665_n N_B_c_668_n \
 N_B_c_684_n N_B_c_685_n N_B_c_670_n N_B_c_671_n N_B_c_672_n N_B_c_673_n \
 N_B_c_634_n N_B_c_636_n )  PM_AND3X1\%B
x_PM_AND3X1\%C ( C C C C C C C N_C_c_743_n N_C_c_744_n N_C_c_748_n N_C_c_749_n \
 N_C_M2_noxref_g N_C_M8_noxref_g N_C_M9_noxref_g N_C_c_759_n N_C_c_761_n \
 N_C_c_764_n N_C_c_765_n N_C_c_767_n N_C_c_771_n N_C_c_773_n N_C_c_777_n \
 N_C_c_778_n N_C_c_780_n )  PM_AND3X1\%C
x_PM_AND3X1\%Y ( Y Y Y Y Y Y Y N_Y_c_849_n N_Y_c_856_n N_Y_c_860_n N_Y_c_861_n \
 N_Y_c_863_n N_Y_c_864_n N_Y_c_867_n N_Y_c_875_n N_Y_M3_noxref_d \
 N_Y_M10_noxref_d )  PM_AND3X1\%Y
x_PM_AND3X1\%noxref_9 ( N_noxref_9_c_937_n N_noxref_9_c_915_n \
 N_noxref_9_c_920_n N_noxref_9_c_925_n N_noxref_9_c_952_n \
 N_noxref_9_M0_noxref_s )  PM_AND3X1\%noxref_9
cc_1 ( N_noxref_1_c_1_p N_VDD_c_229_n ) capacitor c=0.00621363f //x=2.78 \
 //y=5.335 //x2=6.78 //y2=7.58
cc_2 ( N_noxref_1_c_2_p N_VDD_c_229_n ) capacitor c=0.00627192f //x=3.665 \
 //y=5.335 //x2=6.78 //y2=7.58
cc_3 ( N_noxref_1_c_3_p N_VDD_c_229_n ) capacitor c=0.00256036f //x=3.78 \
 //y=5.56 //x2=6.78 //y2=7.58
cc_4 ( N_noxref_1_c_4_p N_VDD_c_229_n ) capacitor c=0.00829251f //x=4.475 \
 //y=5.335 //x2=6.78 //y2=7.58
cc_5 ( N_noxref_1_c_5_p N_VDD_c_229_n ) capacitor c=4.28832e-19 //x=4.56 \
 //y=3.67 //x2=6.78 //y2=7.58
cc_6 ( N_noxref_1_c_6_p N_VDD_c_229_n ) capacitor c=2.47416e-19 //x=6.04 \
 //y=3.67 //x2=6.78 //y2=7.58
cc_7 ( N_noxref_1_c_7_p N_VDD_c_229_n ) capacitor c=5.73169e-19 //x=6.04 \
 //y=4.76 //x2=6.78 //y2=7.58
cc_8 ( N_noxref_1_c_8_p N_VDD_c_229_n ) capacitor c=0.00261804f //x=2.022 \
 //y=5.335 //x2=6.78 //y2=7.58
cc_9 ( N_noxref_1_c_9_p N_VDD_c_229_n ) capacitor c=0.00270108f //x=2.9 \
 //y=5.335 //x2=6.78 //y2=7.58
cc_10 ( N_noxref_1_c_10_p N_VDD_c_229_n ) capacitor c=0.0024232f //x=2.02 \
 //y=5.56 //x2=6.78 //y2=7.58
cc_11 ( N_noxref_1_c_11_p N_VDD_c_229_n ) capacitor c=0.0024232f //x=2.9 \
 //y=5.56 //x2=6.78 //y2=7.58
cc_12 ( N_noxref_1_c_12_p N_VDD_c_229_n ) capacitor c=0.0024232f //x=3.78 \
 //y=5.56 //x2=6.78 //y2=7.58
cc_13 ( N_noxref_1_c_13_p N_VDD_c_229_n ) capacitor c=3.40755e-19 //x=6.04 \
 //y=4.88 //x2=6.78 //y2=7.58
cc_14 ( N_noxref_1_c_8_p N_VDD_c_242_n ) capacitor c=0.00331944f //x=2.022 \
 //y=5.335 //x2=1.23 //y2=7.58
cc_15 ( N_noxref_1_c_10_p N_VDD_c_242_n ) capacitor c=0.00509469f //x=2.02 \
 //y=5.56 //x2=1.23 //y2=7.58
cc_16 ( N_noxref_1_c_1_p N_VDD_c_244_n ) capacitor c=0.00207166f //x=2.78 \
 //y=5.335 //x2=2.375 //y2=7.585
cc_17 ( N_noxref_1_c_8_p N_VDD_c_244_n ) capacitor c=0.00105965f //x=2.022 \
 //y=5.335 //x2=2.375 //y2=7.585
cc_18 ( N_noxref_1_c_10_p N_VDD_c_244_n ) capacitor c=0.0138074f //x=2.02 \
 //y=5.56 //x2=2.375 //y2=7.585
cc_19 ( N_noxref_1_c_1_p N_VDD_c_247_n ) capacitor c=0.0017708f //x=2.78 \
 //y=5.335 //x2=3.255 //y2=7.585
cc_20 ( N_noxref_1_c_2_p N_VDD_c_247_n ) capacitor c=0.00207166f //x=3.665 \
 //y=5.335 //x2=3.255 //y2=7.585
cc_21 ( N_noxref_1_c_9_p N_VDD_c_247_n ) capacitor c=0.00105504f //x=2.9 \
 //y=5.335 //x2=3.255 //y2=7.585
cc_22 ( N_noxref_1_c_11_p N_VDD_c_247_n ) capacitor c=0.0138074f //x=2.9 \
 //y=5.56 //x2=3.255 //y2=7.585
cc_23 ( N_noxref_1_c_2_p N_VDD_c_251_n ) capacitor c=0.00210773f //x=3.665 \
 //y=5.335 //x2=4.135 //y2=7.585
cc_24 ( N_noxref_1_c_3_p N_VDD_c_251_n ) capacitor c=9.07918e-19 //x=3.78 \
 //y=5.56 //x2=4.135 //y2=7.585
cc_25 ( N_noxref_1_c_4_p N_VDD_c_251_n ) capacitor c=0.00207983f //x=4.475 \
 //y=5.335 //x2=4.135 //y2=7.585
cc_26 ( N_noxref_1_c_12_p N_VDD_c_251_n ) capacitor c=0.0138074f //x=3.78 \
 //y=5.56 //x2=4.135 //y2=7.585
cc_27 ( N_noxref_1_c_4_p N_VDD_c_255_n ) capacitor c=0.00189983f //x=4.475 \
 //y=5.335 //x2=5.13 //y2=7.585
cc_28 ( N_noxref_1_c_7_p N_VDD_c_256_n ) capacitor c=5.48929e-19 //x=6.04 \
 //y=4.76 //x2=6.77 //y2=7.585
cc_29 ( N_noxref_1_M10_noxref_g N_VDD_c_256_n ) capacitor c=0.00753931f \
 //x=6.195 //y=6.2 //x2=6.77 //y2=7.585
cc_30 ( N_noxref_1_M11_noxref_g N_VDD_c_256_n ) capacitor c=0.00755544f \
 //x=6.635 //y=6.2 //x2=6.77 //y2=7.585
cc_31 ( N_noxref_1_c_3_p N_VDD_c_259_n ) capacitor c=0.00263969f //x=3.78 \
 //y=5.56 //x2=5.3 //y2=7.585
cc_32 ( N_noxref_1_c_32_p N_VDD_c_259_n ) capacitor c=0.0300566f //x=4.56 \
 //y=5.25 //x2=5.3 //y2=7.585
cc_33 ( N_noxref_1_c_7_p N_VDD_c_259_n ) capacitor c=0.0155837f //x=6.04 \
 //y=4.76 //x2=5.3 //y2=7.585
cc_34 ( N_noxref_1_c_34_p N_VDD_c_259_n ) capacitor c=0.00501359f //x=5.875 \
 //y=3.51 //x2=5.3 //y2=7.585
cc_35 ( N_noxref_1_c_12_p N_VDD_c_259_n ) capacitor c=0.00777894f //x=3.78 \
 //y=5.56 //x2=5.3 //y2=7.585
cc_36 ( N_noxref_1_c_13_p N_VDD_c_259_n ) capacitor c=0.00795306f //x=6.04 \
 //y=4.88 //x2=5.3 //y2=7.585
cc_37 ( N_noxref_1_M10_noxref_g N_VDD_c_259_n ) capacitor c=0.00713874f \
 //x=6.195 //y=6.2 //x2=5.3 //y2=7.585
cc_38 ( N_noxref_1_c_38_p N_VDD_c_259_n ) capacitor c=0.00799922f //x=6.27 \
 //y=4.97 //x2=5.3 //y2=7.585
cc_39 ( N_noxref_1_c_10_p N_VDD_c_267_n ) capacitor c=0.00135089f //x=2.02 \
 //y=5.56 //x2=6.78 //y2=7.58
cc_40 ( N_noxref_1_c_11_p N_VDD_c_267_n ) capacitor c=0.00135089f //x=2.9 \
 //y=5.56 //x2=6.78 //y2=7.58
cc_41 ( N_noxref_1_c_12_p N_VDD_c_267_n ) capacitor c=0.00135089f //x=3.78 \
 //y=5.56 //x2=6.78 //y2=7.58
cc_42 ( N_noxref_1_c_13_p N_VDD_c_267_n ) capacitor c=0.00241457f //x=6.04 \
 //y=4.88 //x2=6.78 //y2=7.58
cc_43 ( N_noxref_1_c_43_p N_VDD_c_267_n ) capacitor c=0.0225829f //x=6.56 \
 //y=4.97 //x2=6.78 //y2=7.58
cc_44 ( N_noxref_1_c_8_p N_VDD_M4_noxref_s ) capacitor c=0.0451824f //x=2.022 \
 //y=5.335 //x2=1.445 //y2=5.2
cc_45 ( N_noxref_1_c_9_p N_VDD_M4_noxref_s ) capacitor c=7.80122e-19 //x=2.9 \
 //y=5.335 //x2=1.445 //y2=5.2
cc_46 ( N_noxref_1_c_10_p N_VDD_M4_noxref_s ) capacitor c=0.09305f //x=2.02 \
 //y=5.56 //x2=1.445 //y2=5.2
cc_47 ( N_noxref_1_c_1_p N_VDD_M5_noxref_d ) capacitor c=0.0077575f //x=2.78 \
 //y=5.335 //x2=2.315 //y2=5.2
cc_48 ( N_noxref_1_c_10_p N_VDD_M5_noxref_d ) capacitor c=0.0674491f //x=2.02 \
 //y=5.56 //x2=2.315 //y2=5.2
cc_49 ( N_noxref_1_c_11_p N_VDD_M5_noxref_d ) capacitor c=0.0674762f //x=2.9 \
 //y=5.56 //x2=2.315 //y2=5.2
cc_50 ( N_noxref_1_c_2_p N_VDD_M7_noxref_d ) capacitor c=0.00775749f //x=3.665 \
 //y=5.335 //x2=3.195 //y2=5.2
cc_51 ( N_noxref_1_c_11_p N_VDD_M7_noxref_d ) capacitor c=0.067493f //x=2.9 \
 //y=5.56 //x2=3.195 //y2=5.2
cc_52 ( N_noxref_1_c_12_p N_VDD_M7_noxref_d ) capacitor c=0.0674991f //x=3.78 \
 //y=5.56 //x2=3.195 //y2=5.2
cc_53 ( N_noxref_1_c_4_p N_VDD_M9_noxref_d ) capacitor c=0.0077575f //x=4.475 \
 //y=5.335 //x2=4.075 //y2=5.2
cc_54 ( N_noxref_1_c_12_p N_VDD_M9_noxref_d ) capacitor c=0.0674932f //x=3.78 \
 //y=5.56 //x2=4.075 //y2=5.2
cc_55 ( N_noxref_1_c_3_p N_VDD_M10_noxref_s ) capacitor c=0.00605846f //x=3.78 \
 //y=5.56 //x2=5.84 //y2=5.2
cc_56 ( N_noxref_1_c_4_p N_VDD_M10_noxref_s ) capacitor c=0.00111769f \
 //x=4.475 //y=5.335 //x2=5.84 //y2=5.2
cc_57 ( N_noxref_1_c_6_p N_VDD_M10_noxref_s ) capacitor c=0.00120123f //x=6.04 \
 //y=3.67 //x2=5.84 //y2=5.2
cc_58 ( N_noxref_1_c_7_p N_VDD_M10_noxref_s ) capacitor c=0.0211605f //x=6.04 \
 //y=4.76 //x2=5.84 //y2=5.2
cc_59 ( N_noxref_1_c_9_p N_VDD_M10_noxref_s ) capacitor c=2.21057e-19 //x=2.9 \
 //y=5.335 //x2=5.84 //y2=5.2
cc_60 ( N_noxref_1_c_60_p N_VDD_M10_noxref_s ) capacitor c=4.8313e-19 \
 //x=6.035 //y=3.51 //x2=5.84 //y2=5.2
cc_61 ( N_noxref_1_c_13_p N_VDD_M10_noxref_s ) capacitor c=0.00986169f \
 //x=6.04 //y=4.88 //x2=5.84 //y2=5.2
cc_62 ( N_noxref_1_M10_noxref_g N_VDD_M10_noxref_s ) capacitor c=0.0573441f \
 //x=6.195 //y=6.2 //x2=5.84 //y2=5.2
cc_63 ( N_noxref_1_c_38_p N_VDD_M10_noxref_s ) capacitor c=0.00524567f \
 //x=6.27 //y=4.97 //x2=5.84 //y2=5.2
cc_64 ( N_noxref_1_M11_noxref_g N_VDD_M11_noxref_d ) capacitor c=0.0572684f \
 //x=6.635 //y=6.2 //x2=6.71 //y2=5.2
cc_65 ( N_noxref_1_c_65_p N_GND_c_334_n ) capacitor c=0.00907421f //x=4.075 \
 //y=1.305 //x2=6.78 //y2=0.18
cc_66 ( N_noxref_1_c_66_p N_GND_c_334_n ) capacitor c=0.00713708f //x=4.475 \
 //y=1.845 //x2=6.78 //y2=0.18
cc_67 ( N_noxref_1_c_5_p N_GND_c_334_n ) capacitor c=5.00252e-19 //x=4.56 \
 //y=3.67 //x2=6.78 //y2=0.18
cc_68 ( N_noxref_1_c_6_p N_GND_c_334_n ) capacitor c=4.40979e-19 //x=6.04 \
 //y=3.67 //x2=6.78 //y2=0.18
cc_69 ( N_noxref_1_c_69_p N_GND_c_334_n ) capacitor c=0.00249122f //x=6.04 \
 //y=2.265 //x2=6.78 //y2=0.18
cc_70 ( N_noxref_1_c_70_p N_GND_c_334_n ) capacitor c=7.5371e-19 //x=6.04 \
 //y=2.265 //x2=6.78 //y2=0.18
cc_71 ( N_noxref_1_M2_noxref_d N_GND_c_334_n ) capacitor c=2.9462e-19 \
 //x=3.885 //y=1.095 //x2=6.78 //y2=0.18
cc_72 ( N_noxref_1_c_66_p N_GND_c_341_n ) capacitor c=6.86343e-19 //x=4.475 \
 //y=1.845 //x2=5.13 //y2=0.175
cc_73 ( N_noxref_1_c_5_p N_GND_c_341_n ) capacitor c=4.02711e-19 //x=4.56 \
 //y=3.67 //x2=5.13 //y2=0.175
cc_74 ( N_noxref_1_c_69_p N_GND_c_343_n ) capacitor c=0.00114179f //x=6.04 \
 //y=2.265 //x2=6.325 //y2=0.715
cc_75 ( N_noxref_1_c_70_p N_GND_c_343_n ) capacitor c=3.95714e-19 //x=6.04 \
 //y=2.265 //x2=6.325 //y2=0.715
cc_76 ( N_noxref_1_c_76_p N_GND_c_343_n ) capacitor c=0.0125444f //x=6.15 \
 //y=1.09 //x2=6.325 //y2=0.715
cc_77 ( N_noxref_1_c_77_p N_GND_c_343_n ) capacitor c=2.1838e-19 //x=6.04 \
 //y=2.265 //x2=6.325 //y2=0.715
cc_78 ( N_noxref_1_c_78_p N_GND_c_347_n ) capacitor c=0.0134289f //x=6.68 \
 //y=1.09 //x2=6.815 //y2=0.715
cc_79 ( N_noxref_1_c_79_p N_GND_c_348_n ) capacitor c=0.00259059f //x=4.075 \
 //y=1.76 //x2=5.3 //y2=0.175
cc_80 ( N_noxref_1_c_66_p N_GND_c_348_n ) capacitor c=0.0293019f //x=4.475 \
 //y=1.845 //x2=5.3 //y2=0.175
cc_81 ( N_noxref_1_c_81_p N_GND_c_348_n ) capacitor c=0.0103129f //x=6.04 \
 //y=3.35 //x2=5.3 //y2=0.175
cc_82 ( N_noxref_1_c_69_p N_GND_c_348_n ) capacitor c=0.00682461f //x=6.04 \
 //y=2.265 //x2=5.3 //y2=0.175
cc_83 ( N_noxref_1_c_34_p N_GND_c_348_n ) capacitor c=0.00560367f //x=5.875 \
 //y=3.51 //x2=5.3 //y2=0.175
cc_84 ( N_noxref_1_c_70_p N_GND_c_348_n ) capacitor c=0.00733236f //x=6.04 \
 //y=2.265 //x2=5.3 //y2=0.175
cc_85 ( N_noxref_1_c_85_p N_GND_c_348_n ) capacitor c=0.00425302f //x=6.15 \
 //y=2.1 //x2=5.3 //y2=0.175
cc_86 ( N_noxref_1_c_77_p N_GND_c_348_n ) capacitor c=0.00786308f //x=6.04 \
 //y=2.265 //x2=5.3 //y2=0.175
cc_87 ( N_noxref_1_c_65_p N_GND_c_356_n ) capacitor c=2.81113e-19 //x=4.075 \
 //y=1.305 //x2=6.9 //y2=0.175
cc_88 ( N_noxref_1_c_70_p N_GND_c_356_n ) capacitor c=0.0022444f //x=6.04 \
 //y=2.265 //x2=6.9 //y2=0.175
cc_89 ( N_noxref_1_c_77_p N_GND_c_356_n ) capacitor c=2.63786e-19 //x=6.04 \
 //y=2.265 //x2=6.9 //y2=0.175
cc_90 ( N_noxref_1_c_6_p N_GND_M3_noxref_s ) capacitor c=8.20337e-19 //x=6.04 \
 //y=3.67 //x2=5.795 //y2=0.55
cc_91 ( N_noxref_1_c_69_p N_GND_M3_noxref_s ) capacitor c=0.00297876f //x=6.04 \
 //y=2.265 //x2=5.795 //y2=0.55
cc_92 ( N_noxref_1_c_70_p N_GND_M3_noxref_s ) capacitor c=0.00651326f //x=6.04 \
 //y=2.265 //x2=5.795 //y2=0.55
cc_93 ( N_noxref_1_c_76_p N_GND_M3_noxref_s ) capacitor c=0.0301053f //x=6.15 \
 //y=1.09 //x2=5.795 //y2=0.55
cc_94 ( N_noxref_1_c_94_p N_GND_M3_noxref_s ) capacitor c=0.002132f //x=6.15 \
 //y=1.745 //x2=5.795 //y2=0.55
cc_95 ( N_noxref_1_c_85_p N_GND_M3_noxref_s ) capacitor c=0.00304786f //x=6.15 \
 //y=2.1 //x2=5.795 //y2=0.55
cc_96 ( N_noxref_1_c_96_p N_GND_M3_noxref_s ) capacitor c=0.00517463f \
 //x=6.525 //y=0.935 //x2=5.795 //y2=0.55
cc_97 ( N_noxref_1_c_78_p N_GND_M3_noxref_s ) capacitor c=0.0153553f //x=6.68 \
 //y=1.09 //x2=5.795 //y2=0.55
cc_98 ( N_noxref_1_c_98_p N_GND_M3_noxref_s ) capacitor c=0.00629878f //x=6.68 \
 //y=1.435 //x2=5.795 //y2=0.55
cc_99 ( N_noxref_1_c_77_p N_GND_M3_noxref_s ) capacitor c=0.00660555f //x=6.04 \
 //y=2.265 //x2=5.795 //y2=0.55
cc_100 ( N_noxref_1_c_8_p N_A_M4_noxref_g ) capacitor c=0.00501342f //x=2.022 \
 //y=5.335 //x2=1.8 //y2=6.2
cc_101 ( N_noxref_1_c_10_p N_A_M4_noxref_g ) capacitor c=0.0162284f //x=2.02 \
 //y=5.56 //x2=1.8 //y2=6.2
cc_102 ( N_noxref_1_c_1_p N_A_M5_noxref_g ) capacitor c=0.0130704f //x=2.78 \
 //y=5.335 //x2=2.24 //y2=6.2
cc_103 ( N_noxref_1_c_8_p N_A_M5_noxref_g ) capacitor c=0.00229208f //x=2.022 \
 //y=5.335 //x2=2.24 //y2=6.2
cc_104 ( N_noxref_1_c_10_p N_A_M5_noxref_g ) capacitor c=0.0179041f //x=2.02 \
 //y=5.56 //x2=2.24 //y2=6.2
cc_105 ( N_noxref_1_c_8_p N_A_c_466_n ) capacitor c=0.00171885f //x=2.022 \
 //y=5.335 //x2=2.165 //y2=4.97
cc_106 ( N_noxref_1_c_10_p N_A_c_466_n ) capacitor c=0.00291477f //x=2.02 \
 //y=5.56 //x2=2.165 //y2=4.97
cc_107 ( N_noxref_1_c_65_p N_noxref_5_c_555_n ) capacitor c=0.00361816f \
 //x=4.075 //y=1.305 //x2=4.475 //y2=0.72
cc_108 ( N_noxref_1_c_66_p N_noxref_5_c_555_n ) capacitor c=0.00365967f \
 //x=4.475 //y=1.845 //x2=4.475 //y2=0.72
cc_109 ( N_noxref_1_M2_noxref_d N_noxref_5_c_555_n ) capacitor c=0.00910163f \
 //x=3.885 //y=1.095 //x2=4.475 //y2=0.72
cc_110 ( N_noxref_1_M2_noxref_d N_noxref_5_c_558_n ) capacitor c=0.00120711f \
 //x=3.885 //y=1.095 //x2=3.59 //y2=1.175
cc_111 ( N_noxref_1_c_1_p N_noxref_5_M1_noxref_d ) capacitor c=0.00159056f \
 //x=2.78 //y=5.335 //x2=2.35 //y2=1.09
cc_112 ( N_noxref_1_c_65_p N_noxref_5_M1_noxref_d ) capacitor c=0.00802207f \
 //x=4.075 //y=1.305 //x2=2.35 //y2=1.09
cc_113 ( N_noxref_1_c_65_p N_noxref_5_M2_noxref_s ) capacitor c=0.00981855f \
 //x=4.075 //y=1.305 //x2=3.455 //y2=0.555
cc_114 ( N_noxref_1_c_79_p N_noxref_5_M2_noxref_s ) capacitor c=0.0268343f \
 //x=4.075 //y=1.76 //x2=3.455 //y2=0.555
cc_115 ( N_noxref_1_c_66_p N_noxref_5_M2_noxref_s ) capacitor c=0.00871957f \
 //x=4.475 //y=1.845 //x2=3.455 //y2=0.555
cc_116 ( N_noxref_1_c_116_p N_noxref_5_M2_noxref_s ) capacitor c=0.0016218f \
 //x=4.56 //y=3.51 //x2=3.455 //y2=0.555
cc_117 ( N_noxref_1_M2_noxref_d N_noxref_5_M2_noxref_s ) capacitor \
 c=0.0279003f //x=3.885 //y=1.095 //x2=3.455 //y2=0.555
cc_118 ( N_noxref_1_c_118_p B ) capacitor c=0.00189765f //x=4.56 //y=3.35 \
 //x2=2.71 //y2=2.4
cc_119 ( N_noxref_1_c_32_p B ) capacitor c=0.00199373f //x=4.56 //y=5.25 \
 //x2=2.71 //y2=2.4
cc_120 ( N_noxref_1_c_1_p N_B_c_623_n ) capacitor c=0.0220212f //x=2.78 \
 //y=5.335 //x2=2.71 //y2=4.765
cc_121 ( N_noxref_1_c_9_p N_B_c_623_n ) capacitor c=0.00259321f //x=2.9 \
 //y=5.335 //x2=2.71 //y2=4.765
cc_122 ( N_noxref_1_c_11_p N_B_c_623_n ) capacitor c=7.85344e-19 //x=2.9 \
 //y=5.56 //x2=2.71 //y2=4.765
cc_123 ( N_noxref_1_c_1_p N_B_c_626_n ) capacitor c=0.00492634f //x=2.78 \
 //y=5.335 //x2=2.71 //y2=4.88
cc_124 ( N_noxref_1_c_9_p N_B_c_626_n ) capacitor c=0.00132214f //x=2.9 \
 //y=5.335 //x2=2.71 //y2=4.88
cc_125 ( N_noxref_1_c_1_p N_B_M6_noxref_g ) capacitor c=0.00858241f //x=2.78 \
 //y=5.335 //x2=2.68 //y2=6.2
cc_126 ( N_noxref_1_c_9_p N_B_M6_noxref_g ) capacitor c=0.00229818f //x=2.9 \
 //y=5.335 //x2=2.68 //y2=6.2
cc_127 ( N_noxref_1_c_11_p N_B_M6_noxref_g ) capacitor c=0.0179041f //x=2.9 \
 //y=5.56 //x2=2.68 //y2=6.2
cc_128 ( N_noxref_1_c_2_p N_B_M7_noxref_g ) capacitor c=0.0136936f //x=3.665 \
 //y=5.335 //x2=3.12 //y2=6.2
cc_129 ( N_noxref_1_c_9_p N_B_M7_noxref_g ) capacitor c=0.00230699f //x=2.9 \
 //y=5.335 //x2=3.12 //y2=6.2
cc_130 ( N_noxref_1_c_11_p N_B_M7_noxref_g ) capacitor c=0.0179041f //x=2.9 \
 //y=5.56 //x2=3.12 //y2=6.2
cc_131 ( N_noxref_1_c_9_p N_B_c_634_n ) capacitor c=0.00171075f //x=2.9 \
 //y=5.335 //x2=3.045 //y2=4.97
cc_132 ( N_noxref_1_c_11_p N_B_c_634_n ) capacitor c=0.00290085f //x=2.9 \
 //y=5.56 //x2=3.045 //y2=4.97
cc_133 ( N_noxref_1_c_1_p N_B_c_636_n ) capacitor c=6.59853e-19 //x=2.78 \
 //y=5.335 //x2=2.71 //y2=4.88
cc_134 ( N_noxref_1_c_118_p C ) capacitor c=0.0445642f //x=4.56 //y=3.35 \
 //x2=3.82 //y2=2.4
cc_135 ( N_noxref_1_c_5_p C ) capacitor c=0.0146933f //x=4.56 //y=3.67 \
 //x2=3.82 //y2=2.4
cc_136 ( N_noxref_1_c_32_p C ) capacitor c=0.0498822f //x=4.56 //y=5.25 \
 //x2=3.82 //y2=2.4
cc_137 ( N_noxref_1_c_81_p C ) capacitor c=0.00222924f //x=6.04 //y=3.35 \
 //x2=3.82 //y2=2.4
cc_138 ( N_noxref_1_c_7_p C ) capacitor c=0.00225537f //x=6.04 //y=4.76 \
 //x2=3.82 //y2=2.4
cc_139 ( N_noxref_1_c_116_p C ) capacitor c=6.03895e-19 //x=4.56 //y=3.51 \
 //x2=3.82 //y2=2.4
cc_140 ( N_noxref_1_c_140_p C ) capacitor c=0.00684342f //x=4.725 //y=3.51 \
 //x2=3.82 //y2=2.4
cc_141 ( N_noxref_1_c_118_p N_C_c_743_n ) capacitor c=0.0154269f //x=4.56 \
 //y=3.35 //x2=3.82 //y2=2.375
cc_142 ( N_noxref_1_c_4_p N_C_c_744_n ) capacitor c=0.00244389f //x=4.475 \
 //y=5.335 //x2=3.82 //y2=4.75
cc_143 ( N_noxref_1_c_32_p N_C_c_744_n ) capacitor c=0.0152702f //x=4.56 \
 //y=5.25 //x2=3.82 //y2=4.75
cc_144 ( N_noxref_1_c_144_p N_C_c_744_n ) capacitor c=0.024066f //x=3.78 \
 //y=5.335 //x2=3.82 //y2=4.75
cc_145 ( N_noxref_1_c_12_p N_C_c_744_n ) capacitor c=0.00266871f //x=3.78 \
 //y=5.56 //x2=3.82 //y2=4.75
cc_146 ( N_noxref_1_c_118_p N_C_c_748_n ) capacitor c=0.00163444f //x=4.56 \
 //y=3.35 //x2=3.82 //y2=2.26
cc_147 ( N_noxref_1_c_4_p N_C_c_749_n ) capacitor c=0.00130631f //x=4.475 \
 //y=5.335 //x2=3.82 //y2=4.88
cc_148 ( N_noxref_1_c_32_p N_C_c_749_n ) capacitor c=0.00131258f //x=4.56 \
 //y=5.25 //x2=3.82 //y2=4.88
cc_149 ( N_noxref_1_c_144_p N_C_c_749_n ) capacitor c=0.00346456f //x=3.78 \
 //y=5.335 //x2=3.82 //y2=4.88
cc_150 ( N_noxref_1_c_12_p N_C_c_749_n ) capacitor c=0.00624059f //x=3.78 \
 //y=5.56 //x2=3.82 //y2=4.88
cc_151 ( N_noxref_1_c_2_p N_C_M8_noxref_g ) capacitor c=0.0136936f //x=3.665 \
 //y=5.335 //x2=3.56 //y2=6.2
cc_152 ( N_noxref_1_c_3_p N_C_M8_noxref_g ) capacitor c=0.00226521f //x=3.78 \
 //y=5.56 //x2=3.56 //y2=6.2
cc_153 ( N_noxref_1_c_12_p N_C_M8_noxref_g ) capacitor c=0.0178885f //x=3.78 \
 //y=5.56 //x2=3.56 //y2=6.2
cc_154 ( N_noxref_1_c_3_p N_C_M9_noxref_g ) capacitor c=0.00362729f //x=3.78 \
 //y=5.56 //x2=4 //y2=6.2
cc_155 ( N_noxref_1_c_4_p N_C_M9_noxref_g ) capacitor c=0.0122802f //x=4.475 \
 //y=5.335 //x2=4 //y2=6.2
cc_156 ( N_noxref_1_c_12_p N_C_M9_noxref_g ) capacitor c=0.0188608f //x=3.78 \
 //y=5.56 //x2=4 //y2=6.2
cc_157 ( N_noxref_1_c_65_p N_C_c_759_n ) capacitor c=4.64015e-19 //x=4.075 \
 //y=1.305 //x2=3.81 //y2=1.095
cc_158 ( N_noxref_1_M2_noxref_d N_C_c_759_n ) capacitor c=0.00137165f \
 //x=3.885 //y=1.095 //x2=3.81 //y2=1.095
cc_159 ( N_noxref_1_c_65_p N_C_c_761_n ) capacitor c=0.0026012f //x=4.075 \
 //y=1.305 //x2=3.81 //y2=1.44
cc_160 ( N_noxref_1_c_79_p N_C_c_761_n ) capacitor c=0.00127432f //x=4.075 \
 //y=1.76 //x2=3.81 //y2=1.44
cc_161 ( N_noxref_1_M2_noxref_d N_C_c_761_n ) capacitor c=0.00237422f \
 //x=3.885 //y=1.095 //x2=3.81 //y2=1.44
cc_162 ( N_noxref_1_c_79_p N_C_c_764_n ) capacitor c=0.00429966f //x=4.075 \
 //y=1.76 //x2=3.81 //y2=1.75
cc_163 ( N_noxref_1_c_65_p N_C_c_765_n ) capacitor c=5.29969e-19 //x=4.075 \
 //y=1.305 //x2=4.185 //y2=0.94
cc_164 ( N_noxref_1_M2_noxref_d N_C_c_765_n ) capacitor c=0.0020782f //x=3.885 \
 //y=1.095 //x2=4.185 //y2=0.94
cc_165 ( N_noxref_1_c_65_p N_C_c_767_n ) capacitor c=5.54437e-19 //x=4.075 \
 //y=1.305 //x2=4.185 //y2=1.595
cc_166 ( N_noxref_1_c_79_p N_C_c_767_n ) capacitor c=0.00912153f //x=4.075 \
 //y=1.76 //x2=4.185 //y2=1.595
cc_167 ( N_noxref_1_c_66_p N_C_c_767_n ) capacitor c=0.00194716f //x=4.475 \
 //y=1.845 //x2=4.185 //y2=1.595
cc_168 ( N_noxref_1_M2_noxref_d N_C_c_767_n ) capacitor c=0.00356097f \
 //x=3.885 //y=1.095 //x2=4.185 //y2=1.595
cc_169 ( N_noxref_1_c_65_p N_C_c_771_n ) capacitor c=5.26469e-19 //x=4.075 \
 //y=1.305 //x2=4.34 //y2=1.095
cc_170 ( N_noxref_1_M2_noxref_d N_C_c_771_n ) capacitor c=0.00139206f \
 //x=3.885 //y=1.095 //x2=4.34 //y2=1.095
cc_171 ( N_noxref_1_c_65_p N_C_c_773_n ) capacitor c=0.00306686f //x=4.075 \
 //y=1.305 //x2=4.34 //y2=1.44
cc_172 ( N_noxref_1_c_79_p N_C_c_773_n ) capacitor c=0.00326859f //x=4.075 \
 //y=1.76 //x2=4.34 //y2=1.44
cc_173 ( N_noxref_1_c_66_p N_C_c_773_n ) capacitor c=0.00323576f //x=4.475 \
 //y=1.845 //x2=4.34 //y2=1.44
cc_174 ( N_noxref_1_M2_noxref_d N_C_c_773_n ) capacitor c=0.00237422f \
 //x=3.885 //y=1.095 //x2=4.34 //y2=1.44
cc_175 ( N_noxref_1_c_118_p N_C_c_777_n ) capacitor c=0.0025845f //x=4.56 \
 //y=3.35 //x2=3.82 //y2=2.26
cc_176 ( N_noxref_1_c_79_p N_C_c_778_n ) capacitor c=0.00372124f //x=4.075 \
 //y=1.76 //x2=3.82 //y2=2.095
cc_177 ( N_noxref_1_c_118_p N_C_c_778_n ) capacitor c=0.00282067f //x=4.56 \
 //y=3.35 //x2=3.82 //y2=2.095
cc_178 ( N_noxref_1_c_32_p N_C_c_780_n ) capacitor c=0.00739875f //x=4.56 \
 //y=5.25 //x2=3.82 //y2=4.88
cc_179 ( N_noxref_1_c_144_p N_C_c_780_n ) capacitor c=0.00203307f //x=3.78 \
 //y=5.335 //x2=3.82 //y2=4.88
cc_180 ( N_noxref_1_c_12_p N_C_c_780_n ) capacitor c=0.00375636f //x=3.78 \
 //y=5.56 //x2=3.82 //y2=4.88
cc_181 ( N_noxref_1_c_118_p Y ) capacitor c=0.00269396f //x=4.56 //y=3.35 \
 //x2=6.78 //y2=2.4
cc_182 ( N_noxref_1_c_32_p Y ) capacitor c=0.00275096f //x=4.56 //y=5.25 \
 //x2=6.78 //y2=2.4
cc_183 ( N_noxref_1_c_81_p Y ) capacitor c=0.0423348f //x=6.04 //y=3.35 \
 //x2=6.78 //y2=2.4
cc_184 ( N_noxref_1_c_6_p Y ) capacitor c=0.0147607f //x=6.04 //y=3.67 \
 //x2=6.78 //y2=2.4
cc_185 ( N_noxref_1_c_7_p Y ) capacitor c=0.0572653f //x=6.04 //y=4.76 \
 //x2=6.78 //y2=2.4
cc_186 ( N_noxref_1_c_186_p Y ) capacitor c=0.00540946f //x=6.035 //y=3.51 \
 //x2=6.78 //y2=2.4
cc_187 ( N_noxref_1_c_69_p Y ) capacitor c=0.00825076f //x=6.04 //y=2.265 \
 //x2=6.78 //y2=2.4
cc_188 ( N_noxref_1_c_60_p Y ) capacitor c=0.00684342f //x=6.035 //y=3.51 \
 //x2=6.78 //y2=2.4
cc_189 ( N_noxref_1_c_70_p Y ) capacitor c=0.0023016f //x=6.04 //y=2.265 \
 //x2=6.78 //y2=2.4
cc_190 ( N_noxref_1_c_13_p Y ) capacitor c=0.00250262f //x=6.04 //y=4.88 \
 //x2=6.78 //y2=2.4
cc_191 ( N_noxref_1_c_43_p Y ) capacitor c=4.08297e-19 //x=6.56 //y=4.97 \
 //x2=6.78 //y2=2.4
cc_192 ( N_noxref_1_c_38_p Y ) capacitor c=0.00124564f //x=6.27 //y=4.97 \
 //x2=6.78 //y2=2.4
cc_193 ( N_noxref_1_c_77_p Y ) capacitor c=0.00112403f //x=6.04 //y=2.265 \
 //x2=6.78 //y2=2.4
cc_194 ( N_noxref_1_c_79_p N_Y_c_849_n ) capacitor c=0.00466232f //x=4.075 \
 //y=1.76 //x2=6.41 //y2=1.935
cc_195 ( N_noxref_1_c_66_p N_Y_c_849_n ) capacitor c=0.00319702f //x=4.475 \
 //y=1.845 //x2=6.41 //y2=1.935
cc_196 ( N_noxref_1_c_196_p N_Y_c_849_n ) capacitor c=0.00109599f //x=6.15 \
 //y=1.435 //x2=6.41 //y2=1.935
cc_197 ( N_noxref_1_c_94_p N_Y_c_849_n ) capacitor c=0.00526049f //x=6.15 \
 //y=1.745 //x2=6.41 //y2=1.935
cc_198 ( N_noxref_1_c_85_p N_Y_c_849_n ) capacitor c=0.00376866f //x=6.15 \
 //y=2.1 //x2=6.41 //y2=1.935
cc_199 ( N_noxref_1_c_199_p N_Y_c_849_n ) capacitor c=0.00935561f //x=6.525 \
 //y=1.59 //x2=6.41 //y2=1.935
cc_200 ( N_noxref_1_c_98_p N_Y_c_849_n ) capacitor c=0.00362207f //x=6.68 \
 //y=1.435 //x2=6.41 //y2=1.935
cc_201 ( N_noxref_1_c_3_p N_Y_c_856_n ) capacitor c=6.28306e-19 //x=3.78 \
 //y=5.56 //x2=6.415 //y2=5.42
cc_202 ( N_noxref_1_c_4_p N_Y_c_856_n ) capacitor c=0.00294058f //x=4.475 \
 //y=5.335 //x2=6.415 //y2=5.42
cc_203 ( N_noxref_1_M10_noxref_g N_Y_c_856_n ) capacitor c=0.00141266f \
 //x=6.195 //y=6.2 //x2=6.415 //y2=5.42
cc_204 ( N_noxref_1_M11_noxref_g N_Y_c_856_n ) capacitor c=0.00377331f \
 //x=6.635 //y=6.2 //x2=6.415 //y2=5.42
cc_205 ( N_noxref_1_c_199_p N_Y_c_860_n ) capacitor c=0.00180253f //x=6.525 \
 //y=1.59 //x2=6.695 //y2=2.02
cc_206 ( N_noxref_1_c_118_p N_Y_c_861_n ) capacitor c=0.00319702f //x=4.56 \
 //y=3.35 //x2=6.495 //y2=2.02
cc_207 ( N_noxref_1_c_77_p N_Y_c_861_n ) capacitor c=0.00376866f //x=6.04 \
 //y=2.265 //x2=6.495 //y2=2.02
cc_208 ( N_noxref_1_M11_noxref_g N_Y_c_863_n ) capacitor c=0.00966342f \
 //x=6.635 //y=6.2 //x2=6.695 //y2=5.14
cc_209 ( N_noxref_1_c_32_p N_Y_c_864_n ) capacitor c=0.00294058f //x=4.56 \
 //y=5.25 //x2=6.5 //y2=5.14
cc_210 ( N_noxref_1_M10_noxref_g N_Y_c_864_n ) capacitor c=0.00427521f \
 //x=6.195 //y=6.2 //x2=6.5 //y2=5.14
cc_211 ( N_noxref_1_c_43_p N_Y_c_864_n ) capacitor c=0.00262283f //x=6.56 \
 //y=4.97 //x2=6.5 //y2=5.14
cc_212 ( N_noxref_1_c_65_p N_Y_c_867_n ) capacitor c=0.0057403f //x=4.075 \
 //y=1.305 //x2=6.41 //y2=1.185
cc_213 ( N_noxref_1_c_79_p N_Y_c_867_n ) capacitor c=5.10373e-19 //x=4.075 \
 //y=1.76 //x2=6.41 //y2=1.185
cc_214 ( N_noxref_1_c_76_p N_Y_c_867_n ) capacitor c=0.00177147f //x=6.15 \
 //y=1.09 //x2=6.41 //y2=1.185
cc_215 ( N_noxref_1_c_196_p N_Y_c_867_n ) capacitor c=0.00356637f //x=6.15 \
 //y=1.435 //x2=6.41 //y2=1.185
cc_216 ( N_noxref_1_c_96_p N_Y_c_867_n ) capacitor c=5.57924e-19 //x=6.525 \
 //y=0.935 //x2=6.41 //y2=1.185
cc_217 ( N_noxref_1_c_199_p N_Y_c_867_n ) capacitor c=5.75878e-19 //x=6.525 \
 //y=1.59 //x2=6.41 //y2=1.185
cc_218 ( N_noxref_1_c_78_p N_Y_c_867_n ) capacitor c=0.00160969f //x=6.68 \
 //y=1.09 //x2=6.41 //y2=1.185
cc_219 ( N_noxref_1_c_98_p N_Y_c_867_n ) capacitor c=0.00411132f //x=6.68 \
 //y=1.435 //x2=6.41 //y2=1.185
cc_220 ( N_noxref_1_M10_noxref_g N_Y_c_875_n ) capacitor c=0.0162066f \
 //x=6.195 //y=6.2 //x2=6.415 //y2=5.56
cc_221 ( N_noxref_1_M11_noxref_g N_Y_c_875_n ) capacitor c=0.0162066f \
 //x=6.635 //y=6.2 //x2=6.415 //y2=5.56
cc_222 ( N_noxref_1_c_43_p N_Y_c_875_n ) capacitor c=0.00290963f //x=6.56 \
 //y=4.97 //x2=6.415 //y2=5.56
cc_223 ( N_noxref_1_c_76_p N_Y_M3_noxref_d ) capacitor c=0.00137914f //x=6.15 \
 //y=1.09 //x2=6.225 //y2=1.09
cc_224 ( N_noxref_1_c_196_p N_Y_M3_noxref_d ) capacitor c=0.0023891f //x=6.15 \
 //y=1.435 //x2=6.225 //y2=1.09
cc_225 ( N_noxref_1_c_96_p N_Y_M3_noxref_d ) capacitor c=0.0020782f //x=6.525 \
 //y=0.935 //x2=6.225 //y2=1.09
cc_226 ( N_noxref_1_c_199_p N_Y_M3_noxref_d ) capacitor c=0.00356097f \
 //x=6.525 //y=1.59 //x2=6.225 //y2=1.09
cc_227 ( N_noxref_1_c_78_p N_Y_M3_noxref_d ) capacitor c=0.00138452f //x=6.68 \
 //y=1.09 //x2=6.225 //y2=1.09
cc_228 ( N_noxref_1_c_98_p N_Y_M3_noxref_d ) capacitor c=0.00235934f //x=6.68 \
 //y=1.435 //x2=6.225 //y2=1.09
cc_229 ( N_VDD_M4_noxref_s N_GND_c_369_n ) capacitor c=5.21561e-19 //x=1.445 \
 //y=5.2 //x2=1.565 //y2=1.145
cc_230 ( N_VDD_c_242_n N_GND_c_370_n ) capacitor c=0.00989514f //x=1.23 \
 //y=7.58 //x2=1.23 //y2=0.18
cc_231 ( N_VDD_c_259_n N_GND_c_348_n ) capacitor c=0.00912573f //x=5.3 \
 //y=7.585 //x2=5.3 //y2=0.175
cc_232 ( N_VDD_c_267_n N_GND_c_356_n ) capacitor c=0.00989514f //x=6.78 \
 //y=7.58 //x2=6.9 //y2=0.175
cc_233 ( N_VDD_c_242_n A ) capacitor c=0.0112437f //x=1.23 //y=7.58 //x2=1.6 \
 //y2=2.4
cc_234 ( N_VDD_c_242_n N_A_c_469_n ) capacitor c=0.00805425f //x=1.23 //y=7.58 \
 //x2=1.6 //y2=4.755
cc_235 ( N_VDD_M4_noxref_s N_A_c_469_n ) capacitor c=0.0230396f //x=1.445 \
 //y=5.2 //x2=1.6 //y2=4.755
cc_236 ( N_VDD_c_242_n N_A_c_471_n ) capacitor c=0.00371026f //x=1.23 //y=7.58 \
 //x2=1.6 //y2=4.88
cc_237 ( N_VDD_M4_noxref_s N_A_c_471_n ) capacitor c=0.00983413f //x=1.445 \
 //y=5.2 //x2=1.6 //y2=4.88
cc_238 ( N_VDD_c_244_n N_A_M4_noxref_g ) capacitor c=0.00755614f //x=2.375 \
 //y=7.585 //x2=1.8 //y2=6.2
cc_239 ( N_VDD_M4_noxref_s N_A_M4_noxref_g ) capacitor c=0.053419f //x=1.445 \
 //y=5.2 //x2=1.8 //y2=6.2
cc_240 ( N_VDD_c_244_n N_A_M5_noxref_g ) capacitor c=0.00755544f //x=2.375 \
 //y=7.585 //x2=2.24 //y2=6.2
cc_241 ( N_VDD_M5_noxref_d N_A_M5_noxref_g ) capacitor c=0.015318f //x=2.315 \
 //y=5.2 //x2=2.24 //y2=6.2
cc_242 ( N_VDD_c_242_n N_A_c_477_n ) capacitor c=0.00594885f //x=1.23 //y=7.58 \
 //x2=1.875 //y2=4.97
cc_243 ( N_VDD_M4_noxref_s N_A_c_477_n ) capacitor c=0.00633126f //x=1.445 \
 //y=5.2 //x2=1.875 //y2=4.97
cc_244 ( N_VDD_c_247_n N_B_M6_noxref_g ) capacitor c=0.00705252f //x=3.255 \
 //y=7.585 //x2=2.68 //y2=6.2
cc_245 ( N_VDD_M5_noxref_d N_B_M6_noxref_g ) capacitor c=0.015318f //x=2.315 \
 //y=5.2 //x2=2.68 //y2=6.2
cc_246 ( N_VDD_c_247_n N_B_M7_noxref_g ) capacitor c=0.00755544f //x=3.255 \
 //y=7.585 //x2=3.12 //y2=6.2
cc_247 ( N_VDD_M7_noxref_d N_B_M7_noxref_g ) capacitor c=0.015318f //x=3.195 \
 //y=5.2 //x2=3.12 //y2=6.2
cc_248 ( N_VDD_c_259_n N_C_c_749_n ) capacitor c=0.00224736f //x=5.3 //y=7.585 \
 //x2=3.82 //y2=4.88
cc_249 ( N_VDD_c_251_n N_C_M8_noxref_g ) capacitor c=0.00755544f //x=4.135 \
 //y=7.585 //x2=3.56 //y2=6.2
cc_250 ( N_VDD_M7_noxref_d N_C_M8_noxref_g ) capacitor c=0.015318f //x=3.195 \
 //y=5.2 //x2=3.56 //y2=6.2
cc_251 ( N_VDD_c_251_n N_C_M9_noxref_g ) capacitor c=0.00755754f //x=4.135 \
 //y=7.585 //x2=4 //y2=6.2
cc_252 ( N_VDD_M9_noxref_d N_C_M9_noxref_g ) capacitor c=0.0394719f //x=4.075 \
 //y=5.2 //x2=4 //y2=6.2
cc_253 ( N_VDD_c_259_n N_C_c_780_n ) capacitor c=2.63786e-19 //x=5.3 //y=7.585 \
 //x2=3.82 //y2=4.88
cc_254 ( N_VDD_c_267_n Y ) capacitor c=0.0297606f //x=6.78 //y=7.58 //x2=6.78 \
 //y2=2.4
cc_255 ( N_VDD_c_229_n N_Y_c_856_n ) capacitor c=0.00259721f //x=6.78 //y=7.58 \
 //x2=6.415 //y2=5.42
cc_256 ( N_VDD_c_256_n N_Y_c_856_n ) capacitor c=0.00100699f //x=6.77 \
 //y=7.585 //x2=6.415 //y2=5.42
cc_257 ( N_VDD_c_267_n N_Y_c_856_n ) capacitor c=0.00295945f //x=6.78 //y=7.58 \
 //x2=6.415 //y2=5.42
cc_258 ( N_VDD_M10_noxref_s N_Y_c_856_n ) capacitor c=0.0467655f //x=5.84 \
 //y=5.2 //x2=6.415 //y2=5.42
cc_259 ( N_VDD_M11_noxref_d N_Y_c_856_n ) capacitor c=0.0486749f //x=6.71 \
 //y=5.2 //x2=6.415 //y2=5.42
cc_260 ( N_VDD_c_229_n N_Y_c_863_n ) capacitor c=0.00199795f //x=6.78 //y=7.58 \
 //x2=6.695 //y2=5.14
cc_261 ( N_VDD_c_256_n N_Y_c_863_n ) capacitor c=0.00207379f //x=6.77 \
 //y=7.585 //x2=6.695 //y2=5.14
cc_262 ( N_VDD_M11_noxref_d N_Y_c_863_n ) capacitor c=0.0235609f //x=6.71 \
 //y=5.2 //x2=6.695 //y2=5.14
cc_263 ( N_VDD_c_259_n N_Y_c_864_n ) capacitor c=0.00464635f //x=5.3 //y=7.585 \
 //x2=6.5 //y2=5.14
cc_264 ( N_VDD_c_229_n N_Y_c_875_n ) capacitor c=0.00241566f //x=6.78 //y=7.58 \
 //x2=6.415 //y2=5.56
cc_265 ( N_VDD_c_256_n N_Y_c_875_n ) capacitor c=0.0138017f //x=6.77 //y=7.585 \
 //x2=6.415 //y2=5.56
cc_266 ( N_VDD_c_259_n N_Y_c_875_n ) capacitor c=0.00824382f //x=5.3 //y=7.585 \
 //x2=6.415 //y2=5.56
cc_267 ( N_VDD_c_267_n N_Y_c_875_n ) capacitor c=0.00962126f //x=6.78 //y=7.58 \
 //x2=6.415 //y2=5.56
cc_268 ( N_VDD_M10_noxref_s N_Y_c_875_n ) capacitor c=0.0902047f //x=5.84 \
 //y=5.2 //x2=6.415 //y2=5.56
cc_269 ( N_VDD_M11_noxref_d N_Y_c_875_n ) capacitor c=0.0935379f //x=6.71 \
 //y=5.2 //x2=6.415 //y2=5.56
cc_270 ( N_GND_c_370_n A ) capacitor c=0.0126319f //x=1.23 //y=0.18 //x2=1.6 \
 //y2=2.4
cc_271 ( N_GND_c_369_n N_A_c_480_n ) capacitor c=0.00849742f //x=1.565 \
 //y=1.145 //x2=1.6 //y2=2.375
cc_272 ( N_GND_c_370_n N_A_c_480_n ) capacitor c=0.00779049f //x=1.23 //y=0.18 \
 //x2=1.6 //y2=2.375
cc_273 ( N_GND_M0_noxref_d N_A_c_480_n ) capacitor c=4.4417e-19 //x=1.375 \
 //y=1.055 //x2=1.6 //y2=2.375
cc_274 ( N_GND_c_369_n N_A_c_483_n ) capacitor c=2.22883e-19 //x=1.565 \
 //y=1.145 //x2=1.6 //y2=2.26
cc_275 ( N_GND_c_370_n N_A_c_483_n ) capacitor c=0.00394776f //x=1.23 //y=0.18 \
 //x2=1.6 //y2=2.26
cc_276 ( N_GND_c_379_p N_A_c_485_n ) capacitor c=3.97665e-19 //x=1.565 \
 //y=1.015 //x2=1.3 //y2=1.055
cc_277 ( N_GND_c_369_n N_A_c_485_n ) capacitor c=0.00142616f //x=1.565 \
 //y=1.145 //x2=1.3 //y2=1.055
cc_278 ( N_GND_c_341_n N_A_c_485_n ) capacitor c=0.00684566f //x=5.13 \
 //y=0.175 //x2=1.3 //y2=1.055
cc_279 ( N_GND_M0_noxref_d N_A_c_485_n ) capacitor c=0.00184354f //x=1.375 \
 //y=1.055 //x2=1.3 //y2=1.055
cc_280 ( N_GND_c_369_n N_A_c_489_n ) capacitor c=0.00411286f //x=1.565 \
 //y=1.145 //x2=1.3 //y2=1.4
cc_281 ( N_GND_M0_noxref_d N_A_c_489_n ) capacitor c=0.00210798f //x=1.375 \
 //y=1.055 //x2=1.3 //y2=1.4
cc_282 ( N_GND_c_369_n N_A_c_491_n ) capacitor c=4.86145e-19 //x=1.565 \
 //y=1.145 //x2=1.3 //y2=1.71
cc_283 ( N_GND_c_370_n N_A_c_491_n ) capacitor c=0.00295461f //x=1.23 //y=0.18 \
 //x2=1.3 //y2=1.71
cc_284 ( N_GND_c_370_n N_A_c_493_n ) capacitor c=0.0112432f //x=1.23 //y=0.18 \
 //x2=1.3 //y2=2.095
cc_285 ( N_GND_c_379_p N_A_c_494_n ) capacitor c=0.00864776f //x=1.565 \
 //y=1.015 //x2=1.675 //y2=0.9
cc_286 ( N_GND_c_369_n N_A_c_494_n ) capacitor c=5.37984e-19 //x=1.565 \
 //y=1.145 //x2=1.675 //y2=0.9
cc_287 ( N_GND_M0_noxref_d N_A_c_494_n ) capacitor c=0.00474029f //x=1.375 \
 //y=1.055 //x2=1.675 //y2=0.9
cc_288 ( N_GND_c_369_n N_A_c_497_n ) capacitor c=6.35695e-19 //x=1.565 \
 //y=1.145 //x2=1.675 //y2=1.555
cc_289 ( N_GND_M0_noxref_d N_A_c_497_n ) capacitor c=0.00166857f //x=1.375 \
 //y=1.055 //x2=1.675 //y2=1.555
cc_290 ( N_GND_c_379_p N_A_c_499_n ) capacitor c=4.45447e-19 //x=1.565 \
 //y=1.015 //x2=1.83 //y2=1.055
cc_291 ( N_GND_c_369_n N_A_c_499_n ) capacitor c=0.00158223f //x=1.565 \
 //y=1.145 //x2=1.83 //y2=1.055
cc_292 ( N_GND_M0_noxref_d N_A_c_499_n ) capacitor c=0.00230174f //x=1.375 \
 //y=1.055 //x2=1.83 //y2=1.055
cc_293 ( N_GND_c_369_n N_A_c_502_n ) capacitor c=0.00276804f //x=1.565 \
 //y=1.145 //x2=1.83 //y2=1.4
cc_294 ( N_GND_M0_noxref_d N_A_c_502_n ) capacitor c=0.00210798f //x=1.375 \
 //y=1.055 //x2=1.83 //y2=1.4
cc_295 ( N_GND_c_334_n N_noxref_5_c_566_n ) capacitor c=0.0079063f //x=6.78 \
 //y=0.18 //x2=3.505 //y2=1.175
cc_296 ( N_GND_c_341_n N_noxref_5_c_566_n ) capacitor c=0.0080792f //x=5.13 \
 //y=0.175 //x2=3.505 //y2=1.175
cc_297 ( N_GND_c_356_n N_noxref_5_c_566_n ) capacitor c=3.53825e-19 //x=6.9 \
 //y=0.175 //x2=3.505 //y2=1.175
cc_298 ( N_GND_c_334_n N_noxref_5_c_569_n ) capacitor c=0.00710913f //x=6.78 \
 //y=0.18 //x2=3.59 //y2=0.805
cc_299 ( N_GND_c_341_n N_noxref_5_c_569_n ) capacitor c=0.0140604f //x=5.13 \
 //y=0.175 //x2=3.59 //y2=0.805
cc_300 ( N_GND_c_356_n N_noxref_5_c_569_n ) capacitor c=0.00138062f //x=6.9 \
 //y=0.175 //x2=3.59 //y2=0.805
cc_301 ( N_GND_c_334_n N_noxref_5_c_555_n ) capacitor c=0.0104369f //x=6.78 \
 //y=0.18 //x2=4.475 //y2=0.72
cc_302 ( N_GND_c_341_n N_noxref_5_c_555_n ) capacitor c=0.0364637f //x=5.13 \
 //y=0.175 //x2=4.475 //y2=0.72
cc_303 ( N_GND_c_356_n N_noxref_5_c_555_n ) capacitor c=0.00282763f //x=6.9 \
 //y=0.175 //x2=4.475 //y2=0.72
cc_304 ( N_GND_c_334_n N_noxref_5_c_575_n ) capacitor c=0.00232964f //x=6.78 \
 //y=0.18 //x2=4.56 //y2=0.805
cc_305 ( N_GND_c_341_n N_noxref_5_c_575_n ) capacitor c=0.013886f //x=5.13 \
 //y=0.175 //x2=4.56 //y2=0.805
cc_306 ( N_GND_c_409_p N_noxref_5_c_575_n ) capacitor c=0.00163916f //x=5.93 \
 //y=0.63 //x2=4.56 //y2=0.805
cc_307 ( N_GND_c_348_n N_noxref_5_c_575_n ) capacitor c=0.0383696f //x=5.3 \
 //y=0.175 //x2=4.56 //y2=0.805
cc_308 ( N_GND_c_356_n N_noxref_5_c_575_n ) capacitor c=0.0013725f //x=6.9 \
 //y=0.175 //x2=4.56 //y2=0.805
cc_309 ( N_GND_c_334_n N_noxref_5_M1_noxref_d ) capacitor c=0.0134285f \
 //x=6.78 //y=0.18 //x2=2.35 //y2=1.09
cc_310 ( N_GND_c_369_n N_noxref_5_M1_noxref_d ) capacitor c=0.0156367f \
 //x=1.565 //y=1.145 //x2=2.35 //y2=1.09
cc_311 ( N_GND_c_356_n N_noxref_5_M1_noxref_d ) capacitor c=2.7648e-19 //x=6.9 \
 //y=0.175 //x2=2.35 //y2=1.09
cc_312 ( N_GND_M0_noxref_d N_noxref_5_M1_noxref_d ) capacitor c=3.12752e-19 \
 //x=1.375 //y=1.055 //x2=2.35 //y2=1.09
cc_313 ( N_GND_c_370_n N_noxref_5_M2_noxref_s ) capacitor c=8.16352e-19 \
 //x=1.23 //y=0.18 //x2=3.455 //y2=0.555
cc_314 ( N_GND_c_348_n N_noxref_5_M2_noxref_s ) capacitor c=0.00513825f \
 //x=5.3 //y=0.175 //x2=3.455 //y2=0.555
cc_315 ( N_GND_M3_noxref_s N_noxref_5_M2_noxref_s ) capacitor c=0.00266775f \
 //x=5.795 //y=0.55 //x2=3.455 //y2=0.555
cc_316 ( N_GND_c_334_n N_B_c_641_n ) capacitor c=9.16602e-19 //x=6.78 //y=0.18 \
 //x2=2.71 //y2=2.375
cc_317 ( N_GND_c_334_n N_C_c_743_n ) capacitor c=0.0021992f //x=6.78 //y=0.18 \
 //x2=3.82 //y2=2.375
cc_318 ( N_GND_c_341_n N_C_c_743_n ) capacitor c=2.016e-19 //x=5.13 //y=0.175 \
 //x2=3.82 //y2=2.375
cc_319 ( N_GND_c_348_n N_C_c_748_n ) capacitor c=0.00246191f //x=5.3 //y=0.175 \
 //x2=3.82 //y2=2.26
cc_320 ( N_GND_c_348_n N_C_c_773_n ) capacitor c=0.00262688f //x=5.3 //y=0.175 \
 //x2=4.34 //y2=1.44
cc_321 ( N_GND_c_348_n N_Y_c_849_n ) capacitor c=0.00290989f //x=5.3 //y=0.175 \
 //x2=6.41 //y2=1.935
cc_322 ( N_GND_c_356_n N_Y_c_849_n ) capacitor c=0.00122336f //x=6.9 //y=0.175 \
 //x2=6.41 //y2=1.935
cc_323 ( N_GND_M3_noxref_s N_Y_c_849_n ) capacitor c=0.0325932f //x=5.795 \
 //y=0.55 //x2=6.41 //y2=1.935
cc_324 ( N_GND_c_334_n N_Y_c_860_n ) capacitor c=0.00497604f //x=6.78 //y=0.18 \
 //x2=6.695 //y2=2.02
cc_325 ( N_GND_c_347_n N_Y_c_860_n ) capacitor c=0.00321695f //x=6.815 \
 //y=0.715 //x2=6.695 //y2=2.02
cc_326 ( N_GND_c_356_n N_Y_c_860_n ) capacitor c=0.030726f //x=6.9 //y=0.175 \
 //x2=6.695 //y2=2.02
cc_327 ( N_GND_M3_noxref_s N_Y_c_860_n ) capacitor c=0.00565821f //x=5.795 \
 //y=0.55 //x2=6.695 //y2=2.02
cc_328 ( N_GND_c_334_n N_Y_c_867_n ) capacitor c=0.00998676f //x=6.78 //y=0.18 \
 //x2=6.41 //y2=1.185
cc_329 ( N_GND_c_343_n N_Y_c_867_n ) capacitor c=0.00124813f //x=6.325 \
 //y=0.715 //x2=6.41 //y2=1.185
cc_330 ( N_GND_c_347_n N_Y_c_867_n ) capacitor c=0.00130539f //x=6.815 \
 //y=0.715 //x2=6.41 //y2=1.185
cc_331 ( N_GND_c_356_n N_Y_c_867_n ) capacitor c=2.8029e-19 //x=6.9 //y=0.175 \
 //x2=6.41 //y2=1.185
cc_332 ( N_GND_M3_noxref_s N_Y_c_867_n ) capacitor c=0.0157008f //x=5.795 \
 //y=0.55 //x2=6.41 //y2=1.185
cc_333 ( N_GND_c_334_n N_Y_M3_noxref_d ) capacitor c=0.00119455f //x=6.78 \
 //y=0.18 //x2=6.225 //y2=1.09
cc_334 ( N_GND_c_356_n N_Y_M3_noxref_d ) capacitor c=2.70835e-19 //x=6.9 \
 //y=0.175 //x2=6.225 //y2=1.09
cc_335 ( N_GND_M3_noxref_s N_Y_M3_noxref_d ) capacitor c=0.0377642f //x=5.795 \
 //y=0.55 //x2=6.225 //y2=1.09
cc_336 ( N_GND_c_439_p N_noxref_9_c_915_n ) capacitor c=0.00293992f //x=1.48 \
 //y=0.175 //x2=1.965 //y2=1.77
cc_337 ( N_GND_c_334_n N_noxref_9_c_915_n ) capacitor c=0.00196056f //x=6.78 \
 //y=0.18 //x2=1.965 //y2=1.77
cc_338 ( N_GND_c_369_n N_noxref_9_c_915_n ) capacitor c=0.00388652f //x=1.565 \
 //y=1.145 //x2=1.965 //y2=1.77
cc_339 ( N_GND_c_341_n N_noxref_9_c_915_n ) capacitor c=0.00396777f //x=5.13 \
 //y=0.175 //x2=1.965 //y2=1.77
cc_340 ( N_GND_M0_noxref_d N_noxref_9_c_915_n ) capacitor c=0.00578031f \
 //x=1.375 //y=1.055 //x2=1.965 //y2=1.77
cc_341 ( N_GND_c_379_p N_noxref_9_c_920_n ) capacitor c=0.0169052f //x=1.565 \
 //y=1.015 //x2=2.05 //y2=0.805
cc_342 ( N_GND_c_334_n N_noxref_9_c_920_n ) capacitor c=0.00710913f //x=6.78 \
 //y=0.18 //x2=2.05 //y2=0.805
cc_343 ( N_GND_c_341_n N_noxref_9_c_920_n ) capacitor c=0.0140604f //x=5.13 \
 //y=0.175 //x2=2.05 //y2=0.805
cc_344 ( N_GND_c_370_n N_noxref_9_c_920_n ) capacitor c=0.00323118f //x=1.23 \
 //y=0.18 //x2=2.05 //y2=0.805
cc_345 ( N_GND_c_356_n N_noxref_9_c_920_n ) capacitor c=0.00138062f //x=6.9 \
 //y=0.175 //x2=2.05 //y2=0.805
cc_346 ( N_GND_c_334_n N_noxref_9_c_925_n ) capacitor c=0.0140761f //x=6.78 \
 //y=0.18 //x2=2.935 //y2=0.72
cc_347 ( N_GND_c_341_n N_noxref_9_c_925_n ) capacitor c=0.0356451f //x=5.13 \
 //y=0.175 //x2=2.935 //y2=0.72
cc_348 ( N_GND_c_356_n N_noxref_9_c_925_n ) capacitor c=0.00264707f //x=6.9 \
 //y=0.175 //x2=2.935 //y2=0.72
cc_349 ( N_GND_c_439_p N_noxref_9_M0_noxref_s ) capacitor c=0.00710913f \
 //x=1.48 //y=0.175 //x2=0.945 //y2=0.555
cc_350 ( N_GND_c_379_p N_noxref_9_M0_noxref_s ) capacitor c=0.0173062f \
 //x=1.565 //y=1.015 //x2=0.945 //y2=0.555
cc_351 ( N_GND_c_334_n N_noxref_9_M0_noxref_s ) capacitor c=0.00683407f \
 //x=6.78 //y=0.18 //x2=0.945 //y2=0.555
cc_352 ( N_GND_c_369_n N_noxref_9_M0_noxref_s ) capacitor c=0.0113024f \
 //x=1.565 //y=1.145 //x2=0.945 //y2=0.555
cc_353 ( N_GND_c_341_n N_noxref_9_M0_noxref_s ) capacitor c=0.0272246f \
 //x=5.13 //y=0.175 //x2=0.945 //y2=0.555
cc_354 ( N_GND_c_370_n N_noxref_9_M0_noxref_s ) capacitor c=0.0675506f \
 //x=1.23 //y=0.18 //x2=0.945 //y2=0.555
cc_355 ( N_GND_c_348_n N_noxref_9_M0_noxref_s ) capacitor c=0.00136136f \
 //x=5.3 //y=0.175 //x2=0.945 //y2=0.555
cc_356 ( N_GND_c_356_n N_noxref_9_M0_noxref_s ) capacitor c=0.00272322f \
 //x=6.9 //y=0.175 //x2=0.945 //y2=0.555
cc_357 ( N_GND_M0_noxref_d N_noxref_9_M0_noxref_s ) capacitor c=0.0271316f \
 //x=1.375 //y=1.055 //x2=0.945 //y2=0.555
cc_358 ( A B ) capacitor c=0.0763092f //x=1.6 //y=2.4 //x2=2.71 //y2=2.4
cc_359 ( N_A_c_469_n B ) capacitor c=4.22428e-19 //x=1.6 //y=4.755 //x2=2.71 \
 //y2=2.4
cc_360 ( N_A_c_483_n B ) capacitor c=4.16726e-19 //x=1.6 //y=2.26 //x2=2.71 \
 //y2=2.4
cc_361 ( N_A_c_471_n B ) capacitor c=3.36194e-19 //x=1.6 //y=4.88 //x2=2.71 \
 //y2=2.4
cc_362 ( N_A_c_480_n N_B_c_641_n ) capacitor c=0.0115546f //x=1.6 //y=2.375 \
 //x2=2.71 //y2=2.375
cc_363 ( N_A_c_483_n N_B_c_641_n ) capacitor c=5.40058e-19 //x=1.6 //y=2.26 \
 //x2=2.71 //y2=2.375
cc_364 ( N_A_c_493_n N_B_c_641_n ) capacitor c=0.00147006f //x=1.3 //y=2.095 \
 //x2=2.71 //y2=2.375
cc_365 ( N_A_c_469_n N_B_c_623_n ) capacitor c=0.0110307f //x=1.6 //y=4.755 \
 //x2=2.71 //y2=4.765
cc_366 ( N_A_c_471_n N_B_c_623_n ) capacitor c=2.89813e-19 //x=1.6 //y=4.88 \
 //x2=2.71 //y2=4.765
cc_367 ( N_A_c_466_n N_B_c_623_n ) capacitor c=7.66769e-19 //x=2.165 //y=4.97 \
 //x2=2.71 //y2=4.765
cc_368 ( N_A_c_477_n N_B_c_623_n ) capacitor c=7.54501e-19 //x=1.875 //y=4.97 \
 //x2=2.71 //y2=4.765
cc_369 ( A N_B_c_653_n ) capacitor c=4.16726e-19 //x=1.6 //y=2.4 //x2=2.71 \
 //y2=2.26
cc_370 ( N_A_c_480_n N_B_c_653_n ) capacitor c=0.00375644f //x=1.6 //y=2.375 \
 //x2=2.71 //y2=2.26
cc_371 ( N_A_c_483_n N_B_c_653_n ) capacitor c=0.00125213f //x=1.6 //y=2.26 \
 //x2=2.71 //y2=2.26
cc_372 ( N_A_c_493_n N_B_c_653_n ) capacitor c=0.00214573f //x=1.3 //y=2.095 \
 //x2=2.71 //y2=2.26
cc_373 ( A N_B_c_626_n ) capacitor c=3.30718e-19 //x=1.6 //y=2.4 //x2=2.71 \
 //y2=4.88
cc_374 ( N_A_c_469_n N_B_c_626_n ) capacitor c=0.0037876f //x=1.6 //y=4.755 \
 //x2=2.71 //y2=4.88
cc_375 ( N_A_c_471_n N_B_c_626_n ) capacitor c=0.00113984f //x=1.6 //y=4.88 \
 //x2=2.71 //y2=4.88
cc_376 ( N_A_c_466_n N_B_c_626_n ) capacitor c=0.00116563f //x=2.165 //y=4.97 \
 //x2=2.71 //y2=4.88
cc_377 ( N_A_c_477_n N_B_c_626_n ) capacitor c=0.00129812f //x=1.875 //y=4.97 \
 //x2=2.71 //y2=4.88
cc_378 ( N_A_M4_noxref_g N_B_M6_noxref_g ) capacitor c=0.0106276f //x=1.8 \
 //y=6.2 //x2=2.68 //y2=6.2
cc_379 ( N_A_M5_noxref_g N_B_M6_noxref_g ) capacitor c=0.107144f //x=2.24 \
 //y=6.2 //x2=2.68 //y2=6.2
cc_380 ( N_A_M5_noxref_g N_B_M7_noxref_g ) capacitor c=0.0101598f //x=2.24 \
 //y=6.2 //x2=3.12 //y2=6.2
cc_381 ( N_A_c_485_n N_B_c_665_n ) capacitor c=5.72528e-19 //x=1.3 //y=1.055 \
 //x2=2.275 //y2=1.09
cc_382 ( N_A_c_489_n N_B_c_665_n ) capacitor c=0.00150277f //x=1.3 //y=1.4 \
 //x2=2.275 //y2=1.09
cc_383 ( N_A_c_499_n N_B_c_665_n ) capacitor c=0.0160123f //x=1.83 //y=1.055 \
 //x2=2.275 //y2=1.09
cc_384 ( N_A_c_491_n N_B_c_668_n ) capacitor c=0.00111227f //x=1.3 //y=1.71 \
 //x2=2.275 //y2=1.4
cc_385 ( N_A_c_502_n N_B_c_668_n ) capacitor c=0.0124075f //x=1.83 //y=1.4 \
 //x2=2.275 //y2=1.4
cc_386 ( N_A_c_499_n N_B_c_670_n ) capacitor c=9.19165e-19 //x=1.83 //y=1.055 \
 //x2=2.8 //y2=1.09
cc_387 ( N_A_c_502_n N_B_c_671_n ) capacitor c=0.0010154f //x=1.83 //y=1.4 \
 //x2=2.8 //y2=1.4
cc_388 ( N_A_c_502_n N_B_c_672_n ) capacitor c=9.23422e-19 //x=1.83 //y=1.4 \
 //x2=2.8 //y2=1.63
cc_389 ( N_A_c_480_n N_B_c_673_n ) capacitor c=0.00140534f //x=1.6 //y=2.375 \
 //x2=2.8 //y2=2.095
cc_390 ( N_A_c_483_n N_B_c_673_n ) capacitor c=0.0020754f //x=1.6 //y=2.26 \
 //x2=2.8 //y2=2.095
cc_391 ( N_A_c_493_n N_B_c_673_n ) capacitor c=0.00964411f //x=1.3 //y=2.095 \
 //x2=2.8 //y2=2.095
cc_392 ( N_A_c_469_n N_B_c_636_n ) capacitor c=0.00116212f //x=1.6 //y=4.755 \
 //x2=2.71 //y2=4.88
cc_393 ( N_A_c_471_n N_B_c_636_n ) capacitor c=0.00155973f //x=1.6 //y=4.88 \
 //x2=2.71 //y2=4.88
cc_394 ( N_A_c_466_n N_B_c_636_n ) capacitor c=0.0171374f //x=2.165 //y=4.97 \
 //x2=2.71 //y2=4.88
cc_395 ( N_A_c_477_n N_B_c_636_n ) capacitor c=0.00484466f //x=1.875 //y=4.97 \
 //x2=2.71 //y2=4.88
cc_396 ( A C ) capacitor c=0.00357941f //x=1.6 //y=2.4 //x2=3.82 //y2=2.4
cc_397 ( N_A_c_493_n N_noxref_9_c_937_n ) capacitor c=0.00267608f //x=1.3 \
 //y=2.095 //x2=1.08 //y2=1.685
cc_398 ( N_A_c_480_n N_noxref_9_c_915_n ) capacitor c=0.00411069f //x=1.6 \
 //y=2.375 //x2=1.965 //y2=1.77
cc_399 ( N_A_c_469_n N_noxref_9_c_915_n ) capacitor c=2.27025e-19 //x=1.6 \
 //y=4.755 //x2=1.965 //y2=1.77
cc_400 ( N_A_c_483_n N_noxref_9_c_915_n ) capacitor c=0.0104666f //x=1.6 \
 //y=2.26 //x2=1.965 //y2=1.77
cc_401 ( N_A_c_491_n N_noxref_9_c_915_n ) capacitor c=0.00703864f //x=1.3 \
 //y=1.71 //x2=1.965 //y2=1.77
cc_402 ( N_A_c_493_n N_noxref_9_c_915_n ) capacitor c=0.0234088f //x=1.3 \
 //y=2.095 //x2=1.965 //y2=1.77
cc_403 ( N_A_c_497_n N_noxref_9_c_915_n ) capacitor c=0.00588627f //x=1.675 \
 //y=1.555 //x2=1.965 //y2=1.77
cc_404 ( N_A_c_502_n N_noxref_9_c_915_n ) capacitor c=0.00698822f //x=1.83 \
 //y=1.4 //x2=1.965 //y2=1.77
cc_405 ( N_A_c_485_n N_noxref_9_M0_noxref_s ) capacitor c=0.0295256f //x=1.3 \
 //y=1.055 //x2=0.945 //y2=0.555
cc_406 ( N_A_c_491_n N_noxref_9_M0_noxref_s ) capacitor c=7.99997e-19 //x=1.3 \
 //y=1.71 //x2=0.945 //y2=0.555
cc_407 ( N_A_c_493_n N_noxref_9_M0_noxref_s ) capacitor c=0.00122123f //x=1.3 \
 //y=2.095 //x2=0.945 //y2=0.555
cc_408 ( N_A_c_499_n N_noxref_9_M0_noxref_s ) capacitor c=0.0125924f //x=1.83 \
 //y=1.055 //x2=0.945 //y2=0.555
cc_409 ( N_noxref_5_M1_noxref_d N_B_c_641_n ) capacitor c=0.00610736f //x=2.35 \
 //y=1.09 //x2=2.71 //y2=2.375
cc_410 ( N_noxref_5_M1_noxref_d N_B_c_653_n ) capacitor c=2.2052e-19 //x=2.35 \
 //y=1.09 //x2=2.71 //y2=2.26
cc_411 ( N_noxref_5_M1_noxref_d N_B_c_665_n ) capacitor c=0.00253592f //x=2.35 \
 //y=1.09 //x2=2.275 //y2=1.09
cc_412 ( N_noxref_5_M1_noxref_d N_B_c_668_n ) capacitor c=0.00604634f //x=2.35 \
 //y=1.09 //x2=2.275 //y2=1.4
cc_413 ( N_noxref_5_M1_noxref_d N_B_c_684_n ) capacitor c=0.002686f //x=2.35 \
 //y=1.09 //x2=2.645 //y2=0.935
cc_414 ( N_noxref_5_M1_noxref_d N_B_c_685_n ) capacitor c=0.00251995f //x=2.35 \
 //y=1.09 //x2=2.645 //y2=1.555
cc_415 ( N_noxref_5_c_566_n N_B_c_670_n ) capacitor c=0.00123426f //x=3.505 \
 //y=1.175 //x2=2.8 //y2=1.09
cc_416 ( N_noxref_5_M1_noxref_d N_B_c_670_n ) capacitor c=0.00314523f //x=2.35 \
 //y=1.09 //x2=2.8 //y2=1.09
cc_417 ( N_noxref_5_M2_noxref_s N_B_c_670_n ) capacitor c=7.21316e-19 \
 //x=3.455 //y=0.555 //x2=2.8 //y2=1.09
cc_418 ( N_noxref_5_c_566_n N_B_c_671_n ) capacitor c=0.0129288f //x=3.505 \
 //y=1.175 //x2=2.8 //y2=1.4
cc_419 ( N_noxref_5_M1_noxref_d N_B_c_671_n ) capacitor c=0.00168289f //x=2.35 \
 //y=1.09 //x2=2.8 //y2=1.4
cc_420 ( N_noxref_5_M2_noxref_s N_B_c_671_n ) capacitor c=0.00365271f \
 //x=3.455 //y=0.555 //x2=2.8 //y2=1.4
cc_421 ( N_noxref_5_c_566_n N_B_c_672_n ) capacitor c=0.00132209f //x=3.505 \
 //y=1.175 //x2=2.8 //y2=1.63
cc_422 ( N_noxref_5_M1_noxref_d N_B_c_672_n ) capacitor c=0.00111165f //x=2.35 \
 //y=1.09 //x2=2.8 //y2=1.63
cc_423 ( N_noxref_5_M2_noxref_s N_B_c_673_n ) capacitor c=9.86711e-19 \
 //x=3.455 //y=0.555 //x2=2.8 //y2=2.095
cc_424 ( N_noxref_5_c_555_n N_C_c_743_n ) capacitor c=0.00171317f //x=4.475 \
 //y=0.72 //x2=3.82 //y2=2.375
cc_425 ( N_noxref_5_c_555_n N_C_c_748_n ) capacitor c=0.00117306f //x=4.475 \
 //y=0.72 //x2=3.82 //y2=2.26
cc_426 ( N_noxref_5_c_555_n N_C_c_759_n ) capacitor c=0.0205874f //x=4.475 \
 //y=0.72 //x2=3.81 //y2=1.095
cc_427 ( N_noxref_5_M2_noxref_s N_C_c_759_n ) capacitor c=0.0071177f //x=3.455 \
 //y=0.555 //x2=3.81 //y2=1.095
cc_428 ( N_noxref_5_c_558_n N_C_c_761_n ) capacitor c=0.0071177f //x=3.59 \
 //y=1.175 //x2=3.81 //y2=1.44
cc_429 ( N_noxref_5_M2_noxref_s N_C_c_764_n ) capacitor c=0.0071177f //x=3.455 \
 //y=0.555 //x2=3.81 //y2=1.75
cc_430 ( N_noxref_5_c_555_n N_C_c_771_n ) capacitor c=0.00825432f //x=4.475 \
 //y=0.72 //x2=4.34 //y2=1.095
cc_431 ( N_noxref_5_M2_noxref_s N_C_c_771_n ) capacitor c=0.015333f //x=3.455 \
 //y=0.555 //x2=4.34 //y2=1.095
cc_432 ( N_noxref_5_M2_noxref_s N_C_c_773_n ) capacitor c=0.00248746f \
 //x=3.455 //y=0.555 //x2=4.34 //y2=1.44
cc_433 ( N_noxref_5_c_555_n N_C_c_777_n ) capacitor c=2.20712e-19 //x=4.475 \
 //y=0.72 //x2=3.82 //y2=2.26
cc_434 ( N_noxref_5_c_569_n N_noxref_9_c_920_n ) capacitor c=2.15937e-19 \
 //x=3.59 //y=0.805 //x2=2.05 //y2=0.805
cc_435 ( N_noxref_5_c_566_n N_noxref_9_c_925_n ) capacitor c=0.0132582f \
 //x=3.505 //y=1.175 //x2=2.935 //y2=0.72
cc_436 ( N_noxref_5_M1_noxref_d N_noxref_9_c_925_n ) capacitor c=0.016458f \
 //x=2.35 //y=1.09 //x2=2.935 //y2=0.72
cc_437 ( N_noxref_5_c_566_n N_noxref_9_c_952_n ) capacitor c=0.00954209f \
 //x=3.505 //y=1.175 //x2=2.935 //y2=1.77
cc_438 ( N_noxref_5_M1_noxref_d N_noxref_9_c_952_n ) capacitor c=0.0152939f \
 //x=2.35 //y=1.09 //x2=2.935 //y2=1.77
cc_439 ( N_noxref_5_c_566_n N_noxref_9_M0_noxref_s ) capacitor c=0.023368f \
 //x=3.505 //y=1.175 //x2=0.945 //y2=0.555
cc_440 ( N_noxref_5_c_569_n N_noxref_9_M0_noxref_s ) capacitor c=0.0182125f \
 //x=3.59 //y=0.805 //x2=0.945 //y2=0.555
cc_441 ( N_noxref_5_M1_noxref_d N_noxref_9_M0_noxref_s ) capacitor \
 c=0.0187969f //x=2.35 //y=1.09 //x2=0.945 //y2=0.555
cc_442 ( N_noxref_5_M2_noxref_s N_noxref_9_M0_noxref_s ) capacitor \
 c=0.0209954f //x=3.455 //y=0.555 //x2=0.945 //y2=0.555
cc_443 ( B C ) capacitor c=0.0718143f //x=2.71 //y=2.4 //x2=3.82 //y2=2.4
cc_444 ( N_B_c_653_n C ) capacitor c=4.16726e-19 //x=2.71 //y=2.26 //x2=3.82 \
 //y2=2.4
cc_445 ( N_B_c_626_n C ) capacitor c=2.8902e-19 //x=2.71 //y=4.88 //x2=3.82 \
 //y2=2.4
cc_446 ( N_B_c_641_n N_C_c_743_n ) capacitor c=0.0116288f //x=2.71 //y=2.375 \
 //x2=3.82 //y2=2.375
cc_447 ( N_B_c_653_n N_C_c_743_n ) capacitor c=5.39999e-19 //x=2.71 //y=2.26 \
 //x2=3.82 //y2=2.375
cc_448 ( N_B_c_673_n N_C_c_743_n ) capacitor c=0.00141236f //x=2.8 //y=2.095 \
 //x2=3.82 //y2=2.375
cc_449 ( B N_C_c_744_n ) capacitor c=6.3306e-19 //x=2.71 //y=2.4 //x2=3.82 \
 //y2=4.75
cc_450 ( N_B_c_623_n N_C_c_744_n ) capacitor c=0.0107551f //x=2.71 //y=4.765 \
 //x2=3.82 //y2=4.75
cc_451 ( N_B_c_626_n N_C_c_744_n ) capacitor c=6.63375e-19 //x=2.71 //y=4.88 \
 //x2=3.82 //y2=4.75
cc_452 ( N_B_c_636_n N_C_c_744_n ) capacitor c=8.42568e-19 //x=2.71 //y=4.88 \
 //x2=3.82 //y2=4.75
cc_453 ( B N_C_c_748_n ) capacitor c=4.16726e-19 //x=2.71 //y=2.4 //x2=3.82 \
 //y2=2.26
cc_454 ( N_B_c_641_n N_C_c_748_n ) capacitor c=5.42289e-19 //x=2.71 //y=2.375 \
 //x2=3.82 //y2=2.26
cc_455 ( N_B_c_653_n N_C_c_748_n ) capacitor c=0.00125213f //x=2.71 //y=2.26 \
 //x2=3.82 //y2=2.26
cc_456 ( N_B_c_673_n N_C_c_748_n ) capacitor c=0.00209664f //x=2.8 //y=2.095 \
 //x2=3.82 //y2=2.26
cc_457 ( B N_C_c_749_n ) capacitor c=2.94497e-19 //x=2.71 //y=2.4 //x2=3.82 \
 //y2=4.88
cc_458 ( N_B_c_623_n N_C_c_749_n ) capacitor c=4.56604e-19 //x=2.71 //y=4.765 \
 //x2=3.82 //y2=4.88
cc_459 ( N_B_c_626_n N_C_c_749_n ) capacitor c=0.00113985f //x=2.71 //y=4.88 \
 //x2=3.82 //y2=4.88
cc_460 ( N_B_c_636_n N_C_c_749_n ) capacitor c=0.00129812f //x=2.71 //y=4.88 \
 //x2=3.82 //y2=4.88
cc_461 ( N_B_M6_noxref_g N_C_M8_noxref_g ) capacitor c=0.0101598f //x=2.68 \
 //y=6.2 //x2=3.56 //y2=6.2
cc_462 ( N_B_M7_noxref_g N_C_M8_noxref_g ) capacitor c=0.0607518f //x=3.12 \
 //y=6.2 //x2=3.56 //y2=6.2
cc_463 ( N_B_M7_noxref_g N_C_M9_noxref_g ) capacitor c=0.0101598f //x=3.12 \
 //y=6.2 //x2=4 //y2=6.2
cc_464 ( N_B_c_670_n N_C_c_759_n ) capacitor c=0.00456962f //x=2.8 //y=1.09 \
 //x2=3.81 //y2=1.095
cc_465 ( N_B_c_671_n N_C_c_761_n ) capacitor c=0.00438372f //x=2.8 //y=1.4 \
 //x2=3.81 //y2=1.44
cc_466 ( N_B_c_672_n N_C_c_764_n ) capacitor c=0.00438372f //x=2.8 //y=1.63 \
 //x2=3.81 //y2=1.75
cc_467 ( N_B_c_641_n N_C_c_777_n ) capacitor c=0.00139071f //x=2.71 //y=2.375 \
 //x2=3.82 //y2=2.26
cc_468 ( N_B_c_653_n N_C_c_777_n ) capacitor c=0.00204868f //x=2.71 //y=2.26 \
 //x2=3.82 //y2=2.26
cc_469 ( N_B_c_673_n N_C_c_777_n ) capacitor c=0.00933826f //x=2.8 //y=2.095 \
 //x2=3.82 //y2=2.26
cc_470 ( N_B_c_673_n N_C_c_778_n ) capacitor c=0.00438372f //x=2.8 //y=2.095 \
 //x2=3.82 //y2=2.095
cc_471 ( N_B_c_623_n N_C_c_780_n ) capacitor c=0.00124604f //x=2.71 //y=4.765 \
 //x2=3.82 //y2=4.88
cc_472 ( N_B_c_626_n N_C_c_780_n ) capacitor c=0.00187046f //x=2.71 //y=4.88 \
 //x2=3.82 //y2=4.88
cc_473 ( N_B_c_634_n N_C_c_780_n ) capacitor c=0.0616777f //x=3.045 //y=4.97 \
 //x2=3.82 //y2=4.88
cc_474 ( N_B_c_636_n N_C_c_780_n ) capacitor c=0.00487508f //x=2.71 //y=4.88 \
 //x2=3.82 //y2=4.88
cc_475 ( N_B_c_665_n N_noxref_9_c_925_n ) capacitor c=0.0167228f //x=2.275 \
 //y=1.09 //x2=2.935 //y2=0.72
cc_476 ( N_B_c_670_n N_noxref_9_c_925_n ) capacitor c=0.00534519f //x=2.8 \
 //y=1.09 //x2=2.935 //y2=0.72
cc_477 ( N_B_c_641_n N_noxref_9_c_952_n ) capacitor c=0.0048147f //x=2.71 \
 //y=2.375 //x2=2.935 //y2=1.77
cc_478 ( N_B_c_653_n N_noxref_9_c_952_n ) capacitor c=0.0105652f //x=2.71 \
 //y=2.26 //x2=2.935 //y2=1.77
cc_479 ( N_B_c_668_n N_noxref_9_c_952_n ) capacitor c=0.0153476f //x=2.275 \
 //y=1.4 //x2=2.935 //y2=1.77
cc_480 ( N_B_c_673_n N_noxref_9_c_952_n ) capacitor c=0.0206484f //x=2.8 \
 //y=2.095 //x2=2.935 //y2=1.77
cc_481 ( N_B_c_665_n N_noxref_9_M0_noxref_s ) capacitor c=0.00798959f \
 //x=2.275 //y=1.09 //x2=0.945 //y2=0.555
cc_482 ( N_B_c_672_n N_noxref_9_M0_noxref_s ) capacitor c=0.00212176f //x=2.8 \
 //y=1.63 //x2=0.945 //y2=0.555
cc_483 ( N_B_c_673_n N_noxref_9_M0_noxref_s ) capacitor c=0.00298115f //x=2.8 \
 //y=2.095 //x2=0.945 //y2=0.555
