// File: AND3X1.spi.AND3X1.pxi
// Created: Tue Apr 29 10:38:10 2025
//
simulator lang=spectre
x_PM_AND3X1\%GND ( GND N_GND_c_4_p N_GND_c_31_p N_GND_c_1_p N_GND_c_5_p \
 N_GND_c_6_p N_GND_c_73_p N_GND_c_7_p N_GND_c_22_p N_GND_c_2_p N_GND_c_3_p \
 N_GND_M0_noxref_d N_GND_M3_noxref_s )  PM_AND3X1\%GND
x_PM_AND3X1\%VDD ( VDD N_VDD_c_92_p N_VDD_c_89_n N_VDD_c_97_p N_VDD_c_98_p \
 N_VDD_c_104_p N_VDD_c_108_p N_VDD_c_115_p N_VDD_c_90_n N_VDD_c_91_n \
 N_VDD_M4_noxref_s N_VDD_M5_noxref_d N_VDD_M7_noxref_d N_VDD_M9_noxref_d \
 N_VDD_M10_noxref_s N_VDD_M11_noxref_d )  PM_AND3X1\%VDD
x_PM_AND3X1\%noxref_3 ( N_noxref_3_c_172_n N_noxref_3_c_178_n \
 N_noxref_3_c_202_n N_noxref_3_c_206_n N_noxref_3_c_208_n N_noxref_3_c_212_n \
 N_noxref_3_c_179_n N_noxref_3_c_285_p N_noxref_3_c_216_n N_noxref_3_c_181_n \
 N_noxref_3_c_257_p N_noxref_3_c_263_p N_noxref_3_M3_noxref_g \
 N_noxref_3_M10_noxref_g N_noxref_3_M11_noxref_g N_noxref_3_c_186_n \
 N_noxref_3_c_301_p N_noxref_3_c_302_p N_noxref_3_c_188_n N_noxref_3_c_226_n \
 N_noxref_3_c_227_n N_noxref_3_c_189_n N_noxref_3_c_293_p N_noxref_3_c_190_n \
 N_noxref_3_c_192_n N_noxref_3_c_193_n N_noxref_3_M2_noxref_d \
 N_noxref_3_M4_noxref_d N_noxref_3_M6_noxref_d N_noxref_3_M8_noxref_d )  \
 PM_AND3X1\%noxref_3
x_PM_AND3X1\%A ( A A A A A A A N_A_c_313_n N_A_M0_noxref_g N_A_M4_noxref_g \
 N_A_M5_noxref_g N_A_c_314_n N_A_c_316_n N_A_c_317_n N_A_c_318_n N_A_c_319_n \
 N_A_c_320_n N_A_c_321_n N_A_c_323_n N_A_c_336_n N_A_c_331_n )  PM_AND3X1\%A
x_PM_AND3X1\%B ( B B B B B B B N_B_c_368_n N_B_M1_noxref_g N_B_M6_noxref_g \
 N_B_M7_noxref_g N_B_c_390_n N_B_c_393_n N_B_c_426_p N_B_c_433_p N_B_c_395_n \
 N_B_c_396_n N_B_c_397_n N_B_c_398_n N_B_c_381_n N_B_c_382_n )  PM_AND3X1\%B
x_PM_AND3X1\%noxref_6 ( N_noxref_6_c_457_n N_noxref_6_c_438_n \
 N_noxref_6_c_442_n N_noxref_6_c_446_n N_noxref_6_c_469_n \
 N_noxref_6_M0_noxref_s )  PM_AND3X1\%noxref_6
x_PM_AND3X1\%C ( C C C C C C C N_C_c_483_n N_C_M2_noxref_g N_C_M8_noxref_g \
 N_C_M9_noxref_g N_C_c_497_n N_C_c_498_n N_C_c_499_n N_C_c_500_n N_C_c_501_n \
 N_C_c_503_n N_C_c_504_n N_C_c_506_n N_C_c_507_n N_C_c_509_n )  PM_AND3X1\%C
x_PM_AND3X1\%noxref_8 ( N_noxref_8_c_537_n N_noxref_8_c_540_n \
 N_noxref_8_c_544_n N_noxref_8_c_547_n N_noxref_8_c_558_n \
 N_noxref_8_M1_noxref_d N_noxref_8_M2_noxref_s )  PM_AND3X1\%noxref_8
x_PM_AND3X1\%Y ( Y Y Y Y Y Y Y N_Y_c_592_n N_Y_c_616_n N_Y_c_602_n N_Y_c_605_n \
 N_Y_M3_noxref_d N_Y_M10_noxref_d )  PM_AND3X1\%Y
cc_1 ( N_GND_c_1_p N_VDD_c_89_n ) capacitor c=0.00989514f //x=1.23 //y=0.18 \
 //x2=1.23 //y2=7.58
cc_2 ( N_GND_c_2_p N_VDD_c_90_n ) capacitor c=0.00856126f //x=5.3 //y=0.175 \
 //x2=5.3 //y2=7.585
cc_3 ( N_GND_c_3_p N_VDD_c_91_n ) capacitor c=0.00989514f //x=6.9 //y=0.175 \
 //x2=6.78 //y2=7.58
cc_4 ( N_GND_c_4_p N_noxref_3_c_172_n ) capacitor c=0.0116406f //x=6.78 \
 //y=0.18 //x2=5.925 //y2=3.51
cc_5 ( N_GND_c_5_p N_noxref_3_c_172_n ) capacitor c=0.00162234f //x=5.13 \
 //y=0.175 //x2=5.925 //y2=3.51
cc_6 ( N_GND_c_6_p N_noxref_3_c_172_n ) capacitor c=0.00110287f //x=5.845 \
 //y=0.175 //x2=5.925 //y2=3.51
cc_7 ( N_GND_c_7_p N_noxref_3_c_172_n ) capacitor c=2.76195e-19 //x=6.33 \
 //y=0.715 //x2=5.925 //y2=3.51
cc_8 ( N_GND_c_2_p N_noxref_3_c_172_n ) capacitor c=0.00820859f //x=5.3 \
 //y=0.175 //x2=5.925 //y2=3.51
cc_9 ( N_GND_M3_noxref_s N_noxref_3_c_172_n ) capacitor c=0.00164589f \
 //x=5.795 //y=0.55 //x2=5.925 //y2=3.51
cc_10 ( N_GND_c_4_p N_noxref_3_c_178_n ) capacitor c=0.00177317f //x=6.78 \
 //y=0.18 //x2=4.675 //y2=3.51
cc_11 ( N_GND_c_2_p N_noxref_3_c_179_n ) capacitor c=0.0458509f //x=5.3 \
 //y=0.175 //x2=4.475 //y2=1.845
cc_12 ( N_GND_M3_noxref_s N_noxref_3_c_179_n ) capacitor c=3.19788e-19 \
 //x=5.795 //y=0.55 //x2=4.475 //y2=1.845
cc_13 ( N_GND_c_4_p N_noxref_3_c_181_n ) capacitor c=0.00184912f //x=6.78 \
 //y=0.18 //x2=6.04 //y2=2.265
cc_14 ( N_GND_c_7_p N_noxref_3_c_181_n ) capacitor c=7.87839e-19 //x=6.33 \
 //y=0.715 //x2=6.04 //y2=2.265
cc_15 ( N_GND_c_2_p N_noxref_3_c_181_n ) capacitor c=0.029021f //x=5.3 \
 //y=0.175 //x2=6.04 //y2=2.265
cc_16 ( N_GND_c_3_p N_noxref_3_c_181_n ) capacitor c=0.00118981f //x=6.9 \
 //y=0.175 //x2=6.04 //y2=2.265
cc_17 ( N_GND_M3_noxref_s N_noxref_3_c_181_n ) capacitor c=0.0108553f \
 //x=5.795 //y=0.55 //x2=6.04 //y2=2.265
cc_18 ( N_GND_c_7_p N_noxref_3_c_186_n ) capacitor c=0.0121786f //x=6.33 \
 //y=0.715 //x2=6.15 //y2=1.09
cc_19 ( N_GND_M3_noxref_s N_noxref_3_c_186_n ) capacitor c=0.0318107f \
 //x=5.795 //y=0.55 //x2=6.15 //y2=1.09
cc_20 ( N_GND_c_2_p N_noxref_3_c_188_n ) capacitor c=0.00561485f //x=5.3 \
 //y=0.175 //x2=6.15 //y2=2.1
cc_21 ( N_GND_M3_noxref_s N_noxref_3_c_189_n ) capacitor c=0.00483567f \
 //x=5.795 //y=0.55 //x2=6.525 //y2=0.935
cc_22 ( N_GND_c_22_p N_noxref_3_c_190_n ) capacitor c=0.0118631f //x=6.815 \
 //y=0.715 //x2=6.68 //y2=1.09
cc_23 ( N_GND_M3_noxref_s N_noxref_3_c_190_n ) capacitor c=0.0143355f \
 //x=5.795 //y=0.55 //x2=6.68 //y2=1.09
cc_24 ( N_GND_M3_noxref_s N_noxref_3_c_192_n ) capacitor c=0.0074042f \
 //x=5.795 //y=0.55 //x2=6.68 //y2=1.435
cc_25 ( N_GND_c_7_p N_noxref_3_c_193_n ) capacitor c=2.1838e-19 //x=6.33 \
 //y=0.715 //x2=6.04 //y2=2.265
cc_26 ( N_GND_c_2_p N_noxref_3_c_193_n ) capacitor c=0.0108179f //x=5.3 \
 //y=0.175 //x2=6.04 //y2=2.265
cc_27 ( N_GND_M3_noxref_s N_noxref_3_c_193_n ) capacitor c=0.006558f //x=5.795 \
 //y=0.55 //x2=6.04 //y2=2.265
cc_28 ( N_GND_c_2_p N_noxref_3_M2_noxref_d ) capacitor c=0.00591582f //x=5.3 \
 //y=0.175 //x2=3.885 //y2=1.095
cc_29 ( N_GND_M3_noxref_s N_noxref_3_M2_noxref_d ) capacitor c=2.07235e-19 \
 //x=5.795 //y=0.55 //x2=3.885 //y2=1.095
cc_30 ( N_GND_c_1_p N_A_c_313_n ) capacitor c=0.0180363f //x=1.23 //y=0.18 \
 //x2=1.6 //y2=2.26
cc_31 ( N_GND_c_31_p N_A_c_314_n ) capacitor c=0.00133465f //x=1.48 //y=0.175 \
 //x2=1.3 //y2=1.055
cc_32 ( N_GND_M0_noxref_d N_A_c_314_n ) capacitor c=0.00211996f //x=1.375 \
 //y=1.055 //x2=1.3 //y2=1.055
cc_33 ( N_GND_M0_noxref_d N_A_c_316_n ) capacitor c=0.00255985f //x=1.375 \
 //y=1.055 //x2=1.3 //y2=1.4
cc_34 ( N_GND_c_1_p N_A_c_317_n ) capacitor c=0.00295461f //x=1.23 //y=0.18 \
 //x2=1.3 //y2=1.71
cc_35 ( N_GND_c_1_p N_A_c_318_n ) capacitor c=0.0134214f //x=1.23 //y=0.18 \
 //x2=1.3 //y2=2.095
cc_36 ( N_GND_M0_noxref_d N_A_c_319_n ) capacitor c=0.0131387f //x=1.375 \
 //y=1.055 //x2=1.675 //y2=0.9
cc_37 ( N_GND_M0_noxref_d N_A_c_320_n ) capacitor c=0.00193165f //x=1.375 \
 //y=1.055 //x2=1.675 //y2=1.555
cc_38 ( N_GND_c_5_p N_A_c_321_n ) capacitor c=0.00129623f //x=5.13 //y=0.175 \
 //x2=1.83 //y2=1.055
cc_39 ( N_GND_M0_noxref_d N_A_c_321_n ) capacitor c=0.00257848f //x=1.375 \
 //y=1.055 //x2=1.83 //y2=1.055
cc_40 ( N_GND_M0_noxref_d N_A_c_323_n ) capacitor c=0.00255985f //x=1.375 \
 //y=1.055 //x2=1.83 //y2=1.4
cc_41 ( N_GND_c_1_p N_B_c_368_n ) capacitor c=7.64246e-19 //x=1.23 //y=0.18 \
 //x2=2.71 //y2=2.26
cc_42 ( N_GND_c_4_p N_noxref_6_c_438_n ) capacitor c=0.00710601f //x=6.78 \
 //y=0.18 //x2=1.965 //y2=1.77
cc_43 ( N_GND_c_31_p N_noxref_6_c_438_n ) capacitor c=0.00110148f //x=1.48 \
 //y=0.175 //x2=1.965 //y2=1.77
cc_44 ( N_GND_c_5_p N_noxref_6_c_438_n ) capacitor c=0.0017942f //x=5.13 \
 //y=0.175 //x2=1.965 //y2=1.77
cc_45 ( N_GND_M0_noxref_d N_noxref_6_c_438_n ) capacitor c=0.00900213f \
 //x=1.375 //y=1.055 //x2=1.965 //y2=1.77
cc_46 ( N_GND_c_4_p N_noxref_6_c_442_n ) capacitor c=0.00710913f //x=6.78 \
 //y=0.18 //x2=2.05 //y2=0.805
cc_47 ( N_GND_c_5_p N_noxref_6_c_442_n ) capacitor c=0.0140604f //x=5.13 \
 //y=0.175 //x2=2.05 //y2=0.805
cc_48 ( N_GND_c_3_p N_noxref_6_c_442_n ) capacitor c=0.00138062f //x=6.9 \
 //y=0.175 //x2=2.05 //y2=0.805
cc_49 ( N_GND_M0_noxref_d N_noxref_6_c_442_n ) capacitor c=0.033954f //x=1.375 \
 //y=1.055 //x2=2.05 //y2=0.805
cc_50 ( N_GND_c_4_p N_noxref_6_c_446_n ) capacitor c=0.019241f //x=6.78 \
 //y=0.18 //x2=2.935 //y2=0.72
cc_51 ( N_GND_c_5_p N_noxref_6_c_446_n ) capacitor c=0.0356451f //x=5.13 \
 //y=0.175 //x2=2.935 //y2=0.72
cc_52 ( N_GND_c_3_p N_noxref_6_c_446_n ) capacitor c=0.00264707f //x=6.9 \
 //y=0.175 //x2=2.935 //y2=0.72
cc_53 ( N_GND_c_4_p N_noxref_6_M0_noxref_s ) capacitor c=0.0139432f //x=6.78 \
 //y=0.18 //x2=0.945 //y2=0.555
cc_54 ( N_GND_c_31_p N_noxref_6_M0_noxref_s ) capacitor c=0.0140604f //x=1.48 \
 //y=0.175 //x2=0.945 //y2=0.555
cc_55 ( N_GND_c_1_p N_noxref_6_M0_noxref_s ) capacitor c=0.0712607f //x=1.23 \
 //y=0.18 //x2=0.945 //y2=0.555
cc_56 ( N_GND_c_5_p N_noxref_6_M0_noxref_s ) capacitor c=0.0131642f //x=5.13 \
 //y=0.175 //x2=0.945 //y2=0.555
cc_57 ( N_GND_c_2_p N_noxref_6_M0_noxref_s ) capacitor c=3.31601e-19 //x=5.3 \
 //y=0.175 //x2=0.945 //y2=0.555
cc_58 ( N_GND_c_3_p N_noxref_6_M0_noxref_s ) capacitor c=0.00272322f //x=6.9 \
 //y=0.175 //x2=0.945 //y2=0.555
cc_59 ( N_GND_M0_noxref_d N_noxref_6_M0_noxref_s ) capacitor c=0.033718f \
 //x=1.375 //y=1.055 //x2=0.945 //y2=0.555
cc_60 ( N_GND_c_2_p N_C_c_483_n ) capacitor c=9.53263e-19 //x=5.3 //y=0.175 \
 //x2=3.82 //y2=2.26
cc_61 ( N_GND_c_4_p N_noxref_8_c_537_n ) capacitor c=0.0079063f //x=6.78 \
 //y=0.18 //x2=3.505 //y2=1.175
cc_62 ( N_GND_c_5_p N_noxref_8_c_537_n ) capacitor c=0.00830851f //x=5.13 \
 //y=0.175 //x2=3.505 //y2=1.175
cc_63 ( N_GND_c_3_p N_noxref_8_c_537_n ) capacitor c=3.53825e-19 //x=6.9 \
 //y=0.175 //x2=3.505 //y2=1.175
cc_64 ( N_GND_c_4_p N_noxref_8_c_540_n ) capacitor c=0.00710913f //x=6.78 \
 //y=0.18 //x2=3.59 //y2=0.805
cc_65 ( N_GND_c_5_p N_noxref_8_c_540_n ) capacitor c=0.0140604f //x=5.13 \
 //y=0.175 //x2=3.59 //y2=0.805
cc_66 ( N_GND_c_3_p N_noxref_8_c_540_n ) capacitor c=0.00138062f //x=6.9 \
 //y=0.175 //x2=3.59 //y2=0.805
cc_67 ( N_GND_M0_noxref_d N_noxref_8_c_540_n ) capacitor c=6.21394e-19 \
 //x=1.375 //y=1.055 //x2=3.59 //y2=0.805
cc_68 ( N_GND_c_4_p N_noxref_8_c_544_n ) capacitor c=0.0183112f //x=6.78 \
 //y=0.18 //x2=4.475 //y2=0.72
cc_69 ( N_GND_c_5_p N_noxref_8_c_544_n ) capacitor c=0.0363189f //x=5.13 \
 //y=0.175 //x2=4.475 //y2=0.72
cc_70 ( N_GND_c_3_p N_noxref_8_c_544_n ) capacitor c=0.00282763f //x=6.9 \
 //y=0.175 //x2=4.475 //y2=0.72
cc_71 ( N_GND_c_4_p N_noxref_8_c_547_n ) capacitor c=0.00286787f //x=6.78 \
 //y=0.18 //x2=4.56 //y2=0.805
cc_72 ( N_GND_c_5_p N_noxref_8_c_547_n ) capacitor c=0.0142801f //x=5.13 \
 //y=0.175 //x2=4.56 //y2=0.805
cc_73 ( N_GND_c_73_p N_noxref_8_c_547_n ) capacitor c=9.29926e-19 //x=5.93 \
 //y=0.63 //x2=4.56 //y2=0.805
cc_74 ( N_GND_c_2_p N_noxref_8_c_547_n ) capacitor c=0.0404137f //x=5.3 \
 //y=0.175 //x2=4.56 //y2=0.805
cc_75 ( N_GND_c_3_p N_noxref_8_c_547_n ) capacitor c=0.0013725f //x=6.9 \
 //y=0.175 //x2=4.56 //y2=0.805
cc_76 ( N_GND_M0_noxref_d N_noxref_8_M1_noxref_d ) capacitor c=0.00162435f \
 //x=1.375 //y=1.055 //x2=2.35 //y2=1.09
cc_77 ( N_GND_c_1_p N_noxref_8_M2_noxref_s ) capacitor c=8.16352e-19 //x=1.23 \
 //y=0.18 //x2=3.455 //y2=0.555
cc_78 ( N_GND_c_2_p N_noxref_8_M2_noxref_s ) capacitor c=0.00183149f //x=5.3 \
 //y=0.175 //x2=3.455 //y2=0.555
cc_79 ( N_GND_M3_noxref_s N_noxref_8_M2_noxref_s ) capacitor c=9.29926e-19 \
 //x=5.795 //y=0.55 //x2=3.455 //y2=0.555
cc_80 ( N_GND_c_2_p Y ) capacitor c=8.10282e-19 //x=5.3 //y=0.175 //x2=6.78 \
 //y2=2.4
cc_81 ( N_GND_c_4_p N_Y_c_592_n ) capacitor c=0.00181107f //x=6.78 //y=0.18 \
 //x2=6.695 //y2=2.26
cc_82 ( N_GND_c_3_p N_Y_c_592_n ) capacitor c=0.0301661f //x=6.9 //y=0.175 \
 //x2=6.695 //y2=2.26
cc_83 ( N_GND_M3_noxref_s N_Y_c_592_n ) capacitor c=0.0099963f //x=5.795 \
 //y=0.55 //x2=6.695 //y2=2.26
cc_84 ( N_GND_c_4_p N_Y_M3_noxref_d ) capacitor c=0.00194747f //x=6.78 \
 //y=0.18 //x2=6.225 //y2=1.09
cc_85 ( N_GND_c_7_p N_Y_M3_noxref_d ) capacitor c=0.014622f //x=6.33 //y=0.715 \
 //x2=6.225 //y2=1.09
cc_86 ( N_GND_c_2_p N_Y_M3_noxref_d ) capacitor c=0.00924905f //x=5.3 \
 //y=0.175 //x2=6.225 //y2=1.09
cc_87 ( N_GND_c_3_p N_Y_M3_noxref_d ) capacitor c=0.00973758f //x=6.9 \
 //y=0.175 //x2=6.225 //y2=1.09
cc_88 ( N_GND_M3_noxref_s N_Y_M3_noxref_d ) capacitor c=0.076995f //x=5.795 \
 //y=0.55 //x2=6.225 //y2=1.09
cc_89 ( N_VDD_c_92_p N_noxref_3_c_172_n ) capacitor c=0.00921913f //x=6.78 \
 //y=7.58 //x2=5.925 //y2=3.51
cc_90 ( N_VDD_c_90_n N_noxref_3_c_172_n ) capacitor c=0.00694659f //x=5.3 \
 //y=7.585 //x2=5.925 //y2=3.51
cc_91 ( N_VDD_M10_noxref_s N_noxref_3_c_172_n ) capacitor c=0.0010609f \
 //x=5.84 //y=5.2 //x2=5.925 //y2=3.51
cc_92 ( N_VDD_c_92_p N_noxref_3_c_178_n ) capacitor c=0.00163604f //x=6.78 \
 //y=7.58 //x2=4.675 //y2=3.51
cc_93 ( N_VDD_c_92_p N_noxref_3_c_202_n ) capacitor c=0.00591596f //x=6.78 \
 //y=7.58 //x2=2.815 //y2=5.335
cc_94 ( N_VDD_c_97_p N_noxref_3_c_202_n ) capacitor c=4.18731e-19 //x=2.375 \
 //y=7.585 //x2=2.815 //y2=5.335
cc_95 ( N_VDD_c_98_p N_noxref_3_c_202_n ) capacitor c=4.18731e-19 //x=3.255 \
 //y=7.585 //x2=2.815 //y2=5.335
cc_96 ( N_VDD_M5_noxref_d N_noxref_3_c_202_n ) capacitor c=0.0119121f \
 //x=2.315 //y=5.2 //x2=2.815 //y2=5.335
cc_97 ( N_VDD_c_89_n N_noxref_3_c_206_n ) capacitor c=0.00880189f //x=1.23 \
 //y=7.58 //x2=2.105 //y2=5.335
cc_98 ( N_VDD_M4_noxref_s N_noxref_3_c_206_n ) capacitor c=0.0831083f \
 //x=1.445 //y=5.2 //x2=2.105 //y2=5.335
cc_99 ( N_VDD_c_92_p N_noxref_3_c_208_n ) capacitor c=0.00593323f //x=6.78 \
 //y=7.58 //x2=3.695 //y2=5.335
cc_100 ( N_VDD_c_98_p N_noxref_3_c_208_n ) capacitor c=4.18731e-19 //x=3.255 \
 //y=7.585 //x2=3.695 //y2=5.335
cc_101 ( N_VDD_c_104_p N_noxref_3_c_208_n ) capacitor c=4.18731e-19 //x=4.135 \
 //y=7.585 //x2=3.695 //y2=5.335
cc_102 ( N_VDD_M7_noxref_d N_noxref_3_c_208_n ) capacitor c=0.0119121f \
 //x=3.195 //y=5.2 //x2=3.695 //y2=5.335
cc_103 ( N_VDD_c_92_p N_noxref_3_c_212_n ) capacitor c=0.0059345f //x=6.78 \
 //y=7.58 //x2=4.475 //y2=5.335
cc_104 ( N_VDD_c_104_p N_noxref_3_c_212_n ) capacitor c=6.99544e-19 //x=4.135 \
 //y=7.585 //x2=4.475 //y2=5.335
cc_105 ( N_VDD_c_108_p N_noxref_3_c_212_n ) capacitor c=0.00180478f //x=5.13 \
 //y=7.585 //x2=4.475 //y2=5.335
cc_106 ( N_VDD_M9_noxref_d N_noxref_3_c_212_n ) capacitor c=0.0119121f \
 //x=4.075 //y=5.2 //x2=4.475 //y2=5.335
cc_107 ( N_VDD_c_90_n N_noxref_3_c_216_n ) capacitor c=0.0456169f //x=5.3 \
 //y=7.585 //x2=4.56 //y2=3.51
cc_108 ( N_VDD_c_92_p N_noxref_3_c_181_n ) capacitor c=0.00160062f //x=6.78 \
 //y=7.58 //x2=6.04 //y2=2.265
cc_109 ( N_VDD_c_90_n N_noxref_3_c_181_n ) capacitor c=0.0272885f //x=5.3 \
 //y=7.585 //x2=6.04 //y2=2.265
cc_110 ( N_VDD_c_91_n N_noxref_3_c_181_n ) capacitor c=0.00144809f //x=6.78 \
 //y=7.58 //x2=6.04 //y2=2.265
cc_111 ( N_VDD_M10_noxref_s N_noxref_3_c_181_n ) capacitor c=0.00971925f \
 //x=5.84 //y=5.2 //x2=6.04 //y2=2.265
cc_112 ( N_VDD_c_115_p N_noxref_3_M10_noxref_g ) capacitor c=0.00753931f \
 //x=6.77 //y=7.585 //x2=6.195 //y2=6.2
cc_113 ( N_VDD_c_90_n N_noxref_3_M10_noxref_g ) capacitor c=0.00935943f \
 //x=5.3 //y=7.585 //x2=6.195 //y2=6.2
cc_114 ( N_VDD_M10_noxref_s N_noxref_3_M10_noxref_g ) capacitor c=0.0528676f \
 //x=5.84 //y=5.2 //x2=6.195 //y2=6.2
cc_115 ( N_VDD_c_115_p N_noxref_3_M11_noxref_g ) capacitor c=0.00702238f \
 //x=6.77 //y=7.585 //x2=6.635 //y2=6.2
cc_116 ( N_VDD_M11_noxref_d N_noxref_3_M11_noxref_g ) capacitor c=0.0528676f \
 //x=6.71 //y=5.2 //x2=6.635 //y2=6.2
cc_117 ( N_VDD_c_91_n N_noxref_3_c_226_n ) capacitor c=0.0287802f //x=6.78 \
 //y=7.58 //x2=6.56 //y2=4.97
cc_118 ( N_VDD_c_90_n N_noxref_3_c_227_n ) capacitor c=0.011132f //x=5.3 \
 //y=7.585 //x2=6.27 //y2=4.97
cc_119 ( N_VDD_M10_noxref_s N_noxref_3_c_227_n ) capacitor c=0.0052728f \
 //x=5.84 //y=5.2 //x2=6.27 //y2=4.97
cc_120 ( N_VDD_c_92_p N_noxref_3_M4_noxref_d ) capacitor c=0.00707991f \
 //x=6.78 //y=7.58 //x2=1.875 //y2=5.2
cc_121 ( N_VDD_c_97_p N_noxref_3_M4_noxref_d ) capacitor c=0.0138842f \
 //x=2.375 //y=7.585 //x2=1.875 //y2=5.2
cc_122 ( N_VDD_c_91_n N_noxref_3_M4_noxref_d ) capacitor c=0.00135292f \
 //x=6.78 //y=7.58 //x2=1.875 //y2=5.2
cc_123 ( N_VDD_M5_noxref_d N_noxref_3_M4_noxref_d ) capacitor c=0.0664752f \
 //x=2.315 //y=5.2 //x2=1.875 //y2=5.2
cc_124 ( N_VDD_c_92_p N_noxref_3_M6_noxref_d ) capacitor c=0.00707991f \
 //x=6.78 //y=7.58 //x2=2.755 //y2=5.2
cc_125 ( N_VDD_c_98_p N_noxref_3_M6_noxref_d ) capacitor c=0.0138842f \
 //x=3.255 //y=7.585 //x2=2.755 //y2=5.2
cc_126 ( N_VDD_c_90_n N_noxref_3_M6_noxref_d ) capacitor c=4.9285e-19 //x=5.3 \
 //y=7.585 //x2=2.755 //y2=5.2
cc_127 ( N_VDD_c_91_n N_noxref_3_M6_noxref_d ) capacitor c=0.00135292f \
 //x=6.78 //y=7.58 //x2=2.755 //y2=5.2
cc_128 ( N_VDD_M4_noxref_s N_noxref_3_M6_noxref_d ) capacitor c=0.00130656f \
 //x=1.445 //y=5.2 //x2=2.755 //y2=5.2
cc_129 ( N_VDD_M5_noxref_d N_noxref_3_M6_noxref_d ) capacitor c=0.0664752f \
 //x=2.315 //y=5.2 //x2=2.755 //y2=5.2
cc_130 ( N_VDD_M7_noxref_d N_noxref_3_M6_noxref_d ) capacitor c=0.0664752f \
 //x=3.195 //y=5.2 //x2=2.755 //y2=5.2
cc_131 ( N_VDD_c_92_p N_noxref_3_M8_noxref_d ) capacitor c=0.00707991f \
 //x=6.78 //y=7.58 //x2=3.635 //y2=5.2
cc_132 ( N_VDD_c_104_p N_noxref_3_M8_noxref_d ) capacitor c=0.0138122f \
 //x=4.135 //y=7.585 //x2=3.635 //y2=5.2
cc_133 ( N_VDD_c_90_n N_noxref_3_M8_noxref_d ) capacitor c=0.00939849f //x=5.3 \
 //y=7.585 //x2=3.635 //y2=5.2
cc_134 ( N_VDD_c_91_n N_noxref_3_M8_noxref_d ) capacitor c=0.00135292f \
 //x=6.78 //y=7.58 //x2=3.635 //y2=5.2
cc_135 ( N_VDD_M7_noxref_d N_noxref_3_M8_noxref_d ) capacitor c=0.0664752f \
 //x=3.195 //y=5.2 //x2=3.635 //y2=5.2
cc_136 ( N_VDD_M9_noxref_d N_noxref_3_M8_noxref_d ) capacitor c=0.0664752f \
 //x=4.075 //y=5.2 //x2=3.635 //y2=5.2
cc_137 ( N_VDD_M10_noxref_s N_noxref_3_M8_noxref_d ) capacitor c=5.22106e-19 \
 //x=5.84 //y=5.2 //x2=3.635 //y2=5.2
cc_138 ( N_VDD_c_92_p N_A_c_313_n ) capacitor c=0.0011224f //x=6.78 //y=7.58 \
 //x2=1.6 //y2=2.26
cc_139 ( N_VDD_c_89_n N_A_c_313_n ) capacitor c=0.0168497f //x=1.23 //y=7.58 \
 //x2=1.6 //y2=2.26
cc_140 ( N_VDD_M4_noxref_s N_A_c_313_n ) capacitor c=0.0130258f //x=1.445 \
 //y=5.2 //x2=1.6 //y2=2.26
cc_141 ( N_VDD_c_97_p N_A_M4_noxref_g ) capacitor c=0.00755614f //x=2.375 \
 //y=7.585 //x2=1.8 //y2=6.2
cc_142 ( N_VDD_M4_noxref_s N_A_M4_noxref_g ) capacitor c=0.0477201f //x=1.445 \
 //y=5.2 //x2=1.8 //y2=6.2
cc_143 ( N_VDD_c_97_p N_A_M5_noxref_g ) capacitor c=0.00679791f //x=2.375 \
 //y=7.585 //x2=2.24 //y2=6.2
cc_144 ( N_VDD_M5_noxref_d N_A_M5_noxref_g ) capacitor c=0.015318f //x=2.315 \
 //y=5.2 //x2=2.24 //y2=6.2
cc_145 ( N_VDD_c_89_n N_A_c_331_n ) capacitor c=0.0076931f //x=1.23 //y=7.58 \
 //x2=1.875 //y2=4.97
cc_146 ( N_VDD_M4_noxref_s N_A_c_331_n ) capacitor c=0.00442985f //x=1.445 \
 //y=5.2 //x2=1.875 //y2=4.97
cc_147 ( N_VDD_c_92_p N_B_c_368_n ) capacitor c=2.41129e-19 //x=6.78 //y=7.58 \
 //x2=2.71 //y2=2.26
cc_148 ( N_VDD_c_89_n N_B_c_368_n ) capacitor c=7.34553e-19 //x=1.23 //y=7.58 \
 //x2=2.71 //y2=2.26
cc_149 ( N_VDD_c_98_p N_B_M6_noxref_g ) capacitor c=0.00680845f //x=3.255 \
 //y=7.585 //x2=2.68 //y2=6.2
cc_150 ( N_VDD_M5_noxref_d N_B_M6_noxref_g ) capacitor c=0.015318f //x=2.315 \
 //y=5.2 //x2=2.68 //y2=6.2
cc_151 ( N_VDD_c_98_p N_B_M7_noxref_g ) capacitor c=0.00679791f //x=3.255 \
 //y=7.585 //x2=3.12 //y2=6.2
cc_152 ( N_VDD_M7_noxref_d N_B_M7_noxref_g ) capacitor c=0.015318f //x=3.195 \
 //y=5.2 //x2=3.12 //y2=6.2
cc_153 ( N_VDD_c_90_n N_C_c_483_n ) capacitor c=8.81482e-19 //x=5.3 //y=7.585 \
 //x2=3.82 //y2=2.26
cc_154 ( N_VDD_c_104_p N_C_M8_noxref_g ) capacitor c=0.00679791f //x=4.135 \
 //y=7.585 //x2=3.56 //y2=6.2
cc_155 ( N_VDD_M7_noxref_d N_C_M8_noxref_g ) capacitor c=0.015318f //x=3.195 \
 //y=5.2 //x2=3.56 //y2=6.2
cc_156 ( N_VDD_c_104_p N_C_M9_noxref_g ) capacitor c=0.00680002f //x=4.135 \
 //y=7.585 //x2=4 //y2=6.2
cc_157 ( N_VDD_M9_noxref_d N_C_M9_noxref_g ) capacitor c=0.0394719f //x=4.075 \
 //y=5.2 //x2=4 //y2=6.2
cc_158 ( N_VDD_c_90_n Y ) capacitor c=4.80934e-19 //x=5.3 //y=7.585 //x2=6.78 \
 //y2=2.4
cc_159 ( N_VDD_c_91_n Y ) capacitor c=0.0232778f //x=6.78 //y=7.58 //x2=6.78 \
 //y2=2.4
cc_160 ( N_VDD_c_92_p N_Y_c_602_n ) capacitor c=0.00191195f //x=6.78 //y=7.58 \
 //x2=6.695 //y2=4.76
cc_161 ( N_VDD_c_115_p N_Y_c_602_n ) capacitor c=8.83313e-19 //x=6.77 \
 //y=7.585 //x2=6.695 //y2=4.76
cc_162 ( N_VDD_M11_noxref_d N_Y_c_602_n ) capacitor c=0.00641652f //x=6.71 \
 //y=5.2 //x2=6.695 //y2=4.76
cc_163 ( N_VDD_c_90_n N_Y_c_605_n ) capacitor c=0.017572f //x=5.3 //y=7.585 \
 //x2=6.5 //y2=4.76
cc_164 ( N_VDD_c_92_p N_Y_M10_noxref_d ) capacitor c=0.00710215f //x=6.78 \
 //y=7.58 //x2=6.27 //y2=5.2
cc_165 ( N_VDD_c_115_p N_Y_M10_noxref_d ) capacitor c=0.0139426f //x=6.77 \
 //y=7.585 //x2=6.27 //y2=5.2
cc_166 ( N_VDD_c_91_n N_Y_M10_noxref_d ) capacitor c=0.0219131f //x=6.78 \
 //y=7.58 //x2=6.27 //y2=5.2
cc_167 ( N_VDD_M10_noxref_s N_Y_M10_noxref_d ) capacitor c=0.0843065f //x=5.84 \
 //y=5.2 //x2=6.27 //y2=5.2
cc_168 ( N_VDD_M11_noxref_d N_Y_M10_noxref_d ) capacitor c=0.0832641f //x=6.71 \
 //y=5.2 //x2=6.27 //y2=5.2
cc_169 ( N_noxref_3_c_206_n N_A_M4_noxref_g ) capacitor c=0.0213876f //x=2.105 \
 //y=5.335 //x2=1.8 //y2=6.2
cc_170 ( N_noxref_3_c_202_n N_A_M5_noxref_g ) capacitor c=0.0204065f //x=2.815 \
 //y=5.335 //x2=2.24 //y2=6.2
cc_171 ( N_noxref_3_M4_noxref_d N_A_M5_noxref_g ) capacitor c=0.0180032f \
 //x=1.875 //y=5.2 //x2=2.24 //y2=6.2
cc_172 ( N_noxref_3_c_206_n N_A_c_336_n ) capacitor c=0.00437952f //x=2.105 \
 //y=5.335 //x2=2.165 //y2=4.97
cc_173 ( N_noxref_3_c_202_n N_B_c_368_n ) capacitor c=0.0149929f //x=2.815 \
 //y=5.335 //x2=2.71 //y2=2.26
cc_174 ( N_noxref_3_c_216_n N_B_c_368_n ) capacitor c=0.00326759f //x=4.56 \
 //y=3.51 //x2=2.71 //y2=2.26
cc_175 ( N_noxref_3_c_202_n N_B_M6_noxref_g ) capacitor c=0.0170029f //x=2.815 \
 //y=5.335 //x2=2.68 //y2=6.2
cc_176 ( N_noxref_3_M6_noxref_d N_B_M6_noxref_g ) capacitor c=0.0180032f \
 //x=2.755 //y=5.2 //x2=2.68 //y2=6.2
cc_177 ( N_noxref_3_c_208_n N_B_M7_noxref_g ) capacitor c=0.0209317f //x=3.695 \
 //y=5.335 //x2=3.12 //y2=6.2
cc_178 ( N_noxref_3_M6_noxref_d N_B_M7_noxref_g ) capacitor c=0.0180032f \
 //x=2.755 //y=5.2 //x2=3.12 //y2=6.2
cc_179 ( N_noxref_3_c_257_p N_B_c_381_n ) capacitor c=0.004361f //x=2.9 \
 //y=5.335 //x2=3.045 //y2=4.97
cc_180 ( N_noxref_3_c_202_n N_B_c_382_n ) capacitor c=0.0032428f //x=2.815 \
 //y=5.335 //x2=2.71 //y2=4.88
cc_181 ( N_noxref_3_M2_noxref_d N_noxref_6_M0_noxref_s ) capacitor \
 c=0.00309936f //x=3.885 //y=1.095 //x2=0.945 //y2=0.555
cc_182 ( N_noxref_3_c_178_n N_C_c_483_n ) capacitor c=0.00717888f //x=4.675 \
 //y=3.51 //x2=3.82 //y2=2.26
cc_183 ( N_noxref_3_c_216_n N_C_c_483_n ) capacitor c=0.0910677f //x=4.56 \
 //y=3.51 //x2=3.82 //y2=2.26
cc_184 ( N_noxref_3_c_181_n N_C_c_483_n ) capacitor c=0.00126776f //x=6.04 \
 //y=2.265 //x2=3.82 //y2=2.26
cc_185 ( N_noxref_3_c_263_p N_C_c_483_n ) capacitor c=0.0176831f //x=3.78 \
 //y=5.335 //x2=3.82 //y2=2.26
cc_186 ( N_noxref_3_c_208_n N_C_M8_noxref_g ) capacitor c=0.0209317f //x=3.695 \
 //y=5.335 //x2=3.56 //y2=6.2
cc_187 ( N_noxref_3_M8_noxref_d N_C_M8_noxref_g ) capacitor c=0.0180032f \
 //x=3.635 //y=5.2 //x2=3.56 //y2=6.2
cc_188 ( N_noxref_3_c_212_n N_C_M9_noxref_g ) capacitor c=0.0230698f //x=4.475 \
 //y=5.335 //x2=4 //y2=6.2
cc_189 ( N_noxref_3_M8_noxref_d N_C_M9_noxref_g ) capacitor c=0.0194246f \
 //x=3.635 //y=5.2 //x2=4 //y2=6.2
cc_190 ( N_noxref_3_M2_noxref_d N_C_c_497_n ) capacitor c=0.00217566f \
 //x=3.885 //y=1.095 //x2=3.81 //y2=1.095
cc_191 ( N_noxref_3_M2_noxref_d N_C_c_498_n ) capacitor c=0.0034598f //x=3.885 \
 //y=1.095 //x2=3.81 //y2=1.44
cc_192 ( N_noxref_3_M2_noxref_d N_C_c_499_n ) capacitor c=0.00544291f \
 //x=3.885 //y=1.095 //x2=3.81 //y2=1.75
cc_193 ( N_noxref_3_M2_noxref_d N_C_c_500_n ) capacitor c=0.00241102f \
 //x=3.885 //y=1.095 //x2=4.185 //y2=0.94
cc_194 ( N_noxref_3_c_179_n N_C_c_501_n ) capacitor c=0.00359704f //x=4.475 \
 //y=1.845 //x2=4.185 //y2=1.595
cc_195 ( N_noxref_3_M2_noxref_d N_C_c_501_n ) capacitor c=0.0140297f //x=3.885 \
 //y=1.095 //x2=4.185 //y2=1.595
cc_196 ( N_noxref_3_M2_noxref_d N_C_c_503_n ) capacitor c=0.00219619f \
 //x=3.885 //y=1.095 //x2=4.34 //y2=1.095
cc_197 ( N_noxref_3_c_179_n N_C_c_504_n ) capacitor c=0.00457401f //x=4.475 \
 //y=1.845 //x2=4.34 //y2=1.44
cc_198 ( N_noxref_3_M2_noxref_d N_C_c_504_n ) capacitor c=0.00603828f \
 //x=3.885 //y=1.095 //x2=4.34 //y2=1.44
cc_199 ( N_noxref_3_c_216_n N_C_c_506_n ) capacitor c=0.00877984f //x=4.56 \
 //y=3.51 //x2=3.82 //y2=2.26
cc_200 ( N_noxref_3_c_216_n N_C_c_507_n ) capacitor c=0.00283672f //x=4.56 \
 //y=3.51 //x2=3.82 //y2=2.095
cc_201 ( N_noxref_3_M2_noxref_d N_C_c_507_n ) capacitor c=0.00661782f \
 //x=3.885 //y=1.095 //x2=3.82 //y2=2.095
cc_202 ( N_noxref_3_c_212_n N_C_c_509_n ) capacitor c=0.00201851f //x=4.475 \
 //y=5.335 //x2=3.82 //y2=4.88
cc_203 ( N_noxref_3_c_216_n N_C_c_509_n ) capacitor c=0.013844f //x=4.56 \
 //y=3.51 //x2=3.82 //y2=4.88
cc_204 ( N_noxref_3_c_263_p N_C_c_509_n ) capacitor c=0.00475314f //x=3.78 \
 //y=5.335 //x2=3.82 //y2=4.88
cc_205 ( N_noxref_3_c_179_n N_noxref_8_c_544_n ) capacitor c=0.00469128f \
 //x=4.475 //y=1.845 //x2=4.475 //y2=0.72
cc_206 ( N_noxref_3_M2_noxref_d N_noxref_8_c_544_n ) capacitor c=0.0118457f \
 //x=3.885 //y=1.095 //x2=4.475 //y2=0.72
cc_207 ( N_noxref_3_c_285_p N_noxref_8_c_558_n ) capacitor c=0.0200405f \
 //x=4.16 //y=1.845 //x2=3.59 //y2=1.175
cc_208 ( N_noxref_3_M2_noxref_d N_noxref_8_M1_noxref_d ) capacitor \
 c=5.27807e-19 //x=3.885 //y=1.095 //x2=2.35 //y2=1.09
cc_209 ( N_noxref_3_c_179_n N_noxref_8_M2_noxref_s ) capacitor c=0.020752f \
 //x=4.475 //y=1.845 //x2=3.455 //y2=0.555
cc_210 ( N_noxref_3_M2_noxref_d N_noxref_8_M2_noxref_s ) capacitor \
 c=0.0426368f //x=3.885 //y=1.095 //x2=3.455 //y2=0.555
cc_211 ( N_noxref_3_c_172_n Y ) capacitor c=0.00582634f //x=5.925 //y=3.51 \
 //x2=6.78 //y2=2.4
cc_212 ( N_noxref_3_c_216_n Y ) capacitor c=0.00126776f //x=4.56 //y=3.51 \
 //x2=6.78 //y2=2.4
cc_213 ( N_noxref_3_c_181_n Y ) capacitor c=0.0711303f //x=6.04 //y=2.265 \
 //x2=6.78 //y2=2.4
cc_214 ( N_noxref_3_c_193_n Y ) capacitor c=8.49451e-19 //x=6.04 //y=2.265 \
 //x2=6.78 //y2=2.4
cc_215 ( N_noxref_3_c_293_p N_Y_c_592_n ) capacitor c=0.0023507f //x=6.525 \
 //y=1.59 //x2=6.695 //y2=2.26
cc_216 ( N_noxref_3_c_193_n N_Y_c_616_n ) capacitor c=0.0167852f //x=6.04 \
 //y=2.265 //x2=6.495 //y2=2.26
cc_217 ( N_noxref_3_c_226_n N_Y_c_602_n ) capacitor c=0.0101013f //x=6.56 \
 //y=4.97 //x2=6.695 //y2=4.76
cc_218 ( N_noxref_3_c_181_n N_Y_c_605_n ) capacitor c=0.0250789f //x=6.04 \
 //y=2.265 //x2=6.5 //y2=4.76
cc_219 ( N_noxref_3_c_227_n N_Y_c_605_n ) capacitor c=0.00962086f //x=6.27 \
 //y=4.97 //x2=6.5 //y2=4.76
cc_220 ( N_noxref_3_c_216_n N_Y_M3_noxref_d ) capacitor c=3.36976e-19 //x=4.56 \
 //y=3.51 //x2=6.225 //y2=1.09
cc_221 ( N_noxref_3_c_181_n N_Y_M3_noxref_d ) capacitor c=0.0175773f //x=6.04 \
 //y=2.265 //x2=6.225 //y2=1.09
cc_222 ( N_noxref_3_c_186_n N_Y_M3_noxref_d ) capacitor c=0.00218556f //x=6.15 \
 //y=1.09 //x2=6.225 //y2=1.09
cc_223 ( N_noxref_3_c_301_p N_Y_M3_noxref_d ) capacitor c=0.00347355f //x=6.15 \
 //y=1.435 //x2=6.225 //y2=1.09
cc_224 ( N_noxref_3_c_302_p N_Y_M3_noxref_d ) capacitor c=0.00742431f //x=6.15 \
 //y=1.745 //x2=6.225 //y2=1.09
cc_225 ( N_noxref_3_c_188_n N_Y_M3_noxref_d ) capacitor c=0.00957707f //x=6.15 \
 //y=2.1 //x2=6.225 //y2=1.09
cc_226 ( N_noxref_3_c_189_n N_Y_M3_noxref_d ) capacitor c=0.00220879f \
 //x=6.525 //y=0.935 //x2=6.225 //y2=1.09
cc_227 ( N_noxref_3_c_293_p N_Y_M3_noxref_d ) capacitor c=0.0138447f //x=6.525 \
 //y=1.59 //x2=6.225 //y2=1.09
cc_228 ( N_noxref_3_c_190_n N_Y_M3_noxref_d ) capacitor c=0.00218624f //x=6.68 \
 //y=1.09 //x2=6.225 //y2=1.09
cc_229 ( N_noxref_3_c_192_n N_Y_M3_noxref_d ) capacitor c=0.00601286f //x=6.68 \
 //y=1.435 //x2=6.225 //y2=1.09
cc_230 ( N_noxref_3_c_216_n N_Y_M10_noxref_d ) capacitor c=6.5427e-19 //x=4.56 \
 //y=3.51 //x2=6.27 //y2=5.2
cc_231 ( N_noxref_3_M10_noxref_g N_Y_M10_noxref_d ) capacitor c=0.0219309f \
 //x=6.195 //y=6.2 //x2=6.27 //y2=5.2
cc_232 ( N_noxref_3_M11_noxref_g N_Y_M10_noxref_d ) capacitor c=0.021902f \
 //x=6.635 //y=6.2 //x2=6.27 //y2=5.2
cc_233 ( N_noxref_3_c_226_n N_Y_M10_noxref_d ) capacitor c=0.0148755f //x=6.56 \
 //y=4.97 //x2=6.27 //y2=5.2
cc_234 ( N_noxref_3_c_227_n N_Y_M10_noxref_d ) capacitor c=0.00307344f \
 //x=6.27 //y=4.97 //x2=6.27 //y2=5.2
cc_235 ( N_A_c_313_n N_B_c_368_n ) capacitor c=0.0585104f //x=1.6 //y=2.26 \
 //x2=2.71 //y2=2.26
cc_236 ( N_A_c_318_n N_B_c_368_n ) capacitor c=0.00238338f //x=1.3 //y=2.095 \
 //x2=2.71 //y2=2.26
cc_237 ( N_A_c_336_n N_B_c_368_n ) capacitor c=0.00147352f //x=2.165 //y=4.97 \
 //x2=2.71 //y2=2.26
cc_238 ( N_A_c_331_n N_B_c_368_n ) capacitor c=0.00142741f //x=1.875 //y=4.97 \
 //x2=2.71 //y2=2.26
cc_239 ( N_A_M4_noxref_g N_B_M6_noxref_g ) capacitor c=0.0105869f //x=1.8 \
 //y=6.2 //x2=2.68 //y2=6.2
cc_240 ( N_A_M5_noxref_g N_B_M6_noxref_g ) capacitor c=0.10632f //x=2.24 \
 //y=6.2 //x2=2.68 //y2=6.2
cc_241 ( N_A_M5_noxref_g N_B_M7_noxref_g ) capacitor c=0.0101598f //x=2.24 \
 //y=6.2 //x2=3.12 //y2=6.2
cc_242 ( N_A_c_314_n N_B_c_390_n ) capacitor c=5.72482e-19 //x=1.3 //y=1.055 \
 //x2=2.275 //y2=1.09
cc_243 ( N_A_c_316_n N_B_c_390_n ) capacitor c=0.00149976f //x=1.3 //y=1.4 \
 //x2=2.275 //y2=1.09
cc_244 ( N_A_c_321_n N_B_c_390_n ) capacitor c=0.0160123f //x=1.83 //y=1.055 \
 //x2=2.275 //y2=1.09
cc_245 ( N_A_c_317_n N_B_c_393_n ) capacitor c=0.00111227f //x=1.3 //y=1.71 \
 //x2=2.275 //y2=1.4
cc_246 ( N_A_c_323_n N_B_c_393_n ) capacitor c=0.0124075f //x=1.83 //y=1.4 \
 //x2=2.275 //y2=1.4
cc_247 ( N_A_c_321_n N_B_c_395_n ) capacitor c=0.00103227f //x=1.83 //y=1.055 \
 //x2=2.8 //y2=1.09
cc_248 ( N_A_c_323_n N_B_c_396_n ) capacitor c=0.0010154f //x=1.83 //y=1.4 \
 //x2=2.8 //y2=1.4
cc_249 ( N_A_c_323_n N_B_c_397_n ) capacitor c=9.23422e-19 //x=1.83 //y=1.4 \
 //x2=2.8 //y2=1.63
cc_250 ( N_A_c_313_n N_B_c_398_n ) capacitor c=0.00231304f //x=1.6 //y=2.26 \
 //x2=2.8 //y2=2.095
cc_251 ( N_A_c_318_n N_B_c_398_n ) capacitor c=0.00964411f //x=1.3 //y=2.095 \
 //x2=2.8 //y2=2.095
cc_252 ( N_A_c_313_n N_B_c_382_n ) capacitor c=0.00183762f //x=1.6 //y=2.26 \
 //x2=2.71 //y2=4.88
cc_253 ( N_A_c_336_n N_B_c_382_n ) capacitor c=0.0168581f //x=2.165 //y=4.97 \
 //x2=2.71 //y2=4.88
cc_254 ( N_A_c_331_n N_B_c_382_n ) capacitor c=0.00484466f //x=1.875 //y=4.97 \
 //x2=2.71 //y2=4.88
cc_255 ( N_A_c_318_n N_noxref_6_c_457_n ) capacitor c=0.0034165f //x=1.3 \
 //y=2.095 //x2=1.08 //y2=1.685
cc_256 ( N_A_c_313_n N_noxref_6_c_438_n ) capacitor c=0.0122915f //x=1.6 \
 //y=2.26 //x2=1.965 //y2=1.77
cc_257 ( N_A_c_317_n N_noxref_6_c_438_n ) capacitor c=0.00703864f //x=1.3 \
 //y=1.71 //x2=1.965 //y2=1.77
cc_258 ( N_A_c_318_n N_noxref_6_c_438_n ) capacitor c=0.0259045f //x=1.3 \
 //y=2.095 //x2=1.965 //y2=1.77
cc_259 ( N_A_c_320_n N_noxref_6_c_438_n ) capacitor c=0.00708583f //x=1.675 \
 //y=1.555 //x2=1.965 //y2=1.77
cc_260 ( N_A_c_323_n N_noxref_6_c_438_n ) capacitor c=0.00698822f //x=1.83 \
 //y=1.4 //x2=1.965 //y2=1.77
cc_261 ( N_A_c_314_n N_noxref_6_M0_noxref_s ) capacitor c=0.0327271f //x=1.3 \
 //y=1.055 //x2=0.945 //y2=0.555
cc_262 ( N_A_c_317_n N_noxref_6_M0_noxref_s ) capacitor c=7.99997e-19 //x=1.3 \
 //y=1.71 //x2=0.945 //y2=0.555
cc_263 ( N_A_c_318_n N_noxref_6_M0_noxref_s ) capacitor c=0.00122123f //x=1.3 \
 //y=2.095 //x2=0.945 //y2=0.555
cc_264 ( N_A_c_321_n N_noxref_6_M0_noxref_s ) capacitor c=0.0121427f //x=1.83 \
 //y=1.055 //x2=0.945 //y2=0.555
cc_265 ( N_A_c_313_n N_C_c_483_n ) capacitor c=0.00155228f //x=1.6 //y=2.26 \
 //x2=3.82 //y2=2.26
cc_266 ( N_B_c_390_n N_noxref_6_c_446_n ) capacitor c=0.0167228f //x=2.275 \
 //y=1.09 //x2=2.935 //y2=0.72
cc_267 ( N_B_c_395_n N_noxref_6_c_446_n ) capacitor c=0.00534519f //x=2.8 \
 //y=1.09 //x2=2.935 //y2=0.72
cc_268 ( N_B_c_368_n N_noxref_6_c_469_n ) capacitor c=0.0124072f //x=2.71 \
 //y=2.26 //x2=2.935 //y2=1.77
cc_269 ( N_B_c_393_n N_noxref_6_c_469_n ) capacitor c=0.0153476f //x=2.275 \
 //y=1.4 //x2=2.935 //y2=1.77
cc_270 ( N_B_c_398_n N_noxref_6_c_469_n ) capacitor c=0.023396f //x=2.8 \
 //y=2.095 //x2=2.935 //y2=1.77
cc_271 ( N_B_c_390_n N_noxref_6_M0_noxref_s ) capacitor c=0.00798959f \
 //x=2.275 //y=1.09 //x2=0.945 //y2=0.555
cc_272 ( N_B_c_397_n N_noxref_6_M0_noxref_s ) capacitor c=0.00212176f //x=2.8 \
 //y=1.63 //x2=0.945 //y2=0.555
cc_273 ( N_B_c_398_n N_noxref_6_M0_noxref_s ) capacitor c=0.00298115f //x=2.8 \
 //y=2.095 //x2=0.945 //y2=0.555
cc_274 ( N_B_c_368_n N_C_c_483_n ) capacitor c=0.05827f //x=2.71 //y=2.26 \
 //x2=3.82 //y2=2.26
cc_275 ( N_B_c_398_n N_C_c_483_n ) capacitor c=0.0023343f //x=2.8 //y=2.095 \
 //x2=3.82 //y2=2.26
cc_276 ( N_B_c_382_n N_C_c_483_n ) capacitor c=0.00142741f //x=2.71 //y=4.88 \
 //x2=3.82 //y2=2.26
cc_277 ( N_B_M6_noxref_g N_C_M8_noxref_g ) capacitor c=0.0101598f //x=2.68 \
 //y=6.2 //x2=3.56 //y2=6.2
cc_278 ( N_B_M7_noxref_g N_C_M8_noxref_g ) capacitor c=0.0602553f //x=3.12 \
 //y=6.2 //x2=3.56 //y2=6.2
cc_279 ( N_B_M7_noxref_g N_C_M9_noxref_g ) capacitor c=0.0101598f //x=3.12 \
 //y=6.2 //x2=4 //y2=6.2
cc_280 ( N_B_c_395_n N_C_c_497_n ) capacitor c=0.00456962f //x=2.8 //y=1.09 \
 //x2=3.81 //y2=1.095
cc_281 ( N_B_c_396_n N_C_c_498_n ) capacitor c=0.00438372f //x=2.8 //y=1.4 \
 //x2=3.81 //y2=1.44
cc_282 ( N_B_c_397_n N_C_c_499_n ) capacitor c=0.00438372f //x=2.8 //y=1.63 \
 //x2=3.81 //y2=1.75
cc_283 ( N_B_c_368_n N_C_c_506_n ) capacitor c=0.00228632f //x=2.71 //y=2.26 \
 //x2=3.82 //y2=2.26
cc_284 ( N_B_c_398_n N_C_c_506_n ) capacitor c=0.00933826f //x=2.8 //y=2.095 \
 //x2=3.82 //y2=2.26
cc_285 ( N_B_c_398_n N_C_c_507_n ) capacitor c=0.00438372f //x=2.8 //y=2.095 \
 //x2=3.82 //y2=2.095
cc_286 ( N_B_c_368_n N_C_c_509_n ) capacitor c=0.00219458f //x=2.71 //y=2.26 \
 //x2=3.82 //y2=4.88
cc_287 ( N_B_c_381_n N_C_c_509_n ) capacitor c=0.0611812f //x=3.045 //y=4.97 \
 //x2=3.82 //y2=4.88
cc_288 ( N_B_c_382_n N_C_c_509_n ) capacitor c=0.00487508f //x=2.71 //y=4.88 \
 //x2=3.82 //y2=4.88
cc_289 ( N_B_c_426_p N_noxref_8_c_537_n ) capacitor c=2.14837e-19 //x=2.645 \
 //y=0.935 //x2=3.505 //y2=1.175
cc_290 ( N_B_c_395_n N_noxref_8_c_537_n ) capacitor c=0.00123426f //x=2.8 \
 //y=1.09 //x2=3.505 //y2=1.175
cc_291 ( N_B_c_396_n N_noxref_8_c_537_n ) capacitor c=0.0129288f //x=2.8 \
 //y=1.4 //x2=3.505 //y2=1.175
cc_292 ( N_B_c_397_n N_noxref_8_c_537_n ) capacitor c=0.00142359f //x=2.8 \
 //y=1.63 //x2=3.505 //y2=1.175
cc_293 ( N_B_c_390_n N_noxref_8_M1_noxref_d ) capacitor c=0.00223875f \
 //x=2.275 //y=1.09 //x2=2.35 //y2=1.09
cc_294 ( N_B_c_393_n N_noxref_8_M1_noxref_d ) capacitor c=0.00262485f \
 //x=2.275 //y=1.4 //x2=2.35 //y2=1.09
cc_295 ( N_B_c_426_p N_noxref_8_M1_noxref_d ) capacitor c=0.00220746f \
 //x=2.645 //y=0.935 //x2=2.35 //y2=1.09
cc_296 ( N_B_c_433_p N_noxref_8_M1_noxref_d ) capacitor c=0.00194798f \
 //x=2.645 //y=1.555 //x2=2.35 //y2=1.09
cc_297 ( N_B_c_395_n N_noxref_8_M1_noxref_d ) capacitor c=0.00198465f //x=2.8 \
 //y=1.09 //x2=2.35 //y2=1.09
cc_298 ( N_B_c_396_n N_noxref_8_M1_noxref_d ) capacitor c=0.00128384f //x=2.8 \
 //y=1.4 //x2=2.35 //y2=1.09
cc_299 ( N_B_c_395_n N_noxref_8_M2_noxref_s ) capacitor c=7.21316e-19 //x=2.8 \
 //y=1.09 //x2=3.455 //y2=0.555
cc_300 ( N_B_c_396_n N_noxref_8_M2_noxref_s ) capacitor c=0.00348171f //x=2.8 \
 //y=1.4 //x2=3.455 //y2=0.555
cc_301 ( N_noxref_6_c_446_n N_noxref_8_c_537_n ) capacitor c=0.0136048f \
 //x=2.935 //y=0.72 //x2=3.505 //y2=1.175
cc_302 ( N_noxref_6_c_469_n N_noxref_8_c_537_n ) capacitor c=0.0102337f \
 //x=2.935 //y=1.77 //x2=3.505 //y2=1.175
cc_303 ( N_noxref_6_M0_noxref_s N_noxref_8_c_537_n ) capacitor c=0.023368f \
 //x=0.945 //y=0.555 //x2=3.505 //y2=1.175
cc_304 ( N_noxref_6_M0_noxref_s N_noxref_8_c_540_n ) capacitor c=0.0180035f \
 //x=0.945 //y=0.555 //x2=3.59 //y2=0.805
cc_305 ( N_noxref_6_c_446_n N_noxref_8_M1_noxref_d ) capacitor c=0.0129526f \
 //x=2.935 //y=0.72 //x2=2.35 //y2=1.09
cc_306 ( N_noxref_6_c_469_n N_noxref_8_M1_noxref_d ) capacitor c=0.0091401f \
 //x=2.935 //y=1.77 //x2=2.35 //y2=1.09
cc_307 ( N_noxref_6_M0_noxref_s N_noxref_8_M1_noxref_d ) capacitor \
 c=0.0159202f //x=0.945 //y=0.555 //x2=2.35 //y2=1.09
cc_308 ( N_noxref_6_M0_noxref_s N_noxref_8_M2_noxref_s ) capacitor \
 c=0.0213553f //x=0.945 //y=0.555 //x2=3.455 //y2=0.555
cc_309 ( N_C_c_483_n N_noxref_8_c_544_n ) capacitor c=0.00210069f //x=3.82 \
 //y=2.26 //x2=4.475 //y2=0.72
cc_310 ( N_C_c_497_n N_noxref_8_c_544_n ) capacitor c=0.0192822f //x=3.81 \
 //y=1.095 //x2=4.475 //y2=0.72
cc_311 ( N_C_c_503_n N_noxref_8_c_544_n ) capacitor c=0.00656458f //x=4.34 \
 //y=1.095 //x2=4.475 //y2=0.72
cc_312 ( N_C_c_506_n N_noxref_8_c_544_n ) capacitor c=2.20712e-19 //x=3.82 \
 //y=2.26 //x2=4.475 //y2=0.72
cc_313 ( N_C_c_498_n N_noxref_8_c_558_n ) capacitor c=0.00538829f //x=3.81 \
 //y=1.44 //x2=3.59 //y2=1.175
cc_314 ( N_C_c_497_n N_noxref_8_M2_noxref_s ) capacitor c=0.00538829f //x=3.81 \
 //y=1.095 //x2=3.455 //y2=0.555
cc_315 ( N_C_c_499_n N_noxref_8_M2_noxref_s ) capacitor c=0.00538829f //x=3.81 \
 //y=1.75 //x2=3.455 //y2=0.555
cc_316 ( N_C_c_503_n N_noxref_8_M2_noxref_s ) capacitor c=0.0143002f //x=4.34 \
 //y=1.095 //x2=3.455 //y2=0.555
cc_317 ( N_C_c_504_n N_noxref_8_M2_noxref_s ) capacitor c=0.00290153f //x=4.34 \
 //y=1.44 //x2=3.455 //y2=0.555
