// File: dffx1_pcell.spi.DFFX1_PCELL.pxi
// Created: Sun Apr 12 08:40:32 2026
//
simulator lang=spectre
x_PM_DFFX1_PCELL\%noxref_1 ( N_noxref_1_c_25_p N_noxref_1_c_28_p \
 N_noxref_1_c_29_p N_noxref_1_c_30_p N_noxref_1_c_158_p N_noxref_1_c_2_p \
 N_noxref_1_c_8_p N_noxref_1_c_3_p N_noxref_1_c_89_p N_noxref_1_c_4_p \
 N_noxref_1_c_136_p N_noxref_1_c_6_p N_noxref_1_c_5_p N_noxref_1_c_9_p \
 N_noxref_1_c_31_p N_noxref_1_c_39_p N_noxref_1_c_10_p N_noxref_1_c_11_p \
 N_noxref_1_c_17_p N_noxref_1_c_275_p N_noxref_1_c_18_p N_noxref_1_c_187_p \
 N_noxref_1_c_12_p N_noxref_1_c_7_p N_noxref_1_c_43_p N_noxref_1_c_32_p \
 N_noxref_1_c_103_p N_noxref_1_c_115_p N_noxref_1_c_116_p N_noxref_1_c_117_p \
 N_noxref_1_c_19_p N_noxref_1_c_138_p N_noxref_1_c_26_p N_noxref_1_c_35_p \
 N_noxref_1_c_121_p N_noxref_1_c_235_p N_noxref_1_c_179_p N_noxref_1_c_13_p \
 N_noxref_1_M2_noxref_g N_noxref_1_M5_noxref_g N_noxref_1_M17_noxref_g \
 N_noxref_1_M18_noxref_g N_noxref_1_M23_noxref_g N_noxref_1_M24_noxref_g \
 N_noxref_1_c_55_p N_noxref_1_c_56_p N_noxref_1_c_57_p N_noxref_1_c_79_p \
 N_noxref_1_c_80_p N_noxref_1_c_81_p N_noxref_1_c_82_p N_noxref_1_c_211_p \
 N_noxref_1_c_212_p N_noxref_1_c_214_p N_noxref_1_c_189_p N_noxref_1_c_351_p \
 N_noxref_1_c_352_p N_noxref_1_c_213_p N_noxref_1_c_215_p N_noxref_1_c_27_p \
 N_noxref_1_c_61_p N_noxref_1_c_36_p N_noxref_1_c_16_p N_noxref_1_M4_noxref_d \
 N_noxref_1_M19_noxref_d N_noxref_1_M21_noxref_d )  PM_DFFX1_PCELL\%noxref_1
x_PM_DFFX1_PCELL\%noxref_2 ( N_noxref_2_c_411_n N_noxref_2_c_412_n \
 N_noxref_2_c_517_p N_noxref_2_c_481_p N_noxref_2_c_413_n N_noxref_2_c_414_n \
 N_noxref_2_c_483_p N_noxref_2_c_416_n N_noxref_2_c_441_p N_noxref_2_c_442_p \
 N_noxref_2_c_418_n N_noxref_2_c_453_p N_noxref_2_c_520_p N_noxref_2_c_427_n \
 N_noxref_2_c_428_n N_noxref_2_c_443_p N_noxref_2_c_447_p N_noxref_2_c_435_p \
 N_noxref_2_c_436_p N_noxref_2_c_488_p N_noxref_2_c_429_n N_noxref_2_c_445_p \
 N_noxref_2_c_430_n N_noxref_2_c_541_p N_noxref_2_c_446_p N_noxref_2_c_437_p \
 N_noxref_2_M7_noxref_g N_noxref_2_M27_noxref_g N_noxref_2_M28_noxref_g \
 N_noxref_2_c_466_p N_noxref_2_c_467_p N_noxref_2_c_469_p N_noxref_2_c_449_p \
 N_noxref_2_c_635_p N_noxref_2_c_636_p N_noxref_2_c_468_p N_noxref_2_c_470_p \
 N_noxref_2_c_438_p N_noxref_2_M6_noxref_d N_noxref_2_M23_noxref_d \
 N_noxref_2_M25_noxref_d )  PM_DFFX1_PCELL\%noxref_2
x_PM_DFFX1_PCELL\%noxref_3 ( N_noxref_3_c_687_n N_noxref_3_c_690_n \
 N_noxref_3_c_696_n N_noxref_3_c_727_n N_noxref_3_c_731_n N_noxref_3_c_739_n \
 N_noxref_3_c_699_n N_noxref_3_c_744_n N_noxref_3_c_706_n N_noxref_3_c_707_n \
 N_noxref_3_c_711_n N_noxref_3_c_748_n N_noxref_3_c_752_n \
 N_noxref_3_M1_noxref_g N_noxref_3_M8_noxref_g N_noxref_3_M15_noxref_g \
 N_noxref_3_M16_noxref_g N_noxref_3_M29_noxref_g N_noxref_3_M30_noxref_g \
 N_noxref_3_c_887_p N_noxref_3_c_889_p N_noxref_3_c_937_p N_noxref_3_c_938_p \
 N_noxref_3_c_717_n N_noxref_3_c_718_n N_noxref_3_c_719_n N_noxref_3_c_720_n \
 N_noxref_3_c_724_n N_noxref_3_c_758_n N_noxref_3_c_761_n N_noxref_3_c_763_n \
 N_noxref_3_c_842_p N_noxref_3_c_855_p N_noxref_3_c_830_p N_noxref_3_c_766_n \
 N_noxref_3_c_767_n N_noxref_3_c_725_n N_noxref_3_c_768_n N_noxref_3_c_832_p \
 N_noxref_3_c_771_n )  PM_DFFX1_PCELL\%noxref_3
x_PM_DFFX1_PCELL\%noxref_4 ( N_noxref_4_c_1091_n N_noxref_4_c_973_n \
 N_noxref_4_c_974_n N_noxref_4_c_977_n N_noxref_4_c_982_n N_noxref_4_c_991_n \
 N_noxref_4_c_997_n N_noxref_4_c_1002_n N_noxref_4_c_1004_n \
 N_noxref_4_c_1015_n N_noxref_4_c_1017_n N_noxref_4_c_1021_n \
 N_noxref_4_c_1026_n N_noxref_4_c_1102_n N_noxref_4_c_1132_p \
 N_noxref_4_c_1143_p N_noxref_4_c_1103_n N_noxref_4_c_1030_n \
 N_noxref_4_c_1034_n N_noxref_4_c_1260_p N_noxref_4_c_1035_n \
 N_noxref_4_c_1036_n N_noxref_4_c_1038_n N_noxref_4_c_1298_p \
 N_noxref_4_c_1133_p N_noxref_4_c_1138_p N_noxref_4_c_1110_n \
 N_noxref_4_c_1040_n N_noxref_4_c_1042_n N_noxref_4_c_1044_n \
 N_noxref_4_c_1047_n N_noxref_4_c_1051_n N_noxref_4_c_1055_n \
 N_noxref_4_c_1077_n N_noxref_4_c_1082_n N_noxref_4_c_1085_n \
 N_noxref_4_c_1089_n N_noxref_4_c_1172_p N_noxref_4_c_1122_n \
 N_noxref_4_c_1057_n N_noxref_4_c_1264_p N_noxref_4_c_1062_n \
 N_noxref_4_c_1302_p N_noxref_4_c_1193_p N_noxref_4_M3_noxref_g \
 N_noxref_4_M9_noxref_g N_noxref_4_M19_noxref_g N_noxref_4_M20_noxref_g \
 N_noxref_4_M31_noxref_g N_noxref_4_M32_noxref_g N_noxref_4_c_1280_p \
 N_noxref_4_c_1281_p N_noxref_4_c_1283_p N_noxref_4_c_1269_p \
 N_noxref_4_c_1359_p N_noxref_4_c_1360_p N_noxref_4_c_1282_p \
 N_noxref_4_c_1284_p N_noxref_4_c_1318_p N_noxref_4_c_1319_p \
 N_noxref_4_c_1321_p N_noxref_4_c_1307_p N_noxref_4_c_1371_p \
 N_noxref_4_c_1372_p N_noxref_4_c_1320_p N_noxref_4_c_1322_p \
 N_noxref_4_c_1069_n N_noxref_4_c_1225_p N_noxref_4_M2_noxref_d \
 N_noxref_4_M13_noxref_d N_noxref_4_M15_noxref_d N_noxref_4_M17_noxref_d )  \
 PM_DFFX1_PCELL\%noxref_4
x_PM_DFFX1_PCELL\%noxref_5 ( N_noxref_5_c_1572_n N_noxref_5_c_1438_n \
 N_noxref_5_c_1577_n N_noxref_5_c_1440_n N_noxref_5_c_1441_n \
 N_noxref_5_c_1449_n N_noxref_5_c_1450_n N_noxref_5_c_1508_n \
 N_noxref_5_c_1509_n N_noxref_5_c_1597_n N_noxref_5_c_1598_n \
 N_noxref_5_c_1510_n N_noxref_5_c_1511_n N_noxref_5_c_1605_n \
 N_noxref_5_c_1514_n N_noxref_5_c_1819_p N_noxref_5_c_1837_p \
 N_noxref_5_c_1820_p N_noxref_5_c_1612_n N_noxref_5_c_1455_n \
 N_noxref_5_c_1456_n N_noxref_5_c_1518_n N_noxref_5_c_1614_n \
 N_noxref_5_c_1731_p N_noxref_5_c_1527_n N_noxref_5_c_1623_n \
 N_noxref_5_c_1755_p N_noxref_5_c_1828_p N_noxref_5_c_1459_n \
 N_noxref_5_c_1463_n N_noxref_5_c_1464_n N_noxref_5_c_1465_n \
 N_noxref_5_c_1528_n N_noxref_5_c_1466_n N_noxref_5_c_1713_n \
 N_noxref_5_c_1635_n N_noxref_5_c_1636_n N_noxref_5_c_1637_n \
 N_noxref_5_c_1641_n N_noxref_5_c_1470_n N_noxref_5_c_1474_n \
 N_noxref_5_c_1535_n N_noxref_5_c_1644_n N_noxref_5_c_1830_p \
 N_noxref_5_c_1756_p N_noxref_5_M0_noxref_g N_noxref_5_M6_noxref_g \
 N_noxref_5_M12_noxref_g N_noxref_5_M13_noxref_g N_noxref_5_M14_noxref_g \
 N_noxref_5_M25_noxref_g N_noxref_5_M26_noxref_g N_noxref_5_M37_noxref_g \
 N_noxref_5_M38_noxref_g N_noxref_5_c_1651_n N_noxref_5_c_1652_n \
 N_noxref_5_c_1653_n N_noxref_5_c_1654_n N_noxref_5_c_1869_p \
 N_noxref_5_c_1885_p N_noxref_5_c_1657_n N_noxref_5_c_1659_n \
 N_noxref_5_c_1662_n N_noxref_5_c_1665_n N_noxref_5_c_1480_n \
 N_noxref_5_c_1483_n N_noxref_5_c_1485_n N_noxref_5_c_1552_n \
 N_noxref_5_c_1555_n N_noxref_5_c_1557_n N_noxref_5_c_1488_n \
 N_noxref_5_c_1489_n N_noxref_5_c_1852_p N_noxref_5_c_1854_p \
 N_noxref_5_c_1855_p N_noxref_5_c_1757_p N_noxref_5_c_1952_p \
 N_noxref_5_c_1928_p N_noxref_5_c_1861_p N_noxref_5_c_1864_p \
 N_noxref_5_c_1490_n N_noxref_5_c_1568_n N_noxref_5_c_1493_n \
 N_noxref_5_c_1831_p N_noxref_5_c_1930_p N_noxref_5_c_1758_p \
 N_noxref_5_M8_noxref_d N_noxref_5_M27_noxref_d N_noxref_5_M29_noxref_d )  \
 PM_DFFX1_PCELL\%noxref_5
x_PM_DFFX1_PCELL\%noxref_6 ( N_noxref_6_c_2010_n N_noxref_6_c_2117_n \
 N_noxref_6_c_2155_n N_noxref_6_c_2118_n N_noxref_6_c_2020_n \
 N_noxref_6_c_2166_n N_noxref_6_c_2022_n N_noxref_6_c_2025_n \
 N_noxref_6_c_2030_n N_noxref_6_c_2080_n N_noxref_6_c_2085_n \
 N_noxref_6_c_2120_n N_noxref_6_c_2170_n N_noxref_6_c_2297_p \
 N_noxref_6_c_2341_p N_noxref_6_c_2231_n N_noxref_6_c_2233_n \
 N_noxref_6_c_2033_n N_noxref_6_c_2038_n N_noxref_6_c_2091_n \
 N_noxref_6_c_2126_n N_noxref_6_c_2256_n N_noxref_6_M13_noxref_s \
 N_noxref_6_M14_noxref_d N_noxref_6_M16_noxref_d N_noxref_6_M18_noxref_d \
 N_noxref_6_M19_noxref_s N_noxref_6_M20_noxref_d N_noxref_6_M22_noxref_d \
 N_noxref_6_M23_noxref_s N_noxref_6_M24_noxref_d N_noxref_6_M26_noxref_d \
 N_noxref_6_M27_noxref_s N_noxref_6_M28_noxref_d N_noxref_6_M30_noxref_d \
 N_noxref_6_M31_noxref_s N_noxref_6_M32_noxref_d N_noxref_6_M34_noxref_d \
 N_noxref_6_M35_noxref_s N_noxref_6_M36_noxref_d N_noxref_6_M38_noxref_d )  \
 PM_DFFX1_PCELL\%noxref_6
x_PM_DFFX1_PCELL\%noxref_7 ( N_noxref_7_c_2401_n N_noxref_7_c_2428_p \
 N_noxref_7_c_2391_n N_noxref_7_c_2430_p N_noxref_7_c_2396_n \
 N_noxref_7_M1_noxref_d N_noxref_7_M2_noxref_s )  PM_DFFX1_PCELL\%noxref_7
x_PM_DFFX1_PCELL\%noxref_8 ( N_noxref_8_c_2455_n N_noxref_8_c_2463_n \
 N_noxref_8_c_2465_n N_noxref_8_c_2466_n N_noxref_8_M4_noxref_g \
 N_noxref_8_M21_noxref_g N_noxref_8_M22_noxref_g N_noxref_8_c_2474_n \
 N_noxref_8_c_2476_n N_noxref_8_c_2479_n N_noxref_8_c_2480_n \
 N_noxref_8_c_2483_n N_noxref_8_c_2485_n N_noxref_8_c_2489_n \
 N_noxref_8_c_2491_n N_noxref_8_c_2495_n N_noxref_8_c_2496_n \
 N_noxref_8_c_2498_n )  PM_DFFX1_PCELL\%noxref_8
x_PM_DFFX1_PCELL\%noxref_9 ( N_noxref_9_c_2566_n N_noxref_9_c_2575_n \
 N_noxref_9_c_2578_n N_noxref_9_c_2582_n N_noxref_9_M10_noxref_g \
 N_noxref_9_M33_noxref_g N_noxref_9_M34_noxref_g N_noxref_9_c_2588_n \
 N_noxref_9_c_2591_n N_noxref_9_c_2593_n N_noxref_9_c_2613_n \
 N_noxref_9_c_2641_p N_noxref_9_c_2623_p N_noxref_9_c_2596_n \
 N_noxref_9_c_2597_n N_noxref_9_c_2598_n N_noxref_9_c_2625_p \
 N_noxref_9_c_2601_n )  PM_DFFX1_PCELL\%noxref_9
x_PM_DFFX1_PCELL\%noxref_10 ( N_noxref_10_c_2671_n N_noxref_10_c_2687_n \
 N_noxref_10_c_2703_n N_noxref_10_c_2746_n N_noxref_10_c_2688_n \
 N_noxref_10_c_2672_n N_noxref_10_c_2674_n N_noxref_10_c_2697_n \
 N_noxref_10_c_2719_n N_noxref_10_c_2698_n N_noxref_10_c_2680_n \
 N_noxref_10_c_2730_n N_noxref_10_M10_noxref_d N_noxref_10_M31_noxref_d \
 N_noxref_10_M33_noxref_d )  PM_DFFX1_PCELL\%noxref_10
x_PM_DFFX1_PCELL\%noxref_11 ( N_noxref_11_c_2803_n N_noxref_11_c_2807_n \
 N_noxref_11_c_2811_n N_noxref_11_c_2817_n N_noxref_11_c_2821_n \
 N_noxref_11_M11_noxref_g N_noxref_11_M35_noxref_g N_noxref_11_M36_noxref_g \
 N_noxref_11_c_2827_n N_noxref_11_c_2828_n N_noxref_11_c_2829_n \
 N_noxref_11_c_2831_n N_noxref_11_c_2863_p N_noxref_11_c_2864_p \
 N_noxref_11_c_2835_n N_noxref_11_c_2837_n N_noxref_11_c_2840_n )  \
 PM_DFFX1_PCELL\%noxref_11
x_PM_DFFX1_PCELL\%noxref_12 ( N_noxref_12_c_3190_p N_noxref_12_c_3057_n \
 N_noxref_12_c_2906_n N_noxref_12_c_2907_n N_noxref_12_c_2951_n \
 N_noxref_12_c_2993_n N_noxref_12_c_3137_n N_noxref_12_c_3065_n \
 N_noxref_12_c_3067_n N_noxref_12_c_2910_n N_noxref_12_c_3012_n \
 N_noxref_12_c_2913_n N_noxref_12_c_2923_n N_noxref_12_c_2958_n \
 N_noxref_12_c_2968_n N_noxref_12_c_3015_n N_noxref_12_c_3024_n \
 N_noxref_12_c_3148_n N_noxref_12_c_3163_n N_noxref_12_c_2926_n \
 N_noxref_12_c_3082_n N_noxref_12_c_2927_n N_noxref_12_c_2928_n \
 N_noxref_12_c_2973_n N_noxref_12_c_3029_n N_noxref_12_c_2929_n \
 N_noxref_12_c_2930_n N_noxref_12_c_2935_n N_noxref_12_c_2976_n \
 N_noxref_12_c_2995_n N_noxref_12_c_3100_n N_noxref_12_M0_noxref_d \
 N_noxref_12_M3_noxref_d N_noxref_12_M5_noxref_d N_noxref_12_M7_noxref_d \
 N_noxref_12_M9_noxref_d N_noxref_12_M11_noxref_d )  PM_DFFX1_PCELL\%noxref_12
x_PM_DFFX1_PCELL\%noxref_13 ( N_noxref_13_c_3326_n N_noxref_13_c_3332_n \
 N_noxref_13_c_3337_n N_noxref_13_c_3338_n N_noxref_13_c_3405_n \
 N_noxref_13_c_3340_n N_noxref_13_c_3351_n N_noxref_13_c_3352_n \
 N_noxref_13_c_3389_n N_noxref_13_c_3356_n N_noxref_13_c_3394_n \
 N_noxref_13_c_3362_n N_noxref_13_M12_noxref_d N_noxref_13_M35_noxref_d \
 N_noxref_13_M37_noxref_d )  PM_DFFX1_PCELL\%noxref_13
x_PM_DFFX1_PCELL\%noxref_14 ( N_noxref_14_c_3452_n N_noxref_14_c_3453_n \
 N_noxref_14_c_3464_n N_noxref_14_c_3442_n N_noxref_14_c_3444_n \
 N_noxref_14_M0_noxref_s )  PM_DFFX1_PCELL\%noxref_14
x_PM_DFFX1_PCELL\%noxref_15 ( N_noxref_15_c_3494_n N_noxref_15_c_3495_n \
 N_noxref_15_c_3538_n N_noxref_15_c_3497_n N_noxref_15_c_3499_n \
 N_noxref_15_c_3547_n N_noxref_15_M3_noxref_s )  PM_DFFX1_PCELL\%noxref_15
x_PM_DFFX1_PCELL\%noxref_16 ( N_noxref_16_c_3560_n N_noxref_16_c_3562_n \
 N_noxref_16_c_3603_n N_noxref_16_c_3570_n N_noxref_16_c_3575_n \
 N_noxref_16_c_3612_n N_noxref_16_M5_noxref_s )  PM_DFFX1_PCELL\%noxref_16
x_PM_DFFX1_PCELL\%noxref_17 ( N_noxref_17_c_3628_n N_noxref_17_c_3630_n \
 N_noxref_17_c_3669_n N_noxref_17_c_3638_n N_noxref_17_c_3645_n \
 N_noxref_17_c_3678_n N_noxref_17_M7_noxref_s )  PM_DFFX1_PCELL\%noxref_17
x_PM_DFFX1_PCELL\%noxref_18 ( N_noxref_18_c_3694_n N_noxref_18_c_3696_n \
 N_noxref_18_c_3732_n N_noxref_18_c_3704_n N_noxref_18_c_3711_n \
 N_noxref_18_c_3741_n N_noxref_18_M9_noxref_s )  PM_DFFX1_PCELL\%noxref_18
x_PM_DFFX1_PCELL\%noxref_19 ( N_noxref_19_c_3769_n N_noxref_19_c_3770_n \
 N_noxref_19_c_3785_n N_noxref_19_c_3757_n N_noxref_19_c_3761_n \
 N_noxref_19_c_3792_n N_noxref_19_M11_noxref_s )  PM_DFFX1_PCELL\%noxref_19
cc_1 ( N_noxref_1_M24_noxref_g N_noxref_2_c_411_n ) capacitor c=0.00889217f \
 //x=9.59 //y=6.02 //x2=10.135 //y2=5.2
cc_2 ( N_noxref_1_c_2_p N_noxref_2_c_412_n ) capacitor c=0.00324213f //x=6.96 \
 //y=1.57 //x2=10.29 //y2=1.57
cc_3 ( N_noxref_1_c_3_p N_noxref_2_c_413_n ) capacitor c=0.00231467f //x=7.315 \
 //y=1.655 //x2=10.375 //y2=1.655
cc_4 ( N_noxref_1_c_4_p N_noxref_2_c_414_n ) capacitor c=0.00204244f //x=7.4 \
 //y=3.17 //x2=10.73 //y2=3.17
cc_5 ( N_noxref_1_c_5_p N_noxref_2_c_414_n ) capacitor c=0.00326312f //x=9.25 \
 //y=3.165 //x2=10.73 //y2=3.17
cc_6 ( N_noxref_1_c_6_p N_noxref_2_c_416_n ) capacitor c=0.00281705f //x=7.4 \
 //y=5.115 //x2=10.73 //y2=5.115
cc_7 ( N_noxref_1_c_7_p N_noxref_2_c_416_n ) capacitor c=0.00193818f //x=9.252 \
 //y=4.56 //x2=10.73 //y2=5.115
cc_8 ( N_noxref_1_c_8_p N_noxref_2_c_418_n ) capacitor c=0.00114153f //x=7.315 \
 //y=5.2 //x2=9.37 //y2=5.38
cc_9 ( N_noxref_1_c_9_p N_noxref_2_c_418_n ) capacitor c=5.6496e-19 //x=9.25 \
 //y=3.485 //x2=9.37 //y2=5.38
cc_10 ( N_noxref_1_c_10_p N_noxref_2_c_418_n ) capacitor c=5.29822e-19 \
 //x=6.92 //y=5.2 //x2=9.37 //y2=5.38
cc_11 ( N_noxref_1_c_11_p N_noxref_2_c_418_n ) capacitor c=0.00147119f \
 //x=6.92 //y=5.38 //x2=9.37 //y2=5.38
cc_12 ( N_noxref_1_c_12_p N_noxref_2_c_418_n ) capacitor c=0.0117744f //x=9.25 \
 //y=4.7 //x2=9.37 //y2=5.38
cc_13 ( N_noxref_1_c_13_p N_noxref_2_c_418_n ) capacitor c=0.00277154f \
 //x=9.25 //y=4.7 //x2=9.37 //y2=5.38
cc_14 ( N_noxref_1_M23_noxref_g N_noxref_2_c_418_n ) capacitor c=0.00201806f \
 //x=9.15 //y=6.02 //x2=9.37 //y2=5.38
cc_15 ( N_noxref_1_M24_noxref_g N_noxref_2_c_418_n ) capacitor c=0.00192712f \
 //x=9.59 //y=6.02 //x2=9.37 //y2=5.38
cc_16 ( N_noxref_1_c_16_p N_noxref_2_c_418_n ) capacitor c=0.00194573f \
 //x=9.25 //y=4.7 //x2=9.37 //y2=5.38
cc_17 ( N_noxref_1_c_17_p N_noxref_2_c_427_n ) capacitor c=6.99317e-19 \
 //x=6.96 //y=1 //x2=10.29 //y2=1
cc_18 ( N_noxref_1_c_18_p N_noxref_2_c_428_n ) capacitor c=0.00251357f \
 //x=9.25 //y=3.33 //x2=10.73 //y2=3.33
cc_19 ( N_noxref_1_c_19_p N_noxref_2_c_429_n ) capacitor c=0.00518466f \
 //x=9.245 //y=3.325 //x2=10.895 //y2=3.33
cc_20 ( N_noxref_1_c_12_p N_noxref_2_c_430_n ) capacitor c=0.00104426f \
 //x=9.25 //y=4.7 //x2=9.37 //y2=5.38
cc_21 ( N_noxref_1_c_13_p N_noxref_2_c_430_n ) capacitor c=0.00377369f \
 //x=9.25 //y=4.7 //x2=9.37 //y2=5.38
cc_22 ( N_noxref_1_M23_noxref_g N_noxref_2_c_430_n ) capacitor c=0.0158358f \
 //x=9.15 //y=6.02 //x2=9.37 //y2=5.38
cc_23 ( N_noxref_1_M24_noxref_g N_noxref_2_c_430_n ) capacitor c=0.0178987f \
 //x=9.59 //y=6.02 //x2=9.37 //y2=5.38
cc_24 ( N_noxref_1_c_16_p N_noxref_2_c_430_n ) capacitor c=0.0043218f //x=9.25 \
 //y=4.7 //x2=9.37 //y2=5.38
cc_25 ( N_noxref_1_c_25_p N_noxref_3_c_687_n ) capacitor c=0.0116288f //x=3.33 \
 //y=2.195 //x2=2.22 //y2=2.195
cc_26 ( N_noxref_1_c_26_p N_noxref_3_c_687_n ) capacitor c=5.42289e-19 \
 //x=3.33 //y=2.08 //x2=2.22 //y2=2.195
cc_27 ( N_noxref_1_c_27_p N_noxref_3_c_687_n ) capacitor c=0.00139071f \
 //x=3.33 //y=2.08 //x2=2.22 //y2=2.195
cc_28 ( N_noxref_1_c_28_p N_noxref_3_c_690_n ) capacitor c=0.029075f //x=3.33 \
 //y=3.17 //x2=2.22 //y2=4.54
cc_29 ( N_noxref_1_c_29_p N_noxref_3_c_690_n ) capacitor c=0.00769355f \
 //x=3.33 //y=3.49 //x2=2.22 //y2=4.54
cc_30 ( N_noxref_1_c_30_p N_noxref_3_c_690_n ) capacitor c=0.0251329f //x=3.33 \
 //y=4.57 //x2=2.22 //y2=4.54
cc_31 ( N_noxref_1_c_31_p N_noxref_3_c_690_n ) capacitor c=3.35971e-19 \
 //x=3.33 //y=3.33 //x2=2.22 //y2=4.54
cc_32 ( N_noxref_1_c_32_p N_noxref_3_c_690_n ) capacitor c=0.00514279f \
 //x=3.495 //y=3.33 //x2=2.22 //y2=4.54
cc_33 ( N_noxref_1_c_26_p N_noxref_3_c_690_n ) capacitor c=4.16726e-19 \
 //x=3.33 //y=2.08 //x2=2.22 //y2=4.54
cc_34 ( N_noxref_1_c_30_p N_noxref_3_c_696_n ) capacitor c=0.00713797f \
 //x=3.33 //y=4.57 //x2=2.22 //y2=4.7
cc_35 ( N_noxref_1_c_35_p N_noxref_3_c_696_n ) capacitor c=6.80672e-19 \
 //x=3.33 //y=4.7 //x2=2.22 //y2=4.7
cc_36 ( N_noxref_1_c_36_p N_noxref_3_c_696_n ) capacitor c=0.00153715f \
 //x=3.33 //y=4.7 //x2=2.22 //y2=4.7
cc_37 ( N_noxref_1_c_30_p N_noxref_3_c_699_n ) capacitor c=0.0290946f //x=3.33 \
 //y=4.57 //x2=9.61 //y2=4.44
cc_38 ( N_noxref_1_c_6_p N_noxref_3_c_699_n ) capacitor c=0.0287614f //x=7.4 \
 //y=5.115 //x2=9.61 //y2=4.44
cc_39 ( N_noxref_1_c_39_p N_noxref_3_c_699_n ) capacitor c=0.0223096f //x=6.04 \
 //y=5.38 //x2=9.61 //y2=4.44
cc_40 ( N_noxref_1_c_10_p N_noxref_3_c_699_n ) capacitor c=0.0204096f //x=6.92 \
 //y=5.2 //x2=9.61 //y2=4.44
cc_41 ( N_noxref_1_c_12_p N_noxref_3_c_699_n ) capacitor c=0.00405241f \
 //x=9.25 //y=4.7 //x2=9.61 //y2=4.44
cc_42 ( N_noxref_1_c_7_p N_noxref_3_c_699_n ) capacitor c=0.0271167f //x=9.252 \
 //y=4.56 //x2=9.61 //y2=4.44
cc_43 ( N_noxref_1_c_43_p N_noxref_3_c_699_n ) capacitor c=0.00206462f \
 //x=3.685 //y=3.33 //x2=9.61 //y2=4.44
cc_44 ( N_noxref_1_c_30_p N_noxref_3_c_706_n ) capacitor c=0.00732998f \
 //x=3.33 //y=4.57 //x2=2.22 //y2=4.44
cc_45 ( N_noxref_1_c_25_p N_noxref_3_c_707_n ) capacitor c=5.39999e-19 \
 //x=3.33 //y=2.195 //x2=2.22 //y2=2.08
cc_46 ( N_noxref_1_c_28_p N_noxref_3_c_707_n ) capacitor c=4.16726e-19 \
 //x=3.33 //y=3.17 //x2=2.22 //y2=2.08
cc_47 ( N_noxref_1_c_26_p N_noxref_3_c_707_n ) capacitor c=0.00125213f \
 //x=3.33 //y=2.08 //x2=2.22 //y2=2.08
cc_48 ( N_noxref_1_c_27_p N_noxref_3_c_707_n ) capacitor c=0.00204868f \
 //x=3.33 //y=2.08 //x2=2.22 //y2=2.08
cc_49 ( N_noxref_1_c_30_p N_noxref_3_c_711_n ) capacitor c=2.50728e-19 \
 //x=3.33 //y=4.57 //x2=2.22 //y2=4.7
cc_50 ( N_noxref_1_c_35_p N_noxref_3_c_711_n ) capacitor c=0.00114249f \
 //x=3.33 //y=4.7 //x2=2.22 //y2=4.7
cc_51 ( N_noxref_1_c_36_p N_noxref_3_c_711_n ) capacitor c=0.00195911f \
 //x=3.33 //y=4.7 //x2=2.22 //y2=4.7
cc_52 ( N_noxref_1_M17_noxref_g N_noxref_3_M15_noxref_g ) capacitor \
 c=0.0101598f //x=3.07 //y=6.02 //x2=2.19 //y2=6.02
cc_53 ( N_noxref_1_M17_noxref_g N_noxref_3_M16_noxref_g ) capacitor \
 c=0.0607232f //x=3.07 //y=6.02 //x2=2.63 //y2=6.02
cc_54 ( N_noxref_1_M18_noxref_g N_noxref_3_M16_noxref_g ) capacitor \
 c=0.0101598f //x=3.51 //y=6.02 //x2=2.63 //y2=6.02
cc_55 ( N_noxref_1_c_55_p N_noxref_3_c_717_n ) capacitor c=0.00456962f \
 //x=3.32 //y=0.915 //x2=2.31 //y2=0.91
cc_56 ( N_noxref_1_c_56_p N_noxref_3_c_718_n ) capacitor c=0.00438372f \
 //x=3.32 //y=1.26 //x2=2.31 //y2=1.22
cc_57 ( N_noxref_1_c_57_p N_noxref_3_c_719_n ) capacitor c=0.00438372f \
 //x=3.32 //y=1.57 //x2=2.31 //y2=1.45
cc_58 ( N_noxref_1_c_25_p N_noxref_3_c_720_n ) capacitor c=0.00141236f \
 //x=3.33 //y=2.195 //x2=2.31 //y2=1.915
cc_59 ( N_noxref_1_c_26_p N_noxref_3_c_720_n ) capacitor c=0.00209664f \
 //x=3.33 //y=2.08 //x2=2.31 //y2=1.915
cc_60 ( N_noxref_1_c_27_p N_noxref_3_c_720_n ) capacitor c=0.00933826f \
 //x=3.33 //y=2.08 //x2=2.31 //y2=1.915
cc_61 ( N_noxref_1_c_61_p N_noxref_3_c_720_n ) capacitor c=0.00438372f \
 //x=3.33 //y=1.915 //x2=2.31 //y2=1.915
cc_62 ( N_noxref_1_c_36_p N_noxref_3_c_724_n ) capacitor c=0.0616491f //x=3.33 \
 //y=4.7 //x2=2.555 //y2=4.79
cc_63 ( N_noxref_1_c_35_p N_noxref_3_c_725_n ) capacitor c=9.8646e-19 //x=3.33 \
 //y=4.7 //x2=2.22 //y2=4.7
cc_64 ( N_noxref_1_c_36_p N_noxref_3_c_725_n ) capacitor c=0.00428612f \
 //x=3.33 //y=4.7 //x2=2.22 //y2=4.7
cc_65 ( N_noxref_1_M17_noxref_g N_noxref_4_c_973_n ) capacitor c=0.00955829f \
 //x=3.07 //y=6.02 //x2=3.175 //y2=5.155
cc_66 ( N_noxref_1_c_39_p N_noxref_4_c_974_n ) capacitor c=5.58535e-19 \
 //x=6.04 //y=5.38 //x2=3.29 //y2=5.38
cc_67 ( N_noxref_1_M17_noxref_g N_noxref_4_c_974_n ) capacitor c=0.00226521f \
 //x=3.07 //y=6.02 //x2=3.29 //y2=5.38
cc_68 ( N_noxref_1_M18_noxref_g N_noxref_4_c_974_n ) capacitor c=0.00368945f \
 //x=3.51 //y=6.02 //x2=3.29 //y2=5.38
cc_69 ( N_noxref_1_c_29_p N_noxref_4_c_977_n ) capacitor c=0.00109953f \
 //x=3.33 //y=3.49 //x2=3.985 //y2=5.155
cc_70 ( N_noxref_1_c_30_p N_noxref_4_c_977_n ) capacitor c=0.00228791f \
 //x=3.33 //y=4.57 //x2=3.985 //y2=5.155
cc_71 ( N_noxref_1_c_39_p N_noxref_4_c_977_n ) capacitor c=0.00104762f \
 //x=6.04 //y=5.38 //x2=3.985 //y2=5.155
cc_72 ( N_noxref_1_c_35_p N_noxref_4_c_977_n ) capacitor c=0.00130631f \
 //x=3.33 //y=4.7 //x2=3.985 //y2=5.155
cc_73 ( N_noxref_1_M18_noxref_g N_noxref_4_c_977_n ) capacitor c=0.0110523f \
 //x=3.51 //y=6.02 //x2=3.985 //y2=5.155
cc_74 ( N_noxref_1_c_29_p N_noxref_4_c_982_n ) capacitor c=2.43846e-19 \
 //x=3.33 //y=3.49 //x2=3.585 //y2=1.125
cc_75 ( N_noxref_1_c_17_p N_noxref_4_c_982_n ) capacitor c=6.5615e-19 //x=6.96 \
 //y=1 //x2=3.585 //y2=1.125
cc_76 ( N_noxref_1_c_32_p N_noxref_4_c_982_n ) capacitor c=2.14389e-19 \
 //x=3.495 //y=3.33 //x2=3.585 //y2=1.125
cc_77 ( N_noxref_1_c_55_p N_noxref_4_c_982_n ) capacitor c=4.64015e-19 \
 //x=3.32 //y=0.915 //x2=3.585 //y2=1.125
cc_78 ( N_noxref_1_c_56_p N_noxref_4_c_982_n ) capacitor c=0.0026012f //x=3.32 \
 //y=1.26 //x2=3.585 //y2=1.125
cc_79 ( N_noxref_1_c_79_p N_noxref_4_c_982_n ) capacitor c=5.29969e-19 \
 //x=3.695 //y=0.76 //x2=3.585 //y2=1.125
cc_80 ( N_noxref_1_c_80_p N_noxref_4_c_982_n ) capacitor c=5.00648e-19 \
 //x=3.695 //y=1.415 //x2=3.585 //y2=1.125
cc_81 ( N_noxref_1_c_81_p N_noxref_4_c_982_n ) capacitor c=5.28622e-19 \
 //x=3.85 //y=0.915 //x2=3.585 //y2=1.125
cc_82 ( N_noxref_1_c_82_p N_noxref_4_c_982_n ) capacitor c=0.00312156f \
 //x=3.85 //y=1.26 //x2=3.585 //y2=1.125
cc_83 ( N_noxref_1_c_2_p N_noxref_4_c_991_n ) capacitor c=0.00326079f //x=6.96 \
 //y=1.57 //x2=3.585 //y2=1.58
cc_84 ( N_noxref_1_c_56_p N_noxref_4_c_991_n ) capacitor c=0.00127432f \
 //x=3.32 //y=1.26 //x2=3.585 //y2=1.58
cc_85 ( N_noxref_1_c_57_p N_noxref_4_c_991_n ) capacitor c=0.00429966f \
 //x=3.32 //y=1.57 //x2=3.585 //y2=1.58
cc_86 ( N_noxref_1_c_80_p N_noxref_4_c_991_n ) capacitor c=0.00930387f \
 //x=3.695 //y=1.415 //x2=3.585 //y2=1.58
cc_87 ( N_noxref_1_c_82_p N_noxref_4_c_991_n ) capacitor c=0.00347599f \
 //x=3.85 //y=1.26 //x2=3.585 //y2=1.58
cc_88 ( N_noxref_1_c_61_p N_noxref_4_c_991_n ) capacitor c=0.00372124f \
 //x=3.33 //y=1.915 //x2=3.585 //y2=1.58
cc_89 ( N_noxref_1_c_89_p N_noxref_4_c_997_n ) capacitor c=0.00218808f \
 //x=7.045 //y=1.655 //x2=3.985 //y2=1.665
cc_90 ( N_noxref_1_c_4_p N_noxref_4_c_997_n ) capacitor c=0.00203605f //x=7.4 \
 //y=3.17 //x2=3.985 //y2=1.665
cc_91 ( N_noxref_1_c_43_p N_noxref_4_c_997_n ) capacitor c=0.00343082f \
 //x=3.685 //y=3.33 //x2=3.985 //y2=1.665
cc_92 ( N_noxref_1_c_80_p N_noxref_4_c_997_n ) capacitor c=0.00194716f \
 //x=3.695 //y=1.415 //x2=3.985 //y2=1.665
cc_93 ( N_noxref_1_c_82_p N_noxref_4_c_997_n ) capacitor c=0.00323576f \
 //x=3.85 //y=1.26 //x2=3.985 //y2=1.665
cc_94 ( N_noxref_1_c_29_p N_noxref_4_c_1002_n ) capacitor c=0.00112398f \
 //x=3.33 //y=3.49 //x2=3.67 //y2=1.665
cc_95 ( N_noxref_1_c_43_p N_noxref_4_c_1002_n ) capacitor c=0.00420474f \
 //x=3.685 //y=3.33 //x2=3.67 //y2=1.665
cc_96 ( N_noxref_1_c_25_p N_noxref_4_c_1004_n ) capacitor c=0.0154269f \
 //x=3.33 //y=2.195 //x2=4.07 //y2=3.54
cc_97 ( N_noxref_1_c_28_p N_noxref_4_c_1004_n ) capacitor c=0.0445642f \
 //x=3.33 //y=3.17 //x2=4.07 //y2=3.54
cc_98 ( N_noxref_1_c_29_p N_noxref_4_c_1004_n ) capacitor c=0.017329f //x=3.33 \
 //y=3.49 //x2=4.07 //y2=3.54
cc_99 ( N_noxref_1_c_30_p N_noxref_4_c_1004_n ) capacitor c=0.00225898f \
 //x=3.33 //y=4.57 //x2=4.07 //y2=3.54
cc_100 ( N_noxref_1_c_31_p N_noxref_4_c_1004_n ) capacitor c=6.78671e-19 \
 //x=3.33 //y=3.33 //x2=4.07 //y2=3.54
cc_101 ( N_noxref_1_c_43_p N_noxref_4_c_1004_n ) capacitor c=2.75635e-19 \
 //x=3.685 //y=3.33 //x2=4.07 //y2=3.54
cc_102 ( N_noxref_1_c_32_p N_noxref_4_c_1004_n ) capacitor c=0.00308371f \
 //x=3.495 //y=3.33 //x2=4.07 //y2=3.54
cc_103 ( N_noxref_1_c_103_p N_noxref_4_c_1004_n ) capacitor c=0.0277316f \
 //x=4.285 //y=3.315 //x2=4.07 //y2=3.54
cc_104 ( N_noxref_1_c_26_p N_noxref_4_c_1004_n ) capacitor c=0.00163444f \
 //x=3.33 //y=2.08 //x2=4.07 //y2=3.54
cc_105 ( N_noxref_1_c_27_p N_noxref_4_c_1004_n ) capacitor c=0.0025845f \
 //x=3.33 //y=2.08 //x2=4.07 //y2=3.54
cc_106 ( N_noxref_1_c_61_p N_noxref_4_c_1004_n ) capacitor c=0.00282067f \
 //x=3.33 //y=1.915 //x2=4.07 //y2=3.54
cc_107 ( N_noxref_1_c_30_p N_noxref_4_c_1015_n ) capacitor c=0.0148501f \
 //x=3.33 //y=4.57 //x2=4.07 //y2=3.86
cc_108 ( N_noxref_1_c_103_p N_noxref_4_c_1015_n ) capacitor c=0.00899533f \
 //x=4.285 //y=3.315 //x2=4.07 //y2=3.86
cc_109 ( N_noxref_1_c_30_p N_noxref_4_c_1017_n ) capacitor c=0.0416218f \
 //x=3.33 //y=4.57 //x2=4.07 //y2=5.07
cc_110 ( N_noxref_1_c_6_p N_noxref_4_c_1017_n ) capacitor c=0.00283621f \
 //x=7.4 //y=5.115 //x2=4.07 //y2=5.07
cc_111 ( N_noxref_1_c_35_p N_noxref_4_c_1017_n ) capacitor c=0.00131258f \
 //x=3.33 //y=4.7 //x2=4.07 //y2=5.07
cc_112 ( N_noxref_1_c_36_p N_noxref_4_c_1017_n ) capacitor c=0.00737085f \
 //x=3.33 //y=4.7 //x2=4.07 //y2=5.07
cc_113 ( N_noxref_1_c_28_p N_noxref_4_c_1021_n ) capacitor c=0.00210705f \
 //x=3.33 //y=3.17 //x2=5.92 //y2=3.54
cc_114 ( N_noxref_1_c_4_p N_noxref_4_c_1021_n ) capacitor c=0.00327648f \
 //x=7.4 //y=3.17 //x2=5.92 //y2=3.54
cc_115 ( N_noxref_1_c_115_p N_noxref_4_c_1021_n ) capacitor c=4.98743e-19 \
 //x=5.53 //y=3.33 //x2=5.92 //y2=3.54
cc_116 ( N_noxref_1_c_116_p N_noxref_4_c_1021_n ) capacitor c=0.0272333f \
 //x=6.13 //y=3.315 //x2=5.92 //y2=3.54
cc_117 ( N_noxref_1_c_117_p N_noxref_4_c_1021_n ) capacitor c=3.14213e-19 \
 //x=7.555 //y=3.33 //x2=5.92 //y2=3.54
cc_118 ( N_noxref_1_c_39_p N_noxref_4_c_1026_n ) capacitor c=7.23153e-19 \
 //x=6.04 //y=5.38 //x2=5.92 //y2=3.86
cc_119 ( N_noxref_1_c_115_p N_noxref_4_c_1026_n ) capacitor c=0.00229532f \
 //x=5.53 //y=3.33 //x2=5.92 //y2=3.86
cc_120 ( N_noxref_1_c_116_p N_noxref_4_c_1026_n ) capacitor c=0.00505309f \
 //x=6.13 //y=3.315 //x2=5.92 //y2=3.86
cc_121 ( N_noxref_1_c_121_p N_noxref_4_c_1026_n ) capacitor c=2.08455e-19 \
 //x=6.04 //y=5.38 //x2=5.92 //y2=3.86
cc_122 ( N_noxref_1_c_29_p N_noxref_4_c_1030_n ) capacitor c=6.86112e-19 \
 //x=3.33 //y=3.49 //x2=3.29 //y2=5.155
cc_123 ( N_noxref_1_c_30_p N_noxref_4_c_1030_n ) capacitor c=0.0228808f \
 //x=3.33 //y=4.57 //x2=3.29 //y2=5.155
cc_124 ( N_noxref_1_c_35_p N_noxref_4_c_1030_n ) capacitor c=0.00346456f \
 //x=3.33 //y=4.7 //x2=3.29 //y2=5.155
cc_125 ( N_noxref_1_c_36_p N_noxref_4_c_1030_n ) capacitor c=0.00203307f \
 //x=3.33 //y=4.7 //x2=3.29 //y2=5.155
cc_126 ( N_noxref_1_c_30_p N_noxref_4_c_1034_n ) capacitor c=6.03895e-19 \
 //x=3.33 //y=4.57 //x2=4.07 //y2=3.7
cc_127 ( N_noxref_1_c_116_p N_noxref_4_c_1035_n ) capacitor c=0.00211017f \
 //x=6.13 //y=3.315 //x2=5.92 //y2=2.08
cc_128 ( N_noxref_1_c_39_p N_noxref_4_c_1036_n ) capacitor c=0.0117744f \
 //x=6.04 //y=5.38 //x2=5.92 //y2=4.7
cc_129 ( N_noxref_1_c_121_p N_noxref_4_c_1036_n ) capacitor c=0.00104426f \
 //x=6.04 //y=5.38 //x2=5.92 //y2=4.7
cc_130 ( N_noxref_1_c_30_p N_noxref_4_c_1038_n ) capacitor c=8.55722e-19 \
 //x=3.33 //y=4.57 //x2=5.922 //y2=4.56
cc_131 ( N_noxref_1_c_6_p N_noxref_4_c_1038_n ) capacitor c=0.00133619f \
 //x=7.4 //y=5.115 //x2=5.922 //y2=4.56
cc_132 ( N_noxref_1_c_103_p N_noxref_4_c_1040_n ) capacitor c=0.132114f \
 //x=4.285 //y=3.315 //x2=5.755 //y2=3.7
cc_133 ( N_noxref_1_c_115_p N_noxref_4_c_1040_n ) capacitor c=0.01106f \
 //x=5.53 //y=3.33 //x2=5.755 //y2=3.7
cc_134 ( N_noxref_1_c_30_p N_noxref_4_c_1042_n ) capacitor c=0.00686853f \
 //x=3.33 //y=4.57 //x2=4.23 //y2=3.7
cc_135 ( N_noxref_1_c_103_p N_noxref_4_c_1042_n ) capacitor c=0.0365231f \
 //x=4.285 //y=3.315 //x2=4.23 //y2=3.7
cc_136 ( N_noxref_1_c_136_p N_noxref_4_c_1044_n ) capacitor c=0.0040382f \
 //x=7.4 //y=3.49 //x2=7.61 //y2=3.715
cc_137 ( N_noxref_1_c_6_p N_noxref_4_c_1044_n ) capacitor c=0.0226569f //x=7.4 \
 //y=5.115 //x2=7.61 //y2=3.715
cc_138 ( N_noxref_1_c_138_p N_noxref_4_c_1044_n ) capacitor c=0.134732f \
 //x=9.085 //y=3.325 //x2=7.61 //y2=3.715
cc_139 ( N_noxref_1_c_136_p N_noxref_4_c_1047_n ) capacitor c=0.00307263f \
 //x=7.4 //y=3.49 //x2=7.265 //y2=3.715
cc_140 ( N_noxref_1_c_6_p N_noxref_4_c_1047_n ) capacitor c=3.08624e-19 \
 //x=7.4 //y=5.115 //x2=7.265 //y2=3.715
cc_141 ( N_noxref_1_c_116_p N_noxref_4_c_1047_n ) capacitor c=0.0488575f \
 //x=6.13 //y=3.315 //x2=7.265 //y2=3.715
cc_142 ( N_noxref_1_c_117_p N_noxref_4_c_1047_n ) capacitor c=0.126579f \
 //x=7.555 //y=3.33 //x2=7.265 //y2=3.715
cc_143 ( N_noxref_1_c_9_p N_noxref_4_c_1051_n ) capacitor c=0.00342917f \
 //x=9.25 //y=3.485 //x2=8.86 //y2=3.7
cc_144 ( N_noxref_1_c_7_p N_noxref_4_c_1051_n ) capacitor c=3.32529e-19 \
 //x=9.252 //y=4.56 //x2=8.86 //y2=3.7
cc_145 ( N_noxref_1_c_19_p N_noxref_4_c_1051_n ) capacitor c=0.0367952f \
 //x=9.245 //y=3.325 //x2=8.86 //y2=3.7
cc_146 ( N_noxref_1_c_138_p N_noxref_4_c_1051_n ) capacitor c=0.0115365f \
 //x=9.085 //y=3.325 //x2=8.86 //y2=3.7
cc_147 ( N_noxref_1_c_9_p N_noxref_4_c_1055_n ) capacitor c=0.00251313f \
 //x=9.25 //y=3.485 //x2=9.46 //y2=3.71
cc_148 ( N_noxref_1_c_7_p N_noxref_4_c_1055_n ) capacitor c=0.0228115f \
 //x=9.252 //y=4.56 //x2=9.46 //y2=3.71
cc_149 ( N_noxref_1_c_30_p N_noxref_4_c_1057_n ) capacitor c=0.00217653f \
 //x=3.33 //y=4.57 //x2=3.29 //y2=5.38
cc_150 ( N_noxref_1_c_35_p N_noxref_4_c_1057_n ) capacitor c=0.00624059f \
 //x=3.33 //y=4.7 //x2=3.29 //y2=5.38
cc_151 ( N_noxref_1_M17_noxref_g N_noxref_4_c_1057_n ) capacitor c=0.0178885f \
 //x=3.07 //y=6.02 //x2=3.29 //y2=5.38
cc_152 ( N_noxref_1_M18_noxref_g N_noxref_4_c_1057_n ) capacitor c=0.0188608f \
 //x=3.51 //y=6.02 //x2=3.29 //y2=5.38
cc_153 ( N_noxref_1_c_36_p N_noxref_4_c_1057_n ) capacitor c=0.00375636f \
 //x=3.33 //y=4.7 //x2=3.29 //y2=5.38
cc_154 ( N_noxref_1_c_39_p N_noxref_4_c_1062_n ) capacitor c=0.00277154f \
 //x=6.04 //y=5.38 //x2=5.92 //y2=4.7
cc_155 ( N_noxref_1_c_121_p N_noxref_4_c_1062_n ) capacitor c=0.00377369f \
 //x=6.04 //y=5.38 //x2=5.92 //y2=4.7
cc_156 ( N_noxref_1_c_39_p N_noxref_4_M19_noxref_g ) capacitor c=0.00201806f \
 //x=6.04 //y=5.38 //x2=5.82 //y2=6.02
cc_157 ( N_noxref_1_c_121_p N_noxref_4_M19_noxref_g ) capacitor c=0.0158358f \
 //x=6.04 //y=5.38 //x2=5.82 //y2=6.02
cc_158 ( N_noxref_1_c_158_p N_noxref_4_M20_noxref_g ) capacitor c=0.00889217f \
 //x=6.805 //y=5.2 //x2=6.26 //y2=6.02
cc_159 ( N_noxref_1_c_39_p N_noxref_4_M20_noxref_g ) capacitor c=0.00192712f \
 //x=6.04 //y=5.38 //x2=6.26 //y2=6.02
cc_160 ( N_noxref_1_c_121_p N_noxref_4_M20_noxref_g ) capacitor c=0.0178987f \
 //x=6.04 //y=5.38 //x2=6.26 //y2=6.02
cc_161 ( N_noxref_1_c_39_p N_noxref_4_c_1069_n ) capacitor c=0.00189999f \
 //x=6.04 //y=5.38 //x2=5.92 //y2=4.7
cc_162 ( N_noxref_1_c_121_p N_noxref_4_c_1069_n ) capacitor c=0.0043218f \
 //x=6.04 //y=5.38 //x2=5.92 //y2=4.7
cc_163 ( N_noxref_1_c_55_p N_noxref_4_M2_noxref_d ) capacitor c=0.00137165f \
 //x=3.32 //y=0.915 //x2=3.395 //y2=0.915
cc_164 ( N_noxref_1_c_56_p N_noxref_4_M2_noxref_d ) capacitor c=0.00237422f \
 //x=3.32 //y=1.26 //x2=3.395 //y2=0.915
cc_165 ( N_noxref_1_c_79_p N_noxref_4_M2_noxref_d ) capacitor c=0.0020782f \
 //x=3.695 //y=0.76 //x2=3.395 //y2=0.915
cc_166 ( N_noxref_1_c_80_p N_noxref_4_M2_noxref_d ) capacitor c=0.00356097f \
 //x=3.695 //y=1.415 //x2=3.395 //y2=0.915
cc_167 ( N_noxref_1_c_81_p N_noxref_4_M2_noxref_d ) capacitor c=0.00139206f \
 //x=3.85 //y=0.915 //x2=3.395 //y2=0.915
cc_168 ( N_noxref_1_c_82_p N_noxref_4_M2_noxref_d ) capacitor c=0.00237422f \
 //x=3.85 //y=1.26 //x2=3.395 //y2=0.915
cc_169 ( N_noxref_1_c_28_p N_noxref_5_c_1438_n ) capacitor c=0.00142312f \
 //x=3.33 //y=3.17 //x2=1.11 //y2=3.915
cc_170 ( N_noxref_1_c_30_p N_noxref_5_c_1438_n ) capacitor c=7.99748e-19 \
 //x=3.33 //y=4.57 //x2=1.11 //y2=3.915
cc_171 ( N_noxref_1_c_30_p N_noxref_5_c_1440_n ) capacitor c=5.49831e-19 \
 //x=3.33 //y=4.57 //x2=1.11 //y2=4.575
cc_172 ( N_noxref_1_c_4_p N_noxref_5_c_1441_n ) capacitor c=0.00215025f \
 //x=7.4 //y=3.17 //x2=9.99 //y2=3.915
cc_173 ( N_noxref_1_c_6_p N_noxref_5_c_1441_n ) capacitor c=3.0421e-19 //x=7.4 \
 //y=5.115 //x2=9.99 //y2=3.915
cc_174 ( N_noxref_1_c_5_p N_noxref_5_c_1441_n ) capacitor c=0.0427017f \
 //x=9.25 //y=3.165 //x2=9.99 //y2=3.915
cc_175 ( N_noxref_1_c_9_p N_noxref_5_c_1441_n ) capacitor c=0.0146933f \
 //x=9.25 //y=3.485 //x2=9.99 //y2=3.915
cc_176 ( N_noxref_1_c_18_p N_noxref_5_c_1441_n ) capacitor c=5.57251e-19 \
 //x=9.25 //y=3.33 //x2=9.99 //y2=3.915
cc_177 ( N_noxref_1_c_7_p N_noxref_5_c_1441_n ) capacitor c=0.0172039f \
 //x=9.252 //y=4.56 //x2=9.99 //y2=3.915
cc_178 ( N_noxref_1_c_19_p N_noxref_5_c_1441_n ) capacitor c=0.00364775f \
 //x=9.245 //y=3.325 //x2=9.99 //y2=3.915
cc_179 ( N_noxref_1_c_179_p N_noxref_5_c_1441_n ) capacitor c=3.49899e-19 \
 //x=9.25 //y=2.08 //x2=9.99 //y2=3.915
cc_180 ( N_noxref_1_c_7_p N_noxref_5_c_1449_n ) capacitor c=0.0172847f \
 //x=9.252 //y=4.56 //x2=9.99 //y2=4.235
cc_181 ( N_noxref_1_c_6_p N_noxref_5_c_1450_n ) capacitor c=7.63307e-19 \
 //x=7.4 //y=5.115 //x2=9.99 //y2=4.555
cc_182 ( N_noxref_1_c_12_p N_noxref_5_c_1450_n ) capacitor c=0.0172958f \
 //x=9.25 //y=4.7 //x2=9.99 //y2=4.555
cc_183 ( N_noxref_1_c_7_p N_noxref_5_c_1450_n ) capacitor c=0.0114865f \
 //x=9.252 //y=4.56 //x2=9.99 //y2=4.555
cc_184 ( N_noxref_1_c_13_p N_noxref_5_c_1450_n ) capacitor c=7.25895e-19 \
 //x=9.25 //y=4.7 //x2=9.99 //y2=4.555
cc_185 ( N_noxref_1_c_16_p N_noxref_5_c_1450_n ) capacitor c=0.00200292f \
 //x=9.25 //y=4.7 //x2=9.99 //y2=4.555
cc_186 ( N_noxref_1_c_7_p N_noxref_5_c_1455_n ) capacitor c=6.89957e-19 \
 //x=9.252 //y=4.56 //x2=9.99 //y2=4.07
cc_187 ( N_noxref_1_c_187_p N_noxref_5_c_1456_n ) capacitor c=0.0205342f \
 //x=9.25 //y=2.08 //x2=9.99 //y2=2.08
cc_188 ( N_noxref_1_c_179_p N_noxref_5_c_1456_n ) capacitor c=5.16867e-19 \
 //x=9.25 //y=2.08 //x2=9.99 //y2=2.08
cc_189 ( N_noxref_1_c_189_p N_noxref_5_c_1456_n ) capacitor c=0.00167888f \
 //x=9.055 //y=1.915 //x2=9.99 //y2=2.08
cc_190 ( N_noxref_1_c_29_p N_noxref_5_c_1459_n ) capacitor c=0.0031669f \
 //x=3.33 //y=3.49 //x2=3.685 //y2=4.07
cc_191 ( N_noxref_1_c_30_p N_noxref_5_c_1459_n ) capacitor c=0.0245794f \
 //x=3.33 //y=4.57 //x2=3.685 //y2=4.07
cc_192 ( N_noxref_1_c_43_p N_noxref_5_c_1459_n ) capacitor c=0.0162663f \
 //x=3.685 //y=3.33 //x2=3.685 //y2=4.07
cc_193 ( N_noxref_1_c_32_p N_noxref_5_c_1459_n ) capacitor c=0.0160589f \
 //x=3.495 //y=3.33 //x2=3.685 //y2=4.07
cc_194 ( N_noxref_1_c_103_p N_noxref_5_c_1463_n ) capacitor c=0.00849955f \
 //x=4.285 //y=3.315 //x2=4.285 //y2=4.085
cc_195 ( N_noxref_1_c_115_p N_noxref_5_c_1464_n ) capacitor c=0.00536077f \
 //x=5.53 //y=3.33 //x2=5.53 //y2=4.07
cc_196 ( N_noxref_1_c_116_p N_noxref_5_c_1465_n ) capacitor c=0.00123107f \
 //x=6.13 //y=3.315 //x2=6.13 //y2=4.085
cc_197 ( N_noxref_1_c_6_p N_noxref_5_c_1466_n ) capacitor c=0.0232181f //x=7.4 \
 //y=5.115 //x2=10.155 //y2=4.07
cc_198 ( N_noxref_1_c_7_p N_noxref_5_c_1466_n ) capacitor c=0.0254145f \
 //x=9.252 //y=4.56 //x2=10.155 //y2=4.07
cc_199 ( N_noxref_1_c_117_p N_noxref_5_c_1466_n ) capacitor c=0.00761293f \
 //x=7.555 //y=3.33 //x2=10.155 //y2=4.07
cc_200 ( N_noxref_1_c_138_p N_noxref_5_c_1466_n ) capacitor c=0.00977708f \
 //x=9.085 //y=3.325 //x2=10.155 //y2=4.07
cc_201 ( N_noxref_1_c_5_p N_noxref_5_c_1470_n ) capacitor c=3.49899e-19 \
 //x=9.25 //y=3.165 //x2=9.99 //y2=2.08
cc_202 ( N_noxref_1_c_187_p N_noxref_5_c_1470_n ) capacitor c=5.24723e-19 \
 //x=9.25 //y=2.08 //x2=9.99 //y2=2.08
cc_203 ( N_noxref_1_c_179_p N_noxref_5_c_1470_n ) capacitor c=0.00525888f \
 //x=9.25 //y=2.08 //x2=9.99 //y2=2.08
cc_204 ( N_noxref_1_c_189_p N_noxref_5_c_1470_n ) capacitor c=0.00190888f \
 //x=9.055 //y=1.915 //x2=9.99 //y2=2.08
cc_205 ( N_noxref_1_c_12_p N_noxref_5_c_1474_n ) capacitor c=4.80626e-19 \
 //x=9.25 //y=4.7 //x2=10.02 //y2=4.7
cc_206 ( N_noxref_1_c_13_p N_noxref_5_c_1474_n ) capacitor c=0.00397338f \
 //x=9.25 //y=4.7 //x2=10.02 //y2=4.7
cc_207 ( N_noxref_1_c_16_p N_noxref_5_c_1474_n ) capacitor c=0.00283894f \
 //x=9.25 //y=4.7 //x2=10.02 //y2=4.7
cc_208 ( N_noxref_1_M23_noxref_g N_noxref_5_M25_noxref_g ) capacitor \
 c=0.0104892f //x=9.15 //y=6.02 //x2=10.03 //y2=6.02
cc_209 ( N_noxref_1_M24_noxref_g N_noxref_5_M25_noxref_g ) capacitor \
 c=0.107636f //x=9.59 //y=6.02 //x2=10.03 //y2=6.02
cc_210 ( N_noxref_1_M24_noxref_g N_noxref_5_M26_noxref_g ) capacitor \
 c=0.0100341f //x=9.59 //y=6.02 //x2=10.47 //y2=6.02
cc_211 ( N_noxref_1_c_211_p N_noxref_5_c_1480_n ) capacitor c=4.86545e-19 \
 //x=9.055 //y=0.865 //x2=10.025 //y2=0.905
cc_212 ( N_noxref_1_c_212_p N_noxref_5_c_1480_n ) capacitor c=0.00152405f \
 //x=9.055 //y=1.21 //x2=10.025 //y2=0.905
cc_213 ( N_noxref_1_c_213_p N_noxref_5_c_1480_n ) capacitor c=0.0151475f \
 //x=9.585 //y=0.865 //x2=10.025 //y2=0.905
cc_214 ( N_noxref_1_c_214_p N_noxref_5_c_1483_n ) capacitor c=0.00109982f \
 //x=9.055 //y=1.52 //x2=10.025 //y2=1.25
cc_215 ( N_noxref_1_c_215_p N_noxref_5_c_1483_n ) capacitor c=0.0111064f \
 //x=9.585 //y=1.21 //x2=10.025 //y2=1.25
cc_216 ( N_noxref_1_c_214_p N_noxref_5_c_1485_n ) capacitor c=9.58243e-19 \
 //x=9.055 //y=1.52 //x2=10.025 //y2=1.56
cc_217 ( N_noxref_1_c_189_p N_noxref_5_c_1485_n ) capacitor c=0.00662747f \
 //x=9.055 //y=1.915 //x2=10.025 //y2=1.56
cc_218 ( N_noxref_1_c_215_p N_noxref_5_c_1485_n ) capacitor c=0.00862358f \
 //x=9.585 //y=1.21 //x2=10.025 //y2=1.56
cc_219 ( N_noxref_1_c_213_p N_noxref_5_c_1488_n ) capacitor c=0.00127211f \
 //x=9.585 //y=0.865 //x2=10.555 //y2=0.905
cc_220 ( N_noxref_1_c_215_p N_noxref_5_c_1489_n ) capacitor c=0.00204774f \
 //x=9.585 //y=1.21 //x2=10.555 //y2=1.25
cc_221 ( N_noxref_1_c_187_p N_noxref_5_c_1490_n ) capacitor c=0.00167305f \
 //x=9.25 //y=2.08 //x2=9.99 //y2=2.08
cc_222 ( N_noxref_1_c_179_p N_noxref_5_c_1490_n ) capacitor c=0.0018937f \
 //x=9.25 //y=2.08 //x2=9.99 //y2=2.08
cc_223 ( N_noxref_1_c_189_p N_noxref_5_c_1490_n ) capacitor c=0.0181449f \
 //x=9.055 //y=1.915 //x2=9.99 //y2=2.08
cc_224 ( N_noxref_1_c_12_p N_noxref_5_c_1493_n ) capacitor c=0.00158715f \
 //x=9.25 //y=4.7 //x2=10.02 //y2=4.7
cc_225 ( N_noxref_1_c_13_p N_noxref_5_c_1493_n ) capacitor c=0.00237977f \
 //x=9.25 //y=4.7 //x2=10.02 //y2=4.7
cc_226 ( N_noxref_1_c_16_p N_noxref_5_c_1493_n ) capacitor c=0.0297875f \
 //x=9.25 //y=4.7 //x2=10.02 //y2=4.7
cc_227 ( N_noxref_1_c_158_p N_noxref_6_c_2010_n ) capacitor c=0.00647565f \
 //x=6.805 //y=5.2 //x2=21.09 //y2=7.4
cc_228 ( N_noxref_1_c_8_p N_noxref_6_c_2010_n ) capacitor c=0.00491443f \
 //x=7.315 //y=5.2 //x2=21.09 //y2=7.4
cc_229 ( N_noxref_1_c_9_p N_noxref_6_c_2010_n ) capacitor c=2.00356e-19 \
 //x=9.25 //y=3.485 //x2=21.09 //y2=7.4
cc_230 ( N_noxref_1_c_39_p N_noxref_6_c_2010_n ) capacitor c=0.00368144f \
 //x=6.04 //y=5.38 //x2=21.09 //y2=7.4
cc_231 ( N_noxref_1_c_10_p N_noxref_6_c_2010_n ) capacitor c=8.41206e-19 \
 //x=6.92 //y=5.2 //x2=21.09 //y2=7.4
cc_232 ( N_noxref_1_c_11_p N_noxref_6_c_2010_n ) capacitor c=0.00285294f \
 //x=6.92 //y=5.38 //x2=21.09 //y2=7.4
cc_233 ( N_noxref_1_c_12_p N_noxref_6_c_2010_n ) capacitor c=9.05427e-19 \
 //x=9.25 //y=4.7 //x2=21.09 //y2=7.4
cc_234 ( N_noxref_1_c_121_p N_noxref_6_c_2010_n ) capacitor c=0.00224727f \
 //x=6.04 //y=5.38 //x2=21.09 //y2=7.4
cc_235 ( N_noxref_1_c_235_p N_noxref_6_c_2010_n ) capacitor c=0.00224727f \
 //x=6.92 //y=5.38 //x2=21.09 //y2=7.4
cc_236 ( N_noxref_1_c_13_p N_noxref_6_c_2010_n ) capacitor c=6.23118e-19 \
 //x=9.25 //y=4.7 //x2=21.09 //y2=7.4
cc_237 ( N_noxref_1_M17_noxref_g N_noxref_6_c_2020_n ) capacitor c=0.00749619f \
 //x=3.07 //y=6.02 //x2=3.645 //y2=7.4
cc_238 ( N_noxref_1_M18_noxref_g N_noxref_6_c_2020_n ) capacitor c=0.00749823f \
 //x=3.51 //y=6.02 //x2=3.645 //y2=7.4
cc_239 ( N_noxref_1_c_158_p N_noxref_6_c_2022_n ) capacitor c=0.00208112f \
 //x=6.805 //y=5.2 //x2=6.395 //y2=7.4
cc_240 ( N_noxref_1_c_39_p N_noxref_6_c_2022_n ) capacitor c=9.41091e-19 \
 //x=6.04 //y=5.38 //x2=6.395 //y2=7.4
cc_241 ( N_noxref_1_c_121_p N_noxref_6_c_2022_n ) capacitor c=0.0136475f \
 //x=6.04 //y=5.38 //x2=6.395 //y2=7.4
cc_242 ( N_noxref_1_c_158_p N_noxref_6_c_2025_n ) capacitor c=0.00180744f \
 //x=6.805 //y=5.2 //x2=7.275 //y2=7.4
cc_243 ( N_noxref_1_c_8_p N_noxref_6_c_2025_n ) capacitor c=0.00208112f \
 //x=7.315 //y=5.2 //x2=7.275 //y2=7.4
cc_244 ( N_noxref_1_c_10_p N_noxref_6_c_2025_n ) capacitor c=4.23323e-19 \
 //x=6.92 //y=5.2 //x2=7.275 //y2=7.4
cc_245 ( N_noxref_1_c_11_p N_noxref_6_c_2025_n ) capacitor c=5.78261e-19 \
 //x=6.92 //y=5.38 //x2=7.275 //y2=7.4
cc_246 ( N_noxref_1_c_235_p N_noxref_6_c_2025_n ) capacitor c=0.0136475f \
 //x=6.92 //y=5.38 //x2=7.275 //y2=7.4
cc_247 ( N_noxref_1_c_12_p N_noxref_6_c_2030_n ) capacitor c=6.28732e-19 \
 //x=9.25 //y=4.7 //x2=9.725 //y2=7.4
cc_248 ( N_noxref_1_M23_noxref_g N_noxref_6_c_2030_n ) capacitor c=0.0072715f \
 //x=9.15 //y=6.02 //x2=9.725 //y2=7.4
cc_249 ( N_noxref_1_M24_noxref_g N_noxref_6_c_2030_n ) capacitor c=0.00749619f \
 //x=9.59 //y=6.02 //x2=9.725 //y2=7.4
cc_250 ( N_noxref_1_c_6_p N_noxref_6_c_2033_n ) capacitor c=0.0013228f //x=7.4 \
 //y=5.115 //x2=4.81 //y2=7.4
cc_251 ( N_noxref_1_c_39_p N_noxref_6_c_2033_n ) capacitor c=4.91377e-19 \
 //x=6.04 //y=5.38 //x2=4.81 //y2=7.4
cc_252 ( N_noxref_1_c_35_p N_noxref_6_c_2033_n ) capacitor c=0.00224736f \
 //x=3.33 //y=4.7 //x2=4.81 //y2=7.4
cc_253 ( N_noxref_1_c_121_p N_noxref_6_c_2033_n ) capacitor c=0.0064135f \
 //x=6.04 //y=5.38 //x2=4.81 //y2=7.4
cc_254 ( N_noxref_1_c_36_p N_noxref_6_c_2033_n ) capacitor c=2.63786e-19 \
 //x=3.33 //y=4.7 //x2=4.81 //y2=7.4
cc_255 ( N_noxref_1_c_6_p N_noxref_6_c_2038_n ) capacitor c=0.0291261f //x=7.4 \
 //y=5.115 //x2=8.14 //y2=7.4
cc_256 ( N_noxref_1_c_10_p N_noxref_6_c_2038_n ) capacitor c=0.00240948f \
 //x=6.92 //y=5.2 //x2=8.14 //y2=7.4
cc_257 ( N_noxref_1_c_11_p N_noxref_6_c_2038_n ) capacitor c=4.09141e-19 \
 //x=6.92 //y=5.38 //x2=8.14 //y2=7.4
cc_258 ( N_noxref_1_c_12_p N_noxref_6_c_2038_n ) capacitor c=0.00447349f \
 //x=9.25 //y=4.7 //x2=8.14 //y2=7.4
cc_259 ( N_noxref_1_c_7_p N_noxref_6_c_2038_n ) capacitor c=0.00564116f \
 //x=9.252 //y=4.56 //x2=8.14 //y2=7.4
cc_260 ( N_noxref_1_c_235_p N_noxref_6_c_2038_n ) capacitor c=0.0101861f \
 //x=6.92 //y=5.38 //x2=8.14 //y2=7.4
cc_261 ( N_noxref_1_c_13_p N_noxref_6_c_2038_n ) capacitor c=0.00370494f \
 //x=9.25 //y=4.7 //x2=8.14 //y2=7.4
cc_262 ( N_noxref_1_c_16_p N_noxref_6_c_2038_n ) capacitor c=0.0129564f \
 //x=9.25 //y=4.7 //x2=8.14 //y2=7.4
cc_263 ( N_noxref_1_M17_noxref_g N_noxref_6_M16_noxref_d ) capacitor \
 c=0.015318f //x=3.07 //y=6.02 //x2=2.705 //y2=5.02
cc_264 ( N_noxref_1_M18_noxref_g N_noxref_6_M18_noxref_d ) capacitor \
 c=0.0394719f //x=3.51 //y=6.02 //x2=3.585 //y2=5.02
cc_265 ( N_noxref_1_c_39_p N_noxref_6_M19_noxref_s ) capacitor c=0.0611368f \
 //x=6.04 //y=5.38 //x2=5.465 //y2=5.02
cc_266 ( N_noxref_1_c_10_p N_noxref_6_M19_noxref_s ) capacitor c=6.52457e-19 \
 //x=6.92 //y=5.2 //x2=5.465 //y2=5.02
cc_267 ( N_noxref_1_c_121_p N_noxref_6_M19_noxref_s ) capacitor c=0.0887533f \
 //x=6.04 //y=5.38 //x2=5.465 //y2=5.02
cc_268 ( N_noxref_1_c_158_p N_noxref_6_M20_noxref_d ) capacitor c=0.00734028f \
 //x=6.805 //y=5.2 //x2=6.335 //y2=5.02
cc_269 ( N_noxref_1_c_39_p N_noxref_6_M20_noxref_d ) capacitor c=0.0043528f \
 //x=6.04 //y=5.38 //x2=6.335 //y2=5.02
cc_270 ( N_noxref_1_c_11_p N_noxref_6_M20_noxref_d ) capacitor c=0.0043528f \
 //x=6.92 //y=5.38 //x2=6.335 //y2=5.02
cc_271 ( N_noxref_1_c_121_p N_noxref_6_M20_noxref_d ) capacitor c=0.065554f \
 //x=6.04 //y=5.38 //x2=6.335 //y2=5.02
cc_272 ( N_noxref_1_c_235_p N_noxref_6_M20_noxref_d ) capacitor c=0.065554f \
 //x=6.92 //y=5.38 //x2=6.335 //y2=5.02
cc_273 ( N_noxref_1_c_8_p N_noxref_6_M22_noxref_d ) capacitor c=0.00933287f \
 //x=7.315 //y=5.2 //x2=7.215 //y2=5.02
cc_274 ( N_noxref_1_c_11_p N_noxref_6_M22_noxref_d ) capacitor c=0.00587834f \
 //x=6.92 //y=5.38 //x2=7.215 //y2=5.02
cc_275 ( N_noxref_1_c_275_p N_noxref_6_M22_noxref_d ) capacitor c=9.65858e-19 \
 //x=7.395 //y=3.33 //x2=7.215 //y2=5.02
cc_276 ( N_noxref_1_c_235_p N_noxref_6_M22_noxref_d ) capacitor c=0.065554f \
 //x=6.92 //y=5.38 //x2=7.215 //y2=5.02
cc_277 ( N_noxref_1_c_8_p N_noxref_6_M23_noxref_s ) capacitor c=0.00326953f \
 //x=7.315 //y=5.2 //x2=8.795 //y2=5.02
cc_278 ( N_noxref_1_c_9_p N_noxref_6_M23_noxref_s ) capacitor c=0.00111268f \
 //x=9.25 //y=3.485 //x2=8.795 //y2=5.02
cc_279 ( N_noxref_1_c_10_p N_noxref_6_M23_noxref_s ) capacitor c=0.00515461f \
 //x=6.92 //y=5.2 //x2=8.795 //y2=5.02
cc_280 ( N_noxref_1_c_11_p N_noxref_6_M23_noxref_s ) capacitor c=3.28075e-19 \
 //x=6.92 //y=5.38 //x2=8.795 //y2=5.02
cc_281 ( N_noxref_1_M23_noxref_g N_noxref_6_M23_noxref_s ) capacitor \
 c=0.0567929f //x=9.15 //y=6.02 //x2=8.795 //y2=5.02
cc_282 ( N_noxref_1_M24_noxref_g N_noxref_6_M24_noxref_d ) capacitor \
 c=0.015318f //x=9.59 //y=6.02 //x2=9.665 //y2=5.02
cc_283 ( N_noxref_1_c_25_p N_noxref_7_c_2391_n ) capacitor c=0.00177186f \
 //x=3.33 //y=2.195 //x2=3.985 //y2=0.54
cc_284 ( N_noxref_1_c_26_p N_noxref_7_c_2391_n ) capacitor c=0.00117306f \
 //x=3.33 //y=2.08 //x2=3.985 //y2=0.54
cc_285 ( N_noxref_1_c_55_p N_noxref_7_c_2391_n ) capacitor c=0.0206349f \
 //x=3.32 //y=0.915 //x2=3.985 //y2=0.54
cc_286 ( N_noxref_1_c_81_p N_noxref_7_c_2391_n ) capacitor c=0.00825432f \
 //x=3.85 //y=0.915 //x2=3.985 //y2=0.54
cc_287 ( N_noxref_1_c_27_p N_noxref_7_c_2391_n ) capacitor c=2.20712e-19 \
 //x=3.33 //y=2.08 //x2=3.985 //y2=0.54
cc_288 ( N_noxref_1_c_56_p N_noxref_7_c_2396_n ) capacitor c=0.0071177f \
 //x=3.32 //y=1.26 //x2=3.1 //y2=0.995
cc_289 ( N_noxref_1_c_55_p N_noxref_7_M2_noxref_s ) capacitor c=0.0071177f \
 //x=3.32 //y=0.915 //x2=2.965 //y2=0.375
cc_290 ( N_noxref_1_c_57_p N_noxref_7_M2_noxref_s ) capacitor c=0.0071177f \
 //x=3.32 //y=1.57 //x2=2.965 //y2=0.375
cc_291 ( N_noxref_1_c_81_p N_noxref_7_M2_noxref_s ) capacitor c=0.015333f \
 //x=3.85 //y=0.915 //x2=2.965 //y2=0.375
cc_292 ( N_noxref_1_c_82_p N_noxref_7_M2_noxref_s ) capacitor c=0.00248746f \
 //x=3.85 //y=1.26 //x2=2.965 //y2=0.375
cc_293 ( N_noxref_1_c_158_p N_noxref_8_c_2455_n ) capacitor c=0.0218552f \
 //x=6.805 //y=5.2 //x2=6.66 //y2=4.555
cc_294 ( N_noxref_1_c_4_p N_noxref_8_c_2455_n ) capacitor c=0.0428886f //x=7.4 \
 //y=3.17 //x2=6.66 //y2=4.555
cc_295 ( N_noxref_1_c_136_p N_noxref_8_c_2455_n ) capacitor c=0.0174172f \
 //x=7.4 //y=3.49 //x2=6.66 //y2=4.555
cc_296 ( N_noxref_1_c_6_p N_noxref_8_c_2455_n ) capacitor c=0.0566971f //x=7.4 \
 //y=5.115 //x2=6.66 //y2=4.555
cc_297 ( N_noxref_1_c_5_p N_noxref_8_c_2455_n ) capacitor c=0.00210175f \
 //x=9.25 //y=3.165 //x2=6.66 //y2=4.555
cc_298 ( N_noxref_1_c_275_p N_noxref_8_c_2455_n ) capacitor c=6.03895e-19 \
 //x=7.395 //y=3.33 //x2=6.66 //y2=4.555
cc_299 ( N_noxref_1_c_7_p N_noxref_8_c_2455_n ) capacitor c=0.00136917f \
 //x=9.252 //y=4.56 //x2=6.66 //y2=4.555
cc_300 ( N_noxref_1_c_117_p N_noxref_8_c_2455_n ) capacitor c=0.0277375f \
 //x=7.555 //y=3.33 //x2=6.66 //y2=4.555
cc_301 ( N_noxref_1_c_4_p N_noxref_8_c_2463_n ) capacitor c=0.015397f //x=7.4 \
 //y=3.17 //x2=6.66 //y2=2.08
cc_302 ( N_noxref_1_c_117_p N_noxref_8_c_2463_n ) capacitor c=0.00255328f \
 //x=7.555 //y=3.33 //x2=6.66 //y2=2.08
cc_303 ( N_noxref_1_c_4_p N_noxref_8_c_2465_n ) capacitor c=9.90728e-19 \
 //x=7.4 //y=3.17 //x2=6.66 //y2=2.08
cc_304 ( N_noxref_1_c_158_p N_noxref_8_c_2466_n ) capacitor c=0.00469257f \
 //x=6.805 //y=5.2 //x2=6.69 //y2=4.7
cc_305 ( N_noxref_1_c_6_p N_noxref_8_c_2466_n ) capacitor c=7.76118e-19 \
 //x=7.4 //y=5.115 //x2=6.69 //y2=4.7
cc_306 ( N_noxref_1_c_158_p N_noxref_8_M21_noxref_g ) capacitor c=0.00842859f \
 //x=6.805 //y=5.2 //x2=6.7 //y2=6.02
cc_307 ( N_noxref_1_c_10_p N_noxref_8_M21_noxref_g ) capacitor c=0.00192712f \
 //x=6.92 //y=5.2 //x2=6.7 //y2=6.02
cc_308 ( N_noxref_1_c_235_p N_noxref_8_M21_noxref_g ) capacitor c=0.0178987f \
 //x=6.92 //y=5.38 //x2=6.7 //y2=6.02
cc_309 ( N_noxref_1_c_8_p N_noxref_8_M22_noxref_g ) capacitor c=0.0107429f \
 //x=7.315 //y=5.2 //x2=7.14 //y2=6.02
cc_310 ( N_noxref_1_c_10_p N_noxref_8_M22_noxref_g ) capacitor c=0.00298276f \
 //x=6.92 //y=5.2 //x2=7.14 //y2=6.02
cc_311 ( N_noxref_1_c_235_p N_noxref_8_M22_noxref_g ) capacitor c=0.0178506f \
 //x=6.92 //y=5.38 //x2=7.14 //y2=6.02
cc_312 ( N_noxref_1_c_17_p N_noxref_8_c_2474_n ) capacitor c=0.00120406f \
 //x=6.96 //y=1 //x2=6.695 //y2=0.905
cc_313 ( N_noxref_1_M4_noxref_d N_noxref_8_c_2474_n ) capacitor c=0.00137165f \
 //x=6.77 //y=0.905 //x2=6.695 //y2=0.905
cc_314 ( N_noxref_1_c_2_p N_noxref_8_c_2476_n ) capacitor c=0.00119302f \
 //x=6.96 //y=1.57 //x2=6.695 //y2=1.25
cc_315 ( N_noxref_1_c_17_p N_noxref_8_c_2476_n ) capacitor c=0.00218772f \
 //x=6.96 //y=1 //x2=6.695 //y2=1.25
cc_316 ( N_noxref_1_M4_noxref_d N_noxref_8_c_2476_n ) capacitor c=0.00237422f \
 //x=6.77 //y=0.905 //x2=6.695 //y2=1.25
cc_317 ( N_noxref_1_c_2_p N_noxref_8_c_2479_n ) capacitor c=0.00439215f \
 //x=6.96 //y=1.57 //x2=6.695 //y2=1.56
cc_318 ( N_noxref_1_c_6_p N_noxref_8_c_2480_n ) capacitor c=0.00845606f \
 //x=7.4 //y=5.115 //x2=7.065 //y2=4.79
cc_319 ( N_noxref_1_c_10_p N_noxref_8_c_2480_n ) capacitor c=0.0020909f \
 //x=6.92 //y=5.2 //x2=7.065 //y2=4.79
cc_320 ( N_noxref_1_c_235_p N_noxref_8_c_2480_n ) capacitor c=0.00291714f \
 //x=6.92 //y=5.38 //x2=7.065 //y2=4.79
cc_321 ( N_noxref_1_c_17_p N_noxref_8_c_2483_n ) capacitor c=5.50523e-19 \
 //x=6.96 //y=1 //x2=7.07 //y2=0.75
cc_322 ( N_noxref_1_M4_noxref_d N_noxref_8_c_2483_n ) capacitor c=0.0020782f \
 //x=6.77 //y=0.905 //x2=7.07 //y2=0.75
cc_323 ( N_noxref_1_c_2_p N_noxref_8_c_2485_n ) capacitor c=0.00917366f \
 //x=6.96 //y=1.57 //x2=7.07 //y2=1.405
cc_324 ( N_noxref_1_c_3_p N_noxref_8_c_2485_n ) capacitor c=0.00194324f \
 //x=7.315 //y=1.655 //x2=7.07 //y2=1.405
cc_325 ( N_noxref_1_c_17_p N_noxref_8_c_2485_n ) capacitor c=5.67071e-19 \
 //x=6.96 //y=1 //x2=7.07 //y2=1.405
cc_326 ( N_noxref_1_M4_noxref_d N_noxref_8_c_2485_n ) capacitor c=0.00356097f \
 //x=6.77 //y=0.905 //x2=7.07 //y2=1.405
cc_327 ( N_noxref_1_c_17_p N_noxref_8_c_2489_n ) capacitor c=0.00109205f \
 //x=6.96 //y=1 //x2=7.225 //y2=0.905
cc_328 ( N_noxref_1_M4_noxref_d N_noxref_8_c_2489_n ) capacitor c=8.50095e-19 \
 //x=6.77 //y=0.905 //x2=7.225 //y2=0.905
cc_329 ( N_noxref_1_c_2_p N_noxref_8_c_2491_n ) capacitor c=0.003249f //x=6.96 \
 //y=1.57 //x2=7.225 //y2=1.25
cc_330 ( N_noxref_1_c_3_p N_noxref_8_c_2491_n ) capacitor c=0.00323005f \
 //x=7.315 //y=1.655 //x2=7.225 //y2=1.25
cc_331 ( N_noxref_1_c_17_p N_noxref_8_c_2491_n ) capacitor c=0.00317092f \
 //x=6.96 //y=1 //x2=7.225 //y2=1.25
cc_332 ( N_noxref_1_M4_noxref_d N_noxref_8_c_2491_n ) capacitor c=0.00237422f \
 //x=6.77 //y=0.905 //x2=7.225 //y2=1.25
cc_333 ( N_noxref_1_c_4_p N_noxref_8_c_2495_n ) capacitor c=0.00281392f \
 //x=7.4 //y=3.17 //x2=6.66 //y2=2.08
cc_334 ( N_noxref_1_c_2_p N_noxref_8_c_2496_n ) capacitor c=0.00341688f \
 //x=6.96 //y=1.57 //x2=6.66 //y2=1.915
cc_335 ( N_noxref_1_c_4_p N_noxref_8_c_2496_n ) capacitor c=0.00309058f \
 //x=7.4 //y=3.17 //x2=6.66 //y2=1.915
cc_336 ( N_noxref_1_c_158_p N_noxref_8_c_2498_n ) capacitor c=9.61466e-19 \
 //x=6.805 //y=5.2 //x2=6.69 //y2=4.7
cc_337 ( N_noxref_1_c_6_p N_noxref_8_c_2498_n ) capacitor c=0.00142201f \
 //x=7.4 //y=5.115 //x2=6.69 //y2=4.7
cc_338 ( N_noxref_1_c_25_p N_noxref_12_c_2906_n ) capacitor c=0.00219445f \
 //x=3.33 //y=2.195 //x2=5.905 //y2=0
cc_339 ( N_noxref_1_c_3_p N_noxref_12_c_2907_n ) capacitor c=0.00653239f \
 //x=7.315 //y=1.655 //x2=9.235 //y2=0
cc_340 ( N_noxref_1_c_17_p N_noxref_12_c_2907_n ) capacitor c=0.00963092f \
 //x=6.96 //y=1 //x2=9.235 //y2=0
cc_341 ( N_noxref_1_M4_noxref_d N_noxref_12_c_2907_n ) capacitor c=3.01654e-19 \
 //x=6.77 //y=0.905 //x2=9.235 //y2=0
cc_342 ( N_noxref_1_c_39_p N_noxref_12_c_2910_n ) capacitor c=6.81737e-19 \
 //x=6.04 //y=5.38 //x2=5.99 //y2=0.955
cc_343 ( N_noxref_1_c_17_p N_noxref_12_c_2910_n ) capacitor c=0.0140211f \
 //x=6.96 //y=1 //x2=5.99 //y2=0.955
cc_344 ( N_noxref_1_M4_noxref_d N_noxref_12_c_2910_n ) capacitor c=2.93544e-19 \
 //x=6.77 //y=0.905 //x2=5.99 //y2=0.955
cc_345 ( N_noxref_1_c_17_p N_noxref_12_c_2913_n ) capacitor c=0.00549186f \
 //x=6.96 //y=1 //x2=9.32 //y2=0.955
cc_346 ( N_noxref_1_c_187_p N_noxref_12_c_2913_n ) capacitor c=0.00709452f \
 //x=9.25 //y=2.08 //x2=9.32 //y2=0.955
cc_347 ( N_noxref_1_c_179_p N_noxref_12_c_2913_n ) capacitor c=2.13705e-19 \
 //x=9.25 //y=2.08 //x2=9.32 //y2=0.955
cc_348 ( N_noxref_1_c_211_p N_noxref_12_c_2913_n ) capacitor c=0.00171023f \
 //x=9.055 //y=0.865 //x2=9.32 //y2=0.955
cc_349 ( N_noxref_1_c_212_p N_noxref_12_c_2913_n ) capacitor c=0.00357815f \
 //x=9.055 //y=1.21 //x2=9.32 //y2=0.955
cc_350 ( N_noxref_1_c_214_p N_noxref_12_c_2913_n ) capacitor c=4.2764e-19 \
 //x=9.055 //y=1.52 //x2=9.32 //y2=0.955
cc_351 ( N_noxref_1_c_351_p N_noxref_12_c_2913_n ) capacitor c=9.36995e-19 \
 //x=9.43 //y=0.71 //x2=9.32 //y2=0.955
cc_352 ( N_noxref_1_c_352_p N_noxref_12_c_2913_n ) capacitor c=6.38426e-19 \
 //x=9.43 //y=1.365 //x2=9.32 //y2=0.955
cc_353 ( N_noxref_1_c_213_p N_noxref_12_c_2913_n ) capacitor c=0.00171721f \
 //x=9.585 //y=0.865 //x2=9.32 //y2=0.955
cc_354 ( N_noxref_1_c_215_p N_noxref_12_c_2913_n ) capacitor c=0.00296337f \
 //x=9.585 //y=1.21 //x2=9.32 //y2=0.955
cc_355 ( N_noxref_1_c_211_p N_noxref_12_c_2923_n ) capacitor c=3.46594e-19 \
 //x=9.055 //y=0.865 //x2=9.317 //y2=0.825
cc_356 ( N_noxref_1_c_351_p N_noxref_12_c_2923_n ) capacitor c=0.00839621f \
 //x=9.43 //y=0.71 //x2=9.317 //y2=0.825
cc_357 ( N_noxref_1_c_213_p N_noxref_12_c_2923_n ) capacitor c=4.40641e-19 \
 //x=9.585 //y=0.865 //x2=9.317 //y2=0.825
cc_358 ( N_noxref_1_c_25_p N_noxref_12_c_2926_n ) capacitor c=2.01623e-19 \
 //x=3.33 //y=2.195 //x2=4.64 //y2=0
cc_359 ( N_noxref_1_c_3_p N_noxref_12_c_2927_n ) capacitor c=7.76556e-19 \
 //x=7.315 //y=1.655 //x2=7.97 //y2=0
cc_360 ( N_noxref_1_c_211_p N_noxref_12_c_2928_n ) capacitor c=0.00685132f \
 //x=9.055 //y=0.865 //x2=11.3 //y2=0
cc_361 ( N_noxref_1_c_17_p N_noxref_12_c_2929_n ) capacitor c=2.83275e-19 \
 //x=6.96 //y=1 //x2=21.09 //y2=0
cc_362 ( N_noxref_1_c_4_p N_noxref_12_c_2930_n ) capacitor c=9.32616e-19 \
 //x=7.4 //y=3.17 //x2=4.81 //y2=0
cc_363 ( N_noxref_1_c_115_p N_noxref_12_c_2930_n ) capacitor c=0.00560353f \
 //x=5.53 //y=3.33 //x2=4.81 //y2=0
cc_364 ( N_noxref_1_c_26_p N_noxref_12_c_2930_n ) capacitor c=0.00239899f \
 //x=3.33 //y=2.08 //x2=4.81 //y2=0
cc_365 ( N_noxref_1_c_82_p N_noxref_12_c_2930_n ) capacitor c=0.00262688f \
 //x=3.85 //y=1.26 //x2=4.81 //y2=0
cc_366 ( N_noxref_1_c_27_p N_noxref_12_c_2930_n ) capacitor c=2.63786e-19 \
 //x=3.33 //y=2.08 //x2=4.81 //y2=0
cc_367 ( N_noxref_1_c_2_p N_noxref_12_c_2935_n ) capacitor c=0.002973f \
 //x=6.96 //y=1.57 //x2=8.14 //y2=0
cc_368 ( N_noxref_1_c_3_p N_noxref_12_c_2935_n ) capacitor c=0.0300121f \
 //x=7.315 //y=1.655 //x2=8.14 //y2=0
cc_369 ( N_noxref_1_c_5_p N_noxref_12_c_2935_n ) capacitor c=0.00829739f \
 //x=9.25 //y=3.165 //x2=8.14 //y2=0
cc_370 ( N_noxref_1_c_187_p N_noxref_12_c_2935_n ) capacitor c=0.00427323f \
 //x=9.25 //y=2.08 //x2=8.14 //y2=0
cc_371 ( N_noxref_1_c_138_p N_noxref_12_c_2935_n ) capacitor c=0.00560353f \
 //x=9.085 //y=3.325 //x2=8.14 //y2=0
cc_372 ( N_noxref_1_c_179_p N_noxref_12_c_2935_n ) capacitor c=0.0038607f \
 //x=9.25 //y=2.08 //x2=8.14 //y2=0
cc_373 ( N_noxref_1_c_214_p N_noxref_12_c_2935_n ) capacitor c=0.0015404f \
 //x=9.055 //y=1.52 //x2=8.14 //y2=0
cc_374 ( N_noxref_1_c_189_p N_noxref_12_c_2935_n ) capacitor c=0.00906518f \
 //x=9.055 //y=1.915 //x2=8.14 //y2=0
cc_375 ( N_noxref_1_c_17_p N_noxref_12_M3_noxref_d ) capacitor c=2.82748e-19 \
 //x=6.96 //y=1 //x2=5.8 //y2=0.865
cc_376 ( N_noxref_1_c_187_p N_noxref_12_M5_noxref_d ) capacitor c=2.20438e-19 \
 //x=9.25 //y=2.08 //x2=9.13 //y2=0.865
cc_377 ( N_noxref_1_c_211_p N_noxref_12_M5_noxref_d ) capacitor c=0.00192399f \
 //x=9.055 //y=0.865 //x2=9.13 //y2=0.865
cc_378 ( N_noxref_1_c_212_p N_noxref_12_M5_noxref_d ) capacitor c=0.00210798f \
 //x=9.055 //y=1.21 //x2=9.13 //y2=0.865
cc_379 ( N_noxref_1_c_351_p N_noxref_12_M5_noxref_d ) capacitor c=0.00472259f \
 //x=9.43 //y=0.71 //x2=9.13 //y2=0.865
cc_380 ( N_noxref_1_c_352_p N_noxref_12_M5_noxref_d ) capacitor c=0.00166857f \
 //x=9.43 //y=1.365 //x2=9.13 //y2=0.865
cc_381 ( N_noxref_1_c_213_p N_noxref_12_M5_noxref_d ) capacitor c=0.00230174f \
 //x=9.585 //y=0.865 //x2=9.13 //y2=0.865
cc_382 ( N_noxref_1_c_215_p N_noxref_12_M5_noxref_d ) capacitor c=0.00210798f \
 //x=9.585 //y=1.21 //x2=9.13 //y2=0.865
cc_383 ( N_noxref_1_c_115_p N_noxref_15_c_3494_n ) capacitor c=0.00263807f \
 //x=5.53 //y=3.33 //x2=5.505 //y2=1.495
cc_384 ( N_noxref_1_c_115_p N_noxref_15_c_3495_n ) capacitor c=0.00586062f \
 //x=5.53 //y=3.33 //x2=6.39 //y2=1.58
cc_385 ( N_noxref_1_c_117_p N_noxref_15_c_3495_n ) capacitor c=0.00236963f \
 //x=7.555 //y=3.33 //x2=6.39 //y2=1.58
cc_386 ( N_noxref_1_c_89_p N_noxref_15_c_3497_n ) capacitor c=0.00911405f \
 //x=7.045 //y=1.655 //x2=6.475 //y2=1.495
cc_387 ( N_noxref_1_c_117_p N_noxref_15_c_3497_n ) capacitor c=0.0023811f \
 //x=7.555 //y=3.33 //x2=6.475 //y2=1.495
cc_388 ( N_noxref_1_c_3_p N_noxref_15_c_3499_n ) capacitor c=0.00389706f \
 //x=7.315 //y=1.655 //x2=7.36 //y2=0.53
cc_389 ( N_noxref_1_c_17_p N_noxref_15_c_3499_n ) capacitor c=0.00367971f \
 //x=6.96 //y=1 //x2=7.36 //y2=0.53
cc_390 ( N_noxref_1_M4_noxref_d N_noxref_15_c_3499_n ) capacitor c=0.00910163f \
 //x=6.77 //y=0.905 //x2=7.36 //y2=0.53
cc_391 ( N_noxref_1_c_2_p N_noxref_15_M3_noxref_s ) capacitor c=0.01625f \
 //x=6.96 //y=1.57 //x2=5.37 //y2=0.365
cc_392 ( N_noxref_1_c_3_p N_noxref_15_M3_noxref_s ) capacitor c=0.00640979f \
 //x=7.315 //y=1.655 //x2=5.37 //y2=0.365
cc_393 ( N_noxref_1_c_136_p N_noxref_15_M3_noxref_s ) capacitor c=4.17069e-19 \
 //x=7.4 //y=3.49 //x2=5.37 //y2=0.365
cc_394 ( N_noxref_1_c_17_p N_noxref_15_M3_noxref_s ) capacitor c=0.00905337f \
 //x=6.96 //y=1 //x2=5.37 //y2=0.365
cc_395 ( N_noxref_1_c_275_p N_noxref_15_M3_noxref_s ) capacitor c=0.0010514f \
 //x=7.395 //y=3.33 //x2=5.37 //y2=0.365
cc_396 ( N_noxref_1_M4_noxref_d N_noxref_15_M3_noxref_s ) capacitor \
 c=0.0275552f //x=6.77 //y=0.905 //x2=5.37 //y2=0.365
cc_397 ( N_noxref_1_c_138_p N_noxref_16_c_3560_n ) capacitor c=0.00264481f \
 //x=9.085 //y=3.325 //x2=8.835 //y2=1.495
cc_398 ( N_noxref_1_c_189_p N_noxref_16_c_3560_n ) capacitor c=0.00262672f \
 //x=9.055 //y=1.915 //x2=8.835 //y2=1.495
cc_399 ( N_noxref_1_c_9_p N_noxref_16_c_3562_n ) capacitor c=0.00402488f \
 //x=9.25 //y=3.485 //x2=9.72 //y2=1.58
cc_400 ( N_noxref_1_c_187_p N_noxref_16_c_3562_n ) capacitor c=0.00509504f \
 //x=9.25 //y=2.08 //x2=9.72 //y2=1.58
cc_401 ( N_noxref_1_c_138_p N_noxref_16_c_3562_n ) capacitor c=9.85544e-19 \
 //x=9.085 //y=3.325 //x2=9.72 //y2=1.58
cc_402 ( N_noxref_1_c_179_p N_noxref_16_c_3562_n ) capacitor c=0.00763108f \
 //x=9.25 //y=2.08 //x2=9.72 //y2=1.58
cc_403 ( N_noxref_1_c_214_p N_noxref_16_c_3562_n ) capacitor c=0.00697076f \
 //x=9.055 //y=1.52 //x2=9.72 //y2=1.58
cc_404 ( N_noxref_1_c_189_p N_noxref_16_c_3562_n ) capacitor c=0.0180051f \
 //x=9.055 //y=1.915 //x2=9.72 //y2=1.58
cc_405 ( N_noxref_1_c_352_p N_noxref_16_c_3562_n ) capacitor c=0.00723574f \
 //x=9.43 //y=1.365 //x2=9.72 //y2=1.58
cc_406 ( N_noxref_1_c_215_p N_noxref_16_c_3562_n ) capacitor c=0.00399755f \
 //x=9.585 //y=1.21 //x2=9.72 //y2=1.58
cc_407 ( N_noxref_1_c_189_p N_noxref_16_c_3570_n ) capacitor c=6.71402e-19 \
 //x=9.055 //y=1.915 //x2=9.805 //y2=1.495
cc_408 ( N_noxref_1_c_211_p N_noxref_16_M5_noxref_s ) capacitor c=0.0294925f \
 //x=9.055 //y=0.865 //x2=8.7 //y2=0.365
cc_409 ( N_noxref_1_c_214_p N_noxref_16_M5_noxref_s ) capacitor c=3.48408e-19 \
 //x=9.055 //y=1.52 //x2=8.7 //y2=0.365
cc_410 ( N_noxref_1_c_213_p N_noxref_16_M5_noxref_s ) capacitor c=0.0125442f \
 //x=9.585 //y=0.865 //x2=8.7 //y2=0.365
cc_411 ( N_noxref_2_c_435_p N_noxref_3_c_727_n ) capacitor c=0.0147952f \
 //x=12.58 //y=4.7 //x2=13.345 //y2=4.685
cc_412 ( N_noxref_2_c_436_p N_noxref_3_c_727_n ) capacitor c=0.00198309f \
 //x=12.582 //y=4.56 //x2=13.345 //y2=4.685
cc_413 ( N_noxref_2_c_437_p N_noxref_3_c_727_n ) capacitor c=7.64003e-19 \
 //x=12.58 //y=4.7 //x2=13.345 //y2=4.685
cc_414 ( N_noxref_2_c_438_p N_noxref_3_c_727_n ) capacitor c=0.00163736f \
 //x=12.58 //y=4.7 //x2=13.345 //y2=4.685
cc_415 ( N_noxref_2_c_414_n N_noxref_3_c_731_n ) capacitor c=0.0021505f \
 //x=10.73 //y=3.17 //x2=13.345 //y2=4.525
cc_416 ( N_noxref_2_c_416_n N_noxref_3_c_731_n ) capacitor c=0.00126687f \
 //x=10.73 //y=5.115 //x2=13.345 //y2=4.525
cc_417 ( N_noxref_2_c_441_p N_noxref_3_c_731_n ) capacitor c=0.0428988f \
 //x=12.58 //y=3.17 //x2=13.345 //y2=4.525
cc_418 ( N_noxref_2_c_442_p N_noxref_3_c_731_n ) capacitor c=0.0146933f \
 //x=12.58 //y=3.49 //x2=13.345 //y2=4.525
cc_419 ( N_noxref_2_c_443_p N_noxref_3_c_731_n ) capacitor c=6.03895e-19 \
 //x=12.575 //y=3.33 //x2=13.345 //y2=4.525
cc_420 ( N_noxref_2_c_436_p N_noxref_3_c_731_n ) capacitor c=0.0384373f \
 //x=12.582 //y=4.56 //x2=13.345 //y2=4.525
cc_421 ( N_noxref_2_c_445_p N_noxref_3_c_731_n ) capacitor c=0.00684103f \
 //x=12.575 //y=3.33 //x2=13.345 //y2=4.525
cc_422 ( N_noxref_2_c_446_p N_noxref_3_c_731_n ) capacitor c=3.49899e-19 \
 //x=12.58 //y=2.08 //x2=13.345 //y2=4.525
cc_423 ( N_noxref_2_c_447_p N_noxref_3_c_739_n ) capacitor c=0.0205342f \
 //x=12.58 //y=2.08 //x2=13.32 //y2=2.08
cc_424 ( N_noxref_2_c_446_p N_noxref_3_c_739_n ) capacitor c=5.16867e-19 \
 //x=12.58 //y=2.08 //x2=13.32 //y2=2.08
cc_425 ( N_noxref_2_c_449_p N_noxref_3_c_739_n ) capacitor c=0.00167888f \
 //x=12.385 //y=1.915 //x2=13.32 //y2=2.08
cc_426 ( N_noxref_2_c_411_n N_noxref_3_c_699_n ) capacitor c=0.00611627f \
 //x=10.135 //y=5.2 //x2=9.61 //y2=4.44
cc_427 ( N_noxref_2_c_418_n N_noxref_3_c_699_n ) capacitor c=0.0154722f \
 //x=9.37 //y=5.38 //x2=9.61 //y2=4.44
cc_428 ( N_noxref_2_c_416_n N_noxref_3_c_744_n ) capacitor c=0.0291324f \
 //x=10.73 //y=5.115 //x2=10.21 //y2=4.46
cc_429 ( N_noxref_2_c_453_p N_noxref_3_c_744_n ) capacitor c=0.0211374f \
 //x=10.25 //y=5.2 //x2=10.21 //y2=4.46
cc_430 ( N_noxref_2_c_435_p N_noxref_3_c_744_n ) capacitor c=0.0114767f \
 //x=12.58 //y=4.7 //x2=10.21 //y2=4.46
cc_431 ( N_noxref_2_c_436_p N_noxref_3_c_744_n ) capacitor c=0.0274896f \
 //x=12.582 //y=4.56 //x2=10.21 //y2=4.46
cc_432 ( N_noxref_2_c_441_p N_noxref_3_c_748_n ) capacitor c=3.49899e-19 \
 //x=12.58 //y=3.17 //x2=13.32 //y2=2.08
cc_433 ( N_noxref_2_c_447_p N_noxref_3_c_748_n ) capacitor c=5.24723e-19 \
 //x=12.58 //y=2.08 //x2=13.32 //y2=2.08
cc_434 ( N_noxref_2_c_446_p N_noxref_3_c_748_n ) capacitor c=0.00525888f \
 //x=12.58 //y=2.08 //x2=13.32 //y2=2.08
cc_435 ( N_noxref_2_c_449_p N_noxref_3_c_748_n ) capacitor c=0.00190888f \
 //x=12.385 //y=1.915 //x2=13.32 //y2=2.08
cc_436 ( N_noxref_2_c_435_p N_noxref_3_c_752_n ) capacitor c=4.80626e-19 \
 //x=12.58 //y=4.7 //x2=13.35 //y2=4.7
cc_437 ( N_noxref_2_c_437_p N_noxref_3_c_752_n ) capacitor c=0.00396769f \
 //x=12.58 //y=4.7 //x2=13.35 //y2=4.7
cc_438 ( N_noxref_2_c_438_p N_noxref_3_c_752_n ) capacitor c=0.0028411f \
 //x=12.58 //y=4.7 //x2=13.35 //y2=4.7
cc_439 ( N_noxref_2_M27_noxref_g N_noxref_3_M29_noxref_g ) capacitor \
 c=0.0104892f //x=12.48 //y=6.02 //x2=13.36 //y2=6.02
cc_440 ( N_noxref_2_M28_noxref_g N_noxref_3_M29_noxref_g ) capacitor \
 c=0.107636f //x=12.92 //y=6.02 //x2=13.36 //y2=6.02
cc_441 ( N_noxref_2_M28_noxref_g N_noxref_3_M30_noxref_g ) capacitor \
 c=0.0100341f //x=12.92 //y=6.02 //x2=13.8 //y2=6.02
cc_442 ( N_noxref_2_c_466_p N_noxref_3_c_758_n ) capacitor c=4.86545e-19 \
 //x=12.385 //y=0.865 //x2=13.355 //y2=0.905
cc_443 ( N_noxref_2_c_467_p N_noxref_3_c_758_n ) capacitor c=0.00152405f \
 //x=12.385 //y=1.21 //x2=13.355 //y2=0.905
cc_444 ( N_noxref_2_c_468_p N_noxref_3_c_758_n ) capacitor c=0.0151475f \
 //x=12.915 //y=0.865 //x2=13.355 //y2=0.905
cc_445 ( N_noxref_2_c_469_p N_noxref_3_c_761_n ) capacitor c=0.00109982f \
 //x=12.385 //y=1.52 //x2=13.355 //y2=1.25
cc_446 ( N_noxref_2_c_470_p N_noxref_3_c_761_n ) capacitor c=0.0111064f \
 //x=12.915 //y=1.21 //x2=13.355 //y2=1.25
cc_447 ( N_noxref_2_c_469_p N_noxref_3_c_763_n ) capacitor c=9.58243e-19 \
 //x=12.385 //y=1.52 //x2=13.355 //y2=1.56
cc_448 ( N_noxref_2_c_449_p N_noxref_3_c_763_n ) capacitor c=0.00662747f \
 //x=12.385 //y=1.915 //x2=13.355 //y2=1.56
cc_449 ( N_noxref_2_c_470_p N_noxref_3_c_763_n ) capacitor c=0.00862358f \
 //x=12.915 //y=1.21 //x2=13.355 //y2=1.56
cc_450 ( N_noxref_2_c_468_p N_noxref_3_c_766_n ) capacitor c=0.00127211f \
 //x=12.915 //y=0.865 //x2=13.885 //y2=0.905
cc_451 ( N_noxref_2_c_470_p N_noxref_3_c_767_n ) capacitor c=0.00204774f \
 //x=12.915 //y=1.21 //x2=13.885 //y2=1.25
cc_452 ( N_noxref_2_c_447_p N_noxref_3_c_768_n ) capacitor c=0.00167305f \
 //x=12.58 //y=2.08 //x2=13.32 //y2=2.08
cc_453 ( N_noxref_2_c_446_p N_noxref_3_c_768_n ) capacitor c=0.0018937f \
 //x=12.58 //y=2.08 //x2=13.32 //y2=2.08
cc_454 ( N_noxref_2_c_449_p N_noxref_3_c_768_n ) capacitor c=0.0181449f \
 //x=12.385 //y=1.915 //x2=13.32 //y2=2.08
cc_455 ( N_noxref_2_c_437_p N_noxref_3_c_771_n ) capacitor c=0.00202662f \
 //x=12.58 //y=4.7 //x2=13.35 //y2=4.7
cc_456 ( N_noxref_2_c_438_p N_noxref_3_c_771_n ) capacitor c=0.0288755f \
 //x=12.58 //y=4.7 //x2=13.35 //y2=4.7
cc_457 ( N_noxref_2_c_481_p N_noxref_4_c_1077_n ) capacitor c=0.00188982f \
 //x=10.645 //y=1.655 //x2=10.21 //y2=3.69
cc_458 ( N_noxref_2_c_413_n N_noxref_4_c_1077_n ) capacitor c=0.00322729f \
 //x=10.375 //y=1.655 //x2=10.21 //y2=3.69
cc_459 ( N_noxref_2_c_483_p N_noxref_4_c_1077_n ) capacitor c=0.00129068f \
 //x=10.73 //y=3.49 //x2=10.21 //y2=3.69
cc_460 ( N_noxref_2_c_416_n N_noxref_4_c_1077_n ) capacitor c=7.17731e-19 \
 //x=10.73 //y=5.115 //x2=10.21 //y2=3.69
cc_461 ( N_noxref_2_c_429_n N_noxref_4_c_1077_n ) capacitor c=0.0367952f \
 //x=10.895 //y=3.33 //x2=10.21 //y2=3.69
cc_462 ( N_noxref_2_c_483_p N_noxref_4_c_1082_n ) capacitor c=0.00771097f \
 //x=10.73 //y=3.49 //x2=10.95 //y2=3.715
cc_463 ( N_noxref_2_c_416_n N_noxref_4_c_1082_n ) capacitor c=0.0225064f \
 //x=10.73 //y=5.115 //x2=10.95 //y2=3.715
cc_464 ( N_noxref_2_c_488_p N_noxref_4_c_1082_n ) capacitor c=0.132506f \
 //x=12.415 //y=3.33 //x2=10.95 //y2=3.715
cc_465 ( N_noxref_2_c_442_p N_noxref_4_c_1085_n ) capacitor c=0.00341263f \
 //x=12.58 //y=3.49 //x2=12.19 //y2=3.7
cc_466 ( N_noxref_2_c_436_p N_noxref_4_c_1085_n ) capacitor c=4.98692e-19 \
 //x=12.582 //y=4.56 //x2=12.19 //y2=3.7
cc_467 ( N_noxref_2_c_488_p N_noxref_4_c_1085_n ) capacitor c=0.0114055f \
 //x=12.415 //y=3.33 //x2=12.19 //y2=3.7
cc_468 ( N_noxref_2_c_445_p N_noxref_4_c_1085_n ) capacitor c=0.0367952f \
 //x=12.575 //y=3.33 //x2=12.19 //y2=3.7
cc_469 ( N_noxref_2_c_442_p N_noxref_4_c_1089_n ) capacitor c=0.00251183f \
 //x=12.58 //y=3.49 //x2=12.79 //y2=3.715
cc_470 ( N_noxref_2_c_436_p N_noxref_4_c_1089_n ) capacitor c=0.0224596f \
 //x=12.582 //y=4.56 //x2=12.79 //y2=3.715
cc_471 ( N_noxref_2_c_414_n N_noxref_5_c_1441_n ) capacitor c=0.0428807f \
 //x=10.73 //y=3.17 //x2=9.99 //y2=3.915
cc_472 ( N_noxref_2_c_483_p N_noxref_5_c_1441_n ) capacitor c=0.0146933f \
 //x=10.73 //y=3.49 //x2=9.99 //y2=3.915
cc_473 ( N_noxref_2_c_416_n N_noxref_5_c_1441_n ) capacitor c=0.0169815f \
 //x=10.73 //y=5.115 //x2=9.99 //y2=3.915
cc_474 ( N_noxref_2_c_441_p N_noxref_5_c_1441_n ) capacitor c=0.00211383f \
 //x=12.58 //y=3.17 //x2=9.99 //y2=3.915
cc_475 ( N_noxref_2_c_428_n N_noxref_5_c_1441_n ) capacitor c=5.52402e-19 \
 //x=10.73 //y=3.33 //x2=9.99 //y2=3.915
cc_476 ( N_noxref_2_c_436_p N_noxref_5_c_1441_n ) capacitor c=3.11039e-19 \
 //x=12.582 //y=4.56 //x2=9.99 //y2=3.915
cc_477 ( N_noxref_2_c_429_n N_noxref_5_c_1441_n ) capacitor c=0.00365012f \
 //x=10.895 //y=3.33 //x2=9.99 //y2=3.915
cc_478 ( N_noxref_2_c_411_n N_noxref_5_c_1449_n ) capacitor c=0.0042527f \
 //x=10.135 //y=5.2 //x2=9.99 //y2=4.235
cc_479 ( N_noxref_2_c_416_n N_noxref_5_c_1449_n ) capacitor c=0.0147977f \
 //x=10.73 //y=5.115 //x2=9.99 //y2=4.235
cc_480 ( N_noxref_2_c_411_n N_noxref_5_c_1450_n ) capacitor c=0.0215252f \
 //x=10.135 //y=5.2 //x2=9.99 //y2=4.555
cc_481 ( N_noxref_2_c_416_n N_noxref_5_c_1450_n ) capacitor c=0.0281817f \
 //x=10.73 //y=5.115 //x2=9.99 //y2=4.555
cc_482 ( N_noxref_2_c_436_p N_noxref_5_c_1450_n ) capacitor c=4.6528e-19 \
 //x=12.582 //y=4.56 //x2=9.99 //y2=4.555
cc_483 ( N_noxref_2_M28_noxref_g N_noxref_5_c_1508_n ) capacitor c=0.00889217f \
 //x=12.92 //y=6.02 //x2=13.465 //y2=5.2
cc_484 ( N_noxref_2_c_412_n N_noxref_5_c_1509_n ) capacitor c=0.00324213f \
 //x=10.29 //y=1.57 //x2=13.62 //y2=1.57
cc_485 ( N_noxref_2_c_481_p N_noxref_5_c_1510_n ) capacitor c=0.00231467f \
 //x=10.645 //y=1.655 //x2=13.705 //y2=1.655
cc_486 ( N_noxref_2_c_414_n N_noxref_5_c_1511_n ) capacitor c=0.00204244f \
 //x=10.73 //y=3.17 //x2=14.06 //y2=3.925
cc_487 ( N_noxref_2_c_441_p N_noxref_5_c_1511_n ) capacitor c=0.00327648f \
 //x=12.58 //y=3.17 //x2=14.06 //y2=3.925
cc_488 ( N_noxref_2_c_436_p N_noxref_5_c_1511_n ) capacitor c=7.58839e-19 \
 //x=12.582 //y=4.56 //x2=14.06 //y2=3.925
cc_489 ( N_noxref_2_c_416_n N_noxref_5_c_1514_n ) capacitor c=0.00281705f \
 //x=10.73 //y=5.115 //x2=14.06 //y2=5.115
cc_490 ( N_noxref_2_c_436_p N_noxref_5_c_1514_n ) capacitor c=0.00105238f \
 //x=12.582 //y=4.56 //x2=14.06 //y2=5.115
cc_491 ( N_noxref_2_c_416_n N_noxref_5_c_1455_n ) capacitor c=6.89957e-19 \
 //x=10.73 //y=5.115 //x2=9.99 //y2=4.07
cc_492 ( N_noxref_2_c_414_n N_noxref_5_c_1456_n ) capacitor c=0.015397f \
 //x=10.73 //y=3.17 //x2=9.99 //y2=2.08
cc_493 ( N_noxref_2_c_517_p N_noxref_5_c_1518_n ) capacitor c=0.00114153f \
 //x=10.645 //y=5.2 //x2=12.7 //y2=5.38
cc_494 ( N_noxref_2_c_442_p N_noxref_5_c_1518_n ) capacitor c=5.66772e-19 \
 //x=12.58 //y=3.49 //x2=12.7 //y2=5.38
cc_495 ( N_noxref_2_c_453_p N_noxref_5_c_1518_n ) capacitor c=5.29822e-19 \
 //x=10.25 //y=5.2 //x2=12.7 //y2=5.38
cc_496 ( N_noxref_2_c_520_p N_noxref_5_c_1518_n ) capacitor c=0.00147119f \
 //x=10.25 //y=5.38 //x2=12.7 //y2=5.38
cc_497 ( N_noxref_2_c_435_p N_noxref_5_c_1518_n ) capacitor c=0.0117744f \
 //x=12.58 //y=4.7 //x2=12.7 //y2=5.38
cc_498 ( N_noxref_2_c_437_p N_noxref_5_c_1518_n ) capacitor c=0.00277154f \
 //x=12.58 //y=4.7 //x2=12.7 //y2=5.38
cc_499 ( N_noxref_2_M27_noxref_g N_noxref_5_c_1518_n ) capacitor c=0.00201806f \
 //x=12.48 //y=6.02 //x2=12.7 //y2=5.38
cc_500 ( N_noxref_2_M28_noxref_g N_noxref_5_c_1518_n ) capacitor c=0.00192712f \
 //x=12.92 //y=6.02 //x2=12.7 //y2=5.38
cc_501 ( N_noxref_2_c_438_p N_noxref_5_c_1518_n ) capacitor c=0.00194519f \
 //x=12.58 //y=4.7 //x2=12.7 //y2=5.38
cc_502 ( N_noxref_2_c_427_n N_noxref_5_c_1527_n ) capacitor c=6.99317e-19 \
 //x=10.29 //y=1 //x2=13.62 //y2=1
cc_503 ( N_noxref_2_c_416_n N_noxref_5_c_1528_n ) capacitor c=0.0227736f \
 //x=10.73 //y=5.115 //x2=13.89 //y2=4.07
cc_504 ( N_noxref_2_c_436_p N_noxref_5_c_1528_n ) capacitor c=0.0232046f \
 //x=12.582 //y=4.56 //x2=13.89 //y2=4.07
cc_505 ( N_noxref_2_c_488_p N_noxref_5_c_1528_n ) capacitor c=0.00973574f \
 //x=12.415 //y=3.33 //x2=13.89 //y2=4.07
cc_506 ( N_noxref_2_c_416_n N_noxref_5_c_1466_n ) capacitor c=0.00328982f \
 //x=10.73 //y=5.115 //x2=10.155 //y2=4.07
cc_507 ( N_noxref_2_c_414_n N_noxref_5_c_1470_n ) capacitor c=9.90728e-19 \
 //x=10.73 //y=3.17 //x2=9.99 //y2=2.08
cc_508 ( N_noxref_2_c_411_n N_noxref_5_c_1474_n ) capacitor c=0.00469257f \
 //x=10.135 //y=5.2 //x2=10.02 //y2=4.7
cc_509 ( N_noxref_2_c_416_n N_noxref_5_c_1474_n ) capacitor c=7.76118e-19 \
 //x=10.73 //y=5.115 //x2=10.02 //y2=4.7
cc_510 ( N_noxref_2_c_435_p N_noxref_5_c_1535_n ) capacitor c=0.00104426f \
 //x=12.58 //y=4.7 //x2=12.7 //y2=5.38
cc_511 ( N_noxref_2_c_437_p N_noxref_5_c_1535_n ) capacitor c=0.00377369f \
 //x=12.58 //y=4.7 //x2=12.7 //y2=5.38
cc_512 ( N_noxref_2_M27_noxref_g N_noxref_5_c_1535_n ) capacitor c=0.0158358f \
 //x=12.48 //y=6.02 //x2=12.7 //y2=5.38
cc_513 ( N_noxref_2_M28_noxref_g N_noxref_5_c_1535_n ) capacitor c=0.0178987f \
 //x=12.92 //y=6.02 //x2=12.7 //y2=5.38
cc_514 ( N_noxref_2_c_438_p N_noxref_5_c_1535_n ) capacitor c=0.0043218f \
 //x=12.58 //y=4.7 //x2=12.7 //y2=5.38
cc_515 ( N_noxref_2_c_411_n N_noxref_5_M25_noxref_g ) capacitor c=0.00842859f \
 //x=10.135 //y=5.2 //x2=10.03 //y2=6.02
cc_516 ( N_noxref_2_c_453_p N_noxref_5_M25_noxref_g ) capacitor c=0.00192712f \
 //x=10.25 //y=5.2 //x2=10.03 //y2=6.02
cc_517 ( N_noxref_2_c_541_p N_noxref_5_M25_noxref_g ) capacitor c=0.0178987f \
 //x=10.25 //y=5.38 //x2=10.03 //y2=6.02
cc_518 ( N_noxref_2_c_517_p N_noxref_5_M26_noxref_g ) capacitor c=0.0106088f \
 //x=10.645 //y=5.2 //x2=10.47 //y2=6.02
cc_519 ( N_noxref_2_c_453_p N_noxref_5_M26_noxref_g ) capacitor c=0.00298276f \
 //x=10.25 //y=5.2 //x2=10.47 //y2=6.02
cc_520 ( N_noxref_2_c_541_p N_noxref_5_M26_noxref_g ) capacitor c=0.0178506f \
 //x=10.25 //y=5.38 //x2=10.47 //y2=6.02
cc_521 ( N_noxref_2_c_427_n N_noxref_5_c_1480_n ) capacitor c=0.00120406f \
 //x=10.29 //y=1 //x2=10.025 //y2=0.905
cc_522 ( N_noxref_2_M6_noxref_d N_noxref_5_c_1480_n ) capacitor c=0.00137165f \
 //x=10.1 //y=0.905 //x2=10.025 //y2=0.905
cc_523 ( N_noxref_2_c_412_n N_noxref_5_c_1483_n ) capacitor c=0.00119008f \
 //x=10.29 //y=1.57 //x2=10.025 //y2=1.25
cc_524 ( N_noxref_2_c_427_n N_noxref_5_c_1483_n ) capacitor c=0.00218694f \
 //x=10.29 //y=1 //x2=10.025 //y2=1.25
cc_525 ( N_noxref_2_M6_noxref_d N_noxref_5_c_1483_n ) capacitor c=0.00237422f \
 //x=10.1 //y=0.905 //x2=10.025 //y2=1.25
cc_526 ( N_noxref_2_c_412_n N_noxref_5_c_1485_n ) capacitor c=0.00438634f \
 //x=10.29 //y=1.57 //x2=10.025 //y2=1.56
cc_527 ( N_noxref_2_c_416_n N_noxref_5_c_1552_n ) capacitor c=0.00845606f \
 //x=10.73 //y=5.115 //x2=10.395 //y2=4.79
cc_528 ( N_noxref_2_c_453_p N_noxref_5_c_1552_n ) capacitor c=0.0020909f \
 //x=10.25 //y=5.2 //x2=10.395 //y2=4.79
cc_529 ( N_noxref_2_c_541_p N_noxref_5_c_1552_n ) capacitor c=0.00291714f \
 //x=10.25 //y=5.38 //x2=10.395 //y2=4.79
cc_530 ( N_noxref_2_c_427_n N_noxref_5_c_1555_n ) capacitor c=5.50523e-19 \
 //x=10.29 //y=1 //x2=10.4 //y2=0.75
cc_531 ( N_noxref_2_M6_noxref_d N_noxref_5_c_1555_n ) capacitor c=0.0020782f \
 //x=10.1 //y=0.905 //x2=10.4 //y2=0.75
cc_532 ( N_noxref_2_c_412_n N_noxref_5_c_1557_n ) capacitor c=0.00916852f \
 //x=10.29 //y=1.57 //x2=10.4 //y2=1.405
cc_533 ( N_noxref_2_c_481_p N_noxref_5_c_1557_n ) capacitor c=0.00194324f \
 //x=10.645 //y=1.655 //x2=10.4 //y2=1.405
cc_534 ( N_noxref_2_c_427_n N_noxref_5_c_1557_n ) capacitor c=5.67071e-19 \
 //x=10.29 //y=1 //x2=10.4 //y2=1.405
cc_535 ( N_noxref_2_M6_noxref_d N_noxref_5_c_1557_n ) capacitor c=0.00356097f \
 //x=10.1 //y=0.905 //x2=10.4 //y2=1.405
cc_536 ( N_noxref_2_c_427_n N_noxref_5_c_1488_n ) capacitor c=0.00109205f \
 //x=10.29 //y=1 //x2=10.555 //y2=0.905
cc_537 ( N_noxref_2_M6_noxref_d N_noxref_5_c_1488_n ) capacitor c=8.50095e-19 \
 //x=10.1 //y=0.905 //x2=10.555 //y2=0.905
cc_538 ( N_noxref_2_c_412_n N_noxref_5_c_1489_n ) capacitor c=0.003249f \
 //x=10.29 //y=1.57 //x2=10.555 //y2=1.25
cc_539 ( N_noxref_2_c_481_p N_noxref_5_c_1489_n ) capacitor c=0.00323005f \
 //x=10.645 //y=1.655 //x2=10.555 //y2=1.25
cc_540 ( N_noxref_2_c_427_n N_noxref_5_c_1489_n ) capacitor c=0.00317092f \
 //x=10.29 //y=1 //x2=10.555 //y2=1.25
cc_541 ( N_noxref_2_M6_noxref_d N_noxref_5_c_1489_n ) capacitor c=0.00237422f \
 //x=10.1 //y=0.905 //x2=10.555 //y2=1.25
cc_542 ( N_noxref_2_c_414_n N_noxref_5_c_1490_n ) capacitor c=0.00281392f \
 //x=10.73 //y=3.17 //x2=9.99 //y2=2.08
cc_543 ( N_noxref_2_c_412_n N_noxref_5_c_1568_n ) capacitor c=0.00341114f \
 //x=10.29 //y=1.57 //x2=9.99 //y2=1.915
cc_544 ( N_noxref_2_c_414_n N_noxref_5_c_1568_n ) capacitor c=0.00309058f \
 //x=10.73 //y=3.17 //x2=9.99 //y2=1.915
cc_545 ( N_noxref_2_c_411_n N_noxref_5_c_1493_n ) capacitor c=8.41897e-19 \
 //x=10.135 //y=5.2 //x2=10.02 //y2=4.7
cc_546 ( N_noxref_2_c_416_n N_noxref_5_c_1493_n ) capacitor c=0.00142201f \
 //x=10.73 //y=5.115 //x2=10.02 //y2=4.7
cc_547 ( N_noxref_2_c_411_n N_noxref_6_c_2010_n ) capacitor c=0.00647526f \
 //x=10.135 //y=5.2 //x2=21.09 //y2=7.4
cc_548 ( N_noxref_2_c_517_p N_noxref_6_c_2010_n ) capacitor c=0.0049145f \
 //x=10.645 //y=5.2 //x2=21.09 //y2=7.4
cc_549 ( N_noxref_2_c_483_p N_noxref_6_c_2010_n ) capacitor c=4.58585e-19 \
 //x=10.73 //y=3.49 //x2=21.09 //y2=7.4
cc_550 ( N_noxref_2_c_442_p N_noxref_6_c_2010_n ) capacitor c=2.00577e-19 \
 //x=12.58 //y=3.49 //x2=21.09 //y2=7.4
cc_551 ( N_noxref_2_c_418_n N_noxref_6_c_2010_n ) capacitor c=0.00368144f \
 //x=9.37 //y=5.38 //x2=21.09 //y2=7.4
cc_552 ( N_noxref_2_c_453_p N_noxref_6_c_2010_n ) capacitor c=8.41092e-19 \
 //x=10.25 //y=5.2 //x2=21.09 //y2=7.4
cc_553 ( N_noxref_2_c_520_p N_noxref_6_c_2010_n ) capacitor c=0.00285294f \
 //x=10.25 //y=5.38 //x2=21.09 //y2=7.4
cc_554 ( N_noxref_2_c_435_p N_noxref_6_c_2010_n ) capacitor c=9.05427e-19 \
 //x=12.58 //y=4.7 //x2=21.09 //y2=7.4
cc_555 ( N_noxref_2_c_430_n N_noxref_6_c_2010_n ) capacitor c=0.00224727f \
 //x=9.37 //y=5.38 //x2=21.09 //y2=7.4
cc_556 ( N_noxref_2_c_541_p N_noxref_6_c_2010_n ) capacitor c=0.00224727f \
 //x=10.25 //y=5.38 //x2=21.09 //y2=7.4
cc_557 ( N_noxref_2_c_437_p N_noxref_6_c_2010_n ) capacitor c=6.23118e-19 \
 //x=12.58 //y=4.7 //x2=21.09 //y2=7.4
cc_558 ( N_noxref_2_c_411_n N_noxref_6_c_2030_n ) capacitor c=0.00208112f \
 //x=10.135 //y=5.2 //x2=9.725 //y2=7.4
cc_559 ( N_noxref_2_c_418_n N_noxref_6_c_2030_n ) capacitor c=9.41091e-19 \
 //x=9.37 //y=5.38 //x2=9.725 //y2=7.4
cc_560 ( N_noxref_2_c_430_n N_noxref_6_c_2030_n ) capacitor c=0.0136475f \
 //x=9.37 //y=5.38 //x2=9.725 //y2=7.4
cc_561 ( N_noxref_2_c_411_n N_noxref_6_c_2080_n ) capacitor c=0.00180744f \
 //x=10.135 //y=5.2 //x2=10.605 //y2=7.4
cc_562 ( N_noxref_2_c_517_p N_noxref_6_c_2080_n ) capacitor c=0.00208112f \
 //x=10.645 //y=5.2 //x2=10.605 //y2=7.4
cc_563 ( N_noxref_2_c_453_p N_noxref_6_c_2080_n ) capacitor c=4.23323e-19 \
 //x=10.25 //y=5.2 //x2=10.605 //y2=7.4
cc_564 ( N_noxref_2_c_520_p N_noxref_6_c_2080_n ) capacitor c=5.78261e-19 \
 //x=10.25 //y=5.38 //x2=10.605 //y2=7.4
cc_565 ( N_noxref_2_c_541_p N_noxref_6_c_2080_n ) capacitor c=0.0136475f \
 //x=10.25 //y=5.38 //x2=10.605 //y2=7.4
cc_566 ( N_noxref_2_c_435_p N_noxref_6_c_2085_n ) capacitor c=6.28732e-19 \
 //x=12.58 //y=4.7 //x2=13.055 //y2=7.4
cc_567 ( N_noxref_2_M27_noxref_g N_noxref_6_c_2085_n ) capacitor c=0.0072715f \
 //x=12.48 //y=6.02 //x2=13.055 //y2=7.4
cc_568 ( N_noxref_2_M28_noxref_g N_noxref_6_c_2085_n ) capacitor c=0.00749619f \
 //x=12.92 //y=6.02 //x2=13.055 //y2=7.4
cc_569 ( N_noxref_2_c_416_n N_noxref_6_c_2038_n ) capacitor c=0.0013228f \
 //x=10.73 //y=5.115 //x2=8.14 //y2=7.4
cc_570 ( N_noxref_2_c_418_n N_noxref_6_c_2038_n ) capacitor c=4.91377e-19 \
 //x=9.37 //y=5.38 //x2=8.14 //y2=7.4
cc_571 ( N_noxref_2_c_430_n N_noxref_6_c_2038_n ) capacitor c=0.0064135f \
 //x=9.37 //y=5.38 //x2=8.14 //y2=7.4
cc_572 ( N_noxref_2_c_416_n N_noxref_6_c_2091_n ) capacitor c=0.0285805f \
 //x=10.73 //y=5.115 //x2=11.47 //y2=7.4
cc_573 ( N_noxref_2_c_453_p N_noxref_6_c_2091_n ) capacitor c=0.00240948f \
 //x=10.25 //y=5.2 //x2=11.47 //y2=7.4
cc_574 ( N_noxref_2_c_520_p N_noxref_6_c_2091_n ) capacitor c=4.09141e-19 \
 //x=10.25 //y=5.38 //x2=11.47 //y2=7.4
cc_575 ( N_noxref_2_c_435_p N_noxref_6_c_2091_n ) capacitor c=0.00508547f \
 //x=12.58 //y=4.7 //x2=11.47 //y2=7.4
cc_576 ( N_noxref_2_c_436_p N_noxref_6_c_2091_n ) capacitor c=0.005822f \
 //x=12.582 //y=4.56 //x2=11.47 //y2=7.4
cc_577 ( N_noxref_2_c_541_p N_noxref_6_c_2091_n ) capacitor c=0.0101861f \
 //x=10.25 //y=5.38 //x2=11.47 //y2=7.4
cc_578 ( N_noxref_2_c_437_p N_noxref_6_c_2091_n ) capacitor c=0.00370494f \
 //x=12.58 //y=4.7 //x2=11.47 //y2=7.4
cc_579 ( N_noxref_2_c_438_p N_noxref_6_c_2091_n ) capacitor c=0.0129564f \
 //x=12.58 //y=4.7 //x2=11.47 //y2=7.4
cc_580 ( N_noxref_2_c_418_n N_noxref_6_M23_noxref_s ) capacitor c=0.0572211f \
 //x=9.37 //y=5.38 //x2=8.795 //y2=5.02
cc_581 ( N_noxref_2_c_453_p N_noxref_6_M23_noxref_s ) capacitor c=6.52457e-19 \
 //x=10.25 //y=5.2 //x2=8.795 //y2=5.02
cc_582 ( N_noxref_2_c_430_n N_noxref_6_M23_noxref_s ) capacitor c=0.0887533f \
 //x=9.37 //y=5.38 //x2=8.795 //y2=5.02
cc_583 ( N_noxref_2_c_411_n N_noxref_6_M24_noxref_d ) capacitor c=0.00734028f \
 //x=10.135 //y=5.2 //x2=9.665 //y2=5.02
cc_584 ( N_noxref_2_c_418_n N_noxref_6_M24_noxref_d ) capacitor c=0.0043528f \
 //x=9.37 //y=5.38 //x2=9.665 //y2=5.02
cc_585 ( N_noxref_2_c_520_p N_noxref_6_M24_noxref_d ) capacitor c=0.0043528f \
 //x=10.25 //y=5.38 //x2=9.665 //y2=5.02
cc_586 ( N_noxref_2_c_430_n N_noxref_6_M24_noxref_d ) capacitor c=0.065554f \
 //x=9.37 //y=5.38 //x2=9.665 //y2=5.02
cc_587 ( N_noxref_2_c_541_p N_noxref_6_M24_noxref_d ) capacitor c=0.065554f \
 //x=10.25 //y=5.38 //x2=9.665 //y2=5.02
cc_588 ( N_noxref_2_c_517_p N_noxref_6_M26_noxref_d ) capacitor c=0.00933287f \
 //x=10.645 //y=5.2 //x2=10.545 //y2=5.02
cc_589 ( N_noxref_2_c_520_p N_noxref_6_M26_noxref_d ) capacitor c=0.00587834f \
 //x=10.25 //y=5.38 //x2=10.545 //y2=5.02
cc_590 ( N_noxref_2_c_428_n N_noxref_6_M26_noxref_d ) capacitor c=9.65858e-19 \
 //x=10.73 //y=3.33 //x2=10.545 //y2=5.02
cc_591 ( N_noxref_2_c_541_p N_noxref_6_M26_noxref_d ) capacitor c=0.065554f \
 //x=10.25 //y=5.38 //x2=10.545 //y2=5.02
cc_592 ( N_noxref_2_c_517_p N_noxref_6_M27_noxref_s ) capacitor c=0.00326953f \
 //x=10.645 //y=5.2 //x2=12.125 //y2=5.02
cc_593 ( N_noxref_2_c_442_p N_noxref_6_M27_noxref_s ) capacitor c=0.00111275f \
 //x=12.58 //y=3.49 //x2=12.125 //y2=5.02
cc_594 ( N_noxref_2_c_453_p N_noxref_6_M27_noxref_s ) capacitor c=0.00515461f \
 //x=10.25 //y=5.2 //x2=12.125 //y2=5.02
cc_595 ( N_noxref_2_c_520_p N_noxref_6_M27_noxref_s ) capacitor c=3.28075e-19 \
 //x=10.25 //y=5.38 //x2=12.125 //y2=5.02
cc_596 ( N_noxref_2_M27_noxref_g N_noxref_6_M27_noxref_s ) capacitor \
 c=0.0567929f //x=12.48 //y=6.02 //x2=12.125 //y2=5.02
cc_597 ( N_noxref_2_M28_noxref_g N_noxref_6_M28_noxref_d ) capacitor \
 c=0.015318f //x=12.92 //y=6.02 //x2=12.995 //y2=5.02
cc_598 ( N_noxref_2_c_481_p N_noxref_12_c_2951_n ) capacitor c=0.00653239f \
 //x=10.645 //y=1.655 //x2=12.565 //y2=0
cc_599 ( N_noxref_2_c_483_p N_noxref_12_c_2951_n ) capacitor c=4.52837e-19 \
 //x=10.73 //y=3.49 //x2=12.565 //y2=0
cc_600 ( N_noxref_2_c_427_n N_noxref_12_c_2951_n ) capacitor c=0.00963092f \
 //x=10.29 //y=1 //x2=12.565 //y2=0
cc_601 ( N_noxref_2_M6_noxref_d N_noxref_12_c_2951_n ) capacitor c=3.01654e-19 \
 //x=10.1 //y=0.905 //x2=12.565 //y2=0
cc_602 ( N_noxref_2_c_418_n N_noxref_12_c_2913_n ) capacitor c=7.78494e-19 \
 //x=9.37 //y=5.38 //x2=9.32 //y2=0.955
cc_603 ( N_noxref_2_c_427_n N_noxref_12_c_2913_n ) capacitor c=0.0140087f \
 //x=10.29 //y=1 //x2=9.32 //y2=0.955
cc_604 ( N_noxref_2_M6_noxref_d N_noxref_12_c_2913_n ) capacitor c=2.93544e-19 \
 //x=10.1 //y=0.905 //x2=9.32 //y2=0.955
cc_605 ( N_noxref_2_c_427_n N_noxref_12_c_2958_n ) capacitor c=0.00549186f \
 //x=10.29 //y=1 //x2=12.65 //y2=0.955
cc_606 ( N_noxref_2_c_447_p N_noxref_12_c_2958_n ) capacitor c=0.00709452f \
 //x=12.58 //y=2.08 //x2=12.65 //y2=0.955
cc_607 ( N_noxref_2_c_446_p N_noxref_12_c_2958_n ) capacitor c=2.13705e-19 \
 //x=12.58 //y=2.08 //x2=12.65 //y2=0.955
cc_608 ( N_noxref_2_c_466_p N_noxref_12_c_2958_n ) capacitor c=0.00171023f \
 //x=12.385 //y=0.865 //x2=12.65 //y2=0.955
cc_609 ( N_noxref_2_c_467_p N_noxref_12_c_2958_n ) capacitor c=0.00357815f \
 //x=12.385 //y=1.21 //x2=12.65 //y2=0.955
cc_610 ( N_noxref_2_c_469_p N_noxref_12_c_2958_n ) capacitor c=4.2764e-19 \
 //x=12.385 //y=1.52 //x2=12.65 //y2=0.955
cc_611 ( N_noxref_2_c_635_p N_noxref_12_c_2958_n ) capacitor c=9.36995e-19 \
 //x=12.76 //y=0.71 //x2=12.65 //y2=0.955
cc_612 ( N_noxref_2_c_636_p N_noxref_12_c_2958_n ) capacitor c=6.38426e-19 \
 //x=12.76 //y=1.365 //x2=12.65 //y2=0.955
cc_613 ( N_noxref_2_c_468_p N_noxref_12_c_2958_n ) capacitor c=0.00171721f \
 //x=12.915 //y=0.865 //x2=12.65 //y2=0.955
cc_614 ( N_noxref_2_c_470_p N_noxref_12_c_2958_n ) capacitor c=0.00296337f \
 //x=12.915 //y=1.21 //x2=12.65 //y2=0.955
cc_615 ( N_noxref_2_c_466_p N_noxref_12_c_2968_n ) capacitor c=3.46594e-19 \
 //x=12.385 //y=0.865 //x2=12.647 //y2=0.825
cc_616 ( N_noxref_2_c_635_p N_noxref_12_c_2968_n ) capacitor c=0.00839621f \
 //x=12.76 //y=0.71 //x2=12.647 //y2=0.825
cc_617 ( N_noxref_2_c_468_p N_noxref_12_c_2968_n ) capacitor c=4.40641e-19 \
 //x=12.915 //y=0.865 //x2=12.647 //y2=0.825
cc_618 ( N_noxref_2_c_481_p N_noxref_12_c_2928_n ) capacitor c=7.76556e-19 \
 //x=10.645 //y=1.655 //x2=11.3 //y2=0
cc_619 ( N_noxref_2_c_483_p N_noxref_12_c_2928_n ) capacitor c=3.21814e-19 \
 //x=10.73 //y=3.49 //x2=11.3 //y2=0
cc_620 ( N_noxref_2_c_466_p N_noxref_12_c_2973_n ) capacitor c=0.00685132f \
 //x=12.385 //y=0.865 //x2=14.63 //y2=0
cc_621 ( N_noxref_2_c_427_n N_noxref_12_c_2929_n ) capacitor c=2.83275e-19 \
 //x=10.29 //y=1 //x2=21.09 //y2=0
cc_622 ( N_noxref_2_c_414_n N_noxref_12_c_2935_n ) capacitor c=9.32616e-19 \
 //x=10.73 //y=3.17 //x2=8.14 //y2=0
cc_623 ( N_noxref_2_c_412_n N_noxref_12_c_2976_n ) capacitor c=0.002973f \
 //x=10.29 //y=1.57 //x2=11.47 //y2=0
cc_624 ( N_noxref_2_c_481_p N_noxref_12_c_2976_n ) capacitor c=0.0300121f \
 //x=10.645 //y=1.655 //x2=11.47 //y2=0
cc_625 ( N_noxref_2_c_441_p N_noxref_12_c_2976_n ) capacitor c=0.00829739f \
 //x=12.58 //y=3.17 //x2=11.47 //y2=0
cc_626 ( N_noxref_2_c_447_p N_noxref_12_c_2976_n ) capacitor c=0.00427323f \
 //x=12.58 //y=2.08 //x2=11.47 //y2=0
cc_627 ( N_noxref_2_c_488_p N_noxref_12_c_2976_n ) capacitor c=0.00560353f \
 //x=12.415 //y=3.33 //x2=11.47 //y2=0
cc_628 ( N_noxref_2_c_446_p N_noxref_12_c_2976_n ) capacitor c=0.0038607f \
 //x=12.58 //y=2.08 //x2=11.47 //y2=0
cc_629 ( N_noxref_2_c_469_p N_noxref_12_c_2976_n ) capacitor c=0.0015404f \
 //x=12.385 //y=1.52 //x2=11.47 //y2=0
cc_630 ( N_noxref_2_c_449_p N_noxref_12_c_2976_n ) capacitor c=0.00906518f \
 //x=12.385 //y=1.915 //x2=11.47 //y2=0
cc_631 ( N_noxref_2_c_427_n N_noxref_12_M5_noxref_d ) capacitor c=2.82748e-19 \
 //x=10.29 //y=1 //x2=9.13 //y2=0.865
cc_632 ( N_noxref_2_c_447_p N_noxref_12_M7_noxref_d ) capacitor c=2.20438e-19 \
 //x=12.58 //y=2.08 //x2=12.46 //y2=0.865
cc_633 ( N_noxref_2_c_466_p N_noxref_12_M7_noxref_d ) capacitor c=0.00192399f \
 //x=12.385 //y=0.865 //x2=12.46 //y2=0.865
cc_634 ( N_noxref_2_c_467_p N_noxref_12_M7_noxref_d ) capacitor c=0.00210798f \
 //x=12.385 //y=1.21 //x2=12.46 //y2=0.865
cc_635 ( N_noxref_2_c_635_p N_noxref_12_M7_noxref_d ) capacitor c=0.00472259f \
 //x=12.76 //y=0.71 //x2=12.46 //y2=0.865
cc_636 ( N_noxref_2_c_636_p N_noxref_12_M7_noxref_d ) capacitor c=0.00166857f \
 //x=12.76 //y=1.365 //x2=12.46 //y2=0.865
cc_637 ( N_noxref_2_c_468_p N_noxref_12_M7_noxref_d ) capacitor c=0.00230174f \
 //x=12.915 //y=0.865 //x2=12.46 //y2=0.865
cc_638 ( N_noxref_2_c_470_p N_noxref_12_M7_noxref_d ) capacitor c=0.00210798f \
 //x=12.915 //y=1.21 //x2=12.46 //y2=0.865
cc_639 ( N_noxref_2_c_413_n N_noxref_16_c_3570_n ) capacitor c=0.00911498f \
 //x=10.375 //y=1.655 //x2=9.805 //y2=1.495
cc_640 ( N_noxref_2_c_481_p N_noxref_16_c_3575_n ) capacitor c=0.00372218f \
 //x=10.645 //y=1.655 //x2=10.69 //y2=0.53
cc_641 ( N_noxref_2_c_427_n N_noxref_16_c_3575_n ) capacitor c=0.00367971f \
 //x=10.29 //y=1 //x2=10.69 //y2=0.53
cc_642 ( N_noxref_2_M6_noxref_d N_noxref_16_c_3575_n ) capacitor c=0.00910163f \
 //x=10.1 //y=0.905 //x2=10.69 //y2=0.53
cc_643 ( N_noxref_2_c_412_n N_noxref_16_M5_noxref_s ) capacitor c=0.0162484f \
 //x=10.29 //y=1.57 //x2=8.7 //y2=0.365
cc_644 ( N_noxref_2_c_481_p N_noxref_16_M5_noxref_s ) capacitor c=0.00640979f \
 //x=10.645 //y=1.655 //x2=8.7 //y2=0.365
cc_645 ( N_noxref_2_c_483_p N_noxref_16_M5_noxref_s ) capacitor c=4.17069e-19 \
 //x=10.73 //y=3.49 //x2=8.7 //y2=0.365
cc_646 ( N_noxref_2_c_427_n N_noxref_16_M5_noxref_s ) capacitor c=0.00905169f \
 //x=10.29 //y=1 //x2=8.7 //y2=0.365
cc_647 ( N_noxref_2_c_428_n N_noxref_16_M5_noxref_s ) capacitor c=0.0010514f \
 //x=10.73 //y=3.33 //x2=8.7 //y2=0.365
cc_648 ( N_noxref_2_M6_noxref_d N_noxref_16_M5_noxref_s ) capacitor \
 c=0.0275552f //x=10.1 //y=0.905 //x2=8.7 //y2=0.365
cc_649 ( N_noxref_2_c_488_p N_noxref_17_c_3628_n ) capacitor c=0.00264481f \
 //x=12.415 //y=3.33 //x2=12.165 //y2=1.495
cc_650 ( N_noxref_2_c_449_p N_noxref_17_c_3628_n ) capacitor c=0.00262672f \
 //x=12.385 //y=1.915 //x2=12.165 //y2=1.495
cc_651 ( N_noxref_2_c_442_p N_noxref_17_c_3630_n ) capacitor c=0.00402188f \
 //x=12.58 //y=3.49 //x2=13.05 //y2=1.58
cc_652 ( N_noxref_2_c_447_p N_noxref_17_c_3630_n ) capacitor c=0.00509504f \
 //x=12.58 //y=2.08 //x2=13.05 //y2=1.58
cc_653 ( N_noxref_2_c_488_p N_noxref_17_c_3630_n ) capacitor c=9.85544e-19 \
 //x=12.415 //y=3.33 //x2=13.05 //y2=1.58
cc_654 ( N_noxref_2_c_446_p N_noxref_17_c_3630_n ) capacitor c=0.00763108f \
 //x=12.58 //y=2.08 //x2=13.05 //y2=1.58
cc_655 ( N_noxref_2_c_469_p N_noxref_17_c_3630_n ) capacitor c=0.00697076f \
 //x=12.385 //y=1.52 //x2=13.05 //y2=1.58
cc_656 ( N_noxref_2_c_449_p N_noxref_17_c_3630_n ) capacitor c=0.0180072f \
 //x=12.385 //y=1.915 //x2=13.05 //y2=1.58
cc_657 ( N_noxref_2_c_636_p N_noxref_17_c_3630_n ) capacitor c=0.00723574f \
 //x=12.76 //y=1.365 //x2=13.05 //y2=1.58
cc_658 ( N_noxref_2_c_470_p N_noxref_17_c_3630_n ) capacitor c=0.00399755f \
 //x=12.915 //y=1.21 //x2=13.05 //y2=1.58
cc_659 ( N_noxref_2_c_449_p N_noxref_17_c_3638_n ) capacitor c=6.71402e-19 \
 //x=12.385 //y=1.915 //x2=13.135 //y2=1.495
cc_660 ( N_noxref_2_c_466_p N_noxref_17_M7_noxref_s ) capacitor c=0.0294925f \
 //x=12.385 //y=0.865 //x2=12.03 //y2=0.365
cc_661 ( N_noxref_2_c_469_p N_noxref_17_M7_noxref_s ) capacitor c=3.48408e-19 \
 //x=12.385 //y=1.52 //x2=12.03 //y2=0.365
cc_662 ( N_noxref_2_c_468_p N_noxref_17_M7_noxref_s ) capacitor c=0.0125442f \
 //x=12.915 //y=0.865 //x2=12.03 //y2=0.365
cc_663 ( N_noxref_3_c_696_n N_noxref_4_c_1091_n ) capacitor c=0.0292733f \
 //x=2.22 //y=4.7 //x2=2.29 //y2=5.155
cc_664 ( N_noxref_3_c_706_n N_noxref_4_c_1091_n ) capacitor c=0.0107219f \
 //x=2.22 //y=4.44 //x2=2.29 //y2=5.155
cc_665 ( N_noxref_3_c_711_n N_noxref_4_c_1091_n ) capacitor c=0.00495283f \
 //x=2.22 //y=4.7 //x2=2.29 //y2=5.155
cc_666 ( N_noxref_3_M15_noxref_g N_noxref_4_c_1091_n ) capacitor c=0.00853188f \
 //x=2.19 //y=6.02 //x2=2.29 //y2=5.155
cc_667 ( N_noxref_3_c_725_n N_noxref_4_c_1091_n ) capacitor c=3.4353e-19 \
 //x=2.22 //y=4.7 //x2=2.29 //y2=5.155
cc_668 ( N_noxref_3_M16_noxref_g N_noxref_4_c_973_n ) capacitor c=0.00955829f \
 //x=2.63 //y=6.02 //x2=3.175 //y2=5.155
cc_669 ( N_noxref_3_c_699_n N_noxref_4_c_977_n ) capacitor c=0.0205765f \
 //x=9.61 //y=4.44 //x2=3.985 //y2=5.155
cc_670 ( N_noxref_3_c_690_n N_noxref_4_c_1004_n ) capacitor c=0.00285669f \
 //x=2.22 //y=4.54 //x2=4.07 //y2=3.54
cc_671 ( N_noxref_3_c_690_n N_noxref_4_c_1017_n ) capacitor c=9.69745e-19 \
 //x=2.22 //y=4.54 //x2=4.07 //y2=5.07
cc_672 ( N_noxref_3_c_696_n N_noxref_4_c_1017_n ) capacitor c=9.02672e-19 \
 //x=2.22 //y=4.7 //x2=4.07 //y2=5.07
cc_673 ( N_noxref_3_c_699_n N_noxref_4_c_1017_n ) capacitor c=0.0299085f \
 //x=9.61 //y=4.44 //x2=4.07 //y2=5.07
cc_674 ( N_noxref_3_c_731_n N_noxref_4_c_1102_n ) capacitor c=0.00278331f \
 //x=13.345 //y=4.525 //x2=15.91 //y2=3.545
cc_675 ( N_noxref_3_c_699_n N_noxref_4_c_1103_n ) capacitor c=0.0381516f \
 //x=9.61 //y=4.44 //x2=2.41 //y2=5.155
cc_676 ( N_noxref_3_c_711_n N_noxref_4_c_1103_n ) capacitor c=0.00132214f \
 //x=2.22 //y=4.7 //x2=2.41 //y2=5.155
cc_677 ( N_noxref_3_M15_noxref_g N_noxref_4_c_1103_n ) capacitor c=0.00229818f \
 //x=2.19 //y=6.02 //x2=2.41 //y2=5.155
cc_678 ( N_noxref_3_M16_noxref_g N_noxref_4_c_1103_n ) capacitor c=0.00230699f \
 //x=2.63 //y=6.02 //x2=2.41 //y2=5.155
cc_679 ( N_noxref_3_c_724_n N_noxref_4_c_1103_n ) capacitor c=0.0016987f \
 //x=2.555 //y=4.79 //x2=2.41 //y2=5.155
cc_680 ( N_noxref_3_c_699_n N_noxref_4_c_1036_n ) capacitor c=0.00354963f \
 //x=9.61 //y=4.44 //x2=5.92 //y2=4.7
cc_681 ( N_noxref_3_c_699_n N_noxref_4_c_1038_n ) capacitor c=0.0265157f \
 //x=9.61 //y=4.44 //x2=5.922 //y2=4.56
cc_682 ( N_noxref_3_c_731_n N_noxref_4_c_1110_n ) capacitor c=0.0011503f \
 //x=13.345 //y=4.525 //x2=15.912 //y2=4.56
cc_683 ( N_noxref_3_c_699_n N_noxref_4_c_1040_n ) capacitor c=0.00797964f \
 //x=9.61 //y=4.44 //x2=5.755 //y2=3.7
cc_684 ( N_noxref_3_c_699_n N_noxref_4_c_1044_n ) capacitor c=0.00651104f \
 //x=9.61 //y=4.44 //x2=7.61 //y2=3.715
cc_685 ( N_noxref_3_c_699_n N_noxref_4_c_1047_n ) capacitor c=0.00977423f \
 //x=9.61 //y=4.44 //x2=7.265 //y2=3.715
cc_686 ( N_noxref_3_c_699_n N_noxref_4_c_1051_n ) capacitor c=0.0036569f \
 //x=9.61 //y=4.44 //x2=8.86 //y2=3.7
cc_687 ( N_noxref_3_c_699_n N_noxref_4_c_1055_n ) capacitor c=0.00297965f \
 //x=9.61 //y=4.44 //x2=9.46 //y2=3.71
cc_688 ( N_noxref_3_c_744_n N_noxref_4_c_1077_n ) capacitor c=0.00625039f \
 //x=10.21 //y=4.46 //x2=10.21 //y2=3.69
cc_689 ( N_noxref_3_c_744_n N_noxref_4_c_1082_n ) capacitor c=0.00646181f \
 //x=10.21 //y=4.46 //x2=10.95 //y2=3.715
cc_690 ( N_noxref_3_c_744_n N_noxref_4_c_1085_n ) capacitor c=0.00367719f \
 //x=10.21 //y=4.46 //x2=12.19 //y2=3.7
cc_691 ( N_noxref_3_c_731_n N_noxref_4_c_1089_n ) capacitor c=0.0264298f \
 //x=13.345 //y=4.525 //x2=12.79 //y2=3.715
cc_692 ( N_noxref_3_c_739_n N_noxref_4_c_1089_n ) capacitor c=0.00196738f \
 //x=13.32 //y=2.08 //x2=12.79 //y2=3.715
cc_693 ( N_noxref_3_c_744_n N_noxref_4_c_1089_n ) capacitor c=0.00287528f \
 //x=10.21 //y=4.46 //x2=12.79 //y2=3.715
cc_694 ( N_noxref_3_c_696_n N_noxref_4_c_1122_n ) capacitor c=0.00156871f \
 //x=2.22 //y=4.7 //x2=2.41 //y2=5.38
cc_695 ( N_noxref_3_M15_noxref_g N_noxref_4_c_1122_n ) capacitor c=0.0179041f \
 //x=2.19 //y=6.02 //x2=2.41 //y2=5.38
cc_696 ( N_noxref_3_M16_noxref_g N_noxref_4_c_1122_n ) capacitor c=0.0179041f \
 //x=2.63 //y=6.02 //x2=2.41 //y2=5.38
cc_697 ( N_noxref_3_c_724_n N_noxref_4_c_1122_n ) capacitor c=0.00294585f \
 //x=2.555 //y=4.79 //x2=2.41 //y2=5.38
cc_698 ( N_noxref_3_c_687_n N_noxref_5_c_1572_n ) capacitor c=0.0115546f \
 //x=2.22 //y=2.195 //x2=1.11 //y2=2.195
cc_699 ( N_noxref_3_c_707_n N_noxref_5_c_1572_n ) capacitor c=0.00375644f \
 //x=2.22 //y=2.08 //x2=1.11 //y2=2.195
cc_700 ( N_noxref_3_c_720_n N_noxref_5_c_1572_n ) capacitor c=0.00140534f \
 //x=2.31 //y=1.915 //x2=1.11 //y2=2.195
cc_701 ( N_noxref_3_c_690_n N_noxref_5_c_1438_n ) capacitor c=0.0542809f \
 //x=2.22 //y=4.54 //x2=1.11 //y2=3.915
cc_702 ( N_noxref_3_c_707_n N_noxref_5_c_1438_n ) capacitor c=4.16726e-19 \
 //x=2.22 //y=2.08 //x2=1.11 //y2=3.915
cc_703 ( N_noxref_3_c_690_n N_noxref_5_c_1577_n ) capacitor c=0.00797621f \
 //x=2.22 //y=4.54 //x2=1.11 //y2=4.235
cc_704 ( N_noxref_3_c_690_n N_noxref_5_c_1440_n ) capacitor c=0.00733288f \
 //x=2.22 //y=4.54 //x2=1.11 //y2=4.575
cc_705 ( N_noxref_3_c_696_n N_noxref_5_c_1440_n ) capacitor c=0.00759719f \
 //x=2.22 //y=4.7 //x2=1.11 //y2=4.575
cc_706 ( N_noxref_3_c_706_n N_noxref_5_c_1440_n ) capacitor c=0.00978415f \
 //x=2.22 //y=4.44 //x2=1.11 //y2=4.575
cc_707 ( N_noxref_3_c_711_n N_noxref_5_c_1440_n ) capacitor c=0.00402107f \
 //x=2.22 //y=4.7 //x2=1.11 //y2=4.575
cc_708 ( N_noxref_3_c_725_n N_noxref_5_c_1440_n ) capacitor c=0.0011347f \
 //x=2.22 //y=4.7 //x2=1.11 //y2=4.575
cc_709 ( N_noxref_3_c_699_n N_noxref_5_c_1449_n ) capacitor c=0.00260076f \
 //x=9.61 //y=4.44 //x2=9.99 //y2=4.235
cc_710 ( N_noxref_3_c_744_n N_noxref_5_c_1449_n ) capacitor c=0.00232598f \
 //x=10.21 //y=4.46 //x2=9.99 //y2=4.235
cc_711 ( N_noxref_3_c_699_n N_noxref_5_c_1450_n ) capacitor c=4.19842e-19 \
 //x=9.61 //y=4.44 //x2=9.99 //y2=4.555
cc_712 ( N_noxref_3_c_744_n N_noxref_5_c_1450_n ) capacitor c=0.0260326f \
 //x=10.21 //y=4.46 //x2=9.99 //y2=4.555
cc_713 ( N_noxref_3_c_727_n N_noxref_5_c_1508_n ) capacitor c=0.0247435f \
 //x=13.345 //y=4.685 //x2=13.465 //y2=5.2
cc_714 ( N_noxref_3_c_744_n N_noxref_5_c_1508_n ) capacitor c=0.00963579f \
 //x=10.21 //y=4.46 //x2=13.465 //y2=5.2
cc_715 ( N_noxref_3_c_752_n N_noxref_5_c_1508_n ) capacitor c=0.00469232f \
 //x=13.35 //y=4.7 //x2=13.465 //y2=5.2
cc_716 ( N_noxref_3_M29_noxref_g N_noxref_5_c_1508_n ) capacitor c=0.00842814f \
 //x=13.36 //y=6.02 //x2=13.465 //y2=5.2
cc_717 ( N_noxref_3_c_771_n N_noxref_5_c_1508_n ) capacitor c=7.7763e-19 \
 //x=13.35 //y=4.7 //x2=13.465 //y2=5.2
cc_718 ( N_noxref_3_c_761_n N_noxref_5_c_1509_n ) capacitor c=0.00119008f \
 //x=13.355 //y=1.25 //x2=13.62 //y2=1.57
cc_719 ( N_noxref_3_c_763_n N_noxref_5_c_1509_n ) capacitor c=0.00438634f \
 //x=13.355 //y=1.56 //x2=13.62 //y2=1.57
cc_720 ( N_noxref_3_c_830_p N_noxref_5_c_1509_n ) capacitor c=0.00916852f \
 //x=13.73 //y=1.405 //x2=13.62 //y2=1.57
cc_721 ( N_noxref_3_c_767_n N_noxref_5_c_1509_n ) capacitor c=0.003249f \
 //x=13.885 //y=1.25 //x2=13.62 //y2=1.57
cc_722 ( N_noxref_3_c_832_p N_noxref_5_c_1509_n ) capacitor c=0.00341114f \
 //x=13.32 //y=1.915 //x2=13.62 //y2=1.57
cc_723 ( N_noxref_3_M30_noxref_g N_noxref_5_c_1597_n ) capacitor c=0.0108037f \
 //x=13.8 //y=6.02 //x2=13.975 //y2=5.2
cc_724 ( N_noxref_3_c_830_p N_noxref_5_c_1598_n ) capacitor c=0.00194324f \
 //x=13.73 //y=1.405 //x2=13.975 //y2=1.655
cc_725 ( N_noxref_3_c_767_n N_noxref_5_c_1598_n ) capacitor c=0.00323005f \
 //x=13.885 //y=1.25 //x2=13.975 //y2=1.655
cc_726 ( N_noxref_3_c_731_n N_noxref_5_c_1511_n ) capacitor c=0.0741032f \
 //x=13.345 //y=4.525 //x2=14.06 //y2=3.925
cc_727 ( N_noxref_3_c_739_n N_noxref_5_c_1511_n ) capacitor c=0.015397f \
 //x=13.32 //y=2.08 //x2=14.06 //y2=3.925
cc_728 ( N_noxref_3_c_748_n N_noxref_5_c_1511_n ) capacitor c=9.90728e-19 \
 //x=13.32 //y=2.08 //x2=14.06 //y2=3.925
cc_729 ( N_noxref_3_c_768_n N_noxref_5_c_1511_n ) capacitor c=0.00281392f \
 //x=13.32 //y=2.08 //x2=14.06 //y2=3.925
cc_730 ( N_noxref_3_c_832_p N_noxref_5_c_1511_n ) capacitor c=0.00309058f \
 //x=13.32 //y=1.915 //x2=14.06 //y2=3.925
cc_731 ( N_noxref_3_c_731_n N_noxref_5_c_1605_n ) capacitor c=0.01773f \
 //x=13.345 //y=4.525 //x2=14.06 //y2=4.245
cc_732 ( N_noxref_3_c_842_p N_noxref_5_c_1605_n ) capacitor c=9.17945e-19 \
 //x=13.725 //y=4.79 //x2=14.06 //y2=4.245
cc_733 ( N_noxref_3_c_727_n N_noxref_5_c_1514_n ) capacitor c=0.0154991f \
 //x=13.345 //y=4.685 //x2=14.06 //y2=5.115
cc_734 ( N_noxref_3_c_731_n N_noxref_5_c_1514_n ) capacitor c=0.0103877f \
 //x=13.345 //y=4.525 //x2=14.06 //y2=5.115
cc_735 ( N_noxref_3_c_744_n N_noxref_5_c_1514_n ) capacitor c=0.0121733f \
 //x=10.21 //y=4.46 //x2=14.06 //y2=5.115
cc_736 ( N_noxref_3_c_752_n N_noxref_5_c_1514_n ) capacitor c=5.14671e-19 \
 //x=13.35 //y=4.7 //x2=14.06 //y2=5.115
cc_737 ( N_noxref_3_c_842_p N_noxref_5_c_1514_n ) capacitor c=0.00841383f \
 //x=13.725 //y=4.79 //x2=14.06 //y2=5.115
cc_738 ( N_noxref_3_c_690_n N_noxref_5_c_1612_n ) capacitor c=3.43503e-19 \
 //x=2.22 //y=4.54 //x2=1.11 //y2=4.07
cc_739 ( N_noxref_3_c_744_n N_noxref_5_c_1518_n ) capacitor c=0.0207179f \
 //x=10.21 //y=4.46 //x2=12.7 //y2=5.38
cc_740 ( N_noxref_3_M29_noxref_g N_noxref_5_c_1614_n ) capacitor c=0.00192712f \
 //x=13.36 //y=6.02 //x2=13.58 //y2=5.2
cc_741 ( N_noxref_3_M30_noxref_g N_noxref_5_c_1614_n ) capacitor c=0.00298276f \
 //x=13.8 //y=6.02 //x2=13.58 //y2=5.2
cc_742 ( N_noxref_3_c_842_p N_noxref_5_c_1614_n ) capacitor c=0.0020909f \
 //x=13.725 //y=4.79 //x2=13.58 //y2=5.2
cc_743 ( N_noxref_3_c_758_n N_noxref_5_c_1527_n ) capacitor c=0.00120406f \
 //x=13.355 //y=0.905 //x2=13.62 //y2=1
cc_744 ( N_noxref_3_c_761_n N_noxref_5_c_1527_n ) capacitor c=0.00218694f \
 //x=13.355 //y=1.25 //x2=13.62 //y2=1
cc_745 ( N_noxref_3_c_855_p N_noxref_5_c_1527_n ) capacitor c=5.50523e-19 \
 //x=13.73 //y=0.75 //x2=13.62 //y2=1
cc_746 ( N_noxref_3_c_830_p N_noxref_5_c_1527_n ) capacitor c=5.67071e-19 \
 //x=13.73 //y=1.405 //x2=13.62 //y2=1
cc_747 ( N_noxref_3_c_766_n N_noxref_5_c_1527_n ) capacitor c=0.00109205f \
 //x=13.885 //y=0.905 //x2=13.62 //y2=1
cc_748 ( N_noxref_3_c_767_n N_noxref_5_c_1527_n ) capacitor c=0.00317092f \
 //x=13.885 //y=1.25 //x2=13.62 //y2=1
cc_749 ( N_noxref_3_c_731_n N_noxref_5_c_1623_n ) capacitor c=9.19401e-19 \
 //x=13.345 //y=4.525 //x2=14.06 //y2=4.07
cc_750 ( N_noxref_3_c_687_n N_noxref_5_c_1459_n ) capacitor c=0.0015676f \
 //x=2.22 //y=2.195 //x2=3.685 //y2=4.07
cc_751 ( N_noxref_3_c_690_n N_noxref_5_c_1459_n ) capacitor c=0.0290324f \
 //x=2.22 //y=4.54 //x2=3.685 //y2=4.07
cc_752 ( N_noxref_3_c_696_n N_noxref_5_c_1459_n ) capacitor c=0.00370332f \
 //x=2.22 //y=4.7 //x2=3.685 //y2=4.07
cc_753 ( N_noxref_3_c_699_n N_noxref_5_c_1459_n ) capacitor c=0.0597544f \
 //x=9.61 //y=4.44 //x2=3.685 //y2=4.07
cc_754 ( N_noxref_3_c_706_n N_noxref_5_c_1459_n ) capacitor c=0.15521f \
 //x=2.22 //y=4.44 //x2=3.685 //y2=4.07
cc_755 ( N_noxref_3_c_699_n N_noxref_5_c_1463_n ) capacitor c=0.11637f \
 //x=9.61 //y=4.44 //x2=4.285 //y2=4.085
cc_756 ( N_noxref_3_c_699_n N_noxref_5_c_1464_n ) capacitor c=0.059022f \
 //x=9.61 //y=4.44 //x2=5.53 //y2=4.07
cc_757 ( N_noxref_3_c_727_n N_noxref_5_c_1528_n ) capacitor c=0.00171763f \
 //x=13.345 //y=4.685 //x2=13.89 //y2=4.07
cc_758 ( N_noxref_3_c_731_n N_noxref_5_c_1528_n ) capacitor c=0.0195347f \
 //x=13.345 //y=4.525 //x2=13.89 //y2=4.07
cc_759 ( N_noxref_3_c_744_n N_noxref_5_c_1528_n ) capacitor c=0.305221f \
 //x=10.21 //y=4.46 //x2=13.89 //y2=4.07
cc_760 ( N_noxref_3_c_699_n N_noxref_5_c_1466_n ) capacitor c=0.364548f \
 //x=9.61 //y=4.44 //x2=10.155 //y2=4.07
cc_761 ( N_noxref_3_c_731_n N_noxref_5_c_1635_n ) capacitor c=0.00330634f \
 //x=13.345 //y=4.525 //x2=15.78 //y2=4.09
cc_762 ( N_noxref_3_c_690_n N_noxref_5_c_1636_n ) capacitor c=0.00243311f \
 //x=2.22 //y=4.54 //x2=1.275 //y2=4.075
cc_763 ( N_noxref_3_c_687_n N_noxref_5_c_1637_n ) capacitor c=5.40058e-19 \
 //x=2.22 //y=2.195 //x2=1.11 //y2=2.08
cc_764 ( N_noxref_3_c_690_n N_noxref_5_c_1637_n ) capacitor c=4.16726e-19 \
 //x=2.22 //y=4.54 //x2=1.11 //y2=2.08
cc_765 ( N_noxref_3_c_707_n N_noxref_5_c_1637_n ) capacitor c=0.00125213f \
 //x=2.22 //y=2.08 //x2=1.11 //y2=2.08
cc_766 ( N_noxref_3_c_720_n N_noxref_5_c_1637_n ) capacitor c=0.0020754f \
 //x=2.31 //y=1.915 //x2=1.11 //y2=2.08
cc_767 ( N_noxref_3_c_696_n N_noxref_5_c_1641_n ) capacitor c=5.84784e-19 \
 //x=2.22 //y=4.7 //x2=1.11 //y2=4.7
cc_768 ( N_noxref_3_c_711_n N_noxref_5_c_1641_n ) capacitor c=0.00114249f \
 //x=2.22 //y=4.7 //x2=1.11 //y2=4.7
cc_769 ( N_noxref_3_c_725_n N_noxref_5_c_1641_n ) capacitor c=0.00124807f \
 //x=2.22 //y=4.7 //x2=1.11 //y2=4.7
cc_770 ( N_noxref_3_c_727_n N_noxref_5_c_1644_n ) capacitor c=8.41381e-19 \
 //x=13.345 //y=4.685 //x2=13.58 //y2=5.38
cc_771 ( N_noxref_3_M29_noxref_g N_noxref_5_c_1644_n ) capacitor c=0.0178987f \
 //x=13.36 //y=6.02 //x2=13.58 //y2=5.38
cc_772 ( N_noxref_3_M30_noxref_g N_noxref_5_c_1644_n ) capacitor c=0.0178506f \
 //x=13.8 //y=6.02 //x2=13.58 //y2=5.38
cc_773 ( N_noxref_3_c_842_p N_noxref_5_c_1644_n ) capacitor c=0.00291714f \
 //x=13.725 //y=4.79 //x2=13.58 //y2=5.38
cc_774 ( N_noxref_3_M15_noxref_g N_noxref_5_M13_noxref_g ) capacitor \
 c=0.0106276f //x=2.19 //y=6.02 //x2=1.31 //y2=6.02
cc_775 ( N_noxref_3_M15_noxref_g N_noxref_5_M14_noxref_g ) capacitor \
 c=0.107144f //x=2.19 //y=6.02 //x2=1.75 //y2=6.02
cc_776 ( N_noxref_3_M16_noxref_g N_noxref_5_M14_noxref_g ) capacitor \
 c=0.0101598f //x=2.63 //y=6.02 //x2=1.75 //y2=6.02
cc_777 ( N_noxref_3_c_887_p N_noxref_5_c_1651_n ) capacitor c=5.72528e-19 \
 //x=1.785 //y=0.91 //x2=0.81 //y2=0.875
cc_778 ( N_noxref_3_c_887_p N_noxref_5_c_1652_n ) capacitor c=0.00150277f \
 //x=1.785 //y=0.91 //x2=0.81 //y2=1.22
cc_779 ( N_noxref_3_c_889_p N_noxref_5_c_1653_n ) capacitor c=0.00111227f \
 //x=1.785 //y=1.22 //x2=0.81 //y2=1.53
cc_780 ( N_noxref_3_c_687_n N_noxref_5_c_1654_n ) capacitor c=0.00147006f \
 //x=2.22 //y=2.195 //x2=0.81 //y2=1.915
cc_781 ( N_noxref_3_c_707_n N_noxref_5_c_1654_n ) capacitor c=0.00214573f \
 //x=2.22 //y=2.08 //x2=0.81 //y2=1.915
cc_782 ( N_noxref_3_c_720_n N_noxref_5_c_1654_n ) capacitor c=0.00964411f \
 //x=2.31 //y=1.915 //x2=0.81 //y2=1.915
cc_783 ( N_noxref_3_c_887_p N_noxref_5_c_1657_n ) capacitor c=0.0160123f \
 //x=1.785 //y=0.91 //x2=1.34 //y2=0.875
cc_784 ( N_noxref_3_c_717_n N_noxref_5_c_1657_n ) capacitor c=9.19165e-19 \
 //x=2.31 //y=0.91 //x2=1.34 //y2=0.875
cc_785 ( N_noxref_3_c_889_p N_noxref_5_c_1659_n ) capacitor c=0.0124075f \
 //x=1.785 //y=1.22 //x2=1.34 //y2=1.22
cc_786 ( N_noxref_3_c_718_n N_noxref_5_c_1659_n ) capacitor c=0.0010154f \
 //x=2.31 //y=1.22 //x2=1.34 //y2=1.22
cc_787 ( N_noxref_3_c_719_n N_noxref_5_c_1659_n ) capacitor c=9.23422e-19 \
 //x=2.31 //y=1.45 //x2=1.34 //y2=1.22
cc_788 ( N_noxref_3_c_696_n N_noxref_5_c_1662_n ) capacitor c=0.00112623f \
 //x=2.22 //y=4.7 //x2=1.675 //y2=4.79
cc_789 ( N_noxref_3_c_711_n N_noxref_5_c_1662_n ) capacitor c=0.00133699f \
 //x=2.22 //y=4.7 //x2=1.675 //y2=4.79
cc_790 ( N_noxref_3_c_725_n N_noxref_5_c_1662_n ) capacitor c=0.0163966f \
 //x=2.22 //y=4.7 //x2=1.675 //y2=4.79
cc_791 ( N_noxref_3_c_696_n N_noxref_5_c_1665_n ) capacitor c=8.39124e-19 \
 //x=2.22 //y=4.7 //x2=1.385 //y2=4.79
cc_792 ( N_noxref_3_c_711_n N_noxref_5_c_1665_n ) capacitor c=0.00129812f \
 //x=2.22 //y=4.7 //x2=1.385 //y2=4.79
cc_793 ( N_noxref_3_c_725_n N_noxref_5_c_1665_n ) capacitor c=0.00409733f \
 //x=2.22 //y=4.7 //x2=1.385 //y2=4.79
cc_794 ( N_noxref_3_c_758_n N_noxref_5_M8_noxref_d ) capacitor c=0.00137165f \
 //x=13.355 //y=0.905 //x2=13.43 //y2=0.905
cc_795 ( N_noxref_3_c_761_n N_noxref_5_M8_noxref_d ) capacitor c=0.00237422f \
 //x=13.355 //y=1.25 //x2=13.43 //y2=0.905
cc_796 ( N_noxref_3_c_855_p N_noxref_5_M8_noxref_d ) capacitor c=0.0020782f \
 //x=13.73 //y=0.75 //x2=13.43 //y2=0.905
cc_797 ( N_noxref_3_c_830_p N_noxref_5_M8_noxref_d ) capacitor c=0.00356097f \
 //x=13.73 //y=1.405 //x2=13.43 //y2=0.905
cc_798 ( N_noxref_3_c_766_n N_noxref_5_M8_noxref_d ) capacitor c=8.50095e-19 \
 //x=13.885 //y=0.905 //x2=13.43 //y2=0.905
cc_799 ( N_noxref_3_c_767_n N_noxref_5_M8_noxref_d ) capacitor c=0.00237422f \
 //x=13.885 //y=1.25 //x2=13.43 //y2=0.905
cc_800 ( N_noxref_3_c_711_n N_noxref_6_c_2117_n ) capacitor c=4.52718e-19 \
 //x=2.22 //y=4.7 //x2=0.74 //y2=7.4
cc_801 ( N_noxref_3_M15_noxref_g N_noxref_6_c_2118_n ) capacitor c=0.00699875f \
 //x=2.19 //y=6.02 //x2=2.765 //y2=7.4
cc_802 ( N_noxref_3_M16_noxref_g N_noxref_6_c_2118_n ) capacitor c=0.00749619f \
 //x=2.63 //y=6.02 //x2=2.765 //y2=7.4
cc_803 ( N_noxref_3_M29_noxref_g N_noxref_6_c_2120_n ) capacitor c=0.00692597f \
 //x=13.36 //y=6.02 //x2=13.935 //y2=7.4
cc_804 ( N_noxref_3_M30_noxref_g N_noxref_6_c_2120_n ) capacitor c=0.00749619f \
 //x=13.8 //y=6.02 //x2=13.935 //y2=7.4
cc_805 ( N_noxref_3_c_699_n N_noxref_6_c_2033_n ) capacitor c=0.0263067f \
 //x=9.61 //y=4.44 //x2=4.81 //y2=7.4
cc_806 ( N_noxref_3_c_711_n N_noxref_6_c_2033_n ) capacitor c=3.15216e-19 \
 //x=2.22 //y=4.7 //x2=4.81 //y2=7.4
cc_807 ( N_noxref_3_c_699_n N_noxref_6_c_2038_n ) capacitor c=0.0264152f \
 //x=9.61 //y=4.44 //x2=8.14 //y2=7.4
cc_808 ( N_noxref_3_c_744_n N_noxref_6_c_2091_n ) capacitor c=0.0262144f \
 //x=10.21 //y=4.46 //x2=11.47 //y2=7.4
cc_809 ( N_noxref_3_c_752_n N_noxref_6_c_2126_n ) capacitor c=0.00228191f \
 //x=13.35 //y=4.7 //x2=14.8 //y2=7.4
cc_810 ( N_noxref_3_c_842_p N_noxref_6_c_2126_n ) capacitor c=0.0129149f \
 //x=13.725 //y=4.79 //x2=14.8 //y2=7.4
cc_811 ( N_noxref_3_c_771_n N_noxref_6_c_2126_n ) capacitor c=2.73429e-19 \
 //x=13.35 //y=4.7 //x2=14.8 //y2=7.4
cc_812 ( N_noxref_3_M15_noxref_g N_noxref_6_M14_noxref_d ) capacitor \
 c=0.015318f //x=2.19 //y=6.02 //x2=1.825 //y2=5.02
cc_813 ( N_noxref_3_M16_noxref_g N_noxref_6_M16_noxref_d ) capacitor \
 c=0.015318f //x=2.63 //y=6.02 //x2=2.705 //y2=5.02
cc_814 ( N_noxref_3_c_699_n N_noxref_6_M19_noxref_s ) capacitor c=0.00752361f \
 //x=9.61 //y=4.44 //x2=5.465 //y2=5.02
cc_815 ( N_noxref_3_c_699_n N_noxref_6_M23_noxref_s ) capacitor c=0.00765173f \
 //x=9.61 //y=4.44 //x2=8.795 //y2=5.02
cc_816 ( N_noxref_3_c_744_n N_noxref_6_M27_noxref_s ) capacitor c=0.00765173f \
 //x=10.21 //y=4.46 //x2=12.125 //y2=5.02
cc_817 ( N_noxref_3_M29_noxref_g N_noxref_6_M28_noxref_d ) capacitor \
 c=0.015318f //x=13.36 //y=6.02 //x2=12.995 //y2=5.02
cc_818 ( N_noxref_3_c_771_n N_noxref_6_M28_noxref_d ) capacitor c=3.50187e-19 \
 //x=13.35 //y=4.7 //x2=12.995 //y2=5.02
cc_819 ( N_noxref_3_M30_noxref_g N_noxref_6_M30_noxref_d ) capacitor \
 c=0.0430452f //x=13.8 //y=6.02 //x2=13.875 //y2=5.02
cc_820 ( N_noxref_3_c_717_n N_noxref_7_c_2401_n ) capacitor c=0.00123426f \
 //x=2.31 //y=0.91 //x2=3.015 //y2=0.995
cc_821 ( N_noxref_3_c_718_n N_noxref_7_c_2401_n ) capacitor c=0.0129288f \
 //x=2.31 //y=1.22 //x2=3.015 //y2=0.995
cc_822 ( N_noxref_3_c_719_n N_noxref_7_c_2401_n ) capacitor c=0.00132209f \
 //x=2.31 //y=1.45 //x2=3.015 //y2=0.995
cc_823 ( N_noxref_3_c_687_n N_noxref_7_M1_noxref_d ) capacitor c=0.00610765f \
 //x=2.22 //y=2.195 //x2=1.86 //y2=0.91
cc_824 ( N_noxref_3_c_707_n N_noxref_7_M1_noxref_d ) capacitor c=2.2052e-19 \
 //x=2.22 //y=2.08 //x2=1.86 //y2=0.91
cc_825 ( N_noxref_3_c_887_p N_noxref_7_M1_noxref_d ) capacitor c=0.00253592f \
 //x=1.785 //y=0.91 //x2=1.86 //y2=0.91
cc_826 ( N_noxref_3_c_889_p N_noxref_7_M1_noxref_d ) capacitor c=0.00604634f \
 //x=1.785 //y=1.22 //x2=1.86 //y2=0.91
cc_827 ( N_noxref_3_c_937_p N_noxref_7_M1_noxref_d ) capacitor c=0.002686f \
 //x=2.155 //y=0.755 //x2=1.86 //y2=0.91
cc_828 ( N_noxref_3_c_938_p N_noxref_7_M1_noxref_d ) capacitor c=0.00251995f \
 //x=2.155 //y=1.375 //x2=1.86 //y2=0.91
cc_829 ( N_noxref_3_c_717_n N_noxref_7_M1_noxref_d ) capacitor c=0.00314523f \
 //x=2.31 //y=0.91 //x2=1.86 //y2=0.91
cc_830 ( N_noxref_3_c_718_n N_noxref_7_M1_noxref_d ) capacitor c=0.00168289f \
 //x=2.31 //y=1.22 //x2=1.86 //y2=0.91
cc_831 ( N_noxref_3_c_719_n N_noxref_7_M1_noxref_d ) capacitor c=0.00111165f \
 //x=2.31 //y=1.45 //x2=1.86 //y2=0.91
cc_832 ( N_noxref_3_c_717_n N_noxref_7_M2_noxref_s ) capacitor c=7.21316e-19 \
 //x=2.31 //y=0.91 //x2=2.965 //y2=0.375
cc_833 ( N_noxref_3_c_718_n N_noxref_7_M2_noxref_s ) capacitor c=0.00365271f \
 //x=2.31 //y=1.22 //x2=2.965 //y2=0.375
cc_834 ( N_noxref_3_c_720_n N_noxref_7_M2_noxref_s ) capacitor c=9.86711e-19 \
 //x=2.31 //y=1.915 //x2=2.965 //y2=0.375
cc_835 ( N_noxref_3_c_699_n N_noxref_8_c_2455_n ) capacitor c=0.0275303f \
 //x=9.61 //y=4.44 //x2=6.66 //y2=4.555
cc_836 ( N_noxref_3_c_687_n N_noxref_12_c_2906_n ) capacitor c=9.14688e-19 \
 //x=2.22 //y=2.195 //x2=5.905 //y2=0
cc_837 ( N_noxref_3_c_739_n N_noxref_12_c_2993_n ) capacitor c=0.00234099f \
 //x=13.32 //y=2.08 //x2=15.895 //y2=0
cc_838 ( N_noxref_3_c_739_n N_noxref_12_c_2973_n ) capacitor c=3.77673e-19 \
 //x=13.32 //y=2.08 //x2=14.63 //y2=0
cc_839 ( N_noxref_3_c_748_n N_noxref_12_c_2995_n ) capacitor c=0.00224736f \
 //x=13.32 //y=2.08 //x2=14.8 //y2=0
cc_840 ( N_noxref_3_c_767_n N_noxref_12_c_2995_n ) capacitor c=0.00275184f \
 //x=13.885 //y=1.25 //x2=14.8 //y2=0
cc_841 ( N_noxref_3_c_768_n N_noxref_12_c_2995_n ) capacitor c=2.63786e-19 \
 //x=13.32 //y=2.08 //x2=14.8 //y2=0
cc_842 ( N_noxref_3_c_887_p N_noxref_14_c_3442_n ) capacitor c=0.0167228f \
 //x=1.785 //y=0.91 //x2=2.445 //y2=0.54
cc_843 ( N_noxref_3_c_717_n N_noxref_14_c_3442_n ) capacitor c=0.00534519f \
 //x=2.31 //y=0.91 //x2=2.445 //y2=0.54
cc_844 ( N_noxref_3_c_687_n N_noxref_14_c_3444_n ) capacitor c=0.0048147f \
 //x=2.22 //y=2.195 //x2=2.445 //y2=1.59
cc_845 ( N_noxref_3_c_696_n N_noxref_14_c_3444_n ) capacitor c=9.34338e-19 \
 //x=2.22 //y=4.7 //x2=2.445 //y2=1.59
cc_846 ( N_noxref_3_c_707_n N_noxref_14_c_3444_n ) capacitor c=0.0105652f \
 //x=2.22 //y=2.08 //x2=2.445 //y2=1.59
cc_847 ( N_noxref_3_c_889_p N_noxref_14_c_3444_n ) capacitor c=0.0153476f \
 //x=1.785 //y=1.22 //x2=2.445 //y2=1.59
cc_848 ( N_noxref_3_c_720_n N_noxref_14_c_3444_n ) capacitor c=0.0205552f \
 //x=2.31 //y=1.915 //x2=2.445 //y2=1.59
cc_849 ( N_noxref_3_c_887_p N_noxref_14_M0_noxref_s ) capacitor c=0.00798959f \
 //x=1.785 //y=0.91 //x2=0.455 //y2=0.375
cc_850 ( N_noxref_3_c_719_n N_noxref_14_M0_noxref_s ) capacitor c=0.00212176f \
 //x=2.31 //y=1.45 //x2=0.455 //y2=0.375
cc_851 ( N_noxref_3_c_720_n N_noxref_14_M0_noxref_s ) capacitor c=0.00298115f \
 //x=2.31 //y=1.915 //x2=0.455 //y2=0.375
cc_852 ( N_noxref_3_c_739_n N_noxref_17_c_3638_n ) capacitor c=7.50092e-19 \
 //x=13.32 //y=2.08 //x2=13.135 //y2=1.495
cc_853 ( N_noxref_3_c_763_n N_noxref_17_c_3638_n ) capacitor c=0.00888238f \
 //x=13.355 //y=1.56 //x2=13.135 //y2=1.495
cc_854 ( N_noxref_3_c_768_n N_noxref_17_c_3638_n ) capacitor c=0.00175171f \
 //x=13.32 //y=2.08 //x2=13.135 //y2=1.495
cc_855 ( N_noxref_3_c_739_n N_noxref_17_c_3645_n ) capacitor c=0.00141156f \
 //x=13.32 //y=2.08 //x2=14.02 //y2=0.53
cc_856 ( N_noxref_3_c_748_n N_noxref_17_c_3645_n ) capacitor c=8.82141e-19 \
 //x=13.32 //y=2.08 //x2=14.02 //y2=0.53
cc_857 ( N_noxref_3_c_758_n N_noxref_17_c_3645_n ) capacitor c=0.0199501f \
 //x=13.355 //y=0.905 //x2=14.02 //y2=0.53
cc_858 ( N_noxref_3_c_766_n N_noxref_17_c_3645_n ) capacitor c=0.00825432f \
 //x=13.885 //y=0.905 //x2=14.02 //y2=0.53
cc_859 ( N_noxref_3_c_768_n N_noxref_17_c_3645_n ) capacitor c=2.1838e-19 \
 //x=13.32 //y=2.08 //x2=14.02 //y2=0.53
cc_860 ( N_noxref_3_c_758_n N_noxref_17_M7_noxref_s ) capacitor c=0.00888238f \
 //x=13.355 //y=0.905 //x2=12.03 //y2=0.365
cc_861 ( N_noxref_3_c_766_n N_noxref_17_M7_noxref_s ) capacitor c=0.015333f \
 //x=13.885 //y=0.905 //x2=12.03 //y2=0.365
cc_862 ( N_noxref_3_c_767_n N_noxref_17_M7_noxref_s ) capacitor c=0.00248746f \
 //x=13.885 //y=1.25 //x2=12.03 //y2=0.365
cc_863 ( N_noxref_4_c_1055_n N_noxref_5_c_1441_n ) capacitor c=4.05935e-19 \
 //x=9.46 //y=3.71 //x2=9.99 //y2=3.915
cc_864 ( N_noxref_4_c_1077_n N_noxref_5_c_1441_n ) capacitor c=0.0258164f \
 //x=10.21 //y=3.69 //x2=9.99 //y2=3.915
cc_865 ( N_noxref_4_c_1055_n N_noxref_5_c_1449_n ) capacitor c=0.00219434f \
 //x=9.46 //y=3.71 //x2=9.99 //y2=4.235
cc_866 ( N_noxref_4_c_1077_n N_noxref_5_c_1449_n ) capacitor c=0.00450788f \
 //x=10.21 //y=3.69 //x2=9.99 //y2=4.235
cc_867 ( N_noxref_4_c_1089_n N_noxref_5_c_1510_n ) capacitor c=0.00551458f \
 //x=12.79 //y=3.715 //x2=13.705 //y2=1.655
cc_868 ( N_noxref_4_c_1102_n N_noxref_5_c_1511_n ) capacitor c=0.0241716f \
 //x=15.91 //y=3.545 //x2=14.06 //y2=3.925
cc_869 ( N_noxref_4_c_1132_p N_noxref_5_c_1511_n ) capacitor c=0.00254581f \
 //x=15.91 //y=3.865 //x2=14.06 //y2=3.925
cc_870 ( N_noxref_4_c_1133_p N_noxref_5_c_1511_n ) capacitor c=0.00457386f \
 //x=15.91 //y=2.08 //x2=14.06 //y2=3.925
cc_871 ( N_noxref_4_c_1110_n N_noxref_5_c_1511_n ) capacitor c=0.00103966f \
 //x=15.912 //y=4.56 //x2=14.06 //y2=3.925
cc_872 ( N_noxref_4_c_1089_n N_noxref_5_c_1511_n ) capacitor c=0.0308123f \
 //x=12.79 //y=3.715 //x2=14.06 //y2=3.925
cc_873 ( N_noxref_4_c_1110_n N_noxref_5_c_1605_n ) capacitor c=0.00233357f \
 //x=15.912 //y=4.56 //x2=14.06 //y2=4.245
cc_874 ( N_noxref_4_c_1089_n N_noxref_5_c_1605_n ) capacitor c=0.00721489f \
 //x=12.79 //y=3.715 //x2=14.06 //y2=4.245
cc_875 ( N_noxref_4_c_1138_p N_noxref_5_c_1514_n ) capacitor c=0.00476843f \
 //x=15.91 //y=4.7 //x2=14.06 //y2=5.115
cc_876 ( N_noxref_4_c_1110_n N_noxref_5_c_1514_n ) capacitor c=0.00494123f \
 //x=15.912 //y=4.56 //x2=14.06 //y2=5.115
cc_877 ( N_noxref_4_c_1077_n N_noxref_5_c_1456_n ) capacitor c=0.00161291f \
 //x=10.21 //y=3.69 //x2=9.99 //y2=2.08
cc_878 ( N_noxref_4_c_1015_n N_noxref_5_c_1459_n ) capacitor c=0.00127339f \
 //x=4.07 //y=3.86 //x2=3.685 //y2=4.07
cc_879 ( N_noxref_4_c_1017_n N_noxref_5_c_1459_n ) capacitor c=3.11164e-19 \
 //x=4.07 //y=5.07 //x2=3.685 //y2=4.07
cc_880 ( N_noxref_4_c_1143_p N_noxref_5_c_1459_n ) capacitor c=0.0220746f \
 //x=1.532 //y=5.155 //x2=3.685 //y2=4.07
cc_881 ( N_noxref_4_c_1042_n N_noxref_5_c_1459_n ) capacitor c=0.0358254f \
 //x=4.23 //y=3.7 //x2=3.685 //y2=4.07
cc_882 ( N_noxref_4_c_1015_n N_noxref_5_c_1463_n ) capacitor c=0.00757046f \
 //x=4.07 //y=3.86 //x2=4.285 //y2=4.085
cc_883 ( N_noxref_4_c_1017_n N_noxref_5_c_1463_n ) capacitor c=0.0226561f \
 //x=4.07 //y=5.07 //x2=4.285 //y2=4.085
cc_884 ( N_noxref_4_c_1040_n N_noxref_5_c_1463_n ) capacitor c=0.127758f \
 //x=5.755 //y=3.7 //x2=4.285 //y2=4.085
cc_885 ( N_noxref_4_c_1026_n N_noxref_5_c_1464_n ) capacitor c=0.00447313f \
 //x=5.92 //y=3.86 //x2=5.53 //y2=4.07
cc_886 ( N_noxref_4_c_1038_n N_noxref_5_c_1464_n ) capacitor c=4.98743e-19 \
 //x=5.922 //y=4.56 //x2=5.53 //y2=4.07
cc_887 ( N_noxref_4_c_1040_n N_noxref_5_c_1464_n ) capacitor c=0.0108816f \
 //x=5.755 //y=3.7 //x2=5.53 //y2=4.07
cc_888 ( N_noxref_4_c_1047_n N_noxref_5_c_1464_n ) capacitor c=0.0358254f \
 //x=7.265 //y=3.715 //x2=5.53 //y2=4.07
cc_889 ( N_noxref_4_c_1026_n N_noxref_5_c_1465_n ) capacitor c=0.00240423f \
 //x=5.92 //y=3.86 //x2=6.13 //y2=4.085
cc_890 ( N_noxref_4_c_1038_n N_noxref_5_c_1465_n ) capacitor c=0.0221402f \
 //x=5.922 //y=4.56 //x2=6.13 //y2=4.085
cc_891 ( N_noxref_4_c_1047_n N_noxref_5_c_1465_n ) capacitor c=0.011929f \
 //x=7.265 //y=3.715 //x2=6.13 //y2=4.085
cc_892 ( N_noxref_4_c_1077_n N_noxref_5_c_1528_n ) capacitor c=0.0834487f \
 //x=10.21 //y=3.69 //x2=13.89 //y2=4.07
cc_893 ( N_noxref_4_c_1082_n N_noxref_5_c_1528_n ) capacitor c=0.110992f \
 //x=10.95 //y=3.715 //x2=13.89 //y2=4.07
cc_894 ( N_noxref_4_c_1085_n N_noxref_5_c_1528_n ) capacitor c=0.0573431f \
 //x=12.19 //y=3.7 //x2=13.89 //y2=4.07
cc_895 ( N_noxref_4_c_1089_n N_noxref_5_c_1528_n ) capacitor c=0.0912005f \
 //x=12.79 //y=3.715 //x2=13.89 //y2=4.07
cc_896 ( N_noxref_4_c_1038_n N_noxref_5_c_1466_n ) capacitor c=3.14882e-19 \
 //x=5.922 //y=4.56 //x2=10.155 //y2=4.07
cc_897 ( N_noxref_4_c_1044_n N_noxref_5_c_1466_n ) capacitor c=0.111913f \
 //x=7.61 //y=3.715 //x2=10.155 //y2=4.07
cc_898 ( N_noxref_4_c_1047_n N_noxref_5_c_1466_n ) capacitor c=0.133647f \
 //x=7.265 //y=3.715 //x2=10.155 //y2=4.07
cc_899 ( N_noxref_4_c_1051_n N_noxref_5_c_1466_n ) capacitor c=0.05672f \
 //x=8.86 //y=3.7 //x2=10.155 //y2=4.07
cc_900 ( N_noxref_4_c_1055_n N_noxref_5_c_1466_n ) capacitor c=0.0248422f \
 //x=9.46 //y=3.71 //x2=10.155 //y2=4.07
cc_901 ( N_noxref_4_c_1077_n N_noxref_5_c_1466_n ) capacitor c=0.0365231f \
 //x=10.21 //y=3.69 //x2=10.155 //y2=4.07
cc_902 ( N_noxref_4_c_1132_p N_noxref_5_c_1713_n ) capacitor c=0.00248847f \
 //x=15.91 //y=3.865 //x2=16.125 //y2=4.09
cc_903 ( N_noxref_4_c_1138_p N_noxref_5_c_1713_n ) capacitor c=0.00242573f \
 //x=15.91 //y=4.7 //x2=16.125 //y2=4.09
cc_904 ( N_noxref_4_c_1110_n N_noxref_5_c_1713_n ) capacitor c=0.0263613f \
 //x=15.912 //y=4.56 //x2=16.125 //y2=4.09
cc_905 ( N_noxref_4_c_1132_p N_noxref_5_c_1635_n ) capacitor c=0.0044381f \
 //x=15.91 //y=3.865 //x2=15.78 //y2=4.09
cc_906 ( N_noxref_4_c_1110_n N_noxref_5_c_1635_n ) capacitor c=0.00208639f \
 //x=15.912 //y=4.56 //x2=15.78 //y2=4.09
cc_907 ( N_noxref_4_c_1089_n N_noxref_5_c_1635_n ) capacitor c=0.222337f \
 //x=12.79 //y=3.715 //x2=15.78 //y2=4.09
cc_908 ( N_noxref_4_c_1143_p N_noxref_5_M13_noxref_g ) capacitor c=0.00501342f \
 //x=1.532 //y=5.155 //x2=1.31 //y2=6.02
cc_909 ( N_noxref_4_c_1172_p N_noxref_5_M13_noxref_g ) capacitor c=0.0162284f \
 //x=1.53 //y=5.38 //x2=1.31 //y2=6.02
cc_910 ( N_noxref_4_c_1091_n N_noxref_5_M14_noxref_g ) capacitor c=0.00973141f \
 //x=2.29 //y=5.155 //x2=1.75 //y2=6.02
cc_911 ( N_noxref_4_c_1143_p N_noxref_5_M14_noxref_g ) capacitor c=0.00229208f \
 //x=1.532 //y=5.155 //x2=1.75 //y2=6.02
cc_912 ( N_noxref_4_c_1172_p N_noxref_5_M14_noxref_g ) capacitor c=0.0179041f \
 //x=1.53 //y=5.38 //x2=1.75 //y2=6.02
cc_913 ( N_noxref_4_c_1143_p N_noxref_5_c_1662_n ) capacitor c=0.00171885f \
 //x=1.532 //y=5.155 //x2=1.675 //y2=4.79
cc_914 ( N_noxref_4_c_1172_p N_noxref_5_c_1662_n ) capacitor c=0.00291477f \
 //x=1.53 //y=5.38 //x2=1.675 //y2=4.79
cc_915 ( N_noxref_4_c_1091_n N_noxref_6_c_2010_n ) capacitor c=0.0062064f \
 //x=2.29 //y=5.155 //x2=21.09 //y2=7.4
cc_916 ( N_noxref_4_c_973_n N_noxref_6_c_2010_n ) capacitor c=0.00626474f \
 //x=3.175 //y=5.155 //x2=21.09 //y2=7.4
cc_917 ( N_noxref_4_c_974_n N_noxref_6_c_2010_n ) capacitor c=0.00255587f \
 //x=3.29 //y=5.38 //x2=21.09 //y2=7.4
cc_918 ( N_noxref_4_c_977_n N_noxref_6_c_2010_n ) capacitor c=0.00827852f \
 //x=3.985 //y=5.155 //x2=21.09 //y2=7.4
cc_919 ( N_noxref_4_c_1015_n N_noxref_6_c_2010_n ) capacitor c=5.12302e-19 \
 //x=4.07 //y=3.86 //x2=21.09 //y2=7.4
cc_920 ( N_noxref_4_c_1026_n N_noxref_6_c_2010_n ) capacitor c=2.12281e-19 \
 //x=5.92 //y=3.86 //x2=21.09 //y2=7.4
cc_921 ( N_noxref_4_c_1132_p N_noxref_6_c_2010_n ) capacitor c=2.12449e-19 \
 //x=15.91 //y=3.865 //x2=21.09 //y2=7.4
cc_922 ( N_noxref_4_c_1143_p N_noxref_6_c_2010_n ) capacitor c=0.00261379f \
 //x=1.532 //y=5.155 //x2=21.09 //y2=7.4
cc_923 ( N_noxref_4_c_1103_n N_noxref_6_c_2010_n ) capacitor c=0.0026965f \
 //x=2.41 //y=5.155 //x2=21.09 //y2=7.4
cc_924 ( N_noxref_4_c_1036_n N_noxref_6_c_2010_n ) capacitor c=9.05427e-19 \
 //x=5.92 //y=4.7 //x2=21.09 //y2=7.4
cc_925 ( N_noxref_4_c_1138_p N_noxref_6_c_2010_n ) capacitor c=9.05427e-19 \
 //x=15.91 //y=4.7 //x2=21.09 //y2=7.4
cc_926 ( N_noxref_4_c_1172_p N_noxref_6_c_2010_n ) capacitor c=0.00242194f \
 //x=1.53 //y=5.38 //x2=21.09 //y2=7.4
cc_927 ( N_noxref_4_c_1122_n N_noxref_6_c_2010_n ) capacitor c=0.00242194f \
 //x=2.41 //y=5.38 //x2=21.09 //y2=7.4
cc_928 ( N_noxref_4_c_1057_n N_noxref_6_c_2010_n ) capacitor c=0.00242194f \
 //x=3.29 //y=5.38 //x2=21.09 //y2=7.4
cc_929 ( N_noxref_4_c_1062_n N_noxref_6_c_2010_n ) capacitor c=6.23118e-19 \
 //x=5.92 //y=4.7 //x2=21.09 //y2=7.4
cc_930 ( N_noxref_4_c_1193_p N_noxref_6_c_2010_n ) capacitor c=6.23118e-19 \
 //x=15.91 //y=4.7 //x2=21.09 //y2=7.4
cc_931 ( N_noxref_4_c_1143_p N_noxref_6_c_2117_n ) capacitor c=0.00331944f \
 //x=1.532 //y=5.155 //x2=0.74 //y2=7.4
cc_932 ( N_noxref_4_c_1172_p N_noxref_6_c_2117_n ) capacitor c=0.00509469f \
 //x=1.53 //y=5.38 //x2=0.74 //y2=7.4
cc_933 ( N_noxref_4_c_1091_n N_noxref_6_c_2155_n ) capacitor c=0.00202948f \
 //x=2.29 //y=5.155 //x2=1.885 //y2=7.4
cc_934 ( N_noxref_4_c_1143_p N_noxref_6_c_2155_n ) capacitor c=9.37357e-19 \
 //x=1.532 //y=5.155 //x2=1.885 //y2=7.4
cc_935 ( N_noxref_4_c_1172_p N_noxref_6_c_2155_n ) capacitor c=0.0137846f \
 //x=1.53 //y=5.38 //x2=1.885 //y2=7.4
cc_936 ( N_noxref_4_c_1091_n N_noxref_6_c_2118_n ) capacitor c=0.00177019f \
 //x=2.29 //y=5.155 //x2=2.765 //y2=7.4
cc_937 ( N_noxref_4_c_973_n N_noxref_6_c_2118_n ) capacitor c=0.00202948f \
 //x=3.175 //y=5.155 //x2=2.765 //y2=7.4
cc_938 ( N_noxref_4_c_1103_n N_noxref_6_c_2118_n ) capacitor c=9.47801e-19 \
 //x=2.41 //y=5.155 //x2=2.765 //y2=7.4
cc_939 ( N_noxref_4_c_1122_n N_noxref_6_c_2118_n ) capacitor c=0.0137846f \
 //x=2.41 //y=5.38 //x2=2.765 //y2=7.4
cc_940 ( N_noxref_4_c_973_n N_noxref_6_c_2020_n ) capacitor c=0.00205929f \
 //x=3.175 //y=5.155 //x2=3.645 //y2=7.4
cc_941 ( N_noxref_4_c_974_n N_noxref_6_c_2020_n ) capacitor c=8.49349e-19 \
 //x=3.29 //y=5.38 //x2=3.645 //y2=7.4
cc_942 ( N_noxref_4_c_977_n N_noxref_6_c_2020_n ) capacitor c=0.00204261f \
 //x=3.985 //y=5.155 //x2=3.645 //y2=7.4
cc_943 ( N_noxref_4_c_1057_n N_noxref_6_c_2020_n ) capacitor c=0.0137846f \
 //x=3.29 //y=5.38 //x2=3.645 //y2=7.4
cc_944 ( N_noxref_4_c_977_n N_noxref_6_c_2166_n ) capacitor c=0.00183429f \
 //x=3.985 //y=5.155 //x2=4.64 //y2=7.4
cc_945 ( N_noxref_4_c_1036_n N_noxref_6_c_2022_n ) capacitor c=6.28732e-19 \
 //x=5.92 //y=4.7 //x2=6.395 //y2=7.4
cc_946 ( N_noxref_4_M19_noxref_g N_noxref_6_c_2022_n ) capacitor c=0.0072715f \
 //x=5.82 //y=6.02 //x2=6.395 //y2=7.4
cc_947 ( N_noxref_4_M20_noxref_g N_noxref_6_c_2022_n ) capacitor c=0.00749619f \
 //x=6.26 //y=6.02 //x2=6.395 //y2=7.4
cc_948 ( N_noxref_4_c_1138_p N_noxref_6_c_2170_n ) capacitor c=6.28732e-19 \
 //x=15.91 //y=4.7 //x2=16.385 //y2=7.4
cc_949 ( N_noxref_4_M31_noxref_g N_noxref_6_c_2170_n ) capacitor c=0.0072715f \
 //x=15.81 //y=6.02 //x2=16.385 //y2=7.4
cc_950 ( N_noxref_4_M32_noxref_g N_noxref_6_c_2170_n ) capacitor c=0.00749619f \
 //x=16.25 //y=6.02 //x2=16.385 //y2=7.4
cc_951 ( N_noxref_4_c_974_n N_noxref_6_c_2033_n ) capacitor c=0.00269779f \
 //x=3.29 //y=5.38 //x2=4.81 //y2=7.4
cc_952 ( N_noxref_4_c_1017_n N_noxref_6_c_2033_n ) capacitor c=0.0311457f \
 //x=4.07 //y=5.07 //x2=4.81 //y2=7.4
cc_953 ( N_noxref_4_c_1036_n N_noxref_6_c_2033_n ) capacitor c=0.00447349f \
 //x=5.92 //y=4.7 //x2=4.81 //y2=7.4
cc_954 ( N_noxref_4_c_1038_n N_noxref_6_c_2033_n ) capacitor c=0.005882f \
 //x=5.922 //y=4.56 //x2=4.81 //y2=7.4
cc_955 ( N_noxref_4_c_1057_n N_noxref_6_c_2033_n ) capacitor c=0.00776541f \
 //x=3.29 //y=5.38 //x2=4.81 //y2=7.4
cc_956 ( N_noxref_4_c_1062_n N_noxref_6_c_2033_n ) capacitor c=0.00387138f \
 //x=5.92 //y=4.7 //x2=4.81 //y2=7.4
cc_957 ( N_noxref_4_c_1069_n N_noxref_6_c_2033_n ) capacitor c=0.0125313f \
 //x=5.92 //y=4.7 //x2=4.81 //y2=7.4
cc_958 ( N_noxref_4_c_1138_p N_noxref_6_c_2126_n ) capacitor c=0.00447349f \
 //x=15.91 //y=4.7 //x2=14.8 //y2=7.4
cc_959 ( N_noxref_4_c_1110_n N_noxref_6_c_2126_n ) capacitor c=0.00695635f \
 //x=15.912 //y=4.56 //x2=14.8 //y2=7.4
cc_960 ( N_noxref_4_c_1089_n N_noxref_6_c_2126_n ) capacitor c=0.00271682f \
 //x=12.79 //y=3.715 //x2=14.8 //y2=7.4
cc_961 ( N_noxref_4_c_1193_p N_noxref_6_c_2126_n ) capacitor c=0.00370494f \
 //x=15.91 //y=4.7 //x2=14.8 //y2=7.4
cc_962 ( N_noxref_4_c_1225_p N_noxref_6_c_2126_n ) capacitor c=0.0129564f \
 //x=15.91 //y=4.7 //x2=14.8 //y2=7.4
cc_963 ( N_noxref_4_c_1143_p N_noxref_6_M13_noxref_s ) capacitor c=0.0451824f \
 //x=1.532 //y=5.155 //x2=0.955 //y2=5.02
cc_964 ( N_noxref_4_c_1103_n N_noxref_6_M13_noxref_s ) capacitor c=7.80122e-19 \
 //x=2.41 //y=5.155 //x2=0.955 //y2=5.02
cc_965 ( N_noxref_4_c_1172_p N_noxref_6_M13_noxref_s ) capacitor c=0.09305f \
 //x=1.53 //y=5.38 //x2=0.955 //y2=5.02
cc_966 ( N_noxref_4_c_1091_n N_noxref_6_M14_noxref_d ) capacitor c=0.00700078f \
 //x=2.29 //y=5.155 //x2=1.825 //y2=5.02
cc_967 ( N_noxref_4_c_1172_p N_noxref_6_M14_noxref_d ) capacitor c=0.0674491f \
 //x=1.53 //y=5.38 //x2=1.825 //y2=5.02
cc_968 ( N_noxref_4_c_1122_n N_noxref_6_M14_noxref_d ) capacitor c=0.0674762f \
 //x=2.41 //y=5.38 //x2=1.825 //y2=5.02
cc_969 ( N_noxref_4_c_973_n N_noxref_6_M16_noxref_d ) capacitor c=0.00700078f \
 //x=3.175 //y=5.155 //x2=2.705 //y2=5.02
cc_970 ( N_noxref_4_c_1122_n N_noxref_6_M16_noxref_d ) capacitor c=0.067493f \
 //x=2.41 //y=5.38 //x2=2.705 //y2=5.02
cc_971 ( N_noxref_4_c_1057_n N_noxref_6_M16_noxref_d ) capacitor c=0.0674288f \
 //x=3.29 //y=5.38 //x2=2.705 //y2=5.02
cc_972 ( N_noxref_4_c_977_n N_noxref_6_M18_noxref_d ) capacitor c=0.00700078f \
 //x=3.985 //y=5.155 //x2=3.585 //y2=5.02
cc_973 ( N_noxref_4_c_1057_n N_noxref_6_M18_noxref_d ) capacitor c=0.0673824f \
 //x=3.29 //y=5.38 //x2=3.585 //y2=5.02
cc_974 ( N_noxref_4_c_974_n N_noxref_6_M19_noxref_s ) capacitor c=0.00536022f \
 //x=3.29 //y=5.38 //x2=5.465 //y2=5.02
cc_975 ( N_noxref_4_c_977_n N_noxref_6_M19_noxref_s ) capacitor c=0.00211796f \
 //x=3.985 //y=5.155 //x2=5.465 //y2=5.02
cc_976 ( N_noxref_4_c_1026_n N_noxref_6_M19_noxref_s ) capacitor c=0.00143547f \
 //x=5.92 //y=3.86 //x2=5.465 //y2=5.02
cc_977 ( N_noxref_4_M19_noxref_g N_noxref_6_M19_noxref_s ) capacitor \
 c=0.0567929f //x=5.82 //y=6.02 //x2=5.465 //y2=5.02
cc_978 ( N_noxref_4_M20_noxref_g N_noxref_6_M20_noxref_d ) capacitor \
 c=0.015318f //x=6.26 //y=6.02 //x2=6.335 //y2=5.02
cc_979 ( N_noxref_4_c_1132_p N_noxref_6_M31_noxref_s ) capacitor c=0.00144559f \
 //x=15.91 //y=3.865 //x2=15.455 //y2=5.02
cc_980 ( N_noxref_4_M31_noxref_g N_noxref_6_M31_noxref_s ) capacitor \
 c=0.0567929f //x=15.81 //y=6.02 //x2=15.455 //y2=5.02
cc_981 ( N_noxref_4_M32_noxref_g N_noxref_6_M32_noxref_d ) capacitor \
 c=0.015318f //x=16.25 //y=6.02 //x2=16.325 //y2=5.02
cc_982 ( N_noxref_4_c_982_n N_noxref_7_c_2391_n ) capacitor c=0.0036878f \
 //x=3.585 //y=1.125 //x2=3.985 //y2=0.54
cc_983 ( N_noxref_4_c_997_n N_noxref_7_c_2391_n ) capacitor c=0.00366757f \
 //x=3.985 //y=1.665 //x2=3.985 //y2=0.54
cc_984 ( N_noxref_4_M2_noxref_d N_noxref_7_c_2391_n ) capacitor c=0.00949319f \
 //x=3.395 //y=0.915 //x2=3.985 //y2=0.54
cc_985 ( N_noxref_4_M2_noxref_d N_noxref_7_c_2396_n ) capacitor c=0.00120711f \
 //x=3.395 //y=0.915 //x2=3.1 //y2=0.995
cc_986 ( N_noxref_4_c_1091_n N_noxref_7_M1_noxref_d ) capacitor c=0.00164346f \
 //x=2.29 //y=5.155 //x2=1.86 //y2=0.91
cc_987 ( N_noxref_4_c_982_n N_noxref_7_M1_noxref_d ) capacitor c=0.00802836f \
 //x=3.585 //y=1.125 //x2=1.86 //y2=0.91
cc_988 ( N_noxref_4_c_982_n N_noxref_7_M2_noxref_s ) capacitor c=0.00993092f \
 //x=3.585 //y=1.125 //x2=2.965 //y2=0.375
cc_989 ( N_noxref_4_c_991_n N_noxref_7_M2_noxref_s ) capacitor c=0.0273402f \
 //x=3.585 //y=1.58 //x2=2.965 //y2=0.375
cc_990 ( N_noxref_4_c_997_n N_noxref_7_M2_noxref_s ) capacitor c=0.00911719f \
 //x=3.985 //y=1.665 //x2=2.965 //y2=0.375
cc_991 ( N_noxref_4_c_1034_n N_noxref_7_M2_noxref_s ) capacitor c=0.00129723f \
 //x=4.07 //y=3.7 //x2=2.965 //y2=0.375
cc_992 ( N_noxref_4_M2_noxref_d N_noxref_7_M2_noxref_s ) capacitor \
 c=0.0279003f //x=3.395 //y=0.915 //x2=2.965 //y2=0.375
cc_993 ( N_noxref_4_c_1004_n N_noxref_8_c_2455_n ) capacitor c=0.00275583f \
 //x=4.07 //y=3.54 //x2=6.66 //y2=4.555
cc_994 ( N_noxref_4_c_1017_n N_noxref_8_c_2455_n ) capacitor c=0.00115385f \
 //x=4.07 //y=5.07 //x2=6.66 //y2=4.555
cc_995 ( N_noxref_4_c_1021_n N_noxref_8_c_2455_n ) capacitor c=0.0565531f \
 //x=5.92 //y=3.54 //x2=6.66 //y2=4.555
cc_996 ( N_noxref_4_c_1026_n N_noxref_8_c_2455_n ) capacitor c=0.0144744f \
 //x=5.92 //y=3.86 //x2=6.66 //y2=4.555
cc_997 ( N_noxref_4_c_1260_p N_noxref_8_c_2455_n ) capacitor c=6.03895e-19 \
 //x=5.915 //y=3.7 //x2=6.66 //y2=4.555
cc_998 ( N_noxref_4_c_1036_n N_noxref_8_c_2455_n ) capacitor c=0.0172863f \
 //x=5.92 //y=4.7 //x2=6.66 //y2=4.555
cc_999 ( N_noxref_4_c_1038_n N_noxref_8_c_2455_n ) capacitor c=0.0261735f \
 //x=5.922 //y=4.56 //x2=6.66 //y2=4.555
cc_1000 ( N_noxref_4_c_1047_n N_noxref_8_c_2455_n ) capacitor c=0.0234467f \
 //x=7.265 //y=3.715 //x2=6.66 //y2=4.555
cc_1001 ( N_noxref_4_c_1264_p N_noxref_8_c_2455_n ) capacitor c=3.49899e-19 \
 //x=5.92 //y=2.08 //x2=6.66 //y2=4.555
cc_1002 ( N_noxref_4_c_1062_n N_noxref_8_c_2455_n ) capacitor c=7.76143e-19 \
 //x=5.92 //y=4.7 //x2=6.66 //y2=4.555
cc_1003 ( N_noxref_4_c_1069_n N_noxref_8_c_2455_n ) capacitor c=0.00201171f \
 //x=5.92 //y=4.7 //x2=6.66 //y2=4.555
cc_1004 ( N_noxref_4_c_1035_n N_noxref_8_c_2463_n ) capacitor c=0.0205342f \
 //x=5.92 //y=2.08 //x2=6.66 //y2=2.08
cc_1005 ( N_noxref_4_c_1264_p N_noxref_8_c_2463_n ) capacitor c=5.16867e-19 \
 //x=5.92 //y=2.08 //x2=6.66 //y2=2.08
cc_1006 ( N_noxref_4_c_1269_p N_noxref_8_c_2463_n ) capacitor c=0.00167888f \
 //x=5.725 //y=1.915 //x2=6.66 //y2=2.08
cc_1007 ( N_noxref_4_c_1021_n N_noxref_8_c_2465_n ) capacitor c=3.49899e-19 \
 //x=5.92 //y=3.54 //x2=6.66 //y2=2.08
cc_1008 ( N_noxref_4_c_1035_n N_noxref_8_c_2465_n ) capacitor c=5.24723e-19 \
 //x=5.92 //y=2.08 //x2=6.66 //y2=2.08
cc_1009 ( N_noxref_4_c_1264_p N_noxref_8_c_2465_n ) capacitor c=0.00485709f \
 //x=5.92 //y=2.08 //x2=6.66 //y2=2.08
cc_1010 ( N_noxref_4_c_1269_p N_noxref_8_c_2465_n ) capacitor c=0.00190888f \
 //x=5.725 //y=1.915 //x2=6.66 //y2=2.08
cc_1011 ( N_noxref_4_c_1036_n N_noxref_8_c_2466_n ) capacitor c=4.80626e-19 \
 //x=5.92 //y=4.7 //x2=6.69 //y2=4.7
cc_1012 ( N_noxref_4_c_1062_n N_noxref_8_c_2466_n ) capacitor c=0.00397338f \
 //x=5.92 //y=4.7 //x2=6.69 //y2=4.7
cc_1013 ( N_noxref_4_c_1069_n N_noxref_8_c_2466_n ) capacitor c=0.00283894f \
 //x=5.92 //y=4.7 //x2=6.69 //y2=4.7
cc_1014 ( N_noxref_4_M19_noxref_g N_noxref_8_M21_noxref_g ) capacitor \
 c=0.0104892f //x=5.82 //y=6.02 //x2=6.7 //y2=6.02
cc_1015 ( N_noxref_4_M20_noxref_g N_noxref_8_M21_noxref_g ) capacitor \
 c=0.107636f //x=6.26 //y=6.02 //x2=6.7 //y2=6.02
cc_1016 ( N_noxref_4_M20_noxref_g N_noxref_8_M22_noxref_g ) capacitor \
 c=0.0100341f //x=6.26 //y=6.02 //x2=7.14 //y2=6.02
cc_1017 ( N_noxref_4_c_1280_p N_noxref_8_c_2474_n ) capacitor c=4.86545e-19 \
 //x=5.725 //y=0.865 //x2=6.695 //y2=0.905
cc_1018 ( N_noxref_4_c_1281_p N_noxref_8_c_2474_n ) capacitor c=0.00152405f \
 //x=5.725 //y=1.21 //x2=6.695 //y2=0.905
cc_1019 ( N_noxref_4_c_1282_p N_noxref_8_c_2474_n ) capacitor c=0.0151475f \
 //x=6.255 //y=0.865 //x2=6.695 //y2=0.905
cc_1020 ( N_noxref_4_c_1283_p N_noxref_8_c_2476_n ) capacitor c=0.00109982f \
 //x=5.725 //y=1.52 //x2=6.695 //y2=1.25
cc_1021 ( N_noxref_4_c_1284_p N_noxref_8_c_2476_n ) capacitor c=0.0111064f \
 //x=6.255 //y=1.21 //x2=6.695 //y2=1.25
cc_1022 ( N_noxref_4_c_1283_p N_noxref_8_c_2479_n ) capacitor c=9.58243e-19 \
 //x=5.725 //y=1.52 //x2=6.695 //y2=1.56
cc_1023 ( N_noxref_4_c_1269_p N_noxref_8_c_2479_n ) capacitor c=0.00662747f \
 //x=5.725 //y=1.915 //x2=6.695 //y2=1.56
cc_1024 ( N_noxref_4_c_1284_p N_noxref_8_c_2479_n ) capacitor c=0.00862358f \
 //x=6.255 //y=1.21 //x2=6.695 //y2=1.56
cc_1025 ( N_noxref_4_c_1282_p N_noxref_8_c_2489_n ) capacitor c=0.00127211f \
 //x=6.255 //y=0.865 //x2=7.225 //y2=0.905
cc_1026 ( N_noxref_4_c_1284_p N_noxref_8_c_2491_n ) capacitor c=0.00204774f \
 //x=6.255 //y=1.21 //x2=7.225 //y2=1.25
cc_1027 ( N_noxref_4_c_1035_n N_noxref_8_c_2495_n ) capacitor c=0.00167305f \
 //x=5.92 //y=2.08 //x2=6.66 //y2=2.08
cc_1028 ( N_noxref_4_c_1264_p N_noxref_8_c_2495_n ) capacitor c=0.00266443f \
 //x=5.92 //y=2.08 //x2=6.66 //y2=2.08
cc_1029 ( N_noxref_4_c_1269_p N_noxref_8_c_2495_n ) capacitor c=0.0181449f \
 //x=5.725 //y=1.915 //x2=6.66 //y2=2.08
cc_1030 ( N_noxref_4_c_1036_n N_noxref_8_c_2498_n ) capacitor c=0.00158715f \
 //x=5.92 //y=4.7 //x2=6.69 //y2=4.7
cc_1031 ( N_noxref_4_c_1062_n N_noxref_8_c_2498_n ) capacitor c=0.00237977f \
 //x=5.92 //y=4.7 //x2=6.69 //y2=4.7
cc_1032 ( N_noxref_4_c_1069_n N_noxref_8_c_2498_n ) capacitor c=0.0297875f \
 //x=5.92 //y=4.7 //x2=6.69 //y2=4.7
cc_1033 ( N_noxref_4_c_1102_n N_noxref_9_c_2566_n ) capacitor c=0.0607818f \
 //x=15.91 //y=3.545 //x2=16.65 //y2=4.555
cc_1034 ( N_noxref_4_c_1132_p N_noxref_9_c_2566_n ) capacitor c=0.0148501f \
 //x=15.91 //y=3.865 //x2=16.65 //y2=4.555
cc_1035 ( N_noxref_4_c_1298_p N_noxref_9_c_2566_n ) capacitor c=6.89957e-19 \
 //x=15.91 //y=3.7 //x2=16.65 //y2=4.555
cc_1036 ( N_noxref_4_c_1138_p N_noxref_9_c_2566_n ) capacitor c=0.0172863f \
 //x=15.91 //y=4.7 //x2=16.65 //y2=4.555
cc_1037 ( N_noxref_4_c_1110_n N_noxref_9_c_2566_n ) capacitor c=0.027626f \
 //x=15.912 //y=4.56 //x2=16.65 //y2=4.555
cc_1038 ( N_noxref_4_c_1089_n N_noxref_9_c_2566_n ) capacitor c=0.00686853f \
 //x=12.79 //y=3.715 //x2=16.65 //y2=4.555
cc_1039 ( N_noxref_4_c_1302_p N_noxref_9_c_2566_n ) capacitor c=3.49899e-19 \
 //x=15.91 //y=2.08 //x2=16.65 //y2=4.555
cc_1040 ( N_noxref_4_c_1193_p N_noxref_9_c_2566_n ) capacitor c=7.76143e-19 \
 //x=15.91 //y=4.7 //x2=16.65 //y2=4.555
cc_1041 ( N_noxref_4_c_1225_p N_noxref_9_c_2566_n ) capacitor c=0.00201171f \
 //x=15.91 //y=4.7 //x2=16.65 //y2=4.555
cc_1042 ( N_noxref_4_c_1133_p N_noxref_9_c_2575_n ) capacitor c=0.0205342f \
 //x=15.91 //y=2.08 //x2=16.65 //y2=2.08
cc_1043 ( N_noxref_4_c_1302_p N_noxref_9_c_2575_n ) capacitor c=5.16867e-19 \
 //x=15.91 //y=2.08 //x2=16.65 //y2=2.08
cc_1044 ( N_noxref_4_c_1307_p N_noxref_9_c_2575_n ) capacitor c=0.00167888f \
 //x=15.715 //y=1.915 //x2=16.65 //y2=2.08
cc_1045 ( N_noxref_4_c_1102_n N_noxref_9_c_2578_n ) capacitor c=3.49899e-19 \
 //x=15.91 //y=3.545 //x2=16.65 //y2=2.08
cc_1046 ( N_noxref_4_c_1133_p N_noxref_9_c_2578_n ) capacitor c=5.24723e-19 \
 //x=15.91 //y=2.08 //x2=16.65 //y2=2.08
cc_1047 ( N_noxref_4_c_1302_p N_noxref_9_c_2578_n ) capacitor c=0.00525888f \
 //x=15.91 //y=2.08 //x2=16.65 //y2=2.08
cc_1048 ( N_noxref_4_c_1307_p N_noxref_9_c_2578_n ) capacitor c=0.00190888f \
 //x=15.715 //y=1.915 //x2=16.65 //y2=2.08
cc_1049 ( N_noxref_4_c_1138_p N_noxref_9_c_2582_n ) capacitor c=4.80626e-19 \
 //x=15.91 //y=4.7 //x2=16.68 //y2=4.7
cc_1050 ( N_noxref_4_c_1193_p N_noxref_9_c_2582_n ) capacitor c=0.00397338f \
 //x=15.91 //y=4.7 //x2=16.68 //y2=4.7
cc_1051 ( N_noxref_4_c_1225_p N_noxref_9_c_2582_n ) capacitor c=0.00283894f \
 //x=15.91 //y=4.7 //x2=16.68 //y2=4.7
cc_1052 ( N_noxref_4_M31_noxref_g N_noxref_9_M33_noxref_g ) capacitor \
 c=0.0104892f //x=15.81 //y=6.02 //x2=16.69 //y2=6.02
cc_1053 ( N_noxref_4_M32_noxref_g N_noxref_9_M33_noxref_g ) capacitor \
 c=0.107636f //x=16.25 //y=6.02 //x2=16.69 //y2=6.02
cc_1054 ( N_noxref_4_M32_noxref_g N_noxref_9_M34_noxref_g ) capacitor \
 c=0.0100341f //x=16.25 //y=6.02 //x2=17.13 //y2=6.02
cc_1055 ( N_noxref_4_c_1318_p N_noxref_9_c_2588_n ) capacitor c=4.86545e-19 \
 //x=15.715 //y=0.865 //x2=16.685 //y2=0.905
cc_1056 ( N_noxref_4_c_1319_p N_noxref_9_c_2588_n ) capacitor c=0.00152405f \
 //x=15.715 //y=1.21 //x2=16.685 //y2=0.905
cc_1057 ( N_noxref_4_c_1320_p N_noxref_9_c_2588_n ) capacitor c=0.0151475f \
 //x=16.245 //y=0.865 //x2=16.685 //y2=0.905
cc_1058 ( N_noxref_4_c_1321_p N_noxref_9_c_2591_n ) capacitor c=0.00109982f \
 //x=15.715 //y=1.52 //x2=16.685 //y2=1.25
cc_1059 ( N_noxref_4_c_1322_p N_noxref_9_c_2591_n ) capacitor c=0.0111064f \
 //x=16.245 //y=1.21 //x2=16.685 //y2=1.25
cc_1060 ( N_noxref_4_c_1321_p N_noxref_9_c_2593_n ) capacitor c=9.58243e-19 \
 //x=15.715 //y=1.52 //x2=16.685 //y2=1.56
cc_1061 ( N_noxref_4_c_1307_p N_noxref_9_c_2593_n ) capacitor c=0.00662747f \
 //x=15.715 //y=1.915 //x2=16.685 //y2=1.56
cc_1062 ( N_noxref_4_c_1322_p N_noxref_9_c_2593_n ) capacitor c=0.00862358f \
 //x=16.245 //y=1.21 //x2=16.685 //y2=1.56
cc_1063 ( N_noxref_4_c_1320_p N_noxref_9_c_2596_n ) capacitor c=0.00127211f \
 //x=16.245 //y=0.865 //x2=17.215 //y2=0.905
cc_1064 ( N_noxref_4_c_1322_p N_noxref_9_c_2597_n ) capacitor c=0.00204774f \
 //x=16.245 //y=1.21 //x2=17.215 //y2=1.25
cc_1065 ( N_noxref_4_c_1133_p N_noxref_9_c_2598_n ) capacitor c=0.00167305f \
 //x=15.91 //y=2.08 //x2=16.65 //y2=2.08
cc_1066 ( N_noxref_4_c_1302_p N_noxref_9_c_2598_n ) capacitor c=0.0018937f \
 //x=15.91 //y=2.08 //x2=16.65 //y2=2.08
cc_1067 ( N_noxref_4_c_1307_p N_noxref_9_c_2598_n ) capacitor c=0.0181449f \
 //x=15.715 //y=1.915 //x2=16.65 //y2=2.08
cc_1068 ( N_noxref_4_c_1138_p N_noxref_9_c_2601_n ) capacitor c=0.00158715f \
 //x=15.91 //y=4.7 //x2=16.68 //y2=4.7
cc_1069 ( N_noxref_4_c_1193_p N_noxref_9_c_2601_n ) capacitor c=0.00237977f \
 //x=15.91 //y=4.7 //x2=16.68 //y2=4.7
cc_1070 ( N_noxref_4_c_1225_p N_noxref_9_c_2601_n ) capacitor c=0.0297875f \
 //x=15.91 //y=4.7 //x2=16.68 //y2=4.7
cc_1071 ( N_noxref_4_M32_noxref_g N_noxref_10_c_2671_n ) capacitor \
 c=0.00966488f //x=16.25 //y=6.02 //x2=16.795 //y2=5.2
cc_1072 ( N_noxref_4_c_1102_n N_noxref_10_c_2672_n ) capacitor c=0.0039119f \
 //x=15.91 //y=3.545 //x2=17.39 //y2=5.115
cc_1073 ( N_noxref_4_c_1110_n N_noxref_10_c_2672_n ) capacitor c=0.0023234f \
 //x=15.912 //y=4.56 //x2=17.39 //y2=5.115
cc_1074 ( N_noxref_4_c_1132_p N_noxref_10_c_2674_n ) capacitor c=8.193e-19 \
 //x=15.91 //y=3.865 //x2=16.03 //y2=5.38
cc_1075 ( N_noxref_4_c_1138_p N_noxref_10_c_2674_n ) capacitor c=0.0118007f \
 //x=15.91 //y=4.7 //x2=16.03 //y2=5.38
cc_1076 ( N_noxref_4_c_1193_p N_noxref_10_c_2674_n ) capacitor c=0.00277154f \
 //x=15.91 //y=4.7 //x2=16.03 //y2=5.38
cc_1077 ( N_noxref_4_M31_noxref_g N_noxref_10_c_2674_n ) capacitor \
 c=0.00201806f //x=15.81 //y=6.02 //x2=16.03 //y2=5.38
cc_1078 ( N_noxref_4_M32_noxref_g N_noxref_10_c_2674_n ) capacitor \
 c=0.00192712f //x=16.25 //y=6.02 //x2=16.03 //y2=5.38
cc_1079 ( N_noxref_4_c_1225_p N_noxref_10_c_2674_n ) capacitor c=0.00187457f \
 //x=15.91 //y=4.7 //x2=16.03 //y2=5.38
cc_1080 ( N_noxref_4_c_1132_p N_noxref_10_c_2680_n ) capacitor c=2.39213e-19 \
 //x=15.91 //y=3.865 //x2=16.03 //y2=5.38
cc_1081 ( N_noxref_4_c_1138_p N_noxref_10_c_2680_n ) capacitor c=0.00104426f \
 //x=15.91 //y=4.7 //x2=16.03 //y2=5.38
cc_1082 ( N_noxref_4_c_1193_p N_noxref_10_c_2680_n ) capacitor c=0.00377369f \
 //x=15.91 //y=4.7 //x2=16.03 //y2=5.38
cc_1083 ( N_noxref_4_M31_noxref_g N_noxref_10_c_2680_n ) capacitor \
 c=0.0158358f //x=15.81 //y=6.02 //x2=16.03 //y2=5.38
cc_1084 ( N_noxref_4_M32_noxref_g N_noxref_10_c_2680_n ) capacitor \
 c=0.0178987f //x=16.25 //y=6.02 //x2=16.03 //y2=5.38
cc_1085 ( N_noxref_4_c_1225_p N_noxref_10_c_2680_n ) capacitor c=0.0043218f \
 //x=15.91 //y=4.7 //x2=16.03 //y2=5.38
cc_1086 ( N_noxref_4_c_982_n N_noxref_12_c_2906_n ) capacitor c=0.00900212f \
 //x=3.585 //y=1.125 //x2=5.905 //y2=0
cc_1087 ( N_noxref_4_c_997_n N_noxref_12_c_2906_n ) capacitor c=0.00712383f \
 //x=3.985 //y=1.665 //x2=5.905 //y2=0
cc_1088 ( N_noxref_4_c_1015_n N_noxref_12_c_2906_n ) capacitor c=5.12302e-19 \
 //x=4.07 //y=3.86 //x2=5.905 //y2=0
cc_1089 ( N_noxref_4_M2_noxref_d N_noxref_12_c_2906_n ) capacitor \
 c=2.94508e-19 //x=3.395 //y=0.915 //x2=5.905 //y2=0
cc_1090 ( N_noxref_4_c_982_n N_noxref_12_c_2910_n ) capacitor c=0.00488628f \
 //x=3.585 //y=1.125 //x2=5.99 //y2=0.955
cc_1091 ( N_noxref_4_c_1035_n N_noxref_12_c_2910_n ) capacitor c=0.00709452f \
 //x=5.92 //y=2.08 //x2=5.99 //y2=0.955
cc_1092 ( N_noxref_4_c_1264_p N_noxref_12_c_2910_n ) capacitor c=2.13705e-19 \
 //x=5.92 //y=2.08 //x2=5.99 //y2=0.955
cc_1093 ( N_noxref_4_c_1280_p N_noxref_12_c_2910_n ) capacitor c=0.00176535f \
 //x=5.725 //y=0.865 //x2=5.99 //y2=0.955
cc_1094 ( N_noxref_4_c_1281_p N_noxref_12_c_2910_n ) capacitor c=0.0036005f \
 //x=5.725 //y=1.21 //x2=5.99 //y2=0.955
cc_1095 ( N_noxref_4_c_1283_p N_noxref_12_c_2910_n ) capacitor c=4.2764e-19 \
 //x=5.725 //y=1.52 //x2=5.99 //y2=0.955
cc_1096 ( N_noxref_4_c_1359_p N_noxref_12_c_2910_n ) capacitor c=9.36995e-19 \
 //x=6.1 //y=0.71 //x2=5.99 //y2=0.955
cc_1097 ( N_noxref_4_c_1360_p N_noxref_12_c_2910_n ) capacitor c=6.38426e-19 \
 //x=6.1 //y=1.365 //x2=5.99 //y2=0.955
cc_1098 ( N_noxref_4_c_1282_p N_noxref_12_c_2910_n ) capacitor c=0.00171721f \
 //x=6.255 //y=0.865 //x2=5.99 //y2=0.955
cc_1099 ( N_noxref_4_c_1284_p N_noxref_12_c_2910_n ) capacitor c=0.00296337f \
 //x=6.255 //y=1.21 //x2=5.99 //y2=0.955
cc_1100 ( N_noxref_4_c_1280_p N_noxref_12_c_3012_n ) capacitor c=3.51399e-19 \
 //x=5.725 //y=0.865 //x2=5.987 //y2=0.825
cc_1101 ( N_noxref_4_c_1359_p N_noxref_12_c_3012_n ) capacitor c=0.00852028f \
 //x=6.1 //y=0.71 //x2=5.987 //y2=0.825
cc_1102 ( N_noxref_4_c_1282_p N_noxref_12_c_3012_n ) capacitor c=4.40641e-19 \
 //x=6.255 //y=0.865 //x2=5.987 //y2=0.825
cc_1103 ( N_noxref_4_c_1133_p N_noxref_12_c_3015_n ) capacitor c=0.00709452f \
 //x=15.91 //y=2.08 //x2=15.98 //y2=0.955
cc_1104 ( N_noxref_4_c_1302_p N_noxref_12_c_3015_n ) capacitor c=2.13705e-19 \
 //x=15.91 //y=2.08 //x2=15.98 //y2=0.955
cc_1105 ( N_noxref_4_c_1318_p N_noxref_12_c_3015_n ) capacitor c=0.00171023f \
 //x=15.715 //y=0.865 //x2=15.98 //y2=0.955
cc_1106 ( N_noxref_4_c_1319_p N_noxref_12_c_3015_n ) capacitor c=0.00357815f \
 //x=15.715 //y=1.21 //x2=15.98 //y2=0.955
cc_1107 ( N_noxref_4_c_1321_p N_noxref_12_c_3015_n ) capacitor c=4.2764e-19 \
 //x=15.715 //y=1.52 //x2=15.98 //y2=0.955
cc_1108 ( N_noxref_4_c_1371_p N_noxref_12_c_3015_n ) capacitor c=9.36995e-19 \
 //x=16.09 //y=0.71 //x2=15.98 //y2=0.955
cc_1109 ( N_noxref_4_c_1372_p N_noxref_12_c_3015_n ) capacitor c=6.30911e-19 \
 //x=16.09 //y=1.365 //x2=15.98 //y2=0.955
cc_1110 ( N_noxref_4_c_1320_p N_noxref_12_c_3015_n ) capacitor c=0.00171721f \
 //x=16.245 //y=0.865 //x2=15.98 //y2=0.955
cc_1111 ( N_noxref_4_c_1322_p N_noxref_12_c_3015_n ) capacitor c=0.00296337f \
 //x=16.245 //y=1.21 //x2=15.98 //y2=0.955
cc_1112 ( N_noxref_4_c_1318_p N_noxref_12_c_3024_n ) capacitor c=3.46594e-19 \
 //x=15.715 //y=0.865 //x2=15.977 //y2=0.825
cc_1113 ( N_noxref_4_c_1371_p N_noxref_12_c_3024_n ) capacitor c=0.00839621f \
 //x=16.09 //y=0.71 //x2=15.977 //y2=0.825
cc_1114 ( N_noxref_4_c_1320_p N_noxref_12_c_3024_n ) capacitor c=4.40641e-19 \
 //x=16.245 //y=0.865 //x2=15.977 //y2=0.825
cc_1115 ( N_noxref_4_c_997_n N_noxref_12_c_2926_n ) capacitor c=6.86937e-19 \
 //x=3.985 //y=1.665 //x2=4.64 //y2=0
cc_1116 ( N_noxref_4_c_1280_p N_noxref_12_c_2927_n ) capacitor c=0.00685132f \
 //x=5.725 //y=0.865 //x2=7.97 //y2=0
cc_1117 ( N_noxref_4_c_1318_p N_noxref_12_c_3029_n ) capacitor c=0.00685132f \
 //x=15.715 //y=0.865 //x2=17.96 //y2=0
cc_1118 ( N_noxref_4_c_991_n N_noxref_12_c_2930_n ) capacitor c=0.00285697f \
 //x=3.585 //y=1.58 //x2=4.81 //y2=0
cc_1119 ( N_noxref_4_c_997_n N_noxref_12_c_2930_n ) capacitor c=0.0341806f \
 //x=3.985 //y=1.665 //x2=4.81 //y2=0
cc_1120 ( N_noxref_4_c_1021_n N_noxref_12_c_2930_n ) capacitor c=0.00829739f \
 //x=5.92 //y=3.54 //x2=4.81 //y2=0
cc_1121 ( N_noxref_4_c_1035_n N_noxref_12_c_2930_n ) capacitor c=0.00427323f \
 //x=5.92 //y=2.08 //x2=4.81 //y2=0
cc_1122 ( N_noxref_4_c_1264_p N_noxref_12_c_2930_n ) capacitor c=0.00369427f \
 //x=5.92 //y=2.08 //x2=4.81 //y2=0
cc_1123 ( N_noxref_4_c_1283_p N_noxref_12_c_2930_n ) capacitor c=0.0015404f \
 //x=5.725 //y=1.52 //x2=4.81 //y2=0
cc_1124 ( N_noxref_4_c_1269_p N_noxref_12_c_2930_n ) capacitor c=0.0095324f \
 //x=5.725 //y=1.915 //x2=4.81 //y2=0
cc_1125 ( N_noxref_4_c_1102_n N_noxref_12_c_2995_n ) capacitor c=0.00829739f \
 //x=15.91 //y=3.545 //x2=14.8 //y2=0
cc_1126 ( N_noxref_4_c_1133_p N_noxref_12_c_2995_n ) capacitor c=0.00427323f \
 //x=15.91 //y=2.08 //x2=14.8 //y2=0
cc_1127 ( N_noxref_4_c_1089_n N_noxref_12_c_2995_n ) capacitor c=0.00440663f \
 //x=12.79 //y=3.715 //x2=14.8 //y2=0
cc_1128 ( N_noxref_4_c_1302_p N_noxref_12_c_2995_n ) capacitor c=0.0038607f \
 //x=15.91 //y=2.08 //x2=14.8 //y2=0
cc_1129 ( N_noxref_4_c_1321_p N_noxref_12_c_2995_n ) capacitor c=0.0015404f \
 //x=15.715 //y=1.52 //x2=14.8 //y2=0
cc_1130 ( N_noxref_4_c_1307_p N_noxref_12_c_2995_n ) capacitor c=0.00908419f \
 //x=15.715 //y=1.915 //x2=14.8 //y2=0
cc_1131 ( N_noxref_4_c_1035_n N_noxref_12_M3_noxref_d ) capacitor \
 c=2.20438e-19 //x=5.92 //y=2.08 //x2=5.8 //y2=0.865
cc_1132 ( N_noxref_4_c_1280_p N_noxref_12_M3_noxref_d ) capacitor \
 c=0.00192399f //x=5.725 //y=0.865 //x2=5.8 //y2=0.865
cc_1133 ( N_noxref_4_c_1281_p N_noxref_12_M3_noxref_d ) capacitor \
 c=0.00210798f //x=5.725 //y=1.21 //x2=5.8 //y2=0.865
cc_1134 ( N_noxref_4_c_1359_p N_noxref_12_M3_noxref_d ) capacitor \
 c=0.00472259f //x=6.1 //y=0.71 //x2=5.8 //y2=0.865
cc_1135 ( N_noxref_4_c_1360_p N_noxref_12_M3_noxref_d ) capacitor \
 c=0.00166857f //x=6.1 //y=1.365 //x2=5.8 //y2=0.865
cc_1136 ( N_noxref_4_c_1282_p N_noxref_12_M3_noxref_d ) capacitor \
 c=0.00230174f //x=6.255 //y=0.865 //x2=5.8 //y2=0.865
cc_1137 ( N_noxref_4_c_1284_p N_noxref_12_M3_noxref_d ) capacitor \
 c=0.00210798f //x=6.255 //y=1.21 //x2=5.8 //y2=0.865
cc_1138 ( N_noxref_4_c_1133_p N_noxref_12_M9_noxref_d ) capacitor \
 c=2.20438e-19 //x=15.91 //y=2.08 //x2=15.79 //y2=0.865
cc_1139 ( N_noxref_4_c_1318_p N_noxref_12_M9_noxref_d ) capacitor \
 c=0.00192399f //x=15.715 //y=0.865 //x2=15.79 //y2=0.865
cc_1140 ( N_noxref_4_c_1319_p N_noxref_12_M9_noxref_d ) capacitor \
 c=0.00210798f //x=15.715 //y=1.21 //x2=15.79 //y2=0.865
cc_1141 ( N_noxref_4_c_1371_p N_noxref_12_M9_noxref_d ) capacitor \
 c=0.00472259f //x=16.09 //y=0.71 //x2=15.79 //y2=0.865
cc_1142 ( N_noxref_4_c_1372_p N_noxref_12_M9_noxref_d ) capacitor \
 c=0.00166857f //x=16.09 //y=1.365 //x2=15.79 //y2=0.865
cc_1143 ( N_noxref_4_c_1320_p N_noxref_12_M9_noxref_d ) capacitor \
 c=0.00230174f //x=16.245 //y=0.865 //x2=15.79 //y2=0.865
cc_1144 ( N_noxref_4_c_1322_p N_noxref_12_M9_noxref_d ) capacitor \
 c=0.00210798f //x=16.245 //y=1.21 //x2=15.79 //y2=0.865
cc_1145 ( N_noxref_4_c_1269_p N_noxref_15_c_3494_n ) capacitor c=0.00262672f \
 //x=5.725 //y=1.915 //x2=5.505 //y2=1.495
cc_1146 ( N_noxref_4_c_1026_n N_noxref_15_c_3495_n ) capacitor c=0.00361134f \
 //x=5.92 //y=3.86 //x2=6.39 //y2=1.58
cc_1147 ( N_noxref_4_c_1035_n N_noxref_15_c_3495_n ) capacitor c=0.00509504f \
 //x=5.92 //y=2.08 //x2=6.39 //y2=1.58
cc_1148 ( N_noxref_4_c_1264_p N_noxref_15_c_3495_n ) capacitor c=0.00763108f \
 //x=5.92 //y=2.08 //x2=6.39 //y2=1.58
cc_1149 ( N_noxref_4_c_1283_p N_noxref_15_c_3495_n ) capacitor c=0.00697076f \
 //x=5.725 //y=1.52 //x2=6.39 //y2=1.58
cc_1150 ( N_noxref_4_c_1269_p N_noxref_15_c_3495_n ) capacitor c=0.0182994f \
 //x=5.725 //y=1.915 //x2=6.39 //y2=1.58
cc_1151 ( N_noxref_4_c_1360_p N_noxref_15_c_3495_n ) capacitor c=0.00723574f \
 //x=6.1 //y=1.365 //x2=6.39 //y2=1.58
cc_1152 ( N_noxref_4_c_1284_p N_noxref_15_c_3495_n ) capacitor c=0.00339872f \
 //x=6.255 //y=1.21 //x2=6.39 //y2=1.58
cc_1153 ( N_noxref_4_c_1269_p N_noxref_15_c_3497_n ) capacitor c=6.71402e-19 \
 //x=5.725 //y=1.915 //x2=6.475 //y2=1.495
cc_1154 ( N_noxref_4_c_1280_p N_noxref_15_M3_noxref_s ) capacitor c=0.0295366f \
 //x=5.725 //y=0.865 //x2=5.37 //y2=0.365
cc_1155 ( N_noxref_4_c_1283_p N_noxref_15_M3_noxref_s ) capacitor \
 c=3.48408e-19 //x=5.725 //y=1.52 //x2=5.37 //y2=0.365
cc_1156 ( N_noxref_4_c_1282_p N_noxref_15_M3_noxref_s ) capacitor c=0.0125442f \
 //x=6.255 //y=0.865 //x2=5.37 //y2=0.365
cc_1157 ( N_noxref_4_c_1055_n N_noxref_16_c_3562_n ) capacitor c=0.00399388f \
 //x=9.46 //y=3.71 //x2=9.72 //y2=1.58
cc_1158 ( N_noxref_4_c_1055_n N_noxref_16_c_3570_n ) capacitor c=0.00176186f \
 //x=9.46 //y=3.71 //x2=9.805 //y2=1.495
cc_1159 ( N_noxref_4_c_1089_n N_noxref_17_c_3630_n ) capacitor c=0.00398838f \
 //x=12.79 //y=3.715 //x2=13.05 //y2=1.58
cc_1160 ( N_noxref_4_c_1089_n N_noxref_17_c_3638_n ) capacitor c=0.0019353f \
 //x=12.79 //y=3.715 //x2=13.135 //y2=1.495
cc_1161 ( N_noxref_4_c_1089_n N_noxref_18_c_3694_n ) capacitor c=0.00214296f \
 //x=12.79 //y=3.715 //x2=15.495 //y2=1.495
cc_1162 ( N_noxref_4_c_1307_p N_noxref_18_c_3694_n ) capacitor c=0.00262672f \
 //x=15.715 //y=1.915 //x2=15.495 //y2=1.495
cc_1163 ( N_noxref_4_c_1132_p N_noxref_18_c_3696_n ) capacitor c=0.00364314f \
 //x=15.91 //y=3.865 //x2=16.38 //y2=1.58
cc_1164 ( N_noxref_4_c_1133_p N_noxref_18_c_3696_n ) capacitor c=0.00509504f \
 //x=15.91 //y=2.08 //x2=16.38 //y2=1.58
cc_1165 ( N_noxref_4_c_1089_n N_noxref_18_c_3696_n ) capacitor c=0.00120647f \
 //x=12.79 //y=3.715 //x2=16.38 //y2=1.58
cc_1166 ( N_noxref_4_c_1302_p N_noxref_18_c_3696_n ) capacitor c=0.00763108f \
 //x=15.91 //y=2.08 //x2=16.38 //y2=1.58
cc_1167 ( N_noxref_4_c_1321_p N_noxref_18_c_3696_n ) capacitor c=0.00697076f \
 //x=15.715 //y=1.52 //x2=16.38 //y2=1.58
cc_1168 ( N_noxref_4_c_1307_p N_noxref_18_c_3696_n ) capacitor c=0.0184249f \
 //x=15.715 //y=1.915 //x2=16.38 //y2=1.58
cc_1169 ( N_noxref_4_c_1372_p N_noxref_18_c_3696_n ) capacitor c=0.00723574f \
 //x=16.09 //y=1.365 //x2=16.38 //y2=1.58
cc_1170 ( N_noxref_4_c_1322_p N_noxref_18_c_3696_n ) capacitor c=0.00399755f \
 //x=16.245 //y=1.21 //x2=16.38 //y2=1.58
cc_1171 ( N_noxref_4_c_1307_p N_noxref_18_c_3704_n ) capacitor c=6.71402e-19 \
 //x=15.715 //y=1.915 //x2=16.465 //y2=1.495
cc_1172 ( N_noxref_4_c_1318_p N_noxref_18_M9_noxref_s ) capacitor c=0.0294925f \
 //x=15.715 //y=0.865 //x2=15.36 //y2=0.365
cc_1173 ( N_noxref_4_c_1321_p N_noxref_18_M9_noxref_s ) capacitor \
 c=3.48408e-19 //x=15.715 //y=1.52 //x2=15.36 //y2=0.365
cc_1174 ( N_noxref_4_c_1320_p N_noxref_18_M9_noxref_s ) capacitor c=0.0125442f \
 //x=16.245 //y=0.865 //x2=15.36 //y2=0.365
cc_1175 ( N_noxref_5_c_1577_n N_noxref_6_c_2010_n ) capacitor c=3.70734e-19 \
 //x=1.11 //y=4.235 //x2=21.09 //y2=7.4
cc_1176 ( N_noxref_5_c_1508_n N_noxref_6_c_2010_n ) capacitor c=0.00647553f \
 //x=13.465 //y=5.2 //x2=21.09 //y2=7.4
cc_1177 ( N_noxref_5_c_1597_n N_noxref_6_c_2010_n ) capacitor c=0.00491433f \
 //x=13.975 //y=5.2 //x2=21.09 //y2=7.4
cc_1178 ( N_noxref_5_c_1518_n N_noxref_6_c_2010_n ) capacitor c=0.00368144f \
 //x=12.7 //y=5.38 //x2=21.09 //y2=7.4
cc_1179 ( N_noxref_5_c_1614_n N_noxref_6_c_2010_n ) capacitor c=8.41034e-19 \
 //x=13.58 //y=5.2 //x2=21.09 //y2=7.4
cc_1180 ( N_noxref_5_c_1731_p N_noxref_6_c_2010_n ) capacitor c=0.00285294f \
 //x=13.58 //y=5.38 //x2=21.09 //y2=7.4
cc_1181 ( N_noxref_5_c_1623_n N_noxref_6_c_2010_n ) capacitor c=3.85299e-19 \
 //x=14.06 //y=4.07 //x2=21.09 //y2=7.4
cc_1182 ( N_noxref_5_c_1535_n N_noxref_6_c_2010_n ) capacitor c=0.00224727f \
 //x=12.7 //y=5.38 //x2=21.09 //y2=7.4
cc_1183 ( N_noxref_5_c_1644_n N_noxref_6_c_2010_n ) capacitor c=0.00224727f \
 //x=13.58 //y=5.38 //x2=21.09 //y2=7.4
cc_1184 ( N_noxref_5_c_1577_n N_noxref_6_c_2117_n ) capacitor c=0.00179679f \
 //x=1.11 //y=4.235 //x2=0.74 //y2=7.4
cc_1185 ( N_noxref_5_c_1440_n N_noxref_6_c_2117_n ) capacitor c=0.0158335f \
 //x=1.11 //y=4.575 //x2=0.74 //y2=7.4
cc_1186 ( N_noxref_5_c_1612_n N_noxref_6_c_2117_n ) capacitor c=0.00229699f \
 //x=1.11 //y=4.07 //x2=0.74 //y2=7.4
cc_1187 ( N_noxref_5_c_1641_n N_noxref_6_c_2117_n ) capacitor c=0.00371026f \
 //x=1.11 //y=4.7 //x2=0.74 //y2=7.4
cc_1188 ( N_noxref_5_c_1665_n N_noxref_6_c_2117_n ) capacitor c=0.00587308f \
 //x=1.385 //y=4.79 //x2=0.74 //y2=7.4
cc_1189 ( N_noxref_5_c_1577_n N_noxref_6_c_2155_n ) capacitor c=3.2435e-19 \
 //x=1.11 //y=4.235 //x2=1.885 //y2=7.4
cc_1190 ( N_noxref_5_M13_noxref_g N_noxref_6_c_2155_n ) capacitor \
 c=0.00749687f //x=1.31 //y=6.02 //x2=1.885 //y2=7.4
cc_1191 ( N_noxref_5_M14_noxref_g N_noxref_6_c_2155_n ) capacitor \
 c=0.00749619f //x=1.75 //y=6.02 //x2=1.885 //y2=7.4
cc_1192 ( N_noxref_5_M25_noxref_g N_noxref_6_c_2080_n ) capacitor \
 c=0.00692597f //x=10.03 //y=6.02 //x2=10.605 //y2=7.4
cc_1193 ( N_noxref_5_M26_noxref_g N_noxref_6_c_2080_n ) capacitor \
 c=0.00749619f //x=10.47 //y=6.02 //x2=10.605 //y2=7.4
cc_1194 ( N_noxref_5_c_1508_n N_noxref_6_c_2085_n ) capacitor c=0.00208112f \
 //x=13.465 //y=5.2 //x2=13.055 //y2=7.4
cc_1195 ( N_noxref_5_c_1518_n N_noxref_6_c_2085_n ) capacitor c=9.41091e-19 \
 //x=12.7 //y=5.38 //x2=13.055 //y2=7.4
cc_1196 ( N_noxref_5_c_1535_n N_noxref_6_c_2085_n ) capacitor c=0.0136475f \
 //x=12.7 //y=5.38 //x2=13.055 //y2=7.4
cc_1197 ( N_noxref_5_c_1508_n N_noxref_6_c_2120_n ) capacitor c=0.00180744f \
 //x=13.465 //y=5.2 //x2=13.935 //y2=7.4
cc_1198 ( N_noxref_5_c_1597_n N_noxref_6_c_2120_n ) capacitor c=0.00208112f \
 //x=13.975 //y=5.2 //x2=13.935 //y2=7.4
cc_1199 ( N_noxref_5_c_1614_n N_noxref_6_c_2120_n ) capacitor c=4.23323e-19 \
 //x=13.58 //y=5.2 //x2=13.935 //y2=7.4
cc_1200 ( N_noxref_5_c_1731_p N_noxref_6_c_2120_n ) capacitor c=5.78261e-19 \
 //x=13.58 //y=5.38 //x2=13.935 //y2=7.4
cc_1201 ( N_noxref_5_c_1644_n N_noxref_6_c_2120_n ) capacitor c=0.0136475f \
 //x=13.58 //y=5.38 //x2=13.935 //y2=7.4
cc_1202 ( N_noxref_5_M37_noxref_g N_noxref_6_c_2231_n ) capacitor \
 c=0.00692597f //x=20.02 //y=6.02 //x2=20.595 //y2=7.4
cc_1203 ( N_noxref_5_M38_noxref_g N_noxref_6_c_2231_n ) capacitor \
 c=0.00749619f //x=20.46 //y=6.02 //x2=20.595 //y2=7.4
cc_1204 ( N_noxref_5_c_1755_p N_noxref_6_c_2233_n ) capacitor c=0.00143077f \
 //x=19.98 //y=4.07 //x2=21.09 //y2=7.4
cc_1205 ( N_noxref_5_c_1756_p N_noxref_6_c_2233_n ) capacitor c=0.00226427f \
 //x=20.01 //y=4.7 //x2=21.09 //y2=7.4
cc_1206 ( N_noxref_5_c_1757_p N_noxref_6_c_2233_n ) capacitor c=0.0237963f \
 //x=20.385 //y=4.79 //x2=21.09 //y2=7.4
cc_1207 ( N_noxref_5_c_1758_p N_noxref_6_c_2233_n ) capacitor c=2.73429e-19 \
 //x=20.01 //y=4.7 //x2=21.09 //y2=7.4
cc_1208 ( N_noxref_5_c_1463_n N_noxref_6_c_2033_n ) capacitor c=3.90041e-19 \
 //x=4.285 //y=4.085 //x2=4.81 //y2=7.4
cc_1209 ( N_noxref_5_c_1464_n N_noxref_6_c_2033_n ) capacitor c=0.00904116f \
 //x=5.53 //y=4.07 //x2=4.81 //y2=7.4
cc_1210 ( N_noxref_5_c_1455_n N_noxref_6_c_2038_n ) capacitor c=8.50173e-19 \
 //x=9.99 //y=4.07 //x2=8.14 //y2=7.4
cc_1211 ( N_noxref_5_c_1466_n N_noxref_6_c_2038_n ) capacitor c=0.0087315f \
 //x=10.155 //y=4.07 //x2=8.14 //y2=7.4
cc_1212 ( N_noxref_5_c_1514_n N_noxref_6_c_2091_n ) capacitor c=0.0013228f \
 //x=14.06 //y=5.115 //x2=11.47 //y2=7.4
cc_1213 ( N_noxref_5_c_1455_n N_noxref_6_c_2091_n ) capacitor c=0.00133985f \
 //x=9.99 //y=4.07 //x2=11.47 //y2=7.4
cc_1214 ( N_noxref_5_c_1518_n N_noxref_6_c_2091_n ) capacitor c=4.91377e-19 \
 //x=12.7 //y=5.38 //x2=11.47 //y2=7.4
cc_1215 ( N_noxref_5_c_1623_n N_noxref_6_c_2091_n ) capacitor c=4.55587e-19 \
 //x=14.06 //y=4.07 //x2=11.47 //y2=7.4
cc_1216 ( N_noxref_5_c_1528_n N_noxref_6_c_2091_n ) capacitor c=0.0086272f \
 //x=13.89 //y=4.07 //x2=11.47 //y2=7.4
cc_1217 ( N_noxref_5_c_1474_n N_noxref_6_c_2091_n ) capacitor c=0.00233202f \
 //x=10.02 //y=4.7 //x2=11.47 //y2=7.4
cc_1218 ( N_noxref_5_c_1535_n N_noxref_6_c_2091_n ) capacitor c=0.0064135f \
 //x=12.7 //y=5.38 //x2=11.47 //y2=7.4
cc_1219 ( N_noxref_5_c_1552_n N_noxref_6_c_2091_n ) capacitor c=0.0129149f \
 //x=10.395 //y=4.79 //x2=11.47 //y2=7.4
cc_1220 ( N_noxref_5_c_1605_n N_noxref_6_c_2126_n ) capacitor c=0.00197635f \
 //x=14.06 //y=4.245 //x2=14.8 //y2=7.4
cc_1221 ( N_noxref_5_c_1514_n N_noxref_6_c_2126_n ) capacitor c=0.0275831f \
 //x=14.06 //y=5.115 //x2=14.8 //y2=7.4
cc_1222 ( N_noxref_5_c_1614_n N_noxref_6_c_2126_n ) capacitor c=0.00240948f \
 //x=13.58 //y=5.2 //x2=14.8 //y2=7.4
cc_1223 ( N_noxref_5_c_1731_p N_noxref_6_c_2126_n ) capacitor c=4.09141e-19 \
 //x=13.58 //y=5.38 //x2=14.8 //y2=7.4
cc_1224 ( N_noxref_5_c_1623_n N_noxref_6_c_2126_n ) capacitor c=0.00494039f \
 //x=14.06 //y=4.07 //x2=14.8 //y2=7.4
cc_1225 ( N_noxref_5_c_1635_n N_noxref_6_c_2126_n ) capacitor c=0.0195658f \
 //x=15.78 //y=4.09 //x2=14.8 //y2=7.4
cc_1226 ( N_noxref_5_c_1644_n N_noxref_6_c_2126_n ) capacitor c=0.0101861f \
 //x=13.58 //y=5.38 //x2=14.8 //y2=7.4
cc_1227 ( N_noxref_5_c_1755_p N_noxref_6_c_2256_n ) capacitor c=8.4651e-19 \
 //x=19.98 //y=4.07 //x2=18.13 //y2=7.4
cc_1228 ( N_noxref_5_c_1713_n N_noxref_6_c_2256_n ) capacitor c=0.0194224f \
 //x=16.125 //y=4.09 //x2=18.13 //y2=7.4
cc_1229 ( N_noxref_5_c_1577_n N_noxref_6_M13_noxref_s ) capacitor c=9.6101e-19 \
 //x=1.11 //y=4.235 //x2=0.955 //y2=5.02
cc_1230 ( N_noxref_5_c_1440_n N_noxref_6_M13_noxref_s ) capacitor c=0.0223568f \
 //x=1.11 //y=4.575 //x2=0.955 //y2=5.02
cc_1231 ( N_noxref_5_c_1636_n N_noxref_6_M13_noxref_s ) capacitor \
 c=4.27239e-19 //x=1.275 //y=4.075 //x2=0.955 //y2=5.02
cc_1232 ( N_noxref_5_c_1641_n N_noxref_6_M13_noxref_s ) capacitor \
 c=0.00911304f //x=1.11 //y=4.7 //x2=0.955 //y2=5.02
cc_1233 ( N_noxref_5_M13_noxref_g N_noxref_6_M13_noxref_s ) capacitor \
 c=0.053419f //x=1.31 //y=6.02 //x2=0.955 //y2=5.02
cc_1234 ( N_noxref_5_c_1665_n N_noxref_6_M13_noxref_s ) capacitor \
 c=0.00597641f //x=1.385 //y=4.79 //x2=0.955 //y2=5.02
cc_1235 ( N_noxref_5_M14_noxref_g N_noxref_6_M14_noxref_d ) capacitor \
 c=0.015318f //x=1.75 //y=6.02 //x2=1.825 //y2=5.02
cc_1236 ( N_noxref_5_M25_noxref_g N_noxref_6_M24_noxref_d ) capacitor \
 c=0.015318f //x=10.03 //y=6.02 //x2=9.665 //y2=5.02
cc_1237 ( N_noxref_5_c_1493_n N_noxref_6_M24_noxref_d ) capacitor \
 c=3.50187e-19 //x=10.02 //y=4.7 //x2=9.665 //y2=5.02
cc_1238 ( N_noxref_5_M26_noxref_g N_noxref_6_M26_noxref_d ) capacitor \
 c=0.0430452f //x=10.47 //y=6.02 //x2=10.545 //y2=5.02
cc_1239 ( N_noxref_5_c_1518_n N_noxref_6_M27_noxref_s ) capacitor c=0.0572211f \
 //x=12.7 //y=5.38 //x2=12.125 //y2=5.02
cc_1240 ( N_noxref_5_c_1614_n N_noxref_6_M27_noxref_s ) capacitor \
 c=6.52457e-19 //x=13.58 //y=5.2 //x2=12.125 //y2=5.02
cc_1241 ( N_noxref_5_c_1535_n N_noxref_6_M27_noxref_s ) capacitor c=0.0887533f \
 //x=12.7 //y=5.38 //x2=12.125 //y2=5.02
cc_1242 ( N_noxref_5_c_1508_n N_noxref_6_M28_noxref_d ) capacitor \
 c=0.00734028f //x=13.465 //y=5.2 //x2=12.995 //y2=5.02
cc_1243 ( N_noxref_5_c_1518_n N_noxref_6_M28_noxref_d ) capacitor c=0.0043528f \
 //x=12.7 //y=5.38 //x2=12.995 //y2=5.02
cc_1244 ( N_noxref_5_c_1731_p N_noxref_6_M28_noxref_d ) capacitor c=0.0043528f \
 //x=13.58 //y=5.38 //x2=12.995 //y2=5.02
cc_1245 ( N_noxref_5_c_1535_n N_noxref_6_M28_noxref_d ) capacitor c=0.065554f \
 //x=12.7 //y=5.38 //x2=12.995 //y2=5.02
cc_1246 ( N_noxref_5_c_1644_n N_noxref_6_M28_noxref_d ) capacitor c=0.065554f \
 //x=13.58 //y=5.38 //x2=12.995 //y2=5.02
cc_1247 ( N_noxref_5_c_1597_n N_noxref_6_M30_noxref_d ) capacitor \
 c=0.00852088f //x=13.975 //y=5.2 //x2=13.875 //y2=5.02
cc_1248 ( N_noxref_5_c_1731_p N_noxref_6_M30_noxref_d ) capacitor \
 c=0.00587834f //x=13.58 //y=5.38 //x2=13.875 //y2=5.02
cc_1249 ( N_noxref_5_c_1623_n N_noxref_6_M30_noxref_d ) capacitor c=0.0016716f \
 //x=14.06 //y=4.07 //x2=13.875 //y2=5.02
cc_1250 ( N_noxref_5_c_1644_n N_noxref_6_M30_noxref_d ) capacitor c=0.065554f \
 //x=13.58 //y=5.38 //x2=13.875 //y2=5.02
cc_1251 ( N_noxref_5_c_1597_n N_noxref_6_M31_noxref_s ) capacitor \
 c=0.00326953f //x=13.975 //y=5.2 //x2=15.455 //y2=5.02
cc_1252 ( N_noxref_5_c_1614_n N_noxref_6_M31_noxref_s ) capacitor \
 c=0.00515461f //x=13.58 //y=5.2 //x2=15.455 //y2=5.02
cc_1253 ( N_noxref_5_c_1731_p N_noxref_6_M31_noxref_s ) capacitor \
 c=3.28075e-19 //x=13.58 //y=5.38 //x2=15.455 //y2=5.02
cc_1254 ( N_noxref_5_c_1635_n N_noxref_6_M31_noxref_s ) capacitor \
 c=0.00546936f //x=15.78 //y=4.09 //x2=15.455 //y2=5.02
cc_1255 ( N_noxref_5_c_1713_n N_noxref_6_M35_noxref_s ) capacitor \
 c=0.00623384f //x=16.125 //y=4.09 //x2=18.785 //y2=5.02
cc_1256 ( N_noxref_5_M37_noxref_g N_noxref_6_M36_noxref_d ) capacitor \
 c=0.015318f //x=20.02 //y=6.02 //x2=19.655 //y2=5.02
cc_1257 ( N_noxref_5_c_1758_p N_noxref_6_M36_noxref_d ) capacitor \
 c=3.50187e-19 //x=20.01 //y=4.7 //x2=19.655 //y2=5.02
cc_1258 ( N_noxref_5_M38_noxref_g N_noxref_6_M38_noxref_d ) capacitor \
 c=0.0430452f //x=20.46 //y=6.02 //x2=20.535 //y2=5.02
cc_1259 ( N_noxref_5_c_1466_n N_noxref_8_c_2455_n ) capacitor c=0.0209367f \
 //x=10.155 //y=4.07 //x2=6.66 //y2=4.555
cc_1260 ( N_noxref_5_c_1511_n N_noxref_9_c_2566_n ) capacitor c=0.00354611f \
 //x=14.06 //y=3.925 //x2=16.65 //y2=4.555
cc_1261 ( N_noxref_5_c_1514_n N_noxref_9_c_2566_n ) capacitor c=0.00130218f \
 //x=14.06 //y=5.115 //x2=16.65 //y2=4.555
cc_1262 ( N_noxref_5_c_1713_n N_noxref_9_c_2566_n ) capacitor c=0.0342429f \
 //x=16.125 //y=4.09 //x2=16.65 //y2=4.555
cc_1263 ( N_noxref_5_c_1713_n N_noxref_9_c_2575_n ) capacitor c=0.00168937f \
 //x=16.125 //y=4.09 //x2=16.65 //y2=2.08
cc_1264 ( N_noxref_5_c_1713_n N_noxref_10_c_2671_n ) capacitor c=0.0124994f \
 //x=16.125 //y=4.09 //x2=16.795 //y2=5.2
cc_1265 ( N_noxref_5_c_1509_n N_noxref_10_c_2687_n ) capacitor c=0.00324213f \
 //x=13.62 //y=1.57 //x2=16.95 //y2=1.57
cc_1266 ( N_noxref_5_c_1598_n N_noxref_10_c_2688_n ) capacitor c=0.00231467f \
 //x=13.975 //y=1.655 //x2=17.035 //y2=1.655
cc_1267 ( N_noxref_5_c_1514_n N_noxref_10_c_2672_n ) capacitor c=9.42509e-19 \
 //x=14.06 //y=5.115 //x2=17.39 //y2=5.115
cc_1268 ( N_noxref_5_c_1819_p N_noxref_10_c_2672_n ) capacitor c=0.00289995f \
 //x=19.98 //y=3.91 //x2=17.39 //y2=5.115
cc_1269 ( N_noxref_5_c_1820_p N_noxref_10_c_2672_n ) capacitor c=0.00134252f \
 //x=19.98 //y=4.555 //x2=17.39 //y2=5.115
cc_1270 ( N_noxref_5_c_1713_n N_noxref_10_c_2672_n ) capacitor c=0.0360574f \
 //x=16.125 //y=4.09 //x2=17.39 //y2=5.115
cc_1271 ( N_noxref_5_c_1597_n N_noxref_10_c_2674_n ) capacitor c=0.00114153f \
 //x=13.975 //y=5.2 //x2=16.03 //y2=5.38
cc_1272 ( N_noxref_5_c_1614_n N_noxref_10_c_2674_n ) capacitor c=5.29822e-19 \
 //x=13.58 //y=5.2 //x2=16.03 //y2=5.38
cc_1273 ( N_noxref_5_c_1731_p N_noxref_10_c_2674_n ) capacitor c=0.00147119f \
 //x=13.58 //y=5.38 //x2=16.03 //y2=5.38
cc_1274 ( N_noxref_5_c_1713_n N_noxref_10_c_2674_n ) capacitor c=0.00584757f \
 //x=16.125 //y=4.09 //x2=16.03 //y2=5.38
cc_1275 ( N_noxref_5_c_1713_n N_noxref_10_c_2697_n ) capacitor c=0.0158953f \
 //x=16.125 //y=4.09 //x2=16.91 //y2=5.2
cc_1276 ( N_noxref_5_c_1527_n N_noxref_10_c_2698_n ) capacitor c=6.99317e-19 \
 //x=13.62 //y=1 //x2=16.95 //y2=1
cc_1277 ( N_noxref_5_c_1828_p N_noxref_11_c_2803_n ) capacitor c=0.0205342f \
 //x=19.98 //y=2.08 //x2=19.24 //y2=2.08
cc_1278 ( N_noxref_5_c_1713_n N_noxref_11_c_2803_n ) capacitor c=0.00180283f \
 //x=16.125 //y=4.09 //x2=19.24 //y2=2.08
cc_1279 ( N_noxref_5_c_1830_p N_noxref_11_c_2803_n ) capacitor c=5.24723e-19 \
 //x=19.98 //y=2.08 //x2=19.24 //y2=2.08
cc_1280 ( N_noxref_5_c_1831_p N_noxref_11_c_2803_n ) capacitor c=0.00167305f \
 //x=19.98 //y=2.08 //x2=19.24 //y2=2.08
cc_1281 ( N_noxref_5_c_1820_p N_noxref_11_c_2807_n ) capacitor c=0.0172958f \
 //x=19.98 //y=4.555 //x2=19.24 //y2=4.7
cc_1282 ( N_noxref_5_c_1713_n N_noxref_11_c_2807_n ) capacitor c=0.00370655f \
 //x=16.125 //y=4.09 //x2=19.24 //y2=4.7
cc_1283 ( N_noxref_5_c_1756_p N_noxref_11_c_2807_n ) capacitor c=4.80626e-19 \
 //x=20.01 //y=4.7 //x2=19.24 //y2=4.7
cc_1284 ( N_noxref_5_c_1758_p N_noxref_11_c_2807_n ) capacitor c=0.00158715f \
 //x=20.01 //y=4.7 //x2=19.24 //y2=4.7
cc_1285 ( N_noxref_5_c_1819_p N_noxref_11_c_2811_n ) capacitor c=0.0782814f \
 //x=19.98 //y=3.91 //x2=19.242 //y2=4.56
cc_1286 ( N_noxref_5_c_1837_p N_noxref_11_c_2811_n ) capacitor c=0.0173413f \
 //x=19.98 //y=4.23 //x2=19.242 //y2=4.56
cc_1287 ( N_noxref_5_c_1820_p N_noxref_11_c_2811_n ) capacitor c=0.0138018f \
 //x=19.98 //y=4.555 //x2=19.242 //y2=4.56
cc_1288 ( N_noxref_5_c_1755_p N_noxref_11_c_2811_n ) capacitor c=6.16997e-19 \
 //x=19.98 //y=4.07 //x2=19.242 //y2=4.56
cc_1289 ( N_noxref_5_c_1713_n N_noxref_11_c_2811_n ) capacitor c=0.0353317f \
 //x=16.125 //y=4.09 //x2=19.242 //y2=4.56
cc_1290 ( N_noxref_5_c_1830_p N_noxref_11_c_2811_n ) capacitor c=3.49899e-19 \
 //x=19.98 //y=2.08 //x2=19.242 //y2=4.56
cc_1291 ( N_noxref_5_c_1819_p N_noxref_11_c_2817_n ) capacitor c=3.49899e-19 \
 //x=19.98 //y=3.91 //x2=19.24 //y2=2.08
cc_1292 ( N_noxref_5_c_1828_p N_noxref_11_c_2817_n ) capacitor c=5.16867e-19 \
 //x=19.98 //y=2.08 //x2=19.24 //y2=2.08
cc_1293 ( N_noxref_5_c_1830_p N_noxref_11_c_2817_n ) capacitor c=0.00445529f \
 //x=19.98 //y=2.08 //x2=19.24 //y2=2.08
cc_1294 ( N_noxref_5_c_1831_p N_noxref_11_c_2817_n ) capacitor c=0.00266443f \
 //x=19.98 //y=2.08 //x2=19.24 //y2=2.08
cc_1295 ( N_noxref_5_c_1820_p N_noxref_11_c_2821_n ) capacitor c=7.76099e-19 \
 //x=19.98 //y=4.555 //x2=19.24 //y2=4.7
cc_1296 ( N_noxref_5_c_1756_p N_noxref_11_c_2821_n ) capacitor c=0.00397338f \
 //x=20.01 //y=4.7 //x2=19.24 //y2=4.7
cc_1297 ( N_noxref_5_c_1758_p N_noxref_11_c_2821_n ) capacitor c=0.00237977f \
 //x=20.01 //y=4.7 //x2=19.24 //y2=4.7
cc_1298 ( N_noxref_5_M37_noxref_g N_noxref_11_M35_noxref_g ) capacitor \
 c=0.0104892f //x=20.02 //y=6.02 //x2=19.14 //y2=6.02
cc_1299 ( N_noxref_5_M37_noxref_g N_noxref_11_M36_noxref_g ) capacitor \
 c=0.107636f //x=20.02 //y=6.02 //x2=19.58 //y2=6.02
cc_1300 ( N_noxref_5_M38_noxref_g N_noxref_11_M36_noxref_g ) capacitor \
 c=0.0100341f //x=20.46 //y=6.02 //x2=19.58 //y2=6.02
cc_1301 ( N_noxref_5_c_1852_p N_noxref_11_c_2827_n ) capacitor c=4.86545e-19 \
 //x=20.015 //y=0.905 //x2=19.045 //y2=0.865
cc_1302 ( N_noxref_5_c_1852_p N_noxref_11_c_2828_n ) capacitor c=0.00152405f \
 //x=20.015 //y=0.905 //x2=19.045 //y2=1.21
cc_1303 ( N_noxref_5_c_1854_p N_noxref_11_c_2829_n ) capacitor c=0.00109982f \
 //x=20.015 //y=1.25 //x2=19.045 //y2=1.52
cc_1304 ( N_noxref_5_c_1855_p N_noxref_11_c_2829_n ) capacitor c=9.58243e-19 \
 //x=20.015 //y=1.56 //x2=19.045 //y2=1.52
cc_1305 ( N_noxref_5_c_1828_p N_noxref_11_c_2831_n ) capacitor c=0.00167888f \
 //x=19.98 //y=2.08 //x2=19.045 //y2=1.915
cc_1306 ( N_noxref_5_c_1830_p N_noxref_11_c_2831_n ) capacitor c=0.00267961f \
 //x=19.98 //y=2.08 //x2=19.045 //y2=1.915
cc_1307 ( N_noxref_5_c_1855_p N_noxref_11_c_2831_n ) capacitor c=0.00662747f \
 //x=20.015 //y=1.56 //x2=19.045 //y2=1.915
cc_1308 ( N_noxref_5_c_1831_p N_noxref_11_c_2831_n ) capacitor c=0.0181449f \
 //x=19.98 //y=2.08 //x2=19.045 //y2=1.915
cc_1309 ( N_noxref_5_c_1852_p N_noxref_11_c_2835_n ) capacitor c=0.0151475f \
 //x=20.015 //y=0.905 //x2=19.575 //y2=0.865
cc_1310 ( N_noxref_5_c_1861_p N_noxref_11_c_2835_n ) capacitor c=0.00127211f \
 //x=20.545 //y=0.905 //x2=19.575 //y2=0.865
cc_1311 ( N_noxref_5_c_1854_p N_noxref_11_c_2837_n ) capacitor c=0.0111064f \
 //x=20.015 //y=1.25 //x2=19.575 //y2=1.21
cc_1312 ( N_noxref_5_c_1855_p N_noxref_11_c_2837_n ) capacitor c=0.00862358f \
 //x=20.015 //y=1.56 //x2=19.575 //y2=1.21
cc_1313 ( N_noxref_5_c_1864_p N_noxref_11_c_2837_n ) capacitor c=0.00204774f \
 //x=20.545 //y=1.25 //x2=19.575 //y2=1.21
cc_1314 ( N_noxref_5_c_1820_p N_noxref_11_c_2840_n ) capacitor c=0.00201171f \
 //x=19.98 //y=4.555 //x2=19.24 //y2=4.7
cc_1315 ( N_noxref_5_c_1756_p N_noxref_11_c_2840_n ) capacitor c=0.00283894f \
 //x=20.01 //y=4.7 //x2=19.24 //y2=4.7
cc_1316 ( N_noxref_5_c_1758_p N_noxref_11_c_2840_n ) capacitor c=0.0297875f \
 //x=20.01 //y=4.7 //x2=19.24 //y2=4.7
cc_1317 ( N_noxref_5_c_1651_n N_noxref_12_c_3057_n ) capacitor c=3.97665e-19 \
 //x=0.81 //y=0.875 //x2=1.075 //y2=0.835
cc_1318 ( N_noxref_5_c_1869_p N_noxref_12_c_3057_n ) capacitor c=0.00864609f \
 //x=1.185 //y=0.72 //x2=1.075 //y2=0.835
cc_1319 ( N_noxref_5_c_1657_n N_noxref_12_c_3057_n ) capacitor c=4.45447e-19 \
 //x=1.34 //y=0.875 //x2=1.075 //y2=0.835
cc_1320 ( N_noxref_5_c_1449_n N_noxref_12_c_2951_n ) capacitor c=2.70451e-19 \
 //x=9.99 //y=4.235 //x2=12.565 //y2=0
cc_1321 ( N_noxref_5_c_1456_n N_noxref_12_c_2951_n ) capacitor c=0.00234099f \
 //x=9.99 //y=2.08 //x2=12.565 //y2=0
cc_1322 ( N_noxref_5_c_1598_n N_noxref_12_c_2993_n ) capacitor c=0.00653239f \
 //x=13.975 //y=1.655 //x2=15.895 //y2=0
cc_1323 ( N_noxref_5_c_1527_n N_noxref_12_c_2993_n ) capacitor c=0.00963092f \
 //x=13.62 //y=1 //x2=15.895 //y2=0
cc_1324 ( N_noxref_5_M8_noxref_d N_noxref_12_c_2993_n ) capacitor \
 c=3.01654e-19 //x=13.43 //y=0.905 //x2=15.895 //y2=0
cc_1325 ( N_noxref_5_c_1837_p N_noxref_12_c_3065_n ) capacitor c=2.63584e-19 \
 //x=19.98 //y=4.23 //x2=21.09 //y2=0
cc_1326 ( N_noxref_5_c_1828_p N_noxref_12_c_3065_n ) capacitor c=0.00234099f \
 //x=19.98 //y=2.08 //x2=21.09 //y2=0
cc_1327 ( N_noxref_5_c_1572_n N_noxref_12_c_3067_n ) capacitor c=0.00849484f \
 //x=1.11 //y=2.195 //x2=1.075 //y2=0.965
cc_1328 ( N_noxref_5_c_1577_n N_noxref_12_c_3067_n ) capacitor c=4.89019e-19 \
 //x=1.11 //y=4.235 //x2=1.075 //y2=0.965
cc_1329 ( N_noxref_5_c_1637_n N_noxref_12_c_3067_n ) capacitor c=2.22861e-19 \
 //x=1.11 //y=2.08 //x2=1.075 //y2=0.965
cc_1330 ( N_noxref_5_c_1651_n N_noxref_12_c_3067_n ) capacitor c=0.00142616f \
 //x=0.81 //y=0.875 //x2=1.075 //y2=0.965
cc_1331 ( N_noxref_5_c_1652_n N_noxref_12_c_3067_n ) capacitor c=0.00411286f \
 //x=0.81 //y=1.22 //x2=1.075 //y2=0.965
cc_1332 ( N_noxref_5_c_1653_n N_noxref_12_c_3067_n ) capacitor c=4.68816e-19 \
 //x=0.81 //y=1.53 //x2=1.075 //y2=0.965
cc_1333 ( N_noxref_5_c_1869_p N_noxref_12_c_3067_n ) capacitor c=7.3749e-19 \
 //x=1.185 //y=0.72 //x2=1.075 //y2=0.965
cc_1334 ( N_noxref_5_c_1885_p N_noxref_12_c_3067_n ) capacitor c=6.09659e-19 \
 //x=1.185 //y=1.375 //x2=1.075 //y2=0.965
cc_1335 ( N_noxref_5_c_1657_n N_noxref_12_c_3067_n ) capacitor c=0.0017438f \
 //x=1.34 //y=0.875 //x2=1.075 //y2=0.965
cc_1336 ( N_noxref_5_c_1659_n N_noxref_12_c_3067_n ) capacitor c=0.00276804f \
 //x=1.34 //y=1.22 //x2=1.075 //y2=0.965
cc_1337 ( N_noxref_5_c_1518_n N_noxref_12_c_2958_n ) capacitor c=7.78541e-19 \
 //x=12.7 //y=5.38 //x2=12.65 //y2=0.955
cc_1338 ( N_noxref_5_c_1527_n N_noxref_12_c_2958_n ) capacitor c=0.0140087f \
 //x=13.62 //y=1 //x2=12.65 //y2=0.955
cc_1339 ( N_noxref_5_M8_noxref_d N_noxref_12_c_2958_n ) capacitor \
 c=2.93544e-19 //x=13.43 //y=0.905 //x2=12.65 //y2=0.955
cc_1340 ( N_noxref_5_c_1527_n N_noxref_12_c_3015_n ) capacitor c=0.00549186f \
 //x=13.62 //y=1 //x2=15.98 //y2=0.955
cc_1341 ( N_noxref_5_c_1651_n N_noxref_12_c_2926_n ) capacitor c=0.00678001f \
 //x=0.81 //y=0.875 //x2=4.64 //y2=0
cc_1342 ( N_noxref_5_c_1572_n N_noxref_12_c_3082_n ) capacitor c=0.00779049f \
 //x=1.11 //y=2.195 //x2=0.74 //y2=0
cc_1343 ( N_noxref_5_c_1438_n N_noxref_12_c_3082_n ) capacitor c=0.0126319f \
 //x=1.11 //y=3.915 //x2=0.74 //y2=0
cc_1344 ( N_noxref_5_c_1637_n N_noxref_12_c_3082_n ) capacitor c=0.00394776f \
 //x=1.11 //y=2.08 //x2=0.74 //y2=0
cc_1345 ( N_noxref_5_c_1653_n N_noxref_12_c_3082_n ) capacitor c=0.00295461f \
 //x=0.81 //y=1.53 //x2=0.74 //y2=0
cc_1346 ( N_noxref_5_c_1654_n N_noxref_12_c_3082_n ) capacitor c=0.0112432f \
 //x=0.81 //y=1.915 //x2=0.74 //y2=0
cc_1347 ( N_noxref_5_c_1456_n N_noxref_12_c_2928_n ) capacitor c=3.77673e-19 \
 //x=9.99 //y=2.08 //x2=11.3 //y2=0
cc_1348 ( N_noxref_5_c_1598_n N_noxref_12_c_2973_n ) capacitor c=7.78078e-19 \
 //x=13.975 //y=1.655 //x2=14.63 //y2=0
cc_1349 ( N_noxref_5_c_1527_n N_noxref_12_c_2929_n ) capacitor c=2.83275e-19 \
 //x=13.62 //y=1 //x2=21.09 //y2=0
cc_1350 ( N_noxref_5_c_1828_p N_noxref_12_c_2929_n ) capacitor c=3.77673e-19 \
 //x=19.98 //y=2.08 //x2=21.09 //y2=0
cc_1351 ( N_noxref_5_c_1830_p N_noxref_12_c_2929_n ) capacitor c=0.00224736f \
 //x=19.98 //y=2.08 //x2=21.09 //y2=0
cc_1352 ( N_noxref_5_c_1864_p N_noxref_12_c_2929_n ) capacitor c=0.0028807f \
 //x=20.545 //y=1.25 //x2=21.09 //y2=0
cc_1353 ( N_noxref_5_c_1831_p N_noxref_12_c_2929_n ) capacitor c=2.63786e-19 \
 //x=19.98 //y=2.08 //x2=21.09 //y2=0
cc_1354 ( N_noxref_5_c_1511_n N_noxref_12_c_2976_n ) capacitor c=9.32616e-19 \
 //x=14.06 //y=3.925 //x2=11.47 //y2=0
cc_1355 ( N_noxref_5_c_1470_n N_noxref_12_c_2976_n ) capacitor c=0.00224736f \
 //x=9.99 //y=2.08 //x2=11.47 //y2=0
cc_1356 ( N_noxref_5_c_1489_n N_noxref_12_c_2976_n ) capacitor c=0.00275184f \
 //x=10.555 //y=1.25 //x2=11.47 //y2=0
cc_1357 ( N_noxref_5_c_1490_n N_noxref_12_c_2976_n ) capacitor c=2.63786e-19 \
 //x=9.99 //y=2.08 //x2=11.47 //y2=0
cc_1358 ( N_noxref_5_c_1509_n N_noxref_12_c_2995_n ) capacitor c=0.002973f \
 //x=13.62 //y=1.57 //x2=14.8 //y2=0
cc_1359 ( N_noxref_5_c_1598_n N_noxref_12_c_2995_n ) capacitor c=0.0308456f \
 //x=13.975 //y=1.655 //x2=14.8 //y2=0
cc_1360 ( N_noxref_5_c_1713_n N_noxref_12_c_3100_n ) capacitor c=0.00353812f \
 //x=16.125 //y=4.09 //x2=18.13 //y2=0
cc_1361 ( N_noxref_5_c_1572_n N_noxref_12_M0_noxref_d ) capacitor c=4.4417e-19 \
 //x=1.11 //y=2.195 //x2=0.885 //y2=0.875
cc_1362 ( N_noxref_5_c_1651_n N_noxref_12_M0_noxref_d ) capacitor \
 c=0.00184354f //x=0.81 //y=0.875 //x2=0.885 //y2=0.875
cc_1363 ( N_noxref_5_c_1652_n N_noxref_12_M0_noxref_d ) capacitor \
 c=0.00210798f //x=0.81 //y=1.22 //x2=0.885 //y2=0.875
cc_1364 ( N_noxref_5_c_1869_p N_noxref_12_M0_noxref_d ) capacitor \
 c=0.00474029f //x=1.185 //y=0.72 //x2=0.885 //y2=0.875
cc_1365 ( N_noxref_5_c_1885_p N_noxref_12_M0_noxref_d ) capacitor \
 c=0.00166857f //x=1.185 //y=1.375 //x2=0.885 //y2=0.875
cc_1366 ( N_noxref_5_c_1657_n N_noxref_12_M0_noxref_d ) capacitor \
 c=0.00230174f //x=1.34 //y=0.875 //x2=0.885 //y2=0.875
cc_1367 ( N_noxref_5_c_1659_n N_noxref_12_M0_noxref_d ) capacitor \
 c=0.00210798f //x=1.34 //y=1.22 //x2=0.885 //y2=0.875
cc_1368 ( N_noxref_5_c_1527_n N_noxref_12_M7_noxref_d ) capacitor \
 c=2.82748e-19 //x=13.62 //y=1 //x2=12.46 //y2=0.865
cc_1369 ( N_noxref_5_c_1837_p N_noxref_13_c_3326_n ) capacitor c=0.00425321f \
 //x=19.98 //y=4.23 //x2=20.125 //y2=5.2
cc_1370 ( N_noxref_5_c_1820_p N_noxref_13_c_3326_n ) capacitor c=0.0220569f \
 //x=19.98 //y=4.555 //x2=20.125 //y2=5.2
cc_1371 ( N_noxref_5_c_1713_n N_noxref_13_c_3326_n ) capacitor c=0.00277534f \
 //x=16.125 //y=4.09 //x2=20.125 //y2=5.2
cc_1372 ( N_noxref_5_c_1756_p N_noxref_13_c_3326_n ) capacitor c=0.00469257f \
 //x=20.01 //y=4.7 //x2=20.125 //y2=5.2
cc_1373 ( N_noxref_5_M37_noxref_g N_noxref_13_c_3326_n ) capacitor \
 c=0.00842859f //x=20.02 //y=6.02 //x2=20.125 //y2=5.2
cc_1374 ( N_noxref_5_c_1758_p N_noxref_13_c_3326_n ) capacitor c=8.42507e-19 \
 //x=20.01 //y=4.7 //x2=20.125 //y2=5.2
cc_1375 ( N_noxref_5_c_1854_p N_noxref_13_c_3332_n ) capacitor c=0.00119008f \
 //x=20.015 //y=1.25 //x2=20.28 //y2=1.57
cc_1376 ( N_noxref_5_c_1855_p N_noxref_13_c_3332_n ) capacitor c=0.00438634f \
 //x=20.015 //y=1.56 //x2=20.28 //y2=1.57
cc_1377 ( N_noxref_5_c_1928_p N_noxref_13_c_3332_n ) capacitor c=0.00929259f \
 //x=20.39 //y=1.405 //x2=20.28 //y2=1.57
cc_1378 ( N_noxref_5_c_1864_p N_noxref_13_c_3332_n ) capacitor c=0.00341295f \
 //x=20.545 //y=1.25 //x2=20.28 //y2=1.57
cc_1379 ( N_noxref_5_c_1930_p N_noxref_13_c_3332_n ) capacitor c=0.00341114f \
 //x=19.98 //y=1.915 //x2=20.28 //y2=1.57
cc_1380 ( N_noxref_5_M38_noxref_g N_noxref_13_c_3337_n ) capacitor \
 c=0.0115937f //x=20.46 //y=6.02 //x2=20.635 //y2=5.2
cc_1381 ( N_noxref_5_c_1928_p N_noxref_13_c_3338_n ) capacitor c=0.00194324f \
 //x=20.39 //y=1.405 //x2=20.635 //y2=1.655
cc_1382 ( N_noxref_5_c_1864_p N_noxref_13_c_3338_n ) capacitor c=0.00323005f \
 //x=20.545 //y=1.25 //x2=20.635 //y2=1.655
cc_1383 ( N_noxref_5_c_1819_p N_noxref_13_c_3340_n ) capacitor c=0.0802564f \
 //x=19.98 //y=3.91 //x2=20.72 //y2=5.115
cc_1384 ( N_noxref_5_c_1837_p N_noxref_13_c_3340_n ) capacitor c=0.0149195f \
 //x=19.98 //y=4.23 //x2=20.72 //y2=5.115
cc_1385 ( N_noxref_5_c_1820_p N_noxref_13_c_3340_n ) capacitor c=0.0311001f \
 //x=19.98 //y=4.555 //x2=20.72 //y2=5.115
cc_1386 ( N_noxref_5_c_1755_p N_noxref_13_c_3340_n ) capacitor c=0.00462354f \
 //x=19.98 //y=4.07 //x2=20.72 //y2=5.115
cc_1387 ( N_noxref_5_c_1828_p N_noxref_13_c_3340_n ) capacitor c=0.015397f \
 //x=19.98 //y=2.08 //x2=20.72 //y2=5.115
cc_1388 ( N_noxref_5_c_1713_n N_noxref_13_c_3340_n ) capacitor c=0.00686844f \
 //x=16.125 //y=4.09 //x2=20.72 //y2=5.115
cc_1389 ( N_noxref_5_c_1830_p N_noxref_13_c_3340_n ) capacitor c=0.00440663f \
 //x=19.98 //y=2.08 //x2=20.72 //y2=5.115
cc_1390 ( N_noxref_5_c_1756_p N_noxref_13_c_3340_n ) capacitor c=0.00448306f \
 //x=20.01 //y=4.7 //x2=20.72 //y2=5.115
cc_1391 ( N_noxref_5_c_1757_p N_noxref_13_c_3340_n ) capacitor c=0.00461871f \
 //x=20.385 //y=4.79 //x2=20.72 //y2=5.115
cc_1392 ( N_noxref_5_c_1831_p N_noxref_13_c_3340_n ) capacitor c=0.00271446f \
 //x=19.98 //y=2.08 //x2=20.72 //y2=5.115
cc_1393 ( N_noxref_5_c_1758_p N_noxref_13_c_3340_n ) capacitor c=0.00142201f \
 //x=20.01 //y=4.7 //x2=20.72 //y2=5.115
cc_1394 ( N_noxref_5_c_1713_n N_noxref_13_c_3351_n ) capacitor c=0.0138219f \
 //x=16.125 //y=4.09 //x2=19.36 //y2=5.38
cc_1395 ( N_noxref_5_c_1713_n N_noxref_13_c_3352_n ) capacitor c=2.42699e-19 \
 //x=16.125 //y=4.09 //x2=20.24 //y2=5.2
cc_1396 ( N_noxref_5_M37_noxref_g N_noxref_13_c_3352_n ) capacitor \
 c=0.00192712f //x=20.02 //y=6.02 //x2=20.24 //y2=5.2
cc_1397 ( N_noxref_5_M38_noxref_g N_noxref_13_c_3352_n ) capacitor \
 c=0.00362563f //x=20.46 //y=6.02 //x2=20.24 //y2=5.2
cc_1398 ( N_noxref_5_c_1757_p N_noxref_13_c_3352_n ) capacitor c=0.0020909f \
 //x=20.385 //y=4.79 //x2=20.24 //y2=5.2
cc_1399 ( N_noxref_5_c_1852_p N_noxref_13_c_3356_n ) capacitor c=0.00120406f \
 //x=20.015 //y=0.905 //x2=20.28 //y2=1
cc_1400 ( N_noxref_5_c_1854_p N_noxref_13_c_3356_n ) capacitor c=0.00218694f \
 //x=20.015 //y=1.25 //x2=20.28 //y2=1
cc_1401 ( N_noxref_5_c_1952_p N_noxref_13_c_3356_n ) capacitor c=5.50523e-19 \
 //x=20.39 //y=0.75 //x2=20.28 //y2=1
cc_1402 ( N_noxref_5_c_1928_p N_noxref_13_c_3356_n ) capacitor c=5.67071e-19 \
 //x=20.39 //y=1.405 //x2=20.28 //y2=1
cc_1403 ( N_noxref_5_c_1861_p N_noxref_13_c_3356_n ) capacitor c=0.00121175f \
 //x=20.545 //y=0.905 //x2=20.28 //y2=1
cc_1404 ( N_noxref_5_c_1864_p N_noxref_13_c_3356_n ) capacitor c=0.00366282f \
 //x=20.545 //y=1.25 //x2=20.28 //y2=1
cc_1405 ( N_noxref_5_M37_noxref_g N_noxref_13_c_3362_n ) capacitor \
 c=0.0178987f //x=20.02 //y=6.02 //x2=20.24 //y2=5.38
cc_1406 ( N_noxref_5_M38_noxref_g N_noxref_13_c_3362_n ) capacitor \
 c=0.0178506f //x=20.46 //y=6.02 //x2=20.24 //y2=5.38
cc_1407 ( N_noxref_5_c_1757_p N_noxref_13_c_3362_n ) capacitor c=0.00291714f \
 //x=20.385 //y=4.79 //x2=20.24 //y2=5.38
cc_1408 ( N_noxref_5_c_1852_p N_noxref_13_M12_noxref_d ) capacitor \
 c=0.00137165f //x=20.015 //y=0.905 //x2=20.09 //y2=0.905
cc_1409 ( N_noxref_5_c_1854_p N_noxref_13_M12_noxref_d ) capacitor \
 c=0.00237422f //x=20.015 //y=1.25 //x2=20.09 //y2=0.905
cc_1410 ( N_noxref_5_c_1952_p N_noxref_13_M12_noxref_d ) capacitor \
 c=0.0020782f //x=20.39 //y=0.75 //x2=20.09 //y2=0.905
cc_1411 ( N_noxref_5_c_1928_p N_noxref_13_M12_noxref_d ) capacitor \
 c=0.00356097f //x=20.39 //y=1.405 //x2=20.09 //y2=0.905
cc_1412 ( N_noxref_5_c_1861_p N_noxref_13_M12_noxref_d ) capacitor \
 c=8.50095e-19 //x=20.545 //y=0.905 //x2=20.09 //y2=0.905
cc_1413 ( N_noxref_5_c_1864_p N_noxref_13_M12_noxref_d ) capacitor \
 c=0.00237422f //x=20.545 //y=1.25 //x2=20.09 //y2=0.905
cc_1414 ( N_noxref_5_c_1654_n N_noxref_14_c_3452_n ) capacitor c=0.00267608f \
 //x=0.81 //y=1.915 //x2=0.59 //y2=1.505
cc_1415 ( N_noxref_5_c_1572_n N_noxref_14_c_3453_n ) capacitor c=0.00428451f \
 //x=1.11 //y=2.195 //x2=1.475 //y2=1.59
cc_1416 ( N_noxref_5_c_1577_n N_noxref_14_c_3453_n ) capacitor c=0.0010535f \
 //x=1.11 //y=4.235 //x2=1.475 //y2=1.59
cc_1417 ( N_noxref_5_c_1637_n N_noxref_14_c_3453_n ) capacitor c=0.0104666f \
 //x=1.11 //y=2.08 //x2=1.475 //y2=1.59
cc_1418 ( N_noxref_5_c_1653_n N_noxref_14_c_3453_n ) capacitor c=0.00703864f \
 //x=0.81 //y=1.53 //x2=1.475 //y2=1.59
cc_1419 ( N_noxref_5_c_1654_n N_noxref_14_c_3453_n ) capacitor c=0.0232409f \
 //x=0.81 //y=1.915 //x2=1.475 //y2=1.59
cc_1420 ( N_noxref_5_c_1885_p N_noxref_14_c_3453_n ) capacitor c=0.00588627f \
 //x=1.185 //y=1.375 //x2=1.475 //y2=1.59
cc_1421 ( N_noxref_5_c_1659_n N_noxref_14_c_3453_n ) capacitor c=0.00698822f \
 //x=1.34 //y=1.22 //x2=1.475 //y2=1.59
cc_1422 ( N_noxref_5_c_1651_n N_noxref_14_M0_noxref_s ) capacitor c=0.0295256f \
 //x=0.81 //y=0.875 //x2=0.455 //y2=0.375
cc_1423 ( N_noxref_5_c_1653_n N_noxref_14_M0_noxref_s ) capacitor \
 c=7.99997e-19 //x=0.81 //y=1.53 //x2=0.455 //y2=0.375
cc_1424 ( N_noxref_5_c_1654_n N_noxref_14_M0_noxref_s ) capacitor \
 c=0.00122123f //x=0.81 //y=1.915 //x2=0.455 //y2=0.375
cc_1425 ( N_noxref_5_c_1657_n N_noxref_14_M0_noxref_s ) capacitor c=0.0125924f \
 //x=1.34 //y=0.875 //x2=0.455 //y2=0.375
cc_1426 ( N_noxref_5_c_1449_n N_noxref_16_c_3570_n ) capacitor c=9.48063e-19 \
 //x=9.99 //y=4.235 //x2=9.805 //y2=1.495
cc_1427 ( N_noxref_5_c_1456_n N_noxref_16_c_3570_n ) capacitor c=7.50092e-19 \
 //x=9.99 //y=2.08 //x2=9.805 //y2=1.495
cc_1428 ( N_noxref_5_c_1485_n N_noxref_16_c_3570_n ) capacitor c=0.00888238f \
 //x=10.025 //y=1.56 //x2=9.805 //y2=1.495
cc_1429 ( N_noxref_5_c_1490_n N_noxref_16_c_3570_n ) capacitor c=0.00175171f \
 //x=9.99 //y=2.08 //x2=9.805 //y2=1.495
cc_1430 ( N_noxref_5_c_1456_n N_noxref_16_c_3575_n ) capacitor c=0.001463f \
 //x=9.99 //y=2.08 //x2=10.69 //y2=0.53
cc_1431 ( N_noxref_5_c_1470_n N_noxref_16_c_3575_n ) capacitor c=8.82141e-19 \
 //x=9.99 //y=2.08 //x2=10.69 //y2=0.53
cc_1432 ( N_noxref_5_c_1480_n N_noxref_16_c_3575_n ) capacitor c=0.0200357f \
 //x=10.025 //y=0.905 //x2=10.69 //y2=0.53
cc_1433 ( N_noxref_5_c_1488_n N_noxref_16_c_3575_n ) capacitor c=0.00825432f \
 //x=10.555 //y=0.905 //x2=10.69 //y2=0.53
cc_1434 ( N_noxref_5_c_1490_n N_noxref_16_c_3575_n ) capacitor c=2.1838e-19 \
 //x=9.99 //y=2.08 //x2=10.69 //y2=0.53
cc_1435 ( N_noxref_5_c_1480_n N_noxref_16_M5_noxref_s ) capacitor \
 c=0.00888238f //x=10.025 //y=0.905 //x2=8.7 //y2=0.365
cc_1436 ( N_noxref_5_c_1488_n N_noxref_16_M5_noxref_s ) capacitor c=0.015333f \
 //x=10.555 //y=0.905 //x2=8.7 //y2=0.365
cc_1437 ( N_noxref_5_c_1489_n N_noxref_16_M5_noxref_s ) capacitor \
 c=0.00248746f //x=10.555 //y=1.25 //x2=8.7 //y2=0.365
cc_1438 ( N_noxref_5_c_1510_n N_noxref_17_c_3638_n ) capacitor c=0.00911498f \
 //x=13.705 //y=1.655 //x2=13.135 //y2=1.495
cc_1439 ( N_noxref_5_c_1598_n N_noxref_17_c_3645_n ) capacitor c=0.00361884f \
 //x=13.975 //y=1.655 //x2=14.02 //y2=0.53
cc_1440 ( N_noxref_5_c_1527_n N_noxref_17_c_3645_n ) capacitor c=0.00367971f \
 //x=13.62 //y=1 //x2=14.02 //y2=0.53
cc_1441 ( N_noxref_5_M8_noxref_d N_noxref_17_c_3645_n ) capacitor \
 c=0.00910163f //x=13.43 //y=0.905 //x2=14.02 //y2=0.53
cc_1442 ( N_noxref_5_c_1509_n N_noxref_17_M7_noxref_s ) capacitor c=0.0162484f \
 //x=13.62 //y=1.57 //x2=12.03 //y2=0.365
cc_1443 ( N_noxref_5_c_1598_n N_noxref_17_M7_noxref_s ) capacitor \
 c=0.00692219f //x=13.975 //y=1.655 //x2=12.03 //y2=0.365
cc_1444 ( N_noxref_5_c_1527_n N_noxref_17_M7_noxref_s ) capacitor \
 c=0.00905169f //x=13.62 //y=1 //x2=12.03 //y2=0.365
cc_1445 ( N_noxref_5_c_1623_n N_noxref_17_M7_noxref_s ) capacitor \
 c=7.05305e-19 //x=14.06 //y=4.07 //x2=12.03 //y2=0.365
cc_1446 ( N_noxref_5_M8_noxref_d N_noxref_17_M7_noxref_s ) capacitor \
 c=0.0275552f //x=13.43 //y=0.905 //x2=12.03 //y2=0.365
cc_1447 ( N_noxref_5_c_1837_p N_noxref_19_c_3757_n ) capacitor c=7.70811e-19 \
 //x=19.98 //y=4.23 //x2=19.795 //y2=1.495
cc_1448 ( N_noxref_5_c_1828_p N_noxref_19_c_3757_n ) capacitor c=7.50092e-19 \
 //x=19.98 //y=2.08 //x2=19.795 //y2=1.495
cc_1449 ( N_noxref_5_c_1855_p N_noxref_19_c_3757_n ) capacitor c=0.00890678f \
 //x=20.015 //y=1.56 //x2=19.795 //y2=1.495
cc_1450 ( N_noxref_5_c_1831_p N_noxref_19_c_3757_n ) capacitor c=0.00175171f \
 //x=19.98 //y=2.08 //x2=19.795 //y2=1.495
cc_1451 ( N_noxref_5_c_1828_p N_noxref_19_c_3761_n ) capacitor c=0.001463f \
 //x=19.98 //y=2.08 //x2=20.68 //y2=0.53
cc_1452 ( N_noxref_5_c_1830_p N_noxref_19_c_3761_n ) capacitor c=8.82141e-19 \
 //x=19.98 //y=2.08 //x2=20.68 //y2=0.53
cc_1453 ( N_noxref_5_c_1852_p N_noxref_19_c_3761_n ) capacitor c=0.0200262f \
 //x=20.015 //y=0.905 //x2=20.68 //y2=0.53
cc_1454 ( N_noxref_5_c_1861_p N_noxref_19_c_3761_n ) capacitor c=0.00825432f \
 //x=20.545 //y=0.905 //x2=20.68 //y2=0.53
cc_1455 ( N_noxref_5_c_1831_p N_noxref_19_c_3761_n ) capacitor c=2.1838e-19 \
 //x=19.98 //y=2.08 //x2=20.68 //y2=0.53
cc_1456 ( N_noxref_5_c_1852_p N_noxref_19_M11_noxref_s ) capacitor \
 c=0.00890678f //x=20.015 //y=0.905 //x2=18.69 //y2=0.365
cc_1457 ( N_noxref_5_c_1861_p N_noxref_19_M11_noxref_s ) capacitor c=0.015333f \
 //x=20.545 //y=0.905 //x2=18.69 //y2=0.365
cc_1458 ( N_noxref_5_c_1864_p N_noxref_19_M11_noxref_s ) capacitor \
 c=0.00248746f //x=20.545 //y=1.25 //x2=18.69 //y2=0.365
cc_1459 ( N_noxref_6_c_2038_n N_noxref_8_c_2466_n ) capacitor c=0.00226427f \
 //x=8.14 //y=7.4 //x2=6.69 //y2=4.7
cc_1460 ( N_noxref_6_c_2025_n N_noxref_8_M21_noxref_g ) capacitor \
 c=0.00692597f //x=7.275 //y=7.4 //x2=6.7 //y2=6.02
cc_1461 ( N_noxref_6_M20_noxref_d N_noxref_8_M21_noxref_g ) capacitor \
 c=0.015318f //x=6.335 //y=5.02 //x2=6.7 //y2=6.02
cc_1462 ( N_noxref_6_c_2025_n N_noxref_8_M22_noxref_g ) capacitor \
 c=0.00749619f //x=7.275 //y=7.4 //x2=7.14 //y2=6.02
cc_1463 ( N_noxref_6_M22_noxref_d N_noxref_8_M22_noxref_g ) capacitor \
 c=0.0430452f //x=7.215 //y=5.02 //x2=7.14 //y2=6.02
cc_1464 ( N_noxref_6_c_2038_n N_noxref_8_c_2480_n ) capacitor c=0.0129149f \
 //x=8.14 //y=7.4 //x2=7.065 //y2=4.79
cc_1465 ( N_noxref_6_c_2038_n N_noxref_8_c_2498_n ) capacitor c=2.73429e-19 \
 //x=8.14 //y=7.4 //x2=6.69 //y2=4.7
cc_1466 ( N_noxref_6_M20_noxref_d N_noxref_8_c_2498_n ) capacitor \
 c=3.32274e-19 //x=6.335 //y=5.02 //x2=6.69 //y2=4.7
cc_1467 ( N_noxref_6_c_2256_n N_noxref_9_c_2582_n ) capacitor c=0.00226427f \
 //x=18.13 //y=7.4 //x2=16.68 //y2=4.7
cc_1468 ( N_noxref_6_c_2297_p N_noxref_9_M33_noxref_g ) capacitor \
 c=0.00692597f //x=17.265 //y=7.4 //x2=16.69 //y2=6.02
cc_1469 ( N_noxref_6_M32_noxref_d N_noxref_9_M33_noxref_g ) capacitor \
 c=0.015318f //x=16.325 //y=5.02 //x2=16.69 //y2=6.02
cc_1470 ( N_noxref_6_c_2297_p N_noxref_9_M34_noxref_g ) capacitor \
 c=0.00749619f //x=17.265 //y=7.4 //x2=17.13 //y2=6.02
cc_1471 ( N_noxref_6_M34_noxref_d N_noxref_9_M34_noxref_g ) capacitor \
 c=0.0430452f //x=17.205 //y=5.02 //x2=17.13 //y2=6.02
cc_1472 ( N_noxref_6_c_2256_n N_noxref_9_c_2613_n ) capacitor c=0.0131895f \
 //x=18.13 //y=7.4 //x2=17.055 //y2=4.79
cc_1473 ( N_noxref_6_c_2256_n N_noxref_9_c_2601_n ) capacitor c=2.73429e-19 \
 //x=18.13 //y=7.4 //x2=16.68 //y2=4.7
cc_1474 ( N_noxref_6_M32_noxref_d N_noxref_9_c_2601_n ) capacitor \
 c=3.32274e-19 //x=16.325 //y=5.02 //x2=16.68 //y2=4.7
cc_1475 ( N_noxref_6_c_2010_n N_noxref_10_c_2671_n ) capacitor c=0.00647565f \
 //x=21.09 //y=7.4 //x2=16.795 //y2=5.2
cc_1476 ( N_noxref_6_c_2170_n N_noxref_10_c_2671_n ) capacitor c=0.00208112f \
 //x=16.385 //y=7.4 //x2=16.795 //y2=5.2
cc_1477 ( N_noxref_6_c_2297_p N_noxref_10_c_2671_n ) capacitor c=0.00180744f \
 //x=17.265 //y=7.4 //x2=16.795 //y2=5.2
cc_1478 ( N_noxref_6_M32_noxref_d N_noxref_10_c_2671_n ) capacitor \
 c=0.00734028f //x=16.325 //y=5.02 //x2=16.795 //y2=5.2
cc_1479 ( N_noxref_6_c_2010_n N_noxref_10_c_2703_n ) capacitor c=0.0048744f \
 //x=21.09 //y=7.4 //x2=17.305 //y2=5.2
cc_1480 ( N_noxref_6_c_2297_p N_noxref_10_c_2703_n ) capacitor c=0.00208112f \
 //x=17.265 //y=7.4 //x2=17.305 //y2=5.2
cc_1481 ( N_noxref_6_M34_noxref_d N_noxref_10_c_2703_n ) capacitor c=0.010542f \
 //x=17.205 //y=5.02 //x2=17.305 //y2=5.2
cc_1482 ( N_noxref_6_M35_noxref_s N_noxref_10_c_2703_n ) capacitor \
 c=0.00388014f //x=18.785 //y=5.02 //x2=17.305 //y2=5.2
cc_1483 ( N_noxref_6_c_2126_n N_noxref_10_c_2672_n ) capacitor c=4.41765e-19 \
 //x=14.8 //y=7.4 //x2=17.39 //y2=5.115
cc_1484 ( N_noxref_6_c_2256_n N_noxref_10_c_2672_n ) capacitor c=0.0321f \
 //x=18.13 //y=7.4 //x2=17.39 //y2=5.115
cc_1485 ( N_noxref_6_c_2010_n N_noxref_10_c_2674_n ) capacitor c=0.00368144f \
 //x=21.09 //y=7.4 //x2=16.03 //y2=5.38
cc_1486 ( N_noxref_6_c_2170_n N_noxref_10_c_2674_n ) capacitor c=9.41091e-19 \
 //x=16.385 //y=7.4 //x2=16.03 //y2=5.38
cc_1487 ( N_noxref_6_c_2126_n N_noxref_10_c_2674_n ) capacitor c=4.91377e-19 \
 //x=14.8 //y=7.4 //x2=16.03 //y2=5.38
cc_1488 ( N_noxref_6_M31_noxref_s N_noxref_10_c_2674_n ) capacitor \
 c=0.0572211f //x=15.455 //y=5.02 //x2=16.03 //y2=5.38
cc_1489 ( N_noxref_6_M32_noxref_d N_noxref_10_c_2674_n ) capacitor \
 c=0.0043528f //x=16.325 //y=5.02 //x2=16.03 //y2=5.38
cc_1490 ( N_noxref_6_c_2010_n N_noxref_10_c_2697_n ) capacitor c=8.41206e-19 \
 //x=21.09 //y=7.4 //x2=16.91 //y2=5.2
cc_1491 ( N_noxref_6_c_2297_p N_noxref_10_c_2697_n ) capacitor c=4.23323e-19 \
 //x=17.265 //y=7.4 //x2=16.91 //y2=5.2
cc_1492 ( N_noxref_6_c_2256_n N_noxref_10_c_2697_n ) capacitor c=0.00240948f \
 //x=18.13 //y=7.4 //x2=16.91 //y2=5.2
cc_1493 ( N_noxref_6_M31_noxref_s N_noxref_10_c_2697_n ) capacitor \
 c=6.52457e-19 //x=15.455 //y=5.02 //x2=16.91 //y2=5.2
cc_1494 ( N_noxref_6_M35_noxref_s N_noxref_10_c_2697_n ) capacitor \
 c=0.00515461f //x=18.785 //y=5.02 //x2=16.91 //y2=5.2
cc_1495 ( N_noxref_6_c_2010_n N_noxref_10_c_2719_n ) capacitor c=0.00285294f \
 //x=21.09 //y=7.4 //x2=16.91 //y2=5.38
cc_1496 ( N_noxref_6_c_2297_p N_noxref_10_c_2719_n ) capacitor c=5.78261e-19 \
 //x=17.265 //y=7.4 //x2=16.91 //y2=5.38
cc_1497 ( N_noxref_6_c_2256_n N_noxref_10_c_2719_n ) capacitor c=4.09141e-19 \
 //x=18.13 //y=7.4 //x2=16.91 //y2=5.38
cc_1498 ( N_noxref_6_M32_noxref_d N_noxref_10_c_2719_n ) capacitor \
 c=0.0043528f //x=16.325 //y=5.02 //x2=16.91 //y2=5.38
cc_1499 ( N_noxref_6_M34_noxref_d N_noxref_10_c_2719_n ) capacitor \
 c=0.00587834f //x=17.205 //y=5.02 //x2=16.91 //y2=5.38
cc_1500 ( N_noxref_6_M35_noxref_s N_noxref_10_c_2719_n ) capacitor \
 c=3.28075e-19 //x=18.785 //y=5.02 //x2=16.91 //y2=5.38
cc_1501 ( N_noxref_6_c_2010_n N_noxref_10_c_2680_n ) capacitor c=0.00224727f \
 //x=21.09 //y=7.4 //x2=16.03 //y2=5.38
cc_1502 ( N_noxref_6_c_2170_n N_noxref_10_c_2680_n ) capacitor c=0.0136475f \
 //x=16.385 //y=7.4 //x2=16.03 //y2=5.38
cc_1503 ( N_noxref_6_c_2126_n N_noxref_10_c_2680_n ) capacitor c=0.0064135f \
 //x=14.8 //y=7.4 //x2=16.03 //y2=5.38
cc_1504 ( N_noxref_6_M31_noxref_s N_noxref_10_c_2680_n ) capacitor \
 c=0.0887533f //x=15.455 //y=5.02 //x2=16.03 //y2=5.38
cc_1505 ( N_noxref_6_M32_noxref_d N_noxref_10_c_2680_n ) capacitor c=0.065554f \
 //x=16.325 //y=5.02 //x2=16.03 //y2=5.38
cc_1506 ( N_noxref_6_c_2010_n N_noxref_10_c_2730_n ) capacitor c=0.00224727f \
 //x=21.09 //y=7.4 //x2=16.91 //y2=5.38
cc_1507 ( N_noxref_6_c_2297_p N_noxref_10_c_2730_n ) capacitor c=0.0136475f \
 //x=17.265 //y=7.4 //x2=16.91 //y2=5.38
cc_1508 ( N_noxref_6_c_2256_n N_noxref_10_c_2730_n ) capacitor c=0.0101861f \
 //x=18.13 //y=7.4 //x2=16.91 //y2=5.38
cc_1509 ( N_noxref_6_M32_noxref_d N_noxref_10_c_2730_n ) capacitor c=0.065554f \
 //x=16.325 //y=5.02 //x2=16.91 //y2=5.38
cc_1510 ( N_noxref_6_M34_noxref_d N_noxref_10_c_2730_n ) capacitor c=0.065554f \
 //x=17.205 //y=5.02 //x2=16.91 //y2=5.38
cc_1511 ( N_noxref_6_c_2010_n N_noxref_11_c_2807_n ) capacitor c=9.05427e-19 \
 //x=21.09 //y=7.4 //x2=19.24 //y2=4.7
cc_1512 ( N_noxref_6_c_2341_p N_noxref_11_c_2807_n ) capacitor c=6.28732e-19 \
 //x=19.715 //y=7.4 //x2=19.24 //y2=4.7
cc_1513 ( N_noxref_6_c_2256_n N_noxref_11_c_2807_n ) capacitor c=0.00447349f \
 //x=18.13 //y=7.4 //x2=19.24 //y2=4.7
cc_1514 ( N_noxref_6_c_2256_n N_noxref_11_c_2811_n ) capacitor c=0.00675188f \
 //x=18.13 //y=7.4 //x2=19.242 //y2=4.56
cc_1515 ( N_noxref_6_c_2010_n N_noxref_11_c_2821_n ) capacitor c=6.23118e-19 \
 //x=21.09 //y=7.4 //x2=19.24 //y2=4.7
cc_1516 ( N_noxref_6_c_2256_n N_noxref_11_c_2821_n ) capacitor c=0.00370494f \
 //x=18.13 //y=7.4 //x2=19.24 //y2=4.7
cc_1517 ( N_noxref_6_c_2341_p N_noxref_11_M35_noxref_g ) capacitor \
 c=0.0072715f //x=19.715 //y=7.4 //x2=19.14 //y2=6.02
cc_1518 ( N_noxref_6_M35_noxref_s N_noxref_11_M35_noxref_g ) capacitor \
 c=0.0567929f //x=18.785 //y=5.02 //x2=19.14 //y2=6.02
cc_1519 ( N_noxref_6_c_2341_p N_noxref_11_M36_noxref_g ) capacitor \
 c=0.00749619f //x=19.715 //y=7.4 //x2=19.58 //y2=6.02
cc_1520 ( N_noxref_6_M36_noxref_d N_noxref_11_M36_noxref_g ) capacitor \
 c=0.015318f //x=19.655 //y=5.02 //x2=19.58 //y2=6.02
cc_1521 ( N_noxref_6_c_2256_n N_noxref_11_c_2840_n ) capacitor c=0.0129564f \
 //x=18.13 //y=7.4 //x2=19.24 //y2=4.7
cc_1522 ( N_noxref_6_c_2117_n N_noxref_12_c_3082_n ) capacitor c=0.00989031f \
 //x=0.74 //y=7.4 //x2=0.74 //y2=0
cc_1523 ( N_noxref_6_c_2233_n N_noxref_12_c_2929_n ) capacitor c=0.00989031f \
 //x=21.09 //y=7.4 //x2=21.09 //y2=0
cc_1524 ( N_noxref_6_c_2033_n N_noxref_12_c_2930_n ) capacitor c=0.00654201f \
 //x=4.81 //y=7.4 //x2=4.81 //y2=0
cc_1525 ( N_noxref_6_c_2038_n N_noxref_12_c_2935_n ) capacitor c=0.00654201f \
 //x=8.14 //y=7.4 //x2=8.14 //y2=0
cc_1526 ( N_noxref_6_c_2091_n N_noxref_12_c_2976_n ) capacitor c=0.00654201f \
 //x=11.47 //y=7.4 //x2=11.47 //y2=0
cc_1527 ( N_noxref_6_c_2126_n N_noxref_12_c_2995_n ) capacitor c=0.00663522f \
 //x=14.8 //y=7.4 //x2=14.8 //y2=0
cc_1528 ( N_noxref_6_c_2256_n N_noxref_12_c_3100_n ) capacitor c=0.00654903f \
 //x=18.13 //y=7.4 //x2=18.13 //y2=0
cc_1529 ( N_noxref_6_c_2010_n N_noxref_13_c_3326_n ) capacitor c=0.00647526f \
 //x=21.09 //y=7.4 //x2=20.125 //y2=5.2
cc_1530 ( N_noxref_6_c_2341_p N_noxref_13_c_3326_n ) capacitor c=0.00208112f \
 //x=19.715 //y=7.4 //x2=20.125 //y2=5.2
cc_1531 ( N_noxref_6_c_2231_n N_noxref_13_c_3326_n ) capacitor c=0.00180744f \
 //x=20.595 //y=7.4 //x2=20.125 //y2=5.2
cc_1532 ( N_noxref_6_M36_noxref_d N_noxref_13_c_3326_n ) capacitor \
 c=0.00734028f //x=19.655 //y=5.02 //x2=20.125 //y2=5.2
cc_1533 ( N_noxref_6_c_2010_n N_noxref_13_c_3337_n ) capacitor c=0.0048744f \
 //x=21.09 //y=7.4 //x2=20.635 //y2=5.2
cc_1534 ( N_noxref_6_c_2231_n N_noxref_13_c_3337_n ) capacitor c=0.00213214f \
 //x=20.595 //y=7.4 //x2=20.635 //y2=5.2
cc_1535 ( N_noxref_6_M38_noxref_d N_noxref_13_c_3337_n ) capacitor \
 c=0.0125278f //x=20.535 //y=5.02 //x2=20.635 //y2=5.2
cc_1536 ( N_noxref_6_c_2233_n N_noxref_13_c_3340_n ) capacitor c=0.0384145f \
 //x=21.09 //y=7.4 //x2=20.72 //y2=5.115
cc_1537 ( N_noxref_6_c_2256_n N_noxref_13_c_3340_n ) capacitor c=6.19352e-19 \
 //x=18.13 //y=7.4 //x2=20.72 //y2=5.115
cc_1538 ( N_noxref_6_c_2010_n N_noxref_13_c_3351_n ) capacitor c=0.00368144f \
 //x=21.09 //y=7.4 //x2=19.36 //y2=5.38
cc_1539 ( N_noxref_6_c_2341_p N_noxref_13_c_3351_n ) capacitor c=9.41091e-19 \
 //x=19.715 //y=7.4 //x2=19.36 //y2=5.38
cc_1540 ( N_noxref_6_c_2256_n N_noxref_13_c_3351_n ) capacitor c=4.91377e-19 \
 //x=18.13 //y=7.4 //x2=19.36 //y2=5.38
cc_1541 ( N_noxref_6_M35_noxref_s N_noxref_13_c_3351_n ) capacitor \
 c=0.0577058f //x=18.785 //y=5.02 //x2=19.36 //y2=5.38
cc_1542 ( N_noxref_6_M36_noxref_d N_noxref_13_c_3351_n ) capacitor \
 c=0.0043528f //x=19.655 //y=5.02 //x2=19.36 //y2=5.38
cc_1543 ( N_noxref_6_c_2010_n N_noxref_13_c_3352_n ) capacitor c=8.4112e-19 \
 //x=21.09 //y=7.4 //x2=20.24 //y2=5.2
cc_1544 ( N_noxref_6_c_2231_n N_noxref_13_c_3352_n ) capacitor c=5.09756e-19 \
 //x=20.595 //y=7.4 //x2=20.24 //y2=5.2
cc_1545 ( N_noxref_6_c_2233_n N_noxref_13_c_3352_n ) capacitor c=0.00379179f \
 //x=21.09 //y=7.4 //x2=20.24 //y2=5.2
cc_1546 ( N_noxref_6_M35_noxref_s N_noxref_13_c_3352_n ) capacitor \
 c=6.52457e-19 //x=18.785 //y=5.02 //x2=20.24 //y2=5.2
cc_1547 ( N_noxref_6_c_2010_n N_noxref_13_c_3389_n ) capacitor c=0.00285294f \
 //x=21.09 //y=7.4 //x2=20.24 //y2=5.38
cc_1548 ( N_noxref_6_c_2231_n N_noxref_13_c_3389_n ) capacitor c=5.78261e-19 \
 //x=20.595 //y=7.4 //x2=20.24 //y2=5.38
cc_1549 ( N_noxref_6_c_2233_n N_noxref_13_c_3389_n ) capacitor c=0.0016115f \
 //x=21.09 //y=7.4 //x2=20.24 //y2=5.38
cc_1550 ( N_noxref_6_M36_noxref_d N_noxref_13_c_3389_n ) capacitor \
 c=0.0043528f //x=19.655 //y=5.02 //x2=20.24 //y2=5.38
cc_1551 ( N_noxref_6_M38_noxref_d N_noxref_13_c_3389_n ) capacitor \
 c=0.00979407f //x=20.535 //y=5.02 //x2=20.24 //y2=5.38
cc_1552 ( N_noxref_6_c_2010_n N_noxref_13_c_3394_n ) capacitor c=0.00224727f \
 //x=21.09 //y=7.4 //x2=19.36 //y2=5.38
cc_1553 ( N_noxref_6_c_2341_p N_noxref_13_c_3394_n ) capacitor c=0.0136475f \
 //x=19.715 //y=7.4 //x2=19.36 //y2=5.38
cc_1554 ( N_noxref_6_c_2256_n N_noxref_13_c_3394_n ) capacitor c=0.0064135f \
 //x=18.13 //y=7.4 //x2=19.36 //y2=5.38
cc_1555 ( N_noxref_6_M35_noxref_s N_noxref_13_c_3394_n ) capacitor \
 c=0.0887533f //x=18.785 //y=5.02 //x2=19.36 //y2=5.38
cc_1556 ( N_noxref_6_M36_noxref_d N_noxref_13_c_3394_n ) capacitor c=0.065554f \
 //x=19.655 //y=5.02 //x2=19.36 //y2=5.38
cc_1557 ( N_noxref_6_c_2010_n N_noxref_13_c_3362_n ) capacitor c=0.00224727f \
 //x=21.09 //y=7.4 //x2=20.24 //y2=5.38
cc_1558 ( N_noxref_6_c_2231_n N_noxref_13_c_3362_n ) capacitor c=0.0136475f \
 //x=20.595 //y=7.4 //x2=20.24 //y2=5.38
cc_1559 ( N_noxref_6_c_2233_n N_noxref_13_c_3362_n ) capacitor c=0.0101867f \
 //x=21.09 //y=7.4 //x2=20.24 //y2=5.38
cc_1560 ( N_noxref_6_M36_noxref_d N_noxref_13_c_3362_n ) capacitor c=0.065554f \
 //x=19.655 //y=5.02 //x2=20.24 //y2=5.38
cc_1561 ( N_noxref_6_M38_noxref_d N_noxref_13_c_3362_n ) capacitor c=0.065554f \
 //x=20.535 //y=5.02 //x2=20.24 //y2=5.38
cc_1562 ( N_noxref_7_c_2401_n N_noxref_12_c_2906_n ) capacitor c=0.00789826f \
 //x=3.015 //y=0.995 //x2=5.905 //y2=0
cc_1563 ( N_noxref_7_c_2428_p N_noxref_12_c_2906_n ) capacitor c=0.00684574f \
 //x=3.1 //y=0.625 //x2=5.905 //y2=0
cc_1564 ( N_noxref_7_c_2391_n N_noxref_12_c_2906_n ) capacitor c=0.00957811f \
 //x=3.985 //y=0.54 //x2=5.905 //y2=0
cc_1565 ( N_noxref_7_c_2430_p N_noxref_12_c_2906_n ) capacitor c=0.00232857f \
 //x=4.07 //y=0.625 //x2=5.905 //y2=0
cc_1566 ( N_noxref_7_M1_noxref_d N_noxref_12_c_2906_n ) capacitor c=0.013411f \
 //x=1.86 //y=0.91 //x2=5.905 //y2=0
cc_1567 ( N_noxref_7_M1_noxref_d N_noxref_12_c_3067_n ) capacitor c=0.0156367f \
 //x=1.86 //y=0.91 //x2=1.075 //y2=0.965
cc_1568 ( N_noxref_7_c_2401_n N_noxref_12_c_2926_n ) capacitor c=0.00807048f \
 //x=3.015 //y=0.995 //x2=4.64 //y2=0
cc_1569 ( N_noxref_7_c_2428_p N_noxref_12_c_2926_n ) capacitor c=0.014039f \
 //x=3.1 //y=0.625 //x2=4.64 //y2=0
cc_1570 ( N_noxref_7_c_2391_n N_noxref_12_c_2926_n ) capacitor c=0.036459f \
 //x=3.985 //y=0.54 //x2=4.64 //y2=0
cc_1571 ( N_noxref_7_c_2430_p N_noxref_12_c_2926_n ) capacitor c=0.0138658f \
 //x=4.07 //y=0.625 //x2=4.64 //y2=0
cc_1572 ( N_noxref_7_M2_noxref_s N_noxref_12_c_3082_n ) capacitor \
 c=8.16352e-19 //x=2.965 //y=0.375 //x2=0.74 //y2=0
cc_1573 ( N_noxref_7_c_2391_n N_noxref_12_c_2929_n ) capacitor c=0.00189848f \
 //x=3.985 //y=0.54 //x2=21.09 //y2=0
cc_1574 ( N_noxref_7_M1_noxref_d N_noxref_12_c_2929_n ) capacitor c=2.7648e-19 \
 //x=1.86 //y=0.91 //x2=21.09 //y2=0
cc_1575 ( N_noxref_7_c_2430_p N_noxref_12_c_2930_n ) capacitor c=0.0374312f \
 //x=4.07 //y=0.625 //x2=4.81 //y2=0
cc_1576 ( N_noxref_7_M2_noxref_s N_noxref_12_c_2930_n ) capacitor \
 c=0.00519576f //x=2.965 //y=0.375 //x2=4.81 //y2=0
cc_1577 ( N_noxref_7_M1_noxref_d N_noxref_12_M0_noxref_d ) capacitor \
 c=3.12752e-19 //x=1.86 //y=0.91 //x2=0.885 //y2=0.875
cc_1578 ( N_noxref_7_c_2428_p N_noxref_14_c_3464_n ) capacitor c=2.15937e-19 \
 //x=3.1 //y=0.625 //x2=1.56 //y2=0.625
cc_1579 ( N_noxref_7_c_2401_n N_noxref_14_c_3442_n ) capacitor c=0.0132582f \
 //x=3.015 //y=0.995 //x2=2.445 //y2=0.54
cc_1580 ( N_noxref_7_M1_noxref_d N_noxref_14_c_3442_n ) capacitor c=0.016458f \
 //x=1.86 //y=0.91 //x2=2.445 //y2=0.54
cc_1581 ( N_noxref_7_c_2401_n N_noxref_14_c_3444_n ) capacitor c=0.00954209f \
 //x=3.015 //y=0.995 //x2=2.445 //y2=1.59
cc_1582 ( N_noxref_7_M1_noxref_d N_noxref_14_c_3444_n ) capacitor c=0.015272f \
 //x=1.86 //y=0.91 //x2=2.445 //y2=1.59
cc_1583 ( N_noxref_7_c_2401_n N_noxref_14_M0_noxref_s ) capacitor c=0.023368f \
 //x=3.015 //y=0.995 //x2=0.455 //y2=0.375
cc_1584 ( N_noxref_7_c_2428_p N_noxref_14_M0_noxref_s ) capacitor c=0.0175532f \
 //x=3.1 //y=0.625 //x2=0.455 //y2=0.375
cc_1585 ( N_noxref_7_c_2430_p N_noxref_14_M0_noxref_s ) capacitor \
 c=2.98721e-19 //x=4.07 //y=0.625 //x2=0.455 //y2=0.375
cc_1586 ( N_noxref_7_M1_noxref_d N_noxref_14_M0_noxref_s ) capacitor \
 c=0.0187969f //x=1.86 //y=0.91 //x2=0.455 //y2=0.375
cc_1587 ( N_noxref_7_M2_noxref_s N_noxref_14_M0_noxref_s ) capacitor \
 c=0.021082f //x=2.965 //y=0.375 //x2=0.455 //y2=0.375
cc_1588 ( N_noxref_7_c_2430_p N_noxref_15_M3_noxref_s ) capacitor \
 c=0.00370912f //x=4.07 //y=0.625 //x2=5.37 //y2=0.365
cc_1589 ( N_noxref_7_M2_noxref_s N_noxref_15_M3_noxref_s ) capacitor \
 c=0.00101401f //x=2.965 //y=0.375 //x2=5.37 //y2=0.365
cc_1590 ( N_noxref_8_c_2463_n N_noxref_12_c_2907_n ) capacitor c=0.00234099f \
 //x=6.66 //y=2.08 //x2=9.235 //y2=0
cc_1591 ( N_noxref_8_c_2463_n N_noxref_12_c_2927_n ) capacitor c=3.77673e-19 \
 //x=6.66 //y=2.08 //x2=7.97 //y2=0
cc_1592 ( N_noxref_8_c_2465_n N_noxref_12_c_2935_n ) capacitor c=0.00224736f \
 //x=6.66 //y=2.08 //x2=8.14 //y2=0
cc_1593 ( N_noxref_8_c_2491_n N_noxref_12_c_2935_n ) capacitor c=0.00275184f \
 //x=7.225 //y=1.25 //x2=8.14 //y2=0
cc_1594 ( N_noxref_8_c_2495_n N_noxref_12_c_2935_n ) capacitor c=2.63786e-19 \
 //x=6.66 //y=2.08 //x2=8.14 //y2=0
cc_1595 ( N_noxref_8_c_2463_n N_noxref_15_c_3497_n ) capacitor c=7.50092e-19 \
 //x=6.66 //y=2.08 //x2=6.475 //y2=1.495
cc_1596 ( N_noxref_8_c_2479_n N_noxref_15_c_3497_n ) capacitor c=0.00888238f \
 //x=6.695 //y=1.56 //x2=6.475 //y2=1.495
cc_1597 ( N_noxref_8_c_2495_n N_noxref_15_c_3497_n ) capacitor c=0.00175171f \
 //x=6.66 //y=2.08 //x2=6.475 //y2=1.495
cc_1598 ( N_noxref_8_c_2463_n N_noxref_15_c_3499_n ) capacitor c=0.00141156f \
 //x=6.66 //y=2.08 //x2=7.36 //y2=0.53
cc_1599 ( N_noxref_8_c_2465_n N_noxref_15_c_3499_n ) capacitor c=8.82141e-19 \
 //x=6.66 //y=2.08 //x2=7.36 //y2=0.53
cc_1600 ( N_noxref_8_c_2474_n N_noxref_15_c_3499_n ) capacitor c=0.0199501f \
 //x=6.695 //y=0.905 //x2=7.36 //y2=0.53
cc_1601 ( N_noxref_8_c_2489_n N_noxref_15_c_3499_n ) capacitor c=0.00825432f \
 //x=7.225 //y=0.905 //x2=7.36 //y2=0.53
cc_1602 ( N_noxref_8_c_2495_n N_noxref_15_c_3499_n ) capacitor c=2.1838e-19 \
 //x=6.66 //y=2.08 //x2=7.36 //y2=0.53
cc_1603 ( N_noxref_8_c_2474_n N_noxref_15_M3_noxref_s ) capacitor \
 c=0.00888238f //x=6.695 //y=0.905 //x2=5.37 //y2=0.365
cc_1604 ( N_noxref_8_c_2489_n N_noxref_15_M3_noxref_s ) capacitor c=0.015333f \
 //x=7.225 //y=0.905 //x2=5.37 //y2=0.365
cc_1605 ( N_noxref_8_c_2491_n N_noxref_15_M3_noxref_s ) capacitor \
 c=0.00248746f //x=7.225 //y=1.25 //x2=5.37 //y2=0.365
cc_1606 ( N_noxref_9_c_2566_n N_noxref_10_c_2671_n ) capacitor c=0.0224225f \
 //x=16.65 //y=4.555 //x2=16.795 //y2=5.2
cc_1607 ( N_noxref_9_c_2575_n N_noxref_10_c_2671_n ) capacitor c=2.10628e-19 \
 //x=16.65 //y=2.08 //x2=16.795 //y2=5.2
cc_1608 ( N_noxref_9_c_2582_n N_noxref_10_c_2671_n ) capacitor c=0.00469257f \
 //x=16.68 //y=4.7 //x2=16.795 //y2=5.2
cc_1609 ( N_noxref_9_M33_noxref_g N_noxref_10_c_2671_n ) capacitor \
 c=0.00842859f //x=16.69 //y=6.02 //x2=16.795 //y2=5.2
cc_1610 ( N_noxref_9_c_2601_n N_noxref_10_c_2671_n ) capacitor c=9.61466e-19 \
 //x=16.68 //y=4.7 //x2=16.795 //y2=5.2
cc_1611 ( N_noxref_9_c_2591_n N_noxref_10_c_2687_n ) capacitor c=0.00119008f \
 //x=16.685 //y=1.25 //x2=16.95 //y2=1.57
cc_1612 ( N_noxref_9_c_2593_n N_noxref_10_c_2687_n ) capacitor c=0.00438634f \
 //x=16.685 //y=1.56 //x2=16.95 //y2=1.57
cc_1613 ( N_noxref_9_c_2623_p N_noxref_10_c_2687_n ) capacitor c=0.00916852f \
 //x=17.06 //y=1.405 //x2=16.95 //y2=1.57
cc_1614 ( N_noxref_9_c_2597_n N_noxref_10_c_2687_n ) capacitor c=0.003249f \
 //x=17.215 //y=1.25 //x2=16.95 //y2=1.57
cc_1615 ( N_noxref_9_c_2625_p N_noxref_10_c_2687_n ) capacitor c=0.00341114f \
 //x=16.65 //y=1.915 //x2=16.95 //y2=1.57
cc_1616 ( N_noxref_9_M34_noxref_g N_noxref_10_c_2703_n ) capacitor \
 c=0.0110279f //x=17.13 //y=6.02 //x2=17.305 //y2=5.2
cc_1617 ( N_noxref_9_c_2623_p N_noxref_10_c_2746_n ) capacitor c=0.00194324f \
 //x=17.06 //y=1.405 //x2=17.305 //y2=1.655
cc_1618 ( N_noxref_9_c_2597_n N_noxref_10_c_2746_n ) capacitor c=0.00323005f \
 //x=17.215 //y=1.25 //x2=17.305 //y2=1.655
cc_1619 ( N_noxref_9_c_2566_n N_noxref_10_c_2672_n ) capacitor c=0.118938f \
 //x=16.65 //y=4.555 //x2=17.39 //y2=5.115
cc_1620 ( N_noxref_9_c_2575_n N_noxref_10_c_2672_n ) capacitor c=0.015397f \
 //x=16.65 //y=2.08 //x2=17.39 //y2=5.115
cc_1621 ( N_noxref_9_c_2578_n N_noxref_10_c_2672_n ) capacitor c=9.90728e-19 \
 //x=16.65 //y=2.08 //x2=17.39 //y2=5.115
cc_1622 ( N_noxref_9_c_2582_n N_noxref_10_c_2672_n ) capacitor c=7.76118e-19 \
 //x=16.68 //y=4.7 //x2=17.39 //y2=5.115
cc_1623 ( N_noxref_9_c_2613_n N_noxref_10_c_2672_n ) capacitor c=0.00461871f \
 //x=17.055 //y=4.79 //x2=17.39 //y2=5.115
cc_1624 ( N_noxref_9_c_2598_n N_noxref_10_c_2672_n ) capacitor c=0.00271446f \
 //x=16.65 //y=2.08 //x2=17.39 //y2=5.115
cc_1625 ( N_noxref_9_c_2601_n N_noxref_10_c_2672_n ) capacitor c=0.00142201f \
 //x=16.68 //y=4.7 //x2=17.39 //y2=5.115
cc_1626 ( N_noxref_9_M33_noxref_g N_noxref_10_c_2697_n ) capacitor \
 c=0.00192712f //x=16.69 //y=6.02 //x2=16.91 //y2=5.2
cc_1627 ( N_noxref_9_M34_noxref_g N_noxref_10_c_2697_n ) capacitor \
 c=0.00298276f //x=17.13 //y=6.02 //x2=16.91 //y2=5.2
cc_1628 ( N_noxref_9_c_2613_n N_noxref_10_c_2697_n ) capacitor c=0.0020909f \
 //x=17.055 //y=4.79 //x2=16.91 //y2=5.2
cc_1629 ( N_noxref_9_c_2588_n N_noxref_10_c_2698_n ) capacitor c=0.00120406f \
 //x=16.685 //y=0.905 //x2=16.95 //y2=1
cc_1630 ( N_noxref_9_c_2591_n N_noxref_10_c_2698_n ) capacitor c=0.00218694f \
 //x=16.685 //y=1.25 //x2=16.95 //y2=1
cc_1631 ( N_noxref_9_c_2641_p N_noxref_10_c_2698_n ) capacitor c=5.50523e-19 \
 //x=17.06 //y=0.75 //x2=16.95 //y2=1
cc_1632 ( N_noxref_9_c_2623_p N_noxref_10_c_2698_n ) capacitor c=5.67071e-19 \
 //x=17.06 //y=1.405 //x2=16.95 //y2=1
cc_1633 ( N_noxref_9_c_2596_n N_noxref_10_c_2698_n ) capacitor c=0.00109205f \
 //x=17.215 //y=0.905 //x2=16.95 //y2=1
cc_1634 ( N_noxref_9_c_2597_n N_noxref_10_c_2698_n ) capacitor c=0.00317092f \
 //x=17.215 //y=1.25 //x2=16.95 //y2=1
cc_1635 ( N_noxref_9_M33_noxref_g N_noxref_10_c_2730_n ) capacitor \
 c=0.0178987f //x=16.69 //y=6.02 //x2=16.91 //y2=5.38
cc_1636 ( N_noxref_9_M34_noxref_g N_noxref_10_c_2730_n ) capacitor \
 c=0.0178506f //x=17.13 //y=6.02 //x2=16.91 //y2=5.38
cc_1637 ( N_noxref_9_c_2613_n N_noxref_10_c_2730_n ) capacitor c=0.00291714f \
 //x=17.055 //y=4.79 //x2=16.91 //y2=5.38
cc_1638 ( N_noxref_9_c_2588_n N_noxref_10_M10_noxref_d ) capacitor \
 c=0.00137165f //x=16.685 //y=0.905 //x2=16.76 //y2=0.905
cc_1639 ( N_noxref_9_c_2591_n N_noxref_10_M10_noxref_d ) capacitor \
 c=0.00237422f //x=16.685 //y=1.25 //x2=16.76 //y2=0.905
cc_1640 ( N_noxref_9_c_2641_p N_noxref_10_M10_noxref_d ) capacitor \
 c=0.0020782f //x=17.06 //y=0.75 //x2=16.76 //y2=0.905
cc_1641 ( N_noxref_9_c_2623_p N_noxref_10_M10_noxref_d ) capacitor \
 c=0.00356097f //x=17.06 //y=1.405 //x2=16.76 //y2=0.905
cc_1642 ( N_noxref_9_c_2596_n N_noxref_10_M10_noxref_d ) capacitor \
 c=8.50095e-19 //x=17.215 //y=0.905 //x2=16.76 //y2=0.905
cc_1643 ( N_noxref_9_c_2597_n N_noxref_10_M10_noxref_d ) capacitor \
 c=0.00237422f //x=17.215 //y=1.25 //x2=16.76 //y2=0.905
cc_1644 ( N_noxref_9_c_2566_n N_noxref_11_c_2811_n ) capacitor c=0.00467253f \
 //x=16.65 //y=4.555 //x2=19.242 //y2=4.56
cc_1645 ( N_noxref_9_c_2575_n N_noxref_12_c_3137_n ) capacitor c=0.00234099f \
 //x=16.65 //y=2.08 //x2=19.225 //y2=0
cc_1646 ( N_noxref_9_c_2575_n N_noxref_12_c_3029_n ) capacitor c=3.77673e-19 \
 //x=16.65 //y=2.08 //x2=17.96 //y2=0
cc_1647 ( N_noxref_9_c_2578_n N_noxref_12_c_3100_n ) capacitor c=0.00224736f \
 //x=16.65 //y=2.08 //x2=18.13 //y2=0
cc_1648 ( N_noxref_9_c_2597_n N_noxref_12_c_3100_n ) capacitor c=0.00275184f \
 //x=17.215 //y=1.25 //x2=18.13 //y2=0
cc_1649 ( N_noxref_9_c_2598_n N_noxref_12_c_3100_n ) capacitor c=2.63786e-19 \
 //x=16.65 //y=2.08 //x2=18.13 //y2=0
cc_1650 ( N_noxref_9_c_2575_n N_noxref_18_c_3704_n ) capacitor c=7.471e-19 \
 //x=16.65 //y=2.08 //x2=16.465 //y2=1.495
cc_1651 ( N_noxref_9_c_2593_n N_noxref_18_c_3704_n ) capacitor c=0.00890678f \
 //x=16.685 //y=1.56 //x2=16.465 //y2=1.495
cc_1652 ( N_noxref_9_c_2598_n N_noxref_18_c_3704_n ) capacitor c=0.00173073f \
 //x=16.65 //y=2.08 //x2=16.465 //y2=1.495
cc_1653 ( N_noxref_9_c_2575_n N_noxref_18_c_3711_n ) capacitor c=0.00141156f \
 //x=16.65 //y=2.08 //x2=17.35 //y2=0.53
cc_1654 ( N_noxref_9_c_2578_n N_noxref_18_c_3711_n ) capacitor c=8.82141e-19 \
 //x=16.65 //y=2.08 //x2=17.35 //y2=0.53
cc_1655 ( N_noxref_9_c_2588_n N_noxref_18_c_3711_n ) capacitor c=0.0199501f \
 //x=16.685 //y=0.905 //x2=17.35 //y2=0.53
cc_1656 ( N_noxref_9_c_2596_n N_noxref_18_c_3711_n ) capacitor c=0.00825432f \
 //x=17.215 //y=0.905 //x2=17.35 //y2=0.53
cc_1657 ( N_noxref_9_c_2598_n N_noxref_18_c_3711_n ) capacitor c=2.1838e-19 \
 //x=16.65 //y=2.08 //x2=17.35 //y2=0.53
cc_1658 ( N_noxref_9_c_2588_n N_noxref_18_M9_noxref_s ) capacitor \
 c=0.00890678f //x=16.685 //y=0.905 //x2=15.36 //y2=0.365
cc_1659 ( N_noxref_9_c_2596_n N_noxref_18_M9_noxref_s ) capacitor c=0.015333f \
 //x=17.215 //y=0.905 //x2=15.36 //y2=0.365
cc_1660 ( N_noxref_9_c_2597_n N_noxref_18_M9_noxref_s ) capacitor \
 c=0.00248746f //x=17.215 //y=1.25 //x2=15.36 //y2=0.365
cc_1661 ( N_noxref_10_c_2672_n N_noxref_11_c_2803_n ) capacitor c=0.00457386f \
 //x=17.39 //y=5.115 //x2=19.24 //y2=2.08
cc_1662 ( N_noxref_10_c_2672_n N_noxref_11_c_2807_n ) capacitor c=0.00476843f \
 //x=17.39 //y=5.115 //x2=19.24 //y2=4.7
cc_1663 ( N_noxref_10_c_2672_n N_noxref_11_c_2811_n ) capacitor c=0.0399479f \
 //x=17.39 //y=5.115 //x2=19.242 //y2=4.56
cc_1664 ( N_noxref_10_c_2746_n N_noxref_12_c_3137_n ) capacitor c=0.00651357f \
 //x=17.305 //y=1.655 //x2=19.225 //y2=0
cc_1665 ( N_noxref_10_c_2698_n N_noxref_12_c_3137_n ) capacitor c=0.00963092f \
 //x=16.95 //y=1 //x2=19.225 //y2=0
cc_1666 ( N_noxref_10_M10_noxref_d N_noxref_12_c_3137_n ) capacitor \
 c=3.01654e-19 //x=16.76 //y=0.905 //x2=19.225 //y2=0
cc_1667 ( N_noxref_10_c_2674_n N_noxref_12_c_3015_n ) capacitor c=6.12504e-19 \
 //x=16.03 //y=5.38 //x2=15.98 //y2=0.955
cc_1668 ( N_noxref_10_c_2698_n N_noxref_12_c_3015_n ) capacitor c=0.0140087f \
 //x=16.95 //y=1 //x2=15.98 //y2=0.955
cc_1669 ( N_noxref_10_M10_noxref_d N_noxref_12_c_3015_n ) capacitor \
 c=2.93544e-19 //x=16.76 //y=0.905 //x2=15.98 //y2=0.955
cc_1670 ( N_noxref_10_c_2698_n N_noxref_12_c_3148_n ) capacitor c=0.00549186f \
 //x=16.95 //y=1 //x2=19.31 //y2=0.955
cc_1671 ( N_noxref_10_c_2746_n N_noxref_12_c_3029_n ) capacitor c=0.00103764f \
 //x=17.305 //y=1.655 //x2=17.96 //y2=0
cc_1672 ( N_noxref_10_c_2698_n N_noxref_12_c_2929_n ) capacitor c=2.83275e-19 \
 //x=16.95 //y=1 //x2=21.09 //y2=0
cc_1673 ( N_noxref_10_c_2687_n N_noxref_12_c_3100_n ) capacitor c=0.002973f \
 //x=16.95 //y=1.57 //x2=18.13 //y2=0
cc_1674 ( N_noxref_10_c_2746_n N_noxref_12_c_3100_n ) capacitor c=0.0321496f \
 //x=17.305 //y=1.655 //x2=18.13 //y2=0
cc_1675 ( N_noxref_10_c_2698_n N_noxref_12_M9_noxref_d ) capacitor \
 c=2.82748e-19 //x=16.95 //y=1 //x2=15.79 //y2=0.865
cc_1676 ( N_noxref_10_c_2687_n N_noxref_13_c_3332_n ) capacitor c=0.00324213f \
 //x=16.95 //y=1.57 //x2=20.28 //y2=1.57
cc_1677 ( N_noxref_10_c_2746_n N_noxref_13_c_3405_n ) capacitor c=0.00271739f \
 //x=17.305 //y=1.655 //x2=20.365 //y2=1.655
cc_1678 ( N_noxref_10_c_2672_n N_noxref_13_c_3340_n ) capacitor c=0.00110039f \
 //x=17.39 //y=5.115 //x2=20.72 //y2=5.115
cc_1679 ( N_noxref_10_c_2703_n N_noxref_13_c_3351_n ) capacitor c=0.00114153f \
 //x=17.305 //y=5.2 //x2=19.36 //y2=5.38
cc_1680 ( N_noxref_10_c_2697_n N_noxref_13_c_3351_n ) capacitor c=5.29822e-19 \
 //x=16.91 //y=5.2 //x2=19.36 //y2=5.38
cc_1681 ( N_noxref_10_c_2719_n N_noxref_13_c_3351_n ) capacitor c=0.00147119f \
 //x=16.91 //y=5.38 //x2=19.36 //y2=5.38
cc_1682 ( N_noxref_10_c_2698_n N_noxref_13_c_3356_n ) capacitor c=6.99317e-19 \
 //x=16.95 //y=1 //x2=20.28 //y2=1
cc_1683 ( N_noxref_10_c_2688_n N_noxref_18_c_3704_n ) capacitor c=0.00911498f \
 //x=17.035 //y=1.655 //x2=16.465 //y2=1.495
cc_1684 ( N_noxref_10_c_2746_n N_noxref_18_c_3711_n ) capacitor c=0.00361884f \
 //x=17.305 //y=1.655 //x2=17.35 //y2=0.53
cc_1685 ( N_noxref_10_c_2698_n N_noxref_18_c_3711_n ) capacitor c=0.00367971f \
 //x=16.95 //y=1 //x2=17.35 //y2=0.53
cc_1686 ( N_noxref_10_M10_noxref_d N_noxref_18_c_3711_n ) capacitor \
 c=0.00910163f //x=16.76 //y=0.905 //x2=17.35 //y2=0.53
cc_1687 ( N_noxref_10_c_2687_n N_noxref_18_M9_noxref_s ) capacitor \
 c=0.0162484f //x=16.95 //y=1.57 //x2=15.36 //y2=0.365
cc_1688 ( N_noxref_10_c_2746_n N_noxref_18_M9_noxref_s ) capacitor \
 c=0.0078077f //x=17.305 //y=1.655 //x2=15.36 //y2=0.365
cc_1689 ( N_noxref_10_c_2698_n N_noxref_18_M9_noxref_s ) capacitor \
 c=0.00905169f //x=16.95 //y=1 //x2=15.36 //y2=0.365
cc_1690 ( N_noxref_10_M10_noxref_d N_noxref_18_M9_noxref_s ) capacitor \
 c=0.0275552f //x=16.76 //y=0.905 //x2=15.36 //y2=0.365
cc_1691 ( N_noxref_11_c_2803_n N_noxref_12_c_3148_n ) capacitor c=0.00709452f \
 //x=19.24 //y=2.08 //x2=19.31 //y2=0.955
cc_1692 ( N_noxref_11_c_2817_n N_noxref_12_c_3148_n ) capacitor c=2.13705e-19 \
 //x=19.24 //y=2.08 //x2=19.31 //y2=0.955
cc_1693 ( N_noxref_11_c_2827_n N_noxref_12_c_3148_n ) capacitor c=0.00171023f \
 //x=19.045 //y=0.865 //x2=19.31 //y2=0.955
cc_1694 ( N_noxref_11_c_2828_n N_noxref_12_c_3148_n ) capacitor c=0.00357815f \
 //x=19.045 //y=1.21 //x2=19.31 //y2=0.955
cc_1695 ( N_noxref_11_c_2829_n N_noxref_12_c_3148_n ) capacitor c=4.2764e-19 \
 //x=19.045 //y=1.52 //x2=19.31 //y2=0.955
cc_1696 ( N_noxref_11_c_2863_p N_noxref_12_c_3148_n ) capacitor c=7.35788e-19 \
 //x=19.42 //y=0.71 //x2=19.31 //y2=0.955
cc_1697 ( N_noxref_11_c_2864_p N_noxref_12_c_3148_n ) capacitor c=6.38426e-19 \
 //x=19.42 //y=1.365 //x2=19.31 //y2=0.955
cc_1698 ( N_noxref_11_c_2835_n N_noxref_12_c_3148_n ) capacitor c=0.00158609f \
 //x=19.575 //y=0.865 //x2=19.31 //y2=0.955
cc_1699 ( N_noxref_11_c_2837_n N_noxref_12_c_3148_n ) capacitor c=0.00296337f \
 //x=19.575 //y=1.21 //x2=19.31 //y2=0.955
cc_1700 ( N_noxref_11_c_2827_n N_noxref_12_c_3163_n ) capacitor c=3.46594e-19 \
 //x=19.045 //y=0.865 //x2=19.307 //y2=0.825
cc_1701 ( N_noxref_11_c_2863_p N_noxref_12_c_3163_n ) capacitor c=0.00852028f \
 //x=19.42 //y=0.71 //x2=19.307 //y2=0.825
cc_1702 ( N_noxref_11_c_2835_n N_noxref_12_c_3163_n ) capacitor c=4.45447e-19 \
 //x=19.575 //y=0.865 //x2=19.307 //y2=0.825
cc_1703 ( N_noxref_11_c_2827_n N_noxref_12_c_2929_n ) capacitor c=0.00689257f \
 //x=19.045 //y=0.865 //x2=21.09 //y2=0
cc_1704 ( N_noxref_11_c_2803_n N_noxref_12_c_3100_n ) capacitor c=0.00427323f \
 //x=19.24 //y=2.08 //x2=18.13 //y2=0
cc_1705 ( N_noxref_11_c_2811_n N_noxref_12_c_3100_n ) capacitor c=0.00829739f \
 //x=19.242 //y=4.56 //x2=18.13 //y2=0
cc_1706 ( N_noxref_11_c_2817_n N_noxref_12_c_3100_n ) capacitor c=0.0038607f \
 //x=19.24 //y=2.08 //x2=18.13 //y2=0
cc_1707 ( N_noxref_11_c_2829_n N_noxref_12_c_3100_n ) capacitor c=0.0015404f \
 //x=19.045 //y=1.52 //x2=18.13 //y2=0
cc_1708 ( N_noxref_11_c_2831_n N_noxref_12_c_3100_n ) capacitor c=0.00908419f \
 //x=19.045 //y=1.915 //x2=18.13 //y2=0
cc_1709 ( N_noxref_11_c_2803_n N_noxref_12_M11_noxref_d ) capacitor \
 c=2.20438e-19 //x=19.24 //y=2.08 //x2=19.12 //y2=0.865
cc_1710 ( N_noxref_11_c_2827_n N_noxref_12_M11_noxref_d ) capacitor \
 c=0.00192399f //x=19.045 //y=0.865 //x2=19.12 //y2=0.865
cc_1711 ( N_noxref_11_c_2828_n N_noxref_12_M11_noxref_d ) capacitor \
 c=0.00210798f //x=19.045 //y=1.21 //x2=19.12 //y2=0.865
cc_1712 ( N_noxref_11_c_2863_p N_noxref_12_M11_noxref_d ) capacitor \
 c=0.00472259f //x=19.42 //y=0.71 //x2=19.12 //y2=0.865
cc_1713 ( N_noxref_11_c_2864_p N_noxref_12_M11_noxref_d ) capacitor \
 c=0.00166857f //x=19.42 //y=1.365 //x2=19.12 //y2=0.865
cc_1714 ( N_noxref_11_c_2835_n N_noxref_12_M11_noxref_d ) capacitor \
 c=0.00230174f //x=19.575 //y=0.865 //x2=19.12 //y2=0.865
cc_1715 ( N_noxref_11_c_2837_n N_noxref_12_M11_noxref_d ) capacitor \
 c=0.00210798f //x=19.575 //y=1.21 //x2=19.12 //y2=0.865
cc_1716 ( N_noxref_11_M36_noxref_g N_noxref_13_c_3326_n ) capacitor \
 c=0.00967396f //x=19.58 //y=6.02 //x2=20.125 //y2=5.2
cc_1717 ( N_noxref_11_c_2811_n N_noxref_13_c_3340_n ) capacitor c=0.00725306f \
 //x=19.242 //y=4.56 //x2=20.72 //y2=5.115
cc_1718 ( N_noxref_11_c_2807_n N_noxref_13_c_3351_n ) capacitor c=0.0118019f \
 //x=19.24 //y=4.7 //x2=19.36 //y2=5.38
cc_1719 ( N_noxref_11_c_2821_n N_noxref_13_c_3351_n ) capacitor c=0.00277154f \
 //x=19.24 //y=4.7 //x2=19.36 //y2=5.38
cc_1720 ( N_noxref_11_M35_noxref_g N_noxref_13_c_3351_n ) capacitor \
 c=0.00201806f //x=19.14 //y=6.02 //x2=19.36 //y2=5.38
cc_1721 ( N_noxref_11_M36_noxref_g N_noxref_13_c_3351_n ) capacitor \
 c=0.00192712f //x=19.58 //y=6.02 //x2=19.36 //y2=5.38
cc_1722 ( N_noxref_11_c_2840_n N_noxref_13_c_3351_n ) capacitor c=0.00207241f \
 //x=19.24 //y=4.7 //x2=19.36 //y2=5.38
cc_1723 ( N_noxref_11_c_2807_n N_noxref_13_c_3394_n ) capacitor c=0.00165549f \
 //x=19.24 //y=4.7 //x2=19.36 //y2=5.38
cc_1724 ( N_noxref_11_c_2821_n N_noxref_13_c_3394_n ) capacitor c=0.00377369f \
 //x=19.24 //y=4.7 //x2=19.36 //y2=5.38
cc_1725 ( N_noxref_11_M35_noxref_g N_noxref_13_c_3394_n ) capacitor \
 c=0.0158358f //x=19.14 //y=6.02 //x2=19.36 //y2=5.38
cc_1726 ( N_noxref_11_M36_noxref_g N_noxref_13_c_3394_n ) capacitor \
 c=0.0178987f //x=19.58 //y=6.02 //x2=19.36 //y2=5.38
cc_1727 ( N_noxref_11_c_2840_n N_noxref_13_c_3394_n ) capacitor c=0.0043218f \
 //x=19.24 //y=4.7 //x2=19.36 //y2=5.38
cc_1728 ( N_noxref_11_c_2831_n N_noxref_19_c_3769_n ) capacitor c=0.00262672f \
 //x=19.045 //y=1.915 //x2=18.825 //y2=1.495
cc_1729 ( N_noxref_11_c_2803_n N_noxref_19_c_3770_n ) capacitor c=0.00509504f \
 //x=19.24 //y=2.08 //x2=19.71 //y2=1.58
cc_1730 ( N_noxref_11_c_2817_n N_noxref_19_c_3770_n ) capacitor c=0.00763108f \
 //x=19.24 //y=2.08 //x2=19.71 //y2=1.58
cc_1731 ( N_noxref_11_c_2829_n N_noxref_19_c_3770_n ) capacitor c=0.00697076f \
 //x=19.045 //y=1.52 //x2=19.71 //y2=1.58
cc_1732 ( N_noxref_11_c_2831_n N_noxref_19_c_3770_n ) capacitor c=0.0193303f \
 //x=19.045 //y=1.915 //x2=19.71 //y2=1.58
cc_1733 ( N_noxref_11_c_2864_p N_noxref_19_c_3770_n ) capacitor c=0.00723574f \
 //x=19.42 //y=1.365 //x2=19.71 //y2=1.58
cc_1734 ( N_noxref_11_c_2837_n N_noxref_19_c_3770_n ) capacitor c=0.00339872f \
 //x=19.575 //y=1.21 //x2=19.71 //y2=1.58
cc_1735 ( N_noxref_11_c_2831_n N_noxref_19_c_3757_n ) capacitor c=6.71402e-19 \
 //x=19.045 //y=1.915 //x2=19.795 //y2=1.495
cc_1736 ( N_noxref_11_c_2827_n N_noxref_19_M11_noxref_s ) capacitor \
 c=0.0294925f //x=19.045 //y=0.865 //x2=18.69 //y2=0.365
cc_1737 ( N_noxref_11_c_2829_n N_noxref_19_M11_noxref_s ) capacitor \
 c=3.48408e-19 //x=19.045 //y=1.52 //x2=18.69 //y2=0.365
cc_1738 ( N_noxref_11_c_2835_n N_noxref_19_M11_noxref_s ) capacitor \
 c=0.0125442f //x=19.575 //y=0.865 //x2=18.69 //y2=0.365
cc_1739 ( N_noxref_12_c_2929_n N_noxref_13_c_3332_n ) capacitor c=0.00528499f \
 //x=21.09 //y=0 //x2=20.28 //y2=1.57
cc_1740 ( N_noxref_12_c_3065_n N_noxref_13_c_3338_n ) capacitor c=0.00651357f \
 //x=21.09 //y=0 //x2=20.635 //y2=1.655
cc_1741 ( N_noxref_12_c_2929_n N_noxref_13_c_3338_n ) capacitor c=0.0406521f \
 //x=21.09 //y=0 //x2=20.635 //y2=1.655
cc_1742 ( N_noxref_12_c_3100_n N_noxref_13_c_3340_n ) capacitor c=3.54807e-19 \
 //x=18.13 //y=0 //x2=20.72 //y2=5.115
cc_1743 ( N_noxref_12_c_3148_n N_noxref_13_c_3351_n ) capacitor c=8.63724e-19 \
 //x=19.31 //y=0.955 //x2=19.36 //y2=5.38
cc_1744 ( N_noxref_12_c_3065_n N_noxref_13_c_3356_n ) capacitor c=0.00963092f \
 //x=21.09 //y=0 //x2=20.28 //y2=1
cc_1745 ( N_noxref_12_c_3148_n N_noxref_13_c_3356_n ) capacitor c=0.0141824f \
 //x=19.31 //y=0.955 //x2=20.28 //y2=1
cc_1746 ( N_noxref_12_c_2929_n N_noxref_13_c_3356_n ) capacitor c=2.83275e-19 \
 //x=21.09 //y=0 //x2=20.28 //y2=1
cc_1747 ( N_noxref_12_M11_noxref_d N_noxref_13_c_3356_n ) capacitor \
 c=2.82748e-19 //x=19.12 //y=0.865 //x2=20.28 //y2=1
cc_1748 ( N_noxref_12_c_3065_n N_noxref_13_M12_noxref_d ) capacitor \
 c=3.01654e-19 //x=21.09 //y=0 //x2=20.09 //y2=0.905
cc_1749 ( N_noxref_12_c_3148_n N_noxref_13_M12_noxref_d ) capacitor \
 c=2.93544e-19 //x=19.31 //y=0.955 //x2=20.09 //y2=0.905
cc_1750 ( N_noxref_12_c_3190_p N_noxref_14_c_3453_n ) capacitor c=0.00294033f \
 //x=0.99 //y=0 //x2=1.475 //y2=1.59
cc_1751 ( N_noxref_12_c_2906_n N_noxref_14_c_3453_n ) capacitor c=7.00327e-19 \
 //x=5.905 //y=0 //x2=1.475 //y2=1.59
cc_1752 ( N_noxref_12_c_3067_n N_noxref_14_c_3453_n ) capacitor c=0.0037937f \
 //x=1.075 //y=0.965 //x2=1.475 //y2=1.59
cc_1753 ( N_noxref_12_c_2926_n N_noxref_14_c_3453_n ) capacitor c=0.00371343f \
 //x=4.64 //y=0 //x2=1.475 //y2=1.59
cc_1754 ( N_noxref_12_M0_noxref_d N_noxref_14_c_3453_n ) capacitor \
 c=0.00578031f //x=0.885 //y=0.875 //x2=1.475 //y2=1.59
cc_1755 ( N_noxref_12_c_3057_n N_noxref_14_c_3464_n ) capacitor c=0.0169052f \
 //x=1.075 //y=0.835 //x2=1.56 //y2=0.625
cc_1756 ( N_noxref_12_c_2906_n N_noxref_14_c_3464_n ) capacitor c=0.00709506f \
 //x=5.905 //y=0 //x2=1.56 //y2=0.625
cc_1757 ( N_noxref_12_c_2926_n N_noxref_14_c_3464_n ) capacitor c=0.0140218f \
 //x=4.64 //y=0 //x2=1.56 //y2=0.625
cc_1758 ( N_noxref_12_c_3082_n N_noxref_14_c_3464_n ) capacitor c=0.00323118f \
 //x=0.74 //y=0 //x2=1.56 //y2=0.625
cc_1759 ( N_noxref_12_c_2906_n N_noxref_14_c_3442_n ) capacitor c=0.013829f \
 //x=5.905 //y=0 //x2=2.445 //y2=0.54
cc_1760 ( N_noxref_12_c_2926_n N_noxref_14_c_3442_n ) capacitor c=0.0356078f \
 //x=4.64 //y=0 //x2=2.445 //y2=0.54
cc_1761 ( N_noxref_12_c_2929_n N_noxref_14_c_3442_n ) capacitor c=0.00177725f \
 //x=21.09 //y=0 //x2=2.445 //y2=0.54
cc_1762 ( N_noxref_12_c_3190_p N_noxref_14_M0_noxref_s ) capacitor \
 c=0.00709506f //x=0.99 //y=0 //x2=0.455 //y2=0.375
cc_1763 ( N_noxref_12_c_3057_n N_noxref_14_M0_noxref_s ) capacitor \
 c=0.0173062f //x=1.075 //y=0.835 //x2=0.455 //y2=0.375
cc_1764 ( N_noxref_12_c_2906_n N_noxref_14_M0_noxref_s ) capacitor \
 c=0.00682701f //x=5.905 //y=0 //x2=0.455 //y2=0.375
cc_1765 ( N_noxref_12_c_3067_n N_noxref_14_M0_noxref_s ) capacitor \
 c=0.0113024f //x=1.075 //y=0.965 //x2=0.455 //y2=0.375
cc_1766 ( N_noxref_12_c_2926_n N_noxref_14_M0_noxref_s ) capacitor c=0.027164f \
 //x=4.64 //y=0 //x2=0.455 //y2=0.375
cc_1767 ( N_noxref_12_c_3082_n N_noxref_14_M0_noxref_s ) capacitor \
 c=0.0675506f //x=0.74 //y=0 //x2=0.455 //y2=0.375
cc_1768 ( N_noxref_12_c_2930_n N_noxref_14_M0_noxref_s ) capacitor \
 c=0.00166451f //x=4.81 //y=0 //x2=0.455 //y2=0.375
cc_1769 ( N_noxref_12_M0_noxref_d N_noxref_14_M0_noxref_s ) capacitor \
 c=0.0271316f //x=0.885 //y=0.875 //x2=0.455 //y2=0.375
cc_1770 ( N_noxref_12_c_2906_n N_noxref_15_c_3495_n ) capacitor c=9.8929e-19 \
 //x=5.905 //y=0 //x2=6.39 //y2=1.58
cc_1771 ( N_noxref_12_c_2907_n N_noxref_15_c_3495_n ) capacitor c=7.45312e-19 \
 //x=9.235 //y=0 //x2=6.39 //y2=1.58
cc_1772 ( N_noxref_12_c_2910_n N_noxref_15_c_3495_n ) capacitor c=0.00402257f \
 //x=5.99 //y=0.955 //x2=6.39 //y2=1.58
cc_1773 ( N_noxref_12_c_2927_n N_noxref_15_c_3495_n ) capacitor c=0.00392341f \
 //x=7.97 //y=0 //x2=6.39 //y2=1.58
cc_1774 ( N_noxref_12_M3_noxref_d N_noxref_15_c_3495_n ) capacitor \
 c=0.00578453f //x=5.8 //y=0.865 //x2=6.39 //y2=1.58
cc_1775 ( N_noxref_12_c_2907_n N_noxref_15_c_3538_n ) capacitor c=0.00681952f \
 //x=9.235 //y=0 //x2=6.475 //y2=0.615
cc_1776 ( N_noxref_12_c_3012_n N_noxref_15_c_3538_n ) capacitor c=0.0120153f \
 //x=5.987 //y=0.825 //x2=6.475 //y2=0.615
cc_1777 ( N_noxref_12_c_2927_n N_noxref_15_c_3538_n ) capacitor c=0.0146219f \
 //x=7.97 //y=0 //x2=6.475 //y2=0.615
cc_1778 ( N_noxref_12_c_2930_n N_noxref_15_c_3538_n ) capacitor c=0.00282583f \
 //x=4.81 //y=0 //x2=6.475 //y2=0.615
cc_1779 ( N_noxref_12_c_2935_n N_noxref_15_c_3538_n ) capacitor c=2.99356e-19 \
 //x=8.14 //y=0 //x2=6.475 //y2=0.615
cc_1780 ( N_noxref_12_c_2930_n N_noxref_15_c_3497_n ) capacitor c=2.8386e-19 \
 //x=4.81 //y=0 //x2=6.475 //y2=1.495
cc_1781 ( N_noxref_12_c_2907_n N_noxref_15_c_3499_n ) capacitor c=0.0100493f \
 //x=9.235 //y=0 //x2=7.36 //y2=0.53
cc_1782 ( N_noxref_12_c_2927_n N_noxref_15_c_3499_n ) capacitor c=0.0374392f \
 //x=7.97 //y=0 //x2=7.36 //y2=0.53
cc_1783 ( N_noxref_12_c_2929_n N_noxref_15_c_3499_n ) capacitor c=0.00198885f \
 //x=21.09 //y=0 //x2=7.36 //y2=0.53
cc_1784 ( N_noxref_12_c_2907_n N_noxref_15_c_3547_n ) capacitor c=0.00250835f \
 //x=9.235 //y=0 //x2=7.445 //y2=0.615
cc_1785 ( N_noxref_12_c_2927_n N_noxref_15_c_3547_n ) capacitor c=0.0145577f \
 //x=7.97 //y=0 //x2=7.445 //y2=0.615
cc_1786 ( N_noxref_12_c_2935_n N_noxref_15_c_3547_n ) capacitor c=0.0392026f \
 //x=8.14 //y=0 //x2=7.445 //y2=0.615
cc_1787 ( N_noxref_12_c_2906_n N_noxref_15_M3_noxref_s ) capacitor \
 c=0.00723598f //x=5.905 //y=0 //x2=5.37 //y2=0.365
cc_1788 ( N_noxref_12_c_2910_n N_noxref_15_M3_noxref_s ) capacitor \
 c=0.0100997f //x=5.99 //y=0.955 //x2=5.37 //y2=0.365
cc_1789 ( N_noxref_12_c_3012_n N_noxref_15_M3_noxref_s ) capacitor \
 c=0.0170652f //x=5.987 //y=0.825 //x2=5.37 //y2=0.365
cc_1790 ( N_noxref_12_c_2927_n N_noxref_15_M3_noxref_s ) capacitor \
 c=0.0146208f //x=7.97 //y=0 //x2=5.37 //y2=0.365
cc_1791 ( N_noxref_12_c_2930_n N_noxref_15_M3_noxref_s ) capacitor \
 c=0.0528206f //x=4.81 //y=0 //x2=5.37 //y2=0.365
cc_1792 ( N_noxref_12_c_2935_n N_noxref_15_M3_noxref_s ) capacitor \
 c=0.0064811f //x=8.14 //y=0 //x2=5.37 //y2=0.365
cc_1793 ( N_noxref_12_M3_noxref_d N_noxref_15_M3_noxref_s ) capacitor \
 c=0.0271276f //x=5.8 //y=0.865 //x2=5.37 //y2=0.365
cc_1794 ( N_noxref_12_c_2907_n N_noxref_16_c_3562_n ) capacitor c=9.7972e-19 \
 //x=9.235 //y=0 //x2=9.72 //y2=1.58
cc_1795 ( N_noxref_12_c_2951_n N_noxref_16_c_3562_n ) capacitor c=7.73914e-19 \
 //x=12.565 //y=0 //x2=9.72 //y2=1.58
cc_1796 ( N_noxref_12_c_2913_n N_noxref_16_c_3562_n ) capacitor c=0.00400645f \
 //x=9.32 //y=0.955 //x2=9.72 //y2=1.58
cc_1797 ( N_noxref_12_c_2928_n N_noxref_16_c_3562_n ) capacitor c=0.00392341f \
 //x=11.3 //y=0 //x2=9.72 //y2=1.58
cc_1798 ( N_noxref_12_M5_noxref_d N_noxref_16_c_3562_n ) capacitor \
 c=0.00578453f //x=9.13 //y=0.865 //x2=9.72 //y2=1.58
cc_1799 ( N_noxref_12_c_2951_n N_noxref_16_c_3603_n ) capacitor c=0.00558916f \
 //x=12.565 //y=0 //x2=9.805 //y2=0.615
cc_1800 ( N_noxref_12_c_2923_n N_noxref_16_c_3603_n ) capacitor c=0.0120153f \
 //x=9.317 //y=0.825 //x2=9.805 //y2=0.615
cc_1801 ( N_noxref_12_c_2928_n N_noxref_16_c_3603_n ) capacitor c=0.0146219f \
 //x=11.3 //y=0 //x2=9.805 //y2=0.615
cc_1802 ( N_noxref_12_c_2935_n N_noxref_16_c_3603_n ) capacitor c=0.00282552f \
 //x=8.14 //y=0 //x2=9.805 //y2=0.615
cc_1803 ( N_noxref_12_c_2976_n N_noxref_16_c_3603_n ) capacitor c=2.99356e-19 \
 //x=11.47 //y=0 //x2=9.805 //y2=0.615
cc_1804 ( N_noxref_12_c_2935_n N_noxref_16_c_3570_n ) capacitor c=2.8386e-19 \
 //x=8.14 //y=0 //x2=9.805 //y2=1.495
cc_1805 ( N_noxref_12_c_2951_n N_noxref_16_c_3575_n ) capacitor c=0.00989231f \
 //x=12.565 //y=0 //x2=10.69 //y2=0.53
cc_1806 ( N_noxref_12_c_2928_n N_noxref_16_c_3575_n ) capacitor c=0.0374392f \
 //x=11.3 //y=0 //x2=10.69 //y2=0.53
cc_1807 ( N_noxref_12_c_2929_n N_noxref_16_c_3575_n ) capacitor c=0.00198885f \
 //x=21.09 //y=0 //x2=10.69 //y2=0.53
cc_1808 ( N_noxref_12_c_2951_n N_noxref_16_c_3612_n ) capacitor c=0.00250835f \
 //x=12.565 //y=0 //x2=10.775 //y2=0.615
cc_1809 ( N_noxref_12_c_2928_n N_noxref_16_c_3612_n ) capacitor c=0.0145577f \
 //x=11.3 //y=0 //x2=10.775 //y2=0.615
cc_1810 ( N_noxref_12_c_2976_n N_noxref_16_c_3612_n ) capacitor c=0.0392026f \
 //x=11.47 //y=0 //x2=10.775 //y2=0.615
cc_1811 ( N_noxref_12_c_2907_n N_noxref_16_M5_noxref_s ) capacitor \
 c=0.00723598f //x=9.235 //y=0 //x2=8.7 //y2=0.365
cc_1812 ( N_noxref_12_c_2913_n N_noxref_16_M5_noxref_s ) capacitor \
 c=0.0099136f //x=9.32 //y=0.955 //x2=8.7 //y2=0.365
cc_1813 ( N_noxref_12_c_2923_n N_noxref_16_M5_noxref_s ) capacitor \
 c=0.0123761f //x=9.317 //y=0.825 //x2=8.7 //y2=0.365
cc_1814 ( N_noxref_12_c_2928_n N_noxref_16_M5_noxref_s ) capacitor \
 c=0.0146208f //x=11.3 //y=0 //x2=8.7 //y2=0.365
cc_1815 ( N_noxref_12_c_2935_n N_noxref_16_M5_noxref_s ) capacitor \
 c=0.0518718f //x=8.14 //y=0 //x2=8.7 //y2=0.365
cc_1816 ( N_noxref_12_c_2976_n N_noxref_16_M5_noxref_s ) capacitor \
 c=0.0064811f //x=11.47 //y=0 //x2=8.7 //y2=0.365
cc_1817 ( N_noxref_12_M5_noxref_d N_noxref_16_M5_noxref_s ) capacitor \
 c=0.0271276f //x=9.13 //y=0.865 //x2=8.7 //y2=0.365
cc_1818 ( N_noxref_12_c_2951_n N_noxref_17_c_3630_n ) capacitor c=9.7972e-19 \
 //x=12.565 //y=0 //x2=13.05 //y2=1.58
cc_1819 ( N_noxref_12_c_2993_n N_noxref_17_c_3630_n ) capacitor c=7.73914e-19 \
 //x=15.895 //y=0 //x2=13.05 //y2=1.58
cc_1820 ( N_noxref_12_c_2958_n N_noxref_17_c_3630_n ) capacitor c=0.00400667f \
 //x=12.65 //y=0.955 //x2=13.05 //y2=1.58
cc_1821 ( N_noxref_12_c_2973_n N_noxref_17_c_3630_n ) capacitor c=0.00392341f \
 //x=14.63 //y=0 //x2=13.05 //y2=1.58
cc_1822 ( N_noxref_12_M7_noxref_d N_noxref_17_c_3630_n ) capacitor \
 c=0.00578453f //x=12.46 //y=0.865 //x2=13.05 //y2=1.58
cc_1823 ( N_noxref_12_c_2993_n N_noxref_17_c_3669_n ) capacitor c=0.00667036f \
 //x=15.895 //y=0 //x2=13.135 //y2=0.615
cc_1824 ( N_noxref_12_c_2968_n N_noxref_17_c_3669_n ) capacitor c=0.0120153f \
 //x=12.647 //y=0.825 //x2=13.135 //y2=0.615
cc_1825 ( N_noxref_12_c_2973_n N_noxref_17_c_3669_n ) capacitor c=0.0146219f \
 //x=14.63 //y=0 //x2=13.135 //y2=0.615
cc_1826 ( N_noxref_12_c_2976_n N_noxref_17_c_3669_n ) capacitor c=0.00282552f \
 //x=11.47 //y=0 //x2=13.135 //y2=0.615
cc_1827 ( N_noxref_12_c_2995_n N_noxref_17_c_3669_n ) capacitor c=2.99356e-19 \
 //x=14.8 //y=0 //x2=13.135 //y2=0.615
cc_1828 ( N_noxref_12_c_2976_n N_noxref_17_c_3638_n ) capacitor c=2.8386e-19 \
 //x=11.47 //y=0 //x2=13.135 //y2=1.495
cc_1829 ( N_noxref_12_c_2993_n N_noxref_17_c_3645_n ) capacitor c=0.00979822f \
 //x=15.895 //y=0 //x2=14.02 //y2=0.53
cc_1830 ( N_noxref_12_c_2973_n N_noxref_17_c_3645_n ) capacitor c=0.037518f \
 //x=14.63 //y=0 //x2=14.02 //y2=0.53
cc_1831 ( N_noxref_12_c_2929_n N_noxref_17_c_3645_n ) capacitor c=0.00198885f \
 //x=21.09 //y=0 //x2=14.02 //y2=0.53
cc_1832 ( N_noxref_12_c_2993_n N_noxref_17_c_3678_n ) capacitor c=0.0032688f \
 //x=15.895 //y=0 //x2=14.105 //y2=0.615
cc_1833 ( N_noxref_12_c_2973_n N_noxref_17_c_3678_n ) capacitor c=0.0144641f \
 //x=14.63 //y=0 //x2=14.105 //y2=0.615
cc_1834 ( N_noxref_12_c_2995_n N_noxref_17_c_3678_n ) capacitor c=0.0392026f \
 //x=14.8 //y=0 //x2=14.105 //y2=0.615
cc_1835 ( N_noxref_12_c_2951_n N_noxref_17_M7_noxref_s ) capacitor \
 c=0.00723598f //x=12.565 //y=0 //x2=12.03 //y2=0.365
cc_1836 ( N_noxref_12_c_2958_n N_noxref_17_M7_noxref_s ) capacitor \
 c=0.0099136f //x=12.65 //y=0.955 //x2=12.03 //y2=0.365
cc_1837 ( N_noxref_12_c_2968_n N_noxref_17_M7_noxref_s ) capacitor \
 c=0.0123761f //x=12.647 //y=0.825 //x2=12.03 //y2=0.365
cc_1838 ( N_noxref_12_c_2973_n N_noxref_17_M7_noxref_s ) capacitor \
 c=0.0146208f //x=14.63 //y=0 //x2=12.03 //y2=0.365
cc_1839 ( N_noxref_12_c_2976_n N_noxref_17_M7_noxref_s ) capacitor \
 c=0.0518718f //x=11.47 //y=0 //x2=12.03 //y2=0.365
cc_1840 ( N_noxref_12_c_2995_n N_noxref_17_M7_noxref_s ) capacitor \
 c=0.0064811f //x=14.8 //y=0 //x2=12.03 //y2=0.365
cc_1841 ( N_noxref_12_M7_noxref_d N_noxref_17_M7_noxref_s ) capacitor \
 c=0.0271276f //x=12.46 //y=0.865 //x2=12.03 //y2=0.365
cc_1842 ( N_noxref_12_c_2993_n N_noxref_18_c_3696_n ) capacitor c=0.00101789f \
 //x=15.895 //y=0 //x2=16.38 //y2=1.58
cc_1843 ( N_noxref_12_c_3137_n N_noxref_18_c_3696_n ) capacitor c=7.73914e-19 \
 //x=19.225 //y=0 //x2=16.38 //y2=1.58
cc_1844 ( N_noxref_12_c_3015_n N_noxref_18_c_3696_n ) capacitor c=0.00400845f \
 //x=15.98 //y=0.955 //x2=16.38 //y2=1.58
cc_1845 ( N_noxref_12_c_3029_n N_noxref_18_c_3696_n ) capacitor c=0.00392341f \
 //x=17.96 //y=0 //x2=16.38 //y2=1.58
cc_1846 ( N_noxref_12_M9_noxref_d N_noxref_18_c_3696_n ) capacitor \
 c=0.00578453f //x=15.79 //y=0.865 //x2=16.38 //y2=1.58
cc_1847 ( N_noxref_12_c_3137_n N_noxref_18_c_3732_n ) capacitor c=0.00681952f \
 //x=19.225 //y=0 //x2=16.465 //y2=0.615
cc_1848 ( N_noxref_12_c_3024_n N_noxref_18_c_3732_n ) capacitor c=0.0120153f \
 //x=15.977 //y=0.825 //x2=16.465 //y2=0.615
cc_1849 ( N_noxref_12_c_3029_n N_noxref_18_c_3732_n ) capacitor c=0.0146219f \
 //x=17.96 //y=0 //x2=16.465 //y2=0.615
cc_1850 ( N_noxref_12_c_2995_n N_noxref_18_c_3732_n ) capacitor c=0.00282552f \
 //x=14.8 //y=0 //x2=16.465 //y2=0.615
cc_1851 ( N_noxref_12_c_3100_n N_noxref_18_c_3732_n ) capacitor c=2.99356e-19 \
 //x=18.13 //y=0 //x2=16.465 //y2=0.615
cc_1852 ( N_noxref_12_c_2995_n N_noxref_18_c_3704_n ) capacitor c=2.84067e-19 \
 //x=14.8 //y=0 //x2=16.465 //y2=1.495
cc_1853 ( N_noxref_12_c_3137_n N_noxref_18_c_3711_n ) capacitor c=0.0100595f \
 //x=19.225 //y=0 //x2=17.35 //y2=0.53
cc_1854 ( N_noxref_12_c_3029_n N_noxref_18_c_3711_n ) capacitor c=0.037518f \
 //x=17.96 //y=0 //x2=17.35 //y2=0.53
cc_1855 ( N_noxref_12_c_2929_n N_noxref_18_c_3711_n ) capacitor c=0.00198885f \
 //x=21.09 //y=0 //x2=17.35 //y2=0.53
cc_1856 ( N_noxref_12_c_3137_n N_noxref_18_c_3741_n ) capacitor c=0.00364221f \
 //x=19.225 //y=0 //x2=17.435 //y2=0.615
cc_1857 ( N_noxref_12_c_3029_n N_noxref_18_c_3741_n ) capacitor c=0.0144641f \
 //x=17.96 //y=0 //x2=17.435 //y2=0.615
cc_1858 ( N_noxref_12_c_3100_n N_noxref_18_c_3741_n ) capacitor c=0.0392026f \
 //x=18.13 //y=0 //x2=17.435 //y2=0.615
cc_1859 ( N_noxref_12_c_2993_n N_noxref_18_M9_noxref_s ) capacitor \
 c=0.00723598f //x=15.895 //y=0 //x2=15.36 //y2=0.365
cc_1860 ( N_noxref_12_c_3015_n N_noxref_18_M9_noxref_s ) capacitor \
 c=0.0099136f //x=15.98 //y=0.955 //x2=15.36 //y2=0.365
cc_1861 ( N_noxref_12_c_3024_n N_noxref_18_M9_noxref_s ) capacitor \
 c=0.0123761f //x=15.977 //y=0.825 //x2=15.36 //y2=0.365
cc_1862 ( N_noxref_12_c_3029_n N_noxref_18_M9_noxref_s ) capacitor \
 c=0.0146208f //x=17.96 //y=0 //x2=15.36 //y2=0.365
cc_1863 ( N_noxref_12_c_2995_n N_noxref_18_M9_noxref_s ) capacitor \
 c=0.0518734f //x=14.8 //y=0 //x2=15.36 //y2=0.365
cc_1864 ( N_noxref_12_c_3100_n N_noxref_18_M9_noxref_s ) capacitor \
 c=0.00648459f //x=18.13 //y=0 //x2=15.36 //y2=0.365
cc_1865 ( N_noxref_12_M9_noxref_d N_noxref_18_M9_noxref_s ) capacitor \
 c=0.0271276f //x=15.79 //y=0.865 //x2=15.36 //y2=0.365
cc_1866 ( N_noxref_12_c_3137_n N_noxref_19_c_3770_n ) capacitor c=0.00116473f \
 //x=19.225 //y=0 //x2=19.71 //y2=1.58
cc_1867 ( N_noxref_12_c_3065_n N_noxref_19_c_3770_n ) capacitor c=0.00203715f \
 //x=21.09 //y=0 //x2=19.71 //y2=1.58
cc_1868 ( N_noxref_12_c_3148_n N_noxref_19_c_3770_n ) capacitor c=0.00407704f \
 //x=19.31 //y=0.955 //x2=19.71 //y2=1.58
cc_1869 ( N_noxref_12_c_2929_n N_noxref_19_c_3770_n ) capacitor c=0.00386563f \
 //x=21.09 //y=0 //x2=19.71 //y2=1.58
cc_1870 ( N_noxref_12_M11_noxref_d N_noxref_19_c_3770_n ) capacitor \
 c=0.00578453f //x=19.12 //y=0.865 //x2=19.71 //y2=1.58
cc_1871 ( N_noxref_12_c_3065_n N_noxref_19_c_3785_n ) capacitor c=0.00558835f \
 //x=21.09 //y=0 //x2=19.795 //y2=0.615
cc_1872 ( N_noxref_12_c_3163_n N_noxref_19_c_3785_n ) capacitor c=0.0167642f \
 //x=19.307 //y=0.825 //x2=19.795 //y2=0.615
cc_1873 ( N_noxref_12_c_2929_n N_noxref_19_c_3785_n ) capacitor c=0.0148437f \
 //x=21.09 //y=0 //x2=19.795 //y2=0.615
cc_1874 ( N_noxref_12_c_3100_n N_noxref_19_c_3785_n ) capacitor c=0.00282552f \
 //x=18.13 //y=0 //x2=19.795 //y2=0.615
cc_1875 ( N_noxref_12_c_3100_n N_noxref_19_c_3757_n ) capacitor c=2.84067e-19 \
 //x=18.13 //y=0 //x2=19.795 //y2=1.495
cc_1876 ( N_noxref_12_c_3065_n N_noxref_19_c_3761_n ) capacitor c=0.00993685f \
 //x=21.09 //y=0 //x2=20.68 //y2=0.53
cc_1877 ( N_noxref_12_c_2929_n N_noxref_19_c_3761_n ) capacitor c=0.0395069f \
 //x=21.09 //y=0 //x2=20.68 //y2=0.53
cc_1878 ( N_noxref_12_c_3065_n N_noxref_19_c_3792_n ) capacitor c=0.00364221f \
 //x=21.09 //y=0 //x2=20.765 //y2=0.615
cc_1879 ( N_noxref_12_c_2929_n N_noxref_19_c_3792_n ) capacitor c=0.0567482f \
 //x=21.09 //y=0 //x2=20.765 //y2=0.615
cc_1880 ( N_noxref_12_c_3137_n N_noxref_19_M11_noxref_s ) capacitor \
 c=0.00723598f //x=19.225 //y=0 //x2=18.69 //y2=0.365
cc_1881 ( N_noxref_12_c_3148_n N_noxref_19_M11_noxref_s ) capacitor \
 c=0.0100024f //x=19.31 //y=0.955 //x2=18.69 //y2=0.365
cc_1882 ( N_noxref_12_c_3163_n N_noxref_19_M11_noxref_s ) capacitor \
 c=0.012617f //x=19.307 //y=0.825 //x2=18.69 //y2=0.365
cc_1883 ( N_noxref_12_c_2929_n N_noxref_19_M11_noxref_s ) capacitor \
 c=0.0212635f //x=21.09 //y=0 //x2=18.69 //y2=0.365
cc_1884 ( N_noxref_12_c_3100_n N_noxref_19_M11_noxref_s ) capacitor \
 c=0.0518734f //x=18.13 //y=0 //x2=18.69 //y2=0.365
cc_1885 ( N_noxref_12_M11_noxref_d N_noxref_19_M11_noxref_s ) capacitor \
 c=0.0271276f //x=19.12 //y=0.865 //x2=18.69 //y2=0.365
cc_1886 ( N_noxref_13_c_3405_n N_noxref_19_c_3757_n ) capacitor c=0.00911498f \
 //x=20.365 //y=1.655 //x2=19.795 //y2=1.495
cc_1887 ( N_noxref_13_c_3338_n N_noxref_19_c_3761_n ) capacitor c=0.00361884f \
 //x=20.635 //y=1.655 //x2=20.68 //y2=0.53
cc_1888 ( N_noxref_13_c_3356_n N_noxref_19_c_3761_n ) capacitor c=0.00367971f \
 //x=20.28 //y=1 //x2=20.68 //y2=0.53
cc_1889 ( N_noxref_13_M12_noxref_d N_noxref_19_c_3761_n ) capacitor \
 c=0.00910163f //x=20.09 //y=0.905 //x2=20.68 //y2=0.53
cc_1890 ( N_noxref_13_c_3332_n N_noxref_19_M11_noxref_s ) capacitor \
 c=0.0175047f //x=20.28 //y=1.57 //x2=18.69 //y2=0.365
cc_1891 ( N_noxref_13_c_3338_n N_noxref_19_M11_noxref_s ) capacitor \
 c=0.0078077f //x=20.635 //y=1.655 //x2=18.69 //y2=0.365
cc_1892 ( N_noxref_13_c_3356_n N_noxref_19_M11_noxref_s ) capacitor \
 c=0.0104658f //x=20.28 //y=1 //x2=18.69 //y2=0.365
cc_1893 ( N_noxref_13_M12_noxref_d N_noxref_19_M11_noxref_s ) capacitor \
 c=0.0275552f //x=20.09 //y=0.905 //x2=18.69 //y2=0.365
cc_1894 ( N_noxref_15_c_3497_n N_noxref_16_c_3560_n ) capacitor c=5.34352e-19 \
 //x=6.475 //y=1.495 //x2=8.835 //y2=1.495
cc_1895 ( N_noxref_15_c_3547_n N_noxref_16_M5_noxref_s ) capacitor \
 c=0.0045327f //x=7.445 //y=0.615 //x2=8.7 //y2=0.365
cc_1896 ( N_noxref_15_M3_noxref_s N_noxref_16_M5_noxref_s ) capacitor \
 c=5.34352e-19 //x=5.37 //y=0.365 //x2=8.7 //y2=0.365
cc_1897 ( N_noxref_16_c_3570_n N_noxref_17_c_3628_n ) capacitor c=5.34352e-19 \
 //x=9.805 //y=1.495 //x2=12.165 //y2=1.495
cc_1898 ( N_noxref_16_c_3612_n N_noxref_17_M7_noxref_s ) capacitor \
 c=0.0045327f //x=10.775 //y=0.615 //x2=12.03 //y2=0.365
cc_1899 ( N_noxref_16_M5_noxref_s N_noxref_17_M7_noxref_s ) capacitor \
 c=5.34352e-19 //x=8.7 //y=0.365 //x2=12.03 //y2=0.365
cc_1900 ( N_noxref_17_c_3638_n N_noxref_18_c_3694_n ) capacitor c=5.34352e-19 \
 //x=13.135 //y=1.495 //x2=15.495 //y2=1.495
cc_1901 ( N_noxref_17_c_3678_n N_noxref_18_M9_noxref_s ) capacitor \
 c=0.0045327f //x=14.105 //y=0.615 //x2=15.36 //y2=0.365
cc_1902 ( N_noxref_17_M7_noxref_s N_noxref_18_M9_noxref_s ) capacitor \
 c=5.34352e-19 //x=12.03 //y=0.365 //x2=15.36 //y2=0.365
cc_1903 ( N_noxref_18_c_3704_n N_noxref_19_c_3769_n ) capacitor c=5.34554e-19 \
 //x=16.465 //y=1.495 //x2=18.825 //y2=1.495
cc_1904 ( N_noxref_18_c_3741_n N_noxref_19_M11_noxref_s ) capacitor \
 c=0.0045327f //x=17.435 //y=0.615 //x2=18.69 //y2=0.365
cc_1905 ( N_noxref_18_M9_noxref_s N_noxref_19_M11_noxref_s ) capacitor \
 c=5.34554e-19 //x=15.36 //y=0.365 //x2=18.69 //y2=0.365
