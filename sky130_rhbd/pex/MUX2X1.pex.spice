// File: MUX2X1.spi.pex
// Created: Thu Jan 22 07:06:49 2026
// Program "Calibre xRC"
// Version "v2023.2_27.15"
// Nominal Temperature: 30C
// Circuit Temperature: 30C
//
simulator lang=spectre
subckt PM_MUX2X1\%S ( 1 2 3 4 5 6 7 8 9 10 11 12 13 17 18 27 33 46 49 53 58 59 \
 62 71 76 85 89 90 91 92 93 94 95 96 97 98 102 103 104 106 112 113 114 115 116 \
 117 121 123 126 127 132 146 )
c222 ( 146 0 ) capacitor c=0.0682508f //x=3.82 //y=4.88
c223 ( 132 0 ) capacitor c=0.0526948f //x=1.23 //y=2.265
c224 ( 127 0 ) capacitor c=0.0318956f //x=4.155 //y=1.39
c225 ( 126 0 ) capacitor c=0.0186809f //x=4.155 //y=1.045
c226 ( 123 0 ) capacitor c=0.0141821f //x=4 //y=1.545
c227 ( 121 0 ) capacitor c=0.0158553f //x=4 //y=0.89
c228 ( 117 0 ) capacitor c=0.0818195f //x=3.625 //y=2.095
c229 ( 116 0 ) capacitor c=0.0229235f //x=3.625 //y=1.7
c230 ( 115 0 ) capacitor c=0.0234359f //x=3.625 //y=1.39
c231 ( 114 0 ) capacitor c=0.0198759f //x=3.625 //y=1.045
c232 ( 113 0 ) capacitor c=0.0439576f //x=1.87 //y=1.435
c233 ( 112 0 ) capacitor c=0.0201087f //x=1.87 //y=1.09
c234 ( 106 0 ) capacitor c=0.0161986f //x=1.715 //y=1.59
c235 ( 104 0 ) capacitor c=0.0157807f //x=1.715 //y=0.935
c236 ( 103 0 ) capacitor c=0.0554306f //x=1.46 //y=4.97
c237 ( 102 0 ) capacitor c=0.0406047f //x=1.75 //y=4.97
c238 ( 98 0 ) capacitor c=0.0301471f //x=1.34 //y=2.1
c239 ( 97 0 ) capacitor c=0.0255349f //x=1.34 //y=1.745
c240 ( 96 0 ) capacitor c=0.0234346f //x=1.34 //y=1.435
c241 ( 95 0 ) capacitor c=0.02013f //x=1.34 //y=1.09
c242 ( 94 0 ) capacitor c=0.110369f //x=4.16 //y=6.2
c243 ( 93 0 ) capacitor c=0.154619f //x=3.72 //y=6.2
c244 ( 92 0 ) capacitor c=0.153944f //x=1.825 //y=6.2
c245 ( 91 0 ) capacitor c=0.154411f //x=1.385 //y=6.2
c246 ( 85 0 ) capacitor c=8.13425e-19 //x=3.82 //y=4.88
c247 ( 76 0 ) capacitor c=5.17312e-19 //x=3.82 //y=2.26
c248 ( 71 0 ) capacitor c=9.4527e-19 //x=1.23 //y=4.88
c249 ( 62 0 ) capacitor c=6.43121e-19 //x=1.23 //y=2.265
c250 ( 59 0 ) capacitor c=0.0693034f //x=3.66 //y=3.12
c251 ( 58 0 ) capacitor c=0.00206083f //x=3.82 //y=3.12
c252 ( 53 0 ) capacitor c=0.0127448f //x=1.39 //y=3.14
c253 ( 49 0 ) capacitor c=0.00624278f //x=3.82 //y=4.88
c254 ( 46 0 ) capacitor c=0.00567042f //x=3.82 //y=2.26
c255 ( 33 0 ) capacitor c=0.01346f //x=1.23 //y=2.265
c256 ( 27 0 ) capacitor c=0.0131846f //x=3.82 //y=3.28
c257 ( 18 0 ) capacitor c=0.00982096f //x=1.23 //y=4.76
c258 ( 17 0 ) capacitor c=0.0123553f //x=1.23 //y=3.3
c259 ( 13 0 ) capacitor c=0.0164384f //x=3.82 //y=3.14
c260 ( 12 0 ) capacitor c=0.0184047f //x=1.23 //y=3.14
c261 ( 8 0 ) capacitor c=0.0442006f //x=3.82 //y=3.88
c262 ( 6 0 ) capacitor c=0.0141802f //x=3.82 //y=2.4
c263 ( 2 0 ) capacitor c=0.0625829f //x=1.23 //y=3.51
c264 ( 1 0 ) capacitor c=0.0179469f //x=1.23 //y=2.77
r265 (  144 146 ) resistor r=20.6867 //w=0.233 //l=0.1 //layer=ply \
 //thickness=0.18 //x=3.72 //y=4.88 //x2=3.82 //y2=4.88
r266 (  132 133 ) resistor r=17.5563 //w=0.302 //l=0.11 //layer=ply \
 //thickness=0.18 //x=1.23 //y=2.265 //x2=1.34 //y2=2.265
r267 (  128 146 ) resistor r=70.3348 //w=0.233 //l=0.414367 //layer=ply \
 //thickness=0.18 //x=4.16 //y=5.045 //x2=3.82 //y2=4.88
r268 (  127 148 ) resistor r=45.1352 //w=0.168 //l=0.173853 //layer=ply \
 //thickness=0.18 //x=4.155 //y=1.39 //x2=4.115 //y2=1.545
r269 (  126 147 ) resistor r=45.1352 //w=0.168 //l=0.173853 //layer=ply \
 //thickness=0.18 //x=4.155 //y=1.045 //x2=4.115 //y2=0.89
r270 (  126 127 ) resistor r=176.904 //w=0.094 //l=0.345 //layer=ply \
 //thickness=0.18 //x=4.155 //y=1.045 //x2=4.155 //y2=1.39
r271 (  124 143 ) resistor r=10.701 //w=0.21 //l=0.115 //layer=ply \
 //thickness=0.18 //x=3.78 //y=1.545 //x2=3.665 //y2=1.545
r272 (  123 148 ) resistor r=5.52526 //w=0.168 //l=0.115 //layer=ply \
 //thickness=0.18 //x=4 //y=1.545 //x2=4.115 //y2=1.545
r273 (  122 142 ) resistor r=5.52526 //w=0.168 //l=0.115 //layer=ply \
 //thickness=0.18 //x=3.78 //y=0.89 //x2=3.665 //y2=0.89
r274 (  121 147 ) resistor r=5.52526 //w=0.168 //l=0.115 //layer=ply \
 //thickness=0.18 //x=4 //y=0.89 //x2=4.115 //y2=0.89
r275 (  121 122 ) resistor r=112.809 //w=0.094 //l=0.22 //layer=ply \
 //thickness=0.18 //x=4 //y=0.89 //x2=3.78 //y2=0.89
r276 (  118 144 ) resistor r=13.0941 //w=0.233 //l=0.165 //layer=ply \
 //thickness=0.18 //x=3.72 //y=5.045 //x2=3.72 //y2=4.88
r277 (  117 141 ) resistor r=34.8111 //w=0.27 //l=0.264953 //layer=ply \
 //thickness=0.18 //x=3.625 //y=2.095 //x2=3.82 //y2=2.26
r278 (  116 143 ) resistor r=39.5823 //w=0.21 //l=0.173853 //layer=ply \
 //thickness=0.18 //x=3.625 //y=1.7 //x2=3.665 //y2=1.545
r279 (  116 117 ) resistor r=202.543 //w=0.094 //l=0.395 //layer=ply \
 //thickness=0.18 //x=3.625 //y=1.7 //x2=3.625 //y2=2.095
r280 (  115 143 ) resistor r=39.5823 //w=0.21 //l=0.173853 //layer=ply \
 //thickness=0.18 //x=3.625 //y=1.39 //x2=3.665 //y2=1.545
r281 (  114 142 ) resistor r=45.1352 //w=0.168 //l=0.173853 //layer=ply \
 //thickness=0.18 //x=3.625 //y=1.045 //x2=3.665 //y2=0.89
r282 (  114 115 ) resistor r=176.904 //w=0.094 //l=0.345 //layer=ply \
 //thickness=0.18 //x=3.625 //y=1.045 //x2=3.625 //y2=1.39
r283 (  113 139 ) resistor r=45.1352 //w=0.168 //l=0.173853 //layer=ply \
 //thickness=0.18 //x=1.87 //y=1.435 //x2=1.83 //y2=1.59
r284 (  112 138 ) resistor r=45.1352 //w=0.168 //l=0.173853 //layer=ply \
 //thickness=0.18 //x=1.87 //y=1.09 //x2=1.83 //y2=0.935
r285 (  112 113 ) resistor r=176.904 //w=0.094 //l=0.345 //layer=ply \
 //thickness=0.18 //x=1.87 //y=1.09 //x2=1.87 //y2=1.435
r286 (  107 137 ) resistor r=10.701 //w=0.21 //l=0.115 //layer=ply \
 //thickness=0.18 //x=1.495 //y=1.59 //x2=1.38 //y2=1.59
r287 (  106 139 ) resistor r=5.52526 //w=0.168 //l=0.115 //layer=ply \
 //thickness=0.18 //x=1.715 //y=1.59 //x2=1.83 //y2=1.59
r288 (  105 136 ) resistor r=5.52526 //w=0.168 //l=0.115 //layer=ply \
 //thickness=0.18 //x=1.495 //y=0.935 //x2=1.38 //y2=0.935
r289 (  104 138 ) resistor r=5.52526 //w=0.168 //l=0.115 //layer=ply \
 //thickness=0.18 //x=1.715 //y=0.935 //x2=1.83 //y2=0.935
r290 (  104 105 ) resistor r=112.809 //w=0.094 //l=0.22 //layer=ply \
 //thickness=0.18 //x=1.715 //y=0.935 //x2=1.495 //y2=0.935
r291 (  102 109 ) resistor r=26.9307 //w=0.15 //l=0.106066 //layer=ply \
 //thickness=0.18 //x=1.75 //y=4.97 //x2=1.825 //y2=5.045
r292 (  102 103 ) resistor r=148.702 //w=0.094 //l=0.29 //layer=ply \
 //thickness=0.18 //x=1.75 //y=4.97 //x2=1.46 //y2=4.97
r293 (  99 103 ) resistor r=23.403 //w=0.284 //l=0.106066 //layer=ply \
 //thickness=0.18 //x=1.385 //y=5.045 //x2=1.46 //y2=4.97
r294 (  99 135 ) resistor r=26.3063 //w=0.284 //l=0.229783 //layer=ply \
 //thickness=0.18 //x=1.385 //y=5.045 //x2=1.23 //y2=4.88
r295 (  98 133 ) resistor r=19.1248 //w=0.302 //l=0.165 //layer=ply \
 //thickness=0.18 //x=1.34 //y=2.1 //x2=1.34 //y2=2.265
r296 (  97 137 ) resistor r=39.5823 //w=0.21 //l=0.173853 //layer=ply \
 //thickness=0.18 //x=1.34 //y=1.745 //x2=1.38 //y2=1.59
r297 (  97 98 ) resistor r=182.032 //w=0.094 //l=0.355 //layer=ply \
 //thickness=0.18 //x=1.34 //y=1.745 //x2=1.34 //y2=2.1
r298 (  96 137 ) resistor r=39.5823 //w=0.21 //l=0.173853 //layer=ply \
 //thickness=0.18 //x=1.34 //y=1.435 //x2=1.38 //y2=1.59
r299 (  95 136 ) resistor r=45.1352 //w=0.168 //l=0.173853 //layer=ply \
 //thickness=0.18 //x=1.34 //y=1.09 //x2=1.38 //y2=0.935
r300 (  95 96 ) resistor r=176.904 //w=0.094 //l=0.345 //layer=ply \
 //thickness=0.18 //x=1.34 //y=1.09 //x2=1.34 //y2=1.435
r301 (  94 128 ) resistor r=592.245 //w=0.094 //l=1.155 //layer=ply \
 //thickness=0.18 //x=4.16 //y=6.2 //x2=4.16 //y2=5.045
r302 (  93 118 ) resistor r=592.245 //w=0.094 //l=1.155 //layer=ply \
 //thickness=0.18 //x=3.72 //y=6.2 //x2=3.72 //y2=5.045
r303 (  92 109 ) resistor r=592.245 //w=0.094 //l=1.155 //layer=ply \
 //thickness=0.18 //x=1.825 //y=6.2 //x2=1.825 //y2=5.045
r304 (  91 99 ) resistor r=592.245 //w=0.094 //l=1.155 //layer=ply \
 //thickness=0.18 //x=1.385 //y=6.2 //x2=1.385 //y2=5.045
r305 (  90 123 ) resistor r=56.4043 //w=0.094 //l=0.11 //layer=ply \
 //thickness=0.18 //x=3.89 //y=1.545 //x2=4 //y2=1.545
r306 (  90 124 ) resistor r=56.4043 //w=0.094 //l=0.11 //layer=ply \
 //thickness=0.18 //x=3.89 //y=1.545 //x2=3.78 //y2=1.545
r307 (  89 106 ) resistor r=56.4043 //w=0.094 //l=0.11 //layer=ply \
 //thickness=0.18 //x=1.605 //y=1.59 //x2=1.715 //y2=1.59
r308 (  89 107 ) resistor r=56.4043 //w=0.094 //l=0.11 //layer=ply \
 //thickness=0.18 //x=1.605 //y=1.59 //x2=1.495 //y2=1.59
r309 (  85 146 ) resistor r=152 //w=0.17 //l=0.17 //layer=licon //count=1 \
 //x=3.82 //y=4.88 //x2=3.82 //y2=4.88
r310 (  76 141 ) resistor r=152 //w=0.17 //l=0.17 //layer=licon //count=1 \
 //x=3.82 //y=2.26 //x2=3.82 //y2=2.26
r311 (  71 135 ) resistor r=152 //w=0.17 //l=0.17 //layer=licon //count=1 \
 //x=1.23 //y=4.88 //x2=1.23 //y2=4.88
r312 (  62 132 ) resistor r=152 //w=0.17 //l=0.17 //layer=licon //count=1 \
 //x=1.23 //y=2.265 //x2=1.23 //y2=2.265
r313 (  58 59 ) resistor r=0.10734 //w=0.281 //l=0.16 //layer=m2 \
 //thickness=0.36 //x=3.82 //y=3.12 //x2=3.66 //y2=3.12
r314 (  53 55 ) resistor r=0.10734 //w=0.281 //l=0.16 //layer=m2 \
 //thickness=0.36 //x=1.39 //y=3.14 //x2=1.23 //y2=3.14
r315 (  53 59 ) resistor r=2.16603 //w=0.131 //l=2.27 //layer=m2 \
 //thickness=0.36 //x=1.39 //y=3.14 //x2=3.66 //y2=3.14
r316 (  49 85 ) resistor r=9.3 //w=0.17 //l=0.17 //layer=mcon //count=1 \
 //x=3.82 //y=4.88 //x2=3.82 //y2=4.88
r317 (  49 50 ) resistor r=0.103207 //w=0.196 //l=0.14 //layer=m1 \
 //thickness=0.36 //x=3.822 //y=4.88 //x2=3.822 //y2=4.74
r318 (  46 76 ) resistor r=9.3 //w=0.17 //l=0.17 //layer=mcon //count=1 \
 //x=3.82 //y=2.26 //x2=3.82 //y2=2.26
r319 (  42 58 ) resistor r=4.5 //w=0.15 //l=0.15 //layer=via1 //count=1 \
 //x=3.82 //y=3.12 //x2=3.82 //y2=3.12
r320 (  37 71 ) resistor r=9.3 //w=0.17 //l=0.17 //layer=mcon //count=1 \
 //x=1.23 //y=4.88 //x2=1.23 //y2=4.88
r321 (  33 62 ) resistor r=9.3 //w=0.17 //l=0.17 //layer=mcon //count=1 \
 //x=1.23 //y=2.265 //x2=1.23 //y2=2.265
r322 (  24 42 ) resistor r=0.0911593 //w=0.376 //l=0.184608 //layer=m1 \
 //thickness=0.36 //x=3.82 //y=2.96 //x2=3.767 //y2=3.12
r323 (  23 46 ) resistor r=0.0933015 //w=0.201 //l=0.125 //layer=m1 \
 //thickness=0.36 //x=3.82 //y=2.385 //x2=3.82 //y2=2.26
r324 (  18 37 ) resistor r=0.0732479 //w=0.241 //l=0.122474 //layer=m1 \
 //thickness=0.36 //x=1.23 //y=4.76 //x2=1.235 //y2=4.88
r325 (  13 27 ) resistor r=0.0845104 //w=0.376 //l=0.164378 //layer=m1 \
 //thickness=0.36 //x=3.767 //y=3.14 //x2=3.82 //y2=3.28
r326 (  13 42 ) resistor r=0.00664894 //w=0.376 //l=0.02 //layer=m1 \
 //thickness=0.36 //x=3.767 //y=3.14 //x2=3.767 //y2=3.12
r327 (  12 55 ) resistor r=4.5 //w=0.15 //l=0.15 //layer=via1 //count=1 \
 //x=1.23 //y=3.14 //x2=1.23 //y2=3.14
r328 (  12 17 ) resistor r=0.0911593 //w=0.376 //l=0.184174 //layer=m1 \
 //thickness=0.36 //x=1.282 //y=3.14 //x2=1.23 //y2=3.3
r329 (  12 15 ) resistor r=0.0911593 //w=0.376 //l=0.184174 //layer=m1 \
 //thickness=0.36 //x=1.282 //y=3.14 //x2=1.23 //y2=2.98
r330 (  11 14 ) resistor r=0.0360744 //w=0.211 //l=0.03 //layer=m1 \
 //thickness=0.36 //x=1.23 //y=2.4 //x2=1.23 //y2=2.43
r331 (  11 33 ) resistor r=0.0799763 //w=0.211 //l=0.135 //layer=m1 \
 //thickness=0.36 //x=1.23 //y=2.4 //x2=1.23 //y2=2.265
r332 (  10 50 ) resistor r=0.114504 //w=0.131 //l=0.12 //layer=m1 \
 //thickness=0.36 //x=3.82 //y=4.62 //x2=3.82 //y2=4.74
r333 (  9 10 ) resistor r=0.353053 //w=0.131 //l=0.37 //layer=m1 \
 //thickness=0.36 //x=3.82 //y=4.25 //x2=3.82 //y2=4.62
r334 (  8 9 ) resistor r=0.353053 //w=0.131 //l=0.37 //layer=m1 \
 //thickness=0.36 //x=3.82 //y=3.88 //x2=3.82 //y2=4.25
r335 (  8 27 ) resistor r=0.572519 //w=0.131 //l=0.6 //layer=m1 \
 //thickness=0.36 //x=3.82 //y=3.88 //x2=3.82 //y2=3.28
r336 (  7 24 ) resistor r=0.181298 //w=0.131 //l=0.19 //layer=m1 \
 //thickness=0.36 //x=3.82 //y=2.77 //x2=3.82 //y2=2.96
r337 (  6 7 ) resistor r=0.353053 //w=0.131 //l=0.37 //layer=m1 \
 //thickness=0.36 //x=3.82 //y=2.4 //x2=3.82 //y2=2.77
r338 (  6 23 ) resistor r=0.014313 //w=0.131 //l=0.015 //layer=m1 \
 //thickness=0.36 //x=3.82 //y=2.4 //x2=3.82 //y2=2.385
r339 (  5 18 ) resistor r=0.133588 //w=0.131 //l=0.14 //layer=m1 \
 //thickness=0.36 //x=1.23 //y=4.62 //x2=1.23 //y2=4.76
r340 (  4 5 ) resistor r=0.353053 //w=0.131 //l=0.37 //layer=m1 \
 //thickness=0.36 //x=1.23 //y=4.25 //x2=1.23 //y2=4.62
r341 (  3 4 ) resistor r=0.353053 //w=0.131 //l=0.37 //layer=m1 \
 //thickness=0.36 //x=1.23 //y=3.88 //x2=1.23 //y2=4.25
r342 (  2 3 ) resistor r=0.353053 //w=0.131 //l=0.37 //layer=m1 \
 //thickness=0.36 //x=1.23 //y=3.51 //x2=1.23 //y2=3.88
r343 (  2 17 ) resistor r=0.200382 //w=0.131 //l=0.21 //layer=m1 \
 //thickness=0.36 //x=1.23 //y=3.51 //x2=1.23 //y2=3.3
r344 (  1 15 ) resistor r=0.200382 //w=0.131 //l=0.21 //layer=m1 \
 //thickness=0.36 //x=1.23 //y=2.77 //x2=1.23 //y2=2.98
r345 (  1 14 ) resistor r=0.324427 //w=0.131 //l=0.34 //layer=m1 \
 //thickness=0.36 //x=1.23 //y=2.77 //x2=1.23 //y2=2.43
ends PM_MUX2X1\%S

subckt PM_MUX2X1\%noxref_2 ( 2 4 5 6 7 8 10 11 12 14 15 18 23 27 31 34 35 42 \
 44 45 53 65 74 78 79 80 81 82 83 84 88 90 93 94 104 107 109 )
c256 ( 107 0 ) capacitor c=0.00869746f //x=1.415 //y=1.09
c257 ( 104 0 ) capacitor c=0.0682508f //x=7.15 //y=4.88
c258 ( 94 0 ) capacitor c=0.0318956f //x=7.485 //y=1.39
c259 ( 93 0 ) capacitor c=0.0186809f //x=7.485 //y=1.045
c260 ( 90 0 ) capacitor c=0.0141821f //x=7.33 //y=1.545
c261 ( 88 0 ) capacitor c=0.0158553f //x=7.33 //y=0.89
c262 ( 84 0 ) capacitor c=0.0854244f //x=6.955 //y=2.095
c263 ( 83 0 ) capacitor c=0.0229235f //x=6.955 //y=1.7
c264 ( 82 0 ) capacitor c=0.0234359f //x=6.955 //y=1.39
c265 ( 81 0 ) capacitor c=0.0198759f //x=6.955 //y=1.045
c266 ( 80 0 ) capacitor c=0.110369f //x=7.49 //y=6.2
c267 ( 79 0 ) capacitor c=0.154619f //x=7.05 //y=6.2
c268 ( 74 0 ) capacitor c=8.13425e-19 //x=7.15 //y=4.88
c269 ( 65 0 ) capacitor c=7.85889e-19 //x=7.15 //y=2.26
c270 ( 53 0 ) capacitor c=0.0262474f //x=1.605 //y=5.56
c271 ( 45 0 ) capacitor c=0.154161f //x=6.99 //y=3.52
c272 ( 44 0 ) capacitor c=0.00238894f //x=7.15 //y=3.52
c273 ( 42 0 ) capacitor c=0.00127082f //x=2.13 //y=3.53
c274 ( 35 0 ) capacitor c=0.0340357f //x=7.152 //y=4.74
c275 ( 34 0 ) capacitor c=0.00610769f //x=7.15 //y=4.88
c276 ( 31 0 ) capacitor c=0.00641515f //x=7.15 //y=2.26
c277 ( 27 0 ) capacitor c=0.0160819f //x=7.15 //y=3.51
c278 ( 23 0 ) capacitor c=0.0156888f //x=1.97 //y=3.51
c279 ( 18 0 ) capacitor c=0.0190609f //x=1.6 //y=1.185
c280 ( 15 0 ) capacitor c=0.0126737f //x=7.15 //y=3.68
c281 ( 14 0 ) capacitor c=0.0246383f //x=7.15 //y=3.36
c282 ( 12 0 ) capacitor c=0.0368518f //x=1.97 //y=5.055
c283 ( 11 0 ) capacitor c=0.0123772f //x=1.97 //y=3.69
c284 ( 10 0 ) capacitor c=0.0271897f //x=1.97 //y=3.37
c285 ( 8 0 ) capacitor c=0.00703409f //x=1.69 //y=5.14
c286 ( 7 0 ) capacitor c=0.00776478f //x=1.885 //y=5.14
c287 ( 6 0 ) capacitor c=0.00807721f //x=1.685 //y=2.02
c288 ( 5 0 ) capacitor c=0.0120876f //x=1.885 //y=2.02
c289 ( 4 0 ) capacitor c=0.0121131f //x=1.605 //y=5.42
c290 ( 2 0 ) capacitor c=0.0184708f //x=1.6 //y=1.935
r291 (  102 104 ) resistor r=20.6867 //w=0.233 //l=0.1 //layer=ply \
 //thickness=0.18 //x=7.05 //y=4.88 //x2=7.15 //y2=4.88
r292 (  95 104 ) resistor r=70.3348 //w=0.233 //l=0.414367 //layer=ply \
 //thickness=0.18 //x=7.49 //y=5.045 //x2=7.15 //y2=4.88
r293 (  94 106 ) resistor r=45.1352 //w=0.168 //l=0.173853 //layer=ply \
 //thickness=0.18 //x=7.485 //y=1.39 //x2=7.445 //y2=1.545
r294 (  93 105 ) resistor r=45.1352 //w=0.168 //l=0.173853 //layer=ply \
 //thickness=0.18 //x=7.485 //y=1.045 //x2=7.445 //y2=0.89
r295 (  93 94 ) resistor r=176.904 //w=0.094 //l=0.345 //layer=ply \
 //thickness=0.18 //x=7.485 //y=1.045 //x2=7.485 //y2=1.39
r296 (  91 101 ) resistor r=10.701 //w=0.21 //l=0.115 //layer=ply \
 //thickness=0.18 //x=7.11 //y=1.545 //x2=6.995 //y2=1.545
r297 (  90 106 ) resistor r=5.52526 //w=0.168 //l=0.115 //layer=ply \
 //thickness=0.18 //x=7.33 //y=1.545 //x2=7.445 //y2=1.545
r298 (  89 100 ) resistor r=5.52526 //w=0.168 //l=0.115 //layer=ply \
 //thickness=0.18 //x=7.11 //y=0.89 //x2=6.995 //y2=0.89
r299 (  88 105 ) resistor r=5.52526 //w=0.168 //l=0.115 //layer=ply \
 //thickness=0.18 //x=7.33 //y=0.89 //x2=7.445 //y2=0.89
r300 (  88 89 ) resistor r=112.809 //w=0.094 //l=0.22 //layer=ply \
 //thickness=0.18 //x=7.33 //y=0.89 //x2=7.11 //y2=0.89
r301 (  85 102 ) resistor r=13.0941 //w=0.233 //l=0.165 //layer=ply \
 //thickness=0.18 //x=7.05 //y=5.045 //x2=7.05 //y2=4.88
r302 (  84 99 ) resistor r=34.8111 //w=0.27 //l=0.264953 //layer=ply \
 //thickness=0.18 //x=6.955 //y=2.095 //x2=7.15 //y2=2.26
r303 (  83 101 ) resistor r=39.5823 //w=0.21 //l=0.173853 //layer=ply \
 //thickness=0.18 //x=6.955 //y=1.7 //x2=6.995 //y2=1.545
r304 (  83 84 ) resistor r=202.543 //w=0.094 //l=0.395 //layer=ply \
 //thickness=0.18 //x=6.955 //y=1.7 //x2=6.955 //y2=2.095
r305 (  82 101 ) resistor r=39.5823 //w=0.21 //l=0.173853 //layer=ply \
 //thickness=0.18 //x=6.955 //y=1.39 //x2=6.995 //y2=1.545
r306 (  81 100 ) resistor r=45.1352 //w=0.168 //l=0.173853 //layer=ply \
 //thickness=0.18 //x=6.955 //y=1.045 //x2=6.995 //y2=0.89
r307 (  81 82 ) resistor r=176.904 //w=0.094 //l=0.345 //layer=ply \
 //thickness=0.18 //x=6.955 //y=1.045 //x2=6.955 //y2=1.39
r308 (  80 95 ) resistor r=592.245 //w=0.094 //l=1.155 //layer=ply \
 //thickness=0.18 //x=7.49 //y=6.2 //x2=7.49 //y2=5.045
r309 (  79 85 ) resistor r=592.245 //w=0.094 //l=1.155 //layer=ply \
 //thickness=0.18 //x=7.05 //y=6.2 //x2=7.05 //y2=5.045
r310 (  78 90 ) resistor r=56.4043 //w=0.094 //l=0.11 //layer=ply \
 //thickness=0.18 //x=7.22 //y=1.545 //x2=7.33 //y2=1.545
r311 (  78 91 ) resistor r=56.4043 //w=0.094 //l=0.11 //layer=ply \
 //thickness=0.18 //x=7.22 //y=1.545 //x2=7.11 //y2=1.545
r312 (  74 104 ) resistor r=152 //w=0.17 //l=0.17 //layer=licon //count=1 \
 //x=7.15 //y=4.88 //x2=7.15 //y2=4.88
r313 (  65 99 ) resistor r=152 //w=0.17 //l=0.17 //layer=licon //count=1 \
 //x=7.15 //y=2.26 //x2=7.15 //y2=2.26
r314 (  53 109 ) resistor r=23.615 //w=0.187 //l=0.345 //layer=li \
 //thickness=0.1 //x=1.605 //y=5.56 //x2=1.605 //y2=5.905
r315 (  44 45 ) resistor r=0.10734 //w=0.281 //l=0.16 //layer=m2 \
 //thickness=0.36 //x=7.15 //y=3.52 //x2=6.99 //y2=3.52
r316 (  42 45 ) resistor r=4.6374 //w=0.131 //l=4.86 //layer=m2 \
 //thickness=0.36 //x=2.13 //y=3.51 //x2=6.99 //y2=3.51
r317 (  40 42 ) resistor r=0.10734 //w=0.281 //l=0.16 //layer=m2 \
 //thickness=0.36 //x=1.97 //y=3.53 //x2=2.13 //y2=3.53
r318 (  34 74 ) resistor r=9.3 //w=0.17 //l=0.17 //layer=mcon //count=1 \
 //x=7.15 //y=4.88 //x2=7.15 //y2=4.88
r319 (  34 35 ) resistor r=0.103207 //w=0.196 //l=0.14 //layer=m1 \
 //thickness=0.36 //x=7.152 //y=4.88 //x2=7.152 //y2=4.74
r320 (  31 65 ) resistor r=9.3 //w=0.17 //l=0.17 //layer=mcon //count=1 \
 //x=7.15 //y=2.26 //x2=7.15 //y2=2.26
r321 (  29 44 ) resistor r=4.5 //w=0.15 //l=0.15 //layer=via1 //count=1 \
 //x=7.15 //y=3.52 //x2=7.15 //y2=3.52
r322 (  27 29 ) resistor r=0.00332447 //w=0.376 //l=0.01 //layer=m1 \
 //thickness=0.36 //x=7.097 //y=3.51 //x2=7.097 //y2=3.52
r323 (  25 40 ) resistor r=4.5 //w=0.15 //l=0.15 //layer=via1 //count=1 \
 //x=1.97 //y=3.53 //x2=1.97 //y2=3.53
r324 (  23 25 ) resistor r=0.00664894 //w=0.376 //l=0.02 //layer=m1 \
 //thickness=0.36 //x=2.022 //y=3.51 //x2=2.022 //y2=3.53
r325 (  21 53 ) resistor r=9.3 //w=0.17 //l=0.17 //layer=mcon //count=1 \
 //x=1.605 //y=5.56 //x2=1.605 //y2=5.56
r326 (  18 107 ) resistor r=9.3 //w=0.17 //l=0.17 //layer=mcon //count=1 \
 //x=1.6 //y=1.185 //x2=1.6 //y2=1.185
r327 (  15 29 ) resistor r=0.0911593 //w=0.376 //l=0.184608 //layer=m1 \
 //thickness=0.36 //x=7.15 //y=3.68 //x2=7.097 //y2=3.52
r328 (  15 35 ) resistor r=1.01145 //w=0.131 //l=1.06 //layer=m1 \
 //thickness=0.36 //x=7.15 //y=3.68 //x2=7.15 //y2=4.74
r329 (  14 27 ) resistor r=0.0878349 //w=0.376 //l=0.174499 //layer=m1 \
 //thickness=0.36 //x=7.15 //y=3.36 //x2=7.097 //y2=3.51
r330 (  13 31 ) resistor r=0.0933015 //w=0.201 //l=0.125 //layer=m1 \
 //thickness=0.36 //x=7.15 //y=2.385 //x2=7.15 //y2=2.26
r331 (  13 14 ) resistor r=0.930344 //w=0.131 //l=0.975 //layer=m1 \
 //thickness=0.36 //x=7.15 //y=2.385 //x2=7.15 //y2=3.36
r332 (  11 25 ) resistor r=0.0911593 //w=0.376 //l=0.184174 //layer=m1 \
 //thickness=0.36 //x=1.97 //y=3.69 //x2=2.022 //y2=3.53
r333 (  11 12 ) resistor r=1.30248 //w=0.131 //l=1.365 //layer=m1 \
 //thickness=0.36 //x=1.97 //y=3.69 //x2=1.97 //y2=5.055
r334 (  10 23 ) resistor r=0.0845104 //w=0.376 //l=0.163951 //layer=m1 \
 //thickness=0.36 //x=1.97 //y=3.37 //x2=2.022 //y2=3.51
r335 (  9 10 ) resistor r=1.20706 //w=0.131 //l=1.265 //layer=m1 \
 //thickness=0.36 //x=1.97 //y=2.105 //x2=1.97 //y2=3.37
r336 (  7 12 ) resistor r=0.0698411 //w=0.17 //l=0.120208 //layer=m1 \
 //thickness=0.36 //x=1.885 //y=5.14 //x2=1.97 //y2=5.055
r337 (  7 8 ) resistor r=0.186069 //w=0.131 //l=0.195 //layer=m1 \
 //thickness=0.36 //x=1.885 //y=5.14 //x2=1.69 //y2=5.14
r338 (  5 9 ) resistor r=0.0698411 //w=0.17 //l=0.120208 //layer=m1 \
 //thickness=0.36 //x=1.885 //y=2.02 //x2=1.97 //y2=2.105
r339 (  5 6 ) resistor r=0.19084 //w=0.131 //l=0.2 //layer=m1 //thickness=0.36 \
 //x=1.885 //y=2.02 //x2=1.685 //y2=2.02
r340 (  4 21 ) resistor r=0.086672 //w=0.218 //l=0.14 //layer=m1 \
 //thickness=0.36 //x=1.605 //y=5.42 //x2=1.605 //y2=5.56
r341 (  3 8 ) resistor r=0.0698411 //w=0.17 //l=0.120208 //layer=m1 \
 //thickness=0.36 //x=1.605 //y=5.225 //x2=1.69 //y2=5.14
r342 (  3 4 ) resistor r=0.186069 //w=0.131 //l=0.195 //layer=m1 \
 //thickness=0.36 //x=1.605 //y=5.225 //x2=1.605 //y2=5.42
r343 (  2 6 ) resistor r=0.0698411 //w=0.17 //l=0.120208 //layer=m1 \
 //thickness=0.36 //x=1.6 //y=1.935 //x2=1.685 //y2=2.02
r344 (  1 18 ) resistor r=0.105739 //w=0.201 //l=0.145 //layer=m1 \
 //thickness=0.36 //x=1.6 //y=1.33 //x2=1.6 //y2=1.185
r345 (  1 2 ) resistor r=0.57729 //w=0.131 //l=0.605 //layer=m1 \
 //thickness=0.36 //x=1.6 //y=1.33 //x2=1.6 //y2=1.935
ends PM_MUX2X1\%noxref_2

subckt PM_MUX2X1\%noxref_3 ( 3 8 9 11 12 14 15 16 18 19 23 24 27 29 34 38 40 \
 43 44 46 48 50 52 57 61 69 86 95 99 100 101 102 103 104 105 109 111 114 115 \
 125 128 130 131 )
c306 ( 128 0 ) capacitor c=0.00878249f //x=4.67 //y=1.085
c307 ( 125 0 ) capacitor c=0.0682508f //x=10.48 //y=4.88
c308 ( 115 0 ) capacitor c=0.0318956f //x=10.815 //y=1.39
c309 ( 114 0 ) capacitor c=0.0186809f //x=10.815 //y=1.045
c310 ( 111 0 ) capacitor c=0.0141821f //x=10.66 //y=1.545
c311 ( 109 0 ) capacitor c=0.0158553f //x=10.66 //y=0.89
c312 ( 105 0 ) capacitor c=0.0818149f //x=10.285 //y=2.095
c313 ( 104 0 ) capacitor c=0.0229235f //x=10.285 //y=1.7
c314 ( 103 0 ) capacitor c=0.0234359f //x=10.285 //y=1.39
c315 ( 102 0 ) capacitor c=0.0198759f //x=10.285 //y=1.045
c316 ( 101 0 ) capacitor c=0.110369f //x=10.82 //y=6.2
c317 ( 100 0 ) capacitor c=0.154619f //x=10.38 //y=6.2
c318 ( 95 0 ) capacitor c=8.13425e-19 //x=10.48 //y=4.88
c319 ( 86 0 ) capacitor c=5.17312e-19 //x=10.48 //y=2.26
c320 ( 69 0 ) capacitor c=0.0321204f //x=4.82 //y=5.56
c321 ( 61 0 ) capacitor c=0.0289608f //x=3.94 //y=5.56
c322 ( 57 0 ) capacitor c=0.00245975f //x=5.46 //y=3.12
c323 ( 52 0 ) capacitor c=0.059142f //x=8.845 //y=3.13
c324 ( 50 0 ) capacitor c=0.0343373f //x=8.245 //y=3.14
c325 ( 48 0 ) capacitor c=0.0220123f //x=7.365 //y=3.13
c326 ( 46 0 ) capacitor c=0.0492234f //x=6.765 //y=3.14
c327 ( 44 0 ) capacitor c=0.0428591f //x=10.482 //y=4.74
c328 ( 43 0 ) capacitor c=0.00624278f //x=10.48 //y=4.88
c329 ( 40 0 ) capacitor c=0.00627028f //x=10.48 //y=2.26
c330 ( 38 0 ) capacitor c=0.0145644f //x=10.48 //y=3.14
c331 ( 34 0 ) capacitor c=0.0167172f //x=5.3 //y=3.14
c332 ( 29 0 ) capacitor c=0.0114441f //x=4.86 //y=1.18
c333 ( 27 0 ) capacitor c=6.70882e-19 //x=4.82 //y=5.56
c334 ( 24 0 ) capacitor c=0.0119196f //x=4.82 //y=5.38
c335 ( 23 0 ) capacitor c=0.00964616f //x=3.94 //y=5.56
c336 ( 19 0 ) capacitor c=0.0133945f //x=10.48 //y=3.28
c337 ( 18 0 ) capacitor c=0.0141802f //x=10.48 //y=2.96
c338 ( 16 0 ) capacitor c=0.0571372f //x=5.3 //y=5.295
c339 ( 15 0 ) capacitor c=0.0138111f //x=5.3 //y=3.28
c340 ( 14 0 ) capacitor c=0.0251585f //x=5.3 //y=2.96
c341 ( 12 0 ) capacitor c=0.00662006f //x=4.945 //y=1.835
c342 ( 11 0 ) capacitor c=0.0138229f //x=5.215 //y=1.835
c343 ( 9 0 ) capacitor c=0.0120533f //x=5.215 //y=5.38
c344 ( 8 0 ) capacitor c=0.0101031f //x=4.86 //y=1.75
c345 ( 3 0 ) capacitor c=0.0158797f //x=4.705 //y=5.38
r346 (  123 125 ) resistor r=20.6867 //w=0.233 //l=0.1 //layer=ply \
 //thickness=0.18 //x=10.38 //y=4.88 //x2=10.48 //y2=4.88
r347 (  116 125 ) resistor r=70.3348 //w=0.233 //l=0.414367 //layer=ply \
 //thickness=0.18 //x=10.82 //y=5.045 //x2=10.48 //y2=4.88
r348 (  115 127 ) resistor r=45.1352 //w=0.168 //l=0.173853 //layer=ply \
 //thickness=0.18 //x=10.815 //y=1.39 //x2=10.775 //y2=1.545
r349 (  114 126 ) resistor r=45.1352 //w=0.168 //l=0.173853 //layer=ply \
 //thickness=0.18 //x=10.815 //y=1.045 //x2=10.775 //y2=0.89
r350 (  114 115 ) resistor r=176.904 //w=0.094 //l=0.345 //layer=ply \
 //thickness=0.18 //x=10.815 //y=1.045 //x2=10.815 //y2=1.39
r351 (  112 122 ) resistor r=10.701 //w=0.21 //l=0.115 //layer=ply \
 //thickness=0.18 //x=10.44 //y=1.545 //x2=10.325 //y2=1.545
r352 (  111 127 ) resistor r=5.52526 //w=0.168 //l=0.115 //layer=ply \
 //thickness=0.18 //x=10.66 //y=1.545 //x2=10.775 //y2=1.545
r353 (  110 121 ) resistor r=5.52526 //w=0.168 //l=0.115 //layer=ply \
 //thickness=0.18 //x=10.44 //y=0.89 //x2=10.325 //y2=0.89
r354 (  109 126 ) resistor r=5.52526 //w=0.168 //l=0.115 //layer=ply \
 //thickness=0.18 //x=10.66 //y=0.89 //x2=10.775 //y2=0.89
r355 (  109 110 ) resistor r=112.809 //w=0.094 //l=0.22 //layer=ply \
 //thickness=0.18 //x=10.66 //y=0.89 //x2=10.44 //y2=0.89
r356 (  106 123 ) resistor r=13.0941 //w=0.233 //l=0.165 //layer=ply \
 //thickness=0.18 //x=10.38 //y=5.045 //x2=10.38 //y2=4.88
r357 (  105 120 ) resistor r=34.8111 //w=0.27 //l=0.264953 //layer=ply \
 //thickness=0.18 //x=10.285 //y=2.095 //x2=10.48 //y2=2.26
r358 (  104 122 ) resistor r=39.5823 //w=0.21 //l=0.173853 //layer=ply \
 //thickness=0.18 //x=10.285 //y=1.7 //x2=10.325 //y2=1.545
r359 (  104 105 ) resistor r=202.543 //w=0.094 //l=0.395 //layer=ply \
 //thickness=0.18 //x=10.285 //y=1.7 //x2=10.285 //y2=2.095
r360 (  103 122 ) resistor r=39.5823 //w=0.21 //l=0.173853 //layer=ply \
 //thickness=0.18 //x=10.285 //y=1.39 //x2=10.325 //y2=1.545
r361 (  102 121 ) resistor r=45.1352 //w=0.168 //l=0.173853 //layer=ply \
 //thickness=0.18 //x=10.285 //y=1.045 //x2=10.325 //y2=0.89
r362 (  102 103 ) resistor r=176.904 //w=0.094 //l=0.345 //layer=ply \
 //thickness=0.18 //x=10.285 //y=1.045 //x2=10.285 //y2=1.39
r363 (  101 116 ) resistor r=592.245 //w=0.094 //l=1.155 //layer=ply \
 //thickness=0.18 //x=10.82 //y=6.2 //x2=10.82 //y2=5.045
r364 (  100 106 ) resistor r=592.245 //w=0.094 //l=1.155 //layer=ply \
 //thickness=0.18 //x=10.38 //y=6.2 //x2=10.38 //y2=5.045
r365 (  99 111 ) resistor r=56.4043 //w=0.094 //l=0.11 //layer=ply \
 //thickness=0.18 //x=10.55 //y=1.545 //x2=10.66 //y2=1.545
r366 (  99 112 ) resistor r=56.4043 //w=0.094 //l=0.11 //layer=ply \
 //thickness=0.18 //x=10.55 //y=1.545 //x2=10.44 //y2=1.545
r367 (  95 125 ) resistor r=152 //w=0.17 //l=0.17 //layer=licon //count=1 \
 //x=10.48 //y=4.88 //x2=10.48 //y2=4.88
r368 (  86 120 ) resistor r=152 //w=0.17 //l=0.17 //layer=licon //count=1 \
 //x=10.48 //y=2.26 //x2=10.48 //y2=2.26
r369 (  69 131 ) resistor r=23.615 //w=0.187 //l=0.345 //layer=li \
 //thickness=0.1 //x=4.82 //y=5.56 //x2=4.82 //y2=5.905
r370 (  61 130 ) resistor r=23.615 //w=0.187 //l=0.345 //layer=li \
 //thickness=0.1 //x=3.94 //y=5.56 //x2=3.94 //y2=5.905
r371 (  55 57 ) resistor r=0.10734 //w=0.281 //l=0.16 //layer=m2 \
 //thickness=0.36 //x=5.3 //y=3.12 //x2=5.46 //y2=3.12
r372 (  52 59 ) resistor r=1.03378 //w=0.197 //l=1.62999 //layer=m2 \
 //thickness=0.36 //x=8.845 //y=3.13 //x2=10.47 //y2=3.12
r373 (  52 53 ) resistor r=0.410305 //w=0.131 //l=0.43 //layer=m2 \
 //thickness=0.36 //x=8.845 //y=3.13 //x2=8.415 //y2=3.13
r374 (  50 53 ) resistor r=0.125 //w=0.17 //l=0.174929 //layer=m2 \
 //thickness=0.36 //x=8.245 //y=3.14 //x2=8.415 //y2=3.13
r375 (  50 51 ) resistor r=0.596374 //w=0.131 //l=0.625 //layer=m2 \
 //thickness=0.36 //x=8.245 //y=3.14 //x2=7.62 //y2=3.14
r376 (  48 51 ) resistor r=0.1875 //w=0.17 //l=0.259952 //layer=m2 \
 //thickness=0.36 //x=7.365 //y=3.13 //x2=7.62 //y2=3.14
r377 (  48 49 ) resistor r=0.410305 //w=0.131 //l=0.43 //layer=m2 \
 //thickness=0.36 //x=7.365 //y=3.13 //x2=6.935 //y2=3.13
r378 (  46 49 ) resistor r=0.125 //w=0.17 //l=0.174929 //layer=m2 \
 //thickness=0.36 //x=6.765 //y=3.14 //x2=6.935 //y2=3.13
r379 (  46 57 ) resistor r=1.24523 //w=0.131 //l=1.305 //layer=m2 \
 //thickness=0.36 //x=6.765 //y=3.14 //x2=5.46 //y2=3.14
r380 (  43 95 ) resistor r=9.3 //w=0.17 //l=0.17 //layer=mcon //count=1 \
 //x=10.48 //y=4.88 //x2=10.48 //y2=4.88
r381 (  43 44 ) resistor r=0.103207 //w=0.196 //l=0.14 //layer=m1 \
 //thickness=0.36 //x=10.482 //y=4.88 //x2=10.482 //y2=4.74
r382 (  40 86 ) resistor r=9.3 //w=0.17 //l=0.17 //layer=mcon //count=1 \
 //x=10.48 //y=2.26 //x2=10.48 //y2=2.26
r383 (  36 59 ) resistor r=4.5 //w=0.15 //l=0.15 //layer=via1 //count=1 \
 //x=10.47 //y=3.12 //x2=10.47 //y2=3.12
r384 (  36 38 ) resistor r=0.00673854 //w=0.371 //l=0.02 //layer=m1 \
 //thickness=0.36 //x=10.422 //y=3.12 //x2=10.422 //y2=3.14
r385 (  32 55 ) resistor r=4.5 //w=0.15 //l=0.15 //layer=via1 //count=1 \
 //x=5.3 //y=3.12 //x2=5.3 //y2=3.12
r386 (  32 34 ) resistor r=0.00664894 //w=0.376 //l=0.02 //layer=m1 \
 //thickness=0.36 //x=5.352 //y=3.12 //x2=5.352 //y2=3.14
r387 (  29 128 ) resistor r=9.3 //w=0.17 //l=0.17 //layer=mcon //count=1 \
 //x=4.86 //y=1.18 //x2=4.86 //y2=1.18
r388 (  27 69 ) resistor r=9.3 //w=0.17 //l=0.17 //layer=mcon //count=1 \
 //x=4.82 //y=5.56 //x2=4.82 //y2=5.56
r389 (  24 27 ) resistor r=0.117801 //w=0.191 //l=0.18 //layer=m1 \
 //thickness=0.36 //x=4.82 //y=5.38 //x2=4.82 //y2=5.56
r390 (  23 61 ) resistor r=9.3 //w=0.17 //l=0.17 //layer=mcon //count=1 \
 //x=3.94 //y=5.56 //x2=3.94 //y2=5.56
r391 (  21 23 ) resistor r=0.10274 //w=0.219 //l=0.18 //layer=m1 \
 //thickness=0.36 //x=3.94 //y=5.38 //x2=3.94 //y2=5.56
r392 (  19 38 ) resistor r=0.0842262 //w=0.371 //l=0.166493 //layer=m1 \
 //thickness=0.36 //x=10.48 //y=3.28 //x2=10.422 //y2=3.14
r393 (  19 44 ) resistor r=1.39313 //w=0.131 //l=1.46 //layer=m1 \
 //thickness=0.36 //x=10.48 //y=3.28 //x2=10.48 //y2=4.74
r394 (  18 36 ) resistor r=0.0909648 //w=0.371 //l=0.186762 //layer=m1 \
 //thickness=0.36 //x=10.48 //y=2.96 //x2=10.422 //y2=3.12
r395 (  17 40 ) resistor r=0.0933015 //w=0.201 //l=0.125 //layer=m1 \
 //thickness=0.36 //x=10.48 //y=2.385 //x2=10.48 //y2=2.26
r396 (  17 18 ) resistor r=0.548664 //w=0.131 //l=0.575 //layer=m1 \
 //thickness=0.36 //x=10.48 //y=2.385 //x2=10.48 //y2=2.96
r397 (  15 34 ) resistor r=0.0845104 //w=0.376 //l=0.163951 //layer=m1 \
 //thickness=0.36 //x=5.3 //y=3.28 //x2=5.352 //y2=3.14
r398 (  15 16 ) resistor r=1.92271 //w=0.131 //l=2.015 //layer=m1 \
 //thickness=0.36 //x=5.3 //y=3.28 //x2=5.3 //y2=5.295
r399 (  14 32 ) resistor r=0.0911593 //w=0.376 //l=0.184174 //layer=m1 \
 //thickness=0.36 //x=5.3 //y=2.96 //x2=5.352 //y2=3.12
r400 (  13 14 ) resistor r=0.992366 //w=0.131 //l=1.04 //layer=m1 \
 //thickness=0.36 //x=5.3 //y=1.92 //x2=5.3 //y2=2.96
r401 (  11 13 ) resistor r=0.0698411 //w=0.17 //l=0.120208 //layer=m1 \
 //thickness=0.36 //x=5.215 //y=1.835 //x2=5.3 //y2=1.92
r402 (  11 12 ) resistor r=0.257634 //w=0.131 //l=0.27 //layer=m1 \
 //thickness=0.36 //x=5.215 //y=1.835 //x2=4.945 //y2=1.835
r403 (  10 24 ) resistor r=0.0257089 //w=0.23 //l=0.115 //layer=m1 \
 //thickness=0.36 //x=4.935 //y=5.38 //x2=4.82 //y2=5.38
r404 (  9 16 ) resistor r=0.0698411 //w=0.17 //l=0.120208 //layer=m1 \
 //thickness=0.36 //x=5.215 //y=5.38 //x2=5.3 //y2=5.295
r405 (  9 10 ) resistor r=0.267176 //w=0.131 //l=0.28 //layer=m1 \
 //thickness=0.36 //x=5.215 //y=5.38 //x2=4.935 //y2=5.38
r406 (  8 12 ) resistor r=0.0698411 //w=0.17 //l=0.120208 //layer=m1 \
 //thickness=0.36 //x=4.86 //y=1.75 //x2=4.945 //y2=1.835
r407 (  7 29 ) resistor r=0.0913624 //w=0.191 //l=0.12 //layer=m1 \
 //thickness=0.36 //x=4.86 //y=1.3 //x2=4.86 //y2=1.18
r408 (  7 8 ) resistor r=0.429389 //w=0.131 //l=0.45 //layer=m1 \
 //thickness=0.36 //x=4.86 //y=1.3 //x2=4.86 //y2=1.75
r409 (  4 21 ) resistor r=0.0227762 //w=0.219 //l=0.115 //layer=m1 \
 //thickness=0.36 //x=4.055 //y=5.38 //x2=3.94 //y2=5.38
r410 (  3 24 ) resistor r=0.0257089 //w=0.23 //l=0.115 //layer=m1 \
 //thickness=0.36 //x=4.705 //y=5.38 //x2=4.82 //y2=5.38
r411 (  3 4 ) resistor r=0.620229 //w=0.131 //l=0.65 //layer=m1 \
 //thickness=0.36 //x=4.705 //y=5.38 //x2=4.055 //y2=5.38
ends PM_MUX2X1\%noxref_3

subckt PM_MUX2X1\%noxref_4 ( 3 8 9 11 12 14 15 16 18 19 20 23 24 27 29 32 36 \
 39 44 49 51 54 62 79 88 92 93 94 95 96 97 102 104 106 112 113 115 116 119 127 \
 129 130 )
c276 ( 127 0 ) capacitor c=0.00878249f //x=8 //y=1.085
c277 ( 119 0 ) capacitor c=0.0393541f //x=11.25 //y=4.88
c278 ( 116 0 ) capacitor c=0.0303735f //x=11.22 //y=2.095
c279 ( 115 0 ) capacitor c=0.045117f //x=11.22 //y=2.26
c280 ( 113 0 ) capacitor c=0.0439708f //x=11.785 //y=1.43
c281 ( 112 0 ) capacitor c=0.0192582f //x=11.785 //y=1.085
c282 ( 106 0 ) capacitor c=0.0162526f //x=11.63 //y=1.585
c283 ( 104 0 ) capacitor c=0.0157807f //x=11.63 //y=0.93
c284 ( 102 0 ) capacitor c=0.0372668f //x=11.625 //y=4.97
c285 ( 97 0 ) capacitor c=0.0210762f //x=11.255 //y=1.74
c286 ( 96 0 ) capacitor c=0.0168511f //x=11.255 //y=1.43
c287 ( 95 0 ) capacitor c=0.0175485f //x=11.255 //y=1.085
c288 ( 94 0 ) capacitor c=0.155269f //x=11.7 //y=6.2
c289 ( 93 0 ) capacitor c=0.110375f //x=11.26 //y=6.2
c290 ( 88 0 ) capacitor c=8.90417e-19 //x=11.25 //y=4.88
c291 ( 79 0 ) capacitor c=5.78095e-19 //x=11.22 //y=2.26
c292 ( 62 0 ) capacitor c=0.0326476f //x=8.15 //y=5.56
c293 ( 54 0 ) capacitor c=0.029418f //x=7.27 //y=5.56
c294 ( 51 0 ) capacitor c=0.00358268f //x=11.22 //y=3.51
c295 ( 49 0 ) capacitor c=0.00298797f //x=8.79 //y=3.52
c296 ( 44 0 ) capacitor c=0.0694867f //x=11.06 //y=3.51
c297 ( 39 0 ) capacitor c=0.00637966f //x=11.22 //y=2.26
c298 ( 36 0 ) capacitor c=0.0158758f //x=11.22 //y=3.51
c299 ( 32 0 ) capacitor c=0.0175241f //x=8.63 //y=3.51
c300 ( 29 0 ) capacitor c=0.011403f //x=8.19 //y=1.18
c301 ( 27 0 ) capacitor c=6.70882e-19 //x=8.15 //y=5.56
c302 ( 24 0 ) capacitor c=0.0127386f //x=8.15 //y=5.38
c303 ( 23 0 ) capacitor c=0.0100037f //x=7.27 //y=5.56
c304 ( 20 0 ) capacitor c=0.031346f //x=11.22 //y=4.735
c305 ( 19 0 ) capacitor c=0.0101286f //x=11.22 //y=3.67
c306 ( 18 0 ) capacitor c=0.0196935f //x=11.22 //y=3.35
c307 ( 16 0 ) capacitor c=0.0481967f //x=8.63 //y=5.295
c308 ( 15 0 ) capacitor c=0.0121613f //x=8.63 //y=3.68
c309 ( 14 0 ) capacitor c=0.0367664f //x=8.63 //y=3.36
c310 ( 12 0 ) capacitor c=0.00619099f //x=8.275 //y=1.835
c311 ( 11 0 ) capacitor c=0.0136643f //x=8.545 //y=1.835
c312 ( 9 0 ) capacitor c=0.011962f //x=8.545 //y=5.38
c313 ( 8 0 ) capacitor c=0.0101547f //x=8.19 //y=1.75
c314 ( 3 0 ) capacitor c=0.0195602f //x=8.035 //y=5.38
r315 (  121 122 ) resistor r=32.4568 //w=0.214 //l=0.075 //layer=ply \
 //thickness=0.18 //x=11.25 //y=4.97 //x2=11.25 //y2=5.045
r316 (  119 121 ) resistor r=20.271 //w=0.214 //l=0.09 //layer=ply \
 //thickness=0.18 //x=11.25 //y=4.88 //x2=11.25 //y2=4.97
r317 (  115 116 ) resistor r=52.7279 //w=0.214 //l=0.165 //layer=ply \
 //thickness=0.18 //x=11.22 //y=2.26 //x2=11.22 //y2=2.095
r318 (  113 126 ) resistor r=45.1352 //w=0.168 //l=0.173853 //layer=ply \
 //thickness=0.18 //x=11.785 //y=1.43 //x2=11.745 //y2=1.585
r319 (  112 125 ) resistor r=45.1352 //w=0.168 //l=0.173853 //layer=ply \
 //thickness=0.18 //x=11.785 //y=1.085 //x2=11.745 //y2=0.93
r320 (  112 113 ) resistor r=176.904 //w=0.094 //l=0.345 //layer=ply \
 //thickness=0.18 //x=11.785 //y=1.085 //x2=11.785 //y2=1.43
r321 (  107 124 ) resistor r=10.701 //w=0.21 //l=0.115 //layer=ply \
 //thickness=0.18 //x=11.41 //y=1.585 //x2=11.295 //y2=1.585
r322 (  106 126 ) resistor r=5.52526 //w=0.168 //l=0.115 //layer=ply \
 //thickness=0.18 //x=11.63 //y=1.585 //x2=11.745 //y2=1.585
r323 (  105 123 ) resistor r=5.52526 //w=0.168 //l=0.115 //layer=ply \
 //thickness=0.18 //x=11.41 //y=0.93 //x2=11.295 //y2=0.93
r324 (  104 125 ) resistor r=5.52526 //w=0.168 //l=0.115 //layer=ply \
 //thickness=0.18 //x=11.63 //y=0.93 //x2=11.745 //y2=0.93
r325 (  104 105 ) resistor r=112.809 //w=0.094 //l=0.22 //layer=ply \
 //thickness=0.18 //x=11.63 //y=0.93 //x2=11.41 //y2=0.93
r326 (  103 121 ) resistor r=16.5046 //w=0.27 //l=0.135 //layer=ply \
 //thickness=0.18 //x=11.385 //y=4.97 //x2=11.25 //y2=4.97
r327 (  102 109 ) resistor r=26.9307 //w=0.15 //l=0.106066 //layer=ply \
 //thickness=0.18 //x=11.625 //y=4.97 //x2=11.7 //y2=5.045
r328 (  102 103 ) resistor r=123.064 //w=0.094 //l=0.24 //layer=ply \
 //thickness=0.18 //x=11.625 //y=4.97 //x2=11.385 //y2=4.97
r329 (  97 124 ) resistor r=39.5823 //w=0.21 //l=0.173853 //layer=ply \
 //thickness=0.18 //x=11.255 //y=1.74 //x2=11.295 //y2=1.585
r330 (  97 116 ) resistor r=182.032 //w=0.094 //l=0.355 //layer=ply \
 //thickness=0.18 //x=11.255 //y=1.74 //x2=11.255 //y2=2.095
r331 (  96 124 ) resistor r=39.5823 //w=0.21 //l=0.173853 //layer=ply \
 //thickness=0.18 //x=11.255 //y=1.43 //x2=11.295 //y2=1.585
r332 (  95 123 ) resistor r=45.1352 //w=0.168 //l=0.173853 //layer=ply \
 //thickness=0.18 //x=11.255 //y=1.085 //x2=11.295 //y2=0.93
r333 (  95 96 ) resistor r=176.904 //w=0.094 //l=0.345 //layer=ply \
 //thickness=0.18 //x=11.255 //y=1.085 //x2=11.255 //y2=1.43
r334 (  94 109 ) resistor r=592.245 //w=0.094 //l=1.155 //layer=ply \
 //thickness=0.18 //x=11.7 //y=6.2 //x2=11.7 //y2=5.045
r335 (  93 122 ) resistor r=592.245 //w=0.094 //l=1.155 //layer=ply \
 //thickness=0.18 //x=11.26 //y=6.2 //x2=11.26 //y2=5.045
r336 (  92 106 ) resistor r=56.4043 //w=0.094 //l=0.11 //layer=ply \
 //thickness=0.18 //x=11.52 //y=1.585 //x2=11.63 //y2=1.585
r337 (  92 107 ) resistor r=56.4043 //w=0.094 //l=0.11 //layer=ply \
 //thickness=0.18 //x=11.52 //y=1.585 //x2=11.41 //y2=1.585
r338 (  88 119 ) resistor r=152 //w=0.17 //l=0.17 //layer=licon //count=1 \
 //x=11.25 //y=4.88 //x2=11.25 //y2=4.88
r339 (  79 115 ) resistor r=152 //w=0.17 //l=0.17 //layer=licon //count=1 \
 //x=11.22 //y=2.26 //x2=11.22 //y2=2.26
r340 (  62 130 ) resistor r=23.615 //w=0.187 //l=0.345 //layer=li \
 //thickness=0.1 //x=8.15 //y=5.56 //x2=8.15 //y2=5.905
r341 (  54 129 ) resistor r=23.615 //w=0.187 //l=0.345 //layer=li \
 //thickness=0.1 //x=7.27 //y=5.56 //x2=7.27 //y2=5.905
r342 (  47 49 ) resistor r=0.10734 //w=0.281 //l=0.16 //layer=m2 \
 //thickness=0.36 //x=8.63 //y=3.52 //x2=8.79 //y2=3.52
r343 (  44 51 ) resistor r=0.10734 //w=0.281 //l=0.16 //layer=m2 \
 //thickness=0.36 //x=11.06 //y=3.51 //x2=11.22 //y2=3.51
r344 (  44 49 ) resistor r=2.16603 //w=0.131 //l=2.27 //layer=m2 \
 //thickness=0.36 //x=11.06 //y=3.51 //x2=8.79 //y2=3.51
r345 (  43 88 ) resistor r=9.3 //w=0.17 //l=0.17 //layer=mcon //count=1 \
 //x=11.25 //y=4.88 //x2=11.25 //y2=4.88
r346 (  39 79 ) resistor r=9.3 //w=0.17 //l=0.17 //layer=mcon //count=1 \
 //x=11.22 //y=2.26 //x2=11.22 //y2=2.26
r347 (  39 41 ) resistor r=0.0936408 //w=0.196 //l=0.125 //layer=m1 \
 //thickness=0.36 //x=11.222 //y=2.26 //x2=11.222 //y2=2.385
r348 (  36 51 ) resistor r=4.5 //w=0.15 //l=0.15 //layer=via1 //count=1 \
 //x=11.22 //y=3.51 //x2=11.22 //y2=3.51
r349 (  34 47 ) resistor r=4.5 //w=0.15 //l=0.15 //layer=via1 //count=1 \
 //x=8.63 //y=3.52 //x2=8.63 //y2=3.52
r350 (  32 34 ) resistor r=0.00332447 //w=0.376 //l=0.01 //layer=m1 \
 //thickness=0.36 //x=8.682 //y=3.51 //x2=8.682 //y2=3.52
r351 (  29 127 ) resistor r=9.3 //w=0.17 //l=0.17 //layer=mcon //count=1 \
 //x=8.19 //y=1.18 //x2=8.19 //y2=1.18
r352 (  27 62 ) resistor r=9.3 //w=0.17 //l=0.17 //layer=mcon //count=1 \
 //x=8.15 //y=5.56 //x2=8.15 //y2=5.56
r353 (  24 27 ) resistor r=0.117801 //w=0.191 //l=0.18 //layer=m1 \
 //thickness=0.36 //x=8.15 //y=5.38 //x2=8.15 //y2=5.56
r354 (  23 54 ) resistor r=9.3 //w=0.17 //l=0.17 //layer=mcon //count=1 \
 //x=7.27 //y=5.56 //x2=7.27 //y2=5.56
r355 (  21 23 ) resistor r=0.10274 //w=0.219 //l=0.18 //layer=m1 \
 //thickness=0.36 //x=7.27 //y=5.38 //x2=7.27 //y2=5.56
r356 (  20 43 ) resistor r=0.0878548 //w=0.228 //l=0.159295 //layer=m1 \
 //thickness=0.36 //x=11.22 //y=4.735 //x2=11.25 //y2=4.88
r357 (  19 36 ) resistor r=0.0911593 //w=0.376 //l=0.184608 //layer=m1 \
 //thickness=0.36 //x=11.22 //y=3.67 //x2=11.167 //y2=3.51
r358 (  19 20 ) resistor r=1.01622 //w=0.131 //l=1.065 //layer=m1 \
 //thickness=0.36 //x=11.22 //y=3.67 //x2=11.22 //y2=4.735
r359 (  18 36 ) resistor r=0.0911593 //w=0.376 //l=0.184608 //layer=m1 \
 //thickness=0.36 //x=11.22 //y=3.35 //x2=11.167 //y2=3.51
r360 (  18 41 ) resistor r=0.920802 //w=0.131 //l=0.965 //layer=m1 \
 //thickness=0.36 //x=11.22 //y=3.35 //x2=11.22 //y2=2.385
r361 (  15 34 ) resistor r=0.0911593 //w=0.376 //l=0.184174 //layer=m1 \
 //thickness=0.36 //x=8.63 //y=3.68 //x2=8.682 //y2=3.52
r362 (  15 16 ) resistor r=1.54103 //w=0.131 //l=1.615 //layer=m1 \
 //thickness=0.36 //x=8.63 //y=3.68 //x2=8.63 //y2=5.295
r363 (  14 32 ) resistor r=0.0878349 //w=0.376 //l=0.174069 //layer=m1 \
 //thickness=0.36 //x=8.63 //y=3.36 //x2=8.682 //y2=3.51
r364 (  13 14 ) resistor r=1.37405 //w=0.131 //l=1.44 //layer=m1 \
 //thickness=0.36 //x=8.63 //y=1.92 //x2=8.63 //y2=3.36
r365 (  11 13 ) resistor r=0.0698411 //w=0.17 //l=0.120208 //layer=m1 \
 //thickness=0.36 //x=8.545 //y=1.835 //x2=8.63 //y2=1.92
r366 (  11 12 ) resistor r=0.257634 //w=0.131 //l=0.27 //layer=m1 \
 //thickness=0.36 //x=8.545 //y=1.835 //x2=8.275 //y2=1.835
r367 (  10 24 ) resistor r=0.0257089 //w=0.23 //l=0.115 //layer=m1 \
 //thickness=0.36 //x=8.265 //y=5.38 //x2=8.15 //y2=5.38
r368 (  9 16 ) resistor r=0.0698411 //w=0.17 //l=0.120208 //layer=m1 \
 //thickness=0.36 //x=8.545 //y=5.38 //x2=8.63 //y2=5.295
r369 (  9 10 ) resistor r=0.267176 //w=0.131 //l=0.28 //layer=m1 \
 //thickness=0.36 //x=8.545 //y=5.38 //x2=8.265 //y2=5.38
r370 (  8 12 ) resistor r=0.0698411 //w=0.17 //l=0.120208 //layer=m1 \
 //thickness=0.36 //x=8.19 //y=1.75 //x2=8.275 //y2=1.835
r371 (  7 29 ) resistor r=0.0913624 //w=0.191 //l=0.12 //layer=m1 \
 //thickness=0.36 //x=8.19 //y=1.3 //x2=8.19 //y2=1.18
r372 (  7 8 ) resistor r=0.429389 //w=0.131 //l=0.45 //layer=m1 \
 //thickness=0.36 //x=8.19 //y=1.3 //x2=8.19 //y2=1.75
r373 (  4 21 ) resistor r=0.0227762 //w=0.219 //l=0.115 //layer=m1 \
 //thickness=0.36 //x=7.385 //y=5.38 //x2=7.27 //y2=5.38
r374 (  3 24 ) resistor r=0.0257089 //w=0.23 //l=0.115 //layer=m1 \
 //thickness=0.36 //x=8.035 //y=5.38 //x2=8.15 //y2=5.38
r375 (  3 4 ) resistor r=0.620229 //w=0.131 //l=0.65 //layer=m1 \
 //thickness=0.36 //x=8.035 //y=5.38 //x2=7.385 //y2=5.38
ends PM_MUX2X1\%noxref_4

subckt PM_MUX2X1\%VDD ( 1 23 47 73 83 109 119 141 149 164 166 170 175 180 181 \
 182 183 184 185 186 187 188 189 190 191 )
c229 ( 191 0 ) capacitor c=0.0392524f //x=11.775 //y=5.2
c230 ( 190 0 ) capacitor c=0.0248174f //x=10.895 //y=5.2
c231 ( 189 0 ) capacitor c=0.0631165f //x=10.025 //y=5.2
c232 ( 188 0 ) capacitor c=0.039544f //x=8.445 //y=5.2
c233 ( 187 0 ) capacitor c=0.0248174f //x=7.565 //y=5.2
c234 ( 186 0 ) capacitor c=0.0630312f //x=6.695 //y=5.2
c235 ( 185 0 ) capacitor c=0.0397412f //x=5.115 //y=5.2
c236 ( 184 0 ) capacitor c=0.0248174f //x=4.235 //y=5.2
c237 ( 183 0 ) capacitor c=0.0595532f //x=3.365 //y=5.2
c238 ( 182 0 ) capacitor c=0.0544217f //x=1.9 //y=5.2
c239 ( 181 0 ) capacitor c=0.0611142f //x=1.03 //y=5.2
c240 ( 180 0 ) capacitor c=0.269011f //x=11.96 //y=7.58
c241 ( 178 0 ) capacitor c=0.00597439f //x=11.04 //y=7.585
c242 ( 177 0 ) capacitor c=0.00597439f //x=10.11 //y=7.58
c243 ( 175 0 ) capacitor c=0.130627f //x=9.37 //y=7.585
c244 ( 174 0 ) capacitor c=0.00597439f //x=8.63 //y=7.58
c245 ( 172 0 ) capacitor c=0.00597439f //x=7.71 //y=7.585
c246 ( 171 0 ) capacitor c=0.00597439f //x=6.83 //y=7.585
c247 ( 170 0 ) capacitor c=0.130573f //x=6.04 //y=7.585
c248 ( 169 0 ) capacitor c=0.00597439f //x=5.26 //y=7.585
c249 ( 168 0 ) capacitor c=0.00597439f //x=4.38 //y=7.585
c250 ( 167 0 ) capacitor c=0.00597439f //x=3.5 //y=7.585
c251 ( 166 0 ) capacitor c=0.128233f //x=2.71 //y=7.585
c252 ( 165 0 ) capacitor c=0.00597439f //x=2.045 //y=7.585
c253 ( 164 0 ) capacitor c=0.257865f //x=1.23 //y=7.58
c254 ( 149 0 ) capacitor c=0.0287375f //x=11.835 //y=7.585
c255 ( 141 0 ) capacitor c=0.0291078f //x=10.955 //y=7.585
c256 ( 131 0 ) capacitor c=0.0283511f //x=10.075 //y=7.585
c257 ( 127 0 ) capacitor c=0.0277785f //x=9.2 //y=7.585
c258 ( 119 0 ) capacitor c=0.0287375f //x=8.505 //y=7.585
c259 ( 109 0 ) capacitor c=0.0291078f //x=7.625 //y=7.585
c260 ( 97 0 ) capacitor c=0.0283511f //x=6.745 //y=7.585
c261 ( 93 0 ) capacitor c=0.0277785f //x=5.87 //y=7.585
c262 ( 83 0 ) capacitor c=0.0287375f //x=5.175 //y=7.585
c263 ( 73 0 ) capacitor c=0.0291078f //x=4.295 //y=7.585
c264 ( 63 0 ) capacitor c=0.0283511f //x=3.415 //y=7.585
c265 ( 57 0 ) capacitor c=0.0211939f //x=2.54 //y=7.585
c266 ( 47 0 ) capacitor c=0.0289924f //x=1.96 //y=7.585
c267 ( 23 0 ) capacitor c=0.499233f //x=11.96 //y=7.58
r268 (  153 180 ) resistor r=4.23183 //w=0.7 //l=0.175 //layer=li \
 //thickness=0.1 //x=11.92 //y=7.41 //x2=11.92 //y2=7.585
r269 (  153 191 ) resistor r=33.1979 //w=0.187 //l=0.485 //layer=li \
 //thickness=0.1 //x=11.92 //y=7.41 //x2=11.92 //y2=6.925
r270 (  150 178 ) resistor r=2.87058 //w=0.35 //l=0.085 //layer=li \
 //thickness=0.1 //x=11.125 //y=7.585 //x2=11.04 //y2=7.585
r271 (  150 152 ) resistor r=3.31335 //w=0.367 //l=0.095 //layer=li \
 //thickness=0.1 //x=11.125 //y=7.585 //x2=11.22 //y2=7.585
r272 (  149 180 ) resistor r=2.87058 //w=0.35 //l=0.085 //layer=li \
 //thickness=0.1 //x=11.835 //y=7.585 //x2=11.92 //y2=7.585
r273 (  149 152 ) resistor r=21.4496 //w=0.367 //l=0.615 //layer=li \
 //thickness=0.1 //x=11.835 //y=7.585 //x2=11.22 //y2=7.585
r274 (  143 178 ) resistor r=4.23183 //w=0.7 //l=0.175 //layer=li \
 //thickness=0.1 //x=11.04 //y=7.41 //x2=11.04 //y2=7.585
r275 (  143 190 ) resistor r=33.1979 //w=0.187 //l=0.485 //layer=li \
 //thickness=0.1 //x=11.04 //y=7.41 //x2=11.04 //y2=6.925
r276 (  142 177 ) resistor r=2.87058 //w=0.35 //l=0.085 //layer=li \
 //thickness=0.1 //x=10.245 //y=7.585 //x2=10.16 //y2=7.585
r277 (  141 178 ) resistor r=2.87058 //w=0.35 //l=0.085 //layer=li \
 //thickness=0.1 //x=10.955 //y=7.585 //x2=11.04 //y2=7.585
r278 (  141 142 ) resistor r=24.7629 //w=0.367 //l=0.71 //layer=li \
 //thickness=0.1 //x=10.955 //y=7.585 //x2=10.245 //y2=7.585
r279 (  133 177 ) resistor r=4.23183 //w=0.7 //l=0.175 //layer=li \
 //thickness=0.1 //x=10.16 //y=7.41 //x2=10.16 //y2=7.585
r280 (  133 189 ) resistor r=56.4706 //w=0.187 //l=0.825 //layer=li \
 //thickness=0.1 //x=10.16 //y=7.41 //x2=10.16 //y2=6.585
r281 (  132 175 ) resistor r=5.29055 //w=0.35 //l=0.17 //layer=li \
 //thickness=0.1 //x=9.54 //y=7.585 //x2=9.37 //y2=7.585
r282 (  131 177 ) resistor r=2.87058 //w=0.35 //l=0.085 //layer=li \
 //thickness=0.1 //x=10.075 //y=7.585 //x2=10.16 //y2=7.585
r283 (  131 132 ) resistor r=18.6594 //w=0.367 //l=0.535 //layer=li \
 //thickness=0.1 //x=10.075 //y=7.585 //x2=9.54 //y2=7.585
r284 (  128 174 ) resistor r=2.87058 //w=0.35 //l=0.085 //layer=li \
 //thickness=0.1 //x=8.675 //y=7.585 //x2=8.59 //y2=7.585
r285 (  127 175 ) resistor r=5.29055 //w=0.35 //l=0.17 //layer=li \
 //thickness=0.1 //x=9.2 //y=7.585 //x2=9.37 //y2=7.585
r286 (  127 128 ) resistor r=18.3106 //w=0.367 //l=0.525 //layer=li \
 //thickness=0.1 //x=9.2 //y=7.585 //x2=8.675 //y2=7.585
r287 (  121 174 ) resistor r=4.23183 //w=0.7 //l=0.175 //layer=li \
 //thickness=0.1 //x=8.59 //y=7.41 //x2=8.59 //y2=7.585
r288 (  121 188 ) resistor r=33.1979 //w=0.187 //l=0.485 //layer=li \
 //thickness=0.1 //x=8.59 //y=7.41 //x2=8.59 //y2=6.925
r289 (  120 172 ) resistor r=2.87058 //w=0.35 //l=0.085 //layer=li \
 //thickness=0.1 //x=7.795 //y=7.585 //x2=7.71 //y2=7.585
r290 (  119 174 ) resistor r=2.87058 //w=0.35 //l=0.085 //layer=li \
 //thickness=0.1 //x=8.505 //y=7.585 //x2=8.59 //y2=7.585
r291 (  119 120 ) resistor r=24.7629 //w=0.367 //l=0.71 //layer=li \
 //thickness=0.1 //x=8.505 //y=7.585 //x2=7.795 //y2=7.585
r292 (  113 172 ) resistor r=4.23183 //w=0.7 //l=0.175 //layer=li \
 //thickness=0.1 //x=7.71 //y=7.41 //x2=7.71 //y2=7.585
r293 (  113 187 ) resistor r=33.1979 //w=0.187 //l=0.485 //layer=li \
 //thickness=0.1 //x=7.71 //y=7.41 //x2=7.71 //y2=6.925
r294 (  110 171 ) resistor r=2.87058 //w=0.35 //l=0.085 //layer=li \
 //thickness=0.1 //x=6.915 //y=7.585 //x2=6.83 //y2=7.585
r295 (  110 112 ) resistor r=21.1008 //w=0.367 //l=0.605 //layer=li \
 //thickness=0.1 //x=6.915 //y=7.585 //x2=7.52 //y2=7.585
r296 (  109 172 ) resistor r=2.87058 //w=0.35 //l=0.085 //layer=li \
 //thickness=0.1 //x=7.625 //y=7.585 //x2=7.71 //y2=7.585
r297 (  109 112 ) resistor r=3.66213 //w=0.367 //l=0.105 //layer=li \
 //thickness=0.1 //x=7.625 //y=7.585 //x2=7.52 //y2=7.585
r298 (  101 171 ) resistor r=4.23183 //w=0.7 //l=0.175 //layer=li \
 //thickness=0.1 //x=6.83 //y=7.41 //x2=6.83 //y2=7.585
r299 (  101 186 ) resistor r=56.4706 //w=0.187 //l=0.825 //layer=li \
 //thickness=0.1 //x=6.83 //y=7.41 //x2=6.83 //y2=6.585
r300 (  98 170 ) resistor r=5.29055 //w=0.35 //l=0.17 //layer=li \
 //thickness=0.1 //x=6.21 //y=7.585 //x2=6.04 //y2=7.585
r301 (  98 100 ) resistor r=6.97548 //w=0.367 //l=0.2 //layer=li \
 //thickness=0.1 //x=6.21 //y=7.585 //x2=6.41 //y2=7.585
r302 (  97 171 ) resistor r=2.87058 //w=0.35 //l=0.085 //layer=li \
 //thickness=0.1 //x=6.745 //y=7.585 //x2=6.83 //y2=7.585
r303 (  97 100 ) resistor r=11.6839 //w=0.367 //l=0.335 //layer=li \
 //thickness=0.1 //x=6.745 //y=7.585 //x2=6.41 //y2=7.585
r304 (  94 169 ) resistor r=2.87058 //w=0.35 //l=0.085 //layer=li \
 //thickness=0.1 //x=5.345 //y=7.585 //x2=5.26 //y2=7.585
r305 (  93 170 ) resistor r=5.29055 //w=0.35 //l=0.17 //layer=li \
 //thickness=0.1 //x=5.87 //y=7.585 //x2=6.04 //y2=7.585
r306 (  93 94 ) resistor r=18.3106 //w=0.367 //l=0.525 //layer=li \
 //thickness=0.1 //x=5.87 //y=7.585 //x2=5.345 //y2=7.585
r307 (  87 169 ) resistor r=4.23183 //w=0.7 //l=0.175 //layer=li \
 //thickness=0.1 //x=5.26 //y=7.41 //x2=5.26 //y2=7.585
r308 (  87 185 ) resistor r=33.1979 //w=0.187 //l=0.485 //layer=li \
 //thickness=0.1 //x=5.26 //y=7.41 //x2=5.26 //y2=6.925
r309 (  84 168 ) resistor r=2.87058 //w=0.35 //l=0.085 //layer=li \
 //thickness=0.1 //x=4.465 //y=7.585 //x2=4.38 //y2=7.585
r310 (  84 86 ) resistor r=16.218 //w=0.367 //l=0.465 //layer=li \
 //thickness=0.1 //x=4.465 //y=7.585 //x2=4.93 //y2=7.585
r311 (  83 169 ) resistor r=2.87058 //w=0.35 //l=0.085 //layer=li \
 //thickness=0.1 //x=5.175 //y=7.585 //x2=5.26 //y2=7.585
r312 (  83 86 ) resistor r=8.54496 //w=0.367 //l=0.245 //layer=li \
 //thickness=0.1 //x=5.175 //y=7.585 //x2=4.93 //y2=7.585
r313 (  77 168 ) resistor r=4.23183 //w=0.7 //l=0.175 //layer=li \
 //thickness=0.1 //x=4.38 //y=7.41 //x2=4.38 //y2=7.585
r314 (  77 184 ) resistor r=33.1979 //w=0.187 //l=0.485 //layer=li \
 //thickness=0.1 //x=4.38 //y=7.41 //x2=4.38 //y2=6.925
r315 (  74 167 ) resistor r=2.87058 //w=0.35 //l=0.085 //layer=li \
 //thickness=0.1 //x=3.585 //y=7.585 //x2=3.5 //y2=7.585
r316 (  74 76 ) resistor r=8.19619 //w=0.367 //l=0.235 //layer=li \
 //thickness=0.1 //x=3.585 //y=7.585 //x2=3.82 //y2=7.585
r317 (  73 168 ) resistor r=2.87058 //w=0.35 //l=0.085 //layer=li \
 //thickness=0.1 //x=4.295 //y=7.585 //x2=4.38 //y2=7.585
r318 (  73 76 ) resistor r=16.5668 //w=0.367 //l=0.475 //layer=li \
 //thickness=0.1 //x=4.295 //y=7.585 //x2=3.82 //y2=7.585
r319 (  65 167 ) resistor r=4.23183 //w=0.7 //l=0.175 //layer=li \
 //thickness=0.1 //x=3.5 //y=7.41 //x2=3.5 //y2=7.585
r320 (  65 183 ) resistor r=56.4706 //w=0.187 //l=0.825 //layer=li \
 //thickness=0.1 //x=3.5 //y=7.41 //x2=3.5 //y2=6.585
r321 (  64 166 ) resistor r=5.29055 //w=0.35 //l=0.17 //layer=li \
 //thickness=0.1 //x=2.88 //y=7.585 //x2=2.71 //y2=7.585
r322 (  63 167 ) resistor r=2.87058 //w=0.35 //l=0.085 //layer=li \
 //thickness=0.1 //x=3.415 //y=7.585 //x2=3.5 //y2=7.585
r323 (  63 64 ) resistor r=18.6594 //w=0.367 //l=0.535 //layer=li \
 //thickness=0.1 //x=3.415 //y=7.585 //x2=2.88 //y2=7.585
r324 (  58 165 ) resistor r=2.87058 //w=0.35 //l=0.085 //layer=li \
 //thickness=0.1 //x=2.13 //y=7.585 //x2=2.045 //y2=7.585
r325 (  58 60 ) resistor r=7.32425 //w=0.367 //l=0.21 //layer=li \
 //thickness=0.1 //x=2.13 //y=7.585 //x2=2.34 //y2=7.585
r326 (  57 166 ) resistor r=5.29055 //w=0.35 //l=0.17 //layer=li \
 //thickness=0.1 //x=2.54 //y=7.585 //x2=2.71 //y2=7.585
r327 (  57 60 ) resistor r=6.97548 //w=0.367 //l=0.2 //layer=li \
 //thickness=0.1 //x=2.54 //y=7.585 //x2=2.34 //y2=7.585
r328 (  49 165 ) resistor r=4.23183 //w=0.7 //l=0.175 //layer=li \
 //thickness=0.1 //x=2.045 //y=7.41 //x2=2.045 //y2=7.585
r329 (  49 182 ) resistor r=56.4706 //w=0.187 //l=0.825 //layer=li \
 //thickness=0.1 //x=2.045 //y=7.41 //x2=2.045 //y2=6.585
r330 (  48 164 ) resistor r=2.87058 //w=0.35 //l=0.085 //layer=li \
 //thickness=0.1 //x=1.25 //y=7.585 //x2=1.165 //y2=7.585
r331 (  47 165 ) resistor r=2.87058 //w=0.35 //l=0.085 //layer=li \
 //thickness=0.1 //x=1.96 //y=7.585 //x2=2.045 //y2=7.585
r332 (  47 48 ) resistor r=24.7629 //w=0.367 //l=0.71 //layer=li \
 //thickness=0.1 //x=1.96 //y=7.585 //x2=1.25 //y2=7.585
r333 (  39 164 ) resistor r=4.23183 //w=0.7 //l=0.175 //layer=li \
 //thickness=0.1 //x=1.165 //y=7.41 //x2=1.165 //y2=7.585
r334 (  39 181 ) resistor r=56.4706 //w=0.187 //l=0.825 //layer=li \
 //thickness=0.1 //x=1.165 //y=7.41 //x2=1.165 //y2=6.585
r335 (  23 180 ) resistor r=4.65 //w=0.17 //l=0.34 //layer=mcon //count=2 \
 //x=11.96 //y=7.58 //x2=11.96 //y2=7.58
r336 (  21 152 ) resistor r=3.1 //w=0.17 //l=0.51 //layer=mcon //count=3 \
 //x=11.22 //y=7.58 //x2=11.22 //y2=7.58
r337 (  21 23 ) resistor r=0.297428 //w=0.311 //l=0.74 //layer=m1 \
 //thickness=0.36 //x=11.22 //y=7.585 //x2=11.96 //y2=7.585
r338 (  19 177 ) resistor r=3.1 //w=0.17 //l=0.51 //layer=mcon //count=3 \
 //x=10.11 //y=7.58 //x2=10.11 //y2=7.58
r339 (  19 21 ) resistor r=0.446141 //w=0.311 //l=1.11 //layer=m1 \
 //thickness=0.36 //x=10.11 //y=7.585 //x2=11.22 //y2=7.585
r340 (  17 174 ) resistor r=3.1 //w=0.17 //l=0.51 //layer=mcon //count=3 \
 //x=8.63 //y=7.58 //x2=8.63 //y2=7.58
r341 (  17 19 ) resistor r=0.594855 //w=0.311 //l=1.48 //layer=m1 \
 //thickness=0.36 //x=8.63 //y=7.585 //x2=10.11 //y2=7.585
r342 (  15 112 ) resistor r=3.1 //w=0.17 //l=0.51 //layer=mcon //count=3 \
 //x=7.52 //y=7.58 //x2=7.52 //y2=7.58
r343 (  15 17 ) resistor r=0.446141 //w=0.311 //l=1.11 //layer=m1 \
 //thickness=0.36 //x=7.52 //y=7.585 //x2=8.63 //y2=7.585
r344 (  12 100 ) resistor r=3.1 //w=0.17 //l=0.51 //layer=mcon //count=3 \
 //x=6.41 //y=7.58 //x2=6.41 //y2=7.58
r345 (  10 86 ) resistor r=3.1 //w=0.17 //l=0.51 //layer=mcon //count=3 \
 //x=4.93 //y=7.58 //x2=4.93 //y2=7.58
r346 (  10 12 ) resistor r=0.594855 //w=0.311 //l=1.48 //layer=m1 \
 //thickness=0.36 //x=4.93 //y=7.585 //x2=6.41 //y2=7.585
r347 (  8 76 ) resistor r=3.1 //w=0.17 //l=0.51 //layer=mcon //count=3 \
 //x=3.82 //y=7.58 //x2=3.82 //y2=7.58
r348 (  8 10 ) resistor r=0.446141 //w=0.311 //l=1.11 //layer=m1 \
 //thickness=0.36 //x=3.82 //y=7.585 //x2=4.93 //y2=7.585
r349 (  6 60 ) resistor r=3.1 //w=0.17 //l=0.51 //layer=mcon //count=3 \
 //x=2.34 //y=7.58 //x2=2.34 //y2=7.58
r350 (  6 8 ) resistor r=0.594855 //w=0.311 //l=1.48 //layer=m1 \
 //thickness=0.36 //x=2.34 //y=7.585 //x2=3.82 //y2=7.585
r351 (  3 164 ) resistor r=3.1 //w=0.17 //l=0.51 //layer=mcon //count=3 \
 //x=1.23 //y=7.58 //x2=1.23 //y2=7.58
r352 (  3 6 ) resistor r=0.446141 //w=0.311 //l=1.11 //layer=m1 \
 //thickness=0.36 //x=1.23 //y=7.585 //x2=2.34 //y2=7.585
r353 (  1 15 ) resistor r=0.371785 //w=0.311 //l=0.925 //layer=m1 \
 //thickness=0.36 //x=6.595 //y=7.585 //x2=7.52 //y2=7.585
r354 (  1 12 ) resistor r=0.0743569 //w=0.311 //l=0.185 //layer=m1 \
 //thickness=0.36 //x=6.595 //y=7.585 //x2=6.41 //y2=7.585
ends PM_MUX2X1\%VDD

subckt PM_MUX2X1\%A0 ( 1 2 3 4 5 6 8 16 22 27 31 32 33 34 35 36 41 43 45 51 52 \
 54 55 58 )
c115 ( 58 0 ) capacitor c=0.0393541f //x=4.59 //y=4.88
c116 ( 55 0 ) capacitor c=0.0284095f //x=4.56 //y=2.095
c117 ( 54 0 ) capacitor c=0.0476356f //x=4.56 //y=2.26
c118 ( 52 0 ) capacitor c=0.0439708f //x=5.125 //y=1.43
c119 ( 51 0 ) capacitor c=0.0192582f //x=5.125 //y=1.085
c120 ( 45 0 ) capacitor c=0.0162526f //x=4.97 //y=1.585
c121 ( 43 0 ) capacitor c=0.0157807f //x=4.97 //y=0.93
c122 ( 41 0 ) capacitor c=0.0372668f //x=4.965 //y=4.97
c123 ( 36 0 ) capacitor c=0.0210762f //x=4.595 //y=1.74
c124 ( 35 0 ) capacitor c=0.0168511f //x=4.595 //y=1.43
c125 ( 34 0 ) capacitor c=0.0175485f //x=4.595 //y=1.085
c126 ( 33 0 ) capacitor c=0.155269f //x=5.04 //y=6.2
c127 ( 32 0 ) capacitor c=0.110375f //x=4.6 //y=6.2
c128 ( 27 0 ) capacitor c=8.90417e-19 //x=4.59 //y=4.88
c129 ( 22 0 ) capacitor c=7.72439e-19 //x=4.56 //y=2.26
c130 ( 16 0 ) capacitor c=0.00687137f //x=4.56 //y=2.26
c131 ( 8 0 ) capacitor c=0.00488579f //x=4.56 //y=4.735
c132 ( 1 0 ) capacitor c=0.0514534f //x=4.56 //y=2.4
r133 (  60 61 ) resistor r=32.4568 //w=0.214 //l=0.075 //layer=ply \
 //thickness=0.18 //x=4.59 //y=4.97 //x2=4.59 //y2=5.045
r134 (  58 60 ) resistor r=20.271 //w=0.214 //l=0.09 //layer=ply \
 //thickness=0.18 //x=4.59 //y=4.88 //x2=4.59 //y2=4.97
r135 (  54 55 ) resistor r=52.7279 //w=0.214 //l=0.165 //layer=ply \
 //thickness=0.18 //x=4.56 //y=2.26 //x2=4.56 //y2=2.095
r136 (  52 65 ) resistor r=45.1352 //w=0.168 //l=0.173853 //layer=ply \
 //thickness=0.18 //x=5.125 //y=1.43 //x2=5.085 //y2=1.585
r137 (  51 64 ) resistor r=45.1352 //w=0.168 //l=0.173853 //layer=ply \
 //thickness=0.18 //x=5.125 //y=1.085 //x2=5.085 //y2=0.93
r138 (  51 52 ) resistor r=176.904 //w=0.094 //l=0.345 //layer=ply \
 //thickness=0.18 //x=5.125 //y=1.085 //x2=5.125 //y2=1.43
r139 (  46 63 ) resistor r=10.701 //w=0.21 //l=0.115 //layer=ply \
 //thickness=0.18 //x=4.75 //y=1.585 //x2=4.635 //y2=1.585
r140 (  45 65 ) resistor r=5.52526 //w=0.168 //l=0.115 //layer=ply \
 //thickness=0.18 //x=4.97 //y=1.585 //x2=5.085 //y2=1.585
r141 (  44 62 ) resistor r=5.52526 //w=0.168 //l=0.115 //layer=ply \
 //thickness=0.18 //x=4.75 //y=0.93 //x2=4.635 //y2=0.93
r142 (  43 64 ) resistor r=5.52526 //w=0.168 //l=0.115 //layer=ply \
 //thickness=0.18 //x=4.97 //y=0.93 //x2=5.085 //y2=0.93
r143 (  43 44 ) resistor r=112.809 //w=0.094 //l=0.22 //layer=ply \
 //thickness=0.18 //x=4.97 //y=0.93 //x2=4.75 //y2=0.93
r144 (  42 60 ) resistor r=16.5046 //w=0.27 //l=0.135 //layer=ply \
 //thickness=0.18 //x=4.725 //y=4.97 //x2=4.59 //y2=4.97
r145 (  41 48 ) resistor r=26.9307 //w=0.15 //l=0.106066 //layer=ply \
 //thickness=0.18 //x=4.965 //y=4.97 //x2=5.04 //y2=5.045
r146 (  41 42 ) resistor r=123.064 //w=0.094 //l=0.24 //layer=ply \
 //thickness=0.18 //x=4.965 //y=4.97 //x2=4.725 //y2=4.97
r147 (  36 63 ) resistor r=39.5823 //w=0.21 //l=0.173853 //layer=ply \
 //thickness=0.18 //x=4.595 //y=1.74 //x2=4.635 //y2=1.585
r148 (  36 55 ) resistor r=182.032 //w=0.094 //l=0.355 //layer=ply \
 //thickness=0.18 //x=4.595 //y=1.74 //x2=4.595 //y2=2.095
r149 (  35 63 ) resistor r=39.5823 //w=0.21 //l=0.173853 //layer=ply \
 //thickness=0.18 //x=4.595 //y=1.43 //x2=4.635 //y2=1.585
r150 (  34 62 ) resistor r=45.1352 //w=0.168 //l=0.173853 //layer=ply \
 //thickness=0.18 //x=4.595 //y=1.085 //x2=4.635 //y2=0.93
r151 (  34 35 ) resistor r=176.904 //w=0.094 //l=0.345 //layer=ply \
 //thickness=0.18 //x=4.595 //y=1.085 //x2=4.595 //y2=1.43
r152 (  33 48 ) resistor r=592.245 //w=0.094 //l=1.155 //layer=ply \
 //thickness=0.18 //x=5.04 //y=6.2 //x2=5.04 //y2=5.045
r153 (  32 61 ) resistor r=592.245 //w=0.094 //l=1.155 //layer=ply \
 //thickness=0.18 //x=4.6 //y=6.2 //x2=4.6 //y2=5.045
r154 (  31 45 ) resistor r=56.4043 //w=0.094 //l=0.11 //layer=ply \
 //thickness=0.18 //x=4.86 //y=1.585 //x2=4.97 //y2=1.585
r155 (  31 46 ) resistor r=56.4043 //w=0.094 //l=0.11 //layer=ply \
 //thickness=0.18 //x=4.86 //y=1.585 //x2=4.75 //y2=1.585
r156 (  27 58 ) resistor r=152 //w=0.17 //l=0.17 //layer=licon //count=1 \
 //x=4.59 //y=4.88 //x2=4.59 //y2=4.88
r157 (  22 54 ) resistor r=152 //w=0.17 //l=0.17 //layer=licon //count=1 \
 //x=4.56 //y=2.26 //x2=4.56 //y2=2.26
r158 (  20 27 ) resistor r=9.3 //w=0.17 //l=0.17 //layer=mcon //count=1 \
 //x=4.59 //y=4.88 //x2=4.59 //y2=4.88
r159 (  16 22 ) resistor r=9.3 //w=0.17 //l=0.17 //layer=mcon //count=1 \
 //x=4.56 //y=2.26 //x2=4.56 //y2=2.26
r160 (  16 18 ) resistor r=0.0936408 //w=0.196 //l=0.125 //layer=m1 \
 //thickness=0.36 //x=4.562 //y=2.26 //x2=4.562 //y2=2.385
r161 (  8 20 ) resistor r=0.0878548 //w=0.228 //l=0.159295 //layer=m1 \
 //thickness=0.36 //x=4.56 //y=4.735 //x2=4.59 //y2=4.88
r162 (  6 8 ) resistor r=0.109733 //w=0.131 //l=0.115 //layer=m1 \
 //thickness=0.36 //x=4.56 //y=4.62 //x2=4.56 //y2=4.735
r163 (  5 6 ) resistor r=0.353053 //w=0.131 //l=0.37 //layer=m1 \
 //thickness=0.36 //x=4.56 //y=4.25 //x2=4.56 //y2=4.62
r164 (  4 5 ) resistor r=0.353053 //w=0.131 //l=0.37 //layer=m1 \
 //thickness=0.36 //x=4.56 //y=3.88 //x2=4.56 //y2=4.25
r165 (  3 4 ) resistor r=0.706107 //w=0.131 //l=0.74 //layer=m1 \
 //thickness=0.36 //x=4.56 //y=3.14 //x2=4.56 //y2=3.88
r166 (  2 3 ) resistor r=0.353053 //w=0.131 //l=0.37 //layer=m1 \
 //thickness=0.36 //x=4.56 //y=2.77 //x2=4.56 //y2=3.14
r167 (  1 2 ) resistor r=0.353053 //w=0.131 //l=0.37 //layer=m1 \
 //thickness=0.36 //x=4.56 //y=2.4 //x2=4.56 //y2=2.77
r168 (  1 18 ) resistor r=0.014313 //w=0.131 //l=0.015 //layer=m1 \
 //thickness=0.36 //x=4.56 //y=2.4 //x2=4.56 //y2=2.385
ends PM_MUX2X1\%A0

subckt PM_MUX2X1\%A1 ( 1 2 3 4 5 6 8 16 22 27 31 32 33 34 35 36 41 43 45 51 52 \
 54 55 58 )
c114 ( 58 0 ) capacitor c=0.0393541f //x=7.92 //y=4.88
c115 ( 55 0 ) capacitor c=0.0284095f //x=7.89 //y=2.095
c116 ( 54 0 ) capacitor c=0.0476356f //x=7.89 //y=2.26
c117 ( 52 0 ) capacitor c=0.0439708f //x=8.455 //y=1.43
c118 ( 51 0 ) capacitor c=0.0192582f //x=8.455 //y=1.085
c119 ( 45 0 ) capacitor c=0.0162526f //x=8.3 //y=1.585
c120 ( 43 0 ) capacitor c=0.0157807f //x=8.3 //y=0.93
c121 ( 41 0 ) capacitor c=0.0372668f //x=8.295 //y=4.97
c122 ( 36 0 ) capacitor c=0.0210762f //x=7.925 //y=1.74
c123 ( 35 0 ) capacitor c=0.0168511f //x=7.925 //y=1.43
c124 ( 34 0 ) capacitor c=0.0175485f //x=7.925 //y=1.085
c125 ( 33 0 ) capacitor c=0.155269f //x=8.37 //y=6.2
c126 ( 32 0 ) capacitor c=0.110375f //x=7.93 //y=6.2
c127 ( 27 0 ) capacitor c=8.90417e-19 //x=7.92 //y=4.88
c128 ( 22 0 ) capacitor c=7.72439e-19 //x=7.89 //y=2.26
c129 ( 16 0 ) capacitor c=0.00706954f //x=7.89 //y=2.26
c130 ( 8 0 ) capacitor c=0.00488947f //x=7.89 //y=4.735
c131 ( 1 0 ) capacitor c=0.0516434f //x=7.89 //y=2.4
r132 (  60 61 ) resistor r=32.4568 //w=0.214 //l=0.075 //layer=ply \
 //thickness=0.18 //x=7.92 //y=4.97 //x2=7.92 //y2=5.045
r133 (  58 60 ) resistor r=20.271 //w=0.214 //l=0.09 //layer=ply \
 //thickness=0.18 //x=7.92 //y=4.88 //x2=7.92 //y2=4.97
r134 (  54 55 ) resistor r=52.7279 //w=0.214 //l=0.165 //layer=ply \
 //thickness=0.18 //x=7.89 //y=2.26 //x2=7.89 //y2=2.095
r135 (  52 65 ) resistor r=45.1352 //w=0.168 //l=0.173853 //layer=ply \
 //thickness=0.18 //x=8.455 //y=1.43 //x2=8.415 //y2=1.585
r136 (  51 64 ) resistor r=45.1352 //w=0.168 //l=0.173853 //layer=ply \
 //thickness=0.18 //x=8.455 //y=1.085 //x2=8.415 //y2=0.93
r137 (  51 52 ) resistor r=176.904 //w=0.094 //l=0.345 //layer=ply \
 //thickness=0.18 //x=8.455 //y=1.085 //x2=8.455 //y2=1.43
r138 (  46 63 ) resistor r=10.701 //w=0.21 //l=0.115 //layer=ply \
 //thickness=0.18 //x=8.08 //y=1.585 //x2=7.965 //y2=1.585
r139 (  45 65 ) resistor r=5.52526 //w=0.168 //l=0.115 //layer=ply \
 //thickness=0.18 //x=8.3 //y=1.585 //x2=8.415 //y2=1.585
r140 (  44 62 ) resistor r=5.52526 //w=0.168 //l=0.115 //layer=ply \
 //thickness=0.18 //x=8.08 //y=0.93 //x2=7.965 //y2=0.93
r141 (  43 64 ) resistor r=5.52526 //w=0.168 //l=0.115 //layer=ply \
 //thickness=0.18 //x=8.3 //y=0.93 //x2=8.415 //y2=0.93
r142 (  43 44 ) resistor r=112.809 //w=0.094 //l=0.22 //layer=ply \
 //thickness=0.18 //x=8.3 //y=0.93 //x2=8.08 //y2=0.93
r143 (  42 60 ) resistor r=16.5046 //w=0.27 //l=0.135 //layer=ply \
 //thickness=0.18 //x=8.055 //y=4.97 //x2=7.92 //y2=4.97
r144 (  41 48 ) resistor r=26.9307 //w=0.15 //l=0.106066 //layer=ply \
 //thickness=0.18 //x=8.295 //y=4.97 //x2=8.37 //y2=5.045
r145 (  41 42 ) resistor r=123.064 //w=0.094 //l=0.24 //layer=ply \
 //thickness=0.18 //x=8.295 //y=4.97 //x2=8.055 //y2=4.97
r146 (  36 63 ) resistor r=39.5823 //w=0.21 //l=0.173853 //layer=ply \
 //thickness=0.18 //x=7.925 //y=1.74 //x2=7.965 //y2=1.585
r147 (  36 55 ) resistor r=182.032 //w=0.094 //l=0.355 //layer=ply \
 //thickness=0.18 //x=7.925 //y=1.74 //x2=7.925 //y2=2.095
r148 (  35 63 ) resistor r=39.5823 //w=0.21 //l=0.173853 //layer=ply \
 //thickness=0.18 //x=7.925 //y=1.43 //x2=7.965 //y2=1.585
r149 (  34 62 ) resistor r=45.1352 //w=0.168 //l=0.173853 //layer=ply \
 //thickness=0.18 //x=7.925 //y=1.085 //x2=7.965 //y2=0.93
r150 (  34 35 ) resistor r=176.904 //w=0.094 //l=0.345 //layer=ply \
 //thickness=0.18 //x=7.925 //y=1.085 //x2=7.925 //y2=1.43
r151 (  33 48 ) resistor r=592.245 //w=0.094 //l=1.155 //layer=ply \
 //thickness=0.18 //x=8.37 //y=6.2 //x2=8.37 //y2=5.045
r152 (  32 61 ) resistor r=592.245 //w=0.094 //l=1.155 //layer=ply \
 //thickness=0.18 //x=7.93 //y=6.2 //x2=7.93 //y2=5.045
r153 (  31 45 ) resistor r=56.4043 //w=0.094 //l=0.11 //layer=ply \
 //thickness=0.18 //x=8.19 //y=1.585 //x2=8.3 //y2=1.585
r154 (  31 46 ) resistor r=56.4043 //w=0.094 //l=0.11 //layer=ply \
 //thickness=0.18 //x=8.19 //y=1.585 //x2=8.08 //y2=1.585
r155 (  27 58 ) resistor r=152 //w=0.17 //l=0.17 //layer=licon //count=1 \
 //x=7.92 //y=4.88 //x2=7.92 //y2=4.88
r156 (  22 54 ) resistor r=152 //w=0.17 //l=0.17 //layer=licon //count=1 \
 //x=7.89 //y=2.26 //x2=7.89 //y2=2.26
r157 (  20 27 ) resistor r=9.3 //w=0.17 //l=0.17 //layer=mcon //count=1 \
 //x=7.92 //y=4.88 //x2=7.92 //y2=4.88
r158 (  16 22 ) resistor r=9.3 //w=0.17 //l=0.17 //layer=mcon //count=1 \
 //x=7.89 //y=2.26 //x2=7.89 //y2=2.26
r159 (  16 18 ) resistor r=0.0936408 //w=0.196 //l=0.125 //layer=m1 \
 //thickness=0.36 //x=7.892 //y=2.26 //x2=7.892 //y2=2.385
r160 (  8 20 ) resistor r=0.0878548 //w=0.228 //l=0.159295 //layer=m1 \
 //thickness=0.36 //x=7.89 //y=4.735 //x2=7.92 //y2=4.88
r161 (  6 8 ) resistor r=0.109733 //w=0.131 //l=0.115 //layer=m1 \
 //thickness=0.36 //x=7.89 //y=4.62 //x2=7.89 //y2=4.735
r162 (  5 6 ) resistor r=0.353053 //w=0.131 //l=0.37 //layer=m1 \
 //thickness=0.36 //x=7.89 //y=4.25 //x2=7.89 //y2=4.62
r163 (  4 5 ) resistor r=0.353053 //w=0.131 //l=0.37 //layer=m1 \
 //thickness=0.36 //x=7.89 //y=3.88 //x2=7.89 //y2=4.25
r164 (  3 4 ) resistor r=0.353053 //w=0.131 //l=0.37 //layer=m1 \
 //thickness=0.36 //x=7.89 //y=3.51 //x2=7.89 //y2=3.88
r165 (  2 3 ) resistor r=0.706107 //w=0.131 //l=0.74 //layer=m1 \
 //thickness=0.36 //x=7.89 //y=2.77 //x2=7.89 //y2=3.51
r166 (  1 2 ) resistor r=0.353053 //w=0.131 //l=0.37 //layer=m1 \
 //thickness=0.36 //x=7.89 //y=2.4 //x2=7.89 //y2=2.77
r167 (  1 18 ) resistor r=0.014313 //w=0.131 //l=0.015 //layer=m1 \
 //thickness=0.36 //x=7.89 //y=2.4 //x2=7.89 //y2=2.385
ends PM_MUX2X1\%A1

subckt PM_MUX2X1\%GND ( 1 2 10 19 33 36 37 42 43 47 48 61 65 68 79 92 114 122 \
 133 134 135 136 137 138 139 )
c269 ( 139 0 ) capacitor c=0.00843555f //x=10.36 //y=1.045
c270 ( 138 0 ) capacitor c=0.00843555f //x=7.03 //y=1.045
c271 ( 137 0 ) capacitor c=0.00843555f //x=3.7 //y=1.045
c272 ( 136 0 ) capacitor c=0.0634806f //x=0.985 //y=0.55
c273 ( 135 0 ) capacitor c=0.117588f //x=9.37 //y=0.175
c274 ( 134 0 ) capacitor c=0.117537f //x=6.04 //y=0.175
c275 ( 133 0 ) capacitor c=0.112336f //x=2.71 //y=0.175
c276 ( 122 0 ) capacitor c=0.216606f //x=1.12 //y=0.175
c277 ( 114 0 ) capacitor c=0.335328f //x=11.96 //y=0.18
c278 ( 92 0 ) capacitor c=0.125208f //x=9.2 //y=0.175
c279 ( 79 0 ) capacitor c=0.125154f //x=5.87 //y=0.175
c280 ( 74 0 ) capacitor c=0.0366946f //x=2.175 //y=0.175
c281 ( 73 0 ) capacitor c=0.0185464f //x=2.54 //y=0.175
c282 ( 68 0 ) capacitor c=0.00585268f //x=2.09 //y=0.63
c283 ( 65 0 ) capacitor c=0.0061439f //x=2.005 //y=0.715
c284 ( 64 0 ) capacitor c=0.00479851f //x=1.6 //y=0.63
c285 ( 61 0 ) capacitor c=0.00599877f //x=1.515 //y=0.715
c286 ( 56 0 ) capacitor c=0.00590583f //x=1.12 //y=0.63
c287 ( 50 0 ) capacitor c=0.00509083f //x=10.55 //y=0.175
c288 ( 48 0 ) capacitor c=0.0232551f //x=10.547 //y=1.005
c289 ( 47 0 ) capacitor c=0.0129318f //x=10.55 //y=1.135
c290 ( 45 0 ) capacitor c=0.00509083f //x=7.22 //y=0.175
c291 ( 43 0 ) capacitor c=0.0188922f //x=7.217 //y=1.005
c292 ( 42 0 ) capacitor c=0.0125287f //x=7.22 //y=1.135
c293 ( 40 0 ) capacitor c=0.00509083f //x=3.82 //y=0.18
c294 ( 37 0 ) capacitor c=0.0235363f //x=3.887 //y=1.005
c295 ( 36 0 ) capacitor c=0.0126338f //x=3.89 //y=1.135
c296 ( 33 0 ) capacitor c=0.102486f //x=11.96 //y=0.18
c297 ( 19 0 ) capacitor c=0.110839f //x=10.465 //y=0.175
c298 ( 10 0 ) capacitor c=0.110659f //x=7.135 //y=0.175
c299 ( 2 0 ) capacitor c=0.15397f //x=3.805 //y=0.175
r300 (  125 126 ) resistor r=17.0899 //w=0.367 //l=0.49 //layer=li \
 //thickness=0.1 //x=1.6 //y=0.175 //x2=2.09 //y2=0.175
r301 (  124 125 ) resistor r=12.9046 //w=0.367 //l=0.37 //layer=li \
 //thickness=0.1 //x=1.23 //y=0.175 //x2=1.6 //y2=0.175
r302 (  122 124 ) resistor r=3.83651 //w=0.367 //l=0.11 //layer=li \
 //thickness=0.1 //x=1.12 //y=0.175 //x2=1.23 //y2=0.175
r303 (  112 114 ) resistor r=25.8093 //w=0.367 //l=0.74 //layer=li \
 //thickness=0.1 //x=11.22 //y=0.175 //x2=11.96 //y2=0.175
r304 (  110 112 ) resistor r=38.7139 //w=0.367 //l=1.11 //layer=li \
 //thickness=0.1 //x=10.11 //y=0.175 //x2=11.22 //y2=0.175
r305 (  108 135 ) resistor r=5.29055 //w=0.35 //l=0.17 //layer=li \
 //thickness=0.1 //x=9.54 //y=0.175 //x2=9.37 //y2=0.175
r306 (  108 110 ) resistor r=19.8801 //w=0.367 //l=0.57 //layer=li \
 //thickness=0.1 //x=9.54 //y=0.175 //x2=10.11 //y2=0.175
r307 (  97 99 ) resistor r=38.7139 //w=0.367 //l=1.11 //layer=li \
 //thickness=0.1 //x=7.52 //y=0.175 //x2=8.63 //y2=0.175
r308 (  95 97 ) resistor r=38.7139 //w=0.367 //l=1.11 //layer=li \
 //thickness=0.1 //x=6.41 //y=0.175 //x2=7.52 //y2=0.175
r309 (  93 134 ) resistor r=5.29055 //w=0.35 //l=0.17 //layer=li \
 //thickness=0.1 //x=6.21 //y=0.175 //x2=6.04 //y2=0.175
r310 (  93 95 ) resistor r=6.97548 //w=0.367 //l=0.2 //layer=li \
 //thickness=0.1 //x=6.21 //y=0.175 //x2=6.41 //y2=0.175
r311 (  92 135 ) resistor r=5.29055 //w=0.35 //l=0.17 //layer=li \
 //thickness=0.1 //x=9.2 //y=0.175 //x2=9.37 //y2=0.175
r312 (  92 99 ) resistor r=19.8801 //w=0.367 //l=0.57 //layer=li \
 //thickness=0.1 //x=9.2 //y=0.175 //x2=8.63 //y2=0.175
r313 (  82 84 ) resistor r=38.7139 //w=0.367 //l=1.11 //layer=li \
 //thickness=0.1 //x=3.82 //y=0.175 //x2=4.93 //y2=0.175
r314 (  80 133 ) resistor r=5.29055 //w=0.35 //l=0.17 //layer=li \
 //thickness=0.1 //x=2.88 //y=0.175 //x2=2.71 //y2=0.175
r315 (  80 82 ) resistor r=32.7847 //w=0.367 //l=0.94 //layer=li \
 //thickness=0.1 //x=2.88 //y=0.175 //x2=3.82 //y2=0.175
r316 (  79 134 ) resistor r=5.29055 //w=0.35 //l=0.17 //layer=li \
 //thickness=0.1 //x=5.87 //y=0.175 //x2=6.04 //y2=0.175
r317 (  79 84 ) resistor r=32.7847 //w=0.367 //l=0.94 //layer=li \
 //thickness=0.1 //x=5.87 //y=0.175 //x2=4.93 //y2=0.175
r318 (  74 126 ) resistor r=2.96458 //w=0.367 //l=0.085 //layer=li \
 //thickness=0.1 //x=2.175 //y=0.175 //x2=2.09 //y2=0.175
r319 (  74 76 ) resistor r=5.75477 //w=0.367 //l=0.165 //layer=li \
 //thickness=0.1 //x=2.175 //y=0.175 //x2=2.34 //y2=0.175
r320 (  73 133 ) resistor r=5.29055 //w=0.35 //l=0.17 //layer=li \
 //thickness=0.1 //x=2.54 //y=0.175 //x2=2.71 //y2=0.175
r321 (  73 76 ) resistor r=6.97548 //w=0.367 //l=0.2 //layer=li \
 //thickness=0.1 //x=2.54 //y=0.175 //x2=2.34 //y2=0.175
r322 (  69 136 ) resistor r=5.4201 //w=0.17 //l=0.085 //layer=li \
 //thickness=0.1 //x=2.09 //y=0.8 //x2=2.09 //y2=0.715
r323 (  69 136 ) resistor r=41.4118 //w=0.187 //l=0.605 //layer=li \
 //thickness=0.1 //x=2.09 //y=0.8 //x2=2.09 //y2=1.405
r324 (  68 136 ) resistor r=5.4201 //w=0.17 //l=0.085 //layer=li \
 //thickness=0.1 //x=2.09 //y=0.63 //x2=2.09 //y2=0.715
r325 (  67 126 ) resistor r=5.21862 //w=0.35 //l=0.175 //layer=li \
 //thickness=0.1 //x=2.09 //y=0.35 //x2=2.09 //y2=0.175
r326 (  67 68 ) resistor r=19.1658 //w=0.187 //l=0.28 //layer=li \
 //thickness=0.1 //x=2.09 //y=0.35 //x2=2.09 //y2=0.63
r327 (  66 136 ) resistor r=5.4201 //w=0.17 //l=0.085 //layer=li \
 //thickness=0.1 //x=1.685 //y=0.715 //x2=1.6 //y2=0.715
r328 (  65 136 ) resistor r=1.40859 //w=0.34 //l=0.085 //layer=li \
 //thickness=0.1 //x=2.005 //y=0.715 //x2=2.09 //y2=0.715
r329 (  65 66 ) resistor r=21.9037 //w=0.187 //l=0.32 //layer=li \
 //thickness=0.1 //x=2.005 //y=0.715 //x2=1.685 //y2=0.715
r330 (  64 136 ) resistor r=1.40859 //w=0.34 //l=0.085 //layer=li \
 //thickness=0.1 //x=1.6 //y=0.63 //x2=1.6 //y2=0.715
r331 (  63 125 ) resistor r=5.21862 //w=0.35 //l=0.175 //layer=li \
 //thickness=0.1 //x=1.6 //y=0.35 //x2=1.6 //y2=0.175
r332 (  63 64 ) resistor r=19.1658 //w=0.187 //l=0.28 //layer=li \
 //thickness=0.1 //x=1.6 //y=0.35 //x2=1.6 //y2=0.63
r333 (  62 136 ) resistor r=1.40859 //w=0.34 //l=0.085 //layer=li \
 //thickness=0.1 //x=1.205 //y=0.715 //x2=1.12 //y2=0.715
r334 (  61 136 ) resistor r=5.4201 //w=0.17 //l=0.085 //layer=li \
 //thickness=0.1 //x=1.515 //y=0.715 //x2=1.6 //y2=0.715
r335 (  61 62 ) resistor r=21.2193 //w=0.187 //l=0.31 //layer=li \
 //thickness=0.1 //x=1.515 //y=0.715 //x2=1.205 //y2=0.715
r336 (  57 136 ) resistor r=5.4201 //w=0.17 //l=0.085 //layer=li \
 //thickness=0.1 //x=1.12 //y=0.8 //x2=1.12 //y2=0.715
r337 (  57 136 ) resistor r=41.4118 //w=0.187 //l=0.605 //layer=li \
 //thickness=0.1 //x=1.12 //y=0.8 //x2=1.12 //y2=1.405
r338 (  56 136 ) resistor r=5.4201 //w=0.17 //l=0.085 //layer=li \
 //thickness=0.1 //x=1.12 //y=0.63 //x2=1.12 //y2=0.715
r339 (  55 122 ) resistor r=5.21862 //w=0.35 //l=0.175 //layer=li \
 //thickness=0.1 //x=1.12 //y=0.35 //x2=1.12 //y2=0.175
r340 (  55 56 ) resistor r=19.1658 //w=0.187 //l=0.28 //layer=li \
 //thickness=0.1 //x=1.12 //y=0.35 //x2=1.12 //y2=0.63
r341 (  47 139 ) resistor r=9.3 //w=0.17 //l=0.17 //layer=mcon //count=1 \
 //x=10.55 //y=1.135 //x2=10.55 //y2=1.135
r342 (  47 48 ) resistor r=0.0939994 //w=0.226 //l=0.13 //layer=m1 \
 //thickness=0.36 //x=10.547 //y=1.135 //x2=10.547 //y2=1.005
r343 (  42 138 ) resistor r=9.3 //w=0.17 //l=0.17 //layer=mcon //count=1 \
 //x=7.22 //y=1.135 //x2=7.22 //y2=1.135
r344 (  42 43 ) resistor r=0.0939994 //w=0.226 //l=0.13 //layer=m1 \
 //thickness=0.36 //x=7.217 //y=1.135 //x2=7.217 //y2=1.005
r345 (  40 82 ) resistor r=3.1 //w=0.17 //l=0.51 //layer=mcon //count=3 \
 //x=3.82 //y=0.18 //x2=3.82 //y2=0.18
r346 (  36 137 ) resistor r=9.3 //w=0.17 //l=0.17 //layer=mcon //count=1 \
 //x=3.89 //y=1.135 //x2=3.89 //y2=1.135
r347 (  36 37 ) resistor r=0.0939994 //w=0.226 //l=0.13 //layer=m1 \
 //thickness=0.36 //x=3.887 //y=1.135 //x2=3.887 //y2=1.005
r348 (  33 114 ) resistor r=4.65 //w=0.17 //l=0.34 //layer=mcon //count=2 \
 //x=11.96 //y=0.18 //x2=11.96 //y2=0.18
r349 (  31 112 ) resistor r=3.1 //w=0.17 //l=0.51 //layer=mcon //count=3 \
 //x=11.22 //y=0.18 //x2=11.22 //y2=0.18
r350 (  31 33 ) resistor r=0.297428 //w=0.311 //l=0.74 //layer=m1 \
 //thickness=0.36 //x=11.22 //y=0.175 //x2=11.96 //y2=0.175
r351 (  29 50 ) resistor r=0.028033 //w=0.35 //l=0.085 //layer=m1 \
 //thickness=0.36 //x=10.635 //y=0.175 //x2=10.55 //y2=0.175
r352 (  29 31 ) resistor r=0.235129 //w=0.311 //l=0.585 //layer=m1 \
 //thickness=0.36 //x=10.635 //y=0.175 //x2=11.22 //y2=0.175
r353 (  27 50 ) resistor r=0.0413265 //w=0.7 //l=0.175 //layer=m1 \
 //thickness=0.36 //x=10.55 //y=0.35 //x2=10.55 //y2=0.175
r354 (  27 48 ) resistor r=0.625 //w=0.131 //l=0.655 //layer=m1 \
 //thickness=0.36 //x=10.55 //y=0.35 //x2=10.55 //y2=1.005
r355 (  26 110 ) resistor r=3.1 //w=0.17 //l=0.51 //layer=mcon //count=3 \
 //x=10.11 //y=0.18 //x2=10.11 //y2=0.18
r356 (  24 99 ) resistor r=3.1 //w=0.17 //l=0.51 //layer=mcon //count=3 \
 //x=8.63 //y=0.18 //x2=8.63 //y2=0.18
r357 (  24 26 ) resistor r=0.594855 //w=0.311 //l=1.48 //layer=m1 \
 //thickness=0.36 //x=8.63 //y=0.175 //x2=10.11 //y2=0.175
r358 (  22 97 ) resistor r=3.1 //w=0.17 //l=0.51 //layer=mcon //count=3 \
 //x=7.52 //y=0.18 //x2=7.52 //y2=0.18
r359 (  22 24 ) resistor r=0.446141 //w=0.311 //l=1.11 //layer=m1 \
 //thickness=0.36 //x=7.52 //y=0.175 //x2=8.63 //y2=0.175
r360 (  20 45 ) resistor r=0.028033 //w=0.35 //l=0.085 //layer=m1 \
 //thickness=0.36 //x=7.305 //y=0.175 //x2=7.22 //y2=0.175
r361 (  20 22 ) resistor r=0.0864148 //w=0.311 //l=0.215 //layer=m1 \
 //thickness=0.36 //x=7.305 //y=0.175 //x2=7.52 //y2=0.175
r362 (  19 50 ) resistor r=0.028033 //w=0.35 //l=0.085 //layer=m1 \
 //thickness=0.36 //x=10.465 //y=0.175 //x2=10.55 //y2=0.175
r363 (  19 26 ) resistor r=0.142685 //w=0.311 //l=0.355 //layer=m1 \
 //thickness=0.36 //x=10.465 //y=0.175 //x2=10.11 //y2=0.175
r364 (  17 45 ) resistor r=0.0413265 //w=0.7 //l=0.175 //layer=m1 \
 //thickness=0.36 //x=7.22 //y=0.35 //x2=7.22 //y2=0.175
r365 (  17 43 ) resistor r=0.625 //w=0.131 //l=0.655 //layer=m1 \
 //thickness=0.36 //x=7.22 //y=0.35 //x2=7.22 //y2=1.005
r366 (  15 95 ) resistor r=3.1 //w=0.17 //l=0.51 //layer=mcon //count=3 \
 //x=6.41 //y=0.18 //x2=6.41 //y2=0.18
r367 (  13 84 ) resistor r=3.1 //w=0.17 //l=0.51 //layer=mcon //count=3 \
 //x=4.93 //y=0.18 //x2=4.93 //y2=0.18
r368 (  13 15 ) resistor r=0.594855 //w=0.311 //l=1.48 //layer=m1 \
 //thickness=0.36 //x=4.93 //y=0.175 //x2=6.41 //y2=0.175
r369 (  11 40 ) resistor r=0.028033 //w=0.35 //l=0.085 //layer=m1 \
 //thickness=0.36 //x=3.975 //y=0.175 //x2=3.89 //y2=0.175
r370 (  11 13 ) resistor r=0.383842 //w=0.311 //l=0.955 //layer=m1 \
 //thickness=0.36 //x=3.975 //y=0.175 //x2=4.93 //y2=0.175
r371 (  10 45 ) resistor r=0.028033 //w=0.35 //l=0.085 //layer=m1 \
 //thickness=0.36 //x=7.135 //y=0.175 //x2=7.22 //y2=0.175
r372 (  8 40 ) resistor r=0.0413265 //w=0.7 //l=0.175 //layer=m1 \
 //thickness=0.36 //x=3.89 //y=0.35 //x2=3.89 //y2=0.175
r373 (  8 37 ) resistor r=0.625 //w=0.131 //l=0.655 //layer=m1 \
 //thickness=0.36 //x=3.89 //y=0.35 //x2=3.89 //y2=1.005
r374 (  7 76 ) resistor r=3.1 //w=0.17 //l=0.51 //layer=mcon //count=3 \
 //x=2.34 //y=0.18 //x2=2.34 //y2=0.18
r375 (  4 124 ) resistor r=3.1 //w=0.17 //l=0.51 //layer=mcon //count=3 \
 //x=1.23 //y=0.18 //x2=1.23 //y2=0.18
r376 (  4 7 ) resistor r=0.446141 //w=0.311 //l=1.11 //layer=m1 \
 //thickness=0.36 //x=1.23 //y=0.175 //x2=2.34 //y2=0.175
r377 (  2 40 ) resistor r=0.028033 //w=0.35 //l=0.085 //layer=m1 \
 //thickness=0.36 //x=3.805 //y=0.175 //x2=3.89 //y2=0.175
r378 (  2 7 ) resistor r=0.588826 //w=0.311 //l=1.465 //layer=m1 \
 //thickness=0.36 //x=3.805 //y=0.175 //x2=2.34 //y2=0.175
r379 (  1 10 ) resistor r=0.217042 //w=0.311 //l=0.54 //layer=m1 \
 //thickness=0.36 //x=6.595 //y=0.175 //x2=7.135 //y2=0.175
r380 (  1 15 ) resistor r=0.0743569 //w=0.311 //l=0.185 //layer=m1 \
 //thickness=0.36 //x=6.595 //y=0.175 //x2=6.41 //y2=0.175
ends PM_MUX2X1\%GND

subckt PM_MUX2X1\%Y ( 1 2 3 4 5 6 7 8 11 16 17 19 20 33 34 37 39 42 50 62 64 \
 65 )
c119 ( 62 0 ) capacitor c=0.00878249f //x=11.33 //y=1.085
c120 ( 50 0 ) capacitor c=0.0326476f //x=11.48 //y=5.56
c121 ( 42 0 ) capacitor c=0.0290186f //x=10.6 //y=5.56
c122 ( 39 0 ) capacitor c=0.014893f //x=11.52 //y=1.18
c123 ( 37 0 ) capacitor c=6.70882e-19 //x=11.48 //y=5.56
c124 ( 34 0 ) capacitor c=0.0157742f //x=11.48 //y=5.38
c125 ( 33 0 ) capacitor c=0.00950636f //x=10.6 //y=5.56
c126 ( 20 0 ) capacitor c=0.0069619f //x=11.605 //y=1.835
c127 ( 19 0 ) capacitor c=0.0165738f //x=11.875 //y=1.835
c128 ( 17 0 ) capacitor c=0.0143926f //x=11.875 //y=5.38
c129 ( 16 0 ) capacitor c=0.0133876f //x=11.52 //y=1.75
c130 ( 11 0 ) capacitor c=0.0145661f //x=11.365 //y=5.38
c131 ( 1 0 ) capacitor c=0.129787f //x=11.96 //y=2.4
r132 (  50 65 ) resistor r=23.615 //w=0.187 //l=0.345 //layer=li \
 //thickness=0.1 //x=11.48 //y=5.56 //x2=11.48 //y2=5.905
r133 (  42 64 ) resistor r=23.615 //w=0.187 //l=0.345 //layer=li \
 //thickness=0.1 //x=10.6 //y=5.56 //x2=10.6 //y2=5.905
r134 (  39 62 ) resistor r=9.3 //w=0.17 //l=0.17 //layer=mcon //count=1 \
 //x=11.52 //y=1.18 //x2=11.52 //y2=1.18
r135 (  37 50 ) resistor r=9.3 //w=0.17 //l=0.17 //layer=mcon //count=1 \
 //x=11.48 //y=5.56 //x2=11.48 //y2=5.56
r136 (  34 37 ) resistor r=0.117801 //w=0.191 //l=0.18 //layer=m1 \
 //thickness=0.36 //x=11.48 //y=5.38 //x2=11.48 //y2=5.56
r137 (  33 42 ) resistor r=9.3 //w=0.17 //l=0.17 //layer=mcon //count=1 \
 //x=10.6 //y=5.56 //x2=10.6 //y2=5.56
r138 (  31 33 ) resistor r=0.10274 //w=0.219 //l=0.18 //layer=m1 \
 //thickness=0.36 //x=10.6 //y=5.38 //x2=10.6 //y2=5.56
r139 (  19 21 ) resistor r=0.0698411 //w=0.17 //l=0.120208 //layer=m1 \
 //thickness=0.36 //x=11.875 //y=1.835 //x2=11.96 //y2=1.92
r140 (  19 20 ) resistor r=0.257634 //w=0.131 //l=0.27 //layer=m1 \
 //thickness=0.36 //x=11.875 //y=1.835 //x2=11.605 //y2=1.835
r141 (  18 34 ) resistor r=0.0257089 //w=0.23 //l=0.115 //layer=m1 \
 //thickness=0.36 //x=11.595 //y=5.38 //x2=11.48 //y2=5.38
r142 (  17 22 ) resistor r=0.0698411 //w=0.17 //l=0.120208 //layer=m1 \
 //thickness=0.36 //x=11.875 //y=5.38 //x2=11.96 //y2=5.295
r143 (  17 18 ) resistor r=0.267176 //w=0.131 //l=0.28 //layer=m1 \
 //thickness=0.36 //x=11.875 //y=5.38 //x2=11.595 //y2=5.38
r144 (  16 20 ) resistor r=0.0698411 //w=0.17 //l=0.120208 //layer=m1 \
 //thickness=0.36 //x=11.52 //y=1.75 //x2=11.605 //y2=1.835
r145 (  15 39 ) resistor r=0.0913624 //w=0.191 //l=0.12 //layer=m1 \
 //thickness=0.36 //x=11.52 //y=1.3 //x2=11.52 //y2=1.18
r146 (  15 16 ) resistor r=0.429389 //w=0.131 //l=0.45 //layer=m1 \
 //thickness=0.36 //x=11.52 //y=1.3 //x2=11.52 //y2=1.75
r147 (  12 31 ) resistor r=0.0227762 //w=0.219 //l=0.115 //layer=m1 \
 //thickness=0.36 //x=10.715 //y=5.38 //x2=10.6 //y2=5.38
r148 (  11 34 ) resistor r=0.0257089 //w=0.23 //l=0.115 //layer=m1 \
 //thickness=0.36 //x=11.365 //y=5.38 //x2=11.48 //y2=5.38
r149 (  11 12 ) resistor r=0.620229 //w=0.131 //l=0.65 //layer=m1 \
 //thickness=0.36 //x=11.365 //y=5.38 //x2=10.715 //y2=5.38
r150 (  8 22 ) resistor r=0.291031 //w=0.131 //l=0.305 //layer=m1 \
 //thickness=0.36 //x=11.96 //y=4.99 //x2=11.96 //y2=5.295
r151 (  7 8 ) resistor r=0.353053 //w=0.131 //l=0.37 //layer=m1 \
 //thickness=0.36 //x=11.96 //y=4.62 //x2=11.96 //y2=4.99
r152 (  6 7 ) resistor r=0.353053 //w=0.131 //l=0.37 //layer=m1 \
 //thickness=0.36 //x=11.96 //y=4.25 //x2=11.96 //y2=4.62
r153 (  5 6 ) resistor r=0.353053 //w=0.131 //l=0.37 //layer=m1 \
 //thickness=0.36 //x=11.96 //y=3.88 //x2=11.96 //y2=4.25
r154 (  4 5 ) resistor r=0.353053 //w=0.131 //l=0.37 //layer=m1 \
 //thickness=0.36 //x=11.96 //y=3.51 //x2=11.96 //y2=3.88
r155 (  3 4 ) resistor r=0.353053 //w=0.131 //l=0.37 //layer=m1 \
 //thickness=0.36 //x=11.96 //y=3.14 //x2=11.96 //y2=3.51
r156 (  2 3 ) resistor r=0.353053 //w=0.131 //l=0.37 //layer=m1 \
 //thickness=0.36 //x=11.96 //y=2.77 //x2=11.96 //y2=3.14
r157 (  1 2 ) resistor r=0.353053 //w=0.131 //l=0.37 //layer=m1 \
 //thickness=0.36 //x=11.96 //y=2.4 //x2=11.96 //y2=2.77
r158 (  1 21 ) resistor r=0.458015 //w=0.131 //l=0.48 //layer=m1 \
 //thickness=0.36 //x=11.96 //y=2.4 //x2=11.96 //y2=1.92
ends PM_MUX2X1\%Y

subckt PM_MUX2X1\%noxref_10 ( 1 5 9 10 13 17 29 )
c69 ( 29 0 ) capacitor c=0.0665721f //x=3.27 //y=0.545
c70 ( 17 0 ) capacitor c=0.0067865f //x=5.345 //y=0.795
c71 ( 13 0 ) capacitor c=0.0157877f //x=5.26 //y=0.71
c72 ( 10 0 ) capacitor c=0.0072478f //x=4.375 //y=1.675
c73 ( 9 0 ) capacitor c=0.00770028f //x=4.375 //y=0.795
c74 ( 5 0 ) capacitor c=0.0191851f //x=4.29 //y=1.76
c75 ( 1 0 ) capacitor c=0.00806643f //x=3.405 //y=1.675
r76 (  17 29 ) resistor r=3.57586 //w=0.17 //l=0.125 //layer=li \
 //thickness=0.1 //x=5.345 //y=0.795 //x2=5.345 //y2=0.67
r77 (  17 29 ) resistor r=18.139 //w=0.187 //l=0.265 //layer=li \
 //thickness=0.1 //x=5.345 //y=0.795 //x2=5.345 //y2=1.06
r78 (  14 29 ) resistor r=3.57586 //w=0.17 //l=0.103078 //layer=li \
 //thickness=0.1 //x=4.46 //y=0.71 //x2=4.375 //y2=0.67
r79 (  14 29 ) resistor r=27.3797 //w=0.187 //l=0.4 //layer=li //thickness=0.1 \
 //x=4.46 //y=0.71 //x2=4.86 //y2=0.71
r80 (  13 29 ) resistor r=3.57586 //w=0.17 //l=0.103078 //layer=li \
 //thickness=0.1 //x=5.26 //y=0.71 //x2=5.345 //y2=0.67
r81 (  13 29 ) resistor r=27.3797 //w=0.187 //l=0.4 //layer=li //thickness=0.1 \
 //x=5.26 //y=0.71 //x2=4.86 //y2=0.71
r82 (  10 29 ) resistor r=3.57586 //w=0.17 //l=0.125 //layer=li \
 //thickness=0.1 //x=4.375 //y=1.675 //x2=4.375 //y2=1.8
r83 (  10 29 ) resistor r=42.0963 //w=0.187 //l=0.615 //layer=li \
 //thickness=0.1 //x=4.375 //y=1.675 //x2=4.375 //y2=1.06
r84 (  9 29 ) resistor r=3.57586 //w=0.17 //l=0.125 //layer=li //thickness=0.1 \
 //x=4.375 //y=0.795 //x2=4.375 //y2=0.67
r85 (  9 29 ) resistor r=18.139 //w=0.187 //l=0.265 //layer=li //thickness=0.1 \
 //x=4.375 //y=0.795 //x2=4.375 //y2=1.06
r86 (  6 29 ) resistor r=3.57586 //w=0.17 //l=0.103078 //layer=li \
 //thickness=0.1 //x=3.49 //y=1.76 //x2=3.405 //y2=1.8
r87 (  6 29 ) resistor r=27.3797 //w=0.187 //l=0.4 //layer=li //thickness=0.1 \
 //x=3.49 //y=1.76 //x2=3.89 //y2=1.76
r88 (  5 29 ) resistor r=3.57586 //w=0.17 //l=0.103078 //layer=li \
 //thickness=0.1 //x=4.29 //y=1.76 //x2=4.375 //y2=1.8
r89 (  5 29 ) resistor r=27.3797 //w=0.187 //l=0.4 //layer=li //thickness=0.1 \
 //x=4.29 //y=1.76 //x2=3.89 //y2=1.76
r90 (  1 29 ) resistor r=3.57586 //w=0.17 //l=0.125 //layer=li //thickness=0.1 \
 //x=3.405 //y=1.675 //x2=3.405 //y2=1.8
r91 (  1 29 ) resistor r=42.0963 //w=0.187 //l=0.615 //layer=li \
 //thickness=0.1 //x=3.405 //y=1.675 //x2=3.405 //y2=1.06
ends PM_MUX2X1\%noxref_10

subckt PM_MUX2X1\%noxref_11 ( 1 5 9 10 13 17 29 )
c71 ( 29 0 ) capacitor c=0.0667959f //x=6.6 //y=0.545
c72 ( 17 0 ) capacitor c=0.0067865f //x=8.675 //y=0.795
c73 ( 13 0 ) capacitor c=0.0157877f //x=8.59 //y=0.71
c74 ( 10 0 ) capacitor c=0.00705387f //x=7.705 //y=1.675
c75 ( 9 0 ) capacitor c=0.00770028f //x=7.705 //y=0.795
c76 ( 5 0 ) capacitor c=0.0188663f //x=7.62 //y=1.76
c77 ( 1 0 ) capacitor c=0.00798633f //x=6.735 //y=1.675
r78 (  17 29 ) resistor r=3.57586 //w=0.17 //l=0.125 //layer=li \
 //thickness=0.1 //x=8.675 //y=0.795 //x2=8.675 //y2=0.67
r79 (  17 29 ) resistor r=18.139 //w=0.187 //l=0.265 //layer=li \
 //thickness=0.1 //x=8.675 //y=0.795 //x2=8.675 //y2=1.06
r80 (  14 29 ) resistor r=3.57586 //w=0.17 //l=0.103078 //layer=li \
 //thickness=0.1 //x=7.79 //y=0.71 //x2=7.705 //y2=0.67
r81 (  14 29 ) resistor r=27.3797 //w=0.187 //l=0.4 //layer=li //thickness=0.1 \
 //x=7.79 //y=0.71 //x2=8.19 //y2=0.71
r82 (  13 29 ) resistor r=3.57586 //w=0.17 //l=0.103078 //layer=li \
 //thickness=0.1 //x=8.59 //y=0.71 //x2=8.675 //y2=0.67
r83 (  13 29 ) resistor r=27.3797 //w=0.187 //l=0.4 //layer=li //thickness=0.1 \
 //x=8.59 //y=0.71 //x2=8.19 //y2=0.71
r84 (  10 29 ) resistor r=3.57586 //w=0.17 //l=0.125 //layer=li \
 //thickness=0.1 //x=7.705 //y=1.675 //x2=7.705 //y2=1.8
r85 (  10 29 ) resistor r=42.0963 //w=0.187 //l=0.615 //layer=li \
 //thickness=0.1 //x=7.705 //y=1.675 //x2=7.705 //y2=1.06
r86 (  9 29 ) resistor r=3.57586 //w=0.17 //l=0.125 //layer=li //thickness=0.1 \
 //x=7.705 //y=0.795 //x2=7.705 //y2=0.67
r87 (  9 29 ) resistor r=18.139 //w=0.187 //l=0.265 //layer=li //thickness=0.1 \
 //x=7.705 //y=0.795 //x2=7.705 //y2=1.06
r88 (  6 29 ) resistor r=3.57586 //w=0.17 //l=0.103078 //layer=li \
 //thickness=0.1 //x=6.82 //y=1.76 //x2=6.735 //y2=1.8
r89 (  6 29 ) resistor r=27.3797 //w=0.187 //l=0.4 //layer=li //thickness=0.1 \
 //x=6.82 //y=1.76 //x2=7.22 //y2=1.76
r90 (  5 29 ) resistor r=3.57586 //w=0.17 //l=0.103078 //layer=li \
 //thickness=0.1 //x=7.62 //y=1.76 //x2=7.705 //y2=1.8
r91 (  5 29 ) resistor r=27.3797 //w=0.187 //l=0.4 //layer=li //thickness=0.1 \
 //x=7.62 //y=1.76 //x2=7.22 //y2=1.76
r92 (  1 29 ) resistor r=3.57586 //w=0.17 //l=0.125 //layer=li //thickness=0.1 \
 //x=6.735 //y=1.675 //x2=6.735 //y2=1.8
r93 (  1 29 ) resistor r=42.0963 //w=0.187 //l=0.615 //layer=li \
 //thickness=0.1 //x=6.735 //y=1.675 //x2=6.735 //y2=1.06
ends PM_MUX2X1\%noxref_11

subckt PM_MUX2X1\%noxref_12 ( 1 5 9 10 13 17 29 )
c58 ( 29 0 ) capacitor c=0.0681699f //x=9.93 //y=0.545
c59 ( 17 0 ) capacitor c=0.00709791f //x=12.005 //y=0.795
c60 ( 13 0 ) capacitor c=0.0157752f //x=11.92 //y=0.71
c61 ( 10 0 ) capacitor c=0.00708541f //x=11.035 //y=1.675
c62 ( 9 0 ) capacitor c=0.00770028f //x=11.035 //y=0.795
c63 ( 5 0 ) capacitor c=0.019147f //x=10.95 //y=1.76
c64 ( 1 0 ) capacitor c=0.00798655f //x=10.065 //y=1.675
r65 (  17 29 ) resistor r=3.57586 //w=0.17 //l=0.125 //layer=li \
 //thickness=0.1 //x=12.005 //y=0.795 //x2=12.005 //y2=0.67
r66 (  17 29 ) resistor r=18.139 //w=0.187 //l=0.265 //layer=li \
 //thickness=0.1 //x=12.005 //y=0.795 //x2=12.005 //y2=1.06
r67 (  14 29 ) resistor r=3.57586 //w=0.17 //l=0.103078 //layer=li \
 //thickness=0.1 //x=11.12 //y=0.71 //x2=11.035 //y2=0.67
r68 (  14 29 ) resistor r=27.3797 //w=0.187 //l=0.4 //layer=li //thickness=0.1 \
 //x=11.12 //y=0.71 //x2=11.52 //y2=0.71
r69 (  13 29 ) resistor r=3.57586 //w=0.17 //l=0.103078 //layer=li \
 //thickness=0.1 //x=11.92 //y=0.71 //x2=12.005 //y2=0.67
r70 (  13 29 ) resistor r=27.3797 //w=0.187 //l=0.4 //layer=li //thickness=0.1 \
 //x=11.92 //y=0.71 //x2=11.52 //y2=0.71
r71 (  10 29 ) resistor r=3.57586 //w=0.17 //l=0.125 //layer=li \
 //thickness=0.1 //x=11.035 //y=1.675 //x2=11.035 //y2=1.8
r72 (  10 29 ) resistor r=42.0963 //w=0.187 //l=0.615 //layer=li \
 //thickness=0.1 //x=11.035 //y=1.675 //x2=11.035 //y2=1.06
r73 (  9 29 ) resistor r=3.57586 //w=0.17 //l=0.125 //layer=li //thickness=0.1 \
 //x=11.035 //y=0.795 //x2=11.035 //y2=0.67
r74 (  9 29 ) resistor r=18.139 //w=0.187 //l=0.265 //layer=li //thickness=0.1 \
 //x=11.035 //y=0.795 //x2=11.035 //y2=1.06
r75 (  6 29 ) resistor r=3.57586 //w=0.17 //l=0.103078 //layer=li \
 //thickness=0.1 //x=10.15 //y=1.76 //x2=10.065 //y2=1.8
r76 (  6 29 ) resistor r=27.3797 //w=0.187 //l=0.4 //layer=li //thickness=0.1 \
 //x=10.15 //y=1.76 //x2=10.55 //y2=1.76
r77 (  5 29 ) resistor r=3.57586 //w=0.17 //l=0.103078 //layer=li \
 //thickness=0.1 //x=10.95 //y=1.76 //x2=11.035 //y2=1.8
r78 (  5 29 ) resistor r=27.3797 //w=0.187 //l=0.4 //layer=li //thickness=0.1 \
 //x=10.95 //y=1.76 //x2=10.55 //y2=1.76
r79 (  1 29 ) resistor r=3.57586 //w=0.17 //l=0.125 //layer=li //thickness=0.1 \
 //x=10.065 //y=1.675 //x2=10.065 //y2=1.8
r80 (  1 29 ) resistor r=42.0963 //w=0.187 //l=0.615 //layer=li \
 //thickness=0.1 //x=10.065 //y=1.675 //x2=10.065 //y2=1.06
ends PM_MUX2X1\%noxref_12
