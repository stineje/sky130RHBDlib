// File: MUX2X1.spi.pex
// Created: Tue Apr 29 10:43:02 2025
// Program "Calibre xRC"
// Version "v2023.2_27.15"
// Nominal Temperature: 30C
// Circuit Temperature: 30C
//
simulator lang=spectre
subckt PM_MUX2X1\%GND ( 1 23 35 39 42 47 53 59 65 73 81 94 97 108 111 113 115 \
 116 117 118 )
c165 ( 118 0 ) capacitor c=0.0207872f //x=10.36 //y=1.045
c166 ( 117 0 ) capacitor c=0.0207874f //x=7.03 //y=1.045
c167 ( 116 0 ) capacitor c=0.0207872f //x=3.7 //y=1.045
c168 ( 115 0 ) capacitor c=0.0583166f //x=0.985 //y=0.55
c169 ( 114 0 ) capacitor c=0.00446416f //x=10.55 //y=0.175
c170 ( 113 0 ) capacitor c=0.106669f //x=9.37 //y=0.175
c171 ( 112 0 ) capacitor c=0.00446416f //x=7.22 //y=0.175
c172 ( 111 0 ) capacitor c=0.106669f //x=6.04 //y=0.175
c173 ( 110 0 ) capacitor c=0.00446416f //x=3.82 //y=0.18
c174 ( 108 0 ) capacitor c=0.102357f //x=2.71 //y=0.175
c175 ( 97 0 ) capacitor c=0.211791f //x=1.12 //y=0.175
c176 ( 94 0 ) capacitor c=0.278889f //x=11.96 //y=0.18
c177 ( 81 0 ) capacitor c=0.0392687f //x=10.465 //y=0.175
c178 ( 73 0 ) capacitor c=0.0727797f //x=9.2 //y=0.175
c179 ( 65 0 ) capacitor c=0.0392687f //x=7.135 //y=0.175
c180 ( 59 0 ) capacitor c=0.0729525f //x=5.87 //y=0.175
c181 ( 53 0 ) capacitor c=0.0392687f //x=3.805 //y=0.175
c182 ( 48 0 ) capacitor c=0.0367f //x=2.175 //y=0.175
c183 ( 47 0 ) capacitor c=0.0161513f //x=2.54 //y=0.175
c184 ( 42 0 ) capacitor c=0.00583665f //x=2.09 //y=0.63
c185 ( 39 0 ) capacitor c=0.00531815f //x=2.005 //y=0.715
c186 ( 38 0 ) capacitor c=0.00479856f //x=1.605 //y=0.63
c187 ( 35 0 ) capacitor c=0.00644318f //x=1.52 //y=0.715
c188 ( 30 0 ) capacitor c=0.00592191f //x=1.12 //y=0.63
c189 ( 23 0 ) capacitor c=0.460423f //x=11.96 //y=0.18
r190 (  100 101 ) resistor r=16.9155 //w=0.367 //l=0.485 //layer=li \
 //thickness=0.1 //x=1.605 //y=0.175 //x2=2.09 //y2=0.175
r191 (  99 100 ) resistor r=13.079 //w=0.367 //l=0.375 //layer=li \
 //thickness=0.1 //x=1.23 //y=0.175 //x2=1.605 //y2=0.175
r192 (  97 99 ) resistor r=3.83651 //w=0.367 //l=0.11 //layer=li \
 //thickness=0.1 //x=1.12 //y=0.175 //x2=1.23 //y2=0.175
r193 (  92 94 ) resistor r=25.8093 //w=0.367 //l=0.74 //layer=li \
 //thickness=0.1 //x=11.22 //y=0.175 //x2=11.96 //y2=0.175
r194 (  90 114 ) resistor r=2.87058 //w=0.35 //l=0.085 //layer=li \
 //thickness=0.1 //x=10.635 //y=0.175 //x2=10.55 //y2=0.175
r195 (  90 92 ) resistor r=20.4033 //w=0.367 //l=0.585 //layer=li \
 //thickness=0.1 //x=10.635 //y=0.175 //x2=11.22 //y2=0.175
r196 (  85 114 ) resistor r=4.23183 //w=0.7 //l=0.175 //layer=li \
 //thickness=0.1 //x=10.55 //y=0.35 //x2=10.55 //y2=0.175
r197 (  85 118 ) resistor r=53.7326 //w=0.187 //l=0.785 //layer=li \
 //thickness=0.1 //x=10.55 //y=0.35 //x2=10.55 //y2=1.135
r198 (  82 113 ) resistor r=5.29055 //w=0.35 //l=0.17 //layer=li \
 //thickness=0.1 //x=9.54 //y=0.175 //x2=9.37 //y2=0.175
r199 (  82 84 ) resistor r=19.8801 //w=0.367 //l=0.57 //layer=li \
 //thickness=0.1 //x=9.54 //y=0.175 //x2=10.11 //y2=0.175
r200 (  81 114 ) resistor r=2.87058 //w=0.35 //l=0.085 //layer=li \
 //thickness=0.1 //x=10.465 //y=0.175 //x2=10.55 //y2=0.175
r201 (  81 84 ) resistor r=12.3815 //w=0.367 //l=0.355 //layer=li \
 //thickness=0.1 //x=10.465 //y=0.175 //x2=10.11 //y2=0.175
r202 (  76 78 ) resistor r=38.7139 //w=0.367 //l=1.11 //layer=li \
 //thickness=0.1 //x=7.52 //y=0.175 //x2=8.63 //y2=0.175
r203 (  74 112 ) resistor r=2.87058 //w=0.35 //l=0.085 //layer=li \
 //thickness=0.1 //x=7.305 //y=0.175 //x2=7.22 //y2=0.175
r204 (  74 76 ) resistor r=7.49864 //w=0.367 //l=0.215 //layer=li \
 //thickness=0.1 //x=7.305 //y=0.175 //x2=7.52 //y2=0.175
r205 (  73 113 ) resistor r=5.29055 //w=0.35 //l=0.17 //layer=li \
 //thickness=0.1 //x=9.2 //y=0.175 //x2=9.37 //y2=0.175
r206 (  73 78 ) resistor r=19.8801 //w=0.367 //l=0.57 //layer=li \
 //thickness=0.1 //x=9.2 //y=0.175 //x2=8.63 //y2=0.175
r207 (  69 112 ) resistor r=4.23183 //w=0.7 //l=0.175 //layer=li \
 //thickness=0.1 //x=7.22 //y=0.35 //x2=7.22 //y2=0.175
r208 (  69 117 ) resistor r=53.7326 //w=0.187 //l=0.785 //layer=li \
 //thickness=0.1 //x=7.22 //y=0.35 //x2=7.22 //y2=1.135
r209 (  66 111 ) resistor r=5.29055 //w=0.35 //l=0.17 //layer=li \
 //thickness=0.1 //x=6.21 //y=0.175 //x2=6.04 //y2=0.175
r210 (  66 68 ) resistor r=6.97548 //w=0.367 //l=0.2 //layer=li \
 //thickness=0.1 //x=6.21 //y=0.175 //x2=6.41 //y2=0.175
r211 (  65 112 ) resistor r=2.87058 //w=0.35 //l=0.085 //layer=li \
 //thickness=0.1 //x=7.135 //y=0.175 //x2=7.22 //y2=0.175
r212 (  65 68 ) resistor r=25.2861 //w=0.367 //l=0.725 //layer=li \
 //thickness=0.1 //x=7.135 //y=0.175 //x2=6.41 //y2=0.175
r213 (  60 110 ) resistor r=2.87058 //w=0.35 //l=0.085 //layer=li \
 //thickness=0.1 //x=3.975 //y=0.175 //x2=3.89 //y2=0.175
r214 (  60 62 ) resistor r=33.3079 //w=0.367 //l=0.955 //layer=li \
 //thickness=0.1 //x=3.975 //y=0.175 //x2=4.93 //y2=0.175
r215 (  59 111 ) resistor r=5.29055 //w=0.35 //l=0.17 //layer=li \
 //thickness=0.1 //x=5.87 //y=0.175 //x2=6.04 //y2=0.175
r216 (  59 62 ) resistor r=32.7847 //w=0.367 //l=0.94 //layer=li \
 //thickness=0.1 //x=5.87 //y=0.175 //x2=4.93 //y2=0.175
r217 (  55 110 ) resistor r=4.23183 //w=0.7 //l=0.175 //layer=li \
 //thickness=0.1 //x=3.89 //y=0.35 //x2=3.89 //y2=0.175
r218 (  55 116 ) resistor r=53.7326 //w=0.187 //l=0.785 //layer=li \
 //thickness=0.1 //x=3.89 //y=0.35 //x2=3.89 //y2=1.135
r219 (  54 108 ) resistor r=5.29055 //w=0.35 //l=0.17 //layer=li \
 //thickness=0.1 //x=2.88 //y=0.175 //x2=2.71 //y2=0.175
r220 (  53 110 ) resistor r=2.87058 //w=0.35 //l=0.085 //layer=li \
 //thickness=0.1 //x=3.805 //y=0.175 //x2=3.89 //y2=0.175
r221 (  53 54 ) resistor r=32.2616 //w=0.367 //l=0.925 //layer=li \
 //thickness=0.1 //x=3.805 //y=0.175 //x2=2.88 //y2=0.175
r222 (  48 101 ) resistor r=2.96458 //w=0.367 //l=0.085 //layer=li \
 //thickness=0.1 //x=2.175 //y=0.175 //x2=2.09 //y2=0.175
r223 (  48 50 ) resistor r=5.75477 //w=0.367 //l=0.165 //layer=li \
 //thickness=0.1 //x=2.175 //y=0.175 //x2=2.34 //y2=0.175
r224 (  47 108 ) resistor r=5.29055 //w=0.35 //l=0.17 //layer=li \
 //thickness=0.1 //x=2.54 //y=0.175 //x2=2.71 //y2=0.175
r225 (  47 50 ) resistor r=6.97548 //w=0.367 //l=0.2 //layer=li \
 //thickness=0.1 //x=2.54 //y=0.175 //x2=2.34 //y2=0.175
r226 (  43 115 ) resistor r=5.4201 //w=0.17 //l=0.085 //layer=li \
 //thickness=0.1 //x=2.09 //y=0.8 //x2=2.09 //y2=0.715
r227 (  43 115 ) resistor r=41.4118 //w=0.187 //l=0.605 //layer=li \
 //thickness=0.1 //x=2.09 //y=0.8 //x2=2.09 //y2=1.405
r228 (  42 115 ) resistor r=5.4201 //w=0.17 //l=0.085 //layer=li \
 //thickness=0.1 //x=2.09 //y=0.63 //x2=2.09 //y2=0.715
r229 (  41 101 ) resistor r=5.21862 //w=0.35 //l=0.175 //layer=li \
 //thickness=0.1 //x=2.09 //y=0.35 //x2=2.09 //y2=0.175
r230 (  41 42 ) resistor r=19.1658 //w=0.187 //l=0.28 //layer=li \
 //thickness=0.1 //x=2.09 //y=0.35 //x2=2.09 //y2=0.63
r231 (  40 115 ) resistor r=5.4201 //w=0.17 //l=0.085 //layer=li \
 //thickness=0.1 //x=1.69 //y=0.715 //x2=1.605 //y2=0.715
r232 (  39 115 ) resistor r=1.40859 //w=0.34 //l=0.085 //layer=li \
 //thickness=0.1 //x=2.005 //y=0.715 //x2=2.09 //y2=0.715
r233 (  39 40 ) resistor r=21.5615 //w=0.187 //l=0.315 //layer=li \
 //thickness=0.1 //x=2.005 //y=0.715 //x2=1.69 //y2=0.715
r234 (  38 115 ) resistor r=1.40859 //w=0.34 //l=0.085 //layer=li \
 //thickness=0.1 //x=1.605 //y=0.63 //x2=1.605 //y2=0.715
r235 (  37 100 ) resistor r=5.21862 //w=0.35 //l=0.175 //layer=li \
 //thickness=0.1 //x=1.605 //y=0.35 //x2=1.605 //y2=0.175
r236 (  37 38 ) resistor r=19.1658 //w=0.187 //l=0.28 //layer=li \
 //thickness=0.1 //x=1.605 //y=0.35 //x2=1.605 //y2=0.63
r237 (  36 115 ) resistor r=1.40859 //w=0.34 //l=0.085 //layer=li \
 //thickness=0.1 //x=1.205 //y=0.715 //x2=1.12 //y2=0.715
r238 (  35 115 ) resistor r=5.4201 //w=0.17 //l=0.085 //layer=li \
 //thickness=0.1 //x=1.52 //y=0.715 //x2=1.605 //y2=0.715
r239 (  35 36 ) resistor r=21.5615 //w=0.187 //l=0.315 //layer=li \
 //thickness=0.1 //x=1.52 //y=0.715 //x2=1.205 //y2=0.715
r240 (  31 115 ) resistor r=5.4201 //w=0.17 //l=0.085 //layer=li \
 //thickness=0.1 //x=1.12 //y=0.8 //x2=1.12 //y2=0.715
r241 (  31 115 ) resistor r=41.4118 //w=0.187 //l=0.605 //layer=li \
 //thickness=0.1 //x=1.12 //y=0.8 //x2=1.12 //y2=1.405
r242 (  30 115 ) resistor r=5.4201 //w=0.17 //l=0.085 //layer=li \
 //thickness=0.1 //x=1.12 //y=0.63 //x2=1.12 //y2=0.715
r243 (  29 97 ) resistor r=5.21862 //w=0.35 //l=0.175 //layer=li \
 //thickness=0.1 //x=1.12 //y=0.35 //x2=1.12 //y2=0.175
r244 (  29 30 ) resistor r=19.1658 //w=0.187 //l=0.28 //layer=li \
 //thickness=0.1 //x=1.12 //y=0.35 //x2=1.12 //y2=0.63
r245 (  23 94 ) resistor r=4.65 //w=0.17 //l=0.34 //layer=mcon //count=2 \
 //x=11.96 //y=0.18 //x2=11.96 //y2=0.18
r246 (  21 92 ) resistor r=3.1 //w=0.17 //l=0.51 //layer=mcon //count=3 \
 //x=11.22 //y=0.18 //x2=11.22 //y2=0.18
r247 (  21 23 ) resistor r=0.297428 //w=0.311 //l=0.74 //layer=m1 \
 //thickness=0.36 //x=11.22 //y=0.175 //x2=11.96 //y2=0.175
r248 (  19 84 ) resistor r=3.1 //w=0.17 //l=0.51 //layer=mcon //count=3 \
 //x=10.11 //y=0.18 //x2=10.11 //y2=0.18
r249 (  19 21 ) resistor r=0.446141 //w=0.311 //l=1.11 //layer=m1 \
 //thickness=0.36 //x=10.11 //y=0.175 //x2=11.22 //y2=0.175
r250 (  17 78 ) resistor r=3.1 //w=0.17 //l=0.51 //layer=mcon //count=3 \
 //x=8.63 //y=0.18 //x2=8.63 //y2=0.18
r251 (  17 19 ) resistor r=0.594855 //w=0.311 //l=1.48 //layer=m1 \
 //thickness=0.36 //x=8.63 //y=0.175 //x2=10.11 //y2=0.175
r252 (  15 76 ) resistor r=3.1 //w=0.17 //l=0.51 //layer=mcon //count=3 \
 //x=7.52 //y=0.18 //x2=7.52 //y2=0.18
r253 (  15 17 ) resistor r=0.446141 //w=0.311 //l=1.11 //layer=m1 \
 //thickness=0.36 //x=7.52 //y=0.175 //x2=8.63 //y2=0.175
r254 (  12 68 ) resistor r=3.1 //w=0.17 //l=0.51 //layer=mcon //count=3 \
 //x=6.41 //y=0.18 //x2=6.41 //y2=0.18
r255 (  10 62 ) resistor r=3.1 //w=0.17 //l=0.51 //layer=mcon //count=3 \
 //x=4.93 //y=0.18 //x2=4.93 //y2=0.18
r256 (  10 12 ) resistor r=0.594855 //w=0.311 //l=1.48 //layer=m1 \
 //thickness=0.36 //x=4.93 //y=0.175 //x2=6.41 //y2=0.175
r257 (  8 110 ) resistor r=3.1 //w=0.17 //l=0.51 //layer=mcon //count=3 \
 //x=3.82 //y=0.18 //x2=3.82 //y2=0.18
r258 (  8 10 ) resistor r=0.446141 //w=0.311 //l=1.11 //layer=m1 \
 //thickness=0.36 //x=3.82 //y=0.175 //x2=4.93 //y2=0.175
r259 (  6 50 ) resistor r=3.1 //w=0.17 //l=0.51 //layer=mcon //count=3 \
 //x=2.34 //y=0.18 //x2=2.34 //y2=0.18
r260 (  6 8 ) resistor r=0.594855 //w=0.311 //l=1.48 //layer=m1 \
 //thickness=0.36 //x=2.34 //y=0.175 //x2=3.82 //y2=0.175
r261 (  3 99 ) resistor r=3.1 //w=0.17 //l=0.51 //layer=mcon //count=3 \
 //x=1.23 //y=0.18 //x2=1.23 //y2=0.18
r262 (  3 6 ) resistor r=0.446141 //w=0.311 //l=1.11 //layer=m1 \
 //thickness=0.36 //x=1.23 //y=0.175 //x2=2.34 //y2=0.175
r263 (  1 15 ) resistor r=0.371785 //w=0.311 //l=0.925 //layer=m1 \
 //thickness=0.36 //x=6.595 //y=0.175 //x2=7.52 //y2=0.175
r264 (  1 12 ) resistor r=0.0743569 //w=0.311 //l=0.185 //layer=m1 \
 //thickness=0.36 //x=6.595 //y=0.175 //x2=6.41 //y2=0.175
ends PM_MUX2X1\%GND

subckt PM_MUX2X1\%VDD ( 1 23 35 57 67 91 101 121 129 144 146 150 155 160 161 \
 162 163 164 165 166 167 168 169 170 171 )
c163 ( 171 0 ) capacitor c=0.0383754f //x=11.775 //y=5.2
c164 ( 170 0 ) capacitor c=0.0241902f //x=10.895 //y=5.2
c165 ( 169 0 ) capacitor c=0.0499727f //x=10.025 //y=5.2
c166 ( 168 0 ) capacitor c=0.0382537f //x=8.445 //y=5.2
c167 ( 167 0 ) capacitor c=0.0242221f //x=7.565 //y=5.2
c168 ( 166 0 ) capacitor c=0.0499727f //x=6.695 //y=5.2
c169 ( 165 0 ) capacitor c=0.0382566f //x=5.115 //y=5.2
c170 ( 164 0 ) capacitor c=0.0241905f //x=4.235 //y=5.2
c171 ( 163 0 ) capacitor c=0.0500638f //x=3.365 //y=5.2
c172 ( 162 0 ) capacitor c=0.0436619f //x=1.9 //y=5.2
c173 ( 161 0 ) capacitor c=0.0423207f //x=1.03 //y=5.2
c174 ( 160 0 ) capacitor c=0.262707f //x=11.96 //y=7.58
c175 ( 158 0 ) capacitor c=0.00597439f //x=11.04 //y=7.585
c176 ( 157 0 ) capacitor c=0.00597439f //x=10.11 //y=7.58
c177 ( 155 0 ) capacitor c=0.119574f //x=9.37 //y=7.585
c178 ( 154 0 ) capacitor c=0.00597439f //x=8.63 //y=7.58
c179 ( 152 0 ) capacitor c=0.00597439f //x=7.71 //y=7.585
c180 ( 151 0 ) capacitor c=0.00597439f //x=6.83 //y=7.585
c181 ( 150 0 ) capacitor c=0.119574f //x=6.04 //y=7.585
c182 ( 149 0 ) capacitor c=0.00597439f //x=5.26 //y=7.585
c183 ( 148 0 ) capacitor c=0.00597439f //x=4.38 //y=7.585
c184 ( 147 0 ) capacitor c=0.00597439f //x=3.5 //y=7.585
c185 ( 146 0 ) capacitor c=0.117118f //x=2.71 //y=7.585
c186 ( 145 0 ) capacitor c=0.00597439f //x=2.045 //y=7.585
c187 ( 144 0 ) capacitor c=0.252156f //x=1.23 //y=7.58
c188 ( 129 0 ) capacitor c=0.0287734f //x=11.835 //y=7.585
c189 ( 121 0 ) capacitor c=0.0289072f //x=10.955 //y=7.585
c190 ( 113 0 ) capacitor c=0.0283511f //x=10.075 //y=7.585
c191 ( 109 0 ) capacitor c=0.0277785f //x=9.2 //y=7.585
c192 ( 101 0 ) capacitor c=0.0287734f //x=8.505 //y=7.585
c193 ( 91 0 ) capacitor c=0.0289072f //x=7.625 //y=7.585
c194 ( 81 0 ) capacitor c=0.0283511f //x=6.745 //y=7.585
c195 ( 77 0 ) capacitor c=0.0277785f //x=5.87 //y=7.585
c196 ( 67 0 ) capacitor c=0.0287734f //x=5.175 //y=7.585
c197 ( 57 0 ) capacitor c=0.0289072f //x=4.295 //y=7.585
c198 ( 49 0 ) capacitor c=0.0283511f //x=3.415 //y=7.585
c199 ( 43 0 ) capacitor c=0.0211939f //x=2.54 //y=7.585
c200 ( 35 0 ) capacitor c=0.0289916f //x=1.96 //y=7.585
c201 ( 23 0 ) capacitor c=0.486656f //x=11.96 //y=7.58
r202 (  133 160 ) resistor r=4.23183 //w=0.7 //l=0.175 //layer=li \
 //thickness=0.1 //x=11.92 //y=7.41 //x2=11.92 //y2=7.585
r203 (  133 171 ) resistor r=33.1979 //w=0.187 //l=0.485 //layer=li \
 //thickness=0.1 //x=11.92 //y=7.41 //x2=11.92 //y2=6.925
r204 (  130 158 ) resistor r=2.87058 //w=0.35 //l=0.085 //layer=li \
 //thickness=0.1 //x=11.125 //y=7.585 //x2=11.04 //y2=7.585
r205 (  130 132 ) resistor r=3.31335 //w=0.367 //l=0.095 //layer=li \
 //thickness=0.1 //x=11.125 //y=7.585 //x2=11.22 //y2=7.585
r206 (  129 160 ) resistor r=2.87058 //w=0.35 //l=0.085 //layer=li \
 //thickness=0.1 //x=11.835 //y=7.585 //x2=11.92 //y2=7.585
r207 (  129 132 ) resistor r=21.4496 //w=0.367 //l=0.615 //layer=li \
 //thickness=0.1 //x=11.835 //y=7.585 //x2=11.22 //y2=7.585
r208 (  123 158 ) resistor r=4.23183 //w=0.7 //l=0.175 //layer=li \
 //thickness=0.1 //x=11.04 //y=7.41 //x2=11.04 //y2=7.585
r209 (  123 170 ) resistor r=33.1979 //w=0.187 //l=0.485 //layer=li \
 //thickness=0.1 //x=11.04 //y=7.41 //x2=11.04 //y2=6.925
r210 (  122 157 ) resistor r=2.87058 //w=0.35 //l=0.085 //layer=li \
 //thickness=0.1 //x=10.245 //y=7.585 //x2=10.16 //y2=7.585
r211 (  121 158 ) resistor r=2.87058 //w=0.35 //l=0.085 //layer=li \
 //thickness=0.1 //x=10.955 //y=7.585 //x2=11.04 //y2=7.585
r212 (  121 122 ) resistor r=24.7629 //w=0.367 //l=0.71 //layer=li \
 //thickness=0.1 //x=10.955 //y=7.585 //x2=10.245 //y2=7.585
r213 (  115 157 ) resistor r=4.23183 //w=0.7 //l=0.175 //layer=li \
 //thickness=0.1 //x=10.16 //y=7.41 //x2=10.16 //y2=7.585
r214 (  115 169 ) resistor r=56.4706 //w=0.187 //l=0.825 //layer=li \
 //thickness=0.1 //x=10.16 //y=7.41 //x2=10.16 //y2=6.585
r215 (  114 155 ) resistor r=5.29055 //w=0.35 //l=0.17 //layer=li \
 //thickness=0.1 //x=9.54 //y=7.585 //x2=9.37 //y2=7.585
r216 (  113 157 ) resistor r=2.87058 //w=0.35 //l=0.085 //layer=li \
 //thickness=0.1 //x=10.075 //y=7.585 //x2=10.16 //y2=7.585
r217 (  113 114 ) resistor r=18.6594 //w=0.367 //l=0.535 //layer=li \
 //thickness=0.1 //x=10.075 //y=7.585 //x2=9.54 //y2=7.585
r218 (  110 154 ) resistor r=2.87058 //w=0.35 //l=0.085 //layer=li \
 //thickness=0.1 //x=8.675 //y=7.585 //x2=8.59 //y2=7.585
r219 (  109 155 ) resistor r=5.29055 //w=0.35 //l=0.17 //layer=li \
 //thickness=0.1 //x=9.2 //y=7.585 //x2=9.37 //y2=7.585
r220 (  109 110 ) resistor r=18.3106 //w=0.367 //l=0.525 //layer=li \
 //thickness=0.1 //x=9.2 //y=7.585 //x2=8.675 //y2=7.585
r221 (  103 154 ) resistor r=4.23183 //w=0.7 //l=0.175 //layer=li \
 //thickness=0.1 //x=8.59 //y=7.41 //x2=8.59 //y2=7.585
r222 (  103 168 ) resistor r=33.1979 //w=0.187 //l=0.485 //layer=li \
 //thickness=0.1 //x=8.59 //y=7.41 //x2=8.59 //y2=6.925
r223 (  102 152 ) resistor r=2.87058 //w=0.35 //l=0.085 //layer=li \
 //thickness=0.1 //x=7.795 //y=7.585 //x2=7.71 //y2=7.585
r224 (  101 154 ) resistor r=2.87058 //w=0.35 //l=0.085 //layer=li \
 //thickness=0.1 //x=8.505 //y=7.585 //x2=8.59 //y2=7.585
r225 (  101 102 ) resistor r=24.7629 //w=0.367 //l=0.71 //layer=li \
 //thickness=0.1 //x=8.505 //y=7.585 //x2=7.795 //y2=7.585
r226 (  95 152 ) resistor r=4.23183 //w=0.7 //l=0.175 //layer=li \
 //thickness=0.1 //x=7.71 //y=7.41 //x2=7.71 //y2=7.585
r227 (  95 167 ) resistor r=33.1979 //w=0.187 //l=0.485 //layer=li \
 //thickness=0.1 //x=7.71 //y=7.41 //x2=7.71 //y2=6.925
r228 (  92 151 ) resistor r=2.87058 //w=0.35 //l=0.085 //layer=li \
 //thickness=0.1 //x=6.915 //y=7.585 //x2=6.83 //y2=7.585
r229 (  92 94 ) resistor r=21.1008 //w=0.367 //l=0.605 //layer=li \
 //thickness=0.1 //x=6.915 //y=7.585 //x2=7.52 //y2=7.585
r230 (  91 152 ) resistor r=2.87058 //w=0.35 //l=0.085 //layer=li \
 //thickness=0.1 //x=7.625 //y=7.585 //x2=7.71 //y2=7.585
r231 (  91 94 ) resistor r=3.66213 //w=0.367 //l=0.105 //layer=li \
 //thickness=0.1 //x=7.625 //y=7.585 //x2=7.52 //y2=7.585
r232 (  85 151 ) resistor r=4.23183 //w=0.7 //l=0.175 //layer=li \
 //thickness=0.1 //x=6.83 //y=7.41 //x2=6.83 //y2=7.585
r233 (  85 166 ) resistor r=56.4706 //w=0.187 //l=0.825 //layer=li \
 //thickness=0.1 //x=6.83 //y=7.41 //x2=6.83 //y2=6.585
r234 (  82 150 ) resistor r=5.29055 //w=0.35 //l=0.17 //layer=li \
 //thickness=0.1 //x=6.21 //y=7.585 //x2=6.04 //y2=7.585
r235 (  82 84 ) resistor r=6.97548 //w=0.367 //l=0.2 //layer=li \
 //thickness=0.1 //x=6.21 //y=7.585 //x2=6.41 //y2=7.585
r236 (  81 151 ) resistor r=2.87058 //w=0.35 //l=0.085 //layer=li \
 //thickness=0.1 //x=6.745 //y=7.585 //x2=6.83 //y2=7.585
r237 (  81 84 ) resistor r=11.6839 //w=0.367 //l=0.335 //layer=li \
 //thickness=0.1 //x=6.745 //y=7.585 //x2=6.41 //y2=7.585
r238 (  78 149 ) resistor r=2.87058 //w=0.35 //l=0.085 //layer=li \
 //thickness=0.1 //x=5.345 //y=7.585 //x2=5.26 //y2=7.585
r239 (  77 150 ) resistor r=5.29055 //w=0.35 //l=0.17 //layer=li \
 //thickness=0.1 //x=5.87 //y=7.585 //x2=6.04 //y2=7.585
r240 (  77 78 ) resistor r=18.3106 //w=0.367 //l=0.525 //layer=li \
 //thickness=0.1 //x=5.87 //y=7.585 //x2=5.345 //y2=7.585
r241 (  71 149 ) resistor r=4.23183 //w=0.7 //l=0.175 //layer=li \
 //thickness=0.1 //x=5.26 //y=7.41 //x2=5.26 //y2=7.585
r242 (  71 165 ) resistor r=33.1979 //w=0.187 //l=0.485 //layer=li \
 //thickness=0.1 //x=5.26 //y=7.41 //x2=5.26 //y2=6.925
r243 (  68 148 ) resistor r=2.87058 //w=0.35 //l=0.085 //layer=li \
 //thickness=0.1 //x=4.465 //y=7.585 //x2=4.38 //y2=7.585
r244 (  68 70 ) resistor r=16.218 //w=0.367 //l=0.465 //layer=li \
 //thickness=0.1 //x=4.465 //y=7.585 //x2=4.93 //y2=7.585
r245 (  67 149 ) resistor r=2.87058 //w=0.35 //l=0.085 //layer=li \
 //thickness=0.1 //x=5.175 //y=7.585 //x2=5.26 //y2=7.585
r246 (  67 70 ) resistor r=8.54496 //w=0.367 //l=0.245 //layer=li \
 //thickness=0.1 //x=5.175 //y=7.585 //x2=4.93 //y2=7.585
r247 (  61 148 ) resistor r=4.23183 //w=0.7 //l=0.175 //layer=li \
 //thickness=0.1 //x=4.38 //y=7.41 //x2=4.38 //y2=7.585
r248 (  61 164 ) resistor r=33.1979 //w=0.187 //l=0.485 //layer=li \
 //thickness=0.1 //x=4.38 //y=7.41 //x2=4.38 //y2=6.925
r249 (  58 147 ) resistor r=2.87058 //w=0.35 //l=0.085 //layer=li \
 //thickness=0.1 //x=3.585 //y=7.585 //x2=3.5 //y2=7.585
r250 (  58 60 ) resistor r=8.19619 //w=0.367 //l=0.235 //layer=li \
 //thickness=0.1 //x=3.585 //y=7.585 //x2=3.82 //y2=7.585
r251 (  57 148 ) resistor r=2.87058 //w=0.35 //l=0.085 //layer=li \
 //thickness=0.1 //x=4.295 //y=7.585 //x2=4.38 //y2=7.585
r252 (  57 60 ) resistor r=16.5668 //w=0.367 //l=0.475 //layer=li \
 //thickness=0.1 //x=4.295 //y=7.585 //x2=3.82 //y2=7.585
r253 (  51 147 ) resistor r=4.23183 //w=0.7 //l=0.175 //layer=li \
 //thickness=0.1 //x=3.5 //y=7.41 //x2=3.5 //y2=7.585
r254 (  51 163 ) resistor r=56.4706 //w=0.187 //l=0.825 //layer=li \
 //thickness=0.1 //x=3.5 //y=7.41 //x2=3.5 //y2=6.585
r255 (  50 146 ) resistor r=5.29055 //w=0.35 //l=0.17 //layer=li \
 //thickness=0.1 //x=2.88 //y=7.585 //x2=2.71 //y2=7.585
r256 (  49 147 ) resistor r=2.87058 //w=0.35 //l=0.085 //layer=li \
 //thickness=0.1 //x=3.415 //y=7.585 //x2=3.5 //y2=7.585
r257 (  49 50 ) resistor r=18.6594 //w=0.367 //l=0.535 //layer=li \
 //thickness=0.1 //x=3.415 //y=7.585 //x2=2.88 //y2=7.585
r258 (  44 145 ) resistor r=2.87058 //w=0.35 //l=0.085 //layer=li \
 //thickness=0.1 //x=2.13 //y=7.585 //x2=2.045 //y2=7.585
r259 (  44 46 ) resistor r=7.32425 //w=0.367 //l=0.21 //layer=li \
 //thickness=0.1 //x=2.13 //y=7.585 //x2=2.34 //y2=7.585
r260 (  43 146 ) resistor r=5.29055 //w=0.35 //l=0.17 //layer=li \
 //thickness=0.1 //x=2.54 //y=7.585 //x2=2.71 //y2=7.585
r261 (  43 46 ) resistor r=6.97548 //w=0.367 //l=0.2 //layer=li \
 //thickness=0.1 //x=2.54 //y=7.585 //x2=2.34 //y2=7.585
r262 (  37 145 ) resistor r=4.23183 //w=0.7 //l=0.175 //layer=li \
 //thickness=0.1 //x=2.045 //y=7.41 //x2=2.045 //y2=7.585
r263 (  37 162 ) resistor r=56.4706 //w=0.187 //l=0.825 //layer=li \
 //thickness=0.1 //x=2.045 //y=7.41 //x2=2.045 //y2=6.585
r264 (  36 144 ) resistor r=2.87058 //w=0.35 //l=0.085 //layer=li \
 //thickness=0.1 //x=1.25 //y=7.585 //x2=1.165 //y2=7.585
r265 (  35 145 ) resistor r=2.87058 //w=0.35 //l=0.085 //layer=li \
 //thickness=0.1 //x=1.96 //y=7.585 //x2=2.045 //y2=7.585
r266 (  35 36 ) resistor r=24.7629 //w=0.367 //l=0.71 //layer=li \
 //thickness=0.1 //x=1.96 //y=7.585 //x2=1.25 //y2=7.585
r267 (  29 144 ) resistor r=4.23183 //w=0.7 //l=0.175 //layer=li \
 //thickness=0.1 //x=1.165 //y=7.41 //x2=1.165 //y2=7.585
r268 (  29 161 ) resistor r=56.4706 //w=0.187 //l=0.825 //layer=li \
 //thickness=0.1 //x=1.165 //y=7.41 //x2=1.165 //y2=6.585
r269 (  23 160 ) resistor r=4.65 //w=0.17 //l=0.34 //layer=mcon //count=2 \
 //x=11.96 //y=7.58 //x2=11.96 //y2=7.58
r270 (  21 132 ) resistor r=3.1 //w=0.17 //l=0.51 //layer=mcon //count=3 \
 //x=11.22 //y=7.58 //x2=11.22 //y2=7.58
r271 (  21 23 ) resistor r=0.297428 //w=0.311 //l=0.74 //layer=m1 \
 //thickness=0.36 //x=11.22 //y=7.585 //x2=11.96 //y2=7.585
r272 (  19 157 ) resistor r=3.1 //w=0.17 //l=0.51 //layer=mcon //count=3 \
 //x=10.11 //y=7.58 //x2=10.11 //y2=7.58
r273 (  19 21 ) resistor r=0.446141 //w=0.311 //l=1.11 //layer=m1 \
 //thickness=0.36 //x=10.11 //y=7.585 //x2=11.22 //y2=7.585
r274 (  17 154 ) resistor r=3.1 //w=0.17 //l=0.51 //layer=mcon //count=3 \
 //x=8.63 //y=7.58 //x2=8.63 //y2=7.58
r275 (  17 19 ) resistor r=0.594855 //w=0.311 //l=1.48 //layer=m1 \
 //thickness=0.36 //x=8.63 //y=7.585 //x2=10.11 //y2=7.585
r276 (  15 94 ) resistor r=3.1 //w=0.17 //l=0.51 //layer=mcon //count=3 \
 //x=7.52 //y=7.58 //x2=7.52 //y2=7.58
r277 (  15 17 ) resistor r=0.446141 //w=0.311 //l=1.11 //layer=m1 \
 //thickness=0.36 //x=7.52 //y=7.585 //x2=8.63 //y2=7.585
r278 (  12 84 ) resistor r=3.1 //w=0.17 //l=0.51 //layer=mcon //count=3 \
 //x=6.41 //y=7.58 //x2=6.41 //y2=7.58
r279 (  10 70 ) resistor r=3.1 //w=0.17 //l=0.51 //layer=mcon //count=3 \
 //x=4.93 //y=7.58 //x2=4.93 //y2=7.58
r280 (  10 12 ) resistor r=0.594855 //w=0.311 //l=1.48 //layer=m1 \
 //thickness=0.36 //x=4.93 //y=7.585 //x2=6.41 //y2=7.585
r281 (  8 60 ) resistor r=3.1 //w=0.17 //l=0.51 //layer=mcon //count=3 \
 //x=3.82 //y=7.58 //x2=3.82 //y2=7.58
r282 (  8 10 ) resistor r=0.446141 //w=0.311 //l=1.11 //layer=m1 \
 //thickness=0.36 //x=3.82 //y=7.585 //x2=4.93 //y2=7.585
r283 (  6 46 ) resistor r=3.1 //w=0.17 //l=0.51 //layer=mcon //count=3 \
 //x=2.34 //y=7.58 //x2=2.34 //y2=7.58
r284 (  6 8 ) resistor r=0.594855 //w=0.311 //l=1.48 //layer=m1 \
 //thickness=0.36 //x=2.34 //y=7.585 //x2=3.82 //y2=7.585
r285 (  3 144 ) resistor r=3.1 //w=0.17 //l=0.51 //layer=mcon //count=3 \
 //x=1.23 //y=7.58 //x2=1.23 //y2=7.58
r286 (  3 6 ) resistor r=0.446141 //w=0.311 //l=1.11 //layer=m1 \
 //thickness=0.36 //x=1.23 //y=7.585 //x2=2.34 //y2=7.585
r287 (  1 15 ) resistor r=0.371785 //w=0.311 //l=0.925 //layer=m1 \
 //thickness=0.36 //x=6.595 //y=7.585 //x2=7.52 //y2=7.585
r288 (  1 12 ) resistor r=0.0743569 //w=0.311 //l=0.185 //layer=m1 \
 //thickness=0.36 //x=6.595 //y=7.585 //x2=6.41 //y2=7.585
ends PM_MUX2X1\%VDD

subckt PM_MUX2X1\%S ( 1 2 7 8 9 10 11 12 13 14 15 16 17 18 19 21 35 47 48 49 \
 50 51 52 53 54 55 56 60 61 62 64 70 71 72 73 74 75 79 81 84 85 90 104 )
c127 ( 104 0 ) capacitor c=0.0667949f //x=3.82 //y=4.88
c128 ( 90 0 ) capacitor c=0.051138f //x=1.23 //y=2.265
c129 ( 85 0 ) capacitor c=0.0318948f //x=4.155 //y=1.39
c130 ( 84 0 ) capacitor c=0.0187384f //x=4.155 //y=1.045
c131 ( 81 0 ) capacitor c=0.0141798f //x=4 //y=1.545
c132 ( 79 0 ) capacitor c=0.0149844f //x=4 //y=0.89
c133 ( 75 0 ) capacitor c=0.0819722f //x=3.625 //y=2.095
c134 ( 74 0 ) capacitor c=0.0229722f //x=3.625 //y=1.7
c135 ( 73 0 ) capacitor c=0.0234352f //x=3.625 //y=1.39
c136 ( 72 0 ) capacitor c=0.0199343f //x=3.625 //y=1.045
c137 ( 71 0 ) capacitor c=0.0435629f //x=1.87 //y=1.435
c138 ( 70 0 ) capacitor c=0.0200386f //x=1.87 //y=1.09
c139 ( 64 0 ) capacitor c=0.0152946f //x=1.715 //y=1.59
c140 ( 62 0 ) capacitor c=0.0157804f //x=1.715 //y=0.935
c141 ( 61 0 ) capacitor c=0.0524167f //x=1.46 //y=4.97
c142 ( 60 0 ) capacitor c=0.0322983f //x=1.75 //y=4.97
c143 ( 56 0 ) capacitor c=0.0290017f //x=1.34 //y=2.1
c144 ( 55 0 ) capacitor c=0.0250027f //x=1.34 //y=1.745
c145 ( 54 0 ) capacitor c=0.0234316f //x=1.34 //y=1.435
c146 ( 53 0 ) capacitor c=0.0200596f //x=1.34 //y=1.09
c147 ( 52 0 ) capacitor c=0.110275f //x=4.16 //y=6.2
c148 ( 51 0 ) capacitor c=0.154305f //x=3.72 //y=6.2
c149 ( 50 0 ) capacitor c=0.154218f //x=1.825 //y=6.2
c150 ( 49 0 ) capacitor c=0.154243f //x=1.385 //y=6.2
c151 ( 35 0 ) capacitor c=0.0971096f //x=3.82 //y=2.26
c152 ( 21 0 ) capacitor c=0.110891f //x=1.23 //y=2.265
c153 ( 2 0 ) capacitor c=0.0133976f //x=1.345 //y=3.14
c154 ( 1 0 ) capacitor c=0.0813108f //x=3.705 //y=3.14
r155 (  102 104 ) resistor r=20.6867 //w=0.233 //l=0.1 //layer=ply \
 //thickness=0.18 //x=3.72 //y=4.88 //x2=3.82 //y2=4.88
r156 (  90 91 ) resistor r=17.5563 //w=0.302 //l=0.11 //layer=ply \
 //thickness=0.18 //x=1.23 //y=2.265 //x2=1.34 //y2=2.265
r157 (  86 104 ) resistor r=70.3348 //w=0.233 //l=0.414367 //layer=ply \
 //thickness=0.18 //x=4.16 //y=5.045 //x2=3.82 //y2=4.88
r158 (  85 106 ) resistor r=45.1352 //w=0.168 //l=0.173853 //layer=ply \
 //thickness=0.18 //x=4.155 //y=1.39 //x2=4.115 //y2=1.545
r159 (  84 105 ) resistor r=45.1352 //w=0.168 //l=0.173853 //layer=ply \
 //thickness=0.18 //x=4.155 //y=1.045 //x2=4.115 //y2=0.89
r160 (  84 85 ) resistor r=176.904 //w=0.094 //l=0.345 //layer=ply \
 //thickness=0.18 //x=4.155 //y=1.045 //x2=4.155 //y2=1.39
r161 (  82 101 ) resistor r=10.701 //w=0.21 //l=0.115 //layer=ply \
 //thickness=0.18 //x=3.78 //y=1.545 //x2=3.665 //y2=1.545
r162 (  81 106 ) resistor r=5.52526 //w=0.168 //l=0.115 //layer=ply \
 //thickness=0.18 //x=4 //y=1.545 //x2=4.115 //y2=1.545
r163 (  80 100 ) resistor r=5.52526 //w=0.168 //l=0.115 //layer=ply \
 //thickness=0.18 //x=3.78 //y=0.89 //x2=3.665 //y2=0.89
r164 (  79 105 ) resistor r=5.52526 //w=0.168 //l=0.115 //layer=ply \
 //thickness=0.18 //x=4 //y=0.89 //x2=4.115 //y2=0.89
r165 (  79 80 ) resistor r=112.809 //w=0.094 //l=0.22 //layer=ply \
 //thickness=0.18 //x=4 //y=0.89 //x2=3.78 //y2=0.89
r166 (  76 102 ) resistor r=13.0941 //w=0.233 //l=0.165 //layer=ply \
 //thickness=0.18 //x=3.72 //y=5.045 //x2=3.72 //y2=4.88
r167 (  75 99 ) resistor r=34.8111 //w=0.27 //l=0.264953 //layer=ply \
 //thickness=0.18 //x=3.625 //y=2.095 //x2=3.82 //y2=2.26
r168 (  74 101 ) resistor r=39.5823 //w=0.21 //l=0.173853 //layer=ply \
 //thickness=0.18 //x=3.625 //y=1.7 //x2=3.665 //y2=1.545
r169 (  74 75 ) resistor r=202.543 //w=0.094 //l=0.395 //layer=ply \
 //thickness=0.18 //x=3.625 //y=1.7 //x2=3.625 //y2=2.095
r170 (  73 101 ) resistor r=39.5823 //w=0.21 //l=0.173853 //layer=ply \
 //thickness=0.18 //x=3.625 //y=1.39 //x2=3.665 //y2=1.545
r171 (  72 100 ) resistor r=45.1352 //w=0.168 //l=0.173853 //layer=ply \
 //thickness=0.18 //x=3.625 //y=1.045 //x2=3.665 //y2=0.89
r172 (  72 73 ) resistor r=176.904 //w=0.094 //l=0.345 //layer=ply \
 //thickness=0.18 //x=3.625 //y=1.045 //x2=3.625 //y2=1.39
r173 (  71 97 ) resistor r=45.1352 //w=0.168 //l=0.173853 //layer=ply \
 //thickness=0.18 //x=1.87 //y=1.435 //x2=1.83 //y2=1.59
r174 (  70 96 ) resistor r=45.1352 //w=0.168 //l=0.173853 //layer=ply \
 //thickness=0.18 //x=1.87 //y=1.09 //x2=1.83 //y2=0.935
r175 (  70 71 ) resistor r=176.904 //w=0.094 //l=0.345 //layer=ply \
 //thickness=0.18 //x=1.87 //y=1.09 //x2=1.87 //y2=1.435
r176 (  65 95 ) resistor r=10.701 //w=0.21 //l=0.115 //layer=ply \
 //thickness=0.18 //x=1.495 //y=1.59 //x2=1.38 //y2=1.59
r177 (  64 97 ) resistor r=5.52526 //w=0.168 //l=0.115 //layer=ply \
 //thickness=0.18 //x=1.715 //y=1.59 //x2=1.83 //y2=1.59
r178 (  63 94 ) resistor r=5.52526 //w=0.168 //l=0.115 //layer=ply \
 //thickness=0.18 //x=1.495 //y=0.935 //x2=1.38 //y2=0.935
r179 (  62 96 ) resistor r=5.52526 //w=0.168 //l=0.115 //layer=ply \
 //thickness=0.18 //x=1.715 //y=0.935 //x2=1.83 //y2=0.935
r180 (  62 63 ) resistor r=112.809 //w=0.094 //l=0.22 //layer=ply \
 //thickness=0.18 //x=1.715 //y=0.935 //x2=1.495 //y2=0.935
r181 (  60 67 ) resistor r=26.9307 //w=0.15 //l=0.106066 //layer=ply \
 //thickness=0.18 //x=1.75 //y=4.97 //x2=1.825 //y2=5.045
r182 (  60 61 ) resistor r=148.702 //w=0.094 //l=0.29 //layer=ply \
 //thickness=0.18 //x=1.75 //y=4.97 //x2=1.46 //y2=4.97
r183 (  57 61 ) resistor r=23.403 //w=0.284 //l=0.106066 //layer=ply \
 //thickness=0.18 //x=1.385 //y=5.045 //x2=1.46 //y2=4.97
r184 (  57 93 ) resistor r=26.3063 //w=0.284 //l=0.229783 //layer=ply \
 //thickness=0.18 //x=1.385 //y=5.045 //x2=1.23 //y2=4.88
r185 (  56 91 ) resistor r=19.1248 //w=0.302 //l=0.165 //layer=ply \
 //thickness=0.18 //x=1.34 //y=2.1 //x2=1.34 //y2=2.265
r186 (  55 95 ) resistor r=39.5823 //w=0.21 //l=0.173853 //layer=ply \
 //thickness=0.18 //x=1.34 //y=1.745 //x2=1.38 //y2=1.59
r187 (  55 56 ) resistor r=182.032 //w=0.094 //l=0.355 //layer=ply \
 //thickness=0.18 //x=1.34 //y=1.745 //x2=1.34 //y2=2.1
r188 (  54 95 ) resistor r=39.5823 //w=0.21 //l=0.173853 //layer=ply \
 //thickness=0.18 //x=1.34 //y=1.435 //x2=1.38 //y2=1.59
r189 (  53 94 ) resistor r=45.1352 //w=0.168 //l=0.173853 //layer=ply \
 //thickness=0.18 //x=1.34 //y=1.09 //x2=1.38 //y2=0.935
r190 (  53 54 ) resistor r=176.904 //w=0.094 //l=0.345 //layer=ply \
 //thickness=0.18 //x=1.34 //y=1.09 //x2=1.34 //y2=1.435
r191 (  52 86 ) resistor r=592.245 //w=0.094 //l=1.155 //layer=ply \
 //thickness=0.18 //x=4.16 //y=6.2 //x2=4.16 //y2=5.045
r192 (  51 76 ) resistor r=592.245 //w=0.094 //l=1.155 //layer=ply \
 //thickness=0.18 //x=3.72 //y=6.2 //x2=3.72 //y2=5.045
r193 (  50 67 ) resistor r=592.245 //w=0.094 //l=1.155 //layer=ply \
 //thickness=0.18 //x=1.825 //y=6.2 //x2=1.825 //y2=5.045
r194 (  49 57 ) resistor r=592.245 //w=0.094 //l=1.155 //layer=ply \
 //thickness=0.18 //x=1.385 //y=6.2 //x2=1.385 //y2=5.045
r195 (  48 81 ) resistor r=56.4043 //w=0.094 //l=0.11 //layer=ply \
 //thickness=0.18 //x=3.89 //y=1.545 //x2=4 //y2=1.545
r196 (  48 82 ) resistor r=56.4043 //w=0.094 //l=0.11 //layer=ply \
 //thickness=0.18 //x=3.89 //y=1.545 //x2=3.78 //y2=1.545
r197 (  47 64 ) resistor r=56.4043 //w=0.094 //l=0.11 //layer=ply \
 //thickness=0.18 //x=1.605 //y=1.59 //x2=1.715 //y2=1.59
r198 (  47 65 ) resistor r=56.4043 //w=0.094 //l=0.11 //layer=ply \
 //thickness=0.18 //x=1.605 //y=1.59 //x2=1.495 //y2=1.59
r199 (  45 104 ) resistor r=152 //w=0.17 //l=0.17 //layer=licon //count=1 \
 //x=3.82 //y=4.88 //x2=3.82 //y2=4.88
r200 (  35 99 ) resistor r=152 //w=0.17 //l=0.17 //layer=licon //count=1 \
 //x=3.82 //y=2.26 //x2=3.82 //y2=2.26
r201 (  32 93 ) resistor r=152 //w=0.17 //l=0.17 //layer=licon //count=1 \
 //x=1.23 //y=4.88 //x2=1.23 //y2=4.88
r202 (  21 90 ) resistor r=152 //w=0.17 //l=0.17 //layer=licon //count=1 \
 //x=1.23 //y=2.265 //x2=1.23 //y2=2.265
r203 (  19 45 ) resistor r=17.7968 //w=0.187 //l=0.26 //layer=li \
 //thickness=0.1 //x=3.82 //y=4.62 //x2=3.82 //y2=4.88
r204 (  18 19 ) resistor r=25.3262 //w=0.187 //l=0.37 //layer=li \
 //thickness=0.1 //x=3.82 //y=4.25 //x2=3.82 //y2=4.62
r205 (  17 18 ) resistor r=25.3262 //w=0.187 //l=0.37 //layer=li \
 //thickness=0.1 //x=3.82 //y=3.88 //x2=3.82 //y2=4.25
r206 (  16 17 ) resistor r=50.6524 //w=0.187 //l=0.74 //layer=li \
 //thickness=0.1 //x=3.82 //y=3.14 //x2=3.82 //y2=3.88
r207 (  15 16 ) resistor r=25.3262 //w=0.187 //l=0.37 //layer=li \
 //thickness=0.1 //x=3.82 //y=2.77 //x2=3.82 //y2=3.14
r208 (  14 15 ) resistor r=25.3262 //w=0.187 //l=0.37 //layer=li \
 //thickness=0.1 //x=3.82 //y=2.4 //x2=3.82 //y2=2.77
r209 (  14 35 ) resistor r=9.58289 //w=0.187 //l=0.14 //layer=li \
 //thickness=0.1 //x=3.82 //y=2.4 //x2=3.82 //y2=2.26
r210 (  13 32 ) resistor r=17.7968 //w=0.187 //l=0.26 //layer=li \
 //thickness=0.1 //x=1.23 //y=4.62 //x2=1.23 //y2=4.88
r211 (  12 13 ) resistor r=25.3262 //w=0.187 //l=0.37 //layer=li \
 //thickness=0.1 //x=1.23 //y=4.25 //x2=1.23 //y2=4.62
r212 (  11 12 ) resistor r=25.3262 //w=0.187 //l=0.37 //layer=li \
 //thickness=0.1 //x=1.23 //y=3.88 //x2=1.23 //y2=4.25
r213 (  10 11 ) resistor r=25.3262 //w=0.187 //l=0.37 //layer=li \
 //thickness=0.1 //x=1.23 //y=3.51 //x2=1.23 //y2=3.88
r214 (  9 10 ) resistor r=25.3262 //w=0.187 //l=0.37 //layer=li \
 //thickness=0.1 //x=1.23 //y=3.14 //x2=1.23 //y2=3.51
r215 (  8 9 ) resistor r=25.3262 //w=0.187 //l=0.37 //layer=li //thickness=0.1 \
 //x=1.23 //y=2.77 //x2=1.23 //y2=3.14
r216 (  7 8 ) resistor r=25.3262 //w=0.187 //l=0.37 //layer=li //thickness=0.1 \
 //x=1.23 //y=2.4 //x2=1.23 //y2=2.77
r217 (  7 21 ) resistor r=9.24064 //w=0.187 //l=0.135 //layer=li \
 //thickness=0.1 //x=1.23 //y=2.4 //x2=1.23 //y2=2.265
r218 (  6 16 ) resistor r=9.3 //w=0.17 //l=0.17 //layer=mcon //count=1 \
 //x=3.82 //y=3.14 //x2=3.82 //y2=3.14
r219 (  4 9 ) resistor r=9.3 //w=0.17 //l=0.17 //layer=mcon //count=1 //x=1.23 \
 //y=3.14 //x2=1.23 //y2=3.14
r220 (  2 4 ) resistor r=0.0717383 //w=0.224 //l=0.115 //layer=m1 \
 //thickness=0.36 //x=1.345 //y=3.14 //x2=1.23 //y2=3.14
r221 (  1 6 ) resistor r=0.0717383 //w=0.224 //l=0.115 //layer=m1 \
 //thickness=0.36 //x=3.705 //y=3.14 //x2=3.82 //y2=3.14
r222 (  1 2 ) resistor r=2.25191 //w=0.131 //l=2.36 //layer=m1 \
 //thickness=0.36 //x=3.705 //y=3.14 //x2=1.345 //y2=3.14
ends PM_MUX2X1\%S

subckt PM_MUX2X1\%noxref_4 ( 1 2 17 18 19 20 24 26 33 34 35 36 37 38 39 43 45 \
 48 49 59 62 64 )
c139 ( 64 0 ) capacitor c=0.0288745f //x=1.46 //y=5.2
c140 ( 62 0 ) capacitor c=0.0173218f //x=1.415 //y=1.09
c141 ( 59 0 ) capacitor c=0.0667949f //x=7.15 //y=4.88
c142 ( 49 0 ) capacitor c=0.0318948f //x=7.485 //y=1.39
c143 ( 48 0 ) capacitor c=0.0187384f //x=7.485 //y=1.045
c144 ( 45 0 ) capacitor c=0.0141798f //x=7.33 //y=1.545
c145 ( 43 0 ) capacitor c=0.0149844f //x=7.33 //y=0.89
c146 ( 39 0 ) capacitor c=0.0819799f //x=6.955 //y=2.095
c147 ( 38 0 ) capacitor c=0.0229722f //x=6.955 //y=1.7
c148 ( 37 0 ) capacitor c=0.0234352f //x=6.955 //y=1.39
c149 ( 36 0 ) capacitor c=0.0199343f //x=6.955 //y=1.045
c150 ( 35 0 ) capacitor c=0.110275f //x=7.49 //y=6.2
c151 ( 34 0 ) capacitor c=0.154305f //x=7.05 //y=6.2
c152 ( 26 0 ) capacitor c=0.0969029f //x=7.15 //y=2.26
c153 ( 24 0 ) capacitor c=0.0857489f //x=1.97 //y=3.51
c154 ( 20 0 ) capacitor c=0.00560375f //x=1.69 //y=4.76
c155 ( 19 0 ) capacitor c=0.0134399f //x=1.885 //y=4.76
c156 ( 18 0 ) capacitor c=0.00549299f //x=1.685 //y=2.26
c157 ( 17 0 ) capacitor c=0.013178f //x=1.885 //y=2.26
c158 ( 2 0 ) capacitor c=0.0158256f //x=2.085 //y=3.51
c159 ( 1 0 ) capacitor c=0.183474f //x=7.035 //y=3.51
r160 (  57 59 ) resistor r=20.6867 //w=0.233 //l=0.1 //layer=ply \
 //thickness=0.18 //x=7.05 //y=4.88 //x2=7.15 //y2=4.88
r161 (  50 59 ) resistor r=70.3348 //w=0.233 //l=0.414367 //layer=ply \
 //thickness=0.18 //x=7.49 //y=5.045 //x2=7.15 //y2=4.88
r162 (  49 61 ) resistor r=45.1352 //w=0.168 //l=0.173853 //layer=ply \
 //thickness=0.18 //x=7.485 //y=1.39 //x2=7.445 //y2=1.545
r163 (  48 60 ) resistor r=45.1352 //w=0.168 //l=0.173853 //layer=ply \
 //thickness=0.18 //x=7.485 //y=1.045 //x2=7.445 //y2=0.89
r164 (  48 49 ) resistor r=176.904 //w=0.094 //l=0.345 //layer=ply \
 //thickness=0.18 //x=7.485 //y=1.045 //x2=7.485 //y2=1.39
r165 (  46 56 ) resistor r=10.701 //w=0.21 //l=0.115 //layer=ply \
 //thickness=0.18 //x=7.11 //y=1.545 //x2=6.995 //y2=1.545
r166 (  45 61 ) resistor r=5.52526 //w=0.168 //l=0.115 //layer=ply \
 //thickness=0.18 //x=7.33 //y=1.545 //x2=7.445 //y2=1.545
r167 (  44 55 ) resistor r=5.52526 //w=0.168 //l=0.115 //layer=ply \
 //thickness=0.18 //x=7.11 //y=0.89 //x2=6.995 //y2=0.89
r168 (  43 60 ) resistor r=5.52526 //w=0.168 //l=0.115 //layer=ply \
 //thickness=0.18 //x=7.33 //y=0.89 //x2=7.445 //y2=0.89
r169 (  43 44 ) resistor r=112.809 //w=0.094 //l=0.22 //layer=ply \
 //thickness=0.18 //x=7.33 //y=0.89 //x2=7.11 //y2=0.89
r170 (  40 57 ) resistor r=13.0941 //w=0.233 //l=0.165 //layer=ply \
 //thickness=0.18 //x=7.05 //y=5.045 //x2=7.05 //y2=4.88
r171 (  39 54 ) resistor r=34.8111 //w=0.27 //l=0.264953 //layer=ply \
 //thickness=0.18 //x=6.955 //y=2.095 //x2=7.15 //y2=2.26
r172 (  38 56 ) resistor r=39.5823 //w=0.21 //l=0.173853 //layer=ply \
 //thickness=0.18 //x=6.955 //y=1.7 //x2=6.995 //y2=1.545
r173 (  38 39 ) resistor r=202.543 //w=0.094 //l=0.395 //layer=ply \
 //thickness=0.18 //x=6.955 //y=1.7 //x2=6.955 //y2=2.095
r174 (  37 56 ) resistor r=39.5823 //w=0.21 //l=0.173853 //layer=ply \
 //thickness=0.18 //x=6.955 //y=1.39 //x2=6.995 //y2=1.545
r175 (  36 55 ) resistor r=45.1352 //w=0.168 //l=0.173853 //layer=ply \
 //thickness=0.18 //x=6.955 //y=1.045 //x2=6.995 //y2=0.89
r176 (  36 37 ) resistor r=176.904 //w=0.094 //l=0.345 //layer=ply \
 //thickness=0.18 //x=6.955 //y=1.045 //x2=6.955 //y2=1.39
r177 (  35 50 ) resistor r=592.245 //w=0.094 //l=1.155 //layer=ply \
 //thickness=0.18 //x=7.49 //y=6.2 //x2=7.49 //y2=5.045
r178 (  34 40 ) resistor r=592.245 //w=0.094 //l=1.155 //layer=ply \
 //thickness=0.18 //x=7.05 //y=6.2 //x2=7.05 //y2=5.045
r179 (  33 45 ) resistor r=56.4043 //w=0.094 //l=0.11 //layer=ply \
 //thickness=0.18 //x=7.22 //y=1.545 //x2=7.33 //y2=1.545
r180 (  33 46 ) resistor r=56.4043 //w=0.094 //l=0.11 //layer=ply \
 //thickness=0.18 //x=7.22 //y=1.545 //x2=7.11 //y2=1.545
r181 (  31 59 ) resistor r=152 //w=0.17 //l=0.17 //layer=licon //count=1 \
 //x=7.15 //y=4.88 //x2=7.15 //y2=4.88
r182 (  29 31 ) resistor r=93.7754 //w=0.187 //l=1.37 //layer=li \
 //thickness=0.1 //x=7.15 //y=3.51 //x2=7.15 //y2=4.88
r183 (  26 54 ) resistor r=152 //w=0.17 //l=0.17 //layer=licon //count=1 \
 //x=7.15 //y=2.26 //x2=7.15 //y2=2.26
r184 (  26 29 ) resistor r=85.5615 //w=0.187 //l=1.25 //layer=li \
 //thickness=0.1 //x=7.15 //y=2.26 //x2=7.15 //y2=3.51
r185 (  22 24 ) resistor r=79.7433 //w=0.187 //l=1.165 //layer=li \
 //thickness=0.1 //x=1.97 //y=4.675 //x2=1.97 //y2=3.51
r186 (  21 24 ) resistor r=79.7433 //w=0.187 //l=1.165 //layer=li \
 //thickness=0.1 //x=1.97 //y=2.345 //x2=1.97 //y2=3.51
r187 (  19 22 ) resistor r=7.15173 //w=0.17 //l=0.120208 //layer=li \
 //thickness=0.1 //x=1.885 //y=4.76 //x2=1.97 //y2=4.675
r188 (  19 20 ) resistor r=13.3476 //w=0.187 //l=0.195 //layer=li \
 //thickness=0.1 //x=1.885 //y=4.76 //x2=1.69 //y2=4.76
r189 (  17 21 ) resistor r=7.15173 //w=0.17 //l=0.120208 //layer=li \
 //thickness=0.1 //x=1.885 //y=2.26 //x2=1.97 //y2=2.345
r190 (  17 18 ) resistor r=13.6898 //w=0.187 //l=0.2 //layer=li \
 //thickness=0.1 //x=1.885 //y=2.26 //x2=1.685 //y2=2.26
r191 (  11 20 ) resistor r=7.15173 //w=0.17 //l=0.120208 //layer=li \
 //thickness=0.1 //x=1.605 //y=4.845 //x2=1.69 //y2=4.76
r192 (  11 64 ) resistor r=72.5562 //w=0.187 //l=1.06 //layer=li \
 //thickness=0.1 //x=1.605 //y=4.845 //x2=1.605 //y2=5.905
r193 (  7 18 ) resistor r=7.15173 //w=0.17 //l=0.120208 //layer=li \
 //thickness=0.1 //x=1.6 //y=2.175 //x2=1.685 //y2=2.26
r194 (  7 62 ) resistor r=67.7647 //w=0.187 //l=0.99 //layer=li \
 //thickness=0.1 //x=1.6 //y=2.175 //x2=1.6 //y2=1.185
r195 (  6 29 ) resistor r=9.3 //w=0.17 //l=0.17 //layer=mcon //count=1 \
 //x=7.15 //y=3.51 //x2=7.15 //y2=3.51
r196 (  4 24 ) resistor r=9.3 //w=0.17 //l=0.17 //layer=mcon //count=1 \
 //x=1.97 //y=3.51 //x2=1.97 //y2=3.51
r197 (  2 4 ) resistor r=0.0717383 //w=0.224 //l=0.115 //layer=m1 \
 //thickness=0.36 //x=2.085 //y=3.51 //x2=1.97 //y2=3.51
r198 (  1 6 ) resistor r=0.0717383 //w=0.224 //l=0.115 //layer=m1 \
 //thickness=0.36 //x=7.035 //y=3.51 //x2=7.15 //y2=3.51
r199 (  1 2 ) resistor r=4.72328 //w=0.131 //l=4.95 //layer=m1 \
 //thickness=0.36 //x=7.035 //y=3.51 //x2=2.085 //y2=3.51
ends PM_MUX2X1\%noxref_4

subckt PM_MUX2X1\%noxref_5 ( 1 2 13 14 25 27 28 32 34 41 42 43 44 45 46 47 48 \
 52 54 57 58 68 71 73 74 )
c168 ( 74 0 ) capacitor c=0.0220291f //x=4.675 //y=5.2
c169 ( 73 0 ) capacitor c=0.0217503f //x=3.795 //y=5.2
c170 ( 71 0 ) capacitor c=0.00866655f //x=4.67 //y=1.085
c171 ( 68 0 ) capacitor c=0.0667949f //x=10.48 //y=4.88
c172 ( 58 0 ) capacitor c=0.0318948f //x=10.815 //y=1.39
c173 ( 57 0 ) capacitor c=0.0187384f //x=10.815 //y=1.045
c174 ( 54 0 ) capacitor c=0.0141798f //x=10.66 //y=1.545
c175 ( 52 0 ) capacitor c=0.0149844f //x=10.66 //y=0.89
c176 ( 48 0 ) capacitor c=0.0819722f //x=10.285 //y=2.095
c177 ( 47 0 ) capacitor c=0.0229722f //x=10.285 //y=1.7
c178 ( 46 0 ) capacitor c=0.0234352f //x=10.285 //y=1.39
c179 ( 45 0 ) capacitor c=0.0199343f //x=10.285 //y=1.045
c180 ( 44 0 ) capacitor c=0.110275f //x=10.82 //y=6.2
c181 ( 43 0 ) capacitor c=0.154305f //x=10.38 //y=6.2
c182 ( 41 0 ) capacitor c=0.00264586f //x=4.82 //y=5.38
c183 ( 34 0 ) capacitor c=0.09625f //x=10.48 //y=2.26
c184 ( 32 0 ) capacitor c=0.113528f //x=5.3 //y=3.14
c185 ( 28 0 ) capacitor c=0.00498573f //x=4.945 //y=1.835
c186 ( 27 0 ) capacitor c=0.0135368f //x=5.215 //y=1.835
c187 ( 25 0 ) capacitor c=0.0145797f //x=5.215 //y=5.38
c188 ( 14 0 ) capacitor c=0.00290084f //x=4.025 //y=5.38
c189 ( 13 0 ) capacitor c=0.0161139f //x=4.735 //y=5.38
c190 ( 2 0 ) capacitor c=0.00976341f //x=5.415 //y=3.14
c191 ( 1 0 ) capacitor c=0.168301f //x=10.365 //y=3.14
r192 (  66 68 ) resistor r=20.6867 //w=0.233 //l=0.1 //layer=ply \
 //thickness=0.18 //x=10.38 //y=4.88 //x2=10.48 //y2=4.88
r193 (  59 68 ) resistor r=70.3348 //w=0.233 //l=0.414367 //layer=ply \
 //thickness=0.18 //x=10.82 //y=5.045 //x2=10.48 //y2=4.88
r194 (  58 70 ) resistor r=45.1352 //w=0.168 //l=0.173853 //layer=ply \
 //thickness=0.18 //x=10.815 //y=1.39 //x2=10.775 //y2=1.545
r195 (  57 69 ) resistor r=45.1352 //w=0.168 //l=0.173853 //layer=ply \
 //thickness=0.18 //x=10.815 //y=1.045 //x2=10.775 //y2=0.89
r196 (  57 58 ) resistor r=176.904 //w=0.094 //l=0.345 //layer=ply \
 //thickness=0.18 //x=10.815 //y=1.045 //x2=10.815 //y2=1.39
r197 (  55 65 ) resistor r=10.701 //w=0.21 //l=0.115 //layer=ply \
 //thickness=0.18 //x=10.44 //y=1.545 //x2=10.325 //y2=1.545
r198 (  54 70 ) resistor r=5.52526 //w=0.168 //l=0.115 //layer=ply \
 //thickness=0.18 //x=10.66 //y=1.545 //x2=10.775 //y2=1.545
r199 (  53 64 ) resistor r=5.52526 //w=0.168 //l=0.115 //layer=ply \
 //thickness=0.18 //x=10.44 //y=0.89 //x2=10.325 //y2=0.89
r200 (  52 69 ) resistor r=5.52526 //w=0.168 //l=0.115 //layer=ply \
 //thickness=0.18 //x=10.66 //y=0.89 //x2=10.775 //y2=0.89
r201 (  52 53 ) resistor r=112.809 //w=0.094 //l=0.22 //layer=ply \
 //thickness=0.18 //x=10.66 //y=0.89 //x2=10.44 //y2=0.89
r202 (  49 66 ) resistor r=13.0941 //w=0.233 //l=0.165 //layer=ply \
 //thickness=0.18 //x=10.38 //y=5.045 //x2=10.38 //y2=4.88
r203 (  48 63 ) resistor r=34.8111 //w=0.27 //l=0.264953 //layer=ply \
 //thickness=0.18 //x=10.285 //y=2.095 //x2=10.48 //y2=2.26
r204 (  47 65 ) resistor r=39.5823 //w=0.21 //l=0.173853 //layer=ply \
 //thickness=0.18 //x=10.285 //y=1.7 //x2=10.325 //y2=1.545
r205 (  47 48 ) resistor r=202.543 //w=0.094 //l=0.395 //layer=ply \
 //thickness=0.18 //x=10.285 //y=1.7 //x2=10.285 //y2=2.095
r206 (  46 65 ) resistor r=39.5823 //w=0.21 //l=0.173853 //layer=ply \
 //thickness=0.18 //x=10.285 //y=1.39 //x2=10.325 //y2=1.545
r207 (  45 64 ) resistor r=45.1352 //w=0.168 //l=0.173853 //layer=ply \
 //thickness=0.18 //x=10.285 //y=1.045 //x2=10.325 //y2=0.89
r208 (  45 46 ) resistor r=176.904 //w=0.094 //l=0.345 //layer=ply \
 //thickness=0.18 //x=10.285 //y=1.045 //x2=10.285 //y2=1.39
r209 (  44 59 ) resistor r=592.245 //w=0.094 //l=1.155 //layer=ply \
 //thickness=0.18 //x=10.82 //y=6.2 //x2=10.82 //y2=5.045
r210 (  43 49 ) resistor r=592.245 //w=0.094 //l=1.155 //layer=ply \
 //thickness=0.18 //x=10.38 //y=6.2 //x2=10.38 //y2=5.045
r211 (  42 54 ) resistor r=56.4043 //w=0.094 //l=0.11 //layer=ply \
 //thickness=0.18 //x=10.55 //y=1.545 //x2=10.66 //y2=1.545
r212 (  42 55 ) resistor r=56.4043 //w=0.094 //l=0.11 //layer=ply \
 //thickness=0.18 //x=10.55 //y=1.545 //x2=10.44 //y2=1.545
r213 (  39 68 ) resistor r=152 //w=0.17 //l=0.17 //layer=licon //count=1 \
 //x=10.48 //y=4.88 //x2=10.48 //y2=4.88
r214 (  37 39 ) resistor r=119.102 //w=0.187 //l=1.74 //layer=li \
 //thickness=0.1 //x=10.48 //y=3.14 //x2=10.48 //y2=4.88
r215 (  34 63 ) resistor r=152 //w=0.17 //l=0.17 //layer=licon //count=1 \
 //x=10.48 //y=2.26 //x2=10.48 //y2=2.26
r216 (  34 37 ) resistor r=60.2353 //w=0.187 //l=0.88 //layer=li \
 //thickness=0.1 //x=10.48 //y=2.26 //x2=10.48 //y2=3.14
r217 (  30 32 ) resistor r=147.508 //w=0.187 //l=2.155 //layer=li \
 //thickness=0.1 //x=5.3 //y=5.295 //x2=5.3 //y2=3.14
r218 (  29 32 ) resistor r=83.508 //w=0.187 //l=1.22 //layer=li \
 //thickness=0.1 //x=5.3 //y=1.92 //x2=5.3 //y2=3.14
r219 (  27 29 ) resistor r=7.15173 //w=0.17 //l=0.120208 //layer=li \
 //thickness=0.1 //x=5.215 //y=1.835 //x2=5.3 //y2=1.92
r220 (  27 28 ) resistor r=18.4813 //w=0.187 //l=0.27 //layer=li \
 //thickness=0.1 //x=5.215 //y=1.835 //x2=4.945 //y2=1.835
r221 (  26 41 ) resistor r=5.4201 //w=0.17 //l=0.085 //layer=li \
 //thickness=0.1 //x=4.905 //y=5.38 //x2=4.82 //y2=5.38
r222 (  25 30 ) resistor r=7.15173 //w=0.17 //l=0.120208 //layer=li \
 //thickness=0.1 //x=5.215 //y=5.38 //x2=5.3 //y2=5.295
r223 (  25 26 ) resistor r=21.2193 //w=0.187 //l=0.31 //layer=li \
 //thickness=0.1 //x=5.215 //y=5.38 //x2=4.905 //y2=5.38
r224 (  21 28 ) resistor r=7.15173 //w=0.17 //l=0.120208 //layer=li \
 //thickness=0.1 //x=4.86 //y=1.75 //x2=4.945 //y2=1.835
r225 (  21 71 ) resistor r=39.016 //w=0.187 //l=0.57 //layer=li \
 //thickness=0.1 //x=4.86 //y=1.75 //x2=4.86 //y2=1.18
r226 (  15 41 ) resistor r=1.40859 //w=0.34 //l=0.085 //layer=li \
 //thickness=0.1 //x=4.82 //y=5.465 //x2=4.82 //y2=5.38
r227 (  15 74 ) resistor r=30.1176 //w=0.187 //l=0.44 //layer=li \
 //thickness=0.1 //x=4.82 //y=5.465 //x2=4.82 //y2=5.905
r228 (  13 41 ) resistor r=5.4201 //w=0.17 //l=0.085 //layer=li \
 //thickness=0.1 //x=4.735 //y=5.38 //x2=4.82 //y2=5.38
r229 (  13 14 ) resistor r=48.5989 //w=0.187 //l=0.71 //layer=li \
 //thickness=0.1 //x=4.735 //y=5.38 //x2=4.025 //y2=5.38
r230 (  7 14 ) resistor r=7.15173 //w=0.17 //l=0.120208 //layer=li \
 //thickness=0.1 //x=3.94 //y=5.465 //x2=4.025 //y2=5.38
r231 (  7 73 ) resistor r=30.1176 //w=0.187 //l=0.44 //layer=li \
 //thickness=0.1 //x=3.94 //y=5.465 //x2=3.94 //y2=5.905
r232 (  6 37 ) resistor r=9.3 //w=0.17 //l=0.17 //layer=mcon //count=1 \
 //x=10.48 //y=3.14 //x2=10.48 //y2=3.14
r233 (  4 32 ) resistor r=9.3 //w=0.17 //l=0.17 //layer=mcon //count=1 //x=5.3 \
 //y=3.14 //x2=5.3 //y2=3.14
r234 (  2 4 ) resistor r=0.0717383 //w=0.224 //l=0.115 //layer=m1 \
 //thickness=0.36 //x=5.415 //y=3.14 //x2=5.3 //y2=3.14
r235 (  1 6 ) resistor r=0.0717383 //w=0.224 //l=0.115 //layer=m1 \
 //thickness=0.36 //x=10.365 //y=3.14 //x2=10.48 //y2=3.14
r236 (  1 2 ) resistor r=4.72328 //w=0.131 //l=4.95 //layer=m1 \
 //thickness=0.36 //x=10.365 //y=3.14 //x2=5.415 //y2=3.14
ends PM_MUX2X1\%noxref_5

subckt PM_MUX2X1\%noxref_6 ( 1 2 13 14 25 27 28 32 33 35 39 42 43 44 45 46 47 \
 52 54 56 62 63 65 66 69 77 79 80 )
c155 ( 80 0 ) capacitor c=0.0220291f //x=8.005 //y=5.2
c156 ( 79 0 ) capacitor c=0.0217503f //x=7.125 //y=5.2
c157 ( 77 0 ) capacitor c=0.00866655f //x=8 //y=1.085
c158 ( 69 0 ) capacitor c=0.034715f //x=11.25 //y=4.88
c159 ( 66 0 ) capacitor c=0.0279499f //x=11.22 //y=2.095
c160 ( 65 0 ) capacitor c=0.0428694f //x=11.22 //y=2.26
c161 ( 63 0 ) capacitor c=0.0429696f //x=11.785 //y=1.43
c162 ( 62 0 ) capacitor c=0.0192208f //x=11.785 //y=1.085
c163 ( 56 0 ) capacitor c=0.0158629f //x=11.63 //y=1.585
c164 ( 54 0 ) capacitor c=0.0157803f //x=11.63 //y=0.93
c165 ( 52 0 ) capacitor c=0.0366192f //x=11.625 //y=4.97
c166 ( 47 0 ) capacitor c=0.0205163f //x=11.255 //y=1.74
c167 ( 46 0 ) capacitor c=0.0168481f //x=11.255 //y=1.43
c168 ( 45 0 ) capacitor c=0.0174783f //x=11.255 //y=1.085
c169 ( 44 0 ) capacitor c=0.15358f //x=11.7 //y=6.2
c170 ( 43 0 ) capacitor c=0.110281f //x=11.26 //y=6.2
c171 ( 39 0 ) capacitor c=0.00279371f //x=8.15 //y=5.38
c172 ( 35 0 ) capacitor c=0.0787765f //x=11.22 //y=2.26
c173 ( 33 0 ) capacitor c=0.00453889f //x=11.22 //y=4.715
c174 ( 32 0 ) capacitor c=0.113733f //x=8.63 //y=3.51
c175 ( 28 0 ) capacitor c=0.00468667f //x=8.275 //y=1.835
c176 ( 27 0 ) capacitor c=0.0131863f //x=8.545 //y=1.835
c177 ( 25 0 ) capacitor c=0.0147208f //x=8.545 //y=5.38
c178 ( 14 0 ) capacitor c=0.0029559f //x=7.355 //y=5.38
c179 ( 13 0 ) capacitor c=0.0166338f //x=8.065 //y=5.38
c180 ( 2 0 ) capacitor c=0.00897649f //x=8.745 //y=3.51
c181 ( 1 0 ) capacitor c=0.100712f //x=11.105 //y=3.51
r182 (  71 72 ) resistor r=32.4568 //w=0.214 //l=0.075 //layer=ply \
 //thickness=0.18 //x=11.25 //y=4.97 //x2=11.25 //y2=5.045
r183 (  69 71 ) resistor r=20.271 //w=0.214 //l=0.09 //layer=ply \
 //thickness=0.18 //x=11.25 //y=4.88 //x2=11.25 //y2=4.97
r184 (  65 66 ) resistor r=52.7279 //w=0.214 //l=0.165 //layer=ply \
 //thickness=0.18 //x=11.22 //y=2.26 //x2=11.22 //y2=2.095
r185 (  63 76 ) resistor r=45.1352 //w=0.168 //l=0.173853 //layer=ply \
 //thickness=0.18 //x=11.785 //y=1.43 //x2=11.745 //y2=1.585
r186 (  62 75 ) resistor r=45.1352 //w=0.168 //l=0.173853 //layer=ply \
 //thickness=0.18 //x=11.785 //y=1.085 //x2=11.745 //y2=0.93
r187 (  62 63 ) resistor r=176.904 //w=0.094 //l=0.345 //layer=ply \
 //thickness=0.18 //x=11.785 //y=1.085 //x2=11.785 //y2=1.43
r188 (  57 74 ) resistor r=10.701 //w=0.21 //l=0.115 //layer=ply \
 //thickness=0.18 //x=11.41 //y=1.585 //x2=11.295 //y2=1.585
r189 (  56 76 ) resistor r=5.52526 //w=0.168 //l=0.115 //layer=ply \
 //thickness=0.18 //x=11.63 //y=1.585 //x2=11.745 //y2=1.585
r190 (  55 73 ) resistor r=5.52526 //w=0.168 //l=0.115 //layer=ply \
 //thickness=0.18 //x=11.41 //y=0.93 //x2=11.295 //y2=0.93
r191 (  54 75 ) resistor r=5.52526 //w=0.168 //l=0.115 //layer=ply \
 //thickness=0.18 //x=11.63 //y=0.93 //x2=11.745 //y2=0.93
r192 (  54 55 ) resistor r=112.809 //w=0.094 //l=0.22 //layer=ply \
 //thickness=0.18 //x=11.63 //y=0.93 //x2=11.41 //y2=0.93
r193 (  53 71 ) resistor r=16.5046 //w=0.27 //l=0.135 //layer=ply \
 //thickness=0.18 //x=11.385 //y=4.97 //x2=11.25 //y2=4.97
r194 (  52 59 ) resistor r=26.9307 //w=0.15 //l=0.106066 //layer=ply \
 //thickness=0.18 //x=11.625 //y=4.97 //x2=11.7 //y2=5.045
r195 (  52 53 ) resistor r=123.064 //w=0.094 //l=0.24 //layer=ply \
 //thickness=0.18 //x=11.625 //y=4.97 //x2=11.385 //y2=4.97
r196 (  47 74 ) resistor r=39.5823 //w=0.21 //l=0.173853 //layer=ply \
 //thickness=0.18 //x=11.255 //y=1.74 //x2=11.295 //y2=1.585
r197 (  47 66 ) resistor r=182.032 //w=0.094 //l=0.355 //layer=ply \
 //thickness=0.18 //x=11.255 //y=1.74 //x2=11.255 //y2=2.095
r198 (  46 74 ) resistor r=39.5823 //w=0.21 //l=0.173853 //layer=ply \
 //thickness=0.18 //x=11.255 //y=1.43 //x2=11.295 //y2=1.585
r199 (  45 73 ) resistor r=45.1352 //w=0.168 //l=0.173853 //layer=ply \
 //thickness=0.18 //x=11.255 //y=1.085 //x2=11.295 //y2=0.93
r200 (  45 46 ) resistor r=176.904 //w=0.094 //l=0.345 //layer=ply \
 //thickness=0.18 //x=11.255 //y=1.085 //x2=11.255 //y2=1.43
r201 (  44 59 ) resistor r=592.245 //w=0.094 //l=1.155 //layer=ply \
 //thickness=0.18 //x=11.7 //y=6.2 //x2=11.7 //y2=5.045
r202 (  43 72 ) resistor r=592.245 //w=0.094 //l=1.155 //layer=ply \
 //thickness=0.18 //x=11.26 //y=6.2 //x2=11.26 //y2=5.045
r203 (  42 56 ) resistor r=56.4043 //w=0.094 //l=0.11 //layer=ply \
 //thickness=0.18 //x=11.52 //y=1.585 //x2=11.63 //y2=1.585
r204 (  42 57 ) resistor r=56.4043 //w=0.094 //l=0.11 //layer=ply \
 //thickness=0.18 //x=11.52 //y=1.585 //x2=11.41 //y2=1.585
r205 (  41 69 ) resistor r=152 //w=0.17 //l=0.17 //layer=licon //count=1 \
 //x=11.25 //y=4.88 //x2=11.25 //y2=4.88
r206 (  35 65 ) resistor r=152 //w=0.17 //l=0.17 //layer=licon //count=1 \
 //x=11.22 //y=2.26 //x2=11.22 //y2=2.26
r207 (  35 38 ) resistor r=85.5615 //w=0.187 //l=1.25 //layer=li \
 //thickness=0.1 //x=11.22 //y=2.26 //x2=11.22 //y2=3.51
r208 (  33 41 ) resistor r=11.4737 //w=0.186 //l=0.172337 //layer=li \
 //thickness=0.1 //x=11.22 //y=4.715 //x2=11.235 //y2=4.88
r209 (  33 38 ) resistor r=82.4813 //w=0.187 //l=1.205 //layer=li \
 //thickness=0.1 //x=11.22 //y=4.715 //x2=11.22 //y2=3.51
r210 (  30 32 ) resistor r=122.182 //w=0.187 //l=1.785 //layer=li \
 //thickness=0.1 //x=8.63 //y=5.295 //x2=8.63 //y2=3.51
r211 (  29 32 ) resistor r=108.834 //w=0.187 //l=1.59 //layer=li \
 //thickness=0.1 //x=8.63 //y=1.92 //x2=8.63 //y2=3.51
r212 (  27 29 ) resistor r=7.15173 //w=0.17 //l=0.120208 //layer=li \
 //thickness=0.1 //x=8.545 //y=1.835 //x2=8.63 //y2=1.92
r213 (  27 28 ) resistor r=18.4813 //w=0.187 //l=0.27 //layer=li \
 //thickness=0.1 //x=8.545 //y=1.835 //x2=8.275 //y2=1.835
r214 (  26 39 ) resistor r=5.4201 //w=0.17 //l=0.085 //layer=li \
 //thickness=0.1 //x=8.235 //y=5.38 //x2=8.15 //y2=5.38
r215 (  25 30 ) resistor r=7.15173 //w=0.17 //l=0.120208 //layer=li \
 //thickness=0.1 //x=8.545 //y=5.38 //x2=8.63 //y2=5.295
r216 (  25 26 ) resistor r=21.2193 //w=0.187 //l=0.31 //layer=li \
 //thickness=0.1 //x=8.545 //y=5.38 //x2=8.235 //y2=5.38
r217 (  21 28 ) resistor r=7.15173 //w=0.17 //l=0.120208 //layer=li \
 //thickness=0.1 //x=8.19 //y=1.75 //x2=8.275 //y2=1.835
r218 (  21 77 ) resistor r=39.016 //w=0.187 //l=0.57 //layer=li \
 //thickness=0.1 //x=8.19 //y=1.75 //x2=8.19 //y2=1.18
r219 (  15 39 ) resistor r=1.40859 //w=0.34 //l=0.085 //layer=li \
 //thickness=0.1 //x=8.15 //y=5.465 //x2=8.15 //y2=5.38
r220 (  15 80 ) resistor r=30.1176 //w=0.187 //l=0.44 //layer=li \
 //thickness=0.1 //x=8.15 //y=5.465 //x2=8.15 //y2=5.905
r221 (  13 39 ) resistor r=5.4201 //w=0.17 //l=0.085 //layer=li \
 //thickness=0.1 //x=8.065 //y=5.38 //x2=8.15 //y2=5.38
r222 (  13 14 ) resistor r=48.5989 //w=0.187 //l=0.71 //layer=li \
 //thickness=0.1 //x=8.065 //y=5.38 //x2=7.355 //y2=5.38
r223 (  7 14 ) resistor r=7.15173 //w=0.17 //l=0.120208 //layer=li \
 //thickness=0.1 //x=7.27 //y=5.465 //x2=7.355 //y2=5.38
r224 (  7 79 ) resistor r=30.1176 //w=0.187 //l=0.44 //layer=li \
 //thickness=0.1 //x=7.27 //y=5.465 //x2=7.27 //y2=5.905
r225 (  6 38 ) resistor r=9.3 //w=0.17 //l=0.17 //layer=mcon //count=1 \
 //x=11.22 //y=3.51 //x2=11.22 //y2=3.51
r226 (  4 32 ) resistor r=9.3 //w=0.17 //l=0.17 //layer=mcon //count=1 \
 //x=8.63 //y=3.51 //x2=8.63 //y2=3.51
r227 (  2 4 ) resistor r=0.0717383 //w=0.224 //l=0.115 //layer=m1 \
 //thickness=0.36 //x=8.745 //y=3.51 //x2=8.63 //y2=3.51
r228 (  1 6 ) resistor r=0.0717383 //w=0.224 //l=0.115 //layer=m1 \
 //thickness=0.36 //x=11.105 //y=3.51 //x2=11.22 //y2=3.51
r229 (  1 2 ) resistor r=2.25191 //w=0.131 //l=2.36 //layer=m1 \
 //thickness=0.36 //x=11.105 //y=3.51 //x2=8.745 //y2=3.51
ends PM_MUX2X1\%noxref_6

subckt PM_MUX2X1\%A0 ( 1 2 3 4 5 6 7 9 19 20 21 22 23 24 29 31 33 39 40 42 43 \
 46 )
c68 ( 46 0 ) capacitor c=0.034715f //x=4.59 //y=4.88
c69 ( 43 0 ) capacitor c=0.0279499f //x=4.56 //y=2.095
c70 ( 42 0 ) capacitor c=0.0437302f //x=4.56 //y=2.26
c71 ( 40 0 ) capacitor c=0.0429696f //x=5.125 //y=1.43
c72 ( 39 0 ) capacitor c=0.0192208f //x=5.125 //y=1.085
c73 ( 33 0 ) capacitor c=0.0158629f //x=4.97 //y=1.585
c74 ( 31 0 ) capacitor c=0.0157803f //x=4.97 //y=0.93
c75 ( 29 0 ) capacitor c=0.0366192f //x=4.965 //y=4.97
c76 ( 24 0 ) capacitor c=0.0205163f //x=4.595 //y=1.74
c77 ( 23 0 ) capacitor c=0.0168481f //x=4.595 //y=1.43
c78 ( 22 0 ) capacitor c=0.0174783f //x=4.595 //y=1.085
c79 ( 21 0 ) capacitor c=0.15358f //x=5.04 //y=6.2
c80 ( 20 0 ) capacitor c=0.110281f //x=4.6 //y=6.2
c81 ( 9 0 ) capacitor c=0.0784233f //x=4.56 //y=2.26
c82 ( 7 0 ) capacitor c=0.00453889f //x=4.56 //y=4.715
r83 (  48 49 ) resistor r=32.4568 //w=0.214 //l=0.075 //layer=ply \
 //thickness=0.18 //x=4.59 //y=4.97 //x2=4.59 //y2=5.045
r84 (  46 48 ) resistor r=20.271 //w=0.214 //l=0.09 //layer=ply \
 //thickness=0.18 //x=4.59 //y=4.88 //x2=4.59 //y2=4.97
r85 (  42 43 ) resistor r=52.7279 //w=0.214 //l=0.165 //layer=ply \
 //thickness=0.18 //x=4.56 //y=2.26 //x2=4.56 //y2=2.095
r86 (  40 53 ) resistor r=45.1352 //w=0.168 //l=0.173853 //layer=ply \
 //thickness=0.18 //x=5.125 //y=1.43 //x2=5.085 //y2=1.585
r87 (  39 52 ) resistor r=45.1352 //w=0.168 //l=0.173853 //layer=ply \
 //thickness=0.18 //x=5.125 //y=1.085 //x2=5.085 //y2=0.93
r88 (  39 40 ) resistor r=176.904 //w=0.094 //l=0.345 //layer=ply \
 //thickness=0.18 //x=5.125 //y=1.085 //x2=5.125 //y2=1.43
r89 (  34 51 ) resistor r=10.701 //w=0.21 //l=0.115 //layer=ply \
 //thickness=0.18 //x=4.75 //y=1.585 //x2=4.635 //y2=1.585
r90 (  33 53 ) resistor r=5.52526 //w=0.168 //l=0.115 //layer=ply \
 //thickness=0.18 //x=4.97 //y=1.585 //x2=5.085 //y2=1.585
r91 (  32 50 ) resistor r=5.52526 //w=0.168 //l=0.115 //layer=ply \
 //thickness=0.18 //x=4.75 //y=0.93 //x2=4.635 //y2=0.93
r92 (  31 52 ) resistor r=5.52526 //w=0.168 //l=0.115 //layer=ply \
 //thickness=0.18 //x=4.97 //y=0.93 //x2=5.085 //y2=0.93
r93 (  31 32 ) resistor r=112.809 //w=0.094 //l=0.22 //layer=ply \
 //thickness=0.18 //x=4.97 //y=0.93 //x2=4.75 //y2=0.93
r94 (  30 48 ) resistor r=16.5046 //w=0.27 //l=0.135 //layer=ply \
 //thickness=0.18 //x=4.725 //y=4.97 //x2=4.59 //y2=4.97
r95 (  29 36 ) resistor r=26.9307 //w=0.15 //l=0.106066 //layer=ply \
 //thickness=0.18 //x=4.965 //y=4.97 //x2=5.04 //y2=5.045
r96 (  29 30 ) resistor r=123.064 //w=0.094 //l=0.24 //layer=ply \
 //thickness=0.18 //x=4.965 //y=4.97 //x2=4.725 //y2=4.97
r97 (  24 51 ) resistor r=39.5823 //w=0.21 //l=0.173853 //layer=ply \
 //thickness=0.18 //x=4.595 //y=1.74 //x2=4.635 //y2=1.585
r98 (  24 43 ) resistor r=182.032 //w=0.094 //l=0.355 //layer=ply \
 //thickness=0.18 //x=4.595 //y=1.74 //x2=4.595 //y2=2.095
r99 (  23 51 ) resistor r=39.5823 //w=0.21 //l=0.173853 //layer=ply \
 //thickness=0.18 //x=4.595 //y=1.43 //x2=4.635 //y2=1.585
r100 (  22 50 ) resistor r=45.1352 //w=0.168 //l=0.173853 //layer=ply \
 //thickness=0.18 //x=4.595 //y=1.085 //x2=4.635 //y2=0.93
r101 (  22 23 ) resistor r=176.904 //w=0.094 //l=0.345 //layer=ply \
 //thickness=0.18 //x=4.595 //y=1.085 //x2=4.595 //y2=1.43
r102 (  21 36 ) resistor r=592.245 //w=0.094 //l=1.155 //layer=ply \
 //thickness=0.18 //x=5.04 //y=6.2 //x2=5.04 //y2=5.045
r103 (  20 49 ) resistor r=592.245 //w=0.094 //l=1.155 //layer=ply \
 //thickness=0.18 //x=4.6 //y=6.2 //x2=4.6 //y2=5.045
r104 (  19 33 ) resistor r=56.4043 //w=0.094 //l=0.11 //layer=ply \
 //thickness=0.18 //x=4.86 //y=1.585 //x2=4.97 //y2=1.585
r105 (  19 34 ) resistor r=56.4043 //w=0.094 //l=0.11 //layer=ply \
 //thickness=0.18 //x=4.86 //y=1.585 //x2=4.75 //y2=1.585
r106 (  18 46 ) resistor r=152 //w=0.17 //l=0.17 //layer=licon //count=1 \
 //x=4.59 //y=4.88 //x2=4.59 //y2=4.88
r107 (  9 42 ) resistor r=152 //w=0.17 //l=0.17 //layer=licon //count=1 \
 //x=4.56 //y=2.26 //x2=4.56 //y2=2.26
r108 (  7 18 ) resistor r=11.4737 //w=0.186 //l=0.172337 //layer=li \
 //thickness=0.1 //x=4.56 //y=4.715 //x2=4.575 //y2=4.88
r109 (  6 7 ) resistor r=6.50267 //w=0.187 //l=0.095 //layer=li \
 //thickness=0.1 //x=4.56 //y=4.62 //x2=4.56 //y2=4.715
r110 (  5 6 ) resistor r=25.3262 //w=0.187 //l=0.37 //layer=li //thickness=0.1 \
 //x=4.56 //y=4.25 //x2=4.56 //y2=4.62
r111 (  4 5 ) resistor r=25.3262 //w=0.187 //l=0.37 //layer=li //thickness=0.1 \
 //x=4.56 //y=3.88 //x2=4.56 //y2=4.25
r112 (  3 4 ) resistor r=50.6524 //w=0.187 //l=0.74 //layer=li //thickness=0.1 \
 //x=4.56 //y=3.14 //x2=4.56 //y2=3.88
r113 (  2 3 ) resistor r=25.3262 //w=0.187 //l=0.37 //layer=li //thickness=0.1 \
 //x=4.56 //y=2.77 //x2=4.56 //y2=3.14
r114 (  1 2 ) resistor r=25.3262 //w=0.187 //l=0.37 //layer=li //thickness=0.1 \
 //x=4.56 //y=2.4 //x2=4.56 //y2=2.77
r115 (  1 9 ) resistor r=9.58289 //w=0.187 //l=0.14 //layer=li //thickness=0.1 \
 //x=4.56 //y=2.4 //x2=4.56 //y2=2.26
ends PM_MUX2X1\%A0

subckt PM_MUX2X1\%noxref_8 ( 1 5 9 10 13 17 29 )
c57 ( 29 0 ) capacitor c=0.0632369f //x=3.27 //y=0.545
c58 ( 17 0 ) capacitor c=0.00722223f //x=5.345 //y=0.795
c59 ( 13 0 ) capacitor c=0.0148778f //x=5.26 //y=0.71
c60 ( 10 0 ) capacitor c=0.00664066f //x=4.375 //y=1.675
c61 ( 9 0 ) capacitor c=0.006761f //x=4.375 //y=0.795
c62 ( 5 0 ) capacitor c=0.0194491f //x=4.29 //y=1.76
c63 ( 1 0 ) capacitor c=0.00798521f //x=3.405 //y=1.675
r64 (  17 29 ) resistor r=3.57586 //w=0.17 //l=0.125 //layer=li \
 //thickness=0.1 //x=5.345 //y=0.795 //x2=5.345 //y2=0.67
r65 (  17 29 ) resistor r=18.139 //w=0.187 //l=0.265 //layer=li \
 //thickness=0.1 //x=5.345 //y=0.795 //x2=5.345 //y2=1.06
r66 (  14 29 ) resistor r=3.57586 //w=0.17 //l=0.103078 //layer=li \
 //thickness=0.1 //x=4.46 //y=0.71 //x2=4.375 //y2=0.67
r67 (  14 29 ) resistor r=27.3797 //w=0.187 //l=0.4 //layer=li //thickness=0.1 \
 //x=4.46 //y=0.71 //x2=4.86 //y2=0.71
r68 (  13 29 ) resistor r=3.57586 //w=0.17 //l=0.103078 //layer=li \
 //thickness=0.1 //x=5.26 //y=0.71 //x2=5.345 //y2=0.67
r69 (  13 29 ) resistor r=27.3797 //w=0.187 //l=0.4 //layer=li //thickness=0.1 \
 //x=5.26 //y=0.71 //x2=4.86 //y2=0.71
r70 (  10 29 ) resistor r=3.57586 //w=0.17 //l=0.125 //layer=li \
 //thickness=0.1 //x=4.375 //y=1.675 //x2=4.375 //y2=1.8
r71 (  10 29 ) resistor r=42.0963 //w=0.187 //l=0.615 //layer=li \
 //thickness=0.1 //x=4.375 //y=1.675 //x2=4.375 //y2=1.06
r72 (  9 29 ) resistor r=3.57586 //w=0.17 //l=0.125 //layer=li //thickness=0.1 \
 //x=4.375 //y=0.795 //x2=4.375 //y2=0.67
r73 (  9 29 ) resistor r=18.139 //w=0.187 //l=0.265 //layer=li //thickness=0.1 \
 //x=4.375 //y=0.795 //x2=4.375 //y2=1.06
r74 (  6 29 ) resistor r=3.57586 //w=0.17 //l=0.103078 //layer=li \
 //thickness=0.1 //x=3.49 //y=1.76 //x2=3.405 //y2=1.8
r75 (  6 29 ) resistor r=27.3797 //w=0.187 //l=0.4 //layer=li //thickness=0.1 \
 //x=3.49 //y=1.76 //x2=3.89 //y2=1.76
r76 (  5 29 ) resistor r=3.57586 //w=0.17 //l=0.103078 //layer=li \
 //thickness=0.1 //x=4.29 //y=1.76 //x2=4.375 //y2=1.8
r77 (  5 29 ) resistor r=27.3797 //w=0.187 //l=0.4 //layer=li //thickness=0.1 \
 //x=4.29 //y=1.76 //x2=3.89 //y2=1.76
r78 (  1 29 ) resistor r=3.57586 //w=0.17 //l=0.125 //layer=li //thickness=0.1 \
 //x=3.405 //y=1.675 //x2=3.405 //y2=1.8
r79 (  1 29 ) resistor r=42.0963 //w=0.187 //l=0.615 //layer=li \
 //thickness=0.1 //x=3.405 //y=1.675 //x2=3.405 //y2=1.06
ends PM_MUX2X1\%noxref_8

subckt PM_MUX2X1\%A1 ( 1 2 3 4 5 6 7 9 19 20 21 22 23 24 29 31 33 39 40 42 43 \
 46 )
c69 ( 46 0 ) capacitor c=0.034715f //x=7.92 //y=4.88
c70 ( 43 0 ) capacitor c=0.0279499f //x=7.89 //y=2.095
c71 ( 42 0 ) capacitor c=0.0422587f //x=7.89 //y=2.26
c72 ( 40 0 ) capacitor c=0.0429696f //x=8.455 //y=1.43
c73 ( 39 0 ) capacitor c=0.0192208f //x=8.455 //y=1.085
c74 ( 33 0 ) capacitor c=0.0158629f //x=8.3 //y=1.585
c75 ( 31 0 ) capacitor c=0.0157803f //x=8.3 //y=0.93
c76 ( 29 0 ) capacitor c=0.0366192f //x=8.295 //y=4.97
c77 ( 24 0 ) capacitor c=0.0205163f //x=7.925 //y=1.74
c78 ( 23 0 ) capacitor c=0.0168481f //x=7.925 //y=1.43
c79 ( 22 0 ) capacitor c=0.0174783f //x=7.925 //y=1.085
c80 ( 21 0 ) capacitor c=0.15358f //x=8.37 //y=6.2
c81 ( 20 0 ) capacitor c=0.110281f //x=7.93 //y=6.2
c82 ( 9 0 ) capacitor c=0.0784233f //x=7.89 //y=2.26
c83 ( 7 0 ) capacitor c=0.00453889f //x=7.89 //y=4.715
r84 (  48 49 ) resistor r=32.4568 //w=0.214 //l=0.075 //layer=ply \
 //thickness=0.18 //x=7.92 //y=4.97 //x2=7.92 //y2=5.045
r85 (  46 48 ) resistor r=20.271 //w=0.214 //l=0.09 //layer=ply \
 //thickness=0.18 //x=7.92 //y=4.88 //x2=7.92 //y2=4.97
r86 (  42 43 ) resistor r=52.7279 //w=0.214 //l=0.165 //layer=ply \
 //thickness=0.18 //x=7.89 //y=2.26 //x2=7.89 //y2=2.095
r87 (  40 53 ) resistor r=45.1352 //w=0.168 //l=0.173853 //layer=ply \
 //thickness=0.18 //x=8.455 //y=1.43 //x2=8.415 //y2=1.585
r88 (  39 52 ) resistor r=45.1352 //w=0.168 //l=0.173853 //layer=ply \
 //thickness=0.18 //x=8.455 //y=1.085 //x2=8.415 //y2=0.93
r89 (  39 40 ) resistor r=176.904 //w=0.094 //l=0.345 //layer=ply \
 //thickness=0.18 //x=8.455 //y=1.085 //x2=8.455 //y2=1.43
r90 (  34 51 ) resistor r=10.701 //w=0.21 //l=0.115 //layer=ply \
 //thickness=0.18 //x=8.08 //y=1.585 //x2=7.965 //y2=1.585
r91 (  33 53 ) resistor r=5.52526 //w=0.168 //l=0.115 //layer=ply \
 //thickness=0.18 //x=8.3 //y=1.585 //x2=8.415 //y2=1.585
r92 (  32 50 ) resistor r=5.52526 //w=0.168 //l=0.115 //layer=ply \
 //thickness=0.18 //x=8.08 //y=0.93 //x2=7.965 //y2=0.93
r93 (  31 52 ) resistor r=5.52526 //w=0.168 //l=0.115 //layer=ply \
 //thickness=0.18 //x=8.3 //y=0.93 //x2=8.415 //y2=0.93
r94 (  31 32 ) resistor r=112.809 //w=0.094 //l=0.22 //layer=ply \
 //thickness=0.18 //x=8.3 //y=0.93 //x2=8.08 //y2=0.93
r95 (  30 48 ) resistor r=16.5046 //w=0.27 //l=0.135 //layer=ply \
 //thickness=0.18 //x=8.055 //y=4.97 //x2=7.92 //y2=4.97
r96 (  29 36 ) resistor r=26.9307 //w=0.15 //l=0.106066 //layer=ply \
 //thickness=0.18 //x=8.295 //y=4.97 //x2=8.37 //y2=5.045
r97 (  29 30 ) resistor r=123.064 //w=0.094 //l=0.24 //layer=ply \
 //thickness=0.18 //x=8.295 //y=4.97 //x2=8.055 //y2=4.97
r98 (  24 51 ) resistor r=39.5823 //w=0.21 //l=0.173853 //layer=ply \
 //thickness=0.18 //x=7.925 //y=1.74 //x2=7.965 //y2=1.585
r99 (  24 43 ) resistor r=182.032 //w=0.094 //l=0.355 //layer=ply \
 //thickness=0.18 //x=7.925 //y=1.74 //x2=7.925 //y2=2.095
r100 (  23 51 ) resistor r=39.5823 //w=0.21 //l=0.173853 //layer=ply \
 //thickness=0.18 //x=7.925 //y=1.43 //x2=7.965 //y2=1.585
r101 (  22 50 ) resistor r=45.1352 //w=0.168 //l=0.173853 //layer=ply \
 //thickness=0.18 //x=7.925 //y=1.085 //x2=7.965 //y2=0.93
r102 (  22 23 ) resistor r=176.904 //w=0.094 //l=0.345 //layer=ply \
 //thickness=0.18 //x=7.925 //y=1.085 //x2=7.925 //y2=1.43
r103 (  21 36 ) resistor r=592.245 //w=0.094 //l=1.155 //layer=ply \
 //thickness=0.18 //x=8.37 //y=6.2 //x2=8.37 //y2=5.045
r104 (  20 49 ) resistor r=592.245 //w=0.094 //l=1.155 //layer=ply \
 //thickness=0.18 //x=7.93 //y=6.2 //x2=7.93 //y2=5.045
r105 (  19 33 ) resistor r=56.4043 //w=0.094 //l=0.11 //layer=ply \
 //thickness=0.18 //x=8.19 //y=1.585 //x2=8.3 //y2=1.585
r106 (  19 34 ) resistor r=56.4043 //w=0.094 //l=0.11 //layer=ply \
 //thickness=0.18 //x=8.19 //y=1.585 //x2=8.08 //y2=1.585
r107 (  18 46 ) resistor r=152 //w=0.17 //l=0.17 //layer=licon //count=1 \
 //x=7.92 //y=4.88 //x2=7.92 //y2=4.88
r108 (  9 42 ) resistor r=152 //w=0.17 //l=0.17 //layer=licon //count=1 \
 //x=7.89 //y=2.26 //x2=7.89 //y2=2.26
r109 (  7 18 ) resistor r=11.4737 //w=0.186 //l=0.172337 //layer=li \
 //thickness=0.1 //x=7.89 //y=4.715 //x2=7.905 //y2=4.88
r110 (  6 7 ) resistor r=6.50267 //w=0.187 //l=0.095 //layer=li \
 //thickness=0.1 //x=7.89 //y=4.62 //x2=7.89 //y2=4.715
r111 (  5 6 ) resistor r=25.3262 //w=0.187 //l=0.37 //layer=li //thickness=0.1 \
 //x=7.89 //y=4.25 //x2=7.89 //y2=4.62
r112 (  4 5 ) resistor r=25.3262 //w=0.187 //l=0.37 //layer=li //thickness=0.1 \
 //x=7.89 //y=3.88 //x2=7.89 //y2=4.25
r113 (  3 4 ) resistor r=25.3262 //w=0.187 //l=0.37 //layer=li //thickness=0.1 \
 //x=7.89 //y=3.51 //x2=7.89 //y2=3.88
r114 (  2 3 ) resistor r=50.6524 //w=0.187 //l=0.74 //layer=li //thickness=0.1 \
 //x=7.89 //y=2.77 //x2=7.89 //y2=3.51
r115 (  1 2 ) resistor r=25.3262 //w=0.187 //l=0.37 //layer=li //thickness=0.1 \
 //x=7.89 //y=2.4 //x2=7.89 //y2=2.77
r116 (  1 9 ) resistor r=9.58289 //w=0.187 //l=0.14 //layer=li //thickness=0.1 \
 //x=7.89 //y=2.4 //x2=7.89 //y2=2.26
ends PM_MUX2X1\%A1

subckt PM_MUX2X1\%noxref_10 ( 1 5 9 10 13 17 29 )
c55 ( 29 0 ) capacitor c=0.0635478f //x=6.6 //y=0.545
c56 ( 17 0 ) capacitor c=0.00722223f //x=8.675 //y=0.795
c57 ( 13 0 ) capacitor c=0.0147854f //x=8.59 //y=0.71
c58 ( 10 0 ) capacitor c=0.00638095f //x=7.705 //y=1.675
c59 ( 9 0 ) capacitor c=0.006761f //x=7.705 //y=0.795
c60 ( 5 0 ) capacitor c=0.0189075f //x=7.62 //y=1.76
c61 ( 1 0 ) capacitor c=0.00798521f //x=6.735 //y=1.675
r62 (  17 29 ) resistor r=3.57586 //w=0.17 //l=0.125 //layer=li \
 //thickness=0.1 //x=8.675 //y=0.795 //x2=8.675 //y2=0.67
r63 (  17 29 ) resistor r=18.139 //w=0.187 //l=0.265 //layer=li \
 //thickness=0.1 //x=8.675 //y=0.795 //x2=8.675 //y2=1.06
r64 (  14 29 ) resistor r=3.57586 //w=0.17 //l=0.103078 //layer=li \
 //thickness=0.1 //x=7.79 //y=0.71 //x2=7.705 //y2=0.67
r65 (  14 29 ) resistor r=27.3797 //w=0.187 //l=0.4 //layer=li //thickness=0.1 \
 //x=7.79 //y=0.71 //x2=8.19 //y2=0.71
r66 (  13 29 ) resistor r=3.57586 //w=0.17 //l=0.103078 //layer=li \
 //thickness=0.1 //x=8.59 //y=0.71 //x2=8.675 //y2=0.67
r67 (  13 29 ) resistor r=27.3797 //w=0.187 //l=0.4 //layer=li //thickness=0.1 \
 //x=8.59 //y=0.71 //x2=8.19 //y2=0.71
r68 (  10 29 ) resistor r=3.57586 //w=0.17 //l=0.125 //layer=li \
 //thickness=0.1 //x=7.705 //y=1.675 //x2=7.705 //y2=1.8
r69 (  10 29 ) resistor r=42.0963 //w=0.187 //l=0.615 //layer=li \
 //thickness=0.1 //x=7.705 //y=1.675 //x2=7.705 //y2=1.06
r70 (  9 29 ) resistor r=3.57586 //w=0.17 //l=0.125 //layer=li //thickness=0.1 \
 //x=7.705 //y=0.795 //x2=7.705 //y2=0.67
r71 (  9 29 ) resistor r=18.139 //w=0.187 //l=0.265 //layer=li //thickness=0.1 \
 //x=7.705 //y=0.795 //x2=7.705 //y2=1.06
r72 (  6 29 ) resistor r=3.57586 //w=0.17 //l=0.103078 //layer=li \
 //thickness=0.1 //x=6.82 //y=1.76 //x2=6.735 //y2=1.8
r73 (  6 29 ) resistor r=27.3797 //w=0.187 //l=0.4 //layer=li //thickness=0.1 \
 //x=6.82 //y=1.76 //x2=7.22 //y2=1.76
r74 (  5 29 ) resistor r=3.57586 //w=0.17 //l=0.103078 //layer=li \
 //thickness=0.1 //x=7.62 //y=1.76 //x2=7.705 //y2=1.8
r75 (  5 29 ) resistor r=27.3797 //w=0.187 //l=0.4 //layer=li //thickness=0.1 \
 //x=7.62 //y=1.76 //x2=7.22 //y2=1.76
r76 (  1 29 ) resistor r=3.57586 //w=0.17 //l=0.125 //layer=li //thickness=0.1 \
 //x=6.735 //y=1.675 //x2=6.735 //y2=1.8
r77 (  1 29 ) resistor r=42.0963 //w=0.187 //l=0.615 //layer=li \
 //thickness=0.1 //x=6.735 //y=1.675 //x2=6.735 //y2=1.06
ends PM_MUX2X1\%noxref_10

subckt PM_MUX2X1\%Y ( 1 2 3 4 5 6 7 8 15 16 27 29 30 41 42 44 45 )
c65 ( 45 0 ) capacitor c=0.0220291f //x=11.335 //y=5.2
c66 ( 44 0 ) capacitor c=0.0217503f //x=10.455 //y=5.2
c67 ( 42 0 ) capacitor c=0.0084702f //x=11.33 //y=1.085
c68 ( 41 0 ) capacitor c=0.00427536f //x=11.48 //y=5.38
c69 ( 30 0 ) capacitor c=0.00781917f //x=11.605 //y=1.835
c70 ( 29 0 ) capacitor c=0.0167625f //x=11.875 //y=1.835
c71 ( 27 0 ) capacitor c=0.0162757f //x=11.875 //y=5.38
c72 ( 16 0 ) capacitor c=0.00289676f //x=10.685 //y=5.38
c73 ( 15 0 ) capacitor c=0.0167385f //x=11.395 //y=5.38
c74 ( 1 0 ) capacitor c=0.132268f //x=11.96 //y=2.4
r75 (  29 31 ) resistor r=7.15173 //w=0.17 //l=0.120208 //layer=li \
 //thickness=0.1 //x=11.875 //y=1.835 //x2=11.96 //y2=1.92
r76 (  29 30 ) resistor r=18.4813 //w=0.187 //l=0.27 //layer=li \
 //thickness=0.1 //x=11.875 //y=1.835 //x2=11.605 //y2=1.835
r77 (  28 41 ) resistor r=5.4201 //w=0.17 //l=0.085 //layer=li //thickness=0.1 \
 //x=11.565 //y=5.38 //x2=11.48 //y2=5.38
r78 (  27 32 ) resistor r=7.15173 //w=0.17 //l=0.120208 //layer=li \
 //thickness=0.1 //x=11.875 //y=5.38 //x2=11.96 //y2=5.295
r79 (  27 28 ) resistor r=21.2193 //w=0.187 //l=0.31 //layer=li \
 //thickness=0.1 //x=11.875 //y=5.38 //x2=11.565 //y2=5.38
r80 (  23 30 ) resistor r=7.15173 //w=0.17 //l=0.120208 //layer=li \
 //thickness=0.1 //x=11.52 //y=1.75 //x2=11.605 //y2=1.835
r81 (  23 42 ) resistor r=39.016 //w=0.187 //l=0.57 //layer=li //thickness=0.1 \
 //x=11.52 //y=1.75 //x2=11.52 //y2=1.18
r82 (  17 41 ) resistor r=1.40859 //w=0.34 //l=0.085 //layer=li \
 //thickness=0.1 //x=11.48 //y=5.465 //x2=11.48 //y2=5.38
r83 (  17 45 ) resistor r=30.1176 //w=0.187 //l=0.44 //layer=li \
 //thickness=0.1 //x=11.48 //y=5.465 //x2=11.48 //y2=5.905
r84 (  15 41 ) resistor r=5.4201 //w=0.17 //l=0.085 //layer=li //thickness=0.1 \
 //x=11.395 //y=5.38 //x2=11.48 //y2=5.38
r85 (  15 16 ) resistor r=48.5989 //w=0.187 //l=0.71 //layer=li \
 //thickness=0.1 //x=11.395 //y=5.38 //x2=10.685 //y2=5.38
r86 (  9 16 ) resistor r=7.15173 //w=0.17 //l=0.120208 //layer=li \
 //thickness=0.1 //x=10.6 //y=5.465 //x2=10.685 //y2=5.38
r87 (  9 44 ) resistor r=30.1176 //w=0.187 //l=0.44 //layer=li //thickness=0.1 \
 //x=10.6 //y=5.465 //x2=10.6 //y2=5.905
r88 (  8 32 ) resistor r=20.877 //w=0.187 //l=0.305 //layer=li //thickness=0.1 \
 //x=11.96 //y=4.99 //x2=11.96 //y2=5.295
r89 (  7 8 ) resistor r=25.3262 //w=0.187 //l=0.37 //layer=li //thickness=0.1 \
 //x=11.96 //y=4.62 //x2=11.96 //y2=4.99
r90 (  6 7 ) resistor r=25.3262 //w=0.187 //l=0.37 //layer=li //thickness=0.1 \
 //x=11.96 //y=4.25 //x2=11.96 //y2=4.62
r91 (  5 6 ) resistor r=25.3262 //w=0.187 //l=0.37 //layer=li //thickness=0.1 \
 //x=11.96 //y=3.88 //x2=11.96 //y2=4.25
r92 (  4 5 ) resistor r=25.3262 //w=0.187 //l=0.37 //layer=li //thickness=0.1 \
 //x=11.96 //y=3.51 //x2=11.96 //y2=3.88
r93 (  3 4 ) resistor r=25.3262 //w=0.187 //l=0.37 //layer=li //thickness=0.1 \
 //x=11.96 //y=3.14 //x2=11.96 //y2=3.51
r94 (  2 3 ) resistor r=25.3262 //w=0.187 //l=0.37 //layer=li //thickness=0.1 \
 //x=11.96 //y=2.77 //x2=11.96 //y2=3.14
r95 (  1 2 ) resistor r=25.3262 //w=0.187 //l=0.37 //layer=li //thickness=0.1 \
 //x=11.96 //y=2.4 //x2=11.96 //y2=2.77
r96 (  1 31 ) resistor r=32.8556 //w=0.187 //l=0.48 //layer=li //thickness=0.1 \
 //x=11.96 //y=2.4 //x2=11.96 //y2=1.92
ends PM_MUX2X1\%Y

subckt PM_MUX2X1\%noxref_12 ( 1 5 9 10 13 17 29 )
c49 ( 29 0 ) capacitor c=0.0644508f //x=9.93 //y=0.545
c50 ( 17 0 ) capacitor c=0.00722223f //x=12.005 //y=0.795
c51 ( 13 0 ) capacitor c=0.0152085f //x=11.92 //y=0.71
c52 ( 10 0 ) capacitor c=0.00664f //x=11.035 //y=1.675
c53 ( 9 0 ) capacitor c=0.006761f //x=11.035 //y=0.795
c54 ( 5 0 ) capacitor c=0.0194491f //x=10.95 //y=1.76
c55 ( 1 0 ) capacitor c=0.00798521f //x=10.065 //y=1.675
r56 (  17 29 ) resistor r=3.57586 //w=0.17 //l=0.125 //layer=li \
 //thickness=0.1 //x=12.005 //y=0.795 //x2=12.005 //y2=0.67
r57 (  17 29 ) resistor r=18.139 //w=0.187 //l=0.265 //layer=li \
 //thickness=0.1 //x=12.005 //y=0.795 //x2=12.005 //y2=1.06
r58 (  14 29 ) resistor r=3.57586 //w=0.17 //l=0.103078 //layer=li \
 //thickness=0.1 //x=11.12 //y=0.71 //x2=11.035 //y2=0.67
r59 (  14 29 ) resistor r=27.3797 //w=0.187 //l=0.4 //layer=li //thickness=0.1 \
 //x=11.12 //y=0.71 //x2=11.52 //y2=0.71
r60 (  13 29 ) resistor r=3.57586 //w=0.17 //l=0.103078 //layer=li \
 //thickness=0.1 //x=11.92 //y=0.71 //x2=12.005 //y2=0.67
r61 (  13 29 ) resistor r=27.3797 //w=0.187 //l=0.4 //layer=li //thickness=0.1 \
 //x=11.92 //y=0.71 //x2=11.52 //y2=0.71
r62 (  10 29 ) resistor r=3.57586 //w=0.17 //l=0.125 //layer=li \
 //thickness=0.1 //x=11.035 //y=1.675 //x2=11.035 //y2=1.8
r63 (  10 29 ) resistor r=42.0963 //w=0.187 //l=0.615 //layer=li \
 //thickness=0.1 //x=11.035 //y=1.675 //x2=11.035 //y2=1.06
r64 (  9 29 ) resistor r=3.57586 //w=0.17 //l=0.125 //layer=li //thickness=0.1 \
 //x=11.035 //y=0.795 //x2=11.035 //y2=0.67
r65 (  9 29 ) resistor r=18.139 //w=0.187 //l=0.265 //layer=li //thickness=0.1 \
 //x=11.035 //y=0.795 //x2=11.035 //y2=1.06
r66 (  6 29 ) resistor r=3.57586 //w=0.17 //l=0.103078 //layer=li \
 //thickness=0.1 //x=10.15 //y=1.76 //x2=10.065 //y2=1.8
r67 (  6 29 ) resistor r=27.3797 //w=0.187 //l=0.4 //layer=li //thickness=0.1 \
 //x=10.15 //y=1.76 //x2=10.55 //y2=1.76
r68 (  5 29 ) resistor r=3.57586 //w=0.17 //l=0.103078 //layer=li \
 //thickness=0.1 //x=10.95 //y=1.76 //x2=11.035 //y2=1.8
r69 (  5 29 ) resistor r=27.3797 //w=0.187 //l=0.4 //layer=li //thickness=0.1 \
 //x=10.95 //y=1.76 //x2=10.55 //y2=1.76
r70 (  1 29 ) resistor r=3.57586 //w=0.17 //l=0.125 //layer=li //thickness=0.1 \
 //x=10.065 //y=1.675 //x2=10.065 //y2=1.8
r71 (  1 29 ) resistor r=42.0963 //w=0.187 //l=0.615 //layer=li \
 //thickness=0.1 //x=10.065 //y=1.675 //x2=10.065 //y2=1.06
ends PM_MUX2X1\%noxref_12
