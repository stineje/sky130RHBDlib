// File: nor2x1_pcell.spi
// Created: Sun Apr 12 08:42:49 2026
// Program "Calibre xRC"
// Version "v2023.2_27.15"
//
simulator lang=spectre
include "/import/yukari1/lrburle/sky130RHBDlib/calibre/sky130_rhbd_output/spice/nor2x1_pcell.pex.spice"
subckt nor2x1_pcell (  )
//
M0_noxref ( N_noxref_6_M0_noxref_d N_noxref_3_M0_noxref_g \
 N_noxref_1_M0_noxref_s noxref_53 ) NMOS l=0.163346 w=2.31104 m=1
M1_noxref ( N_noxref_6_M1_noxref_d N_noxref_5_M1_noxref_g \
 N_noxref_1_M0_noxref_s noxref_53 ) NMOS l=0.163129 w=2.31397 m=1
M2_noxref ( N_noxref_4_M2_noxref_d N_noxref_3_M2_noxref_g \
 N_noxref_2_M2_noxref_s noxref_51 ) PMOS l=0.15 w=2 ad=0.57 as=0.57 pd=2.57 \
 ps=2.57 nrd=0 nrs=0 m=1
M3_noxref ( N_noxref_2_M3_noxref_d N_noxref_3_M3_noxref_g \
 N_noxref_4_M2_noxref_d noxref_51 ) PMOS l=0.15 w=2 ad=0.58 as=0.58 pd=2.58 \
 ps=2.58 nrd=0 nrs=0 m=1
M4_noxref ( N_noxref_6_M4_noxref_d N_noxref_5_M4_noxref_g \
 N_noxref_2_M3_noxref_d noxref_51 ) PMOS l=0.15 w=2 ad=0.58 as=0.58 pd=2.58 \
 ps=2.58 nrd=0 nrs=0 m=1
M5_noxref ( N_noxref_2_M5_noxref_d N_noxref_5_M5_noxref_g \
 N_noxref_6_M4_noxref_d noxref_51 ) PMOS l=0.15 w=2 ad=0.56 as=0.56 pd=2.56 \
 ps=2.56 nrd=0 nrs=0 m=1
//
include "/import/yukari1/lrburle/sky130RHBDlib/calibre/sky130_rhbd_output/spice/nor2x1_pcell.pxi.spice"
//
ends NOR2X1_PCELL
//
//
