// File: OR2X1.spi.OR2X1.pxi
// Created: Tue Apr 29 10:44:03 2025
//
simulator lang=spectre
x_PM_OR2X1\%GND ( GND N_GND_c_4_p N_GND_c_48_p N_GND_c_13_p N_GND_c_14_p \
 N_GND_c_17_p N_GND_c_5_p N_GND_c_6_p N_GND_c_7_p N_GND_c_31_p N_GND_c_2_p \
 N_GND_c_1_p N_GND_c_3_p N_GND_M0_noxref_s N_GND_M2_noxref_s )  PM_OR2X1\%GND
x_PM_OR2X1\%VDD ( VDD N_VDD_c_78_p N_VDD_c_106_p N_VDD_c_75_n N_VDD_c_83_p \
 N_VDD_c_91_p N_VDD_c_76_n N_VDD_c_77_n N_VDD_M3_noxref_d N_VDD_M7_noxref_s \
 N_VDD_M8_noxref_d )  PM_OR2X1\%VDD
x_PM_OR2X1\%noxref_3 ( N_noxref_3_c_147_n N_noxref_3_c_153_n \
 N_noxref_3_c_155_n N_noxref_3_c_214_p N_noxref_3_c_194_n N_noxref_3_c_196_n \
 N_noxref_3_c_159_n N_noxref_3_c_164_n N_noxref_3_c_165_n \
 N_noxref_3_M2_noxref_g N_noxref_3_M7_noxref_g N_noxref_3_M8_noxref_g \
 N_noxref_3_c_170_n N_noxref_3_c_271_p N_noxref_3_c_272_p N_noxref_3_c_172_n \
 N_noxref_3_c_208_n N_noxref_3_c_209_n N_noxref_3_c_173_n N_noxref_3_c_263_p \
 N_noxref_3_c_174_n N_noxref_3_c_176_n N_noxref_3_c_177_n \
 N_noxref_3_M0_noxref_d N_noxref_3_M1_noxref_d N_noxref_3_M5_noxref_d )  \
 PM_OR2X1\%noxref_3
x_PM_OR2X1\%A ( A A A A A A A N_A_c_283_n N_A_c_295_n N_A_M0_noxref_g \
 N_A_M3_noxref_g N_A_M4_noxref_g N_A_c_286_n N_A_c_307_n N_A_c_308_n \
 N_A_c_288_n N_A_c_290_n N_A_c_312_n N_A_c_317_p N_A_c_291_n N_A_c_293_n \
 N_A_c_303_n )  PM_OR2X1\%A
x_PM_OR2X1\%B ( B B B B B B B N_B_c_362_n N_B_c_349_n N_B_M1_noxref_g \
 N_B_M5_noxref_g N_B_M6_noxref_g N_B_c_351_n N_B_c_371_n N_B_c_372_n \
 N_B_c_375_n N_B_c_353_n N_B_c_354_n N_B_c_355_n N_B_c_381_n N_B_c_382_n \
 N_B_c_384_n N_B_c_387_n )  PM_OR2X1\%B
x_PM_OR2X1\%noxref_6 ( N_noxref_6_c_418_n N_noxref_6_c_423_n \
 N_noxref_6_c_424_n N_noxref_6_c_425_n N_noxref_6_M3_noxref_s \
 N_noxref_6_M4_noxref_d N_noxref_6_M6_noxref_d )  PM_OR2X1\%noxref_6
x_PM_OR2X1\%Y ( Y Y Y Y Y Y Y N_Y_c_460_n N_Y_c_484_n N_Y_c_470_n N_Y_c_473_n \
 N_Y_M2_noxref_d N_Y_M7_noxref_d )  PM_OR2X1\%Y
cc_1 ( N_GND_c_1_p N_VDD_c_75_n ) capacitor c=0.00989514f //x=1.185 //y=0.175 \
 //x2=1.23 //y2=7.58
cc_2 ( N_GND_c_2_p N_VDD_c_76_n ) capacitor c=0.00989514f //x=5.67 //y=0.18 \
 //x2=5.67 //y2=7.58
cc_3 ( N_GND_c_3_p N_VDD_c_77_n ) capacitor c=0.00856126f //x=3.82 //y=0.175 \
 //x2=3.82 //y2=7.585
cc_4 ( N_GND_c_4_p N_noxref_3_c_147_n ) capacitor c=0.0116218f //x=5.67 \
 //y=0.18 //x2=4.445 //y2=3.51
cc_5 ( N_GND_c_5_p N_noxref_3_c_147_n ) capacitor c=0.00136355f //x=3.65 \
 //y=0.175 //x2=4.445 //y2=3.51
cc_6 ( N_GND_c_6_p N_noxref_3_c_147_n ) capacitor c=0.00110287f //x=4.365 \
 //y=0.175 //x2=4.445 //y2=3.51
cc_7 ( N_GND_c_7_p N_noxref_3_c_147_n ) capacitor c=2.76195e-19 //x=4.85 \
 //y=0.715 //x2=4.445 //y2=3.51
cc_8 ( N_GND_c_3_p N_noxref_3_c_147_n ) capacitor c=0.00820859f //x=3.82 \
 //y=0.175 //x2=4.445 //y2=3.51
cc_9 ( N_GND_M2_noxref_s N_noxref_3_c_147_n ) capacitor c=0.00164589f \
 //x=4.315 //y=0.55 //x2=4.445 //y2=3.51
cc_10 ( N_GND_c_4_p N_noxref_3_c_153_n ) capacitor c=0.00192554f //x=5.67 \
 //y=0.18 //x2=3.195 //y2=3.51
cc_11 ( N_GND_M0_noxref_s N_noxref_3_c_153_n ) capacitor c=6.50534e-19 \
 //x=1.05 //y=0.545 //x2=3.195 //y2=3.51
cc_12 ( N_GND_c_4_p N_noxref_3_c_155_n ) capacitor c=0.00359332f //x=5.67 \
 //y=0.18 //x2=2.555 //y2=1.835
cc_13 ( N_GND_c_13_p N_noxref_3_c_155_n ) capacitor c=0.00381844f //x=2.07 \
 //y=0.71 //x2=2.555 //y2=1.835
cc_14 ( N_GND_c_14_p N_noxref_3_c_155_n ) capacitor c=0.00323369f //x=2.555 \
 //y=0.71 //x2=2.555 //y2=1.835
cc_15 ( N_GND_M0_noxref_s N_noxref_3_c_155_n ) capacitor c=0.0173696f //x=1.05 \
 //y=0.545 //x2=2.555 //y2=1.835
cc_16 ( N_GND_c_4_p N_noxref_3_c_159_n ) capacitor c=0.00197536f //x=5.67 \
 //y=0.18 //x2=2.995 //y2=1.835
cc_17 ( N_GND_c_17_p N_noxref_3_c_159_n ) capacitor c=0.0047917f //x=3.04 \
 //y=0.71 //x2=2.995 //y2=1.835
cc_18 ( N_GND_c_3_p N_noxref_3_c_159_n ) capacitor c=0.0464456f //x=3.82 \
 //y=0.175 //x2=2.995 //y2=1.835
cc_19 ( N_GND_M0_noxref_s N_noxref_3_c_159_n ) capacitor c=0.0158849f //x=1.05 \
 //y=0.545 //x2=2.995 //y2=1.835
cc_20 ( N_GND_M2_noxref_s N_noxref_3_c_159_n ) capacitor c=3.53679e-19 \
 //x=4.315 //y=0.55 //x2=2.995 //y2=1.835
cc_21 ( N_GND_c_1_p N_noxref_3_c_164_n ) capacitor c=0.00101801f //x=1.185 \
 //y=0.175 //x2=3.08 //y2=3.51
cc_22 ( N_GND_c_4_p N_noxref_3_c_165_n ) capacitor c=0.00184912f //x=5.67 \
 //y=0.18 //x2=4.56 //y2=2.265
cc_23 ( N_GND_c_7_p N_noxref_3_c_165_n ) capacitor c=7.87839e-19 //x=4.85 \
 //y=0.715 //x2=4.56 //y2=2.265
cc_24 ( N_GND_c_2_p N_noxref_3_c_165_n ) capacitor c=0.00118981f //x=5.67 \
 //y=0.18 //x2=4.56 //y2=2.265
cc_25 ( N_GND_c_3_p N_noxref_3_c_165_n ) capacitor c=0.029021f //x=3.82 \
 //y=0.175 //x2=4.56 //y2=2.265
cc_26 ( N_GND_M2_noxref_s N_noxref_3_c_165_n ) capacitor c=0.0108553f \
 //x=4.315 //y=0.55 //x2=4.56 //y2=2.265
cc_27 ( N_GND_c_7_p N_noxref_3_c_170_n ) capacitor c=0.0121786f //x=4.85 \
 //y=0.715 //x2=4.67 //y2=1.09
cc_28 ( N_GND_M2_noxref_s N_noxref_3_c_170_n ) capacitor c=0.0317181f \
 //x=4.315 //y=0.55 //x2=4.67 //y2=1.09
cc_29 ( N_GND_c_3_p N_noxref_3_c_172_n ) capacitor c=0.00552709f //x=3.82 \
 //y=0.175 //x2=4.67 //y2=2.1
cc_30 ( N_GND_M2_noxref_s N_noxref_3_c_173_n ) capacitor c=0.00483567f \
 //x=4.315 //y=0.55 //x2=5.045 //y2=0.935
cc_31 ( N_GND_c_31_p N_noxref_3_c_174_n ) capacitor c=0.0118631f //x=5.335 \
 //y=0.715 //x2=5.2 //y2=1.09
cc_32 ( N_GND_M2_noxref_s N_noxref_3_c_174_n ) capacitor c=0.0143355f \
 //x=4.315 //y=0.55 //x2=5.2 //y2=1.09
cc_33 ( N_GND_M2_noxref_s N_noxref_3_c_176_n ) capacitor c=0.0074042f \
 //x=4.315 //y=0.55 //x2=5.2 //y2=1.435
cc_34 ( N_GND_c_7_p N_noxref_3_c_177_n ) capacitor c=2.1838e-19 //x=4.85 \
 //y=0.715 //x2=4.56 //y2=2.265
cc_35 ( N_GND_c_3_p N_noxref_3_c_177_n ) capacitor c=0.0108179f //x=3.82 \
 //y=0.175 //x2=4.56 //y2=2.265
cc_36 ( N_GND_M2_noxref_s N_noxref_3_c_177_n ) capacitor c=0.006558f //x=4.315 \
 //y=0.55 //x2=4.56 //y2=2.265
cc_37 ( N_GND_c_4_p N_noxref_3_M0_noxref_d ) capacitor c=0.00175671f //x=5.67 \
 //y=0.18 //x2=1.48 //y2=1.085
cc_38 ( N_GND_c_2_p N_noxref_3_M0_noxref_d ) capacitor c=2.31043e-19 //x=5.67 \
 //y=0.18 //x2=1.48 //y2=1.085
cc_39 ( N_GND_c_1_p N_noxref_3_M0_noxref_d ) capacitor c=0.00416273f //x=1.185 \
 //y=0.175 //x2=1.48 //y2=1.085
cc_40 ( N_GND_c_3_p N_noxref_3_M0_noxref_d ) capacitor c=2.57516e-19 //x=3.82 \
 //y=0.175 //x2=1.48 //y2=1.085
cc_41 ( N_GND_M0_noxref_s N_noxref_3_M0_noxref_d ) capacitor c=0.0771017f \
 //x=1.05 //y=0.545 //x2=1.48 //y2=1.085
cc_42 ( N_GND_c_4_p N_noxref_3_M1_noxref_d ) capacitor c=0.00195238f //x=5.67 \
 //y=0.18 //x2=2.45 //y2=1.085
cc_43 ( N_GND_c_2_p N_noxref_3_M1_noxref_d ) capacitor c=2.31043e-19 //x=5.67 \
 //y=0.18 //x2=2.45 //y2=1.085
cc_44 ( N_GND_c_3_p N_noxref_3_M1_noxref_d ) capacitor c=0.00609243f //x=3.82 \
 //y=0.175 //x2=2.45 //y2=1.085
cc_45 ( N_GND_M0_noxref_s N_noxref_3_M1_noxref_d ) capacitor c=0.061033f \
 //x=1.05 //y=0.545 //x2=2.45 //y2=1.085
cc_46 ( N_GND_M2_noxref_s N_noxref_3_M1_noxref_d ) capacitor c=2.04477e-19 \
 //x=4.315 //y=0.55 //x2=2.45 //y2=1.085
cc_47 ( N_GND_c_4_p N_A_c_283_n ) capacitor c=6.77224e-19 //x=5.67 //y=0.18 \
 //x2=1.6 //y2=2.26
cc_48 ( N_GND_c_48_p N_A_c_283_n ) capacitor c=0.00136225f //x=1.585 //y=0.71 \
 //x2=1.6 //y2=2.26
cc_49 ( N_GND_c_1_p N_A_c_283_n ) capacitor c=0.0176887f //x=1.185 //y=0.175 \
 //x2=1.6 //y2=2.26
cc_50 ( N_GND_c_48_p N_A_c_286_n ) capacitor c=0.0122398f //x=1.585 //y=0.71 \
 //x2=1.405 //y2=1.085
cc_51 ( N_GND_M0_noxref_s N_A_c_286_n ) capacitor c=0.0318086f //x=1.05 \
 //y=0.545 //x2=1.405 //y2=1.085
cc_52 ( N_GND_c_48_p N_A_c_288_n ) capacitor c=2.1838e-19 //x=1.585 //y=0.71 \
 //x2=1.405 //y2=2.095
cc_53 ( N_GND_c_1_p N_A_c_288_n ) capacitor c=0.0196165f //x=1.185 //y=0.175 \
 //x2=1.405 //y2=2.095
cc_54 ( N_GND_M0_noxref_s N_A_c_290_n ) capacitor c=0.00474701f //x=1.05 \
 //y=0.545 //x2=1.78 //y2=0.93
cc_55 ( N_GND_c_13_p N_A_c_291_n ) capacitor c=0.0113116f //x=2.07 //y=0.71 \
 //x2=1.935 //y2=1.085
cc_56 ( N_GND_M0_noxref_s N_A_c_291_n ) capacitor c=0.00514143f //x=1.05 \
 //y=0.545 //x2=1.935 //y2=1.085
cc_57 ( N_GND_M0_noxref_s N_A_c_293_n ) capacitor c=8.33128e-19 //x=1.05 \
 //y=0.545 //x2=1.935 //y2=1.43
cc_58 ( N_GND_c_1_p N_B_c_349_n ) capacitor c=9.2064e-19 //x=1.185 //y=0.175 \
 //x2=2.34 //y2=2.26
cc_59 ( N_GND_c_3_p N_B_c_349_n ) capacitor c=9.53263e-19 //x=3.82 //y=0.175 \
 //x2=2.34 //y2=2.26
cc_60 ( N_GND_c_14_p N_B_c_351_n ) capacitor c=0.0109831f //x=2.555 //y=0.71 \
 //x2=2.375 //y2=1.085
cc_61 ( N_GND_M0_noxref_s N_B_c_351_n ) capacitor c=0.00590563f //x=1.05 \
 //y=0.545 //x2=2.375 //y2=1.085
cc_62 ( N_GND_M0_noxref_s N_B_c_353_n ) capacitor c=0.00467042f //x=1.05 \
 //y=0.545 //x2=2.75 //y2=0.93
cc_63 ( N_GND_M0_noxref_s N_B_c_354_n ) capacitor c=0.00316186f //x=1.05 \
 //y=0.545 //x2=2.75 //y2=1.585
cc_64 ( N_GND_c_17_p N_B_c_355_n ) capacitor c=0.011235f //x=3.04 //y=0.71 \
 //x2=2.905 //y2=1.085
cc_65 ( N_GND_M0_noxref_s N_B_c_355_n ) capacitor c=0.0142835f //x=1.05 \
 //y=0.545 //x2=2.905 //y2=1.085
cc_66 ( N_GND_c_3_p Y ) capacitor c=8.10282e-19 //x=3.82 //y=0.175 //x2=5.3 \
 //y2=2.4
cc_67 ( N_GND_c_4_p N_Y_c_460_n ) capacitor c=0.00181107f //x=5.67 //y=0.18 \
 //x2=5.215 //y2=2.26
cc_68 ( N_GND_c_2_p N_Y_c_460_n ) capacitor c=0.0301661f //x=5.67 //y=0.18 \
 //x2=5.215 //y2=2.26
cc_69 ( N_GND_M2_noxref_s N_Y_c_460_n ) capacitor c=0.0099963f //x=4.315 \
 //y=0.55 //x2=5.215 //y2=2.26
cc_70 ( N_GND_c_4_p N_Y_M2_noxref_d ) capacitor c=0.00194747f //x=5.67 \
 //y=0.18 //x2=4.745 //y2=1.09
cc_71 ( N_GND_c_7_p N_Y_M2_noxref_d ) capacitor c=0.014622f //x=4.85 //y=0.715 \
 //x2=4.745 //y2=1.09
cc_72 ( N_GND_c_2_p N_Y_M2_noxref_d ) capacitor c=0.00973758f //x=5.67 \
 //y=0.18 //x2=4.745 //y2=1.09
cc_73 ( N_GND_c_3_p N_Y_M2_noxref_d ) capacitor c=0.00924905f //x=3.82 \
 //y=0.175 //x2=4.745 //y2=1.09
cc_74 ( N_GND_M2_noxref_s N_Y_M2_noxref_d ) capacitor c=0.076995f //x=4.315 \
 //y=0.55 //x2=4.745 //y2=1.09
cc_75 ( N_VDD_c_78_p N_noxref_3_c_147_n ) capacitor c=0.00921913f //x=5.67 \
 //y=7.58 //x2=4.445 //y2=3.51
cc_76 ( N_VDD_c_77_n N_noxref_3_c_147_n ) capacitor c=0.00694659f //x=3.82 \
 //y=7.585 //x2=4.445 //y2=3.51
cc_77 ( N_VDD_M7_noxref_s N_noxref_3_c_147_n ) capacitor c=0.0010609f //x=4.36 \
 //y=5.2 //x2=4.445 //y2=3.51
cc_78 ( N_VDD_c_78_p N_noxref_3_c_153_n ) capacitor c=0.00145597f //x=5.67 \
 //y=7.58 //x2=3.195 //y2=3.51
cc_79 ( N_VDD_c_78_p N_noxref_3_c_194_n ) capacitor c=0.00178388f //x=5.67 \
 //y=7.58 //x2=2.995 //y2=5.39
cc_80 ( N_VDD_c_83_p N_noxref_3_c_194_n ) capacitor c=0.00137054f //x=3.65 \
 //y=7.585 //x2=2.995 //y2=5.39
cc_81 ( N_VDD_c_75_n N_noxref_3_c_196_n ) capacitor c=8.9933e-19 //x=1.23 \
 //y=7.58 //x2=2.685 //y2=5.39
cc_82 ( N_VDD_c_75_n N_noxref_3_c_164_n ) capacitor c=0.00163766f //x=1.23 \
 //y=7.58 //x2=3.08 //y2=3.51
cc_83 ( N_VDD_c_77_n N_noxref_3_c_164_n ) capacitor c=0.0462234f //x=3.82 \
 //y=7.585 //x2=3.08 //y2=3.51
cc_84 ( N_VDD_c_78_p N_noxref_3_c_165_n ) capacitor c=0.00160062f //x=5.67 \
 //y=7.58 //x2=4.56 //y2=2.265
cc_85 ( N_VDD_c_76_n N_noxref_3_c_165_n ) capacitor c=0.00144809f //x=5.67 \
 //y=7.58 //x2=4.56 //y2=2.265
cc_86 ( N_VDD_c_77_n N_noxref_3_c_165_n ) capacitor c=0.0272885f //x=3.82 \
 //y=7.585 //x2=4.56 //y2=2.265
cc_87 ( N_VDD_M7_noxref_s N_noxref_3_c_165_n ) capacitor c=0.00971925f \
 //x=4.36 //y=5.2 //x2=4.56 //y2=2.265
cc_88 ( N_VDD_c_91_p N_noxref_3_M7_noxref_g ) capacitor c=0.00753931f //x=5.29 \
 //y=7.585 //x2=4.715 //y2=6.2
cc_89 ( N_VDD_c_77_n N_noxref_3_M7_noxref_g ) capacitor c=0.0102569f //x=3.82 \
 //y=7.585 //x2=4.715 //y2=6.2
cc_90 ( N_VDD_M7_noxref_s N_noxref_3_M7_noxref_g ) capacitor c=0.0528676f \
 //x=4.36 //y=5.2 //x2=4.715 //y2=6.2
cc_91 ( N_VDD_c_91_p N_noxref_3_M8_noxref_g ) capacitor c=0.00702238f //x=5.29 \
 //y=7.585 //x2=5.155 //y2=6.2
cc_92 ( N_VDD_M8_noxref_d N_noxref_3_M8_noxref_g ) capacitor c=0.0528676f \
 //x=5.23 //y=5.2 //x2=5.155 //y2=6.2
cc_93 ( N_VDD_c_76_n N_noxref_3_c_208_n ) capacitor c=0.0287802f //x=5.67 \
 //y=7.58 //x2=5.08 //y2=4.97
cc_94 ( N_VDD_c_77_n N_noxref_3_c_209_n ) capacitor c=0.011132f //x=3.82 \
 //y=7.585 //x2=4.79 //y2=4.97
cc_95 ( N_VDD_M7_noxref_s N_noxref_3_c_209_n ) capacitor c=0.0052728f //x=4.36 \
 //y=5.2 //x2=4.79 //y2=4.97
cc_96 ( N_VDD_c_77_n N_noxref_3_M5_noxref_d ) capacitor c=0.00966019f //x=3.82 \
 //y=7.585 //x2=2.455 //y2=5.205
cc_97 ( N_VDD_M3_noxref_d N_noxref_3_M5_noxref_d ) capacitor c=0.00561178f \
 //x=1.575 //y=5.205 //x2=2.455 //y2=5.205
cc_98 ( N_VDD_M7_noxref_s N_noxref_3_M5_noxref_d ) capacitor c=4.94992e-19 \
 //x=4.36 //y=5.2 //x2=2.455 //y2=5.205
cc_99 ( N_VDD_c_75_n N_A_c_283_n ) capacitor c=0.0104719f //x=1.23 //y=7.58 \
 //x2=1.6 //y2=2.26
cc_100 ( N_VDD_c_78_p N_A_c_295_n ) capacitor c=3.36051e-19 //x=5.67 //y=7.58 \
 //x2=1.445 //y2=4.885
cc_101 ( N_VDD_c_75_n N_A_c_295_n ) capacitor c=0.008636f //x=1.23 //y=7.58 \
 //x2=1.445 //y2=4.885
cc_102 ( N_VDD_M3_noxref_d N_A_c_295_n ) capacitor c=2.82994e-19 //x=1.575 \
 //y=5.205 //x2=1.445 //y2=4.885
cc_103 ( N_VDD_c_106_p N_A_M3_noxref_g ) capacitor c=0.00683851f //x=1.635 \
 //y=7.585 //x2=1.5 //y2=6.205
cc_104 ( N_VDD_c_75_n N_A_M3_noxref_g ) capacitor c=0.0237757f //x=1.23 \
 //y=7.58 //x2=1.5 //y2=6.205
cc_105 ( N_VDD_M3_noxref_d N_A_M3_noxref_g ) capacitor c=0.0156786f //x=1.575 \
 //y=5.205 //x2=1.5 //y2=6.205
cc_106 ( N_VDD_c_83_p N_A_M4_noxref_g ) capacitor c=0.0068279f //x=3.65 \
 //y=7.585 //x2=1.94 //y2=6.205
cc_107 ( N_VDD_M3_noxref_d N_A_M4_noxref_g ) capacitor c=0.0183011f //x=1.575 \
 //y=5.205 //x2=1.94 //y2=6.205
cc_108 ( N_VDD_c_75_n N_A_c_303_n ) capacitor c=0.00890932f //x=1.23 //y=7.58 \
 //x2=1.445 //y2=4.885
cc_109 ( N_VDD_c_75_n N_B_c_349_n ) capacitor c=7.02327e-19 //x=1.23 //y=7.58 \
 //x2=2.34 //y2=2.26
cc_110 ( N_VDD_c_77_n N_B_c_349_n ) capacitor c=6.16704e-19 //x=3.82 //y=7.585 \
 //x2=2.34 //y2=2.26
cc_111 ( N_VDD_c_83_p N_B_M5_noxref_g ) capacitor c=0.00516984f //x=3.65 \
 //y=7.585 //x2=2.38 //y2=6.205
cc_112 ( N_VDD_c_83_p N_B_M6_noxref_g ) capacitor c=0.00515938f //x=3.65 \
 //y=7.585 //x2=2.82 //y2=6.205
cc_113 ( N_VDD_c_77_n N_B_M6_noxref_g ) capacitor c=0.0120232f //x=3.82 \
 //y=7.585 //x2=2.82 //y2=6.205
cc_114 ( N_VDD_c_78_p N_noxref_6_c_418_n ) capacitor c=0.00568136f //x=5.67 \
 //y=7.58 //x2=2.075 //y2=5.39
cc_115 ( N_VDD_c_106_p N_noxref_6_c_418_n ) capacitor c=4.38114e-19 //x=1.635 \
 //y=7.585 //x2=2.075 //y2=5.39
cc_116 ( N_VDD_c_83_p N_noxref_6_c_418_n ) capacitor c=4.38114e-19 //x=3.65 \
 //y=7.585 //x2=2.075 //y2=5.39
cc_117 ( N_VDD_c_77_n N_noxref_6_c_418_n ) capacitor c=0.00289291f //x=3.82 \
 //y=7.585 //x2=2.075 //y2=5.39
cc_118 ( N_VDD_M3_noxref_d N_noxref_6_c_418_n ) capacitor c=0.0130902f \
 //x=1.575 //y=5.205 //x2=2.075 //y2=5.39
cc_119 ( N_VDD_c_75_n N_noxref_6_c_423_n ) capacitor c=0.0679103f //x=1.23 \
 //y=7.58 //x2=1.365 //y2=5.39
cc_120 ( N_VDD_c_76_n N_noxref_6_c_424_n ) capacitor c=0.00359315f //x=5.67 \
 //y=7.58 //x2=2.955 //y2=7.09
cc_121 ( N_VDD_c_78_p N_noxref_6_c_425_n ) capacitor c=0.0352163f //x=5.67 \
 //y=7.58 //x2=2.245 //y2=7.09
cc_122 ( N_VDD_c_83_p N_noxref_6_c_425_n ) capacitor c=0.0587731f //x=3.65 \
 //y=7.585 //x2=2.245 //y2=7.09
cc_123 ( N_VDD_c_76_n N_noxref_6_c_425_n ) capacitor c=0.00118659f //x=5.67 \
 //y=7.58 //x2=2.245 //y2=7.09
cc_124 ( N_VDD_c_78_p N_noxref_6_M3_noxref_s ) capacitor c=0.00714423f \
 //x=5.67 //y=7.58 //x2=1.145 //y2=5.205
cc_125 ( N_VDD_c_106_p N_noxref_6_M3_noxref_s ) capacitor c=0.0141529f \
 //x=1.635 //y=7.585 //x2=1.145 //y2=5.205
cc_126 ( N_VDD_c_76_n N_noxref_6_M3_noxref_s ) capacitor c=0.00138926f \
 //x=5.67 //y=7.58 //x2=1.145 //y2=5.205
cc_127 ( N_VDD_M3_noxref_d N_noxref_6_M3_noxref_s ) capacitor c=0.0667021f \
 //x=1.575 //y=5.205 //x2=1.145 //y2=5.205
cc_128 ( N_VDD_c_75_n N_noxref_6_M4_noxref_d ) capacitor c=8.88629e-19 \
 //x=1.23 //y=7.58 //x2=2.015 //y2=5.205
cc_129 ( N_VDD_M3_noxref_d N_noxref_6_M4_noxref_d ) capacitor c=0.0659925f \
 //x=1.575 //y=5.205 //x2=2.015 //y2=5.205
cc_130 ( N_VDD_c_77_n N_noxref_6_M6_noxref_d ) capacitor c=0.0520312f //x=3.82 \
 //y=7.585 //x2=2.895 //y2=5.205
cc_131 ( N_VDD_M3_noxref_d N_noxref_6_M6_noxref_d ) capacitor c=0.00107819f \
 //x=1.575 //y=5.205 //x2=2.895 //y2=5.205
cc_132 ( N_VDD_M7_noxref_s N_noxref_6_M6_noxref_d ) capacitor c=0.00226909f \
 //x=4.36 //y=5.2 //x2=2.895 //y2=5.205
cc_133 ( N_VDD_c_76_n Y ) capacitor c=0.0232778f //x=5.67 //y=7.58 //x2=5.3 \
 //y2=2.4
cc_134 ( N_VDD_c_77_n Y ) capacitor c=4.80934e-19 //x=3.82 //y=7.585 //x2=5.3 \
 //y2=2.4
cc_135 ( N_VDD_c_78_p N_Y_c_470_n ) capacitor c=0.00191195f //x=5.67 //y=7.58 \
 //x2=5.215 //y2=4.76
cc_136 ( N_VDD_c_91_p N_Y_c_470_n ) capacitor c=8.83313e-19 //x=5.29 //y=7.585 \
 //x2=5.215 //y2=4.76
cc_137 ( N_VDD_M8_noxref_d N_Y_c_470_n ) capacitor c=0.00641652f //x=5.23 \
 //y=5.2 //x2=5.215 //y2=4.76
cc_138 ( N_VDD_c_77_n N_Y_c_473_n ) capacitor c=0.017572f //x=3.82 //y=7.585 \
 //x2=5.02 //y2=4.76
cc_139 ( N_VDD_c_78_p N_Y_M7_noxref_d ) capacitor c=0.00710215f //x=5.67 \
 //y=7.58 //x2=4.79 //y2=5.2
cc_140 ( N_VDD_c_91_p N_Y_M7_noxref_d ) capacitor c=0.0139426f //x=5.29 \
 //y=7.585 //x2=4.79 //y2=5.2
cc_141 ( N_VDD_c_76_n N_Y_M7_noxref_d ) capacitor c=0.0219131f //x=5.67 \
 //y=7.58 //x2=4.79 //y2=5.2
cc_142 ( N_VDD_M7_noxref_s N_Y_M7_noxref_d ) capacitor c=0.0843065f //x=4.36 \
 //y=5.2 //x2=4.79 //y2=5.2
cc_143 ( N_VDD_M8_noxref_d N_Y_M7_noxref_d ) capacitor c=0.0832641f //x=5.23 \
 //y=5.2 //x2=4.79 //y2=5.2
cc_144 ( N_noxref_3_c_214_p N_A_c_283_n ) capacitor c=0.0112169f //x=1.755 \
 //y=1.835 //x2=1.6 //y2=2.26
cc_145 ( N_noxref_3_c_164_n N_A_c_283_n ) capacitor c=0.00392263f //x=3.08 \
 //y=3.51 //x2=1.6 //y2=2.26
cc_146 ( N_noxref_3_M0_noxref_d N_A_c_286_n ) capacitor c=0.0013184f //x=1.48 \
 //y=1.085 //x2=1.405 //y2=1.085
cc_147 ( N_noxref_3_M0_noxref_d N_A_c_307_n ) capacitor c=0.0034598f //x=1.48 \
 //y=1.085 //x2=1.405 //y2=1.43
cc_148 ( N_noxref_3_M0_noxref_d N_A_c_308_n ) capacitor c=0.00300148f //x=1.48 \
 //y=1.085 //x2=1.405 //y2=1.74
cc_149 ( N_noxref_3_c_214_p N_A_c_288_n ) capacitor c=0.00589082f //x=1.755 \
 //y=1.835 //x2=1.405 //y2=2.095
cc_150 ( N_noxref_3_M0_noxref_d N_A_c_288_n ) capacitor c=0.00273686f //x=1.48 \
 //y=1.085 //x2=1.405 //y2=2.095
cc_151 ( N_noxref_3_M0_noxref_d N_A_c_290_n ) capacitor c=0.00241102f //x=1.48 \
 //y=1.085 //x2=1.78 //y2=0.93
cc_152 ( N_noxref_3_M0_noxref_d N_A_c_312_n ) capacitor c=0.0123304f //x=1.48 \
 //y=1.085 //x2=1.78 //y2=1.585
cc_153 ( N_noxref_3_M0_noxref_d N_A_c_291_n ) capacitor c=0.00219619f //x=1.48 \
 //y=1.085 //x2=1.935 //y2=1.085
cc_154 ( N_noxref_3_c_155_n N_A_c_293_n ) capacitor c=0.00431513f //x=2.555 \
 //y=1.835 //x2=1.935 //y2=1.43
cc_155 ( N_noxref_3_M0_noxref_d N_A_c_293_n ) capacitor c=0.00603828f //x=1.48 \
 //y=1.085 //x2=1.935 //y2=1.43
cc_156 ( N_noxref_3_c_164_n N_B_c_362_n ) capacitor c=0.0102183f //x=3.08 \
 //y=3.51 //x2=2.34 //y2=4.72
cc_157 ( N_noxref_3_c_153_n N_B_c_349_n ) capacitor c=0.00717888f //x=3.195 \
 //y=3.51 //x2=2.34 //y2=2.26
cc_158 ( N_noxref_3_c_155_n N_B_c_349_n ) capacitor c=0.0162392f //x=2.555 \
 //y=1.835 //x2=2.34 //y2=2.26
cc_159 ( N_noxref_3_c_164_n N_B_c_349_n ) capacitor c=0.0815617f //x=3.08 \
 //y=3.51 //x2=2.34 //y2=2.26
cc_160 ( N_noxref_3_c_165_n N_B_c_349_n ) capacitor c=0.00126776f //x=4.56 \
 //y=2.265 //x2=2.34 //y2=2.26
cc_161 ( N_noxref_3_c_196_n N_B_M5_noxref_g ) capacitor c=0.0132788f //x=2.685 \
 //y=5.39 //x2=2.38 //y2=6.205
cc_162 ( N_noxref_3_c_194_n N_B_M6_noxref_g ) capacitor c=0.0217686f //x=2.995 \
 //y=5.39 //x2=2.82 //y2=6.205
cc_163 ( N_noxref_3_M5_noxref_d N_B_M6_noxref_g ) capacitor c=0.0136385f \
 //x=2.455 //y=5.205 //x2=2.82 //y2=6.205
cc_164 ( N_noxref_3_M1_noxref_d N_B_c_351_n ) capacitor c=0.00226395f //x=2.45 \
 //y=1.085 //x2=2.375 //y2=1.085
cc_165 ( N_noxref_3_M1_noxref_d N_B_c_371_n ) capacitor c=0.0035101f //x=2.45 \
 //y=1.085 //x2=2.375 //y2=1.435
cc_166 ( N_noxref_3_c_155_n N_B_c_372_n ) capacitor c=0.00218915f //x=2.555 \
 //y=1.835 //x2=2.375 //y2=1.74
cc_167 ( N_noxref_3_M0_noxref_d N_B_c_372_n ) capacitor c=0.00148728f //x=1.48 \
 //y=1.085 //x2=2.375 //y2=1.74
cc_168 ( N_noxref_3_M1_noxref_d N_B_c_372_n ) capacitor c=0.00546704f //x=2.45 \
 //y=1.085 //x2=2.375 //y2=1.74
cc_169 ( N_noxref_3_c_196_n N_B_c_375_n ) capacitor c=0.00410596f //x=2.685 \
 //y=5.39 //x2=2.745 //y2=4.975
cc_170 ( N_noxref_3_c_164_n N_B_c_375_n ) capacitor c=0.0144455f //x=3.08 \
 //y=3.51 //x2=2.745 //y2=4.975
cc_171 ( N_noxref_3_M1_noxref_d N_B_c_353_n ) capacitor c=0.00241102f //x=2.45 \
 //y=1.085 //x2=2.75 //y2=0.93
cc_172 ( N_noxref_3_c_159_n N_B_c_354_n ) capacitor c=0.00801563f //x=2.995 \
 //y=1.835 //x2=2.75 //y2=1.585
cc_173 ( N_noxref_3_M1_noxref_d N_B_c_354_n ) capacitor c=0.0158021f //x=2.45 \
 //y=1.085 //x2=2.75 //y2=1.585
cc_174 ( N_noxref_3_M1_noxref_d N_B_c_355_n ) capacitor c=0.00132831f //x=2.45 \
 //y=1.085 //x2=2.905 //y2=1.085
cc_175 ( N_noxref_3_M1_noxref_d N_B_c_381_n ) capacitor c=0.0035101f //x=2.45 \
 //y=1.085 //x2=2.905 //y2=1.435
cc_176 ( N_noxref_3_c_155_n N_B_c_382_n ) capacitor c=0.00633758f //x=2.555 \
 //y=1.835 //x2=2.34 //y2=2.26
cc_177 ( N_noxref_3_c_164_n N_B_c_382_n ) capacitor c=0.00877984f //x=3.08 \
 //y=3.51 //x2=2.34 //y2=2.26
cc_178 ( N_noxref_3_c_155_n N_B_c_384_n ) capacitor c=0.0189958f //x=2.555 \
 //y=1.835 //x2=2.34 //y2=2.095
cc_179 ( N_noxref_3_c_164_n N_B_c_384_n ) capacitor c=0.00306024f //x=3.08 \
 //y=3.51 //x2=2.34 //y2=2.095
cc_180 ( N_noxref_3_M1_noxref_d N_B_c_384_n ) capacitor c=3.4952e-19 //x=2.45 \
 //y=1.085 //x2=2.34 //y2=2.095
cc_181 ( N_noxref_3_c_164_n N_B_c_387_n ) capacitor c=0.00537091f //x=3.08 \
 //y=3.51 //x2=2.375 //y2=4.885
cc_182 ( N_noxref_3_c_196_n N_noxref_6_c_418_n ) capacitor c=0.0348754f \
 //x=2.685 //y=5.39 //x2=2.075 //y2=5.39
cc_183 ( N_noxref_3_c_194_n N_noxref_6_c_424_n ) capacitor c=0.00173777f \
 //x=2.995 //y=5.39 //x2=2.955 //y2=7.09
cc_184 ( N_noxref_3_M5_noxref_d N_noxref_6_c_424_n ) capacitor c=0.0118172f \
 //x=2.455 //y=5.205 //x2=2.955 //y2=7.09
cc_185 ( N_noxref_3_M5_noxref_d N_noxref_6_M3_noxref_s ) capacitor \
 c=0.00107541f //x=2.455 //y=5.205 //x2=1.145 //y2=5.205
cc_186 ( N_noxref_3_M5_noxref_d N_noxref_6_M4_noxref_d ) capacitor \
 c=0.0348754f //x=2.455 //y=5.205 //x2=2.015 //y2=5.205
cc_187 ( N_noxref_3_c_194_n N_noxref_6_M6_noxref_d ) capacitor c=0.015774f \
 //x=2.995 //y=5.39 //x2=2.895 //y2=5.205
cc_188 ( N_noxref_3_M5_noxref_d N_noxref_6_M6_noxref_d ) capacitor \
 c=0.0458293f //x=2.455 //y=5.205 //x2=2.895 //y2=5.205
cc_189 ( N_noxref_3_c_147_n Y ) capacitor c=0.00582634f //x=4.445 //y=3.51 \
 //x2=5.3 //y2=2.4
cc_190 ( N_noxref_3_c_164_n Y ) capacitor c=0.00126776f //x=3.08 //y=3.51 \
 //x2=5.3 //y2=2.4
cc_191 ( N_noxref_3_c_165_n Y ) capacitor c=0.0711303f //x=4.56 //y=2.265 \
 //x2=5.3 //y2=2.4
cc_192 ( N_noxref_3_c_177_n Y ) capacitor c=8.49451e-19 //x=4.56 //y=2.265 \
 //x2=5.3 //y2=2.4
cc_193 ( N_noxref_3_c_263_p N_Y_c_460_n ) capacitor c=0.0023507f //x=5.045 \
 //y=1.59 //x2=5.215 //y2=2.26
cc_194 ( N_noxref_3_c_177_n N_Y_c_484_n ) capacitor c=0.0167852f //x=4.56 \
 //y=2.265 //x2=5.015 //y2=2.26
cc_195 ( N_noxref_3_c_208_n N_Y_c_470_n ) capacitor c=0.0101013f //x=5.08 \
 //y=4.97 //x2=5.215 //y2=4.76
cc_196 ( N_noxref_3_c_165_n N_Y_c_473_n ) capacitor c=0.0250878f //x=4.56 \
 //y=2.265 //x2=5.02 //y2=4.76
cc_197 ( N_noxref_3_c_209_n N_Y_c_473_n ) capacitor c=0.00962086f //x=4.79 \
 //y=4.97 //x2=5.02 //y2=4.76
cc_198 ( N_noxref_3_c_164_n N_Y_M2_noxref_d ) capacitor c=3.35192e-19 //x=3.08 \
 //y=3.51 //x2=4.745 //y2=1.09
cc_199 ( N_noxref_3_c_165_n N_Y_M2_noxref_d ) capacitor c=0.0175773f //x=4.56 \
 //y=2.265 //x2=4.745 //y2=1.09
cc_200 ( N_noxref_3_c_170_n N_Y_M2_noxref_d ) capacitor c=0.00218556f //x=4.67 \
 //y=1.09 //x2=4.745 //y2=1.09
cc_201 ( N_noxref_3_c_271_p N_Y_M2_noxref_d ) capacitor c=0.00347355f //x=4.67 \
 //y=1.435 //x2=4.745 //y2=1.09
cc_202 ( N_noxref_3_c_272_p N_Y_M2_noxref_d ) capacitor c=0.00742431f //x=4.67 \
 //y=1.745 //x2=4.745 //y2=1.09
cc_203 ( N_noxref_3_c_172_n N_Y_M2_noxref_d ) capacitor c=0.00957707f //x=4.67 \
 //y=2.1 //x2=4.745 //y2=1.09
cc_204 ( N_noxref_3_c_173_n N_Y_M2_noxref_d ) capacitor c=0.00220879f \
 //x=5.045 //y=0.935 //x2=4.745 //y2=1.09
cc_205 ( N_noxref_3_c_263_p N_Y_M2_noxref_d ) capacitor c=0.0138447f //x=5.045 \
 //y=1.59 //x2=4.745 //y2=1.09
cc_206 ( N_noxref_3_c_174_n N_Y_M2_noxref_d ) capacitor c=0.00218624f //x=5.2 \
 //y=1.09 //x2=4.745 //y2=1.09
cc_207 ( N_noxref_3_c_176_n N_Y_M2_noxref_d ) capacitor c=0.00601286f //x=5.2 \
 //y=1.435 //x2=4.745 //y2=1.09
cc_208 ( N_noxref_3_c_164_n N_Y_M7_noxref_d ) capacitor c=6.2839e-19 //x=3.08 \
 //y=3.51 //x2=4.79 //y2=5.2
cc_209 ( N_noxref_3_M7_noxref_g N_Y_M7_noxref_d ) capacitor c=0.0219309f \
 //x=4.715 //y=6.2 //x2=4.79 //y2=5.2
cc_210 ( N_noxref_3_M8_noxref_g N_Y_M7_noxref_d ) capacitor c=0.021902f \
 //x=5.155 //y=6.2 //x2=4.79 //y2=5.2
cc_211 ( N_noxref_3_c_208_n N_Y_M7_noxref_d ) capacitor c=0.0148755f //x=5.08 \
 //y=4.97 //x2=4.79 //y2=5.2
cc_212 ( N_noxref_3_c_209_n N_Y_M7_noxref_d ) capacitor c=0.00307344f //x=4.79 \
 //y=4.97 //x2=4.79 //y2=5.2
cc_213 ( N_A_c_295_n N_B_c_362_n ) capacitor c=0.0480335f //x=1.445 //y=4.885 \
 //x2=2.34 //y2=4.72
cc_214 ( N_A_c_317_p N_B_c_362_n ) capacitor c=0.00146509f //x=1.865 //y=4.975 \
 //x2=2.34 //y2=4.72
cc_215 ( N_A_c_303_n N_B_c_362_n ) capacitor c=0.00112871f //x=1.445 //y=4.885 \
 //x2=2.34 //y2=4.72
cc_216 ( N_A_c_283_n N_B_c_349_n ) capacitor c=0.0452884f //x=1.6 //y=2.26 \
 //x2=2.34 //y2=2.26
cc_217 ( N_A_c_288_n N_B_c_349_n ) capacitor c=0.00308814f //x=1.405 //y=2.095 \
 //x2=2.34 //y2=2.26
cc_218 ( N_A_M3_noxref_g N_B_M5_noxref_g ) capacitor c=0.0100243f //x=1.5 \
 //y=6.205 //x2=2.38 //y2=6.205
cc_219 ( N_A_M4_noxref_g N_B_M5_noxref_g ) capacitor c=0.107798f //x=1.94 \
 //y=6.205 //x2=2.38 //y2=6.205
cc_220 ( N_A_M4_noxref_g N_B_M6_noxref_g ) capacitor c=0.0094155f //x=1.94 \
 //y=6.205 //x2=2.82 //y2=6.205
cc_221 ( N_A_c_286_n N_B_c_351_n ) capacitor c=0.00125788f //x=1.405 //y=1.085 \
 //x2=2.375 //y2=1.085
cc_222 ( N_A_c_291_n N_B_c_351_n ) capacitor c=0.0126654f //x=1.935 //y=1.085 \
 //x2=2.375 //y2=1.085
cc_223 ( N_A_c_307_n N_B_c_371_n ) capacitor c=0.00148539f //x=1.405 //y=1.43 \
 //x2=2.375 //y2=1.435
cc_224 ( N_A_c_308_n N_B_c_371_n ) capacitor c=0.00105591f //x=1.405 //y=1.74 \
 //x2=2.375 //y2=1.435
cc_225 ( N_A_c_293_n N_B_c_371_n ) capacitor c=0.0126654f //x=1.935 //y=1.43 \
 //x2=2.375 //y2=1.435
cc_226 ( N_A_c_308_n N_B_c_372_n ) capacitor c=0.00109549f //x=1.405 //y=1.74 \
 //x2=2.375 //y2=1.74
cc_227 ( N_A_c_293_n N_B_c_372_n ) capacitor c=0.00886999f //x=1.935 //y=1.43 \
 //x2=2.375 //y2=1.74
cc_228 ( N_A_c_293_n N_B_c_354_n ) capacitor c=0.00123863f //x=1.935 //y=1.43 \
 //x2=2.75 //y2=1.585
cc_229 ( N_A_c_291_n N_B_c_355_n ) capacitor c=0.00132934f //x=1.935 //y=1.085 \
 //x2=2.905 //y2=1.085
cc_230 ( N_A_c_293_n N_B_c_381_n ) capacitor c=0.00150734f //x=1.935 //y=1.43 \
 //x2=2.905 //y2=1.435
cc_231 ( N_A_c_283_n N_B_c_382_n ) capacitor c=0.00307062f //x=1.6 //y=2.26 \
 //x2=2.34 //y2=2.26
cc_232 ( N_A_c_288_n N_B_c_382_n ) capacitor c=0.0179092f //x=1.405 //y=2.095 \
 //x2=2.34 //y2=2.26
cc_233 ( N_A_c_288_n N_B_c_384_n ) capacitor c=0.00577193f //x=1.405 //y=2.095 \
 //x2=2.34 //y2=2.095
cc_234 ( N_A_c_295_n N_B_c_387_n ) capacitor c=0.00336963f //x=1.445 //y=4.885 \
 //x2=2.375 //y2=4.885
cc_235 ( N_A_c_317_p N_B_c_387_n ) capacitor c=0.020271f //x=1.865 //y=4.975 \
 //x2=2.375 //y2=4.885
cc_236 ( N_A_c_303_n N_B_c_387_n ) capacitor c=0.00546725f //x=1.445 //y=4.885 \
 //x2=2.375 //y2=4.885
cc_237 ( N_A_c_295_n N_noxref_6_c_418_n ) capacitor c=0.00628365f //x=1.445 \
 //y=4.885 //x2=2.075 //y2=5.39
cc_238 ( N_A_M3_noxref_g N_noxref_6_c_418_n ) capacitor c=0.0182391f //x=1.5 \
 //y=6.205 //x2=2.075 //y2=5.39
cc_239 ( N_A_M4_noxref_g N_noxref_6_c_418_n ) capacitor c=0.0203804f //x=1.94 \
 //y=6.205 //x2=2.075 //y2=5.39
cc_240 ( N_A_c_317_p N_noxref_6_c_418_n ) capacitor c=0.00343485f //x=1.865 \
 //y=4.975 //x2=2.075 //y2=5.39
cc_241 ( N_A_c_303_n N_noxref_6_c_418_n ) capacitor c=0.0017421f //x=1.445 \
 //y=4.885 //x2=2.075 //y2=5.39
cc_242 ( N_A_c_295_n N_noxref_6_c_423_n ) capacitor c=0.0120346f //x=1.445 \
 //y=4.885 //x2=1.365 //y2=5.39
cc_243 ( N_A_c_303_n N_noxref_6_c_423_n ) capacitor c=0.00518332f //x=1.445 \
 //y=4.885 //x2=1.365 //y2=5.39
cc_244 ( N_A_M3_noxref_g N_noxref_6_M3_noxref_s ) capacitor c=0.0473218f \
 //x=1.5 //y=6.205 //x2=1.145 //y2=5.205
cc_245 ( N_A_M4_noxref_g N_noxref_6_M4_noxref_d ) capacitor c=0.0170604f \
 //x=1.94 //y=6.205 //x2=2.015 //y2=5.205
cc_246 ( N_B_M5_noxref_g N_noxref_6_c_418_n ) capacitor c=0.0170604f //x=2.38 \
 //y=6.205 //x2=2.075 //y2=5.39
cc_247 ( N_B_c_387_n N_noxref_6_c_418_n ) capacitor c=2.24869e-19 //x=2.375 \
 //y=4.885 //x2=2.075 //y2=5.39
cc_248 ( N_B_c_362_n N_noxref_6_c_424_n ) capacitor c=8.92402e-19 //x=2.34 \
 //y=4.72 //x2=2.955 //y2=7.09
cc_249 ( N_B_M5_noxref_g N_noxref_6_c_424_n ) capacitor c=0.0148484f //x=2.38 \
 //y=6.205 //x2=2.955 //y2=7.09
cc_250 ( N_B_M6_noxref_g N_noxref_6_c_424_n ) capacitor c=0.0163196f //x=2.82 \
 //y=6.205 //x2=2.955 //y2=7.09
cc_251 ( N_B_M6_noxref_g N_noxref_6_M6_noxref_d ) capacitor c=0.0351101f \
 //x=2.82 //y=6.205 //x2=2.895 //y2=5.205
