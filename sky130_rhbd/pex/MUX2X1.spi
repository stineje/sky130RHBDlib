// File: MUX2X1.spi
// Created: Fri Feb 20 10:13:21 2026
// Program "Calibre xRC"
// Version "v2023.2_27.15"
//
simulator lang=spectre
include "/import/yukari1/lrburle/sky130RHBDlib/calibre/sky130_rhbd_output/spice/MUX2X1.pex.spice"
subckt MUX2X1 (  S VDD A0 A1 GND Y )
//
// Y	Y
// GND	GND
// A1	A1
// A0	A0
// VDD	VDD
// S	S
M0_noxref ( N_noxref_2_M0_noxref_d N_S_M0_noxref_g N_GND_M0_noxref_s \
 noxref_143 ) NMOS l=0.163346 w=2.31104 m=1
M1_noxref ( N_GND_M1_noxref_d N_S_M1_noxref_g N_noxref_10_M1_noxref_s \
 noxref_143 ) NMOS l=0.163119 w=2.35104 m=1
M2_noxref ( N_noxref_3_M2_noxref_d N_A0_M2_noxref_g N_noxref_10_M1_noxref_s \
 noxref_143 ) NMOS l=0.163346 w=2.31104 m=1
M3_noxref ( N_GND_M3_noxref_d N_noxref_2_M3_noxref_g N_noxref_11_M3_noxref_s \
 noxref_143 ) NMOS l=0.163119 w=2.35104 m=1
M4_noxref ( N_noxref_4_M4_noxref_d N_A1_M4_noxref_g N_noxref_11_M3_noxref_s \
 noxref_143 ) NMOS l=0.163346 w=2.31104 m=1
M5_noxref ( N_GND_M5_noxref_d N_noxref_3_M5_noxref_g N_noxref_12_M5_noxref_s \
 noxref_143 ) NMOS l=0.163119 w=2.35104 m=1
M6_noxref ( N_Y_M6_noxref_d N_noxref_4_M6_noxref_g N_noxref_12_M5_noxref_s \
 noxref_143 ) NMOS l=0.163346 w=2.31104 m=1
M7_noxref ( N_noxref_2_M7_noxref_d N_S_M7_noxref_g N_VDD_M7_noxref_s \
 noxref_141 ) PMOS l=0.15 w=2 ad=0.57 as=0.57 pd=2.57 ps=2.57 nrd=0 nrs=0 m=1
M8_noxref ( N_VDD_M8_noxref_d N_S_M8_noxref_g N_noxref_2_M7_noxref_d \
 noxref_141 ) PMOS l=0.15 w=2 ad=0.56 as=0.56 pd=2.56 ps=2.56 nrd=0 nrs=0 m=1
M9_noxref ( N_noxref_3_M9_noxref_d N_S_M9_noxref_g N_VDD_M9_noxref_s \
 noxref_141 ) PMOS l=0.15 w=2 ad=0.57 as=0.57 pd=2.57 ps=2.57 nrd=0 nrs=0 m=1
M10_noxref ( N_VDD_M10_noxref_d N_S_M10_noxref_g N_noxref_3_M9_noxref_d \
 noxref_141 ) PMOS l=0.15 w=2 ad=0.58 as=0.58 pd=2.58 ps=2.58 nrd=0 nrs=0 m=1
M11_noxref ( N_noxref_3_M11_noxref_d N_A0_M11_noxref_g N_VDD_M10_noxref_d \
 noxref_141 ) PMOS l=0.15 w=2 ad=0.58 as=0.58 pd=2.58 ps=2.58 nrd=0 nrs=0 m=1
M12_noxref ( N_VDD_M12_noxref_d N_A0_M12_noxref_g N_noxref_3_M11_noxref_d \
 noxref_141 ) PMOS l=0.15 w=2 ad=0.56 as=0.56 pd=2.56 ps=2.56 nrd=0 nrs=0 m=1
M13_noxref ( N_noxref_4_M13_noxref_d N_noxref_2_M13_noxref_g \
 N_VDD_M13_noxref_s noxref_141 ) PMOS l=0.15 w=2 ad=0.57 as=0.57 pd=2.57 \
 ps=2.57 nrd=0 nrs=0 m=1
M14_noxref ( N_VDD_M14_noxref_d N_noxref_2_M14_noxref_g \
 N_noxref_4_M13_noxref_d noxref_141 ) PMOS l=0.15 w=2 ad=0.58 as=0.58 pd=2.58 \
 ps=2.58 nrd=0 nrs=0 m=1
M15_noxref ( N_noxref_4_M15_noxref_d N_A1_M15_noxref_g N_VDD_M14_noxref_d \
 noxref_141 ) PMOS l=0.15 w=2 ad=0.58 as=0.58 pd=2.58 ps=2.58 nrd=0 nrs=0 m=1
M16_noxref ( N_VDD_M16_noxref_d N_A1_M16_noxref_g N_noxref_4_M15_noxref_d \
 noxref_141 ) PMOS l=0.15 w=2 ad=0.56 as=0.56 pd=2.56 ps=2.56 nrd=0 nrs=0 m=1
M17_noxref ( N_Y_M17_noxref_d N_noxref_3_M17_noxref_g N_VDD_M17_noxref_s \
 noxref_141 ) PMOS l=0.15 w=2 ad=0.57 as=0.57 pd=2.57 ps=2.57 nrd=0 nrs=0 m=1
M18_noxref ( N_VDD_M18_noxref_d N_noxref_3_M18_noxref_g N_Y_M17_noxref_d \
 noxref_141 ) PMOS l=0.15 w=2 ad=0.58 as=0.58 pd=2.58 ps=2.58 nrd=0 nrs=0 m=1
M19_noxref ( N_Y_M19_noxref_d N_noxref_4_M19_noxref_g N_VDD_M18_noxref_d \
 noxref_141 ) PMOS l=0.15 w=2 ad=0.58 as=0.58 pd=2.58 ps=2.58 nrd=0 nrs=0 m=1
M20_noxref ( N_VDD_M20_noxref_d N_noxref_4_M20_noxref_g N_Y_M19_noxref_d \
 noxref_141 ) PMOS l=0.15 w=2 ad=0.56 as=0.56 pd=2.56 ps=2.56 nrd=0 nrs=0 m=1
//
include "/import/yukari1/lrburle/sky130RHBDlib/calibre/sky130_rhbd_output/spice/MUX2X1.pxi.spice"
//
ends MUX2X1
//
//
