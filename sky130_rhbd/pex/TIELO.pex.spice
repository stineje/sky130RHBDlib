// File: TIELO.spi.pex
// Created: Tue Apr 29 10:44:39 2025
// Program "Calibre xRC"
// Version "v2023.2_27.15"
// Nominal Temperature: 30C
// Circuit Temperature: 30C
//
simulator lang=spectre
subckt PM_TIELO\%GND ( 1 7 19 23 35 41 48 )
c21 ( 48 0 ) capacitor c=0.0630825f //x=0.985 //y=0.545
c22 ( 41 0 ) capacitor c=0.25682f //x=2.09 //y=0.175
c23 ( 35 0 ) capacitor c=0.21181f //x=1.12 //y=0.175
c24 ( 26 0 ) capacitor c=0.00576908f //x=2.09 //y=0.625
c25 ( 23 0 ) capacitor c=0.00782031f //x=2.005 //y=0.71
c26 ( 22 0 ) capacitor c=0.00468229f //x=1.6 //y=0.625
c27 ( 19 0 ) capacitor c=0.00697428f //x=1.515 //y=0.71
c28 ( 14 0 ) capacitor c=0.00578481f //x=1.12 //y=0.625
c29 ( 7 0 ) capacitor c=0.145824f //x=1.97 //y=0.18
r30 (  40 41 ) resistor r=4.18529 //w=0.367 //l=0.12 //layer=li \
 //thickness=0.1 //x=1.97 //y=0.175 //x2=2.09 //y2=0.175
r31 (  38 40 ) resistor r=12.9046 //w=0.367 //l=0.37 //layer=li \
 //thickness=0.1 //x=1.6 //y=0.175 //x2=1.97 //y2=0.175
r32 (  37 38 ) resistor r=12.9046 //w=0.367 //l=0.37 //layer=li \
 //thickness=0.1 //x=1.23 //y=0.175 //x2=1.6 //y2=0.175
r33 (  35 37 ) resistor r=3.83651 //w=0.367 //l=0.11 //layer=li \
 //thickness=0.1 //x=1.12 //y=0.175 //x2=1.23 //y2=0.175
r34 (  27 48 ) resistor r=5.4201 //w=0.17 //l=0.085 //layer=li //thickness=0.1 \
 //x=2.09 //y=0.795 //x2=2.09 //y2=0.71
r35 (  27 48 ) resistor r=41.4118 //w=0.187 //l=0.605 //layer=li \
 //thickness=0.1 //x=2.09 //y=0.795 //x2=2.09 //y2=1.4
r36 (  26 48 ) resistor r=5.4201 //w=0.17 //l=0.085 //layer=li //thickness=0.1 \
 //x=2.09 //y=0.625 //x2=2.09 //y2=0.71
r37 (  25 41 ) resistor r=5.21862 //w=0.35 //l=0.175 //layer=li \
 //thickness=0.1 //x=2.09 //y=0.35 //x2=2.09 //y2=0.175
r38 (  25 26 ) resistor r=18.8235 //w=0.187 //l=0.275 //layer=li \
 //thickness=0.1 //x=2.09 //y=0.35 //x2=2.09 //y2=0.625
r39 (  24 48 ) resistor r=5.4201 //w=0.17 //l=0.085 //layer=li //thickness=0.1 \
 //x=1.685 //y=0.71 //x2=1.6 //y2=0.71
r40 (  23 48 ) resistor r=1.40859 //w=0.34 //l=0.085 //layer=li \
 //thickness=0.1 //x=2.005 //y=0.71 //x2=2.09 //y2=0.71
r41 (  23 24 ) resistor r=21.9037 //w=0.187 //l=0.32 //layer=li \
 //thickness=0.1 //x=2.005 //y=0.71 //x2=1.685 //y2=0.71
r42 (  22 48 ) resistor r=1.40859 //w=0.34 //l=0.085 //layer=li \
 //thickness=0.1 //x=1.6 //y=0.625 //x2=1.6 //y2=0.71
r43 (  21 38 ) resistor r=5.21862 //w=0.35 //l=0.175 //layer=li \
 //thickness=0.1 //x=1.6 //y=0.35 //x2=1.6 //y2=0.175
r44 (  21 22 ) resistor r=18.8235 //w=0.187 //l=0.275 //layer=li \
 //thickness=0.1 //x=1.6 //y=0.35 //x2=1.6 //y2=0.625
r45 (  20 48 ) resistor r=1.40859 //w=0.34 //l=0.085 //layer=li \
 //thickness=0.1 //x=1.205 //y=0.71 //x2=1.12 //y2=0.71
r46 (  19 48 ) resistor r=5.4201 //w=0.17 //l=0.085 //layer=li //thickness=0.1 \
 //x=1.515 //y=0.71 //x2=1.6 //y2=0.71
r47 (  19 20 ) resistor r=21.2193 //w=0.187 //l=0.31 //layer=li \
 //thickness=0.1 //x=1.515 //y=0.71 //x2=1.205 //y2=0.71
r48 (  15 48 ) resistor r=5.4201 //w=0.17 //l=0.085 //layer=li //thickness=0.1 \
 //x=1.12 //y=0.795 //x2=1.12 //y2=0.71
r49 (  15 48 ) resistor r=41.4118 //w=0.187 //l=0.605 //layer=li \
 //thickness=0.1 //x=1.12 //y=0.795 //x2=1.12 //y2=1.4
r50 (  14 48 ) resistor r=5.4201 //w=0.17 //l=0.085 //layer=li //thickness=0.1 \
 //x=1.12 //y=0.625 //x2=1.12 //y2=0.71
r51 (  13 35 ) resistor r=5.21862 //w=0.35 //l=0.175 //layer=li \
 //thickness=0.1 //x=1.12 //y=0.35 //x2=1.12 //y2=0.175
r52 (  13 14 ) resistor r=18.8235 //w=0.187 //l=0.275 //layer=li \
 //thickness=0.1 //x=1.12 //y=0.35 //x2=1.12 //y2=0.625
r53 (  7 40 ) resistor r=4.65 //w=0.17 //l=0.34 //layer=mcon //count=2 \
 //x=1.97 //y=0.18 //x2=1.97 //y2=0.18
r54 (  3 37 ) resistor r=3.1 //w=0.17 //l=0.51 //layer=mcon //count=3 //x=1.23 \
 //y=0.18 //x2=1.23 //y2=0.18
r55 (  1 7 ) resistor r=0.148714 //w=0.311 //l=0.37 //layer=m1 \
 //thickness=0.36 //x=1.6 //y=0.175 //x2=1.97 //y2=0.175
r56 (  1 3 ) resistor r=0.148714 //w=0.311 //l=0.37 //layer=m1 \
 //thickness=0.36 //x=1.6 //y=0.175 //x2=1.23 //y2=0.175
ends PM_TIELO\%GND

subckt PM_TIELO\%VDD ( 1 7 19 32 34 35 36 )
c22 ( 36 0 ) capacitor c=0.0502404f //x=1.895 //y=5.2
c23 ( 35 0 ) capacitor c=0.0446712f //x=1.025 //y=5.2
c24 ( 34 0 ) capacitor c=0.25844f //x=1.97 //y=7.58
c25 ( 32 0 ) capacitor c=0.251657f //x=1.23 //y=7.58
c26 ( 19 0 ) capacitor c=0.0291283f //x=1.955 //y=7.585
c27 ( 7 0 ) capacitor c=0.14636f //x=1.97 //y=7.58
r28 (  21 34 ) resistor r=4.23183 //w=0.7 //l=0.175 //layer=li //thickness=0.1 \
 //x=2.04 //y=7.41 //x2=2.04 //y2=7.585
r29 (  21 36 ) resistor r=56.4706 //w=0.187 //l=0.825 //layer=li \
 //thickness=0.1 //x=2.04 //y=7.41 //x2=2.04 //y2=6.585
r30 (  20 32 ) resistor r=2.87058 //w=0.35 //l=0.085 //layer=li \
 //thickness=0.1 //x=1.245 //y=7.585 //x2=1.16 //y2=7.585
r31 (  19 34 ) resistor r=2.87058 //w=0.35 //l=0.085 //layer=li \
 //thickness=0.1 //x=1.955 //y=7.585 //x2=2.04 //y2=7.585
r32 (  19 20 ) resistor r=24.7629 //w=0.367 //l=0.71 //layer=li \
 //thickness=0.1 //x=1.955 //y=7.585 //x2=1.245 //y2=7.585
r33 (  13 32 ) resistor r=4.23183 //w=0.7 //l=0.175 //layer=li //thickness=0.1 \
 //x=1.16 //y=7.41 //x2=1.16 //y2=7.585
r34 (  13 35 ) resistor r=56.4706 //w=0.187 //l=0.825 //layer=li \
 //thickness=0.1 //x=1.16 //y=7.41 //x2=1.16 //y2=6.585
r35 (  7 34 ) resistor r=4.65 //w=0.17 //l=0.34 //layer=mcon //count=2 \
 //x=1.97 //y=7.58 //x2=1.97 //y2=7.58
r36 (  3 32 ) resistor r=3.1 //w=0.17 //l=0.51 //layer=mcon //count=3 //x=1.23 \
 //y=7.58 //x2=1.23 //y2=7.58
r37 (  1 7 ) resistor r=0.148714 //w=0.311 //l=0.37 //layer=m1 \
 //thickness=0.36 //x=1.6 //y=7.585 //x2=1.97 //y2=7.585
r38 (  1 3 ) resistor r=0.148714 //w=0.311 //l=0.37 //layer=m1 \
 //thickness=0.36 //x=1.6 //y=7.585 //x2=1.23 //y2=7.585
ends PM_TIELO\%VDD

subckt PM_TIELO\%YN ( 1 2 3 11 )
c15 ( 11 0 ) capacitor c=0.0602601f //x=1.415 //y=1.085
r16 (  2 3 ) resistor r=25.3262 //w=0.187 //l=0.37 //layer=li //thickness=0.1 \
 //x=1.6 //y=2.77 //x2=1.6 //y2=3.14
r17 (  1 2 ) resistor r=25.3262 //w=0.187 //l=0.37 //layer=li //thickness=0.1 \
 //x=1.6 //y=2.4 //x2=1.6 //y2=2.77
r18 (  1 11 ) resistor r=83.508 //w=0.187 //l=1.22 //layer=li //thickness=0.1 \
 //x=1.6 //y=2.4 //x2=1.6 //y2=1.18
ends PM_TIELO\%YN

subckt PM_TIELO\%noxref_4 ( 1 3 5 15 16 17 18 19 20 21 25 26 27 29 35 36 38 46 )
c46 ( 46 0 ) capacitor c=0.0267071f //x=1.455 //y=5.2
c47 ( 38 0 ) capacitor c=0.0528519f //x=1.23 //y=2.26
c48 ( 36 0 ) capacitor c=0.0450427f //x=1.87 //y=1.43
c49 ( 35 0 ) capacitor c=0.0200386f //x=1.87 //y=1.085
c50 ( 29 0 ) capacitor c=0.0155406f //x=1.715 //y=1.585
c51 ( 27 0 ) capacitor c=0.0157804f //x=1.715 //y=0.93
c52 ( 26 0 ) capacitor c=0.0524209f //x=1.455 //y=4.97
c53 ( 25 0 ) capacitor c=0.0362815f //x=1.745 //y=4.97
c54 ( 21 0 ) capacitor c=0.0290017f //x=1.34 //y=2.095
c55 ( 20 0 ) capacitor c=0.0250027f //x=1.34 //y=1.74
c56 ( 19 0 ) capacitor c=0.0234316f //x=1.34 //y=1.43
c57 ( 18 0 ) capacitor c=0.0200596f //x=1.34 //y=1.085
c58 ( 17 0 ) capacitor c=0.153902f //x=1.82 //y=6.2
c59 ( 16 0 ) capacitor c=0.153904f //x=1.38 //y=6.2
c60 ( 5 0 ) capacitor c=0.0128331f //x=1.515 //y=4.88
c61 ( 3 0 ) capacitor c=0.131408f //x=1.23 //y=2.26
c62 ( 1 0 ) capacitor c=0.00389662f //x=1.23 //y=4.795
r63 (  38 39 ) resistor r=17.5563 //w=0.302 //l=0.11 //layer=ply \
 //thickness=0.18 //x=1.23 //y=2.26 //x2=1.34 //y2=2.26
r64 (  36 45 ) resistor r=45.1352 //w=0.168 //l=0.173853 //layer=ply \
 //thickness=0.18 //x=1.87 //y=1.43 //x2=1.83 //y2=1.585
r65 (  35 44 ) resistor r=45.1352 //w=0.168 //l=0.173853 //layer=ply \
 //thickness=0.18 //x=1.87 //y=1.085 //x2=1.83 //y2=0.93
r66 (  35 36 ) resistor r=176.904 //w=0.094 //l=0.345 //layer=ply \
 //thickness=0.18 //x=1.87 //y=1.085 //x2=1.87 //y2=1.43
r67 (  30 43 ) resistor r=10.701 //w=0.21 //l=0.115 //layer=ply \
 //thickness=0.18 //x=1.495 //y=1.585 //x2=1.38 //y2=1.585
r68 (  29 45 ) resistor r=5.52526 //w=0.168 //l=0.115 //layer=ply \
 //thickness=0.18 //x=1.715 //y=1.585 //x2=1.83 //y2=1.585
r69 (  28 42 ) resistor r=5.52526 //w=0.168 //l=0.115 //layer=ply \
 //thickness=0.18 //x=1.495 //y=0.93 //x2=1.38 //y2=0.93
r70 (  27 44 ) resistor r=5.52526 //w=0.168 //l=0.115 //layer=ply \
 //thickness=0.18 //x=1.715 //y=0.93 //x2=1.83 //y2=0.93
r71 (  27 28 ) resistor r=112.809 //w=0.094 //l=0.22 //layer=ply \
 //thickness=0.18 //x=1.715 //y=0.93 //x2=1.495 //y2=0.93
r72 (  25 32 ) resistor r=26.9307 //w=0.15 //l=0.106066 //layer=ply \
 //thickness=0.18 //x=1.745 //y=4.97 //x2=1.82 //y2=5.045
r73 (  25 26 ) resistor r=148.702 //w=0.094 //l=0.29 //layer=ply \
 //thickness=0.18 //x=1.745 //y=4.97 //x2=1.455 //y2=4.97
r74 (  22 26 ) resistor r=23.4449 //w=0.285 //l=0.106066 //layer=ply \
 //thickness=0.18 //x=1.38 //y=5.045 //x2=1.455 //y2=4.97
r75 (  22 41 ) resistor r=25.3684 //w=0.285 //l=0.22798 //layer=ply \
 //thickness=0.18 //x=1.38 //y=5.045 //x2=1.23 //y2=4.88
r76 (  21 39 ) resistor r=19.1248 //w=0.302 //l=0.165 //layer=ply \
 //thickness=0.18 //x=1.34 //y=2.095 //x2=1.34 //y2=2.26
r77 (  20 43 ) resistor r=39.5823 //w=0.21 //l=0.173853 //layer=ply \
 //thickness=0.18 //x=1.34 //y=1.74 //x2=1.38 //y2=1.585
r78 (  20 21 ) resistor r=182.032 //w=0.094 //l=0.355 //layer=ply \
 //thickness=0.18 //x=1.34 //y=1.74 //x2=1.34 //y2=2.095
r79 (  19 43 ) resistor r=39.5823 //w=0.21 //l=0.173853 //layer=ply \
 //thickness=0.18 //x=1.34 //y=1.43 //x2=1.38 //y2=1.585
r80 (  18 42 ) resistor r=45.1352 //w=0.168 //l=0.173853 //layer=ply \
 //thickness=0.18 //x=1.34 //y=1.085 //x2=1.38 //y2=0.93
r81 (  18 19 ) resistor r=176.904 //w=0.094 //l=0.345 //layer=ply \
 //thickness=0.18 //x=1.34 //y=1.085 //x2=1.34 //y2=1.43
r82 (  17 32 ) resistor r=592.245 //w=0.094 //l=1.155 //layer=ply \
 //thickness=0.18 //x=1.82 //y=6.2 //x2=1.82 //y2=5.045
r83 (  16 22 ) resistor r=592.245 //w=0.094 //l=1.155 //layer=ply \
 //thickness=0.18 //x=1.38 //y=6.2 //x2=1.38 //y2=5.045
r84 (  15 29 ) resistor r=56.4043 //w=0.094 //l=0.11 //layer=ply \
 //thickness=0.18 //x=1.605 //y=1.585 //x2=1.715 //y2=1.585
r85 (  15 30 ) resistor r=56.4043 //w=0.094 //l=0.11 //layer=ply \
 //thickness=0.18 //x=1.605 //y=1.585 //x2=1.495 //y2=1.585
r86 (  14 41 ) resistor r=152 //w=0.17 //l=0.17 //layer=licon //count=1 \
 //x=1.23 //y=4.88 //x2=1.23 //y2=4.88
r87 (  7 46 ) resistor r=64.3422 //w=0.187 //l=0.94 //layer=li //thickness=0.1 \
 //x=1.6 //y=4.965 //x2=1.6 //y2=5.905
r88 (  6 14 ) resistor r=3.57586 //w=0.17 //l=0.103078 //layer=li \
 //thickness=0.1 //x=1.315 //y=4.88 //x2=1.23 //y2=4.92
r89 (  5 7 ) resistor r=7.15173 //w=0.17 //l=0.120208 //layer=li \
 //thickness=0.1 //x=1.515 //y=4.88 //x2=1.6 //y2=4.965
r90 (  5 6 ) resistor r=13.6898 //w=0.187 //l=0.2 //layer=li //thickness=0.1 \
 //x=1.515 //y=4.88 //x2=1.315 //y2=4.88
r91 (  3 38 ) resistor r=152 //w=0.17 //l=0.17 //layer=licon //count=1 \
 //x=1.23 //y=2.26 //x2=1.23 //y2=2.26
r92 (  1 14 ) resistor r=3.57586 //w=0.17 //l=0.125 //layer=li //thickness=0.1 \
 //x=1.23 //y=4.795 //x2=1.23 //y2=4.92
r93 (  1 3 ) resistor r=173.519 //w=0.187 //l=2.535 //layer=li //thickness=0.1 \
 //x=1.23 //y=4.795 //x2=1.23 //y2=2.26
ends PM_TIELO\%noxref_4
