// File: TMRDFFQX1.spi.TMRDFFQX1.pxi
// Created: Sun Mar 15 12:45:10 2026
//
simulator lang=spectre
x_PM_TMRDFFQX1\%noxref_1 ( N_noxref_1_c_56_p N_noxref_1_c_57_p \
 N_noxref_1_c_29_p N_noxref_1_c_30_p N_noxref_1_c_118_p N_noxref_1_c_2_p \
 N_noxref_1_c_8_p N_noxref_1_c_3_p N_noxref_1_c_49_p N_noxref_1_c_4_p \
 N_noxref_1_c_96_p N_noxref_1_c_6_p N_noxref_1_c_5_p N_noxref_1_c_9_p \
 N_noxref_1_c_60_p N_noxref_1_c_26_p N_noxref_1_c_10_p N_noxref_1_c_11_p \
 N_noxref_1_c_17_p N_noxref_1_c_191_p N_noxref_1_c_18_p N_noxref_1_c_147_p \
 N_noxref_1_c_12_p N_noxref_1_c_7_p N_noxref_1_c_51_p N_noxref_1_c_36_p \
 N_noxref_1_c_63_p N_noxref_1_c_75_p N_noxref_1_c_76_p N_noxref_1_c_77_p \
 N_noxref_1_c_19_p N_noxref_1_c_98_p N_noxref_1_c_64_p N_noxref_1_c_32_p \
 N_noxref_1_c_81_p N_noxref_1_c_203_p N_noxref_1_c_139_p N_noxref_1_c_13_p \
 N_noxref_1_M2_noxref_g N_noxref_1_M5_noxref_g N_noxref_1_M50_noxref_g \
 N_noxref_1_M51_noxref_g N_noxref_1_M56_noxref_g N_noxref_1_M57_noxref_g \
 N_noxref_1_c_37_p N_noxref_1_c_38_p N_noxref_1_c_45_p N_noxref_1_c_39_p \
 N_noxref_1_c_40_p N_noxref_1_c_41_p N_noxref_1_c_42_p N_noxref_1_c_171_p \
 N_noxref_1_c_172_p N_noxref_1_c_174_p N_noxref_1_c_149_p N_noxref_1_c_375_p \
 N_noxref_1_c_376_p N_noxref_1_c_173_p N_noxref_1_c_175_p N_noxref_1_c_65_p \
 N_noxref_1_c_48_p N_noxref_1_c_72_p N_noxref_1_c_16_p N_noxref_1_M4_noxref_d \
 N_noxref_1_M52_noxref_d N_noxref_1_M54_noxref_d )  PM_TMRDFFQX1\%noxref_1
x_PM_TMRDFFQX1\%noxref_2 ( N_noxref_2_c_432_n N_noxref_2_c_433_n \
 N_noxref_2_c_490_p N_noxref_2_c_482_p N_noxref_2_c_434_n N_noxref_2_c_435_n \
 N_noxref_2_c_456_p N_noxref_2_c_437_n N_noxref_2_c_471_p N_noxref_2_c_462_p \
 N_noxref_2_c_439_n N_noxref_2_c_492_p N_noxref_2_c_493_p N_noxref_2_c_448_n \
 N_noxref_2_c_449_n N_noxref_2_c_558_p N_noxref_2_c_550_p N_noxref_2_c_494_p \
 N_noxref_2_c_463_p N_noxref_2_c_461_p N_noxref_2_c_450_n N_noxref_2_c_465_p \
 N_noxref_2_c_451_n N_noxref_2_c_514_p N_noxref_2_c_561_p N_noxref_2_c_495_p \
 N_noxref_2_M7_noxref_g N_noxref_2_M60_noxref_g N_noxref_2_M61_noxref_g \
 N_noxref_2_c_586_p N_noxref_2_c_587_p N_noxref_2_c_589_p N_noxref_2_c_568_p \
 N_noxref_2_c_665_p N_noxref_2_c_666_p N_noxref_2_c_588_p N_noxref_2_c_590_p \
 N_noxref_2_c_498_p N_noxref_2_M6_noxref_d N_noxref_2_M56_noxref_d \
 N_noxref_2_M58_noxref_d )  PM_TMRDFFQX1\%noxref_2
x_PM_TMRDFFQX1\%noxref_3 ( N_noxref_3_c_891_p N_noxref_3_c_714_n \
 N_noxref_3_c_715_n N_noxref_3_c_718_n N_noxref_3_c_723_n N_noxref_3_c_732_n \
 N_noxref_3_c_738_n N_noxref_3_c_743_n N_noxref_3_c_745_n N_noxref_3_c_756_n \
 N_noxref_3_c_758_n N_noxref_3_c_762_n N_noxref_3_c_767_n N_noxref_3_c_831_p \
 N_noxref_3_c_833_p N_noxref_3_c_862_p N_noxref_3_c_964_p N_noxref_3_c_771_n \
 N_noxref_3_c_775_n N_noxref_3_c_900_p N_noxref_3_c_776_n N_noxref_3_c_777_n \
 N_noxref_3_c_779_n N_noxref_3_c_839_p N_noxref_3_c_853_p N_noxref_3_c_834_p \
 N_noxref_3_c_832_p N_noxref_3_c_781_n N_noxref_3_c_783_n N_noxref_3_c_785_n \
 N_noxref_3_c_788_n N_noxref_3_c_792_n N_noxref_3_c_796_n N_noxref_3_c_818_n \
 N_noxref_3_c_821_n N_noxref_3_c_824_n N_noxref_3_c_828_n N_noxref_3_c_890_p \
 N_noxref_3_c_961_p N_noxref_3_c_798_n N_noxref_3_c_908_p N_noxref_3_c_803_n \
 N_noxref_3_c_994_p N_noxref_3_c_835_p N_noxref_3_M3_noxref_g \
 N_noxref_3_M9_noxref_g N_noxref_3_M52_noxref_g N_noxref_3_M53_noxref_g \
 N_noxref_3_M64_noxref_g N_noxref_3_M65_noxref_g N_noxref_3_c_938_p \
 N_noxref_3_c_939_p N_noxref_3_c_941_p N_noxref_3_c_915_p N_noxref_3_c_1122_p \
 N_noxref_3_c_1123_p N_noxref_3_c_940_p N_noxref_3_c_942_p N_noxref_3_c_1019_p \
 N_noxref_3_c_1020_p N_noxref_3_c_1022_p N_noxref_3_c_1006_p \
 N_noxref_3_c_1134_p N_noxref_3_c_1135_p N_noxref_3_c_1021_p \
 N_noxref_3_c_1023_p N_noxref_3_c_810_n N_noxref_3_c_838_p \
 N_noxref_3_M2_noxref_d N_noxref_3_M46_noxref_d N_noxref_3_M48_noxref_d \
 N_noxref_3_M50_noxref_d )  PM_TMRDFFQX1\%noxref_3
x_PM_TMRDFFQX1\%noxref_4 ( N_noxref_4_c_1195_n N_noxref_4_c_1212_p \
 N_noxref_4_c_1276_p N_noxref_4_c_1301_p N_noxref_4_c_1214_p \
 N_noxref_4_c_1196_n N_noxref_4_c_1237_p N_noxref_4_c_1197_n \
 N_noxref_4_c_1218_p N_noxref_4_c_1219_p N_noxref_4_c_1198_n \
 N_noxref_4_c_1281_p N_noxref_4_c_1312_p N_noxref_4_c_1232_p \
 N_noxref_4_c_1204_n N_noxref_4_c_1220_p N_noxref_4_c_1234_p \
 N_noxref_4_c_1226_p N_noxref_4_c_1221_p N_noxref_4_c_1205_n \
 N_noxref_4_c_1222_p N_noxref_4_c_1243_p N_noxref_4_c_1206_n \
 N_noxref_4_c_1290_p N_noxref_4_c_1223_p N_noxref_4_c_1228_p \
 N_noxref_4_M11_noxref_g N_noxref_4_M68_noxref_g N_noxref_4_M69_noxref_g \
 N_noxref_4_c_1254_p N_noxref_4_c_1255_p N_noxref_4_c_1257_p \
 N_noxref_4_c_1236_p N_noxref_4_c_1432_p N_noxref_4_c_1433_p \
 N_noxref_4_c_1256_p N_noxref_4_c_1258_p N_noxref_4_c_1229_p \
 N_noxref_4_M10_noxref_d N_noxref_4_M64_noxref_d N_noxref_4_M66_noxref_d )  \
 PM_TMRDFFQX1\%noxref_4
x_PM_TMRDFFQX1\%noxref_5 ( N_noxref_5_c_1749_p N_noxref_5_c_1479_n \
 N_noxref_5_c_1737_p N_noxref_5_c_1481_n N_noxref_5_c_1482_n \
 N_noxref_5_c_1490_n N_noxref_5_c_1491_n N_noxref_5_c_1549_n \
 N_noxref_5_c_1550_n N_noxref_5_c_1663_n N_noxref_5_c_1664_n \
 N_noxref_5_c_1551_n N_noxref_5_c_1552_n N_noxref_5_c_1622_n \
 N_noxref_5_c_1555_n N_noxref_5_c_1667_n N_noxref_5_c_1674_n \
 N_noxref_5_c_1675_n N_noxref_5_c_1739_p N_noxref_5_c_1496_n \
 N_noxref_5_c_1497_n N_noxref_5_c_1559_n N_noxref_5_c_1680_n \
 N_noxref_5_c_1681_n N_noxref_5_c_1568_n N_noxref_5_c_1746_p \
 N_noxref_5_c_1683_n N_noxref_5_c_1684_n N_noxref_5_c_1500_n \
 N_noxref_5_c_1504_n N_noxref_5_c_1505_n N_noxref_5_c_1506_n \
 N_noxref_5_c_1569_n N_noxref_5_c_1507_n N_noxref_5_c_1650_n \
 N_noxref_5_c_1652_n N_noxref_5_c_1741_p N_noxref_5_c_1742_p \
 N_noxref_5_c_1755_p N_noxref_5_c_1511_n N_noxref_5_c_1515_n \
 N_noxref_5_c_1576_n N_noxref_5_c_1761_p N_noxref_5_c_1694_n \
 N_noxref_5_c_1698_n N_noxref_5_M0_noxref_g N_noxref_5_M6_noxref_g \
 N_noxref_5_M12_noxref_g N_noxref_5_M46_noxref_g N_noxref_5_M47_noxref_g \
 N_noxref_5_M58_noxref_g N_noxref_5_M59_noxref_g N_noxref_5_M70_noxref_g \
 N_noxref_5_M71_noxref_g N_noxref_5_c_1816_p N_noxref_5_c_1817_p \
 N_noxref_5_c_1819_p N_noxref_5_c_1752_p N_noxref_5_c_1997_p \
 N_noxref_5_c_2011_p N_noxref_5_c_1818_p N_noxref_5_c_1820_p \
 N_noxref_5_c_1660_n N_noxref_5_c_1757_p N_noxref_5_c_1521_n \
 N_noxref_5_c_1524_n N_noxref_5_c_1526_n N_noxref_5_c_1593_n \
 N_noxref_5_c_1596_n N_noxref_5_c_1598_n N_noxref_5_c_1529_n \
 N_noxref_5_c_1530_n N_noxref_5_c_1704_n N_noxref_5_c_1707_n \
 N_noxref_5_c_1709_n N_noxref_5_c_1887_p N_noxref_5_c_1894_p \
 N_noxref_5_c_1869_p N_noxref_5_c_1712_n N_noxref_5_c_1713_n \
 N_noxref_5_c_1531_n N_noxref_5_c_1609_n N_noxref_5_c_1534_n \
 N_noxref_5_c_1714_n N_noxref_5_c_1871_p N_noxref_5_c_1717_n \
 N_noxref_5_M8_noxref_d N_noxref_5_M60_noxref_d N_noxref_5_M62_noxref_d )  \
 PM_TMRDFFQX1\%noxref_5
x_PM_TMRDFFQX1\%noxref_6 ( N_noxref_6_c_2145_p N_noxref_6_c_2146_p \
 N_noxref_6_c_2121_p N_noxref_6_c_2122_p N_noxref_6_c_2206_p \
 N_noxref_6_c_2094_p N_noxref_6_c_2100_p N_noxref_6_c_2095_p \
 N_noxref_6_c_2140_p N_noxref_6_c_2096_p N_noxref_6_c_2184_p \
 N_noxref_6_c_2098_p N_noxref_6_c_2097_p N_noxref_6_c_2101_p \
 N_noxref_6_c_2149_p N_noxref_6_c_2118_p N_noxref_6_c_2102_p \
 N_noxref_6_c_2103_p N_noxref_6_c_2109_p N_noxref_6_c_2290_p \
 N_noxref_6_c_2110_p N_noxref_6_c_2235_p N_noxref_6_c_2104_p \
 N_noxref_6_c_2099_p N_noxref_6_c_2150_p N_noxref_6_c_2151_p \
 N_noxref_6_c_2152_p N_noxref_6_c_2164_p N_noxref_6_c_2165_p \
 N_noxref_6_c_2166_p N_noxref_6_c_2111_p N_noxref_6_c_2186_p \
 N_noxref_6_c_2153_p N_noxref_6_c_2124_p N_noxref_6_c_2170_p \
 N_noxref_6_c_2283_p N_noxref_6_c_2227_p N_noxref_6_c_2105_p \
 N_noxref_6_M15_noxref_g N_noxref_6_M18_noxref_g N_noxref_6_M76_noxref_g \
 N_noxref_6_M77_noxref_g N_noxref_6_M82_noxref_g N_noxref_6_M83_noxref_g \
 N_noxref_6_c_2128_p N_noxref_6_c_2129_p N_noxref_6_c_2136_p \
 N_noxref_6_c_2130_p N_noxref_6_c_2131_p N_noxref_6_c_2132_p \
 N_noxref_6_c_2133_p N_noxref_6_c_2259_p N_noxref_6_c_2260_p \
 N_noxref_6_c_2262_p N_noxref_6_c_2237_p N_noxref_6_c_2483_p \
 N_noxref_6_c_2484_p N_noxref_6_c_2261_p N_noxref_6_c_2263_p \
 N_noxref_6_c_2154_p N_noxref_6_c_2139_p N_noxref_6_c_2161_p \
 N_noxref_6_c_2108_p N_noxref_6_M17_noxref_d N_noxref_6_M78_noxref_d \
 N_noxref_6_M80_noxref_d )  PM_TMRDFFQX1\%noxref_6
x_PM_TMRDFFQX1\%noxref_7 ( N_noxref_7_c_2534_n N_noxref_7_c_2535_n \
 N_noxref_7_c_2592_p N_noxref_7_c_2584_p N_noxref_7_c_2536_n \
 N_noxref_7_c_2537_n N_noxref_7_c_2558_p N_noxref_7_c_2539_n \
 N_noxref_7_c_2573_p N_noxref_7_c_2564_p N_noxref_7_c_2541_n \
 N_noxref_7_c_2594_p N_noxref_7_c_2595_p N_noxref_7_c_2550_n \
 N_noxref_7_c_2551_n N_noxref_7_c_2656_p N_noxref_7_c_2650_p \
 N_noxref_7_c_2596_p N_noxref_7_c_2565_p N_noxref_7_c_2563_p \
 N_noxref_7_c_2552_n N_noxref_7_c_2567_p N_noxref_7_c_2553_n \
 N_noxref_7_c_2616_p N_noxref_7_c_2659_p N_noxref_7_c_2597_p \
 N_noxref_7_M20_noxref_g N_noxref_7_M86_noxref_g N_noxref_7_M87_noxref_g \
 N_noxref_7_c_2684_p N_noxref_7_c_2685_p N_noxref_7_c_2687_p \
 N_noxref_7_c_2666_p N_noxref_7_c_2774_p N_noxref_7_c_2775_p \
 N_noxref_7_c_2686_p N_noxref_7_c_2688_p N_noxref_7_c_2600_p \
 N_noxref_7_M19_noxref_d N_noxref_7_M82_noxref_d N_noxref_7_M84_noxref_d )  \
 PM_TMRDFFQX1\%noxref_7
x_PM_TMRDFFQX1\%noxref_8 ( N_noxref_8_c_2994_p N_noxref_8_c_2822_n \
 N_noxref_8_c_2823_n N_noxref_8_c_2826_n N_noxref_8_c_2831_n \
 N_noxref_8_c_2839_n N_noxref_8_c_2845_n N_noxref_8_c_2849_n \
 N_noxref_8_c_2850_n N_noxref_8_c_2861_n N_noxref_8_c_2863_n \
 N_noxref_8_c_2867_n N_noxref_8_c_2872_n N_noxref_8_c_2935_p \
 N_noxref_8_c_2937_p N_noxref_8_c_2992_p N_noxref_8_c_3067_p \
 N_noxref_8_c_2876_n N_noxref_8_c_2880_n N_noxref_8_c_3008_p \
 N_noxref_8_c_3014_p N_noxref_8_c_2881_n N_noxref_8_c_2883_n \
 N_noxref_8_c_2943_p N_noxref_8_c_2957_p N_noxref_8_c_2938_p \
 N_noxref_8_c_2936_p N_noxref_8_c_2885_n N_noxref_8_c_2887_n \
 N_noxref_8_c_2889_n N_noxref_8_c_2892_n N_noxref_8_c_2896_n \
 N_noxref_8_c_2900_n N_noxref_8_c_2922_n N_noxref_8_c_2925_n \
 N_noxref_8_c_2928_n N_noxref_8_c_2932_n N_noxref_8_c_2993_p \
 N_noxref_8_c_3061_p N_noxref_8_c_2902_n N_noxref_8_c_3002_p \
 N_noxref_8_c_2907_n N_noxref_8_c_3096_p N_noxref_8_c_2939_p \
 N_noxref_8_M16_noxref_g N_noxref_8_M22_noxref_g N_noxref_8_M78_noxref_g \
 N_noxref_8_M79_noxref_g N_noxref_8_M90_noxref_g N_noxref_8_M91_noxref_g \
 N_noxref_8_c_3038_p N_noxref_8_c_3039_p N_noxref_8_c_3041_p \
 N_noxref_8_c_3016_p N_noxref_8_c_3241_p N_noxref_8_c_3242_p \
 N_noxref_8_c_3040_p N_noxref_8_c_3042_p N_noxref_8_c_3117_p \
 N_noxref_8_c_3118_p N_noxref_8_c_3120_p N_noxref_8_c_3097_p \
 N_noxref_8_c_3253_p N_noxref_8_c_3254_p N_noxref_8_c_3119_p \
 N_noxref_8_c_3121_p N_noxref_8_c_2914_n N_noxref_8_c_2942_p \
 N_noxref_8_M15_noxref_d N_noxref_8_M72_noxref_d N_noxref_8_M74_noxref_d \
 N_noxref_8_M76_noxref_d )  PM_TMRDFFQX1\%noxref_8
x_PM_TMRDFFQX1\%noxref_9 ( N_noxref_9_c_3313_n N_noxref_9_c_3330_p \
 N_noxref_9_c_3421_p N_noxref_9_c_3436_p N_noxref_9_c_3332_p \
 N_noxref_9_c_3314_n N_noxref_9_c_3355_p N_noxref_9_c_3315_n \
 N_noxref_9_c_3336_p N_noxref_9_c_3337_p N_noxref_9_c_3316_n \
 N_noxref_9_c_3393_p N_noxref_9_c_3463_p N_noxref_9_c_3350_p \
 N_noxref_9_c_3322_n N_noxref_9_c_3338_p N_noxref_9_c_3352_p \
 N_noxref_9_c_3344_p N_noxref_9_c_3339_p N_noxref_9_c_3323_n \
 N_noxref_9_c_3340_p N_noxref_9_c_3361_p N_noxref_9_c_3324_n \
 N_noxref_9_c_3420_p N_noxref_9_c_3341_p N_noxref_9_c_3346_p \
 N_noxref_9_M24_noxref_g N_noxref_9_M94_noxref_g N_noxref_9_M95_noxref_g \
 N_noxref_9_c_3372_p N_noxref_9_c_3373_p N_noxref_9_c_3375_p \
 N_noxref_9_c_3354_p N_noxref_9_c_3544_p N_noxref_9_c_3545_p \
 N_noxref_9_c_3374_p N_noxref_9_c_3376_p N_noxref_9_c_3347_p \
 N_noxref_9_M23_noxref_d N_noxref_9_M90_noxref_d N_noxref_9_M92_noxref_d )  \
 PM_TMRDFFQX1\%noxref_9
x_PM_TMRDFFQX1\%noxref_10 ( N_noxref_10_c_3836_p N_noxref_10_c_3591_n \
 N_noxref_10_c_3847_p N_noxref_10_c_3592_n N_noxref_10_c_3598_n \
 N_noxref_10_c_3606_n N_noxref_10_c_3607_n N_noxref_10_c_3665_n \
 N_noxref_10_c_3666_n N_noxref_10_c_3778_n N_noxref_10_c_3779_n \
 N_noxref_10_c_3667_n N_noxref_10_c_3668_n N_noxref_10_c_3738_n \
 N_noxref_10_c_3671_n N_noxref_10_c_3782_n N_noxref_10_c_3789_n \
 N_noxref_10_c_3790_n N_noxref_10_c_3593_n N_noxref_10_c_3612_n \
 N_noxref_10_c_3613_n N_noxref_10_c_3675_n N_noxref_10_c_3795_n \
 N_noxref_10_c_3796_n N_noxref_10_c_3684_n N_noxref_10_c_3856_p \
 N_noxref_10_c_3798_n N_noxref_10_c_3799_n N_noxref_10_c_3616_n \
 N_noxref_10_c_3620_n N_noxref_10_c_3621_n N_noxref_10_c_3622_n \
 N_noxref_10_c_3685_n N_noxref_10_c_3623_n N_noxref_10_c_3765_n \
 N_noxref_10_c_3767_n N_noxref_10_c_3594_n N_noxref_10_c_3852_p \
 N_noxref_10_c_3864_p N_noxref_10_c_3627_n N_noxref_10_c_3631_n \
 N_noxref_10_c_3692_n N_noxref_10_c_3870_p N_noxref_10_c_3809_n \
 N_noxref_10_c_3813_n N_noxref_10_M13_noxref_g N_noxref_10_M19_noxref_g \
 N_noxref_10_M25_noxref_g N_noxref_10_M72_noxref_g N_noxref_10_M73_noxref_g \
 N_noxref_10_M84_noxref_g N_noxref_10_M85_noxref_g N_noxref_10_M96_noxref_g \
 N_noxref_10_M97_noxref_g N_noxref_10_c_3930_p N_noxref_10_c_3931_p \
 N_noxref_10_c_3933_p N_noxref_10_c_3861_p N_noxref_10_c_4135_p \
 N_noxref_10_c_4149_p N_noxref_10_c_3932_p N_noxref_10_c_3934_p \
 N_noxref_10_c_3775_n N_noxref_10_c_3866_p N_noxref_10_c_3637_n \
 N_noxref_10_c_3640_n N_noxref_10_c_3642_n N_noxref_10_c_3709_n \
 N_noxref_10_c_3712_n N_noxref_10_c_3714_n N_noxref_10_c_3645_n \
 N_noxref_10_c_3646_n N_noxref_10_c_3819_n N_noxref_10_c_3822_n \
 N_noxref_10_c_3824_n N_noxref_10_c_4054_p N_noxref_10_c_4117_p \
 N_noxref_10_c_4090_p N_noxref_10_c_3827_n N_noxref_10_c_3828_n \
 N_noxref_10_c_3647_n N_noxref_10_c_3725_n N_noxref_10_c_3650_n \
 N_noxref_10_c_3829_n N_noxref_10_c_4092_p N_noxref_10_c_3832_n \
 N_noxref_10_M21_noxref_d N_noxref_10_M86_noxref_d N_noxref_10_M88_noxref_d )  \
 PM_TMRDFFQX1\%noxref_10
x_PM_TMRDFFQX1\%D ( D D D D N_D_c_4236_n N_D_c_4238_n N_D_c_4246_n \
 N_D_c_4383_n N_D_c_4385_n N_D_c_4392_n N_D_c_4540_p N_D_c_4526_p N_D_c_4527_p \
 N_D_c_4248_n N_D_c_4400_n N_D_c_4543_p N_D_c_4249_n N_D_c_4251_n N_D_c_4407_n \
 N_D_c_4544_p N_D_c_4408_n N_D_c_4261_n N_D_c_4262_n N_D_c_4415_n N_D_c_4416_n \
 N_D_c_4545_p N_D_c_4528_p N_D_M4_noxref_g N_D_M17_noxref_g N_D_M30_noxref_g \
 N_D_M54_noxref_g N_D_M55_noxref_g N_D_M80_noxref_g N_D_M81_noxref_g \
 N_D_M106_noxref_g N_D_M107_noxref_g N_D_c_4270_n N_D_c_4272_n N_D_c_4275_n \
 N_D_c_4276_n N_D_c_4279_n N_D_c_4281_n N_D_c_4285_n N_D_c_4287_n N_D_c_4424_n \
 N_D_c_4426_n N_D_c_4429_n N_D_c_4430_n N_D_c_4433_n N_D_c_4435_n N_D_c_4439_n \
 N_D_c_4441_n N_D_c_4558_p N_D_c_4531_p N_D_c_4532_p N_D_c_4551_p N_D_c_4560_p \
 N_D_c_4533_p N_D_c_4562_p N_D_c_4534_p N_D_c_4291_n N_D_c_4292_n N_D_c_4294_n \
 N_D_c_4445_n N_D_c_4446_n N_D_c_4448_n N_D_c_4546_p N_D_c_4535_p N_D_c_4530_p \
 )  PM_TMRDFFQX1\%D
x_PM_TMRDFFQX1\%noxref_12 ( N_noxref_12_c_4941_p N_noxref_12_c_4856_n \
 N_noxref_12_c_4936_p N_noxref_12_c_4937_p N_noxref_12_c_4857_n \
 N_noxref_12_c_4862_n N_noxref_12_c_4867_n N_noxref_12_c_4868_n \
 N_noxref_12_c_4998_p N_noxref_12_c_4870_n N_noxref_12_c_4879_n \
 N_noxref_12_c_4880_n N_noxref_12_c_4884_n N_noxref_12_c_4919_p \
 N_noxref_12_c_4938_p N_noxref_12_c_4950_p N_noxref_12_c_4886_n \
 N_noxref_12_c_4921_p N_noxref_12_c_4889_n N_noxref_12_c_4895_n \
 N_noxref_12_c_4928_p N_noxref_12_c_5093_p N_noxref_12_c_4922_p \
 N_noxref_12_c_4896_n N_noxref_12_c_4897_n N_noxref_12_c_4939_p \
 N_noxref_12_c_4898_n N_noxref_12_c_4899_n N_noxref_12_c_5023_p \
 N_noxref_12_c_4900_n N_noxref_12_c_4929_p N_noxref_12_c_5044_p \
 N_noxref_12_c_4940_p N_noxref_12_c_4945_p N_noxref_12_c_5028_p \
 N_noxref_12_c_4902_n N_noxref_12_c_5085_p N_noxref_12_c_4923_p \
 N_noxref_12_M28_noxref_g N_noxref_12_M31_noxref_g N_noxref_12_M102_noxref_g \
 N_noxref_12_M103_noxref_g N_noxref_12_M108_noxref_g N_noxref_12_M109_noxref_g \
 N_noxref_12_c_4965_p N_noxref_12_c_4966_p N_noxref_12_c_4967_p \
 N_noxref_12_c_4988_p N_noxref_12_c_4989_p N_noxref_12_c_4990_p \
 N_noxref_12_c_4991_p N_noxref_12_c_5117_p N_noxref_12_c_5118_p \
 N_noxref_12_c_5120_p N_noxref_12_c_5095_p N_noxref_12_c_5245_p \
 N_noxref_12_c_5246_p N_noxref_12_c_5119_p N_noxref_12_c_5121_p \
 N_noxref_12_c_4943_p N_noxref_12_c_4971_p N_noxref_12_c_4946_p \
 N_noxref_12_c_4926_p N_noxref_12_M30_noxref_d N_noxref_12_M104_noxref_d \
 N_noxref_12_M106_noxref_d )  PM_TMRDFFQX1\%noxref_12
x_PM_TMRDFFQX1\%noxref_13 ( N_noxref_13_c_5296_n N_noxref_13_c_5297_n \
 N_noxref_13_c_5400_p N_noxref_13_c_5392_p N_noxref_13_c_5298_n \
 N_noxref_13_c_5299_n N_noxref_13_c_5366_p N_noxref_13_c_5301_n \
 N_noxref_13_c_5322_p N_noxref_13_c_5323_p N_noxref_13_c_5303_n \
 N_noxref_13_c_5336_p N_noxref_13_c_5403_p N_noxref_13_c_5312_n \
 N_noxref_13_c_5313_n N_noxref_13_c_5324_p N_noxref_13_c_5332_p \
 N_noxref_13_c_5328_p N_noxref_13_c_5325_p N_noxref_13_c_5371_p \
 N_noxref_13_c_5314_n N_noxref_13_c_5326_p N_noxref_13_c_5315_n \
 N_noxref_13_c_5424_p N_noxref_13_c_5327_p N_noxref_13_c_5330_p \
 N_noxref_13_M33_noxref_g N_noxref_13_M112_noxref_g N_noxref_13_M113_noxref_g \
 N_noxref_13_c_5351_p N_noxref_13_c_5352_p N_noxref_13_c_5354_p \
 N_noxref_13_c_5334_p N_noxref_13_c_5537_p N_noxref_13_c_5538_p \
 N_noxref_13_c_5353_p N_noxref_13_c_5355_p N_noxref_13_c_5331_p \
 N_noxref_13_M32_noxref_d N_noxref_13_M108_noxref_d N_noxref_13_M110_noxref_d ) \
 PM_TMRDFFQX1\%noxref_13
x_PM_TMRDFFQX1\%CLK ( CLK CLK CLK CLK CLK CLK CLK CLK CLK CLK CLK CLK CLK CLK \
 CLK CLK CLK CLK N_CLK_c_5591_n N_CLK_c_5845_n N_CLK_c_6118_n N_CLK_c_5594_n \
 N_CLK_c_5633_n N_CLK_c_5637_n N_CLK_c_5848_n N_CLK_c_5887_n N_CLK_c_5891_n \
 N_CLK_c_6121_n N_CLK_c_6160_n N_CLK_c_6164_n N_CLK_c_5597_n N_CLK_c_5642_n \
 N_CLK_c_5691_n N_CLK_c_5643_n N_CLK_c_5711_n N_CLK_c_5716_n N_CLK_c_5771_n \
 N_CLK_c_5998_n N_CLK_c_6001_n N_CLK_c_5851_n N_CLK_c_5894_n N_CLK_c_5852_n \
 N_CLK_c_5947_n N_CLK_c_5897_n N_CLK_c_5953_n N_CLK_c_6033_n N_CLK_c_6109_n \
 N_CLK_c_6240_p N_CLK_c_6124_n N_CLK_c_6167_n N_CLK_c_6110_n N_CLK_c_5604_n \
 N_CLK_c_5698_n N_CLK_c_5605_n N_CLK_c_5609_n N_CLK_c_5647_n N_CLK_c_5651_n \
 N_CLK_c_5859_n N_CLK_c_5863_n N_CLK_c_5901_n N_CLK_c_5905_n N_CLK_c_6132_n \
 N_CLK_c_6136_n N_CLK_c_6173_n N_CLK_c_6177_n N_CLK_M1_noxref_g \
 N_CLK_M8_noxref_g N_CLK_M14_noxref_g N_CLK_M21_noxref_g N_CLK_M27_noxref_g \
 N_CLK_M34_noxref_g N_CLK_M48_noxref_g N_CLK_M49_noxref_g N_CLK_M62_noxref_g \
 N_CLK_M63_noxref_g N_CLK_M74_noxref_g N_CLK_M75_noxref_g N_CLK_M88_noxref_g \
 N_CLK_M89_noxref_g N_CLK_M100_noxref_g N_CLK_M101_noxref_g \
 N_CLK_M114_noxref_g N_CLK_M115_noxref_g N_CLK_c_5798_n N_CLK_c_5801_n \
 N_CLK_c_6456_p N_CLK_c_6457_p N_CLK_c_5615_n N_CLK_c_5616_n N_CLK_c_5617_n \
 N_CLK_c_5618_n N_CLK_c_5622_n N_CLK_c_5657_n N_CLK_c_5660_n N_CLK_c_5662_n \
 N_CLK_c_5815_n N_CLK_c_5819_n N_CLK_c_5821_n N_CLK_c_5665_n N_CLK_c_5666_n \
 N_CLK_c_6056_n N_CLK_c_6059_n N_CLK_c_6471_p N_CLK_c_6472_p N_CLK_c_5869_n \
 N_CLK_c_5870_n N_CLK_c_5871_n N_CLK_c_5872_n N_CLK_c_5876_n N_CLK_c_5911_n \
 N_CLK_c_5914_n N_CLK_c_5916_n N_CLK_c_6073_n N_CLK_c_6077_n N_CLK_c_6079_n \
 N_CLK_c_5919_n N_CLK_c_5920_n N_CLK_c_6316_p N_CLK_c_6318_p N_CLK_c_6494_p \
 N_CLK_c_6495_p N_CLK_c_6142_n N_CLK_c_6143_n N_CLK_c_6144_n N_CLK_c_6145_n \
 N_CLK_c_6149_n N_CLK_c_6183_n N_CLK_c_6186_n N_CLK_c_6188_n N_CLK_c_6271_p \
 N_CLK_c_6284_p N_CLK_c_6259_p N_CLK_c_6191_n N_CLK_c_6192_n N_CLK_c_5623_n \
 N_CLK_c_5667_n N_CLK_c_5836_n N_CLK_c_5670_n N_CLK_c_5877_n N_CLK_c_5921_n \
 N_CLK_c_6093_n N_CLK_c_5924_n N_CLK_c_6150_n N_CLK_c_6193_n N_CLK_c_6261_p \
 N_CLK_c_6196_n )  PM_TMRDFFQX1\%CLK
x_PM_TMRDFFQX1\%noxref_15 ( N_noxref_15_c_6742_n N_noxref_15_c_6630_n \
 N_noxref_15_c_6631_n N_noxref_15_c_6634_n N_noxref_15_c_6639_n \
 N_noxref_15_c_6647_n N_noxref_15_c_6653_n N_noxref_15_c_6657_n \
 N_noxref_15_c_6583_n N_noxref_15_c_6669_n N_noxref_15_c_6586_n \
 N_noxref_15_c_6587_n N_noxref_15_c_6594_n N_noxref_15_c_6753_n \
 N_noxref_15_c_6780_p N_noxref_15_c_6754_n N_noxref_15_c_6755_n \
 N_noxref_15_c_6684_n N_noxref_15_c_6688_n N_noxref_15_c_6595_n \
 N_noxref_15_c_6596_n N_noxref_15_c_6599_n N_noxref_15_c_6602_n \
 N_noxref_15_c_6845_p N_noxref_15_c_6798_p N_noxref_15_c_6781_p \
 N_noxref_15_c_6762_n N_noxref_15_c_6693_n N_noxref_15_c_6695_n \
 N_noxref_15_c_6697_n N_noxref_15_c_6603_n N_noxref_15_c_6704_n \
 N_noxref_15_c_6708_n N_noxref_15_c_6730_n N_noxref_15_c_6733_n \
 N_noxref_15_c_6736_n N_noxref_15_c_6740_n N_noxref_15_c_6835_p \
 N_noxref_15_c_6773_n N_noxref_15_c_6710_n N_noxref_15_c_6604_n \
 N_noxref_15_c_6608_n N_noxref_15_c_6842_p N_noxref_15_c_6782_p \
 N_noxref_15_M29_noxref_g N_noxref_15_M35_noxref_g N_noxref_15_M104_noxref_g \
 N_noxref_15_M105_noxref_g N_noxref_15_M116_noxref_g N_noxref_15_M117_noxref_g \
 N_noxref_15_c_6614_n N_noxref_15_c_6615_n N_noxref_15_c_6616_n \
 N_noxref_15_c_6618_n N_noxref_15_c_7007_p N_noxref_15_c_7008_p \
 N_noxref_15_c_6622_n N_noxref_15_c_6624_n N_noxref_15_c_6871_p \
 N_noxref_15_c_6872_p N_noxref_15_c_6874_p N_noxref_15_c_6855_p \
 N_noxref_15_c_7019_p N_noxref_15_c_7020_p N_noxref_15_c_6873_p \
 N_noxref_15_c_6875_p N_noxref_15_c_6627_n N_noxref_15_c_6785_p \
 N_noxref_15_M28_noxref_d N_noxref_15_M98_noxref_d N_noxref_15_M100_noxref_d \
 N_noxref_15_M102_noxref_d )  PM_TMRDFFQX1\%noxref_15
x_PM_TMRDFFQX1\%noxref_16 ( N_noxref_16_c_7079_n N_noxref_16_c_7094_p \
 N_noxref_16_c_7174_p N_noxref_16_c_7167_p N_noxref_16_c_7096_p \
 N_noxref_16_c_7080_n N_noxref_16_c_7117_p N_noxref_16_c_7098_p \
 N_noxref_16_c_7100_p N_noxref_16_c_7082_n N_noxref_16_c_7120_p \
 N_noxref_16_c_7176_p N_noxref_16_c_7110_p N_noxref_16_c_7163_p \
 N_noxref_16_c_7104_p N_noxref_16_c_7112_p N_noxref_16_c_7122_p \
 N_noxref_16_c_7123_p N_noxref_16_c_7105_p N_noxref_16_c_7088_n \
 N_noxref_16_c_7157_p N_noxref_16_c_7101_p N_noxref_16_c_7106_p \
 N_noxref_16_M37_noxref_g N_noxref_16_M120_noxref_g N_noxref_16_M121_noxref_g \
 N_noxref_16_c_7135_p N_noxref_16_c_7136_p N_noxref_16_c_7138_p \
 N_noxref_16_c_7114_p N_noxref_16_c_7311_p N_noxref_16_c_7312_p \
 N_noxref_16_c_7137_p N_noxref_16_c_7139_p N_noxref_16_c_7107_p \
 N_noxref_16_M36_noxref_d N_noxref_16_M116_noxref_d N_noxref_16_M118_noxref_d ) \
 PM_TMRDFFQX1\%noxref_16
x_PM_TMRDFFQX1\%noxref_17 ( N_noxref_17_c_7499_n N_noxref_17_c_7358_n \
 N_noxref_17_c_7504_n N_noxref_17_c_7359_n N_noxref_17_c_7368_n \
 N_noxref_17_c_7376_n N_noxref_17_c_7377_n N_noxref_17_c_7435_n \
 N_noxref_17_c_7436_n N_noxref_17_c_7528_n N_noxref_17_c_7529_n \
 N_noxref_17_c_7437_n N_noxref_17_c_7438_n N_noxref_17_c_7536_n \
 N_noxref_17_c_7441_n N_noxref_17_c_7661_n N_noxref_17_c_7664_n \
 N_noxref_17_c_7665_n N_noxref_17_c_7360_n N_noxref_17_c_7382_n \
 N_noxref_17_c_7383_n N_noxref_17_c_7445_n N_noxref_17_c_7545_n \
 N_noxref_17_c_7671_n N_noxref_17_c_7454_n N_noxref_17_c_7554_n \
 N_noxref_17_c_7673_n N_noxref_17_c_7674_n N_noxref_17_c_7363_n \
 N_noxref_17_c_7390_n N_noxref_17_c_7391_n N_noxref_17_c_7392_n \
 N_noxref_17_c_7455_n N_noxref_17_c_7364_n N_noxref_17_c_7643_n \
 N_noxref_17_c_7565_n N_noxref_17_c_7361_n N_noxref_17_c_7568_n \
 N_noxref_17_c_7572_n N_noxref_17_c_7397_n N_noxref_17_c_7401_n \
 N_noxref_17_c_7462_n N_noxref_17_c_7575_n N_noxref_17_c_7687_n \
 N_noxref_17_c_7691_n N_noxref_17_M26_noxref_g N_noxref_17_M32_noxref_g \
 N_noxref_17_M38_noxref_g N_noxref_17_M98_noxref_g N_noxref_17_M99_noxref_g \
 N_noxref_17_M110_noxref_g N_noxref_17_M111_noxref_g N_noxref_17_M122_noxref_g \
 N_noxref_17_M123_noxref_g N_noxref_17_c_7582_n N_noxref_17_c_7583_n \
 N_noxref_17_c_7584_n N_noxref_17_c_7585_n N_noxref_17_c_7893_p \
 N_noxref_17_c_7907_p N_noxref_17_c_7588_n N_noxref_17_c_7590_n \
 N_noxref_17_c_7593_n N_noxref_17_c_7596_n N_noxref_17_c_7407_n \
 N_noxref_17_c_7410_n N_noxref_17_c_7412_n N_noxref_17_c_7479_n \
 N_noxref_17_c_7482_n N_noxref_17_c_7484_n N_noxref_17_c_7415_n \
 N_noxref_17_c_7416_n N_noxref_17_c_7697_n N_noxref_17_c_7700_n \
 N_noxref_17_c_7702_n N_noxref_17_c_7743_p N_noxref_17_c_7753_p \
 N_noxref_17_c_7725_p N_noxref_17_c_7705_n N_noxref_17_c_7706_n \
 N_noxref_17_c_7417_n N_noxref_17_c_7495_n N_noxref_17_c_7420_n \
 N_noxref_17_c_7707_n N_noxref_17_c_7727_p N_noxref_17_c_7710_n \
 N_noxref_17_M34_noxref_d N_noxref_17_M112_noxref_d N_noxref_17_M114_noxref_d ) \
 PM_TMRDFFQX1\%noxref_17
x_PM_TMRDFFQX1\%noxref_18 ( N_noxref_18_c_7986_n N_noxref_18_c_7988_n \
 N_noxref_18_c_7992_n N_noxref_18_c_8046_n N_noxref_18_c_8047_n \
 N_noxref_18_c_8127_n N_noxref_18_c_8128_n N_noxref_18_c_8048_n \
 N_noxref_18_c_8049_n N_noxref_18_c_8135_n N_noxref_18_c_8051_n \
 N_noxref_18_c_8174_p N_noxref_18_c_8144_n N_noxref_18_c_8182_p \
 N_noxref_18_c_8187_p N_noxref_18_c_8176_p N_noxref_18_c_8177_p \
 N_noxref_18_c_7998_n N_noxref_18_c_8001_n N_noxref_18_c_8055_n \
 N_noxref_18_c_8146_n N_noxref_18_c_8316_p N_noxref_18_c_8064_n \
 N_noxref_18_c_8156_n N_noxref_18_c_8184_p N_noxref_18_c_8193_p \
 N_noxref_18_c_8194_p N_noxref_18_c_8065_n N_noxref_18_c_8160_n \
 N_noxref_18_c_8163_n N_noxref_18_c_8195_p N_noxref_18_c_8003_n \
 N_noxref_18_c_8185_p N_noxref_18_c_8213_p N_noxref_18_c_8196_p \
 N_noxref_18_c_8189_p N_noxref_18_c_8006_n N_noxref_18_c_8010_n \
 N_noxref_18_c_8073_n N_noxref_18_c_8165_n N_noxref_18_c_8178_p \
 N_noxref_18_c_8198_p N_noxref_18_c_8252_p N_noxref_18_c_8258_p \
 N_noxref_18_M36_noxref_g N_noxref_18_M39_noxref_g N_noxref_18_M41_noxref_g \
 N_noxref_18_M118_noxref_g N_noxref_18_M119_noxref_g N_noxref_18_M124_noxref_g \
 N_noxref_18_M125_noxref_g N_noxref_18_M128_noxref_g N_noxref_18_M129_noxref_g \
 N_noxref_18_c_8016_n N_noxref_18_c_8019_n N_noxref_18_c_8021_n \
 N_noxref_18_c_8090_n N_noxref_18_c_8093_n N_noxref_18_c_8095_n \
 N_noxref_18_c_8024_n N_noxref_18_c_8025_n N_noxref_18_c_8234_p \
 N_noxref_18_c_8235_p N_noxref_18_c_8237_p N_noxref_18_c_8240_p \
 N_noxref_18_c_8440_p N_noxref_18_c_8441_p N_noxref_18_c_8199_p \
 N_noxref_18_c_8200_p N_noxref_18_c_8236_p N_noxref_18_c_8238_p \
 N_noxref_18_c_8290_p N_noxref_18_c_8291_p N_noxref_18_c_8293_p \
 N_noxref_18_c_8283_p N_noxref_18_c_8449_p N_noxref_18_c_8450_p \
 N_noxref_18_c_8292_p N_noxref_18_c_8294_p N_noxref_18_c_8026_n \
 N_noxref_18_c_8106_n N_noxref_18_c_8029_n N_noxref_18_c_8179_p \
 N_noxref_18_c_8259_p N_noxref_18_M38_noxref_d N_noxref_18_M120_noxref_d \
 N_noxref_18_M122_noxref_d )  PM_TMRDFFQX1\%noxref_18
x_PM_TMRDFFQX1\%noxref_19 ( N_noxref_19_c_8542_n N_noxref_19_c_8546_n \
 N_noxref_19_c_8715_n N_noxref_19_c_8721_n N_noxref_19_c_8727_n \
 N_noxref_19_c_8731_n N_noxref_19_c_8800_p N_noxref_19_c_8793_p \
 N_noxref_19_c_8806_p N_noxref_19_c_8798_p N_noxref_19_c_8742_n \
 N_noxref_19_c_8808_p N_noxref_19_c_8591_n N_noxref_19_c_8645_n \
 N_noxref_19_c_8554_n N_noxref_19_c_8758_n N_noxref_19_c_8809_p \
 N_noxref_19_c_8762_n N_noxref_19_c_8556_n N_noxref_19_c_8559_n \
 N_noxref_19_c_8766_n N_noxref_19_c_8769_n N_noxref_19_c_8803_p \
 N_noxref_19_c_8811_p N_noxref_19_M23_noxref_g N_noxref_19_M40_noxref_g \
 N_noxref_19_M44_noxref_g N_noxref_19_M92_noxref_g N_noxref_19_M93_noxref_g \
 N_noxref_19_M126_noxref_g N_noxref_19_M127_noxref_g N_noxref_19_M134_noxref_g \
 N_noxref_19_M135_noxref_g N_noxref_19_c_8565_n N_noxref_19_c_8568_n \
 N_noxref_19_c_8570_n N_noxref_19_c_8614_n N_noxref_19_c_8617_n \
 N_noxref_19_c_8619_n N_noxref_19_c_8573_n N_noxref_19_c_8574_n \
 N_noxref_19_c_8775_n N_noxref_19_c_8778_n N_noxref_19_c_8780_n \
 N_noxref_19_c_8964_p N_noxref_19_c_8907_p N_noxref_19_c_8908_p \
 N_noxref_19_c_8783_n N_noxref_19_c_8784_n N_noxref_19_c_8844_p \
 N_noxref_19_c_8846_p N_noxref_19_c_8847_p N_noxref_19_c_8899_p \
 N_noxref_19_c_8876_p N_noxref_19_c_8859_p N_noxref_19_c_8856_p \
 N_noxref_19_c_8860_p N_noxref_19_c_8575_n N_noxref_19_c_8630_n \
 N_noxref_19_c_8578_n N_noxref_19_c_8785_n N_noxref_19_c_9119_p \
 N_noxref_19_c_8787_n N_noxref_19_c_8804_p N_noxref_19_c_8885_p \
 N_noxref_19_c_8812_p )  PM_TMRDFFQX1\%noxref_19
x_PM_TMRDFFQX1\%noxref_20 ( N_noxref_20_c_9133_n N_noxref_20_c_9135_n \
 N_noxref_20_c_9136_n N_noxref_20_c_9191_n N_noxref_20_c_9192_n \
 N_noxref_20_c_9275_n N_noxref_20_c_9276_n N_noxref_20_c_9193_n \
 N_noxref_20_c_9194_n N_noxref_20_c_9283_n N_noxref_20_c_9196_n \
 N_noxref_20_c_9514_n N_noxref_20_c_9517_n N_noxref_20_c_9518_n \
 N_noxref_20_c_9519_n N_noxref_20_c_9577_n N_noxref_20_c_9524_n \
 N_noxref_20_c_9144_n N_noxref_20_c_9147_n N_noxref_20_c_9201_n \
 N_noxref_20_c_9292_n N_noxref_20_c_9688_p N_noxref_20_c_9210_n \
 N_noxref_20_c_9301_n N_noxref_20_c_9525_n N_noxref_20_c_9211_n \
 N_noxref_20_c_9316_n N_noxref_20_c_9305_n N_noxref_20_c_9321_n \
 N_noxref_20_c_9324_n N_noxref_20_c_9327_n N_noxref_20_c_9331_n \
 N_noxref_20_c_9334_n N_noxref_20_c_9337_n N_noxref_20_c_9338_n \
 N_noxref_20_c_9342_n N_noxref_20_c_9345_n N_noxref_20_c_9365_n \
 N_noxref_20_c_9422_n N_noxref_20_c_9423_n N_noxref_20_c_9437_n \
 N_noxref_20_c_9441_n N_noxref_20_c_9444_n N_noxref_20_c_9447_n \
 N_noxref_20_c_9448_n N_noxref_20_c_9452_n N_noxref_20_c_9455_n \
 N_noxref_20_c_9148_n N_noxref_20_c_9542_n N_noxref_20_c_9608_n \
 N_noxref_20_c_9611_n N_noxref_20_c_9149_n N_noxref_20_c_9153_n \
 N_noxref_20_c_9222_n N_noxref_20_c_9307_n N_noxref_20_c_9544_n \
 N_noxref_20_c_9548_n N_noxref_20_c_9612_n N_noxref_20_c_9615_n \
 N_noxref_20_M10_noxref_g N_noxref_20_M42_noxref_g N_noxref_20_M43_noxref_g \
 N_noxref_20_M66_noxref_g N_noxref_20_M67_noxref_g N_noxref_20_M130_noxref_g \
 N_noxref_20_M131_noxref_g N_noxref_20_M132_noxref_g N_noxref_20_M133_noxref_g \
 N_noxref_20_c_9159_n N_noxref_20_c_9162_n N_noxref_20_c_9164_n \
 N_noxref_20_c_9240_n N_noxref_20_c_9243_n N_noxref_20_c_9245_n \
 N_noxref_20_c_9167_n N_noxref_20_c_9168_n N_noxref_20_c_9554_n \
 N_noxref_20_c_9557_n N_noxref_20_c_9771_p N_noxref_20_c_9559_n \
 N_noxref_20_c_9649_p N_noxref_20_c_9650_p N_noxref_20_c_9561_n \
 N_noxref_20_c_9563_n N_noxref_20_c_9564_n N_noxref_20_c_9565_n \
 N_noxref_20_c_9566_n N_noxref_20_c_9621_n N_noxref_20_c_9622_n \
 N_noxref_20_c_9623_n N_noxref_20_c_9625_n N_noxref_20_c_9790_p \
 N_noxref_20_c_9791_p N_noxref_20_c_9626_n N_noxref_20_c_9629_n \
 N_noxref_20_c_9632_n N_noxref_20_c_9634_n N_noxref_20_c_9169_n \
 N_noxref_20_c_9256_n N_noxref_20_c_9172_n N_noxref_20_c_9638_n \
 N_noxref_20_M12_noxref_d N_noxref_20_M68_noxref_d N_noxref_20_M70_noxref_d )  \
 PM_TMRDFFQX1\%noxref_20
x_PM_TMRDFFQX1\%noxref_21 ( N_noxref_21_c_9906_n N_noxref_21_c_9913_n \
 N_noxref_21_c_9923_n N_noxref_21_c_9925_n N_noxref_21_c_9926_n \
 N_noxref_21_c_9927_n N_noxref_21_c_9928_n N_noxref_21_c_9935_n \
 N_noxref_21_c_9939_n N_noxref_21_c_9943_n N_noxref_21_c_10031_p \
 N_noxref_21_c_9944_n N_noxref_21_c_9900_n N_noxref_21_c_9992_n \
 N_noxref_21_c_9953_n N_noxref_21_c_9954_n N_noxref_21_c_9958_n \
 N_noxref_21_c_10049_p N_noxref_21_c_10124_p N_noxref_21_c_9960_n \
 N_noxref_21_c_9902_n N_noxref_21_c_10006_n N_noxref_21_c_9962_n \
 N_noxref_21_c_9964_n N_noxref_21_c_9967_n N_noxref_21_c_10063_p \
 N_noxref_21_c_10050_p N_noxref_21_c_10019_n N_noxref_21_c_9970_n \
 N_noxref_21_c_10127_p N_noxref_21_c_10033_p N_noxref_21_M45_noxref_g \
 N_noxref_21_M136_noxref_g N_noxref_21_M137_noxref_g N_noxref_21_c_10132_p \
 N_noxref_21_c_10178_p N_noxref_21_c_10155_p N_noxref_21_c_10146_p \
 N_noxref_21_c_10057_p N_noxref_21_c_10054_p N_noxref_21_c_10157_p \
 N_noxref_21_c_10181_p N_noxref_21_c_10134_p N_noxref_21_c_10159_p \
 N_noxref_21_c_10133_p N_noxref_21_M40_noxref_d N_noxref_21_M42_noxref_d \
 N_noxref_21_M44_noxref_d N_noxref_21_M132_noxref_d N_noxref_21_M134_noxref_d ) \
 PM_TMRDFFQX1\%noxref_21
x_PM_TMRDFFQX1\%VDD ( VDD N_VDD_c_10241_n N_VDD_c_11275_n N_VDD_c_11276_n \
 N_VDD_c_11511_p N_VDD_c_11277_n N_VDD_c_11278_n N_VDD_c_11513_p \
 N_VDD_c_11343_n N_VDD_c_11344_n N_VDD_c_11434_n N_VDD_c_10364_n \
 N_VDD_c_10366_n N_VDD_c_10369_n N_VDD_c_10251_n N_VDD_c_10377_n \
 N_VDD_c_10253_n N_VDD_c_10256_n N_VDD_c_10261_n N_VDD_c_10311_n \
 N_VDD_c_10316_n N_VDD_c_10487_n N_VDD_c_10381_n N_VDD_c_10428_n \
 N_VDD_c_10433_n N_VDD_c_10492_n N_VDD_c_10670_n N_VDD_c_10673_n \
 N_VDD_c_10557_n N_VDD_c_10681_n N_VDD_c_10559_n N_VDD_c_10562_n \
 N_VDD_c_10567_n N_VDD_c_10617_n N_VDD_c_10622_n N_VDD_c_10789_n \
 N_VDD_c_10685_n N_VDD_c_10735_n N_VDD_c_10740_n N_VDD_c_10794_n \
 N_VDD_c_11074_n N_VDD_c_10993_n N_VDD_c_10887_n N_VDD_c_11085_n \
 N_VDD_c_10889_n N_VDD_c_10857_n N_VDD_c_10897_n N_VDD_c_10947_n \
 N_VDD_c_10952_n N_VDD_c_10995_n N_VDD_c_11089_n N_VDD_c_11140_n \
 N_VDD_c_11145_n N_VDD_c_11146_n N_VDD_c_11205_n N_VDD_c_11289_n \
 N_VDD_c_11292_n N_VDD_c_11349_n N_VDD_c_11443_n N_VDD_c_10264_n \
 N_VDD_c_10269_n N_VDD_c_10322_n N_VDD_c_10391_n N_VDD_c_10439_n \
 N_VDD_c_10515_n N_VDD_c_10570_n N_VDD_c_10575_n N_VDD_c_10628_n \
 N_VDD_c_10697_n N_VDD_c_10746_n N_VDD_c_10822_n N_VDD_c_10900_n \
 N_VDD_c_10865_n N_VDD_c_10958_n N_VDD_c_11025_n N_VDD_c_11153_n \
 N_VDD_c_11233_n N_VDD_c_11310_n N_VDD_c_11316_n N_VDD_c_11366_n \
 N_VDD_c_11460_n N_VDD_M46_noxref_s N_VDD_M47_noxref_d N_VDD_M49_noxref_d \
 N_VDD_M51_noxref_d N_VDD_M52_noxref_s N_VDD_M53_noxref_d N_VDD_M55_noxref_d \
 N_VDD_M56_noxref_s N_VDD_M57_noxref_d N_VDD_M59_noxref_d N_VDD_M60_noxref_s \
 N_VDD_M61_noxref_d N_VDD_M63_noxref_d N_VDD_M64_noxref_s N_VDD_M65_noxref_d \
 N_VDD_M67_noxref_d N_VDD_M68_noxref_s N_VDD_M69_noxref_d N_VDD_M71_noxref_d \
 N_VDD_M72_noxref_s N_VDD_M73_noxref_d N_VDD_M75_noxref_d N_VDD_M77_noxref_d \
 N_VDD_M78_noxref_s N_VDD_M79_noxref_d N_VDD_M81_noxref_d N_VDD_M82_noxref_s \
 N_VDD_M83_noxref_d N_VDD_M85_noxref_d N_VDD_M86_noxref_s N_VDD_M87_noxref_d \
 N_VDD_M89_noxref_d N_VDD_M90_noxref_s N_VDD_M91_noxref_d N_VDD_M93_noxref_d \
 N_VDD_M94_noxref_s N_VDD_M95_noxref_d N_VDD_M97_noxref_d N_VDD_M98_noxref_s \
 N_VDD_M99_noxref_d N_VDD_M101_noxref_d N_VDD_M103_noxref_d \
 N_VDD_M104_noxref_s N_VDD_M105_noxref_d N_VDD_M107_noxref_d \
 N_VDD_M108_noxref_s N_VDD_M109_noxref_d N_VDD_M111_noxref_d \
 N_VDD_M112_noxref_s N_VDD_M113_noxref_d N_VDD_M115_noxref_d \
 N_VDD_M116_noxref_s N_VDD_M117_noxref_d N_VDD_M119_noxref_d \
 N_VDD_M120_noxref_s N_VDD_M121_noxref_d N_VDD_M123_noxref_d \
 N_VDD_M124_noxref_s N_VDD_M125_noxref_d N_VDD_M127_noxref_d \
 N_VDD_M136_noxref_s N_VDD_M137_noxref_d )  PM_TMRDFFQX1\%VDD
x_PM_TMRDFFQX1\%noxref_23 ( N_noxref_23_c_11678_n N_noxref_23_c_11694_p \
 N_noxref_23_c_11656_n N_noxref_23_c_11696_p N_noxref_23_c_11661_n \
 N_noxref_23_M1_noxref_d N_noxref_23_M2_noxref_s )  PM_TMRDFFQX1\%noxref_23
x_PM_TMRDFFQX1\%noxref_24 ( N_noxref_24_c_11741_n N_noxref_24_c_11762_p \
 N_noxref_24_c_11720_n N_noxref_24_c_11764_p N_noxref_24_c_11725_n \
 N_noxref_24_M14_noxref_d N_noxref_24_M15_noxref_s )  PM_TMRDFFQX1\%noxref_24
x_PM_TMRDFFQX1\%noxref_25 ( N_noxref_25_c_11788_n N_noxref_25_c_11789_n \
 N_noxref_25_c_11821_n N_noxref_25_c_11822_n N_noxref_25_c_11790_n \
 N_noxref_25_c_11791_n N_noxref_25_c_11828_n N_noxref_25_c_11792_n \
 N_noxref_25_c_11795_n N_noxref_25_c_11840_n N_noxref_25_c_11908_n \
 N_noxref_25_c_11804_n N_noxref_25_c_11849_n N_noxref_25_c_11805_n \
 N_noxref_25_c_11853_n N_noxref_25_M25_noxref_d N_noxref_25_M94_noxref_d \
 N_noxref_25_M96_noxref_d )  PM_TMRDFFQX1\%noxref_25
x_PM_TMRDFFQX1\%noxref_26 ( N_noxref_26_c_11964_n N_noxref_26_c_11996_p \
 N_noxref_26_c_11954_n N_noxref_26_c_11998_p N_noxref_26_c_11959_n \
 N_noxref_26_M27_noxref_d N_noxref_26_M28_noxref_s )  PM_TMRDFFQX1\%noxref_26
x_PM_TMRDFFQX1\%noxref_27 ( N_noxref_27_c_12022_n N_noxref_27_c_12024_n \
 N_noxref_27_c_12027_n N_noxref_27_c_12029_n N_noxref_27_c_12070_n \
 N_noxref_27_c_12035_n N_noxref_27_c_12041_n N_noxref_27_c_12042_n \
 N_noxref_27_c_12073_n N_noxref_27_c_12043_n N_noxref_27_c_12046_n \
 N_noxref_27_c_12047_n N_noxref_27_M124_noxref_d N_noxref_27_M126_noxref_d \
 N_noxref_27_M128_noxref_s N_noxref_27_M129_noxref_d N_noxref_27_M131_noxref_d \
 )  PM_TMRDFFQX1\%noxref_27
x_PM_TMRDFFQX1\%noxref_28 ( N_noxref_28_c_12183_n N_noxref_28_c_12195_n \
 N_noxref_28_c_12196_n N_noxref_28_c_12221_n N_noxref_28_c_12197_n \
 N_noxref_28_c_12184_n N_noxref_28_c_12200_n N_noxref_28_c_12226_n \
 N_noxref_28_c_12201_n N_noxref_28_c_12202_n N_noxref_28_c_12190_n \
 N_noxref_28_c_12203_n N_noxref_28_M128_noxref_d N_noxref_28_M132_noxref_s \
 N_noxref_28_M133_noxref_d N_noxref_28_M135_noxref_d )  PM_TMRDFFQX1\%noxref_28
x_PM_TMRDFFQX1\%GND ( GND N_GND_c_13409_p N_GND_c_12498_n N_GND_c_12316_n \
 N_GND_c_12317_n N_GND_c_12361_n N_GND_c_12502_n N_GND_c_12460_n \
 N_GND_c_12505_n N_GND_c_12723_n N_GND_c_12546_n N_GND_c_12547_n \
 N_GND_c_12588_n N_GND_c_12727_n N_GND_c_12685_n N_GND_c_12730_n \
 N_GND_c_13024_n N_GND_c_12829_n N_GND_c_12788_n N_GND_c_12871_n \
 N_GND_c_12915_n N_GND_c_12986_n N_GND_c_13031_n N_GND_c_13079_n \
 N_GND_c_13145_n N_GND_c_13087_n N_GND_c_13181_n N_GND_c_13184_n \
 N_GND_c_13147_n N_GND_c_12506_n N_GND_c_12320_n N_GND_c_12415_n \
 N_GND_c_12324_n N_GND_c_12334_n N_GND_c_12368_n N_GND_c_12378_n \
 N_GND_c_12418_n N_GND_c_12427_n N_GND_c_12467_n N_GND_c_12477_n \
 N_GND_c_12731_n N_GND_c_12550_n N_GND_c_12641_n N_GND_c_12553_n \
 N_GND_c_12563_n N_GND_c_12595_n N_GND_c_12605_n N_GND_c_12644_n \
 N_GND_c_12653_n N_GND_c_12692_n N_GND_c_12702_n N_GND_c_13032_n \
 N_GND_c_12833_n N_GND_c_12942_n N_GND_c_12836_n N_GND_c_12846_n \
 N_GND_c_12878_n N_GND_c_12888_n N_GND_c_12945_n N_GND_c_12954_n \
 N_GND_c_12993_n N_GND_c_13003_n N_GND_c_12337_n N_GND_c_12521_n \
 N_GND_c_12338_n N_GND_c_12339_n N_GND_c_12383_n N_GND_c_12432_n \
 N_GND_c_12481_n N_GND_c_12566_n N_GND_c_12567_n N_GND_c_12568_n \
 N_GND_c_12610_n N_GND_c_12658_n N_GND_c_12706_n N_GND_c_12849_n \
 N_GND_c_12801_n N_GND_c_12851_n N_GND_c_12893_n N_GND_c_12959_n \
 N_GND_c_13007_n N_GND_c_13101_n N_GND_c_13102_n N_GND_c_13157_n \
 N_GND_c_13891_p N_GND_c_13274_n N_GND_c_13278_n N_GND_c_12340_n \
 N_GND_c_12345_n N_GND_c_12385_n N_GND_c_12440_n N_GND_c_12483_n \
 N_GND_c_12535_n N_GND_c_12569_n N_GND_c_12573_n N_GND_c_12612_n \
 N_GND_c_12666_n N_GND_c_12708_n N_GND_c_12760_n N_GND_c_12823_n \
 N_GND_c_12825_n N_GND_c_12895_n N_GND_c_12925_n N_GND_c_13009_n \
 N_GND_c_13061_n N_GND_c_13115_n N_GND_c_13172_n N_GND_c_13173_n \
 N_GND_c_13293_n N_GND_M0_noxref_d N_GND_M3_noxref_d N_GND_M5_noxref_d \
 N_GND_M7_noxref_d N_GND_M9_noxref_d N_GND_M11_noxref_d N_GND_M13_noxref_d \
 N_GND_M16_noxref_d N_GND_M18_noxref_d N_GND_M20_noxref_d N_GND_M22_noxref_d \
 N_GND_M24_noxref_d N_GND_M26_noxref_d N_GND_M29_noxref_d N_GND_M31_noxref_d \
 N_GND_M33_noxref_d N_GND_M35_noxref_d N_GND_M37_noxref_d N_GND_M39_noxref_d \
 N_GND_M41_noxref_d N_GND_M43_noxref_d N_GND_M45_noxref_s )  PM_TMRDFFQX1\%GND
x_PM_TMRDFFQX1\%Q ( Q Q Q Q Q Q N_Q_c_13913_n N_Q_c_13922_n N_Q_c_13926_n \
 N_Q_c_13927_n N_Q_c_13929_n N_Q_c_13930_n N_Q_c_13933_n N_Q_c_13941_n \
 N_Q_M45_noxref_d N_Q_M136_noxref_d )  PM_TMRDFFQX1\%Q
x_PM_TMRDFFQX1\%noxref_31 ( N_noxref_31_c_13980_n N_noxref_31_c_13981_n \
 N_noxref_31_c_14005_n N_noxref_31_c_13995_n N_noxref_31_c_13989_n \
 N_noxref_31_M0_noxref_s )  PM_TMRDFFQX1\%noxref_31
x_PM_TMRDFFQX1\%noxref_32 ( N_noxref_32_c_14035_n N_noxref_32_c_14036_n \
 N_noxref_32_c_14082_n N_noxref_32_c_14038_n N_noxref_32_c_14040_n \
 N_noxref_32_c_14091_n N_noxref_32_M3_noxref_s )  PM_TMRDFFQX1\%noxref_32
x_PM_TMRDFFQX1\%noxref_33 ( N_noxref_33_c_14104_n N_noxref_33_c_14105_n \
 N_noxref_33_c_14148_n N_noxref_33_c_14112_n N_noxref_33_c_14117_n \
 N_noxref_33_c_14157_n N_noxref_33_M5_noxref_s )  PM_TMRDFFQX1\%noxref_33
x_PM_TMRDFFQX1\%noxref_34 ( N_noxref_34_c_14173_n N_noxref_34_c_14174_n \
 N_noxref_34_c_14216_n N_noxref_34_c_14181_n N_noxref_34_c_14186_n \
 N_noxref_34_c_14225_n N_noxref_34_M7_noxref_s )  PM_TMRDFFQX1\%noxref_34
x_PM_TMRDFFQX1\%noxref_35 ( N_noxref_35_c_14241_n N_noxref_35_c_14242_n \
 N_noxref_35_c_14286_n N_noxref_35_c_14249_n N_noxref_35_c_14254_n \
 N_noxref_35_c_14295_n N_noxref_35_M9_noxref_s )  PM_TMRDFFQX1\%noxref_35
x_PM_TMRDFFQX1\%noxref_36 ( N_noxref_36_c_14311_n N_noxref_36_c_14312_n \
 N_noxref_36_c_14355_n N_noxref_36_c_14319_n N_noxref_36_c_14327_n \
 N_noxref_36_c_14364_n N_noxref_36_M11_noxref_s )  PM_TMRDFFQX1\%noxref_36
x_PM_TMRDFFQX1\%noxref_37 ( N_noxref_37_c_14380_n N_noxref_37_c_14381_n \
 N_noxref_37_c_14406_n N_noxref_37_c_14396_n N_noxref_37_c_14394_n \
 N_noxref_37_M13_noxref_s )  PM_TMRDFFQX1\%noxref_37
x_PM_TMRDFFQX1\%noxref_38 ( N_noxref_38_c_14449_n N_noxref_38_c_14450_n \
 N_noxref_38_c_14485_n N_noxref_38_c_14439_n N_noxref_38_c_14440_n \
 N_noxref_38_c_14494_n N_noxref_38_M16_noxref_s )  PM_TMRDFFQX1\%noxref_38
x_PM_TMRDFFQX1\%noxref_39 ( N_noxref_39_c_14507_n N_noxref_39_c_14508_n \
 N_noxref_39_c_14551_n N_noxref_39_c_14515_n N_noxref_39_c_14520_n \
 N_noxref_39_c_14560_n N_noxref_39_M18_noxref_s )  PM_TMRDFFQX1\%noxref_39
x_PM_TMRDFFQX1\%noxref_40 ( N_noxref_40_c_14576_n N_noxref_40_c_14577_n \
 N_noxref_40_c_14619_n N_noxref_40_c_14584_n N_noxref_40_c_14589_n \
 N_noxref_40_c_14628_n N_noxref_40_M20_noxref_s )  PM_TMRDFFQX1\%noxref_40
x_PM_TMRDFFQX1\%noxref_41 ( N_noxref_41_c_14644_n N_noxref_41_c_14645_n \
 N_noxref_41_c_14687_n N_noxref_41_c_14652_n N_noxref_41_c_14657_n \
 N_noxref_41_c_14696_n N_noxref_41_M22_noxref_s )  PM_TMRDFFQX1\%noxref_41
x_PM_TMRDFFQX1\%noxref_42 ( N_noxref_42_c_14712_n N_noxref_42_c_14713_n \
 N_noxref_42_c_14755_n N_noxref_42_c_14720_n N_noxref_42_c_14728_n \
 N_noxref_42_c_14764_n N_noxref_42_M24_noxref_s )  PM_TMRDFFQX1\%noxref_42
x_PM_TMRDFFQX1\%noxref_43 ( N_noxref_43_c_14790_n N_noxref_43_c_14791_n \
 N_noxref_43_c_14806_n N_noxref_43_c_14780_n N_noxref_43_c_14782_n \
 N_noxref_43_M26_noxref_s )  PM_TMRDFFQX1\%noxref_43
x_PM_TMRDFFQX1\%noxref_44 ( N_noxref_44_c_14862_n N_noxref_44_c_14863_n \
 N_noxref_44_c_14886_n N_noxref_44_c_14839_n N_noxref_44_c_14843_n \
 N_noxref_44_c_14895_n N_noxref_44_M29_noxref_s )  PM_TMRDFFQX1\%noxref_44
x_PM_TMRDFFQX1\%noxref_45 ( N_noxref_45_c_14908_n N_noxref_45_c_14909_n \
 N_noxref_45_c_14952_n N_noxref_45_c_14916_n N_noxref_45_c_14921_n \
 N_noxref_45_c_14961_n N_noxref_45_M31_noxref_s )  PM_TMRDFFQX1\%noxref_45
x_PM_TMRDFFQX1\%noxref_46 ( N_noxref_46_c_14977_n N_noxref_46_c_14978_n \
 N_noxref_46_c_15020_n N_noxref_46_c_14985_n N_noxref_46_c_14992_n \
 N_noxref_46_c_15029_n N_noxref_46_M33_noxref_s )  PM_TMRDFFQX1\%noxref_46
x_PM_TMRDFFQX1\%noxref_47 ( N_noxref_47_c_15045_n N_noxref_47_c_15046_n \
 N_noxref_47_c_15090_n N_noxref_47_c_15053_n N_noxref_47_c_15058_n \
 N_noxref_47_c_15099_n N_noxref_47_M35_noxref_s )  PM_TMRDFFQX1\%noxref_47
x_PM_TMRDFFQX1\%noxref_48 ( N_noxref_48_c_15115_n N_noxref_48_c_15116_n \
 N_noxref_48_c_15159_n N_noxref_48_c_15123_n N_noxref_48_c_15131_n \
 N_noxref_48_c_15168_n N_noxref_48_M37_noxref_s )  PM_TMRDFFQX1\%noxref_48
x_PM_TMRDFFQX1\%noxref_49 ( N_noxref_49_c_15184_n N_noxref_49_c_15188_n \
 N_noxref_49_c_15229_n N_noxref_49_c_15197_n N_noxref_49_c_15207_n \
 N_noxref_49_c_15238_n N_noxref_49_M39_noxref_s )  PM_TMRDFFQX1\%noxref_49
x_PM_TMRDFFQX1\%noxref_51 ( N_noxref_51_c_15262_n N_noxref_51_c_15263_n \
 N_noxref_51_c_15304_n N_noxref_51_c_15270_n N_noxref_51_c_15278_n \
 N_noxref_51_c_15313_n N_noxref_51_M41_noxref_s )  PM_TMRDFFQX1\%noxref_51
x_PM_TMRDFFQX1\%noxref_52 ( N_noxref_52_c_15339_n N_noxref_52_c_15326_n \
 N_noxref_52_c_15374_n N_noxref_52_c_15327_n N_noxref_52_c_15331_n \
 N_noxref_52_c_15383_n N_noxref_52_M43_noxref_s )  PM_TMRDFFQX1\%noxref_52
cc_1 ( N_noxref_1_M57_noxref_g N_noxref_2_c_432_n ) capacitor c=0.00889217f \
 //x=10.08 //y=6.2 //x2=10.625 //y2=5.38
cc_2 ( N_noxref_1_c_2_p N_noxref_2_c_433_n ) capacitor c=0.00324213f //x=7.45 \
 //y=1.75 //x2=10.78 //y2=1.75
cc_3 ( N_noxref_1_c_3_p N_noxref_2_c_434_n ) capacitor c=0.00231467f //x=7.805 \
 //y=1.835 //x2=10.865 //y2=1.835
cc_4 ( N_noxref_1_c_4_p N_noxref_2_c_435_n ) capacitor c=0.00204244f //x=7.89 \
 //y=3.35 //x2=11.22 //y2=3.35
cc_5 ( N_noxref_1_c_5_p N_noxref_2_c_435_n ) capacitor c=0.00239728f //x=9.74 \
 //y=3.345 //x2=11.22 //y2=3.35
cc_6 ( N_noxref_1_c_6_p N_noxref_2_c_437_n ) capacitor c=0.00281705f //x=7.89 \
 //y=5.295 //x2=11.22 //y2=5.295
cc_7 ( N_noxref_1_c_7_p N_noxref_2_c_437_n ) capacitor c=0.00193818f //x=9.742 \
 //y=4.74 //x2=11.22 //y2=5.295
cc_8 ( N_noxref_1_c_8_p N_noxref_2_c_439_n ) capacitor c=0.00114153f //x=7.805 \
 //y=5.38 //x2=9.86 //y2=5.56
cc_9 ( N_noxref_1_c_9_p N_noxref_2_c_439_n ) capacitor c=5.6496e-19 //x=9.74 \
 //y=3.665 //x2=9.86 //y2=5.56
cc_10 ( N_noxref_1_c_10_p N_noxref_2_c_439_n ) capacitor c=5.29822e-19 \
 //x=7.41 //y=5.38 //x2=9.86 //y2=5.56
cc_11 ( N_noxref_1_c_11_p N_noxref_2_c_439_n ) capacitor c=0.00147119f \
 //x=7.41 //y=5.56 //x2=9.86 //y2=5.56
cc_12 ( N_noxref_1_c_12_p N_noxref_2_c_439_n ) capacitor c=0.0117744f //x=9.74 \
 //y=4.88 //x2=9.86 //y2=5.56
cc_13 ( N_noxref_1_c_13_p N_noxref_2_c_439_n ) capacitor c=0.00277154f \
 //x=9.74 //y=4.88 //x2=9.86 //y2=5.56
cc_14 ( N_noxref_1_M56_noxref_g N_noxref_2_c_439_n ) capacitor c=0.00201806f \
 //x=9.64 //y=6.2 //x2=9.86 //y2=5.56
cc_15 ( N_noxref_1_M57_noxref_g N_noxref_2_c_439_n ) capacitor c=0.00192712f \
 //x=10.08 //y=6.2 //x2=9.86 //y2=5.56
cc_16 ( N_noxref_1_c_16_p N_noxref_2_c_439_n ) capacitor c=0.00194573f \
 //x=9.74 //y=4.88 //x2=9.86 //y2=5.56
cc_17 ( N_noxref_1_c_17_p N_noxref_2_c_448_n ) capacitor c=6.99317e-19 \
 //x=7.45 //y=1.18 //x2=10.78 //y2=1.18
cc_18 ( N_noxref_1_c_18_p N_noxref_2_c_449_n ) capacitor c=0.00251357f \
 //x=9.74 //y=3.51 //x2=11.22 //y2=3.51
cc_19 ( N_noxref_1_c_19_p N_noxref_2_c_450_n ) capacitor c=0.00521181f \
 //x=9.735 //y=3.505 //x2=11.385 //y2=3.51
cc_20 ( N_noxref_1_c_12_p N_noxref_2_c_451_n ) capacitor c=0.00104426f \
 //x=9.74 //y=4.88 //x2=9.86 //y2=5.56
cc_21 ( N_noxref_1_c_13_p N_noxref_2_c_451_n ) capacitor c=0.00377369f \
 //x=9.74 //y=4.88 //x2=9.86 //y2=5.56
cc_22 ( N_noxref_1_M56_noxref_g N_noxref_2_c_451_n ) capacitor c=0.0158358f \
 //x=9.64 //y=6.2 //x2=9.86 //y2=5.56
cc_23 ( N_noxref_1_M57_noxref_g N_noxref_2_c_451_n ) capacitor c=0.0178987f \
 //x=10.08 //y=6.2 //x2=9.86 //y2=5.56
cc_24 ( N_noxref_1_c_16_p N_noxref_2_c_451_n ) capacitor c=0.0043218f //x=9.74 \
 //y=4.88 //x2=9.86 //y2=5.56
cc_25 ( N_noxref_1_M50_noxref_g N_noxref_3_c_714_n ) capacitor c=0.00955829f \
 //x=3.56 //y=6.2 //x2=3.665 //y2=5.335
cc_26 ( N_noxref_1_c_26_p N_noxref_3_c_715_n ) capacitor c=5.58535e-19 \
 //x=6.53 //y=5.56 //x2=3.78 //y2=5.56
cc_27 ( N_noxref_1_M50_noxref_g N_noxref_3_c_715_n ) capacitor c=0.00226521f \
 //x=3.56 //y=6.2 //x2=3.78 //y2=5.56
cc_28 ( N_noxref_1_M51_noxref_g N_noxref_3_c_715_n ) capacitor c=0.00368945f \
 //x=4 //y=6.2 //x2=3.78 //y2=5.56
cc_29 ( N_noxref_1_c_29_p N_noxref_3_c_718_n ) capacitor c=0.00109953f \
 //x=3.82 //y=3.67 //x2=4.475 //y2=5.335
cc_30 ( N_noxref_1_c_30_p N_noxref_3_c_718_n ) capacitor c=0.00228791f \
 //x=3.82 //y=4.75 //x2=4.475 //y2=5.335
cc_31 ( N_noxref_1_c_26_p N_noxref_3_c_718_n ) capacitor c=0.00104762f \
 //x=6.53 //y=5.56 //x2=4.475 //y2=5.335
cc_32 ( N_noxref_1_c_32_p N_noxref_3_c_718_n ) capacitor c=0.00130631f \
 //x=3.82 //y=4.88 //x2=4.475 //y2=5.335
cc_33 ( N_noxref_1_M51_noxref_g N_noxref_3_c_718_n ) capacitor c=0.0110523f \
 //x=4 //y=6.2 //x2=4.475 //y2=5.335
cc_34 ( N_noxref_1_c_29_p N_noxref_3_c_723_n ) capacitor c=2.43192e-19 \
 //x=3.82 //y=3.67 //x2=4.075 //y2=1.305
cc_35 ( N_noxref_1_c_17_p N_noxref_3_c_723_n ) capacitor c=6.5615e-19 //x=7.45 \
 //y=1.18 //x2=4.075 //y2=1.305
cc_36 ( N_noxref_1_c_36_p N_noxref_3_c_723_n ) capacitor c=2.18498e-19 \
 //x=3.985 //y=3.51 //x2=4.075 //y2=1.305
cc_37 ( N_noxref_1_c_37_p N_noxref_3_c_723_n ) capacitor c=4.64015e-19 \
 //x=3.81 //y=1.095 //x2=4.075 //y2=1.305
cc_38 ( N_noxref_1_c_38_p N_noxref_3_c_723_n ) capacitor c=0.0026012f //x=3.81 \
 //y=1.44 //x2=4.075 //y2=1.305
cc_39 ( N_noxref_1_c_39_p N_noxref_3_c_723_n ) capacitor c=5.29969e-19 \
 //x=4.185 //y=0.94 //x2=4.075 //y2=1.305
cc_40 ( N_noxref_1_c_40_p N_noxref_3_c_723_n ) capacitor c=5.00648e-19 \
 //x=4.185 //y=1.595 //x2=4.075 //y2=1.305
cc_41 ( N_noxref_1_c_41_p N_noxref_3_c_723_n ) capacitor c=5.28622e-19 \
 //x=4.34 //y=1.095 //x2=4.075 //y2=1.305
cc_42 ( N_noxref_1_c_42_p N_noxref_3_c_723_n ) capacitor c=0.00312156f \
 //x=4.34 //y=1.44 //x2=4.075 //y2=1.305
cc_43 ( N_noxref_1_c_2_p N_noxref_3_c_732_n ) capacitor c=0.00326079f //x=7.45 \
 //y=1.75 //x2=4.075 //y2=1.76
cc_44 ( N_noxref_1_c_38_p N_noxref_3_c_732_n ) capacitor c=0.00127432f \
 //x=3.81 //y=1.44 //x2=4.075 //y2=1.76
cc_45 ( N_noxref_1_c_45_p N_noxref_3_c_732_n ) capacitor c=0.00429966f \
 //x=3.81 //y=1.75 //x2=4.075 //y2=1.76
cc_46 ( N_noxref_1_c_40_p N_noxref_3_c_732_n ) capacitor c=0.00930387f \
 //x=4.185 //y=1.595 //x2=4.075 //y2=1.76
cc_47 ( N_noxref_1_c_42_p N_noxref_3_c_732_n ) capacitor c=0.00347599f \
 //x=4.34 //y=1.44 //x2=4.075 //y2=1.76
cc_48 ( N_noxref_1_c_48_p N_noxref_3_c_732_n ) capacitor c=0.00372124f \
 //x=3.82 //y=2.095 //x2=4.075 //y2=1.76
cc_49 ( N_noxref_1_c_49_p N_noxref_3_c_738_n ) capacitor c=0.00218808f \
 //x=7.535 //y=1.835 //x2=4.475 //y2=1.845
cc_50 ( N_noxref_1_c_4_p N_noxref_3_c_738_n ) capacitor c=0.00203605f //x=7.89 \
 //y=3.35 //x2=4.475 //y2=1.845
cc_51 ( N_noxref_1_c_51_p N_noxref_3_c_738_n ) capacitor c=0.00343082f \
 //x=4.175 //y=3.51 //x2=4.475 //y2=1.845
cc_52 ( N_noxref_1_c_40_p N_noxref_3_c_738_n ) capacitor c=0.00194716f \
 //x=4.185 //y=1.595 //x2=4.475 //y2=1.845
cc_53 ( N_noxref_1_c_42_p N_noxref_3_c_738_n ) capacitor c=0.00323576f \
 //x=4.34 //y=1.44 //x2=4.475 //y2=1.845
cc_54 ( N_noxref_1_c_29_p N_noxref_3_c_743_n ) capacitor c=0.00112398f \
 //x=3.82 //y=3.67 //x2=4.16 //y2=1.845
cc_55 ( N_noxref_1_c_51_p N_noxref_3_c_743_n ) capacitor c=0.00421491f \
 //x=4.175 //y=3.51 //x2=4.16 //y2=1.845
cc_56 ( N_noxref_1_c_56_p N_noxref_3_c_745_n ) capacitor c=0.0154269f //x=3.82 \
 //y=2.375 //x2=4.56 //y2=3.72
cc_57 ( N_noxref_1_c_57_p N_noxref_3_c_745_n ) capacitor c=0.0444717f //x=3.82 \
 //y=3.35 //x2=4.56 //y2=3.72
cc_58 ( N_noxref_1_c_29_p N_noxref_3_c_745_n ) capacitor c=0.017329f //x=3.82 \
 //y=3.67 //x2=4.56 //y2=3.72
cc_59 ( N_noxref_1_c_30_p N_noxref_3_c_745_n ) capacitor c=0.00225898f \
 //x=3.82 //y=4.75 //x2=4.56 //y2=3.72
cc_60 ( N_noxref_1_c_60_p N_noxref_3_c_745_n ) capacitor c=6.78671e-19 \
 //x=3.82 //y=3.51 //x2=4.56 //y2=3.72
cc_61 ( N_noxref_1_c_51_p N_noxref_3_c_745_n ) capacitor c=2.75635e-19 \
 //x=4.175 //y=3.51 //x2=4.56 //y2=3.72
cc_62 ( N_noxref_1_c_36_p N_noxref_3_c_745_n ) capacitor c=0.00308371f \
 //x=3.985 //y=3.51 //x2=4.56 //y2=3.72
cc_63 ( N_noxref_1_c_63_p N_noxref_3_c_745_n ) capacitor c=0.0277316f \
 //x=4.775 //y=3.495 //x2=4.56 //y2=3.72
cc_64 ( N_noxref_1_c_64_p N_noxref_3_c_745_n ) capacitor c=0.00163444f \
 //x=3.82 //y=2.26 //x2=4.56 //y2=3.72
cc_65 ( N_noxref_1_c_65_p N_noxref_3_c_745_n ) capacitor c=0.0025845f //x=3.82 \
 //y=2.26 //x2=4.56 //y2=3.72
cc_66 ( N_noxref_1_c_48_p N_noxref_3_c_745_n ) capacitor c=0.00282067f \
 //x=3.82 //y=2.095 //x2=4.56 //y2=3.72
cc_67 ( N_noxref_1_c_30_p N_noxref_3_c_756_n ) capacitor c=0.0148501f //x=3.82 \
 //y=4.75 //x2=4.56 //y2=4.04
cc_68 ( N_noxref_1_c_63_p N_noxref_3_c_756_n ) capacitor c=0.00899533f \
 //x=4.775 //y=3.495 //x2=4.56 //y2=4.04
cc_69 ( N_noxref_1_c_30_p N_noxref_3_c_758_n ) capacitor c=0.0416218f //x=3.82 \
 //y=4.75 //x2=4.56 //y2=5.25
cc_70 ( N_noxref_1_c_6_p N_noxref_3_c_758_n ) capacitor c=0.00283621f //x=7.89 \
 //y=5.295 //x2=4.56 //y2=5.25
cc_71 ( N_noxref_1_c_32_p N_noxref_3_c_758_n ) capacitor c=0.00131258f \
 //x=3.82 //y=4.88 //x2=4.56 //y2=5.25
cc_72 ( N_noxref_1_c_72_p N_noxref_3_c_758_n ) capacitor c=0.00737085f \
 //x=3.82 //y=4.88 //x2=4.56 //y2=5.25
cc_73 ( N_noxref_1_c_57_p N_noxref_3_c_762_n ) capacitor c=0.00216701f \
 //x=3.82 //y=3.35 //x2=6.41 //y2=3.72
cc_74 ( N_noxref_1_c_4_p N_noxref_3_c_762_n ) capacitor c=0.00288961f //x=7.89 \
 //y=3.35 //x2=6.41 //y2=3.72
cc_75 ( N_noxref_1_c_75_p N_noxref_3_c_762_n ) capacitor c=4.98743e-19 \
 //x=6.02 //y=3.51 //x2=6.41 //y2=3.72
cc_76 ( N_noxref_1_c_76_p N_noxref_3_c_762_n ) capacitor c=0.0272333f //x=6.62 \
 //y=3.495 //x2=6.41 //y2=3.72
cc_77 ( N_noxref_1_c_77_p N_noxref_3_c_762_n ) capacitor c=3.14213e-19 \
 //x=8.045 //y=3.51 //x2=6.41 //y2=3.72
cc_78 ( N_noxref_1_c_26_p N_noxref_3_c_767_n ) capacitor c=7.23153e-19 \
 //x=6.53 //y=5.56 //x2=6.41 //y2=4.04
cc_79 ( N_noxref_1_c_75_p N_noxref_3_c_767_n ) capacitor c=0.00229532f \
 //x=6.02 //y=3.51 //x2=6.41 //y2=4.04
cc_80 ( N_noxref_1_c_76_p N_noxref_3_c_767_n ) capacitor c=0.00505309f \
 //x=6.62 //y=3.495 //x2=6.41 //y2=4.04
cc_81 ( N_noxref_1_c_81_p N_noxref_3_c_767_n ) capacitor c=2.08455e-19 \
 //x=6.53 //y=5.56 //x2=6.41 //y2=4.04
cc_82 ( N_noxref_1_c_29_p N_noxref_3_c_771_n ) capacitor c=6.86112e-19 \
 //x=3.82 //y=3.67 //x2=3.78 //y2=5.335
cc_83 ( N_noxref_1_c_30_p N_noxref_3_c_771_n ) capacitor c=0.0228808f //x=3.82 \
 //y=4.75 //x2=3.78 //y2=5.335
cc_84 ( N_noxref_1_c_32_p N_noxref_3_c_771_n ) capacitor c=0.00346456f \
 //x=3.82 //y=4.88 //x2=3.78 //y2=5.335
cc_85 ( N_noxref_1_c_72_p N_noxref_3_c_771_n ) capacitor c=0.00203307f \
 //x=3.82 //y=4.88 //x2=3.78 //y2=5.335
cc_86 ( N_noxref_1_c_30_p N_noxref_3_c_775_n ) capacitor c=6.03895e-19 \
 //x=3.82 //y=4.75 //x2=4.56 //y2=3.88
cc_87 ( N_noxref_1_c_76_p N_noxref_3_c_776_n ) capacitor c=0.00211017f \
 //x=6.62 //y=3.495 //x2=6.41 //y2=2.26
cc_88 ( N_noxref_1_c_26_p N_noxref_3_c_777_n ) capacitor c=0.0117744f //x=6.53 \
 //y=5.56 //x2=6.41 //y2=4.88
cc_89 ( N_noxref_1_c_81_p N_noxref_3_c_777_n ) capacitor c=0.00104426f \
 //x=6.53 //y=5.56 //x2=6.41 //y2=4.88
cc_90 ( N_noxref_1_c_30_p N_noxref_3_c_779_n ) capacitor c=8.55722e-19 \
 //x=3.82 //y=4.75 //x2=6.412 //y2=4.74
cc_91 ( N_noxref_1_c_6_p N_noxref_3_c_779_n ) capacitor c=0.00133619f //x=7.89 \
 //y=5.295 //x2=6.412 //y2=4.74
cc_92 ( N_noxref_1_c_63_p N_noxref_3_c_781_n ) capacitor c=0.132114f //x=4.775 \
 //y=3.495 //x2=6.245 //y2=3.88
cc_93 ( N_noxref_1_c_75_p N_noxref_3_c_781_n ) capacitor c=0.01106f //x=6.02 \
 //y=3.51 //x2=6.245 //y2=3.88
cc_94 ( N_noxref_1_c_30_p N_noxref_3_c_783_n ) capacitor c=0.00686853f \
 //x=3.82 //y=4.75 //x2=4.72 //y2=3.88
cc_95 ( N_noxref_1_c_63_p N_noxref_3_c_783_n ) capacitor c=0.0365231f \
 //x=4.775 //y=3.495 //x2=4.72 //y2=3.88
cc_96 ( N_noxref_1_c_96_p N_noxref_3_c_785_n ) capacitor c=0.0033292f //x=7.89 \
 //y=3.67 //x2=8.1 //y2=3.895
cc_97 ( N_noxref_1_c_6_p N_noxref_3_c_785_n ) capacitor c=0.0226441f //x=7.89 \
 //y=5.295 //x2=8.1 //y2=3.895
cc_98 ( N_noxref_1_c_98_p N_noxref_3_c_785_n ) capacitor c=0.129077f //x=9.575 \
 //y=3.505 //x2=8.1 //y2=3.895
cc_99 ( N_noxref_1_c_96_p N_noxref_3_c_788_n ) capacitor c=0.00307263f \
 //x=7.89 //y=3.67 //x2=7.755 //y2=3.895
cc_100 ( N_noxref_1_c_6_p N_noxref_3_c_788_n ) capacitor c=3.08624e-19 \
 //x=7.89 //y=5.295 //x2=7.755 //y2=3.895
cc_101 ( N_noxref_1_c_76_p N_noxref_3_c_788_n ) capacitor c=0.0488575f \
 //x=6.62 //y=3.495 //x2=7.755 //y2=3.895
cc_102 ( N_noxref_1_c_77_p N_noxref_3_c_788_n ) capacitor c=0.122226f \
 //x=8.045 //y=3.51 //x2=7.755 //y2=3.895
cc_103 ( N_noxref_1_c_9_p N_noxref_3_c_792_n ) capacitor c=0.00342917f \
 //x=9.74 //y=3.665 //x2=9.35 //y2=3.88
cc_104 ( N_noxref_1_c_7_p N_noxref_3_c_792_n ) capacitor c=3.32529e-19 \
 //x=9.742 //y=4.74 //x2=9.35 //y2=3.88
cc_105 ( N_noxref_1_c_19_p N_noxref_3_c_792_n ) capacitor c=0.0358254f \
 //x=9.735 //y=3.505 //x2=9.35 //y2=3.88
cc_106 ( N_noxref_1_c_98_p N_noxref_3_c_792_n ) capacitor c=0.0109335f \
 //x=9.575 //y=3.505 //x2=9.35 //y2=3.88
cc_107 ( N_noxref_1_c_9_p N_noxref_3_c_796_n ) capacitor c=0.00251313f \
 //x=9.74 //y=3.665 //x2=9.95 //y2=3.89
cc_108 ( N_noxref_1_c_7_p N_noxref_3_c_796_n ) capacitor c=0.0228906f \
 //x=9.742 //y=4.74 //x2=9.95 //y2=3.89
cc_109 ( N_noxref_1_c_30_p N_noxref_3_c_798_n ) capacitor c=0.00217653f \
 //x=3.82 //y=4.75 //x2=3.78 //y2=5.56
cc_110 ( N_noxref_1_c_32_p N_noxref_3_c_798_n ) capacitor c=0.00624059f \
 //x=3.82 //y=4.88 //x2=3.78 //y2=5.56
cc_111 ( N_noxref_1_M50_noxref_g N_noxref_3_c_798_n ) capacitor c=0.0178885f \
 //x=3.56 //y=6.2 //x2=3.78 //y2=5.56
cc_112 ( N_noxref_1_M51_noxref_g N_noxref_3_c_798_n ) capacitor c=0.0188608f \
 //x=4 //y=6.2 //x2=3.78 //y2=5.56
cc_113 ( N_noxref_1_c_72_p N_noxref_3_c_798_n ) capacitor c=0.00375636f \
 //x=3.82 //y=4.88 //x2=3.78 //y2=5.56
cc_114 ( N_noxref_1_c_26_p N_noxref_3_c_803_n ) capacitor c=0.00277154f \
 //x=6.53 //y=5.56 //x2=6.41 //y2=4.88
cc_115 ( N_noxref_1_c_81_p N_noxref_3_c_803_n ) capacitor c=0.00377369f \
 //x=6.53 //y=5.56 //x2=6.41 //y2=4.88
cc_116 ( N_noxref_1_c_26_p N_noxref_3_M52_noxref_g ) capacitor c=0.00201806f \
 //x=6.53 //y=5.56 //x2=6.31 //y2=6.2
cc_117 ( N_noxref_1_c_81_p N_noxref_3_M52_noxref_g ) capacitor c=0.0158358f \
 //x=6.53 //y=5.56 //x2=6.31 //y2=6.2
cc_118 ( N_noxref_1_c_118_p N_noxref_3_M53_noxref_g ) capacitor c=0.00889217f \
 //x=7.295 //y=5.38 //x2=6.75 //y2=6.2
cc_119 ( N_noxref_1_c_26_p N_noxref_3_M53_noxref_g ) capacitor c=0.00192712f \
 //x=6.53 //y=5.56 //x2=6.75 //y2=6.2
cc_120 ( N_noxref_1_c_81_p N_noxref_3_M53_noxref_g ) capacitor c=0.0178987f \
 //x=6.53 //y=5.56 //x2=6.75 //y2=6.2
cc_121 ( N_noxref_1_c_26_p N_noxref_3_c_810_n ) capacitor c=0.00189999f \
 //x=6.53 //y=5.56 //x2=6.41 //y2=4.88
cc_122 ( N_noxref_1_c_81_p N_noxref_3_c_810_n ) capacitor c=0.0043218f \
 //x=6.53 //y=5.56 //x2=6.41 //y2=4.88
cc_123 ( N_noxref_1_c_37_p N_noxref_3_M2_noxref_d ) capacitor c=0.00137165f \
 //x=3.81 //y=1.095 //x2=3.885 //y2=1.095
cc_124 ( N_noxref_1_c_38_p N_noxref_3_M2_noxref_d ) capacitor c=0.00237422f \
 //x=3.81 //y=1.44 //x2=3.885 //y2=1.095
cc_125 ( N_noxref_1_c_39_p N_noxref_3_M2_noxref_d ) capacitor c=0.0020782f \
 //x=4.185 //y=0.94 //x2=3.885 //y2=1.095
cc_126 ( N_noxref_1_c_40_p N_noxref_3_M2_noxref_d ) capacitor c=0.00356097f \
 //x=4.185 //y=1.595 //x2=3.885 //y2=1.095
cc_127 ( N_noxref_1_c_41_p N_noxref_3_M2_noxref_d ) capacitor c=0.00139206f \
 //x=4.34 //y=1.095 //x2=3.885 //y2=1.095
cc_128 ( N_noxref_1_c_42_p N_noxref_3_M2_noxref_d ) capacitor c=0.00237422f \
 //x=4.34 //y=1.44 //x2=3.885 //y2=1.095
cc_129 ( N_noxref_1_c_57_p N_noxref_5_c_1479_n ) capacitor c=0.00142312f \
 //x=3.82 //y=3.35 //x2=1.6 //y2=4.095
cc_130 ( N_noxref_1_c_30_p N_noxref_5_c_1479_n ) capacitor c=7.99748e-19 \
 //x=3.82 //y=4.75 //x2=1.6 //y2=4.095
cc_131 ( N_noxref_1_c_30_p N_noxref_5_c_1481_n ) capacitor c=5.49831e-19 \
 //x=3.82 //y=4.75 //x2=1.6 //y2=4.755
cc_132 ( N_noxref_1_c_4_p N_noxref_5_c_1482_n ) capacitor c=0.00162115f \
 //x=7.89 //y=3.35 //x2=10.48 //y2=4.095
cc_133 ( N_noxref_1_c_6_p N_noxref_5_c_1482_n ) capacitor c=3.20827e-19 \
 //x=7.89 //y=5.295 //x2=10.48 //y2=4.095
cc_134 ( N_noxref_1_c_5_p N_noxref_5_c_1482_n ) capacitor c=0.0407124f \
 //x=9.74 //y=3.345 //x2=10.48 //y2=4.095
cc_135 ( N_noxref_1_c_9_p N_noxref_5_c_1482_n ) capacitor c=0.0146933f \
 //x=9.74 //y=3.665 //x2=10.48 //y2=4.095
cc_136 ( N_noxref_1_c_18_p N_noxref_5_c_1482_n ) capacitor c=5.57251e-19 \
 //x=9.74 //y=3.51 //x2=10.48 //y2=4.095
cc_137 ( N_noxref_1_c_7_p N_noxref_5_c_1482_n ) capacitor c=0.0171876f \
 //x=9.742 //y=4.74 //x2=10.48 //y2=4.095
cc_138 ( N_noxref_1_c_19_p N_noxref_5_c_1482_n ) capacitor c=0.00364775f \
 //x=9.735 //y=3.505 //x2=10.48 //y2=4.095
cc_139 ( N_noxref_1_c_139_p N_noxref_5_c_1482_n ) capacitor c=3.49899e-19 \
 //x=9.74 //y=2.26 //x2=10.48 //y2=4.095
cc_140 ( N_noxref_1_c_7_p N_noxref_5_c_1490_n ) capacitor c=0.0172847f \
 //x=9.742 //y=4.74 //x2=10.48 //y2=4.415
cc_141 ( N_noxref_1_c_6_p N_noxref_5_c_1491_n ) capacitor c=7.6298e-19 \
 //x=7.89 //y=5.295 //x2=10.48 //y2=4.735
cc_142 ( N_noxref_1_c_12_p N_noxref_5_c_1491_n ) capacitor c=0.0172958f \
 //x=9.74 //y=4.88 //x2=10.48 //y2=4.735
cc_143 ( N_noxref_1_c_7_p N_noxref_5_c_1491_n ) capacitor c=0.0114865f \
 //x=9.742 //y=4.74 //x2=10.48 //y2=4.735
cc_144 ( N_noxref_1_c_13_p N_noxref_5_c_1491_n ) capacitor c=7.25895e-19 \
 //x=9.74 //y=4.88 //x2=10.48 //y2=4.735
cc_145 ( N_noxref_1_c_16_p N_noxref_5_c_1491_n ) capacitor c=0.00200292f \
 //x=9.74 //y=4.88 //x2=10.48 //y2=4.735
cc_146 ( N_noxref_1_c_7_p N_noxref_5_c_1496_n ) capacitor c=6.89957e-19 \
 //x=9.742 //y=4.74 //x2=10.48 //y2=4.25
cc_147 ( N_noxref_1_c_147_p N_noxref_5_c_1497_n ) capacitor c=0.0205342f \
 //x=9.74 //y=2.26 //x2=10.48 //y2=2.26
cc_148 ( N_noxref_1_c_139_p N_noxref_5_c_1497_n ) capacitor c=5.16867e-19 \
 //x=9.74 //y=2.26 //x2=10.48 //y2=2.26
cc_149 ( N_noxref_1_c_149_p N_noxref_5_c_1497_n ) capacitor c=0.00167888f \
 //x=9.545 //y=2.095 //x2=10.48 //y2=2.26
cc_150 ( N_noxref_1_c_29_p N_noxref_5_c_1500_n ) capacitor c=0.0031669f \
 //x=3.82 //y=3.67 //x2=4.175 //y2=4.25
cc_151 ( N_noxref_1_c_30_p N_noxref_5_c_1500_n ) capacitor c=0.0245794f \
 //x=3.82 //y=4.75 //x2=4.175 //y2=4.25
cc_152 ( N_noxref_1_c_51_p N_noxref_5_c_1500_n ) capacitor c=0.0160215f \
 //x=4.175 //y=3.51 //x2=4.175 //y2=4.25
cc_153 ( N_noxref_1_c_36_p N_noxref_5_c_1500_n ) capacitor c=0.0160589f \
 //x=3.985 //y=3.51 //x2=4.175 //y2=4.25
cc_154 ( N_noxref_1_c_63_p N_noxref_5_c_1504_n ) capacitor c=0.00873027f \
 //x=4.775 //y=3.495 //x2=4.775 //y2=4.265
cc_155 ( N_noxref_1_c_75_p N_noxref_5_c_1505_n ) capacitor c=0.00581051f \
 //x=6.02 //y=3.51 //x2=6.02 //y2=4.25
cc_156 ( N_noxref_1_c_76_p N_noxref_5_c_1506_n ) capacitor c=0.00139876f \
 //x=6.62 //y=3.495 //x2=6.62 //y2=4.265
cc_157 ( N_noxref_1_c_6_p N_noxref_5_c_1507_n ) capacitor c=0.0232181f \
 //x=7.89 //y=5.295 //x2=10.645 //y2=4.25
cc_158 ( N_noxref_1_c_7_p N_noxref_5_c_1507_n ) capacitor c=0.0254145f \
 //x=9.742 //y=4.74 //x2=10.645 //y2=4.25
cc_159 ( N_noxref_1_c_77_p N_noxref_5_c_1507_n ) capacitor c=0.00966898f \
 //x=8.045 //y=3.51 //x2=10.645 //y2=4.25
cc_160 ( N_noxref_1_c_98_p N_noxref_5_c_1507_n ) capacitor c=0.0104609f \
 //x=9.575 //y=3.505 //x2=10.645 //y2=4.25
cc_161 ( N_noxref_1_c_5_p N_noxref_5_c_1511_n ) capacitor c=3.49899e-19 \
 //x=9.74 //y=3.345 //x2=10.48 //y2=2.26
cc_162 ( N_noxref_1_c_147_p N_noxref_5_c_1511_n ) capacitor c=5.24723e-19 \
 //x=9.74 //y=2.26 //x2=10.48 //y2=2.26
cc_163 ( N_noxref_1_c_139_p N_noxref_5_c_1511_n ) capacitor c=0.00525888f \
 //x=9.74 //y=2.26 //x2=10.48 //y2=2.26
cc_164 ( N_noxref_1_c_149_p N_noxref_5_c_1511_n ) capacitor c=0.00190888f \
 //x=9.545 //y=2.095 //x2=10.48 //y2=2.26
cc_165 ( N_noxref_1_c_12_p N_noxref_5_c_1515_n ) capacitor c=4.80626e-19 \
 //x=9.74 //y=4.88 //x2=10.51 //y2=4.88
cc_166 ( N_noxref_1_c_13_p N_noxref_5_c_1515_n ) capacitor c=0.00397338f \
 //x=9.74 //y=4.88 //x2=10.51 //y2=4.88
cc_167 ( N_noxref_1_c_16_p N_noxref_5_c_1515_n ) capacitor c=0.00283894f \
 //x=9.74 //y=4.88 //x2=10.51 //y2=4.88
cc_168 ( N_noxref_1_M56_noxref_g N_noxref_5_M58_noxref_g ) capacitor \
 c=0.0104892f //x=9.64 //y=6.2 //x2=10.52 //y2=6.2
cc_169 ( N_noxref_1_M57_noxref_g N_noxref_5_M58_noxref_g ) capacitor \
 c=0.107636f //x=10.08 //y=6.2 //x2=10.52 //y2=6.2
cc_170 ( N_noxref_1_M57_noxref_g N_noxref_5_M59_noxref_g ) capacitor \
 c=0.0100341f //x=10.08 //y=6.2 //x2=10.96 //y2=6.2
cc_171 ( N_noxref_1_c_171_p N_noxref_5_c_1521_n ) capacitor c=4.86545e-19 \
 //x=9.545 //y=1.045 //x2=10.515 //y2=1.085
cc_172 ( N_noxref_1_c_172_p N_noxref_5_c_1521_n ) capacitor c=0.00152405f \
 //x=9.545 //y=1.39 //x2=10.515 //y2=1.085
cc_173 ( N_noxref_1_c_173_p N_noxref_5_c_1521_n ) capacitor c=0.0151475f \
 //x=10.075 //y=1.045 //x2=10.515 //y2=1.085
cc_174 ( N_noxref_1_c_174_p N_noxref_5_c_1524_n ) capacitor c=0.00109982f \
 //x=9.545 //y=1.7 //x2=10.515 //y2=1.43
cc_175 ( N_noxref_1_c_175_p N_noxref_5_c_1524_n ) capacitor c=0.0111064f \
 //x=10.075 //y=1.39 //x2=10.515 //y2=1.43
cc_176 ( N_noxref_1_c_174_p N_noxref_5_c_1526_n ) capacitor c=9.58243e-19 \
 //x=9.545 //y=1.7 //x2=10.515 //y2=1.74
cc_177 ( N_noxref_1_c_149_p N_noxref_5_c_1526_n ) capacitor c=0.00662747f \
 //x=9.545 //y=2.095 //x2=10.515 //y2=1.74
cc_178 ( N_noxref_1_c_175_p N_noxref_5_c_1526_n ) capacitor c=0.00862358f \
 //x=10.075 //y=1.39 //x2=10.515 //y2=1.74
cc_179 ( N_noxref_1_c_173_p N_noxref_5_c_1529_n ) capacitor c=0.00127211f \
 //x=10.075 //y=1.045 //x2=11.045 //y2=1.085
cc_180 ( N_noxref_1_c_175_p N_noxref_5_c_1530_n ) capacitor c=0.00204774f \
 //x=10.075 //y=1.39 //x2=11.045 //y2=1.43
cc_181 ( N_noxref_1_c_147_p N_noxref_5_c_1531_n ) capacitor c=0.00167305f \
 //x=9.74 //y=2.26 //x2=10.48 //y2=2.26
cc_182 ( N_noxref_1_c_139_p N_noxref_5_c_1531_n ) capacitor c=0.0018937f \
 //x=9.74 //y=2.26 //x2=10.48 //y2=2.26
cc_183 ( N_noxref_1_c_149_p N_noxref_5_c_1531_n ) capacitor c=0.0181449f \
 //x=9.545 //y=2.095 //x2=10.48 //y2=2.26
cc_184 ( N_noxref_1_c_12_p N_noxref_5_c_1534_n ) capacitor c=0.00158715f \
 //x=9.74 //y=4.88 //x2=10.51 //y2=4.88
cc_185 ( N_noxref_1_c_13_p N_noxref_5_c_1534_n ) capacitor c=0.00237977f \
 //x=9.74 //y=4.88 //x2=10.51 //y2=4.88
cc_186 ( N_noxref_1_c_16_p N_noxref_5_c_1534_n ) capacitor c=0.0297875f \
 //x=9.74 //y=4.88 //x2=10.51 //y2=4.88
cc_187 ( N_noxref_1_c_4_p D ) capacitor c=0.0192736f //x=7.89 //y=3.35 \
 //x2=7.15 //y2=3.14
cc_188 ( N_noxref_1_c_96_p D ) capacitor c=0.0174172f //x=7.89 //y=3.67 \
 //x2=7.15 //y2=3.14
cc_189 ( N_noxref_1_c_6_p D ) capacitor c=0.0397921f //x=7.89 //y=5.295 \
 //x2=7.15 //y2=3.14
cc_190 ( N_noxref_1_c_5_p D ) capacitor c=4.07753e-19 //x=9.74 //y=3.345 \
 //x2=7.15 //y2=3.14
cc_191 ( N_noxref_1_c_191_p D ) capacitor c=6.03895e-19 //x=7.885 //y=3.51 \
 //x2=7.15 //y2=3.14
cc_192 ( N_noxref_1_c_7_p D ) capacitor c=0.00136917f //x=9.742 //y=4.74 \
 //x2=7.15 //y2=3.14
cc_193 ( N_noxref_1_c_77_p D ) capacitor c=0.0248809f //x=8.045 //y=3.51 \
 //x2=7.15 //y2=3.14
cc_194 ( N_noxref_1_c_4_p D ) capacitor c=6.45303e-19 //x=7.89 //y=3.35 \
 //x2=7.15 //y2=2.77
cc_195 ( N_noxref_1_c_4_p N_D_c_4236_n ) capacitor c=0.0098227f //x=7.89 \
 //y=3.35 //x2=7.15 //y2=2.625
cc_196 ( N_noxref_1_c_5_p N_D_c_4236_n ) capacitor c=6.43802e-19 //x=9.74 \
 //y=3.345 //x2=7.15 //y2=2.625
cc_197 ( N_noxref_1_c_118_p N_D_c_4238_n ) capacitor c=8.06101e-19 //x=7.295 \
 //y=5.38 //x2=7.15 //y2=2.945
cc_198 ( N_noxref_1_c_49_p N_D_c_4238_n ) capacitor c=0.00129986f //x=7.535 \
 //y=1.835 //x2=7.15 //y2=2.945
cc_199 ( N_noxref_1_c_4_p N_D_c_4238_n ) capacitor c=0.0176724f //x=7.89 \
 //y=3.35 //x2=7.15 //y2=2.945
cc_200 ( N_noxref_1_c_10_p N_D_c_4238_n ) capacitor c=8.40062e-19 //x=7.41 \
 //y=5.38 //x2=7.15 //y2=2.945
cc_201 ( N_noxref_1_c_17_p N_D_c_4238_n ) capacitor c=3.5828e-19 //x=7.45 \
 //y=1.18 //x2=7.15 //y2=2.945
cc_202 ( N_noxref_1_c_77_p N_D_c_4238_n ) capacitor c=0.00344449f //x=8.045 \
 //y=3.51 //x2=7.15 //y2=2.945
cc_203 ( N_noxref_1_c_203_p N_D_c_4238_n ) capacitor c=2.14011e-19 //x=7.41 \
 //y=5.56 //x2=7.15 //y2=2.945
cc_204 ( N_noxref_1_M4_noxref_d N_D_c_4238_n ) capacitor c=3.01409e-19 \
 //x=7.26 //y=1.085 //x2=7.15 //y2=2.945
cc_205 ( N_noxref_1_c_118_p N_D_c_4246_n ) capacitor c=0.0217631f //x=7.295 \
 //y=5.38 //x2=7.15 //y2=4.735
cc_206 ( N_noxref_1_c_6_p N_D_c_4246_n ) capacitor c=0.016905f //x=7.89 \
 //y=5.295 //x2=7.15 //y2=4.735
cc_207 ( N_noxref_1_c_4_p N_D_c_4248_n ) capacitor c=0.015397f //x=7.89 \
 //y=3.35 //x2=7.15 //y2=2.26
cc_208 ( N_noxref_1_c_4_p N_D_c_4249_n ) capacitor c=0.00338457f //x=7.89 \
 //y=3.35 //x2=7.315 //y2=2.785
cc_209 ( N_noxref_1_c_77_p N_D_c_4249_n ) capacitor c=0.0164948f //x=8.045 \
 //y=3.51 //x2=7.315 //y2=2.785
cc_210 ( N_noxref_1_c_49_p N_D_c_4251_n ) capacitor c=0.0119025f //x=7.535 \
 //y=1.835 //x2=28.435 //y2=2.78
cc_211 ( N_noxref_1_c_4_p N_D_c_4251_n ) capacitor c=0.029893f //x=7.89 \
 //y=3.35 //x2=28.435 //y2=2.78
cc_212 ( N_noxref_1_c_96_p N_D_c_4251_n ) capacitor c=0.00353336f //x=7.89 \
 //y=3.67 //x2=28.435 //y2=2.78
cc_213 ( N_noxref_1_c_5_p N_D_c_4251_n ) capacitor c=0.0294215f //x=9.74 \
 //y=3.345 //x2=28.435 //y2=2.78
cc_214 ( N_noxref_1_c_9_p N_D_c_4251_n ) capacitor c=0.00397204f //x=9.74 \
 //y=3.665 //x2=28.435 //y2=2.78
cc_215 ( N_noxref_1_c_17_p N_D_c_4251_n ) capacitor c=3.52789e-19 //x=7.45 \
 //y=1.18 //x2=28.435 //y2=2.78
cc_216 ( N_noxref_1_c_147_p N_D_c_4251_n ) capacitor c=0.00331451f //x=9.74 \
 //y=2.26 //x2=28.435 //y2=2.78
cc_217 ( N_noxref_1_c_77_p N_D_c_4251_n ) capacitor c=0.0332135f //x=8.045 \
 //y=3.51 //x2=28.435 //y2=2.78
cc_218 ( N_noxref_1_c_19_p N_D_c_4251_n ) capacitor c=0.0158964f //x=9.735 \
 //y=3.505 //x2=28.435 //y2=2.78
cc_219 ( N_noxref_1_c_98_p N_D_c_4251_n ) capacitor c=0.0725566f //x=9.575 \
 //y=3.505 //x2=28.435 //y2=2.78
cc_220 ( N_noxref_1_c_4_p N_D_c_4261_n ) capacitor c=9.90728e-19 //x=7.89 \
 //y=3.35 //x2=7.15 //y2=2.26
cc_221 ( N_noxref_1_c_118_p N_D_c_4262_n ) capacitor c=0.00469257f //x=7.295 \
 //y=5.38 //x2=7.18 //y2=4.88
cc_222 ( N_noxref_1_c_6_p N_D_c_4262_n ) capacitor c=7.76118e-19 //x=7.89 \
 //y=5.295 //x2=7.18 //y2=4.88
cc_223 ( N_noxref_1_c_118_p N_D_M54_noxref_g ) capacitor c=0.00842859f \
 //x=7.295 //y=5.38 //x2=7.19 //y2=6.2
cc_224 ( N_noxref_1_c_10_p N_D_M54_noxref_g ) capacitor c=0.00192712f //x=7.41 \
 //y=5.38 //x2=7.19 //y2=6.2
cc_225 ( N_noxref_1_c_203_p N_D_M54_noxref_g ) capacitor c=0.0178987f //x=7.41 \
 //y=5.56 //x2=7.19 //y2=6.2
cc_226 ( N_noxref_1_c_8_p N_D_M55_noxref_g ) capacitor c=0.0107429f //x=7.805 \
 //y=5.38 //x2=7.63 //y2=6.2
cc_227 ( N_noxref_1_c_10_p N_D_M55_noxref_g ) capacitor c=0.00298276f //x=7.41 \
 //y=5.38 //x2=7.63 //y2=6.2
cc_228 ( N_noxref_1_c_203_p N_D_M55_noxref_g ) capacitor c=0.0178506f //x=7.41 \
 //y=5.56 //x2=7.63 //y2=6.2
cc_229 ( N_noxref_1_c_17_p N_D_c_4270_n ) capacitor c=0.00120406f //x=7.45 \
 //y=1.18 //x2=7.185 //y2=1.085
cc_230 ( N_noxref_1_M4_noxref_d N_D_c_4270_n ) capacitor c=0.00137165f \
 //x=7.26 //y=1.085 //x2=7.185 //y2=1.085
cc_231 ( N_noxref_1_c_2_p N_D_c_4272_n ) capacitor c=0.00119302f //x=7.45 \
 //y=1.75 //x2=7.185 //y2=1.43
cc_232 ( N_noxref_1_c_17_p N_D_c_4272_n ) capacitor c=0.00218772f //x=7.45 \
 //y=1.18 //x2=7.185 //y2=1.43
cc_233 ( N_noxref_1_M4_noxref_d N_D_c_4272_n ) capacitor c=0.00237422f \
 //x=7.26 //y=1.085 //x2=7.185 //y2=1.43
cc_234 ( N_noxref_1_c_2_p N_D_c_4275_n ) capacitor c=0.00473476f //x=7.45 \
 //y=1.75 //x2=7.185 //y2=1.74
cc_235 ( N_noxref_1_c_6_p N_D_c_4276_n ) capacitor c=0.00845606f //x=7.89 \
 //y=5.295 //x2=7.555 //y2=4.97
cc_236 ( N_noxref_1_c_10_p N_D_c_4276_n ) capacitor c=0.00201269f //x=7.41 \
 //y=5.38 //x2=7.555 //y2=4.97
cc_237 ( N_noxref_1_c_203_p N_D_c_4276_n ) capacitor c=0.00291714f //x=7.41 \
 //y=5.56 //x2=7.555 //y2=4.97
cc_238 ( N_noxref_1_c_17_p N_D_c_4279_n ) capacitor c=5.50523e-19 //x=7.45 \
 //y=1.18 //x2=7.56 //y2=0.93
cc_239 ( N_noxref_1_M4_noxref_d N_D_c_4279_n ) capacitor c=0.0020782f //x=7.26 \
 //y=1.085 //x2=7.56 //y2=0.93
cc_240 ( N_noxref_1_c_2_p N_D_c_4281_n ) capacitor c=0.00917366f //x=7.45 \
 //y=1.75 //x2=7.56 //y2=1.585
cc_241 ( N_noxref_1_c_3_p N_D_c_4281_n ) capacitor c=0.00194324f //x=7.805 \
 //y=1.835 //x2=7.56 //y2=1.585
cc_242 ( N_noxref_1_c_17_p N_D_c_4281_n ) capacitor c=4.66519e-19 //x=7.45 \
 //y=1.18 //x2=7.56 //y2=1.585
cc_243 ( N_noxref_1_M4_noxref_d N_D_c_4281_n ) capacitor c=0.00356097f \
 //x=7.26 //y=1.085 //x2=7.56 //y2=1.585
cc_244 ( N_noxref_1_c_17_p N_D_c_4285_n ) capacitor c=0.00109205f //x=7.45 \
 //y=1.18 //x2=7.715 //y2=1.085
cc_245 ( N_noxref_1_M4_noxref_d N_D_c_4285_n ) capacitor c=8.50095e-19 \
 //x=7.26 //y=1.085 //x2=7.715 //y2=1.085
cc_246 ( N_noxref_1_c_2_p N_D_c_4287_n ) capacitor c=0.003249f //x=7.45 \
 //y=1.75 //x2=7.715 //y2=1.43
cc_247 ( N_noxref_1_c_3_p N_D_c_4287_n ) capacitor c=0.00323005f //x=7.805 \
 //y=1.835 //x2=7.715 //y2=1.43
cc_248 ( N_noxref_1_c_17_p N_D_c_4287_n ) capacitor c=0.00317092f //x=7.45 \
 //y=1.18 //x2=7.715 //y2=1.43
cc_249 ( N_noxref_1_M4_noxref_d N_D_c_4287_n ) capacitor c=0.00237422f \
 //x=7.26 //y=1.085 //x2=7.715 //y2=1.43
cc_250 ( N_noxref_1_c_4_p N_D_c_4291_n ) capacitor c=0.00281392f //x=7.89 \
 //y=3.35 //x2=7.15 //y2=2.26
cc_251 ( N_noxref_1_c_2_p N_D_c_4292_n ) capacitor c=0.00341688f //x=7.45 \
 //y=1.75 //x2=7.15 //y2=2.095
cc_252 ( N_noxref_1_c_4_p N_D_c_4292_n ) capacitor c=0.00309058f //x=7.89 \
 //y=3.35 //x2=7.15 //y2=2.095
cc_253 ( N_noxref_1_c_118_p N_D_c_4294_n ) capacitor c=9.44683e-19 //x=7.295 \
 //y=5.38 //x2=7.18 //y2=4.88
cc_254 ( N_noxref_1_c_6_p N_D_c_4294_n ) capacitor c=0.00142201f //x=7.89 \
 //y=5.295 //x2=7.18 //y2=4.88
cc_255 ( N_noxref_1_c_57_p CLK ) capacitor c=0.029075f //x=3.82 //y=3.35 \
 //x2=2.71 //y2=2.77
cc_256 ( N_noxref_1_c_29_p CLK ) capacitor c=0.00769355f //x=3.82 //y=3.67 \
 //x2=2.71 //y2=2.77
cc_257 ( N_noxref_1_c_30_p CLK ) capacitor c=0.0251329f //x=3.82 //y=4.75 \
 //x2=2.71 //y2=2.77
cc_258 ( N_noxref_1_c_60_p CLK ) capacitor c=3.35971e-19 //x=3.82 //y=3.51 \
 //x2=2.71 //y2=2.77
cc_259 ( N_noxref_1_c_36_p CLK ) capacitor c=0.00507285f //x=3.985 //y=3.51 \
 //x2=2.71 //y2=2.77
cc_260 ( N_noxref_1_c_64_p CLK ) capacitor c=4.16726e-19 //x=3.82 //y=2.26 \
 //x2=2.71 //y2=2.77
cc_261 ( N_noxref_1_c_56_p N_CLK_c_5591_n ) capacitor c=0.0116288f //x=3.82 \
 //y=2.375 //x2=2.71 //y2=2.375
cc_262 ( N_noxref_1_c_64_p N_CLK_c_5591_n ) capacitor c=5.42289e-19 //x=3.82 \
 //y=2.26 //x2=2.71 //y2=2.375
cc_263 ( N_noxref_1_c_65_p N_CLK_c_5591_n ) capacitor c=0.00139071f //x=3.82 \
 //y=2.26 //x2=2.71 //y2=2.375
cc_264 ( N_noxref_1_c_30_p N_CLK_c_5594_n ) capacitor c=0.00713797f //x=3.82 \
 //y=4.75 //x2=2.71 //y2=4.88
cc_265 ( N_noxref_1_c_32_p N_CLK_c_5594_n ) capacitor c=6.80672e-19 //x=3.82 \
 //y=4.88 //x2=2.71 //y2=4.88
cc_266 ( N_noxref_1_c_72_p N_CLK_c_5594_n ) capacitor c=0.00153715f //x=3.82 \
 //y=4.88 //x2=2.71 //y2=4.88
cc_267 ( N_noxref_1_c_30_p N_CLK_c_5597_n ) capacitor c=0.0290946f //x=3.82 \
 //y=4.75 //x2=10.1 //y2=4.62
cc_268 ( N_noxref_1_c_6_p N_CLK_c_5597_n ) capacitor c=0.0287614f //x=7.89 \
 //y=5.295 //x2=10.1 //y2=4.62
cc_269 ( N_noxref_1_c_26_p N_CLK_c_5597_n ) capacitor c=0.0224141f //x=6.53 \
 //y=5.56 //x2=10.1 //y2=4.62
cc_270 ( N_noxref_1_c_10_p N_CLK_c_5597_n ) capacitor c=0.0204237f //x=7.41 \
 //y=5.38 //x2=10.1 //y2=4.62
cc_271 ( N_noxref_1_c_12_p N_CLK_c_5597_n ) capacitor c=0.00405241f //x=9.74 \
 //y=4.88 //x2=10.1 //y2=4.62
cc_272 ( N_noxref_1_c_7_p N_CLK_c_5597_n ) capacitor c=0.0272672f //x=9.742 \
 //y=4.74 //x2=10.1 //y2=4.62
cc_273 ( N_noxref_1_c_51_p N_CLK_c_5597_n ) capacitor c=0.0020739f //x=4.175 \
 //y=3.51 //x2=10.1 //y2=4.62
cc_274 ( N_noxref_1_c_30_p N_CLK_c_5604_n ) capacitor c=0.00732998f //x=3.82 \
 //y=4.75 //x2=2.71 //y2=4.62
cc_275 ( N_noxref_1_c_56_p N_CLK_c_5605_n ) capacitor c=5.39999e-19 //x=3.82 \
 //y=2.375 //x2=2.71 //y2=2.26
cc_276 ( N_noxref_1_c_57_p N_CLK_c_5605_n ) capacitor c=4.16726e-19 //x=3.82 \
 //y=3.35 //x2=2.71 //y2=2.26
cc_277 ( N_noxref_1_c_64_p N_CLK_c_5605_n ) capacitor c=0.00125213f //x=3.82 \
 //y=2.26 //x2=2.71 //y2=2.26
cc_278 ( N_noxref_1_c_65_p N_CLK_c_5605_n ) capacitor c=0.00204868f //x=3.82 \
 //y=2.26 //x2=2.71 //y2=2.26
cc_279 ( N_noxref_1_c_30_p N_CLK_c_5609_n ) capacitor c=2.50728e-19 //x=3.82 \
 //y=4.75 //x2=2.71 //y2=4.88
cc_280 ( N_noxref_1_c_32_p N_CLK_c_5609_n ) capacitor c=0.00114249f //x=3.82 \
 //y=4.88 //x2=2.71 //y2=4.88
cc_281 ( N_noxref_1_c_72_p N_CLK_c_5609_n ) capacitor c=0.00195911f //x=3.82 \
 //y=4.88 //x2=2.71 //y2=4.88
cc_282 ( N_noxref_1_M50_noxref_g N_CLK_M48_noxref_g ) capacitor c=0.0101598f \
 //x=3.56 //y=6.2 //x2=2.68 //y2=6.2
cc_283 ( N_noxref_1_M50_noxref_g N_CLK_M49_noxref_g ) capacitor c=0.0607232f \
 //x=3.56 //y=6.2 //x2=3.12 //y2=6.2
cc_284 ( N_noxref_1_M51_noxref_g N_CLK_M49_noxref_g ) capacitor c=0.0101598f \
 //x=4 //y=6.2 //x2=3.12 //y2=6.2
cc_285 ( N_noxref_1_c_37_p N_CLK_c_5615_n ) capacitor c=0.00456962f //x=3.81 \
 //y=1.095 //x2=2.8 //y2=1.09
cc_286 ( N_noxref_1_c_38_p N_CLK_c_5616_n ) capacitor c=0.00438372f //x=3.81 \
 //y=1.44 //x2=2.8 //y2=1.4
cc_287 ( N_noxref_1_c_45_p N_CLK_c_5617_n ) capacitor c=0.00438372f //x=3.81 \
 //y=1.75 //x2=2.8 //y2=1.63
cc_288 ( N_noxref_1_c_56_p N_CLK_c_5618_n ) capacitor c=0.00141236f //x=3.82 \
 //y=2.375 //x2=2.8 //y2=2.095
cc_289 ( N_noxref_1_c_64_p N_CLK_c_5618_n ) capacitor c=0.00209664f //x=3.82 \
 //y=2.26 //x2=2.8 //y2=2.095
cc_290 ( N_noxref_1_c_65_p N_CLK_c_5618_n ) capacitor c=0.00933826f //x=3.82 \
 //y=2.26 //x2=2.8 //y2=2.095
cc_291 ( N_noxref_1_c_48_p N_CLK_c_5618_n ) capacitor c=0.00438372f //x=3.82 \
 //y=2.095 //x2=2.8 //y2=2.095
cc_292 ( N_noxref_1_c_72_p N_CLK_c_5622_n ) capacitor c=0.0616491f //x=3.82 \
 //y=4.88 //x2=3.045 //y2=4.97
cc_293 ( N_noxref_1_c_32_p N_CLK_c_5623_n ) capacitor c=9.8646e-19 //x=3.82 \
 //y=4.88 //x2=2.71 //y2=4.88
cc_294 ( N_noxref_1_c_72_p N_CLK_c_5623_n ) capacitor c=0.00428612f //x=3.82 \
 //y=4.88 //x2=2.71 //y2=4.88
cc_295 ( N_noxref_1_c_118_p N_VDD_c_10241_n ) capacitor c=0.00648307f \
 //x=7.295 //y=5.38 //x2=65.575 //y2=7.585
cc_296 ( N_noxref_1_c_8_p N_VDD_c_10241_n ) capacitor c=0.00492578f //x=7.805 \
 //y=5.38 //x2=65.575 //y2=7.585
cc_297 ( N_noxref_1_c_9_p N_VDD_c_10241_n ) capacitor c=2.0049e-19 //x=9.74 \
 //y=3.665 //x2=65.575 //y2=7.585
cc_298 ( N_noxref_1_c_26_p N_VDD_c_10241_n ) capacitor c=0.00368834f //x=6.53 \
 //y=5.56 //x2=65.575 //y2=7.585
cc_299 ( N_noxref_1_c_10_p N_VDD_c_10241_n ) capacitor c=8.42709e-19 //x=7.41 \
 //y=5.38 //x2=65.575 //y2=7.585
cc_300 ( N_noxref_1_c_11_p N_VDD_c_10241_n ) capacitor c=0.00285853f //x=7.41 \
 //y=5.56 //x2=65.575 //y2=7.585
cc_301 ( N_noxref_1_c_12_p N_VDD_c_10241_n ) capacitor c=9.07241e-19 //x=9.74 \
 //y=4.88 //x2=65.575 //y2=7.585
cc_302 ( N_noxref_1_c_81_p N_VDD_c_10241_n ) capacitor c=0.00224881f //x=6.53 \
 //y=5.56 //x2=65.575 //y2=7.585
cc_303 ( N_noxref_1_c_203_p N_VDD_c_10241_n ) capacitor c=0.00224881f //x=7.41 \
 //y=5.56 //x2=65.575 //y2=7.585
cc_304 ( N_noxref_1_c_13_p N_VDD_c_10241_n ) capacitor c=6.22888e-19 //x=9.74 \
 //y=4.88 //x2=65.575 //y2=7.585
cc_305 ( N_noxref_1_M50_noxref_g N_VDD_c_10251_n ) capacitor c=0.00755544f \
 //x=3.56 //y=6.2 //x2=4.135 //y2=7.585
cc_306 ( N_noxref_1_M51_noxref_g N_VDD_c_10251_n ) capacitor c=0.00755754f \
 //x=4 //y=6.2 //x2=4.135 //y2=7.585
cc_307 ( N_noxref_1_c_118_p N_VDD_c_10253_n ) capacitor c=0.00208087f \
 //x=7.295 //y=5.38 //x2=6.885 //y2=7.585
cc_308 ( N_noxref_1_c_26_p N_VDD_c_10253_n ) capacitor c=9.41185e-19 //x=6.53 \
 //y=5.56 //x2=6.885 //y2=7.585
cc_309 ( N_noxref_1_c_81_p N_VDD_c_10253_n ) capacitor c=0.0136705f //x=6.53 \
 //y=5.56 //x2=6.885 //y2=7.585
cc_310 ( N_noxref_1_c_118_p N_VDD_c_10256_n ) capacitor c=0.00180737f \
 //x=7.295 //y=5.38 //x2=7.765 //y2=7.585
cc_311 ( N_noxref_1_c_8_p N_VDD_c_10256_n ) capacitor c=0.00208087f //x=7.805 \
 //y=5.38 //x2=7.765 //y2=7.585
cc_312 ( N_noxref_1_c_10_p N_VDD_c_10256_n ) capacitor c=4.23719e-19 //x=7.41 \
 //y=5.38 //x2=7.765 //y2=7.585
cc_313 ( N_noxref_1_c_11_p N_VDD_c_10256_n ) capacitor c=5.77976e-19 //x=7.41 \
 //y=5.56 //x2=7.765 //y2=7.585
cc_314 ( N_noxref_1_c_203_p N_VDD_c_10256_n ) capacitor c=0.0136705f //x=7.41 \
 //y=5.56 //x2=7.765 //y2=7.585
cc_315 ( N_noxref_1_c_12_p N_VDD_c_10261_n ) capacitor c=6.28113e-19 //x=9.74 \
 //y=4.88 //x2=10.215 //y2=7.585
cc_316 ( N_noxref_1_M56_noxref_g N_VDD_c_10261_n ) capacitor c=0.00732618f \
 //x=9.64 //y=6.2 //x2=10.215 //y2=7.585
cc_317 ( N_noxref_1_M57_noxref_g N_VDD_c_10261_n ) capacitor c=0.00755544f \
 //x=10.08 //y=6.2 //x2=10.215 //y2=7.585
cc_318 ( N_noxref_1_c_6_p N_VDD_c_10264_n ) capacitor c=0.0013228f //x=7.89 \
 //y=5.295 //x2=5.3 //y2=7.585
cc_319 ( N_noxref_1_c_26_p N_VDD_c_10264_n ) capacitor c=4.91377e-19 //x=6.53 \
 //y=5.56 //x2=5.3 //y2=7.585
cc_320 ( N_noxref_1_c_32_p N_VDD_c_10264_n ) capacitor c=0.00224736f //x=3.82 \
 //y=4.88 //x2=5.3 //y2=7.585
cc_321 ( N_noxref_1_c_81_p N_VDD_c_10264_n ) capacitor c=0.0064135f //x=6.53 \
 //y=5.56 //x2=5.3 //y2=7.585
cc_322 ( N_noxref_1_c_72_p N_VDD_c_10264_n ) capacitor c=2.63786e-19 //x=3.82 \
 //y=4.88 //x2=5.3 //y2=7.585
cc_323 ( N_noxref_1_c_6_p N_VDD_c_10269_n ) capacitor c=0.0291261f //x=7.89 \
 //y=5.295 //x2=8.63 //y2=7.585
cc_324 ( N_noxref_1_c_10_p N_VDD_c_10269_n ) capacitor c=0.00240948f //x=7.41 \
 //y=5.38 //x2=8.63 //y2=7.585
cc_325 ( N_noxref_1_c_11_p N_VDD_c_10269_n ) capacitor c=4.09141e-19 //x=7.41 \
 //y=5.56 //x2=8.63 //y2=7.585
cc_326 ( N_noxref_1_c_12_p N_VDD_c_10269_n ) capacitor c=0.00447349f //x=9.74 \
 //y=4.88 //x2=8.63 //y2=7.585
cc_327 ( N_noxref_1_c_7_p N_VDD_c_10269_n ) capacitor c=0.00564116f //x=9.742 \
 //y=4.74 //x2=8.63 //y2=7.585
cc_328 ( N_noxref_1_c_203_p N_VDD_c_10269_n ) capacitor c=0.0101861f //x=7.41 \
 //y=5.56 //x2=8.63 //y2=7.585
cc_329 ( N_noxref_1_c_13_p N_VDD_c_10269_n ) capacitor c=0.00370494f //x=9.74 \
 //y=4.88 //x2=8.63 //y2=7.585
cc_330 ( N_noxref_1_c_16_p N_VDD_c_10269_n ) capacitor c=0.0129564f //x=9.74 \
 //y=4.88 //x2=8.63 //y2=7.585
cc_331 ( N_noxref_1_M50_noxref_g N_VDD_M49_noxref_d ) capacitor c=0.015318f \
 //x=3.56 //y=6.2 //x2=3.195 //y2=5.2
cc_332 ( N_noxref_1_M51_noxref_g N_VDD_M51_noxref_d ) capacitor c=0.0394719f \
 //x=4 //y=6.2 //x2=4.075 //y2=5.2
cc_333 ( N_noxref_1_c_26_p N_VDD_M52_noxref_s ) capacitor c=0.0611368f \
 //x=6.53 //y=5.56 //x2=5.955 //y2=5.2
cc_334 ( N_noxref_1_c_10_p N_VDD_M52_noxref_s ) capacitor c=6.52457e-19 \
 //x=7.41 //y=5.38 //x2=5.955 //y2=5.2
cc_335 ( N_noxref_1_c_81_p N_VDD_M52_noxref_s ) capacitor c=0.0887533f \
 //x=6.53 //y=5.56 //x2=5.955 //y2=5.2
cc_336 ( N_noxref_1_c_118_p N_VDD_M53_noxref_d ) capacitor c=0.00734094f \
 //x=7.295 //y=5.38 //x2=6.825 //y2=5.2
cc_337 ( N_noxref_1_c_26_p N_VDD_M53_noxref_d ) capacitor c=0.0043528f \
 //x=6.53 //y=5.56 //x2=6.825 //y2=5.2
cc_338 ( N_noxref_1_c_11_p N_VDD_M53_noxref_d ) capacitor c=0.0043528f \
 //x=7.41 //y=5.56 //x2=6.825 //y2=5.2
cc_339 ( N_noxref_1_c_81_p N_VDD_M53_noxref_d ) capacitor c=0.065554f //x=6.53 \
 //y=5.56 //x2=6.825 //y2=5.2
cc_340 ( N_noxref_1_c_203_p N_VDD_M53_noxref_d ) capacitor c=0.065554f \
 //x=7.41 //y=5.56 //x2=6.825 //y2=5.2
cc_341 ( N_noxref_1_c_8_p N_VDD_M55_noxref_d ) capacitor c=0.00934027f \
 //x=7.805 //y=5.38 //x2=7.705 //y2=5.2
cc_342 ( N_noxref_1_c_11_p N_VDD_M55_noxref_d ) capacitor c=0.00587834f \
 //x=7.41 //y=5.56 //x2=7.705 //y2=5.2
cc_343 ( N_noxref_1_c_191_p N_VDD_M55_noxref_d ) capacitor c=9.65951e-19 \
 //x=7.885 //y=3.51 //x2=7.705 //y2=5.2
cc_344 ( N_noxref_1_c_203_p N_VDD_M55_noxref_d ) capacitor c=0.065554f \
 //x=7.41 //y=5.56 //x2=7.705 //y2=5.2
cc_345 ( N_noxref_1_c_8_p N_VDD_M56_noxref_s ) capacitor c=0.00326953f \
 //x=7.805 //y=5.38 //x2=9.285 //y2=5.2
cc_346 ( N_noxref_1_c_9_p N_VDD_M56_noxref_s ) capacitor c=0.00111268f \
 //x=9.74 //y=3.665 //x2=9.285 //y2=5.2
cc_347 ( N_noxref_1_c_10_p N_VDD_M56_noxref_s ) capacitor c=0.00515461f \
 //x=7.41 //y=5.38 //x2=9.285 //y2=5.2
cc_348 ( N_noxref_1_c_11_p N_VDD_M56_noxref_s ) capacitor c=3.28075e-19 \
 //x=7.41 //y=5.56 //x2=9.285 //y2=5.2
cc_349 ( N_noxref_1_M56_noxref_g N_VDD_M56_noxref_s ) capacitor c=0.0567929f \
 //x=9.64 //y=6.2 //x2=9.285 //y2=5.2
cc_350 ( N_noxref_1_M57_noxref_g N_VDD_M57_noxref_d ) capacitor c=0.015318f \
 //x=10.08 //y=6.2 //x2=10.155 //y2=5.2
cc_351 ( N_noxref_1_c_56_p N_noxref_23_c_11656_n ) capacitor c=0.00177186f \
 //x=3.82 //y=2.375 //x2=4.475 //y2=0.72
cc_352 ( N_noxref_1_c_64_p N_noxref_23_c_11656_n ) capacitor c=0.00117306f \
 //x=3.82 //y=2.26 //x2=4.475 //y2=0.72
cc_353 ( N_noxref_1_c_37_p N_noxref_23_c_11656_n ) capacitor c=0.0206349f \
 //x=3.81 //y=1.095 //x2=4.475 //y2=0.72
cc_354 ( N_noxref_1_c_41_p N_noxref_23_c_11656_n ) capacitor c=0.00825432f \
 //x=4.34 //y=1.095 //x2=4.475 //y2=0.72
cc_355 ( N_noxref_1_c_65_p N_noxref_23_c_11656_n ) capacitor c=2.20712e-19 \
 //x=3.82 //y=2.26 //x2=4.475 //y2=0.72
cc_356 ( N_noxref_1_c_38_p N_noxref_23_c_11661_n ) capacitor c=0.0071177f \
 //x=3.81 //y=1.44 //x2=3.59 //y2=1.175
cc_357 ( N_noxref_1_c_37_p N_noxref_23_M2_noxref_s ) capacitor c=0.0071177f \
 //x=3.81 //y=1.095 //x2=3.455 //y2=0.555
cc_358 ( N_noxref_1_c_45_p N_noxref_23_M2_noxref_s ) capacitor c=0.0071177f \
 //x=3.81 //y=1.75 //x2=3.455 //y2=0.555
cc_359 ( N_noxref_1_c_41_p N_noxref_23_M2_noxref_s ) capacitor c=0.015333f \
 //x=4.34 //y=1.095 //x2=3.455 //y2=0.555
cc_360 ( N_noxref_1_c_42_p N_noxref_23_M2_noxref_s ) capacitor c=0.00248746f \
 //x=4.34 //y=1.44 //x2=3.455 //y2=0.555
cc_361 ( N_noxref_1_c_56_p N_GND_c_12316_n ) capacitor c=0.0021992f //x=3.82 \
 //y=2.375 //x2=6.395 //y2=0.175
cc_362 ( N_noxref_1_c_3_p N_GND_c_12317_n ) capacitor c=0.00618782f //x=7.805 \
 //y=1.835 //x2=9.725 //y2=0.175
cc_363 ( N_noxref_1_c_17_p N_GND_c_12317_n ) capacitor c=0.00937893f //x=7.45 \
 //y=1.18 //x2=9.725 //y2=0.175
cc_364 ( N_noxref_1_M4_noxref_d N_GND_c_12317_n ) capacitor c=3.01769e-19 \
 //x=7.26 //y=1.085 //x2=9.725 //y2=0.175
cc_365 ( N_noxref_1_c_26_p N_GND_c_12320_n ) capacitor c=6.72861e-19 //x=6.53 \
 //y=5.56 //x2=6.48 //y2=1.135
cc_366 ( N_noxref_1_c_17_p N_GND_c_12320_n ) capacitor c=0.0140211f //x=7.45 \
 //y=1.18 //x2=6.48 //y2=1.135
cc_367 ( N_noxref_1_c_76_p N_GND_c_12320_n ) capacitor c=0.0029159f //x=6.62 \
 //y=3.495 //x2=6.48 //y2=1.135
cc_368 ( N_noxref_1_M4_noxref_d N_GND_c_12320_n ) capacitor c=2.93544e-19 \
 //x=7.26 //y=1.085 //x2=6.48 //y2=1.135
cc_369 ( N_noxref_1_c_17_p N_GND_c_12324_n ) capacitor c=0.00549186f //x=7.45 \
 //y=1.18 //x2=9.81 //y2=1.135
cc_370 ( N_noxref_1_c_147_p N_GND_c_12324_n ) capacitor c=0.00667419f //x=9.74 \
 //y=2.26 //x2=9.81 //y2=1.135
cc_371 ( N_noxref_1_c_139_p N_GND_c_12324_n ) capacitor c=2.13705e-19 //x=9.74 \
 //y=2.26 //x2=9.81 //y2=1.135
cc_372 ( N_noxref_1_c_171_p N_GND_c_12324_n ) capacitor c=0.00171023f \
 //x=9.545 //y=1.045 //x2=9.81 //y2=1.135
cc_373 ( N_noxref_1_c_172_p N_GND_c_12324_n ) capacitor c=0.00357815f \
 //x=9.545 //y=1.39 //x2=9.81 //y2=1.135
cc_374 ( N_noxref_1_c_174_p N_GND_c_12324_n ) capacitor c=4.2764e-19 //x=9.545 \
 //y=1.7 //x2=9.81 //y2=1.135
cc_375 ( N_noxref_1_c_375_p N_GND_c_12324_n ) capacitor c=9.36995e-19 //x=9.92 \
 //y=0.89 //x2=9.81 //y2=1.135
cc_376 ( N_noxref_1_c_376_p N_GND_c_12324_n ) capacitor c=6.38426e-19 //x=9.92 \
 //y=1.545 //x2=9.81 //y2=1.135
cc_377 ( N_noxref_1_c_173_p N_GND_c_12324_n ) capacitor c=0.00171721f \
 //x=10.075 //y=1.045 //x2=9.81 //y2=1.135
cc_378 ( N_noxref_1_c_175_p N_GND_c_12324_n ) capacitor c=0.00296337f \
 //x=10.075 //y=1.39 //x2=9.81 //y2=1.135
cc_379 ( N_noxref_1_c_171_p N_GND_c_12334_n ) capacitor c=3.46594e-19 \
 //x=9.545 //y=1.045 //x2=9.807 //y2=1.005
cc_380 ( N_noxref_1_c_375_p N_GND_c_12334_n ) capacitor c=0.00839795f //x=9.92 \
 //y=0.89 //x2=9.807 //y2=1.005
cc_381 ( N_noxref_1_c_173_p N_GND_c_12334_n ) capacitor c=4.40641e-19 \
 //x=10.075 //y=1.045 //x2=9.807 //y2=1.005
cc_382 ( N_noxref_1_c_56_p N_GND_c_12337_n ) capacitor c=2.016e-19 //x=3.82 \
 //y=2.375 //x2=5.13 //y2=0.175
cc_383 ( N_noxref_1_c_3_p N_GND_c_12338_n ) capacitor c=7.75992e-19 //x=7.805 \
 //y=1.835 //x2=8.46 //y2=0.175
cc_384 ( N_noxref_1_c_171_p N_GND_c_12339_n ) capacitor c=0.00688027f \
 //x=9.545 //y=1.045 //x2=11.79 //y2=0.175
cc_385 ( N_noxref_1_c_4_p N_GND_c_12340_n ) capacitor c=9.32616e-19 //x=7.89 \
 //y=3.35 //x2=5.3 //y2=0.175
cc_386 ( N_noxref_1_c_75_p N_GND_c_12340_n ) capacitor c=0.00560367f //x=6.02 \
 //y=3.51 //x2=5.3 //y2=0.175
cc_387 ( N_noxref_1_c_64_p N_GND_c_12340_n ) capacitor c=0.00239899f //x=3.82 \
 //y=2.26 //x2=5.3 //y2=0.175
cc_388 ( N_noxref_1_c_42_p N_GND_c_12340_n ) capacitor c=0.00262688f //x=4.34 \
 //y=1.44 //x2=5.3 //y2=0.175
cc_389 ( N_noxref_1_c_65_p N_GND_c_12340_n ) capacitor c=2.63786e-19 //x=3.82 \
 //y=2.26 //x2=5.3 //y2=0.175
cc_390 ( N_noxref_1_c_2_p N_GND_c_12345_n ) capacitor c=0.002973f //x=7.45 \
 //y=1.75 //x2=8.63 //y2=0.175
cc_391 ( N_noxref_1_c_3_p N_GND_c_12345_n ) capacitor c=0.0277399f //x=7.805 \
 //y=1.835 //x2=8.63 //y2=0.175
cc_392 ( N_noxref_1_c_5_p N_GND_c_12345_n ) capacitor c=0.00718667f //x=9.74 \
 //y=3.345 //x2=8.63 //y2=0.175
cc_393 ( N_noxref_1_c_147_p N_GND_c_12345_n ) capacitor c=0.00427323f //x=9.74 \
 //y=2.26 //x2=8.63 //y2=0.175
cc_394 ( N_noxref_1_c_98_p N_GND_c_12345_n ) capacitor c=0.00341388f //x=9.575 \
 //y=3.505 //x2=8.63 //y2=0.175
cc_395 ( N_noxref_1_c_139_p N_GND_c_12345_n ) capacitor c=0.00369427f //x=9.74 \
 //y=2.26 //x2=8.63 //y2=0.175
cc_396 ( N_noxref_1_c_174_p N_GND_c_12345_n ) capacitor c=0.0015404f //x=9.545 \
 //y=1.7 //x2=8.63 //y2=0.175
cc_397 ( N_noxref_1_c_149_p N_GND_c_12345_n ) capacitor c=0.00950704f \
 //x=9.545 //y=2.095 //x2=8.63 //y2=0.175
cc_398 ( N_noxref_1_c_17_p N_GND_M3_noxref_d ) capacitor c=2.82748e-19 \
 //x=7.45 //y=1.18 //x2=6.29 //y2=1.045
cc_399 ( N_noxref_1_c_147_p N_GND_M5_noxref_d ) capacitor c=2.20438e-19 \
 //x=9.74 //y=2.26 //x2=9.62 //y2=1.045
cc_400 ( N_noxref_1_c_171_p N_GND_M5_noxref_d ) capacitor c=0.00192399f \
 //x=9.545 //y=1.045 //x2=9.62 //y2=1.045
cc_401 ( N_noxref_1_c_172_p N_GND_M5_noxref_d ) capacitor c=0.00210798f \
 //x=9.545 //y=1.39 //x2=9.62 //y2=1.045
cc_402 ( N_noxref_1_c_375_p N_GND_M5_noxref_d ) capacitor c=0.00472259f \
 //x=9.92 //y=0.89 //x2=9.62 //y2=1.045
cc_403 ( N_noxref_1_c_376_p N_GND_M5_noxref_d ) capacitor c=0.00166857f \
 //x=9.92 //y=1.545 //x2=9.62 //y2=1.045
cc_404 ( N_noxref_1_c_173_p N_GND_M5_noxref_d ) capacitor c=0.00230174f \
 //x=10.075 //y=1.045 //x2=9.62 //y2=1.045
cc_405 ( N_noxref_1_c_175_p N_GND_M5_noxref_d ) capacitor c=0.00210798f \
 //x=10.075 //y=1.39 //x2=9.62 //y2=1.045
cc_406 ( N_noxref_1_c_75_p N_noxref_32_c_14035_n ) capacitor c=0.00263807f \
 //x=6.02 //y=3.51 //x2=5.995 //y2=1.675
cc_407 ( N_noxref_1_c_75_p N_noxref_32_c_14036_n ) capacitor c=0.00597827f \
 //x=6.02 //y=3.51 //x2=6.88 //y2=1.76
cc_408 ( N_noxref_1_c_77_p N_noxref_32_c_14036_n ) capacitor c=0.00236963f \
 //x=8.045 //y=3.51 //x2=6.88 //y2=1.76
cc_409 ( N_noxref_1_c_49_p N_noxref_32_c_14038_n ) capacitor c=0.00911405f \
 //x=7.535 //y=1.835 //x2=6.965 //y2=1.675
cc_410 ( N_noxref_1_c_77_p N_noxref_32_c_14038_n ) capacitor c=0.00176662f \
 //x=8.045 //y=3.51 //x2=6.965 //y2=1.675
cc_411 ( N_noxref_1_c_3_p N_noxref_32_c_14040_n ) capacitor c=0.00399245f \
 //x=7.805 //y=1.835 //x2=7.85 //y2=0.71
cc_412 ( N_noxref_1_c_17_p N_noxref_32_c_14040_n ) capacitor c=0.003751f \
 //x=7.45 //y=1.18 //x2=7.85 //y2=0.71
cc_413 ( N_noxref_1_M4_noxref_d N_noxref_32_c_14040_n ) capacitor \
 c=0.00910163f //x=7.26 //y=1.085 //x2=7.85 //y2=0.71
cc_414 ( N_noxref_1_c_2_p N_noxref_32_M3_noxref_s ) capacitor c=0.01625f \
 //x=7.45 //y=1.75 //x2=5.86 //y2=0.545
cc_415 ( N_noxref_1_c_3_p N_noxref_32_M3_noxref_s ) capacitor c=0.00640979f \
 //x=7.805 //y=1.835 //x2=5.86 //y2=0.545
cc_416 ( N_noxref_1_c_96_p N_noxref_32_M3_noxref_s ) capacitor c=4.17069e-19 \
 //x=7.89 //y=3.67 //x2=5.86 //y2=0.545
cc_417 ( N_noxref_1_c_17_p N_noxref_32_M3_noxref_s ) capacitor c=0.00905337f \
 //x=7.45 //y=1.18 //x2=5.86 //y2=0.545
cc_418 ( N_noxref_1_c_191_p N_noxref_32_M3_noxref_s ) capacitor c=0.0010514f \
 //x=7.885 //y=3.51 //x2=5.86 //y2=0.545
cc_419 ( N_noxref_1_M4_noxref_d N_noxref_32_M3_noxref_s ) capacitor \
 c=0.0275552f //x=7.26 //y=1.085 //x2=5.86 //y2=0.545
cc_420 ( N_noxref_1_c_149_p N_noxref_33_c_14104_n ) capacitor c=0.00262672f \
 //x=9.545 //y=2.095 //x2=9.325 //y2=1.675
cc_421 ( N_noxref_1_c_9_p N_noxref_33_c_14105_n ) capacitor c=0.00402488f \
 //x=9.74 //y=3.665 //x2=10.21 //y2=1.76
cc_422 ( N_noxref_1_c_147_p N_noxref_33_c_14105_n ) capacitor c=0.00509504f \
 //x=9.74 //y=2.26 //x2=10.21 //y2=1.76
cc_423 ( N_noxref_1_c_139_p N_noxref_33_c_14105_n ) capacitor c=0.00655412f \
 //x=9.74 //y=2.26 //x2=10.21 //y2=1.76
cc_424 ( N_noxref_1_c_174_p N_noxref_33_c_14105_n ) capacitor c=0.00697076f \
 //x=9.545 //y=1.7 //x2=10.21 //y2=1.76
cc_425 ( N_noxref_1_c_149_p N_noxref_33_c_14105_n ) capacitor c=0.0191405f \
 //x=9.545 //y=2.095 //x2=10.21 //y2=1.76
cc_426 ( N_noxref_1_c_376_p N_noxref_33_c_14105_n ) capacitor c=0.00723574f \
 //x=9.92 //y=1.545 //x2=10.21 //y2=1.76
cc_427 ( N_noxref_1_c_175_p N_noxref_33_c_14105_n ) capacitor c=0.00339872f \
 //x=10.075 //y=1.39 //x2=10.21 //y2=1.76
cc_428 ( N_noxref_1_c_149_p N_noxref_33_c_14112_n ) capacitor c=6.71402e-19 \
 //x=9.545 //y=2.095 //x2=10.295 //y2=1.675
cc_429 ( N_noxref_1_c_171_p N_noxref_33_M5_noxref_s ) capacitor c=0.0294925f \
 //x=9.545 //y=1.045 //x2=9.19 //y2=0.545
cc_430 ( N_noxref_1_c_174_p N_noxref_33_M5_noxref_s ) capacitor c=3.48408e-19 \
 //x=9.545 //y=1.7 //x2=9.19 //y2=0.545
cc_431 ( N_noxref_1_c_173_p N_noxref_33_M5_noxref_s ) capacitor c=0.0125442f \
 //x=10.075 //y=1.045 //x2=9.19 //y2=0.545
cc_432 ( N_noxref_2_c_456_p N_noxref_3_c_818_n ) capacitor c=0.00129068f \
 //x=11.22 //y=3.67 //x2=10.7 //y2=3.87
cc_433 ( N_noxref_2_c_437_n N_noxref_3_c_818_n ) capacitor c=7.95945e-19 \
 //x=11.22 //y=5.295 //x2=10.7 //y2=3.87
cc_434 ( N_noxref_2_c_450_n N_noxref_3_c_818_n ) capacitor c=0.0358254f \
 //x=11.385 //y=3.51 //x2=10.7 //y2=3.87
cc_435 ( N_noxref_2_c_456_p N_noxref_3_c_821_n ) capacitor c=0.00700197f \
 //x=11.22 //y=3.67 //x2=11.44 //y2=3.895
cc_436 ( N_noxref_2_c_437_n N_noxref_3_c_821_n ) capacitor c=0.0225064f \
 //x=11.22 //y=5.295 //x2=11.44 //y2=3.895
cc_437 ( N_noxref_2_c_461_p N_noxref_3_c_821_n ) capacitor c=0.126769f \
 //x=12.905 //y=3.51 //x2=11.44 //y2=3.895
cc_438 ( N_noxref_2_c_462_p N_noxref_3_c_824_n ) capacitor c=0.00341263f \
 //x=13.07 //y=3.67 //x2=12.68 //y2=3.88
cc_439 ( N_noxref_2_c_463_p N_noxref_3_c_824_n ) capacitor c=4.98692e-19 \
 //x=13.072 //y=4.74 //x2=12.68 //y2=3.88
cc_440 ( N_noxref_2_c_461_p N_noxref_3_c_824_n ) capacitor c=0.0108087f \
 //x=12.905 //y=3.51 //x2=12.68 //y2=3.88
cc_441 ( N_noxref_2_c_465_p N_noxref_3_c_824_n ) capacitor c=0.0358254f \
 //x=13.065 //y=3.51 //x2=12.68 //y2=3.88
cc_442 ( N_noxref_2_c_462_p N_noxref_3_c_828_n ) capacitor c=0.00251183f \
 //x=13.07 //y=3.67 //x2=13.28 //y2=3.895
cc_443 ( N_noxref_2_c_463_p N_noxref_3_c_828_n ) capacitor c=0.0224596f \
 //x=13.072 //y=4.74 //x2=13.28 //y2=3.895
cc_444 ( N_noxref_2_c_435_n N_noxref_5_c_1482_n ) capacitor c=0.0410116f \
 //x=11.22 //y=3.35 //x2=10.48 //y2=4.095
cc_445 ( N_noxref_2_c_456_p N_noxref_5_c_1482_n ) capacitor c=0.0146933f \
 //x=11.22 //y=3.67 //x2=10.48 //y2=4.095
cc_446 ( N_noxref_2_c_437_n N_noxref_5_c_1482_n ) capacitor c=0.0169815f \
 //x=11.22 //y=5.295 //x2=10.48 //y2=4.095
cc_447 ( N_noxref_2_c_471_p N_noxref_5_c_1482_n ) capacitor c=0.00152432f \
 //x=13.07 //y=3.35 //x2=10.48 //y2=4.095
cc_448 ( N_noxref_2_c_449_n N_noxref_5_c_1482_n ) capacitor c=5.52402e-19 \
 //x=11.22 //y=3.51 //x2=10.48 //y2=4.095
cc_449 ( N_noxref_2_c_463_p N_noxref_5_c_1482_n ) capacitor c=3.19292e-19 \
 //x=13.072 //y=4.74 //x2=10.48 //y2=4.095
cc_450 ( N_noxref_2_c_450_n N_noxref_5_c_1482_n ) capacitor c=0.00365012f \
 //x=11.385 //y=3.51 //x2=10.48 //y2=4.095
cc_451 ( N_noxref_2_c_432_n N_noxref_5_c_1490_n ) capacitor c=0.0042527f \
 //x=10.625 //y=5.38 //x2=10.48 //y2=4.415
cc_452 ( N_noxref_2_c_437_n N_noxref_5_c_1490_n ) capacitor c=0.0147977f \
 //x=11.22 //y=5.295 //x2=10.48 //y2=4.415
cc_453 ( N_noxref_2_c_432_n N_noxref_5_c_1491_n ) capacitor c=0.0215252f \
 //x=10.625 //y=5.38 //x2=10.48 //y2=4.735
cc_454 ( N_noxref_2_c_437_n N_noxref_5_c_1491_n ) capacitor c=0.0281817f \
 //x=11.22 //y=5.295 //x2=10.48 //y2=4.735
cc_455 ( N_noxref_2_c_463_p N_noxref_5_c_1491_n ) capacitor c=4.65109e-19 \
 //x=13.072 //y=4.74 //x2=10.48 //y2=4.735
cc_456 ( N_noxref_2_M61_noxref_g N_noxref_5_c_1549_n ) capacitor c=0.00889217f \
 //x=13.41 //y=6.2 //x2=13.955 //y2=5.38
cc_457 ( N_noxref_2_c_433_n N_noxref_5_c_1550_n ) capacitor c=0.00324213f \
 //x=10.78 //y=1.75 //x2=14.11 //y2=1.75
cc_458 ( N_noxref_2_c_482_p N_noxref_5_c_1551_n ) capacitor c=0.00231467f \
 //x=11.135 //y=1.835 //x2=14.195 //y2=1.835
cc_459 ( N_noxref_2_c_435_n N_noxref_5_c_1552_n ) capacitor c=0.00204244f \
 //x=11.22 //y=3.35 //x2=14.55 //y2=4.105
cc_460 ( N_noxref_2_c_471_p N_noxref_5_c_1552_n ) capacitor c=0.00241064f \
 //x=13.07 //y=3.35 //x2=14.55 //y2=4.105
cc_461 ( N_noxref_2_c_463_p N_noxref_5_c_1552_n ) capacitor c=7.58839e-19 \
 //x=13.072 //y=4.74 //x2=14.55 //y2=4.105
cc_462 ( N_noxref_2_c_437_n N_noxref_5_c_1555_n ) capacitor c=0.00281705f \
 //x=11.22 //y=5.295 //x2=14.55 //y2=5.295
cc_463 ( N_noxref_2_c_463_p N_noxref_5_c_1555_n ) capacitor c=6.95263e-19 \
 //x=13.072 //y=4.74 //x2=14.55 //y2=5.295
cc_464 ( N_noxref_2_c_437_n N_noxref_5_c_1496_n ) capacitor c=6.89957e-19 \
 //x=11.22 //y=5.295 //x2=10.48 //y2=4.25
cc_465 ( N_noxref_2_c_435_n N_noxref_5_c_1497_n ) capacitor c=0.015397f \
 //x=11.22 //y=3.35 //x2=10.48 //y2=2.26
cc_466 ( N_noxref_2_c_490_p N_noxref_5_c_1559_n ) capacitor c=0.00114153f \
 //x=11.135 //y=5.38 //x2=13.19 //y2=5.56
cc_467 ( N_noxref_2_c_462_p N_noxref_5_c_1559_n ) capacitor c=5.66772e-19 \
 //x=13.07 //y=3.67 //x2=13.19 //y2=5.56
cc_468 ( N_noxref_2_c_492_p N_noxref_5_c_1559_n ) capacitor c=5.29822e-19 \
 //x=10.74 //y=5.38 //x2=13.19 //y2=5.56
cc_469 ( N_noxref_2_c_493_p N_noxref_5_c_1559_n ) capacitor c=0.00147119f \
 //x=10.74 //y=5.56 //x2=13.19 //y2=5.56
cc_470 ( N_noxref_2_c_494_p N_noxref_5_c_1559_n ) capacitor c=0.0117744f \
 //x=13.07 //y=4.88 //x2=13.19 //y2=5.56
cc_471 ( N_noxref_2_c_495_p N_noxref_5_c_1559_n ) capacitor c=0.00277154f \
 //x=13.07 //y=4.88 //x2=13.19 //y2=5.56
cc_472 ( N_noxref_2_M60_noxref_g N_noxref_5_c_1559_n ) capacitor c=0.00201806f \
 //x=12.97 //y=6.2 //x2=13.19 //y2=5.56
cc_473 ( N_noxref_2_M61_noxref_g N_noxref_5_c_1559_n ) capacitor c=0.00192712f \
 //x=13.41 //y=6.2 //x2=13.19 //y2=5.56
cc_474 ( N_noxref_2_c_498_p N_noxref_5_c_1559_n ) capacitor c=0.00194519f \
 //x=13.07 //y=4.88 //x2=13.19 //y2=5.56
cc_475 ( N_noxref_2_c_448_n N_noxref_5_c_1568_n ) capacitor c=6.99317e-19 \
 //x=10.78 //y=1.18 //x2=14.11 //y2=1.18
cc_476 ( N_noxref_2_c_437_n N_noxref_5_c_1569_n ) capacitor c=0.0227736f \
 //x=11.22 //y=5.295 //x2=14.38 //y2=4.25
cc_477 ( N_noxref_2_c_463_p N_noxref_5_c_1569_n ) capacitor c=0.0232046f \
 //x=13.072 //y=4.74 //x2=14.38 //y2=4.25
cc_478 ( N_noxref_2_c_461_p N_noxref_5_c_1569_n ) capacitor c=0.0104197f \
 //x=12.905 //y=3.51 //x2=14.38 //y2=4.25
cc_479 ( N_noxref_2_c_437_n N_noxref_5_c_1507_n ) capacitor c=0.00328982f \
 //x=11.22 //y=5.295 //x2=10.645 //y2=4.25
cc_480 ( N_noxref_2_c_435_n N_noxref_5_c_1511_n ) capacitor c=9.90728e-19 \
 //x=11.22 //y=3.35 //x2=10.48 //y2=2.26
cc_481 ( N_noxref_2_c_432_n N_noxref_5_c_1515_n ) capacitor c=0.00469257f \
 //x=10.625 //y=5.38 //x2=10.51 //y2=4.88
cc_482 ( N_noxref_2_c_437_n N_noxref_5_c_1515_n ) capacitor c=7.76118e-19 \
 //x=11.22 //y=5.295 //x2=10.51 //y2=4.88
cc_483 ( N_noxref_2_c_494_p N_noxref_5_c_1576_n ) capacitor c=0.00104426f \
 //x=13.07 //y=4.88 //x2=13.19 //y2=5.56
cc_484 ( N_noxref_2_c_495_p N_noxref_5_c_1576_n ) capacitor c=0.00377369f \
 //x=13.07 //y=4.88 //x2=13.19 //y2=5.56
cc_485 ( N_noxref_2_M60_noxref_g N_noxref_5_c_1576_n ) capacitor c=0.0158358f \
 //x=12.97 //y=6.2 //x2=13.19 //y2=5.56
cc_486 ( N_noxref_2_M61_noxref_g N_noxref_5_c_1576_n ) capacitor c=0.0178987f \
 //x=13.41 //y=6.2 //x2=13.19 //y2=5.56
cc_487 ( N_noxref_2_c_498_p N_noxref_5_c_1576_n ) capacitor c=0.0043218f \
 //x=13.07 //y=4.88 //x2=13.19 //y2=5.56
cc_488 ( N_noxref_2_c_432_n N_noxref_5_M58_noxref_g ) capacitor c=0.00842859f \
 //x=10.625 //y=5.38 //x2=10.52 //y2=6.2
cc_489 ( N_noxref_2_c_492_p N_noxref_5_M58_noxref_g ) capacitor c=0.00192712f \
 //x=10.74 //y=5.38 //x2=10.52 //y2=6.2
cc_490 ( N_noxref_2_c_514_p N_noxref_5_M58_noxref_g ) capacitor c=0.0178987f \
 //x=10.74 //y=5.56 //x2=10.52 //y2=6.2
cc_491 ( N_noxref_2_c_490_p N_noxref_5_M59_noxref_g ) capacitor c=0.0106088f \
 //x=11.135 //y=5.38 //x2=10.96 //y2=6.2
cc_492 ( N_noxref_2_c_492_p N_noxref_5_M59_noxref_g ) capacitor c=0.00298276f \
 //x=10.74 //y=5.38 //x2=10.96 //y2=6.2
cc_493 ( N_noxref_2_c_514_p N_noxref_5_M59_noxref_g ) capacitor c=0.0178506f \
 //x=10.74 //y=5.56 //x2=10.96 //y2=6.2
cc_494 ( N_noxref_2_c_448_n N_noxref_5_c_1521_n ) capacitor c=0.00120406f \
 //x=10.78 //y=1.18 //x2=10.515 //y2=1.085
cc_495 ( N_noxref_2_M6_noxref_d N_noxref_5_c_1521_n ) capacitor c=0.00137165f \
 //x=10.59 //y=1.085 //x2=10.515 //y2=1.085
cc_496 ( N_noxref_2_c_433_n N_noxref_5_c_1524_n ) capacitor c=0.00119008f \
 //x=10.78 //y=1.75 //x2=10.515 //y2=1.43
cc_497 ( N_noxref_2_c_448_n N_noxref_5_c_1524_n ) capacitor c=0.00218694f \
 //x=10.78 //y=1.18 //x2=10.515 //y2=1.43
cc_498 ( N_noxref_2_M6_noxref_d N_noxref_5_c_1524_n ) capacitor c=0.00237422f \
 //x=10.59 //y=1.085 //x2=10.515 //y2=1.43
cc_499 ( N_noxref_2_c_433_n N_noxref_5_c_1526_n ) capacitor c=0.00438634f \
 //x=10.78 //y=1.75 //x2=10.515 //y2=1.74
cc_500 ( N_noxref_2_c_437_n N_noxref_5_c_1593_n ) capacitor c=0.00845606f \
 //x=11.22 //y=5.295 //x2=10.885 //y2=4.97
cc_501 ( N_noxref_2_c_492_p N_noxref_5_c_1593_n ) capacitor c=0.0020909f \
 //x=10.74 //y=5.38 //x2=10.885 //y2=4.97
cc_502 ( N_noxref_2_c_514_p N_noxref_5_c_1593_n ) capacitor c=0.00291714f \
 //x=10.74 //y=5.56 //x2=10.885 //y2=4.97
cc_503 ( N_noxref_2_c_448_n N_noxref_5_c_1596_n ) capacitor c=5.50523e-19 \
 //x=10.78 //y=1.18 //x2=10.89 //y2=0.93
cc_504 ( N_noxref_2_M6_noxref_d N_noxref_5_c_1596_n ) capacitor c=0.0020782f \
 //x=10.59 //y=1.085 //x2=10.89 //y2=0.93
cc_505 ( N_noxref_2_c_433_n N_noxref_5_c_1598_n ) capacitor c=0.00916852f \
 //x=10.78 //y=1.75 //x2=10.89 //y2=1.585
cc_506 ( N_noxref_2_c_482_p N_noxref_5_c_1598_n ) capacitor c=0.00194324f \
 //x=11.135 //y=1.835 //x2=10.89 //y2=1.585
cc_507 ( N_noxref_2_c_448_n N_noxref_5_c_1598_n ) capacitor c=5.67071e-19 \
 //x=10.78 //y=1.18 //x2=10.89 //y2=1.585
cc_508 ( N_noxref_2_M6_noxref_d N_noxref_5_c_1598_n ) capacitor c=0.00356097f \
 //x=10.59 //y=1.085 //x2=10.89 //y2=1.585
cc_509 ( N_noxref_2_c_448_n N_noxref_5_c_1529_n ) capacitor c=0.00109205f \
 //x=10.78 //y=1.18 //x2=11.045 //y2=1.085
cc_510 ( N_noxref_2_M6_noxref_d N_noxref_5_c_1529_n ) capacitor c=8.50095e-19 \
 //x=10.59 //y=1.085 //x2=11.045 //y2=1.085
cc_511 ( N_noxref_2_c_433_n N_noxref_5_c_1530_n ) capacitor c=0.003249f \
 //x=10.78 //y=1.75 //x2=11.045 //y2=1.43
cc_512 ( N_noxref_2_c_482_p N_noxref_5_c_1530_n ) capacitor c=0.00323005f \
 //x=11.135 //y=1.835 //x2=11.045 //y2=1.43
cc_513 ( N_noxref_2_c_448_n N_noxref_5_c_1530_n ) capacitor c=0.00317092f \
 //x=10.78 //y=1.18 //x2=11.045 //y2=1.43
cc_514 ( N_noxref_2_M6_noxref_d N_noxref_5_c_1530_n ) capacitor c=0.00237422f \
 //x=10.59 //y=1.085 //x2=11.045 //y2=1.43
cc_515 ( N_noxref_2_c_435_n N_noxref_5_c_1531_n ) capacitor c=0.00281392f \
 //x=11.22 //y=3.35 //x2=10.48 //y2=2.26
cc_516 ( N_noxref_2_c_433_n N_noxref_5_c_1609_n ) capacitor c=0.00341114f \
 //x=10.78 //y=1.75 //x2=10.48 //y2=2.095
cc_517 ( N_noxref_2_c_435_n N_noxref_5_c_1609_n ) capacitor c=0.00309058f \
 //x=11.22 //y=3.35 //x2=10.48 //y2=2.095
cc_518 ( N_noxref_2_c_432_n N_noxref_5_c_1534_n ) capacitor c=8.41897e-19 \
 //x=10.625 //y=5.38 //x2=10.51 //y2=4.88
cc_519 ( N_noxref_2_c_437_n N_noxref_5_c_1534_n ) capacitor c=0.00142201f \
 //x=11.22 //y=5.295 //x2=10.51 //y2=4.88
cc_520 ( N_noxref_2_c_434_n N_D_c_4251_n ) capacitor c=0.012898f //x=10.865 \
 //y=1.835 //x2=28.435 //y2=2.78
cc_521 ( N_noxref_2_c_435_n N_D_c_4251_n ) capacitor c=0.0309813f //x=11.22 \
 //y=3.35 //x2=28.435 //y2=2.78
cc_522 ( N_noxref_2_c_456_p N_D_c_4251_n ) capacitor c=0.00459562f //x=11.22 \
 //y=3.67 //x2=28.435 //y2=2.78
cc_523 ( N_noxref_2_c_471_p N_D_c_4251_n ) capacitor c=0.0294519f //x=13.07 \
 //y=3.35 //x2=28.435 //y2=2.78
cc_524 ( N_noxref_2_c_462_p N_D_c_4251_n ) capacitor c=0.00395917f //x=13.07 \
 //y=3.67 //x2=28.435 //y2=2.78
cc_525 ( N_noxref_2_c_448_n N_D_c_4251_n ) capacitor c=4.96962e-19 //x=10.78 \
 //y=1.18 //x2=28.435 //y2=2.78
cc_526 ( N_noxref_2_c_550_p N_D_c_4251_n ) capacitor c=0.0033197f //x=13.07 \
 //y=2.26 //x2=28.435 //y2=2.78
cc_527 ( N_noxref_2_c_461_p N_D_c_4251_n ) capacitor c=0.0708168f //x=12.905 \
 //y=3.51 //x2=28.435 //y2=2.78
cc_528 ( N_noxref_2_c_450_n N_D_c_4251_n ) capacitor c=0.0157335f //x=11.385 \
 //y=3.51 //x2=28.435 //y2=2.78
cc_529 ( N_noxref_2_c_465_p N_D_c_4251_n ) capacitor c=0.0157334f //x=13.065 \
 //y=3.51 //x2=28.435 //y2=2.78
cc_530 ( N_noxref_2_c_435_n CLK ) capacitor c=0.00156144f //x=11.22 //y=3.35 \
 //x2=13.81 //y2=3.14
cc_531 ( N_noxref_2_c_437_n CLK ) capacitor c=0.00126687f //x=11.22 //y=5.295 \
 //x2=13.81 //y2=3.14
cc_532 ( N_noxref_2_c_471_p CLK ) capacitor c=0.041002f //x=13.07 //y=3.35 \
 //x2=13.81 //y2=3.14
cc_533 ( N_noxref_2_c_462_p CLK ) capacitor c=0.0146933f //x=13.07 //y=3.67 \
 //x2=13.81 //y2=3.14
cc_534 ( N_noxref_2_c_558_p CLK ) capacitor c=6.03895e-19 //x=13.065 //y=3.51 \
 //x2=13.81 //y2=3.14
cc_535 ( N_noxref_2_c_463_p CLK ) capacitor c=0.0384373f //x=13.072 //y=4.74 \
 //x2=13.81 //y2=3.14
cc_536 ( N_noxref_2_c_465_p CLK ) capacitor c=0.00684103f //x=13.065 //y=3.51 \
 //x2=13.81 //y2=3.14
cc_537 ( N_noxref_2_c_561_p CLK ) capacitor c=3.49899e-19 //x=13.07 //y=2.26 \
 //x2=13.81 //y2=3.14
cc_538 ( N_noxref_2_c_494_p N_CLK_c_5633_n ) capacitor c=0.0147952f //x=13.07 \
 //y=4.88 //x2=13.835 //y2=4.865
cc_539 ( N_noxref_2_c_463_p N_CLK_c_5633_n ) capacitor c=0.00198309f \
 //x=13.072 //y=4.74 //x2=13.835 //y2=4.865
cc_540 ( N_noxref_2_c_495_p N_CLK_c_5633_n ) capacitor c=7.64003e-19 //x=13.07 \
 //y=4.88 //x2=13.835 //y2=4.865
cc_541 ( N_noxref_2_c_498_p N_CLK_c_5633_n ) capacitor c=0.00163736f //x=13.07 \
 //y=4.88 //x2=13.835 //y2=4.865
cc_542 ( N_noxref_2_c_550_p N_CLK_c_5637_n ) capacitor c=0.0205342f //x=13.07 \
 //y=2.26 //x2=13.81 //y2=2.26
cc_543 ( N_noxref_2_c_561_p N_CLK_c_5637_n ) capacitor c=5.16867e-19 //x=13.07 \
 //y=2.26 //x2=13.81 //y2=2.26
cc_544 ( N_noxref_2_c_568_p N_CLK_c_5637_n ) capacitor c=0.00167888f \
 //x=12.875 //y=2.095 //x2=13.81 //y2=2.26
cc_545 ( N_noxref_2_c_432_n N_CLK_c_5597_n ) capacitor c=0.00656522f \
 //x=10.625 //y=5.38 //x2=10.1 //y2=4.62
cc_546 ( N_noxref_2_c_439_n N_CLK_c_5597_n ) capacitor c=0.0154722f //x=9.86 \
 //y=5.56 //x2=10.1 //y2=4.62
cc_547 ( N_noxref_2_c_492_p N_CLK_c_5642_n ) capacitor c=0.00646691f //x=10.74 \
 //y=5.38 //x2=10.7 //y2=4.64
cc_548 ( N_noxref_2_c_437_n N_CLK_c_5643_n ) capacitor c=0.0293287f //x=11.22 \
 //y=5.295 //x2=14.395 //y2=4.642
cc_549 ( N_noxref_2_c_492_p N_CLK_c_5643_n ) capacitor c=0.0151381f //x=10.74 \
 //y=5.38 //x2=14.395 //y2=4.642
cc_550 ( N_noxref_2_c_494_p N_CLK_c_5643_n ) capacitor c=0.0114767f //x=13.07 \
 //y=4.88 //x2=14.395 //y2=4.642
cc_551 ( N_noxref_2_c_463_p N_CLK_c_5643_n ) capacitor c=0.0274896f //x=13.072 \
 //y=4.74 //x2=14.395 //y2=4.642
cc_552 ( N_noxref_2_c_471_p N_CLK_c_5647_n ) capacitor c=3.49899e-19 //x=13.07 \
 //y=3.35 //x2=13.81 //y2=2.26
cc_553 ( N_noxref_2_c_550_p N_CLK_c_5647_n ) capacitor c=5.24723e-19 //x=13.07 \
 //y=2.26 //x2=13.81 //y2=2.26
cc_554 ( N_noxref_2_c_561_p N_CLK_c_5647_n ) capacitor c=0.00525888f //x=13.07 \
 //y=2.26 //x2=13.81 //y2=2.26
cc_555 ( N_noxref_2_c_568_p N_CLK_c_5647_n ) capacitor c=0.00190888f \
 //x=12.875 //y=2.095 //x2=13.81 //y2=2.26
cc_556 ( N_noxref_2_c_494_p N_CLK_c_5651_n ) capacitor c=4.80626e-19 //x=13.07 \
 //y=4.88 //x2=13.84 //y2=4.88
cc_557 ( N_noxref_2_c_495_p N_CLK_c_5651_n ) capacitor c=0.00396769f //x=13.07 \
 //y=4.88 //x2=13.84 //y2=4.88
cc_558 ( N_noxref_2_c_498_p N_CLK_c_5651_n ) capacitor c=0.0028411f //x=13.07 \
 //y=4.88 //x2=13.84 //y2=4.88
cc_559 ( N_noxref_2_M60_noxref_g N_CLK_M62_noxref_g ) capacitor c=0.0104892f \
 //x=12.97 //y=6.2 //x2=13.85 //y2=6.2
cc_560 ( N_noxref_2_M61_noxref_g N_CLK_M62_noxref_g ) capacitor c=0.107636f \
 //x=13.41 //y=6.2 //x2=13.85 //y2=6.2
cc_561 ( N_noxref_2_M61_noxref_g N_CLK_M63_noxref_g ) capacitor c=0.0100341f \
 //x=13.41 //y=6.2 //x2=14.29 //y2=6.2
cc_562 ( N_noxref_2_c_586_p N_CLK_c_5657_n ) capacitor c=4.86545e-19 \
 //x=12.875 //y=1.045 //x2=13.845 //y2=1.085
cc_563 ( N_noxref_2_c_587_p N_CLK_c_5657_n ) capacitor c=0.00152405f \
 //x=12.875 //y=1.39 //x2=13.845 //y2=1.085
cc_564 ( N_noxref_2_c_588_p N_CLK_c_5657_n ) capacitor c=0.0151475f //x=13.405 \
 //y=1.045 //x2=13.845 //y2=1.085
cc_565 ( N_noxref_2_c_589_p N_CLK_c_5660_n ) capacitor c=0.00109982f \
 //x=12.875 //y=1.7 //x2=13.845 //y2=1.43
cc_566 ( N_noxref_2_c_590_p N_CLK_c_5660_n ) capacitor c=0.0111064f //x=13.405 \
 //y=1.39 //x2=13.845 //y2=1.43
cc_567 ( N_noxref_2_c_589_p N_CLK_c_5662_n ) capacitor c=9.58243e-19 \
 //x=12.875 //y=1.7 //x2=13.845 //y2=1.74
cc_568 ( N_noxref_2_c_568_p N_CLK_c_5662_n ) capacitor c=0.00662747f \
 //x=12.875 //y=2.095 //x2=13.845 //y2=1.74
cc_569 ( N_noxref_2_c_590_p N_CLK_c_5662_n ) capacitor c=0.00862358f \
 //x=13.405 //y=1.39 //x2=13.845 //y2=1.74
cc_570 ( N_noxref_2_c_588_p N_CLK_c_5665_n ) capacitor c=0.00127211f \
 //x=13.405 //y=1.045 //x2=14.375 //y2=1.085
cc_571 ( N_noxref_2_c_590_p N_CLK_c_5666_n ) capacitor c=0.00204774f \
 //x=13.405 //y=1.39 //x2=14.375 //y2=1.43
cc_572 ( N_noxref_2_c_550_p N_CLK_c_5667_n ) capacitor c=0.00167305f //x=13.07 \
 //y=2.26 //x2=13.81 //y2=2.26
cc_573 ( N_noxref_2_c_561_p N_CLK_c_5667_n ) capacitor c=0.0018937f //x=13.07 \
 //y=2.26 //x2=13.81 //y2=2.26
cc_574 ( N_noxref_2_c_568_p N_CLK_c_5667_n ) capacitor c=0.0181449f //x=12.875 \
 //y=2.095 //x2=13.81 //y2=2.26
cc_575 ( N_noxref_2_c_495_p N_CLK_c_5670_n ) capacitor c=0.00202662f //x=13.07 \
 //y=4.88 //x2=13.84 //y2=4.88
cc_576 ( N_noxref_2_c_498_p N_CLK_c_5670_n ) capacitor c=0.0288755f //x=13.07 \
 //y=4.88 //x2=13.84 //y2=4.88
cc_577 ( N_noxref_2_c_432_n N_VDD_c_10241_n ) capacitor c=0.00648267f \
 //x=10.625 //y=5.38 //x2=65.575 //y2=7.585
cc_578 ( N_noxref_2_c_490_p N_VDD_c_10241_n ) capacitor c=0.00492586f \
 //x=11.135 //y=5.38 //x2=65.575 //y2=7.585
cc_579 ( N_noxref_2_c_456_p N_VDD_c_10241_n ) capacitor c=4.58912e-19 \
 //x=11.22 //y=3.67 //x2=65.575 //y2=7.585
cc_580 ( N_noxref_2_c_462_p N_VDD_c_10241_n ) capacitor c=2.00712e-19 \
 //x=13.07 //y=3.67 //x2=65.575 //y2=7.585
cc_581 ( N_noxref_2_c_439_n N_VDD_c_10241_n ) capacitor c=0.00368834f //x=9.86 \
 //y=5.56 //x2=65.575 //y2=7.585
cc_582 ( N_noxref_2_c_492_p N_VDD_c_10241_n ) capacitor c=8.42594e-19 \
 //x=10.74 //y=5.38 //x2=65.575 //y2=7.585
cc_583 ( N_noxref_2_c_493_p N_VDD_c_10241_n ) capacitor c=0.00285853f \
 //x=10.74 //y=5.56 //x2=65.575 //y2=7.585
cc_584 ( N_noxref_2_c_494_p N_VDD_c_10241_n ) capacitor c=9.07241e-19 \
 //x=13.07 //y=4.88 //x2=65.575 //y2=7.585
cc_585 ( N_noxref_2_c_451_n N_VDD_c_10241_n ) capacitor c=0.00224881f //x=9.86 \
 //y=5.56 //x2=65.575 //y2=7.585
cc_586 ( N_noxref_2_c_514_p N_VDD_c_10241_n ) capacitor c=0.00224881f \
 //x=10.74 //y=5.56 //x2=65.575 //y2=7.585
cc_587 ( N_noxref_2_c_495_p N_VDD_c_10241_n ) capacitor c=6.22888e-19 \
 //x=13.07 //y=4.88 //x2=65.575 //y2=7.585
cc_588 ( N_noxref_2_c_432_n N_VDD_c_10261_n ) capacitor c=0.00208087f \
 //x=10.625 //y=5.38 //x2=10.215 //y2=7.585
cc_589 ( N_noxref_2_c_439_n N_VDD_c_10261_n ) capacitor c=9.41185e-19 //x=9.86 \
 //y=5.56 //x2=10.215 //y2=7.585
cc_590 ( N_noxref_2_c_451_n N_VDD_c_10261_n ) capacitor c=0.0136705f //x=9.86 \
 //y=5.56 //x2=10.215 //y2=7.585
cc_591 ( N_noxref_2_c_432_n N_VDD_c_10311_n ) capacitor c=0.00180737f \
 //x=10.625 //y=5.38 //x2=11.095 //y2=7.585
cc_592 ( N_noxref_2_c_490_p N_VDD_c_10311_n ) capacitor c=0.00208087f \
 //x=11.135 //y=5.38 //x2=11.095 //y2=7.585
cc_593 ( N_noxref_2_c_492_p N_VDD_c_10311_n ) capacitor c=4.23719e-19 \
 //x=10.74 //y=5.38 //x2=11.095 //y2=7.585
cc_594 ( N_noxref_2_c_493_p N_VDD_c_10311_n ) capacitor c=5.77976e-19 \
 //x=10.74 //y=5.56 //x2=11.095 //y2=7.585
cc_595 ( N_noxref_2_c_514_p N_VDD_c_10311_n ) capacitor c=0.0136705f //x=10.74 \
 //y=5.56 //x2=11.095 //y2=7.585
cc_596 ( N_noxref_2_c_494_p N_VDD_c_10316_n ) capacitor c=6.28113e-19 \
 //x=13.07 //y=4.88 //x2=13.545 //y2=7.585
cc_597 ( N_noxref_2_M60_noxref_g N_VDD_c_10316_n ) capacitor c=0.00732618f \
 //x=12.97 //y=6.2 //x2=13.545 //y2=7.585
cc_598 ( N_noxref_2_M61_noxref_g N_VDD_c_10316_n ) capacitor c=0.00755544f \
 //x=13.41 //y=6.2 //x2=13.545 //y2=7.585
cc_599 ( N_noxref_2_c_437_n N_VDD_c_10269_n ) capacitor c=0.0013228f //x=11.22 \
 //y=5.295 //x2=8.63 //y2=7.585
cc_600 ( N_noxref_2_c_439_n N_VDD_c_10269_n ) capacitor c=4.91377e-19 //x=9.86 \
 //y=5.56 //x2=8.63 //y2=7.585
cc_601 ( N_noxref_2_c_451_n N_VDD_c_10269_n ) capacitor c=0.0064135f //x=9.86 \
 //y=5.56 //x2=8.63 //y2=7.585
cc_602 ( N_noxref_2_c_437_n N_VDD_c_10322_n ) capacitor c=0.0285805f //x=11.22 \
 //y=5.295 //x2=11.96 //y2=7.585
cc_603 ( N_noxref_2_c_492_p N_VDD_c_10322_n ) capacitor c=0.00240948f \
 //x=10.74 //y=5.38 //x2=11.96 //y2=7.585
cc_604 ( N_noxref_2_c_493_p N_VDD_c_10322_n ) capacitor c=4.09141e-19 \
 //x=10.74 //y=5.56 //x2=11.96 //y2=7.585
cc_605 ( N_noxref_2_c_494_p N_VDD_c_10322_n ) capacitor c=0.00508547f \
 //x=13.07 //y=4.88 //x2=11.96 //y2=7.585
cc_606 ( N_noxref_2_c_463_p N_VDD_c_10322_n ) capacitor c=0.005822f //x=13.072 \
 //y=4.74 //x2=11.96 //y2=7.585
cc_607 ( N_noxref_2_c_514_p N_VDD_c_10322_n ) capacitor c=0.0101861f //x=10.74 \
 //y=5.56 //x2=11.96 //y2=7.585
cc_608 ( N_noxref_2_c_495_p N_VDD_c_10322_n ) capacitor c=0.00370494f \
 //x=13.07 //y=4.88 //x2=11.96 //y2=7.585
cc_609 ( N_noxref_2_c_498_p N_VDD_c_10322_n ) capacitor c=0.0129564f //x=13.07 \
 //y=4.88 //x2=11.96 //y2=7.585
cc_610 ( N_noxref_2_c_439_n N_VDD_M56_noxref_s ) capacitor c=0.0572211f \
 //x=9.86 //y=5.56 //x2=9.285 //y2=5.2
cc_611 ( N_noxref_2_c_492_p N_VDD_M56_noxref_s ) capacitor c=6.52457e-19 \
 //x=10.74 //y=5.38 //x2=9.285 //y2=5.2
cc_612 ( N_noxref_2_c_451_n N_VDD_M56_noxref_s ) capacitor c=0.0887533f \
 //x=9.86 //y=5.56 //x2=9.285 //y2=5.2
cc_613 ( N_noxref_2_c_432_n N_VDD_M57_noxref_d ) capacitor c=0.00734094f \
 //x=10.625 //y=5.38 //x2=10.155 //y2=5.2
cc_614 ( N_noxref_2_c_439_n N_VDD_M57_noxref_d ) capacitor c=0.0043528f \
 //x=9.86 //y=5.56 //x2=10.155 //y2=5.2
cc_615 ( N_noxref_2_c_493_p N_VDD_M57_noxref_d ) capacitor c=0.0043528f \
 //x=10.74 //y=5.56 //x2=10.155 //y2=5.2
cc_616 ( N_noxref_2_c_451_n N_VDD_M57_noxref_d ) capacitor c=0.065554f \
 //x=9.86 //y=5.56 //x2=10.155 //y2=5.2
cc_617 ( N_noxref_2_c_514_p N_VDD_M57_noxref_d ) capacitor c=0.065554f \
 //x=10.74 //y=5.56 //x2=10.155 //y2=5.2
cc_618 ( N_noxref_2_c_490_p N_VDD_M59_noxref_d ) capacitor c=0.00934027f \
 //x=11.135 //y=5.38 //x2=11.035 //y2=5.2
cc_619 ( N_noxref_2_c_493_p N_VDD_M59_noxref_d ) capacitor c=0.00587834f \
 //x=10.74 //y=5.56 //x2=11.035 //y2=5.2
cc_620 ( N_noxref_2_c_449_n N_VDD_M59_noxref_d ) capacitor c=9.65951e-19 \
 //x=11.22 //y=3.51 //x2=11.035 //y2=5.2
cc_621 ( N_noxref_2_c_514_p N_VDD_M59_noxref_d ) capacitor c=0.065554f \
 //x=10.74 //y=5.56 //x2=11.035 //y2=5.2
cc_622 ( N_noxref_2_c_490_p N_VDD_M60_noxref_s ) capacitor c=0.00326953f \
 //x=11.135 //y=5.38 //x2=12.615 //y2=5.2
cc_623 ( N_noxref_2_c_462_p N_VDD_M60_noxref_s ) capacitor c=0.00111275f \
 //x=13.07 //y=3.67 //x2=12.615 //y2=5.2
cc_624 ( N_noxref_2_c_492_p N_VDD_M60_noxref_s ) capacitor c=0.00515461f \
 //x=10.74 //y=5.38 //x2=12.615 //y2=5.2
cc_625 ( N_noxref_2_c_493_p N_VDD_M60_noxref_s ) capacitor c=3.28075e-19 \
 //x=10.74 //y=5.56 //x2=12.615 //y2=5.2
cc_626 ( N_noxref_2_M60_noxref_g N_VDD_M60_noxref_s ) capacitor c=0.0567929f \
 //x=12.97 //y=6.2 //x2=12.615 //y2=5.2
cc_627 ( N_noxref_2_M61_noxref_g N_VDD_M61_noxref_d ) capacitor c=0.015318f \
 //x=13.41 //y=6.2 //x2=13.485 //y2=5.2
cc_628 ( N_noxref_2_c_482_p N_GND_c_12361_n ) capacitor c=0.00618782f \
 //x=11.135 //y=1.835 //x2=13.055 //y2=0.175
cc_629 ( N_noxref_2_c_456_p N_GND_c_12361_n ) capacitor c=2.92483e-19 \
 //x=11.22 //y=3.67 //x2=13.055 //y2=0.175
cc_630 ( N_noxref_2_c_448_n N_GND_c_12361_n ) capacitor c=0.00937893f \
 //x=10.78 //y=1.18 //x2=13.055 //y2=0.175
cc_631 ( N_noxref_2_M6_noxref_d N_GND_c_12361_n ) capacitor c=3.01769e-19 \
 //x=10.59 //y=1.085 //x2=13.055 //y2=0.175
cc_632 ( N_noxref_2_c_439_n N_GND_c_12324_n ) capacitor c=7.57776e-19 //x=9.86 \
 //y=5.56 //x2=9.81 //y2=1.135
cc_633 ( N_noxref_2_c_448_n N_GND_c_12324_n ) capacitor c=0.0140087f //x=10.78 \
 //y=1.18 //x2=9.81 //y2=1.135
cc_634 ( N_noxref_2_M6_noxref_d N_GND_c_12324_n ) capacitor c=2.93544e-19 \
 //x=10.59 //y=1.085 //x2=9.81 //y2=1.135
cc_635 ( N_noxref_2_c_448_n N_GND_c_12368_n ) capacitor c=0.00549186f \
 //x=10.78 //y=1.18 //x2=13.14 //y2=1.135
cc_636 ( N_noxref_2_c_550_p N_GND_c_12368_n ) capacitor c=0.00667419f \
 //x=13.07 //y=2.26 //x2=13.14 //y2=1.135
cc_637 ( N_noxref_2_c_561_p N_GND_c_12368_n ) capacitor c=2.13705e-19 \
 //x=13.07 //y=2.26 //x2=13.14 //y2=1.135
cc_638 ( N_noxref_2_c_586_p N_GND_c_12368_n ) capacitor c=0.00171023f \
 //x=12.875 //y=1.045 //x2=13.14 //y2=1.135
cc_639 ( N_noxref_2_c_587_p N_GND_c_12368_n ) capacitor c=0.00357815f \
 //x=12.875 //y=1.39 //x2=13.14 //y2=1.135
cc_640 ( N_noxref_2_c_589_p N_GND_c_12368_n ) capacitor c=4.2764e-19 \
 //x=12.875 //y=1.7 //x2=13.14 //y2=1.135
cc_641 ( N_noxref_2_c_665_p N_GND_c_12368_n ) capacitor c=9.36995e-19 \
 //x=13.25 //y=0.89 //x2=13.14 //y2=1.135
cc_642 ( N_noxref_2_c_666_p N_GND_c_12368_n ) capacitor c=6.38426e-19 \
 //x=13.25 //y=1.545 //x2=13.14 //y2=1.135
cc_643 ( N_noxref_2_c_588_p N_GND_c_12368_n ) capacitor c=0.00171721f \
 //x=13.405 //y=1.045 //x2=13.14 //y2=1.135
cc_644 ( N_noxref_2_c_590_p N_GND_c_12368_n ) capacitor c=0.00296337f \
 //x=13.405 //y=1.39 //x2=13.14 //y2=1.135
cc_645 ( N_noxref_2_c_586_p N_GND_c_12378_n ) capacitor c=3.46594e-19 \
 //x=12.875 //y=1.045 //x2=13.137 //y2=1.005
cc_646 ( N_noxref_2_c_665_p N_GND_c_12378_n ) capacitor c=0.00839795f \
 //x=13.25 //y=0.89 //x2=13.137 //y2=1.005
cc_647 ( N_noxref_2_c_588_p N_GND_c_12378_n ) capacitor c=4.40641e-19 \
 //x=13.405 //y=1.045 //x2=13.137 //y2=1.005
cc_648 ( N_noxref_2_c_482_p N_GND_c_12339_n ) capacitor c=7.75992e-19 \
 //x=11.135 //y=1.835 //x2=11.79 //y2=0.175
cc_649 ( N_noxref_2_c_456_p N_GND_c_12339_n ) capacitor c=3.21489e-19 \
 //x=11.22 //y=3.67 //x2=11.79 //y2=0.175
cc_650 ( N_noxref_2_c_586_p N_GND_c_12383_n ) capacitor c=0.00688027f \
 //x=12.875 //y=1.045 //x2=15.12 //y2=0.175
cc_651 ( N_noxref_2_c_435_n N_GND_c_12345_n ) capacitor c=9.32616e-19 \
 //x=11.22 //y=3.35 //x2=8.63 //y2=0.175
cc_652 ( N_noxref_2_c_433_n N_GND_c_12385_n ) capacitor c=0.002973f //x=10.78 \
 //y=1.75 //x2=11.96 //y2=0.175
cc_653 ( N_noxref_2_c_482_p N_GND_c_12385_n ) capacitor c=0.0287405f \
 //x=11.135 //y=1.835 //x2=11.96 //y2=0.175
cc_654 ( N_noxref_2_c_471_p N_GND_c_12385_n ) capacitor c=0.00718667f \
 //x=13.07 //y=3.35 //x2=11.96 //y2=0.175
cc_655 ( N_noxref_2_c_550_p N_GND_c_12385_n ) capacitor c=0.00427323f \
 //x=13.07 //y=2.26 //x2=11.96 //y2=0.175
cc_656 ( N_noxref_2_c_461_p N_GND_c_12385_n ) capacitor c=0.00341388f \
 //x=12.905 //y=3.51 //x2=11.96 //y2=0.175
cc_657 ( N_noxref_2_c_561_p N_GND_c_12385_n ) capacitor c=0.0038607f //x=13.07 \
 //y=2.26 //x2=11.96 //y2=0.175
cc_658 ( N_noxref_2_c_589_p N_GND_c_12385_n ) capacitor c=0.0015404f \
 //x=12.875 //y=1.7 //x2=11.96 //y2=0.175
cc_659 ( N_noxref_2_c_568_p N_GND_c_12385_n ) capacitor c=0.00906518f \
 //x=12.875 //y=2.095 //x2=11.96 //y2=0.175
cc_660 ( N_noxref_2_c_448_n N_GND_M5_noxref_d ) capacitor c=2.82748e-19 \
 //x=10.78 //y=1.18 //x2=9.62 //y2=1.045
cc_661 ( N_noxref_2_c_550_p N_GND_M7_noxref_d ) capacitor c=2.20438e-19 \
 //x=13.07 //y=2.26 //x2=12.95 //y2=1.045
cc_662 ( N_noxref_2_c_586_p N_GND_M7_noxref_d ) capacitor c=0.00192399f \
 //x=12.875 //y=1.045 //x2=12.95 //y2=1.045
cc_663 ( N_noxref_2_c_587_p N_GND_M7_noxref_d ) capacitor c=0.00210798f \
 //x=12.875 //y=1.39 //x2=12.95 //y2=1.045
cc_664 ( N_noxref_2_c_665_p N_GND_M7_noxref_d ) capacitor c=0.00472259f \
 //x=13.25 //y=0.89 //x2=12.95 //y2=1.045
cc_665 ( N_noxref_2_c_666_p N_GND_M7_noxref_d ) capacitor c=0.00166857f \
 //x=13.25 //y=1.545 //x2=12.95 //y2=1.045
cc_666 ( N_noxref_2_c_588_p N_GND_M7_noxref_d ) capacitor c=0.00230174f \
 //x=13.405 //y=1.045 //x2=12.95 //y2=1.045
cc_667 ( N_noxref_2_c_590_p N_GND_M7_noxref_d ) capacitor c=0.00210798f \
 //x=13.405 //y=1.39 //x2=12.95 //y2=1.045
cc_668 ( N_noxref_2_c_434_n N_noxref_33_c_14112_n ) capacitor c=0.00911498f \
 //x=10.865 //y=1.835 //x2=10.295 //y2=1.675
cc_669 ( N_noxref_2_c_482_p N_noxref_33_c_14117_n ) capacitor c=0.00399245f \
 //x=11.135 //y=1.835 //x2=11.18 //y2=0.71
cc_670 ( N_noxref_2_c_448_n N_noxref_33_c_14117_n ) capacitor c=0.003751f \
 //x=10.78 //y=1.18 //x2=11.18 //y2=0.71
cc_671 ( N_noxref_2_M6_noxref_d N_noxref_33_c_14117_n ) capacitor \
 c=0.00910163f //x=10.59 //y=1.085 //x2=11.18 //y2=0.71
cc_672 ( N_noxref_2_c_433_n N_noxref_33_M5_noxref_s ) capacitor c=0.0162484f \
 //x=10.78 //y=1.75 //x2=9.19 //y2=0.545
cc_673 ( N_noxref_2_c_482_p N_noxref_33_M5_noxref_s ) capacitor c=0.00640979f \
 //x=11.135 //y=1.835 //x2=9.19 //y2=0.545
cc_674 ( N_noxref_2_c_456_p N_noxref_33_M5_noxref_s ) capacitor c=4.17069e-19 \
 //x=11.22 //y=3.67 //x2=9.19 //y2=0.545
cc_675 ( N_noxref_2_c_448_n N_noxref_33_M5_noxref_s ) capacitor c=0.00905169f \
 //x=10.78 //y=1.18 //x2=9.19 //y2=0.545
cc_676 ( N_noxref_2_c_449_n N_noxref_33_M5_noxref_s ) capacitor c=0.0010514f \
 //x=11.22 //y=3.51 //x2=9.19 //y2=0.545
cc_677 ( N_noxref_2_M6_noxref_d N_noxref_33_M5_noxref_s ) capacitor \
 c=0.0275552f //x=10.59 //y=1.085 //x2=9.19 //y2=0.545
cc_678 ( N_noxref_2_c_568_p N_noxref_34_c_14173_n ) capacitor c=0.00262672f \
 //x=12.875 //y=2.095 //x2=12.655 //y2=1.675
cc_679 ( N_noxref_2_c_462_p N_noxref_34_c_14174_n ) capacitor c=0.00402188f \
 //x=13.07 //y=3.67 //x2=13.54 //y2=1.76
cc_680 ( N_noxref_2_c_550_p N_noxref_34_c_14174_n ) capacitor c=0.00509504f \
 //x=13.07 //y=2.26 //x2=13.54 //y2=1.76
cc_681 ( N_noxref_2_c_561_p N_noxref_34_c_14174_n ) capacitor c=0.00655412f \
 //x=13.07 //y=2.26 //x2=13.54 //y2=1.76
cc_682 ( N_noxref_2_c_589_p N_noxref_34_c_14174_n ) capacitor c=0.00697076f \
 //x=12.875 //y=1.7 //x2=13.54 //y2=1.76
cc_683 ( N_noxref_2_c_568_p N_noxref_34_c_14174_n ) capacitor c=0.0191405f \
 //x=12.875 //y=2.095 //x2=13.54 //y2=1.76
cc_684 ( N_noxref_2_c_666_p N_noxref_34_c_14174_n ) capacitor c=0.00723574f \
 //x=13.25 //y=1.545 //x2=13.54 //y2=1.76
cc_685 ( N_noxref_2_c_590_p N_noxref_34_c_14174_n ) capacitor c=0.00339872f \
 //x=13.405 //y=1.39 //x2=13.54 //y2=1.76
cc_686 ( N_noxref_2_c_568_p N_noxref_34_c_14181_n ) capacitor c=6.71402e-19 \
 //x=12.875 //y=2.095 //x2=13.625 //y2=1.675
cc_687 ( N_noxref_2_c_586_p N_noxref_34_M7_noxref_s ) capacitor c=0.0294925f \
 //x=12.875 //y=1.045 //x2=12.52 //y2=0.545
cc_688 ( N_noxref_2_c_589_p N_noxref_34_M7_noxref_s ) capacitor c=3.48408e-19 \
 //x=12.875 //y=1.7 //x2=12.52 //y2=0.545
cc_689 ( N_noxref_2_c_588_p N_noxref_34_M7_noxref_s ) capacitor c=0.0125442f \
 //x=13.405 //y=1.045 //x2=12.52 //y2=0.545
cc_690 ( N_noxref_3_M65_noxref_g N_noxref_4_c_1195_n ) capacitor c=0.00890351f \
 //x=16.74 //y=6.2 //x2=17.285 //y2=5.38
cc_691 ( N_noxref_3_c_831_p N_noxref_4_c_1196_n ) capacitor c=0.00363554f \
 //x=16.4 //y=3.725 //x2=17.88 //y2=3.705
cc_692 ( N_noxref_3_c_832_p N_noxref_4_c_1197_n ) capacitor c=0.00149212f \
 //x=16.402 //y=4.74 //x2=17.88 //y2=5.295
cc_693 ( N_noxref_3_c_833_p N_noxref_4_c_1198_n ) capacitor c=8.193e-19 \
 //x=16.4 //y=4.045 //x2=16.52 //y2=5.56
cc_694 ( N_noxref_3_c_834_p N_noxref_4_c_1198_n ) capacitor c=0.0117748f \
 //x=16.4 //y=4.88 //x2=16.52 //y2=5.56
cc_695 ( N_noxref_3_c_835_p N_noxref_4_c_1198_n ) capacitor c=0.00277154f \
 //x=16.4 //y=4.88 //x2=16.52 //y2=5.56
cc_696 ( N_noxref_3_M64_noxref_g N_noxref_4_c_1198_n ) capacitor c=0.00201806f \
 //x=16.3 //y=6.2 //x2=16.52 //y2=5.56
cc_697 ( N_noxref_3_M65_noxref_g N_noxref_4_c_1198_n ) capacitor c=0.00192712f \
 //x=16.74 //y=6.2 //x2=16.52 //y2=5.56
cc_698 ( N_noxref_3_c_838_p N_noxref_4_c_1198_n ) capacitor c=0.00187457f \
 //x=16.4 //y=4.88 //x2=16.52 //y2=5.56
cc_699 ( N_noxref_3_c_839_p N_noxref_4_c_1204_n ) capacitor c=0.00251935f \
 //x=16.4 //y=3.88 //x2=17.88 //y2=3.88
cc_700 ( N_noxref_3_c_828_n N_noxref_4_c_1205_n ) capacitor c=0.00488914f \
 //x=13.28 //y=3.895 //x2=18.04 //y2=3.865
cc_701 ( N_noxref_3_c_833_p N_noxref_4_c_1206_n ) capacitor c=2.39213e-19 \
 //x=16.4 //y=4.045 //x2=16.52 //y2=5.56
cc_702 ( N_noxref_3_c_834_p N_noxref_4_c_1206_n ) capacitor c=0.00104426f \
 //x=16.4 //y=4.88 //x2=16.52 //y2=5.56
cc_703 ( N_noxref_3_c_835_p N_noxref_4_c_1206_n ) capacitor c=0.00377369f \
 //x=16.4 //y=4.88 //x2=16.52 //y2=5.56
cc_704 ( N_noxref_3_M64_noxref_g N_noxref_4_c_1206_n ) capacitor c=0.0158358f \
 //x=16.3 //y=6.2 //x2=16.52 //y2=5.56
cc_705 ( N_noxref_3_M65_noxref_g N_noxref_4_c_1206_n ) capacitor c=0.0178987f \
 //x=16.74 //y=6.2 //x2=16.52 //y2=5.56
cc_706 ( N_noxref_3_c_838_p N_noxref_4_c_1206_n ) capacitor c=0.0043218f \
 //x=16.4 //y=4.88 //x2=16.52 //y2=5.56
cc_707 ( N_noxref_3_c_796_n N_noxref_5_c_1482_n ) capacitor c=4.05935e-19 \
 //x=9.95 //y=3.89 //x2=10.48 //y2=4.095
cc_708 ( N_noxref_3_c_818_n N_noxref_5_c_1482_n ) capacitor c=0.0245303f \
 //x=10.7 //y=3.87 //x2=10.48 //y2=4.095
cc_709 ( N_noxref_3_c_796_n N_noxref_5_c_1490_n ) capacitor c=0.00219434f \
 //x=9.95 //y=3.89 //x2=10.48 //y2=4.415
cc_710 ( N_noxref_3_c_818_n N_noxref_5_c_1490_n ) capacitor c=0.00450788f \
 //x=10.7 //y=3.87 //x2=10.48 //y2=4.415
cc_711 ( N_noxref_3_c_831_p N_noxref_5_c_1552_n ) capacitor c=0.0213948f \
 //x=16.4 //y=3.725 //x2=14.55 //y2=4.105
cc_712 ( N_noxref_3_c_833_p N_noxref_5_c_1552_n ) capacitor c=0.00254581f \
 //x=16.4 //y=4.045 //x2=14.55 //y2=4.105
cc_713 ( N_noxref_3_c_853_p N_noxref_5_c_1552_n ) capacitor c=0.00457386f \
 //x=16.4 //y=2.26 //x2=14.55 //y2=4.105
cc_714 ( N_noxref_3_c_832_p N_noxref_5_c_1552_n ) capacitor c=0.00103966f \
 //x=16.402 //y=4.74 //x2=14.55 //y2=4.105
cc_715 ( N_noxref_3_c_828_n N_noxref_5_c_1552_n ) capacitor c=0.0284003f \
 //x=13.28 //y=3.895 //x2=14.55 //y2=4.105
cc_716 ( N_noxref_3_c_832_p N_noxref_5_c_1622_n ) capacitor c=0.00233357f \
 //x=16.402 //y=4.74 //x2=14.55 //y2=4.425
cc_717 ( N_noxref_3_c_828_n N_noxref_5_c_1622_n ) capacitor c=0.00650588f \
 //x=13.28 //y=3.895 //x2=14.55 //y2=4.425
cc_718 ( N_noxref_3_c_834_p N_noxref_5_c_1555_n ) capacitor c=0.00413257f \
 //x=16.4 //y=4.88 //x2=14.55 //y2=5.295
cc_719 ( N_noxref_3_c_832_p N_noxref_5_c_1555_n ) capacitor c=0.00287591f \
 //x=16.402 //y=4.74 //x2=14.55 //y2=5.295
cc_720 ( N_noxref_3_c_756_n N_noxref_5_c_1500_n ) capacitor c=0.00127339f \
 //x=4.56 //y=4.04 //x2=4.175 //y2=4.25
cc_721 ( N_noxref_3_c_758_n N_noxref_5_c_1500_n ) capacitor c=3.11164e-19 \
 //x=4.56 //y=5.25 //x2=4.175 //y2=4.25
cc_722 ( N_noxref_3_c_862_p N_noxref_5_c_1500_n ) capacitor c=0.02256f \
 //x=2.022 //y=5.335 //x2=4.175 //y2=4.25
cc_723 ( N_noxref_3_c_783_n N_noxref_5_c_1500_n ) capacitor c=0.0358254f \
 //x=4.72 //y=3.88 //x2=4.175 //y2=4.25
cc_724 ( N_noxref_3_c_756_n N_noxref_5_c_1504_n ) capacitor c=0.00757046f \
 //x=4.56 //y=4.04 //x2=4.775 //y2=4.265
cc_725 ( N_noxref_3_c_758_n N_noxref_5_c_1504_n ) capacitor c=0.0226561f \
 //x=4.56 //y=5.25 //x2=4.775 //y2=4.265
cc_726 ( N_noxref_3_c_781_n N_noxref_5_c_1504_n ) capacitor c=0.127147f \
 //x=6.245 //y=3.88 //x2=4.775 //y2=4.265
cc_727 ( N_noxref_3_c_767_n N_noxref_5_c_1505_n ) capacitor c=0.00324642f \
 //x=6.41 //y=4.04 //x2=6.02 //y2=4.25
cc_728 ( N_noxref_3_c_779_n N_noxref_5_c_1505_n ) capacitor c=4.98743e-19 \
 //x=6.412 //y=4.74 //x2=6.02 //y2=4.25
cc_729 ( N_noxref_3_c_781_n N_noxref_5_c_1505_n ) capacitor c=0.0107932f \
 //x=6.245 //y=3.88 //x2=6.02 //y2=4.25
cc_730 ( N_noxref_3_c_788_n N_noxref_5_c_1505_n ) capacitor c=0.0358254f \
 //x=7.755 //y=3.895 //x2=6.02 //y2=4.25
cc_731 ( N_noxref_3_c_767_n N_noxref_5_c_1506_n ) capacitor c=0.00240423f \
 //x=6.41 //y=4.04 //x2=6.62 //y2=4.265
cc_732 ( N_noxref_3_c_779_n N_noxref_5_c_1506_n ) capacitor c=0.0221402f \
 //x=6.412 //y=4.74 //x2=6.62 //y2=4.265
cc_733 ( N_noxref_3_c_788_n N_noxref_5_c_1506_n ) capacitor c=0.0116221f \
 //x=7.755 //y=3.895 //x2=6.62 //y2=4.265
cc_734 ( N_noxref_3_c_818_n N_noxref_5_c_1569_n ) capacitor c=0.0811622f \
 //x=10.7 //y=3.87 //x2=14.38 //y2=4.25
cc_735 ( N_noxref_3_c_821_n N_noxref_5_c_1569_n ) capacitor c=0.11052f \
 //x=11.44 //y=3.895 //x2=14.38 //y2=4.25
cc_736 ( N_noxref_3_c_824_n N_noxref_5_c_1569_n ) capacitor c=0.0564053f \
 //x=12.68 //y=3.88 //x2=14.38 //y2=4.25
cc_737 ( N_noxref_3_c_828_n N_noxref_5_c_1569_n ) capacitor c=0.0852213f \
 //x=13.28 //y=3.895 //x2=14.38 //y2=4.25
cc_738 ( N_noxref_3_c_779_n N_noxref_5_c_1507_n ) capacitor c=3.14882e-19 \
 //x=6.412 //y=4.74 //x2=10.645 //y2=4.25
cc_739 ( N_noxref_3_c_785_n N_noxref_5_c_1507_n ) capacitor c=0.111441f \
 //x=8.1 //y=3.895 //x2=10.645 //y2=4.25
cc_740 ( N_noxref_3_c_788_n N_noxref_5_c_1507_n ) capacitor c=0.131639f \
 //x=7.755 //y=3.895 //x2=10.645 //y2=4.25
cc_741 ( N_noxref_3_c_792_n N_noxref_5_c_1507_n ) capacitor c=0.055806f \
 //x=9.35 //y=3.88 //x2=10.645 //y2=4.25
cc_742 ( N_noxref_3_c_796_n N_noxref_5_c_1507_n ) capacitor c=0.0237381f \
 //x=9.95 //y=3.89 //x2=10.645 //y2=4.25
cc_743 ( N_noxref_3_c_818_n N_noxref_5_c_1507_n ) capacitor c=0.0358686f \
 //x=10.7 //y=3.87 //x2=10.645 //y2=4.25
cc_744 ( N_noxref_3_c_833_p N_noxref_5_c_1650_n ) capacitor c=0.00248847f \
 //x=16.4 //y=4.045 //x2=16.615 //y2=4.27
cc_745 ( N_noxref_3_c_832_p N_noxref_5_c_1650_n ) capacitor c=0.0223229f \
 //x=16.402 //y=4.74 //x2=16.615 //y2=4.27
cc_746 ( N_noxref_3_c_833_p N_noxref_5_c_1652_n ) capacitor c=0.00322776f \
 //x=16.4 //y=4.045 //x2=16.27 //y2=4.27
cc_747 ( N_noxref_3_c_832_p N_noxref_5_c_1652_n ) capacitor c=0.00208639f \
 //x=16.402 //y=4.74 //x2=16.27 //y2=4.27
cc_748 ( N_noxref_3_c_828_n N_noxref_5_c_1652_n ) capacitor c=0.207673f \
 //x=13.28 //y=3.895 //x2=16.27 //y2=4.27
cc_749 ( N_noxref_3_c_862_p N_noxref_5_M46_noxref_g ) capacitor c=0.00501342f \
 //x=2.022 //y=5.335 //x2=1.8 //y2=6.2
cc_750 ( N_noxref_3_c_890_p N_noxref_5_M46_noxref_g ) capacitor c=0.0162284f \
 //x=2.02 //y=5.56 //x2=1.8 //y2=6.2
cc_751 ( N_noxref_3_c_891_p N_noxref_5_M47_noxref_g ) capacitor c=0.00973141f \
 //x=2.78 //y=5.335 //x2=2.24 //y2=6.2
cc_752 ( N_noxref_3_c_862_p N_noxref_5_M47_noxref_g ) capacitor c=0.00229208f \
 //x=2.022 //y=5.335 //x2=2.24 //y2=6.2
cc_753 ( N_noxref_3_c_890_p N_noxref_5_M47_noxref_g ) capacitor c=0.0179041f \
 //x=2.02 //y=5.56 //x2=2.24 //y2=6.2
cc_754 ( N_noxref_3_c_862_p N_noxref_5_c_1660_n ) capacitor c=0.00171885f \
 //x=2.022 //y=5.335 //x2=2.165 //y2=4.97
cc_755 ( N_noxref_3_c_890_p N_noxref_5_c_1660_n ) capacitor c=0.00291477f \
 //x=2.02 //y=5.56 //x2=2.165 //y2=4.97
cc_756 ( N_noxref_3_c_745_n D ) capacitor c=0.00102517f //x=4.56 //y=3.72 \
 //x2=7.15 //y2=3.14
cc_757 ( N_noxref_3_c_758_n D ) capacitor c=0.00115385f //x=4.56 //y=5.25 \
 //x2=7.15 //y2=3.14
cc_758 ( N_noxref_3_c_762_n D ) capacitor c=0.0329293f //x=6.41 //y=3.72 \
 //x2=7.15 //y2=3.14
cc_759 ( N_noxref_3_c_767_n D ) capacitor c=0.0144744f //x=6.41 //y=4.04 \
 //x2=7.15 //y2=3.14
cc_760 ( N_noxref_3_c_900_p D ) capacitor c=6.03895e-19 //x=6.405 //y=3.88 \
 //x2=7.15 //y2=3.14
cc_761 ( N_noxref_3_c_779_n D ) capacitor c=0.0261735f //x=6.412 //y=4.74 \
 //x2=7.15 //y2=3.14
cc_762 ( N_noxref_3_c_788_n D ) capacitor c=0.0234438f //x=7.755 //y=3.895 \
 //x2=7.15 //y2=3.14
cc_763 ( N_noxref_3_c_803_n D ) capacitor c=3.02466e-19 //x=6.41 //y=4.88 \
 //x2=7.15 //y2=3.14
cc_764 ( N_noxref_3_c_810_n D ) capacitor c=0.00108965f //x=6.41 //y=4.88 \
 //x2=7.15 //y2=3.14
cc_765 ( N_noxref_3_c_762_n D ) capacitor c=6.54489e-19 //x=6.41 //y=3.72 \
 //x2=7.15 //y2=2.77
cc_766 ( N_noxref_3_c_745_n N_D_c_4236_n ) capacitor c=6.80633e-19 //x=4.56 \
 //y=3.72 //x2=7.15 //y2=2.625
cc_767 ( N_noxref_3_c_762_n N_D_c_4236_n ) capacitor c=0.00978472f //x=6.41 \
 //y=3.72 //x2=7.15 //y2=2.625
cc_768 ( N_noxref_3_c_908_p N_D_c_4236_n ) capacitor c=3.49899e-19 //x=6.41 \
 //y=2.26 //x2=7.15 //y2=2.625
cc_769 ( N_noxref_3_c_762_n N_D_c_4238_n ) capacitor c=0.014957f //x=6.41 \
 //y=3.72 //x2=7.15 //y2=2.945
cc_770 ( N_noxref_3_c_777_n N_D_c_4246_n ) capacitor c=0.0172863f //x=6.41 \
 //y=4.88 //x2=7.15 //y2=4.735
cc_771 ( N_noxref_3_c_803_n N_D_c_4246_n ) capacitor c=4.73677e-19 //x=6.41 \
 //y=4.88 //x2=7.15 //y2=4.735
cc_772 ( N_noxref_3_c_810_n N_D_c_4246_n ) capacitor c=9.22067e-19 //x=6.41 \
 //y=4.88 //x2=7.15 //y2=4.735
cc_773 ( N_noxref_3_c_776_n N_D_c_4248_n ) capacitor c=0.0205342f //x=6.41 \
 //y=2.26 //x2=7.15 //y2=2.26
cc_774 ( N_noxref_3_c_908_p N_D_c_4248_n ) capacitor c=5.16867e-19 //x=6.41 \
 //y=2.26 //x2=7.15 //y2=2.26
cc_775 ( N_noxref_3_c_915_p N_D_c_4248_n ) capacitor c=0.00167888f //x=6.215 \
 //y=2.095 //x2=7.15 //y2=2.26
cc_776 ( N_noxref_3_c_762_n N_D_c_4249_n ) capacitor c=0.00692765f //x=6.41 \
 //y=3.72 //x2=7.315 //y2=2.785
cc_777 ( N_noxref_3_c_831_p N_D_c_4251_n ) capacitor c=0.0311996f //x=16.4 \
 //y=3.725 //x2=28.435 //y2=2.78
cc_778 ( N_noxref_3_c_833_p N_D_c_4251_n ) capacitor c=0.0030424f //x=16.4 \
 //y=4.045 //x2=28.435 //y2=2.78
cc_779 ( N_noxref_3_c_853_p N_D_c_4251_n ) capacitor c=0.00366462f //x=16.4 \
 //y=2.26 //x2=28.435 //y2=2.78
cc_780 ( N_noxref_3_c_785_n N_D_c_4251_n ) capacitor c=0.0053399f //x=8.1 \
 //y=3.895 //x2=28.435 //y2=2.78
cc_781 ( N_noxref_3_c_788_n N_D_c_4251_n ) capacitor c=0.00404826f //x=7.755 \
 //y=3.895 //x2=28.435 //y2=2.78
cc_782 ( N_noxref_3_c_792_n N_D_c_4251_n ) capacitor c=0.00668298f //x=9.35 \
 //y=3.88 //x2=28.435 //y2=2.78
cc_783 ( N_noxref_3_c_796_n N_D_c_4251_n ) capacitor c=0.0234797f //x=9.95 \
 //y=3.89 //x2=28.435 //y2=2.78
cc_784 ( N_noxref_3_c_818_n N_D_c_4251_n ) capacitor c=0.0112008f //x=10.7 \
 //y=3.87 //x2=28.435 //y2=2.78
cc_785 ( N_noxref_3_c_821_n N_D_c_4251_n ) capacitor c=0.00530602f //x=11.44 \
 //y=3.895 //x2=28.435 //y2=2.78
cc_786 ( N_noxref_3_c_824_n N_D_c_4251_n ) capacitor c=0.00665349f //x=12.68 \
 //y=3.88 //x2=28.435 //y2=2.78
cc_787 ( N_noxref_3_c_828_n N_D_c_4251_n ) capacitor c=0.0960478f //x=13.28 \
 //y=3.895 //x2=28.435 //y2=2.78
cc_788 ( N_noxref_3_c_762_n N_D_c_4261_n ) capacitor c=3.49899e-19 //x=6.41 \
 //y=3.72 //x2=7.15 //y2=2.26
cc_789 ( N_noxref_3_c_776_n N_D_c_4261_n ) capacitor c=5.24723e-19 //x=6.41 \
 //y=2.26 //x2=7.15 //y2=2.26
cc_790 ( N_noxref_3_c_908_p N_D_c_4261_n ) capacitor c=0.00485709f //x=6.41 \
 //y=2.26 //x2=7.15 //y2=2.26
cc_791 ( N_noxref_3_c_915_p N_D_c_4261_n ) capacitor c=0.00190888f //x=6.215 \
 //y=2.095 //x2=7.15 //y2=2.26
cc_792 ( N_noxref_3_c_777_n N_D_c_4262_n ) capacitor c=4.80626e-19 //x=6.41 \
 //y=4.88 //x2=7.18 //y2=4.88
cc_793 ( N_noxref_3_c_803_n N_D_c_4262_n ) capacitor c=0.00397338f //x=6.41 \
 //y=4.88 //x2=7.18 //y2=4.88
cc_794 ( N_noxref_3_c_810_n N_D_c_4262_n ) capacitor c=0.00283894f //x=6.41 \
 //y=4.88 //x2=7.18 //y2=4.88
cc_795 ( N_noxref_3_M52_noxref_g N_D_M54_noxref_g ) capacitor c=0.0104892f \
 //x=6.31 //y=6.2 //x2=7.19 //y2=6.2
cc_796 ( N_noxref_3_M53_noxref_g N_D_M54_noxref_g ) capacitor c=0.107636f \
 //x=6.75 //y=6.2 //x2=7.19 //y2=6.2
cc_797 ( N_noxref_3_M53_noxref_g N_D_M55_noxref_g ) capacitor c=0.0100341f \
 //x=6.75 //y=6.2 //x2=7.63 //y2=6.2
cc_798 ( N_noxref_3_c_938_p N_D_c_4270_n ) capacitor c=4.86545e-19 //x=6.215 \
 //y=1.045 //x2=7.185 //y2=1.085
cc_799 ( N_noxref_3_c_939_p N_D_c_4270_n ) capacitor c=0.00152405f //x=6.215 \
 //y=1.39 //x2=7.185 //y2=1.085
cc_800 ( N_noxref_3_c_940_p N_D_c_4270_n ) capacitor c=0.0151475f //x=6.745 \
 //y=1.045 //x2=7.185 //y2=1.085
cc_801 ( N_noxref_3_c_941_p N_D_c_4272_n ) capacitor c=0.00109982f //x=6.215 \
 //y=1.7 //x2=7.185 //y2=1.43
cc_802 ( N_noxref_3_c_942_p N_D_c_4272_n ) capacitor c=0.0111064f //x=6.745 \
 //y=1.39 //x2=7.185 //y2=1.43
cc_803 ( N_noxref_3_c_941_p N_D_c_4275_n ) capacitor c=9.58243e-19 //x=6.215 \
 //y=1.7 //x2=7.185 //y2=1.74
cc_804 ( N_noxref_3_c_915_p N_D_c_4275_n ) capacitor c=0.00662747f //x=6.215 \
 //y=2.095 //x2=7.185 //y2=1.74
cc_805 ( N_noxref_3_c_942_p N_D_c_4275_n ) capacitor c=0.00862358f //x=6.745 \
 //y=1.39 //x2=7.185 //y2=1.74
cc_806 ( N_noxref_3_c_940_p N_D_c_4285_n ) capacitor c=0.00127211f //x=6.745 \
 //y=1.045 //x2=7.715 //y2=1.085
cc_807 ( N_noxref_3_c_942_p N_D_c_4287_n ) capacitor c=0.00204774f //x=6.745 \
 //y=1.39 //x2=7.715 //y2=1.43
cc_808 ( N_noxref_3_c_776_n N_D_c_4291_n ) capacitor c=0.00167305f //x=6.41 \
 //y=2.26 //x2=7.15 //y2=2.26
cc_809 ( N_noxref_3_c_908_p N_D_c_4291_n ) capacitor c=0.00266443f //x=6.41 \
 //y=2.26 //x2=7.15 //y2=2.26
cc_810 ( N_noxref_3_c_915_p N_D_c_4291_n ) capacitor c=0.0181449f //x=6.215 \
 //y=2.095 //x2=7.15 //y2=2.26
cc_811 ( N_noxref_3_c_777_n N_D_c_4294_n ) capacitor c=0.00158715f //x=6.41 \
 //y=4.88 //x2=7.18 //y2=4.88
cc_812 ( N_noxref_3_c_803_n N_D_c_4294_n ) capacitor c=0.00237977f //x=6.41 \
 //y=4.88 //x2=7.18 //y2=4.88
cc_813 ( N_noxref_3_c_810_n N_D_c_4294_n ) capacitor c=0.0297875f //x=6.41 \
 //y=4.88 //x2=7.18 //y2=4.88
cc_814 ( N_noxref_3_c_745_n CLK ) capacitor c=0.00285669f //x=4.56 //y=3.72 \
 //x2=2.71 //y2=2.77
cc_815 ( N_noxref_3_c_758_n CLK ) capacitor c=9.69745e-19 //x=4.56 //y=5.25 \
 //x2=2.71 //y2=2.77
cc_816 ( N_noxref_3_c_831_p CLK ) capacitor c=0.00275912f //x=16.4 //y=3.725 \
 //x2=13.81 //y2=3.14
cc_817 ( N_noxref_3_c_832_p CLK ) capacitor c=9.97903e-19 //x=16.402 //y=4.74 \
 //x2=13.81 //y2=3.14
cc_818 ( N_noxref_3_c_828_n CLK ) capacitor c=0.025222f //x=13.28 //y=3.895 \
 //x2=13.81 //y2=3.14
cc_819 ( N_noxref_3_c_891_p N_CLK_c_5594_n ) capacitor c=0.0292733f //x=2.78 \
 //y=5.335 //x2=2.71 //y2=4.88
cc_820 ( N_noxref_3_c_758_n N_CLK_c_5594_n ) capacitor c=9.02672e-19 //x=4.56 \
 //y=5.25 //x2=2.71 //y2=4.88
cc_821 ( N_noxref_3_c_961_p N_CLK_c_5594_n ) capacitor c=0.00156871f //x=2.9 \
 //y=5.56 //x2=2.71 //y2=4.88
cc_822 ( N_noxref_3_c_718_n N_CLK_c_5597_n ) capacitor c=0.0205765f //x=4.475 \
 //y=5.335 //x2=10.1 //y2=4.62
cc_823 ( N_noxref_3_c_758_n N_CLK_c_5597_n ) capacitor c=0.0299085f //x=4.56 \
 //y=5.25 //x2=10.1 //y2=4.62
cc_824 ( N_noxref_3_c_964_p N_CLK_c_5597_n ) capacitor c=0.0381516f //x=2.9 \
 //y=5.335 //x2=10.1 //y2=4.62
cc_825 ( N_noxref_3_c_777_n N_CLK_c_5597_n ) capacitor c=0.00354963f //x=6.41 \
 //y=4.88 //x2=10.1 //y2=4.62
cc_826 ( N_noxref_3_c_779_n N_CLK_c_5597_n ) capacitor c=0.0265157f //x=6.412 \
 //y=4.74 //x2=10.1 //y2=4.62
cc_827 ( N_noxref_3_c_781_n N_CLK_c_5597_n ) capacitor c=0.00800202f //x=6.245 \
 //y=3.88 //x2=10.1 //y2=4.62
cc_828 ( N_noxref_3_c_785_n N_CLK_c_5597_n ) capacitor c=0.00652937f //x=8.1 \
 //y=3.895 //x2=10.1 //y2=4.62
cc_829 ( N_noxref_3_c_788_n N_CLK_c_5597_n ) capacitor c=0.0104759f //x=7.755 \
 //y=3.895 //x2=10.1 //y2=4.62
cc_830 ( N_noxref_3_c_792_n N_CLK_c_5597_n ) capacitor c=0.00366688f //x=9.35 \
 //y=3.88 //x2=10.1 //y2=4.62
cc_831 ( N_noxref_3_c_796_n N_CLK_c_5597_n ) capacitor c=0.00298807f //x=9.95 \
 //y=3.89 //x2=10.1 //y2=4.62
cc_832 ( N_noxref_3_c_818_n N_CLK_c_5642_n ) capacitor c=0.00185444f //x=10.7 \
 //y=3.87 //x2=10.7 //y2=4.64
cc_833 ( N_noxref_3_c_832_p N_CLK_c_5691_n ) capacitor c=3.47049e-19 \
 //x=16.402 //y=4.74 //x2=14.763 //y2=4.642
cc_834 ( N_noxref_3_c_828_n N_CLK_c_5691_n ) capacitor c=0.0072652f //x=13.28 \
 //y=3.895 //x2=14.763 //y2=4.642
cc_835 ( N_noxref_3_c_818_n N_CLK_c_5643_n ) capacitor c=0.00441327f //x=10.7 \
 //y=3.87 //x2=14.395 //y2=4.642
cc_836 ( N_noxref_3_c_821_n N_CLK_c_5643_n ) capacitor c=0.00648f //x=11.44 \
 //y=3.895 //x2=14.395 //y2=4.642
cc_837 ( N_noxref_3_c_824_n N_CLK_c_5643_n ) capacitor c=0.00368716f //x=12.68 \
 //y=3.88 //x2=14.395 //y2=4.642
cc_838 ( N_noxref_3_c_828_n N_CLK_c_5643_n ) capacitor c=0.00886299f //x=13.28 \
 //y=3.895 //x2=14.395 //y2=4.642
cc_839 ( N_noxref_3_c_891_p N_CLK_c_5604_n ) capacitor c=0.0107023f //x=2.78 \
 //y=5.335 //x2=2.71 //y2=4.62
cc_840 ( N_noxref_3_c_834_p N_CLK_c_5698_n ) capacitor c=0.00349424f //x=16.4 \
 //y=4.88 //x2=17.235 //y2=4.62
cc_841 ( N_noxref_3_c_832_p N_CLK_c_5698_n ) capacitor c=0.0248829f //x=16.402 \
 //y=4.74 //x2=17.235 //y2=4.62
cc_842 ( N_noxref_3_c_891_p N_CLK_c_5609_n ) capacitor c=0.00495283f //x=2.78 \
 //y=5.335 //x2=2.71 //y2=4.88
cc_843 ( N_noxref_3_c_964_p N_CLK_c_5609_n ) capacitor c=0.00132214f //x=2.9 \
 //y=5.335 //x2=2.71 //y2=4.88
cc_844 ( N_noxref_3_c_891_p N_CLK_M48_noxref_g ) capacitor c=0.00853188f \
 //x=2.78 //y=5.335 //x2=2.68 //y2=6.2
cc_845 ( N_noxref_3_c_964_p N_CLK_M48_noxref_g ) capacitor c=0.00229818f \
 //x=2.9 //y=5.335 //x2=2.68 //y2=6.2
cc_846 ( N_noxref_3_c_961_p N_CLK_M48_noxref_g ) capacitor c=0.0179041f \
 //x=2.9 //y=5.56 //x2=2.68 //y2=6.2
cc_847 ( N_noxref_3_c_714_n N_CLK_M49_noxref_g ) capacitor c=0.00955829f \
 //x=3.665 //y=5.335 //x2=3.12 //y2=6.2
cc_848 ( N_noxref_3_c_964_p N_CLK_M49_noxref_g ) capacitor c=0.00230699f \
 //x=2.9 //y=5.335 //x2=3.12 //y2=6.2
cc_849 ( N_noxref_3_c_961_p N_CLK_M49_noxref_g ) capacitor c=0.0179041f \
 //x=2.9 //y=5.56 //x2=3.12 //y2=6.2
cc_850 ( N_noxref_3_c_964_p N_CLK_c_5622_n ) capacitor c=0.0016987f //x=2.9 \
 //y=5.335 //x2=3.045 //y2=4.97
cc_851 ( N_noxref_3_c_961_p N_CLK_c_5622_n ) capacitor c=0.00294585f //x=2.9 \
 //y=5.56 //x2=3.045 //y2=4.97
cc_852 ( N_noxref_3_c_891_p N_CLK_c_5623_n ) capacitor c=3.4353e-19 //x=2.78 \
 //y=5.335 //x2=2.71 //y2=4.88
cc_853 ( N_noxref_3_c_831_p N_noxref_20_c_9133_n ) capacitor c=0.0238858f \
 //x=16.4 //y=3.725 //x2=17.14 //y2=2.995
cc_854 ( N_noxref_3_c_994_p N_noxref_20_c_9133_n ) capacitor c=3.49899e-19 \
 //x=16.4 //y=2.26 //x2=17.14 //y2=2.995
cc_855 ( N_noxref_3_c_831_p N_noxref_20_c_9135_n ) capacitor c=0.0156188f \
 //x=16.4 //y=3.725 //x2=17.14 //y2=3.315
cc_856 ( N_noxref_3_c_831_p N_noxref_20_c_9136_n ) capacitor c=0.0194111f \
 //x=16.4 //y=3.725 //x2=17.14 //y2=4.735
cc_857 ( N_noxref_3_c_833_p N_noxref_20_c_9136_n ) capacitor c=0.0148501f \
 //x=16.4 //y=4.045 //x2=17.14 //y2=4.735
cc_858 ( N_noxref_3_c_839_p N_noxref_20_c_9136_n ) capacitor c=5.57251e-19 \
 //x=16.4 //y=3.88 //x2=17.14 //y2=4.735
cc_859 ( N_noxref_3_c_834_p N_noxref_20_c_9136_n ) capacitor c=0.0172863f \
 //x=16.4 //y=4.88 //x2=17.14 //y2=4.735
cc_860 ( N_noxref_3_c_832_p N_noxref_20_c_9136_n ) capacitor c=0.0258648f \
 //x=16.402 //y=4.74 //x2=17.14 //y2=4.735
cc_861 ( N_noxref_3_c_828_n N_noxref_20_c_9136_n ) capacitor c=0.00380919f \
 //x=13.28 //y=3.895 //x2=17.14 //y2=4.735
cc_862 ( N_noxref_3_c_835_p N_noxref_20_c_9136_n ) capacitor c=7.76143e-19 \
 //x=16.4 //y=4.88 //x2=17.14 //y2=4.735
cc_863 ( N_noxref_3_c_838_p N_noxref_20_c_9136_n ) capacitor c=0.00201171f \
 //x=16.4 //y=4.88 //x2=17.14 //y2=4.735
cc_864 ( N_noxref_3_c_853_p N_noxref_20_c_9144_n ) capacitor c=0.0205342f \
 //x=16.4 //y=2.26 //x2=17.14 //y2=2.26
cc_865 ( N_noxref_3_c_994_p N_noxref_20_c_9144_n ) capacitor c=5.16867e-19 \
 //x=16.4 //y=2.26 //x2=17.14 //y2=2.26
cc_866 ( N_noxref_3_c_1006_p N_noxref_20_c_9144_n ) capacitor c=0.00167888f \
 //x=16.205 //y=2.095 //x2=17.14 //y2=2.26
cc_867 ( N_noxref_3_c_831_p N_noxref_20_c_9147_n ) capacitor c=9.19401e-19 \
 //x=16.4 //y=3.725 //x2=17.14 //y2=3.14
cc_868 ( N_noxref_3_c_831_p N_noxref_20_c_9148_n ) capacitor c=0.00706905f \
 //x=16.4 //y=3.725 //x2=17.285 //y2=3.155
cc_869 ( N_noxref_3_c_831_p N_noxref_20_c_9149_n ) capacitor c=3.49899e-19 \
 //x=16.4 //y=3.725 //x2=17.14 //y2=2.26
cc_870 ( N_noxref_3_c_853_p N_noxref_20_c_9149_n ) capacitor c=5.24723e-19 \
 //x=16.4 //y=2.26 //x2=17.14 //y2=2.26
cc_871 ( N_noxref_3_c_994_p N_noxref_20_c_9149_n ) capacitor c=0.00525888f \
 //x=16.4 //y=2.26 //x2=17.14 //y2=2.26
cc_872 ( N_noxref_3_c_1006_p N_noxref_20_c_9149_n ) capacitor c=0.00190888f \
 //x=16.205 //y=2.095 //x2=17.14 //y2=2.26
cc_873 ( N_noxref_3_c_834_p N_noxref_20_c_9153_n ) capacitor c=4.80626e-19 \
 //x=16.4 //y=4.88 //x2=17.17 //y2=4.88
cc_874 ( N_noxref_3_c_835_p N_noxref_20_c_9153_n ) capacitor c=0.00397338f \
 //x=16.4 //y=4.88 //x2=17.17 //y2=4.88
cc_875 ( N_noxref_3_c_838_p N_noxref_20_c_9153_n ) capacitor c=0.00283894f \
 //x=16.4 //y=4.88 //x2=17.17 //y2=4.88
cc_876 ( N_noxref_3_M64_noxref_g N_noxref_20_M66_noxref_g ) capacitor \
 c=0.0104892f //x=16.3 //y=6.2 //x2=17.18 //y2=6.2
cc_877 ( N_noxref_3_M65_noxref_g N_noxref_20_M66_noxref_g ) capacitor \
 c=0.107636f //x=16.74 //y=6.2 //x2=17.18 //y2=6.2
cc_878 ( N_noxref_3_M65_noxref_g N_noxref_20_M67_noxref_g ) capacitor \
 c=0.0100341f //x=16.74 //y=6.2 //x2=17.62 //y2=6.2
cc_879 ( N_noxref_3_c_1019_p N_noxref_20_c_9159_n ) capacitor c=4.86545e-19 \
 //x=16.205 //y=1.045 //x2=17.175 //y2=1.085
cc_880 ( N_noxref_3_c_1020_p N_noxref_20_c_9159_n ) capacitor c=0.00152405f \
 //x=16.205 //y=1.39 //x2=17.175 //y2=1.085
cc_881 ( N_noxref_3_c_1021_p N_noxref_20_c_9159_n ) capacitor c=0.0151475f \
 //x=16.735 //y=1.045 //x2=17.175 //y2=1.085
cc_882 ( N_noxref_3_c_1022_p N_noxref_20_c_9162_n ) capacitor c=0.00109982f \
 //x=16.205 //y=1.7 //x2=17.175 //y2=1.43
cc_883 ( N_noxref_3_c_1023_p N_noxref_20_c_9162_n ) capacitor c=0.0111064f \
 //x=16.735 //y=1.39 //x2=17.175 //y2=1.43
cc_884 ( N_noxref_3_c_1022_p N_noxref_20_c_9164_n ) capacitor c=9.58243e-19 \
 //x=16.205 //y=1.7 //x2=17.175 //y2=1.74
cc_885 ( N_noxref_3_c_1006_p N_noxref_20_c_9164_n ) capacitor c=0.00662747f \
 //x=16.205 //y=2.095 //x2=17.175 //y2=1.74
cc_886 ( N_noxref_3_c_1023_p N_noxref_20_c_9164_n ) capacitor c=0.00862358f \
 //x=16.735 //y=1.39 //x2=17.175 //y2=1.74
cc_887 ( N_noxref_3_c_1021_p N_noxref_20_c_9167_n ) capacitor c=0.00127211f \
 //x=16.735 //y=1.045 //x2=17.705 //y2=1.085
cc_888 ( N_noxref_3_c_1023_p N_noxref_20_c_9168_n ) capacitor c=0.00204774f \
 //x=16.735 //y=1.39 //x2=17.705 //y2=1.43
cc_889 ( N_noxref_3_c_853_p N_noxref_20_c_9169_n ) capacitor c=0.00167305f \
 //x=16.4 //y=2.26 //x2=17.14 //y2=2.26
cc_890 ( N_noxref_3_c_994_p N_noxref_20_c_9169_n ) capacitor c=0.0018937f \
 //x=16.4 //y=2.26 //x2=17.14 //y2=2.26
cc_891 ( N_noxref_3_c_1006_p N_noxref_20_c_9169_n ) capacitor c=0.0181449f \
 //x=16.205 //y=2.095 //x2=17.14 //y2=2.26
cc_892 ( N_noxref_3_c_834_p N_noxref_20_c_9172_n ) capacitor c=0.00158715f \
 //x=16.4 //y=4.88 //x2=17.17 //y2=4.88
cc_893 ( N_noxref_3_c_835_p N_noxref_20_c_9172_n ) capacitor c=0.00237977f \
 //x=16.4 //y=4.88 //x2=17.17 //y2=4.88
cc_894 ( N_noxref_3_c_838_p N_noxref_20_c_9172_n ) capacitor c=0.0297875f \
 //x=16.4 //y=4.88 //x2=17.17 //y2=4.88
cc_895 ( N_noxref_3_c_891_p N_VDD_c_10241_n ) capacitor c=0.00599793f //x=2.78 \
 //y=5.335 //x2=65.575 //y2=7.585
cc_896 ( N_noxref_3_c_714_n N_VDD_c_10241_n ) capacitor c=0.00627192f \
 //x=3.665 //y=5.335 //x2=65.575 //y2=7.585
cc_897 ( N_noxref_3_c_715_n N_VDD_c_10241_n ) capacitor c=0.00256019f //x=3.78 \
 //y=5.56 //x2=65.575 //y2=7.585
cc_898 ( N_noxref_3_c_718_n N_VDD_c_10241_n ) capacitor c=0.00829247f \
 //x=4.475 //y=5.335 //x2=65.575 //y2=7.585
cc_899 ( N_noxref_3_c_756_n N_VDD_c_10241_n ) capacitor c=5.12643e-19 //x=4.56 \
 //y=4.04 //x2=65.575 //y2=7.585
cc_900 ( N_noxref_3_c_767_n N_VDD_c_10241_n ) capacitor c=2.12476e-19 //x=6.41 \
 //y=4.04 //x2=65.575 //y2=7.585
cc_901 ( N_noxref_3_c_833_p N_VDD_c_10241_n ) capacitor c=2.12639e-19 //x=16.4 \
 //y=4.045 //x2=65.575 //y2=7.585
cc_902 ( N_noxref_3_c_862_p N_VDD_c_10241_n ) capacitor c=0.00261804f \
 //x=2.022 //y=5.335 //x2=65.575 //y2=7.585
cc_903 ( N_noxref_3_c_964_p N_VDD_c_10241_n ) capacitor c=0.00262144f //x=2.9 \
 //y=5.335 //x2=65.575 //y2=7.585
cc_904 ( N_noxref_3_c_777_n N_VDD_c_10241_n ) capacitor c=9.07241e-19 //x=6.41 \
 //y=4.88 //x2=65.575 //y2=7.585
cc_905 ( N_noxref_3_c_834_p N_VDD_c_10241_n ) capacitor c=9.07241e-19 //x=16.4 \
 //y=4.88 //x2=65.575 //y2=7.585
cc_906 ( N_noxref_3_c_890_p N_VDD_c_10241_n ) capacitor c=0.0024232f //x=2.02 \
 //y=5.56 //x2=65.575 //y2=7.585
cc_907 ( N_noxref_3_c_961_p N_VDD_c_10241_n ) capacitor c=0.0024232f //x=2.9 \
 //y=5.56 //x2=65.575 //y2=7.585
cc_908 ( N_noxref_3_c_798_n N_VDD_c_10241_n ) capacitor c=0.0024232f //x=3.78 \
 //y=5.56 //x2=65.575 //y2=7.585
cc_909 ( N_noxref_3_c_803_n N_VDD_c_10241_n ) capacitor c=6.22888e-19 //x=6.41 \
 //y=4.88 //x2=65.575 //y2=7.585
cc_910 ( N_noxref_3_c_835_p N_VDD_c_10241_n ) capacitor c=6.22888e-19 //x=16.4 \
 //y=4.88 //x2=65.575 //y2=7.585
cc_911 ( N_noxref_3_c_862_p N_VDD_c_10364_n ) capacitor c=0.00331944f \
 //x=2.022 //y=5.335 //x2=1.23 //y2=7.58
cc_912 ( N_noxref_3_c_890_p N_VDD_c_10364_n ) capacitor c=0.00509469f //x=2.02 \
 //y=5.56 //x2=1.23 //y2=7.58
cc_913 ( N_noxref_3_c_891_p N_VDD_c_10366_n ) capacitor c=0.00202922f //x=2.78 \
 //y=5.335 //x2=2.375 //y2=7.585
cc_914 ( N_noxref_3_c_862_p N_VDD_c_10366_n ) capacitor c=9.3757e-19 //x=2.022 \
 //y=5.335 //x2=2.375 //y2=7.585
cc_915 ( N_noxref_3_c_890_p N_VDD_c_10366_n ) capacitor c=0.0138074f //x=2.02 \
 //y=5.56 //x2=2.375 //y2=7.585
cc_916 ( N_noxref_3_c_891_p N_VDD_c_10369_n ) capacitor c=0.0017701f //x=2.78 \
 //y=5.335 //x2=3.255 //y2=7.585
cc_917 ( N_noxref_3_c_714_n N_VDD_c_10369_n ) capacitor c=0.00202922f \
 //x=3.665 //y=5.335 //x2=3.255 //y2=7.585
cc_918 ( N_noxref_3_c_964_p N_VDD_c_10369_n ) capacitor c=9.48145e-19 //x=2.9 \
 //y=5.335 //x2=3.255 //y2=7.585
cc_919 ( N_noxref_3_c_961_p N_VDD_c_10369_n ) capacitor c=0.0138074f //x=2.9 \
 //y=5.56 //x2=3.255 //y2=7.585
cc_920 ( N_noxref_3_c_714_n N_VDD_c_10251_n ) capacitor c=0.00205906f \
 //x=3.665 //y=5.335 //x2=4.135 //y2=7.585
cc_921 ( N_noxref_3_c_715_n N_VDD_c_10251_n ) capacitor c=8.49654e-19 //x=3.78 \
 //y=5.56 //x2=4.135 //y2=7.585
cc_922 ( N_noxref_3_c_718_n N_VDD_c_10251_n ) capacitor c=0.00204238f \
 //x=4.475 //y=5.335 //x2=4.135 //y2=7.585
cc_923 ( N_noxref_3_c_798_n N_VDD_c_10251_n ) capacitor c=0.0138074f //x=3.78 \
 //y=5.56 //x2=4.135 //y2=7.585
cc_924 ( N_noxref_3_c_718_n N_VDD_c_10377_n ) capacitor c=0.00183742f \
 //x=4.475 //y=5.335 //x2=5.13 //y2=7.585
cc_925 ( N_noxref_3_c_777_n N_VDD_c_10253_n ) capacitor c=6.28113e-19 //x=6.41 \
 //y=4.88 //x2=6.885 //y2=7.585
cc_926 ( N_noxref_3_M52_noxref_g N_VDD_c_10253_n ) capacitor c=0.00732618f \
 //x=6.31 //y=6.2 //x2=6.885 //y2=7.585
cc_927 ( N_noxref_3_M53_noxref_g N_VDD_c_10253_n ) capacitor c=0.00755544f \
 //x=6.75 //y=6.2 //x2=6.885 //y2=7.585
cc_928 ( N_noxref_3_c_834_p N_VDD_c_10381_n ) capacitor c=6.28113e-19 //x=16.4 \
 //y=4.88 //x2=16.875 //y2=7.585
cc_929 ( N_noxref_3_M64_noxref_g N_VDD_c_10381_n ) capacitor c=0.00732618f \
 //x=16.3 //y=6.2 //x2=16.875 //y2=7.585
cc_930 ( N_noxref_3_M65_noxref_g N_VDD_c_10381_n ) capacitor c=0.00755544f \
 //x=16.74 //y=6.2 //x2=16.875 //y2=7.585
cc_931 ( N_noxref_3_c_715_n N_VDD_c_10264_n ) capacitor c=0.00269779f //x=3.78 \
 //y=5.56 //x2=5.3 //y2=7.585
cc_932 ( N_noxref_3_c_758_n N_VDD_c_10264_n ) capacitor c=0.0311457f //x=4.56 \
 //y=5.25 //x2=5.3 //y2=7.585
cc_933 ( N_noxref_3_c_777_n N_VDD_c_10264_n ) capacitor c=0.00447349f //x=6.41 \
 //y=4.88 //x2=5.3 //y2=7.585
cc_934 ( N_noxref_3_c_779_n N_VDD_c_10264_n ) capacitor c=0.005882f //x=6.412 \
 //y=4.74 //x2=5.3 //y2=7.585
cc_935 ( N_noxref_3_c_798_n N_VDD_c_10264_n ) capacitor c=0.00776541f //x=3.78 \
 //y=5.56 //x2=5.3 //y2=7.585
cc_936 ( N_noxref_3_c_803_n N_VDD_c_10264_n ) capacitor c=0.00370494f //x=6.41 \
 //y=4.88 //x2=5.3 //y2=7.585
cc_937 ( N_noxref_3_c_810_n N_VDD_c_10264_n ) capacitor c=0.0129731f //x=6.41 \
 //y=4.88 //x2=5.3 //y2=7.585
cc_938 ( N_noxref_3_c_834_p N_VDD_c_10391_n ) capacitor c=0.00508547f //x=16.4 \
 //y=4.88 //x2=15.29 //y2=7.585
cc_939 ( N_noxref_3_c_832_p N_VDD_c_10391_n ) capacitor c=0.00594364f \
 //x=16.402 //y=4.74 //x2=15.29 //y2=7.585
cc_940 ( N_noxref_3_c_835_p N_VDD_c_10391_n ) capacitor c=0.00370494f //x=16.4 \
 //y=4.88 //x2=15.29 //y2=7.585
cc_941 ( N_noxref_3_c_838_p N_VDD_c_10391_n ) capacitor c=0.0129564f //x=16.4 \
 //y=4.88 //x2=15.29 //y2=7.585
cc_942 ( N_noxref_3_c_862_p N_VDD_M46_noxref_s ) capacitor c=0.0451824f \
 //x=2.022 //y=5.335 //x2=1.445 //y2=5.2
cc_943 ( N_noxref_3_c_964_p N_VDD_M46_noxref_s ) capacitor c=7.80122e-19 \
 //x=2.9 //y=5.335 //x2=1.445 //y2=5.2
cc_944 ( N_noxref_3_c_890_p N_VDD_M46_noxref_s ) capacitor c=0.09305f //x=2.02 \
 //y=5.56 //x2=1.445 //y2=5.2
cc_945 ( N_noxref_3_c_891_p N_VDD_M47_noxref_d ) capacitor c=0.00700141f \
 //x=2.78 //y=5.335 //x2=2.315 //y2=5.2
cc_946 ( N_noxref_3_c_890_p N_VDD_M47_noxref_d ) capacitor c=0.0674491f \
 //x=2.02 //y=5.56 //x2=2.315 //y2=5.2
cc_947 ( N_noxref_3_c_961_p N_VDD_M47_noxref_d ) capacitor c=0.0674762f \
 //x=2.9 //y=5.56 //x2=2.315 //y2=5.2
cc_948 ( N_noxref_3_c_714_n N_VDD_M49_noxref_d ) capacitor c=0.00700141f \
 //x=3.665 //y=5.335 //x2=3.195 //y2=5.2
cc_949 ( N_noxref_3_c_961_p N_VDD_M49_noxref_d ) capacitor c=0.067493f //x=2.9 \
 //y=5.56 //x2=3.195 //y2=5.2
cc_950 ( N_noxref_3_c_798_n N_VDD_M49_noxref_d ) capacitor c=0.0674288f \
 //x=3.78 //y=5.56 //x2=3.195 //y2=5.2
cc_951 ( N_noxref_3_c_718_n N_VDD_M51_noxref_d ) capacitor c=0.00700141f \
 //x=4.475 //y=5.335 //x2=4.075 //y2=5.2
cc_952 ( N_noxref_3_c_798_n N_VDD_M51_noxref_d ) capacitor c=0.0673824f \
 //x=3.78 //y=5.56 //x2=4.075 //y2=5.2
cc_953 ( N_noxref_3_c_715_n N_VDD_M52_noxref_s ) capacitor c=0.00536022f \
 //x=3.78 //y=5.56 //x2=5.955 //y2=5.2
cc_954 ( N_noxref_3_c_718_n N_VDD_M52_noxref_s ) capacitor c=0.00211796f \
 //x=4.475 //y=5.335 //x2=5.955 //y2=5.2
cc_955 ( N_noxref_3_c_767_n N_VDD_M52_noxref_s ) capacitor c=0.00143547f \
 //x=6.41 //y=4.04 //x2=5.955 //y2=5.2
cc_956 ( N_noxref_3_M52_noxref_g N_VDD_M52_noxref_s ) capacitor c=0.0567929f \
 //x=6.31 //y=6.2 //x2=5.955 //y2=5.2
cc_957 ( N_noxref_3_M53_noxref_g N_VDD_M53_noxref_d ) capacitor c=0.015318f \
 //x=6.75 //y=6.2 //x2=6.825 //y2=5.2
cc_958 ( N_noxref_3_c_833_p N_VDD_M64_noxref_s ) capacitor c=0.00143574f \
 //x=16.4 //y=4.045 //x2=15.945 //y2=5.2
cc_959 ( N_noxref_3_M64_noxref_g N_VDD_M64_noxref_s ) capacitor c=0.0567929f \
 //x=16.3 //y=6.2 //x2=15.945 //y2=5.2
cc_960 ( N_noxref_3_M65_noxref_g N_VDD_M65_noxref_d ) capacitor c=0.015318f \
 //x=16.74 //y=6.2 //x2=16.815 //y2=5.2
cc_961 ( N_noxref_3_c_723_n N_noxref_23_c_11656_n ) capacitor c=0.0036878f \
 //x=4.075 //y=1.305 //x2=4.475 //y2=0.72
cc_962 ( N_noxref_3_c_738_n N_noxref_23_c_11656_n ) capacitor c=0.00366757f \
 //x=4.475 //y=1.845 //x2=4.475 //y2=0.72
cc_963 ( N_noxref_3_M2_noxref_d N_noxref_23_c_11656_n ) capacitor \
 c=0.00949319f //x=3.885 //y=1.095 //x2=4.475 //y2=0.72
cc_964 ( N_noxref_3_M2_noxref_d N_noxref_23_c_11661_n ) capacitor \
 c=0.00120711f //x=3.885 //y=1.095 //x2=3.59 //y2=1.175
cc_965 ( N_noxref_3_c_891_p N_noxref_23_M1_noxref_d ) capacitor c=0.00164346f \
 //x=2.78 //y=5.335 //x2=2.35 //y2=1.09
cc_966 ( N_noxref_3_c_723_n N_noxref_23_M1_noxref_d ) capacitor c=0.00802836f \
 //x=4.075 //y=1.305 //x2=2.35 //y2=1.09
cc_967 ( N_noxref_3_c_723_n N_noxref_23_M2_noxref_s ) capacitor c=0.00993092f \
 //x=4.075 //y=1.305 //x2=3.455 //y2=0.555
cc_968 ( N_noxref_3_c_732_n N_noxref_23_M2_noxref_s ) capacitor c=0.0273402f \
 //x=4.075 //y=1.76 //x2=3.455 //y2=0.555
cc_969 ( N_noxref_3_c_738_n N_noxref_23_M2_noxref_s ) capacitor c=0.00911719f \
 //x=4.475 //y=1.845 //x2=3.455 //y2=0.555
cc_970 ( N_noxref_3_c_775_n N_noxref_23_M2_noxref_s ) capacitor c=0.00129723f \
 //x=4.56 //y=3.88 //x2=3.455 //y2=0.555
cc_971 ( N_noxref_3_M2_noxref_d N_noxref_23_M2_noxref_s ) capacitor \
 c=0.0279003f //x=3.885 //y=1.095 //x2=3.455 //y2=0.555
cc_972 ( N_noxref_3_c_723_n N_GND_c_12316_n ) capacitor c=0.00901861f \
 //x=4.075 //y=1.305 //x2=6.395 //y2=0.175
cc_973 ( N_noxref_3_c_738_n N_GND_c_12316_n ) capacitor c=0.00713708f \
 //x=4.475 //y=1.845 //x2=6.395 //y2=0.175
cc_974 ( N_noxref_3_c_756_n N_GND_c_12316_n ) capacitor c=5.12643e-19 //x=4.56 \
 //y=4.04 //x2=6.395 //y2=0.175
cc_975 ( N_noxref_3_M2_noxref_d N_GND_c_12316_n ) capacitor c=2.9462e-19 \
 //x=3.885 //y=1.095 //x2=6.395 //y2=0.175
cc_976 ( N_noxref_3_c_723_n N_GND_c_12320_n ) capacitor c=0.00488628f \
 //x=4.075 //y=1.305 //x2=6.48 //y2=1.135
cc_977 ( N_noxref_3_c_776_n N_GND_c_12320_n ) capacitor c=0.00690832f //x=6.41 \
 //y=2.26 //x2=6.48 //y2=1.135
cc_978 ( N_noxref_3_c_908_p N_GND_c_12320_n ) capacitor c=2.13705e-19 //x=6.41 \
 //y=2.26 //x2=6.48 //y2=1.135
cc_979 ( N_noxref_3_c_938_p N_GND_c_12320_n ) capacitor c=0.00176535f \
 //x=6.215 //y=1.045 //x2=6.48 //y2=1.135
cc_980 ( N_noxref_3_c_939_p N_GND_c_12320_n ) capacitor c=0.0036005f //x=6.215 \
 //y=1.39 //x2=6.48 //y2=1.135
cc_981 ( N_noxref_3_c_941_p N_GND_c_12320_n ) capacitor c=4.2764e-19 //x=6.215 \
 //y=1.7 //x2=6.48 //y2=1.135
cc_982 ( N_noxref_3_c_1122_p N_GND_c_12320_n ) capacitor c=9.36995e-19 \
 //x=6.59 //y=0.89 //x2=6.48 //y2=1.135
cc_983 ( N_noxref_3_c_1123_p N_GND_c_12320_n ) capacitor c=6.38426e-19 \
 //x=6.59 //y=1.545 //x2=6.48 //y2=1.135
cc_984 ( N_noxref_3_c_940_p N_GND_c_12320_n ) capacitor c=0.00171721f \
 //x=6.745 //y=1.045 //x2=6.48 //y2=1.135
cc_985 ( N_noxref_3_c_942_p N_GND_c_12320_n ) capacitor c=0.00296337f \
 //x=6.745 //y=1.39 //x2=6.48 //y2=1.135
cc_986 ( N_noxref_3_c_938_p N_GND_c_12415_n ) capacitor c=3.51399e-19 \
 //x=6.215 //y=1.045 //x2=6.477 //y2=1.005
cc_987 ( N_noxref_3_c_1122_p N_GND_c_12415_n ) capacitor c=0.00852202f \
 //x=6.59 //y=0.89 //x2=6.477 //y2=1.005
cc_988 ( N_noxref_3_c_940_p N_GND_c_12415_n ) capacitor c=4.40641e-19 \
 //x=6.745 //y=1.045 //x2=6.477 //y2=1.005
cc_989 ( N_noxref_3_c_853_p N_GND_c_12418_n ) capacitor c=0.00666561f //x=16.4 \
 //y=2.26 //x2=16.47 //y2=1.135
cc_990 ( N_noxref_3_c_994_p N_GND_c_12418_n ) capacitor c=2.13705e-19 //x=16.4 \
 //y=2.26 //x2=16.47 //y2=1.135
cc_991 ( N_noxref_3_c_1019_p N_GND_c_12418_n ) capacitor c=0.00171023f \
 //x=16.205 //y=1.045 //x2=16.47 //y2=1.135
cc_992 ( N_noxref_3_c_1020_p N_GND_c_12418_n ) capacitor c=0.00357815f \
 //x=16.205 //y=1.39 //x2=16.47 //y2=1.135
cc_993 ( N_noxref_3_c_1022_p N_GND_c_12418_n ) capacitor c=4.2764e-19 \
 //x=16.205 //y=1.7 //x2=16.47 //y2=1.135
cc_994 ( N_noxref_3_c_1134_p N_GND_c_12418_n ) capacitor c=9.36995e-19 \
 //x=16.58 //y=0.89 //x2=16.47 //y2=1.135
cc_995 ( N_noxref_3_c_1135_p N_GND_c_12418_n ) capacitor c=6.30911e-19 \
 //x=16.58 //y=1.545 //x2=16.47 //y2=1.135
cc_996 ( N_noxref_3_c_1021_p N_GND_c_12418_n ) capacitor c=0.00171721f \
 //x=16.735 //y=1.045 //x2=16.47 //y2=1.135
cc_997 ( N_noxref_3_c_1023_p N_GND_c_12418_n ) capacitor c=0.00296337f \
 //x=16.735 //y=1.39 //x2=16.47 //y2=1.135
cc_998 ( N_noxref_3_c_1019_p N_GND_c_12427_n ) capacitor c=3.46594e-19 \
 //x=16.205 //y=1.045 //x2=16.467 //y2=1.005
cc_999 ( N_noxref_3_c_1134_p N_GND_c_12427_n ) capacitor c=0.00839795f \
 //x=16.58 //y=0.89 //x2=16.467 //y2=1.005
cc_1000 ( N_noxref_3_c_1021_p N_GND_c_12427_n ) capacitor c=4.40641e-19 \
 //x=16.735 //y=1.045 //x2=16.467 //y2=1.005
cc_1001 ( N_noxref_3_c_738_n N_GND_c_12337_n ) capacitor c=6.86343e-19 \
 //x=4.475 //y=1.845 //x2=5.13 //y2=0.175
cc_1002 ( N_noxref_3_c_938_p N_GND_c_12338_n ) capacitor c=0.00688027f \
 //x=6.215 //y=1.045 //x2=8.46 //y2=0.175
cc_1003 ( N_noxref_3_c_1019_p N_GND_c_12432_n ) capacitor c=0.00688027f \
 //x=16.205 //y=1.045 //x2=18.45 //y2=0.175
cc_1004 ( N_noxref_3_c_732_n N_GND_c_12340_n ) capacitor c=0.00285697f \
 //x=4.075 //y=1.76 //x2=5.3 //y2=0.175
cc_1005 ( N_noxref_3_c_738_n N_GND_c_12340_n ) capacitor c=0.0327211f \
 //x=4.475 //y=1.845 //x2=5.3 //y2=0.175
cc_1006 ( N_noxref_3_c_762_n N_GND_c_12340_n ) capacitor c=0.00738557f \
 //x=6.41 //y=3.72 //x2=5.3 //y2=0.175
cc_1007 ( N_noxref_3_c_776_n N_GND_c_12340_n ) capacitor c=0.00427323f \
 //x=6.41 //y=2.26 //x2=5.3 //y2=0.175
cc_1008 ( N_noxref_3_c_908_p N_GND_c_12340_n ) capacitor c=0.00369427f \
 //x=6.41 //y=2.26 //x2=5.3 //y2=0.175
cc_1009 ( N_noxref_3_c_941_p N_GND_c_12340_n ) capacitor c=0.0015404f \
 //x=6.215 //y=1.7 //x2=5.3 //y2=0.175
cc_1010 ( N_noxref_3_c_915_p N_GND_c_12340_n ) capacitor c=0.0095324f \
 //x=6.215 //y=2.095 //x2=5.3 //y2=0.175
cc_1011 ( N_noxref_3_c_831_p N_GND_c_12440_n ) capacitor c=0.00718667f \
 //x=16.4 //y=3.725 //x2=15.29 //y2=0.175
cc_1012 ( N_noxref_3_c_853_p N_GND_c_12440_n ) capacitor c=0.00427323f \
 //x=16.4 //y=2.26 //x2=15.29 //y2=0.175
cc_1013 ( N_noxref_3_c_828_n N_GND_c_12440_n ) capacitor c=0.00276652f \
 //x=13.28 //y=3.895 //x2=15.29 //y2=0.175
cc_1014 ( N_noxref_3_c_994_p N_GND_c_12440_n ) capacitor c=0.0038607f //x=16.4 \
 //y=2.26 //x2=15.29 //y2=0.175
cc_1015 ( N_noxref_3_c_1022_p N_GND_c_12440_n ) capacitor c=0.0015404f \
 //x=16.205 //y=1.7 //x2=15.29 //y2=0.175
cc_1016 ( N_noxref_3_c_1006_p N_GND_c_12440_n ) capacitor c=0.00906518f \
 //x=16.205 //y=2.095 //x2=15.29 //y2=0.175
cc_1017 ( N_noxref_3_c_776_n N_GND_M3_noxref_d ) capacitor c=2.20438e-19 \
 //x=6.41 //y=2.26 //x2=6.29 //y2=1.045
cc_1018 ( N_noxref_3_c_938_p N_GND_M3_noxref_d ) capacitor c=0.00192399f \
 //x=6.215 //y=1.045 //x2=6.29 //y2=1.045
cc_1019 ( N_noxref_3_c_939_p N_GND_M3_noxref_d ) capacitor c=0.00210798f \
 //x=6.215 //y=1.39 //x2=6.29 //y2=1.045
cc_1020 ( N_noxref_3_c_1122_p N_GND_M3_noxref_d ) capacitor c=0.00472259f \
 //x=6.59 //y=0.89 //x2=6.29 //y2=1.045
cc_1021 ( N_noxref_3_c_1123_p N_GND_M3_noxref_d ) capacitor c=0.00166857f \
 //x=6.59 //y=1.545 //x2=6.29 //y2=1.045
cc_1022 ( N_noxref_3_c_940_p N_GND_M3_noxref_d ) capacitor c=0.00230174f \
 //x=6.745 //y=1.045 //x2=6.29 //y2=1.045
cc_1023 ( N_noxref_3_c_942_p N_GND_M3_noxref_d ) capacitor c=0.00210798f \
 //x=6.745 //y=1.39 //x2=6.29 //y2=1.045
cc_1024 ( N_noxref_3_c_853_p N_GND_M9_noxref_d ) capacitor c=2.20438e-19 \
 //x=16.4 //y=2.26 //x2=16.28 //y2=1.045
cc_1025 ( N_noxref_3_c_1019_p N_GND_M9_noxref_d ) capacitor c=0.00192399f \
 //x=16.205 //y=1.045 //x2=16.28 //y2=1.045
cc_1026 ( N_noxref_3_c_1020_p N_GND_M9_noxref_d ) capacitor c=0.00210798f \
 //x=16.205 //y=1.39 //x2=16.28 //y2=1.045
cc_1027 ( N_noxref_3_c_1134_p N_GND_M9_noxref_d ) capacitor c=0.00472259f \
 //x=16.58 //y=0.89 //x2=16.28 //y2=1.045
cc_1028 ( N_noxref_3_c_1135_p N_GND_M9_noxref_d ) capacitor c=0.00166857f \
 //x=16.58 //y=1.545 //x2=16.28 //y2=1.045
cc_1029 ( N_noxref_3_c_1021_p N_GND_M9_noxref_d ) capacitor c=0.00230174f \
 //x=16.735 //y=1.045 //x2=16.28 //y2=1.045
cc_1030 ( N_noxref_3_c_1023_p N_GND_M9_noxref_d ) capacitor c=0.00210798f \
 //x=16.735 //y=1.39 //x2=16.28 //y2=1.045
cc_1031 ( N_noxref_3_c_915_p N_noxref_32_c_14035_n ) capacitor c=0.00262672f \
 //x=6.215 //y=2.095 //x2=5.995 //y2=1.675
cc_1032 ( N_noxref_3_c_767_n N_noxref_32_c_14036_n ) capacitor c=0.00361134f \
 //x=6.41 //y=4.04 //x2=6.88 //y2=1.76
cc_1033 ( N_noxref_3_c_776_n N_noxref_32_c_14036_n ) capacitor c=0.00509504f \
 //x=6.41 //y=2.26 //x2=6.88 //y2=1.76
cc_1034 ( N_noxref_3_c_908_p N_noxref_32_c_14036_n ) capacitor c=0.00763108f \
 //x=6.41 //y=2.26 //x2=6.88 //y2=1.76
cc_1035 ( N_noxref_3_c_941_p N_noxref_32_c_14036_n ) capacitor c=0.00697076f \
 //x=6.215 //y=1.7 //x2=6.88 //y2=1.76
cc_1036 ( N_noxref_3_c_915_p N_noxref_32_c_14036_n ) capacitor c=0.0182994f \
 //x=6.215 //y=2.095 //x2=6.88 //y2=1.76
cc_1037 ( N_noxref_3_c_1123_p N_noxref_32_c_14036_n ) capacitor c=0.00723574f \
 //x=6.59 //y=1.545 //x2=6.88 //y2=1.76
cc_1038 ( N_noxref_3_c_942_p N_noxref_32_c_14036_n ) capacitor c=0.00339872f \
 //x=6.745 //y=1.39 //x2=6.88 //y2=1.76
cc_1039 ( N_noxref_3_c_915_p N_noxref_32_c_14038_n ) capacitor c=6.71402e-19 \
 //x=6.215 //y=2.095 //x2=6.965 //y2=1.675
cc_1040 ( N_noxref_3_c_938_p N_noxref_32_M3_noxref_s ) capacitor c=0.0295366f \
 //x=6.215 //y=1.045 //x2=5.86 //y2=0.545
cc_1041 ( N_noxref_3_c_941_p N_noxref_32_M3_noxref_s ) capacitor c=3.48408e-19 \
 //x=6.215 //y=1.7 //x2=5.86 //y2=0.545
cc_1042 ( N_noxref_3_c_940_p N_noxref_32_M3_noxref_s ) capacitor c=0.0125442f \
 //x=6.745 //y=1.045 //x2=5.86 //y2=0.545
cc_1043 ( N_noxref_3_c_1006_p N_noxref_35_c_14241_n ) capacitor c=0.00262672f \
 //x=16.205 //y=2.095 //x2=15.985 //y2=1.675
cc_1044 ( N_noxref_3_c_833_p N_noxref_35_c_14242_n ) capacitor c=0.00364314f \
 //x=16.4 //y=4.045 //x2=16.87 //y2=1.76
cc_1045 ( N_noxref_3_c_853_p N_noxref_35_c_14242_n ) capacitor c=0.00509504f \
 //x=16.4 //y=2.26 //x2=16.87 //y2=1.76
cc_1046 ( N_noxref_3_c_994_p N_noxref_35_c_14242_n ) capacitor c=0.00763108f \
 //x=16.4 //y=2.26 //x2=16.87 //y2=1.76
cc_1047 ( N_noxref_3_c_1022_p N_noxref_35_c_14242_n ) capacitor c=0.00697076f \
 //x=16.205 //y=1.7 //x2=16.87 //y2=1.76
cc_1048 ( N_noxref_3_c_1006_p N_noxref_35_c_14242_n ) capacitor c=0.017492f \
 //x=16.205 //y=2.095 //x2=16.87 //y2=1.76
cc_1049 ( N_noxref_3_c_1135_p N_noxref_35_c_14242_n ) capacitor c=0.00723574f \
 //x=16.58 //y=1.545 //x2=16.87 //y2=1.76
cc_1050 ( N_noxref_3_c_1023_p N_noxref_35_c_14242_n ) capacitor c=0.00339872f \
 //x=16.735 //y=1.39 //x2=16.87 //y2=1.76
cc_1051 ( N_noxref_3_c_1006_p N_noxref_35_c_14249_n ) capacitor c=6.71402e-19 \
 //x=16.205 //y=2.095 //x2=16.955 //y2=1.675
cc_1052 ( N_noxref_3_c_1019_p N_noxref_35_M9_noxref_s ) capacitor c=0.0294925f \
 //x=16.205 //y=1.045 //x2=15.85 //y2=0.545
cc_1053 ( N_noxref_3_c_1022_p N_noxref_35_M9_noxref_s ) capacitor \
 c=3.48408e-19 //x=16.205 //y=1.7 //x2=15.85 //y2=0.545
cc_1054 ( N_noxref_3_c_1021_p N_noxref_35_M9_noxref_s ) capacitor c=0.0125442f \
 //x=16.735 //y=1.045 //x2=15.85 //y2=0.545
cc_1055 ( N_noxref_4_c_1212_p N_noxref_5_c_1550_n ) capacitor c=0.00324213f \
 //x=17.44 //y=1.75 //x2=14.11 //y2=1.75
cc_1056 ( N_noxref_4_c_1198_n N_noxref_5_c_1663_n ) capacitor c=0.00114153f \
 //x=16.52 //y=5.56 //x2=14.465 //y2=5.38
cc_1057 ( N_noxref_4_c_1214_p N_noxref_5_c_1664_n ) capacitor c=0.00231467f \
 //x=17.525 //y=1.835 //x2=14.465 //y2=1.835
cc_1058 ( N_noxref_4_c_1196_n N_noxref_5_c_1552_n ) capacitor c=0.00204244f \
 //x=17.88 //y=3.705 //x2=14.55 //y2=4.105
cc_1059 ( N_noxref_4_c_1197_n N_noxref_5_c_1555_n ) capacitor c=0.00281705f \
 //x=17.88 //y=5.295 //x2=14.55 //y2=5.295
cc_1060 ( N_noxref_4_c_1196_n N_noxref_5_c_1667_n ) capacitor c=0.00215233f \
 //x=17.88 //y=3.705 //x2=20.47 //y2=4.09
cc_1061 ( N_noxref_4_c_1218_p N_noxref_5_c_1667_n ) capacitor c=0.0540317f \
 //x=19.73 //y=3.705 //x2=20.47 //y2=4.09
cc_1062 ( N_noxref_4_c_1219_p N_noxref_5_c_1667_n ) capacitor c=0.014957f \
 //x=19.73 //y=4.025 //x2=20.47 //y2=4.09
cc_1063 ( N_noxref_4_c_1220_p N_noxref_5_c_1667_n ) capacitor c=7.6985e-19 \
 //x=19.73 //y=3.88 //x2=20.47 //y2=4.09
cc_1064 ( N_noxref_4_c_1221_p N_noxref_5_c_1667_n ) capacitor c=0.0028341f \
 //x=19.732 //y=4.74 //x2=20.47 //y2=4.09
cc_1065 ( N_noxref_4_c_1222_p N_noxref_5_c_1667_n ) capacitor c=0.00684101f \
 //x=19.725 //y=3.865 //x2=20.47 //y2=4.09
cc_1066 ( N_noxref_4_c_1223_p N_noxref_5_c_1667_n ) capacitor c=3.49899e-19 \
 //x=19.73 //y=2.26 //x2=20.47 //y2=4.09
cc_1067 ( N_noxref_4_c_1221_p N_noxref_5_c_1674_n ) capacitor c=0.0173413f \
 //x=19.732 //y=4.74 //x2=20.47 //y2=4.41
cc_1068 ( N_noxref_4_c_1197_n N_noxref_5_c_1675_n ) capacitor c=7.59777e-19 \
 //x=17.88 //y=5.295 //x2=20.47 //y2=4.735
cc_1069 ( N_noxref_4_c_1226_p N_noxref_5_c_1675_n ) capacitor c=0.0172958f \
 //x=19.73 //y=4.88 //x2=20.47 //y2=4.735
cc_1070 ( N_noxref_4_c_1221_p N_noxref_5_c_1675_n ) capacitor c=0.0117613f \
 //x=19.732 //y=4.74 //x2=20.47 //y2=4.735
cc_1071 ( N_noxref_4_c_1228_p N_noxref_5_c_1675_n ) capacitor c=7.50997e-19 \
 //x=19.73 //y=4.88 //x2=20.47 //y2=4.735
cc_1072 ( N_noxref_4_c_1229_p N_noxref_5_c_1675_n ) capacitor c=0.00200732f \
 //x=19.73 //y=4.88 //x2=20.47 //y2=4.735
cc_1073 ( N_noxref_4_c_1198_n N_noxref_5_c_1680_n ) capacitor c=5.29822e-19 \
 //x=16.52 //y=5.56 //x2=14.07 //y2=5.38
cc_1074 ( N_noxref_4_c_1198_n N_noxref_5_c_1681_n ) capacitor c=0.00147119f \
 //x=16.52 //y=5.56 //x2=14.07 //y2=5.56
cc_1075 ( N_noxref_4_c_1232_p N_noxref_5_c_1568_n ) capacitor c=6.99317e-19 \
 //x=17.44 //y=1.18 //x2=14.11 //y2=1.18
cc_1076 ( N_noxref_4_c_1221_p N_noxref_5_c_1683_n ) capacitor c=5.79609e-19 \
 //x=19.732 //y=4.74 //x2=20.47 //y2=4.25
cc_1077 ( N_noxref_4_c_1234_p N_noxref_5_c_1684_n ) capacitor c=0.0205342f \
 //x=19.73 //y=2.26 //x2=20.47 //y2=2.26
cc_1078 ( N_noxref_4_c_1223_p N_noxref_5_c_1684_n ) capacitor c=5.16867e-19 \
 //x=19.73 //y=2.26 //x2=20.47 //y2=2.26
cc_1079 ( N_noxref_4_c_1236_p N_noxref_5_c_1684_n ) capacitor c=0.00167888f \
 //x=19.535 //y=2.095 //x2=20.47 //y2=2.26
cc_1080 ( N_noxref_4_c_1237_p N_noxref_5_c_1650_n ) capacitor c=0.00897318f \
 //x=17.88 //y=4.025 //x2=16.615 //y2=4.27
cc_1081 ( N_noxref_4_c_1197_n N_noxref_5_c_1650_n ) capacitor c=0.0227806f \
 //x=17.88 //y=5.295 //x2=16.615 //y2=4.27
cc_1082 ( N_noxref_4_c_1219_p N_noxref_5_c_1650_n ) capacitor c=0.00570748f \
 //x=19.73 //y=4.025 //x2=16.615 //y2=4.27
cc_1083 ( N_noxref_4_c_1221_p N_noxref_5_c_1650_n ) capacitor c=0.0249449f \
 //x=19.732 //y=4.74 //x2=16.615 //y2=4.27
cc_1084 ( N_noxref_4_c_1205_n N_noxref_5_c_1650_n ) capacitor c=0.0358686f \
 //x=18.04 //y=3.865 //x2=16.615 //y2=4.27
cc_1085 ( N_noxref_4_c_1222_p N_noxref_5_c_1650_n ) capacitor c=0.0358686f \
 //x=19.725 //y=3.865 //x2=16.615 //y2=4.27
cc_1086 ( N_noxref_4_c_1243_p N_noxref_5_c_1650_n ) capacitor c=0.133576f \
 //x=19.565 //y=3.865 //x2=16.615 //y2=4.27
cc_1087 ( N_noxref_4_c_1218_p N_noxref_5_c_1694_n ) capacitor c=3.49899e-19 \
 //x=19.73 //y=3.705 //x2=20.47 //y2=2.26
cc_1088 ( N_noxref_4_c_1234_p N_noxref_5_c_1694_n ) capacitor c=5.24723e-19 \
 //x=19.73 //y=2.26 //x2=20.47 //y2=2.26
cc_1089 ( N_noxref_4_c_1223_p N_noxref_5_c_1694_n ) capacitor c=0.00485709f \
 //x=19.73 //y=2.26 //x2=20.47 //y2=2.26
cc_1090 ( N_noxref_4_c_1236_p N_noxref_5_c_1694_n ) capacitor c=0.00267961f \
 //x=19.535 //y=2.095 //x2=20.47 //y2=2.26
cc_1091 ( N_noxref_4_c_1226_p N_noxref_5_c_1698_n ) capacitor c=4.80626e-19 \
 //x=19.73 //y=4.88 //x2=20.5 //y2=4.88
cc_1092 ( N_noxref_4_c_1228_p N_noxref_5_c_1698_n ) capacitor c=0.00397338f \
 //x=19.73 //y=4.88 //x2=20.5 //y2=4.88
cc_1093 ( N_noxref_4_c_1229_p N_noxref_5_c_1698_n ) capacitor c=0.00283894f \
 //x=19.73 //y=4.88 //x2=20.5 //y2=4.88
cc_1094 ( N_noxref_4_M68_noxref_g N_noxref_5_M70_noxref_g ) capacitor \
 c=0.0104892f //x=19.63 //y=6.2 //x2=20.51 //y2=6.2
cc_1095 ( N_noxref_4_M69_noxref_g N_noxref_5_M70_noxref_g ) capacitor \
 c=0.107636f //x=20.07 //y=6.2 //x2=20.51 //y2=6.2
cc_1096 ( N_noxref_4_M69_noxref_g N_noxref_5_M71_noxref_g ) capacitor \
 c=0.0100341f //x=20.07 //y=6.2 //x2=20.95 //y2=6.2
cc_1097 ( N_noxref_4_c_1254_p N_noxref_5_c_1704_n ) capacitor c=4.86545e-19 \
 //x=19.535 //y=1.045 //x2=20.505 //y2=1.085
cc_1098 ( N_noxref_4_c_1255_p N_noxref_5_c_1704_n ) capacitor c=0.00152405f \
 //x=19.535 //y=1.39 //x2=20.505 //y2=1.085
cc_1099 ( N_noxref_4_c_1256_p N_noxref_5_c_1704_n ) capacitor c=0.0151475f \
 //x=20.065 //y=1.045 //x2=20.505 //y2=1.085
cc_1100 ( N_noxref_4_c_1257_p N_noxref_5_c_1707_n ) capacitor c=0.00109982f \
 //x=19.535 //y=1.7 //x2=20.505 //y2=1.43
cc_1101 ( N_noxref_4_c_1258_p N_noxref_5_c_1707_n ) capacitor c=0.0111064f \
 //x=20.065 //y=1.39 //x2=20.505 //y2=1.43
cc_1102 ( N_noxref_4_c_1257_p N_noxref_5_c_1709_n ) capacitor c=9.58243e-19 \
 //x=19.535 //y=1.7 //x2=20.505 //y2=1.74
cc_1103 ( N_noxref_4_c_1236_p N_noxref_5_c_1709_n ) capacitor c=0.00662747f \
 //x=19.535 //y=2.095 //x2=20.505 //y2=1.74
cc_1104 ( N_noxref_4_c_1258_p N_noxref_5_c_1709_n ) capacitor c=0.00862358f \
 //x=20.065 //y=1.39 //x2=20.505 //y2=1.74
cc_1105 ( N_noxref_4_c_1256_p N_noxref_5_c_1712_n ) capacitor c=0.00127211f \
 //x=20.065 //y=1.045 //x2=21.035 //y2=1.085
cc_1106 ( N_noxref_4_c_1258_p N_noxref_5_c_1713_n ) capacitor c=0.00204774f \
 //x=20.065 //y=1.39 //x2=21.035 //y2=1.43
cc_1107 ( N_noxref_4_c_1234_p N_noxref_5_c_1714_n ) capacitor c=0.00167305f \
 //x=19.73 //y=2.26 //x2=20.47 //y2=2.26
cc_1108 ( N_noxref_4_c_1223_p N_noxref_5_c_1714_n ) capacitor c=0.0018937f \
 //x=19.73 //y=2.26 //x2=20.47 //y2=2.26
cc_1109 ( N_noxref_4_c_1236_p N_noxref_5_c_1714_n ) capacitor c=0.0181449f \
 //x=19.535 //y=2.095 //x2=20.47 //y2=2.26
cc_1110 ( N_noxref_4_c_1226_p N_noxref_5_c_1717_n ) capacitor c=0.00158715f \
 //x=19.73 //y=4.88 //x2=20.5 //y2=4.88
cc_1111 ( N_noxref_4_c_1228_p N_noxref_5_c_1717_n ) capacitor c=0.00237977f \
 //x=19.73 //y=4.88 //x2=20.5 //y2=4.88
cc_1112 ( N_noxref_4_c_1229_p N_noxref_5_c_1717_n ) capacitor c=0.0297875f \
 //x=19.73 //y=4.88 //x2=20.5 //y2=4.88
cc_1113 ( N_noxref_4_c_1214_p N_D_c_4251_n ) capacitor c=0.0127395f //x=17.525 \
 //y=1.835 //x2=28.435 //y2=2.78
cc_1114 ( N_noxref_4_c_1196_n N_D_c_4251_n ) capacitor c=0.0287785f //x=17.88 \
 //y=3.705 //x2=28.435 //y2=2.78
cc_1115 ( N_noxref_4_c_1218_p N_D_c_4251_n ) capacitor c=0.0272491f //x=19.73 \
 //y=3.705 //x2=28.435 //y2=2.78
cc_1116 ( N_noxref_4_c_1232_p N_D_c_4251_n ) capacitor c=4.96788e-19 //x=17.44 \
 //y=1.18 //x2=28.435 //y2=2.78
cc_1117 ( N_noxref_4_c_1234_p N_D_c_4251_n ) capacitor c=0.00364826f //x=19.73 \
 //y=2.26 //x2=28.435 //y2=2.78
cc_1118 ( N_noxref_4_c_1243_p N_D_c_4251_n ) capacitor c=0.00558026f \
 //x=19.565 //y=3.865 //x2=28.435 //y2=2.78
cc_1119 ( N_noxref_4_c_1276_p N_CLK_c_5711_n ) capacitor c=0.0104576f \
 //x=17.795 //y=5.38 //x2=20.085 //y2=4.62
cc_1120 ( N_noxref_4_c_1197_n N_CLK_c_5711_n ) capacitor c=0.0287045f \
 //x=17.88 //y=5.295 //x2=20.085 //y2=4.62
cc_1121 ( N_noxref_4_c_1226_p N_CLK_c_5711_n ) capacitor c=0.00357426f \
 //x=19.73 //y=4.88 //x2=20.085 //y2=4.62
cc_1122 ( N_noxref_4_c_1221_p N_CLK_c_5711_n ) capacitor c=0.0270952f \
 //x=19.732 //y=4.74 //x2=20.085 //y2=4.62
cc_1123 ( N_noxref_4_c_1243_p N_CLK_c_5711_n ) capacitor c=0.0079732f \
 //x=19.565 //y=3.865 //x2=20.085 //y2=4.62
cc_1124 ( N_noxref_4_c_1281_p N_CLK_c_5716_n ) capacitor c=0.0104576f //x=17.4 \
 //y=5.38 //x2=17.32 //y2=4.62
cc_1125 ( N_noxref_4_c_1198_n N_CLK_c_5698_n ) capacitor c=0.0220317f \
 //x=16.52 //y=5.56 //x2=17.235 //y2=4.62
cc_1126 ( N_noxref_4_c_1196_n N_noxref_20_c_9133_n ) capacitor c=0.0239033f \
 //x=17.88 //y=3.705 //x2=17.14 //y2=2.995
cc_1127 ( N_noxref_4_c_1218_p N_noxref_20_c_9133_n ) capacitor c=0.00115477f \
 //x=19.73 //y=3.705 //x2=17.14 //y2=2.995
cc_1128 ( N_noxref_4_c_1195_n N_noxref_20_c_9135_n ) capacitor c=7.77351e-19 \
 //x=17.285 //y=5.38 //x2=17.14 //y2=3.315
cc_1129 ( N_noxref_4_c_1214_p N_noxref_20_c_9135_n ) capacitor c=7.90373e-19 \
 //x=17.525 //y=1.835 //x2=17.14 //y2=3.315
cc_1130 ( N_noxref_4_c_1196_n N_noxref_20_c_9135_n ) capacitor c=0.0174284f \
 //x=17.88 //y=3.705 //x2=17.14 //y2=3.315
cc_1131 ( N_noxref_4_c_1281_p N_noxref_20_c_9135_n ) capacitor c=0.00117858f \
 //x=17.4 //y=5.38 //x2=17.14 //y2=3.315
cc_1132 ( N_noxref_4_c_1232_p N_noxref_20_c_9135_n ) capacitor c=2.73952e-19 \
 //x=17.44 //y=1.18 //x2=17.14 //y2=3.315
cc_1133 ( N_noxref_4_c_1290_p N_noxref_20_c_9135_n ) capacitor c=2.58653e-19 \
 //x=17.4 //y=5.56 //x2=17.14 //y2=3.315
cc_1134 ( N_noxref_4_c_1195_n N_noxref_20_c_9136_n ) capacitor c=0.021773f \
 //x=17.285 //y=5.38 //x2=17.14 //y2=4.735
cc_1135 ( N_noxref_4_c_1196_n N_noxref_20_c_9136_n ) capacitor c=0.0185998f \
 //x=17.88 //y=3.705 //x2=17.14 //y2=4.735
cc_1136 ( N_noxref_4_c_1237_p N_noxref_20_c_9136_n ) capacitor c=0.0151188f \
 //x=17.88 //y=4.025 //x2=17.14 //y2=4.735
cc_1137 ( N_noxref_4_c_1197_n N_noxref_20_c_9136_n ) capacitor c=0.0430011f \
 //x=17.88 //y=5.295 //x2=17.14 //y2=4.735
cc_1138 ( N_noxref_4_c_1218_p N_noxref_20_c_9136_n ) capacitor c=3.97534e-19 \
 //x=19.73 //y=3.705 //x2=17.14 //y2=4.735
cc_1139 ( N_noxref_4_c_1204_n N_noxref_20_c_9136_n ) capacitor c=6.47554e-19 \
 //x=17.88 //y=3.88 //x2=17.14 //y2=4.735
cc_1140 ( N_noxref_4_c_1221_p N_noxref_20_c_9136_n ) capacitor c=0.0010663f \
 //x=19.732 //y=4.74 //x2=17.14 //y2=4.735
cc_1141 ( N_noxref_4_c_1205_n N_noxref_20_c_9136_n ) capacitor c=0.00381156f \
 //x=18.04 //y=3.865 //x2=17.14 //y2=4.735
cc_1142 ( N_noxref_4_M69_noxref_g N_noxref_20_c_9191_n ) capacitor \
 c=0.00889217f //x=20.07 //y=6.2 //x2=20.615 //y2=5.38
cc_1143 ( N_noxref_4_c_1212_p N_noxref_20_c_9192_n ) capacitor c=0.00324213f \
 //x=17.44 //y=1.75 //x2=20.77 //y2=1.75
cc_1144 ( N_noxref_4_c_1301_p N_noxref_20_c_9193_n ) capacitor c=0.00231467f \
 //x=17.795 //y=1.835 //x2=20.855 //y2=1.835
cc_1145 ( N_noxref_4_c_1196_n N_noxref_20_c_9194_n ) capacitor c=0.00204244f \
 //x=17.88 //y=3.705 //x2=21.21 //y2=2.995
cc_1146 ( N_noxref_4_c_1218_p N_noxref_20_c_9194_n ) capacitor c=0.0018253f \
 //x=19.73 //y=3.705 //x2=21.21 //y2=2.995
cc_1147 ( N_noxref_4_c_1197_n N_noxref_20_c_9196_n ) capacitor c=0.00281705f \
 //x=17.88 //y=5.295 //x2=21.21 //y2=5.295
cc_1148 ( N_noxref_4_c_1218_p N_noxref_20_c_9196_n ) capacitor c=6.54888e-19 \
 //x=19.73 //y=3.705 //x2=21.21 //y2=5.295
cc_1149 ( N_noxref_4_c_1221_p N_noxref_20_c_9196_n ) capacitor c=0.00198598f \
 //x=19.732 //y=4.74 //x2=21.21 //y2=5.295
cc_1150 ( N_noxref_4_c_1196_n N_noxref_20_c_9144_n ) capacitor c=0.015397f \
 //x=17.88 //y=3.705 //x2=17.14 //y2=2.26
cc_1151 ( N_noxref_4_c_1196_n N_noxref_20_c_9147_n ) capacitor c=9.19401e-19 \
 //x=17.88 //y=3.705 //x2=17.14 //y2=3.14
cc_1152 ( N_noxref_4_c_1276_p N_noxref_20_c_9201_n ) capacitor c=0.00114153f \
 //x=17.795 //y=5.38 //x2=19.85 //y2=5.56
cc_1153 ( N_noxref_4_c_1219_p N_noxref_20_c_9201_n ) capacitor c=7.15631e-19 \
 //x=19.73 //y=4.025 //x2=19.85 //y2=5.56
cc_1154 ( N_noxref_4_c_1281_p N_noxref_20_c_9201_n ) capacitor c=5.29822e-19 \
 //x=17.4 //y=5.38 //x2=19.85 //y2=5.56
cc_1155 ( N_noxref_4_c_1312_p N_noxref_20_c_9201_n ) capacitor c=0.00147119f \
 //x=17.4 //y=5.56 //x2=19.85 //y2=5.56
cc_1156 ( N_noxref_4_c_1226_p N_noxref_20_c_9201_n ) capacitor c=0.0117744f \
 //x=19.73 //y=4.88 //x2=19.85 //y2=5.56
cc_1157 ( N_noxref_4_c_1228_p N_noxref_20_c_9201_n ) capacitor c=0.00277154f \
 //x=19.73 //y=4.88 //x2=19.85 //y2=5.56
cc_1158 ( N_noxref_4_M68_noxref_g N_noxref_20_c_9201_n ) capacitor \
 c=0.00201806f //x=19.63 //y=6.2 //x2=19.85 //y2=5.56
cc_1159 ( N_noxref_4_M69_noxref_g N_noxref_20_c_9201_n ) capacitor \
 c=0.00192712f //x=20.07 //y=6.2 //x2=19.85 //y2=5.56
cc_1160 ( N_noxref_4_c_1229_p N_noxref_20_c_9201_n ) capacitor c=0.00190205f \
 //x=19.73 //y=4.88 //x2=19.85 //y2=5.56
cc_1161 ( N_noxref_4_c_1232_p N_noxref_20_c_9210_n ) capacitor c=6.99317e-19 \
 //x=17.44 //y=1.18 //x2=20.77 //y2=1.18
cc_1162 ( N_noxref_4_c_1196_n N_noxref_20_c_9211_n ) capacitor c=0.0243855f \
 //x=17.88 //y=3.705 //x2=21.04 //y2=3.14
cc_1163 ( N_noxref_4_c_1237_p N_noxref_20_c_9211_n ) capacitor c=0.00478126f \
 //x=17.88 //y=4.025 //x2=21.04 //y2=3.14
cc_1164 ( N_noxref_4_c_1218_p N_noxref_20_c_9211_n ) capacitor c=0.025467f \
 //x=19.73 //y=3.705 //x2=21.04 //y2=3.14
cc_1165 ( N_noxref_4_c_1219_p N_noxref_20_c_9211_n ) capacitor c=0.00408245f \
 //x=19.73 //y=4.025 //x2=21.04 //y2=3.14
cc_1166 ( N_noxref_4_c_1205_n N_noxref_20_c_9211_n ) capacitor c=0.01611f \
 //x=18.04 //y=3.865 //x2=21.04 //y2=3.14
cc_1167 ( N_noxref_4_c_1222_p N_noxref_20_c_9211_n ) capacitor c=0.0161327f \
 //x=19.725 //y=3.865 //x2=21.04 //y2=3.14
cc_1168 ( N_noxref_4_c_1243_p N_noxref_20_c_9211_n ) capacitor c=0.0678573f \
 //x=19.565 //y=3.865 //x2=21.04 //y2=3.14
cc_1169 ( N_noxref_4_c_1196_n N_noxref_20_c_9148_n ) capacitor c=0.00331772f \
 //x=17.88 //y=3.705 //x2=17.285 //y2=3.155
cc_1170 ( N_noxref_4_c_1196_n N_noxref_20_c_9149_n ) capacitor c=9.90728e-19 \
 //x=17.88 //y=3.705 //x2=17.14 //y2=2.26
cc_1171 ( N_noxref_4_c_1195_n N_noxref_20_c_9153_n ) capacitor c=0.00469257f \
 //x=17.285 //y=5.38 //x2=17.17 //y2=4.88
cc_1172 ( N_noxref_4_c_1197_n N_noxref_20_c_9153_n ) capacitor c=7.76118e-19 \
 //x=17.88 //y=5.295 //x2=17.17 //y2=4.88
cc_1173 ( N_noxref_4_c_1219_p N_noxref_20_c_9222_n ) capacitor c=2.05912e-19 \
 //x=19.73 //y=4.025 //x2=19.85 //y2=5.56
cc_1174 ( N_noxref_4_c_1226_p N_noxref_20_c_9222_n ) capacitor c=0.00104426f \
 //x=19.73 //y=4.88 //x2=19.85 //y2=5.56
cc_1175 ( N_noxref_4_c_1228_p N_noxref_20_c_9222_n ) capacitor c=0.00377369f \
 //x=19.73 //y=4.88 //x2=19.85 //y2=5.56
cc_1176 ( N_noxref_4_M68_noxref_g N_noxref_20_c_9222_n ) capacitor \
 c=0.0158358f //x=19.63 //y=6.2 //x2=19.85 //y2=5.56
cc_1177 ( N_noxref_4_M69_noxref_g N_noxref_20_c_9222_n ) capacitor \
 c=0.0178987f //x=20.07 //y=6.2 //x2=19.85 //y2=5.56
cc_1178 ( N_noxref_4_c_1229_p N_noxref_20_c_9222_n ) capacitor c=0.0043218f \
 //x=19.73 //y=4.88 //x2=19.85 //y2=5.56
cc_1179 ( N_noxref_4_c_1195_n N_noxref_20_M66_noxref_g ) capacitor \
 c=0.00842859f //x=17.285 //y=5.38 //x2=17.18 //y2=6.2
cc_1180 ( N_noxref_4_c_1281_p N_noxref_20_M66_noxref_g ) capacitor \
 c=0.00192712f //x=17.4 //y=5.38 //x2=17.18 //y2=6.2
cc_1181 ( N_noxref_4_c_1290_p N_noxref_20_M66_noxref_g ) capacitor \
 c=0.0178987f //x=17.4 //y=5.56 //x2=17.18 //y2=6.2
cc_1182 ( N_noxref_4_c_1276_p N_noxref_20_M67_noxref_g ) capacitor \
 c=0.0106088f //x=17.795 //y=5.38 //x2=17.62 //y2=6.2
cc_1183 ( N_noxref_4_c_1281_p N_noxref_20_M67_noxref_g ) capacitor \
 c=0.00298276f //x=17.4 //y=5.38 //x2=17.62 //y2=6.2
cc_1184 ( N_noxref_4_c_1290_p N_noxref_20_M67_noxref_g ) capacitor \
 c=0.0178506f //x=17.4 //y=5.56 //x2=17.62 //y2=6.2
cc_1185 ( N_noxref_4_c_1232_p N_noxref_20_c_9159_n ) capacitor c=0.00120406f \
 //x=17.44 //y=1.18 //x2=17.175 //y2=1.085
cc_1186 ( N_noxref_4_M10_noxref_d N_noxref_20_c_9159_n ) capacitor \
 c=0.00137165f //x=17.25 //y=1.085 //x2=17.175 //y2=1.085
cc_1187 ( N_noxref_4_c_1212_p N_noxref_20_c_9162_n ) capacitor c=0.00119008f \
 //x=17.44 //y=1.75 //x2=17.175 //y2=1.43
cc_1188 ( N_noxref_4_c_1232_p N_noxref_20_c_9162_n ) capacitor c=0.00218694f \
 //x=17.44 //y=1.18 //x2=17.175 //y2=1.43
cc_1189 ( N_noxref_4_M10_noxref_d N_noxref_20_c_9162_n ) capacitor \
 c=0.00237422f //x=17.25 //y=1.085 //x2=17.175 //y2=1.43
cc_1190 ( N_noxref_4_c_1212_p N_noxref_20_c_9164_n ) capacitor c=0.00438634f \
 //x=17.44 //y=1.75 //x2=17.175 //y2=1.74
cc_1191 ( N_noxref_4_c_1197_n N_noxref_20_c_9240_n ) capacitor c=0.00845606f \
 //x=17.88 //y=5.295 //x2=17.545 //y2=4.97
cc_1192 ( N_noxref_4_c_1281_p N_noxref_20_c_9240_n ) capacitor c=0.00196809f \
 //x=17.4 //y=5.38 //x2=17.545 //y2=4.97
cc_1193 ( N_noxref_4_c_1290_p N_noxref_20_c_9240_n ) capacitor c=0.00291714f \
 //x=17.4 //y=5.56 //x2=17.545 //y2=4.97
cc_1194 ( N_noxref_4_c_1232_p N_noxref_20_c_9243_n ) capacitor c=5.50523e-19 \
 //x=17.44 //y=1.18 //x2=17.55 //y2=0.93
cc_1195 ( N_noxref_4_M10_noxref_d N_noxref_20_c_9243_n ) capacitor \
 c=0.0020782f //x=17.25 //y=1.085 //x2=17.55 //y2=0.93
cc_1196 ( N_noxref_4_c_1212_p N_noxref_20_c_9245_n ) capacitor c=0.00916852f \
 //x=17.44 //y=1.75 //x2=17.55 //y2=1.585
cc_1197 ( N_noxref_4_c_1301_p N_noxref_20_c_9245_n ) capacitor c=0.00194324f \
 //x=17.795 //y=1.835 //x2=17.55 //y2=1.585
cc_1198 ( N_noxref_4_c_1232_p N_noxref_20_c_9245_n ) capacitor c=4.93963e-19 \
 //x=17.44 //y=1.18 //x2=17.55 //y2=1.585
cc_1199 ( N_noxref_4_M10_noxref_d N_noxref_20_c_9245_n ) capacitor \
 c=0.00356097f //x=17.25 //y=1.085 //x2=17.55 //y2=1.585
cc_1200 ( N_noxref_4_c_1232_p N_noxref_20_c_9167_n ) capacitor c=0.00109205f \
 //x=17.44 //y=1.18 //x2=17.705 //y2=1.085
cc_1201 ( N_noxref_4_M10_noxref_d N_noxref_20_c_9167_n ) capacitor \
 c=8.50095e-19 //x=17.25 //y=1.085 //x2=17.705 //y2=1.085
cc_1202 ( N_noxref_4_c_1212_p N_noxref_20_c_9168_n ) capacitor c=0.003249f \
 //x=17.44 //y=1.75 //x2=17.705 //y2=1.43
cc_1203 ( N_noxref_4_c_1301_p N_noxref_20_c_9168_n ) capacitor c=0.00323005f \
 //x=17.795 //y=1.835 //x2=17.705 //y2=1.43
cc_1204 ( N_noxref_4_c_1232_p N_noxref_20_c_9168_n ) capacitor c=0.00317092f \
 //x=17.44 //y=1.18 //x2=17.705 //y2=1.43
cc_1205 ( N_noxref_4_M10_noxref_d N_noxref_20_c_9168_n ) capacitor \
 c=0.00237422f //x=17.25 //y=1.085 //x2=17.705 //y2=1.43
cc_1206 ( N_noxref_4_c_1196_n N_noxref_20_c_9169_n ) capacitor c=0.00281392f \
 //x=17.88 //y=3.705 //x2=17.14 //y2=2.26
cc_1207 ( N_noxref_4_c_1212_p N_noxref_20_c_9256_n ) capacitor c=0.00341114f \
 //x=17.44 //y=1.75 //x2=17.14 //y2=2.095
cc_1208 ( N_noxref_4_c_1196_n N_noxref_20_c_9256_n ) capacitor c=0.00309058f \
 //x=17.88 //y=3.705 //x2=17.14 //y2=2.095
cc_1209 ( N_noxref_4_c_1195_n N_noxref_20_c_9172_n ) capacitor c=9.29537e-19 \
 //x=17.285 //y=5.38 //x2=17.17 //y2=4.88
cc_1210 ( N_noxref_4_c_1197_n N_noxref_20_c_9172_n ) capacitor c=0.00142201f \
 //x=17.88 //y=5.295 //x2=17.17 //y2=4.88
cc_1211 ( N_noxref_4_c_1195_n N_VDD_c_10241_n ) capacitor c=0.00648284f \
 //x=17.285 //y=5.38 //x2=65.575 //y2=7.585
cc_1212 ( N_noxref_4_c_1276_p N_VDD_c_10241_n ) capacitor c=0.00492584f \
 //x=17.795 //y=5.38 //x2=65.575 //y2=7.585
cc_1213 ( N_noxref_4_c_1237_p N_VDD_c_10241_n ) capacitor c=5.11349e-19 \
 //x=17.88 //y=4.025 //x2=65.575 //y2=7.585
cc_1214 ( N_noxref_4_c_1219_p N_VDD_c_10241_n ) capacitor c=2.11935e-19 \
 //x=19.73 //y=4.025 //x2=65.575 //y2=7.585
cc_1215 ( N_noxref_4_c_1198_n N_VDD_c_10241_n ) capacitor c=0.00368834f \
 //x=16.52 //y=5.56 //x2=65.575 //y2=7.585
cc_1216 ( N_noxref_4_c_1281_p N_VDD_c_10241_n ) capacitor c=8.42537e-19 \
 //x=17.4 //y=5.38 //x2=65.575 //y2=7.585
cc_1217 ( N_noxref_4_c_1312_p N_VDD_c_10241_n ) capacitor c=0.00285853f \
 //x=17.4 //y=5.56 //x2=65.575 //y2=7.585
cc_1218 ( N_noxref_4_c_1226_p N_VDD_c_10241_n ) capacitor c=9.07241e-19 \
 //x=19.73 //y=4.88 //x2=65.575 //y2=7.585
cc_1219 ( N_noxref_4_c_1206_n N_VDD_c_10241_n ) capacitor c=0.00224881f \
 //x=16.52 //y=5.56 //x2=65.575 //y2=7.585
cc_1220 ( N_noxref_4_c_1290_p N_VDD_c_10241_n ) capacitor c=0.00224881f \
 //x=17.4 //y=5.56 //x2=65.575 //y2=7.585
cc_1221 ( N_noxref_4_c_1228_p N_VDD_c_10241_n ) capacitor c=6.22888e-19 \
 //x=19.73 //y=4.88 //x2=65.575 //y2=7.585
cc_1222 ( N_noxref_4_c_1195_n N_VDD_c_10381_n ) capacitor c=0.00208087f \
 //x=17.285 //y=5.38 //x2=16.875 //y2=7.585
cc_1223 ( N_noxref_4_c_1198_n N_VDD_c_10381_n ) capacitor c=9.41185e-19 \
 //x=16.52 //y=5.56 //x2=16.875 //y2=7.585
cc_1224 ( N_noxref_4_c_1206_n N_VDD_c_10381_n ) capacitor c=0.0136705f \
 //x=16.52 //y=5.56 //x2=16.875 //y2=7.585
cc_1225 ( N_noxref_4_c_1195_n N_VDD_c_10428_n ) capacitor c=0.00180737f \
 //x=17.285 //y=5.38 //x2=17.755 //y2=7.585
cc_1226 ( N_noxref_4_c_1276_p N_VDD_c_10428_n ) capacitor c=0.00208087f \
 //x=17.795 //y=5.38 //x2=17.755 //y2=7.585
cc_1227 ( N_noxref_4_c_1281_p N_VDD_c_10428_n ) capacitor c=4.23719e-19 \
 //x=17.4 //y=5.38 //x2=17.755 //y2=7.585
cc_1228 ( N_noxref_4_c_1312_p N_VDD_c_10428_n ) capacitor c=5.77976e-19 \
 //x=17.4 //y=5.56 //x2=17.755 //y2=7.585
cc_1229 ( N_noxref_4_c_1290_p N_VDD_c_10428_n ) capacitor c=0.0136705f \
 //x=17.4 //y=5.56 //x2=17.755 //y2=7.585
cc_1230 ( N_noxref_4_c_1226_p N_VDD_c_10433_n ) capacitor c=6.28113e-19 \
 //x=19.73 //y=4.88 //x2=20.205 //y2=7.585
cc_1231 ( N_noxref_4_M68_noxref_g N_VDD_c_10433_n ) capacitor c=0.00732618f \
 //x=19.63 //y=6.2 //x2=20.205 //y2=7.585
cc_1232 ( N_noxref_4_M69_noxref_g N_VDD_c_10433_n ) capacitor c=0.00755544f \
 //x=20.07 //y=6.2 //x2=20.205 //y2=7.585
cc_1233 ( N_noxref_4_c_1197_n N_VDD_c_10391_n ) capacitor c=0.0013228f \
 //x=17.88 //y=5.295 //x2=15.29 //y2=7.585
cc_1234 ( N_noxref_4_c_1198_n N_VDD_c_10391_n ) capacitor c=4.91377e-19 \
 //x=16.52 //y=5.56 //x2=15.29 //y2=7.585
cc_1235 ( N_noxref_4_c_1206_n N_VDD_c_10391_n ) capacitor c=0.0064135f \
 //x=16.52 //y=5.56 //x2=15.29 //y2=7.585
cc_1236 ( N_noxref_4_c_1197_n N_VDD_c_10439_n ) capacitor c=0.0291261f \
 //x=17.88 //y=5.295 //x2=18.62 //y2=7.585
cc_1237 ( N_noxref_4_c_1281_p N_VDD_c_10439_n ) capacitor c=0.00240948f \
 //x=17.4 //y=5.38 //x2=18.62 //y2=7.585
cc_1238 ( N_noxref_4_c_1312_p N_VDD_c_10439_n ) capacitor c=4.09141e-19 \
 //x=17.4 //y=5.56 //x2=18.62 //y2=7.585
cc_1239 ( N_noxref_4_c_1226_p N_VDD_c_10439_n ) capacitor c=0.00447349f \
 //x=19.73 //y=4.88 //x2=18.62 //y2=7.585
cc_1240 ( N_noxref_4_c_1221_p N_VDD_c_10439_n ) capacitor c=0.00564116f \
 //x=19.732 //y=4.74 //x2=18.62 //y2=7.585
cc_1241 ( N_noxref_4_c_1290_p N_VDD_c_10439_n ) capacitor c=0.0101861f \
 //x=17.4 //y=5.56 //x2=18.62 //y2=7.585
cc_1242 ( N_noxref_4_c_1228_p N_VDD_c_10439_n ) capacitor c=0.00370494f \
 //x=19.73 //y=4.88 //x2=18.62 //y2=7.585
cc_1243 ( N_noxref_4_c_1229_p N_VDD_c_10439_n ) capacitor c=0.0129564f \
 //x=19.73 //y=4.88 //x2=18.62 //y2=7.585
cc_1244 ( N_noxref_4_c_1198_n N_VDD_M64_noxref_s ) capacitor c=0.0572211f \
 //x=16.52 //y=5.56 //x2=15.945 //y2=5.2
cc_1245 ( N_noxref_4_c_1281_p N_VDD_M64_noxref_s ) capacitor c=6.52457e-19 \
 //x=17.4 //y=5.38 //x2=15.945 //y2=5.2
cc_1246 ( N_noxref_4_c_1206_n N_VDD_M64_noxref_s ) capacitor c=0.0887533f \
 //x=16.52 //y=5.56 //x2=15.945 //y2=5.2
cc_1247 ( N_noxref_4_c_1195_n N_VDD_M65_noxref_d ) capacitor c=0.00734094f \
 //x=17.285 //y=5.38 //x2=16.815 //y2=5.2
cc_1248 ( N_noxref_4_c_1198_n N_VDD_M65_noxref_d ) capacitor c=0.0043528f \
 //x=16.52 //y=5.56 //x2=16.815 //y2=5.2
cc_1249 ( N_noxref_4_c_1312_p N_VDD_M65_noxref_d ) capacitor c=0.0043528f \
 //x=17.4 //y=5.56 //x2=16.815 //y2=5.2
cc_1250 ( N_noxref_4_c_1206_n N_VDD_M65_noxref_d ) capacitor c=0.065554f \
 //x=16.52 //y=5.56 //x2=16.815 //y2=5.2
cc_1251 ( N_noxref_4_c_1290_p N_VDD_M65_noxref_d ) capacitor c=0.065554f \
 //x=17.4 //y=5.56 //x2=16.815 //y2=5.2
cc_1252 ( N_noxref_4_c_1276_p N_VDD_M67_noxref_d ) capacitor c=0.00898356f \
 //x=17.795 //y=5.38 //x2=17.695 //y2=5.2
cc_1253 ( N_noxref_4_c_1312_p N_VDD_M67_noxref_d ) capacitor c=0.00587834f \
 //x=17.4 //y=5.56 //x2=17.695 //y2=5.2
cc_1254 ( N_noxref_4_c_1204_n N_VDD_M67_noxref_d ) capacitor c=0.00122238f \
 //x=17.88 //y=3.88 //x2=17.695 //y2=5.2
cc_1255 ( N_noxref_4_c_1290_p N_VDD_M67_noxref_d ) capacitor c=0.065554f \
 //x=17.4 //y=5.56 //x2=17.695 //y2=5.2
cc_1256 ( N_noxref_4_c_1276_p N_VDD_M68_noxref_s ) capacitor c=0.00326953f \
 //x=17.795 //y=5.38 //x2=19.275 //y2=5.2
cc_1257 ( N_noxref_4_c_1219_p N_VDD_M68_noxref_s ) capacitor c=0.00143516f \
 //x=19.73 //y=4.025 //x2=19.275 //y2=5.2
cc_1258 ( N_noxref_4_c_1281_p N_VDD_M68_noxref_s ) capacitor c=0.00515461f \
 //x=17.4 //y=5.38 //x2=19.275 //y2=5.2
cc_1259 ( N_noxref_4_c_1312_p N_VDD_M68_noxref_s ) capacitor c=3.28075e-19 \
 //x=17.4 //y=5.56 //x2=19.275 //y2=5.2
cc_1260 ( N_noxref_4_M68_noxref_g N_VDD_M68_noxref_s ) capacitor c=0.0567929f \
 //x=19.63 //y=6.2 //x2=19.275 //y2=5.2
cc_1261 ( N_noxref_4_M69_noxref_g N_VDD_M69_noxref_d ) capacitor c=0.015318f \
 //x=20.07 //y=6.2 //x2=20.145 //y2=5.2
cc_1262 ( N_noxref_4_c_1301_p N_GND_c_12460_n ) capacitor c=0.00618782f \
 //x=17.795 //y=1.835 //x2=19.715 //y2=0.175
cc_1263 ( N_noxref_4_c_1237_p N_GND_c_12460_n ) capacitor c=3.0023e-19 \
 //x=17.88 //y=4.025 //x2=19.715 //y2=0.175
cc_1264 ( N_noxref_4_c_1232_p N_GND_c_12460_n ) capacitor c=0.00937893f \
 //x=17.44 //y=1.18 //x2=19.715 //y2=0.175
cc_1265 ( N_noxref_4_M10_noxref_d N_GND_c_12460_n ) capacitor c=3.01769e-19 \
 //x=17.25 //y=1.085 //x2=19.715 //y2=0.175
cc_1266 ( N_noxref_4_c_1198_n N_GND_c_12418_n ) capacitor c=5.93935e-19 \
 //x=16.52 //y=5.56 //x2=16.47 //y2=1.135
cc_1267 ( N_noxref_4_c_1232_p N_GND_c_12418_n ) capacitor c=0.0140087f \
 //x=17.44 //y=1.18 //x2=16.47 //y2=1.135
cc_1268 ( N_noxref_4_M10_noxref_d N_GND_c_12418_n ) capacitor c=2.93544e-19 \
 //x=17.25 //y=1.085 //x2=16.47 //y2=1.135
cc_1269 ( N_noxref_4_c_1232_p N_GND_c_12467_n ) capacitor c=0.00549186f \
 //x=17.44 //y=1.18 //x2=19.8 //y2=1.135
cc_1270 ( N_noxref_4_c_1234_p N_GND_c_12467_n ) capacitor c=0.00667419f \
 //x=19.73 //y=2.26 //x2=19.8 //y2=1.135
cc_1271 ( N_noxref_4_c_1223_p N_GND_c_12467_n ) capacitor c=2.13705e-19 \
 //x=19.73 //y=2.26 //x2=19.8 //y2=1.135
cc_1272 ( N_noxref_4_c_1254_p N_GND_c_12467_n ) capacitor c=0.00171023f \
 //x=19.535 //y=1.045 //x2=19.8 //y2=1.135
cc_1273 ( N_noxref_4_c_1255_p N_GND_c_12467_n ) capacitor c=0.00357815f \
 //x=19.535 //y=1.39 //x2=19.8 //y2=1.135
cc_1274 ( N_noxref_4_c_1257_p N_GND_c_12467_n ) capacitor c=4.2764e-19 \
 //x=19.535 //y=1.7 //x2=19.8 //y2=1.135
cc_1275 ( N_noxref_4_c_1432_p N_GND_c_12467_n ) capacitor c=9.36995e-19 \
 //x=19.91 //y=0.89 //x2=19.8 //y2=1.135
cc_1276 ( N_noxref_4_c_1433_p N_GND_c_12467_n ) capacitor c=6.38426e-19 \
 //x=19.91 //y=1.545 //x2=19.8 //y2=1.135
cc_1277 ( N_noxref_4_c_1256_p N_GND_c_12467_n ) capacitor c=0.00171483f \
 //x=20.065 //y=1.045 //x2=19.8 //y2=1.135
cc_1278 ( N_noxref_4_c_1258_p N_GND_c_12467_n ) capacitor c=0.00296337f \
 //x=20.065 //y=1.39 //x2=19.8 //y2=1.135
cc_1279 ( N_noxref_4_c_1254_p N_GND_c_12477_n ) capacitor c=3.46594e-19 \
 //x=19.535 //y=1.045 //x2=19.797 //y2=1.005
cc_1280 ( N_noxref_4_c_1432_p N_GND_c_12477_n ) capacitor c=0.00838576f \
 //x=19.91 //y=0.89 //x2=19.797 //y2=1.005
cc_1281 ( N_noxref_4_c_1256_p N_GND_c_12477_n ) capacitor c=4.40196e-19 \
 //x=20.065 //y=1.045 //x2=19.797 //y2=1.005
cc_1282 ( N_noxref_4_c_1301_p N_GND_c_12432_n ) capacitor c=7.77585e-19 \
 //x=17.795 //y=1.835 //x2=18.45 //y2=0.175
cc_1283 ( N_noxref_4_c_1254_p N_GND_c_12481_n ) capacitor c=0.00688027f \
 //x=19.535 //y=1.045 //x2=21.78 //y2=0.175
cc_1284 ( N_noxref_4_c_1196_n N_GND_c_12440_n ) capacitor c=9.32616e-19 \
 //x=17.88 //y=3.705 //x2=15.29 //y2=0.175
cc_1285 ( N_noxref_4_c_1212_p N_GND_c_12483_n ) capacitor c=0.002973f \
 //x=17.44 //y=1.75 //x2=18.62 //y2=0.175
cc_1286 ( N_noxref_4_c_1301_p N_GND_c_12483_n ) capacitor c=0.0287405f \
 //x=17.795 //y=1.835 //x2=18.62 //y2=0.175
cc_1287 ( N_noxref_4_c_1218_p N_GND_c_12483_n ) capacitor c=0.00718667f \
 //x=19.73 //y=3.705 //x2=18.62 //y2=0.175
cc_1288 ( N_noxref_4_c_1234_p N_GND_c_12483_n ) capacitor c=0.00427323f \
 //x=19.73 //y=2.26 //x2=18.62 //y2=0.175
cc_1289 ( N_noxref_4_c_1223_p N_GND_c_12483_n ) capacitor c=0.0038607f \
 //x=19.73 //y=2.26 //x2=18.62 //y2=0.175
cc_1290 ( N_noxref_4_c_1257_p N_GND_c_12483_n ) capacitor c=0.0015404f \
 //x=19.535 //y=1.7 //x2=18.62 //y2=0.175
cc_1291 ( N_noxref_4_c_1236_p N_GND_c_12483_n ) capacitor c=0.00906518f \
 //x=19.535 //y=2.095 //x2=18.62 //y2=0.175
cc_1292 ( N_noxref_4_c_1232_p N_GND_M9_noxref_d ) capacitor c=2.82748e-19 \
 //x=17.44 //y=1.18 //x2=16.28 //y2=1.045
cc_1293 ( N_noxref_4_c_1234_p N_GND_M11_noxref_d ) capacitor c=2.20438e-19 \
 //x=19.73 //y=2.26 //x2=19.61 //y2=1.045
cc_1294 ( N_noxref_4_c_1254_p N_GND_M11_noxref_d ) capacitor c=0.00192399f \
 //x=19.535 //y=1.045 //x2=19.61 //y2=1.045
cc_1295 ( N_noxref_4_c_1255_p N_GND_M11_noxref_d ) capacitor c=0.00210798f \
 //x=19.535 //y=1.39 //x2=19.61 //y2=1.045
cc_1296 ( N_noxref_4_c_1432_p N_GND_M11_noxref_d ) capacitor c=0.00472259f \
 //x=19.91 //y=0.89 //x2=19.61 //y2=1.045
cc_1297 ( N_noxref_4_c_1433_p N_GND_M11_noxref_d ) capacitor c=0.00166857f \
 //x=19.91 //y=1.545 //x2=19.61 //y2=1.045
cc_1298 ( N_noxref_4_c_1256_p N_GND_M11_noxref_d ) capacitor c=0.00230174f \
 //x=20.065 //y=1.045 //x2=19.61 //y2=1.045
cc_1299 ( N_noxref_4_c_1258_p N_GND_M11_noxref_d ) capacitor c=0.00210798f \
 //x=20.065 //y=1.39 //x2=19.61 //y2=1.045
cc_1300 ( N_noxref_4_c_1214_p N_noxref_35_c_14249_n ) capacitor c=0.00911498f \
 //x=17.525 //y=1.835 //x2=16.955 //y2=1.675
cc_1301 ( N_noxref_4_c_1301_p N_noxref_35_c_14254_n ) capacitor c=0.00399245f \
 //x=17.795 //y=1.835 //x2=17.84 //y2=0.71
cc_1302 ( N_noxref_4_c_1232_p N_noxref_35_c_14254_n ) capacitor c=0.003751f \
 //x=17.44 //y=1.18 //x2=17.84 //y2=0.71
cc_1303 ( N_noxref_4_M10_noxref_d N_noxref_35_c_14254_n ) capacitor \
 c=0.00910163f //x=17.25 //y=1.085 //x2=17.84 //y2=0.71
cc_1304 ( N_noxref_4_c_1212_p N_noxref_35_M9_noxref_s ) capacitor c=0.0162484f \
 //x=17.44 //y=1.75 //x2=15.85 //y2=0.545
cc_1305 ( N_noxref_4_c_1301_p N_noxref_35_M9_noxref_s ) capacitor \
 c=0.00670006f //x=17.795 //y=1.835 //x2=15.85 //y2=0.545
cc_1306 ( N_noxref_4_c_1237_p N_noxref_35_M9_noxref_s ) capacitor \
 c=3.24398e-19 //x=17.88 //y=4.025 //x2=15.85 //y2=0.545
cc_1307 ( N_noxref_4_c_1232_p N_noxref_35_M9_noxref_s ) capacitor \
 c=0.00905169f //x=17.44 //y=1.18 //x2=15.85 //y2=0.545
cc_1308 ( N_noxref_4_c_1204_n N_noxref_35_M9_noxref_s ) capacitor \
 c=8.42257e-19 //x=17.88 //y=3.88 //x2=15.85 //y2=0.545
cc_1309 ( N_noxref_4_M10_noxref_d N_noxref_35_M9_noxref_s ) capacitor \
 c=0.0275552f //x=17.25 //y=1.085 //x2=15.85 //y2=0.545
cc_1310 ( N_noxref_4_c_1236_p N_noxref_36_c_14311_n ) capacitor c=0.00262672f \
 //x=19.535 //y=2.095 //x2=19.315 //y2=1.675
cc_1311 ( N_noxref_4_c_1219_p N_noxref_36_c_14312_n ) capacitor c=0.0036189f \
 //x=19.73 //y=4.025 //x2=20.2 //y2=1.76
cc_1312 ( N_noxref_4_c_1234_p N_noxref_36_c_14312_n ) capacitor c=0.00509504f \
 //x=19.73 //y=2.26 //x2=20.2 //y2=1.76
cc_1313 ( N_noxref_4_c_1223_p N_noxref_36_c_14312_n ) capacitor c=0.00763108f \
 //x=19.73 //y=2.26 //x2=20.2 //y2=1.76
cc_1314 ( N_noxref_4_c_1257_p N_noxref_36_c_14312_n ) capacitor c=0.00697076f \
 //x=19.535 //y=1.7 //x2=20.2 //y2=1.76
cc_1315 ( N_noxref_4_c_1236_p N_noxref_36_c_14312_n ) capacitor c=0.017492f \
 //x=19.535 //y=2.095 //x2=20.2 //y2=1.76
cc_1316 ( N_noxref_4_c_1433_p N_noxref_36_c_14312_n ) capacitor c=0.00723574f \
 //x=19.91 //y=1.545 //x2=20.2 //y2=1.76
cc_1317 ( N_noxref_4_c_1258_p N_noxref_36_c_14312_n ) capacitor c=0.00339872f \
 //x=20.065 //y=1.39 //x2=20.2 //y2=1.76
cc_1318 ( N_noxref_4_c_1236_p N_noxref_36_c_14319_n ) capacitor c=6.71402e-19 \
 //x=19.535 //y=2.095 //x2=20.285 //y2=1.675
cc_1319 ( N_noxref_4_c_1254_p N_noxref_36_M11_noxref_s ) capacitor \
 c=0.0294925f //x=19.535 //y=1.045 //x2=19.18 //y2=0.545
cc_1320 ( N_noxref_4_c_1257_p N_noxref_36_M11_noxref_s ) capacitor \
 c=3.48408e-19 //x=19.535 //y=1.7 //x2=19.18 //y2=0.545
cc_1321 ( N_noxref_4_c_1256_p N_noxref_36_M11_noxref_s ) capacitor \
 c=0.0125442f //x=20.065 //y=1.045 //x2=19.18 //y2=0.545
cc_1322 ( N_noxref_5_c_1667_n N_noxref_10_c_3591_n ) capacitor c=0.00277817f \
 //x=20.47 //y=4.09 //x2=23.06 //y2=4.095
cc_1323 ( N_noxref_5_c_1675_n N_noxref_10_c_3592_n ) capacitor c=4.62969e-19 \
 //x=20.47 //y=4.735 //x2=23.06 //y2=4.755
cc_1324 ( N_noxref_5_c_1683_n N_noxref_10_c_3593_n ) capacitor c=3.5728e-19 \
 //x=20.47 //y=4.25 //x2=23.06 //y2=4.25
cc_1325 ( N_noxref_5_c_1650_n N_noxref_10_c_3594_n ) capacitor c=0.00180909f \
 //x=16.615 //y=4.27 //x2=23.225 //y2=4.255
cc_1326 ( N_noxref_5_c_1507_n D ) capacitor c=0.0209359f //x=10.645 //y=4.25 \
 //x2=7.15 //y2=3.14
cc_1327 ( N_noxref_5_c_1482_n N_D_c_4251_n ) capacitor c=0.0287619f //x=10.48 \
 //y=4.095 //x2=28.435 //y2=2.78
cc_1328 ( N_noxref_5_c_1551_n N_D_c_4251_n ) capacitor c=0.013091f //x=14.195 \
 //y=1.835 //x2=28.435 //y2=2.78
cc_1329 ( N_noxref_5_c_1552_n N_D_c_4251_n ) capacitor c=0.0329904f //x=14.55 \
 //y=4.105 //x2=28.435 //y2=2.78
cc_1330 ( N_noxref_5_c_1667_n N_D_c_4251_n ) capacitor c=0.0245244f //x=20.47 \
 //y=4.09 //x2=28.435 //y2=2.78
cc_1331 ( N_noxref_5_c_1497_n N_D_c_4251_n ) capacitor c=0.00365122f //x=10.48 \
 //y=2.26 //x2=28.435 //y2=2.78
cc_1332 ( N_noxref_5_c_1568_n N_D_c_4251_n ) capacitor c=4.96962e-19 //x=14.11 \
 //y=1.18 //x2=28.435 //y2=2.78
cc_1333 ( N_noxref_5_c_1684_n N_D_c_4251_n ) capacitor c=0.00364824f //x=20.47 \
 //y=2.26 //x2=28.435 //y2=2.78
cc_1334 ( N_noxref_5_c_1569_n N_D_c_4251_n ) capacitor c=0.00747088f //x=14.38 \
 //y=4.25 //x2=28.435 //y2=2.78
cc_1335 ( N_noxref_5_c_1507_n N_D_c_4251_n ) capacitor c=0.00203578f \
 //x=10.645 //y=4.25 //x2=28.435 //y2=2.78
cc_1336 ( N_noxref_5_c_1650_n N_D_c_4251_n ) capacitor c=0.0118115f //x=16.615 \
 //y=4.27 //x2=28.435 //y2=2.78
cc_1337 ( N_noxref_5_c_1652_n N_D_c_4251_n ) capacitor c=0.0108456f //x=16.27 \
 //y=4.27 //x2=28.435 //y2=2.78
cc_1338 ( N_noxref_5_c_1479_n CLK ) capacitor c=0.0542809f //x=1.6 //y=4.095 \
 //x2=2.71 //y2=2.77
cc_1339 ( N_noxref_5_c_1737_p CLK ) capacitor c=0.00797621f //x=1.6 //y=4.415 \
 //x2=2.71 //y2=2.77
cc_1340 ( N_noxref_5_c_1481_n CLK ) capacitor c=0.00733288f //x=1.6 //y=4.755 \
 //x2=2.71 //y2=2.77
cc_1341 ( N_noxref_5_c_1739_p CLK ) capacitor c=3.43503e-19 //x=1.6 //y=4.25 \
 //x2=2.71 //y2=2.77
cc_1342 ( N_noxref_5_c_1500_n CLK ) capacitor c=0.0287857f //x=4.175 //y=4.25 \
 //x2=2.71 //y2=2.77
cc_1343 ( N_noxref_5_c_1741_p CLK ) capacitor c=0.00243311f //x=1.765 \
 //y=4.255 //x2=2.71 //y2=2.77
cc_1344 ( N_noxref_5_c_1742_p CLK ) capacitor c=4.16726e-19 //x=1.6 //y=2.26 \
 //x2=2.71 //y2=2.77
cc_1345 ( N_noxref_5_c_1552_n CLK ) capacitor c=0.0713152f //x=14.55 //y=4.105 \
 //x2=13.81 //y2=3.14
cc_1346 ( N_noxref_5_c_1622_n CLK ) capacitor c=0.01773f //x=14.55 //y=4.425 \
 //x2=13.81 //y2=3.14
cc_1347 ( N_noxref_5_c_1555_n CLK ) capacitor c=0.00990547f //x=14.55 \
 //y=5.295 //x2=13.81 //y2=3.14
cc_1348 ( N_noxref_5_c_1746_p CLK ) capacitor c=9.19401e-19 //x=14.55 //y=4.25 \
 //x2=13.81 //y2=3.14
cc_1349 ( N_noxref_5_c_1569_n CLK ) capacitor c=0.0195347f //x=14.38 //y=4.25 \
 //x2=13.81 //y2=3.14
cc_1350 ( N_noxref_5_c_1652_n CLK ) capacitor c=0.00330634f //x=16.27 //y=4.27 \
 //x2=13.81 //y2=3.14
cc_1351 ( N_noxref_5_c_1749_p N_CLK_c_5591_n ) capacitor c=0.0115546f //x=1.6 \
 //y=2.375 //x2=2.71 //y2=2.375
cc_1352 ( N_noxref_5_c_1500_n N_CLK_c_5591_n ) capacitor c=0.00162388f \
 //x=4.175 //y=4.25 //x2=2.71 //y2=2.375
cc_1353 ( N_noxref_5_c_1742_p N_CLK_c_5591_n ) capacitor c=5.40058e-19 //x=1.6 \
 //y=2.26 //x2=2.71 //y2=2.375
cc_1354 ( N_noxref_5_c_1752_p N_CLK_c_5591_n ) capacitor c=0.00147006f //x=1.3 \
 //y=2.095 //x2=2.71 //y2=2.375
cc_1355 ( N_noxref_5_c_1481_n N_CLK_c_5594_n ) capacitor c=0.00759719f //x=1.6 \
 //y=4.755 //x2=2.71 //y2=4.88
cc_1356 ( N_noxref_5_c_1500_n N_CLK_c_5594_n ) capacitor c=0.00370332f \
 //x=4.175 //y=4.25 //x2=2.71 //y2=4.88
cc_1357 ( N_noxref_5_c_1755_p N_CLK_c_5594_n ) capacitor c=5.84784e-19 //x=1.6 \
 //y=4.88 //x2=2.71 //y2=4.88
cc_1358 ( N_noxref_5_c_1660_n N_CLK_c_5594_n ) capacitor c=0.00112623f \
 //x=2.165 //y=4.97 //x2=2.71 //y2=4.88
cc_1359 ( N_noxref_5_c_1757_p N_CLK_c_5594_n ) capacitor c=8.39124e-19 \
 //x=1.875 //y=4.97 //x2=2.71 //y2=4.88
cc_1360 ( N_noxref_5_c_1549_n N_CLK_c_5633_n ) capacitor c=0.0247435f \
 //x=13.955 //y=5.38 //x2=13.835 //y2=4.865
cc_1361 ( N_noxref_5_c_1555_n N_CLK_c_5633_n ) capacitor c=0.0154735f \
 //x=14.55 //y=5.295 //x2=13.835 //y2=4.865
cc_1362 ( N_noxref_5_c_1569_n N_CLK_c_5633_n ) capacitor c=4.16369e-19 \
 //x=14.38 //y=4.25 //x2=13.835 //y2=4.865
cc_1363 ( N_noxref_5_c_1761_p N_CLK_c_5633_n ) capacitor c=8.41381e-19 \
 //x=14.07 //y=5.56 //x2=13.835 //y2=4.865
cc_1364 ( N_noxref_5_c_1552_n N_CLK_c_5637_n ) capacitor c=0.015397f //x=14.55 \
 //y=4.105 //x2=13.81 //y2=2.26
cc_1365 ( N_noxref_5_c_1490_n N_CLK_c_5597_n ) capacitor c=0.00260076f \
 //x=10.48 //y=4.415 //x2=10.1 //y2=4.62
cc_1366 ( N_noxref_5_c_1491_n N_CLK_c_5597_n ) capacitor c=4.19842e-19 \
 //x=10.48 //y=4.735 //x2=10.1 //y2=4.62
cc_1367 ( N_noxref_5_c_1500_n N_CLK_c_5597_n ) capacitor c=0.0597544f \
 //x=4.175 //y=4.25 //x2=10.1 //y2=4.62
cc_1368 ( N_noxref_5_c_1504_n N_CLK_c_5597_n ) capacitor c=0.11637f //x=4.775 \
 //y=4.265 //x2=10.1 //y2=4.62
cc_1369 ( N_noxref_5_c_1505_n N_CLK_c_5597_n ) capacitor c=0.059022f //x=6.02 \
 //y=4.25 //x2=10.1 //y2=4.62
cc_1370 ( N_noxref_5_c_1507_n N_CLK_c_5597_n ) capacitor c=0.363756f \
 //x=10.645 //y=4.25 //x2=10.1 //y2=4.62
cc_1371 ( N_noxref_5_c_1490_n N_CLK_c_5642_n ) capacitor c=0.00232598f \
 //x=10.48 //y=4.415 //x2=10.7 //y2=4.64
cc_1372 ( N_noxref_5_c_1491_n N_CLK_c_5642_n ) capacitor c=0.026106f //x=10.48 \
 //y=4.735 //x2=10.7 //y2=4.64
cc_1373 ( N_noxref_5_c_1569_n N_CLK_c_5642_n ) capacitor c=0.0122383f \
 //x=14.38 //y=4.25 //x2=10.7 //y2=4.64
cc_1374 ( N_noxref_5_c_1534_n N_CLK_c_5642_n ) capacitor c=7.54771e-19 \
 //x=10.51 //y=4.88 //x2=10.7 //y2=4.64
cc_1375 ( N_noxref_5_c_1622_n N_CLK_c_5691_n ) capacitor c=0.00373017f \
 //x=14.55 //y=4.425 //x2=14.763 //y2=4.642
cc_1376 ( N_noxref_5_c_1555_n N_CLK_c_5691_n ) capacitor c=0.0266153f \
 //x=14.55 //y=5.295 //x2=14.763 //y2=4.642
cc_1377 ( N_noxref_5_c_1652_n N_CLK_c_5691_n ) capacitor c=0.126808f //x=16.27 \
 //y=4.27 //x2=14.763 //y2=4.642
cc_1378 ( N_noxref_5_c_1491_n N_CLK_c_5643_n ) capacitor c=4.11672e-19 \
 //x=10.48 //y=4.735 //x2=14.395 //y2=4.642
cc_1379 ( N_noxref_5_c_1549_n N_CLK_c_5643_n ) capacitor c=0.00962575f \
 //x=13.955 //y=5.38 //x2=14.395 //y2=4.642
cc_1380 ( N_noxref_5_c_1663_n N_CLK_c_5643_n ) capacitor c=0.00756397f \
 //x=14.465 //y=5.38 //x2=14.395 //y2=4.642
cc_1381 ( N_noxref_5_c_1622_n N_CLK_c_5643_n ) capacitor c=0.00259669f \
 //x=14.55 //y=4.425 //x2=14.395 //y2=4.642
cc_1382 ( N_noxref_5_c_1555_n N_CLK_c_5643_n ) capacitor c=0.00775567f \
 //x=14.55 //y=5.295 //x2=14.395 //y2=4.642
cc_1383 ( N_noxref_5_c_1559_n N_CLK_c_5643_n ) capacitor c=0.0207179f \
 //x=13.19 //y=5.56 //x2=14.395 //y2=4.642
cc_1384 ( N_noxref_5_c_1680_n N_CLK_c_5643_n ) capacitor c=0.00975439f \
 //x=14.07 //y=5.38 //x2=14.395 //y2=4.642
cc_1385 ( N_noxref_5_c_1569_n N_CLK_c_5643_n ) capacitor c=0.329017f //x=14.38 \
 //y=4.25 //x2=14.395 //y2=4.642
cc_1386 ( N_noxref_5_c_1652_n N_CLK_c_5643_n ) capacitor c=0.0362571f \
 //x=16.27 //y=4.27 //x2=14.395 //y2=4.642
cc_1387 ( N_noxref_5_c_1674_n N_CLK_c_5711_n ) capacitor c=0.00262187f \
 //x=20.47 //y=4.41 //x2=20.085 //y2=4.62
cc_1388 ( N_noxref_5_c_1675_n N_CLK_c_5711_n ) capacitor c=3.1152e-19 \
 //x=20.47 //y=4.735 //x2=20.085 //y2=4.62
cc_1389 ( N_noxref_5_c_1650_n N_CLK_c_5711_n ) capacitor c=0.0475755f \
 //x=16.615 //y=4.27 //x2=20.085 //y2=4.62
cc_1390 ( N_noxref_5_c_1650_n N_CLK_c_5716_n ) capacitor c=0.270005f \
 //x=16.615 //y=4.27 //x2=17.32 //y2=4.62
cc_1391 ( N_noxref_5_c_1674_n N_CLK_c_5771_n ) capacitor c=0.00225107f \
 //x=20.47 //y=4.41 //x2=20.685 //y2=4.635
cc_1392 ( N_noxref_5_c_1675_n N_CLK_c_5771_n ) capacitor c=0.0265693f \
 //x=20.47 //y=4.735 //x2=20.685 //y2=4.635
cc_1393 ( N_noxref_5_c_1717_n N_CLK_c_5771_n ) capacitor c=7.56668e-19 \
 //x=20.5 //y=4.88 //x2=20.685 //y2=4.635
cc_1394 ( N_noxref_5_c_1481_n N_CLK_c_5604_n ) capacitor c=0.00978415f //x=1.6 \
 //y=4.755 //x2=2.71 //y2=4.62
cc_1395 ( N_noxref_5_c_1500_n N_CLK_c_5604_n ) capacitor c=0.155183f //x=4.175 \
 //y=4.25 //x2=2.71 //y2=4.62
cc_1396 ( N_noxref_5_c_1650_n N_CLK_c_5698_n ) capacitor c=0.0454828f \
 //x=16.615 //y=4.27 //x2=17.235 //y2=4.62
cc_1397 ( N_noxref_5_c_1652_n N_CLK_c_5698_n ) capacitor c=0.0580136f \
 //x=16.27 //y=4.27 //x2=17.235 //y2=4.62
cc_1398 ( N_noxref_5_c_1749_p N_CLK_c_5605_n ) capacitor c=0.00375644f //x=1.6 \
 //y=2.375 //x2=2.71 //y2=2.26
cc_1399 ( N_noxref_5_c_1479_n N_CLK_c_5605_n ) capacitor c=4.16726e-19 //x=1.6 \
 //y=4.095 //x2=2.71 //y2=2.26
cc_1400 ( N_noxref_5_c_1742_p N_CLK_c_5605_n ) capacitor c=0.00125213f //x=1.6 \
 //y=2.26 //x2=2.71 //y2=2.26
cc_1401 ( N_noxref_5_c_1752_p N_CLK_c_5605_n ) capacitor c=0.00214573f //x=1.3 \
 //y=2.095 //x2=2.71 //y2=2.26
cc_1402 ( N_noxref_5_c_1481_n N_CLK_c_5609_n ) capacitor c=0.00402107f //x=1.6 \
 //y=4.755 //x2=2.71 //y2=4.88
cc_1403 ( N_noxref_5_c_1755_p N_CLK_c_5609_n ) capacitor c=0.00114249f //x=1.6 \
 //y=4.88 //x2=2.71 //y2=4.88
cc_1404 ( N_noxref_5_c_1660_n N_CLK_c_5609_n ) capacitor c=0.00133699f \
 //x=2.165 //y=4.97 //x2=2.71 //y2=4.88
cc_1405 ( N_noxref_5_c_1757_p N_CLK_c_5609_n ) capacitor c=0.00129812f \
 //x=1.875 //y=4.97 //x2=2.71 //y2=4.88
cc_1406 ( N_noxref_5_c_1552_n N_CLK_c_5647_n ) capacitor c=9.90728e-19 \
 //x=14.55 //y=4.105 //x2=13.81 //y2=2.26
cc_1407 ( N_noxref_5_c_1549_n N_CLK_c_5651_n ) capacitor c=0.00469232f \
 //x=13.955 //y=5.38 //x2=13.84 //y2=4.88
cc_1408 ( N_noxref_5_c_1555_n N_CLK_c_5651_n ) capacitor c=5.14671e-19 \
 //x=14.55 //y=5.295 //x2=13.84 //y2=4.88
cc_1409 ( N_noxref_5_M46_noxref_g N_CLK_M48_noxref_g ) capacitor c=0.0106276f \
 //x=1.8 //y=6.2 //x2=2.68 //y2=6.2
cc_1410 ( N_noxref_5_M47_noxref_g N_CLK_M48_noxref_g ) capacitor c=0.107144f \
 //x=2.24 //y=6.2 //x2=2.68 //y2=6.2
cc_1411 ( N_noxref_5_M47_noxref_g N_CLK_M49_noxref_g ) capacitor c=0.0101598f \
 //x=2.24 //y=6.2 //x2=3.12 //y2=6.2
cc_1412 ( N_noxref_5_c_1549_n N_CLK_M62_noxref_g ) capacitor c=0.00842814f \
 //x=13.955 //y=5.38 //x2=13.85 //y2=6.2
cc_1413 ( N_noxref_5_c_1680_n N_CLK_M62_noxref_g ) capacitor c=0.00192712f \
 //x=14.07 //y=5.38 //x2=13.85 //y2=6.2
cc_1414 ( N_noxref_5_c_1761_p N_CLK_M62_noxref_g ) capacitor c=0.0178987f \
 //x=14.07 //y=5.56 //x2=13.85 //y2=6.2
cc_1415 ( N_noxref_5_c_1663_n N_CLK_M63_noxref_g ) capacitor c=0.010578f \
 //x=14.465 //y=5.38 //x2=14.29 //y2=6.2
cc_1416 ( N_noxref_5_c_1680_n N_CLK_M63_noxref_g ) capacitor c=0.00298276f \
 //x=14.07 //y=5.38 //x2=14.29 //y2=6.2
cc_1417 ( N_noxref_5_c_1761_p N_CLK_M63_noxref_g ) capacitor c=0.0178506f \
 //x=14.07 //y=5.56 //x2=14.29 //y2=6.2
cc_1418 ( N_noxref_5_c_1816_p N_CLK_c_5798_n ) capacitor c=5.72528e-19 //x=1.3 \
 //y=1.055 //x2=2.275 //y2=1.09
cc_1419 ( N_noxref_5_c_1817_p N_CLK_c_5798_n ) capacitor c=0.00150277f //x=1.3 \
 //y=1.4 //x2=2.275 //y2=1.09
cc_1420 ( N_noxref_5_c_1818_p N_CLK_c_5798_n ) capacitor c=0.0160123f //x=1.83 \
 //y=1.055 //x2=2.275 //y2=1.09
cc_1421 ( N_noxref_5_c_1819_p N_CLK_c_5801_n ) capacitor c=0.00111227f //x=1.3 \
 //y=1.71 //x2=2.275 //y2=1.4
cc_1422 ( N_noxref_5_c_1820_p N_CLK_c_5801_n ) capacitor c=0.0124075f //x=1.83 \
 //y=1.4 //x2=2.275 //y2=1.4
cc_1423 ( N_noxref_5_c_1818_p N_CLK_c_5615_n ) capacitor c=9.19165e-19 \
 //x=1.83 //y=1.055 //x2=2.8 //y2=1.09
cc_1424 ( N_noxref_5_c_1820_p N_CLK_c_5616_n ) capacitor c=0.0010154f //x=1.83 \
 //y=1.4 //x2=2.8 //y2=1.4
cc_1425 ( N_noxref_5_c_1820_p N_CLK_c_5617_n ) capacitor c=9.23422e-19 \
 //x=1.83 //y=1.4 //x2=2.8 //y2=1.63
cc_1426 ( N_noxref_5_c_1749_p N_CLK_c_5618_n ) capacitor c=0.00140534f //x=1.6 \
 //y=2.375 //x2=2.8 //y2=2.095
cc_1427 ( N_noxref_5_c_1742_p N_CLK_c_5618_n ) capacitor c=0.0020754f //x=1.6 \
 //y=2.26 //x2=2.8 //y2=2.095
cc_1428 ( N_noxref_5_c_1752_p N_CLK_c_5618_n ) capacitor c=0.00964411f //x=1.3 \
 //y=2.095 //x2=2.8 //y2=2.095
cc_1429 ( N_noxref_5_c_1568_n N_CLK_c_5657_n ) capacitor c=0.00120406f \
 //x=14.11 //y=1.18 //x2=13.845 //y2=1.085
cc_1430 ( N_noxref_5_M8_noxref_d N_CLK_c_5657_n ) capacitor c=0.00137165f \
 //x=13.92 //y=1.085 //x2=13.845 //y2=1.085
cc_1431 ( N_noxref_5_c_1550_n N_CLK_c_5660_n ) capacitor c=0.00119008f \
 //x=14.11 //y=1.75 //x2=13.845 //y2=1.43
cc_1432 ( N_noxref_5_c_1568_n N_CLK_c_5660_n ) capacitor c=0.00218694f \
 //x=14.11 //y=1.18 //x2=13.845 //y2=1.43
cc_1433 ( N_noxref_5_M8_noxref_d N_CLK_c_5660_n ) capacitor c=0.00237422f \
 //x=13.92 //y=1.085 //x2=13.845 //y2=1.43
cc_1434 ( N_noxref_5_c_1550_n N_CLK_c_5662_n ) capacitor c=0.00438634f \
 //x=14.11 //y=1.75 //x2=13.845 //y2=1.74
cc_1435 ( N_noxref_5_c_1622_n N_CLK_c_5815_n ) capacitor c=9.17945e-19 \
 //x=14.55 //y=4.425 //x2=14.215 //y2=4.97
cc_1436 ( N_noxref_5_c_1555_n N_CLK_c_5815_n ) capacitor c=0.00841383f \
 //x=14.55 //y=5.295 //x2=14.215 //y2=4.97
cc_1437 ( N_noxref_5_c_1680_n N_CLK_c_5815_n ) capacitor c=0.0020909f \
 //x=14.07 //y=5.38 //x2=14.215 //y2=4.97
cc_1438 ( N_noxref_5_c_1761_p N_CLK_c_5815_n ) capacitor c=0.00291714f \
 //x=14.07 //y=5.56 //x2=14.215 //y2=4.97
cc_1439 ( N_noxref_5_c_1568_n N_CLK_c_5819_n ) capacitor c=5.50523e-19 \
 //x=14.11 //y=1.18 //x2=14.22 //y2=0.93
cc_1440 ( N_noxref_5_M8_noxref_d N_CLK_c_5819_n ) capacitor c=0.0020782f \
 //x=13.92 //y=1.085 //x2=14.22 //y2=0.93
cc_1441 ( N_noxref_5_c_1550_n N_CLK_c_5821_n ) capacitor c=0.00916852f \
 //x=14.11 //y=1.75 //x2=14.22 //y2=1.585
cc_1442 ( N_noxref_5_c_1664_n N_CLK_c_5821_n ) capacitor c=0.00194324f \
 //x=14.465 //y=1.835 //x2=14.22 //y2=1.585
cc_1443 ( N_noxref_5_c_1568_n N_CLK_c_5821_n ) capacitor c=5.67071e-19 \
 //x=14.11 //y=1.18 //x2=14.22 //y2=1.585
cc_1444 ( N_noxref_5_M8_noxref_d N_CLK_c_5821_n ) capacitor c=0.00356097f \
 //x=13.92 //y=1.085 //x2=14.22 //y2=1.585
cc_1445 ( N_noxref_5_c_1568_n N_CLK_c_5665_n ) capacitor c=0.00109205f \
 //x=14.11 //y=1.18 //x2=14.375 //y2=1.085
cc_1446 ( N_noxref_5_M8_noxref_d N_CLK_c_5665_n ) capacitor c=8.50095e-19 \
 //x=13.92 //y=1.085 //x2=14.375 //y2=1.085
cc_1447 ( N_noxref_5_c_1550_n N_CLK_c_5666_n ) capacitor c=0.003249f //x=14.11 \
 //y=1.75 //x2=14.375 //y2=1.43
cc_1448 ( N_noxref_5_c_1664_n N_CLK_c_5666_n ) capacitor c=0.00323005f \
 //x=14.465 //y=1.835 //x2=14.375 //y2=1.43
cc_1449 ( N_noxref_5_c_1568_n N_CLK_c_5666_n ) capacitor c=0.00317092f \
 //x=14.11 //y=1.18 //x2=14.375 //y2=1.43
cc_1450 ( N_noxref_5_M8_noxref_d N_CLK_c_5666_n ) capacitor c=0.00237422f \
 //x=13.92 //y=1.085 //x2=14.375 //y2=1.43
cc_1451 ( N_noxref_5_c_1481_n N_CLK_c_5623_n ) capacitor c=0.0011347f //x=1.6 \
 //y=4.755 //x2=2.71 //y2=4.88
cc_1452 ( N_noxref_5_c_1755_p N_CLK_c_5623_n ) capacitor c=0.00124807f //x=1.6 \
 //y=4.88 //x2=2.71 //y2=4.88
cc_1453 ( N_noxref_5_c_1660_n N_CLK_c_5623_n ) capacitor c=0.0163966f \
 //x=2.165 //y=4.97 //x2=2.71 //y2=4.88
cc_1454 ( N_noxref_5_c_1757_p N_CLK_c_5623_n ) capacitor c=0.00409733f \
 //x=1.875 //y=4.97 //x2=2.71 //y2=4.88
cc_1455 ( N_noxref_5_c_1552_n N_CLK_c_5667_n ) capacitor c=0.00281392f \
 //x=14.55 //y=4.105 //x2=13.81 //y2=2.26
cc_1456 ( N_noxref_5_c_1550_n N_CLK_c_5836_n ) capacitor c=0.00341114f \
 //x=14.11 //y=1.75 //x2=13.81 //y2=2.095
cc_1457 ( N_noxref_5_c_1552_n N_CLK_c_5836_n ) capacitor c=0.00309058f \
 //x=14.55 //y=4.105 //x2=13.81 //y2=2.095
cc_1458 ( N_noxref_5_c_1549_n N_CLK_c_5670_n ) capacitor c=7.7763e-19 \
 //x=13.955 //y=5.38 //x2=13.84 //y2=4.88
cc_1459 ( N_noxref_5_c_1552_n N_noxref_20_c_9133_n ) capacitor c=0.00119189f \
 //x=14.55 //y=4.105 //x2=17.14 //y2=2.995
cc_1460 ( N_noxref_5_c_1650_n N_noxref_20_c_9135_n ) capacitor c=0.00269006f \
 //x=16.615 //y=4.27 //x2=17.14 //y2=3.315
cc_1461 ( N_noxref_5_c_1552_n N_noxref_20_c_9136_n ) capacitor c=0.00143733f \
 //x=14.55 //y=4.105 //x2=17.14 //y2=4.735
cc_1462 ( N_noxref_5_c_1555_n N_noxref_20_c_9136_n ) capacitor c=7.36441e-19 \
 //x=14.55 //y=5.295 //x2=17.14 //y2=4.735
cc_1463 ( N_noxref_5_c_1650_n N_noxref_20_c_9136_n ) capacitor c=0.0250701f \
 //x=16.615 //y=4.27 //x2=17.14 //y2=4.735
cc_1464 ( N_noxref_5_c_1674_n N_noxref_20_c_9191_n ) capacitor c=0.0041373f \
 //x=20.47 //y=4.41 //x2=20.615 //y2=5.38
cc_1465 ( N_noxref_5_c_1675_n N_noxref_20_c_9191_n ) capacitor c=0.0215376f \
 //x=20.47 //y=4.735 //x2=20.615 //y2=5.38
cc_1466 ( N_noxref_5_c_1698_n N_noxref_20_c_9191_n ) capacitor c=0.00469257f \
 //x=20.5 //y=4.88 //x2=20.615 //y2=5.38
cc_1467 ( N_noxref_5_M70_noxref_g N_noxref_20_c_9191_n ) capacitor \
 c=0.00842859f //x=20.51 //y=6.2 //x2=20.615 //y2=5.38
cc_1468 ( N_noxref_5_c_1717_n N_noxref_20_c_9191_n ) capacitor c=8.42507e-19 \
 //x=20.5 //y=4.88 //x2=20.615 //y2=5.38
cc_1469 ( N_noxref_5_c_1707_n N_noxref_20_c_9192_n ) capacitor c=0.00119008f \
 //x=20.505 //y=1.43 //x2=20.77 //y2=1.75
cc_1470 ( N_noxref_5_c_1709_n N_noxref_20_c_9192_n ) capacitor c=0.00438634f \
 //x=20.505 //y=1.74 //x2=20.77 //y2=1.75
cc_1471 ( N_noxref_5_c_1869_p N_noxref_20_c_9192_n ) capacitor c=0.00929259f \
 //x=20.88 //y=1.585 //x2=20.77 //y2=1.75
cc_1472 ( N_noxref_5_c_1713_n N_noxref_20_c_9192_n ) capacitor c=0.00341295f \
 //x=21.035 //y=1.43 //x2=20.77 //y2=1.75
cc_1473 ( N_noxref_5_c_1871_p N_noxref_20_c_9192_n ) capacitor c=0.00341114f \
 //x=20.47 //y=2.095 //x2=20.77 //y2=1.75
cc_1474 ( N_noxref_5_M71_noxref_g N_noxref_20_c_9275_n ) capacitor \
 c=0.0106088f //x=20.95 //y=6.2 //x2=21.125 //y2=5.38
cc_1475 ( N_noxref_5_c_1869_p N_noxref_20_c_9276_n ) capacitor c=0.00194324f \
 //x=20.88 //y=1.585 //x2=21.125 //y2=1.835
cc_1476 ( N_noxref_5_c_1713_n N_noxref_20_c_9276_n ) capacitor c=0.00323005f \
 //x=21.035 //y=1.43 //x2=21.125 //y2=1.835
cc_1477 ( N_noxref_5_c_1667_n N_noxref_20_c_9194_n ) capacitor c=0.0239033f \
 //x=20.47 //y=4.09 //x2=21.21 //y2=2.995
cc_1478 ( N_noxref_5_c_1684_n N_noxref_20_c_9194_n ) capacitor c=0.015397f \
 //x=20.47 //y=2.26 //x2=21.21 //y2=2.995
cc_1479 ( N_noxref_5_c_1694_n N_noxref_20_c_9194_n ) capacitor c=9.90728e-19 \
 //x=20.47 //y=2.26 //x2=21.21 //y2=2.995
cc_1480 ( N_noxref_5_c_1714_n N_noxref_20_c_9194_n ) capacitor c=0.00281392f \
 //x=20.47 //y=2.26 //x2=21.21 //y2=2.995
cc_1481 ( N_noxref_5_c_1871_p N_noxref_20_c_9194_n ) capacitor c=0.00309058f \
 //x=20.47 //y=2.095 //x2=21.21 //y2=2.995
cc_1482 ( N_noxref_5_c_1667_n N_noxref_20_c_9283_n ) capacitor c=0.0152522f \
 //x=20.47 //y=4.09 //x2=21.21 //y2=3.315
cc_1483 ( N_noxref_5_c_1667_n N_noxref_20_c_9196_n ) capacitor c=0.0355589f \
 //x=20.47 //y=4.09 //x2=21.21 //y2=5.295
cc_1484 ( N_noxref_5_c_1674_n N_noxref_20_c_9196_n ) capacitor c=0.0148501f \
 //x=20.47 //y=4.41 //x2=21.21 //y2=5.295
cc_1485 ( N_noxref_5_c_1675_n N_noxref_20_c_9196_n ) capacitor c=0.0284231f \
 //x=20.47 //y=4.735 //x2=21.21 //y2=5.295
cc_1486 ( N_noxref_5_c_1683_n N_noxref_20_c_9196_n ) capacitor c=5.56854e-19 \
 //x=20.47 //y=4.25 //x2=21.21 //y2=5.295
cc_1487 ( N_noxref_5_c_1650_n N_noxref_20_c_9196_n ) capacitor c=0.00413652f \
 //x=16.615 //y=4.27 //x2=21.21 //y2=5.295
cc_1488 ( N_noxref_5_c_1698_n N_noxref_20_c_9196_n ) capacitor c=7.76118e-19 \
 //x=20.5 //y=4.88 //x2=21.21 //y2=5.295
cc_1489 ( N_noxref_5_c_1887_p N_noxref_20_c_9196_n ) capacitor c=0.00845606f \
 //x=20.875 //y=4.97 //x2=21.21 //y2=5.295
cc_1490 ( N_noxref_5_c_1717_n N_noxref_20_c_9196_n ) capacitor c=0.00142201f \
 //x=20.5 //y=4.88 //x2=21.21 //y2=5.295
cc_1491 ( N_noxref_5_M70_noxref_g N_noxref_20_c_9292_n ) capacitor \
 c=0.00192712f //x=20.51 //y=6.2 //x2=20.73 //y2=5.38
cc_1492 ( N_noxref_5_M71_noxref_g N_noxref_20_c_9292_n ) capacitor \
 c=0.00312463f //x=20.95 //y=6.2 //x2=20.73 //y2=5.38
cc_1493 ( N_noxref_5_c_1887_p N_noxref_20_c_9292_n ) capacitor c=0.0020909f \
 //x=20.875 //y=4.97 //x2=20.73 //y2=5.38
cc_1494 ( N_noxref_5_c_1704_n N_noxref_20_c_9210_n ) capacitor c=0.00120406f \
 //x=20.505 //y=1.085 //x2=20.77 //y2=1.18
cc_1495 ( N_noxref_5_c_1707_n N_noxref_20_c_9210_n ) capacitor c=0.00218694f \
 //x=20.505 //y=1.43 //x2=20.77 //y2=1.18
cc_1496 ( N_noxref_5_c_1894_p N_noxref_20_c_9210_n ) capacitor c=5.50523e-19 \
 //x=20.88 //y=0.93 //x2=20.77 //y2=1.18
cc_1497 ( N_noxref_5_c_1869_p N_noxref_20_c_9210_n ) capacitor c=5.67071e-19 \
 //x=20.88 //y=1.585 //x2=20.77 //y2=1.18
cc_1498 ( N_noxref_5_c_1712_n N_noxref_20_c_9210_n ) capacitor c=0.00108157f \
 //x=21.035 //y=1.085 //x2=20.77 //y2=1.18
cc_1499 ( N_noxref_5_c_1713_n N_noxref_20_c_9210_n ) capacitor c=0.00312028f \
 //x=21.035 //y=1.43 //x2=20.77 //y2=1.18
cc_1500 ( N_noxref_5_c_1667_n N_noxref_20_c_9301_n ) capacitor c=9.19401e-19 \
 //x=20.47 //y=4.09 //x2=21.21 //y2=3.14
cc_1501 ( N_noxref_5_c_1667_n N_noxref_20_c_9211_n ) capacitor c=0.0241487f \
 //x=20.47 //y=4.09 //x2=21.04 //y2=3.14
cc_1502 ( N_noxref_5_c_1674_n N_noxref_20_c_9211_n ) capacitor c=0.00276508f \
 //x=20.47 //y=4.41 //x2=21.04 //y2=3.14
cc_1503 ( N_noxref_5_c_1650_n N_noxref_20_c_9211_n ) capacitor c=0.0421076f \
 //x=16.615 //y=4.27 //x2=21.04 //y2=3.14
cc_1504 ( N_noxref_5_c_1667_n N_noxref_20_c_9305_n ) capacitor c=0.00340182f \
 //x=20.47 //y=4.09 //x2=25.07 //y2=3.125
cc_1505 ( N_noxref_5_c_1650_n N_noxref_20_c_9148_n ) capacitor c=0.00831868f \
 //x=16.615 //y=4.27 //x2=17.285 //y2=3.155
cc_1506 ( N_noxref_5_M70_noxref_g N_noxref_20_c_9307_n ) capacitor \
 c=0.0178987f //x=20.51 //y=6.2 //x2=20.73 //y2=5.56
cc_1507 ( N_noxref_5_M71_noxref_g N_noxref_20_c_9307_n ) capacitor \
 c=0.0178506f //x=20.95 //y=6.2 //x2=20.73 //y2=5.56
cc_1508 ( N_noxref_5_c_1887_p N_noxref_20_c_9307_n ) capacitor c=0.00291714f \
 //x=20.875 //y=4.97 //x2=20.73 //y2=5.56
cc_1509 ( N_noxref_5_c_1704_n N_noxref_20_M12_noxref_d ) capacitor \
 c=0.00137165f //x=20.505 //y=1.085 //x2=20.58 //y2=1.085
cc_1510 ( N_noxref_5_c_1707_n N_noxref_20_M12_noxref_d ) capacitor \
 c=0.00237422f //x=20.505 //y=1.43 //x2=20.58 //y2=1.085
cc_1511 ( N_noxref_5_c_1894_p N_noxref_20_M12_noxref_d ) capacitor \
 c=0.0020782f //x=20.88 //y=0.93 //x2=20.58 //y2=1.085
cc_1512 ( N_noxref_5_c_1869_p N_noxref_20_M12_noxref_d ) capacitor \
 c=0.00356097f //x=20.88 //y=1.585 //x2=20.58 //y2=1.085
cc_1513 ( N_noxref_5_c_1712_n N_noxref_20_M12_noxref_d ) capacitor \
 c=8.50095e-19 //x=21.035 //y=1.085 //x2=20.58 //y2=1.085
cc_1514 ( N_noxref_5_c_1713_n N_noxref_20_M12_noxref_d ) capacitor \
 c=0.00237422f //x=21.035 //y=1.43 //x2=20.58 //y2=1.085
cc_1515 ( N_noxref_5_c_1737_p N_VDD_c_10241_n ) capacitor c=3.71096e-19 \
 //x=1.6 //y=4.415 //x2=65.575 //y2=7.585
cc_1516 ( N_noxref_5_c_1549_n N_VDD_c_10241_n ) capacitor c=0.00621974f \
 //x=13.955 //y=5.38 //x2=65.575 //y2=7.585
cc_1517 ( N_noxref_5_c_1663_n N_VDD_c_10241_n ) capacitor c=0.00492568f \
 //x=14.465 //y=5.38 //x2=65.575 //y2=7.585
cc_1518 ( N_noxref_5_c_1559_n N_VDD_c_10241_n ) capacitor c=0.00368834f \
 //x=13.19 //y=5.56 //x2=65.575 //y2=7.585
cc_1519 ( N_noxref_5_c_1680_n N_VDD_c_10241_n ) capacitor c=8.11516e-19 \
 //x=14.07 //y=5.38 //x2=65.575 //y2=7.585
cc_1520 ( N_noxref_5_c_1681_n N_VDD_c_10241_n ) capacitor c=0.00284979f \
 //x=14.07 //y=5.56 //x2=65.575 //y2=7.585
cc_1521 ( N_noxref_5_c_1746_p N_VDD_c_10241_n ) capacitor c=3.84946e-19 \
 //x=14.55 //y=4.25 //x2=65.575 //y2=7.585
cc_1522 ( N_noxref_5_c_1576_n N_VDD_c_10241_n ) capacitor c=0.00224881f \
 //x=13.19 //y=5.56 //x2=65.575 //y2=7.585
cc_1523 ( N_noxref_5_c_1761_p N_VDD_c_10241_n ) capacitor c=0.00224881f \
 //x=14.07 //y=5.56 //x2=65.575 //y2=7.585
cc_1524 ( N_noxref_5_c_1737_p N_VDD_c_10364_n ) capacitor c=0.00179679f \
 //x=1.6 //y=4.415 //x2=1.23 //y2=7.58
cc_1525 ( N_noxref_5_c_1481_n N_VDD_c_10364_n ) capacitor c=0.0158335f //x=1.6 \
 //y=4.755 //x2=1.23 //y2=7.58
cc_1526 ( N_noxref_5_c_1739_p N_VDD_c_10364_n ) capacitor c=0.00229699f \
 //x=1.6 //y=4.25 //x2=1.23 //y2=7.58
cc_1527 ( N_noxref_5_c_1755_p N_VDD_c_10364_n ) capacitor c=0.00371026f \
 //x=1.6 //y=4.88 //x2=1.23 //y2=7.58
cc_1528 ( N_noxref_5_c_1757_p N_VDD_c_10364_n ) capacitor c=0.00587308f \
 //x=1.875 //y=4.97 //x2=1.23 //y2=7.58
cc_1529 ( N_noxref_5_c_1737_p N_VDD_c_10366_n ) capacitor c=3.24023e-19 \
 //x=1.6 //y=4.415 //x2=2.375 //y2=7.585
cc_1530 ( N_noxref_5_M46_noxref_g N_VDD_c_10366_n ) capacitor c=0.00755614f \
 //x=1.8 //y=6.2 //x2=2.375 //y2=7.585
cc_1531 ( N_noxref_5_M47_noxref_g N_VDD_c_10366_n ) capacitor c=0.00755544f \
 //x=2.24 //y=6.2 //x2=2.375 //y2=7.585
cc_1532 ( N_noxref_5_M58_noxref_g N_VDD_c_10311_n ) capacitor c=0.00697352f \
 //x=10.52 //y=6.2 //x2=11.095 //y2=7.585
cc_1533 ( N_noxref_5_M59_noxref_g N_VDD_c_10311_n ) capacitor c=0.00755544f \
 //x=10.96 //y=6.2 //x2=11.095 //y2=7.585
cc_1534 ( N_noxref_5_c_1549_n N_VDD_c_10316_n ) capacitor c=0.00208087f \
 //x=13.955 //y=5.38 //x2=13.545 //y2=7.585
cc_1535 ( N_noxref_5_c_1559_n N_VDD_c_10316_n ) capacitor c=9.41185e-19 \
 //x=13.19 //y=5.56 //x2=13.545 //y2=7.585
cc_1536 ( N_noxref_5_c_1576_n N_VDD_c_10316_n ) capacitor c=0.0136705f \
 //x=13.19 //y=5.56 //x2=13.545 //y2=7.585
cc_1537 ( N_noxref_5_c_1549_n N_VDD_c_10487_n ) capacitor c=0.00180737f \
 //x=13.955 //y=5.38 //x2=14.425 //y2=7.585
cc_1538 ( N_noxref_5_c_1663_n N_VDD_c_10487_n ) capacitor c=0.00208087f \
 //x=14.465 //y=5.38 //x2=14.425 //y2=7.585
cc_1539 ( N_noxref_5_c_1680_n N_VDD_c_10487_n ) capacitor c=4.23719e-19 \
 //x=14.07 //y=5.38 //x2=14.425 //y2=7.585
cc_1540 ( N_noxref_5_c_1681_n N_VDD_c_10487_n ) capacitor c=5.77976e-19 \
 //x=14.07 //y=5.56 //x2=14.425 //y2=7.585
cc_1541 ( N_noxref_5_c_1761_p N_VDD_c_10487_n ) capacitor c=0.0136705f \
 //x=14.07 //y=5.56 //x2=14.425 //y2=7.585
cc_1542 ( N_noxref_5_M70_noxref_g N_VDD_c_10492_n ) capacitor c=0.00697352f \
 //x=20.51 //y=6.2 //x2=21.085 //y2=7.585
cc_1543 ( N_noxref_5_M71_noxref_g N_VDD_c_10492_n ) capacitor c=0.00755544f \
 //x=20.95 //y=6.2 //x2=21.085 //y2=7.585
cc_1544 ( N_noxref_5_c_1504_n N_VDD_c_10264_n ) capacitor c=3.90041e-19 \
 //x=4.775 //y=4.265 //x2=5.3 //y2=7.585
cc_1545 ( N_noxref_5_c_1505_n N_VDD_c_10264_n ) capacitor c=0.00904116f \
 //x=6.02 //y=4.25 //x2=5.3 //y2=7.585
cc_1546 ( N_noxref_5_c_1496_n N_VDD_c_10269_n ) capacitor c=8.50173e-19 \
 //x=10.48 //y=4.25 //x2=8.63 //y2=7.585
cc_1547 ( N_noxref_5_c_1507_n N_VDD_c_10269_n ) capacitor c=0.0087315f \
 //x=10.645 //y=4.25 //x2=8.63 //y2=7.585
cc_1548 ( N_noxref_5_c_1555_n N_VDD_c_10322_n ) capacitor c=0.0013228f \
 //x=14.55 //y=5.295 //x2=11.96 //y2=7.585
cc_1549 ( N_noxref_5_c_1496_n N_VDD_c_10322_n ) capacitor c=0.00133985f \
 //x=10.48 //y=4.25 //x2=11.96 //y2=7.585
cc_1550 ( N_noxref_5_c_1559_n N_VDD_c_10322_n ) capacitor c=4.91377e-19 \
 //x=13.19 //y=5.56 //x2=11.96 //y2=7.585
cc_1551 ( N_noxref_5_c_1746_p N_VDD_c_10322_n ) capacitor c=4.55587e-19 \
 //x=14.55 //y=4.25 //x2=11.96 //y2=7.585
cc_1552 ( N_noxref_5_c_1569_n N_VDD_c_10322_n ) capacitor c=0.0086272f \
 //x=14.38 //y=4.25 //x2=11.96 //y2=7.585
cc_1553 ( N_noxref_5_c_1515_n N_VDD_c_10322_n ) capacitor c=0.00233202f \
 //x=10.51 //y=4.88 //x2=11.96 //y2=7.585
cc_1554 ( N_noxref_5_c_1576_n N_VDD_c_10322_n ) capacitor c=0.0064135f \
 //x=13.19 //y=5.56 //x2=11.96 //y2=7.585
cc_1555 ( N_noxref_5_c_1593_n N_VDD_c_10322_n ) capacitor c=0.0129149f \
 //x=10.885 //y=4.97 //x2=11.96 //y2=7.585
cc_1556 ( N_noxref_5_c_1622_n N_VDD_c_10391_n ) capacitor c=0.00197635f \
 //x=14.55 //y=4.425 //x2=15.29 //y2=7.585
cc_1557 ( N_noxref_5_c_1555_n N_VDD_c_10391_n ) capacitor c=0.0259523f \
 //x=14.55 //y=5.295 //x2=15.29 //y2=7.585
cc_1558 ( N_noxref_5_c_1680_n N_VDD_c_10391_n ) capacitor c=0.00240948f \
 //x=14.07 //y=5.38 //x2=15.29 //y2=7.585
cc_1559 ( N_noxref_5_c_1681_n N_VDD_c_10391_n ) capacitor c=4.09141e-19 \
 //x=14.07 //y=5.56 //x2=15.29 //y2=7.585
cc_1560 ( N_noxref_5_c_1746_p N_VDD_c_10391_n ) capacitor c=0.00494039f \
 //x=14.55 //y=4.25 //x2=15.29 //y2=7.585
cc_1561 ( N_noxref_5_c_1652_n N_VDD_c_10391_n ) capacitor c=0.00876148f \
 //x=16.27 //y=4.27 //x2=15.29 //y2=7.585
cc_1562 ( N_noxref_5_c_1761_p N_VDD_c_10391_n ) capacitor c=0.0101861f \
 //x=14.07 //y=5.56 //x2=15.29 //y2=7.585
cc_1563 ( N_noxref_5_c_1683_n N_VDD_c_10439_n ) capacitor c=8.4651e-19 \
 //x=20.47 //y=4.25 //x2=18.62 //y2=7.585
cc_1564 ( N_noxref_5_c_1650_n N_VDD_c_10439_n ) capacitor c=0.00865248f \
 //x=16.615 //y=4.27 //x2=18.62 //y2=7.585
cc_1565 ( N_noxref_5_c_1683_n N_VDD_c_10515_n ) capacitor c=0.00143077f \
 //x=20.47 //y=4.25 //x2=21.95 //y2=7.585
cc_1566 ( N_noxref_5_c_1698_n N_VDD_c_10515_n ) capacitor c=0.00226427f \
 //x=20.5 //y=4.88 //x2=21.95 //y2=7.585
cc_1567 ( N_noxref_5_c_1887_p N_VDD_c_10515_n ) capacitor c=0.0129318f \
 //x=20.875 //y=4.97 //x2=21.95 //y2=7.585
cc_1568 ( N_noxref_5_c_1717_n N_VDD_c_10515_n ) capacitor c=2.73429e-19 \
 //x=20.5 //y=4.88 //x2=21.95 //y2=7.585
cc_1569 ( N_noxref_5_c_1737_p N_VDD_M46_noxref_s ) capacitor c=9.6101e-19 \
 //x=1.6 //y=4.415 //x2=1.445 //y2=5.2
cc_1570 ( N_noxref_5_c_1481_n N_VDD_M46_noxref_s ) capacitor c=0.0223566f \
 //x=1.6 //y=4.755 //x2=1.445 //y2=5.2
cc_1571 ( N_noxref_5_c_1741_p N_VDD_M46_noxref_s ) capacitor c=4.27239e-19 \
 //x=1.765 //y=4.255 //x2=1.445 //y2=5.2
cc_1572 ( N_noxref_5_c_1755_p N_VDD_M46_noxref_s ) capacitor c=0.00911317f \
 //x=1.6 //y=4.88 //x2=1.445 //y2=5.2
cc_1573 ( N_noxref_5_M46_noxref_g N_VDD_M46_noxref_s ) capacitor c=0.053419f \
 //x=1.8 //y=6.2 //x2=1.445 //y2=5.2
cc_1574 ( N_noxref_5_c_1757_p N_VDD_M46_noxref_s ) capacitor c=0.00597659f \
 //x=1.875 //y=4.97 //x2=1.445 //y2=5.2
cc_1575 ( N_noxref_5_M47_noxref_g N_VDD_M47_noxref_d ) capacitor c=0.015318f \
 //x=2.24 //y=6.2 //x2=2.315 //y2=5.2
cc_1576 ( N_noxref_5_M58_noxref_g N_VDD_M57_noxref_d ) capacitor c=0.015318f \
 //x=10.52 //y=6.2 //x2=10.155 //y2=5.2
cc_1577 ( N_noxref_5_c_1534_n N_VDD_M57_noxref_d ) capacitor c=3.50465e-19 \
 //x=10.51 //y=4.88 //x2=10.155 //y2=5.2
cc_1578 ( N_noxref_5_M59_noxref_g N_VDD_M59_noxref_d ) capacitor c=0.0430452f \
 //x=10.96 //y=6.2 //x2=11.035 //y2=5.2
cc_1579 ( N_noxref_5_c_1559_n N_VDD_M60_noxref_s ) capacitor c=0.0572211f \
 //x=13.19 //y=5.56 //x2=12.615 //y2=5.2
cc_1580 ( N_noxref_5_c_1680_n N_VDD_M60_noxref_s ) capacitor c=6.52457e-19 \
 //x=14.07 //y=5.38 //x2=12.615 //y2=5.2
cc_1581 ( N_noxref_5_c_1576_n N_VDD_M60_noxref_s ) capacitor c=0.0887533f \
 //x=13.19 //y=5.56 //x2=12.615 //y2=5.2
cc_1582 ( N_noxref_5_c_1549_n N_VDD_M61_noxref_d ) capacitor c=0.00734094f \
 //x=13.955 //y=5.38 //x2=13.485 //y2=5.2
cc_1583 ( N_noxref_5_c_1559_n N_VDD_M61_noxref_d ) capacitor c=0.0043528f \
 //x=13.19 //y=5.56 //x2=13.485 //y2=5.2
cc_1584 ( N_noxref_5_c_1681_n N_VDD_M61_noxref_d ) capacitor c=0.0043528f \
 //x=14.07 //y=5.56 //x2=13.485 //y2=5.2
cc_1585 ( N_noxref_5_c_1576_n N_VDD_M61_noxref_d ) capacitor c=0.065554f \
 //x=13.19 //y=5.56 //x2=13.485 //y2=5.2
cc_1586 ( N_noxref_5_c_1761_p N_VDD_M61_noxref_d ) capacitor c=0.065554f \
 //x=14.07 //y=5.56 //x2=13.485 //y2=5.2
cc_1587 ( N_noxref_5_c_1663_n N_VDD_M63_noxref_d ) capacitor c=0.00852734f \
 //x=14.465 //y=5.38 //x2=14.365 //y2=5.2
cc_1588 ( N_noxref_5_c_1681_n N_VDD_M63_noxref_d ) capacitor c=0.00587834f \
 //x=14.07 //y=5.56 //x2=14.365 //y2=5.2
cc_1589 ( N_noxref_5_c_1746_p N_VDD_M63_noxref_d ) capacitor c=0.00167175f \
 //x=14.55 //y=4.25 //x2=14.365 //y2=5.2
cc_1590 ( N_noxref_5_c_1761_p N_VDD_M63_noxref_d ) capacitor c=0.065554f \
 //x=14.07 //y=5.56 //x2=14.365 //y2=5.2
cc_1591 ( N_noxref_5_c_1663_n N_VDD_M64_noxref_s ) capacitor c=0.00326953f \
 //x=14.465 //y=5.38 //x2=15.945 //y2=5.2
cc_1592 ( N_noxref_5_c_1680_n N_VDD_M64_noxref_s ) capacitor c=0.00515461f \
 //x=14.07 //y=5.38 //x2=15.945 //y2=5.2
cc_1593 ( N_noxref_5_c_1681_n N_VDD_M64_noxref_s ) capacitor c=3.28075e-19 \
 //x=14.07 //y=5.56 //x2=15.945 //y2=5.2
cc_1594 ( N_noxref_5_M70_noxref_g N_VDD_M69_noxref_d ) capacitor c=0.015318f \
 //x=20.51 //y=6.2 //x2=20.145 //y2=5.2
cc_1595 ( N_noxref_5_c_1717_n N_VDD_M69_noxref_d ) capacitor c=3.50465e-19 \
 //x=20.5 //y=4.88 //x2=20.145 //y2=5.2
cc_1596 ( N_noxref_5_M71_noxref_g N_VDD_M71_noxref_d ) capacitor c=0.0430452f \
 //x=20.95 //y=6.2 //x2=21.025 //y2=5.2
cc_1597 ( N_noxref_5_c_1500_n N_noxref_23_M2_noxref_s ) capacitor \
 c=0.00169534f //x=4.175 //y=4.25 //x2=3.455 //y2=0.555
cc_1598 ( N_noxref_5_c_1816_p N_GND_c_12498_n ) capacitor c=3.97665e-19 \
 //x=1.3 //y=1.055 //x2=1.565 //y2=1.015
cc_1599 ( N_noxref_5_c_1997_p N_GND_c_12498_n ) capacitor c=0.00864776f \
 //x=1.675 //y=0.9 //x2=1.565 //y2=1.015
cc_1600 ( N_noxref_5_c_1818_p N_GND_c_12498_n ) capacitor c=4.45447e-19 \
 //x=1.83 //y=1.055 //x2=1.565 //y2=1.015
cc_1601 ( N_noxref_5_c_1497_n N_GND_c_12361_n ) capacitor c=0.00215229f \
 //x=10.48 //y=2.26 //x2=13.055 //y2=0.175
cc_1602 ( N_noxref_5_c_1664_n N_GND_c_12502_n ) capacitor c=0.00618782f \
 //x=14.465 //y=1.835 //x2=16.385 //y2=0.175
cc_1603 ( N_noxref_5_c_1568_n N_GND_c_12502_n ) capacitor c=0.00937893f \
 //x=14.11 //y=1.18 //x2=16.385 //y2=0.175
cc_1604 ( N_noxref_5_M8_noxref_d N_GND_c_12502_n ) capacitor c=3.01769e-19 \
 //x=13.92 //y=1.085 //x2=16.385 //y2=0.175
cc_1605 ( N_noxref_5_c_1684_n N_GND_c_12505_n ) capacitor c=0.00215229f \
 //x=20.47 //y=2.26 //x2=22.94 //y2=0.175
cc_1606 ( N_noxref_5_c_1749_p N_GND_c_12506_n ) capacitor c=0.00849742f \
 //x=1.6 //y=2.375 //x2=1.565 //y2=1.145
cc_1607 ( N_noxref_5_c_1737_p N_GND_c_12506_n ) capacitor c=4.89021e-19 \
 //x=1.6 //y=4.415 //x2=1.565 //y2=1.145
cc_1608 ( N_noxref_5_c_1742_p N_GND_c_12506_n ) capacitor c=2.22883e-19 \
 //x=1.6 //y=2.26 //x2=1.565 //y2=1.145
cc_1609 ( N_noxref_5_c_1816_p N_GND_c_12506_n ) capacitor c=0.00142616f \
 //x=1.3 //y=1.055 //x2=1.565 //y2=1.145
cc_1610 ( N_noxref_5_c_1817_p N_GND_c_12506_n ) capacitor c=0.00411286f \
 //x=1.3 //y=1.4 //x2=1.565 //y2=1.145
cc_1611 ( N_noxref_5_c_1819_p N_GND_c_12506_n ) capacitor c=4.68816e-19 \
 //x=1.3 //y=1.71 //x2=1.565 //y2=1.145
cc_1612 ( N_noxref_5_c_1997_p N_GND_c_12506_n ) capacitor c=7.3749e-19 \
 //x=1.675 //y=0.9 //x2=1.565 //y2=1.145
cc_1613 ( N_noxref_5_c_2011_p N_GND_c_12506_n ) capacitor c=6.09659e-19 \
 //x=1.675 //y=1.555 //x2=1.565 //y2=1.145
cc_1614 ( N_noxref_5_c_1818_p N_GND_c_12506_n ) capacitor c=0.0017438f \
 //x=1.83 //y=1.055 //x2=1.565 //y2=1.145
cc_1615 ( N_noxref_5_c_1820_p N_GND_c_12506_n ) capacitor c=0.00276804f \
 //x=1.83 //y=1.4 //x2=1.565 //y2=1.145
cc_1616 ( N_noxref_5_c_1559_n N_GND_c_12368_n ) capacitor c=7.57822e-19 \
 //x=13.19 //y=5.56 //x2=13.14 //y2=1.135
cc_1617 ( N_noxref_5_c_1568_n N_GND_c_12368_n ) capacitor c=0.0140087f \
 //x=14.11 //y=1.18 //x2=13.14 //y2=1.135
cc_1618 ( N_noxref_5_M8_noxref_d N_GND_c_12368_n ) capacitor c=2.93544e-19 \
 //x=13.92 //y=1.085 //x2=13.14 //y2=1.135
cc_1619 ( N_noxref_5_c_1568_n N_GND_c_12418_n ) capacitor c=0.00549186f \
 //x=14.11 //y=1.18 //x2=16.47 //y2=1.135
cc_1620 ( N_noxref_5_c_1816_p N_GND_c_12337_n ) capacitor c=0.00680635f \
 //x=1.3 //y=1.055 //x2=5.13 //y2=0.175
cc_1621 ( N_noxref_5_c_1749_p N_GND_c_12521_n ) capacitor c=0.00779049f \
 //x=1.6 //y=2.375 //x2=1.23 //y2=0.18
cc_1622 ( N_noxref_5_c_1479_n N_GND_c_12521_n ) capacitor c=0.0126319f //x=1.6 \
 //y=4.095 //x2=1.23 //y2=0.18
cc_1623 ( N_noxref_5_c_1742_p N_GND_c_12521_n ) capacitor c=0.00394776f \
 //x=1.6 //y=2.26 //x2=1.23 //y2=0.18
cc_1624 ( N_noxref_5_c_1819_p N_GND_c_12521_n ) capacitor c=0.00295461f \
 //x=1.3 //y=1.71 //x2=1.23 //y2=0.18
cc_1625 ( N_noxref_5_c_1752_p N_GND_c_12521_n ) capacitor c=0.0112432f //x=1.3 \
 //y=2.095 //x2=1.23 //y2=0.18
cc_1626 ( N_noxref_5_c_1497_n N_GND_c_12339_n ) capacitor c=3.77328e-19 \
 //x=10.48 //y=2.26 //x2=11.79 //y2=0.175
cc_1627 ( N_noxref_5_c_1664_n N_GND_c_12383_n ) capacitor c=7.77585e-19 \
 //x=14.465 //y=1.835 //x2=15.12 //y2=0.175
cc_1628 ( N_noxref_5_c_1684_n N_GND_c_12481_n ) capacitor c=3.77328e-19 \
 //x=20.47 //y=2.26 //x2=21.78 //y2=0.175
cc_1629 ( N_noxref_5_c_1552_n N_GND_c_12385_n ) capacitor c=9.32616e-19 \
 //x=14.55 //y=4.105 //x2=11.96 //y2=0.175
cc_1630 ( N_noxref_5_c_1511_n N_GND_c_12385_n ) capacitor c=0.00224736f \
 //x=10.48 //y=2.26 //x2=11.96 //y2=0.175
cc_1631 ( N_noxref_5_c_1530_n N_GND_c_12385_n ) capacitor c=0.00275184f \
 //x=11.045 //y=1.43 //x2=11.96 //y2=0.175
cc_1632 ( N_noxref_5_c_1531_n N_GND_c_12385_n ) capacitor c=2.63786e-19 \
 //x=10.48 //y=2.26 //x2=11.96 //y2=0.175
cc_1633 ( N_noxref_5_c_1550_n N_GND_c_12440_n ) capacitor c=0.002973f \
 //x=14.11 //y=1.75 //x2=15.29 //y2=0.175
cc_1634 ( N_noxref_5_c_1664_n N_GND_c_12440_n ) capacitor c=0.0287405f \
 //x=14.465 //y=1.835 //x2=15.29 //y2=0.175
cc_1635 ( N_noxref_5_c_1694_n N_GND_c_12535_n ) capacitor c=0.00224736f \
 //x=20.47 //y=2.26 //x2=21.95 //y2=0.175
cc_1636 ( N_noxref_5_c_1713_n N_GND_c_12535_n ) capacitor c=0.00275184f \
 //x=21.035 //y=1.43 //x2=21.95 //y2=0.175
cc_1637 ( N_noxref_5_c_1714_n N_GND_c_12535_n ) capacitor c=2.63786e-19 \
 //x=20.47 //y=2.26 //x2=21.95 //y2=0.175
cc_1638 ( N_noxref_5_c_1749_p N_GND_M0_noxref_d ) capacitor c=4.4417e-19 \
 //x=1.6 //y=2.375 //x2=1.375 //y2=1.055
cc_1639 ( N_noxref_5_c_1816_p N_GND_M0_noxref_d ) capacitor c=0.00184354f \
 //x=1.3 //y=1.055 //x2=1.375 //y2=1.055
cc_1640 ( N_noxref_5_c_1817_p N_GND_M0_noxref_d ) capacitor c=0.00210798f \
 //x=1.3 //y=1.4 //x2=1.375 //y2=1.055
cc_1641 ( N_noxref_5_c_1997_p N_GND_M0_noxref_d ) capacitor c=0.00474029f \
 //x=1.675 //y=0.9 //x2=1.375 //y2=1.055
cc_1642 ( N_noxref_5_c_2011_p N_GND_M0_noxref_d ) capacitor c=0.00166857f \
 //x=1.675 //y=1.555 //x2=1.375 //y2=1.055
cc_1643 ( N_noxref_5_c_1818_p N_GND_M0_noxref_d ) capacitor c=0.00230174f \
 //x=1.83 //y=1.055 //x2=1.375 //y2=1.055
cc_1644 ( N_noxref_5_c_1820_p N_GND_M0_noxref_d ) capacitor c=0.00210798f \
 //x=1.83 //y=1.4 //x2=1.375 //y2=1.055
cc_1645 ( N_noxref_5_c_1568_n N_GND_M7_noxref_d ) capacitor c=2.82748e-19 \
 //x=14.11 //y=1.18 //x2=12.95 //y2=1.045
cc_1646 ( N_noxref_5_c_1752_p N_noxref_31_c_13980_n ) capacitor c=0.00267608f \
 //x=1.3 //y=2.095 //x2=1.08 //y2=1.685
cc_1647 ( N_noxref_5_c_1749_p N_noxref_31_c_13981_n ) capacitor c=0.00428451f \
 //x=1.6 //y=2.375 //x2=1.965 //y2=1.77
cc_1648 ( N_noxref_5_c_1737_p N_noxref_31_c_13981_n ) capacitor c=0.00109792f \
 //x=1.6 //y=4.415 //x2=1.965 //y2=1.77
cc_1649 ( N_noxref_5_c_1500_n N_noxref_31_c_13981_n ) capacitor c=0.00135436f \
 //x=4.175 //y=4.25 //x2=1.965 //y2=1.77
cc_1650 ( N_noxref_5_c_1742_p N_noxref_31_c_13981_n ) capacitor c=0.0104666f \
 //x=1.6 //y=2.26 //x2=1.965 //y2=1.77
cc_1651 ( N_noxref_5_c_1819_p N_noxref_31_c_13981_n ) capacitor c=0.00703864f \
 //x=1.3 //y=1.71 //x2=1.965 //y2=1.77
cc_1652 ( N_noxref_5_c_1752_p N_noxref_31_c_13981_n ) capacitor c=0.0232409f \
 //x=1.3 //y=2.095 //x2=1.965 //y2=1.77
cc_1653 ( N_noxref_5_c_2011_p N_noxref_31_c_13981_n ) capacitor c=0.00588627f \
 //x=1.675 //y=1.555 //x2=1.965 //y2=1.77
cc_1654 ( N_noxref_5_c_1820_p N_noxref_31_c_13981_n ) capacitor c=0.00698822f \
 //x=1.83 //y=1.4 //x2=1.965 //y2=1.77
cc_1655 ( N_noxref_5_c_1500_n N_noxref_31_c_13989_n ) capacitor c=0.00575375f \
 //x=4.175 //y=4.25 //x2=2.935 //y2=1.77
cc_1656 ( N_noxref_5_c_1500_n N_noxref_31_M0_noxref_s ) capacitor \
 c=0.00351966f //x=4.175 //y=4.25 //x2=0.945 //y2=0.555
cc_1657 ( N_noxref_5_c_1816_p N_noxref_31_M0_noxref_s ) capacitor c=0.0295256f \
 //x=1.3 //y=1.055 //x2=0.945 //y2=0.555
cc_1658 ( N_noxref_5_c_1819_p N_noxref_31_M0_noxref_s ) capacitor \
 c=7.99997e-19 //x=1.3 //y=1.71 //x2=0.945 //y2=0.555
cc_1659 ( N_noxref_5_c_1752_p N_noxref_31_M0_noxref_s ) capacitor \
 c=0.00122123f //x=1.3 //y=2.095 //x2=0.945 //y2=0.555
cc_1660 ( N_noxref_5_c_1818_p N_noxref_31_M0_noxref_s ) capacitor c=0.0125924f \
 //x=1.83 //y=1.055 //x2=0.945 //y2=0.555
cc_1661 ( N_noxref_5_c_1490_n N_noxref_33_c_14112_n ) capacitor c=9.48063e-19 \
 //x=10.48 //y=4.415 //x2=10.295 //y2=1.675
cc_1662 ( N_noxref_5_c_1497_n N_noxref_33_c_14112_n ) capacitor c=7.50092e-19 \
 //x=10.48 //y=2.26 //x2=10.295 //y2=1.675
cc_1663 ( N_noxref_5_c_1526_n N_noxref_33_c_14112_n ) capacitor c=0.00888238f \
 //x=10.515 //y=1.74 //x2=10.295 //y2=1.675
cc_1664 ( N_noxref_5_c_1531_n N_noxref_33_c_14112_n ) capacitor c=0.00175171f \
 //x=10.48 //y=2.26 //x2=10.295 //y2=1.675
cc_1665 ( N_noxref_5_c_1497_n N_noxref_33_c_14117_n ) capacitor c=0.001463f \
 //x=10.48 //y=2.26 //x2=11.18 //y2=0.71
cc_1666 ( N_noxref_5_c_1511_n N_noxref_33_c_14117_n ) capacitor c=8.82141e-19 \
 //x=10.48 //y=2.26 //x2=11.18 //y2=0.71
cc_1667 ( N_noxref_5_c_1521_n N_noxref_33_c_14117_n ) capacitor c=0.0200738f \
 //x=10.515 //y=1.085 //x2=11.18 //y2=0.71
cc_1668 ( N_noxref_5_c_1529_n N_noxref_33_c_14117_n ) capacitor c=0.00825432f \
 //x=11.045 //y=1.085 //x2=11.18 //y2=0.71
cc_1669 ( N_noxref_5_c_1531_n N_noxref_33_c_14117_n ) capacitor c=2.1838e-19 \
 //x=10.48 //y=2.26 //x2=11.18 //y2=0.71
cc_1670 ( N_noxref_5_c_1521_n N_noxref_33_M5_noxref_s ) capacitor \
 c=0.00888238f //x=10.515 //y=1.085 //x2=9.19 //y2=0.545
cc_1671 ( N_noxref_5_c_1529_n N_noxref_33_M5_noxref_s ) capacitor c=0.015333f \
 //x=11.045 //y=1.085 //x2=9.19 //y2=0.545
cc_1672 ( N_noxref_5_c_1530_n N_noxref_33_M5_noxref_s ) capacitor \
 c=0.00248746f //x=11.045 //y=1.43 //x2=9.19 //y2=0.545
cc_1673 ( N_noxref_5_c_1551_n N_noxref_34_c_14181_n ) capacitor c=0.00911498f \
 //x=14.195 //y=1.835 //x2=13.625 //y2=1.675
cc_1674 ( N_noxref_5_c_1664_n N_noxref_34_c_14186_n ) capacitor c=0.00399245f \
 //x=14.465 //y=1.835 //x2=14.51 //y2=0.71
cc_1675 ( N_noxref_5_c_1568_n N_noxref_34_c_14186_n ) capacitor c=0.003751f \
 //x=14.11 //y=1.18 //x2=14.51 //y2=0.71
cc_1676 ( N_noxref_5_M8_noxref_d N_noxref_34_c_14186_n ) capacitor \
 c=0.00910163f //x=13.92 //y=1.085 //x2=14.51 //y2=0.71
cc_1677 ( N_noxref_5_c_1550_n N_noxref_34_M7_noxref_s ) capacitor c=0.0162484f \
 //x=14.11 //y=1.75 //x2=12.52 //y2=0.545
cc_1678 ( N_noxref_5_c_1664_n N_noxref_34_M7_noxref_s ) capacitor \
 c=0.00692219f //x=14.465 //y=1.835 //x2=12.52 //y2=0.545
cc_1679 ( N_noxref_5_c_1622_n N_noxref_34_M7_noxref_s ) capacitor \
 c=2.52049e-19 //x=14.55 //y=4.425 //x2=12.52 //y2=0.545
cc_1680 ( N_noxref_5_c_1568_n N_noxref_34_M7_noxref_s ) capacitor \
 c=0.00905169f //x=14.11 //y=1.18 //x2=12.52 //y2=0.545
cc_1681 ( N_noxref_5_c_1746_p N_noxref_34_M7_noxref_s ) capacitor \
 c=7.05305e-19 //x=14.55 //y=4.25 //x2=12.52 //y2=0.545
cc_1682 ( N_noxref_5_M8_noxref_d N_noxref_34_M7_noxref_s ) capacitor \
 c=0.0275552f //x=13.92 //y=1.085 //x2=12.52 //y2=0.545
cc_1683 ( N_noxref_5_c_1674_n N_noxref_36_c_14319_n ) capacitor c=9.54772e-19 \
 //x=20.47 //y=4.41 //x2=20.285 //y2=1.675
cc_1684 ( N_noxref_5_c_1684_n N_noxref_36_c_14319_n ) capacitor c=7.50092e-19 \
 //x=20.47 //y=2.26 //x2=20.285 //y2=1.675
cc_1685 ( N_noxref_5_c_1709_n N_noxref_36_c_14319_n ) capacitor c=0.00888238f \
 //x=20.505 //y=1.74 //x2=20.285 //y2=1.675
cc_1686 ( N_noxref_5_c_1714_n N_noxref_36_c_14319_n ) capacitor c=0.00175171f \
 //x=20.47 //y=2.26 //x2=20.285 //y2=1.675
cc_1687 ( N_noxref_5_c_1684_n N_noxref_36_c_14327_n ) capacitor c=0.001463f \
 //x=20.47 //y=2.26 //x2=21.17 //y2=0.71
cc_1688 ( N_noxref_5_c_1694_n N_noxref_36_c_14327_n ) capacitor c=8.82141e-19 \
 //x=20.47 //y=2.26 //x2=21.17 //y2=0.71
cc_1689 ( N_noxref_5_c_1704_n N_noxref_36_c_14327_n ) capacitor c=0.0200738f \
 //x=20.505 //y=1.085 //x2=21.17 //y2=0.71
cc_1690 ( N_noxref_5_c_1712_n N_noxref_36_c_14327_n ) capacitor c=0.00825432f \
 //x=21.035 //y=1.085 //x2=21.17 //y2=0.71
cc_1691 ( N_noxref_5_c_1714_n N_noxref_36_c_14327_n ) capacitor c=2.1838e-19 \
 //x=20.47 //y=2.26 //x2=21.17 //y2=0.71
cc_1692 ( N_noxref_5_c_1704_n N_noxref_36_M11_noxref_s ) capacitor \
 c=0.00888238f //x=20.505 //y=1.085 //x2=19.18 //y2=0.545
cc_1693 ( N_noxref_5_c_1712_n N_noxref_36_M11_noxref_s ) capacitor c=0.015333f \
 //x=21.035 //y=1.085 //x2=19.18 //y2=0.545
cc_1694 ( N_noxref_5_c_1713_n N_noxref_36_M11_noxref_s ) capacitor \
 c=0.00248746f //x=21.035 //y=1.43 //x2=19.18 //y2=0.545
cc_1695 ( N_noxref_6_M83_noxref_g N_noxref_7_c_2534_n ) capacitor \
 c=0.00889217f //x=31.54 //y=6.2 //x2=32.085 //y2=5.38
cc_1696 ( N_noxref_6_c_2094_p N_noxref_7_c_2535_n ) capacitor c=0.00324213f \
 //x=28.91 //y=1.75 //x2=32.24 //y2=1.75
cc_1697 ( N_noxref_6_c_2095_p N_noxref_7_c_2536_n ) capacitor c=0.00231467f \
 //x=29.265 //y=1.835 //x2=32.325 //y2=1.835
cc_1698 ( N_noxref_6_c_2096_p N_noxref_7_c_2537_n ) capacitor c=0.00204244f \
 //x=29.35 //y=3.35 //x2=32.68 //y2=3.35
cc_1699 ( N_noxref_6_c_2097_p N_noxref_7_c_2537_n ) capacitor c=0.00216477f \
 //x=31.2 //y=3.345 //x2=32.68 //y2=3.35
cc_1700 ( N_noxref_6_c_2098_p N_noxref_7_c_2539_n ) capacitor c=0.00281705f \
 //x=29.35 //y=5.295 //x2=32.68 //y2=5.295
cc_1701 ( N_noxref_6_c_2099_p N_noxref_7_c_2539_n ) capacitor c=0.00193818f \
 //x=31.202 //y=4.74 //x2=32.68 //y2=5.295
cc_1702 ( N_noxref_6_c_2100_p N_noxref_7_c_2541_n ) capacitor c=0.00114153f \
 //x=29.265 //y=5.38 //x2=31.32 //y2=5.56
cc_1703 ( N_noxref_6_c_2101_p N_noxref_7_c_2541_n ) capacitor c=5.6496e-19 \
 //x=31.2 //y=3.665 //x2=31.32 //y2=5.56
cc_1704 ( N_noxref_6_c_2102_p N_noxref_7_c_2541_n ) capacitor c=5.29822e-19 \
 //x=28.87 //y=5.38 //x2=31.32 //y2=5.56
cc_1705 ( N_noxref_6_c_2103_p N_noxref_7_c_2541_n ) capacitor c=0.00147119f \
 //x=28.87 //y=5.56 //x2=31.32 //y2=5.56
cc_1706 ( N_noxref_6_c_2104_p N_noxref_7_c_2541_n ) capacitor c=0.0117744f \
 //x=31.2 //y=4.88 //x2=31.32 //y2=5.56
cc_1707 ( N_noxref_6_c_2105_p N_noxref_7_c_2541_n ) capacitor c=0.00277154f \
 //x=31.2 //y=4.88 //x2=31.32 //y2=5.56
cc_1708 ( N_noxref_6_M82_noxref_g N_noxref_7_c_2541_n ) capacitor \
 c=0.00201806f //x=31.1 //y=6.2 //x2=31.32 //y2=5.56
cc_1709 ( N_noxref_6_M83_noxref_g N_noxref_7_c_2541_n ) capacitor \
 c=0.00192712f //x=31.54 //y=6.2 //x2=31.32 //y2=5.56
cc_1710 ( N_noxref_6_c_2108_p N_noxref_7_c_2541_n ) capacitor c=0.00194573f \
 //x=31.2 //y=4.88 //x2=31.32 //y2=5.56
cc_1711 ( N_noxref_6_c_2109_p N_noxref_7_c_2550_n ) capacitor c=6.99317e-19 \
 //x=28.91 //y=1.18 //x2=32.24 //y2=1.18
cc_1712 ( N_noxref_6_c_2110_p N_noxref_7_c_2551_n ) capacitor c=0.00251357f \
 //x=31.2 //y=3.51 //x2=32.68 //y2=3.51
cc_1713 ( N_noxref_6_c_2111_p N_noxref_7_c_2552_n ) capacitor c=0.00521181f \
 //x=31.195 //y=3.505 //x2=32.845 //y2=3.51
cc_1714 ( N_noxref_6_c_2104_p N_noxref_7_c_2553_n ) capacitor c=0.00104426f \
 //x=31.2 //y=4.88 //x2=31.32 //y2=5.56
cc_1715 ( N_noxref_6_c_2105_p N_noxref_7_c_2553_n ) capacitor c=0.00377369f \
 //x=31.2 //y=4.88 //x2=31.32 //y2=5.56
cc_1716 ( N_noxref_6_M82_noxref_g N_noxref_7_c_2553_n ) capacitor c=0.0158358f \
 //x=31.1 //y=6.2 //x2=31.32 //y2=5.56
cc_1717 ( N_noxref_6_M83_noxref_g N_noxref_7_c_2553_n ) capacitor c=0.0178987f \
 //x=31.54 //y=6.2 //x2=31.32 //y2=5.56
cc_1718 ( N_noxref_6_c_2108_p N_noxref_7_c_2553_n ) capacitor c=0.0043218f \
 //x=31.2 //y=4.88 //x2=31.32 //y2=5.56
cc_1719 ( N_noxref_6_M76_noxref_g N_noxref_8_c_2822_n ) capacitor \
 c=0.00955829f //x=25.02 //y=6.2 //x2=25.125 //y2=5.335
cc_1720 ( N_noxref_6_c_2118_p N_noxref_8_c_2823_n ) capacitor c=5.58535e-19 \
 //x=27.99 //y=5.56 //x2=25.24 //y2=5.56
cc_1721 ( N_noxref_6_M76_noxref_g N_noxref_8_c_2823_n ) capacitor \
 c=0.00226521f //x=25.02 //y=6.2 //x2=25.24 //y2=5.56
cc_1722 ( N_noxref_6_M77_noxref_g N_noxref_8_c_2823_n ) capacitor \
 c=0.00368945f //x=25.46 //y=6.2 //x2=25.24 //y2=5.56
cc_1723 ( N_noxref_6_c_2121_p N_noxref_8_c_2826_n ) capacitor c=0.00109953f \
 //x=25.28 //y=3.67 //x2=25.935 //y2=5.335
cc_1724 ( N_noxref_6_c_2122_p N_noxref_8_c_2826_n ) capacitor c=0.00228791f \
 //x=25.28 //y=4.75 //x2=25.935 //y2=5.335
cc_1725 ( N_noxref_6_c_2118_p N_noxref_8_c_2826_n ) capacitor c=0.00104762f \
 //x=27.99 //y=5.56 //x2=25.935 //y2=5.335
cc_1726 ( N_noxref_6_c_2124_p N_noxref_8_c_2826_n ) capacitor c=0.00130631f \
 //x=25.28 //y=4.88 //x2=25.935 //y2=5.335
cc_1727 ( N_noxref_6_M77_noxref_g N_noxref_8_c_2826_n ) capacitor c=0.0110523f \
 //x=25.46 //y=6.2 //x2=25.935 //y2=5.335
cc_1728 ( N_noxref_6_c_2121_p N_noxref_8_c_2831_n ) capacitor c=2.378e-19 \
 //x=25.28 //y=3.67 //x2=25.535 //y2=1.305
cc_1729 ( N_noxref_6_c_2109_p N_noxref_8_c_2831_n ) capacitor c=6.5615e-19 \
 //x=28.91 //y=1.18 //x2=25.535 //y2=1.305
cc_1730 ( N_noxref_6_c_2128_p N_noxref_8_c_2831_n ) capacitor c=4.64015e-19 \
 //x=25.27 //y=1.095 //x2=25.535 //y2=1.305
cc_1731 ( N_noxref_6_c_2129_p N_noxref_8_c_2831_n ) capacitor c=0.0026012f \
 //x=25.27 //y=1.44 //x2=25.535 //y2=1.305
cc_1732 ( N_noxref_6_c_2130_p N_noxref_8_c_2831_n ) capacitor c=5.29969e-19 \
 //x=25.645 //y=0.94 //x2=25.535 //y2=1.305
cc_1733 ( N_noxref_6_c_2131_p N_noxref_8_c_2831_n ) capacitor c=5.00648e-19 \
 //x=25.645 //y=1.595 //x2=25.535 //y2=1.305
cc_1734 ( N_noxref_6_c_2132_p N_noxref_8_c_2831_n ) capacitor c=5.28622e-19 \
 //x=25.8 //y=1.095 //x2=25.535 //y2=1.305
cc_1735 ( N_noxref_6_c_2133_p N_noxref_8_c_2831_n ) capacitor c=0.00312156f \
 //x=25.8 //y=1.44 //x2=25.535 //y2=1.305
cc_1736 ( N_noxref_6_c_2094_p N_noxref_8_c_2839_n ) capacitor c=0.00326079f \
 //x=28.91 //y=1.75 //x2=25.535 //y2=1.76
cc_1737 ( N_noxref_6_c_2129_p N_noxref_8_c_2839_n ) capacitor c=0.00127432f \
 //x=25.27 //y=1.44 //x2=25.535 //y2=1.76
cc_1738 ( N_noxref_6_c_2136_p N_noxref_8_c_2839_n ) capacitor c=0.00429966f \
 //x=25.27 //y=1.75 //x2=25.535 //y2=1.76
cc_1739 ( N_noxref_6_c_2131_p N_noxref_8_c_2839_n ) capacitor c=0.00930387f \
 //x=25.645 //y=1.595 //x2=25.535 //y2=1.76
cc_1740 ( N_noxref_6_c_2133_p N_noxref_8_c_2839_n ) capacitor c=0.00347599f \
 //x=25.8 //y=1.44 //x2=25.535 //y2=1.76
cc_1741 ( N_noxref_6_c_2139_p N_noxref_8_c_2839_n ) capacitor c=0.00362297f \
 //x=25.28 //y=2.095 //x2=25.535 //y2=1.76
cc_1742 ( N_noxref_6_c_2140_p N_noxref_8_c_2845_n ) capacitor c=0.00218808f \
 //x=28.995 //y=1.835 //x2=25.935 //y2=1.845
cc_1743 ( N_noxref_6_c_2096_p N_noxref_8_c_2845_n ) capacitor c=0.00203605f \
 //x=29.35 //y=3.35 //x2=25.935 //y2=1.845
cc_1744 ( N_noxref_6_c_2131_p N_noxref_8_c_2845_n ) capacitor c=0.00194716f \
 //x=25.645 //y=1.595 //x2=25.935 //y2=1.845
cc_1745 ( N_noxref_6_c_2133_p N_noxref_8_c_2845_n ) capacitor c=0.00323576f \
 //x=25.8 //y=1.44 //x2=25.935 //y2=1.845
cc_1746 ( N_noxref_6_c_2121_p N_noxref_8_c_2849_n ) capacitor c=0.00107302f \
 //x=25.28 //y=3.67 //x2=25.62 //y2=1.845
cc_1747 ( N_noxref_6_c_2145_p N_noxref_8_c_2850_n ) capacitor c=0.0154269f \
 //x=25.28 //y=2.375 //x2=26.02 //y2=3.72
cc_1748 ( N_noxref_6_c_2146_p N_noxref_8_c_2850_n ) capacitor c=0.039096f \
 //x=25.28 //y=3.35 //x2=26.02 //y2=3.72
cc_1749 ( N_noxref_6_c_2121_p N_noxref_8_c_2850_n ) capacitor c=0.017329f \
 //x=25.28 //y=3.67 //x2=26.02 //y2=3.72
cc_1750 ( N_noxref_6_c_2122_p N_noxref_8_c_2850_n ) capacitor c=0.00225898f \
 //x=25.28 //y=4.75 //x2=26.02 //y2=3.72
cc_1751 ( N_noxref_6_c_2149_p N_noxref_8_c_2850_n ) capacitor c=6.78671e-19 \
 //x=25.28 //y=3.51 //x2=26.02 //y2=3.72
cc_1752 ( N_noxref_6_c_2150_p N_noxref_8_c_2850_n ) capacitor c=2.75635e-19 \
 //x=25.635 //y=3.51 //x2=26.02 //y2=3.72
cc_1753 ( N_noxref_6_c_2151_p N_noxref_8_c_2850_n ) capacitor c=0.00308371f \
 //x=25.445 //y=3.51 //x2=26.02 //y2=3.72
cc_1754 ( N_noxref_6_c_2152_p N_noxref_8_c_2850_n ) capacitor c=0.0216394f \
 //x=26.235 //y=3.495 //x2=26.02 //y2=3.72
cc_1755 ( N_noxref_6_c_2153_p N_noxref_8_c_2850_n ) capacitor c=0.00163444f \
 //x=25.28 //y=2.26 //x2=26.02 //y2=3.72
cc_1756 ( N_noxref_6_c_2154_p N_noxref_8_c_2850_n ) capacitor c=0.0025845f \
 //x=25.28 //y=2.26 //x2=26.02 //y2=3.72
cc_1757 ( N_noxref_6_c_2139_p N_noxref_8_c_2850_n ) capacitor c=0.00282067f \
 //x=25.28 //y=2.095 //x2=26.02 //y2=3.72
cc_1758 ( N_noxref_6_c_2122_p N_noxref_8_c_2861_n ) capacitor c=0.0148501f \
 //x=25.28 //y=4.75 //x2=26.02 //y2=4.04
cc_1759 ( N_noxref_6_c_2152_p N_noxref_8_c_2861_n ) capacitor c=0.00899533f \
 //x=26.235 //y=3.495 //x2=26.02 //y2=4.04
cc_1760 ( N_noxref_6_c_2122_p N_noxref_8_c_2863_n ) capacitor c=0.0416218f \
 //x=25.28 //y=4.75 //x2=26.02 //y2=5.25
cc_1761 ( N_noxref_6_c_2098_p N_noxref_8_c_2863_n ) capacitor c=0.00283621f \
 //x=29.35 //y=5.295 //x2=26.02 //y2=5.25
cc_1762 ( N_noxref_6_c_2124_p N_noxref_8_c_2863_n ) capacitor c=0.00131258f \
 //x=25.28 //y=4.88 //x2=26.02 //y2=5.25
cc_1763 ( N_noxref_6_c_2161_p N_noxref_8_c_2863_n ) capacitor c=0.00737085f \
 //x=25.28 //y=4.88 //x2=26.02 //y2=5.25
cc_1764 ( N_noxref_6_c_2146_p N_noxref_8_c_2867_n ) capacitor c=0.0014358f \
 //x=25.28 //y=3.35 //x2=27.87 //y2=3.72
cc_1765 ( N_noxref_6_c_2096_p N_noxref_8_c_2867_n ) capacitor c=0.00231203f \
 //x=29.35 //y=3.35 //x2=27.87 //y2=3.72
cc_1766 ( N_noxref_6_c_2164_p N_noxref_8_c_2867_n ) capacitor c=4.98743e-19 \
 //x=27.48 //y=3.51 //x2=27.87 //y2=3.72
cc_1767 ( N_noxref_6_c_2165_p N_noxref_8_c_2867_n ) capacitor c=0.0221518f \
 //x=28.08 //y=3.495 //x2=27.87 //y2=3.72
cc_1768 ( N_noxref_6_c_2166_p N_noxref_8_c_2867_n ) capacitor c=3.14213e-19 \
 //x=29.505 //y=3.51 //x2=27.87 //y2=3.72
cc_1769 ( N_noxref_6_c_2118_p N_noxref_8_c_2872_n ) capacitor c=7.23153e-19 \
 //x=27.99 //y=5.56 //x2=27.87 //y2=4.04
cc_1770 ( N_noxref_6_c_2164_p N_noxref_8_c_2872_n ) capacitor c=0.00229532f \
 //x=27.48 //y=3.51 //x2=27.87 //y2=4.04
cc_1771 ( N_noxref_6_c_2165_p N_noxref_8_c_2872_n ) capacitor c=0.00505309f \
 //x=28.08 //y=3.495 //x2=27.87 //y2=4.04
cc_1772 ( N_noxref_6_c_2170_p N_noxref_8_c_2872_n ) capacitor c=2.08455e-19 \
 //x=27.99 //y=5.56 //x2=27.87 //y2=4.04
cc_1773 ( N_noxref_6_c_2121_p N_noxref_8_c_2876_n ) capacitor c=6.86112e-19 \
 //x=25.28 //y=3.67 //x2=25.24 //y2=5.335
cc_1774 ( N_noxref_6_c_2122_p N_noxref_8_c_2876_n ) capacitor c=0.0228808f \
 //x=25.28 //y=4.75 //x2=25.24 //y2=5.335
cc_1775 ( N_noxref_6_c_2124_p N_noxref_8_c_2876_n ) capacitor c=0.00346456f \
 //x=25.28 //y=4.88 //x2=25.24 //y2=5.335
cc_1776 ( N_noxref_6_c_2161_p N_noxref_8_c_2876_n ) capacitor c=0.00203307f \
 //x=25.28 //y=4.88 //x2=25.24 //y2=5.335
cc_1777 ( N_noxref_6_c_2122_p N_noxref_8_c_2880_n ) capacitor c=6.03895e-19 \
 //x=25.28 //y=4.75 //x2=26.02 //y2=3.88
cc_1778 ( N_noxref_6_c_2118_p N_noxref_8_c_2881_n ) capacitor c=0.0117744f \
 //x=27.99 //y=5.56 //x2=27.87 //y2=4.88
cc_1779 ( N_noxref_6_c_2170_p N_noxref_8_c_2881_n ) capacitor c=0.00104426f \
 //x=27.99 //y=5.56 //x2=27.87 //y2=4.88
cc_1780 ( N_noxref_6_c_2122_p N_noxref_8_c_2883_n ) capacitor c=8.55722e-19 \
 //x=25.28 //y=4.75 //x2=27.872 //y2=4.74
cc_1781 ( N_noxref_6_c_2098_p N_noxref_8_c_2883_n ) capacitor c=0.00133619f \
 //x=29.35 //y=5.295 //x2=27.872 //y2=4.74
cc_1782 ( N_noxref_6_c_2152_p N_noxref_8_c_2885_n ) capacitor c=0.127135f \
 //x=26.235 //y=3.495 //x2=27.705 //y2=3.88
cc_1783 ( N_noxref_6_c_2164_p N_noxref_8_c_2885_n ) capacitor c=0.0107721f \
 //x=27.48 //y=3.51 //x2=27.705 //y2=3.88
cc_1784 ( N_noxref_6_c_2122_p N_noxref_8_c_2887_n ) capacitor c=0.00686853f \
 //x=25.28 //y=4.75 //x2=26.18 //y2=3.88
cc_1785 ( N_noxref_6_c_2152_p N_noxref_8_c_2887_n ) capacitor c=0.0358686f \
 //x=26.235 //y=3.495 //x2=26.18 //y2=3.88
cc_1786 ( N_noxref_6_c_2184_p N_noxref_8_c_2889_n ) capacitor c=0.0033292f \
 //x=29.35 //y=3.67 //x2=29.56 //y2=3.895
cc_1787 ( N_noxref_6_c_2098_p N_noxref_8_c_2889_n ) capacitor c=0.0226441f \
 //x=29.35 //y=5.295 //x2=29.56 //y2=3.895
cc_1788 ( N_noxref_6_c_2186_p N_noxref_8_c_2889_n ) capacitor c=0.129077f \
 //x=31.035 //y=3.505 //x2=29.56 //y2=3.895
cc_1789 ( N_noxref_6_c_2184_p N_noxref_8_c_2892_n ) capacitor c=0.00307263f \
 //x=29.35 //y=3.67 //x2=29.215 //y2=3.895
cc_1790 ( N_noxref_6_c_2098_p N_noxref_8_c_2892_n ) capacitor c=3.08624e-19 \
 //x=29.35 //y=5.295 //x2=29.215 //y2=3.895
cc_1791 ( N_noxref_6_c_2165_p N_noxref_8_c_2892_n ) capacitor c=0.0475486f \
 //x=28.08 //y=3.495 //x2=29.215 //y2=3.895
cc_1792 ( N_noxref_6_c_2166_p N_noxref_8_c_2892_n ) capacitor c=0.120788f \
 //x=29.505 //y=3.51 //x2=29.215 //y2=3.895
cc_1793 ( N_noxref_6_c_2101_p N_noxref_8_c_2896_n ) capacitor c=0.00342917f \
 //x=31.2 //y=3.665 //x2=30.81 //y2=3.88
cc_1794 ( N_noxref_6_c_2099_p N_noxref_8_c_2896_n ) capacitor c=3.32529e-19 \
 //x=31.202 //y=4.74 //x2=30.81 //y2=3.88
cc_1795 ( N_noxref_6_c_2111_p N_noxref_8_c_2896_n ) capacitor c=0.0358254f \
 //x=31.195 //y=3.505 //x2=30.81 //y2=3.88
cc_1796 ( N_noxref_6_c_2186_p N_noxref_8_c_2896_n ) capacitor c=0.0109335f \
 //x=31.035 //y=3.505 //x2=30.81 //y2=3.88
cc_1797 ( N_noxref_6_c_2101_p N_noxref_8_c_2900_n ) capacitor c=0.00251313f \
 //x=31.2 //y=3.665 //x2=31.41 //y2=3.89
cc_1798 ( N_noxref_6_c_2099_p N_noxref_8_c_2900_n ) capacitor c=0.0228906f \
 //x=31.202 //y=4.74 //x2=31.41 //y2=3.89
cc_1799 ( N_noxref_6_c_2122_p N_noxref_8_c_2902_n ) capacitor c=0.00217653f \
 //x=25.28 //y=4.75 //x2=25.24 //y2=5.56
cc_1800 ( N_noxref_6_c_2124_p N_noxref_8_c_2902_n ) capacitor c=0.00624059f \
 //x=25.28 //y=4.88 //x2=25.24 //y2=5.56
cc_1801 ( N_noxref_6_M76_noxref_g N_noxref_8_c_2902_n ) capacitor c=0.0178885f \
 //x=25.02 //y=6.2 //x2=25.24 //y2=5.56
cc_1802 ( N_noxref_6_M77_noxref_g N_noxref_8_c_2902_n ) capacitor c=0.0188608f \
 //x=25.46 //y=6.2 //x2=25.24 //y2=5.56
cc_1803 ( N_noxref_6_c_2161_p N_noxref_8_c_2902_n ) capacitor c=0.00375636f \
 //x=25.28 //y=4.88 //x2=25.24 //y2=5.56
cc_1804 ( N_noxref_6_c_2118_p N_noxref_8_c_2907_n ) capacitor c=0.00277154f \
 //x=27.99 //y=5.56 //x2=27.87 //y2=4.88
cc_1805 ( N_noxref_6_c_2170_p N_noxref_8_c_2907_n ) capacitor c=0.00377369f \
 //x=27.99 //y=5.56 //x2=27.87 //y2=4.88
cc_1806 ( N_noxref_6_c_2118_p N_noxref_8_M78_noxref_g ) capacitor \
 c=0.00201806f //x=27.99 //y=5.56 //x2=27.77 //y2=6.2
cc_1807 ( N_noxref_6_c_2170_p N_noxref_8_M78_noxref_g ) capacitor c=0.0158358f \
 //x=27.99 //y=5.56 //x2=27.77 //y2=6.2
cc_1808 ( N_noxref_6_c_2206_p N_noxref_8_M79_noxref_g ) capacitor \
 c=0.00889217f //x=28.755 //y=5.38 //x2=28.21 //y2=6.2
cc_1809 ( N_noxref_6_c_2118_p N_noxref_8_M79_noxref_g ) capacitor \
 c=0.00192712f //x=27.99 //y=5.56 //x2=28.21 //y2=6.2
cc_1810 ( N_noxref_6_c_2170_p N_noxref_8_M79_noxref_g ) capacitor c=0.0178987f \
 //x=27.99 //y=5.56 //x2=28.21 //y2=6.2
cc_1811 ( N_noxref_6_c_2118_p N_noxref_8_c_2914_n ) capacitor c=0.00189999f \
 //x=27.99 //y=5.56 //x2=27.87 //y2=4.88
cc_1812 ( N_noxref_6_c_2170_p N_noxref_8_c_2914_n ) capacitor c=0.0043218f \
 //x=27.99 //y=5.56 //x2=27.87 //y2=4.88
cc_1813 ( N_noxref_6_c_2128_p N_noxref_8_M15_noxref_d ) capacitor \
 c=0.00137165f //x=25.27 //y=1.095 //x2=25.345 //y2=1.095
cc_1814 ( N_noxref_6_c_2129_p N_noxref_8_M15_noxref_d ) capacitor \
 c=0.00237422f //x=25.27 //y=1.44 //x2=25.345 //y2=1.095
cc_1815 ( N_noxref_6_c_2130_p N_noxref_8_M15_noxref_d ) capacitor c=0.0020782f \
 //x=25.645 //y=0.94 //x2=25.345 //y2=1.095
cc_1816 ( N_noxref_6_c_2131_p N_noxref_8_M15_noxref_d ) capacitor \
 c=0.00356097f //x=25.645 //y=1.595 //x2=25.345 //y2=1.095
cc_1817 ( N_noxref_6_c_2132_p N_noxref_8_M15_noxref_d ) capacitor \
 c=0.00139206f //x=25.8 //y=1.095 //x2=25.345 //y2=1.095
cc_1818 ( N_noxref_6_c_2133_p N_noxref_8_M15_noxref_d ) capacitor \
 c=0.00237422f //x=25.8 //y=1.44 //x2=25.345 //y2=1.095
cc_1819 ( N_noxref_6_c_2146_p N_noxref_10_c_3591_n ) capacitor c=9.39105e-19 \
 //x=25.28 //y=3.35 //x2=23.06 //y2=4.095
cc_1820 ( N_noxref_6_c_2122_p N_noxref_10_c_3591_n ) capacitor c=7.99748e-19 \
 //x=25.28 //y=4.75 //x2=23.06 //y2=4.095
cc_1821 ( N_noxref_6_c_2122_p N_noxref_10_c_3592_n ) capacitor c=2.98698e-19 \
 //x=25.28 //y=4.75 //x2=23.06 //y2=4.755
cc_1822 ( N_noxref_6_c_2096_p N_noxref_10_c_3598_n ) capacitor c=0.00148873f \
 //x=29.35 //y=3.35 //x2=31.94 //y2=4.095
cc_1823 ( N_noxref_6_c_2098_p N_noxref_10_c_3598_n ) capacitor c=3.20827e-19 \
 //x=29.35 //y=5.295 //x2=31.94 //y2=4.095
cc_1824 ( N_noxref_6_c_2097_p N_noxref_10_c_3598_n ) capacitor c=0.0376092f \
 //x=31.2 //y=3.345 //x2=31.94 //y2=4.095
cc_1825 ( N_noxref_6_c_2101_p N_noxref_10_c_3598_n ) capacitor c=0.0146933f \
 //x=31.2 //y=3.665 //x2=31.94 //y2=4.095
cc_1826 ( N_noxref_6_c_2110_p N_noxref_10_c_3598_n ) capacitor c=5.57251e-19 \
 //x=31.2 //y=3.51 //x2=31.94 //y2=4.095
cc_1827 ( N_noxref_6_c_2099_p N_noxref_10_c_3598_n ) capacitor c=0.0171876f \
 //x=31.202 //y=4.74 //x2=31.94 //y2=4.095
cc_1828 ( N_noxref_6_c_2111_p N_noxref_10_c_3598_n ) capacitor c=0.00364775f \
 //x=31.195 //y=3.505 //x2=31.94 //y2=4.095
cc_1829 ( N_noxref_6_c_2227_p N_noxref_10_c_3598_n ) capacitor c=3.49899e-19 \
 //x=31.2 //y=2.26 //x2=31.94 //y2=4.095
cc_1830 ( N_noxref_6_c_2099_p N_noxref_10_c_3606_n ) capacitor c=0.0172847f \
 //x=31.202 //y=4.74 //x2=31.94 //y2=4.415
cc_1831 ( N_noxref_6_c_2098_p N_noxref_10_c_3607_n ) capacitor c=7.6298e-19 \
 //x=29.35 //y=5.295 //x2=31.94 //y2=4.735
cc_1832 ( N_noxref_6_c_2104_p N_noxref_10_c_3607_n ) capacitor c=0.0172958f \
 //x=31.2 //y=4.88 //x2=31.94 //y2=4.735
cc_1833 ( N_noxref_6_c_2099_p N_noxref_10_c_3607_n ) capacitor c=0.0114865f \
 //x=31.202 //y=4.74 //x2=31.94 //y2=4.735
cc_1834 ( N_noxref_6_c_2105_p N_noxref_10_c_3607_n ) capacitor c=7.25895e-19 \
 //x=31.2 //y=4.88 //x2=31.94 //y2=4.735
cc_1835 ( N_noxref_6_c_2108_p N_noxref_10_c_3607_n ) capacitor c=0.00200292f \
 //x=31.2 //y=4.88 //x2=31.94 //y2=4.735
cc_1836 ( N_noxref_6_c_2099_p N_noxref_10_c_3612_n ) capacitor c=6.89957e-19 \
 //x=31.202 //y=4.74 //x2=31.94 //y2=4.25
cc_1837 ( N_noxref_6_c_2235_p N_noxref_10_c_3613_n ) capacitor c=0.0205342f \
 //x=31.2 //y=2.26 //x2=31.94 //y2=2.26
cc_1838 ( N_noxref_6_c_2227_p N_noxref_10_c_3613_n ) capacitor c=5.16867e-19 \
 //x=31.2 //y=2.26 //x2=31.94 //y2=2.26
cc_1839 ( N_noxref_6_c_2237_p N_noxref_10_c_3613_n ) capacitor c=0.00167888f \
 //x=31.005 //y=2.095 //x2=31.94 //y2=2.26
cc_1840 ( N_noxref_6_c_2121_p N_noxref_10_c_3616_n ) capacitor c=0.0031669f \
 //x=25.28 //y=3.67 //x2=25.635 //y2=4.25
cc_1841 ( N_noxref_6_c_2122_p N_noxref_10_c_3616_n ) capacitor c=0.0245794f \
 //x=25.28 //y=4.75 //x2=25.635 //y2=4.25
cc_1842 ( N_noxref_6_c_2150_p N_noxref_10_c_3616_n ) capacitor c=0.0152263f \
 //x=25.635 //y=3.51 //x2=25.635 //y2=4.25
cc_1843 ( N_noxref_6_c_2151_p N_noxref_10_c_3616_n ) capacitor c=0.0156825f \
 //x=25.445 //y=3.51 //x2=25.635 //y2=4.25
cc_1844 ( N_noxref_6_c_2152_p N_noxref_10_c_3620_n ) capacitor c=0.0085696f \
 //x=26.235 //y=3.495 //x2=26.235 //y2=4.265
cc_1845 ( N_noxref_6_c_2164_p N_noxref_10_c_3621_n ) capacitor c=0.00581051f \
 //x=27.48 //y=3.51 //x2=27.48 //y2=4.25
cc_1846 ( N_noxref_6_c_2165_p N_noxref_10_c_3622_n ) capacitor c=0.00139876f \
 //x=28.08 //y=3.495 //x2=28.08 //y2=4.265
cc_1847 ( N_noxref_6_c_2098_p N_noxref_10_c_3623_n ) capacitor c=0.0232181f \
 //x=29.35 //y=5.295 //x2=32.105 //y2=4.25
cc_1848 ( N_noxref_6_c_2099_p N_noxref_10_c_3623_n ) capacitor c=0.0254145f \
 //x=31.202 //y=4.74 //x2=32.105 //y2=4.25
cc_1849 ( N_noxref_6_c_2166_p N_noxref_10_c_3623_n ) capacitor c=0.00966607f \
 //x=29.505 //y=3.51 //x2=32.105 //y2=4.25
cc_1850 ( N_noxref_6_c_2186_p N_noxref_10_c_3623_n ) capacitor c=0.0104609f \
 //x=31.035 //y=3.505 //x2=32.105 //y2=4.25
cc_1851 ( N_noxref_6_c_2097_p N_noxref_10_c_3627_n ) capacitor c=3.49899e-19 \
 //x=31.2 //y=3.345 //x2=31.94 //y2=2.26
cc_1852 ( N_noxref_6_c_2235_p N_noxref_10_c_3627_n ) capacitor c=5.24723e-19 \
 //x=31.2 //y=2.26 //x2=31.94 //y2=2.26
cc_1853 ( N_noxref_6_c_2227_p N_noxref_10_c_3627_n ) capacitor c=0.00525888f \
 //x=31.2 //y=2.26 //x2=31.94 //y2=2.26
cc_1854 ( N_noxref_6_c_2237_p N_noxref_10_c_3627_n ) capacitor c=0.00190888f \
 //x=31.005 //y=2.095 //x2=31.94 //y2=2.26
cc_1855 ( N_noxref_6_c_2104_p N_noxref_10_c_3631_n ) capacitor c=4.80626e-19 \
 //x=31.2 //y=4.88 //x2=31.97 //y2=4.88
cc_1856 ( N_noxref_6_c_2105_p N_noxref_10_c_3631_n ) capacitor c=0.00397338f \
 //x=31.2 //y=4.88 //x2=31.97 //y2=4.88
cc_1857 ( N_noxref_6_c_2108_p N_noxref_10_c_3631_n ) capacitor c=0.00283894f \
 //x=31.2 //y=4.88 //x2=31.97 //y2=4.88
cc_1858 ( N_noxref_6_M82_noxref_g N_noxref_10_M84_noxref_g ) capacitor \
 c=0.0104892f //x=31.1 //y=6.2 //x2=31.98 //y2=6.2
cc_1859 ( N_noxref_6_M83_noxref_g N_noxref_10_M84_noxref_g ) capacitor \
 c=0.107636f //x=31.54 //y=6.2 //x2=31.98 //y2=6.2
cc_1860 ( N_noxref_6_M83_noxref_g N_noxref_10_M85_noxref_g ) capacitor \
 c=0.0100341f //x=31.54 //y=6.2 //x2=32.42 //y2=6.2
cc_1861 ( N_noxref_6_c_2259_p N_noxref_10_c_3637_n ) capacitor c=4.86545e-19 \
 //x=31.005 //y=1.045 //x2=31.975 //y2=1.085
cc_1862 ( N_noxref_6_c_2260_p N_noxref_10_c_3637_n ) capacitor c=0.00152405f \
 //x=31.005 //y=1.39 //x2=31.975 //y2=1.085
cc_1863 ( N_noxref_6_c_2261_p N_noxref_10_c_3637_n ) capacitor c=0.0151475f \
 //x=31.535 //y=1.045 //x2=31.975 //y2=1.085
cc_1864 ( N_noxref_6_c_2262_p N_noxref_10_c_3640_n ) capacitor c=0.00109982f \
 //x=31.005 //y=1.7 //x2=31.975 //y2=1.43
cc_1865 ( N_noxref_6_c_2263_p N_noxref_10_c_3640_n ) capacitor c=0.0111064f \
 //x=31.535 //y=1.39 //x2=31.975 //y2=1.43
cc_1866 ( N_noxref_6_c_2262_p N_noxref_10_c_3642_n ) capacitor c=9.58243e-19 \
 //x=31.005 //y=1.7 //x2=31.975 //y2=1.74
cc_1867 ( N_noxref_6_c_2237_p N_noxref_10_c_3642_n ) capacitor c=0.00662747f \
 //x=31.005 //y=2.095 //x2=31.975 //y2=1.74
cc_1868 ( N_noxref_6_c_2263_p N_noxref_10_c_3642_n ) capacitor c=0.00862358f \
 //x=31.535 //y=1.39 //x2=31.975 //y2=1.74
cc_1869 ( N_noxref_6_c_2261_p N_noxref_10_c_3645_n ) capacitor c=0.00127211f \
 //x=31.535 //y=1.045 //x2=32.505 //y2=1.085
cc_1870 ( N_noxref_6_c_2263_p N_noxref_10_c_3646_n ) capacitor c=0.00204774f \
 //x=31.535 //y=1.39 //x2=32.505 //y2=1.43
cc_1871 ( N_noxref_6_c_2235_p N_noxref_10_c_3647_n ) capacitor c=0.00167305f \
 //x=31.2 //y=2.26 //x2=31.94 //y2=2.26
cc_1872 ( N_noxref_6_c_2227_p N_noxref_10_c_3647_n ) capacitor c=0.0018937f \
 //x=31.2 //y=2.26 //x2=31.94 //y2=2.26
cc_1873 ( N_noxref_6_c_2237_p N_noxref_10_c_3647_n ) capacitor c=0.0181449f \
 //x=31.005 //y=2.095 //x2=31.94 //y2=2.26
cc_1874 ( N_noxref_6_c_2104_p N_noxref_10_c_3650_n ) capacitor c=0.00158715f \
 //x=31.2 //y=4.88 //x2=31.97 //y2=4.88
cc_1875 ( N_noxref_6_c_2105_p N_noxref_10_c_3650_n ) capacitor c=0.00237977f \
 //x=31.2 //y=4.88 //x2=31.97 //y2=4.88
cc_1876 ( N_noxref_6_c_2108_p N_noxref_10_c_3650_n ) capacitor c=0.0297875f \
 //x=31.2 //y=4.88 //x2=31.97 //y2=4.88
cc_1877 ( N_noxref_6_c_2096_p D ) capacitor c=6.00744e-19 //x=29.35 //y=3.35 \
 //x2=28.61 //y2=2.77
cc_1878 ( N_noxref_6_c_2096_p N_D_c_4383_n ) capacitor c=0.00962989f //x=29.35 \
 //y=3.35 //x2=28.61 //y2=2.62
cc_1879 ( N_noxref_6_c_2097_p N_D_c_4383_n ) capacitor c=6.389e-19 //x=31.2 \
 //y=3.345 //x2=28.61 //y2=2.62
cc_1880 ( N_noxref_6_c_2206_p N_D_c_4385_n ) capacitor c=6.53949e-19 \
 //x=28.755 //y=5.38 //x2=28.61 //y2=2.94
cc_1881 ( N_noxref_6_c_2140_p N_D_c_4385_n ) capacitor c=0.00129986f \
 //x=28.995 //y=1.835 //x2=28.61 //y2=2.94
cc_1882 ( N_noxref_6_c_2096_p N_D_c_4385_n ) capacitor c=0.0171815f //x=29.35 \
 //y=3.35 //x2=28.61 //y2=2.94
cc_1883 ( N_noxref_6_c_2102_p N_D_c_4385_n ) capacitor c=0.00100543f //x=28.87 \
 //y=5.38 //x2=28.61 //y2=2.94
cc_1884 ( N_noxref_6_c_2109_p N_D_c_4385_n ) capacitor c=3.5828e-19 //x=28.91 \
 //y=1.18 //x2=28.61 //y2=2.94
cc_1885 ( N_noxref_6_c_2283_p N_D_c_4385_n ) capacitor c=2.14011e-19 //x=28.87 \
 //y=5.56 //x2=28.61 //y2=2.94
cc_1886 ( N_noxref_6_M17_noxref_d N_D_c_4385_n ) capacitor c=3.01409e-19 \
 //x=28.72 //y=1.085 //x2=28.61 //y2=2.94
cc_1887 ( N_noxref_6_c_2206_p N_D_c_4392_n ) capacitor c=0.0217631f //x=28.755 \
 //y=5.38 //x2=28.61 //y2=4.735
cc_1888 ( N_noxref_6_c_2096_p N_D_c_4392_n ) capacitor c=0.0161617f //x=29.35 \
 //y=3.35 //x2=28.61 //y2=4.735
cc_1889 ( N_noxref_6_c_2184_p N_D_c_4392_n ) capacitor c=0.0174172f //x=29.35 \
 //y=3.67 //x2=28.61 //y2=4.735
cc_1890 ( N_noxref_6_c_2098_p N_D_c_4392_n ) capacitor c=0.0566971f //x=29.35 \
 //y=5.295 //x2=28.61 //y2=4.735
cc_1891 ( N_noxref_6_c_2097_p N_D_c_4392_n ) capacitor c=3.34634e-19 //x=31.2 \
 //y=3.345 //x2=28.61 //y2=4.735
cc_1892 ( N_noxref_6_c_2290_p N_D_c_4392_n ) capacitor c=6.03895e-19 \
 //x=29.345 //y=3.51 //x2=28.61 //y2=4.735
cc_1893 ( N_noxref_6_c_2099_p N_D_c_4392_n ) capacitor c=0.00136917f \
 //x=31.202 //y=4.74 //x2=28.61 //y2=4.735
cc_1894 ( N_noxref_6_c_2166_p N_D_c_4392_n ) capacitor c=0.0225317f //x=29.505 \
 //y=3.51 //x2=28.61 //y2=4.735
cc_1895 ( N_noxref_6_c_2096_p N_D_c_4400_n ) capacitor c=0.015397f //x=29.35 \
 //y=3.35 //x2=28.61 //y2=2.26
cc_1896 ( N_noxref_6_c_2145_p N_D_c_4251_n ) capacitor c=0.00281235f //x=25.28 \
 //y=2.375 //x2=28.435 //y2=2.78
cc_1897 ( N_noxref_6_c_2146_p N_D_c_4251_n ) capacitor c=0.0258216f //x=25.28 \
 //y=3.35 //x2=28.435 //y2=2.78
cc_1898 ( N_noxref_6_c_2150_p N_D_c_4251_n ) capacitor c=0.00608668f \
 //x=25.635 //y=3.51 //x2=28.435 //y2=2.78
cc_1899 ( N_noxref_6_c_2152_p N_D_c_4251_n ) capacitor c=0.00670118f \
 //x=26.235 //y=3.495 //x2=28.435 //y2=2.78
cc_1900 ( N_noxref_6_c_2164_p N_D_c_4251_n ) capacitor c=0.00396499f //x=27.48 \
 //y=3.51 //x2=28.435 //y2=2.78
cc_1901 ( N_noxref_6_c_2166_p N_D_c_4251_n ) capacitor c=0.00207452f \
 //x=29.505 //y=3.51 //x2=28.435 //y2=2.78
cc_1902 ( N_noxref_6_c_2096_p N_D_c_4407_n ) capacitor c=0.00327175f //x=29.35 \
 //y=3.35 //x2=28.755 //y2=2.78
cc_1903 ( N_noxref_6_c_2140_p N_D_c_4408_n ) capacitor c=0.0119025f //x=28.995 \
 //y=1.835 //x2=49.91 //y2=2.755
cc_1904 ( N_noxref_6_c_2096_p N_D_c_4408_n ) capacitor c=0.0275454f //x=29.35 \
 //y=3.35 //x2=49.91 //y2=2.755
cc_1905 ( N_noxref_6_c_2097_p N_D_c_4408_n ) capacitor c=0.0270577f //x=31.2 \
 //y=3.345 //x2=49.91 //y2=2.755
cc_1906 ( N_noxref_6_c_2109_p N_D_c_4408_n ) capacitor c=3.52789e-19 //x=28.91 \
 //y=1.18 //x2=49.91 //y2=2.755
cc_1907 ( N_noxref_6_c_2235_p N_D_c_4408_n ) capacitor c=0.00331451f //x=31.2 \
 //y=2.26 //x2=49.91 //y2=2.755
cc_1908 ( N_noxref_6_c_2166_p N_D_c_4408_n ) capacitor c=0.00269884f \
 //x=29.505 //y=3.51 //x2=49.91 //y2=2.755
cc_1909 ( N_noxref_6_c_2186_p N_D_c_4408_n ) capacitor c=0.00822736f \
 //x=31.035 //y=3.505 //x2=49.91 //y2=2.755
cc_1910 ( N_noxref_6_c_2096_p N_D_c_4415_n ) capacitor c=9.90728e-19 //x=29.35 \
 //y=3.35 //x2=28.61 //y2=2.26
cc_1911 ( N_noxref_6_c_2206_p N_D_c_4416_n ) capacitor c=0.00469257f \
 //x=28.755 //y=5.38 //x2=28.64 //y2=4.88
cc_1912 ( N_noxref_6_c_2098_p N_D_c_4416_n ) capacitor c=7.76118e-19 //x=29.35 \
 //y=5.295 //x2=28.64 //y2=4.88
cc_1913 ( N_noxref_6_c_2206_p N_D_M80_noxref_g ) capacitor c=0.00842859f \
 //x=28.755 //y=5.38 //x2=28.65 //y2=6.2
cc_1914 ( N_noxref_6_c_2102_p N_D_M80_noxref_g ) capacitor c=0.00192712f \
 //x=28.87 //y=5.38 //x2=28.65 //y2=6.2
cc_1915 ( N_noxref_6_c_2283_p N_D_M80_noxref_g ) capacitor c=0.0178987f \
 //x=28.87 //y=5.56 //x2=28.65 //y2=6.2
cc_1916 ( N_noxref_6_c_2100_p N_D_M81_noxref_g ) capacitor c=0.0107429f \
 //x=29.265 //y=5.38 //x2=29.09 //y2=6.2
cc_1917 ( N_noxref_6_c_2102_p N_D_M81_noxref_g ) capacitor c=0.00298276f \
 //x=28.87 //y=5.38 //x2=29.09 //y2=6.2
cc_1918 ( N_noxref_6_c_2283_p N_D_M81_noxref_g ) capacitor c=0.0178506f \
 //x=28.87 //y=5.56 //x2=29.09 //y2=6.2
cc_1919 ( N_noxref_6_c_2109_p N_D_c_4424_n ) capacitor c=0.00120406f //x=28.91 \
 //y=1.18 //x2=28.645 //y2=1.085
cc_1920 ( N_noxref_6_M17_noxref_d N_D_c_4424_n ) capacitor c=0.00137165f \
 //x=28.72 //y=1.085 //x2=28.645 //y2=1.085
cc_1921 ( N_noxref_6_c_2094_p N_D_c_4426_n ) capacitor c=0.00119302f //x=28.91 \
 //y=1.75 //x2=28.645 //y2=1.43
cc_1922 ( N_noxref_6_c_2109_p N_D_c_4426_n ) capacitor c=0.00218772f //x=28.91 \
 //y=1.18 //x2=28.645 //y2=1.43
cc_1923 ( N_noxref_6_M17_noxref_d N_D_c_4426_n ) capacitor c=0.00237422f \
 //x=28.72 //y=1.085 //x2=28.645 //y2=1.43
cc_1924 ( N_noxref_6_c_2094_p N_D_c_4429_n ) capacitor c=0.00450635f //x=28.91 \
 //y=1.75 //x2=28.645 //y2=1.74
cc_1925 ( N_noxref_6_c_2098_p N_D_c_4430_n ) capacitor c=0.00845606f //x=29.35 \
 //y=5.295 //x2=29.015 //y2=4.97
cc_1926 ( N_noxref_6_c_2102_p N_D_c_4430_n ) capacitor c=0.00201269f //x=28.87 \
 //y=5.38 //x2=29.015 //y2=4.97
cc_1927 ( N_noxref_6_c_2283_p N_D_c_4430_n ) capacitor c=0.00291714f //x=28.87 \
 //y=5.56 //x2=29.015 //y2=4.97
cc_1928 ( N_noxref_6_c_2109_p N_D_c_4433_n ) capacitor c=5.50523e-19 //x=28.91 \
 //y=1.18 //x2=29.02 //y2=0.93
cc_1929 ( N_noxref_6_M17_noxref_d N_D_c_4433_n ) capacitor c=0.0020782f \
 //x=28.72 //y=1.085 //x2=29.02 //y2=0.93
cc_1930 ( N_noxref_6_c_2094_p N_D_c_4435_n ) capacitor c=0.00917366f //x=28.91 \
 //y=1.75 //x2=29.02 //y2=1.585
cc_1931 ( N_noxref_6_c_2095_p N_D_c_4435_n ) capacitor c=0.00194324f \
 //x=29.265 //y=1.835 //x2=29.02 //y2=1.585
cc_1932 ( N_noxref_6_c_2109_p N_D_c_4435_n ) capacitor c=4.66519e-19 //x=28.91 \
 //y=1.18 //x2=29.02 //y2=1.585
cc_1933 ( N_noxref_6_M17_noxref_d N_D_c_4435_n ) capacitor c=0.00356097f \
 //x=28.72 //y=1.085 //x2=29.02 //y2=1.585
cc_1934 ( N_noxref_6_c_2109_p N_D_c_4439_n ) capacitor c=0.00109205f //x=28.91 \
 //y=1.18 //x2=29.175 //y2=1.085
cc_1935 ( N_noxref_6_M17_noxref_d N_D_c_4439_n ) capacitor c=8.50095e-19 \
 //x=28.72 //y=1.085 //x2=29.175 //y2=1.085
cc_1936 ( N_noxref_6_c_2094_p N_D_c_4441_n ) capacitor c=0.003249f //x=28.91 \
 //y=1.75 //x2=29.175 //y2=1.43
cc_1937 ( N_noxref_6_c_2095_p N_D_c_4441_n ) capacitor c=0.00323005f \
 //x=29.265 //y=1.835 //x2=29.175 //y2=1.43
cc_1938 ( N_noxref_6_c_2109_p N_D_c_4441_n ) capacitor c=0.00317092f //x=28.91 \
 //y=1.18 //x2=29.175 //y2=1.43
cc_1939 ( N_noxref_6_M17_noxref_d N_D_c_4441_n ) capacitor c=0.00237422f \
 //x=28.72 //y=1.085 //x2=29.175 //y2=1.43
cc_1940 ( N_noxref_6_c_2096_p N_D_c_4445_n ) capacitor c=0.00281392f //x=29.35 \
 //y=3.35 //x2=28.61 //y2=2.26
cc_1941 ( N_noxref_6_c_2094_p N_D_c_4446_n ) capacitor c=0.00341688f //x=28.91 \
 //y=1.75 //x2=28.61 //y2=2.095
cc_1942 ( N_noxref_6_c_2096_p N_D_c_4446_n ) capacitor c=0.00309058f //x=29.35 \
 //y=3.35 //x2=28.61 //y2=2.095
cc_1943 ( N_noxref_6_c_2206_p N_D_c_4448_n ) capacitor c=9.44863e-19 \
 //x=28.755 //y=5.38 //x2=28.64 //y2=4.88
cc_1944 ( N_noxref_6_c_2098_p N_D_c_4448_n ) capacitor c=0.00142201f //x=29.35 \
 //y=5.295 //x2=28.64 //y2=4.88
cc_1945 ( N_noxref_6_c_2146_p CLK ) capacitor c=0.0228508f //x=25.28 //y=3.35 \
 //x2=24.17 //y2=3.51
cc_1946 ( N_noxref_6_c_2121_p CLK ) capacitor c=0.00769355f //x=25.28 //y=3.67 \
 //x2=24.17 //y2=3.51
cc_1947 ( N_noxref_6_c_2122_p CLK ) capacitor c=0.0251266f //x=25.28 //y=4.75 \
 //x2=24.17 //y2=3.51
cc_1948 ( N_noxref_6_c_2149_p CLK ) capacitor c=3.35971e-19 //x=25.28 //y=3.51 \
 //x2=24.17 //y2=3.51
cc_1949 ( N_noxref_6_c_2151_p CLK ) capacitor c=0.00507285f //x=25.445 \
 //y=3.51 //x2=24.17 //y2=3.51
cc_1950 ( N_noxref_6_c_2153_p CLK ) capacitor c=4.16726e-19 //x=25.28 //y=2.26 \
 //x2=24.17 //y2=3.51
cc_1951 ( N_noxref_6_c_2145_p N_CLK_c_5845_n ) capacitor c=0.0116288f \
 //x=25.28 //y=2.375 //x2=24.17 //y2=2.375
cc_1952 ( N_noxref_6_c_2153_p N_CLK_c_5845_n ) capacitor c=5.42289e-19 \
 //x=25.28 //y=2.26 //x2=24.17 //y2=2.375
cc_1953 ( N_noxref_6_c_2154_p N_CLK_c_5845_n ) capacitor c=0.00139071f \
 //x=25.28 //y=2.26 //x2=24.17 //y2=2.375
cc_1954 ( N_noxref_6_c_2122_p N_CLK_c_5848_n ) capacitor c=0.00713797f \
 //x=25.28 //y=4.75 //x2=24.17 //y2=4.88
cc_1955 ( N_noxref_6_c_2124_p N_CLK_c_5848_n ) capacitor c=6.80672e-19 \
 //x=25.28 //y=4.88 //x2=24.17 //y2=4.88
cc_1956 ( N_noxref_6_c_2161_p N_CLK_c_5848_n ) capacitor c=0.00153715f \
 //x=25.28 //y=4.88 //x2=24.17 //y2=4.88
cc_1957 ( N_noxref_6_c_2122_p N_CLK_c_5851_n ) capacitor c=0.00731957f \
 //x=25.28 //y=4.75 //x2=24.17 //y2=4.88
cc_1958 ( N_noxref_6_c_2122_p N_CLK_c_5852_n ) capacitor c=0.0290946f \
 //x=25.28 //y=4.75 //x2=31.815 //y2=4.64
cc_1959 ( N_noxref_6_c_2098_p N_CLK_c_5852_n ) capacitor c=0.0287614f \
 //x=29.35 //y=5.295 //x2=31.815 //y2=4.64
cc_1960 ( N_noxref_6_c_2118_p N_CLK_c_5852_n ) capacitor c=0.0224586f \
 //x=27.99 //y=5.56 //x2=31.815 //y2=4.64
cc_1961 ( N_noxref_6_c_2102_p N_CLK_c_5852_n ) capacitor c=0.0204298f \
 //x=28.87 //y=5.38 //x2=31.815 //y2=4.64
cc_1962 ( N_noxref_6_c_2104_p N_CLK_c_5852_n ) capacitor c=0.00405241f \
 //x=31.2 //y=4.88 //x2=31.815 //y2=4.64
cc_1963 ( N_noxref_6_c_2099_p N_CLK_c_5852_n ) capacitor c=0.0272672f \
 //x=31.202 //y=4.74 //x2=31.815 //y2=4.64
cc_1964 ( N_noxref_6_c_2150_p N_CLK_c_5852_n ) capacitor c=0.0020739f \
 //x=25.635 //y=3.51 //x2=31.815 //y2=4.64
cc_1965 ( N_noxref_6_c_2145_p N_CLK_c_5859_n ) capacitor c=5.39999e-19 \
 //x=25.28 //y=2.375 //x2=24.17 //y2=2.26
cc_1966 ( N_noxref_6_c_2146_p N_CLK_c_5859_n ) capacitor c=4.16726e-19 \
 //x=25.28 //y=3.35 //x2=24.17 //y2=2.26
cc_1967 ( N_noxref_6_c_2153_p N_CLK_c_5859_n ) capacitor c=0.00125213f \
 //x=25.28 //y=2.26 //x2=24.17 //y2=2.26
cc_1968 ( N_noxref_6_c_2154_p N_CLK_c_5859_n ) capacitor c=0.00204868f \
 //x=25.28 //y=2.26 //x2=24.17 //y2=2.26
cc_1969 ( N_noxref_6_c_2122_p N_CLK_c_5863_n ) capacitor c=2.50728e-19 \
 //x=25.28 //y=4.75 //x2=24.17 //y2=4.88
cc_1970 ( N_noxref_6_c_2124_p N_CLK_c_5863_n ) capacitor c=0.00114249f \
 //x=25.28 //y=4.88 //x2=24.17 //y2=4.88
cc_1971 ( N_noxref_6_c_2161_p N_CLK_c_5863_n ) capacitor c=0.00195911f \
 //x=25.28 //y=4.88 //x2=24.17 //y2=4.88
cc_1972 ( N_noxref_6_M76_noxref_g N_CLK_M74_noxref_g ) capacitor c=0.0101598f \
 //x=25.02 //y=6.2 //x2=24.14 //y2=6.2
cc_1973 ( N_noxref_6_M76_noxref_g N_CLK_M75_noxref_g ) capacitor c=0.0607232f \
 //x=25.02 //y=6.2 //x2=24.58 //y2=6.2
cc_1974 ( N_noxref_6_M77_noxref_g N_CLK_M75_noxref_g ) capacitor c=0.0101598f \
 //x=25.46 //y=6.2 //x2=24.58 //y2=6.2
cc_1975 ( N_noxref_6_c_2128_p N_CLK_c_5869_n ) capacitor c=0.00456962f \
 //x=25.27 //y=1.095 //x2=24.26 //y2=1.09
cc_1976 ( N_noxref_6_c_2129_p N_CLK_c_5870_n ) capacitor c=0.00438372f \
 //x=25.27 //y=1.44 //x2=24.26 //y2=1.4
cc_1977 ( N_noxref_6_c_2136_p N_CLK_c_5871_n ) capacitor c=0.00438372f \
 //x=25.27 //y=1.75 //x2=24.26 //y2=1.63
cc_1978 ( N_noxref_6_c_2145_p N_CLK_c_5872_n ) capacitor c=0.00141236f \
 //x=25.28 //y=2.375 //x2=24.26 //y2=2.095
cc_1979 ( N_noxref_6_c_2153_p N_CLK_c_5872_n ) capacitor c=0.00209664f \
 //x=25.28 //y=2.26 //x2=24.26 //y2=2.095
cc_1980 ( N_noxref_6_c_2154_p N_CLK_c_5872_n ) capacitor c=0.00933826f \
 //x=25.28 //y=2.26 //x2=24.26 //y2=2.095
cc_1981 ( N_noxref_6_c_2139_p N_CLK_c_5872_n ) capacitor c=0.00438372f \
 //x=25.28 //y=2.095 //x2=24.26 //y2=2.095
cc_1982 ( N_noxref_6_c_2161_p N_CLK_c_5876_n ) capacitor c=0.0616491f \
 //x=25.28 //y=4.88 //x2=24.505 //y2=4.97
cc_1983 ( N_noxref_6_c_2124_p N_CLK_c_5877_n ) capacitor c=9.8646e-19 \
 //x=25.28 //y=4.88 //x2=24.17 //y2=4.88
cc_1984 ( N_noxref_6_c_2161_p N_CLK_c_5877_n ) capacitor c=0.00428612f \
 //x=25.28 //y=4.88 //x2=24.17 //y2=4.88
cc_1985 ( N_noxref_6_c_2146_p N_noxref_20_c_9316_n ) capacitor c=0.0216209f \
 //x=25.28 //y=3.35 //x2=25.5 //y2=3.125
cc_1986 ( N_noxref_6_c_2121_p N_noxref_20_c_9316_n ) capacitor c=0.00571354f \
 //x=25.28 //y=3.67 //x2=25.5 //y2=3.125
cc_1987 ( N_noxref_6_c_2150_p N_noxref_20_c_9316_n ) capacitor c=0.0509733f \
 //x=25.635 //y=3.51 //x2=25.5 //y2=3.125
cc_1988 ( N_noxref_6_c_2151_p N_noxref_20_c_9316_n ) capacitor c=0.0358686f \
 //x=25.445 //y=3.51 //x2=25.5 //y2=3.125
cc_1989 ( N_noxref_6_c_2146_p N_noxref_20_c_9305_n ) capacitor c=3.81384e-19 \
 //x=25.28 //y=3.35 //x2=25.07 //y2=3.125
cc_1990 ( N_noxref_6_c_2152_p N_noxref_20_c_9321_n ) capacitor c=0.139639f \
 //x=26.235 //y=3.495 //x2=28.21 //y2=3.14
cc_1991 ( N_noxref_6_c_2164_p N_noxref_20_c_9321_n ) capacitor c=0.0564342f \
 //x=27.48 //y=3.51 //x2=28.21 //y2=3.14
cc_1992 ( N_noxref_6_c_2166_p N_noxref_20_c_9321_n ) capacitor c=0.0688878f \
 //x=29.505 //y=3.51 //x2=28.21 //y2=3.14
cc_1993 ( N_noxref_6_c_2096_p N_noxref_20_c_9324_n ) capacitor c=0.00146612f \
 //x=29.35 //y=3.35 //x2=28.81 //y2=3.165
cc_1994 ( N_noxref_6_c_2184_p N_noxref_20_c_9324_n ) capacitor c=0.0015441f \
 //x=29.35 //y=3.67 //x2=28.81 //y2=3.165
cc_1995 ( N_noxref_6_c_2166_p N_noxref_20_c_9324_n ) capacitor c=0.0237056f \
 //x=29.505 //y=3.51 //x2=28.81 //y2=3.165
cc_1996 ( N_noxref_6_c_2096_p N_noxref_20_c_9327_n ) capacitor c=0.0224803f \
 //x=29.35 //y=3.35 //x2=29.56 //y2=3.125
cc_1997 ( N_noxref_6_c_2184_p N_noxref_20_c_9327_n ) capacitor c=0.00465261f \
 //x=29.35 //y=3.67 //x2=29.56 //y2=3.125
cc_1998 ( N_noxref_6_c_2166_p N_noxref_20_c_9327_n ) capacitor c=0.0358686f \
 //x=29.505 //y=3.51 //x2=29.56 //y2=3.125
cc_1999 ( N_noxref_6_c_2186_p N_noxref_20_c_9327_n ) capacitor c=0.129061f \
 //x=31.035 //y=3.505 //x2=29.56 //y2=3.125
cc_2000 ( N_noxref_6_c_2097_p N_noxref_20_c_9331_n ) capacitor c=6.53642e-19 \
 //x=31.2 //y=3.345 //x2=30.81 //y2=3.14
cc_2001 ( N_noxref_6_c_2101_p N_noxref_20_c_9331_n ) capacitor c=0.00223215f \
 //x=31.2 //y=3.665 //x2=30.81 //y2=3.14
cc_2002 ( N_noxref_6_c_2186_p N_noxref_20_c_9331_n ) capacitor c=0.0106514f \
 //x=31.035 //y=3.505 //x2=30.81 //y2=3.14
cc_2003 ( N_noxref_6_c_2097_p N_noxref_20_c_9334_n ) capacitor c=0.0224868f \
 //x=31.2 //y=3.345 //x2=31.41 //y2=3.12
cc_2004 ( N_noxref_6_c_2101_p N_noxref_20_c_9334_n ) capacitor c=0.00491263f \
 //x=31.2 //y=3.665 //x2=31.41 //y2=3.12
cc_2005 ( N_noxref_6_c_2111_p N_noxref_20_c_9334_n ) capacitor c=0.0358686f \
 //x=31.195 //y=3.505 //x2=31.41 //y2=3.12
cc_2006 ( N_noxref_6_c_2206_p N_VDD_c_10241_n ) capacitor c=0.00648307f \
 //x=28.755 //y=5.38 //x2=65.575 //y2=7.585
cc_2007 ( N_noxref_6_c_2100_p N_VDD_c_10241_n ) capacitor c=0.00492578f \
 //x=29.265 //y=5.38 //x2=65.575 //y2=7.585
cc_2008 ( N_noxref_6_c_2101_p N_VDD_c_10241_n ) capacitor c=2.0049e-19 \
 //x=31.2 //y=3.665 //x2=65.575 //y2=7.585
cc_2009 ( N_noxref_6_c_2118_p N_VDD_c_10241_n ) capacitor c=0.00368834f \
 //x=27.99 //y=5.56 //x2=65.575 //y2=7.585
cc_2010 ( N_noxref_6_c_2102_p N_VDD_c_10241_n ) capacitor c=8.42709e-19 \
 //x=28.87 //y=5.38 //x2=65.575 //y2=7.585
cc_2011 ( N_noxref_6_c_2103_p N_VDD_c_10241_n ) capacitor c=0.00285853f \
 //x=28.87 //y=5.56 //x2=65.575 //y2=7.585
cc_2012 ( N_noxref_6_c_2104_p N_VDD_c_10241_n ) capacitor c=9.07241e-19 \
 //x=31.2 //y=4.88 //x2=65.575 //y2=7.585
cc_2013 ( N_noxref_6_c_2170_p N_VDD_c_10241_n ) capacitor c=0.00224881f \
 //x=27.99 //y=5.56 //x2=65.575 //y2=7.585
cc_2014 ( N_noxref_6_c_2283_p N_VDD_c_10241_n ) capacitor c=0.00224881f \
 //x=28.87 //y=5.56 //x2=65.575 //y2=7.585
cc_2015 ( N_noxref_6_c_2105_p N_VDD_c_10241_n ) capacitor c=6.22888e-19 \
 //x=31.2 //y=4.88 //x2=65.575 //y2=7.585
cc_2016 ( N_noxref_6_M76_noxref_g N_VDD_c_10557_n ) capacitor c=0.00755544f \
 //x=25.02 //y=6.2 //x2=25.595 //y2=7.585
cc_2017 ( N_noxref_6_M77_noxref_g N_VDD_c_10557_n ) capacitor c=0.00755754f \
 //x=25.46 //y=6.2 //x2=25.595 //y2=7.585
cc_2018 ( N_noxref_6_c_2206_p N_VDD_c_10559_n ) capacitor c=0.00208087f \
 //x=28.755 //y=5.38 //x2=28.345 //y2=7.585
cc_2019 ( N_noxref_6_c_2118_p N_VDD_c_10559_n ) capacitor c=9.41185e-19 \
 //x=27.99 //y=5.56 //x2=28.345 //y2=7.585
cc_2020 ( N_noxref_6_c_2170_p N_VDD_c_10559_n ) capacitor c=0.0136705f \
 //x=27.99 //y=5.56 //x2=28.345 //y2=7.585
cc_2021 ( N_noxref_6_c_2206_p N_VDD_c_10562_n ) capacitor c=0.00180737f \
 //x=28.755 //y=5.38 //x2=29.225 //y2=7.585
cc_2022 ( N_noxref_6_c_2100_p N_VDD_c_10562_n ) capacitor c=0.00208087f \
 //x=29.265 //y=5.38 //x2=29.225 //y2=7.585
cc_2023 ( N_noxref_6_c_2102_p N_VDD_c_10562_n ) capacitor c=4.23719e-19 \
 //x=28.87 //y=5.38 //x2=29.225 //y2=7.585
cc_2024 ( N_noxref_6_c_2103_p N_VDD_c_10562_n ) capacitor c=5.77976e-19 \
 //x=28.87 //y=5.56 //x2=29.225 //y2=7.585
cc_2025 ( N_noxref_6_c_2283_p N_VDD_c_10562_n ) capacitor c=0.0136705f \
 //x=28.87 //y=5.56 //x2=29.225 //y2=7.585
cc_2026 ( N_noxref_6_c_2104_p N_VDD_c_10567_n ) capacitor c=6.28113e-19 \
 //x=31.2 //y=4.88 //x2=31.675 //y2=7.585
cc_2027 ( N_noxref_6_M82_noxref_g N_VDD_c_10567_n ) capacitor c=0.00732618f \
 //x=31.1 //y=6.2 //x2=31.675 //y2=7.585
cc_2028 ( N_noxref_6_M83_noxref_g N_VDD_c_10567_n ) capacitor c=0.00755544f \
 //x=31.54 //y=6.2 //x2=31.675 //y2=7.585
cc_2029 ( N_noxref_6_c_2098_p N_VDD_c_10570_n ) capacitor c=0.0013228f \
 //x=29.35 //y=5.295 //x2=26.76 //y2=7.585
cc_2030 ( N_noxref_6_c_2118_p N_VDD_c_10570_n ) capacitor c=4.91377e-19 \
 //x=27.99 //y=5.56 //x2=26.76 //y2=7.585
cc_2031 ( N_noxref_6_c_2124_p N_VDD_c_10570_n ) capacitor c=0.00224736f \
 //x=25.28 //y=4.88 //x2=26.76 //y2=7.585
cc_2032 ( N_noxref_6_c_2170_p N_VDD_c_10570_n ) capacitor c=0.0064135f \
 //x=27.99 //y=5.56 //x2=26.76 //y2=7.585
cc_2033 ( N_noxref_6_c_2161_p N_VDD_c_10570_n ) capacitor c=2.63786e-19 \
 //x=25.28 //y=4.88 //x2=26.76 //y2=7.585
cc_2034 ( N_noxref_6_c_2098_p N_VDD_c_10575_n ) capacitor c=0.0291261f \
 //x=29.35 //y=5.295 //x2=30.09 //y2=7.585
cc_2035 ( N_noxref_6_c_2102_p N_VDD_c_10575_n ) capacitor c=0.00240948f \
 //x=28.87 //y=5.38 //x2=30.09 //y2=7.585
cc_2036 ( N_noxref_6_c_2103_p N_VDD_c_10575_n ) capacitor c=4.09141e-19 \
 //x=28.87 //y=5.56 //x2=30.09 //y2=7.585
cc_2037 ( N_noxref_6_c_2104_p N_VDD_c_10575_n ) capacitor c=0.00447349f \
 //x=31.2 //y=4.88 //x2=30.09 //y2=7.585
cc_2038 ( N_noxref_6_c_2099_p N_VDD_c_10575_n ) capacitor c=0.00564116f \
 //x=31.202 //y=4.74 //x2=30.09 //y2=7.585
cc_2039 ( N_noxref_6_c_2283_p N_VDD_c_10575_n ) capacitor c=0.0101861f \
 //x=28.87 //y=5.56 //x2=30.09 //y2=7.585
cc_2040 ( N_noxref_6_c_2105_p N_VDD_c_10575_n ) capacitor c=0.00370494f \
 //x=31.2 //y=4.88 //x2=30.09 //y2=7.585
cc_2041 ( N_noxref_6_c_2108_p N_VDD_c_10575_n ) capacitor c=0.0129564f \
 //x=31.2 //y=4.88 //x2=30.09 //y2=7.585
cc_2042 ( N_noxref_6_M76_noxref_g N_VDD_M75_noxref_d ) capacitor c=0.015318f \
 //x=25.02 //y=6.2 //x2=24.655 //y2=5.2
cc_2043 ( N_noxref_6_M77_noxref_g N_VDD_M77_noxref_d ) capacitor c=0.0394719f \
 //x=25.46 //y=6.2 //x2=25.535 //y2=5.2
cc_2044 ( N_noxref_6_c_2118_p N_VDD_M78_noxref_s ) capacitor c=0.0611368f \
 //x=27.99 //y=5.56 //x2=27.415 //y2=5.2
cc_2045 ( N_noxref_6_c_2102_p N_VDD_M78_noxref_s ) capacitor c=6.52457e-19 \
 //x=28.87 //y=5.38 //x2=27.415 //y2=5.2
cc_2046 ( N_noxref_6_c_2170_p N_VDD_M78_noxref_s ) capacitor c=0.0887533f \
 //x=27.99 //y=5.56 //x2=27.415 //y2=5.2
cc_2047 ( N_noxref_6_c_2206_p N_VDD_M79_noxref_d ) capacitor c=0.00734094f \
 //x=28.755 //y=5.38 //x2=28.285 //y2=5.2
cc_2048 ( N_noxref_6_c_2118_p N_VDD_M79_noxref_d ) capacitor c=0.0043528f \
 //x=27.99 //y=5.56 //x2=28.285 //y2=5.2
cc_2049 ( N_noxref_6_c_2103_p N_VDD_M79_noxref_d ) capacitor c=0.0043528f \
 //x=28.87 //y=5.56 //x2=28.285 //y2=5.2
cc_2050 ( N_noxref_6_c_2170_p N_VDD_M79_noxref_d ) capacitor c=0.065554f \
 //x=27.99 //y=5.56 //x2=28.285 //y2=5.2
cc_2051 ( N_noxref_6_c_2283_p N_VDD_M79_noxref_d ) capacitor c=0.065554f \
 //x=28.87 //y=5.56 //x2=28.285 //y2=5.2
cc_2052 ( N_noxref_6_c_2100_p N_VDD_M81_noxref_d ) capacitor c=0.00934027f \
 //x=29.265 //y=5.38 //x2=29.165 //y2=5.2
cc_2053 ( N_noxref_6_c_2103_p N_VDD_M81_noxref_d ) capacitor c=0.00587834f \
 //x=28.87 //y=5.56 //x2=29.165 //y2=5.2
cc_2054 ( N_noxref_6_c_2290_p N_VDD_M81_noxref_d ) capacitor c=9.65951e-19 \
 //x=29.345 //y=3.51 //x2=29.165 //y2=5.2
cc_2055 ( N_noxref_6_c_2283_p N_VDD_M81_noxref_d ) capacitor c=0.065554f \
 //x=28.87 //y=5.56 //x2=29.165 //y2=5.2
cc_2056 ( N_noxref_6_c_2100_p N_VDD_M82_noxref_s ) capacitor c=0.00326953f \
 //x=29.265 //y=5.38 //x2=30.745 //y2=5.2
cc_2057 ( N_noxref_6_c_2101_p N_VDD_M82_noxref_s ) capacitor c=0.00111268f \
 //x=31.2 //y=3.665 //x2=30.745 //y2=5.2
cc_2058 ( N_noxref_6_c_2102_p N_VDD_M82_noxref_s ) capacitor c=0.00515461f \
 //x=28.87 //y=5.38 //x2=30.745 //y2=5.2
cc_2059 ( N_noxref_6_c_2103_p N_VDD_M82_noxref_s ) capacitor c=3.28075e-19 \
 //x=28.87 //y=5.56 //x2=30.745 //y2=5.2
cc_2060 ( N_noxref_6_M82_noxref_g N_VDD_M82_noxref_s ) capacitor c=0.0567929f \
 //x=31.1 //y=6.2 //x2=30.745 //y2=5.2
cc_2061 ( N_noxref_6_M83_noxref_g N_VDD_M83_noxref_d ) capacitor c=0.015318f \
 //x=31.54 //y=6.2 //x2=31.615 //y2=5.2
cc_2062 ( N_noxref_6_c_2145_p N_noxref_24_c_11720_n ) capacitor c=0.00177186f \
 //x=25.28 //y=2.375 //x2=25.935 //y2=0.72
cc_2063 ( N_noxref_6_c_2153_p N_noxref_24_c_11720_n ) capacitor c=0.00117306f \
 //x=25.28 //y=2.26 //x2=25.935 //y2=0.72
cc_2064 ( N_noxref_6_c_2128_p N_noxref_24_c_11720_n ) capacitor c=0.0206349f \
 //x=25.27 //y=1.095 //x2=25.935 //y2=0.72
cc_2065 ( N_noxref_6_c_2132_p N_noxref_24_c_11720_n ) capacitor c=0.00825432f \
 //x=25.8 //y=1.095 //x2=25.935 //y2=0.72
cc_2066 ( N_noxref_6_c_2154_p N_noxref_24_c_11720_n ) capacitor c=2.20712e-19 \
 //x=25.28 //y=2.26 //x2=25.935 //y2=0.72
cc_2067 ( N_noxref_6_c_2129_p N_noxref_24_c_11725_n ) capacitor c=0.0071177f \
 //x=25.27 //y=1.44 //x2=25.05 //y2=1.175
cc_2068 ( N_noxref_6_c_2128_p N_noxref_24_M15_noxref_s ) capacitor \
 c=0.0071177f //x=25.27 //y=1.095 //x2=24.915 //y2=0.555
cc_2069 ( N_noxref_6_c_2136_p N_noxref_24_M15_noxref_s ) capacitor \
 c=0.0071177f //x=25.27 //y=1.75 //x2=24.915 //y2=0.555
cc_2070 ( N_noxref_6_c_2132_p N_noxref_24_M15_noxref_s ) capacitor c=0.015333f \
 //x=25.8 //y=1.095 //x2=24.915 //y2=0.555
cc_2071 ( N_noxref_6_c_2133_p N_noxref_24_M15_noxref_s ) capacitor \
 c=0.00248746f //x=25.8 //y=1.44 //x2=24.915 //y2=0.555
cc_2072 ( N_noxref_6_c_2145_p N_GND_c_12546_n ) capacitor c=0.00200766f \
 //x=25.28 //y=2.375 //x2=27.855 //y2=0.175
cc_2073 ( N_noxref_6_c_2095_p N_GND_c_12547_n ) capacitor c=0.00618782f \
 //x=29.265 //y=1.835 //x2=31.185 //y2=0.175
cc_2074 ( N_noxref_6_c_2109_p N_GND_c_12547_n ) capacitor c=0.00937893f \
 //x=28.91 //y=1.18 //x2=31.185 //y2=0.175
cc_2075 ( N_noxref_6_M17_noxref_d N_GND_c_12547_n ) capacitor c=3.01769e-19 \
 //x=28.72 //y=1.085 //x2=31.185 //y2=0.175
cc_2076 ( N_noxref_6_c_2118_p N_GND_c_12550_n ) capacitor c=6.61018e-19 \
 //x=27.99 //y=5.56 //x2=27.94 //y2=1.135
cc_2077 ( N_noxref_6_c_2109_p N_GND_c_12550_n ) capacitor c=0.0140211f \
 //x=28.91 //y=1.18 //x2=27.94 //y2=1.135
cc_2078 ( N_noxref_6_M17_noxref_d N_GND_c_12550_n ) capacitor c=2.93544e-19 \
 //x=28.72 //y=1.085 //x2=27.94 //y2=1.135
cc_2079 ( N_noxref_6_c_2109_p N_GND_c_12553_n ) capacitor c=0.00549186f \
 //x=28.91 //y=1.18 //x2=31.27 //y2=1.135
cc_2080 ( N_noxref_6_c_2235_p N_GND_c_12553_n ) capacitor c=0.00667419f \
 //x=31.2 //y=2.26 //x2=31.27 //y2=1.135
cc_2081 ( N_noxref_6_c_2227_p N_GND_c_12553_n ) capacitor c=2.13705e-19 \
 //x=31.2 //y=2.26 //x2=31.27 //y2=1.135
cc_2082 ( N_noxref_6_c_2259_p N_GND_c_12553_n ) capacitor c=0.00171023f \
 //x=31.005 //y=1.045 //x2=31.27 //y2=1.135
cc_2083 ( N_noxref_6_c_2260_p N_GND_c_12553_n ) capacitor c=0.00357815f \
 //x=31.005 //y=1.39 //x2=31.27 //y2=1.135
cc_2084 ( N_noxref_6_c_2262_p N_GND_c_12553_n ) capacitor c=4.2764e-19 \
 //x=31.005 //y=1.7 //x2=31.27 //y2=1.135
cc_2085 ( N_noxref_6_c_2483_p N_GND_c_12553_n ) capacitor c=9.36995e-19 \
 //x=31.38 //y=0.89 //x2=31.27 //y2=1.135
cc_2086 ( N_noxref_6_c_2484_p N_GND_c_12553_n ) capacitor c=6.38426e-19 \
 //x=31.38 //y=1.545 //x2=31.27 //y2=1.135
cc_2087 ( N_noxref_6_c_2261_p N_GND_c_12553_n ) capacitor c=0.00171721f \
 //x=31.535 //y=1.045 //x2=31.27 //y2=1.135
cc_2088 ( N_noxref_6_c_2263_p N_GND_c_12553_n ) capacitor c=0.00296337f \
 //x=31.535 //y=1.39 //x2=31.27 //y2=1.135
cc_2089 ( N_noxref_6_c_2259_p N_GND_c_12563_n ) capacitor c=3.46594e-19 \
 //x=31.005 //y=1.045 //x2=31.267 //y2=1.005
cc_2090 ( N_noxref_6_c_2483_p N_GND_c_12563_n ) capacitor c=0.00839795f \
 //x=31.38 //y=0.89 //x2=31.267 //y2=1.005
cc_2091 ( N_noxref_6_c_2261_p N_GND_c_12563_n ) capacitor c=4.40641e-19 \
 //x=31.535 //y=1.045 //x2=31.267 //y2=1.005
cc_2092 ( N_noxref_6_c_2145_p N_GND_c_12566_n ) capacitor c=2.016e-19 \
 //x=25.28 //y=2.375 //x2=26.59 //y2=0.175
cc_2093 ( N_noxref_6_c_2095_p N_GND_c_12567_n ) capacitor c=7.75992e-19 \
 //x=29.265 //y=1.835 //x2=29.92 //y2=0.175
cc_2094 ( N_noxref_6_c_2259_p N_GND_c_12568_n ) capacitor c=0.00688027f \
 //x=31.005 //y=1.045 //x2=33.25 //y2=0.175
cc_2095 ( N_noxref_6_c_2096_p N_GND_c_12569_n ) capacitor c=9.32616e-19 \
 //x=29.35 //y=3.35 //x2=26.76 //y2=0.175
cc_2096 ( N_noxref_6_c_2153_p N_GND_c_12569_n ) capacitor c=0.00239899f \
 //x=25.28 //y=2.26 //x2=26.76 //y2=0.175
cc_2097 ( N_noxref_6_c_2133_p N_GND_c_12569_n ) capacitor c=0.00262688f \
 //x=25.8 //y=1.44 //x2=26.76 //y2=0.175
cc_2098 ( N_noxref_6_c_2154_p N_GND_c_12569_n ) capacitor c=2.63786e-19 \
 //x=25.28 //y=2.26 //x2=26.76 //y2=0.175
cc_2099 ( N_noxref_6_c_2094_p N_GND_c_12573_n ) capacitor c=0.002973f \
 //x=28.91 //y=1.75 //x2=30.09 //y2=0.175
cc_2100 ( N_noxref_6_c_2095_p N_GND_c_12573_n ) capacitor c=0.0277399f \
 //x=29.265 //y=1.835 //x2=30.09 //y2=0.175
cc_2101 ( N_noxref_6_c_2097_p N_GND_c_12573_n ) capacitor c=0.00718667f \
 //x=31.2 //y=3.345 //x2=30.09 //y2=0.175
cc_2102 ( N_noxref_6_c_2235_p N_GND_c_12573_n ) capacitor c=0.00427323f \
 //x=31.2 //y=2.26 //x2=30.09 //y2=0.175
cc_2103 ( N_noxref_6_c_2227_p N_GND_c_12573_n ) capacitor c=0.00369427f \
 //x=31.2 //y=2.26 //x2=30.09 //y2=0.175
cc_2104 ( N_noxref_6_c_2262_p N_GND_c_12573_n ) capacitor c=0.0015404f \
 //x=31.005 //y=1.7 //x2=30.09 //y2=0.175
cc_2105 ( N_noxref_6_c_2237_p N_GND_c_12573_n ) capacitor c=0.00950704f \
 //x=31.005 //y=2.095 //x2=30.09 //y2=0.175
cc_2106 ( N_noxref_6_c_2109_p N_GND_M16_noxref_d ) capacitor c=2.82748e-19 \
 //x=28.91 //y=1.18 //x2=27.75 //y2=1.045
cc_2107 ( N_noxref_6_c_2235_p N_GND_M18_noxref_d ) capacitor c=2.20438e-19 \
 //x=31.2 //y=2.26 //x2=31.08 //y2=1.045
cc_2108 ( N_noxref_6_c_2259_p N_GND_M18_noxref_d ) capacitor c=0.00192399f \
 //x=31.005 //y=1.045 //x2=31.08 //y2=1.045
cc_2109 ( N_noxref_6_c_2260_p N_GND_M18_noxref_d ) capacitor c=0.00210798f \
 //x=31.005 //y=1.39 //x2=31.08 //y2=1.045
cc_2110 ( N_noxref_6_c_2483_p N_GND_M18_noxref_d ) capacitor c=0.00472259f \
 //x=31.38 //y=0.89 //x2=31.08 //y2=1.045
cc_2111 ( N_noxref_6_c_2484_p N_GND_M18_noxref_d ) capacitor c=0.00166857f \
 //x=31.38 //y=1.545 //x2=31.08 //y2=1.045
cc_2112 ( N_noxref_6_c_2261_p N_GND_M18_noxref_d ) capacitor c=0.00230174f \
 //x=31.535 //y=1.045 //x2=31.08 //y2=1.045
cc_2113 ( N_noxref_6_c_2263_p N_GND_M18_noxref_d ) capacitor c=0.00210798f \
 //x=31.535 //y=1.39 //x2=31.08 //y2=1.045
cc_2114 ( N_noxref_6_c_2140_p N_noxref_38_c_14439_n ) capacitor c=0.00911405f \
 //x=28.995 //y=1.835 //x2=28.425 //y2=1.675
cc_2115 ( N_noxref_6_c_2095_p N_noxref_38_c_14440_n ) capacitor c=0.00399245f \
 //x=29.265 //y=1.835 //x2=29.31 //y2=0.71
cc_2116 ( N_noxref_6_c_2109_p N_noxref_38_c_14440_n ) capacitor c=0.003751f \
 //x=28.91 //y=1.18 //x2=29.31 //y2=0.71
cc_2117 ( N_noxref_6_M17_noxref_d N_noxref_38_c_14440_n ) capacitor \
 c=0.00910163f //x=28.72 //y=1.085 //x2=29.31 //y2=0.71
cc_2118 ( N_noxref_6_c_2094_p N_noxref_38_M16_noxref_s ) capacitor c=0.01625f \
 //x=28.91 //y=1.75 //x2=27.32 //y2=0.545
cc_2119 ( N_noxref_6_c_2095_p N_noxref_38_M16_noxref_s ) capacitor \
 c=0.00640979f //x=29.265 //y=1.835 //x2=27.32 //y2=0.545
cc_2120 ( N_noxref_6_c_2184_p N_noxref_38_M16_noxref_s ) capacitor \
 c=4.17069e-19 //x=29.35 //y=3.67 //x2=27.32 //y2=0.545
cc_2121 ( N_noxref_6_c_2109_p N_noxref_38_M16_noxref_s ) capacitor \
 c=0.00905337f //x=28.91 //y=1.18 //x2=27.32 //y2=0.545
cc_2122 ( N_noxref_6_c_2290_p N_noxref_38_M16_noxref_s ) capacitor \
 c=0.0010514f //x=29.345 //y=3.51 //x2=27.32 //y2=0.545
cc_2123 ( N_noxref_6_M17_noxref_d N_noxref_38_M16_noxref_s ) capacitor \
 c=0.0275552f //x=28.72 //y=1.085 //x2=27.32 //y2=0.545
cc_2124 ( N_noxref_6_c_2237_p N_noxref_39_c_14507_n ) capacitor c=0.00262672f \
 //x=31.005 //y=2.095 //x2=30.785 //y2=1.675
cc_2125 ( N_noxref_6_c_2101_p N_noxref_39_c_14508_n ) capacitor c=0.00402488f \
 //x=31.2 //y=3.665 //x2=31.67 //y2=1.76
cc_2126 ( N_noxref_6_c_2235_p N_noxref_39_c_14508_n ) capacitor c=0.00509504f \
 //x=31.2 //y=2.26 //x2=31.67 //y2=1.76
cc_2127 ( N_noxref_6_c_2227_p N_noxref_39_c_14508_n ) capacitor c=0.00763108f \
 //x=31.2 //y=2.26 //x2=31.67 //y2=1.76
cc_2128 ( N_noxref_6_c_2262_p N_noxref_39_c_14508_n ) capacitor c=0.00697076f \
 //x=31.005 //y=1.7 //x2=31.67 //y2=1.76
cc_2129 ( N_noxref_6_c_2237_p N_noxref_39_c_14508_n ) capacitor c=0.017492f \
 //x=31.005 //y=2.095 //x2=31.67 //y2=1.76
cc_2130 ( N_noxref_6_c_2484_p N_noxref_39_c_14508_n ) capacitor c=0.00723574f \
 //x=31.38 //y=1.545 //x2=31.67 //y2=1.76
cc_2131 ( N_noxref_6_c_2263_p N_noxref_39_c_14508_n ) capacitor c=0.00339872f \
 //x=31.535 //y=1.39 //x2=31.67 //y2=1.76
cc_2132 ( N_noxref_6_c_2237_p N_noxref_39_c_14515_n ) capacitor c=6.71402e-19 \
 //x=31.005 //y=2.095 //x2=31.755 //y2=1.675
cc_2133 ( N_noxref_6_c_2259_p N_noxref_39_M18_noxref_s ) capacitor \
 c=0.0294925f //x=31.005 //y=1.045 //x2=30.65 //y2=0.545
cc_2134 ( N_noxref_6_c_2262_p N_noxref_39_M18_noxref_s ) capacitor \
 c=3.48408e-19 //x=31.005 //y=1.7 //x2=30.65 //y2=0.545
cc_2135 ( N_noxref_6_c_2261_p N_noxref_39_M18_noxref_s ) capacitor \
 c=0.0125442f //x=31.535 //y=1.045 //x2=30.65 //y2=0.545
cc_2136 ( N_noxref_7_c_2558_p N_noxref_8_c_2922_n ) capacitor c=0.00129068f \
 //x=32.68 //y=3.67 //x2=32.16 //y2=3.87
cc_2137 ( N_noxref_7_c_2539_n N_noxref_8_c_2922_n ) capacitor c=7.95945e-19 \
 //x=32.68 //y=5.295 //x2=32.16 //y2=3.87
cc_2138 ( N_noxref_7_c_2552_n N_noxref_8_c_2922_n ) capacitor c=0.0358254f \
 //x=32.845 //y=3.51 //x2=32.16 //y2=3.87
cc_2139 ( N_noxref_7_c_2558_p N_noxref_8_c_2925_n ) capacitor c=0.00700197f \
 //x=32.68 //y=3.67 //x2=32.9 //y2=3.895
cc_2140 ( N_noxref_7_c_2539_n N_noxref_8_c_2925_n ) capacitor c=0.0225064f \
 //x=32.68 //y=5.295 //x2=32.9 //y2=3.895
cc_2141 ( N_noxref_7_c_2563_p N_noxref_8_c_2925_n ) capacitor c=0.126769f \
 //x=34.365 //y=3.51 //x2=32.9 //y2=3.895
cc_2142 ( N_noxref_7_c_2564_p N_noxref_8_c_2928_n ) capacitor c=0.00341263f \
 //x=34.53 //y=3.67 //x2=34.14 //y2=3.88
cc_2143 ( N_noxref_7_c_2565_p N_noxref_8_c_2928_n ) capacitor c=4.98692e-19 \
 //x=34.532 //y=4.74 //x2=34.14 //y2=3.88
cc_2144 ( N_noxref_7_c_2563_p N_noxref_8_c_2928_n ) capacitor c=0.0108087f \
 //x=34.365 //y=3.51 //x2=34.14 //y2=3.88
cc_2145 ( N_noxref_7_c_2567_p N_noxref_8_c_2928_n ) capacitor c=0.0358254f \
 //x=34.525 //y=3.51 //x2=34.14 //y2=3.88
cc_2146 ( N_noxref_7_c_2564_p N_noxref_8_c_2932_n ) capacitor c=0.00251183f \
 //x=34.53 //y=3.67 //x2=34.74 //y2=3.895
cc_2147 ( N_noxref_7_c_2565_p N_noxref_8_c_2932_n ) capacitor c=0.0224596f \
 //x=34.532 //y=4.74 //x2=34.74 //y2=3.895
cc_2148 ( N_noxref_7_c_2537_n N_noxref_10_c_3598_n ) capacitor c=0.0379469f \
 //x=32.68 //y=3.35 //x2=31.94 //y2=4.095
cc_2149 ( N_noxref_7_c_2558_p N_noxref_10_c_3598_n ) capacitor c=0.0146933f \
 //x=32.68 //y=3.67 //x2=31.94 //y2=4.095
cc_2150 ( N_noxref_7_c_2539_n N_noxref_10_c_3598_n ) capacitor c=0.0169815f \
 //x=32.68 //y=5.295 //x2=31.94 //y2=4.095
cc_2151 ( N_noxref_7_c_2573_p N_noxref_10_c_3598_n ) capacitor c=0.00138113f \
 //x=34.53 //y=3.35 //x2=31.94 //y2=4.095
cc_2152 ( N_noxref_7_c_2551_n N_noxref_10_c_3598_n ) capacitor c=5.52402e-19 \
 //x=32.68 //y=3.51 //x2=31.94 //y2=4.095
cc_2153 ( N_noxref_7_c_2565_p N_noxref_10_c_3598_n ) capacitor c=3.19292e-19 \
 //x=34.532 //y=4.74 //x2=31.94 //y2=4.095
cc_2154 ( N_noxref_7_c_2552_n N_noxref_10_c_3598_n ) capacitor c=0.00365012f \
 //x=32.845 //y=3.51 //x2=31.94 //y2=4.095
cc_2155 ( N_noxref_7_c_2534_n N_noxref_10_c_3606_n ) capacitor c=0.0042527f \
 //x=32.085 //y=5.38 //x2=31.94 //y2=4.415
cc_2156 ( N_noxref_7_c_2539_n N_noxref_10_c_3606_n ) capacitor c=0.0147977f \
 //x=32.68 //y=5.295 //x2=31.94 //y2=4.415
cc_2157 ( N_noxref_7_c_2534_n N_noxref_10_c_3607_n ) capacitor c=0.0215252f \
 //x=32.085 //y=5.38 //x2=31.94 //y2=4.735
cc_2158 ( N_noxref_7_c_2539_n N_noxref_10_c_3607_n ) capacitor c=0.0281817f \
 //x=32.68 //y=5.295 //x2=31.94 //y2=4.735
cc_2159 ( N_noxref_7_c_2565_p N_noxref_10_c_3607_n ) capacitor c=4.65109e-19 \
 //x=34.532 //y=4.74 //x2=31.94 //y2=4.735
cc_2160 ( N_noxref_7_M87_noxref_g N_noxref_10_c_3665_n ) capacitor \
 c=0.00889217f //x=34.87 //y=6.2 //x2=35.415 //y2=5.38
cc_2161 ( N_noxref_7_c_2535_n N_noxref_10_c_3666_n ) capacitor c=0.00324213f \
 //x=32.24 //y=1.75 //x2=35.57 //y2=1.75
cc_2162 ( N_noxref_7_c_2584_p N_noxref_10_c_3667_n ) capacitor c=0.00231467f \
 //x=32.595 //y=1.835 //x2=35.655 //y2=1.835
cc_2163 ( N_noxref_7_c_2537_n N_noxref_10_c_3668_n ) capacitor c=0.00204244f \
 //x=32.68 //y=3.35 //x2=36.01 //y2=4.105
cc_2164 ( N_noxref_7_c_2573_p N_noxref_10_c_3668_n ) capacitor c=0.00216751f \
 //x=34.53 //y=3.35 //x2=36.01 //y2=4.105
cc_2165 ( N_noxref_7_c_2565_p N_noxref_10_c_3668_n ) capacitor c=7.58839e-19 \
 //x=34.532 //y=4.74 //x2=36.01 //y2=4.105
cc_2166 ( N_noxref_7_c_2539_n N_noxref_10_c_3671_n ) capacitor c=0.00281705f \
 //x=32.68 //y=5.295 //x2=36.01 //y2=5.295
cc_2167 ( N_noxref_7_c_2565_p N_noxref_10_c_3671_n ) capacitor c=6.58479e-19 \
 //x=34.532 //y=4.74 //x2=36.01 //y2=5.295
cc_2168 ( N_noxref_7_c_2539_n N_noxref_10_c_3612_n ) capacitor c=6.89957e-19 \
 //x=32.68 //y=5.295 //x2=31.94 //y2=4.25
cc_2169 ( N_noxref_7_c_2537_n N_noxref_10_c_3613_n ) capacitor c=0.015397f \
 //x=32.68 //y=3.35 //x2=31.94 //y2=2.26
cc_2170 ( N_noxref_7_c_2592_p N_noxref_10_c_3675_n ) capacitor c=0.00114153f \
 //x=32.595 //y=5.38 //x2=34.65 //y2=5.56
cc_2171 ( N_noxref_7_c_2564_p N_noxref_10_c_3675_n ) capacitor c=5.66772e-19 \
 //x=34.53 //y=3.67 //x2=34.65 //y2=5.56
cc_2172 ( N_noxref_7_c_2594_p N_noxref_10_c_3675_n ) capacitor c=5.29822e-19 \
 //x=32.2 //y=5.38 //x2=34.65 //y2=5.56
cc_2173 ( N_noxref_7_c_2595_p N_noxref_10_c_3675_n ) capacitor c=0.00147119f \
 //x=32.2 //y=5.56 //x2=34.65 //y2=5.56
cc_2174 ( N_noxref_7_c_2596_p N_noxref_10_c_3675_n ) capacitor c=0.0117744f \
 //x=34.53 //y=4.88 //x2=34.65 //y2=5.56
cc_2175 ( N_noxref_7_c_2597_p N_noxref_10_c_3675_n ) capacitor c=0.00277154f \
 //x=34.53 //y=4.88 //x2=34.65 //y2=5.56
cc_2176 ( N_noxref_7_M86_noxref_g N_noxref_10_c_3675_n ) capacitor \
 c=0.00201806f //x=34.43 //y=6.2 //x2=34.65 //y2=5.56
cc_2177 ( N_noxref_7_M87_noxref_g N_noxref_10_c_3675_n ) capacitor \
 c=0.00192712f //x=34.87 //y=6.2 //x2=34.65 //y2=5.56
cc_2178 ( N_noxref_7_c_2600_p N_noxref_10_c_3675_n ) capacitor c=0.00194519f \
 //x=34.53 //y=4.88 //x2=34.65 //y2=5.56
cc_2179 ( N_noxref_7_c_2550_n N_noxref_10_c_3684_n ) capacitor c=6.99317e-19 \
 //x=32.24 //y=1.18 //x2=35.57 //y2=1.18
cc_2180 ( N_noxref_7_c_2539_n N_noxref_10_c_3685_n ) capacitor c=0.0227736f \
 //x=32.68 //y=5.295 //x2=35.84 //y2=4.25
cc_2181 ( N_noxref_7_c_2565_p N_noxref_10_c_3685_n ) capacitor c=0.0232046f \
 //x=34.532 //y=4.74 //x2=35.84 //y2=4.25
cc_2182 ( N_noxref_7_c_2563_p N_noxref_10_c_3685_n ) capacitor c=0.0104197f \
 //x=34.365 //y=3.51 //x2=35.84 //y2=4.25
cc_2183 ( N_noxref_7_c_2539_n N_noxref_10_c_3623_n ) capacitor c=0.00328982f \
 //x=32.68 //y=5.295 //x2=32.105 //y2=4.25
cc_2184 ( N_noxref_7_c_2537_n N_noxref_10_c_3627_n ) capacitor c=9.90728e-19 \
 //x=32.68 //y=3.35 //x2=31.94 //y2=2.26
cc_2185 ( N_noxref_7_c_2534_n N_noxref_10_c_3631_n ) capacitor c=0.00469257f \
 //x=32.085 //y=5.38 //x2=31.97 //y2=4.88
cc_2186 ( N_noxref_7_c_2539_n N_noxref_10_c_3631_n ) capacitor c=7.76118e-19 \
 //x=32.68 //y=5.295 //x2=31.97 //y2=4.88
cc_2187 ( N_noxref_7_c_2596_p N_noxref_10_c_3692_n ) capacitor c=0.00104426f \
 //x=34.53 //y=4.88 //x2=34.65 //y2=5.56
cc_2188 ( N_noxref_7_c_2597_p N_noxref_10_c_3692_n ) capacitor c=0.00377369f \
 //x=34.53 //y=4.88 //x2=34.65 //y2=5.56
cc_2189 ( N_noxref_7_M86_noxref_g N_noxref_10_c_3692_n ) capacitor \
 c=0.0158358f //x=34.43 //y=6.2 //x2=34.65 //y2=5.56
cc_2190 ( N_noxref_7_M87_noxref_g N_noxref_10_c_3692_n ) capacitor \
 c=0.0178987f //x=34.87 //y=6.2 //x2=34.65 //y2=5.56
cc_2191 ( N_noxref_7_c_2600_p N_noxref_10_c_3692_n ) capacitor c=0.0043218f \
 //x=34.53 //y=4.88 //x2=34.65 //y2=5.56
cc_2192 ( N_noxref_7_c_2534_n N_noxref_10_M84_noxref_g ) capacitor \
 c=0.00842859f //x=32.085 //y=5.38 //x2=31.98 //y2=6.2
cc_2193 ( N_noxref_7_c_2594_p N_noxref_10_M84_noxref_g ) capacitor \
 c=0.00192712f //x=32.2 //y=5.38 //x2=31.98 //y2=6.2
cc_2194 ( N_noxref_7_c_2616_p N_noxref_10_M84_noxref_g ) capacitor \
 c=0.0178987f //x=32.2 //y=5.56 //x2=31.98 //y2=6.2
cc_2195 ( N_noxref_7_c_2592_p N_noxref_10_M85_noxref_g ) capacitor \
 c=0.0106088f //x=32.595 //y=5.38 //x2=32.42 //y2=6.2
cc_2196 ( N_noxref_7_c_2594_p N_noxref_10_M85_noxref_g ) capacitor \
 c=0.00298276f //x=32.2 //y=5.38 //x2=32.42 //y2=6.2
cc_2197 ( N_noxref_7_c_2616_p N_noxref_10_M85_noxref_g ) capacitor \
 c=0.0178506f //x=32.2 //y=5.56 //x2=32.42 //y2=6.2
cc_2198 ( N_noxref_7_c_2550_n N_noxref_10_c_3637_n ) capacitor c=0.00120406f \
 //x=32.24 //y=1.18 //x2=31.975 //y2=1.085
cc_2199 ( N_noxref_7_M19_noxref_d N_noxref_10_c_3637_n ) capacitor \
 c=0.00137165f //x=32.05 //y=1.085 //x2=31.975 //y2=1.085
cc_2200 ( N_noxref_7_c_2535_n N_noxref_10_c_3640_n ) capacitor c=0.00119008f \
 //x=32.24 //y=1.75 //x2=31.975 //y2=1.43
cc_2201 ( N_noxref_7_c_2550_n N_noxref_10_c_3640_n ) capacitor c=0.00218694f \
 //x=32.24 //y=1.18 //x2=31.975 //y2=1.43
cc_2202 ( N_noxref_7_M19_noxref_d N_noxref_10_c_3640_n ) capacitor \
 c=0.00237422f //x=32.05 //y=1.085 //x2=31.975 //y2=1.43
cc_2203 ( N_noxref_7_c_2535_n N_noxref_10_c_3642_n ) capacitor c=0.00438634f \
 //x=32.24 //y=1.75 //x2=31.975 //y2=1.74
cc_2204 ( N_noxref_7_c_2539_n N_noxref_10_c_3709_n ) capacitor c=0.00845606f \
 //x=32.68 //y=5.295 //x2=32.345 //y2=4.97
cc_2205 ( N_noxref_7_c_2594_p N_noxref_10_c_3709_n ) capacitor c=0.0020909f \
 //x=32.2 //y=5.38 //x2=32.345 //y2=4.97
cc_2206 ( N_noxref_7_c_2616_p N_noxref_10_c_3709_n ) capacitor c=0.00291714f \
 //x=32.2 //y=5.56 //x2=32.345 //y2=4.97
cc_2207 ( N_noxref_7_c_2550_n N_noxref_10_c_3712_n ) capacitor c=5.50523e-19 \
 //x=32.24 //y=1.18 //x2=32.35 //y2=0.93
cc_2208 ( N_noxref_7_M19_noxref_d N_noxref_10_c_3712_n ) capacitor \
 c=0.0020782f //x=32.05 //y=1.085 //x2=32.35 //y2=0.93
cc_2209 ( N_noxref_7_c_2535_n N_noxref_10_c_3714_n ) capacitor c=0.00916852f \
 //x=32.24 //y=1.75 //x2=32.35 //y2=1.585
cc_2210 ( N_noxref_7_c_2584_p N_noxref_10_c_3714_n ) capacitor c=0.00194324f \
 //x=32.595 //y=1.835 //x2=32.35 //y2=1.585
cc_2211 ( N_noxref_7_c_2550_n N_noxref_10_c_3714_n ) capacitor c=5.67071e-19 \
 //x=32.24 //y=1.18 //x2=32.35 //y2=1.585
cc_2212 ( N_noxref_7_M19_noxref_d N_noxref_10_c_3714_n ) capacitor \
 c=0.00356097f //x=32.05 //y=1.085 //x2=32.35 //y2=1.585
cc_2213 ( N_noxref_7_c_2550_n N_noxref_10_c_3645_n ) capacitor c=0.00109205f \
 //x=32.24 //y=1.18 //x2=32.505 //y2=1.085
cc_2214 ( N_noxref_7_M19_noxref_d N_noxref_10_c_3645_n ) capacitor \
 c=8.50095e-19 //x=32.05 //y=1.085 //x2=32.505 //y2=1.085
cc_2215 ( N_noxref_7_c_2535_n N_noxref_10_c_3646_n ) capacitor c=0.003249f \
 //x=32.24 //y=1.75 //x2=32.505 //y2=1.43
cc_2216 ( N_noxref_7_c_2584_p N_noxref_10_c_3646_n ) capacitor c=0.00323005f \
 //x=32.595 //y=1.835 //x2=32.505 //y2=1.43
cc_2217 ( N_noxref_7_c_2550_n N_noxref_10_c_3646_n ) capacitor c=0.00317092f \
 //x=32.24 //y=1.18 //x2=32.505 //y2=1.43
cc_2218 ( N_noxref_7_M19_noxref_d N_noxref_10_c_3646_n ) capacitor \
 c=0.00237422f //x=32.05 //y=1.085 //x2=32.505 //y2=1.43
cc_2219 ( N_noxref_7_c_2537_n N_noxref_10_c_3647_n ) capacitor c=0.00281392f \
 //x=32.68 //y=3.35 //x2=31.94 //y2=2.26
cc_2220 ( N_noxref_7_c_2535_n N_noxref_10_c_3725_n ) capacitor c=0.00341114f \
 //x=32.24 //y=1.75 //x2=31.94 //y2=2.095
cc_2221 ( N_noxref_7_c_2537_n N_noxref_10_c_3725_n ) capacitor c=0.00309058f \
 //x=32.68 //y=3.35 //x2=31.94 //y2=2.095
cc_2222 ( N_noxref_7_c_2534_n N_noxref_10_c_3650_n ) capacitor c=8.41897e-19 \
 //x=32.085 //y=5.38 //x2=31.97 //y2=4.88
cc_2223 ( N_noxref_7_c_2539_n N_noxref_10_c_3650_n ) capacitor c=0.00142201f \
 //x=32.68 //y=5.295 //x2=31.97 //y2=4.88
cc_2224 ( N_noxref_7_c_2536_n N_D_c_4408_n ) capacitor c=0.012898f //x=32.325 \
 //y=1.835 //x2=49.91 //y2=2.755
cc_2225 ( N_noxref_7_c_2537_n N_D_c_4408_n ) capacitor c=0.0286336f //x=32.68 \
 //y=3.35 //x2=49.91 //y2=2.755
cc_2226 ( N_noxref_7_c_2573_p N_D_c_4408_n ) capacitor c=0.0271043f //x=34.53 \
 //y=3.35 //x2=49.91 //y2=2.755
cc_2227 ( N_noxref_7_c_2550_n N_D_c_4408_n ) capacitor c=4.96962e-19 //x=32.24 \
 //y=1.18 //x2=49.91 //y2=2.755
cc_2228 ( N_noxref_7_c_2650_p N_D_c_4408_n ) capacitor c=0.0033197f //x=34.53 \
 //y=2.26 //x2=49.91 //y2=2.755
cc_2229 ( N_noxref_7_c_2563_p N_D_c_4408_n ) capacitor c=0.00817731f \
 //x=34.365 //y=3.51 //x2=49.91 //y2=2.755
cc_2230 ( N_noxref_7_c_2537_n CLK ) capacitor c=0.00141826f //x=32.68 //y=3.35 \
 //x2=35.27 //y2=3.51
cc_2231 ( N_noxref_7_c_2539_n CLK ) capacitor c=0.00126687f //x=32.68 \
 //y=5.295 //x2=35.27 //y2=3.51
cc_2232 ( N_noxref_7_c_2573_p CLK ) capacitor c=0.037957f //x=34.53 //y=3.35 \
 //x2=35.27 //y2=3.51
cc_2233 ( N_noxref_7_c_2564_p CLK ) capacitor c=0.0146933f //x=34.53 //y=3.67 \
 //x2=35.27 //y2=3.51
cc_2234 ( N_noxref_7_c_2656_p CLK ) capacitor c=6.03895e-19 //x=34.525 \
 //y=3.51 //x2=35.27 //y2=3.51
cc_2235 ( N_noxref_7_c_2565_p CLK ) capacitor c=0.0384373f //x=34.532 //y=4.74 \
 //x2=35.27 //y2=3.51
cc_2236 ( N_noxref_7_c_2567_p CLK ) capacitor c=0.00684103f //x=34.525 \
 //y=3.51 //x2=35.27 //y2=3.51
cc_2237 ( N_noxref_7_c_2659_p CLK ) capacitor c=3.49899e-19 //x=34.53 //y=2.26 \
 //x2=35.27 //y2=3.51
cc_2238 ( N_noxref_7_c_2596_p N_CLK_c_5887_n ) capacitor c=0.0147952f \
 //x=34.53 //y=4.88 //x2=35.295 //y2=4.865
cc_2239 ( N_noxref_7_c_2565_p N_CLK_c_5887_n ) capacitor c=0.00198309f \
 //x=34.532 //y=4.74 //x2=35.295 //y2=4.865
cc_2240 ( N_noxref_7_c_2597_p N_CLK_c_5887_n ) capacitor c=7.64003e-19 \
 //x=34.53 //y=4.88 //x2=35.295 //y2=4.865
cc_2241 ( N_noxref_7_c_2600_p N_CLK_c_5887_n ) capacitor c=0.00163736f \
 //x=34.53 //y=4.88 //x2=35.295 //y2=4.865
cc_2242 ( N_noxref_7_c_2650_p N_CLK_c_5891_n ) capacitor c=0.0205342f \
 //x=34.53 //y=2.26 //x2=35.27 //y2=2.26
cc_2243 ( N_noxref_7_c_2659_p N_CLK_c_5891_n ) capacitor c=5.16867e-19 \
 //x=34.53 //y=2.26 //x2=35.27 //y2=2.26
cc_2244 ( N_noxref_7_c_2666_p N_CLK_c_5891_n ) capacitor c=0.00167888f \
 //x=34.335 //y=2.095 //x2=35.27 //y2=2.26
cc_2245 ( N_noxref_7_c_2594_p N_CLK_c_5894_n ) capacitor c=0.00646691f \
 //x=32.2 //y=5.38 //x2=32.16 //y2=4.64
cc_2246 ( N_noxref_7_c_2534_n N_CLK_c_5852_n ) capacitor c=0.00656522f \
 //x=32.085 //y=5.38 //x2=31.815 //y2=4.64
cc_2247 ( N_noxref_7_c_2541_n N_CLK_c_5852_n ) capacitor c=0.0154924f \
 //x=31.32 //y=5.56 //x2=31.815 //y2=4.64
cc_2248 ( N_noxref_7_c_2539_n N_CLK_c_5897_n ) capacitor c=0.0293305f \
 //x=32.68 //y=5.295 //x2=35.87 //y2=4.65
cc_2249 ( N_noxref_7_c_2594_p N_CLK_c_5897_n ) capacitor c=0.0151381f //x=32.2 \
 //y=5.38 //x2=35.87 //y2=4.65
cc_2250 ( N_noxref_7_c_2596_p N_CLK_c_5897_n ) capacitor c=0.0114767f \
 //x=34.53 //y=4.88 //x2=35.87 //y2=4.65
cc_2251 ( N_noxref_7_c_2565_p N_CLK_c_5897_n ) capacitor c=0.0274896f \
 //x=34.532 //y=4.74 //x2=35.87 //y2=4.65
cc_2252 ( N_noxref_7_c_2573_p N_CLK_c_5901_n ) capacitor c=3.49899e-19 \
 //x=34.53 //y=3.35 //x2=35.27 //y2=2.26
cc_2253 ( N_noxref_7_c_2650_p N_CLK_c_5901_n ) capacitor c=5.24723e-19 \
 //x=34.53 //y=2.26 //x2=35.27 //y2=2.26
cc_2254 ( N_noxref_7_c_2659_p N_CLK_c_5901_n ) capacitor c=0.00485709f \
 //x=34.53 //y=2.26 //x2=35.27 //y2=2.26
cc_2255 ( N_noxref_7_c_2666_p N_CLK_c_5901_n ) capacitor c=0.00267961f \
 //x=34.335 //y=2.095 //x2=35.27 //y2=2.26
cc_2256 ( N_noxref_7_c_2596_p N_CLK_c_5905_n ) capacitor c=4.80626e-19 \
 //x=34.53 //y=4.88 //x2=35.3 //y2=4.88
cc_2257 ( N_noxref_7_c_2597_p N_CLK_c_5905_n ) capacitor c=0.00396769f \
 //x=34.53 //y=4.88 //x2=35.3 //y2=4.88
cc_2258 ( N_noxref_7_c_2600_p N_CLK_c_5905_n ) capacitor c=0.0028411f \
 //x=34.53 //y=4.88 //x2=35.3 //y2=4.88
cc_2259 ( N_noxref_7_M86_noxref_g N_CLK_M88_noxref_g ) capacitor c=0.0104892f \
 //x=34.43 //y=6.2 //x2=35.31 //y2=6.2
cc_2260 ( N_noxref_7_M87_noxref_g N_CLK_M88_noxref_g ) capacitor c=0.107636f \
 //x=34.87 //y=6.2 //x2=35.31 //y2=6.2
cc_2261 ( N_noxref_7_M87_noxref_g N_CLK_M89_noxref_g ) capacitor c=0.0100341f \
 //x=34.87 //y=6.2 //x2=35.75 //y2=6.2
cc_2262 ( N_noxref_7_c_2684_p N_CLK_c_5911_n ) capacitor c=4.86545e-19 \
 //x=34.335 //y=1.045 //x2=35.305 //y2=1.085
cc_2263 ( N_noxref_7_c_2685_p N_CLK_c_5911_n ) capacitor c=0.00152405f \
 //x=34.335 //y=1.39 //x2=35.305 //y2=1.085
cc_2264 ( N_noxref_7_c_2686_p N_CLK_c_5911_n ) capacitor c=0.0151475f \
 //x=34.865 //y=1.045 //x2=35.305 //y2=1.085
cc_2265 ( N_noxref_7_c_2687_p N_CLK_c_5914_n ) capacitor c=0.00109982f \
 //x=34.335 //y=1.7 //x2=35.305 //y2=1.43
cc_2266 ( N_noxref_7_c_2688_p N_CLK_c_5914_n ) capacitor c=0.0111064f \
 //x=34.865 //y=1.39 //x2=35.305 //y2=1.43
cc_2267 ( N_noxref_7_c_2687_p N_CLK_c_5916_n ) capacitor c=9.58243e-19 \
 //x=34.335 //y=1.7 //x2=35.305 //y2=1.74
cc_2268 ( N_noxref_7_c_2666_p N_CLK_c_5916_n ) capacitor c=0.00662747f \
 //x=34.335 //y=2.095 //x2=35.305 //y2=1.74
cc_2269 ( N_noxref_7_c_2688_p N_CLK_c_5916_n ) capacitor c=0.00862358f \
 //x=34.865 //y=1.39 //x2=35.305 //y2=1.74
cc_2270 ( N_noxref_7_c_2686_p N_CLK_c_5919_n ) capacitor c=0.00127211f \
 //x=34.865 //y=1.045 //x2=35.835 //y2=1.085
cc_2271 ( N_noxref_7_c_2688_p N_CLK_c_5920_n ) capacitor c=0.00204774f \
 //x=34.865 //y=1.39 //x2=35.835 //y2=1.43
cc_2272 ( N_noxref_7_c_2650_p N_CLK_c_5921_n ) capacitor c=0.00167305f \
 //x=34.53 //y=2.26 //x2=35.27 //y2=2.26
cc_2273 ( N_noxref_7_c_2659_p N_CLK_c_5921_n ) capacitor c=0.0018937f \
 //x=34.53 //y=2.26 //x2=35.27 //y2=2.26
cc_2274 ( N_noxref_7_c_2666_p N_CLK_c_5921_n ) capacitor c=0.0181449f \
 //x=34.335 //y=2.095 //x2=35.27 //y2=2.26
cc_2275 ( N_noxref_7_c_2597_p N_CLK_c_5924_n ) capacitor c=0.00202662f \
 //x=34.53 //y=4.88 //x2=35.3 //y2=4.88
cc_2276 ( N_noxref_7_c_2600_p N_CLK_c_5924_n ) capacitor c=0.0288755f \
 //x=34.53 //y=4.88 //x2=35.3 //y2=4.88
cc_2277 ( N_noxref_7_c_2537_n N_noxref_20_c_9337_n ) capacitor c=3.26409e-19 \
 //x=32.68 //y=3.35 //x2=32.3 //y2=3.14
cc_2278 ( N_noxref_7_c_2537_n N_noxref_20_c_9338_n ) capacitor c=0.0226523f \
 //x=32.68 //y=3.35 //x2=32.9 //y2=3.125
cc_2279 ( N_noxref_7_c_2558_p N_noxref_20_c_9338_n ) capacitor c=0.00802082f \
 //x=32.68 //y=3.67 //x2=32.9 //y2=3.125
cc_2280 ( N_noxref_7_c_2563_p N_noxref_20_c_9338_n ) capacitor c=0.126752f \
 //x=34.365 //y=3.51 //x2=32.9 //y2=3.125
cc_2281 ( N_noxref_7_c_2552_n N_noxref_20_c_9338_n ) capacitor c=0.0358686f \
 //x=32.845 //y=3.51 //x2=32.9 //y2=3.125
cc_2282 ( N_noxref_7_c_2573_p N_noxref_20_c_9342_n ) capacitor c=4.98692e-19 \
 //x=34.53 //y=3.35 //x2=34.14 //y2=3.14
cc_2283 ( N_noxref_7_c_2564_p N_noxref_20_c_9342_n ) capacitor c=0.00225452f \
 //x=34.53 //y=3.67 //x2=34.14 //y2=3.14
cc_2284 ( N_noxref_7_c_2563_p N_noxref_20_c_9342_n ) capacitor c=0.010775f \
 //x=34.365 //y=3.51 //x2=34.14 //y2=3.14
cc_2285 ( N_noxref_7_c_2573_p N_noxref_20_c_9345_n ) capacitor c=0.02246f \
 //x=34.53 //y=3.35 //x2=34.74 //y2=3.125
cc_2286 ( N_noxref_7_c_2564_p N_noxref_20_c_9345_n ) capacitor c=0.0049147f \
 //x=34.53 //y=3.67 //x2=34.74 //y2=3.125
cc_2287 ( N_noxref_7_c_2567_p N_noxref_20_c_9345_n ) capacitor c=0.0358686f \
 //x=34.525 //y=3.51 //x2=34.74 //y2=3.125
cc_2288 ( N_noxref_7_c_2534_n N_VDD_c_10241_n ) capacitor c=0.00648267f \
 //x=32.085 //y=5.38 //x2=65.575 //y2=7.585
cc_2289 ( N_noxref_7_c_2592_p N_VDD_c_10241_n ) capacitor c=0.00492586f \
 //x=32.595 //y=5.38 //x2=65.575 //y2=7.585
cc_2290 ( N_noxref_7_c_2558_p N_VDD_c_10241_n ) capacitor c=4.58912e-19 \
 //x=32.68 //y=3.67 //x2=65.575 //y2=7.585
cc_2291 ( N_noxref_7_c_2564_p N_VDD_c_10241_n ) capacitor c=2.00712e-19 \
 //x=34.53 //y=3.67 //x2=65.575 //y2=7.585
cc_2292 ( N_noxref_7_c_2541_n N_VDD_c_10241_n ) capacitor c=0.00368834f \
 //x=31.32 //y=5.56 //x2=65.575 //y2=7.585
cc_2293 ( N_noxref_7_c_2594_p N_VDD_c_10241_n ) capacitor c=8.42594e-19 \
 //x=32.2 //y=5.38 //x2=65.575 //y2=7.585
cc_2294 ( N_noxref_7_c_2595_p N_VDD_c_10241_n ) capacitor c=0.00285853f \
 //x=32.2 //y=5.56 //x2=65.575 //y2=7.585
cc_2295 ( N_noxref_7_c_2596_p N_VDD_c_10241_n ) capacitor c=9.07241e-19 \
 //x=34.53 //y=4.88 //x2=65.575 //y2=7.585
cc_2296 ( N_noxref_7_c_2553_n N_VDD_c_10241_n ) capacitor c=0.00224881f \
 //x=31.32 //y=5.56 //x2=65.575 //y2=7.585
cc_2297 ( N_noxref_7_c_2616_p N_VDD_c_10241_n ) capacitor c=0.00224881f \
 //x=32.2 //y=5.56 //x2=65.575 //y2=7.585
cc_2298 ( N_noxref_7_c_2597_p N_VDD_c_10241_n ) capacitor c=6.22888e-19 \
 //x=34.53 //y=4.88 //x2=65.575 //y2=7.585
cc_2299 ( N_noxref_7_c_2534_n N_VDD_c_10567_n ) capacitor c=0.00208087f \
 //x=32.085 //y=5.38 //x2=31.675 //y2=7.585
cc_2300 ( N_noxref_7_c_2541_n N_VDD_c_10567_n ) capacitor c=9.41185e-19 \
 //x=31.32 //y=5.56 //x2=31.675 //y2=7.585
cc_2301 ( N_noxref_7_c_2553_n N_VDD_c_10567_n ) capacitor c=0.0136705f \
 //x=31.32 //y=5.56 //x2=31.675 //y2=7.585
cc_2302 ( N_noxref_7_c_2534_n N_VDD_c_10617_n ) capacitor c=0.00180737f \
 //x=32.085 //y=5.38 //x2=32.555 //y2=7.585
cc_2303 ( N_noxref_7_c_2592_p N_VDD_c_10617_n ) capacitor c=0.00208087f \
 //x=32.595 //y=5.38 //x2=32.555 //y2=7.585
cc_2304 ( N_noxref_7_c_2594_p N_VDD_c_10617_n ) capacitor c=4.23719e-19 \
 //x=32.2 //y=5.38 //x2=32.555 //y2=7.585
cc_2305 ( N_noxref_7_c_2595_p N_VDD_c_10617_n ) capacitor c=5.77976e-19 \
 //x=32.2 //y=5.56 //x2=32.555 //y2=7.585
cc_2306 ( N_noxref_7_c_2616_p N_VDD_c_10617_n ) capacitor c=0.0136705f \
 //x=32.2 //y=5.56 //x2=32.555 //y2=7.585
cc_2307 ( N_noxref_7_c_2596_p N_VDD_c_10622_n ) capacitor c=6.28113e-19 \
 //x=34.53 //y=4.88 //x2=35.005 //y2=7.585
cc_2308 ( N_noxref_7_M86_noxref_g N_VDD_c_10622_n ) capacitor c=0.00732618f \
 //x=34.43 //y=6.2 //x2=35.005 //y2=7.585
cc_2309 ( N_noxref_7_M87_noxref_g N_VDD_c_10622_n ) capacitor c=0.00755544f \
 //x=34.87 //y=6.2 //x2=35.005 //y2=7.585
cc_2310 ( N_noxref_7_c_2539_n N_VDD_c_10575_n ) capacitor c=0.0013228f \
 //x=32.68 //y=5.295 //x2=30.09 //y2=7.585
cc_2311 ( N_noxref_7_c_2541_n N_VDD_c_10575_n ) capacitor c=4.91377e-19 \
 //x=31.32 //y=5.56 //x2=30.09 //y2=7.585
cc_2312 ( N_noxref_7_c_2553_n N_VDD_c_10575_n ) capacitor c=0.0064135f \
 //x=31.32 //y=5.56 //x2=30.09 //y2=7.585
cc_2313 ( N_noxref_7_c_2539_n N_VDD_c_10628_n ) capacitor c=0.0285805f \
 //x=32.68 //y=5.295 //x2=33.42 //y2=7.585
cc_2314 ( N_noxref_7_c_2594_p N_VDD_c_10628_n ) capacitor c=0.00240948f \
 //x=32.2 //y=5.38 //x2=33.42 //y2=7.585
cc_2315 ( N_noxref_7_c_2595_p N_VDD_c_10628_n ) capacitor c=4.09141e-19 \
 //x=32.2 //y=5.56 //x2=33.42 //y2=7.585
cc_2316 ( N_noxref_7_c_2596_p N_VDD_c_10628_n ) capacitor c=0.00508547f \
 //x=34.53 //y=4.88 //x2=33.42 //y2=7.585
cc_2317 ( N_noxref_7_c_2565_p N_VDD_c_10628_n ) capacitor c=0.005822f \
 //x=34.532 //y=4.74 //x2=33.42 //y2=7.585
cc_2318 ( N_noxref_7_c_2616_p N_VDD_c_10628_n ) capacitor c=0.0101861f \
 //x=32.2 //y=5.56 //x2=33.42 //y2=7.585
cc_2319 ( N_noxref_7_c_2597_p N_VDD_c_10628_n ) capacitor c=0.00370494f \
 //x=34.53 //y=4.88 //x2=33.42 //y2=7.585
cc_2320 ( N_noxref_7_c_2600_p N_VDD_c_10628_n ) capacitor c=0.0129564f \
 //x=34.53 //y=4.88 //x2=33.42 //y2=7.585
cc_2321 ( N_noxref_7_c_2541_n N_VDD_M82_noxref_s ) capacitor c=0.0572211f \
 //x=31.32 //y=5.56 //x2=30.745 //y2=5.2
cc_2322 ( N_noxref_7_c_2594_p N_VDD_M82_noxref_s ) capacitor c=6.52457e-19 \
 //x=32.2 //y=5.38 //x2=30.745 //y2=5.2
cc_2323 ( N_noxref_7_c_2553_n N_VDD_M82_noxref_s ) capacitor c=0.0887533f \
 //x=31.32 //y=5.56 //x2=30.745 //y2=5.2
cc_2324 ( N_noxref_7_c_2534_n N_VDD_M83_noxref_d ) capacitor c=0.00734094f \
 //x=32.085 //y=5.38 //x2=31.615 //y2=5.2
cc_2325 ( N_noxref_7_c_2541_n N_VDD_M83_noxref_d ) capacitor c=0.0043528f \
 //x=31.32 //y=5.56 //x2=31.615 //y2=5.2
cc_2326 ( N_noxref_7_c_2595_p N_VDD_M83_noxref_d ) capacitor c=0.0043528f \
 //x=32.2 //y=5.56 //x2=31.615 //y2=5.2
cc_2327 ( N_noxref_7_c_2553_n N_VDD_M83_noxref_d ) capacitor c=0.065554f \
 //x=31.32 //y=5.56 //x2=31.615 //y2=5.2
cc_2328 ( N_noxref_7_c_2616_p N_VDD_M83_noxref_d ) capacitor c=0.065554f \
 //x=32.2 //y=5.56 //x2=31.615 //y2=5.2
cc_2329 ( N_noxref_7_c_2592_p N_VDD_M85_noxref_d ) capacitor c=0.00934027f \
 //x=32.595 //y=5.38 //x2=32.495 //y2=5.2
cc_2330 ( N_noxref_7_c_2595_p N_VDD_M85_noxref_d ) capacitor c=0.00587834f \
 //x=32.2 //y=5.56 //x2=32.495 //y2=5.2
cc_2331 ( N_noxref_7_c_2551_n N_VDD_M85_noxref_d ) capacitor c=9.65951e-19 \
 //x=32.68 //y=3.51 //x2=32.495 //y2=5.2
cc_2332 ( N_noxref_7_c_2616_p N_VDD_M85_noxref_d ) capacitor c=0.065554f \
 //x=32.2 //y=5.56 //x2=32.495 //y2=5.2
cc_2333 ( N_noxref_7_c_2592_p N_VDD_M86_noxref_s ) capacitor c=0.00326953f \
 //x=32.595 //y=5.38 //x2=34.075 //y2=5.2
cc_2334 ( N_noxref_7_c_2564_p N_VDD_M86_noxref_s ) capacitor c=0.00111275f \
 //x=34.53 //y=3.67 //x2=34.075 //y2=5.2
cc_2335 ( N_noxref_7_c_2594_p N_VDD_M86_noxref_s ) capacitor c=0.00515461f \
 //x=32.2 //y=5.38 //x2=34.075 //y2=5.2
cc_2336 ( N_noxref_7_c_2595_p N_VDD_M86_noxref_s ) capacitor c=3.28075e-19 \
 //x=32.2 //y=5.56 //x2=34.075 //y2=5.2
cc_2337 ( N_noxref_7_M86_noxref_g N_VDD_M86_noxref_s ) capacitor c=0.0567929f \
 //x=34.43 //y=6.2 //x2=34.075 //y2=5.2
cc_2338 ( N_noxref_7_M87_noxref_g N_VDD_M87_noxref_d ) capacitor c=0.015318f \
 //x=34.87 //y=6.2 //x2=34.945 //y2=5.2
cc_2339 ( N_noxref_7_c_2584_p N_GND_c_12588_n ) capacitor c=0.00618782f \
 //x=32.595 //y=1.835 //x2=34.515 //y2=0.175
cc_2340 ( N_noxref_7_c_2558_p N_GND_c_12588_n ) capacitor c=2.92483e-19 \
 //x=32.68 //y=3.67 //x2=34.515 //y2=0.175
cc_2341 ( N_noxref_7_c_2550_n N_GND_c_12588_n ) capacitor c=0.00937893f \
 //x=32.24 //y=1.18 //x2=34.515 //y2=0.175
cc_2342 ( N_noxref_7_M19_noxref_d N_GND_c_12588_n ) capacitor c=3.01769e-19 \
 //x=32.05 //y=1.085 //x2=34.515 //y2=0.175
cc_2343 ( N_noxref_7_c_2541_n N_GND_c_12553_n ) capacitor c=7.57776e-19 \
 //x=31.32 //y=5.56 //x2=31.27 //y2=1.135
cc_2344 ( N_noxref_7_c_2550_n N_GND_c_12553_n ) capacitor c=0.0140087f \
 //x=32.24 //y=1.18 //x2=31.27 //y2=1.135
cc_2345 ( N_noxref_7_M19_noxref_d N_GND_c_12553_n ) capacitor c=2.93544e-19 \
 //x=32.05 //y=1.085 //x2=31.27 //y2=1.135
cc_2346 ( N_noxref_7_c_2550_n N_GND_c_12595_n ) capacitor c=0.00549186f \
 //x=32.24 //y=1.18 //x2=34.6 //y2=1.135
cc_2347 ( N_noxref_7_c_2650_p N_GND_c_12595_n ) capacitor c=0.00667419f \
 //x=34.53 //y=2.26 //x2=34.6 //y2=1.135
cc_2348 ( N_noxref_7_c_2659_p N_GND_c_12595_n ) capacitor c=2.13705e-19 \
 //x=34.53 //y=2.26 //x2=34.6 //y2=1.135
cc_2349 ( N_noxref_7_c_2684_p N_GND_c_12595_n ) capacitor c=0.00171023f \
 //x=34.335 //y=1.045 //x2=34.6 //y2=1.135
cc_2350 ( N_noxref_7_c_2685_p N_GND_c_12595_n ) capacitor c=0.00357815f \
 //x=34.335 //y=1.39 //x2=34.6 //y2=1.135
cc_2351 ( N_noxref_7_c_2687_p N_GND_c_12595_n ) capacitor c=4.2764e-19 \
 //x=34.335 //y=1.7 //x2=34.6 //y2=1.135
cc_2352 ( N_noxref_7_c_2774_p N_GND_c_12595_n ) capacitor c=9.36995e-19 \
 //x=34.71 //y=0.89 //x2=34.6 //y2=1.135
cc_2353 ( N_noxref_7_c_2775_p N_GND_c_12595_n ) capacitor c=6.38426e-19 \
 //x=34.71 //y=1.545 //x2=34.6 //y2=1.135
cc_2354 ( N_noxref_7_c_2686_p N_GND_c_12595_n ) capacitor c=0.00171721f \
 //x=34.865 //y=1.045 //x2=34.6 //y2=1.135
cc_2355 ( N_noxref_7_c_2688_p N_GND_c_12595_n ) capacitor c=0.00296337f \
 //x=34.865 //y=1.39 //x2=34.6 //y2=1.135
cc_2356 ( N_noxref_7_c_2684_p N_GND_c_12605_n ) capacitor c=3.46594e-19 \
 //x=34.335 //y=1.045 //x2=34.597 //y2=1.005
cc_2357 ( N_noxref_7_c_2774_p N_GND_c_12605_n ) capacitor c=0.00839795f \
 //x=34.71 //y=0.89 //x2=34.597 //y2=1.005
cc_2358 ( N_noxref_7_c_2686_p N_GND_c_12605_n ) capacitor c=4.40641e-19 \
 //x=34.865 //y=1.045 //x2=34.597 //y2=1.005
cc_2359 ( N_noxref_7_c_2584_p N_GND_c_12568_n ) capacitor c=7.75992e-19 \
 //x=32.595 //y=1.835 //x2=33.25 //y2=0.175
cc_2360 ( N_noxref_7_c_2558_p N_GND_c_12568_n ) capacitor c=3.21489e-19 \
 //x=32.68 //y=3.67 //x2=33.25 //y2=0.175
cc_2361 ( N_noxref_7_c_2684_p N_GND_c_12610_n ) capacitor c=0.00688027f \
 //x=34.335 //y=1.045 //x2=36.58 //y2=0.175
cc_2362 ( N_noxref_7_c_2537_n N_GND_c_12573_n ) capacitor c=9.32616e-19 \
 //x=32.68 //y=3.35 //x2=30.09 //y2=0.175
cc_2363 ( N_noxref_7_c_2535_n N_GND_c_12612_n ) capacitor c=0.002973f \
 //x=32.24 //y=1.75 //x2=33.42 //y2=0.175
cc_2364 ( N_noxref_7_c_2584_p N_GND_c_12612_n ) capacitor c=0.0287405f \
 //x=32.595 //y=1.835 //x2=33.42 //y2=0.175
cc_2365 ( N_noxref_7_c_2573_p N_GND_c_12612_n ) capacitor c=0.00718667f \
 //x=34.53 //y=3.35 //x2=33.42 //y2=0.175
cc_2366 ( N_noxref_7_c_2650_p N_GND_c_12612_n ) capacitor c=0.00427323f \
 //x=34.53 //y=2.26 //x2=33.42 //y2=0.175
cc_2367 ( N_noxref_7_c_2659_p N_GND_c_12612_n ) capacitor c=0.0038607f \
 //x=34.53 //y=2.26 //x2=33.42 //y2=0.175
cc_2368 ( N_noxref_7_c_2687_p N_GND_c_12612_n ) capacitor c=0.0015404f \
 //x=34.335 //y=1.7 //x2=33.42 //y2=0.175
cc_2369 ( N_noxref_7_c_2666_p N_GND_c_12612_n ) capacitor c=0.00906518f \
 //x=34.335 //y=2.095 //x2=33.42 //y2=0.175
cc_2370 ( N_noxref_7_c_2550_n N_GND_M18_noxref_d ) capacitor c=2.82748e-19 \
 //x=32.24 //y=1.18 //x2=31.08 //y2=1.045
cc_2371 ( N_noxref_7_c_2650_p N_GND_M20_noxref_d ) capacitor c=2.20438e-19 \
 //x=34.53 //y=2.26 //x2=34.41 //y2=1.045
cc_2372 ( N_noxref_7_c_2684_p N_GND_M20_noxref_d ) capacitor c=0.00192399f \
 //x=34.335 //y=1.045 //x2=34.41 //y2=1.045
cc_2373 ( N_noxref_7_c_2685_p N_GND_M20_noxref_d ) capacitor c=0.00210798f \
 //x=34.335 //y=1.39 //x2=34.41 //y2=1.045
cc_2374 ( N_noxref_7_c_2774_p N_GND_M20_noxref_d ) capacitor c=0.00472259f \
 //x=34.71 //y=0.89 //x2=34.41 //y2=1.045
cc_2375 ( N_noxref_7_c_2775_p N_GND_M20_noxref_d ) capacitor c=0.00166857f \
 //x=34.71 //y=1.545 //x2=34.41 //y2=1.045
cc_2376 ( N_noxref_7_c_2686_p N_GND_M20_noxref_d ) capacitor c=0.00230174f \
 //x=34.865 //y=1.045 //x2=34.41 //y2=1.045
cc_2377 ( N_noxref_7_c_2688_p N_GND_M20_noxref_d ) capacitor c=0.00210798f \
 //x=34.865 //y=1.39 //x2=34.41 //y2=1.045
cc_2378 ( N_noxref_7_c_2536_n N_noxref_39_c_14515_n ) capacitor c=0.00911498f \
 //x=32.325 //y=1.835 //x2=31.755 //y2=1.675
cc_2379 ( N_noxref_7_c_2584_p N_noxref_39_c_14520_n ) capacitor c=0.00399245f \
 //x=32.595 //y=1.835 //x2=32.64 //y2=0.71
cc_2380 ( N_noxref_7_c_2550_n N_noxref_39_c_14520_n ) capacitor c=0.003751f \
 //x=32.24 //y=1.18 //x2=32.64 //y2=0.71
cc_2381 ( N_noxref_7_M19_noxref_d N_noxref_39_c_14520_n ) capacitor \
 c=0.00910163f //x=32.05 //y=1.085 //x2=32.64 //y2=0.71
cc_2382 ( N_noxref_7_c_2535_n N_noxref_39_M18_noxref_s ) capacitor \
 c=0.0162484f //x=32.24 //y=1.75 //x2=30.65 //y2=0.545
cc_2383 ( N_noxref_7_c_2584_p N_noxref_39_M18_noxref_s ) capacitor \
 c=0.00640979f //x=32.595 //y=1.835 //x2=30.65 //y2=0.545
cc_2384 ( N_noxref_7_c_2558_p N_noxref_39_M18_noxref_s ) capacitor \
 c=4.17069e-19 //x=32.68 //y=3.67 //x2=30.65 //y2=0.545
cc_2385 ( N_noxref_7_c_2550_n N_noxref_39_M18_noxref_s ) capacitor \
 c=0.00905169f //x=32.24 //y=1.18 //x2=30.65 //y2=0.545
cc_2386 ( N_noxref_7_c_2551_n N_noxref_39_M18_noxref_s ) capacitor \
 c=0.0010514f //x=32.68 //y=3.51 //x2=30.65 //y2=0.545
cc_2387 ( N_noxref_7_M19_noxref_d N_noxref_39_M18_noxref_s ) capacitor \
 c=0.0275552f //x=32.05 //y=1.085 //x2=30.65 //y2=0.545
cc_2388 ( N_noxref_7_c_2666_p N_noxref_40_c_14576_n ) capacitor c=0.00262672f \
 //x=34.335 //y=2.095 //x2=34.115 //y2=1.675
cc_2389 ( N_noxref_7_c_2564_p N_noxref_40_c_14577_n ) capacitor c=0.00402188f \
 //x=34.53 //y=3.67 //x2=35 //y2=1.76
cc_2390 ( N_noxref_7_c_2650_p N_noxref_40_c_14577_n ) capacitor c=0.00509504f \
 //x=34.53 //y=2.26 //x2=35 //y2=1.76
cc_2391 ( N_noxref_7_c_2659_p N_noxref_40_c_14577_n ) capacitor c=0.00763108f \
 //x=34.53 //y=2.26 //x2=35 //y2=1.76
cc_2392 ( N_noxref_7_c_2687_p N_noxref_40_c_14577_n ) capacitor c=0.00697076f \
 //x=34.335 //y=1.7 //x2=35 //y2=1.76
cc_2393 ( N_noxref_7_c_2666_p N_noxref_40_c_14577_n ) capacitor c=0.017492f \
 //x=34.335 //y=2.095 //x2=35 //y2=1.76
cc_2394 ( N_noxref_7_c_2775_p N_noxref_40_c_14577_n ) capacitor c=0.00723574f \
 //x=34.71 //y=1.545 //x2=35 //y2=1.76
cc_2395 ( N_noxref_7_c_2688_p N_noxref_40_c_14577_n ) capacitor c=0.00339872f \
 //x=34.865 //y=1.39 //x2=35 //y2=1.76
cc_2396 ( N_noxref_7_c_2666_p N_noxref_40_c_14584_n ) capacitor c=6.71402e-19 \
 //x=34.335 //y=2.095 //x2=35.085 //y2=1.675
cc_2397 ( N_noxref_7_c_2684_p N_noxref_40_M20_noxref_s ) capacitor \
 c=0.0294925f //x=34.335 //y=1.045 //x2=33.98 //y2=0.545
cc_2398 ( N_noxref_7_c_2687_p N_noxref_40_M20_noxref_s ) capacitor \
 c=3.48408e-19 //x=34.335 //y=1.7 //x2=33.98 //y2=0.545
cc_2399 ( N_noxref_7_c_2686_p N_noxref_40_M20_noxref_s ) capacitor \
 c=0.0125442f //x=34.865 //y=1.045 //x2=33.98 //y2=0.545
cc_2400 ( N_noxref_8_M91_noxref_g N_noxref_9_c_3313_n ) capacitor \
 c=0.00889217f //x=38.2 //y=6.2 //x2=38.745 //y2=5.38
cc_2401 ( N_noxref_8_c_2935_p N_noxref_9_c_3314_n ) capacitor c=0.00247001f \
 //x=37.86 //y=3.725 //x2=39.34 //y2=3.705
cc_2402 ( N_noxref_8_c_2936_p N_noxref_9_c_3315_n ) capacitor c=0.00145756f \
 //x=37.862 //y=4.74 //x2=39.34 //y2=5.295
cc_2403 ( N_noxref_8_c_2937_p N_noxref_9_c_3316_n ) capacitor c=8.193e-19 \
 //x=37.86 //y=4.045 //x2=37.98 //y2=5.56
cc_2404 ( N_noxref_8_c_2938_p N_noxref_9_c_3316_n ) capacitor c=0.0117744f \
 //x=37.86 //y=4.88 //x2=37.98 //y2=5.56
cc_2405 ( N_noxref_8_c_2939_p N_noxref_9_c_3316_n ) capacitor c=0.00277154f \
 //x=37.86 //y=4.88 //x2=37.98 //y2=5.56
cc_2406 ( N_noxref_8_M90_noxref_g N_noxref_9_c_3316_n ) capacitor \
 c=0.00201806f //x=37.76 //y=6.2 //x2=37.98 //y2=5.56
cc_2407 ( N_noxref_8_M91_noxref_g N_noxref_9_c_3316_n ) capacitor \
 c=0.00192712f //x=38.2 //y=6.2 //x2=37.98 //y2=5.56
cc_2408 ( N_noxref_8_c_2942_p N_noxref_9_c_3316_n ) capacitor c=0.00187457f \
 //x=37.86 //y=4.88 //x2=37.98 //y2=5.56
cc_2409 ( N_noxref_8_c_2943_p N_noxref_9_c_3322_n ) capacitor c=0.00251935f \
 //x=37.86 //y=3.88 //x2=39.34 //y2=3.88
cc_2410 ( N_noxref_8_c_2932_n N_noxref_9_c_3323_n ) capacitor c=0.00488914f \
 //x=34.74 //y=3.895 //x2=39.5 //y2=3.865
cc_2411 ( N_noxref_8_c_2937_p N_noxref_9_c_3324_n ) capacitor c=2.39213e-19 \
 //x=37.86 //y=4.045 //x2=37.98 //y2=5.56
cc_2412 ( N_noxref_8_c_2938_p N_noxref_9_c_3324_n ) capacitor c=0.00104426f \
 //x=37.86 //y=4.88 //x2=37.98 //y2=5.56
cc_2413 ( N_noxref_8_c_2939_p N_noxref_9_c_3324_n ) capacitor c=0.00377369f \
 //x=37.86 //y=4.88 //x2=37.98 //y2=5.56
cc_2414 ( N_noxref_8_M90_noxref_g N_noxref_9_c_3324_n ) capacitor c=0.0158358f \
 //x=37.76 //y=6.2 //x2=37.98 //y2=5.56
cc_2415 ( N_noxref_8_M91_noxref_g N_noxref_9_c_3324_n ) capacitor c=0.0178987f \
 //x=38.2 //y=6.2 //x2=37.98 //y2=5.56
cc_2416 ( N_noxref_8_c_2942_p N_noxref_9_c_3324_n ) capacitor c=0.0043218f \
 //x=37.86 //y=4.88 //x2=37.98 //y2=5.56
cc_2417 ( N_noxref_8_c_2900_n N_noxref_10_c_3598_n ) capacitor c=4.05935e-19 \
 //x=31.41 //y=3.89 //x2=31.94 //y2=4.095
cc_2418 ( N_noxref_8_c_2922_n N_noxref_10_c_3598_n ) capacitor c=0.0228971f \
 //x=32.16 //y=3.87 //x2=31.94 //y2=4.095
cc_2419 ( N_noxref_8_c_2900_n N_noxref_10_c_3606_n ) capacitor c=0.00219434f \
 //x=31.41 //y=3.89 //x2=31.94 //y2=4.415
cc_2420 ( N_noxref_8_c_2922_n N_noxref_10_c_3606_n ) capacitor c=0.00450788f \
 //x=32.16 //y=3.87 //x2=31.94 //y2=4.415
cc_2421 ( N_noxref_8_c_2935_p N_noxref_10_c_3668_n ) capacitor c=0.0190565f \
 //x=37.86 //y=3.725 //x2=36.01 //y2=4.105
cc_2422 ( N_noxref_8_c_2937_p N_noxref_10_c_3668_n ) capacitor c=0.00254581f \
 //x=37.86 //y=4.045 //x2=36.01 //y2=4.105
cc_2423 ( N_noxref_8_c_2957_p N_noxref_10_c_3668_n ) capacitor c=0.00454683f \
 //x=37.86 //y=2.26 //x2=36.01 //y2=4.105
cc_2424 ( N_noxref_8_c_2936_p N_noxref_10_c_3668_n ) capacitor c=0.00103966f \
 //x=37.862 //y=4.74 //x2=36.01 //y2=4.105
cc_2425 ( N_noxref_8_c_2932_n N_noxref_10_c_3668_n ) capacitor c=0.0267862f \
 //x=34.74 //y=3.895 //x2=36.01 //y2=4.105
cc_2426 ( N_noxref_8_c_2936_p N_noxref_10_c_3738_n ) capacitor c=0.00233357f \
 //x=37.862 //y=4.74 //x2=36.01 //y2=4.425
cc_2427 ( N_noxref_8_c_2932_n N_noxref_10_c_3738_n ) capacitor c=0.00650588f \
 //x=34.74 //y=3.895 //x2=36.01 //y2=4.425
cc_2428 ( N_noxref_8_c_2938_p N_noxref_10_c_3671_n ) capacitor c=0.00413257f \
 //x=37.86 //y=4.88 //x2=36.01 //y2=5.295
cc_2429 ( N_noxref_8_c_2936_p N_noxref_10_c_3671_n ) capacitor c=0.00266367f \
 //x=37.862 //y=4.74 //x2=36.01 //y2=5.295
cc_2430 ( N_noxref_8_c_2861_n N_noxref_10_c_3616_n ) capacitor c=0.00127339f \
 //x=26.02 //y=4.04 //x2=25.635 //y2=4.25
cc_2431 ( N_noxref_8_c_2863_n N_noxref_10_c_3616_n ) capacitor c=3.11164e-19 \
 //x=26.02 //y=5.25 //x2=25.635 //y2=4.25
cc_2432 ( N_noxref_8_c_2887_n N_noxref_10_c_3616_n ) capacitor c=0.0358254f \
 //x=26.18 //y=3.88 //x2=25.635 //y2=4.25
cc_2433 ( N_noxref_8_c_2861_n N_noxref_10_c_3620_n ) capacitor c=0.00757046f \
 //x=26.02 //y=4.04 //x2=26.235 //y2=4.265
cc_2434 ( N_noxref_8_c_2863_n N_noxref_10_c_3620_n ) capacitor c=0.0226561f \
 //x=26.02 //y=5.25 //x2=26.235 //y2=4.265
cc_2435 ( N_noxref_8_c_2885_n N_noxref_10_c_3620_n ) capacitor c=0.127147f \
 //x=27.705 //y=3.88 //x2=26.235 //y2=4.265
cc_2436 ( N_noxref_8_c_2872_n N_noxref_10_c_3621_n ) capacitor c=0.00324642f \
 //x=27.87 //y=4.04 //x2=27.48 //y2=4.25
cc_2437 ( N_noxref_8_c_2883_n N_noxref_10_c_3621_n ) capacitor c=4.98743e-19 \
 //x=27.872 //y=4.74 //x2=27.48 //y2=4.25
cc_2438 ( N_noxref_8_c_2885_n N_noxref_10_c_3621_n ) capacitor c=0.0107932f \
 //x=27.705 //y=3.88 //x2=27.48 //y2=4.25
cc_2439 ( N_noxref_8_c_2892_n N_noxref_10_c_3621_n ) capacitor c=0.0358254f \
 //x=29.215 //y=3.895 //x2=27.48 //y2=4.25
cc_2440 ( N_noxref_8_c_2872_n N_noxref_10_c_3622_n ) capacitor c=0.00240423f \
 //x=27.87 //y=4.04 //x2=28.08 //y2=4.265
cc_2441 ( N_noxref_8_c_2883_n N_noxref_10_c_3622_n ) capacitor c=0.0221402f \
 //x=27.872 //y=4.74 //x2=28.08 //y2=4.265
cc_2442 ( N_noxref_8_c_2892_n N_noxref_10_c_3622_n ) capacitor c=0.0116221f \
 //x=29.215 //y=3.895 //x2=28.08 //y2=4.265
cc_2443 ( N_noxref_8_c_2922_n N_noxref_10_c_3685_n ) capacitor c=0.0811622f \
 //x=32.16 //y=3.87 //x2=35.84 //y2=4.25
cc_2444 ( N_noxref_8_c_2925_n N_noxref_10_c_3685_n ) capacitor c=0.11052f \
 //x=32.9 //y=3.895 //x2=35.84 //y2=4.25
cc_2445 ( N_noxref_8_c_2928_n N_noxref_10_c_3685_n ) capacitor c=0.0564053f \
 //x=34.14 //y=3.88 //x2=35.84 //y2=4.25
cc_2446 ( N_noxref_8_c_2932_n N_noxref_10_c_3685_n ) capacitor c=0.0852213f \
 //x=34.74 //y=3.895 //x2=35.84 //y2=4.25
cc_2447 ( N_noxref_8_c_2883_n N_noxref_10_c_3623_n ) capacitor c=3.14882e-19 \
 //x=27.872 //y=4.74 //x2=32.105 //y2=4.25
cc_2448 ( N_noxref_8_c_2889_n N_noxref_10_c_3623_n ) capacitor c=0.111441f \
 //x=29.56 //y=3.895 //x2=32.105 //y2=4.25
cc_2449 ( N_noxref_8_c_2892_n N_noxref_10_c_3623_n ) capacitor c=0.131615f \
 //x=29.215 //y=3.895 //x2=32.105 //y2=4.25
cc_2450 ( N_noxref_8_c_2896_n N_noxref_10_c_3623_n ) capacitor c=0.055806f \
 //x=30.81 //y=3.88 //x2=32.105 //y2=4.25
cc_2451 ( N_noxref_8_c_2900_n N_noxref_10_c_3623_n ) capacitor c=0.0237381f \
 //x=31.41 //y=3.89 //x2=32.105 //y2=4.25
cc_2452 ( N_noxref_8_c_2922_n N_noxref_10_c_3623_n ) capacitor c=0.0358686f \
 //x=32.16 //y=3.87 //x2=32.105 //y2=4.25
cc_2453 ( N_noxref_8_c_2937_p N_noxref_10_c_3765_n ) capacitor c=0.00248847f \
 //x=37.86 //y=4.045 //x2=38.075 //y2=4.27
cc_2454 ( N_noxref_8_c_2936_p N_noxref_10_c_3765_n ) capacitor c=0.0222301f \
 //x=37.862 //y=4.74 //x2=38.075 //y2=4.27
cc_2455 ( N_noxref_8_c_2937_p N_noxref_10_c_3767_n ) capacitor c=0.00322776f \
 //x=37.86 //y=4.045 //x2=37.73 //y2=4.27
cc_2456 ( N_noxref_8_c_2936_p N_noxref_10_c_3767_n ) capacitor c=0.00208639f \
 //x=37.862 //y=4.74 //x2=37.73 //y2=4.27
cc_2457 ( N_noxref_8_c_2932_n N_noxref_10_c_3767_n ) capacitor c=0.207673f \
 //x=34.74 //y=3.895 //x2=37.73 //y2=4.27
cc_2458 ( N_noxref_8_c_2992_p N_noxref_10_M72_noxref_g ) capacitor \
 c=0.00461408f //x=23.482 //y=5.335 //x2=23.26 //y2=6.2
cc_2459 ( N_noxref_8_c_2993_p N_noxref_10_M72_noxref_g ) capacitor \
 c=0.0162284f //x=23.48 //y=5.56 //x2=23.26 //y2=6.2
cc_2460 ( N_noxref_8_c_2994_p N_noxref_10_M73_noxref_g ) capacitor \
 c=0.00893512f //x=24.24 //y=5.335 //x2=23.7 //y2=6.2
cc_2461 ( N_noxref_8_c_2992_p N_noxref_10_M73_noxref_g ) capacitor \
 c=0.00229208f //x=23.482 //y=5.335 //x2=23.7 //y2=6.2
cc_2462 ( N_noxref_8_c_2993_p N_noxref_10_M73_noxref_g ) capacitor \
 c=0.0179041f //x=23.48 //y=5.56 //x2=23.7 //y2=6.2
cc_2463 ( N_noxref_8_c_2992_p N_noxref_10_c_3775_n ) capacitor c=0.00171885f \
 //x=23.482 //y=5.335 //x2=23.625 //y2=4.97
cc_2464 ( N_noxref_8_c_2993_p N_noxref_10_c_3775_n ) capacitor c=0.00291477f \
 //x=23.48 //y=5.56 //x2=23.625 //y2=4.97
cc_2465 ( N_noxref_8_c_2867_n D ) capacitor c=6.07513e-19 //x=27.87 //y=3.72 \
 //x2=28.61 //y2=2.77
cc_2466 ( N_noxref_8_c_2850_n N_D_c_4383_n ) capacitor c=6.75889e-19 //x=26.02 \
 //y=3.72 //x2=28.61 //y2=2.62
cc_2467 ( N_noxref_8_c_2867_n N_D_c_4383_n ) capacitor c=0.00959191f //x=27.87 \
 //y=3.72 //x2=28.61 //y2=2.62
cc_2468 ( N_noxref_8_c_3002_p N_D_c_4383_n ) capacitor c=3.49899e-19 //x=27.87 \
 //y=2.26 //x2=28.61 //y2=2.62
cc_2469 ( N_noxref_8_c_2867_n N_D_c_4385_n ) capacitor c=0.015428f //x=27.87 \
 //y=3.72 //x2=28.61 //y2=2.94
cc_2470 ( N_noxref_8_c_2850_n N_D_c_4392_n ) capacitor c=9.10012e-19 //x=26.02 \
 //y=3.72 //x2=28.61 //y2=4.735
cc_2471 ( N_noxref_8_c_2863_n N_D_c_4392_n ) capacitor c=0.00115385f //x=26.02 \
 //y=5.25 //x2=28.61 //y2=4.735
cc_2472 ( N_noxref_8_c_2867_n N_D_c_4392_n ) capacitor c=0.0299473f //x=27.87 \
 //y=3.72 //x2=28.61 //y2=4.735
cc_2473 ( N_noxref_8_c_2872_n N_D_c_4392_n ) capacitor c=0.0144744f //x=27.87 \
 //y=4.04 //x2=28.61 //y2=4.735
cc_2474 ( N_noxref_8_c_3008_p N_D_c_4392_n ) capacitor c=6.03895e-19 \
 //x=27.865 //y=3.88 //x2=28.61 //y2=4.735
cc_2475 ( N_noxref_8_c_2881_n N_D_c_4392_n ) capacitor c=0.0172863f //x=27.87 \
 //y=4.88 //x2=28.61 //y2=4.735
cc_2476 ( N_noxref_8_c_2883_n N_D_c_4392_n ) capacitor c=0.0261735f //x=27.872 \
 //y=4.74 //x2=28.61 //y2=4.735
cc_2477 ( N_noxref_8_c_2892_n N_D_c_4392_n ) capacitor c=0.0234438f //x=29.215 \
 //y=3.895 //x2=28.61 //y2=4.735
cc_2478 ( N_noxref_8_c_2907_n N_D_c_4392_n ) capacitor c=7.76143e-19 //x=27.87 \
 //y=4.88 //x2=28.61 //y2=4.735
cc_2479 ( N_noxref_8_c_2914_n N_D_c_4392_n ) capacitor c=0.00201171f //x=27.87 \
 //y=4.88 //x2=28.61 //y2=4.735
cc_2480 ( N_noxref_8_c_3014_p N_D_c_4400_n ) capacitor c=0.0205342f //x=27.87 \
 //y=2.26 //x2=28.61 //y2=2.26
cc_2481 ( N_noxref_8_c_3002_p N_D_c_4400_n ) capacitor c=5.16867e-19 //x=27.87 \
 //y=2.26 //x2=28.61 //y2=2.26
cc_2482 ( N_noxref_8_c_3016_p N_D_c_4400_n ) capacitor c=0.00167888f \
 //x=27.675 //y=2.095 //x2=28.61 //y2=2.26
cc_2483 ( N_noxref_8_c_2831_n N_D_c_4251_n ) capacitor c=5.10712e-19 \
 //x=25.535 //y=1.305 //x2=28.435 //y2=2.78
cc_2484 ( N_noxref_8_c_2849_n N_D_c_4251_n ) capacitor c=0.0140789f //x=25.62 \
 //y=1.845 //x2=28.435 //y2=2.78
cc_2485 ( N_noxref_8_c_2850_n N_D_c_4251_n ) capacitor c=0.0284931f //x=26.02 \
 //y=3.72 //x2=28.435 //y2=2.78
cc_2486 ( N_noxref_8_c_2867_n N_D_c_4251_n ) capacitor c=0.0267449f //x=27.87 \
 //y=3.72 //x2=28.435 //y2=2.78
cc_2487 ( N_noxref_8_c_3014_p N_D_c_4251_n ) capacitor c=0.00366055f //x=27.87 \
 //y=2.26 //x2=28.435 //y2=2.78
cc_2488 ( N_noxref_8_c_2867_n N_D_c_4407_n ) capacitor c=0.00337119f //x=27.87 \
 //y=3.72 //x2=28.755 //y2=2.78
cc_2489 ( N_noxref_8_c_2935_p N_D_c_4408_n ) capacitor c=0.0271873f //x=37.86 \
 //y=3.725 //x2=49.91 //y2=2.755
cc_2490 ( N_noxref_8_c_2957_p N_D_c_4408_n ) capacitor c=0.00366462f //x=37.86 \
 //y=2.26 //x2=49.91 //y2=2.755
cc_2491 ( N_noxref_8_c_2900_n N_D_c_4408_n ) capacitor c=0.00416312f //x=31.41 \
 //y=3.89 //x2=49.91 //y2=2.755
cc_2492 ( N_noxref_8_c_2922_n N_D_c_4408_n ) capacitor c=0.00141105f //x=32.16 \
 //y=3.87 //x2=49.91 //y2=2.755
cc_2493 ( N_noxref_8_c_2932_n N_D_c_4408_n ) capacitor c=0.0120453f //x=34.74 \
 //y=3.895 //x2=49.91 //y2=2.755
cc_2494 ( N_noxref_8_c_2867_n N_D_c_4415_n ) capacitor c=3.49899e-19 //x=27.87 \
 //y=3.72 //x2=28.61 //y2=2.26
cc_2495 ( N_noxref_8_c_3014_p N_D_c_4415_n ) capacitor c=5.24723e-19 //x=27.87 \
 //y=2.26 //x2=28.61 //y2=2.26
cc_2496 ( N_noxref_8_c_3002_p N_D_c_4415_n ) capacitor c=0.00485709f //x=27.87 \
 //y=2.26 //x2=28.61 //y2=2.26
cc_2497 ( N_noxref_8_c_3016_p N_D_c_4415_n ) capacitor c=0.00190888f \
 //x=27.675 //y=2.095 //x2=28.61 //y2=2.26
cc_2498 ( N_noxref_8_c_2881_n N_D_c_4416_n ) capacitor c=4.80626e-19 //x=27.87 \
 //y=4.88 //x2=28.64 //y2=4.88
cc_2499 ( N_noxref_8_c_2907_n N_D_c_4416_n ) capacitor c=0.00397338f //x=27.87 \
 //y=4.88 //x2=28.64 //y2=4.88
cc_2500 ( N_noxref_8_c_2914_n N_D_c_4416_n ) capacitor c=0.00283894f //x=27.87 \
 //y=4.88 //x2=28.64 //y2=4.88
cc_2501 ( N_noxref_8_M78_noxref_g N_D_M80_noxref_g ) capacitor c=0.0104892f \
 //x=27.77 //y=6.2 //x2=28.65 //y2=6.2
cc_2502 ( N_noxref_8_M79_noxref_g N_D_M80_noxref_g ) capacitor c=0.107636f \
 //x=28.21 //y=6.2 //x2=28.65 //y2=6.2
cc_2503 ( N_noxref_8_M79_noxref_g N_D_M81_noxref_g ) capacitor c=0.0100341f \
 //x=28.21 //y=6.2 //x2=29.09 //y2=6.2
cc_2504 ( N_noxref_8_c_3038_p N_D_c_4424_n ) capacitor c=4.86545e-19 \
 //x=27.675 //y=1.045 //x2=28.645 //y2=1.085
cc_2505 ( N_noxref_8_c_3039_p N_D_c_4424_n ) capacitor c=0.00152405f \
 //x=27.675 //y=1.39 //x2=28.645 //y2=1.085
cc_2506 ( N_noxref_8_c_3040_p N_D_c_4424_n ) capacitor c=0.0151475f //x=28.205 \
 //y=1.045 //x2=28.645 //y2=1.085
cc_2507 ( N_noxref_8_c_3041_p N_D_c_4426_n ) capacitor c=0.00109982f \
 //x=27.675 //y=1.7 //x2=28.645 //y2=1.43
cc_2508 ( N_noxref_8_c_3042_p N_D_c_4426_n ) capacitor c=0.0111064f //x=28.205 \
 //y=1.39 //x2=28.645 //y2=1.43
cc_2509 ( N_noxref_8_c_3041_p N_D_c_4429_n ) capacitor c=9.58243e-19 \
 //x=27.675 //y=1.7 //x2=28.645 //y2=1.74
cc_2510 ( N_noxref_8_c_3016_p N_D_c_4429_n ) capacitor c=0.00662747f \
 //x=27.675 //y=2.095 //x2=28.645 //y2=1.74
cc_2511 ( N_noxref_8_c_3042_p N_D_c_4429_n ) capacitor c=0.00862358f \
 //x=28.205 //y=1.39 //x2=28.645 //y2=1.74
cc_2512 ( N_noxref_8_c_3040_p N_D_c_4439_n ) capacitor c=0.00127211f \
 //x=28.205 //y=1.045 //x2=29.175 //y2=1.085
cc_2513 ( N_noxref_8_c_3042_p N_D_c_4441_n ) capacitor c=0.00204774f \
 //x=28.205 //y=1.39 //x2=29.175 //y2=1.43
cc_2514 ( N_noxref_8_c_3014_p N_D_c_4445_n ) capacitor c=0.00167305f //x=27.87 \
 //y=2.26 //x2=28.61 //y2=2.26
cc_2515 ( N_noxref_8_c_3002_p N_D_c_4445_n ) capacitor c=0.00266443f //x=27.87 \
 //y=2.26 //x2=28.61 //y2=2.26
cc_2516 ( N_noxref_8_c_3016_p N_D_c_4445_n ) capacitor c=0.0181449f //x=27.675 \
 //y=2.095 //x2=28.61 //y2=2.26
cc_2517 ( N_noxref_8_c_2881_n N_D_c_4448_n ) capacitor c=0.00158715f //x=27.87 \
 //y=4.88 //x2=28.64 //y2=4.88
cc_2518 ( N_noxref_8_c_2907_n N_D_c_4448_n ) capacitor c=0.00237977f //x=27.87 \
 //y=4.88 //x2=28.64 //y2=4.88
cc_2519 ( N_noxref_8_c_2914_n N_D_c_4448_n ) capacitor c=0.0297875f //x=27.87 \
 //y=4.88 //x2=28.64 //y2=4.88
cc_2520 ( N_noxref_8_c_2850_n CLK ) capacitor c=0.00224563f //x=26.02 //y=3.72 \
 //x2=24.17 //y2=3.51
cc_2521 ( N_noxref_8_c_2863_n CLK ) capacitor c=9.69745e-19 //x=26.02 //y=5.25 \
 //x2=24.17 //y2=3.51
cc_2522 ( N_noxref_8_c_2935_p CLK ) capacitor c=0.00202006f //x=37.86 \
 //y=3.725 //x2=35.27 //y2=3.51
cc_2523 ( N_noxref_8_c_2936_p CLK ) capacitor c=9.83618e-19 //x=37.862 \
 //y=4.74 //x2=35.27 //y2=3.51
cc_2524 ( N_noxref_8_c_2932_n CLK ) capacitor c=0.0236107f //x=34.74 //y=3.895 \
 //x2=35.27 //y2=3.51
cc_2525 ( N_noxref_8_c_2994_p N_CLK_c_5848_n ) capacitor c=0.0292733f \
 //x=24.24 //y=5.335 //x2=24.17 //y2=4.88
cc_2526 ( N_noxref_8_c_2863_n N_CLK_c_5848_n ) capacitor c=9.02672e-19 \
 //x=26.02 //y=5.25 //x2=24.17 //y2=4.88
cc_2527 ( N_noxref_8_c_3061_p N_CLK_c_5848_n ) capacitor c=0.00156871f \
 //x=24.36 //y=5.56 //x2=24.17 //y2=4.88
cc_2528 ( N_noxref_8_c_2994_p N_CLK_c_5851_n ) capacitor c=0.0106918f \
 //x=24.24 //y=5.335 //x2=24.17 //y2=4.88
cc_2529 ( N_noxref_8_c_2922_n N_CLK_c_5894_n ) capacitor c=0.00185444f \
 //x=32.16 //y=3.87 //x2=32.16 //y2=4.64
cc_2530 ( N_noxref_8_c_2826_n N_CLK_c_5852_n ) capacitor c=0.0205765f \
 //x=25.935 //y=5.335 //x2=31.815 //y2=4.64
cc_2531 ( N_noxref_8_c_2863_n N_CLK_c_5852_n ) capacitor c=0.0299085f \
 //x=26.02 //y=5.25 //x2=31.815 //y2=4.64
cc_2532 ( N_noxref_8_c_2992_p N_CLK_c_5852_n ) capacitor c=0.028072f \
 //x=23.482 //y=5.335 //x2=31.815 //y2=4.64
cc_2533 ( N_noxref_8_c_3067_p N_CLK_c_5852_n ) capacitor c=0.0381719f \
 //x=24.36 //y=5.335 //x2=31.815 //y2=4.64
cc_2534 ( N_noxref_8_c_2881_n N_CLK_c_5852_n ) capacitor c=0.00354963f \
 //x=27.87 //y=4.88 //x2=31.815 //y2=4.64
cc_2535 ( N_noxref_8_c_2883_n N_CLK_c_5852_n ) capacitor c=0.0265157f \
 //x=27.872 //y=4.74 //x2=31.815 //y2=4.64
cc_2536 ( N_noxref_8_c_2885_n N_CLK_c_5852_n ) capacitor c=0.00800202f \
 //x=27.705 //y=3.88 //x2=31.815 //y2=4.64
cc_2537 ( N_noxref_8_c_2889_n N_CLK_c_5852_n ) capacitor c=0.00652937f \
 //x=29.56 //y=3.895 //x2=31.815 //y2=4.64
cc_2538 ( N_noxref_8_c_2892_n N_CLK_c_5852_n ) capacitor c=0.0105302f \
 //x=29.215 //y=3.895 //x2=31.815 //y2=4.64
cc_2539 ( N_noxref_8_c_2896_n N_CLK_c_5852_n ) capacitor c=0.00366688f \
 //x=30.81 //y=3.88 //x2=31.815 //y2=4.64
cc_2540 ( N_noxref_8_c_2900_n N_CLK_c_5852_n ) capacitor c=0.00299053f \
 //x=31.41 //y=3.89 //x2=31.815 //y2=4.64
cc_2541 ( N_noxref_8_c_2936_p N_CLK_c_5947_n ) capacitor c=6.65875e-19 \
 //x=37.862 //y=4.74 //x2=36.215 //y2=4.65
cc_2542 ( N_noxref_8_c_2932_n N_CLK_c_5947_n ) capacitor c=0.00738559f \
 //x=34.74 //y=3.895 //x2=36.215 //y2=4.65
cc_2543 ( N_noxref_8_c_2922_n N_CLK_c_5897_n ) capacitor c=0.00441327f \
 //x=32.16 //y=3.87 //x2=35.87 //y2=4.65
cc_2544 ( N_noxref_8_c_2925_n N_CLK_c_5897_n ) capacitor c=0.00648f //x=32.9 \
 //y=3.895 //x2=35.87 //y2=4.65
cc_2545 ( N_noxref_8_c_2928_n N_CLK_c_5897_n ) capacitor c=0.00368716f \
 //x=34.14 //y=3.88 //x2=35.87 //y2=4.65
cc_2546 ( N_noxref_8_c_2932_n N_CLK_c_5897_n ) capacitor c=0.00888546f \
 //x=34.74 //y=3.895 //x2=35.87 //y2=4.65
cc_2547 ( N_noxref_8_c_2938_p N_CLK_c_5953_n ) capacitor c=0.00354132f \
 //x=37.86 //y=4.88 //x2=41.545 //y2=4.62
cc_2548 ( N_noxref_8_c_2936_p N_CLK_c_5953_n ) capacitor c=0.0263707f \
 //x=37.862 //y=4.74 //x2=41.545 //y2=4.62
cc_2549 ( N_noxref_8_c_2994_p N_CLK_c_5863_n ) capacitor c=0.00495283f \
 //x=24.24 //y=5.335 //x2=24.17 //y2=4.88
cc_2550 ( N_noxref_8_c_3067_p N_CLK_c_5863_n ) capacitor c=0.00132214f \
 //x=24.36 //y=5.335 //x2=24.17 //y2=4.88
cc_2551 ( N_noxref_8_c_2994_p N_CLK_M74_noxref_g ) capacitor c=0.00853188f \
 //x=24.24 //y=5.335 //x2=24.14 //y2=6.2
cc_2552 ( N_noxref_8_c_3067_p N_CLK_M74_noxref_g ) capacitor c=0.00229818f \
 //x=24.36 //y=5.335 //x2=24.14 //y2=6.2
cc_2553 ( N_noxref_8_c_3061_p N_CLK_M74_noxref_g ) capacitor c=0.0179041f \
 //x=24.36 //y=5.56 //x2=24.14 //y2=6.2
cc_2554 ( N_noxref_8_c_2822_n N_CLK_M75_noxref_g ) capacitor c=0.00955829f \
 //x=25.125 //y=5.335 //x2=24.58 //y2=6.2
cc_2555 ( N_noxref_8_c_3067_p N_CLK_M75_noxref_g ) capacitor c=0.00230699f \
 //x=24.36 //y=5.335 //x2=24.58 //y2=6.2
cc_2556 ( N_noxref_8_c_3061_p N_CLK_M75_noxref_g ) capacitor c=0.0179041f \
 //x=24.36 //y=5.56 //x2=24.58 //y2=6.2
cc_2557 ( N_noxref_8_c_3067_p N_CLK_c_5876_n ) capacitor c=0.0016987f \
 //x=24.36 //y=5.335 //x2=24.505 //y2=4.97
cc_2558 ( N_noxref_8_c_3061_p N_CLK_c_5876_n ) capacitor c=0.00294585f \
 //x=24.36 //y=5.56 //x2=24.505 //y2=4.97
cc_2559 ( N_noxref_8_c_2994_p N_CLK_c_5877_n ) capacitor c=3.4353e-19 \
 //x=24.24 //y=5.335 //x2=24.17 //y2=4.88
cc_2560 ( N_noxref_8_c_2935_p N_noxref_19_c_8542_n ) capacitor c=0.00532695f \
 //x=37.86 //y=3.725 //x2=38.6 //y2=2.485
cc_2561 ( N_noxref_8_c_2957_p N_noxref_19_c_8542_n ) capacitor c=0.0162421f \
 //x=37.86 //y=2.26 //x2=38.6 //y2=2.485
cc_2562 ( N_noxref_8_c_3096_p N_noxref_19_c_8542_n ) capacitor c=9.6719e-19 \
 //x=37.86 //y=2.26 //x2=38.6 //y2=2.485
cc_2563 ( N_noxref_8_c_3097_p N_noxref_19_c_8542_n ) capacitor c=0.00160758f \
 //x=37.665 //y=2.095 //x2=38.6 //y2=2.485
cc_2564 ( N_noxref_8_c_2935_p N_noxref_19_c_8546_n ) capacitor c=0.0519565f \
 //x=37.86 //y=3.725 //x2=38.6 //y2=4.735
cc_2565 ( N_noxref_8_c_2937_p N_noxref_19_c_8546_n ) capacitor c=0.0148501f \
 //x=37.86 //y=4.045 //x2=38.6 //y2=4.735
cc_2566 ( N_noxref_8_c_2943_p N_noxref_19_c_8546_n ) capacitor c=5.57251e-19 \
 //x=37.86 //y=3.88 //x2=38.6 //y2=4.735
cc_2567 ( N_noxref_8_c_2938_p N_noxref_19_c_8546_n ) capacitor c=0.0172863f \
 //x=37.86 //y=4.88 //x2=38.6 //y2=4.735
cc_2568 ( N_noxref_8_c_2936_p N_noxref_19_c_8546_n ) capacitor c=0.0256763f \
 //x=37.862 //y=4.74 //x2=38.6 //y2=4.735
cc_2569 ( N_noxref_8_c_2932_n N_noxref_19_c_8546_n ) capacitor c=0.00380919f \
 //x=34.74 //y=3.895 //x2=38.6 //y2=4.735
cc_2570 ( N_noxref_8_c_2939_p N_noxref_19_c_8546_n ) capacitor c=7.76099e-19 \
 //x=37.86 //y=4.88 //x2=38.6 //y2=4.735
cc_2571 ( N_noxref_8_c_2942_p N_noxref_19_c_8546_n ) capacitor c=0.00201171f \
 //x=37.86 //y=4.88 //x2=38.6 //y2=4.735
cc_2572 ( N_noxref_8_c_2935_p N_noxref_19_c_8554_n ) capacitor c=0.00229831f \
 //x=37.86 //y=3.725 //x2=38.585 //y2=2.325
cc_2573 ( N_noxref_8_c_2957_p N_noxref_19_c_8554_n ) capacitor c=0.00582695f \
 //x=37.86 //y=2.26 //x2=38.585 //y2=2.325
cc_2574 ( N_noxref_8_c_2957_p N_noxref_19_c_8556_n ) capacitor c=5.24723e-19 \
 //x=37.86 //y=2.26 //x2=38.6 //y2=2.26
cc_2575 ( N_noxref_8_c_3096_p N_noxref_19_c_8556_n ) capacitor c=0.00485115f \
 //x=37.86 //y=2.26 //x2=38.6 //y2=2.26
cc_2576 ( N_noxref_8_c_3097_p N_noxref_19_c_8556_n ) capacitor c=0.00267875f \
 //x=37.665 //y=2.095 //x2=38.6 //y2=2.26
cc_2577 ( N_noxref_8_c_2938_p N_noxref_19_c_8559_n ) capacitor c=4.80626e-19 \
 //x=37.86 //y=4.88 //x2=38.63 //y2=4.88
cc_2578 ( N_noxref_8_c_2939_p N_noxref_19_c_8559_n ) capacitor c=0.00397338f \
 //x=37.86 //y=4.88 //x2=38.63 //y2=4.88
cc_2579 ( N_noxref_8_c_2942_p N_noxref_19_c_8559_n ) capacitor c=0.00283894f \
 //x=37.86 //y=4.88 //x2=38.63 //y2=4.88
cc_2580 ( N_noxref_8_M90_noxref_g N_noxref_19_M92_noxref_g ) capacitor \
 c=0.0104892f //x=37.76 //y=6.2 //x2=38.64 //y2=6.2
cc_2581 ( N_noxref_8_M91_noxref_g N_noxref_19_M92_noxref_g ) capacitor \
 c=0.107636f //x=38.2 //y=6.2 //x2=38.64 //y2=6.2
cc_2582 ( N_noxref_8_M91_noxref_g N_noxref_19_M93_noxref_g ) capacitor \
 c=0.0100341f //x=38.2 //y=6.2 //x2=39.08 //y2=6.2
cc_2583 ( N_noxref_8_c_3117_p N_noxref_19_c_8565_n ) capacitor c=4.86545e-19 \
 //x=37.665 //y=1.045 //x2=38.635 //y2=1.085
cc_2584 ( N_noxref_8_c_3118_p N_noxref_19_c_8565_n ) capacitor c=0.00152405f \
 //x=37.665 //y=1.39 //x2=38.635 //y2=1.085
cc_2585 ( N_noxref_8_c_3119_p N_noxref_19_c_8565_n ) capacitor c=0.0151475f \
 //x=38.195 //y=1.045 //x2=38.635 //y2=1.085
cc_2586 ( N_noxref_8_c_3120_p N_noxref_19_c_8568_n ) capacitor c=0.00109982f \
 //x=37.665 //y=1.7 //x2=38.635 //y2=1.43
cc_2587 ( N_noxref_8_c_3121_p N_noxref_19_c_8568_n ) capacitor c=0.0111064f \
 //x=38.195 //y=1.39 //x2=38.635 //y2=1.43
cc_2588 ( N_noxref_8_c_3120_p N_noxref_19_c_8570_n ) capacitor c=9.58243e-19 \
 //x=37.665 //y=1.7 //x2=38.635 //y2=1.74
cc_2589 ( N_noxref_8_c_3097_p N_noxref_19_c_8570_n ) capacitor c=0.00662747f \
 //x=37.665 //y=2.095 //x2=38.635 //y2=1.74
cc_2590 ( N_noxref_8_c_3121_p N_noxref_19_c_8570_n ) capacitor c=0.00862358f \
 //x=38.195 //y=1.39 //x2=38.635 //y2=1.74
cc_2591 ( N_noxref_8_c_3119_p N_noxref_19_c_8573_n ) capacitor c=0.00127211f \
 //x=38.195 //y=1.045 //x2=39.165 //y2=1.085
cc_2592 ( N_noxref_8_c_3121_p N_noxref_19_c_8574_n ) capacitor c=0.00204774f \
 //x=38.195 //y=1.39 //x2=39.165 //y2=1.43
cc_2593 ( N_noxref_8_c_2957_p N_noxref_19_c_8575_n ) capacitor c=3.09823e-19 \
 //x=37.86 //y=2.26 //x2=38.6 //y2=2.26
cc_2594 ( N_noxref_8_c_3096_p N_noxref_19_c_8575_n ) capacitor c=0.00153237f \
 //x=37.86 //y=2.26 //x2=38.6 //y2=2.26
cc_2595 ( N_noxref_8_c_3097_p N_noxref_19_c_8575_n ) capacitor c=0.0173295f \
 //x=37.665 //y=2.095 //x2=38.6 //y2=2.26
cc_2596 ( N_noxref_8_c_2938_p N_noxref_19_c_8578_n ) capacitor c=0.00158715f \
 //x=37.86 //y=4.88 //x2=38.63 //y2=4.88
cc_2597 ( N_noxref_8_c_2939_p N_noxref_19_c_8578_n ) capacitor c=0.00237977f \
 //x=37.86 //y=4.88 //x2=38.63 //y2=4.88
cc_2598 ( N_noxref_8_c_2942_p N_noxref_19_c_8578_n ) capacitor c=0.0297875f \
 //x=37.86 //y=4.88 //x2=38.63 //y2=4.88
cc_2599 ( N_noxref_8_c_2839_n N_noxref_20_c_9276_n ) capacitor c=8.25606e-19 \
 //x=25.535 //y=1.76 //x2=21.125 //y2=1.835
cc_2600 ( N_noxref_8_c_2849_n N_noxref_20_c_9194_n ) capacitor c=8.25606e-19 \
 //x=25.62 //y=1.845 //x2=21.21 //y2=2.995
cc_2601 ( N_noxref_8_c_2992_p N_noxref_20_c_9196_n ) capacitor c=0.00261914f \
 //x=23.482 //y=5.335 //x2=21.21 //y2=5.295
cc_2602 ( N_noxref_8_c_2992_p N_noxref_20_c_9292_n ) capacitor c=5.0812e-19 \
 //x=23.482 //y=5.335 //x2=20.73 //y2=5.38
cc_2603 ( N_noxref_8_c_2850_n N_noxref_20_c_9316_n ) capacitor c=7.10551e-19 \
 //x=26.02 //y=3.72 //x2=25.5 //y2=3.125
cc_2604 ( N_noxref_8_c_2850_n N_noxref_20_c_9321_n ) capacitor c=0.0229846f \
 //x=26.02 //y=3.72 //x2=28.21 //y2=3.14
cc_2605 ( N_noxref_8_c_2867_n N_noxref_20_c_9321_n ) capacitor c=0.0240382f \
 //x=27.87 //y=3.72 //x2=28.21 //y2=3.14
cc_2606 ( N_noxref_8_c_2885_n N_noxref_20_c_9321_n ) capacitor c=0.0104473f \
 //x=27.705 //y=3.88 //x2=28.21 //y2=3.14
cc_2607 ( N_noxref_8_c_2892_n N_noxref_20_c_9321_n ) capacitor c=0.00733858f \
 //x=29.215 //y=3.895 //x2=28.21 //y2=3.14
cc_2608 ( N_noxref_8_c_2892_n N_noxref_20_c_9324_n ) capacitor c=0.00328565f \
 //x=29.215 //y=3.895 //x2=28.81 //y2=3.165
cc_2609 ( N_noxref_8_c_2889_n N_noxref_20_c_9327_n ) capacitor c=0.00614593f \
 //x=29.56 //y=3.895 //x2=29.56 //y2=3.125
cc_2610 ( N_noxref_8_c_2896_n N_noxref_20_c_9331_n ) capacitor c=0.00868637f \
 //x=30.81 //y=3.88 //x2=30.81 //y2=3.14
cc_2611 ( N_noxref_8_c_2900_n N_noxref_20_c_9334_n ) capacitor c=0.0254348f \
 //x=31.41 //y=3.89 //x2=31.41 //y2=3.12
cc_2612 ( N_noxref_8_c_2922_n N_noxref_20_c_9337_n ) capacitor c=0.0248572f \
 //x=32.16 //y=3.87 //x2=32.3 //y2=3.14
cc_2613 ( N_noxref_8_c_2925_n N_noxref_20_c_9338_n ) capacitor c=0.00855239f \
 //x=32.9 //y=3.895 //x2=32.9 //y2=3.125
cc_2614 ( N_noxref_8_c_2928_n N_noxref_20_c_9342_n ) capacitor c=0.00866164f \
 //x=34.14 //y=3.88 //x2=34.14 //y2=3.14
cc_2615 ( N_noxref_8_c_2932_n N_noxref_20_c_9345_n ) capacitor c=0.129282f \
 //x=34.74 //y=3.895 //x2=34.74 //y2=3.125
cc_2616 ( N_noxref_8_c_2935_p N_noxref_20_c_9365_n ) capacitor c=0.0255274f \
 //x=37.86 //y=3.725 //x2=46.36 //y2=3.14
cc_2617 ( N_noxref_8_c_2937_p N_noxref_20_c_9365_n ) capacitor c=0.0041019f \
 //x=37.86 //y=4.045 //x2=46.36 //y2=3.14
cc_2618 ( N_noxref_8_c_2932_n N_noxref_20_c_9365_n ) capacitor c=0.0154849f \
 //x=34.74 //y=3.895 //x2=46.36 //y2=3.14
cc_2619 ( N_noxref_8_c_2994_p N_VDD_c_10241_n ) capacitor c=0.00599793f \
 //x=24.24 //y=5.335 //x2=65.575 //y2=7.585
cc_2620 ( N_noxref_8_c_2822_n N_VDD_c_10241_n ) capacitor c=0.00627192f \
 //x=25.125 //y=5.335 //x2=65.575 //y2=7.585
cc_2621 ( N_noxref_8_c_2823_n N_VDD_c_10241_n ) capacitor c=0.00256019f \
 //x=25.24 //y=5.56 //x2=65.575 //y2=7.585
cc_2622 ( N_noxref_8_c_2826_n N_VDD_c_10241_n ) capacitor c=0.00829247f \
 //x=25.935 //y=5.335 //x2=65.575 //y2=7.585
cc_2623 ( N_noxref_8_c_2861_n N_VDD_c_10241_n ) capacitor c=5.12643e-19 \
 //x=26.02 //y=4.04 //x2=65.575 //y2=7.585
cc_2624 ( N_noxref_8_c_2872_n N_VDD_c_10241_n ) capacitor c=2.12476e-19 \
 //x=27.87 //y=4.04 //x2=65.575 //y2=7.585
cc_2625 ( N_noxref_8_c_2937_p N_VDD_c_10241_n ) capacitor c=2.12639e-19 \
 //x=37.86 //y=4.045 //x2=65.575 //y2=7.585
cc_2626 ( N_noxref_8_c_2992_p N_VDD_c_10241_n ) capacitor c=0.00261804f \
 //x=23.482 //y=5.335 //x2=65.575 //y2=7.585
cc_2627 ( N_noxref_8_c_3067_p N_VDD_c_10241_n ) capacitor c=0.00262144f \
 //x=24.36 //y=5.335 //x2=65.575 //y2=7.585
cc_2628 ( N_noxref_8_c_2881_n N_VDD_c_10241_n ) capacitor c=9.07241e-19 \
 //x=27.87 //y=4.88 //x2=65.575 //y2=7.585
cc_2629 ( N_noxref_8_c_2938_p N_VDD_c_10241_n ) capacitor c=9.07241e-19 \
 //x=37.86 //y=4.88 //x2=65.575 //y2=7.585
cc_2630 ( N_noxref_8_c_2993_p N_VDD_c_10241_n ) capacitor c=0.0024232f \
 //x=23.48 //y=5.56 //x2=65.575 //y2=7.585
cc_2631 ( N_noxref_8_c_3061_p N_VDD_c_10241_n ) capacitor c=0.0024232f \
 //x=24.36 //y=5.56 //x2=65.575 //y2=7.585
cc_2632 ( N_noxref_8_c_2902_n N_VDD_c_10241_n ) capacitor c=0.0024232f \
 //x=25.24 //y=5.56 //x2=65.575 //y2=7.585
cc_2633 ( N_noxref_8_c_2907_n N_VDD_c_10241_n ) capacitor c=6.22888e-19 \
 //x=27.87 //y=4.88 //x2=65.575 //y2=7.585
cc_2634 ( N_noxref_8_c_2939_p N_VDD_c_10241_n ) capacitor c=6.22888e-19 \
 //x=37.86 //y=4.88 //x2=65.575 //y2=7.585
cc_2635 ( N_noxref_8_c_2994_p N_VDD_c_10670_n ) capacitor c=0.00202922f \
 //x=24.24 //y=5.335 //x2=23.835 //y2=7.585
cc_2636 ( N_noxref_8_c_2992_p N_VDD_c_10670_n ) capacitor c=9.3757e-19 \
 //x=23.482 //y=5.335 //x2=23.835 //y2=7.585
cc_2637 ( N_noxref_8_c_2993_p N_VDD_c_10670_n ) capacitor c=0.0138074f \
 //x=23.48 //y=5.56 //x2=23.835 //y2=7.585
cc_2638 ( N_noxref_8_c_2994_p N_VDD_c_10673_n ) capacitor c=0.0017701f \
 //x=24.24 //y=5.335 //x2=24.715 //y2=7.585
cc_2639 ( N_noxref_8_c_2822_n N_VDD_c_10673_n ) capacitor c=0.00202922f \
 //x=25.125 //y=5.335 //x2=24.715 //y2=7.585
cc_2640 ( N_noxref_8_c_3067_p N_VDD_c_10673_n ) capacitor c=9.48145e-19 \
 //x=24.36 //y=5.335 //x2=24.715 //y2=7.585
cc_2641 ( N_noxref_8_c_3061_p N_VDD_c_10673_n ) capacitor c=0.0138074f \
 //x=24.36 //y=5.56 //x2=24.715 //y2=7.585
cc_2642 ( N_noxref_8_c_2822_n N_VDD_c_10557_n ) capacitor c=0.00205906f \
 //x=25.125 //y=5.335 //x2=25.595 //y2=7.585
cc_2643 ( N_noxref_8_c_2823_n N_VDD_c_10557_n ) capacitor c=8.49654e-19 \
 //x=25.24 //y=5.56 //x2=25.595 //y2=7.585
cc_2644 ( N_noxref_8_c_2826_n N_VDD_c_10557_n ) capacitor c=0.00204238f \
 //x=25.935 //y=5.335 //x2=25.595 //y2=7.585
cc_2645 ( N_noxref_8_c_2902_n N_VDD_c_10557_n ) capacitor c=0.0138074f \
 //x=25.24 //y=5.56 //x2=25.595 //y2=7.585
cc_2646 ( N_noxref_8_c_2826_n N_VDD_c_10681_n ) capacitor c=0.00183742f \
 //x=25.935 //y=5.335 //x2=26.59 //y2=7.585
cc_2647 ( N_noxref_8_c_2881_n N_VDD_c_10559_n ) capacitor c=6.28113e-19 \
 //x=27.87 //y=4.88 //x2=28.345 //y2=7.585
cc_2648 ( N_noxref_8_M78_noxref_g N_VDD_c_10559_n ) capacitor c=0.00732618f \
 //x=27.77 //y=6.2 //x2=28.345 //y2=7.585
cc_2649 ( N_noxref_8_M79_noxref_g N_VDD_c_10559_n ) capacitor c=0.00755544f \
 //x=28.21 //y=6.2 //x2=28.345 //y2=7.585
cc_2650 ( N_noxref_8_c_2938_p N_VDD_c_10685_n ) capacitor c=6.28113e-19 \
 //x=37.86 //y=4.88 //x2=38.335 //y2=7.585
cc_2651 ( N_noxref_8_M90_noxref_g N_VDD_c_10685_n ) capacitor c=0.00732618f \
 //x=37.76 //y=6.2 //x2=38.335 //y2=7.585
cc_2652 ( N_noxref_8_M91_noxref_g N_VDD_c_10685_n ) capacitor c=0.00755544f \
 //x=38.2 //y=6.2 //x2=38.335 //y2=7.585
cc_2653 ( N_noxref_8_c_2992_p N_VDD_c_10515_n ) capacitor c=0.0022955f \
 //x=23.482 //y=5.335 //x2=21.95 //y2=7.585
cc_2654 ( N_noxref_8_c_2993_p N_VDD_c_10515_n ) capacitor c=0.00508013f \
 //x=23.48 //y=5.56 //x2=21.95 //y2=7.585
cc_2655 ( N_noxref_8_c_2823_n N_VDD_c_10570_n ) capacitor c=0.00269779f \
 //x=25.24 //y=5.56 //x2=26.76 //y2=7.585
cc_2656 ( N_noxref_8_c_2863_n N_VDD_c_10570_n ) capacitor c=0.0311457f \
 //x=26.02 //y=5.25 //x2=26.76 //y2=7.585
cc_2657 ( N_noxref_8_c_2881_n N_VDD_c_10570_n ) capacitor c=0.00447349f \
 //x=27.87 //y=4.88 //x2=26.76 //y2=7.585
cc_2658 ( N_noxref_8_c_2883_n N_VDD_c_10570_n ) capacitor c=0.005882f \
 //x=27.872 //y=4.74 //x2=26.76 //y2=7.585
cc_2659 ( N_noxref_8_c_2902_n N_VDD_c_10570_n ) capacitor c=0.00776541f \
 //x=25.24 //y=5.56 //x2=26.76 //y2=7.585
cc_2660 ( N_noxref_8_c_2907_n N_VDD_c_10570_n ) capacitor c=0.00370494f \
 //x=27.87 //y=4.88 //x2=26.76 //y2=7.585
cc_2661 ( N_noxref_8_c_2914_n N_VDD_c_10570_n ) capacitor c=0.0129731f \
 //x=27.87 //y=4.88 //x2=26.76 //y2=7.585
cc_2662 ( N_noxref_8_c_2938_p N_VDD_c_10697_n ) capacitor c=0.00508547f \
 //x=37.86 //y=4.88 //x2=36.75 //y2=7.585
cc_2663 ( N_noxref_8_c_2936_p N_VDD_c_10697_n ) capacitor c=0.00584563f \
 //x=37.862 //y=4.74 //x2=36.75 //y2=7.585
cc_2664 ( N_noxref_8_c_2939_p N_VDD_c_10697_n ) capacitor c=0.00387138f \
 //x=37.86 //y=4.88 //x2=36.75 //y2=7.585
cc_2665 ( N_noxref_8_c_2942_p N_VDD_c_10697_n ) capacitor c=0.0125146f \
 //x=37.86 //y=4.88 //x2=36.75 //y2=7.585
cc_2666 ( N_noxref_8_c_2992_p N_VDD_M68_noxref_s ) capacitor c=4.22189e-19 \
 //x=23.482 //y=5.335 //x2=19.275 //y2=5.2
cc_2667 ( N_noxref_8_c_2992_p N_VDD_M72_noxref_s ) capacitor c=0.0441176f \
 //x=23.482 //y=5.335 //x2=22.905 //y2=5.2
cc_2668 ( N_noxref_8_c_3067_p N_VDD_M72_noxref_s ) capacitor c=7.80122e-19 \
 //x=24.36 //y=5.335 //x2=22.905 //y2=5.2
cc_2669 ( N_noxref_8_c_2993_p N_VDD_M72_noxref_s ) capacitor c=0.0908457f \
 //x=23.48 //y=5.56 //x2=22.905 //y2=5.2
cc_2670 ( N_noxref_8_c_2994_p N_VDD_M73_noxref_d ) capacitor c=0.00700141f \
 //x=24.24 //y=5.335 //x2=23.775 //y2=5.2
cc_2671 ( N_noxref_8_c_2993_p N_VDD_M73_noxref_d ) capacitor c=0.0673792f \
 //x=23.48 //y=5.56 //x2=23.775 //y2=5.2
cc_2672 ( N_noxref_8_c_3061_p N_VDD_M73_noxref_d ) capacitor c=0.0674762f \
 //x=24.36 //y=5.56 //x2=23.775 //y2=5.2
cc_2673 ( N_noxref_8_c_2822_n N_VDD_M75_noxref_d ) capacitor c=0.00700141f \
 //x=25.125 //y=5.335 //x2=24.655 //y2=5.2
cc_2674 ( N_noxref_8_c_3061_p N_VDD_M75_noxref_d ) capacitor c=0.067493f \
 //x=24.36 //y=5.56 //x2=24.655 //y2=5.2
cc_2675 ( N_noxref_8_c_2902_n N_VDD_M75_noxref_d ) capacitor c=0.0674288f \
 //x=25.24 //y=5.56 //x2=24.655 //y2=5.2
cc_2676 ( N_noxref_8_c_2826_n N_VDD_M77_noxref_d ) capacitor c=0.00700141f \
 //x=25.935 //y=5.335 //x2=25.535 //y2=5.2
cc_2677 ( N_noxref_8_c_2902_n N_VDD_M77_noxref_d ) capacitor c=0.0673824f \
 //x=25.24 //y=5.56 //x2=25.535 //y2=5.2
cc_2678 ( N_noxref_8_c_2823_n N_VDD_M78_noxref_s ) capacitor c=0.00536022f \
 //x=25.24 //y=5.56 //x2=27.415 //y2=5.2
cc_2679 ( N_noxref_8_c_2826_n N_VDD_M78_noxref_s ) capacitor c=0.00211796f \
 //x=25.935 //y=5.335 //x2=27.415 //y2=5.2
cc_2680 ( N_noxref_8_c_2872_n N_VDD_M78_noxref_s ) capacitor c=0.00143547f \
 //x=27.87 //y=4.04 //x2=27.415 //y2=5.2
cc_2681 ( N_noxref_8_M78_noxref_g N_VDD_M78_noxref_s ) capacitor c=0.0567929f \
 //x=27.77 //y=6.2 //x2=27.415 //y2=5.2
cc_2682 ( N_noxref_8_M79_noxref_g N_VDD_M79_noxref_d ) capacitor c=0.015318f \
 //x=28.21 //y=6.2 //x2=28.285 //y2=5.2
cc_2683 ( N_noxref_8_c_2937_p N_VDD_M90_noxref_s ) capacitor c=0.00143557f \
 //x=37.86 //y=4.045 //x2=37.405 //y2=5.2
cc_2684 ( N_noxref_8_M90_noxref_g N_VDD_M90_noxref_s ) capacitor c=0.0567929f \
 //x=37.76 //y=6.2 //x2=37.405 //y2=5.2
cc_2685 ( N_noxref_8_M91_noxref_g N_VDD_M91_noxref_d ) capacitor c=0.015318f \
 //x=38.2 //y=6.2 //x2=38.275 //y2=5.2
cc_2686 ( N_noxref_8_c_2831_n N_noxref_24_c_11720_n ) capacitor c=0.0036878f \
 //x=25.535 //y=1.305 //x2=25.935 //y2=0.72
cc_2687 ( N_noxref_8_c_2845_n N_noxref_24_c_11720_n ) capacitor c=0.00399931f \
 //x=25.935 //y=1.845 //x2=25.935 //y2=0.72
cc_2688 ( N_noxref_8_M15_noxref_d N_noxref_24_c_11720_n ) capacitor \
 c=0.00910163f //x=25.345 //y=1.095 //x2=25.935 //y2=0.72
cc_2689 ( N_noxref_8_M15_noxref_d N_noxref_24_c_11725_n ) capacitor \
 c=0.00120711f //x=25.345 //y=1.095 //x2=25.05 //y2=1.175
cc_2690 ( N_noxref_8_c_2994_p N_noxref_24_M14_noxref_d ) capacitor \
 c=0.00152421f //x=24.24 //y=5.335 //x2=23.81 //y2=1.09
cc_2691 ( N_noxref_8_c_2831_n N_noxref_24_M14_noxref_d ) capacitor \
 c=0.00802836f //x=25.535 //y=1.305 //x2=23.81 //y2=1.09
cc_2692 ( N_noxref_8_c_2831_n N_noxref_24_M15_noxref_s ) capacitor \
 c=0.00993092f //x=25.535 //y=1.305 //x2=24.915 //y2=0.555
cc_2693 ( N_noxref_8_c_2839_n N_noxref_24_M15_noxref_s ) capacitor \
 c=0.0270492f //x=25.535 //y=1.76 //x2=24.915 //y2=0.555
cc_2694 ( N_noxref_8_c_2845_n N_noxref_24_M15_noxref_s ) capacitor \
 c=0.00911719f //x=25.935 //y=1.845 //x2=24.915 //y2=0.555
cc_2695 ( N_noxref_8_c_2880_n N_noxref_24_M15_noxref_s ) capacitor \
 c=0.00129723f //x=26.02 //y=3.88 //x2=24.915 //y2=0.555
cc_2696 ( N_noxref_8_M15_noxref_d N_noxref_24_M15_noxref_s ) capacitor \
 c=0.0279003f //x=25.345 //y=1.095 //x2=24.915 //y2=0.555
cc_2697 ( N_noxref_8_c_2831_n N_GND_c_12546_n ) capacitor c=0.00893398f \
 //x=25.535 //y=1.305 //x2=27.855 //y2=0.175
cc_2698 ( N_noxref_8_c_2845_n N_GND_c_12546_n ) capacitor c=0.00674221f \
 //x=25.935 //y=1.845 //x2=27.855 //y2=0.175
cc_2699 ( N_noxref_8_c_2861_n N_GND_c_12546_n ) capacitor c=3.30191e-19 \
 //x=26.02 //y=4.04 //x2=27.855 //y2=0.175
cc_2700 ( N_noxref_8_M15_noxref_d N_GND_c_12546_n ) capacitor c=2.9462e-19 \
 //x=25.345 //y=1.095 //x2=27.855 //y2=0.175
cc_2701 ( N_noxref_8_c_2831_n N_GND_c_12550_n ) capacitor c=0.00488628f \
 //x=25.535 //y=1.305 //x2=27.94 //y2=1.135
cc_2702 ( N_noxref_8_c_3014_p N_GND_c_12550_n ) capacitor c=0.00667419f \
 //x=27.87 //y=2.26 //x2=27.94 //y2=1.135
cc_2703 ( N_noxref_8_c_3002_p N_GND_c_12550_n ) capacitor c=2.13705e-19 \
 //x=27.87 //y=2.26 //x2=27.94 //y2=1.135
cc_2704 ( N_noxref_8_c_3038_p N_GND_c_12550_n ) capacitor c=0.00176535f \
 //x=27.675 //y=1.045 //x2=27.94 //y2=1.135
cc_2705 ( N_noxref_8_c_3039_p N_GND_c_12550_n ) capacitor c=0.0036005f \
 //x=27.675 //y=1.39 //x2=27.94 //y2=1.135
cc_2706 ( N_noxref_8_c_3041_p N_GND_c_12550_n ) capacitor c=4.2764e-19 \
 //x=27.675 //y=1.7 //x2=27.94 //y2=1.135
cc_2707 ( N_noxref_8_c_3241_p N_GND_c_12550_n ) capacitor c=9.36995e-19 \
 //x=28.05 //y=0.89 //x2=27.94 //y2=1.135
cc_2708 ( N_noxref_8_c_3242_p N_GND_c_12550_n ) capacitor c=6.38426e-19 \
 //x=28.05 //y=1.545 //x2=27.94 //y2=1.135
cc_2709 ( N_noxref_8_c_3040_p N_GND_c_12550_n ) capacitor c=0.00171721f \
 //x=28.205 //y=1.045 //x2=27.94 //y2=1.135
cc_2710 ( N_noxref_8_c_3042_p N_GND_c_12550_n ) capacitor c=0.00296337f \
 //x=28.205 //y=1.39 //x2=27.94 //y2=1.135
cc_2711 ( N_noxref_8_c_3038_p N_GND_c_12641_n ) capacitor c=3.51399e-19 \
 //x=27.675 //y=1.045 //x2=27.937 //y2=1.005
cc_2712 ( N_noxref_8_c_3241_p N_GND_c_12641_n ) capacitor c=0.00852202f \
 //x=28.05 //y=0.89 //x2=27.937 //y2=1.005
cc_2713 ( N_noxref_8_c_3040_p N_GND_c_12641_n ) capacitor c=4.40641e-19 \
 //x=28.205 //y=1.045 //x2=27.937 //y2=1.005
cc_2714 ( N_noxref_8_c_2957_p N_GND_c_12644_n ) capacitor c=0.00667419f \
 //x=37.86 //y=2.26 //x2=37.93 //y2=1.135
cc_2715 ( N_noxref_8_c_3096_p N_GND_c_12644_n ) capacitor c=2.13705e-19 \
 //x=37.86 //y=2.26 //x2=37.93 //y2=1.135
cc_2716 ( N_noxref_8_c_3117_p N_GND_c_12644_n ) capacitor c=0.00171023f \
 //x=37.665 //y=1.045 //x2=37.93 //y2=1.135
cc_2717 ( N_noxref_8_c_3118_p N_GND_c_12644_n ) capacitor c=0.00357815f \
 //x=37.665 //y=1.39 //x2=37.93 //y2=1.135
cc_2718 ( N_noxref_8_c_3120_p N_GND_c_12644_n ) capacitor c=4.2764e-19 \
 //x=37.665 //y=1.7 //x2=37.93 //y2=1.135
cc_2719 ( N_noxref_8_c_3253_p N_GND_c_12644_n ) capacitor c=9.36995e-19 \
 //x=38.04 //y=0.89 //x2=37.93 //y2=1.135
cc_2720 ( N_noxref_8_c_3254_p N_GND_c_12644_n ) capacitor c=6.30911e-19 \
 //x=38.04 //y=1.545 //x2=37.93 //y2=1.135
cc_2721 ( N_noxref_8_c_3119_p N_GND_c_12644_n ) capacitor c=0.00171721f \
 //x=38.195 //y=1.045 //x2=37.93 //y2=1.135
cc_2722 ( N_noxref_8_c_3121_p N_GND_c_12644_n ) capacitor c=0.00296337f \
 //x=38.195 //y=1.39 //x2=37.93 //y2=1.135
cc_2723 ( N_noxref_8_c_3117_p N_GND_c_12653_n ) capacitor c=3.46594e-19 \
 //x=37.665 //y=1.045 //x2=37.927 //y2=1.005
cc_2724 ( N_noxref_8_c_3253_p N_GND_c_12653_n ) capacitor c=0.00839795f \
 //x=38.04 //y=0.89 //x2=37.927 //y2=1.005
cc_2725 ( N_noxref_8_c_3119_p N_GND_c_12653_n ) capacitor c=4.40641e-19 \
 //x=38.195 //y=1.045 //x2=37.927 //y2=1.005
cc_2726 ( N_noxref_8_c_2845_n N_GND_c_12566_n ) capacitor c=6.86343e-19 \
 //x=25.935 //y=1.845 //x2=26.59 //y2=0.175
cc_2727 ( N_noxref_8_c_3038_p N_GND_c_12567_n ) capacitor c=0.00688027f \
 //x=27.675 //y=1.045 //x2=29.92 //y2=0.175
cc_2728 ( N_noxref_8_c_3117_p N_GND_c_12658_n ) capacitor c=0.00688027f \
 //x=37.665 //y=1.045 //x2=39.91 //y2=0.175
cc_2729 ( N_noxref_8_c_2839_n N_GND_c_12569_n ) capacitor c=0.00285697f \
 //x=25.535 //y=1.76 //x2=26.76 //y2=0.175
cc_2730 ( N_noxref_8_c_2845_n N_GND_c_12569_n ) capacitor c=0.0310097f \
 //x=25.935 //y=1.845 //x2=26.76 //y2=0.175
cc_2731 ( N_noxref_8_c_2867_n N_GND_c_12569_n ) capacitor c=0.00663128f \
 //x=27.87 //y=3.72 //x2=26.76 //y2=0.175
cc_2732 ( N_noxref_8_c_3014_p N_GND_c_12569_n ) capacitor c=0.00427323f \
 //x=27.87 //y=2.26 //x2=26.76 //y2=0.175
cc_2733 ( N_noxref_8_c_3002_p N_GND_c_12569_n ) capacitor c=0.00369427f \
 //x=27.87 //y=2.26 //x2=26.76 //y2=0.175
cc_2734 ( N_noxref_8_c_3041_p N_GND_c_12569_n ) capacitor c=0.0015404f \
 //x=27.675 //y=1.7 //x2=26.76 //y2=0.175
cc_2735 ( N_noxref_8_c_3016_p N_GND_c_12569_n ) capacitor c=0.0095324f \
 //x=27.675 //y=2.095 //x2=26.76 //y2=0.175
cc_2736 ( N_noxref_8_c_2935_p N_GND_c_12666_n ) capacitor c=0.00718667f \
 //x=37.86 //y=3.725 //x2=36.75 //y2=0.175
cc_2737 ( N_noxref_8_c_2957_p N_GND_c_12666_n ) capacitor c=0.00472919f \
 //x=37.86 //y=2.26 //x2=36.75 //y2=0.175
cc_2738 ( N_noxref_8_c_3096_p N_GND_c_12666_n ) capacitor c=0.0038607f \
 //x=37.86 //y=2.26 //x2=36.75 //y2=0.175
cc_2739 ( N_noxref_8_c_3120_p N_GND_c_12666_n ) capacitor c=0.0015404f \
 //x=37.665 //y=1.7 //x2=36.75 //y2=0.175
cc_2740 ( N_noxref_8_c_3097_p N_GND_c_12666_n ) capacitor c=0.00906518f \
 //x=37.665 //y=2.095 //x2=36.75 //y2=0.175
cc_2741 ( N_noxref_8_c_3014_p N_GND_M16_noxref_d ) capacitor c=2.20438e-19 \
 //x=27.87 //y=2.26 //x2=27.75 //y2=1.045
cc_2742 ( N_noxref_8_c_3038_p N_GND_M16_noxref_d ) capacitor c=0.00192399f \
 //x=27.675 //y=1.045 //x2=27.75 //y2=1.045
cc_2743 ( N_noxref_8_c_3039_p N_GND_M16_noxref_d ) capacitor c=0.00210798f \
 //x=27.675 //y=1.39 //x2=27.75 //y2=1.045
cc_2744 ( N_noxref_8_c_3241_p N_GND_M16_noxref_d ) capacitor c=0.00472259f \
 //x=28.05 //y=0.89 //x2=27.75 //y2=1.045
cc_2745 ( N_noxref_8_c_3242_p N_GND_M16_noxref_d ) capacitor c=0.00166857f \
 //x=28.05 //y=1.545 //x2=27.75 //y2=1.045
cc_2746 ( N_noxref_8_c_3040_p N_GND_M16_noxref_d ) capacitor c=0.00230174f \
 //x=28.205 //y=1.045 //x2=27.75 //y2=1.045
cc_2747 ( N_noxref_8_c_3042_p N_GND_M16_noxref_d ) capacitor c=0.00210798f \
 //x=28.205 //y=1.39 //x2=27.75 //y2=1.045
cc_2748 ( N_noxref_8_c_2957_p N_GND_M22_noxref_d ) capacitor c=2.20438e-19 \
 //x=37.86 //y=2.26 //x2=37.74 //y2=1.045
cc_2749 ( N_noxref_8_c_3117_p N_GND_M22_noxref_d ) capacitor c=0.00192399f \
 //x=37.665 //y=1.045 //x2=37.74 //y2=1.045
cc_2750 ( N_noxref_8_c_3118_p N_GND_M22_noxref_d ) capacitor c=0.00210798f \
 //x=37.665 //y=1.39 //x2=37.74 //y2=1.045
cc_2751 ( N_noxref_8_c_3253_p N_GND_M22_noxref_d ) capacitor c=0.00472259f \
 //x=38.04 //y=0.89 //x2=37.74 //y2=1.045
cc_2752 ( N_noxref_8_c_3254_p N_GND_M22_noxref_d ) capacitor c=0.00166857f \
 //x=38.04 //y=1.545 //x2=37.74 //y2=1.045
cc_2753 ( N_noxref_8_c_3119_p N_GND_M22_noxref_d ) capacitor c=0.00230174f \
 //x=38.195 //y=1.045 //x2=37.74 //y2=1.045
cc_2754 ( N_noxref_8_c_3121_p N_GND_M22_noxref_d ) capacitor c=0.00210798f \
 //x=38.195 //y=1.39 //x2=37.74 //y2=1.045
cc_2755 ( N_noxref_8_c_3016_p N_noxref_38_c_14449_n ) capacitor c=0.00262672f \
 //x=27.675 //y=2.095 //x2=27.455 //y2=1.675
cc_2756 ( N_noxref_8_c_2872_n N_noxref_38_c_14450_n ) capacitor c=0.00361134f \
 //x=27.87 //y=4.04 //x2=28.34 //y2=1.76
cc_2757 ( N_noxref_8_c_3014_p N_noxref_38_c_14450_n ) capacitor c=0.00509504f \
 //x=27.87 //y=2.26 //x2=28.34 //y2=1.76
cc_2758 ( N_noxref_8_c_3002_p N_noxref_38_c_14450_n ) capacitor c=0.00763108f \
 //x=27.87 //y=2.26 //x2=28.34 //y2=1.76
cc_2759 ( N_noxref_8_c_3041_p N_noxref_38_c_14450_n ) capacitor c=0.00697076f \
 //x=27.675 //y=1.7 //x2=28.34 //y2=1.76
cc_2760 ( N_noxref_8_c_3016_p N_noxref_38_c_14450_n ) capacitor c=0.017492f \
 //x=27.675 //y=2.095 //x2=28.34 //y2=1.76
cc_2761 ( N_noxref_8_c_3242_p N_noxref_38_c_14450_n ) capacitor c=0.00723574f \
 //x=28.05 //y=1.545 //x2=28.34 //y2=1.76
cc_2762 ( N_noxref_8_c_3042_p N_noxref_38_c_14450_n ) capacitor c=0.00339872f \
 //x=28.205 //y=1.39 //x2=28.34 //y2=1.76
cc_2763 ( N_noxref_8_c_3016_p N_noxref_38_c_14439_n ) capacitor c=6.71402e-19 \
 //x=27.675 //y=2.095 //x2=28.425 //y2=1.675
cc_2764 ( N_noxref_8_c_3038_p N_noxref_38_M16_noxref_s ) capacitor \
 c=0.0295366f //x=27.675 //y=1.045 //x2=27.32 //y2=0.545
cc_2765 ( N_noxref_8_c_3041_p N_noxref_38_M16_noxref_s ) capacitor \
 c=3.48408e-19 //x=27.675 //y=1.7 //x2=27.32 //y2=0.545
cc_2766 ( N_noxref_8_c_3040_p N_noxref_38_M16_noxref_s ) capacitor \
 c=0.0125442f //x=28.205 //y=1.045 //x2=27.32 //y2=0.545
cc_2767 ( N_noxref_8_c_3097_p N_noxref_41_c_14644_n ) capacitor c=0.00262672f \
 //x=37.665 //y=2.095 //x2=37.445 //y2=1.675
cc_2768 ( N_noxref_8_c_2937_p N_noxref_41_c_14645_n ) capacitor c=0.00364314f \
 //x=37.86 //y=4.045 //x2=38.33 //y2=1.76
cc_2769 ( N_noxref_8_c_2957_p N_noxref_41_c_14645_n ) capacitor c=0.00509504f \
 //x=37.86 //y=2.26 //x2=38.33 //y2=1.76
cc_2770 ( N_noxref_8_c_3096_p N_noxref_41_c_14645_n ) capacitor c=0.00655412f \
 //x=37.86 //y=2.26 //x2=38.33 //y2=1.76
cc_2771 ( N_noxref_8_c_3120_p N_noxref_41_c_14645_n ) capacitor c=0.00697076f \
 //x=37.665 //y=1.7 //x2=38.33 //y2=1.76
cc_2772 ( N_noxref_8_c_3097_p N_noxref_41_c_14645_n ) capacitor c=0.0191405f \
 //x=37.665 //y=2.095 //x2=38.33 //y2=1.76
cc_2773 ( N_noxref_8_c_3254_p N_noxref_41_c_14645_n ) capacitor c=0.00723574f \
 //x=38.04 //y=1.545 //x2=38.33 //y2=1.76
cc_2774 ( N_noxref_8_c_3121_p N_noxref_41_c_14645_n ) capacitor c=0.00339872f \
 //x=38.195 //y=1.39 //x2=38.33 //y2=1.76
cc_2775 ( N_noxref_8_c_3097_p N_noxref_41_c_14652_n ) capacitor c=6.71402e-19 \
 //x=37.665 //y=2.095 //x2=38.415 //y2=1.675
cc_2776 ( N_noxref_8_c_3117_p N_noxref_41_M22_noxref_s ) capacitor \
 c=0.0294925f //x=37.665 //y=1.045 //x2=37.31 //y2=0.545
cc_2777 ( N_noxref_8_c_3120_p N_noxref_41_M22_noxref_s ) capacitor \
 c=3.48408e-19 //x=37.665 //y=1.7 //x2=37.31 //y2=0.545
cc_2778 ( N_noxref_8_c_3119_p N_noxref_41_M22_noxref_s ) capacitor \
 c=0.0125442f //x=38.195 //y=1.045 //x2=37.31 //y2=0.545
cc_2779 ( N_noxref_9_c_3330_p N_noxref_10_c_3666_n ) capacitor c=0.00324213f \
 //x=38.9 //y=1.75 //x2=35.57 //y2=1.75
cc_2780 ( N_noxref_9_c_3316_n N_noxref_10_c_3778_n ) capacitor c=0.00114153f \
 //x=37.98 //y=5.56 //x2=35.925 //y2=5.38
cc_2781 ( N_noxref_9_c_3332_p N_noxref_10_c_3779_n ) capacitor c=0.00231467f \
 //x=38.985 //y=1.835 //x2=35.925 //y2=1.835
cc_2782 ( N_noxref_9_c_3314_n N_noxref_10_c_3668_n ) capacitor c=0.00204244f \
 //x=39.34 //y=3.705 //x2=36.01 //y2=4.105
cc_2783 ( N_noxref_9_c_3315_n N_noxref_10_c_3671_n ) capacitor c=0.00281705f \
 //x=39.34 //y=5.295 //x2=36.01 //y2=5.295
cc_2784 ( N_noxref_9_c_3314_n N_noxref_10_c_3782_n ) capacitor c=0.00149768f \
 //x=39.34 //y=3.705 //x2=41.93 //y2=4.09
cc_2785 ( N_noxref_9_c_3336_p N_noxref_10_c_3782_n ) capacitor c=0.0537413f \
 //x=41.19 //y=3.705 //x2=41.93 //y2=4.09
cc_2786 ( N_noxref_9_c_3337_p N_noxref_10_c_3782_n ) capacitor c=0.014957f \
 //x=41.19 //y=4.025 //x2=41.93 //y2=4.09
cc_2787 ( N_noxref_9_c_3338_p N_noxref_10_c_3782_n ) capacitor c=7.6985e-19 \
 //x=41.19 //y=3.88 //x2=41.93 //y2=4.09
cc_2788 ( N_noxref_9_c_3339_p N_noxref_10_c_3782_n ) capacitor c=0.0028341f \
 //x=41.192 //y=4.74 //x2=41.93 //y2=4.09
cc_2789 ( N_noxref_9_c_3340_p N_noxref_10_c_3782_n ) capacitor c=0.00684101f \
 //x=41.185 //y=3.865 //x2=41.93 //y2=4.09
cc_2790 ( N_noxref_9_c_3341_p N_noxref_10_c_3782_n ) capacitor c=3.30333e-19 \
 //x=41.19 //y=2.26 //x2=41.93 //y2=4.09
cc_2791 ( N_noxref_9_c_3339_p N_noxref_10_c_3789_n ) capacitor c=0.0173413f \
 //x=41.192 //y=4.74 //x2=41.93 //y2=4.41
cc_2792 ( N_noxref_9_c_3315_n N_noxref_10_c_3790_n ) capacitor c=7.59777e-19 \
 //x=39.34 //y=5.295 //x2=41.93 //y2=4.735
cc_2793 ( N_noxref_9_c_3344_p N_noxref_10_c_3790_n ) capacitor c=0.0172958f \
 //x=41.19 //y=4.88 //x2=41.93 //y2=4.735
cc_2794 ( N_noxref_9_c_3339_p N_noxref_10_c_3790_n ) capacitor c=0.0117613f \
 //x=41.192 //y=4.74 //x2=41.93 //y2=4.735
cc_2795 ( N_noxref_9_c_3346_p N_noxref_10_c_3790_n ) capacitor c=7.50997e-19 \
 //x=41.19 //y=4.88 //x2=41.93 //y2=4.735
cc_2796 ( N_noxref_9_c_3347_p N_noxref_10_c_3790_n ) capacitor c=0.00200732f \
 //x=41.19 //y=4.88 //x2=41.93 //y2=4.735
cc_2797 ( N_noxref_9_c_3316_n N_noxref_10_c_3795_n ) capacitor c=5.29822e-19 \
 //x=37.98 //y=5.56 //x2=35.53 //y2=5.38
cc_2798 ( N_noxref_9_c_3316_n N_noxref_10_c_3796_n ) capacitor c=0.00147119f \
 //x=37.98 //y=5.56 //x2=35.53 //y2=5.56
cc_2799 ( N_noxref_9_c_3350_p N_noxref_10_c_3684_n ) capacitor c=6.99317e-19 \
 //x=38.9 //y=1.18 //x2=35.57 //y2=1.18
cc_2800 ( N_noxref_9_c_3339_p N_noxref_10_c_3798_n ) capacitor c=5.79609e-19 \
 //x=41.192 //y=4.74 //x2=41.93 //y2=4.25
cc_2801 ( N_noxref_9_c_3352_p N_noxref_10_c_3799_n ) capacitor c=0.0179797f \
 //x=41.19 //y=2.26 //x2=41.93 //y2=2.26
cc_2802 ( N_noxref_9_c_3341_p N_noxref_10_c_3799_n ) capacitor c=5.16867e-19 \
 //x=41.19 //y=2.26 //x2=41.93 //y2=2.26
cc_2803 ( N_noxref_9_c_3354_p N_noxref_10_c_3799_n ) capacitor c=0.00161745f \
 //x=40.995 //y=2.095 //x2=41.93 //y2=2.26
cc_2804 ( N_noxref_9_c_3355_p N_noxref_10_c_3765_n ) capacitor c=0.00897318f \
 //x=39.34 //y=4.025 //x2=38.075 //y2=4.27
cc_2805 ( N_noxref_9_c_3315_n N_noxref_10_c_3765_n ) capacitor c=0.0227806f \
 //x=39.34 //y=5.295 //x2=38.075 //y2=4.27
cc_2806 ( N_noxref_9_c_3337_p N_noxref_10_c_3765_n ) capacitor c=0.00570748f \
 //x=41.19 //y=4.025 //x2=38.075 //y2=4.27
cc_2807 ( N_noxref_9_c_3339_p N_noxref_10_c_3765_n ) capacitor c=0.0249449f \
 //x=41.192 //y=4.74 //x2=38.075 //y2=4.27
cc_2808 ( N_noxref_9_c_3323_n N_noxref_10_c_3765_n ) capacitor c=0.0358686f \
 //x=39.5 //y=3.865 //x2=38.075 //y2=4.27
cc_2809 ( N_noxref_9_c_3340_p N_noxref_10_c_3765_n ) capacitor c=0.0358686f \
 //x=41.185 //y=3.865 //x2=38.075 //y2=4.27
cc_2810 ( N_noxref_9_c_3361_p N_noxref_10_c_3765_n ) capacitor c=0.133576f \
 //x=41.025 //y=3.865 //x2=38.075 //y2=4.27
cc_2811 ( N_noxref_9_c_3336_p N_noxref_10_c_3809_n ) capacitor c=3.30333e-19 \
 //x=41.19 //y=3.705 //x2=41.93 //y2=2.26
cc_2812 ( N_noxref_9_c_3352_p N_noxref_10_c_3809_n ) capacitor c=5.24723e-19 \
 //x=41.19 //y=2.26 //x2=41.93 //y2=2.26
cc_2813 ( N_noxref_9_c_3341_p N_noxref_10_c_3809_n ) capacitor c=0.00445529f \
 //x=41.19 //y=2.26 //x2=41.93 //y2=2.26
cc_2814 ( N_noxref_9_c_3354_p N_noxref_10_c_3809_n ) capacitor c=0.00267961f \
 //x=40.995 //y=2.095 //x2=41.93 //y2=2.26
cc_2815 ( N_noxref_9_c_3344_p N_noxref_10_c_3813_n ) capacitor c=4.80626e-19 \
 //x=41.19 //y=4.88 //x2=41.96 //y2=4.88
cc_2816 ( N_noxref_9_c_3346_p N_noxref_10_c_3813_n ) capacitor c=0.00397338f \
 //x=41.19 //y=4.88 //x2=41.96 //y2=4.88
cc_2817 ( N_noxref_9_c_3347_p N_noxref_10_c_3813_n ) capacitor c=0.00283894f \
 //x=41.19 //y=4.88 //x2=41.96 //y2=4.88
cc_2818 ( N_noxref_9_M94_noxref_g N_noxref_10_M96_noxref_g ) capacitor \
 c=0.0104892f //x=41.09 //y=6.2 //x2=41.97 //y2=6.2
cc_2819 ( N_noxref_9_M95_noxref_g N_noxref_10_M96_noxref_g ) capacitor \
 c=0.107636f //x=41.53 //y=6.2 //x2=41.97 //y2=6.2
cc_2820 ( N_noxref_9_M95_noxref_g N_noxref_10_M97_noxref_g ) capacitor \
 c=0.0100341f //x=41.53 //y=6.2 //x2=42.41 //y2=6.2
cc_2821 ( N_noxref_9_c_3372_p N_noxref_10_c_3819_n ) capacitor c=4.86545e-19 \
 //x=40.995 //y=1.045 //x2=41.965 //y2=1.085
cc_2822 ( N_noxref_9_c_3373_p N_noxref_10_c_3819_n ) capacitor c=0.00152405f \
 //x=40.995 //y=1.39 //x2=41.965 //y2=1.085
cc_2823 ( N_noxref_9_c_3374_p N_noxref_10_c_3819_n ) capacitor c=0.0151475f \
 //x=41.525 //y=1.045 //x2=41.965 //y2=1.085
cc_2824 ( N_noxref_9_c_3375_p N_noxref_10_c_3822_n ) capacitor c=0.00109982f \
 //x=40.995 //y=1.7 //x2=41.965 //y2=1.43
cc_2825 ( N_noxref_9_c_3376_p N_noxref_10_c_3822_n ) capacitor c=0.0111064f \
 //x=41.525 //y=1.39 //x2=41.965 //y2=1.43
cc_2826 ( N_noxref_9_c_3375_p N_noxref_10_c_3824_n ) capacitor c=9.58243e-19 \
 //x=40.995 //y=1.7 //x2=41.965 //y2=1.74
cc_2827 ( N_noxref_9_c_3354_p N_noxref_10_c_3824_n ) capacitor c=0.00662747f \
 //x=40.995 //y=2.095 //x2=41.965 //y2=1.74
cc_2828 ( N_noxref_9_c_3376_p N_noxref_10_c_3824_n ) capacitor c=0.00862358f \
 //x=41.525 //y=1.39 //x2=41.965 //y2=1.74
cc_2829 ( N_noxref_9_c_3374_p N_noxref_10_c_3827_n ) capacitor c=0.00127211f \
 //x=41.525 //y=1.045 //x2=42.495 //y2=1.085
cc_2830 ( N_noxref_9_c_3376_p N_noxref_10_c_3828_n ) capacitor c=0.00204774f \
 //x=41.525 //y=1.39 //x2=42.495 //y2=1.43
cc_2831 ( N_noxref_9_c_3352_p N_noxref_10_c_3829_n ) capacitor c=0.00161167f \
 //x=41.19 //y=2.26 //x2=41.93 //y2=2.26
cc_2832 ( N_noxref_9_c_3341_p N_noxref_10_c_3829_n ) capacitor c=0.00266443f \
 //x=41.19 //y=2.26 //x2=41.93 //y2=2.26
cc_2833 ( N_noxref_9_c_3354_p N_noxref_10_c_3829_n ) capacitor c=0.0181717f \
 //x=40.995 //y=2.095 //x2=41.93 //y2=2.26
cc_2834 ( N_noxref_9_c_3344_p N_noxref_10_c_3832_n ) capacitor c=0.00158715f \
 //x=41.19 //y=4.88 //x2=41.96 //y2=4.88
cc_2835 ( N_noxref_9_c_3346_p N_noxref_10_c_3832_n ) capacitor c=0.00237977f \
 //x=41.19 //y=4.88 //x2=41.96 //y2=4.88
cc_2836 ( N_noxref_9_c_3347_p N_noxref_10_c_3832_n ) capacitor c=0.0297875f \
 //x=41.19 //y=4.88 //x2=41.96 //y2=4.88
cc_2837 ( N_noxref_9_c_3314_n N_D_c_4408_n ) capacitor c=0.0233623f //x=39.34 \
 //y=3.705 //x2=49.91 //y2=2.755
cc_2838 ( N_noxref_9_c_3336_p N_D_c_4408_n ) capacitor c=0.0233476f //x=41.19 \
 //y=3.705 //x2=49.91 //y2=2.755
cc_2839 ( N_noxref_9_c_3361_p N_D_c_4408_n ) capacitor c=0.00558026f \
 //x=41.025 //y=3.865 //x2=49.91 //y2=2.755
cc_2840 ( N_noxref_9_c_3315_n N_CLK_c_5953_n ) capacitor c=0.0287564f \
 //x=39.34 //y=5.295 //x2=41.545 //y2=4.62
cc_2841 ( N_noxref_9_c_3316_n N_CLK_c_5953_n ) capacitor c=0.0225382f \
 //x=37.98 //y=5.56 //x2=41.545 //y2=4.62
cc_2842 ( N_noxref_9_c_3393_p N_CLK_c_5953_n ) capacitor c=0.0210806f \
 //x=38.86 //y=5.38 //x2=41.545 //y2=4.62
cc_2843 ( N_noxref_9_c_3344_p N_CLK_c_5953_n ) capacitor c=0.00357426f \
 //x=41.19 //y=4.88 //x2=41.545 //y2=4.62
cc_2844 ( N_noxref_9_c_3339_p N_CLK_c_5953_n ) capacitor c=0.0271007f \
 //x=41.192 //y=4.74 //x2=41.545 //y2=4.62
cc_2845 ( N_noxref_9_c_3361_p N_CLK_c_5953_n ) capacitor c=0.0079732f \
 //x=41.025 //y=3.865 //x2=41.545 //y2=4.62
cc_2846 ( N_noxref_9_c_3313_n N_noxref_19_c_8542_n ) capacitor c=5.73838e-19 \
 //x=38.745 //y=5.38 //x2=38.6 //y2=2.485
cc_2847 ( N_noxref_9_c_3314_n N_noxref_19_c_8542_n ) capacitor c=0.0166369f \
 //x=39.34 //y=3.705 //x2=38.6 //y2=2.485
cc_2848 ( N_noxref_9_c_3313_n N_noxref_19_c_8546_n ) capacitor c=0.0217623f \
 //x=38.745 //y=5.38 //x2=38.6 //y2=4.735
cc_2849 ( N_noxref_9_c_3314_n N_noxref_19_c_8546_n ) capacitor c=0.0511054f \
 //x=39.34 //y=3.705 //x2=38.6 //y2=4.735
cc_2850 ( N_noxref_9_c_3355_p N_noxref_19_c_8546_n ) capacitor c=0.0151188f \
 //x=39.34 //y=4.025 //x2=38.6 //y2=4.735
cc_2851 ( N_noxref_9_c_3315_n N_noxref_19_c_8546_n ) capacitor c=0.0429764f \
 //x=39.34 //y=5.295 //x2=38.6 //y2=4.735
cc_2852 ( N_noxref_9_c_3336_p N_noxref_19_c_8546_n ) capacitor c=0.00149585f \
 //x=41.19 //y=3.705 //x2=38.6 //y2=4.735
cc_2853 ( N_noxref_9_c_3322_n N_noxref_19_c_8546_n ) capacitor c=6.47554e-19 \
 //x=39.34 //y=3.88 //x2=38.6 //y2=4.735
cc_2854 ( N_noxref_9_c_3339_p N_noxref_19_c_8546_n ) capacitor c=0.0010355f \
 //x=41.192 //y=4.74 //x2=38.6 //y2=4.735
cc_2855 ( N_noxref_9_c_3323_n N_noxref_19_c_8546_n ) capacitor c=0.00381156f \
 //x=39.5 //y=3.865 //x2=38.6 //y2=4.735
cc_2856 ( N_noxref_9_c_3332_p N_noxref_19_c_8591_n ) capacitor c=0.0195368f \
 //x=38.985 //y=1.835 //x2=49.685 //y2=2.4
cc_2857 ( N_noxref_9_c_3314_n N_noxref_19_c_8591_n ) capacitor c=0.0279333f \
 //x=39.34 //y=3.705 //x2=49.685 //y2=2.4
cc_2858 ( N_noxref_9_c_3336_p N_noxref_19_c_8591_n ) capacitor c=0.0126883f \
 //x=41.19 //y=3.705 //x2=49.685 //y2=2.4
cc_2859 ( N_noxref_9_c_3350_p N_noxref_19_c_8591_n ) capacitor c=7.09092e-19 \
 //x=38.9 //y=1.18 //x2=49.685 //y2=2.4
cc_2860 ( N_noxref_9_c_3352_p N_noxref_19_c_8591_n ) capacitor c=0.0181311f \
 //x=41.19 //y=2.26 //x2=49.685 //y2=2.4
cc_2861 ( N_noxref_9_c_3341_p N_noxref_19_c_8591_n ) capacitor c=2.20453e-19 \
 //x=41.19 //y=2.26 //x2=49.685 //y2=2.4
cc_2862 ( N_noxref_9_c_3354_p N_noxref_19_c_8591_n ) capacitor c=3.61358e-19 \
 //x=40.995 //y=2.095 //x2=49.685 //y2=2.4
cc_2863 ( N_noxref_9_c_3314_n N_noxref_19_c_8554_n ) capacitor c=0.00322577f \
 //x=39.34 //y=3.705 //x2=38.585 //y2=2.325
cc_2864 ( N_noxref_9_c_3314_n N_noxref_19_c_8556_n ) capacitor c=4.71798e-19 \
 //x=39.34 //y=3.705 //x2=38.6 //y2=2.26
cc_2865 ( N_noxref_9_c_3313_n N_noxref_19_c_8559_n ) capacitor c=0.00469257f \
 //x=38.745 //y=5.38 //x2=38.63 //y2=4.88
cc_2866 ( N_noxref_9_c_3315_n N_noxref_19_c_8559_n ) capacitor c=7.76118e-19 \
 //x=39.34 //y=5.295 //x2=38.63 //y2=4.88
cc_2867 ( N_noxref_9_c_3313_n N_noxref_19_M92_noxref_g ) capacitor \
 c=0.00842859f //x=38.745 //y=5.38 //x2=38.64 //y2=6.2
cc_2868 ( N_noxref_9_c_3393_p N_noxref_19_M92_noxref_g ) capacitor \
 c=0.00192712f //x=38.86 //y=5.38 //x2=38.64 //y2=6.2
cc_2869 ( N_noxref_9_c_3420_p N_noxref_19_M92_noxref_g ) capacitor \
 c=0.0178987f //x=38.86 //y=5.56 //x2=38.64 //y2=6.2
cc_2870 ( N_noxref_9_c_3421_p N_noxref_19_M93_noxref_g ) capacitor \
 c=0.0106088f //x=39.255 //y=5.38 //x2=39.08 //y2=6.2
cc_2871 ( N_noxref_9_c_3393_p N_noxref_19_M93_noxref_g ) capacitor \
 c=0.00298276f //x=38.86 //y=5.38 //x2=39.08 //y2=6.2
cc_2872 ( N_noxref_9_c_3420_p N_noxref_19_M93_noxref_g ) capacitor \
 c=0.0178506f //x=38.86 //y=5.56 //x2=39.08 //y2=6.2
cc_2873 ( N_noxref_9_c_3350_p N_noxref_19_c_8565_n ) capacitor c=0.00120406f \
 //x=38.9 //y=1.18 //x2=38.635 //y2=1.085
cc_2874 ( N_noxref_9_M23_noxref_d N_noxref_19_c_8565_n ) capacitor \
 c=0.00137165f //x=38.71 //y=1.085 //x2=38.635 //y2=1.085
cc_2875 ( N_noxref_9_c_3330_p N_noxref_19_c_8568_n ) capacitor c=0.00119008f \
 //x=38.9 //y=1.75 //x2=38.635 //y2=1.43
cc_2876 ( N_noxref_9_c_3350_p N_noxref_19_c_8568_n ) capacitor c=0.00218694f \
 //x=38.9 //y=1.18 //x2=38.635 //y2=1.43
cc_2877 ( N_noxref_9_M23_noxref_d N_noxref_19_c_8568_n ) capacitor \
 c=0.00237422f //x=38.71 //y=1.085 //x2=38.635 //y2=1.43
cc_2878 ( N_noxref_9_c_3330_p N_noxref_19_c_8570_n ) capacitor c=0.00450054f \
 //x=38.9 //y=1.75 //x2=38.635 //y2=1.74
cc_2879 ( N_noxref_9_c_3315_n N_noxref_19_c_8614_n ) capacitor c=0.00845606f \
 //x=39.34 //y=5.295 //x2=39.005 //y2=4.97
cc_2880 ( N_noxref_9_c_3393_p N_noxref_19_c_8614_n ) capacitor c=0.0020909f \
 //x=38.86 //y=5.38 //x2=39.005 //y2=4.97
cc_2881 ( N_noxref_9_c_3420_p N_noxref_19_c_8614_n ) capacitor c=0.00291714f \
 //x=38.86 //y=5.56 //x2=39.005 //y2=4.97
cc_2882 ( N_noxref_9_c_3350_p N_noxref_19_c_8617_n ) capacitor c=5.50523e-19 \
 //x=38.9 //y=1.18 //x2=39.01 //y2=0.93
cc_2883 ( N_noxref_9_M23_noxref_d N_noxref_19_c_8617_n ) capacitor \
 c=0.0020782f //x=38.71 //y=1.085 //x2=39.01 //y2=0.93
cc_2884 ( N_noxref_9_c_3330_p N_noxref_19_c_8619_n ) capacitor c=0.00916852f \
 //x=38.9 //y=1.75 //x2=39.01 //y2=1.585
cc_2885 ( N_noxref_9_c_3436_p N_noxref_19_c_8619_n ) capacitor c=0.00194324f \
 //x=39.255 //y=1.835 //x2=39.01 //y2=1.585
cc_2886 ( N_noxref_9_c_3350_p N_noxref_19_c_8619_n ) capacitor c=5.67071e-19 \
 //x=38.9 //y=1.18 //x2=39.01 //y2=1.585
cc_2887 ( N_noxref_9_M23_noxref_d N_noxref_19_c_8619_n ) capacitor \
 c=0.00356097f //x=38.71 //y=1.085 //x2=39.01 //y2=1.585
cc_2888 ( N_noxref_9_c_3350_p N_noxref_19_c_8573_n ) capacitor c=0.00109205f \
 //x=38.9 //y=1.18 //x2=39.165 //y2=1.085
cc_2889 ( N_noxref_9_M23_noxref_d N_noxref_19_c_8573_n ) capacitor \
 c=8.50095e-19 //x=38.71 //y=1.085 //x2=39.165 //y2=1.085
cc_2890 ( N_noxref_9_c_3330_p N_noxref_19_c_8574_n ) capacitor c=0.003249f \
 //x=38.9 //y=1.75 //x2=39.165 //y2=1.43
cc_2891 ( N_noxref_9_c_3436_p N_noxref_19_c_8574_n ) capacitor c=0.00323005f \
 //x=39.255 //y=1.835 //x2=39.165 //y2=1.43
cc_2892 ( N_noxref_9_c_3350_p N_noxref_19_c_8574_n ) capacitor c=0.00317092f \
 //x=38.9 //y=1.18 //x2=39.165 //y2=1.43
cc_2893 ( N_noxref_9_M23_noxref_d N_noxref_19_c_8574_n ) capacitor \
 c=0.00237422f //x=38.71 //y=1.085 //x2=39.165 //y2=1.43
cc_2894 ( N_noxref_9_c_3314_n N_noxref_19_c_8575_n ) capacitor c=7.86553e-19 \
 //x=39.34 //y=3.705 //x2=38.6 //y2=2.26
cc_2895 ( N_noxref_9_c_3330_p N_noxref_19_c_8630_n ) capacitor c=0.00341114f \
 //x=38.9 //y=1.75 //x2=38.6 //y2=2.095
cc_2896 ( N_noxref_9_c_3314_n N_noxref_19_c_8630_n ) capacitor c=0.00309058f \
 //x=39.34 //y=3.705 //x2=38.6 //y2=2.095
cc_2897 ( N_noxref_9_c_3313_n N_noxref_19_c_8578_n ) capacitor c=9.58916e-19 \
 //x=38.745 //y=5.38 //x2=38.63 //y2=4.88
cc_2898 ( N_noxref_9_c_3315_n N_noxref_19_c_8578_n ) capacitor c=0.00142201f \
 //x=39.34 //y=5.295 //x2=38.63 //y2=4.88
cc_2899 ( N_noxref_9_c_3314_n N_noxref_20_c_9365_n ) capacitor c=0.0254738f \
 //x=39.34 //y=3.705 //x2=46.36 //y2=3.14
cc_2900 ( N_noxref_9_c_3355_p N_noxref_20_c_9365_n ) capacitor c=0.00478126f \
 //x=39.34 //y=4.025 //x2=46.36 //y2=3.14
cc_2901 ( N_noxref_9_c_3336_p N_noxref_20_c_9365_n ) capacitor c=0.025467f \
 //x=41.19 //y=3.705 //x2=46.36 //y2=3.14
cc_2902 ( N_noxref_9_c_3337_p N_noxref_20_c_9365_n ) capacitor c=0.00408245f \
 //x=41.19 //y=4.025 //x2=46.36 //y2=3.14
cc_2903 ( N_noxref_9_c_3323_n N_noxref_20_c_9365_n ) capacitor c=0.01611f \
 //x=39.5 //y=3.865 //x2=46.36 //y2=3.14
cc_2904 ( N_noxref_9_c_3340_p N_noxref_20_c_9365_n ) capacitor c=0.0161327f \
 //x=41.185 //y=3.865 //x2=46.36 //y2=3.14
cc_2905 ( N_noxref_9_c_3361_p N_noxref_20_c_9365_n ) capacitor c=0.0678573f \
 //x=41.025 //y=3.865 //x2=46.36 //y2=3.14
cc_2906 ( N_noxref_9_c_3313_n N_VDD_c_10241_n ) capacitor c=0.00648307f \
 //x=38.745 //y=5.38 //x2=65.575 //y2=7.585
cc_2907 ( N_noxref_9_c_3421_p N_VDD_c_10241_n ) capacitor c=0.00492584f \
 //x=39.255 //y=5.38 //x2=65.575 //y2=7.585
cc_2908 ( N_noxref_9_c_3355_p N_VDD_c_10241_n ) capacitor c=5.11349e-19 \
 //x=39.34 //y=4.025 //x2=65.575 //y2=7.585
cc_2909 ( N_noxref_9_c_3337_p N_VDD_c_10241_n ) capacitor c=2.11935e-19 \
 //x=41.19 //y=4.025 //x2=65.575 //y2=7.585
cc_2910 ( N_noxref_9_c_3316_n N_VDD_c_10241_n ) capacitor c=0.00368834f \
 //x=37.98 //y=5.56 //x2=65.575 //y2=7.585
cc_2911 ( N_noxref_9_c_3393_p N_VDD_c_10241_n ) capacitor c=8.42709e-19 \
 //x=38.86 //y=5.38 //x2=65.575 //y2=7.585
cc_2912 ( N_noxref_9_c_3463_p N_VDD_c_10241_n ) capacitor c=0.00285853f \
 //x=38.86 //y=5.56 //x2=65.575 //y2=7.585
cc_2913 ( N_noxref_9_c_3344_p N_VDD_c_10241_n ) capacitor c=9.07241e-19 \
 //x=41.19 //y=4.88 //x2=65.575 //y2=7.585
cc_2914 ( N_noxref_9_c_3324_n N_VDD_c_10241_n ) capacitor c=0.00224881f \
 //x=37.98 //y=5.56 //x2=65.575 //y2=7.585
cc_2915 ( N_noxref_9_c_3420_p N_VDD_c_10241_n ) capacitor c=0.00224881f \
 //x=38.86 //y=5.56 //x2=65.575 //y2=7.585
cc_2916 ( N_noxref_9_c_3346_p N_VDD_c_10241_n ) capacitor c=6.22888e-19 \
 //x=41.19 //y=4.88 //x2=65.575 //y2=7.585
cc_2917 ( N_noxref_9_c_3313_n N_VDD_c_10685_n ) capacitor c=0.00208087f \
 //x=38.745 //y=5.38 //x2=38.335 //y2=7.585
cc_2918 ( N_noxref_9_c_3316_n N_VDD_c_10685_n ) capacitor c=9.41185e-19 \
 //x=37.98 //y=5.56 //x2=38.335 //y2=7.585
cc_2919 ( N_noxref_9_c_3324_n N_VDD_c_10685_n ) capacitor c=0.0136705f \
 //x=37.98 //y=5.56 //x2=38.335 //y2=7.585
cc_2920 ( N_noxref_9_c_3313_n N_VDD_c_10735_n ) capacitor c=0.00180737f \
 //x=38.745 //y=5.38 //x2=39.215 //y2=7.585
cc_2921 ( N_noxref_9_c_3421_p N_VDD_c_10735_n ) capacitor c=0.00208087f \
 //x=39.255 //y=5.38 //x2=39.215 //y2=7.585
cc_2922 ( N_noxref_9_c_3393_p N_VDD_c_10735_n ) capacitor c=4.23719e-19 \
 //x=38.86 //y=5.38 //x2=39.215 //y2=7.585
cc_2923 ( N_noxref_9_c_3463_p N_VDD_c_10735_n ) capacitor c=5.77976e-19 \
 //x=38.86 //y=5.56 //x2=39.215 //y2=7.585
cc_2924 ( N_noxref_9_c_3420_p N_VDD_c_10735_n ) capacitor c=0.0136705f \
 //x=38.86 //y=5.56 //x2=39.215 //y2=7.585
cc_2925 ( N_noxref_9_c_3344_p N_VDD_c_10740_n ) capacitor c=6.28113e-19 \
 //x=41.19 //y=4.88 //x2=41.665 //y2=7.585
cc_2926 ( N_noxref_9_M94_noxref_g N_VDD_c_10740_n ) capacitor c=0.00732618f \
 //x=41.09 //y=6.2 //x2=41.665 //y2=7.585
cc_2927 ( N_noxref_9_M95_noxref_g N_VDD_c_10740_n ) capacitor c=0.00755544f \
 //x=41.53 //y=6.2 //x2=41.665 //y2=7.585
cc_2928 ( N_noxref_9_c_3315_n N_VDD_c_10697_n ) capacitor c=0.0013228f \
 //x=39.34 //y=5.295 //x2=36.75 //y2=7.585
cc_2929 ( N_noxref_9_c_3316_n N_VDD_c_10697_n ) capacitor c=4.91377e-19 \
 //x=37.98 //y=5.56 //x2=36.75 //y2=7.585
cc_2930 ( N_noxref_9_c_3324_n N_VDD_c_10697_n ) capacitor c=0.0064135f \
 //x=37.98 //y=5.56 //x2=36.75 //y2=7.585
cc_2931 ( N_noxref_9_c_3315_n N_VDD_c_10746_n ) capacitor c=0.0291261f \
 //x=39.34 //y=5.295 //x2=40.08 //y2=7.585
cc_2932 ( N_noxref_9_c_3393_p N_VDD_c_10746_n ) capacitor c=0.00240948f \
 //x=38.86 //y=5.38 //x2=40.08 //y2=7.585
cc_2933 ( N_noxref_9_c_3463_p N_VDD_c_10746_n ) capacitor c=4.09141e-19 \
 //x=38.86 //y=5.56 //x2=40.08 //y2=7.585
cc_2934 ( N_noxref_9_c_3344_p N_VDD_c_10746_n ) capacitor c=0.00447349f \
 //x=41.19 //y=4.88 //x2=40.08 //y2=7.585
cc_2935 ( N_noxref_9_c_3339_p N_VDD_c_10746_n ) capacitor c=0.00564116f \
 //x=41.192 //y=4.74 //x2=40.08 //y2=7.585
cc_2936 ( N_noxref_9_c_3420_p N_VDD_c_10746_n ) capacitor c=0.0101861f \
 //x=38.86 //y=5.56 //x2=40.08 //y2=7.585
cc_2937 ( N_noxref_9_c_3346_p N_VDD_c_10746_n ) capacitor c=0.00370494f \
 //x=41.19 //y=4.88 //x2=40.08 //y2=7.585
cc_2938 ( N_noxref_9_c_3347_p N_VDD_c_10746_n ) capacitor c=0.0129564f \
 //x=41.19 //y=4.88 //x2=40.08 //y2=7.585
cc_2939 ( N_noxref_9_c_3316_n N_VDD_M90_noxref_s ) capacitor c=0.0572211f \
 //x=37.98 //y=5.56 //x2=37.405 //y2=5.2
cc_2940 ( N_noxref_9_c_3393_p N_VDD_M90_noxref_s ) capacitor c=6.52457e-19 \
 //x=38.86 //y=5.38 //x2=37.405 //y2=5.2
cc_2941 ( N_noxref_9_c_3324_n N_VDD_M90_noxref_s ) capacitor c=0.0887533f \
 //x=37.98 //y=5.56 //x2=37.405 //y2=5.2
cc_2942 ( N_noxref_9_c_3313_n N_VDD_M91_noxref_d ) capacitor c=0.00734094f \
 //x=38.745 //y=5.38 //x2=38.275 //y2=5.2
cc_2943 ( N_noxref_9_c_3316_n N_VDD_M91_noxref_d ) capacitor c=0.0043528f \
 //x=37.98 //y=5.56 //x2=38.275 //y2=5.2
cc_2944 ( N_noxref_9_c_3463_p N_VDD_M91_noxref_d ) capacitor c=0.0043528f \
 //x=38.86 //y=5.56 //x2=38.275 //y2=5.2
cc_2945 ( N_noxref_9_c_3324_n N_VDD_M91_noxref_d ) capacitor c=0.065554f \
 //x=37.98 //y=5.56 //x2=38.275 //y2=5.2
cc_2946 ( N_noxref_9_c_3420_p N_VDD_M91_noxref_d ) capacitor c=0.065554f \
 //x=38.86 //y=5.56 //x2=38.275 //y2=5.2
cc_2947 ( N_noxref_9_c_3421_p N_VDD_M93_noxref_d ) capacitor c=0.00898356f \
 //x=39.255 //y=5.38 //x2=39.155 //y2=5.2
cc_2948 ( N_noxref_9_c_3463_p N_VDD_M93_noxref_d ) capacitor c=0.00587834f \
 //x=38.86 //y=5.56 //x2=39.155 //y2=5.2
cc_2949 ( N_noxref_9_c_3322_n N_VDD_M93_noxref_d ) capacitor c=0.00122238f \
 //x=39.34 //y=3.88 //x2=39.155 //y2=5.2
cc_2950 ( N_noxref_9_c_3420_p N_VDD_M93_noxref_d ) capacitor c=0.065554f \
 //x=38.86 //y=5.56 //x2=39.155 //y2=5.2
cc_2951 ( N_noxref_9_c_3421_p N_VDD_M94_noxref_s ) capacitor c=0.00326953f \
 //x=39.255 //y=5.38 //x2=40.735 //y2=5.2
cc_2952 ( N_noxref_9_c_3337_p N_VDD_M94_noxref_s ) capacitor c=0.00143516f \
 //x=41.19 //y=4.025 //x2=40.735 //y2=5.2
cc_2953 ( N_noxref_9_c_3393_p N_VDD_M94_noxref_s ) capacitor c=0.00515461f \
 //x=38.86 //y=5.38 //x2=40.735 //y2=5.2
cc_2954 ( N_noxref_9_c_3463_p N_VDD_M94_noxref_s ) capacitor c=3.28075e-19 \
 //x=38.86 //y=5.56 //x2=40.735 //y2=5.2
cc_2955 ( N_noxref_9_M94_noxref_g N_VDD_M94_noxref_s ) capacitor c=0.0567929f \
 //x=41.09 //y=6.2 //x2=40.735 //y2=5.2
cc_2956 ( N_noxref_9_M95_noxref_g N_VDD_M95_noxref_d ) capacitor c=0.015318f \
 //x=41.53 //y=6.2 //x2=41.605 //y2=5.2
cc_2957 ( N_noxref_9_M95_noxref_g N_noxref_25_c_11788_n ) capacitor \
 c=0.00889217f //x=41.53 //y=6.2 //x2=42.075 //y2=5.38
cc_2958 ( N_noxref_9_c_3330_p N_noxref_25_c_11789_n ) capacitor c=0.00324213f \
 //x=38.9 //y=1.75 //x2=42.23 //y2=1.75
cc_2959 ( N_noxref_9_c_3436_p N_noxref_25_c_11790_n ) capacitor c=0.00231467f \
 //x=39.255 //y=1.835 //x2=42.315 //y2=1.835
cc_2960 ( N_noxref_9_c_3314_n N_noxref_25_c_11791_n ) capacitor c=0.00204244f \
 //x=39.34 //y=3.705 //x2=42.67 //y2=2.285
cc_2961 ( N_noxref_9_c_3315_n N_noxref_25_c_11792_n ) capacitor c=0.00281705f \
 //x=39.34 //y=5.295 //x2=42.67 //y2=5.295
cc_2962 ( N_noxref_9_c_3336_p N_noxref_25_c_11792_n ) capacitor c=0.00203378f \
 //x=41.19 //y=3.705 //x2=42.67 //y2=5.295
cc_2963 ( N_noxref_9_c_3339_p N_noxref_25_c_11792_n ) capacitor c=0.00198598f \
 //x=41.192 //y=4.74 //x2=42.67 //y2=5.295
cc_2964 ( N_noxref_9_c_3421_p N_noxref_25_c_11795_n ) capacitor c=0.00114153f \
 //x=39.255 //y=5.38 //x2=41.31 //y2=5.56
cc_2965 ( N_noxref_9_c_3337_p N_noxref_25_c_11795_n ) capacitor c=7.15631e-19 \
 //x=41.19 //y=4.025 //x2=41.31 //y2=5.56
cc_2966 ( N_noxref_9_c_3393_p N_noxref_25_c_11795_n ) capacitor c=5.29822e-19 \
 //x=38.86 //y=5.38 //x2=41.31 //y2=5.56
cc_2967 ( N_noxref_9_c_3463_p N_noxref_25_c_11795_n ) capacitor c=0.00147119f \
 //x=38.86 //y=5.56 //x2=41.31 //y2=5.56
cc_2968 ( N_noxref_9_c_3344_p N_noxref_25_c_11795_n ) capacitor c=0.0117744f \
 //x=41.19 //y=4.88 //x2=41.31 //y2=5.56
cc_2969 ( N_noxref_9_c_3346_p N_noxref_25_c_11795_n ) capacitor c=0.00277154f \
 //x=41.19 //y=4.88 //x2=41.31 //y2=5.56
cc_2970 ( N_noxref_9_M94_noxref_g N_noxref_25_c_11795_n ) capacitor \
 c=0.00201806f //x=41.09 //y=6.2 //x2=41.31 //y2=5.56
cc_2971 ( N_noxref_9_M95_noxref_g N_noxref_25_c_11795_n ) capacitor \
 c=0.00192712f //x=41.53 //y=6.2 //x2=41.31 //y2=5.56
cc_2972 ( N_noxref_9_c_3347_p N_noxref_25_c_11795_n ) capacitor c=0.00190205f \
 //x=41.19 //y=4.88 //x2=41.31 //y2=5.56
cc_2973 ( N_noxref_9_c_3350_p N_noxref_25_c_11804_n ) capacitor c=6.99317e-19 \
 //x=38.9 //y=1.18 //x2=42.23 //y2=1.18
cc_2974 ( N_noxref_9_c_3337_p N_noxref_25_c_11805_n ) capacitor c=2.05912e-19 \
 //x=41.19 //y=4.025 //x2=41.31 //y2=5.56
cc_2975 ( N_noxref_9_c_3344_p N_noxref_25_c_11805_n ) capacitor c=0.00104426f \
 //x=41.19 //y=4.88 //x2=41.31 //y2=5.56
cc_2976 ( N_noxref_9_c_3346_p N_noxref_25_c_11805_n ) capacitor c=0.00377369f \
 //x=41.19 //y=4.88 //x2=41.31 //y2=5.56
cc_2977 ( N_noxref_9_M94_noxref_g N_noxref_25_c_11805_n ) capacitor \
 c=0.0158358f //x=41.09 //y=6.2 //x2=41.31 //y2=5.56
cc_2978 ( N_noxref_9_M95_noxref_g N_noxref_25_c_11805_n ) capacitor \
 c=0.0178987f //x=41.53 //y=6.2 //x2=41.31 //y2=5.56
cc_2979 ( N_noxref_9_c_3347_p N_noxref_25_c_11805_n ) capacitor c=0.0043218f \
 //x=41.19 //y=4.88 //x2=41.31 //y2=5.56
cc_2980 ( N_noxref_9_c_3436_p N_GND_c_12685_n ) capacitor c=0.00608539f \
 //x=39.255 //y=1.835 //x2=41.175 //y2=0.175
cc_2981 ( N_noxref_9_c_3355_p N_GND_c_12685_n ) capacitor c=2.82958e-19 \
 //x=39.34 //y=4.025 //x2=41.175 //y2=0.175
cc_2982 ( N_noxref_9_c_3350_p N_GND_c_12685_n ) capacitor c=0.00928865f \
 //x=38.9 //y=1.18 //x2=41.175 //y2=0.175
cc_2983 ( N_noxref_9_M23_noxref_d N_GND_c_12685_n ) capacitor c=3.01769e-19 \
 //x=38.71 //y=1.085 //x2=41.175 //y2=0.175
cc_2984 ( N_noxref_9_c_3316_n N_GND_c_12644_n ) capacitor c=5.93935e-19 \
 //x=37.98 //y=5.56 //x2=37.93 //y2=1.135
cc_2985 ( N_noxref_9_c_3350_p N_GND_c_12644_n ) capacitor c=0.0140087f \
 //x=38.9 //y=1.18 //x2=37.93 //y2=1.135
cc_2986 ( N_noxref_9_M23_noxref_d N_GND_c_12644_n ) capacitor c=2.93544e-19 \
 //x=38.71 //y=1.085 //x2=37.93 //y2=1.135
cc_2987 ( N_noxref_9_c_3350_p N_GND_c_12692_n ) capacitor c=0.00549186f \
 //x=38.9 //y=1.18 //x2=41.26 //y2=1.135
cc_2988 ( N_noxref_9_c_3352_p N_GND_c_12692_n ) capacitor c=0.00645051f \
 //x=41.19 //y=2.26 //x2=41.26 //y2=1.135
cc_2989 ( N_noxref_9_c_3341_p N_GND_c_12692_n ) capacitor c=2.13705e-19 \
 //x=41.19 //y=2.26 //x2=41.26 //y2=1.135
cc_2990 ( N_noxref_9_c_3372_p N_GND_c_12692_n ) capacitor c=0.00171023f \
 //x=40.995 //y=1.045 //x2=41.26 //y2=1.135
cc_2991 ( N_noxref_9_c_3373_p N_GND_c_12692_n ) capacitor c=0.00357815f \
 //x=40.995 //y=1.39 //x2=41.26 //y2=1.135
cc_2992 ( N_noxref_9_c_3375_p N_GND_c_12692_n ) capacitor c=4.2764e-19 \
 //x=40.995 //y=1.7 //x2=41.26 //y2=1.135
cc_2993 ( N_noxref_9_c_3544_p N_GND_c_12692_n ) capacitor c=9.36995e-19 \
 //x=41.37 //y=0.89 //x2=41.26 //y2=1.135
cc_2994 ( N_noxref_9_c_3545_p N_GND_c_12692_n ) capacitor c=6.38426e-19 \
 //x=41.37 //y=1.545 //x2=41.26 //y2=1.135
cc_2995 ( N_noxref_9_c_3374_p N_GND_c_12692_n ) capacitor c=0.00171483f \
 //x=41.525 //y=1.045 //x2=41.26 //y2=1.135
cc_2996 ( N_noxref_9_c_3376_p N_GND_c_12692_n ) capacitor c=0.00296337f \
 //x=41.525 //y=1.39 //x2=41.26 //y2=1.135
cc_2997 ( N_noxref_9_c_3372_p N_GND_c_12702_n ) capacitor c=3.46594e-19 \
 //x=40.995 //y=1.045 //x2=41.257 //y2=1.005
cc_2998 ( N_noxref_9_c_3544_p N_GND_c_12702_n ) capacitor c=0.00838576f \
 //x=41.37 //y=0.89 //x2=41.257 //y2=1.005
cc_2999 ( N_noxref_9_c_3374_p N_GND_c_12702_n ) capacitor c=4.40196e-19 \
 //x=41.525 //y=1.045 //x2=41.257 //y2=1.005
cc_3000 ( N_noxref_9_c_3436_p N_GND_c_12658_n ) capacitor c=7.77585e-19 \
 //x=39.255 //y=1.835 //x2=39.91 //y2=0.175
cc_3001 ( N_noxref_9_c_3372_p N_GND_c_12706_n ) capacitor c=0.00688027f \
 //x=40.995 //y=1.045 //x2=43.24 //y2=0.175
cc_3002 ( N_noxref_9_c_3314_n N_GND_c_12666_n ) capacitor c=9.32616e-19 \
 //x=39.34 //y=3.705 //x2=36.75 //y2=0.175
cc_3003 ( N_noxref_9_c_3330_p N_GND_c_12708_n ) capacitor c=0.002973f //x=38.9 \
 //y=1.75 //x2=40.08 //y2=0.175
cc_3004 ( N_noxref_9_c_3436_p N_GND_c_12708_n ) capacitor c=0.0279678f \
 //x=39.255 //y=1.835 //x2=40.08 //y2=0.175
cc_3005 ( N_noxref_9_c_3336_p N_GND_c_12708_n ) capacitor c=0.00659363f \
 //x=41.19 //y=3.705 //x2=40.08 //y2=0.175
cc_3006 ( N_noxref_9_c_3352_p N_GND_c_12708_n ) capacitor c=0.0038267f \
 //x=41.19 //y=2.26 //x2=40.08 //y2=0.175
cc_3007 ( N_noxref_9_c_3341_p N_GND_c_12708_n ) capacitor c=0.00354425f \
 //x=41.19 //y=2.26 //x2=40.08 //y2=0.175
cc_3008 ( N_noxref_9_c_3375_p N_GND_c_12708_n ) capacitor c=0.0015404f \
 //x=40.995 //y=1.7 //x2=40.08 //y2=0.175
cc_3009 ( N_noxref_9_c_3354_p N_GND_c_12708_n ) capacitor c=0.00936534f \
 //x=40.995 //y=2.095 //x2=40.08 //y2=0.175
cc_3010 ( N_noxref_9_c_3350_p N_GND_M22_noxref_d ) capacitor c=2.82748e-19 \
 //x=38.9 //y=1.18 //x2=37.74 //y2=1.045
cc_3011 ( N_noxref_9_c_3352_p N_GND_M24_noxref_d ) capacitor c=2.20438e-19 \
 //x=41.19 //y=2.26 //x2=41.07 //y2=1.045
cc_3012 ( N_noxref_9_c_3372_p N_GND_M24_noxref_d ) capacitor c=0.00192399f \
 //x=40.995 //y=1.045 //x2=41.07 //y2=1.045
cc_3013 ( N_noxref_9_c_3373_p N_GND_M24_noxref_d ) capacitor c=0.00210798f \
 //x=40.995 //y=1.39 //x2=41.07 //y2=1.045
cc_3014 ( N_noxref_9_c_3544_p N_GND_M24_noxref_d ) capacitor c=0.00472259f \
 //x=41.37 //y=0.89 //x2=41.07 //y2=1.045
cc_3015 ( N_noxref_9_c_3545_p N_GND_M24_noxref_d ) capacitor c=0.00166857f \
 //x=41.37 //y=1.545 //x2=41.07 //y2=1.045
cc_3016 ( N_noxref_9_c_3374_p N_GND_M24_noxref_d ) capacitor c=0.00230174f \
 //x=41.525 //y=1.045 //x2=41.07 //y2=1.045
cc_3017 ( N_noxref_9_c_3376_p N_GND_M24_noxref_d ) capacitor c=0.00210798f \
 //x=41.525 //y=1.39 //x2=41.07 //y2=1.045
cc_3018 ( N_noxref_9_c_3332_p N_noxref_41_c_14652_n ) capacitor c=0.00911498f \
 //x=38.985 //y=1.835 //x2=38.415 //y2=1.675
cc_3019 ( N_noxref_9_c_3436_p N_noxref_41_c_14657_n ) capacitor c=0.00399245f \
 //x=39.255 //y=1.835 //x2=39.3 //y2=0.71
cc_3020 ( N_noxref_9_c_3350_p N_noxref_41_c_14657_n ) capacitor c=0.003751f \
 //x=38.9 //y=1.18 //x2=39.3 //y2=0.71
cc_3021 ( N_noxref_9_M23_noxref_d N_noxref_41_c_14657_n ) capacitor \
 c=0.00910163f //x=38.71 //y=1.085 //x2=39.3 //y2=0.71
cc_3022 ( N_noxref_9_c_3330_p N_noxref_41_M22_noxref_s ) capacitor \
 c=0.0162484f //x=38.9 //y=1.75 //x2=37.31 //y2=0.545
cc_3023 ( N_noxref_9_c_3436_p N_noxref_41_M22_noxref_s ) capacitor \
 c=0.00670006f //x=39.255 //y=1.835 //x2=37.31 //y2=0.545
cc_3024 ( N_noxref_9_c_3355_p N_noxref_41_M22_noxref_s ) capacitor \
 c=3.24398e-19 //x=39.34 //y=4.025 //x2=37.31 //y2=0.545
cc_3025 ( N_noxref_9_c_3350_p N_noxref_41_M22_noxref_s ) capacitor \
 c=0.00905169f //x=38.9 //y=1.18 //x2=37.31 //y2=0.545
cc_3026 ( N_noxref_9_c_3322_n N_noxref_41_M22_noxref_s ) capacitor \
 c=8.42257e-19 //x=39.34 //y=3.88 //x2=37.31 //y2=0.545
cc_3027 ( N_noxref_9_M23_noxref_d N_noxref_41_M22_noxref_s ) capacitor \
 c=0.0275552f //x=38.71 //y=1.085 //x2=37.31 //y2=0.545
cc_3028 ( N_noxref_9_c_3354_p N_noxref_42_c_14712_n ) capacitor c=0.00262672f \
 //x=40.995 //y=2.095 //x2=40.775 //y2=1.675
cc_3029 ( N_noxref_9_c_3337_p N_noxref_42_c_14713_n ) capacitor c=0.0036189f \
 //x=41.19 //y=4.025 //x2=41.66 //y2=1.76
cc_3030 ( N_noxref_9_c_3352_p N_noxref_42_c_14713_n ) capacitor c=0.00509504f \
 //x=41.19 //y=2.26 //x2=41.66 //y2=1.76
cc_3031 ( N_noxref_9_c_3341_p N_noxref_42_c_14713_n ) capacitor c=0.00763108f \
 //x=41.19 //y=2.26 //x2=41.66 //y2=1.76
cc_3032 ( N_noxref_9_c_3375_p N_noxref_42_c_14713_n ) capacitor c=0.00697076f \
 //x=40.995 //y=1.7 //x2=41.66 //y2=1.76
cc_3033 ( N_noxref_9_c_3354_p N_noxref_42_c_14713_n ) capacitor c=0.0170561f \
 //x=40.995 //y=2.095 //x2=41.66 //y2=1.76
cc_3034 ( N_noxref_9_c_3545_p N_noxref_42_c_14713_n ) capacitor c=0.00723574f \
 //x=41.37 //y=1.545 //x2=41.66 //y2=1.76
cc_3035 ( N_noxref_9_c_3376_p N_noxref_42_c_14713_n ) capacitor c=0.00339872f \
 //x=41.525 //y=1.39 //x2=41.66 //y2=1.76
cc_3036 ( N_noxref_9_c_3354_p N_noxref_42_c_14720_n ) capacitor c=6.71402e-19 \
 //x=40.995 //y=2.095 //x2=41.745 //y2=1.675
cc_3037 ( N_noxref_9_c_3372_p N_noxref_42_M24_noxref_s ) capacitor \
 c=0.0294925f //x=40.995 //y=1.045 //x2=40.64 //y2=0.545
cc_3038 ( N_noxref_9_c_3375_p N_noxref_42_M24_noxref_s ) capacitor \
 c=3.48408e-19 //x=40.995 //y=1.7 //x2=40.64 //y2=0.545
cc_3039 ( N_noxref_9_c_3374_p N_noxref_42_M24_noxref_s ) capacitor \
 c=0.0125442f //x=41.525 //y=1.045 //x2=40.64 //y2=0.545
cc_3040 ( N_noxref_10_c_3623_n N_D_c_4392_n ) capacitor c=0.0209359f \
 //x=32.105 //y=4.25 //x2=28.61 //y2=4.735
cc_3041 ( N_noxref_10_c_3836_p N_D_c_4251_n ) capacitor c=0.0033323f //x=23.06 \
 //y=2.375 //x2=28.435 //y2=2.78
cc_3042 ( N_noxref_10_c_3591_n N_D_c_4251_n ) capacitor c=0.0286344f //x=23.06 \
 //y=4.095 //x2=28.435 //y2=2.78
cc_3043 ( N_noxref_10_c_3616_n N_D_c_4251_n ) capacitor c=0.0111774f \
 //x=25.635 //y=4.25 //x2=28.435 //y2=2.78
cc_3044 ( N_noxref_10_c_3598_n N_D_c_4408_n ) capacitor c=0.0245244f //x=31.94 \
 //y=4.095 //x2=49.91 //y2=2.755
cc_3045 ( N_noxref_10_c_3667_n N_D_c_4408_n ) capacitor c=0.013091f //x=35.655 \
 //y=1.835 //x2=49.91 //y2=2.755
cc_3046 ( N_noxref_10_c_3668_n N_D_c_4408_n ) capacitor c=0.0287191f //x=36.01 \
 //y=4.105 //x2=49.91 //y2=2.755
cc_3047 ( N_noxref_10_c_3782_n N_D_c_4408_n ) capacitor c=0.0206228f //x=41.93 \
 //y=4.09 //x2=49.91 //y2=2.755
cc_3048 ( N_noxref_10_c_3613_n N_D_c_4408_n ) capacitor c=0.00365122f \
 //x=31.94 //y=2.26 //x2=49.91 //y2=2.755
cc_3049 ( N_noxref_10_c_3684_n N_D_c_4408_n ) capacitor c=4.96962e-19 \
 //x=35.57 //y=1.18 //x2=49.91 //y2=2.755
cc_3050 ( N_noxref_10_c_3765_n N_D_c_4408_n ) capacitor c=0.00609105f \
 //x=38.075 //y=4.27 //x2=49.91 //y2=2.755
cc_3051 ( N_noxref_10_c_3591_n CLK ) capacitor c=0.0461431f //x=23.06 \
 //y=4.095 //x2=24.17 //y2=3.51
cc_3052 ( N_noxref_10_c_3847_p CLK ) capacitor c=0.00774769f //x=23.06 \
 //y=4.415 //x2=24.17 //y2=3.51
cc_3053 ( N_noxref_10_c_3592_n CLK ) capacitor c=0.00604802f //x=23.06 \
 //y=4.755 //x2=24.17 //y2=3.51
cc_3054 ( N_noxref_10_c_3593_n CLK ) capacitor c=3.43503e-19 //x=23.06 \
 //y=4.25 //x2=24.17 //y2=3.51
cc_3055 ( N_noxref_10_c_3616_n CLK ) capacitor c=0.0271902f //x=25.635 \
 //y=4.25 //x2=24.17 //y2=3.51
cc_3056 ( N_noxref_10_c_3594_n CLK ) capacitor c=0.00243311f //x=23.225 \
 //y=4.255 //x2=24.17 //y2=3.51
cc_3057 ( N_noxref_10_c_3852_p CLK ) capacitor c=4.16726e-19 //x=23.06 \
 //y=2.26 //x2=24.17 //y2=3.51
cc_3058 ( N_noxref_10_c_3668_n CLK ) capacitor c=0.0692578f //x=36.01 \
 //y=4.105 //x2=35.27 //y2=3.51
cc_3059 ( N_noxref_10_c_3738_n CLK ) capacitor c=0.01773f //x=36.01 //y=4.425 \
 //x2=35.27 //y2=3.51
cc_3060 ( N_noxref_10_c_3671_n CLK ) capacitor c=0.00990428f //x=36.01 \
 //y=5.295 //x2=35.27 //y2=3.51
cc_3061 ( N_noxref_10_c_3856_p CLK ) capacitor c=9.19401e-19 //x=36.01 \
 //y=4.25 //x2=35.27 //y2=3.51
cc_3062 ( N_noxref_10_c_3685_n CLK ) capacitor c=0.0195347f //x=35.84 //y=4.25 \
 //x2=35.27 //y2=3.51
cc_3063 ( N_noxref_10_c_3767_n CLK ) capacitor c=0.00330634f //x=37.73 \
 //y=4.27 //x2=35.27 //y2=3.51
cc_3064 ( N_noxref_10_c_3836_p N_CLK_c_5845_n ) capacitor c=0.0115546f \
 //x=23.06 //y=2.375 //x2=24.17 //y2=2.375
cc_3065 ( N_noxref_10_c_3852_p N_CLK_c_5845_n ) capacitor c=5.40058e-19 \
 //x=23.06 //y=2.26 //x2=24.17 //y2=2.375
cc_3066 ( N_noxref_10_c_3861_p N_CLK_c_5845_n ) capacitor c=0.00147006f \
 //x=22.76 //y=2.095 //x2=24.17 //y2=2.375
cc_3067 ( N_noxref_10_c_3592_n N_CLK_c_5848_n ) capacitor c=0.00757211f \
 //x=23.06 //y=4.755 //x2=24.17 //y2=4.88
cc_3068 ( N_noxref_10_c_3616_n N_CLK_c_5848_n ) capacitor c=3.90968e-19 \
 //x=25.635 //y=4.25 //x2=24.17 //y2=4.88
cc_3069 ( N_noxref_10_c_3864_p N_CLK_c_5848_n ) capacitor c=5.84784e-19 \
 //x=23.06 //y=4.88 //x2=24.17 //y2=4.88
cc_3070 ( N_noxref_10_c_3775_n N_CLK_c_5848_n ) capacitor c=0.00109563f \
 //x=23.625 //y=4.97 //x2=24.17 //y2=4.88
cc_3071 ( N_noxref_10_c_3866_p N_CLK_c_5848_n ) capacitor c=8.39124e-19 \
 //x=23.335 //y=4.97 //x2=24.17 //y2=4.88
cc_3072 ( N_noxref_10_c_3665_n N_CLK_c_5887_n ) capacitor c=0.0247435f \
 //x=35.415 //y=5.38 //x2=35.295 //y2=4.865
cc_3073 ( N_noxref_10_c_3671_n N_CLK_c_5887_n ) capacitor c=0.0154628f \
 //x=36.01 //y=5.295 //x2=35.295 //y2=4.865
cc_3074 ( N_noxref_10_c_3685_n N_CLK_c_5887_n ) capacitor c=4.16369e-19 \
 //x=35.84 //y=4.25 //x2=35.295 //y2=4.865
cc_3075 ( N_noxref_10_c_3870_p N_CLK_c_5887_n ) capacitor c=8.41381e-19 \
 //x=35.53 //y=5.56 //x2=35.295 //y2=4.865
cc_3076 ( N_noxref_10_c_3668_n N_CLK_c_5891_n ) capacitor c=0.015397f \
 //x=36.01 //y=4.105 //x2=35.27 //y2=2.26
cc_3077 ( N_noxref_10_c_3847_p N_CLK_c_5998_n ) capacitor c=0.00120223f \
 //x=23.06 //y=4.415 //x2=22.68 //y2=4.62
cc_3078 ( N_noxref_10_c_3592_n N_CLK_c_5998_n ) capacitor c=6.82947e-19 \
 //x=23.06 //y=4.755 //x2=22.68 //y2=4.62
cc_3079 ( N_noxref_10_c_3594_n N_CLK_c_5998_n ) capacitor c=0.0364798f \
 //x=23.225 //y=4.255 //x2=22.68 //y2=4.62
cc_3080 ( N_noxref_10_c_3847_p N_CLK_c_6001_n ) capacitor c=0.00655819f \
 //x=23.06 //y=4.415 //x2=23.28 //y2=4.64
cc_3081 ( N_noxref_10_c_3592_n N_CLK_c_6001_n ) capacitor c=0.030731f \
 //x=23.06 //y=4.755 //x2=23.28 //y2=4.64
cc_3082 ( N_noxref_10_c_3616_n N_CLK_c_6001_n ) capacitor c=0.0110662f \
 //x=25.635 //y=4.25 //x2=23.28 //y2=4.64
cc_3083 ( N_noxref_10_c_3866_p N_CLK_c_6001_n ) capacitor c=0.00101612f \
 //x=23.335 //y=4.97 //x2=23.28 //y2=4.64
cc_3084 ( N_noxref_10_c_3592_n N_CLK_c_5851_n ) capacitor c=0.00705538f \
 //x=23.06 //y=4.755 //x2=24.17 //y2=4.88
cc_3085 ( N_noxref_10_c_3606_n N_CLK_c_5894_n ) capacitor c=0.00232598f \
 //x=31.94 //y=4.415 //x2=32.16 //y2=4.64
cc_3086 ( N_noxref_10_c_3607_n N_CLK_c_5894_n ) capacitor c=0.026106f \
 //x=31.94 //y=4.735 //x2=32.16 //y2=4.64
cc_3087 ( N_noxref_10_c_3685_n N_CLK_c_5894_n ) capacitor c=0.0122383f \
 //x=35.84 //y=4.25 //x2=32.16 //y2=4.64
cc_3088 ( N_noxref_10_c_3650_n N_CLK_c_5894_n ) capacitor c=7.54771e-19 \
 //x=31.97 //y=4.88 //x2=32.16 //y2=4.64
cc_3089 ( N_noxref_10_c_3592_n N_CLK_c_5852_n ) capacitor c=4.99762e-19 \
 //x=23.06 //y=4.755 //x2=31.815 //y2=4.64
cc_3090 ( N_noxref_10_c_3606_n N_CLK_c_5852_n ) capacitor c=0.00260076f \
 //x=31.94 //y=4.415 //x2=31.815 //y2=4.64
cc_3091 ( N_noxref_10_c_3607_n N_CLK_c_5852_n ) capacitor c=4.19842e-19 \
 //x=31.94 //y=4.735 //x2=31.815 //y2=4.64
cc_3092 ( N_noxref_10_c_3616_n N_CLK_c_5852_n ) capacitor c=0.274259f \
 //x=25.635 //y=4.25 //x2=31.815 //y2=4.64
cc_3093 ( N_noxref_10_c_3620_n N_CLK_c_5852_n ) capacitor c=0.11637f \
 //x=26.235 //y=4.265 //x2=31.815 //y2=4.64
cc_3094 ( N_noxref_10_c_3621_n N_CLK_c_5852_n ) capacitor c=0.059022f \
 //x=27.48 //y=4.25 //x2=31.815 //y2=4.64
cc_3095 ( N_noxref_10_c_3623_n N_CLK_c_5852_n ) capacitor c=0.363741f \
 //x=32.105 //y=4.25 //x2=31.815 //y2=4.64
cc_3096 ( N_noxref_10_c_3738_n N_CLK_c_5947_n ) capacitor c=0.00374387f \
 //x=36.01 //y=4.425 //x2=36.215 //y2=4.65
cc_3097 ( N_noxref_10_c_3671_n N_CLK_c_5947_n ) capacitor c=0.0280105f \
 //x=36.01 //y=5.295 //x2=36.215 //y2=4.65
cc_3098 ( N_noxref_10_c_3767_n N_CLK_c_5947_n ) capacitor c=0.132895f \
 //x=37.73 //y=4.27 //x2=36.215 //y2=4.65
cc_3099 ( N_noxref_10_c_3607_n N_CLK_c_5897_n ) capacitor c=4.11687e-19 \
 //x=31.94 //y=4.735 //x2=35.87 //y2=4.65
cc_3100 ( N_noxref_10_c_3665_n N_CLK_c_5897_n ) capacitor c=0.00962575f \
 //x=35.415 //y=5.38 //x2=35.87 //y2=4.65
cc_3101 ( N_noxref_10_c_3778_n N_CLK_c_5897_n ) capacitor c=0.00773173f \
 //x=35.925 //y=5.38 //x2=35.87 //y2=4.65
cc_3102 ( N_noxref_10_c_3738_n N_CLK_c_5897_n ) capacitor c=0.00259792f \
 //x=36.01 //y=4.425 //x2=35.87 //y2=4.65
cc_3103 ( N_noxref_10_c_3671_n N_CLK_c_5897_n ) capacitor c=0.00734956f \
 //x=36.01 //y=5.295 //x2=35.87 //y2=4.65
cc_3104 ( N_noxref_10_c_3675_n N_CLK_c_5897_n ) capacitor c=0.0207179f \
 //x=34.65 //y=5.56 //x2=35.87 //y2=4.65
cc_3105 ( N_noxref_10_c_3795_n N_CLK_c_5897_n ) capacitor c=0.00976243f \
 //x=35.53 //y=5.38 //x2=35.87 //y2=4.65
cc_3106 ( N_noxref_10_c_3685_n N_CLK_c_5897_n ) capacitor c=0.329182f \
 //x=35.84 //y=4.25 //x2=35.87 //y2=4.65
cc_3107 ( N_noxref_10_c_3767_n N_CLK_c_5897_n ) capacitor c=0.0364799f \
 //x=37.73 //y=4.27 //x2=35.87 //y2=4.65
cc_3108 ( N_noxref_10_c_3789_n N_CLK_c_5953_n ) capacitor c=0.00262187f \
 //x=41.93 //y=4.41 //x2=41.545 //y2=4.62
cc_3109 ( N_noxref_10_c_3790_n N_CLK_c_5953_n ) capacitor c=3.12067e-19 \
 //x=41.93 //y=4.735 //x2=41.545 //y2=4.62
cc_3110 ( N_noxref_10_c_3765_n N_CLK_c_5953_n ) capacitor c=0.362639f \
 //x=38.075 //y=4.27 //x2=41.545 //y2=4.62
cc_3111 ( N_noxref_10_c_3767_n N_CLK_c_5953_n ) capacitor c=0.0596234f \
 //x=37.73 //y=4.27 //x2=41.545 //y2=4.62
cc_3112 ( N_noxref_10_c_3789_n N_CLK_c_6033_n ) capacitor c=0.00225107f \
 //x=41.93 //y=4.41 //x2=42.145 //y2=4.635
cc_3113 ( N_noxref_10_c_3790_n N_CLK_c_6033_n ) capacitor c=0.0265693f \
 //x=41.93 //y=4.735 //x2=42.145 //y2=4.635
cc_3114 ( N_noxref_10_c_3832_n N_CLK_c_6033_n ) capacitor c=7.56668e-19 \
 //x=41.96 //y=4.88 //x2=42.145 //y2=4.635
cc_3115 ( N_noxref_10_c_3836_p N_CLK_c_5859_n ) capacitor c=5.39999e-19 \
 //x=23.06 //y=2.375 //x2=24.17 //y2=2.26
cc_3116 ( N_noxref_10_c_3591_n N_CLK_c_5859_n ) capacitor c=4.16726e-19 \
 //x=23.06 //y=4.095 //x2=24.17 //y2=2.26
cc_3117 ( N_noxref_10_c_3852_p N_CLK_c_5859_n ) capacitor c=0.00125213f \
 //x=23.06 //y=2.26 //x2=24.17 //y2=2.26
cc_3118 ( N_noxref_10_c_3861_p N_CLK_c_5859_n ) capacitor c=0.00214573f \
 //x=22.76 //y=2.095 //x2=24.17 //y2=2.26
cc_3119 ( N_noxref_10_c_3592_n N_CLK_c_5863_n ) capacitor c=2.50501e-19 \
 //x=23.06 //y=4.755 //x2=24.17 //y2=4.88
cc_3120 ( N_noxref_10_c_3864_p N_CLK_c_5863_n ) capacitor c=0.00114249f \
 //x=23.06 //y=4.88 //x2=24.17 //y2=4.88
cc_3121 ( N_noxref_10_c_3775_n N_CLK_c_5863_n ) capacitor c=0.00133699f \
 //x=23.625 //y=4.97 //x2=24.17 //y2=4.88
cc_3122 ( N_noxref_10_c_3866_p N_CLK_c_5863_n ) capacitor c=0.00129812f \
 //x=23.335 //y=4.97 //x2=24.17 //y2=4.88
cc_3123 ( N_noxref_10_c_3668_n N_CLK_c_5901_n ) capacitor c=9.90728e-19 \
 //x=36.01 //y=4.105 //x2=35.27 //y2=2.26
cc_3124 ( N_noxref_10_c_3665_n N_CLK_c_5905_n ) capacitor c=0.00469232f \
 //x=35.415 //y=5.38 //x2=35.3 //y2=4.88
cc_3125 ( N_noxref_10_c_3671_n N_CLK_c_5905_n ) capacitor c=5.14671e-19 \
 //x=36.01 //y=5.295 //x2=35.3 //y2=4.88
cc_3126 ( N_noxref_10_M72_noxref_g N_CLK_M74_noxref_g ) capacitor c=0.0106276f \
 //x=23.26 //y=6.2 //x2=24.14 //y2=6.2
cc_3127 ( N_noxref_10_M73_noxref_g N_CLK_M74_noxref_g ) capacitor c=0.107144f \
 //x=23.7 //y=6.2 //x2=24.14 //y2=6.2
cc_3128 ( N_noxref_10_M73_noxref_g N_CLK_M75_noxref_g ) capacitor c=0.0101598f \
 //x=23.7 //y=6.2 //x2=24.58 //y2=6.2
cc_3129 ( N_noxref_10_c_3665_n N_CLK_M88_noxref_g ) capacitor c=0.00842814f \
 //x=35.415 //y=5.38 //x2=35.31 //y2=6.2
cc_3130 ( N_noxref_10_c_3795_n N_CLK_M88_noxref_g ) capacitor c=0.00192712f \
 //x=35.53 //y=5.38 //x2=35.31 //y2=6.2
cc_3131 ( N_noxref_10_c_3870_p N_CLK_M88_noxref_g ) capacitor c=0.0178987f \
 //x=35.53 //y=5.56 //x2=35.31 //y2=6.2
cc_3132 ( N_noxref_10_c_3778_n N_CLK_M89_noxref_g ) capacitor c=0.0105692f \
 //x=35.925 //y=5.38 //x2=35.75 //y2=6.2
cc_3133 ( N_noxref_10_c_3795_n N_CLK_M89_noxref_g ) capacitor c=0.00298276f \
 //x=35.53 //y=5.38 //x2=35.75 //y2=6.2
cc_3134 ( N_noxref_10_c_3870_p N_CLK_M89_noxref_g ) capacitor c=0.0178506f \
 //x=35.53 //y=5.56 //x2=35.75 //y2=6.2
cc_3135 ( N_noxref_10_c_3930_p N_CLK_c_6056_n ) capacitor c=5.72528e-19 \
 //x=22.76 //y=1.055 //x2=23.735 //y2=1.09
cc_3136 ( N_noxref_10_c_3931_p N_CLK_c_6056_n ) capacitor c=0.00150277f \
 //x=22.76 //y=1.4 //x2=23.735 //y2=1.09
cc_3137 ( N_noxref_10_c_3932_p N_CLK_c_6056_n ) capacitor c=0.0160123f \
 //x=23.29 //y=1.055 //x2=23.735 //y2=1.09
cc_3138 ( N_noxref_10_c_3933_p N_CLK_c_6059_n ) capacitor c=0.00111227f \
 //x=22.76 //y=1.71 //x2=23.735 //y2=1.4
cc_3139 ( N_noxref_10_c_3934_p N_CLK_c_6059_n ) capacitor c=0.0124075f \
 //x=23.29 //y=1.4 //x2=23.735 //y2=1.4
cc_3140 ( N_noxref_10_c_3932_p N_CLK_c_5869_n ) capacitor c=9.19165e-19 \
 //x=23.29 //y=1.055 //x2=24.26 //y2=1.09
cc_3141 ( N_noxref_10_c_3934_p N_CLK_c_5870_n ) capacitor c=0.0010154f \
 //x=23.29 //y=1.4 //x2=24.26 //y2=1.4
cc_3142 ( N_noxref_10_c_3934_p N_CLK_c_5871_n ) capacitor c=9.23422e-19 \
 //x=23.29 //y=1.4 //x2=24.26 //y2=1.63
cc_3143 ( N_noxref_10_c_3836_p N_CLK_c_5872_n ) capacitor c=0.00140534f \
 //x=23.06 //y=2.375 //x2=24.26 //y2=2.095
cc_3144 ( N_noxref_10_c_3852_p N_CLK_c_5872_n ) capacitor c=0.0020754f \
 //x=23.06 //y=2.26 //x2=24.26 //y2=2.095
cc_3145 ( N_noxref_10_c_3861_p N_CLK_c_5872_n ) capacitor c=0.00964411f \
 //x=22.76 //y=2.095 //x2=24.26 //y2=2.095
cc_3146 ( N_noxref_10_c_3684_n N_CLK_c_5911_n ) capacitor c=0.00120406f \
 //x=35.57 //y=1.18 //x2=35.305 //y2=1.085
cc_3147 ( N_noxref_10_M21_noxref_d N_CLK_c_5911_n ) capacitor c=0.00137165f \
 //x=35.38 //y=1.085 //x2=35.305 //y2=1.085
cc_3148 ( N_noxref_10_c_3666_n N_CLK_c_5914_n ) capacitor c=0.00119008f \
 //x=35.57 //y=1.75 //x2=35.305 //y2=1.43
cc_3149 ( N_noxref_10_c_3684_n N_CLK_c_5914_n ) capacitor c=0.00218694f \
 //x=35.57 //y=1.18 //x2=35.305 //y2=1.43
cc_3150 ( N_noxref_10_M21_noxref_d N_CLK_c_5914_n ) capacitor c=0.00237422f \
 //x=35.38 //y=1.085 //x2=35.305 //y2=1.43
cc_3151 ( N_noxref_10_c_3666_n N_CLK_c_5916_n ) capacitor c=0.00438634f \
 //x=35.57 //y=1.75 //x2=35.305 //y2=1.74
cc_3152 ( N_noxref_10_c_3738_n N_CLK_c_6073_n ) capacitor c=9.17945e-19 \
 //x=36.01 //y=4.425 //x2=35.675 //y2=4.97
cc_3153 ( N_noxref_10_c_3671_n N_CLK_c_6073_n ) capacitor c=0.00841383f \
 //x=36.01 //y=5.295 //x2=35.675 //y2=4.97
cc_3154 ( N_noxref_10_c_3795_n N_CLK_c_6073_n ) capacitor c=0.0020909f \
 //x=35.53 //y=5.38 //x2=35.675 //y2=4.97
cc_3155 ( N_noxref_10_c_3870_p N_CLK_c_6073_n ) capacitor c=0.00291714f \
 //x=35.53 //y=5.56 //x2=35.675 //y2=4.97
cc_3156 ( N_noxref_10_c_3684_n N_CLK_c_6077_n ) capacitor c=5.50523e-19 \
 //x=35.57 //y=1.18 //x2=35.68 //y2=0.93
cc_3157 ( N_noxref_10_M21_noxref_d N_CLK_c_6077_n ) capacitor c=0.0020782f \
 //x=35.38 //y=1.085 //x2=35.68 //y2=0.93
cc_3158 ( N_noxref_10_c_3666_n N_CLK_c_6079_n ) capacitor c=0.00916852f \
 //x=35.57 //y=1.75 //x2=35.68 //y2=1.585
cc_3159 ( N_noxref_10_c_3779_n N_CLK_c_6079_n ) capacitor c=0.00194324f \
 //x=35.925 //y=1.835 //x2=35.68 //y2=1.585
cc_3160 ( N_noxref_10_c_3684_n N_CLK_c_6079_n ) capacitor c=5.67071e-19 \
 //x=35.57 //y=1.18 //x2=35.68 //y2=1.585
cc_3161 ( N_noxref_10_M21_noxref_d N_CLK_c_6079_n ) capacitor c=0.00356097f \
 //x=35.38 //y=1.085 //x2=35.68 //y2=1.585
cc_3162 ( N_noxref_10_c_3684_n N_CLK_c_5919_n ) capacitor c=0.00109205f \
 //x=35.57 //y=1.18 //x2=35.835 //y2=1.085
cc_3163 ( N_noxref_10_M21_noxref_d N_CLK_c_5919_n ) capacitor c=8.50095e-19 \
 //x=35.38 //y=1.085 //x2=35.835 //y2=1.085
cc_3164 ( N_noxref_10_c_3666_n N_CLK_c_5920_n ) capacitor c=0.003249f \
 //x=35.57 //y=1.75 //x2=35.835 //y2=1.43
cc_3165 ( N_noxref_10_c_3779_n N_CLK_c_5920_n ) capacitor c=0.00323005f \
 //x=35.925 //y=1.835 //x2=35.835 //y2=1.43
cc_3166 ( N_noxref_10_c_3684_n N_CLK_c_5920_n ) capacitor c=0.00317092f \
 //x=35.57 //y=1.18 //x2=35.835 //y2=1.43
cc_3167 ( N_noxref_10_M21_noxref_d N_CLK_c_5920_n ) capacitor c=0.00237422f \
 //x=35.38 //y=1.085 //x2=35.835 //y2=1.43
cc_3168 ( N_noxref_10_c_3864_p N_CLK_c_5877_n ) capacitor c=0.00124807f \
 //x=23.06 //y=4.88 //x2=24.17 //y2=4.88
cc_3169 ( N_noxref_10_c_3775_n N_CLK_c_5877_n ) capacitor c=0.0163966f \
 //x=23.625 //y=4.97 //x2=24.17 //y2=4.88
cc_3170 ( N_noxref_10_c_3866_p N_CLK_c_5877_n ) capacitor c=0.00409733f \
 //x=23.335 //y=4.97 //x2=24.17 //y2=4.88
cc_3171 ( N_noxref_10_c_3668_n N_CLK_c_5921_n ) capacitor c=0.00281392f \
 //x=36.01 //y=4.105 //x2=35.27 //y2=2.26
cc_3172 ( N_noxref_10_c_3666_n N_CLK_c_6093_n ) capacitor c=0.00341114f \
 //x=35.57 //y=1.75 //x2=35.27 //y2=2.095
cc_3173 ( N_noxref_10_c_3668_n N_CLK_c_6093_n ) capacitor c=0.00309058f \
 //x=36.01 //y=4.105 //x2=35.27 //y2=2.095
cc_3174 ( N_noxref_10_c_3665_n N_CLK_c_5924_n ) capacitor c=7.7763e-19 \
 //x=35.415 //y=5.38 //x2=35.3 //y2=4.88
cc_3175 ( N_noxref_10_c_3782_n N_noxref_17_c_7358_n ) capacitor c=0.00215984f \
 //x=41.93 //y=4.09 //x2=44.52 //y2=4.095
cc_3176 ( N_noxref_10_c_3790_n N_noxref_17_c_7359_n ) capacitor c=4.62969e-19 \
 //x=41.93 //y=4.735 //x2=44.52 //y2=4.755
cc_3177 ( N_noxref_10_c_3798_n N_noxref_17_c_7360_n ) capacitor c=3.5728e-19 \
 //x=41.93 //y=4.25 //x2=44.52 //y2=4.25
cc_3178 ( N_noxref_10_c_3765_n N_noxref_17_c_7361_n ) capacitor c=0.00180909f \
 //x=38.075 //y=4.27 //x2=44.685 //y2=4.255
cc_3179 ( N_noxref_10_c_3668_n N_noxref_19_c_8546_n ) capacitor c=0.00253496f \
 //x=36.01 //y=4.105 //x2=38.6 //y2=4.735
cc_3180 ( N_noxref_10_c_3671_n N_noxref_19_c_8546_n ) capacitor c=7.08116e-19 \
 //x=36.01 //y=5.295 //x2=38.6 //y2=4.735
cc_3181 ( N_noxref_10_c_3765_n N_noxref_19_c_8546_n ) capacitor c=0.025322f \
 //x=38.075 //y=4.27 //x2=38.6 //y2=4.735
cc_3182 ( N_noxref_10_c_3782_n N_noxref_19_c_8591_n ) capacitor c=0.0107616f \
 //x=41.93 //y=4.09 //x2=49.685 //y2=2.4
cc_3183 ( N_noxref_10_c_3799_n N_noxref_19_c_8591_n ) capacitor c=0.0165348f \
 //x=41.93 //y=2.26 //x2=49.685 //y2=2.4
cc_3184 ( N_noxref_10_c_3829_n N_noxref_19_c_8591_n ) capacitor c=2.98635e-19 \
 //x=41.93 //y=2.26 //x2=49.685 //y2=2.4
cc_3185 ( N_noxref_10_c_3836_p N_noxref_20_c_9194_n ) capacitor c=0.00458539f \
 //x=23.06 //y=2.375 //x2=21.21 //y2=2.995
cc_3186 ( N_noxref_10_c_3591_n N_noxref_20_c_9194_n ) capacitor c=0.00776881f \
 //x=23.06 //y=4.095 //x2=21.21 //y2=2.995
cc_3187 ( N_noxref_10_c_3591_n N_noxref_20_c_9283_n ) capacitor c=0.00253713f \
 //x=23.06 //y=4.095 //x2=21.21 //y2=3.315
cc_3188 ( N_noxref_10_c_3591_n N_noxref_20_c_9196_n ) capacitor c=0.0151507f \
 //x=23.06 //y=4.095 //x2=21.21 //y2=5.295
cc_3189 ( N_noxref_10_c_3847_p N_noxref_20_c_9196_n ) capacitor c=0.00350086f \
 //x=23.06 //y=4.415 //x2=21.21 //y2=5.295
cc_3190 ( N_noxref_10_c_3592_n N_noxref_20_c_9196_n ) capacitor c=0.00761862f \
 //x=23.06 //y=4.755 //x2=21.21 //y2=5.295
cc_3191 ( N_noxref_10_c_3594_n N_noxref_20_c_9196_n ) capacitor c=0.00222409f \
 //x=23.225 //y=4.255 //x2=21.21 //y2=5.295
cc_3192 ( N_noxref_10_c_3616_n N_noxref_20_c_9316_n ) capacitor c=0.00214266f \
 //x=25.635 //y=4.25 //x2=25.5 //y2=3.125
cc_3193 ( N_noxref_10_c_3591_n N_noxref_20_c_9305_n ) capacitor c=0.0301642f \
 //x=23.06 //y=4.095 //x2=25.07 //y2=3.125
cc_3194 ( N_noxref_10_c_3847_p N_noxref_20_c_9305_n ) capacitor c=0.00323333f \
 //x=23.06 //y=4.415 //x2=25.07 //y2=3.125
cc_3195 ( N_noxref_10_c_3616_n N_noxref_20_c_9305_n ) capacitor c=0.0555385f \
 //x=25.635 //y=4.25 //x2=25.07 //y2=3.125
cc_3196 ( N_noxref_10_c_3594_n N_noxref_20_c_9305_n ) capacitor c=0.00806737f \
 //x=23.225 //y=4.255 //x2=25.07 //y2=3.125
cc_3197 ( N_noxref_10_c_3598_n N_noxref_20_c_9334_n ) capacitor c=5.28162e-19 \
 //x=31.94 //y=4.095 //x2=31.41 //y2=3.12
cc_3198 ( N_noxref_10_c_3623_n N_noxref_20_c_9334_n ) capacitor c=0.00277047f \
 //x=32.105 //y=4.25 //x2=31.41 //y2=3.12
cc_3199 ( N_noxref_10_c_3598_n N_noxref_20_c_9337_n ) capacitor c=0.0230131f \
 //x=31.94 //y=4.095 //x2=32.3 //y2=3.14
cc_3200 ( N_noxref_10_c_3685_n N_noxref_20_c_9337_n ) capacitor c=0.00313122f \
 //x=35.84 //y=4.25 //x2=32.3 //y2=3.14
cc_3201 ( N_noxref_10_c_3685_n N_noxref_20_c_9345_n ) capacitor c=0.00691739f \
 //x=35.84 //y=4.25 //x2=34.74 //y2=3.125
cc_3202 ( N_noxref_10_c_3668_n N_noxref_20_c_9365_n ) capacitor c=0.0259568f \
 //x=36.01 //y=4.105 //x2=46.36 //y2=3.14
cc_3203 ( N_noxref_10_c_3782_n N_noxref_20_c_9365_n ) capacitor c=0.0246229f \
 //x=41.93 //y=4.09 //x2=46.36 //y2=3.14
cc_3204 ( N_noxref_10_c_3789_n N_noxref_20_c_9365_n ) capacitor c=0.00276508f \
 //x=41.93 //y=4.41 //x2=46.36 //y2=3.14
cc_3205 ( N_noxref_10_c_3765_n N_noxref_20_c_9365_n ) capacitor c=0.0579567f \
 //x=38.075 //y=4.27 //x2=46.36 //y2=3.14
cc_3206 ( N_noxref_10_c_3767_n N_noxref_20_c_9365_n ) capacitor c=0.0130775f \
 //x=37.73 //y=4.27 //x2=46.36 //y2=3.14
cc_3207 ( N_noxref_10_c_3847_p N_VDD_c_10241_n ) capacitor c=3.76138e-19 \
 //x=23.06 //y=4.415 //x2=65.575 //y2=7.585
cc_3208 ( N_noxref_10_c_3665_n N_VDD_c_10241_n ) capacitor c=0.00621974f \
 //x=35.415 //y=5.38 //x2=65.575 //y2=7.585
cc_3209 ( N_noxref_10_c_3778_n N_VDD_c_10241_n ) capacitor c=0.00492568f \
 //x=35.925 //y=5.38 //x2=65.575 //y2=7.585
cc_3210 ( N_noxref_10_c_3675_n N_VDD_c_10241_n ) capacitor c=0.00368834f \
 //x=34.65 //y=5.56 //x2=65.575 //y2=7.585
cc_3211 ( N_noxref_10_c_3795_n N_VDD_c_10241_n ) capacitor c=8.11516e-19 \
 //x=35.53 //y=5.38 //x2=65.575 //y2=7.585
cc_3212 ( N_noxref_10_c_3796_n N_VDD_c_10241_n ) capacitor c=0.00284979f \
 //x=35.53 //y=5.56 //x2=65.575 //y2=7.585
cc_3213 ( N_noxref_10_c_3856_p N_VDD_c_10241_n ) capacitor c=3.84946e-19 \
 //x=36.01 //y=4.25 //x2=65.575 //y2=7.585
cc_3214 ( N_noxref_10_c_3692_n N_VDD_c_10241_n ) capacitor c=0.00224881f \
 //x=34.65 //y=5.56 //x2=65.575 //y2=7.585
cc_3215 ( N_noxref_10_c_3870_p N_VDD_c_10241_n ) capacitor c=0.00224881f \
 //x=35.53 //y=5.56 //x2=65.575 //y2=7.585
cc_3216 ( N_noxref_10_c_3847_p N_VDD_c_10670_n ) capacitor c=3.24023e-19 \
 //x=23.06 //y=4.415 //x2=23.835 //y2=7.585
cc_3217 ( N_noxref_10_M72_noxref_g N_VDD_c_10670_n ) capacitor c=0.00755614f \
 //x=23.26 //y=6.2 //x2=23.835 //y2=7.585
cc_3218 ( N_noxref_10_M73_noxref_g N_VDD_c_10670_n ) capacitor c=0.00755544f \
 //x=23.7 //y=6.2 //x2=23.835 //y2=7.585
cc_3219 ( N_noxref_10_M84_noxref_g N_VDD_c_10617_n ) capacitor c=0.00697352f \
 //x=31.98 //y=6.2 //x2=32.555 //y2=7.585
cc_3220 ( N_noxref_10_M85_noxref_g N_VDD_c_10617_n ) capacitor c=0.00755544f \
 //x=32.42 //y=6.2 //x2=32.555 //y2=7.585
cc_3221 ( N_noxref_10_c_3665_n N_VDD_c_10622_n ) capacitor c=0.00208087f \
 //x=35.415 //y=5.38 //x2=35.005 //y2=7.585
cc_3222 ( N_noxref_10_c_3675_n N_VDD_c_10622_n ) capacitor c=9.41185e-19 \
 //x=34.65 //y=5.56 //x2=35.005 //y2=7.585
cc_3223 ( N_noxref_10_c_3692_n N_VDD_c_10622_n ) capacitor c=0.0136705f \
 //x=34.65 //y=5.56 //x2=35.005 //y2=7.585
cc_3224 ( N_noxref_10_c_3665_n N_VDD_c_10789_n ) capacitor c=0.00180737f \
 //x=35.415 //y=5.38 //x2=35.885 //y2=7.585
cc_3225 ( N_noxref_10_c_3778_n N_VDD_c_10789_n ) capacitor c=0.00208087f \
 //x=35.925 //y=5.38 //x2=35.885 //y2=7.585
cc_3226 ( N_noxref_10_c_3795_n N_VDD_c_10789_n ) capacitor c=4.23719e-19 \
 //x=35.53 //y=5.38 //x2=35.885 //y2=7.585
cc_3227 ( N_noxref_10_c_3796_n N_VDD_c_10789_n ) capacitor c=5.77976e-19 \
 //x=35.53 //y=5.56 //x2=35.885 //y2=7.585
cc_3228 ( N_noxref_10_c_3870_p N_VDD_c_10789_n ) capacitor c=0.0136705f \
 //x=35.53 //y=5.56 //x2=35.885 //y2=7.585
cc_3229 ( N_noxref_10_M96_noxref_g N_VDD_c_10794_n ) capacitor c=0.00697352f \
 //x=41.97 //y=6.2 //x2=42.545 //y2=7.585
cc_3230 ( N_noxref_10_M97_noxref_g N_VDD_c_10794_n ) capacitor c=0.00755544f \
 //x=42.41 //y=6.2 //x2=42.545 //y2=7.585
cc_3231 ( N_noxref_10_c_3847_p N_VDD_c_10515_n ) capacitor c=0.00117585f \
 //x=23.06 //y=4.415 //x2=21.95 //y2=7.585
cc_3232 ( N_noxref_10_c_3592_n N_VDD_c_10515_n ) capacitor c=0.0101051f \
 //x=23.06 //y=4.755 //x2=21.95 //y2=7.585
cc_3233 ( N_noxref_10_c_3593_n N_VDD_c_10515_n ) capacitor c=0.002687f \
 //x=23.06 //y=4.25 //x2=21.95 //y2=7.585
cc_3234 ( N_noxref_10_c_3864_p N_VDD_c_10515_n ) capacitor c=0.00370784f \
 //x=23.06 //y=4.88 //x2=21.95 //y2=7.585
cc_3235 ( N_noxref_10_c_3866_p N_VDD_c_10515_n ) capacitor c=0.00586228f \
 //x=23.335 //y=4.97 //x2=21.95 //y2=7.585
cc_3236 ( N_noxref_10_c_3620_n N_VDD_c_10570_n ) capacitor c=3.90041e-19 \
 //x=26.235 //y=4.265 //x2=26.76 //y2=7.585
cc_3237 ( N_noxref_10_c_3621_n N_VDD_c_10570_n ) capacitor c=0.00904116f \
 //x=27.48 //y=4.25 //x2=26.76 //y2=7.585
cc_3238 ( N_noxref_10_c_3612_n N_VDD_c_10575_n ) capacitor c=8.50173e-19 \
 //x=31.94 //y=4.25 //x2=30.09 //y2=7.585
cc_3239 ( N_noxref_10_c_3623_n N_VDD_c_10575_n ) capacitor c=0.0087315f \
 //x=32.105 //y=4.25 //x2=30.09 //y2=7.585
cc_3240 ( N_noxref_10_c_3671_n N_VDD_c_10628_n ) capacitor c=0.0013228f \
 //x=36.01 //y=5.295 //x2=33.42 //y2=7.585
cc_3241 ( N_noxref_10_c_3612_n N_VDD_c_10628_n ) capacitor c=0.00133985f \
 //x=31.94 //y=4.25 //x2=33.42 //y2=7.585
cc_3242 ( N_noxref_10_c_3675_n N_VDD_c_10628_n ) capacitor c=4.91377e-19 \
 //x=34.65 //y=5.56 //x2=33.42 //y2=7.585
cc_3243 ( N_noxref_10_c_3856_p N_VDD_c_10628_n ) capacitor c=4.55587e-19 \
 //x=36.01 //y=4.25 //x2=33.42 //y2=7.585
cc_3244 ( N_noxref_10_c_3685_n N_VDD_c_10628_n ) capacitor c=0.0086272f \
 //x=35.84 //y=4.25 //x2=33.42 //y2=7.585
cc_3245 ( N_noxref_10_c_3631_n N_VDD_c_10628_n ) capacitor c=0.00233202f \
 //x=31.97 //y=4.88 //x2=33.42 //y2=7.585
cc_3246 ( N_noxref_10_c_3692_n N_VDD_c_10628_n ) capacitor c=0.0064135f \
 //x=34.65 //y=5.56 //x2=33.42 //y2=7.585
cc_3247 ( N_noxref_10_c_3709_n N_VDD_c_10628_n ) capacitor c=0.0129149f \
 //x=32.345 //y=4.97 //x2=33.42 //y2=7.585
cc_3248 ( N_noxref_10_c_3738_n N_VDD_c_10697_n ) capacitor c=0.00197635f \
 //x=36.01 //y=4.425 //x2=36.75 //y2=7.585
cc_3249 ( N_noxref_10_c_3671_n N_VDD_c_10697_n ) capacitor c=0.0258401f \
 //x=36.01 //y=5.295 //x2=36.75 //y2=7.585
cc_3250 ( N_noxref_10_c_3795_n N_VDD_c_10697_n ) capacitor c=0.00240948f \
 //x=35.53 //y=5.38 //x2=36.75 //y2=7.585
cc_3251 ( N_noxref_10_c_3796_n N_VDD_c_10697_n ) capacitor c=4.09141e-19 \
 //x=35.53 //y=5.56 //x2=36.75 //y2=7.585
cc_3252 ( N_noxref_10_c_3856_p N_VDD_c_10697_n ) capacitor c=0.00494039f \
 //x=36.01 //y=4.25 //x2=36.75 //y2=7.585
cc_3253 ( N_noxref_10_c_3767_n N_VDD_c_10697_n ) capacitor c=0.00869538f \
 //x=37.73 //y=4.27 //x2=36.75 //y2=7.585
cc_3254 ( N_noxref_10_c_3870_p N_VDD_c_10697_n ) capacitor c=0.0101861f \
 //x=35.53 //y=5.56 //x2=36.75 //y2=7.585
cc_3255 ( N_noxref_10_c_3798_n N_VDD_c_10746_n ) capacitor c=8.4651e-19 \
 //x=41.93 //y=4.25 //x2=40.08 //y2=7.585
cc_3256 ( N_noxref_10_c_3765_n N_VDD_c_10746_n ) capacitor c=0.00865248f \
 //x=38.075 //y=4.27 //x2=40.08 //y2=7.585
cc_3257 ( N_noxref_10_c_3798_n N_VDD_c_10822_n ) capacitor c=0.00143077f \
 //x=41.93 //y=4.25 //x2=43.41 //y2=7.585
cc_3258 ( N_noxref_10_c_3813_n N_VDD_c_10822_n ) capacitor c=0.00226427f \
 //x=41.96 //y=4.88 //x2=43.41 //y2=7.585
cc_3259 ( N_noxref_10_c_4054_p N_VDD_c_10822_n ) capacitor c=0.0129318f \
 //x=42.335 //y=4.97 //x2=43.41 //y2=7.585
cc_3260 ( N_noxref_10_c_3832_n N_VDD_c_10822_n ) capacitor c=2.73429e-19 \
 //x=41.96 //y=4.88 //x2=43.41 //y2=7.585
cc_3261 ( N_noxref_10_c_3847_p N_VDD_M72_noxref_s ) capacitor c=9.65142e-19 \
 //x=23.06 //y=4.415 //x2=22.905 //y2=5.2
cc_3262 ( N_noxref_10_c_3592_n N_VDD_M72_noxref_s ) capacitor c=0.0217456f \
 //x=23.06 //y=4.755 //x2=22.905 //y2=5.2
cc_3263 ( N_noxref_10_c_3864_p N_VDD_M72_noxref_s ) capacitor c=0.00983846f \
 //x=23.06 //y=4.88 //x2=22.905 //y2=5.2
cc_3264 ( N_noxref_10_M72_noxref_g N_VDD_M72_noxref_s ) capacitor c=0.053419f \
 //x=23.26 //y=6.2 //x2=22.905 //y2=5.2
cc_3265 ( N_noxref_10_c_3866_p N_VDD_M72_noxref_s ) capacitor c=0.00597659f \
 //x=23.335 //y=4.97 //x2=22.905 //y2=5.2
cc_3266 ( N_noxref_10_M73_noxref_g N_VDD_M73_noxref_d ) capacitor c=0.015318f \
 //x=23.7 //y=6.2 //x2=23.775 //y2=5.2
cc_3267 ( N_noxref_10_M84_noxref_g N_VDD_M83_noxref_d ) capacitor c=0.015318f \
 //x=31.98 //y=6.2 //x2=31.615 //y2=5.2
cc_3268 ( N_noxref_10_c_3650_n N_VDD_M83_noxref_d ) capacitor c=3.50465e-19 \
 //x=31.97 //y=4.88 //x2=31.615 //y2=5.2
cc_3269 ( N_noxref_10_M85_noxref_g N_VDD_M85_noxref_d ) capacitor c=0.0430452f \
 //x=32.42 //y=6.2 //x2=32.495 //y2=5.2
cc_3270 ( N_noxref_10_c_3675_n N_VDD_M86_noxref_s ) capacitor c=0.0572211f \
 //x=34.65 //y=5.56 //x2=34.075 //y2=5.2
cc_3271 ( N_noxref_10_c_3795_n N_VDD_M86_noxref_s ) capacitor c=6.52457e-19 \
 //x=35.53 //y=5.38 //x2=34.075 //y2=5.2
cc_3272 ( N_noxref_10_c_3692_n N_VDD_M86_noxref_s ) capacitor c=0.0887533f \
 //x=34.65 //y=5.56 //x2=34.075 //y2=5.2
cc_3273 ( N_noxref_10_c_3665_n N_VDD_M87_noxref_d ) capacitor c=0.00734094f \
 //x=35.415 //y=5.38 //x2=34.945 //y2=5.2
cc_3274 ( N_noxref_10_c_3675_n N_VDD_M87_noxref_d ) capacitor c=0.0043528f \
 //x=34.65 //y=5.56 //x2=34.945 //y2=5.2
cc_3275 ( N_noxref_10_c_3796_n N_VDD_M87_noxref_d ) capacitor c=0.0043528f \
 //x=35.53 //y=5.56 //x2=34.945 //y2=5.2
cc_3276 ( N_noxref_10_c_3692_n N_VDD_M87_noxref_d ) capacitor c=0.065554f \
 //x=34.65 //y=5.56 //x2=34.945 //y2=5.2
cc_3277 ( N_noxref_10_c_3870_p N_VDD_M87_noxref_d ) capacitor c=0.065554f \
 //x=35.53 //y=5.56 //x2=34.945 //y2=5.2
cc_3278 ( N_noxref_10_c_3778_n N_VDD_M89_noxref_d ) capacitor c=0.00852734f \
 //x=35.925 //y=5.38 //x2=35.825 //y2=5.2
cc_3279 ( N_noxref_10_c_3796_n N_VDD_M89_noxref_d ) capacitor c=0.00587834f \
 //x=35.53 //y=5.56 //x2=35.825 //y2=5.2
cc_3280 ( N_noxref_10_c_3856_p N_VDD_M89_noxref_d ) capacitor c=0.00167175f \
 //x=36.01 //y=4.25 //x2=35.825 //y2=5.2
cc_3281 ( N_noxref_10_c_3870_p N_VDD_M89_noxref_d ) capacitor c=0.065554f \
 //x=35.53 //y=5.56 //x2=35.825 //y2=5.2
cc_3282 ( N_noxref_10_c_3778_n N_VDD_M90_noxref_s ) capacitor c=0.00326953f \
 //x=35.925 //y=5.38 //x2=37.405 //y2=5.2
cc_3283 ( N_noxref_10_c_3795_n N_VDD_M90_noxref_s ) capacitor c=0.00515461f \
 //x=35.53 //y=5.38 //x2=37.405 //y2=5.2
cc_3284 ( N_noxref_10_c_3796_n N_VDD_M90_noxref_s ) capacitor c=3.28075e-19 \
 //x=35.53 //y=5.56 //x2=37.405 //y2=5.2
cc_3285 ( N_noxref_10_M96_noxref_g N_VDD_M95_noxref_d ) capacitor c=0.015318f \
 //x=41.97 //y=6.2 //x2=41.605 //y2=5.2
cc_3286 ( N_noxref_10_c_3832_n N_VDD_M95_noxref_d ) capacitor c=3.50465e-19 \
 //x=41.96 //y=4.88 //x2=41.605 //y2=5.2
cc_3287 ( N_noxref_10_M97_noxref_g N_VDD_M97_noxref_d ) capacitor c=0.0430452f \
 //x=42.41 //y=6.2 //x2=42.485 //y2=5.2
cc_3288 ( N_noxref_10_c_3789_n N_noxref_25_c_11788_n ) capacitor c=0.0041373f \
 //x=41.93 //y=4.41 //x2=42.075 //y2=5.38
cc_3289 ( N_noxref_10_c_3790_n N_noxref_25_c_11788_n ) capacitor c=0.0215376f \
 //x=41.93 //y=4.735 //x2=42.075 //y2=5.38
cc_3290 ( N_noxref_10_c_3813_n N_noxref_25_c_11788_n ) capacitor c=0.00469257f \
 //x=41.96 //y=4.88 //x2=42.075 //y2=5.38
cc_3291 ( N_noxref_10_M96_noxref_g N_noxref_25_c_11788_n ) capacitor \
 c=0.00842859f //x=41.97 //y=6.2 //x2=42.075 //y2=5.38
cc_3292 ( N_noxref_10_c_3832_n N_noxref_25_c_11788_n ) capacitor c=8.42507e-19 \
 //x=41.96 //y=4.88 //x2=42.075 //y2=5.38
cc_3293 ( N_noxref_10_c_3822_n N_noxref_25_c_11789_n ) capacitor c=0.00119008f \
 //x=41.965 //y=1.43 //x2=42.23 //y2=1.75
cc_3294 ( N_noxref_10_c_3824_n N_noxref_25_c_11789_n ) capacitor c=0.00438634f \
 //x=41.965 //y=1.74 //x2=42.23 //y2=1.75
cc_3295 ( N_noxref_10_c_4090_p N_noxref_25_c_11789_n ) capacitor c=0.00929259f \
 //x=42.34 //y=1.585 //x2=42.23 //y2=1.75
cc_3296 ( N_noxref_10_c_3828_n N_noxref_25_c_11789_n ) capacitor c=0.00341295f \
 //x=42.495 //y=1.43 //x2=42.23 //y2=1.75
cc_3297 ( N_noxref_10_c_4092_p N_noxref_25_c_11789_n ) capacitor c=0.00341114f \
 //x=41.93 //y=2.095 //x2=42.23 //y2=1.75
cc_3298 ( N_noxref_10_M97_noxref_g N_noxref_25_c_11821_n ) capacitor \
 c=0.0106834f //x=42.41 //y=6.2 //x2=42.585 //y2=5.38
cc_3299 ( N_noxref_10_c_4090_p N_noxref_25_c_11822_n ) capacitor c=0.00199995f \
 //x=42.34 //y=1.585 //x2=42.585 //y2=1.835
cc_3300 ( N_noxref_10_c_3828_n N_noxref_25_c_11822_n ) capacitor c=0.00323005f \
 //x=42.495 //y=1.43 //x2=42.585 //y2=1.835
cc_3301 ( N_noxref_10_c_3799_n N_noxref_25_c_11791_n ) capacitor c=0.00923651f \
 //x=41.93 //y=2.26 //x2=42.67 //y2=2.285
cc_3302 ( N_noxref_10_c_3809_n N_noxref_25_c_11791_n ) capacitor c=4.71798e-19 \
 //x=41.93 //y=2.26 //x2=42.67 //y2=2.285
cc_3303 ( N_noxref_10_c_3829_n N_noxref_25_c_11791_n ) capacitor c=0.00133073f \
 //x=41.93 //y=2.26 //x2=42.67 //y2=2.285
cc_3304 ( N_noxref_10_c_4092_p N_noxref_25_c_11791_n ) capacitor c=0.00309058f \
 //x=41.93 //y=2.095 //x2=42.67 //y2=2.285
cc_3305 ( N_noxref_10_c_3782_n N_noxref_25_c_11828_n ) capacitor c=0.00760622f \
 //x=41.93 //y=4.09 //x2=42.67 //y2=2.515
cc_3306 ( N_noxref_10_c_3799_n N_noxref_25_c_11828_n ) capacitor c=0.00853025f \
 //x=41.93 //y=2.26 //x2=42.67 //y2=2.515
cc_3307 ( N_noxref_10_c_3809_n N_noxref_25_c_11828_n ) capacitor c=0.00174135f \
 //x=41.93 //y=2.26 //x2=42.67 //y2=2.515
cc_3308 ( N_noxref_10_c_3829_n N_noxref_25_c_11828_n ) capacitor c=0.00218585f \
 //x=41.93 //y=2.26 //x2=42.67 //y2=2.515
cc_3309 ( N_noxref_10_c_3782_n N_noxref_25_c_11792_n ) capacitor c=0.0666298f \
 //x=41.93 //y=4.09 //x2=42.67 //y2=5.295
cc_3310 ( N_noxref_10_c_3789_n N_noxref_25_c_11792_n ) capacitor c=0.0148501f \
 //x=41.93 //y=4.41 //x2=42.67 //y2=5.295
cc_3311 ( N_noxref_10_c_3790_n N_noxref_25_c_11792_n ) capacitor c=0.0284231f \
 //x=41.93 //y=4.735 //x2=42.67 //y2=5.295
cc_3312 ( N_noxref_10_c_3798_n N_noxref_25_c_11792_n ) capacitor c=5.56854e-19 \
 //x=41.93 //y=4.25 //x2=42.67 //y2=5.295
cc_3313 ( N_noxref_10_c_3765_n N_noxref_25_c_11792_n ) capacitor c=0.00413652f \
 //x=38.075 //y=4.27 //x2=42.67 //y2=5.295
cc_3314 ( N_noxref_10_c_3813_n N_noxref_25_c_11792_n ) capacitor c=7.76118e-19 \
 //x=41.96 //y=4.88 //x2=42.67 //y2=5.295
cc_3315 ( N_noxref_10_c_4054_p N_noxref_25_c_11792_n ) capacitor c=0.00845606f \
 //x=42.335 //y=4.97 //x2=42.67 //y2=5.295
cc_3316 ( N_noxref_10_c_3832_n N_noxref_25_c_11792_n ) capacitor c=0.00142201f \
 //x=41.96 //y=4.88 //x2=42.67 //y2=5.295
cc_3317 ( N_noxref_10_M96_noxref_g N_noxref_25_c_11840_n ) capacitor \
 c=0.00192712f //x=41.97 //y=6.2 //x2=42.19 //y2=5.38
cc_3318 ( N_noxref_10_M97_noxref_g N_noxref_25_c_11840_n ) capacitor \
 c=0.00312463f //x=42.41 //y=6.2 //x2=42.19 //y2=5.38
cc_3319 ( N_noxref_10_c_4054_p N_noxref_25_c_11840_n ) capacitor c=0.0020909f \
 //x=42.335 //y=4.97 //x2=42.19 //y2=5.38
cc_3320 ( N_noxref_10_c_3819_n N_noxref_25_c_11804_n ) capacitor c=0.00120406f \
 //x=41.965 //y=1.085 //x2=42.23 //y2=1.18
cc_3321 ( N_noxref_10_c_3822_n N_noxref_25_c_11804_n ) capacitor c=0.00218694f \
 //x=41.965 //y=1.43 //x2=42.23 //y2=1.18
cc_3322 ( N_noxref_10_c_4117_p N_noxref_25_c_11804_n ) capacitor c=5.50523e-19 \
 //x=42.34 //y=0.93 //x2=42.23 //y2=1.18
cc_3323 ( N_noxref_10_c_4090_p N_noxref_25_c_11804_n ) capacitor c=5.67071e-19 \
 //x=42.34 //y=1.585 //x2=42.23 //y2=1.18
cc_3324 ( N_noxref_10_c_3827_n N_noxref_25_c_11804_n ) capacitor c=0.00108157f \
 //x=42.495 //y=1.085 //x2=42.23 //y2=1.18
cc_3325 ( N_noxref_10_c_3828_n N_noxref_25_c_11804_n ) capacitor c=0.00312028f \
 //x=42.495 //y=1.43 //x2=42.23 //y2=1.18
cc_3326 ( N_noxref_10_c_3782_n N_noxref_25_c_11849_n ) capacitor c=9.74895e-19 \
 //x=41.93 //y=4.09 //x2=42.67 //y2=2.4
cc_3327 ( N_noxref_10_c_3799_n N_noxref_25_c_11849_n ) capacitor c=0.00104151f \
 //x=41.93 //y=2.26 //x2=42.67 //y2=2.4
cc_3328 ( N_noxref_10_c_3809_n N_noxref_25_c_11849_n ) capacitor c=0.00480579f \
 //x=41.93 //y=2.26 //x2=42.67 //y2=2.4
cc_3329 ( N_noxref_10_c_3829_n N_noxref_25_c_11849_n ) capacitor c=0.00389543f \
 //x=41.93 //y=2.26 //x2=42.67 //y2=2.4
cc_3330 ( N_noxref_10_M96_noxref_g N_noxref_25_c_11853_n ) capacitor \
 c=0.0178987f //x=41.97 //y=6.2 //x2=42.19 //y2=5.56
cc_3331 ( N_noxref_10_M97_noxref_g N_noxref_25_c_11853_n ) capacitor \
 c=0.0178506f //x=42.41 //y=6.2 //x2=42.19 //y2=5.56
cc_3332 ( N_noxref_10_c_4054_p N_noxref_25_c_11853_n ) capacitor c=0.00291714f \
 //x=42.335 //y=4.97 //x2=42.19 //y2=5.56
cc_3333 ( N_noxref_10_c_3819_n N_noxref_25_M25_noxref_d ) capacitor \
 c=0.00137165f //x=41.965 //y=1.085 //x2=42.04 //y2=1.085
cc_3334 ( N_noxref_10_c_3822_n N_noxref_25_M25_noxref_d ) capacitor \
 c=0.00237422f //x=41.965 //y=1.43 //x2=42.04 //y2=1.085
cc_3335 ( N_noxref_10_c_4117_p N_noxref_25_M25_noxref_d ) capacitor \
 c=0.0020782f //x=42.34 //y=0.93 //x2=42.04 //y2=1.085
cc_3336 ( N_noxref_10_c_4090_p N_noxref_25_M25_noxref_d ) capacitor \
 c=0.00356097f //x=42.34 //y=1.585 //x2=42.04 //y2=1.085
cc_3337 ( N_noxref_10_c_3827_n N_noxref_25_M25_noxref_d ) capacitor \
 c=8.50095e-19 //x=42.495 //y=1.085 //x2=42.04 //y2=1.085
cc_3338 ( N_noxref_10_c_3828_n N_noxref_25_M25_noxref_d ) capacitor \
 c=0.00237422f //x=42.495 //y=1.43 //x2=42.04 //y2=1.085
cc_3339 ( N_noxref_10_c_3930_p N_GND_c_12723_n ) capacitor c=3.92414e-19 \
 //x=22.76 //y=1.055 //x2=23.025 //y2=1.015
cc_3340 ( N_noxref_10_c_4135_p N_GND_c_12723_n ) capacitor c=0.0085115f \
 //x=23.135 //y=0.9 //x2=23.025 //y2=1.015
cc_3341 ( N_noxref_10_c_3932_p N_GND_c_12723_n ) capacitor c=4.45447e-19 \
 //x=23.29 //y=1.055 //x2=23.025 //y2=1.015
cc_3342 ( N_noxref_10_c_3613_n N_GND_c_12588_n ) capacitor c=0.00215229f \
 //x=31.94 //y=2.26 //x2=34.515 //y2=0.175
cc_3343 ( N_noxref_10_c_3779_n N_GND_c_12727_n ) capacitor c=0.00618782f \
 //x=35.925 //y=1.835 //x2=37.845 //y2=0.175
cc_3344 ( N_noxref_10_c_3684_n N_GND_c_12727_n ) capacitor c=0.00937893f \
 //x=35.57 //y=1.18 //x2=37.845 //y2=0.175
cc_3345 ( N_noxref_10_M21_noxref_d N_GND_c_12727_n ) capacitor c=3.01769e-19 \
 //x=35.38 //y=1.085 //x2=37.845 //y2=0.175
cc_3346 ( N_noxref_10_c_3799_n N_GND_c_12730_n ) capacitor c=0.00210951f \
 //x=41.93 //y=2.26 //x2=44.4 //y2=0.175
cc_3347 ( N_noxref_10_c_3836_p N_GND_c_12731_n ) capacitor c=0.00799365f \
 //x=23.06 //y=2.375 //x2=23.025 //y2=1.145
cc_3348 ( N_noxref_10_c_3847_p N_GND_c_12731_n ) capacitor c=4.63926e-19 \
 //x=23.06 //y=4.415 //x2=23.025 //y2=1.145
cc_3349 ( N_noxref_10_c_3852_p N_GND_c_12731_n ) capacitor c=2.22883e-19 \
 //x=23.06 //y=2.26 //x2=23.025 //y2=1.145
cc_3350 ( N_noxref_10_c_3930_p N_GND_c_12731_n ) capacitor c=0.0015128f \
 //x=22.76 //y=1.055 //x2=23.025 //y2=1.145
cc_3351 ( N_noxref_10_c_3931_p N_GND_c_12731_n ) capacitor c=0.00350108f \
 //x=22.76 //y=1.4 //x2=23.025 //y2=1.145
cc_3352 ( N_noxref_10_c_3933_p N_GND_c_12731_n ) capacitor c=4.68816e-19 \
 //x=22.76 //y=1.71 //x2=23.025 //y2=1.145
cc_3353 ( N_noxref_10_c_4135_p N_GND_c_12731_n ) capacitor c=9.36995e-19 \
 //x=23.135 //y=0.9 //x2=23.025 //y2=1.145
cc_3354 ( N_noxref_10_c_4149_p N_GND_c_12731_n ) capacitor c=6.09659e-19 \
 //x=23.135 //y=1.555 //x2=23.025 //y2=1.145
cc_3355 ( N_noxref_10_c_3932_p N_GND_c_12731_n ) capacitor c=0.0017438f \
 //x=23.29 //y=1.055 //x2=23.025 //y2=1.145
cc_3356 ( N_noxref_10_c_3934_p N_GND_c_12731_n ) capacitor c=0.00276804f \
 //x=23.29 //y=1.4 //x2=23.025 //y2=1.145
cc_3357 ( N_noxref_10_c_3675_n N_GND_c_12595_n ) capacitor c=7.57822e-19 \
 //x=34.65 //y=5.56 //x2=34.6 //y2=1.135
cc_3358 ( N_noxref_10_c_3684_n N_GND_c_12595_n ) capacitor c=0.0140087f \
 //x=35.57 //y=1.18 //x2=34.6 //y2=1.135
cc_3359 ( N_noxref_10_M21_noxref_d N_GND_c_12595_n ) capacitor c=2.93544e-19 \
 //x=35.38 //y=1.085 //x2=34.6 //y2=1.135
cc_3360 ( N_noxref_10_c_3684_n N_GND_c_12644_n ) capacitor c=0.00549186f \
 //x=35.57 //y=1.18 //x2=37.93 //y2=1.135
cc_3361 ( N_noxref_10_c_3930_p N_GND_c_12566_n ) capacitor c=0.00677766f \
 //x=22.76 //y=1.055 //x2=26.59 //y2=0.175
cc_3362 ( N_noxref_10_c_3613_n N_GND_c_12568_n ) capacitor c=3.77328e-19 \
 //x=31.94 //y=2.26 //x2=33.25 //y2=0.175
cc_3363 ( N_noxref_10_c_3779_n N_GND_c_12610_n ) capacitor c=7.77585e-19 \
 //x=35.925 //y=1.835 //x2=36.58 //y2=0.175
cc_3364 ( N_noxref_10_c_3799_n N_GND_c_12706_n ) capacitor c=3.77328e-19 \
 //x=41.93 //y=2.26 //x2=43.24 //y2=0.175
cc_3365 ( N_noxref_10_c_3836_p N_GND_c_12535_n ) capacitor c=0.00407472f \
 //x=23.06 //y=2.375 //x2=21.95 //y2=0.175
cc_3366 ( N_noxref_10_c_3591_n N_GND_c_12535_n ) capacitor c=0.00967862f \
 //x=23.06 //y=4.095 //x2=21.95 //y2=0.175
cc_3367 ( N_noxref_10_c_3852_p N_GND_c_12535_n ) capacitor c=0.00394652f \
 //x=23.06 //y=2.26 //x2=21.95 //y2=0.175
cc_3368 ( N_noxref_10_c_3933_p N_GND_c_12535_n ) capacitor c=0.00170145f \
 //x=22.76 //y=1.71 //x2=21.95 //y2=0.175
cc_3369 ( N_noxref_10_c_3861_p N_GND_c_12535_n ) capacitor c=0.0103608f \
 //x=22.76 //y=2.095 //x2=21.95 //y2=0.175
cc_3370 ( N_noxref_10_c_3668_n N_GND_c_12612_n ) capacitor c=9.32616e-19 \
 //x=36.01 //y=4.105 //x2=33.42 //y2=0.175
cc_3371 ( N_noxref_10_c_3627_n N_GND_c_12612_n ) capacitor c=0.00224736f \
 //x=31.94 //y=2.26 //x2=33.42 //y2=0.175
cc_3372 ( N_noxref_10_c_3646_n N_GND_c_12612_n ) capacitor c=0.00275184f \
 //x=32.505 //y=1.43 //x2=33.42 //y2=0.175
cc_3373 ( N_noxref_10_c_3647_n N_GND_c_12612_n ) capacitor c=2.63786e-19 \
 //x=31.94 //y=2.26 //x2=33.42 //y2=0.175
cc_3374 ( N_noxref_10_c_3666_n N_GND_c_12666_n ) capacitor c=0.002973f \
 //x=35.57 //y=1.75 //x2=36.75 //y2=0.175
cc_3375 ( N_noxref_10_c_3779_n N_GND_c_12666_n ) capacitor c=0.0287405f \
 //x=35.925 //y=1.835 //x2=36.75 //y2=0.175
cc_3376 ( N_noxref_10_c_3809_n N_GND_c_12760_n ) capacitor c=0.001023f \
 //x=41.93 //y=2.26 //x2=43.41 //y2=0.175
cc_3377 ( N_noxref_10_c_3828_n N_GND_c_12760_n ) capacitor c=0.00275184f \
 //x=42.495 //y=1.43 //x2=43.41 //y2=0.175
cc_3378 ( N_noxref_10_c_3829_n N_GND_c_12760_n ) capacitor c=2.63786e-19 \
 //x=41.93 //y=2.26 //x2=43.41 //y2=0.175
cc_3379 ( N_noxref_10_c_3836_p N_GND_M13_noxref_d ) capacitor c=4.4417e-19 \
 //x=23.06 //y=2.375 //x2=22.835 //y2=1.055
cc_3380 ( N_noxref_10_c_3930_p N_GND_M13_noxref_d ) capacitor c=0.00184354f \
 //x=22.76 //y=1.055 //x2=22.835 //y2=1.055
cc_3381 ( N_noxref_10_c_3931_p N_GND_M13_noxref_d ) capacitor c=0.00210798f \
 //x=22.76 //y=1.4 //x2=22.835 //y2=1.055
cc_3382 ( N_noxref_10_c_4135_p N_GND_M13_noxref_d ) capacitor c=0.00474029f \
 //x=23.135 //y=0.9 //x2=22.835 //y2=1.055
cc_3383 ( N_noxref_10_c_4149_p N_GND_M13_noxref_d ) capacitor c=0.00166857f \
 //x=23.135 //y=1.555 //x2=22.835 //y2=1.055
cc_3384 ( N_noxref_10_c_3932_p N_GND_M13_noxref_d ) capacitor c=0.00230174f \
 //x=23.29 //y=1.055 //x2=22.835 //y2=1.055
cc_3385 ( N_noxref_10_c_3934_p N_GND_M13_noxref_d ) capacitor c=0.00210798f \
 //x=23.29 //y=1.4 //x2=22.835 //y2=1.055
cc_3386 ( N_noxref_10_c_3684_n N_GND_M20_noxref_d ) capacitor c=2.82748e-19 \
 //x=35.57 //y=1.18 //x2=34.41 //y2=1.045
cc_3387 ( N_noxref_10_c_3861_p N_noxref_37_c_14380_n ) capacitor c=0.00262672f \
 //x=22.76 //y=2.095 //x2=22.54 //y2=1.685
cc_3388 ( N_noxref_10_c_3836_p N_noxref_37_c_14381_n ) capacitor c=0.00428451f \
 //x=23.06 //y=2.375 //x2=23.425 //y2=1.77
cc_3389 ( N_noxref_10_c_3847_p N_noxref_37_c_14381_n ) capacitor c=0.00108531f \
 //x=23.06 //y=4.415 //x2=23.425 //y2=1.77
cc_3390 ( N_noxref_10_c_3852_p N_noxref_37_c_14381_n ) capacitor c=0.0104666f \
 //x=23.06 //y=2.26 //x2=23.425 //y2=1.77
cc_3391 ( N_noxref_10_c_3933_p N_noxref_37_c_14381_n ) capacitor c=0.00705077f \
 //x=22.76 //y=1.71 //x2=23.425 //y2=1.77
cc_3392 ( N_noxref_10_c_3861_p N_noxref_37_c_14381_n ) capacitor c=0.0211416f \
 //x=22.76 //y=2.095 //x2=23.425 //y2=1.77
cc_3393 ( N_noxref_10_c_4149_p N_noxref_37_c_14381_n ) capacitor c=0.00588627f \
 //x=23.135 //y=1.555 //x2=23.425 //y2=1.77
cc_3394 ( N_noxref_10_c_3934_p N_noxref_37_c_14381_n ) capacitor c=0.00698822f \
 //x=23.29 //y=1.4 //x2=23.425 //y2=1.77
cc_3395 ( N_noxref_10_c_3930_p N_noxref_37_M13_noxref_s ) capacitor \
 c=0.0295256f //x=22.76 //y=1.055 //x2=22.405 //y2=0.555
cc_3396 ( N_noxref_10_c_3933_p N_noxref_37_M13_noxref_s ) capacitor \
 c=7.99997e-19 //x=22.76 //y=1.71 //x2=22.405 //y2=0.555
cc_3397 ( N_noxref_10_c_3861_p N_noxref_37_M13_noxref_s ) capacitor \
 c=0.00122123f //x=22.76 //y=2.095 //x2=22.405 //y2=0.555
cc_3398 ( N_noxref_10_c_3932_p N_noxref_37_M13_noxref_s ) capacitor \
 c=0.0125924f //x=23.29 //y=1.055 //x2=22.405 //y2=0.555
cc_3399 ( N_noxref_10_c_3606_n N_noxref_39_c_14515_n ) capacitor c=9.48063e-19 \
 //x=31.94 //y=4.415 //x2=31.755 //y2=1.675
cc_3400 ( N_noxref_10_c_3613_n N_noxref_39_c_14515_n ) capacitor c=7.50092e-19 \
 //x=31.94 //y=2.26 //x2=31.755 //y2=1.675
cc_3401 ( N_noxref_10_c_3642_n N_noxref_39_c_14515_n ) capacitor c=0.00888238f \
 //x=31.975 //y=1.74 //x2=31.755 //y2=1.675
cc_3402 ( N_noxref_10_c_3647_n N_noxref_39_c_14515_n ) capacitor c=0.00175171f \
 //x=31.94 //y=2.26 //x2=31.755 //y2=1.675
cc_3403 ( N_noxref_10_c_3613_n N_noxref_39_c_14520_n ) capacitor c=0.001463f \
 //x=31.94 //y=2.26 //x2=32.64 //y2=0.71
cc_3404 ( N_noxref_10_c_3627_n N_noxref_39_c_14520_n ) capacitor c=8.82141e-19 \
 //x=31.94 //y=2.26 //x2=32.64 //y2=0.71
cc_3405 ( N_noxref_10_c_3637_n N_noxref_39_c_14520_n ) capacitor c=0.0200738f \
 //x=31.975 //y=1.085 //x2=32.64 //y2=0.71
cc_3406 ( N_noxref_10_c_3645_n N_noxref_39_c_14520_n ) capacitor c=0.00825432f \
 //x=32.505 //y=1.085 //x2=32.64 //y2=0.71
cc_3407 ( N_noxref_10_c_3647_n N_noxref_39_c_14520_n ) capacitor c=2.1838e-19 \
 //x=31.94 //y=2.26 //x2=32.64 //y2=0.71
cc_3408 ( N_noxref_10_c_3637_n N_noxref_39_M18_noxref_s ) capacitor \
 c=0.00888238f //x=31.975 //y=1.085 //x2=30.65 //y2=0.545
cc_3409 ( N_noxref_10_c_3645_n N_noxref_39_M18_noxref_s ) capacitor \
 c=0.015333f //x=32.505 //y=1.085 //x2=30.65 //y2=0.545
cc_3410 ( N_noxref_10_c_3646_n N_noxref_39_M18_noxref_s ) capacitor \
 c=0.00248746f //x=32.505 //y=1.43 //x2=30.65 //y2=0.545
cc_3411 ( N_noxref_10_c_3667_n N_noxref_40_c_14584_n ) capacitor c=0.00911498f \
 //x=35.655 //y=1.835 //x2=35.085 //y2=1.675
cc_3412 ( N_noxref_10_c_3779_n N_noxref_40_c_14589_n ) capacitor c=0.00399245f \
 //x=35.925 //y=1.835 //x2=35.97 //y2=0.71
cc_3413 ( N_noxref_10_c_3684_n N_noxref_40_c_14589_n ) capacitor c=0.003751f \
 //x=35.57 //y=1.18 //x2=35.97 //y2=0.71
cc_3414 ( N_noxref_10_M21_noxref_d N_noxref_40_c_14589_n ) capacitor \
 c=0.00910163f //x=35.38 //y=1.085 //x2=35.97 //y2=0.71
cc_3415 ( N_noxref_10_c_3666_n N_noxref_40_M20_noxref_s ) capacitor \
 c=0.0162484f //x=35.57 //y=1.75 //x2=33.98 //y2=0.545
cc_3416 ( N_noxref_10_c_3779_n N_noxref_40_M20_noxref_s ) capacitor \
 c=0.00692219f //x=35.925 //y=1.835 //x2=33.98 //y2=0.545
cc_3417 ( N_noxref_10_c_3738_n N_noxref_40_M20_noxref_s ) capacitor \
 c=2.52049e-19 //x=36.01 //y=4.425 //x2=33.98 //y2=0.545
cc_3418 ( N_noxref_10_c_3684_n N_noxref_40_M20_noxref_s ) capacitor \
 c=0.00905169f //x=35.57 //y=1.18 //x2=33.98 //y2=0.545
cc_3419 ( N_noxref_10_c_3856_p N_noxref_40_M20_noxref_s ) capacitor \
 c=7.05305e-19 //x=36.01 //y=4.25 //x2=33.98 //y2=0.545
cc_3420 ( N_noxref_10_M21_noxref_d N_noxref_40_M20_noxref_s ) capacitor \
 c=0.0275552f //x=35.38 //y=1.085 //x2=33.98 //y2=0.545
cc_3421 ( N_noxref_10_c_3789_n N_noxref_42_c_14720_n ) capacitor c=9.54772e-19 \
 //x=41.93 //y=4.41 //x2=41.745 //y2=1.675
cc_3422 ( N_noxref_10_c_3799_n N_noxref_42_c_14720_n ) capacitor c=7.50092e-19 \
 //x=41.93 //y=2.26 //x2=41.745 //y2=1.675
cc_3423 ( N_noxref_10_c_3824_n N_noxref_42_c_14720_n ) capacitor c=0.00888238f \
 //x=41.965 //y=1.74 //x2=41.745 //y2=1.675
cc_3424 ( N_noxref_10_c_3829_n N_noxref_42_c_14720_n ) capacitor c=0.00175171f \
 //x=41.93 //y=2.26 //x2=41.745 //y2=1.675
cc_3425 ( N_noxref_10_c_3799_n N_noxref_42_c_14728_n ) capacitor c=0.001463f \
 //x=41.93 //y=2.26 //x2=42.63 //y2=0.71
cc_3426 ( N_noxref_10_c_3809_n N_noxref_42_c_14728_n ) capacitor c=8.82141e-19 \
 //x=41.93 //y=2.26 //x2=42.63 //y2=0.71
cc_3427 ( N_noxref_10_c_3819_n N_noxref_42_c_14728_n ) capacitor c=0.0200738f \
 //x=41.965 //y=1.085 //x2=42.63 //y2=0.71
cc_3428 ( N_noxref_10_c_3827_n N_noxref_42_c_14728_n ) capacitor c=0.00825432f \
 //x=42.495 //y=1.085 //x2=42.63 //y2=0.71
cc_3429 ( N_noxref_10_c_3829_n N_noxref_42_c_14728_n ) capacitor c=2.1838e-19 \
 //x=41.93 //y=2.26 //x2=42.63 //y2=0.71
cc_3430 ( N_noxref_10_c_3819_n N_noxref_42_M24_noxref_s ) capacitor \
 c=0.00888238f //x=41.965 //y=1.085 //x2=40.64 //y2=0.545
cc_3431 ( N_noxref_10_c_3827_n N_noxref_42_M24_noxref_s ) capacitor \
 c=0.015333f //x=42.495 //y=1.085 //x2=40.64 //y2=0.545
cc_3432 ( N_noxref_10_c_3828_n N_noxref_42_M24_noxref_s ) capacitor \
 c=0.00248746f //x=42.495 //y=1.43 //x2=40.64 //y2=0.545
cc_3433 ( N_D_c_4408_n N_noxref_12_c_4856_n ) capacitor c=0.02192f //x=49.91 \
 //y=2.755 //x2=46.74 //y2=3.35
cc_3434 ( N_D_c_4526_p N_noxref_12_c_4857_n ) capacitor c=0.00151721f \
 //x=50.07 //y=2.915 //x2=50.215 //y2=5.38
cc_3435 ( N_D_c_4527_p N_noxref_12_c_4857_n ) capacitor c=0.0217631f //x=50.07 \
 //y=4.735 //x2=50.215 //y2=5.38
cc_3436 ( N_D_c_4528_p N_noxref_12_c_4857_n ) capacitor c=0.00469257f //x=50.1 \
 //y=4.88 //x2=50.215 //y2=5.38
cc_3437 ( N_D_M106_noxref_g N_noxref_12_c_4857_n ) capacitor c=0.00842859f \
 //x=50.11 //y=6.2 //x2=50.215 //y2=5.38
cc_3438 ( N_D_c_4530_p N_noxref_12_c_4857_n ) capacitor c=9.45752e-19 //x=50.1 \
 //y=4.88 //x2=50.215 //y2=5.38
cc_3439 ( N_D_c_4531_p N_noxref_12_c_4862_n ) capacitor c=0.00119302f \
 //x=50.105 //y=1.43 //x2=50.37 //y2=1.75
cc_3440 ( N_D_c_4532_p N_noxref_12_c_4862_n ) capacitor c=0.00467766f \
 //x=50.105 //y=1.74 //x2=50.37 //y2=1.75
cc_3441 ( N_D_c_4533_p N_noxref_12_c_4862_n ) capacitor c=0.00917366f \
 //x=50.48 //y=1.585 //x2=50.37 //y2=1.75
cc_3442 ( N_D_c_4534_p N_noxref_12_c_4862_n ) capacitor c=0.003249f //x=50.635 \
 //y=1.43 //x2=50.37 //y2=1.75
cc_3443 ( N_D_c_4535_p N_noxref_12_c_4862_n ) capacitor c=0.00341688f \
 //x=50.07 //y=2.095 //x2=50.37 //y2=1.75
cc_3444 ( N_D_M107_noxref_g N_noxref_12_c_4867_n ) capacitor c=0.0107429f \
 //x=50.55 //y=6.2 //x2=50.725 //y2=5.38
cc_3445 ( N_D_c_4533_p N_noxref_12_c_4868_n ) capacitor c=0.00194324f \
 //x=50.48 //y=1.585 //x2=50.725 //y2=1.835
cc_3446 ( N_D_c_4534_p N_noxref_12_c_4868_n ) capacitor c=0.00323005f \
 //x=50.635 //y=1.43 //x2=50.725 //y2=1.835
cc_3447 ( D N_noxref_12_c_4870_n ) capacitor c=9.19401e-19 //x=50.07 //y=2.77 \
 //x2=50.81 //y2=3.35
cc_3448 ( N_D_c_4540_p N_noxref_12_c_4870_n ) capacitor c=0.00749637f \
 //x=50.07 //y=2.595 //x2=50.81 //y2=3.35
cc_3449 ( N_D_c_4526_p N_noxref_12_c_4870_n ) capacitor c=0.0151178f //x=50.07 \
 //y=2.915 //x2=50.81 //y2=3.35
cc_3450 ( N_D_c_4527_p N_noxref_12_c_4870_n ) capacitor c=0.017464f //x=50.07 \
 //y=4.735 //x2=50.81 //y2=3.35
cc_3451 ( N_D_c_4543_p N_noxref_12_c_4870_n ) capacitor c=0.0134517f //x=50.07 \
 //y=2.26 //x2=50.81 //y2=3.35
cc_3452 ( N_D_c_4544_p N_noxref_12_c_4870_n ) capacitor c=0.00686827f \
 //x=50.07 //y=2.755 //x2=50.81 //y2=3.35
cc_3453 ( N_D_c_4545_p N_noxref_12_c_4870_n ) capacitor c=9.26054e-19 \
 //x=50.07 //y=2.26 //x2=50.81 //y2=3.35
cc_3454 ( N_D_c_4546_p N_noxref_12_c_4870_n ) capacitor c=0.00268898f \
 //x=50.07 //y=2.26 //x2=50.81 //y2=3.35
cc_3455 ( N_D_c_4535_p N_noxref_12_c_4870_n ) capacitor c=0.00309058f \
 //x=50.07 //y=2.095 //x2=50.81 //y2=3.35
cc_3456 ( N_D_c_4527_p N_noxref_12_c_4879_n ) capacitor c=0.0174172f //x=50.07 \
 //y=4.735 //x2=50.81 //y2=3.67
cc_3457 ( N_D_c_4527_p N_noxref_12_c_4880_n ) capacitor c=0.0566971f //x=50.07 \
 //y=4.735 //x2=50.81 //y2=5.295
cc_3458 ( N_D_c_4528_p N_noxref_12_c_4880_n ) capacitor c=7.76118e-19 //x=50.1 \
 //y=4.88 //x2=50.81 //y2=5.295
cc_3459 ( N_D_c_4551_p N_noxref_12_c_4880_n ) capacitor c=0.00845606f \
 //x=50.475 //y=4.97 //x2=50.81 //y2=5.295
cc_3460 ( N_D_c_4530_p N_noxref_12_c_4880_n ) capacitor c=0.00142201f //x=50.1 \
 //y=4.88 //x2=50.81 //y2=5.295
cc_3461 ( N_D_c_4540_p N_noxref_12_c_4884_n ) capacitor c=4.4167e-19 //x=50.07 \
 //y=2.595 //x2=52.66 //y2=3.345
cc_3462 ( N_D_c_4527_p N_noxref_12_c_4884_n ) capacitor c=3.07793e-19 \
 //x=50.07 //y=4.735 //x2=52.66 //y2=3.345
cc_3463 ( N_D_M106_noxref_g N_noxref_12_c_4886_n ) capacitor c=0.00192712f \
 //x=50.11 //y=6.2 //x2=50.33 //y2=5.38
cc_3464 ( N_D_M107_noxref_g N_noxref_12_c_4886_n ) capacitor c=0.00298276f \
 //x=50.55 //y=6.2 //x2=50.33 //y2=5.38
cc_3465 ( N_D_c_4551_p N_noxref_12_c_4886_n ) capacitor c=0.0020909f \
 //x=50.475 //y=4.97 //x2=50.33 //y2=5.38
cc_3466 ( N_D_c_4558_p N_noxref_12_c_4889_n ) capacitor c=0.00120406f \
 //x=50.105 //y=1.085 //x2=50.37 //y2=1.18
cc_3467 ( N_D_c_4531_p N_noxref_12_c_4889_n ) capacitor c=0.00218772f \
 //x=50.105 //y=1.43 //x2=50.37 //y2=1.18
cc_3468 ( N_D_c_4560_p N_noxref_12_c_4889_n ) capacitor c=5.50523e-19 \
 //x=50.48 //y=0.93 //x2=50.37 //y2=1.18
cc_3469 ( N_D_c_4533_p N_noxref_12_c_4889_n ) capacitor c=5.67071e-19 \
 //x=50.48 //y=1.585 //x2=50.37 //y2=1.18
cc_3470 ( N_D_c_4562_p N_noxref_12_c_4889_n ) capacitor c=0.00109205f \
 //x=50.635 //y=1.085 //x2=50.37 //y2=1.18
cc_3471 ( N_D_c_4534_p N_noxref_12_c_4889_n ) capacitor c=0.00317092f \
 //x=50.635 //y=1.43 //x2=50.37 //y2=1.18
cc_3472 ( N_D_c_4527_p N_noxref_12_c_4895_n ) capacitor c=6.03895e-19 \
 //x=50.07 //y=4.735 //x2=50.805 //y2=3.51
cc_3473 ( N_D_c_4527_p N_noxref_12_c_4896_n ) capacitor c=0.00136917f \
 //x=50.07 //y=4.735 //x2=52.662 //y2=4.74
cc_3474 ( N_D_c_4408_n N_noxref_12_c_4897_n ) capacitor c=0.00608668f \
 //x=49.91 //y=2.755 //x2=47.095 //y2=3.51
cc_3475 ( N_D_c_4408_n N_noxref_12_c_4898_n ) capacitor c=0.00670118f \
 //x=49.91 //y=2.755 //x2=47.695 //y2=3.495
cc_3476 ( N_D_c_4408_n N_noxref_12_c_4899_n ) capacitor c=0.00396499f \
 //x=49.91 //y=2.755 //x2=48.94 //y2=3.51
cc_3477 ( N_D_c_4527_p N_noxref_12_c_4900_n ) capacitor c=0.0227634f //x=50.07 \
 //y=4.735 //x2=50.965 //y2=3.51
cc_3478 ( N_D_c_4408_n N_noxref_12_c_4900_n ) capacitor c=0.00188471f \
 //x=49.91 //y=2.755 //x2=50.965 //y2=3.51
cc_3479 ( N_D_M106_noxref_g N_noxref_12_c_4902_n ) capacitor c=0.0178987f \
 //x=50.11 //y=6.2 //x2=50.33 //y2=5.56
cc_3480 ( N_D_M107_noxref_g N_noxref_12_c_4902_n ) capacitor c=0.0178506f \
 //x=50.55 //y=6.2 //x2=50.33 //y2=5.56
cc_3481 ( N_D_c_4551_p N_noxref_12_c_4902_n ) capacitor c=0.00291714f \
 //x=50.475 //y=4.97 //x2=50.33 //y2=5.56
cc_3482 ( N_D_c_4558_p N_noxref_12_M30_noxref_d ) capacitor c=0.00137165f \
 //x=50.105 //y=1.085 //x2=50.18 //y2=1.085
cc_3483 ( N_D_c_4531_p N_noxref_12_M30_noxref_d ) capacitor c=0.00237422f \
 //x=50.105 //y=1.43 //x2=50.18 //y2=1.085
cc_3484 ( N_D_c_4560_p N_noxref_12_M30_noxref_d ) capacitor c=0.0020782f \
 //x=50.48 //y=0.93 //x2=50.18 //y2=1.085
cc_3485 ( N_D_c_4533_p N_noxref_12_M30_noxref_d ) capacitor c=0.00356097f \
 //x=50.48 //y=1.585 //x2=50.18 //y2=1.085
cc_3486 ( N_D_c_4562_p N_noxref_12_M30_noxref_d ) capacitor c=8.50095e-19 \
 //x=50.635 //y=1.085 //x2=50.18 //y2=1.085
cc_3487 ( N_D_c_4534_p N_noxref_12_M30_noxref_d ) capacitor c=0.00237422f \
 //x=50.635 //y=1.43 //x2=50.18 //y2=1.085
cc_3488 ( N_D_c_4251_n CLK ) capacitor c=0.0288028f //x=28.435 //y=2.78 \
 //x2=13.81 //y2=3.14
cc_3489 ( N_D_c_4251_n CLK ) capacitor c=0.0274143f //x=28.435 //y=2.78 \
 //x2=24.17 //y2=3.51
cc_3490 ( N_D_c_4408_n CLK ) capacitor c=0.0245251f //x=49.91 //y=2.755 \
 //x2=35.27 //y2=3.51
cc_3491 ( N_D_c_4408_n CLK ) capacitor c=0.0235128f //x=49.91 //y=2.755 \
 //x2=45.63 //y2=3.51
cc_3492 ( N_D_c_4251_n N_CLK_c_5845_n ) capacitor c=0.00391381f //x=28.435 \
 //y=2.78 //x2=24.17 //y2=2.375
cc_3493 ( N_D_c_4251_n N_CLK_c_5637_n ) capacitor c=0.0039507f //x=28.435 \
 //y=2.78 //x2=13.81 //y2=2.26
cc_3494 ( N_D_c_4408_n N_CLK_c_5891_n ) capacitor c=0.0039507f //x=49.91 \
 //y=2.755 //x2=35.27 //y2=2.26
cc_3495 ( D N_CLK_c_5597_n ) capacitor c=0.0239365f //x=7.15 //y=3.14 \
 //x2=10.1 //y2=4.62
cc_3496 ( N_D_c_4246_n N_CLK_c_5597_n ) capacitor c=0.00419513f //x=7.15 \
 //y=4.735 //x2=10.1 //y2=4.62
cc_3497 ( N_D_c_4251_n N_CLK_c_5771_n ) capacitor c=0.00536015f //x=28.435 \
 //y=2.78 //x2=20.685 //y2=4.635
cc_3498 ( N_D_c_4251_n N_CLK_c_5998_n ) capacitor c=3.84849e-19 //x=28.435 \
 //y=2.78 //x2=22.68 //y2=4.62
cc_3499 ( N_D_c_4392_n N_CLK_c_5852_n ) capacitor c=0.028134f //x=28.61 \
 //y=4.735 //x2=31.815 //y2=4.64
cc_3500 ( N_D_c_4408_n N_CLK_c_6033_n ) capacitor c=0.00471708f //x=49.91 \
 //y=2.755 //x2=42.145 //y2=4.635
cc_3501 ( N_D_c_4408_n N_CLK_c_6109_n ) capacitor c=3.84849e-19 //x=49.91 \
 //y=2.755 //x2=44.14 //y2=4.62
cc_3502 ( N_D_c_4527_p N_CLK_c_6110_n ) capacitor c=0.0281458f //x=50.07 \
 //y=4.735 //x2=53.275 //y2=4.64
cc_3503 ( N_D_c_4251_n N_CLK_c_5698_n ) capacitor c=0.00109611f //x=28.435 \
 //y=2.78 //x2=17.235 //y2=4.62
cc_3504 ( N_D_c_4540_p N_noxref_15_c_6583_n ) capacitor c=4.42074e-19 \
 //x=50.07 //y=2.595 //x2=47.48 //y2=3.72
cc_3505 ( N_D_c_4527_p N_noxref_15_c_6583_n ) capacitor c=8.82962e-19 \
 //x=50.07 //y=4.735 //x2=47.48 //y2=3.72
cc_3506 ( N_D_c_4408_n N_noxref_15_c_6583_n ) capacitor c=0.0233619f //x=49.91 \
 //y=2.755 //x2=47.48 //y2=3.72
cc_3507 ( N_D_c_4527_p N_noxref_15_c_6586_n ) capacitor c=0.00115385f \
 //x=50.07 //y=4.735 //x2=47.48 //y2=5.25
cc_3508 ( D N_noxref_15_c_6587_n ) capacitor c=9.19401e-19 //x=50.07 //y=2.77 \
 //x2=49.33 //y2=3.72
cc_3509 ( N_D_c_4540_p N_noxref_15_c_6587_n ) capacitor c=0.00727376f \
 //x=50.07 //y=2.595 //x2=49.33 //y2=3.72
cc_3510 ( N_D_c_4526_p N_noxref_15_c_6587_n ) capacitor c=0.0176081f //x=50.07 \
 //y=2.915 //x2=49.33 //y2=3.72
cc_3511 ( N_D_c_4527_p N_noxref_15_c_6587_n ) capacitor c=0.0312499f //x=50.07 \
 //y=4.735 //x2=49.33 //y2=3.72
cc_3512 ( N_D_c_4544_p N_noxref_15_c_6587_n ) capacitor c=0.0032735f //x=50.07 \
 //y=2.755 //x2=49.33 //y2=3.72
cc_3513 ( N_D_c_4408_n N_noxref_15_c_6587_n ) capacitor c=0.0222593f //x=49.91 \
 //y=2.755 //x2=49.33 //y2=3.72
cc_3514 ( N_D_c_4545_p N_noxref_15_c_6587_n ) capacitor c=3.30333e-19 \
 //x=50.07 //y=2.26 //x2=49.33 //y2=3.72
cc_3515 ( N_D_c_4527_p N_noxref_15_c_6594_n ) capacitor c=0.0144744f //x=50.07 \
 //y=4.735 //x2=49.33 //y2=4.04
cc_3516 ( N_D_c_4527_p N_noxref_15_c_6595_n ) capacitor c=6.03895e-19 \
 //x=50.07 //y=4.735 //x2=49.325 //y2=3.88
cc_3517 ( N_D_c_4543_p N_noxref_15_c_6596_n ) capacitor c=0.0173232f //x=50.07 \
 //y=2.26 //x2=49.33 //y2=2.26
cc_3518 ( N_D_c_4545_p N_noxref_15_c_6596_n ) capacitor c=5.24723e-19 \
 //x=50.07 //y=2.26 //x2=49.33 //y2=2.26
cc_3519 ( N_D_c_4546_p N_noxref_15_c_6596_n ) capacitor c=0.00161167f \
 //x=50.07 //y=2.26 //x2=49.33 //y2=2.26
cc_3520 ( N_D_c_4527_p N_noxref_15_c_6599_n ) capacitor c=0.0172863f //x=50.07 \
 //y=4.735 //x2=49.33 //y2=4.88
cc_3521 ( N_D_c_4528_p N_noxref_15_c_6599_n ) capacitor c=4.80626e-19 //x=50.1 \
 //y=4.88 //x2=49.33 //y2=4.88
cc_3522 ( N_D_c_4530_p N_noxref_15_c_6599_n ) capacitor c=0.00158715f //x=50.1 \
 //y=4.88 //x2=49.33 //y2=4.88
cc_3523 ( N_D_c_4527_p N_noxref_15_c_6602_n ) capacitor c=0.0261735f //x=50.07 \
 //y=4.735 //x2=49.332 //y2=4.74
cc_3524 ( N_D_c_4527_p N_noxref_15_c_6603_n ) capacitor c=0.0234438f //x=50.07 \
 //y=4.735 //x2=50.675 //y2=3.895
cc_3525 ( N_D_c_4540_p N_noxref_15_c_6604_n ) capacitor c=3.30333e-19 \
 //x=50.07 //y=2.595 //x2=49.33 //y2=2.26
cc_3526 ( N_D_c_4543_p N_noxref_15_c_6604_n ) capacitor c=5.16867e-19 \
 //x=50.07 //y=2.26 //x2=49.33 //y2=2.26
cc_3527 ( N_D_c_4545_p N_noxref_15_c_6604_n ) capacitor c=0.00485709f \
 //x=50.07 //y=2.26 //x2=49.33 //y2=2.26
cc_3528 ( N_D_c_4546_p N_noxref_15_c_6604_n ) capacitor c=0.00266443f \
 //x=50.07 //y=2.26 //x2=49.33 //y2=2.26
cc_3529 ( N_D_c_4527_p N_noxref_15_c_6608_n ) capacitor c=7.76143e-19 \
 //x=50.07 //y=4.735 //x2=49.33 //y2=4.88
cc_3530 ( N_D_c_4528_p N_noxref_15_c_6608_n ) capacitor c=0.00397338f //x=50.1 \
 //y=4.88 //x2=49.33 //y2=4.88
cc_3531 ( N_D_c_4530_p N_noxref_15_c_6608_n ) capacitor c=0.00237977f //x=50.1 \
 //y=4.88 //x2=49.33 //y2=4.88
cc_3532 ( N_D_M106_noxref_g N_noxref_15_M104_noxref_g ) capacitor c=0.0104892f \
 //x=50.11 //y=6.2 //x2=49.23 //y2=6.2
cc_3533 ( N_D_M106_noxref_g N_noxref_15_M105_noxref_g ) capacitor c=0.107636f \
 //x=50.11 //y=6.2 //x2=49.67 //y2=6.2
cc_3534 ( N_D_M107_noxref_g N_noxref_15_M105_noxref_g ) capacitor c=0.0100341f \
 //x=50.55 //y=6.2 //x2=49.67 //y2=6.2
cc_3535 ( N_D_c_4558_p N_noxref_15_c_6614_n ) capacitor c=4.86545e-19 \
 //x=50.105 //y=1.085 //x2=49.135 //y2=1.045
cc_3536 ( N_D_c_4558_p N_noxref_15_c_6615_n ) capacitor c=0.00152405f \
 //x=50.105 //y=1.085 //x2=49.135 //y2=1.39
cc_3537 ( N_D_c_4531_p N_noxref_15_c_6616_n ) capacitor c=0.00109982f \
 //x=50.105 //y=1.43 //x2=49.135 //y2=1.7
cc_3538 ( N_D_c_4532_p N_noxref_15_c_6616_n ) capacitor c=9.58243e-19 \
 //x=50.105 //y=1.74 //x2=49.135 //y2=1.7
cc_3539 ( N_D_c_4543_p N_noxref_15_c_6618_n ) capacitor c=0.00159112f \
 //x=50.07 //y=2.26 //x2=49.135 //y2=2.095
cc_3540 ( N_D_c_4545_p N_noxref_15_c_6618_n ) capacitor c=0.00190888f \
 //x=50.07 //y=2.26 //x2=49.135 //y2=2.095
cc_3541 ( N_D_c_4532_p N_noxref_15_c_6618_n ) capacitor c=0.00662747f \
 //x=50.105 //y=1.74 //x2=49.135 //y2=2.095
cc_3542 ( N_D_c_4546_p N_noxref_15_c_6618_n ) capacitor c=0.0181449f //x=50.07 \
 //y=2.26 //x2=49.135 //y2=2.095
cc_3543 ( N_D_c_4558_p N_noxref_15_c_6622_n ) capacitor c=0.0151475f \
 //x=50.105 //y=1.085 //x2=49.665 //y2=1.045
cc_3544 ( N_D_c_4562_p N_noxref_15_c_6622_n ) capacitor c=0.00127211f \
 //x=50.635 //y=1.085 //x2=49.665 //y2=1.045
cc_3545 ( N_D_c_4531_p N_noxref_15_c_6624_n ) capacitor c=0.0111064f \
 //x=50.105 //y=1.43 //x2=49.665 //y2=1.39
cc_3546 ( N_D_c_4532_p N_noxref_15_c_6624_n ) capacitor c=0.00862358f \
 //x=50.105 //y=1.74 //x2=49.665 //y2=1.39
cc_3547 ( N_D_c_4534_p N_noxref_15_c_6624_n ) capacitor c=0.00204774f \
 //x=50.635 //y=1.43 //x2=49.665 //y2=1.39
cc_3548 ( N_D_c_4527_p N_noxref_15_c_6627_n ) capacitor c=0.00201171f \
 //x=50.07 //y=4.735 //x2=49.33 //y2=4.88
cc_3549 ( N_D_c_4528_p N_noxref_15_c_6627_n ) capacitor c=0.00283894f //x=50.1 \
 //y=4.88 //x2=49.33 //y2=4.88
cc_3550 ( N_D_c_4530_p N_noxref_15_c_6627_n ) capacitor c=0.0297875f //x=50.1 \
 //y=4.88 //x2=49.33 //y2=4.88
cc_3551 ( N_D_c_4408_n N_noxref_17_c_7358_n ) capacitor c=0.0247328f //x=49.91 \
 //y=2.755 //x2=44.52 //y2=4.095
cc_3552 ( N_D_c_4408_n N_noxref_17_c_7363_n ) capacitor c=0.0111774f //x=49.91 \
 //y=2.755 //x2=47.095 //y2=4.25
cc_3553 ( N_D_c_4527_p N_noxref_17_c_7364_n ) capacitor c=0.0209359f //x=50.07 \
 //y=4.735 //x2=53.565 //y2=4.25
cc_3554 ( N_D_c_4408_n N_noxref_19_c_8542_n ) capacitor c=0.00366651f \
 //x=49.91 //y=2.755 //x2=38.6 //y2=2.485
cc_3555 ( N_D_c_4408_n N_noxref_19_c_8546_n ) capacitor c=0.0206236f //x=49.91 \
 //y=2.755 //x2=38.6 //y2=4.735
cc_3556 ( N_D_c_4540_p N_noxref_19_c_8591_n ) capacitor c=6.24134e-19 \
 //x=50.07 //y=2.595 //x2=49.685 //y2=2.4
cc_3557 ( N_D_c_4526_p N_noxref_19_c_8591_n ) capacitor c=0.00175999f \
 //x=50.07 //y=2.915 //x2=49.685 //y2=2.4
cc_3558 ( N_D_c_4408_n N_noxref_19_c_8591_n ) capacitor c=0.010662f //x=49.91 \
 //y=2.755 //x2=49.685 //y2=2.4
cc_3559 ( N_D_c_4540_p N_noxref_19_c_8645_n ) capacitor c=0.00886148f \
 //x=50.07 //y=2.595 //x2=50.285 //y2=2.37
cc_3560 ( N_D_c_4526_p N_noxref_19_c_8645_n ) capacitor c=0.00371495f \
 //x=50.07 //y=2.915 //x2=50.285 //y2=2.37
cc_3561 ( N_D_c_4543_p N_noxref_19_c_8645_n ) capacitor c=0.0170499f //x=50.07 \
 //y=2.26 //x2=50.285 //y2=2.37
cc_3562 ( N_D_c_4544_p N_noxref_19_c_8645_n ) capacitor c=0.0370843f //x=50.07 \
 //y=2.755 //x2=50.285 //y2=2.37
cc_3563 ( N_D_c_4546_p N_noxref_19_c_8645_n ) capacitor c=2.98635e-19 \
 //x=50.07 //y=2.26 //x2=50.285 //y2=2.37
cc_3564 ( N_D_c_4408_n N_noxref_19_c_8554_n ) capacitor c=1.02679f //x=49.91 \
 //y=2.755 //x2=38.585 //y2=2.325
cc_3565 ( N_D_c_4251_n N_noxref_20_c_9133_n ) capacitor c=0.0239395f \
 //x=28.435 //y=2.78 //x2=17.14 //y2=2.995
cc_3566 ( N_D_c_4251_n N_noxref_20_c_9135_n ) capacitor c=0.00597572f \
 //x=28.435 //y=2.78 //x2=17.14 //y2=3.315
cc_3567 ( N_D_c_4251_n N_noxref_20_c_9193_n ) capacitor c=0.0127244f \
 //x=28.435 //y=2.78 //x2=20.855 //y2=1.835
cc_3568 ( N_D_c_4251_n N_noxref_20_c_9194_n ) capacitor c=0.0281342f \
 //x=28.435 //y=2.78 //x2=21.21 //y2=2.995
cc_3569 ( N_D_c_4251_n N_noxref_20_c_9283_n ) capacitor c=0.00808578f \
 //x=28.435 //y=2.78 //x2=21.21 //y2=3.315
cc_3570 ( N_D_c_4251_n N_noxref_20_c_9144_n ) capacitor c=0.00269875f \
 //x=28.435 //y=2.78 //x2=17.14 //y2=2.26
cc_3571 ( N_D_c_4251_n N_noxref_20_c_9210_n ) capacitor c=4.96962e-19 \
 //x=28.435 //y=2.78 //x2=20.77 //y2=1.18
cc_3572 ( N_D_c_4251_n N_noxref_20_c_9211_n ) capacitor c=0.338654f //x=28.435 \
 //y=2.78 //x2=21.04 //y2=3.14
cc_3573 ( N_D_c_4251_n N_noxref_20_c_9316_n ) capacitor c=0.245755f //x=28.435 \
 //y=2.78 //x2=25.5 //y2=3.125
cc_3574 ( N_D_c_4251_n N_noxref_20_c_9305_n ) capacitor c=0.42372f //x=28.435 \
 //y=2.78 //x2=25.07 //y2=3.125
cc_3575 ( N_D_c_4385_n N_noxref_20_c_9321_n ) capacitor c=0.00184616f \
 //x=28.61 //y=2.94 //x2=28.21 //y2=3.14
cc_3576 ( N_D_c_4392_n N_noxref_20_c_9321_n ) capacitor c=5.06355e-19 \
 //x=28.61 //y=4.735 //x2=28.21 //y2=3.14
cc_3577 ( N_D_c_4251_n N_noxref_20_c_9321_n ) capacitor c=0.0123308f \
 //x=28.435 //y=2.78 //x2=28.21 //y2=3.14
cc_3578 ( N_D_c_4407_n N_noxref_20_c_9321_n ) capacitor c=0.0367952f \
 //x=28.755 //y=2.78 //x2=28.21 //y2=3.14
cc_3579 ( N_D_c_4385_n N_noxref_20_c_9324_n ) capacitor c=0.00448508f \
 //x=28.61 //y=2.94 //x2=28.81 //y2=3.165
cc_3580 ( N_D_c_4392_n N_noxref_20_c_9324_n ) capacitor c=0.0207283f //x=28.61 \
 //y=4.735 //x2=28.81 //y2=3.165
cc_3581 ( N_D_c_4408_n N_noxref_20_c_9324_n ) capacitor c=0.0847407f //x=49.91 \
 //y=2.755 //x2=28.81 //y2=3.165
cc_3582 ( N_D_c_4408_n N_noxref_20_c_9327_n ) capacitor c=0.116942f //x=49.91 \
 //y=2.755 //x2=29.56 //y2=3.125
cc_3583 ( N_D_c_4408_n N_noxref_20_c_9331_n ) capacitor c=0.0601364f //x=49.91 \
 //y=2.755 //x2=30.81 //y2=3.14
cc_3584 ( N_D_c_4408_n N_noxref_20_c_9334_n ) capacitor c=0.0795989f //x=49.91 \
 //y=2.755 //x2=31.41 //y2=3.12
cc_3585 ( N_D_c_4408_n N_noxref_20_c_9337_n ) capacitor c=0.0599341f //x=49.91 \
 //y=2.755 //x2=32.3 //y2=3.14
cc_3586 ( N_D_c_4408_n N_noxref_20_c_9338_n ) capacitor c=0.115989f //x=49.91 \
 //y=2.755 //x2=32.9 //y2=3.125
cc_3587 ( N_D_c_4408_n N_noxref_20_c_9342_n ) capacitor c=0.0595023f //x=49.91 \
 //y=2.755 //x2=34.14 //y2=3.14
cc_3588 ( N_D_c_4408_n N_noxref_20_c_9345_n ) capacitor c=1.02099f //x=49.91 \
 //y=2.755 //x2=34.74 //y2=3.125
cc_3589 ( N_D_c_4408_n N_noxref_20_c_9365_n ) capacitor c=0.0561424f //x=49.91 \
 //y=2.755 //x2=46.36 //y2=3.14
cc_3590 ( N_D_c_4408_n N_noxref_20_c_9422_n ) capacitor c=0.248319f //x=49.91 \
 //y=2.755 //x2=46.96 //y2=3.125
cc_3591 ( N_D_c_4526_p N_noxref_20_c_9423_n ) capacitor c=0.00617089f \
 //x=50.07 //y=2.915 //x2=50.42 //y2=3.14
cc_3592 ( N_D_c_4527_p N_noxref_20_c_9423_n ) capacitor c=0.0203726f //x=50.07 \
 //y=4.735 //x2=50.42 //y2=3.14
cc_3593 ( N_D_c_4544_p N_noxref_20_c_9423_n ) capacitor c=0.0358686f //x=50.07 \
 //y=2.755 //x2=50.42 //y2=3.14
cc_3594 ( N_D_c_4251_n N_noxref_20_c_9148_n ) capacitor c=0.0365231f \
 //x=28.435 //y=2.78 //x2=17.285 //y2=3.155
cc_3595 ( N_D_M54_noxref_g N_VDD_c_10256_n ) capacitor c=0.00697352f //x=7.19 \
 //y=6.2 //x2=7.765 //y2=7.585
cc_3596 ( N_D_M55_noxref_g N_VDD_c_10256_n ) capacitor c=0.00755544f //x=7.63 \
 //y=6.2 //x2=7.765 //y2=7.585
cc_3597 ( N_D_M80_noxref_g N_VDD_c_10562_n ) capacitor c=0.00697352f //x=28.65 \
 //y=6.2 //x2=29.225 //y2=7.585
cc_3598 ( N_D_M81_noxref_g N_VDD_c_10562_n ) capacitor c=0.00755544f //x=29.09 \
 //y=6.2 //x2=29.225 //y2=7.585
cc_3599 ( N_D_M106_noxref_g N_VDD_c_10857_n ) capacitor c=0.00697352f \
 //x=50.11 //y=6.2 //x2=50.685 //y2=7.585
cc_3600 ( N_D_M107_noxref_g N_VDD_c_10857_n ) capacitor c=0.00755544f \
 //x=50.55 //y=6.2 //x2=50.685 //y2=7.585
cc_3601 ( N_D_c_4262_n N_VDD_c_10269_n ) capacitor c=0.00226427f //x=7.18 \
 //y=4.88 //x2=8.63 //y2=7.585
cc_3602 ( N_D_c_4276_n N_VDD_c_10269_n ) capacitor c=0.0129149f //x=7.555 \
 //y=4.97 //x2=8.63 //y2=7.585
cc_3603 ( N_D_c_4294_n N_VDD_c_10269_n ) capacitor c=2.73429e-19 //x=7.18 \
 //y=4.88 //x2=8.63 //y2=7.585
cc_3604 ( N_D_c_4416_n N_VDD_c_10575_n ) capacitor c=0.00226427f //x=28.64 \
 //y=4.88 //x2=30.09 //y2=7.585
cc_3605 ( N_D_c_4430_n N_VDD_c_10575_n ) capacitor c=0.0129149f //x=29.015 \
 //y=4.97 //x2=30.09 //y2=7.585
cc_3606 ( N_D_c_4448_n N_VDD_c_10575_n ) capacitor c=2.73429e-19 //x=28.64 \
 //y=4.88 //x2=30.09 //y2=7.585
cc_3607 ( N_D_c_4528_p N_VDD_c_10865_n ) capacitor c=0.00226427f //x=50.1 \
 //y=4.88 //x2=51.55 //y2=7.585
cc_3608 ( N_D_c_4551_p N_VDD_c_10865_n ) capacitor c=0.0129149f //x=50.475 \
 //y=4.97 //x2=51.55 //y2=7.585
cc_3609 ( N_D_c_4530_p N_VDD_c_10865_n ) capacitor c=2.73429e-19 //x=50.1 \
 //y=4.88 //x2=51.55 //y2=7.585
cc_3610 ( N_D_M54_noxref_g N_VDD_M53_noxref_d ) capacitor c=0.015318f //x=7.19 \
 //y=6.2 //x2=6.825 //y2=5.2
cc_3611 ( N_D_c_4294_n N_VDD_M53_noxref_d ) capacitor c=3.32552e-19 //x=7.18 \
 //y=4.88 //x2=6.825 //y2=5.2
cc_3612 ( N_D_M55_noxref_g N_VDD_M55_noxref_d ) capacitor c=0.0430452f \
 //x=7.63 //y=6.2 //x2=7.705 //y2=5.2
cc_3613 ( N_D_M80_noxref_g N_VDD_M79_noxref_d ) capacitor c=0.015318f \
 //x=28.65 //y=6.2 //x2=28.285 //y2=5.2
cc_3614 ( N_D_c_4448_n N_VDD_M79_noxref_d ) capacitor c=3.32552e-19 //x=28.64 \
 //y=4.88 //x2=28.285 //y2=5.2
cc_3615 ( N_D_M81_noxref_g N_VDD_M81_noxref_d ) capacitor c=0.0430452f \
 //x=29.09 //y=6.2 //x2=29.165 //y2=5.2
cc_3616 ( N_D_M106_noxref_g N_VDD_M105_noxref_d ) capacitor c=0.015318f \
 //x=50.11 //y=6.2 //x2=49.745 //y2=5.2
cc_3617 ( N_D_c_4530_p N_VDD_M105_noxref_d ) capacitor c=3.32552e-19 //x=50.1 \
 //y=4.88 //x2=49.745 //y2=5.2
cc_3618 ( N_D_M107_noxref_g N_VDD_M107_noxref_d ) capacitor c=0.0430452f \
 //x=50.55 //y=6.2 //x2=50.625 //y2=5.2
cc_3619 ( N_D_c_4251_n N_noxref_24_c_11741_n ) capacitor c=0.00502763f \
 //x=28.435 //y=2.78 //x2=24.965 //y2=1.175
cc_3620 ( N_D_c_4251_n N_noxref_24_c_11720_n ) capacitor c=3.05316e-19 \
 //x=28.435 //y=2.78 //x2=25.935 //y2=0.72
cc_3621 ( N_D_c_4251_n N_noxref_24_M14_noxref_d ) capacitor c=0.00583745f \
 //x=28.435 //y=2.78 //x2=23.81 //y2=1.09
cc_3622 ( N_D_c_4251_n N_noxref_24_M15_noxref_s ) capacitor c=0.00372255f \
 //x=28.435 //y=2.78 //x2=24.915 //y2=0.555
cc_3623 ( N_D_c_4408_n N_noxref_25_c_11828_n ) capacitor c=0.00581653f \
 //x=49.91 //y=2.755 //x2=42.67 //y2=2.515
cc_3624 ( N_D_c_4408_n N_noxref_25_c_11792_n ) capacitor c=0.0232867f \
 //x=49.91 //y=2.755 //x2=42.67 //y2=5.295
cc_3625 ( N_D_c_4238_n N_GND_c_12317_n ) capacitor c=2.09904e-19 //x=7.15 \
 //y=2.945 //x2=9.725 //y2=0.175
cc_3626 ( N_D_c_4248_n N_GND_c_12317_n ) capacitor c=0.00214592f //x=7.15 \
 //y=2.26 //x2=9.725 //y2=0.175
cc_3627 ( N_D_c_4249_n N_GND_c_12317_n ) capacitor c=0.00453686f //x=7.315 \
 //y=2.785 //x2=9.725 //y2=0.175
cc_3628 ( N_D_c_4251_n N_GND_c_12317_n ) capacitor c=0.0614641f //x=28.435 \
 //y=2.78 //x2=9.725 //y2=0.175
cc_3629 ( N_D_c_4251_n N_GND_c_12361_n ) capacitor c=0.0753571f //x=28.435 \
 //y=2.78 //x2=13.055 //y2=0.175
cc_3630 ( N_D_c_4251_n N_GND_c_12502_n ) capacitor c=0.0779268f //x=28.435 \
 //y=2.78 //x2=16.385 //y2=0.175
cc_3631 ( N_D_c_4251_n N_GND_c_12460_n ) capacitor c=0.0758057f //x=28.435 \
 //y=2.78 //x2=19.715 //y2=0.175
cc_3632 ( N_D_c_4251_n N_GND_c_12505_n ) capacitor c=0.0725157f //x=28.435 \
 //y=2.78 //x2=22.94 //y2=0.175
cc_3633 ( N_D_c_4251_n N_GND_c_12546_n ) capacitor c=0.114841f //x=28.435 \
 //y=2.78 //x2=27.855 //y2=0.175
cc_3634 ( N_D_c_4385_n N_GND_c_12547_n ) capacitor c=2.47494e-19 //x=28.61 \
 //y=2.94 //x2=31.185 //y2=0.175
cc_3635 ( N_D_c_4400_n N_GND_c_12547_n ) capacitor c=0.00214538f //x=28.61 \
 //y=2.26 //x2=31.185 //y2=0.175
cc_3636 ( N_D_c_4251_n N_GND_c_12547_n ) capacitor c=0.00746226f //x=28.435 \
 //y=2.78 //x2=31.185 //y2=0.175
cc_3637 ( N_D_c_4407_n N_GND_c_12547_n ) capacitor c=0.0045448f //x=28.755 \
 //y=2.78 //x2=31.185 //y2=0.175
cc_3638 ( N_D_c_4408_n N_GND_c_12547_n ) capacitor c=0.0617988f //x=49.91 \
 //y=2.755 //x2=31.185 //y2=0.175
cc_3639 ( N_D_c_4408_n N_GND_c_12588_n ) capacitor c=0.0753571f //x=49.91 \
 //y=2.755 //x2=34.515 //y2=0.175
cc_3640 ( N_D_c_4408_n N_GND_c_12727_n ) capacitor c=0.0779268f //x=49.91 \
 //y=2.755 //x2=37.845 //y2=0.175
cc_3641 ( N_D_c_4408_n N_GND_c_12685_n ) capacitor c=0.0074655f //x=49.91 \
 //y=2.755 //x2=41.175 //y2=0.175
cc_3642 ( N_D_c_4526_p N_GND_c_12788_n ) capacitor c=3.4968e-19 //x=50.07 \
 //y=2.915 //x2=52.645 //y2=0.175
cc_3643 ( N_D_c_4543_p N_GND_c_12788_n ) capacitor c=0.00210566f //x=50.07 \
 //y=2.26 //x2=52.645 //y2=0.175
cc_3644 ( N_D_c_4251_n N_GND_c_12324_n ) capacitor c=0.004036f //x=28.435 \
 //y=2.78 //x2=9.81 //y2=1.135
cc_3645 ( N_D_c_4251_n N_GND_c_12368_n ) capacitor c=0.00403698f //x=28.435 \
 //y=2.78 //x2=13.14 //y2=1.135
cc_3646 ( N_D_c_4251_n N_GND_c_12418_n ) capacitor c=0.00411393f //x=28.435 \
 //y=2.78 //x2=16.47 //y2=1.135
cc_3647 ( N_D_c_4251_n N_GND_c_12467_n ) capacitor c=0.00410287f //x=28.435 \
 //y=2.78 //x2=19.8 //y2=1.135
cc_3648 ( N_D_c_4251_n N_GND_c_12731_n ) capacitor c=0.00367609f //x=28.435 \
 //y=2.78 //x2=23.025 //y2=1.145
cc_3649 ( N_D_c_4251_n N_GND_c_12550_n ) capacitor c=0.00410549f //x=28.435 \
 //y=2.78 //x2=27.94 //y2=1.135
cc_3650 ( N_D_c_4408_n N_GND_c_12553_n ) capacitor c=0.004036f //x=49.91 \
 //y=2.755 //x2=31.27 //y2=1.135
cc_3651 ( N_D_c_4408_n N_GND_c_12595_n ) capacitor c=0.00403698f //x=49.91 \
 //y=2.755 //x2=34.6 //y2=1.135
cc_3652 ( N_D_c_4408_n N_GND_c_12644_n ) capacitor c=0.00411393f //x=49.91 \
 //y=2.755 //x2=37.93 //y2=1.135
cc_3653 ( N_D_c_4248_n N_GND_c_12338_n ) capacitor c=3.77328e-19 //x=7.15 \
 //y=2.26 //x2=8.46 //y2=0.175
cc_3654 ( N_D_c_4400_n N_GND_c_12567_n ) capacitor c=3.77328e-19 //x=28.61 \
 //y=2.26 //x2=29.92 //y2=0.175
cc_3655 ( N_D_c_4543_p N_GND_c_12801_n ) capacitor c=3.77328e-19 //x=50.07 \
 //y=2.26 //x2=51.38 //y2=0.175
cc_3656 ( D N_GND_c_12340_n ) capacitor c=0.00221465f //x=7.15 //y=2.77 \
 //x2=5.3 //y2=0.175
cc_3657 ( D N_GND_c_12345_n ) capacitor c=0.00276354f //x=7.15 //y=2.77 \
 //x2=8.63 //y2=0.175
cc_3658 ( N_D_c_4251_n N_GND_c_12345_n ) capacitor c=0.0221146f //x=28.435 \
 //y=2.78 //x2=8.63 //y2=0.175
cc_3659 ( N_D_c_4261_n N_GND_c_12345_n ) capacitor c=0.00224736f //x=7.15 \
 //y=2.26 //x2=8.63 //y2=0.175
cc_3660 ( N_D_c_4287_n N_GND_c_12345_n ) capacitor c=0.00275184f //x=7.715 \
 //y=1.43 //x2=8.63 //y2=0.175
cc_3661 ( N_D_c_4291_n N_GND_c_12345_n ) capacitor c=2.63786e-19 //x=7.15 \
 //y=2.26 //x2=8.63 //y2=0.175
cc_3662 ( N_D_c_4251_n N_GND_c_12385_n ) capacitor c=0.0228231f //x=28.435 \
 //y=2.78 //x2=11.96 //y2=0.175
cc_3663 ( N_D_c_4251_n N_GND_c_12440_n ) capacitor c=0.0236302f //x=28.435 \
 //y=2.78 //x2=15.29 //y2=0.175
cc_3664 ( N_D_c_4251_n N_GND_c_12483_n ) capacitor c=0.0217002f //x=28.435 \
 //y=2.78 //x2=18.62 //y2=0.175
cc_3665 ( N_D_c_4251_n N_GND_c_12535_n ) capacitor c=0.0214106f //x=28.435 \
 //y=2.78 //x2=21.95 //y2=0.175
cc_3666 ( D N_GND_c_12569_n ) capacitor c=0.00172375f //x=28.61 //y=2.77 \
 //x2=26.76 //y2=0.175
cc_3667 ( N_D_c_4251_n N_GND_c_12569_n ) capacitor c=0.021363f //x=28.435 \
 //y=2.78 //x2=26.76 //y2=0.175
cc_3668 ( D N_GND_c_12573_n ) capacitor c=0.00276354f //x=28.61 //y=2.77 \
 //x2=30.09 //y2=0.175
cc_3669 ( N_D_c_4408_n N_GND_c_12573_n ) capacitor c=0.0209918f //x=49.91 \
 //y=2.755 //x2=30.09 //y2=0.175
cc_3670 ( N_D_c_4415_n N_GND_c_12573_n ) capacitor c=0.00224736f //x=28.61 \
 //y=2.26 //x2=30.09 //y2=0.175
cc_3671 ( N_D_c_4441_n N_GND_c_12573_n ) capacitor c=0.00275184f //x=29.175 \
 //y=1.43 //x2=30.09 //y2=0.175
cc_3672 ( N_D_c_4445_n N_GND_c_12573_n ) capacitor c=2.63786e-19 //x=28.61 \
 //y=2.26 //x2=30.09 //y2=0.175
cc_3673 ( N_D_c_4408_n N_GND_c_12612_n ) capacitor c=0.0217002f //x=49.91 \
 //y=2.755 //x2=33.42 //y2=0.175
cc_3674 ( N_D_c_4408_n N_GND_c_12666_n ) capacitor c=0.0217002f //x=49.91 \
 //y=2.755 //x2=36.75 //y2=0.175
cc_3675 ( N_D_c_4408_n N_GND_c_12708_n ) capacitor c=0.012936f //x=49.91 \
 //y=2.755 //x2=40.08 //y2=0.175
cc_3676 ( N_D_c_4408_n N_GND_c_12760_n ) capacitor c=0.0130076f //x=49.91 \
 //y=2.755 //x2=43.41 //y2=0.175
cc_3677 ( D N_GND_c_12823_n ) capacitor c=0.00172742f //x=50.07 //y=2.77 \
 //x2=48.22 //y2=0.175
cc_3678 ( N_D_c_4408_n N_GND_c_12823_n ) capacitor c=0.0125988f //x=49.91 \
 //y=2.755 //x2=48.22 //y2=0.175
cc_3679 ( D N_GND_c_12825_n ) capacitor c=0.00313809f //x=50.07 //y=2.77 \
 //x2=51.55 //y2=0.175
cc_3680 ( N_D_c_4545_p N_GND_c_12825_n ) capacitor c=0.00207214f //x=50.07 \
 //y=2.26 //x2=51.55 //y2=0.175
cc_3681 ( N_D_c_4534_p N_GND_c_12825_n ) capacitor c=0.00275184f //x=50.635 \
 //y=1.43 //x2=51.55 //y2=0.175
cc_3682 ( N_D_c_4546_p N_GND_c_12825_n ) capacitor c=2.63786e-19 //x=50.07 \
 //y=2.26 //x2=51.55 //y2=0.175
cc_3683 ( N_D_c_4238_n N_noxref_32_c_14038_n ) capacitor c=0.00104831f \
 //x=7.15 //y=2.945 //x2=6.965 //y2=1.675
cc_3684 ( N_D_c_4248_n N_noxref_32_c_14038_n ) capacitor c=7.50092e-19 \
 //x=7.15 //y=2.26 //x2=6.965 //y2=1.675
cc_3685 ( N_D_c_4275_n N_noxref_32_c_14038_n ) capacitor c=0.00888238f \
 //x=7.185 //y=1.74 //x2=6.965 //y2=1.675
cc_3686 ( N_D_c_4291_n N_noxref_32_c_14038_n ) capacitor c=0.00173743f \
 //x=7.15 //y=2.26 //x2=6.965 //y2=1.675
cc_3687 ( N_D_c_4238_n N_noxref_32_c_14040_n ) capacitor c=4.72679e-19 \
 //x=7.15 //y=2.945 //x2=7.85 //y2=0.71
cc_3688 ( N_D_c_4248_n N_noxref_32_c_14040_n ) capacitor c=0.001463f //x=7.15 \
 //y=2.26 //x2=7.85 //y2=0.71
cc_3689 ( N_D_c_4261_n N_noxref_32_c_14040_n ) capacitor c=8.82141e-19 \
 //x=7.15 //y=2.26 //x2=7.85 //y2=0.71
cc_3690 ( N_D_c_4270_n N_noxref_32_c_14040_n ) capacitor c=0.0200738f \
 //x=7.185 //y=1.085 //x2=7.85 //y2=0.71
cc_3691 ( N_D_c_4285_n N_noxref_32_c_14040_n ) capacitor c=0.00825432f \
 //x=7.715 //y=1.085 //x2=7.85 //y2=0.71
cc_3692 ( N_D_c_4291_n N_noxref_32_c_14040_n ) capacitor c=2.1838e-19 //x=7.15 \
 //y=2.26 //x2=7.85 //y2=0.71
cc_3693 ( N_D_c_4251_n N_noxref_32_M3_noxref_s ) capacitor c=9.08727e-19 \
 //x=28.435 //y=2.78 //x2=5.86 //y2=0.545
cc_3694 ( N_D_c_4270_n N_noxref_32_M3_noxref_s ) capacitor c=0.00888238f \
 //x=7.185 //y=1.085 //x2=5.86 //y2=0.545
cc_3695 ( N_D_c_4285_n N_noxref_32_M3_noxref_s ) capacitor c=0.015333f \
 //x=7.715 //y=1.085 //x2=5.86 //y2=0.545
cc_3696 ( N_D_c_4287_n N_noxref_32_M3_noxref_s ) capacitor c=0.00248746f \
 //x=7.715 //y=1.43 //x2=5.86 //y2=0.545
cc_3697 ( N_D_c_4251_n N_noxref_33_c_14104_n ) capacitor c=0.00367876f \
 //x=28.435 //y=2.78 //x2=9.325 //y2=1.675
cc_3698 ( N_D_c_4251_n N_noxref_33_c_14105_n ) capacitor c=0.0109223f \
 //x=28.435 //y=2.78 //x2=10.21 //y2=1.76
cc_3699 ( N_D_c_4251_n N_noxref_33_c_14112_n ) capacitor c=0.00370266f \
 //x=28.435 //y=2.78 //x2=10.295 //y2=1.675
cc_3700 ( N_D_c_4251_n N_noxref_33_c_14117_n ) capacitor c=6.92058e-19 \
 //x=28.435 //y=2.78 //x2=11.18 //y2=0.71
cc_3701 ( N_D_c_4251_n N_noxref_33_M5_noxref_s ) capacitor c=9.08727e-19 \
 //x=28.435 //y=2.78 //x2=9.19 //y2=0.545
cc_3702 ( N_D_c_4251_n N_noxref_34_c_14173_n ) capacitor c=0.00367876f \
 //x=28.435 //y=2.78 //x2=12.655 //y2=1.675
cc_3703 ( N_D_c_4251_n N_noxref_34_c_14174_n ) capacitor c=0.0109226f \
 //x=28.435 //y=2.78 //x2=13.54 //y2=1.76
cc_3704 ( N_D_c_4251_n N_noxref_34_c_14181_n ) capacitor c=0.00340063f \
 //x=28.435 //y=2.78 //x2=13.625 //y2=1.675
cc_3705 ( N_D_c_4251_n N_noxref_34_c_14186_n ) capacitor c=6.22861e-19 \
 //x=28.435 //y=2.78 //x2=14.51 //y2=0.71
cc_3706 ( N_D_c_4251_n N_noxref_34_M7_noxref_s ) capacitor c=9.08727e-19 \
 //x=28.435 //y=2.78 //x2=12.52 //y2=0.545
cc_3707 ( N_D_c_4251_n N_noxref_35_c_14241_n ) capacitor c=0.00367876f \
 //x=28.435 //y=2.78 //x2=15.985 //y2=1.675
cc_3708 ( N_D_c_4251_n N_noxref_35_c_14242_n ) capacitor c=0.0109574f \
 //x=28.435 //y=2.78 //x2=16.87 //y2=1.76
cc_3709 ( N_D_c_4251_n N_noxref_35_c_14249_n ) capacitor c=0.00349356f \
 //x=28.435 //y=2.78 //x2=16.955 //y2=1.675
cc_3710 ( N_D_c_4251_n N_noxref_35_c_14254_n ) capacitor c=7.90313e-19 \
 //x=28.435 //y=2.78 //x2=17.84 //y2=0.71
cc_3711 ( N_D_c_4251_n N_noxref_35_M9_noxref_s ) capacitor c=9.08727e-19 \
 //x=28.435 //y=2.78 //x2=15.85 //y2=0.545
cc_3712 ( N_D_c_4251_n N_noxref_36_c_14311_n ) capacitor c=0.00367876f \
 //x=28.435 //y=2.78 //x2=19.315 //y2=1.675
cc_3713 ( N_D_c_4251_n N_noxref_36_c_14312_n ) capacitor c=0.0108513f \
 //x=28.435 //y=2.78 //x2=20.2 //y2=1.76
cc_3714 ( N_D_c_4251_n N_noxref_36_c_14319_n ) capacitor c=0.00370266f \
 //x=28.435 //y=2.78 //x2=20.285 //y2=1.675
cc_3715 ( N_D_c_4251_n N_noxref_36_c_14327_n ) capacitor c=7.31899e-19 \
 //x=28.435 //y=2.78 //x2=21.17 //y2=0.71
cc_3716 ( N_D_c_4251_n N_noxref_36_M11_noxref_s ) capacitor c=9.08727e-19 \
 //x=28.435 //y=2.78 //x2=19.18 //y2=0.545
cc_3717 ( N_D_c_4251_n N_noxref_37_c_14380_n ) capacitor c=0.00369947f \
 //x=28.435 //y=2.78 //x2=22.54 //y2=1.685
cc_3718 ( N_D_c_4251_n N_noxref_37_c_14381_n ) capacitor c=0.0112329f \
 //x=28.435 //y=2.78 //x2=23.425 //y2=1.77
cc_3719 ( N_D_c_4251_n N_noxref_37_c_14394_n ) capacitor c=0.00995347f \
 //x=28.435 //y=2.78 //x2=24.395 //y2=1.77
cc_3720 ( N_D_c_4251_n N_noxref_37_M13_noxref_s ) capacitor c=0.0069245f \
 //x=28.435 //y=2.78 //x2=22.405 //y2=0.555
cc_3721 ( N_D_c_4251_n N_noxref_38_c_14449_n ) capacitor c=0.00367876f \
 //x=28.435 //y=2.78 //x2=27.455 //y2=1.675
cc_3722 ( N_D_c_4251_n N_noxref_38_c_14450_n ) capacitor c=0.0108513f \
 //x=28.435 //y=2.78 //x2=28.34 //y2=1.76
cc_3723 ( N_D_c_4385_n N_noxref_38_c_14439_n ) capacitor c=0.00157229f \
 //x=28.61 //y=2.94 //x2=28.425 //y2=1.675
cc_3724 ( N_D_c_4400_n N_noxref_38_c_14439_n ) capacitor c=7.50092e-19 \
 //x=28.61 //y=2.26 //x2=28.425 //y2=1.675
cc_3725 ( N_D_c_4251_n N_noxref_38_c_14439_n ) capacitor c=0.00204612f \
 //x=28.435 //y=2.78 //x2=28.425 //y2=1.675
cc_3726 ( N_D_c_4429_n N_noxref_38_c_14439_n ) capacitor c=0.00888238f \
 //x=28.645 //y=1.74 //x2=28.425 //y2=1.675
cc_3727 ( N_D_c_4445_n N_noxref_38_c_14439_n ) capacitor c=0.0017374f \
 //x=28.61 //y=2.26 //x2=28.425 //y2=1.675
cc_3728 ( N_D_c_4385_n N_noxref_38_c_14440_n ) capacitor c=4.58824e-19 \
 //x=28.61 //y=2.94 //x2=29.31 //y2=0.71
cc_3729 ( N_D_c_4400_n N_noxref_38_c_14440_n ) capacitor c=0.001463f //x=28.61 \
 //y=2.26 //x2=29.31 //y2=0.71
cc_3730 ( N_D_c_4415_n N_noxref_38_c_14440_n ) capacitor c=8.82141e-19 \
 //x=28.61 //y=2.26 //x2=29.31 //y2=0.71
cc_3731 ( N_D_c_4424_n N_noxref_38_c_14440_n ) capacitor c=0.0200738f \
 //x=28.645 //y=1.085 //x2=29.31 //y2=0.71
cc_3732 ( N_D_c_4439_n N_noxref_38_c_14440_n ) capacitor c=0.00825432f \
 //x=29.175 //y=1.085 //x2=29.31 //y2=0.71
cc_3733 ( N_D_c_4445_n N_noxref_38_c_14440_n ) capacitor c=2.1838e-19 \
 //x=28.61 //y=2.26 //x2=29.31 //y2=0.71
cc_3734 ( N_D_c_4408_n N_noxref_38_M16_noxref_s ) capacitor c=9.08727e-19 \
 //x=49.91 //y=2.755 //x2=27.32 //y2=0.545
cc_3735 ( N_D_c_4424_n N_noxref_38_M16_noxref_s ) capacitor c=0.00888238f \
 //x=28.645 //y=1.085 //x2=27.32 //y2=0.545
cc_3736 ( N_D_c_4439_n N_noxref_38_M16_noxref_s ) capacitor c=0.015333f \
 //x=29.175 //y=1.085 //x2=27.32 //y2=0.545
cc_3737 ( N_D_c_4441_n N_noxref_38_M16_noxref_s ) capacitor c=0.00248746f \
 //x=29.175 //y=1.43 //x2=27.32 //y2=0.545
cc_3738 ( N_D_c_4408_n N_noxref_39_c_14507_n ) capacitor c=0.00367876f \
 //x=49.91 //y=2.755 //x2=30.785 //y2=1.675
cc_3739 ( N_D_c_4408_n N_noxref_39_c_14508_n ) capacitor c=0.0108494f \
 //x=49.91 //y=2.755 //x2=31.67 //y2=1.76
cc_3740 ( N_D_c_4408_n N_noxref_39_c_14515_n ) capacitor c=0.00370266f \
 //x=49.91 //y=2.755 //x2=31.755 //y2=1.675
cc_3741 ( N_D_c_4408_n N_noxref_39_c_14520_n ) capacitor c=7.43582e-19 \
 //x=49.91 //y=2.755 //x2=32.64 //y2=0.71
cc_3742 ( N_D_c_4408_n N_noxref_39_M18_noxref_s ) capacitor c=9.08727e-19 \
 //x=49.91 //y=2.755 //x2=30.65 //y2=0.545
cc_3743 ( N_D_c_4408_n N_noxref_40_c_14576_n ) capacitor c=0.00367876f \
 //x=49.91 //y=2.755 //x2=34.115 //y2=1.675
cc_3744 ( N_D_c_4408_n N_noxref_40_c_14577_n ) capacitor c=0.0108498f \
 //x=49.91 //y=2.755 //x2=35 //y2=1.76
cc_3745 ( N_D_c_4408_n N_noxref_40_c_14584_n ) capacitor c=0.00340063f \
 //x=49.91 //y=2.755 //x2=35.085 //y2=1.675
cc_3746 ( N_D_c_4408_n N_noxref_40_c_14589_n ) capacitor c=7.90313e-19 \
 //x=49.91 //y=2.755 //x2=35.97 //y2=0.71
cc_3747 ( N_D_c_4408_n N_noxref_40_M20_noxref_s ) capacitor c=9.08727e-19 \
 //x=49.91 //y=2.755 //x2=33.98 //y2=0.545
cc_3748 ( N_D_c_4408_n N_noxref_41_c_14644_n ) capacitor c=0.00367876f \
 //x=49.91 //y=2.755 //x2=37.445 //y2=1.675
cc_3749 ( N_D_c_4408_n N_noxref_41_c_14645_n ) capacitor c=0.0108677f \
 //x=49.91 //y=2.755 //x2=38.33 //y2=1.76
cc_3750 ( N_D_c_4408_n N_noxref_41_c_14652_n ) capacitor c=0.00205578f \
 //x=49.91 //y=2.755 //x2=38.415 //y2=1.675
cc_3751 ( N_D_c_4526_p N_noxref_44_c_14839_n ) capacitor c=0.00345354f \
 //x=50.07 //y=2.915 //x2=49.885 //y2=1.675
cc_3752 ( N_D_c_4543_p N_noxref_44_c_14839_n ) capacitor c=7.50092e-19 \
 //x=50.07 //y=2.26 //x2=49.885 //y2=1.675
cc_3753 ( N_D_c_4532_p N_noxref_44_c_14839_n ) capacitor c=0.00888238f \
 //x=50.105 //y=1.74 //x2=49.885 //y2=1.675
cc_3754 ( N_D_c_4546_p N_noxref_44_c_14839_n ) capacitor c=0.00173721f \
 //x=50.07 //y=2.26 //x2=49.885 //y2=1.675
cc_3755 ( N_D_c_4526_p N_noxref_44_c_14843_n ) capacitor c=2.98771e-19 \
 //x=50.07 //y=2.915 //x2=50.77 //y2=0.71
cc_3756 ( N_D_c_4543_p N_noxref_44_c_14843_n ) capacitor c=0.001463f //x=50.07 \
 //y=2.26 //x2=50.77 //y2=0.71
cc_3757 ( N_D_c_4545_p N_noxref_44_c_14843_n ) capacitor c=8.82141e-19 \
 //x=50.07 //y=2.26 //x2=50.77 //y2=0.71
cc_3758 ( N_D_c_4558_p N_noxref_44_c_14843_n ) capacitor c=0.0200738f \
 //x=50.105 //y=1.085 //x2=50.77 //y2=0.71
cc_3759 ( N_D_c_4562_p N_noxref_44_c_14843_n ) capacitor c=0.00825432f \
 //x=50.635 //y=1.085 //x2=50.77 //y2=0.71
cc_3760 ( N_D_c_4546_p N_noxref_44_c_14843_n ) capacitor c=2.1838e-19 \
 //x=50.07 //y=2.26 //x2=50.77 //y2=0.71
cc_3761 ( N_D_c_4558_p N_noxref_44_M29_noxref_s ) capacitor c=0.00888238f \
 //x=50.105 //y=1.085 //x2=48.78 //y2=0.545
cc_3762 ( N_D_c_4562_p N_noxref_44_M29_noxref_s ) capacitor c=0.015333f \
 //x=50.635 //y=1.085 //x2=48.78 //y2=0.545
cc_3763 ( N_D_c_4534_p N_noxref_44_M29_noxref_s ) capacitor c=0.00248746f \
 //x=50.635 //y=1.43 //x2=48.78 //y2=0.545
cc_3764 ( N_noxref_12_M109_noxref_g N_noxref_13_c_5296_n ) capacitor \
 c=0.00889217f //x=53 //y=6.2 //x2=53.545 //y2=5.38
cc_3765 ( N_noxref_12_c_4862_n N_noxref_13_c_5297_n ) capacitor c=0.00324213f \
 //x=50.37 //y=1.75 //x2=53.7 //y2=1.75
cc_3766 ( N_noxref_12_c_4868_n N_noxref_13_c_5298_n ) capacitor c=0.00231467f \
 //x=50.725 //y=1.835 //x2=53.785 //y2=1.835
cc_3767 ( N_noxref_12_c_4870_n N_noxref_13_c_5299_n ) capacitor c=0.00204244f \
 //x=50.81 //y=3.35 //x2=54.14 //y2=3.35
cc_3768 ( N_noxref_12_c_4884_n N_noxref_13_c_5299_n ) capacitor c=0.00262948f \
 //x=52.66 //y=3.345 //x2=54.14 //y2=3.35
cc_3769 ( N_noxref_12_c_4880_n N_noxref_13_c_5301_n ) capacitor c=0.00281705f \
 //x=50.81 //y=5.295 //x2=54.14 //y2=5.295
cc_3770 ( N_noxref_12_c_4896_n N_noxref_13_c_5301_n ) capacitor c=0.00193818f \
 //x=52.662 //y=4.74 //x2=54.14 //y2=5.295
cc_3771 ( N_noxref_12_c_4867_n N_noxref_13_c_5303_n ) capacitor c=0.00114153f \
 //x=50.725 //y=5.38 //x2=52.78 //y2=5.56
cc_3772 ( N_noxref_12_c_4919_p N_noxref_13_c_5303_n ) capacitor c=5.6496e-19 \
 //x=52.66 //y=3.665 //x2=52.78 //y2=5.56
cc_3773 ( N_noxref_12_c_4886_n N_noxref_13_c_5303_n ) capacitor c=5.29822e-19 \
 //x=50.33 //y=5.38 //x2=52.78 //y2=5.56
cc_3774 ( N_noxref_12_c_4921_p N_noxref_13_c_5303_n ) capacitor c=0.00147119f \
 //x=50.33 //y=5.56 //x2=52.78 //y2=5.56
cc_3775 ( N_noxref_12_c_4922_p N_noxref_13_c_5303_n ) capacitor c=0.0117744f \
 //x=52.66 //y=4.88 //x2=52.78 //y2=5.56
cc_3776 ( N_noxref_12_c_4923_p N_noxref_13_c_5303_n ) capacitor c=0.00277154f \
 //x=52.66 //y=4.88 //x2=52.78 //y2=5.56
cc_3777 ( N_noxref_12_M108_noxref_g N_noxref_13_c_5303_n ) capacitor \
 c=0.00201806f //x=52.56 //y=6.2 //x2=52.78 //y2=5.56
cc_3778 ( N_noxref_12_M109_noxref_g N_noxref_13_c_5303_n ) capacitor \
 c=0.00192712f //x=53 //y=6.2 //x2=52.78 //y2=5.56
cc_3779 ( N_noxref_12_c_4926_p N_noxref_13_c_5303_n ) capacitor c=0.00194573f \
 //x=52.66 //y=4.88 //x2=52.78 //y2=5.56
cc_3780 ( N_noxref_12_c_4889_n N_noxref_13_c_5312_n ) capacitor c=6.99317e-19 \
 //x=50.37 //y=1.18 //x2=53.7 //y2=1.18
cc_3781 ( N_noxref_12_c_4928_p N_noxref_13_c_5313_n ) capacitor c=0.00251357f \
 //x=52.66 //y=3.51 //x2=54.14 //y2=3.51
cc_3782 ( N_noxref_12_c_4929_p N_noxref_13_c_5314_n ) capacitor c=0.00521181f \
 //x=52.655 //y=3.505 //x2=54.305 //y2=3.51
cc_3783 ( N_noxref_12_c_4922_p N_noxref_13_c_5315_n ) capacitor c=0.00104426f \
 //x=52.66 //y=4.88 //x2=52.78 //y2=5.56
cc_3784 ( N_noxref_12_c_4923_p N_noxref_13_c_5315_n ) capacitor c=0.00377369f \
 //x=52.66 //y=4.88 //x2=52.78 //y2=5.56
cc_3785 ( N_noxref_12_M108_noxref_g N_noxref_13_c_5315_n ) capacitor \
 c=0.0158358f //x=52.56 //y=6.2 //x2=52.78 //y2=5.56
cc_3786 ( N_noxref_12_M109_noxref_g N_noxref_13_c_5315_n ) capacitor \
 c=0.0178987f //x=53 //y=6.2 //x2=52.78 //y2=5.56
cc_3787 ( N_noxref_12_c_4926_p N_noxref_13_c_5315_n ) capacitor c=0.0043218f \
 //x=52.66 //y=4.88 //x2=52.78 //y2=5.56
cc_3788 ( N_noxref_12_c_4856_n CLK ) capacitor c=0.0212411f //x=46.74 //y=3.35 \
 //x2=45.63 //y2=3.51
cc_3789 ( N_noxref_12_c_4936_p CLK ) capacitor c=0.00769355f //x=46.74 \
 //y=3.67 //x2=45.63 //y2=3.51
cc_3790 ( N_noxref_12_c_4937_p CLK ) capacitor c=0.0251266f //x=46.74 //y=4.75 \
 //x2=45.63 //y2=3.51
cc_3791 ( N_noxref_12_c_4938_p CLK ) capacitor c=3.35971e-19 //x=46.74 \
 //y=3.51 //x2=45.63 //y2=3.51
cc_3792 ( N_noxref_12_c_4939_p CLK ) capacitor c=0.00507285f //x=46.905 \
 //y=3.51 //x2=45.63 //y2=3.51
cc_3793 ( N_noxref_12_c_4940_p CLK ) capacitor c=3.9149e-19 //x=46.74 //y=2.26 \
 //x2=45.63 //y2=3.51
cc_3794 ( N_noxref_12_c_4941_p N_CLK_c_6118_n ) capacitor c=0.00939109f \
 //x=46.74 //y=2.375 //x2=45.63 //y2=2.375
cc_3795 ( N_noxref_12_c_4940_p N_CLK_c_6118_n ) capacitor c=5.42289e-19 \
 //x=46.74 //y=2.26 //x2=45.63 //y2=2.375
cc_3796 ( N_noxref_12_c_4943_p N_CLK_c_6118_n ) capacitor c=0.00134951f \
 //x=46.74 //y=2.26 //x2=45.63 //y2=2.375
cc_3797 ( N_noxref_12_c_4937_p N_CLK_c_6121_n ) capacitor c=0.00713797f \
 //x=46.74 //y=4.75 //x2=45.63 //y2=4.88
cc_3798 ( N_noxref_12_c_4945_p N_CLK_c_6121_n ) capacitor c=6.80672e-19 \
 //x=46.74 //y=4.88 //x2=45.63 //y2=4.88
cc_3799 ( N_noxref_12_c_4946_p N_CLK_c_6121_n ) capacitor c=0.00153715f \
 //x=46.74 //y=4.88 //x2=45.63 //y2=4.88
cc_3800 ( N_noxref_12_c_4937_p N_CLK_c_6124_n ) capacitor c=0.00731957f \
 //x=46.74 //y=4.75 //x2=45.63 //y2=4.88
cc_3801 ( N_noxref_12_c_4937_p N_CLK_c_6110_n ) capacitor c=0.0290946f \
 //x=46.74 //y=4.75 //x2=53.275 //y2=4.64
cc_3802 ( N_noxref_12_c_4880_n N_CLK_c_6110_n ) capacitor c=0.0287614f \
 //x=50.81 //y=5.295 //x2=53.275 //y2=4.64
cc_3803 ( N_noxref_12_c_4950_p N_CLK_c_6110_n ) capacitor c=0.022687f \
 //x=49.45 //y=5.56 //x2=53.275 //y2=4.64
cc_3804 ( N_noxref_12_c_4886_n N_CLK_c_6110_n ) capacitor c=0.0204198f \
 //x=50.33 //y=5.38 //x2=53.275 //y2=4.64
cc_3805 ( N_noxref_12_c_4922_p N_CLK_c_6110_n ) capacitor c=0.00405241f \
 //x=52.66 //y=4.88 //x2=53.275 //y2=4.64
cc_3806 ( N_noxref_12_c_4896_n N_CLK_c_6110_n ) capacitor c=0.0272672f \
 //x=52.662 //y=4.74 //x2=53.275 //y2=4.64
cc_3807 ( N_noxref_12_c_4897_n N_CLK_c_6110_n ) capacitor c=0.0020739f \
 //x=47.095 //y=3.51 //x2=53.275 //y2=4.64
cc_3808 ( N_noxref_12_c_4941_p N_CLK_c_6132_n ) capacitor c=5.39999e-19 \
 //x=46.74 //y=2.375 //x2=45.63 //y2=2.26
cc_3809 ( N_noxref_12_c_4856_n N_CLK_c_6132_n ) capacitor c=3.9149e-19 \
 //x=46.74 //y=3.35 //x2=45.63 //y2=2.26
cc_3810 ( N_noxref_12_c_4940_p N_CLK_c_6132_n ) capacitor c=0.00125213f \
 //x=46.74 //y=2.26 //x2=45.63 //y2=2.26
cc_3811 ( N_noxref_12_c_4943_p N_CLK_c_6132_n ) capacitor c=0.00204868f \
 //x=46.74 //y=2.26 //x2=45.63 //y2=2.26
cc_3812 ( N_noxref_12_c_4937_p N_CLK_c_6136_n ) capacitor c=2.50728e-19 \
 //x=46.74 //y=4.75 //x2=45.63 //y2=4.88
cc_3813 ( N_noxref_12_c_4945_p N_CLK_c_6136_n ) capacitor c=0.00114249f \
 //x=46.74 //y=4.88 //x2=45.63 //y2=4.88
cc_3814 ( N_noxref_12_c_4946_p N_CLK_c_6136_n ) capacitor c=0.00195911f \
 //x=46.74 //y=4.88 //x2=45.63 //y2=4.88
cc_3815 ( N_noxref_12_M102_noxref_g N_CLK_M100_noxref_g ) capacitor \
 c=0.0101598f //x=46.48 //y=6.2 //x2=45.6 //y2=6.2
cc_3816 ( N_noxref_12_M102_noxref_g N_CLK_M101_noxref_g ) capacitor \
 c=0.0607232f //x=46.48 //y=6.2 //x2=46.04 //y2=6.2
cc_3817 ( N_noxref_12_M103_noxref_g N_CLK_M101_noxref_g ) capacitor \
 c=0.0101598f //x=46.92 //y=6.2 //x2=46.04 //y2=6.2
cc_3818 ( N_noxref_12_c_4965_p N_CLK_c_6142_n ) capacitor c=0.00456962f \
 //x=46.73 //y=1.095 //x2=45.72 //y2=1.09
cc_3819 ( N_noxref_12_c_4966_p N_CLK_c_6143_n ) capacitor c=0.00438372f \
 //x=46.73 //y=1.44 //x2=45.72 //y2=1.4
cc_3820 ( N_noxref_12_c_4967_p N_CLK_c_6144_n ) capacitor c=0.00438372f \
 //x=46.73 //y=1.75 //x2=45.72 //y2=1.63
cc_3821 ( N_noxref_12_c_4941_p N_CLK_c_6145_n ) capacitor c=0.00137098f \
 //x=46.74 //y=2.375 //x2=45.72 //y2=2.095
cc_3822 ( N_noxref_12_c_4940_p N_CLK_c_6145_n ) capacitor c=0.00209664f \
 //x=46.74 //y=2.26 //x2=45.72 //y2=2.095
cc_3823 ( N_noxref_12_c_4943_p N_CLK_c_6145_n ) capacitor c=0.00933826f \
 //x=46.74 //y=2.26 //x2=45.72 //y2=2.095
cc_3824 ( N_noxref_12_c_4971_p N_CLK_c_6145_n ) capacitor c=0.00438372f \
 //x=46.74 //y=2.095 //x2=45.72 //y2=2.095
cc_3825 ( N_noxref_12_c_4946_p N_CLK_c_6149_n ) capacitor c=0.0616491f \
 //x=46.74 //y=4.88 //x2=45.965 //y2=4.97
cc_3826 ( N_noxref_12_c_4945_p N_CLK_c_6150_n ) capacitor c=9.8646e-19 \
 //x=46.74 //y=4.88 //x2=45.63 //y2=4.88
cc_3827 ( N_noxref_12_c_4946_p N_CLK_c_6150_n ) capacitor c=0.00428612f \
 //x=46.74 //y=4.88 //x2=45.63 //y2=4.88
cc_3828 ( N_noxref_12_M102_noxref_g N_noxref_15_c_6630_n ) capacitor \
 c=0.00955829f //x=46.48 //y=6.2 //x2=46.585 //y2=5.335
cc_3829 ( N_noxref_12_c_4950_p N_noxref_15_c_6631_n ) capacitor c=5.58535e-19 \
 //x=49.45 //y=5.56 //x2=46.7 //y2=5.56
cc_3830 ( N_noxref_12_M102_noxref_g N_noxref_15_c_6631_n ) capacitor \
 c=0.00226521f //x=46.48 //y=6.2 //x2=46.7 //y2=5.56
cc_3831 ( N_noxref_12_M103_noxref_g N_noxref_15_c_6631_n ) capacitor \
 c=0.00368945f //x=46.92 //y=6.2 //x2=46.7 //y2=5.56
cc_3832 ( N_noxref_12_c_4936_p N_noxref_15_c_6634_n ) capacitor c=0.00109953f \
 //x=46.74 //y=3.67 //x2=47.395 //y2=5.335
cc_3833 ( N_noxref_12_c_4937_p N_noxref_15_c_6634_n ) capacitor c=0.00228791f \
 //x=46.74 //y=4.75 //x2=47.395 //y2=5.335
cc_3834 ( N_noxref_12_c_4950_p N_noxref_15_c_6634_n ) capacitor c=0.00104762f \
 //x=49.45 //y=5.56 //x2=47.395 //y2=5.335
cc_3835 ( N_noxref_12_c_4945_p N_noxref_15_c_6634_n ) capacitor c=0.00130631f \
 //x=46.74 //y=4.88 //x2=47.395 //y2=5.335
cc_3836 ( N_noxref_12_M103_noxref_g N_noxref_15_c_6634_n ) capacitor \
 c=0.0110523f //x=46.92 //y=6.2 //x2=47.395 //y2=5.335
cc_3837 ( N_noxref_12_c_4936_p N_noxref_15_c_6639_n ) capacitor c=2.32545e-19 \
 //x=46.74 //y=3.67 //x2=46.995 //y2=1.305
cc_3838 ( N_noxref_12_c_4889_n N_noxref_15_c_6639_n ) capacitor c=6.5615e-19 \
 //x=50.37 //y=1.18 //x2=46.995 //y2=1.305
cc_3839 ( N_noxref_12_c_4965_p N_noxref_15_c_6639_n ) capacitor c=4.64015e-19 \
 //x=46.73 //y=1.095 //x2=46.995 //y2=1.305
cc_3840 ( N_noxref_12_c_4966_p N_noxref_15_c_6639_n ) capacitor c=0.0026012f \
 //x=46.73 //y=1.44 //x2=46.995 //y2=1.305
cc_3841 ( N_noxref_12_c_4988_p N_noxref_15_c_6639_n ) capacitor c=5.29969e-19 \
 //x=47.105 //y=0.94 //x2=46.995 //y2=1.305
cc_3842 ( N_noxref_12_c_4989_p N_noxref_15_c_6639_n ) capacitor c=5.00648e-19 \
 //x=47.105 //y=1.595 //x2=46.995 //y2=1.305
cc_3843 ( N_noxref_12_c_4990_p N_noxref_15_c_6639_n ) capacitor c=5.28622e-19 \
 //x=47.26 //y=1.095 //x2=46.995 //y2=1.305
cc_3844 ( N_noxref_12_c_4991_p N_noxref_15_c_6639_n ) capacitor c=0.00312156f \
 //x=47.26 //y=1.44 //x2=46.995 //y2=1.305
cc_3845 ( N_noxref_12_c_4862_n N_noxref_15_c_6647_n ) capacitor c=0.00326079f \
 //x=50.37 //y=1.75 //x2=46.995 //y2=1.76
cc_3846 ( N_noxref_12_c_4966_p N_noxref_15_c_6647_n ) capacitor c=0.00127432f \
 //x=46.73 //y=1.44 //x2=46.995 //y2=1.76
cc_3847 ( N_noxref_12_c_4967_p N_noxref_15_c_6647_n ) capacitor c=0.00429966f \
 //x=46.73 //y=1.75 //x2=46.995 //y2=1.76
cc_3848 ( N_noxref_12_c_4989_p N_noxref_15_c_6647_n ) capacitor c=0.00930387f \
 //x=47.105 //y=1.595 //x2=46.995 //y2=1.76
cc_3849 ( N_noxref_12_c_4991_p N_noxref_15_c_6647_n ) capacitor c=0.00347599f \
 //x=47.26 //y=1.44 //x2=46.995 //y2=1.76
cc_3850 ( N_noxref_12_c_4971_p N_noxref_15_c_6647_n ) capacitor c=0.00362297f \
 //x=46.74 //y=2.095 //x2=46.995 //y2=1.76
cc_3851 ( N_noxref_12_c_4998_p N_noxref_15_c_6653_n ) capacitor c=0.00218808f \
 //x=50.455 //y=1.835 //x2=47.395 //y2=1.845
cc_3852 ( N_noxref_12_c_4870_n N_noxref_15_c_6653_n ) capacitor c=0.00203605f \
 //x=50.81 //y=3.35 //x2=47.395 //y2=1.845
cc_3853 ( N_noxref_12_c_4989_p N_noxref_15_c_6653_n ) capacitor c=0.00194716f \
 //x=47.105 //y=1.595 //x2=47.395 //y2=1.845
cc_3854 ( N_noxref_12_c_4991_p N_noxref_15_c_6653_n ) capacitor c=0.00323576f \
 //x=47.26 //y=1.44 //x2=47.395 //y2=1.845
cc_3855 ( N_noxref_12_c_4936_p N_noxref_15_c_6657_n ) capacitor c=0.00103023f \
 //x=46.74 //y=3.67 //x2=47.08 //y2=1.845
cc_3856 ( N_noxref_12_c_4941_p N_noxref_15_c_6583_n ) capacitor c=0.0140058f \
 //x=46.74 //y=2.375 //x2=47.48 //y2=3.72
cc_3857 ( N_noxref_12_c_4856_n N_noxref_15_c_6583_n ) capacitor c=0.0376049f \
 //x=46.74 //y=3.35 //x2=47.48 //y2=3.72
cc_3858 ( N_noxref_12_c_4936_p N_noxref_15_c_6583_n ) capacitor c=0.017329f \
 //x=46.74 //y=3.67 //x2=47.48 //y2=3.72
cc_3859 ( N_noxref_12_c_4937_p N_noxref_15_c_6583_n ) capacitor c=0.00225898f \
 //x=46.74 //y=4.75 //x2=47.48 //y2=3.72
cc_3860 ( N_noxref_12_c_4938_p N_noxref_15_c_6583_n ) capacitor c=6.78671e-19 \
 //x=46.74 //y=3.51 //x2=47.48 //y2=3.72
cc_3861 ( N_noxref_12_c_4897_n N_noxref_15_c_6583_n ) capacitor c=2.75635e-19 \
 //x=47.095 //y=3.51 //x2=47.48 //y2=3.72
cc_3862 ( N_noxref_12_c_4939_p N_noxref_15_c_6583_n ) capacitor c=0.00308371f \
 //x=46.905 //y=3.51 //x2=47.48 //y2=3.72
cc_3863 ( N_noxref_12_c_4898_n N_noxref_15_c_6583_n ) capacitor c=0.0216394f \
 //x=47.695 //y=3.495 //x2=47.48 //y2=3.72
cc_3864 ( N_noxref_12_c_4940_p N_noxref_15_c_6583_n ) capacitor c=0.0015536f \
 //x=46.74 //y=2.26 //x2=47.48 //y2=3.72
cc_3865 ( N_noxref_12_c_4943_p N_noxref_15_c_6583_n ) capacitor c=0.0024584f \
 //x=46.74 //y=2.26 //x2=47.48 //y2=3.72
cc_3866 ( N_noxref_12_c_4971_p N_noxref_15_c_6583_n ) capacitor c=0.00282067f \
 //x=46.74 //y=2.095 //x2=47.48 //y2=3.72
cc_3867 ( N_noxref_12_c_4937_p N_noxref_15_c_6669_n ) capacitor c=0.0148501f \
 //x=46.74 //y=4.75 //x2=47.48 //y2=4.04
cc_3868 ( N_noxref_12_c_4898_n N_noxref_15_c_6669_n ) capacitor c=0.00899533f \
 //x=47.695 //y=3.495 //x2=47.48 //y2=4.04
cc_3869 ( N_noxref_12_c_4937_p N_noxref_15_c_6586_n ) capacitor c=0.0416218f \
 //x=46.74 //y=4.75 //x2=47.48 //y2=5.25
cc_3870 ( N_noxref_12_c_4880_n N_noxref_15_c_6586_n ) capacitor c=0.00283621f \
 //x=50.81 //y=5.295 //x2=47.48 //y2=5.25
cc_3871 ( N_noxref_12_c_4945_p N_noxref_15_c_6586_n ) capacitor c=0.00131258f \
 //x=46.74 //y=4.88 //x2=47.48 //y2=5.25
cc_3872 ( N_noxref_12_c_4946_p N_noxref_15_c_6586_n ) capacitor c=0.00737085f \
 //x=46.74 //y=4.88 //x2=47.48 //y2=5.25
cc_3873 ( N_noxref_12_c_4856_n N_noxref_15_c_6587_n ) capacitor c=0.00122774f \
 //x=46.74 //y=3.35 //x2=49.33 //y2=3.72
cc_3874 ( N_noxref_12_c_4870_n N_noxref_15_c_6587_n ) capacitor c=0.00222582f \
 //x=50.81 //y=3.35 //x2=49.33 //y2=3.72
cc_3875 ( N_noxref_12_c_4899_n N_noxref_15_c_6587_n ) capacitor c=4.98743e-19 \
 //x=48.94 //y=3.51 //x2=49.33 //y2=3.72
cc_3876 ( N_noxref_12_c_5023_p N_noxref_15_c_6587_n ) capacitor c=0.0221518f \
 //x=49.54 //y=3.495 //x2=49.33 //y2=3.72
cc_3877 ( N_noxref_12_c_4900_n N_noxref_15_c_6587_n ) capacitor c=3.14213e-19 \
 //x=50.965 //y=3.51 //x2=49.33 //y2=3.72
cc_3878 ( N_noxref_12_c_4950_p N_noxref_15_c_6594_n ) capacitor c=7.23153e-19 \
 //x=49.45 //y=5.56 //x2=49.33 //y2=4.04
cc_3879 ( N_noxref_12_c_4899_n N_noxref_15_c_6594_n ) capacitor c=0.00229532f \
 //x=48.94 //y=3.51 //x2=49.33 //y2=4.04
cc_3880 ( N_noxref_12_c_5023_p N_noxref_15_c_6594_n ) capacitor c=0.00505309f \
 //x=49.54 //y=3.495 //x2=49.33 //y2=4.04
cc_3881 ( N_noxref_12_c_5028_p N_noxref_15_c_6594_n ) capacitor c=2.08455e-19 \
 //x=49.45 //y=5.56 //x2=49.33 //y2=4.04
cc_3882 ( N_noxref_12_c_4936_p N_noxref_15_c_6684_n ) capacitor c=6.86112e-19 \
 //x=46.74 //y=3.67 //x2=46.7 //y2=5.335
cc_3883 ( N_noxref_12_c_4937_p N_noxref_15_c_6684_n ) capacitor c=0.0228808f \
 //x=46.74 //y=4.75 //x2=46.7 //y2=5.335
cc_3884 ( N_noxref_12_c_4945_p N_noxref_15_c_6684_n ) capacitor c=0.00346456f \
 //x=46.74 //y=4.88 //x2=46.7 //y2=5.335
cc_3885 ( N_noxref_12_c_4946_p N_noxref_15_c_6684_n ) capacitor c=0.00203307f \
 //x=46.74 //y=4.88 //x2=46.7 //y2=5.335
cc_3886 ( N_noxref_12_c_4937_p N_noxref_15_c_6688_n ) capacitor c=6.03895e-19 \
 //x=46.74 //y=4.75 //x2=47.48 //y2=3.88
cc_3887 ( N_noxref_12_c_4950_p N_noxref_15_c_6599_n ) capacitor c=0.0117744f \
 //x=49.45 //y=5.56 //x2=49.33 //y2=4.88
cc_3888 ( N_noxref_12_c_5028_p N_noxref_15_c_6599_n ) capacitor c=0.00104426f \
 //x=49.45 //y=5.56 //x2=49.33 //y2=4.88
cc_3889 ( N_noxref_12_c_4937_p N_noxref_15_c_6602_n ) capacitor c=8.55722e-19 \
 //x=46.74 //y=4.75 //x2=49.332 //y2=4.74
cc_3890 ( N_noxref_12_c_4880_n N_noxref_15_c_6602_n ) capacitor c=0.00133619f \
 //x=50.81 //y=5.295 //x2=49.332 //y2=4.74
cc_3891 ( N_noxref_12_c_4898_n N_noxref_15_c_6693_n ) capacitor c=0.127135f \
 //x=47.695 //y=3.495 //x2=49.165 //y2=3.88
cc_3892 ( N_noxref_12_c_4899_n N_noxref_15_c_6693_n ) capacitor c=0.0107721f \
 //x=48.94 //y=3.51 //x2=49.165 //y2=3.88
cc_3893 ( N_noxref_12_c_4937_p N_noxref_15_c_6695_n ) capacitor c=0.00686853f \
 //x=46.74 //y=4.75 //x2=47.64 //y2=3.88
cc_3894 ( N_noxref_12_c_4898_n N_noxref_15_c_6695_n ) capacitor c=0.0358686f \
 //x=47.695 //y=3.495 //x2=47.64 //y2=3.88
cc_3895 ( N_noxref_12_c_4879_n N_noxref_15_c_6697_n ) capacitor c=0.0033292f \
 //x=50.81 //y=3.67 //x2=51.02 //y2=3.895
cc_3896 ( N_noxref_12_c_4880_n N_noxref_15_c_6697_n ) capacitor c=0.0226441f \
 //x=50.81 //y=5.295 //x2=51.02 //y2=3.895
cc_3897 ( N_noxref_12_c_5044_p N_noxref_15_c_6697_n ) capacitor c=0.129077f \
 //x=52.495 //y=3.505 //x2=51.02 //y2=3.895
cc_3898 ( N_noxref_12_c_4879_n N_noxref_15_c_6603_n ) capacitor c=0.00307263f \
 //x=50.81 //y=3.67 //x2=50.675 //y2=3.895
cc_3899 ( N_noxref_12_c_4880_n N_noxref_15_c_6603_n ) capacitor c=3.08624e-19 \
 //x=50.81 //y=5.295 //x2=50.675 //y2=3.895
cc_3900 ( N_noxref_12_c_5023_p N_noxref_15_c_6603_n ) capacitor c=0.0475486f \
 //x=49.54 //y=3.495 //x2=50.675 //y2=3.895
cc_3901 ( N_noxref_12_c_4900_n N_noxref_15_c_6603_n ) capacitor c=0.120968f \
 //x=50.965 //y=3.51 //x2=50.675 //y2=3.895
cc_3902 ( N_noxref_12_c_4919_p N_noxref_15_c_6704_n ) capacitor c=0.00342917f \
 //x=52.66 //y=3.665 //x2=52.27 //y2=3.88
cc_3903 ( N_noxref_12_c_4896_n N_noxref_15_c_6704_n ) capacitor c=3.32529e-19 \
 //x=52.662 //y=4.74 //x2=52.27 //y2=3.88
cc_3904 ( N_noxref_12_c_4929_p N_noxref_15_c_6704_n ) capacitor c=0.0358254f \
 //x=52.655 //y=3.505 //x2=52.27 //y2=3.88
cc_3905 ( N_noxref_12_c_5044_p N_noxref_15_c_6704_n ) capacitor c=0.0109335f \
 //x=52.495 //y=3.505 //x2=52.27 //y2=3.88
cc_3906 ( N_noxref_12_c_4919_p N_noxref_15_c_6708_n ) capacitor c=0.00251313f \
 //x=52.66 //y=3.665 //x2=52.87 //y2=3.89
cc_3907 ( N_noxref_12_c_4896_n N_noxref_15_c_6708_n ) capacitor c=0.0228906f \
 //x=52.662 //y=4.74 //x2=52.87 //y2=3.89
cc_3908 ( N_noxref_12_c_4937_p N_noxref_15_c_6710_n ) capacitor c=0.00217653f \
 //x=46.74 //y=4.75 //x2=46.7 //y2=5.56
cc_3909 ( N_noxref_12_c_4945_p N_noxref_15_c_6710_n ) capacitor c=0.00624059f \
 //x=46.74 //y=4.88 //x2=46.7 //y2=5.56
cc_3910 ( N_noxref_12_M102_noxref_g N_noxref_15_c_6710_n ) capacitor \
 c=0.0178885f //x=46.48 //y=6.2 //x2=46.7 //y2=5.56
cc_3911 ( N_noxref_12_M103_noxref_g N_noxref_15_c_6710_n ) capacitor \
 c=0.0188608f //x=46.92 //y=6.2 //x2=46.7 //y2=5.56
cc_3912 ( N_noxref_12_c_4946_p N_noxref_15_c_6710_n ) capacitor c=0.00375636f \
 //x=46.74 //y=4.88 //x2=46.7 //y2=5.56
cc_3913 ( N_noxref_12_c_4950_p N_noxref_15_c_6608_n ) capacitor c=0.00277154f \
 //x=49.45 //y=5.56 //x2=49.33 //y2=4.88
cc_3914 ( N_noxref_12_c_5028_p N_noxref_15_c_6608_n ) capacitor c=0.00377369f \
 //x=49.45 //y=5.56 //x2=49.33 //y2=4.88
cc_3915 ( N_noxref_12_c_4950_p N_noxref_15_M104_noxref_g ) capacitor \
 c=0.00201806f //x=49.45 //y=5.56 //x2=49.23 //y2=6.2
cc_3916 ( N_noxref_12_c_5028_p N_noxref_15_M104_noxref_g ) capacitor \
 c=0.0158358f //x=49.45 //y=5.56 //x2=49.23 //y2=6.2
cc_3917 ( N_noxref_12_c_4857_n N_noxref_15_M105_noxref_g ) capacitor \
 c=0.00889217f //x=50.215 //y=5.38 //x2=49.67 //y2=6.2
cc_3918 ( N_noxref_12_c_4950_p N_noxref_15_M105_noxref_g ) capacitor \
 c=0.00192712f //x=49.45 //y=5.56 //x2=49.67 //y2=6.2
cc_3919 ( N_noxref_12_c_5028_p N_noxref_15_M105_noxref_g ) capacitor \
 c=0.0178987f //x=49.45 //y=5.56 //x2=49.67 //y2=6.2
cc_3920 ( N_noxref_12_c_4950_p N_noxref_15_c_6627_n ) capacitor c=0.00189999f \
 //x=49.45 //y=5.56 //x2=49.33 //y2=4.88
cc_3921 ( N_noxref_12_c_5028_p N_noxref_15_c_6627_n ) capacitor c=0.0043218f \
 //x=49.45 //y=5.56 //x2=49.33 //y2=4.88
cc_3922 ( N_noxref_12_c_4965_p N_noxref_15_M28_noxref_d ) capacitor \
 c=0.00137165f //x=46.73 //y=1.095 //x2=46.805 //y2=1.095
cc_3923 ( N_noxref_12_c_4966_p N_noxref_15_M28_noxref_d ) capacitor \
 c=0.00237422f //x=46.73 //y=1.44 //x2=46.805 //y2=1.095
cc_3924 ( N_noxref_12_c_4988_p N_noxref_15_M28_noxref_d ) capacitor \
 c=0.0020782f //x=47.105 //y=0.94 //x2=46.805 //y2=1.095
cc_3925 ( N_noxref_12_c_4989_p N_noxref_15_M28_noxref_d ) capacitor \
 c=0.00356097f //x=47.105 //y=1.595 //x2=46.805 //y2=1.095
cc_3926 ( N_noxref_12_c_4990_p N_noxref_15_M28_noxref_d ) capacitor \
 c=0.00139206f //x=47.26 //y=1.095 //x2=46.805 //y2=1.095
cc_3927 ( N_noxref_12_c_4991_p N_noxref_15_M28_noxref_d ) capacitor \
 c=0.00237422f //x=47.26 //y=1.44 //x2=46.805 //y2=1.095
cc_3928 ( N_noxref_12_c_4856_n N_noxref_17_c_7358_n ) capacitor c=8.1134e-19 \
 //x=46.74 //y=3.35 //x2=44.52 //y2=4.095
cc_3929 ( N_noxref_12_c_4937_p N_noxref_17_c_7358_n ) capacitor c=7.99748e-19 \
 //x=46.74 //y=4.75 //x2=44.52 //y2=4.095
cc_3930 ( N_noxref_12_c_4937_p N_noxref_17_c_7359_n ) capacitor c=2.98698e-19 \
 //x=46.74 //y=4.75 //x2=44.52 //y2=4.755
cc_3931 ( N_noxref_12_c_4870_n N_noxref_17_c_7368_n ) capacitor c=0.00183193f \
 //x=50.81 //y=3.35 //x2=53.4 //y2=4.095
cc_3932 ( N_noxref_12_c_4880_n N_noxref_17_c_7368_n ) capacitor c=3.20827e-19 \
 //x=50.81 //y=5.295 //x2=53.4 //y2=4.095
cc_3933 ( N_noxref_12_c_4884_n N_noxref_17_c_7368_n ) capacitor c=0.0381246f \
 //x=52.66 //y=3.345 //x2=53.4 //y2=4.095
cc_3934 ( N_noxref_12_c_4919_p N_noxref_17_c_7368_n ) capacitor c=0.0146933f \
 //x=52.66 //y=3.665 //x2=53.4 //y2=4.095
cc_3935 ( N_noxref_12_c_4928_p N_noxref_17_c_7368_n ) capacitor c=5.57251e-19 \
 //x=52.66 //y=3.51 //x2=53.4 //y2=4.095
cc_3936 ( N_noxref_12_c_4896_n N_noxref_17_c_7368_n ) capacitor c=0.0171876f \
 //x=52.662 //y=4.74 //x2=53.4 //y2=4.095
cc_3937 ( N_noxref_12_c_4929_p N_noxref_17_c_7368_n ) capacitor c=0.00364775f \
 //x=52.655 //y=3.505 //x2=53.4 //y2=4.095
cc_3938 ( N_noxref_12_c_5085_p N_noxref_17_c_7368_n ) capacitor c=3.30333e-19 \
 //x=52.66 //y=2.26 //x2=53.4 //y2=4.095
cc_3939 ( N_noxref_12_c_4896_n N_noxref_17_c_7376_n ) capacitor c=0.0172847f \
 //x=52.662 //y=4.74 //x2=53.4 //y2=4.415
cc_3940 ( N_noxref_12_c_4880_n N_noxref_17_c_7377_n ) capacitor c=7.6298e-19 \
 //x=50.81 //y=5.295 //x2=53.4 //y2=4.735
cc_3941 ( N_noxref_12_c_4922_p N_noxref_17_c_7377_n ) capacitor c=0.0172958f \
 //x=52.66 //y=4.88 //x2=53.4 //y2=4.735
cc_3942 ( N_noxref_12_c_4896_n N_noxref_17_c_7377_n ) capacitor c=0.0114865f \
 //x=52.662 //y=4.74 //x2=53.4 //y2=4.735
cc_3943 ( N_noxref_12_c_4923_p N_noxref_17_c_7377_n ) capacitor c=7.25895e-19 \
 //x=52.66 //y=4.88 //x2=53.4 //y2=4.735
cc_3944 ( N_noxref_12_c_4926_p N_noxref_17_c_7377_n ) capacitor c=0.00200292f \
 //x=52.66 //y=4.88 //x2=53.4 //y2=4.735
cc_3945 ( N_noxref_12_c_4896_n N_noxref_17_c_7382_n ) capacitor c=6.89957e-19 \
 //x=52.662 //y=4.74 //x2=53.4 //y2=4.25
cc_3946 ( N_noxref_12_c_5093_p N_noxref_17_c_7383_n ) capacitor c=0.0179797f \
 //x=52.66 //y=2.26 //x2=53.4 //y2=2.26
cc_3947 ( N_noxref_12_c_5085_p N_noxref_17_c_7383_n ) capacitor c=5.16867e-19 \
 //x=52.66 //y=2.26 //x2=53.4 //y2=2.26
cc_3948 ( N_noxref_12_c_5095_p N_noxref_17_c_7383_n ) capacitor c=0.00161745f \
 //x=52.465 //y=2.095 //x2=53.4 //y2=2.26
cc_3949 ( N_noxref_12_c_4936_p N_noxref_17_c_7363_n ) capacitor c=0.0031669f \
 //x=46.74 //y=3.67 //x2=47.095 //y2=4.25
cc_3950 ( N_noxref_12_c_4937_p N_noxref_17_c_7363_n ) capacitor c=0.0245794f \
 //x=46.74 //y=4.75 //x2=47.095 //y2=4.25
cc_3951 ( N_noxref_12_c_4897_n N_noxref_17_c_7363_n ) capacitor c=0.0152263f \
 //x=47.095 //y=3.51 //x2=47.095 //y2=4.25
cc_3952 ( N_noxref_12_c_4939_p N_noxref_17_c_7363_n ) capacitor c=0.0156825f \
 //x=46.905 //y=3.51 //x2=47.095 //y2=4.25
cc_3953 ( N_noxref_12_c_4898_n N_noxref_17_c_7390_n ) capacitor c=0.0085696f \
 //x=47.695 //y=3.495 //x2=47.695 //y2=4.265
cc_3954 ( N_noxref_12_c_4899_n N_noxref_17_c_7391_n ) capacitor c=0.00581051f \
 //x=48.94 //y=3.51 //x2=48.94 //y2=4.25
cc_3955 ( N_noxref_12_c_5023_p N_noxref_17_c_7392_n ) capacitor c=0.00139876f \
 //x=49.54 //y=3.495 //x2=49.54 //y2=4.265
cc_3956 ( N_noxref_12_c_4880_n N_noxref_17_c_7364_n ) capacitor c=0.0232181f \
 //x=50.81 //y=5.295 //x2=53.565 //y2=4.25
cc_3957 ( N_noxref_12_c_4896_n N_noxref_17_c_7364_n ) capacitor c=0.0254145f \
 //x=52.662 //y=4.74 //x2=53.565 //y2=4.25
cc_3958 ( N_noxref_12_c_4900_n N_noxref_17_c_7364_n ) capacitor c=0.00951545f \
 //x=50.965 //y=3.51 //x2=53.565 //y2=4.25
cc_3959 ( N_noxref_12_c_5044_p N_noxref_17_c_7364_n ) capacitor c=0.0104609f \
 //x=52.495 //y=3.505 //x2=53.565 //y2=4.25
cc_3960 ( N_noxref_12_c_4884_n N_noxref_17_c_7397_n ) capacitor c=3.30333e-19 \
 //x=52.66 //y=3.345 //x2=53.4 //y2=2.26
cc_3961 ( N_noxref_12_c_5093_p N_noxref_17_c_7397_n ) capacitor c=5.24723e-19 \
 //x=52.66 //y=2.26 //x2=53.4 //y2=2.26
cc_3962 ( N_noxref_12_c_5085_p N_noxref_17_c_7397_n ) capacitor c=0.00525888f \
 //x=52.66 //y=2.26 //x2=53.4 //y2=2.26
cc_3963 ( N_noxref_12_c_5095_p N_noxref_17_c_7397_n ) capacitor c=0.00190888f \
 //x=52.465 //y=2.095 //x2=53.4 //y2=2.26
cc_3964 ( N_noxref_12_c_4922_p N_noxref_17_c_7401_n ) capacitor c=4.80626e-19 \
 //x=52.66 //y=4.88 //x2=53.43 //y2=4.88
cc_3965 ( N_noxref_12_c_4923_p N_noxref_17_c_7401_n ) capacitor c=0.00397338f \
 //x=52.66 //y=4.88 //x2=53.43 //y2=4.88
cc_3966 ( N_noxref_12_c_4926_p N_noxref_17_c_7401_n ) capacitor c=0.00283894f \
 //x=52.66 //y=4.88 //x2=53.43 //y2=4.88
cc_3967 ( N_noxref_12_M108_noxref_g N_noxref_17_M110_noxref_g ) capacitor \
 c=0.0104892f //x=52.56 //y=6.2 //x2=53.44 //y2=6.2
cc_3968 ( N_noxref_12_M109_noxref_g N_noxref_17_M110_noxref_g ) capacitor \
 c=0.107636f //x=53 //y=6.2 //x2=53.44 //y2=6.2
cc_3969 ( N_noxref_12_M109_noxref_g N_noxref_17_M111_noxref_g ) capacitor \
 c=0.0100341f //x=53 //y=6.2 //x2=53.88 //y2=6.2
cc_3970 ( N_noxref_12_c_5117_p N_noxref_17_c_7407_n ) capacitor c=4.86545e-19 \
 //x=52.465 //y=1.045 //x2=53.435 //y2=1.085
cc_3971 ( N_noxref_12_c_5118_p N_noxref_17_c_7407_n ) capacitor c=0.00152405f \
 //x=52.465 //y=1.39 //x2=53.435 //y2=1.085
cc_3972 ( N_noxref_12_c_5119_p N_noxref_17_c_7407_n ) capacitor c=0.0151475f \
 //x=52.995 //y=1.045 //x2=53.435 //y2=1.085
cc_3973 ( N_noxref_12_c_5120_p N_noxref_17_c_7410_n ) capacitor c=0.00109982f \
 //x=52.465 //y=1.7 //x2=53.435 //y2=1.43
cc_3974 ( N_noxref_12_c_5121_p N_noxref_17_c_7410_n ) capacitor c=0.0111064f \
 //x=52.995 //y=1.39 //x2=53.435 //y2=1.43
cc_3975 ( N_noxref_12_c_5120_p N_noxref_17_c_7412_n ) capacitor c=9.58243e-19 \
 //x=52.465 //y=1.7 //x2=53.435 //y2=1.74
cc_3976 ( N_noxref_12_c_5095_p N_noxref_17_c_7412_n ) capacitor c=0.00662747f \
 //x=52.465 //y=2.095 //x2=53.435 //y2=1.74
cc_3977 ( N_noxref_12_c_5121_p N_noxref_17_c_7412_n ) capacitor c=0.00862358f \
 //x=52.995 //y=1.39 //x2=53.435 //y2=1.74
cc_3978 ( N_noxref_12_c_5119_p N_noxref_17_c_7415_n ) capacitor c=0.00127211f \
 //x=52.995 //y=1.045 //x2=53.965 //y2=1.085
cc_3979 ( N_noxref_12_c_5121_p N_noxref_17_c_7416_n ) capacitor c=0.00204774f \
 //x=52.995 //y=1.39 //x2=53.965 //y2=1.43
cc_3980 ( N_noxref_12_c_5093_p N_noxref_17_c_7417_n ) capacitor c=0.00161167f \
 //x=52.66 //y=2.26 //x2=53.4 //y2=2.26
cc_3981 ( N_noxref_12_c_5085_p N_noxref_17_c_7417_n ) capacitor c=0.0018937f \
 //x=52.66 //y=2.26 //x2=53.4 //y2=2.26
cc_3982 ( N_noxref_12_c_5095_p N_noxref_17_c_7417_n ) capacitor c=0.0181449f \
 //x=52.465 //y=2.095 //x2=53.4 //y2=2.26
cc_3983 ( N_noxref_12_c_4922_p N_noxref_17_c_7420_n ) capacitor c=0.00158715f \
 //x=52.66 //y=4.88 //x2=53.43 //y2=4.88
cc_3984 ( N_noxref_12_c_4923_p N_noxref_17_c_7420_n ) capacitor c=0.00237977f \
 //x=52.66 //y=4.88 //x2=53.43 //y2=4.88
cc_3985 ( N_noxref_12_c_4926_p N_noxref_17_c_7420_n ) capacitor c=0.0297875f \
 //x=52.66 //y=4.88 //x2=53.43 //y2=4.88
cc_3986 ( N_noxref_12_c_4941_p N_noxref_19_c_8591_n ) capacitor c=0.0157528f \
 //x=46.74 //y=2.375 //x2=49.685 //y2=2.4
cc_3987 ( N_noxref_12_c_4856_n N_noxref_19_c_8591_n ) capacitor c=0.0129611f \
 //x=46.74 //y=3.35 //x2=49.685 //y2=2.4
cc_3988 ( N_noxref_12_c_4940_p N_noxref_19_c_8591_n ) capacitor c=2.63835e-19 \
 //x=46.74 //y=2.26 //x2=49.685 //y2=2.4
cc_3989 ( N_noxref_12_c_4943_p N_noxref_19_c_8591_n ) capacitor c=3.41298e-19 \
 //x=46.74 //y=2.26 //x2=49.685 //y2=2.4
cc_3990 ( N_noxref_12_c_4998_p N_noxref_19_c_8645_n ) capacitor c=0.0190593f \
 //x=50.455 //y=1.835 //x2=50.285 //y2=2.37
cc_3991 ( N_noxref_12_c_4870_n N_noxref_19_c_8645_n ) capacitor c=0.0313738f \
 //x=50.81 //y=3.35 //x2=50.285 //y2=2.37
cc_3992 ( N_noxref_12_c_4884_n N_noxref_19_c_8645_n ) capacitor c=0.0152186f \
 //x=52.66 //y=3.345 //x2=50.285 //y2=2.37
cc_3993 ( N_noxref_12_c_4889_n N_noxref_19_c_8645_n ) capacitor c=7.18616e-19 \
 //x=50.37 //y=1.18 //x2=50.285 //y2=2.37
cc_3994 ( N_noxref_12_c_5093_p N_noxref_19_c_8645_n ) capacitor c=0.0177648f \
 //x=52.66 //y=2.26 //x2=50.285 //y2=2.37
cc_3995 ( N_noxref_12_c_4900_n N_noxref_19_c_8645_n ) capacitor c=0.00207883f \
 //x=50.965 //y=3.51 //x2=50.285 //y2=2.37
cc_3996 ( N_noxref_12_c_5044_p N_noxref_19_c_8645_n ) capacitor c=0.00626694f \
 //x=52.495 //y=3.505 //x2=50.285 //y2=2.37
cc_3997 ( N_noxref_12_c_5085_p N_noxref_19_c_8645_n ) capacitor c=2.20453e-19 \
 //x=52.66 //y=2.26 //x2=50.285 //y2=2.37
cc_3998 ( N_noxref_12_c_5095_p N_noxref_19_c_8645_n ) capacitor c=3.61358e-19 \
 //x=52.465 //y=2.095 //x2=50.285 //y2=2.37
cc_3999 ( N_noxref_12_c_4856_n N_noxref_20_c_9365_n ) capacitor c=3.81384e-19 \
 //x=46.74 //y=3.35 //x2=46.36 //y2=3.14
cc_4000 ( N_noxref_12_c_4856_n N_noxref_20_c_9422_n ) capacitor c=0.0216209f \
 //x=46.74 //y=3.35 //x2=46.96 //y2=3.125
cc_4001 ( N_noxref_12_c_4936_p N_noxref_20_c_9422_n ) capacitor c=0.00571354f \
 //x=46.74 //y=3.67 //x2=46.96 //y2=3.125
cc_4002 ( N_noxref_12_c_4897_n N_noxref_20_c_9422_n ) capacitor c=0.0535132f \
 //x=47.095 //y=3.51 //x2=46.96 //y2=3.125
cc_4003 ( N_noxref_12_c_4939_p N_noxref_20_c_9422_n ) capacitor c=0.0358686f \
 //x=46.905 //y=3.51 //x2=46.96 //y2=3.125
cc_4004 ( N_noxref_12_c_4870_n N_noxref_20_c_9423_n ) capacitor c=3.08767e-19 \
 //x=50.81 //y=3.35 //x2=50.42 //y2=3.14
cc_4005 ( N_noxref_12_c_4879_n N_noxref_20_c_9423_n ) capacitor c=0.0015441f \
 //x=50.81 //y=3.67 //x2=50.42 //y2=3.14
cc_4006 ( N_noxref_12_c_4898_n N_noxref_20_c_9423_n ) capacitor c=0.139639f \
 //x=47.695 //y=3.495 //x2=50.42 //y2=3.14
cc_4007 ( N_noxref_12_c_4899_n N_noxref_20_c_9423_n ) capacitor c=0.0564342f \
 //x=48.94 //y=3.51 //x2=50.42 //y2=3.14
cc_4008 ( N_noxref_12_c_4900_n N_noxref_20_c_9423_n ) capacitor c=0.0872702f \
 //x=50.965 //y=3.51 //x2=50.42 //y2=3.14
cc_4009 ( N_noxref_12_c_4870_n N_noxref_20_c_9437_n ) capacitor c=0.0253697f \
 //x=50.81 //y=3.35 //x2=51.02 //y2=3.125
cc_4010 ( N_noxref_12_c_4879_n N_noxref_20_c_9437_n ) capacitor c=0.00465261f \
 //x=50.81 //y=3.67 //x2=51.02 //y2=3.125
cc_4011 ( N_noxref_12_c_4900_n N_noxref_20_c_9437_n ) capacitor c=0.0358686f \
 //x=50.965 //y=3.51 //x2=51.02 //y2=3.125
cc_4012 ( N_noxref_12_c_5044_p N_noxref_20_c_9437_n ) capacitor c=0.129061f \
 //x=52.495 //y=3.505 //x2=51.02 //y2=3.125
cc_4013 ( N_noxref_12_c_4884_n N_noxref_20_c_9441_n ) capacitor c=6.53642e-19 \
 //x=52.66 //y=3.345 //x2=52.27 //y2=3.14
cc_4014 ( N_noxref_12_c_4919_p N_noxref_20_c_9441_n ) capacitor c=0.00223215f \
 //x=52.66 //y=3.665 //x2=52.27 //y2=3.14
cc_4015 ( N_noxref_12_c_5044_p N_noxref_20_c_9441_n ) capacitor c=0.0106514f \
 //x=52.495 //y=3.505 //x2=52.27 //y2=3.14
cc_4016 ( N_noxref_12_c_4884_n N_noxref_20_c_9444_n ) capacitor c=0.0252168f \
 //x=52.66 //y=3.345 //x2=52.87 //y2=3.12
cc_4017 ( N_noxref_12_c_4919_p N_noxref_20_c_9444_n ) capacitor c=0.00491263f \
 //x=52.66 //y=3.665 //x2=52.87 //y2=3.12
cc_4018 ( N_noxref_12_c_4929_p N_noxref_20_c_9444_n ) capacitor c=0.0358686f \
 //x=52.655 //y=3.505 //x2=52.87 //y2=3.12
cc_4019 ( N_noxref_12_c_4857_n N_VDD_c_10241_n ) capacitor c=0.00648307f \
 //x=50.215 //y=5.38 //x2=65.575 //y2=7.585
cc_4020 ( N_noxref_12_c_4867_n N_VDD_c_10241_n ) capacitor c=0.00492578f \
 //x=50.725 //y=5.38 //x2=65.575 //y2=7.585
cc_4021 ( N_noxref_12_c_4919_p N_VDD_c_10241_n ) capacitor c=2.0049e-19 \
 //x=52.66 //y=3.665 //x2=65.575 //y2=7.585
cc_4022 ( N_noxref_12_c_4950_p N_VDD_c_10241_n ) capacitor c=0.00368834f \
 //x=49.45 //y=5.56 //x2=65.575 //y2=7.585
cc_4023 ( N_noxref_12_c_4886_n N_VDD_c_10241_n ) capacitor c=8.42709e-19 \
 //x=50.33 //y=5.38 //x2=65.575 //y2=7.585
cc_4024 ( N_noxref_12_c_4921_p N_VDD_c_10241_n ) capacitor c=0.00285853f \
 //x=50.33 //y=5.56 //x2=65.575 //y2=7.585
cc_4025 ( N_noxref_12_c_4922_p N_VDD_c_10241_n ) capacitor c=9.07241e-19 \
 //x=52.66 //y=4.88 //x2=65.575 //y2=7.585
cc_4026 ( N_noxref_12_c_5028_p N_VDD_c_10241_n ) capacitor c=0.00224881f \
 //x=49.45 //y=5.56 //x2=65.575 //y2=7.585
cc_4027 ( N_noxref_12_c_4902_n N_VDD_c_10241_n ) capacitor c=0.00224881f \
 //x=50.33 //y=5.56 //x2=65.575 //y2=7.585
cc_4028 ( N_noxref_12_c_4923_p N_VDD_c_10241_n ) capacitor c=6.22888e-19 \
 //x=52.66 //y=4.88 //x2=65.575 //y2=7.585
cc_4029 ( N_noxref_12_M102_noxref_g N_VDD_c_10887_n ) capacitor c=0.00755544f \
 //x=46.48 //y=6.2 //x2=47.055 //y2=7.585
cc_4030 ( N_noxref_12_M103_noxref_g N_VDD_c_10887_n ) capacitor c=0.00755754f \
 //x=46.92 //y=6.2 //x2=47.055 //y2=7.585
cc_4031 ( N_noxref_12_c_4857_n N_VDD_c_10889_n ) capacitor c=0.00208087f \
 //x=50.215 //y=5.38 //x2=49.805 //y2=7.585
cc_4032 ( N_noxref_12_c_4950_p N_VDD_c_10889_n ) capacitor c=9.41185e-19 \
 //x=49.45 //y=5.56 //x2=49.805 //y2=7.585
cc_4033 ( N_noxref_12_c_5028_p N_VDD_c_10889_n ) capacitor c=0.0136705f \
 //x=49.45 //y=5.56 //x2=49.805 //y2=7.585
cc_4034 ( N_noxref_12_c_4857_n N_VDD_c_10857_n ) capacitor c=0.00180737f \
 //x=50.215 //y=5.38 //x2=50.685 //y2=7.585
cc_4035 ( N_noxref_12_c_4867_n N_VDD_c_10857_n ) capacitor c=0.00208087f \
 //x=50.725 //y=5.38 //x2=50.685 //y2=7.585
cc_4036 ( N_noxref_12_c_4886_n N_VDD_c_10857_n ) capacitor c=4.23719e-19 \
 //x=50.33 //y=5.38 //x2=50.685 //y2=7.585
cc_4037 ( N_noxref_12_c_4921_p N_VDD_c_10857_n ) capacitor c=5.77976e-19 \
 //x=50.33 //y=5.56 //x2=50.685 //y2=7.585
cc_4038 ( N_noxref_12_c_4902_n N_VDD_c_10857_n ) capacitor c=0.0136705f \
 //x=50.33 //y=5.56 //x2=50.685 //y2=7.585
cc_4039 ( N_noxref_12_c_4922_p N_VDD_c_10897_n ) capacitor c=6.28113e-19 \
 //x=52.66 //y=4.88 //x2=53.135 //y2=7.585
cc_4040 ( N_noxref_12_M108_noxref_g N_VDD_c_10897_n ) capacitor c=0.00732618f \
 //x=52.56 //y=6.2 //x2=53.135 //y2=7.585
cc_4041 ( N_noxref_12_M109_noxref_g N_VDD_c_10897_n ) capacitor c=0.00755544f \
 //x=53 //y=6.2 //x2=53.135 //y2=7.585
cc_4042 ( N_noxref_12_c_4880_n N_VDD_c_10900_n ) capacitor c=0.0013228f \
 //x=50.81 //y=5.295 //x2=48.22 //y2=7.585
cc_4043 ( N_noxref_12_c_4950_p N_VDD_c_10900_n ) capacitor c=4.91377e-19 \
 //x=49.45 //y=5.56 //x2=48.22 //y2=7.585
cc_4044 ( N_noxref_12_c_4945_p N_VDD_c_10900_n ) capacitor c=0.00224736f \
 //x=46.74 //y=4.88 //x2=48.22 //y2=7.585
cc_4045 ( N_noxref_12_c_5028_p N_VDD_c_10900_n ) capacitor c=0.0064135f \
 //x=49.45 //y=5.56 //x2=48.22 //y2=7.585
cc_4046 ( N_noxref_12_c_4946_p N_VDD_c_10900_n ) capacitor c=2.63786e-19 \
 //x=46.74 //y=4.88 //x2=48.22 //y2=7.585
cc_4047 ( N_noxref_12_c_4880_n N_VDD_c_10865_n ) capacitor c=0.0291261f \
 //x=50.81 //y=5.295 //x2=51.55 //y2=7.585
cc_4048 ( N_noxref_12_c_4886_n N_VDD_c_10865_n ) capacitor c=0.00240948f \
 //x=50.33 //y=5.38 //x2=51.55 //y2=7.585
cc_4049 ( N_noxref_12_c_4921_p N_VDD_c_10865_n ) capacitor c=4.09141e-19 \
 //x=50.33 //y=5.56 //x2=51.55 //y2=7.585
cc_4050 ( N_noxref_12_c_4922_p N_VDD_c_10865_n ) capacitor c=0.00447349f \
 //x=52.66 //y=4.88 //x2=51.55 //y2=7.585
cc_4051 ( N_noxref_12_c_4896_n N_VDD_c_10865_n ) capacitor c=0.00564116f \
 //x=52.662 //y=4.74 //x2=51.55 //y2=7.585
cc_4052 ( N_noxref_12_c_4902_n N_VDD_c_10865_n ) capacitor c=0.0101861f \
 //x=50.33 //y=5.56 //x2=51.55 //y2=7.585
cc_4053 ( N_noxref_12_c_4923_p N_VDD_c_10865_n ) capacitor c=0.00370494f \
 //x=52.66 //y=4.88 //x2=51.55 //y2=7.585
cc_4054 ( N_noxref_12_c_4926_p N_VDD_c_10865_n ) capacitor c=0.0129564f \
 //x=52.66 //y=4.88 //x2=51.55 //y2=7.585
cc_4055 ( N_noxref_12_M102_noxref_g N_VDD_M101_noxref_d ) capacitor \
 c=0.015318f //x=46.48 //y=6.2 //x2=46.115 //y2=5.2
cc_4056 ( N_noxref_12_M103_noxref_g N_VDD_M103_noxref_d ) capacitor \
 c=0.0394719f //x=46.92 //y=6.2 //x2=46.995 //y2=5.2
cc_4057 ( N_noxref_12_c_4950_p N_VDD_M104_noxref_s ) capacitor c=0.0611368f \
 //x=49.45 //y=5.56 //x2=48.875 //y2=5.2
cc_4058 ( N_noxref_12_c_4886_n N_VDD_M104_noxref_s ) capacitor c=6.52457e-19 \
 //x=50.33 //y=5.38 //x2=48.875 //y2=5.2
cc_4059 ( N_noxref_12_c_5028_p N_VDD_M104_noxref_s ) capacitor c=0.0887533f \
 //x=49.45 //y=5.56 //x2=48.875 //y2=5.2
cc_4060 ( N_noxref_12_c_4857_n N_VDD_M105_noxref_d ) capacitor c=0.00734094f \
 //x=50.215 //y=5.38 //x2=49.745 //y2=5.2
cc_4061 ( N_noxref_12_c_4950_p N_VDD_M105_noxref_d ) capacitor c=0.0043528f \
 //x=49.45 //y=5.56 //x2=49.745 //y2=5.2
cc_4062 ( N_noxref_12_c_4921_p N_VDD_M105_noxref_d ) capacitor c=0.0043528f \
 //x=50.33 //y=5.56 //x2=49.745 //y2=5.2
cc_4063 ( N_noxref_12_c_5028_p N_VDD_M105_noxref_d ) capacitor c=0.065554f \
 //x=49.45 //y=5.56 //x2=49.745 //y2=5.2
cc_4064 ( N_noxref_12_c_4902_n N_VDD_M105_noxref_d ) capacitor c=0.065554f \
 //x=50.33 //y=5.56 //x2=49.745 //y2=5.2
cc_4065 ( N_noxref_12_c_4867_n N_VDD_M107_noxref_d ) capacitor c=0.00934027f \
 //x=50.725 //y=5.38 //x2=50.625 //y2=5.2
cc_4066 ( N_noxref_12_c_4921_p N_VDD_M107_noxref_d ) capacitor c=0.00587834f \
 //x=50.33 //y=5.56 //x2=50.625 //y2=5.2
cc_4067 ( N_noxref_12_c_4895_n N_VDD_M107_noxref_d ) capacitor c=9.65951e-19 \
 //x=50.805 //y=3.51 //x2=50.625 //y2=5.2
cc_4068 ( N_noxref_12_c_4902_n N_VDD_M107_noxref_d ) capacitor c=0.065554f \
 //x=50.33 //y=5.56 //x2=50.625 //y2=5.2
cc_4069 ( N_noxref_12_c_4867_n N_VDD_M108_noxref_s ) capacitor c=0.00326953f \
 //x=50.725 //y=5.38 //x2=52.205 //y2=5.2
cc_4070 ( N_noxref_12_c_4919_p N_VDD_M108_noxref_s ) capacitor c=0.00111268f \
 //x=52.66 //y=3.665 //x2=52.205 //y2=5.2
cc_4071 ( N_noxref_12_c_4886_n N_VDD_M108_noxref_s ) capacitor c=0.00515461f \
 //x=50.33 //y=5.38 //x2=52.205 //y2=5.2
cc_4072 ( N_noxref_12_c_4921_p N_VDD_M108_noxref_s ) capacitor c=3.28075e-19 \
 //x=50.33 //y=5.56 //x2=52.205 //y2=5.2
cc_4073 ( N_noxref_12_M108_noxref_g N_VDD_M108_noxref_s ) capacitor \
 c=0.0567929f //x=52.56 //y=6.2 //x2=52.205 //y2=5.2
cc_4074 ( N_noxref_12_M109_noxref_g N_VDD_M109_noxref_d ) capacitor \
 c=0.015318f //x=53 //y=6.2 //x2=53.075 //y2=5.2
cc_4075 ( N_noxref_12_c_4941_p N_noxref_26_c_11954_n ) capacitor c=0.00177186f \
 //x=46.74 //y=2.375 //x2=47.395 //y2=0.72
cc_4076 ( N_noxref_12_c_4940_p N_noxref_26_c_11954_n ) capacitor c=0.00117306f \
 //x=46.74 //y=2.26 //x2=47.395 //y2=0.72
cc_4077 ( N_noxref_12_c_4965_p N_noxref_26_c_11954_n ) capacitor c=0.0206349f \
 //x=46.73 //y=1.095 //x2=47.395 //y2=0.72
cc_4078 ( N_noxref_12_c_4990_p N_noxref_26_c_11954_n ) capacitor c=0.00825432f \
 //x=47.26 //y=1.095 //x2=47.395 //y2=0.72
cc_4079 ( N_noxref_12_c_4943_p N_noxref_26_c_11954_n ) capacitor c=2.20712e-19 \
 //x=46.74 //y=2.26 //x2=47.395 //y2=0.72
cc_4080 ( N_noxref_12_c_4966_p N_noxref_26_c_11959_n ) capacitor c=0.0071177f \
 //x=46.73 //y=1.44 //x2=46.51 //y2=1.175
cc_4081 ( N_noxref_12_c_4965_p N_noxref_26_M28_noxref_s ) capacitor \
 c=0.0071177f //x=46.73 //y=1.095 //x2=46.375 //y2=0.555
cc_4082 ( N_noxref_12_c_4967_p N_noxref_26_M28_noxref_s ) capacitor \
 c=0.0071177f //x=46.73 //y=1.75 //x2=46.375 //y2=0.555
cc_4083 ( N_noxref_12_c_4990_p N_noxref_26_M28_noxref_s ) capacitor \
 c=0.015333f //x=47.26 //y=1.095 //x2=46.375 //y2=0.555
cc_4084 ( N_noxref_12_c_4991_p N_noxref_26_M28_noxref_s ) capacitor \
 c=0.00248746f //x=47.26 //y=1.44 //x2=46.375 //y2=0.555
cc_4085 ( N_noxref_12_c_4941_p N_GND_c_12829_n ) capacitor c=0.00196498f \
 //x=46.74 //y=2.375 //x2=49.315 //y2=0.175
cc_4086 ( N_noxref_12_c_4868_n N_GND_c_12788_n ) capacitor c=0.00608539f \
 //x=50.725 //y=1.835 //x2=52.645 //y2=0.175
cc_4087 ( N_noxref_12_c_4889_n N_GND_c_12788_n ) capacitor c=0.00928388f \
 //x=50.37 //y=1.18 //x2=52.645 //y2=0.175
cc_4088 ( N_noxref_12_M30_noxref_d N_GND_c_12788_n ) capacitor c=3.01769e-19 \
 //x=50.18 //y=1.085 //x2=52.645 //y2=0.175
cc_4089 ( N_noxref_12_c_4950_p N_GND_c_12833_n ) capacitor c=6.49973e-19 \
 //x=49.45 //y=5.56 //x2=49.4 //y2=1.135
cc_4090 ( N_noxref_12_c_4889_n N_GND_c_12833_n ) capacitor c=0.0140211f \
 //x=50.37 //y=1.18 //x2=49.4 //y2=1.135
cc_4091 ( N_noxref_12_M30_noxref_d N_GND_c_12833_n ) capacitor c=2.93544e-19 \
 //x=50.18 //y=1.085 //x2=49.4 //y2=1.135
cc_4092 ( N_noxref_12_c_4889_n N_GND_c_12836_n ) capacitor c=0.00549186f \
 //x=50.37 //y=1.18 //x2=52.73 //y2=1.135
cc_4093 ( N_noxref_12_c_5093_p N_GND_c_12836_n ) capacitor c=0.00645051f \
 //x=52.66 //y=2.26 //x2=52.73 //y2=1.135
cc_4094 ( N_noxref_12_c_5085_p N_GND_c_12836_n ) capacitor c=2.13705e-19 \
 //x=52.66 //y=2.26 //x2=52.73 //y2=1.135
cc_4095 ( N_noxref_12_c_5117_p N_GND_c_12836_n ) capacitor c=0.00171023f \
 //x=52.465 //y=1.045 //x2=52.73 //y2=1.135
cc_4096 ( N_noxref_12_c_5118_p N_GND_c_12836_n ) capacitor c=0.00357815f \
 //x=52.465 //y=1.39 //x2=52.73 //y2=1.135
cc_4097 ( N_noxref_12_c_5120_p N_GND_c_12836_n ) capacitor c=4.2764e-19 \
 //x=52.465 //y=1.7 //x2=52.73 //y2=1.135
cc_4098 ( N_noxref_12_c_5245_p N_GND_c_12836_n ) capacitor c=9.36995e-19 \
 //x=52.84 //y=0.89 //x2=52.73 //y2=1.135
cc_4099 ( N_noxref_12_c_5246_p N_GND_c_12836_n ) capacitor c=6.38426e-19 \
 //x=52.84 //y=1.545 //x2=52.73 //y2=1.135
cc_4100 ( N_noxref_12_c_5119_p N_GND_c_12836_n ) capacitor c=0.00171721f \
 //x=52.995 //y=1.045 //x2=52.73 //y2=1.135
cc_4101 ( N_noxref_12_c_5121_p N_GND_c_12836_n ) capacitor c=0.00296337f \
 //x=52.995 //y=1.39 //x2=52.73 //y2=1.135
cc_4102 ( N_noxref_12_c_5117_p N_GND_c_12846_n ) capacitor c=3.46594e-19 \
 //x=52.465 //y=1.045 //x2=52.727 //y2=1.005
cc_4103 ( N_noxref_12_c_5245_p N_GND_c_12846_n ) capacitor c=0.00839795f \
 //x=52.84 //y=0.89 //x2=52.727 //y2=1.005
cc_4104 ( N_noxref_12_c_5119_p N_GND_c_12846_n ) capacitor c=4.40641e-19 \
 //x=52.995 //y=1.045 //x2=52.727 //y2=1.005
cc_4105 ( N_noxref_12_c_4941_p N_GND_c_12849_n ) capacitor c=2.016e-19 \
 //x=46.74 //y=2.375 //x2=48.05 //y2=0.175
cc_4106 ( N_noxref_12_c_4868_n N_GND_c_12801_n ) capacitor c=7.75992e-19 \
 //x=50.725 //y=1.835 //x2=51.38 //y2=0.175
cc_4107 ( N_noxref_12_c_5117_p N_GND_c_12851_n ) capacitor c=0.00688027f \
 //x=52.465 //y=1.045 //x2=54.71 //y2=0.175
cc_4108 ( N_noxref_12_c_4870_n N_GND_c_12823_n ) capacitor c=9.32616e-19 \
 //x=50.81 //y=3.35 //x2=48.22 //y2=0.175
cc_4109 ( N_noxref_12_c_4940_p N_GND_c_12823_n ) capacitor c=0.00216084f \
 //x=46.74 //y=2.26 //x2=48.22 //y2=0.175
cc_4110 ( N_noxref_12_c_4991_p N_GND_c_12823_n ) capacitor c=0.00262688f \
 //x=47.26 //y=1.44 //x2=48.22 //y2=0.175
cc_4111 ( N_noxref_12_c_4943_p N_GND_c_12823_n ) capacitor c=2.63786e-19 \
 //x=46.74 //y=2.26 //x2=48.22 //y2=0.175
cc_4112 ( N_noxref_12_c_4862_n N_GND_c_12825_n ) capacitor c=0.002973f \
 //x=50.37 //y=1.75 //x2=51.55 //y2=0.175
cc_4113 ( N_noxref_12_c_4868_n N_GND_c_12825_n ) capacitor c=0.0274736f \
 //x=50.725 //y=1.835 //x2=51.55 //y2=0.175
cc_4114 ( N_noxref_12_c_4884_n N_GND_c_12825_n ) capacitor c=0.00781993f \
 //x=52.66 //y=3.345 //x2=51.55 //y2=0.175
cc_4115 ( N_noxref_12_c_5093_p N_GND_c_12825_n ) capacitor c=0.00357799f \
 //x=52.66 //y=2.26 //x2=51.55 //y2=0.175
cc_4116 ( N_noxref_12_c_5085_p N_GND_c_12825_n ) capacitor c=0.00371068f \
 //x=52.66 //y=2.26 //x2=51.55 //y2=0.175
cc_4117 ( N_noxref_12_c_5120_p N_GND_c_12825_n ) capacitor c=0.0015404f \
 //x=52.465 //y=1.7 //x2=51.55 //y2=0.175
cc_4118 ( N_noxref_12_c_5095_p N_GND_c_12825_n ) capacitor c=0.00936534f \
 //x=52.465 //y=2.095 //x2=51.55 //y2=0.175
cc_4119 ( N_noxref_12_c_4889_n N_GND_M29_noxref_d ) capacitor c=2.82748e-19 \
 //x=50.37 //y=1.18 //x2=49.21 //y2=1.045
cc_4120 ( N_noxref_12_c_5093_p N_GND_M31_noxref_d ) capacitor c=2.20438e-19 \
 //x=52.66 //y=2.26 //x2=52.54 //y2=1.045
cc_4121 ( N_noxref_12_c_5117_p N_GND_M31_noxref_d ) capacitor c=0.00192399f \
 //x=52.465 //y=1.045 //x2=52.54 //y2=1.045
cc_4122 ( N_noxref_12_c_5118_p N_GND_M31_noxref_d ) capacitor c=0.00210798f \
 //x=52.465 //y=1.39 //x2=52.54 //y2=1.045
cc_4123 ( N_noxref_12_c_5245_p N_GND_M31_noxref_d ) capacitor c=0.00472259f \
 //x=52.84 //y=0.89 //x2=52.54 //y2=1.045
cc_4124 ( N_noxref_12_c_5246_p N_GND_M31_noxref_d ) capacitor c=0.00166857f \
 //x=52.84 //y=1.545 //x2=52.54 //y2=1.045
cc_4125 ( N_noxref_12_c_5119_p N_GND_M31_noxref_d ) capacitor c=0.00230174f \
 //x=52.995 //y=1.045 //x2=52.54 //y2=1.045
cc_4126 ( N_noxref_12_c_5121_p N_GND_M31_noxref_d ) capacitor c=0.00210798f \
 //x=52.995 //y=1.39 //x2=52.54 //y2=1.045
cc_4127 ( N_noxref_12_c_4998_p N_noxref_44_c_14839_n ) capacitor c=0.00911405f \
 //x=50.455 //y=1.835 //x2=49.885 //y2=1.675
cc_4128 ( N_noxref_12_c_4868_n N_noxref_44_c_14843_n ) capacitor c=0.00399245f \
 //x=50.725 //y=1.835 //x2=50.77 //y2=0.71
cc_4129 ( N_noxref_12_c_4889_n N_noxref_44_c_14843_n ) capacitor c=0.003751f \
 //x=50.37 //y=1.18 //x2=50.77 //y2=0.71
cc_4130 ( N_noxref_12_M30_noxref_d N_noxref_44_c_14843_n ) capacitor \
 c=0.00910163f //x=50.18 //y=1.085 //x2=50.77 //y2=0.71
cc_4131 ( N_noxref_12_c_4862_n N_noxref_44_M29_noxref_s ) capacitor c=0.01625f \
 //x=50.37 //y=1.75 //x2=48.78 //y2=0.545
cc_4132 ( N_noxref_12_c_4868_n N_noxref_44_M29_noxref_s ) capacitor \
 c=0.00640979f //x=50.725 //y=1.835 //x2=48.78 //y2=0.545
cc_4133 ( N_noxref_12_c_4879_n N_noxref_44_M29_noxref_s ) capacitor \
 c=4.17069e-19 //x=50.81 //y=3.67 //x2=48.78 //y2=0.545
cc_4134 ( N_noxref_12_c_4889_n N_noxref_44_M29_noxref_s ) capacitor \
 c=0.00905337f //x=50.37 //y=1.18 //x2=48.78 //y2=0.545
cc_4135 ( N_noxref_12_c_4895_n N_noxref_44_M29_noxref_s ) capacitor \
 c=0.0010514f //x=50.805 //y=3.51 //x2=48.78 //y2=0.545
cc_4136 ( N_noxref_12_M30_noxref_d N_noxref_44_M29_noxref_s ) capacitor \
 c=0.0275552f //x=50.18 //y=1.085 //x2=48.78 //y2=0.545
cc_4137 ( N_noxref_12_c_5095_p N_noxref_45_c_14908_n ) capacitor c=0.00262672f \
 //x=52.465 //y=2.095 //x2=52.245 //y2=1.675
cc_4138 ( N_noxref_12_c_4919_p N_noxref_45_c_14909_n ) capacitor c=0.00402488f \
 //x=52.66 //y=3.665 //x2=53.13 //y2=1.76
cc_4139 ( N_noxref_12_c_5093_p N_noxref_45_c_14909_n ) capacitor c=0.00509504f \
 //x=52.66 //y=2.26 //x2=53.13 //y2=1.76
cc_4140 ( N_noxref_12_c_5085_p N_noxref_45_c_14909_n ) capacitor c=0.00763108f \
 //x=52.66 //y=2.26 //x2=53.13 //y2=1.76
cc_4141 ( N_noxref_12_c_5120_p N_noxref_45_c_14909_n ) capacitor c=0.00697076f \
 //x=52.465 //y=1.7 //x2=53.13 //y2=1.76
cc_4142 ( N_noxref_12_c_5095_p N_noxref_45_c_14909_n ) capacitor c=0.0170561f \
 //x=52.465 //y=2.095 //x2=53.13 //y2=1.76
cc_4143 ( N_noxref_12_c_5246_p N_noxref_45_c_14909_n ) capacitor c=0.00723574f \
 //x=52.84 //y=1.545 //x2=53.13 //y2=1.76
cc_4144 ( N_noxref_12_c_5121_p N_noxref_45_c_14909_n ) capacitor c=0.00339872f \
 //x=52.995 //y=1.39 //x2=53.13 //y2=1.76
cc_4145 ( N_noxref_12_c_5095_p N_noxref_45_c_14916_n ) capacitor c=6.71402e-19 \
 //x=52.465 //y=2.095 //x2=53.215 //y2=1.675
cc_4146 ( N_noxref_12_c_5117_p N_noxref_45_M31_noxref_s ) capacitor \
 c=0.0294925f //x=52.465 //y=1.045 //x2=52.11 //y2=0.545
cc_4147 ( N_noxref_12_c_5120_p N_noxref_45_M31_noxref_s ) capacitor \
 c=3.48408e-19 //x=52.465 //y=1.7 //x2=52.11 //y2=0.545
cc_4148 ( N_noxref_12_c_5119_p N_noxref_45_M31_noxref_s ) capacitor \
 c=0.0125442f //x=52.995 //y=1.045 //x2=52.11 //y2=0.545
cc_4149 ( N_noxref_13_c_5299_n CLK ) capacitor c=0.00176146f //x=54.14 \
 //y=3.35 //x2=56.73 //y2=3.51
cc_4150 ( N_noxref_13_c_5301_n CLK ) capacitor c=0.00126687f //x=54.14 \
 //y=5.295 //x2=56.73 //y2=3.51
cc_4151 ( N_noxref_13_c_5322_p CLK ) capacitor c=0.0384724f //x=55.99 //y=3.35 \
 //x2=56.73 //y2=3.51
cc_4152 ( N_noxref_13_c_5323_p CLK ) capacitor c=0.0146933f //x=55.99 //y=3.67 \
 //x2=56.73 //y2=3.51
cc_4153 ( N_noxref_13_c_5324_p CLK ) capacitor c=6.03895e-19 //x=55.985 \
 //y=3.51 //x2=56.73 //y2=3.51
cc_4154 ( N_noxref_13_c_5325_p CLK ) capacitor c=0.0384373f //x=55.992 \
 //y=4.74 //x2=56.73 //y2=3.51
cc_4155 ( N_noxref_13_c_5326_p CLK ) capacitor c=0.00684103f //x=55.985 \
 //y=3.51 //x2=56.73 //y2=3.51
cc_4156 ( N_noxref_13_c_5327_p CLK ) capacitor c=3.30333e-19 //x=55.99 \
 //y=2.26 //x2=56.73 //y2=3.51
cc_4157 ( N_noxref_13_c_5328_p N_CLK_c_6160_n ) capacitor c=0.0147952f \
 //x=55.99 //y=4.88 //x2=56.755 //y2=4.865
cc_4158 ( N_noxref_13_c_5325_p N_CLK_c_6160_n ) capacitor c=0.00198309f \
 //x=55.992 //y=4.74 //x2=56.755 //y2=4.865
cc_4159 ( N_noxref_13_c_5330_p N_CLK_c_6160_n ) capacitor c=7.64003e-19 \
 //x=55.99 //y=4.88 //x2=56.755 //y2=4.865
cc_4160 ( N_noxref_13_c_5331_p N_CLK_c_6160_n ) capacitor c=0.00163736f \
 //x=55.99 //y=4.88 //x2=56.755 //y2=4.865
cc_4161 ( N_noxref_13_c_5332_p N_CLK_c_6164_n ) capacitor c=0.0179797f \
 //x=55.99 //y=2.26 //x2=56.73 //y2=2.26
cc_4162 ( N_noxref_13_c_5327_p N_CLK_c_6164_n ) capacitor c=5.16867e-19 \
 //x=55.99 //y=2.26 //x2=56.73 //y2=2.26
cc_4163 ( N_noxref_13_c_5334_p N_CLK_c_6164_n ) capacitor c=0.00161745f \
 //x=55.795 //y=2.095 //x2=56.73 //y2=2.26
cc_4164 ( N_noxref_13_c_5301_n N_CLK_c_6167_n ) capacitor c=0.0292795f \
 //x=54.14 //y=5.295 //x2=53.62 //y2=4.64
cc_4165 ( N_noxref_13_c_5336_p N_CLK_c_6167_n ) capacitor c=0.021605f \
 //x=53.66 //y=5.38 //x2=53.62 //y2=4.64
cc_4166 ( N_noxref_13_c_5328_p N_CLK_c_6167_n ) capacitor c=0.0114767f \
 //x=55.99 //y=4.88 //x2=53.62 //y2=4.64
cc_4167 ( N_noxref_13_c_5325_p N_CLK_c_6167_n ) capacitor c=0.0274896f \
 //x=55.992 //y=4.74 //x2=53.62 //y2=4.64
cc_4168 ( N_noxref_13_c_5296_n N_CLK_c_6110_n ) capacitor c=0.00656522f \
 //x=53.545 //y=5.38 //x2=53.275 //y2=4.64
cc_4169 ( N_noxref_13_c_5303_n N_CLK_c_6110_n ) capacitor c=0.0154924f \
 //x=52.78 //y=5.56 //x2=53.275 //y2=4.64
cc_4170 ( N_noxref_13_c_5322_p N_CLK_c_6173_n ) capacitor c=3.30333e-19 \
 //x=55.99 //y=3.35 //x2=56.73 //y2=2.26
cc_4171 ( N_noxref_13_c_5332_p N_CLK_c_6173_n ) capacitor c=5.24723e-19 \
 //x=55.99 //y=2.26 //x2=56.73 //y2=2.26
cc_4172 ( N_noxref_13_c_5327_p N_CLK_c_6173_n ) capacitor c=0.00525888f \
 //x=55.99 //y=2.26 //x2=56.73 //y2=2.26
cc_4173 ( N_noxref_13_c_5334_p N_CLK_c_6173_n ) capacitor c=0.00190888f \
 //x=55.795 //y=2.095 //x2=56.73 //y2=2.26
cc_4174 ( N_noxref_13_c_5328_p N_CLK_c_6177_n ) capacitor c=4.80626e-19 \
 //x=55.99 //y=4.88 //x2=56.76 //y2=4.88
cc_4175 ( N_noxref_13_c_5330_p N_CLK_c_6177_n ) capacitor c=0.00396769f \
 //x=55.99 //y=4.88 //x2=56.76 //y2=4.88
cc_4176 ( N_noxref_13_c_5331_p N_CLK_c_6177_n ) capacitor c=0.0028411f \
 //x=55.99 //y=4.88 //x2=56.76 //y2=4.88
cc_4177 ( N_noxref_13_M112_noxref_g N_CLK_M114_noxref_g ) capacitor \
 c=0.0104892f //x=55.89 //y=6.2 //x2=56.77 //y2=6.2
cc_4178 ( N_noxref_13_M113_noxref_g N_CLK_M114_noxref_g ) capacitor \
 c=0.107636f //x=56.33 //y=6.2 //x2=56.77 //y2=6.2
cc_4179 ( N_noxref_13_M113_noxref_g N_CLK_M115_noxref_g ) capacitor \
 c=0.0100341f //x=56.33 //y=6.2 //x2=57.21 //y2=6.2
cc_4180 ( N_noxref_13_c_5351_p N_CLK_c_6183_n ) capacitor c=4.86545e-19 \
 //x=55.795 //y=1.045 //x2=56.765 //y2=1.085
cc_4181 ( N_noxref_13_c_5352_p N_CLK_c_6183_n ) capacitor c=0.00152405f \
 //x=55.795 //y=1.39 //x2=56.765 //y2=1.085
cc_4182 ( N_noxref_13_c_5353_p N_CLK_c_6183_n ) capacitor c=0.0151475f \
 //x=56.325 //y=1.045 //x2=56.765 //y2=1.085
cc_4183 ( N_noxref_13_c_5354_p N_CLK_c_6186_n ) capacitor c=0.00109982f \
 //x=55.795 //y=1.7 //x2=56.765 //y2=1.43
cc_4184 ( N_noxref_13_c_5355_p N_CLK_c_6186_n ) capacitor c=0.0111064f \
 //x=56.325 //y=1.39 //x2=56.765 //y2=1.43
cc_4185 ( N_noxref_13_c_5354_p N_CLK_c_6188_n ) capacitor c=9.58243e-19 \
 //x=55.795 //y=1.7 //x2=56.765 //y2=1.74
cc_4186 ( N_noxref_13_c_5334_p N_CLK_c_6188_n ) capacitor c=0.00662747f \
 //x=55.795 //y=2.095 //x2=56.765 //y2=1.74
cc_4187 ( N_noxref_13_c_5355_p N_CLK_c_6188_n ) capacitor c=0.00862358f \
 //x=56.325 //y=1.39 //x2=56.765 //y2=1.74
cc_4188 ( N_noxref_13_c_5353_p N_CLK_c_6191_n ) capacitor c=0.00127211f \
 //x=56.325 //y=1.045 //x2=57.295 //y2=1.085
cc_4189 ( N_noxref_13_c_5355_p N_CLK_c_6192_n ) capacitor c=0.00204774f \
 //x=56.325 //y=1.39 //x2=57.295 //y2=1.43
cc_4190 ( N_noxref_13_c_5332_p N_CLK_c_6193_n ) capacitor c=0.00161167f \
 //x=55.99 //y=2.26 //x2=56.73 //y2=2.26
cc_4191 ( N_noxref_13_c_5327_p N_CLK_c_6193_n ) capacitor c=0.0018937f \
 //x=55.99 //y=2.26 //x2=56.73 //y2=2.26
cc_4192 ( N_noxref_13_c_5334_p N_CLK_c_6193_n ) capacitor c=0.0181449f \
 //x=55.795 //y=2.095 //x2=56.73 //y2=2.26
cc_4193 ( N_noxref_13_c_5330_p N_CLK_c_6196_n ) capacitor c=0.00202662f \
 //x=55.99 //y=4.88 //x2=56.76 //y2=4.88
cc_4194 ( N_noxref_13_c_5331_p N_CLK_c_6196_n ) capacitor c=0.0288755f \
 //x=55.99 //y=4.88 //x2=56.76 //y2=4.88
cc_4195 ( N_noxref_13_c_5366_p N_noxref_15_c_6730_n ) capacitor c=0.00129068f \
 //x=54.14 //y=3.67 //x2=53.62 //y2=3.87
cc_4196 ( N_noxref_13_c_5301_n N_noxref_15_c_6730_n ) capacitor c=7.95945e-19 \
 //x=54.14 //y=5.295 //x2=53.62 //y2=3.87
cc_4197 ( N_noxref_13_c_5314_n N_noxref_15_c_6730_n ) capacitor c=0.0358254f \
 //x=54.305 //y=3.51 //x2=53.62 //y2=3.87
cc_4198 ( N_noxref_13_c_5366_p N_noxref_15_c_6733_n ) capacitor c=0.00700197f \
 //x=54.14 //y=3.67 //x2=54.36 //y2=3.895
cc_4199 ( N_noxref_13_c_5301_n N_noxref_15_c_6733_n ) capacitor c=0.0225064f \
 //x=54.14 //y=5.295 //x2=54.36 //y2=3.895
cc_4200 ( N_noxref_13_c_5371_p N_noxref_15_c_6733_n ) capacitor c=0.126769f \
 //x=55.825 //y=3.51 //x2=54.36 //y2=3.895
cc_4201 ( N_noxref_13_c_5323_p N_noxref_15_c_6736_n ) capacitor c=0.00341263f \
 //x=55.99 //y=3.67 //x2=55.6 //y2=3.88
cc_4202 ( N_noxref_13_c_5325_p N_noxref_15_c_6736_n ) capacitor c=4.98692e-19 \
 //x=55.992 //y=4.74 //x2=55.6 //y2=3.88
cc_4203 ( N_noxref_13_c_5371_p N_noxref_15_c_6736_n ) capacitor c=0.0108087f \
 //x=55.825 //y=3.51 //x2=55.6 //y2=3.88
cc_4204 ( N_noxref_13_c_5326_p N_noxref_15_c_6736_n ) capacitor c=0.0358254f \
 //x=55.985 //y=3.51 //x2=55.6 //y2=3.88
cc_4205 ( N_noxref_13_c_5323_p N_noxref_15_c_6740_n ) capacitor c=0.00251183f \
 //x=55.99 //y=3.67 //x2=56.2 //y2=3.895
cc_4206 ( N_noxref_13_c_5325_p N_noxref_15_c_6740_n ) capacitor c=0.0224596f \
 //x=55.992 //y=4.74 //x2=56.2 //y2=3.895
cc_4207 ( N_noxref_13_c_5299_n N_noxref_17_c_7368_n ) capacitor c=0.0386234f \
 //x=54.14 //y=3.35 //x2=53.4 //y2=4.095
cc_4208 ( N_noxref_13_c_5366_p N_noxref_17_c_7368_n ) capacitor c=0.0146933f \
 //x=54.14 //y=3.67 //x2=53.4 //y2=4.095
cc_4209 ( N_noxref_13_c_5301_n N_noxref_17_c_7368_n ) capacitor c=0.0169815f \
 //x=54.14 //y=5.295 //x2=53.4 //y2=4.095
cc_4210 ( N_noxref_13_c_5322_p N_noxref_17_c_7368_n ) capacitor c=0.00176258f \
 //x=55.99 //y=3.35 //x2=53.4 //y2=4.095
cc_4211 ( N_noxref_13_c_5313_n N_noxref_17_c_7368_n ) capacitor c=5.52402e-19 \
 //x=54.14 //y=3.51 //x2=53.4 //y2=4.095
cc_4212 ( N_noxref_13_c_5325_p N_noxref_17_c_7368_n ) capacitor c=3.19292e-19 \
 //x=55.992 //y=4.74 //x2=53.4 //y2=4.095
cc_4213 ( N_noxref_13_c_5314_n N_noxref_17_c_7368_n ) capacitor c=0.00365012f \
 //x=54.305 //y=3.51 //x2=53.4 //y2=4.095
cc_4214 ( N_noxref_13_c_5296_n N_noxref_17_c_7376_n ) capacitor c=0.0042527f \
 //x=53.545 //y=5.38 //x2=53.4 //y2=4.415
cc_4215 ( N_noxref_13_c_5301_n N_noxref_17_c_7376_n ) capacitor c=0.0147977f \
 //x=54.14 //y=5.295 //x2=53.4 //y2=4.415
cc_4216 ( N_noxref_13_c_5296_n N_noxref_17_c_7377_n ) capacitor c=0.0215252f \
 //x=53.545 //y=5.38 //x2=53.4 //y2=4.735
cc_4217 ( N_noxref_13_c_5301_n N_noxref_17_c_7377_n ) capacitor c=0.0281817f \
 //x=54.14 //y=5.295 //x2=53.4 //y2=4.735
cc_4218 ( N_noxref_13_c_5325_p N_noxref_17_c_7377_n ) capacitor c=4.65109e-19 \
 //x=55.992 //y=4.74 //x2=53.4 //y2=4.735
cc_4219 ( N_noxref_13_M113_noxref_g N_noxref_17_c_7435_n ) capacitor \
 c=0.00889217f //x=56.33 //y=6.2 //x2=56.875 //y2=5.38
cc_4220 ( N_noxref_13_c_5297_n N_noxref_17_c_7436_n ) capacitor c=0.00324213f \
 //x=53.7 //y=1.75 //x2=57.03 //y2=1.75
cc_4221 ( N_noxref_13_c_5392_p N_noxref_17_c_7437_n ) capacitor c=0.00231467f \
 //x=54.055 //y=1.835 //x2=57.115 //y2=1.835
cc_4222 ( N_noxref_13_c_5299_n N_noxref_17_c_7438_n ) capacitor c=0.00204244f \
 //x=54.14 //y=3.35 //x2=57.47 //y2=4.105
cc_4223 ( N_noxref_13_c_5322_p N_noxref_17_c_7438_n ) capacitor c=0.00263223f \
 //x=55.99 //y=3.35 //x2=57.47 //y2=4.105
cc_4224 ( N_noxref_13_c_5325_p N_noxref_17_c_7438_n ) capacitor c=7.58839e-19 \
 //x=55.992 //y=4.74 //x2=57.47 //y2=4.105
cc_4225 ( N_noxref_13_c_5301_n N_noxref_17_c_7441_n ) capacitor c=0.00281705f \
 //x=54.14 //y=5.295 //x2=57.47 //y2=5.295
cc_4226 ( N_noxref_13_c_5325_p N_noxref_17_c_7441_n ) capacitor c=0.00105211f \
 //x=55.992 //y=4.74 //x2=57.47 //y2=5.295
cc_4227 ( N_noxref_13_c_5301_n N_noxref_17_c_7382_n ) capacitor c=6.89957e-19 \
 //x=54.14 //y=5.295 //x2=53.4 //y2=4.25
cc_4228 ( N_noxref_13_c_5299_n N_noxref_17_c_7383_n ) capacitor c=0.0138368f \
 //x=54.14 //y=3.35 //x2=53.4 //y2=2.26
cc_4229 ( N_noxref_13_c_5400_p N_noxref_17_c_7445_n ) capacitor c=0.00114153f \
 //x=54.055 //y=5.38 //x2=56.11 //y2=5.56
cc_4230 ( N_noxref_13_c_5323_p N_noxref_17_c_7445_n ) capacitor c=5.66772e-19 \
 //x=55.99 //y=3.67 //x2=56.11 //y2=5.56
cc_4231 ( N_noxref_13_c_5336_p N_noxref_17_c_7445_n ) capacitor c=5.29822e-19 \
 //x=53.66 //y=5.38 //x2=56.11 //y2=5.56
cc_4232 ( N_noxref_13_c_5403_p N_noxref_17_c_7445_n ) capacitor c=0.00147119f \
 //x=53.66 //y=5.56 //x2=56.11 //y2=5.56
cc_4233 ( N_noxref_13_c_5328_p N_noxref_17_c_7445_n ) capacitor c=0.0117744f \
 //x=55.99 //y=4.88 //x2=56.11 //y2=5.56
cc_4234 ( N_noxref_13_c_5330_p N_noxref_17_c_7445_n ) capacitor c=0.00277154f \
 //x=55.99 //y=4.88 //x2=56.11 //y2=5.56
cc_4235 ( N_noxref_13_M112_noxref_g N_noxref_17_c_7445_n ) capacitor \
 c=0.00201806f //x=55.89 //y=6.2 //x2=56.11 //y2=5.56
cc_4236 ( N_noxref_13_M113_noxref_g N_noxref_17_c_7445_n ) capacitor \
 c=0.00192712f //x=56.33 //y=6.2 //x2=56.11 //y2=5.56
cc_4237 ( N_noxref_13_c_5331_p N_noxref_17_c_7445_n ) capacitor c=0.00194519f \
 //x=55.99 //y=4.88 //x2=56.11 //y2=5.56
cc_4238 ( N_noxref_13_c_5312_n N_noxref_17_c_7454_n ) capacitor c=6.99317e-19 \
 //x=53.7 //y=1.18 //x2=57.03 //y2=1.18
cc_4239 ( N_noxref_13_c_5301_n N_noxref_17_c_7455_n ) capacitor c=0.0227736f \
 //x=54.14 //y=5.295 //x2=57.3 //y2=4.25
cc_4240 ( N_noxref_13_c_5325_p N_noxref_17_c_7455_n ) capacitor c=0.0232046f \
 //x=55.992 //y=4.74 //x2=57.3 //y2=4.25
cc_4241 ( N_noxref_13_c_5371_p N_noxref_17_c_7455_n ) capacitor c=0.0104197f \
 //x=55.825 //y=3.51 //x2=57.3 //y2=4.25
cc_4242 ( N_noxref_13_c_5301_n N_noxref_17_c_7364_n ) capacitor c=0.00328982f \
 //x=54.14 //y=5.295 //x2=53.565 //y2=4.25
cc_4243 ( N_noxref_13_c_5299_n N_noxref_17_c_7397_n ) capacitor c=9.26054e-19 \
 //x=54.14 //y=3.35 //x2=53.4 //y2=2.26
cc_4244 ( N_noxref_13_c_5296_n N_noxref_17_c_7401_n ) capacitor c=0.00469257f \
 //x=53.545 //y=5.38 //x2=53.43 //y2=4.88
cc_4245 ( N_noxref_13_c_5301_n N_noxref_17_c_7401_n ) capacitor c=7.76118e-19 \
 //x=54.14 //y=5.295 //x2=53.43 //y2=4.88
cc_4246 ( N_noxref_13_c_5328_p N_noxref_17_c_7462_n ) capacitor c=0.00104426f \
 //x=55.99 //y=4.88 //x2=56.11 //y2=5.56
cc_4247 ( N_noxref_13_c_5330_p N_noxref_17_c_7462_n ) capacitor c=0.00377369f \
 //x=55.99 //y=4.88 //x2=56.11 //y2=5.56
cc_4248 ( N_noxref_13_M112_noxref_g N_noxref_17_c_7462_n ) capacitor \
 c=0.0158358f //x=55.89 //y=6.2 //x2=56.11 //y2=5.56
cc_4249 ( N_noxref_13_M113_noxref_g N_noxref_17_c_7462_n ) capacitor \
 c=0.0178987f //x=56.33 //y=6.2 //x2=56.11 //y2=5.56
cc_4250 ( N_noxref_13_c_5331_p N_noxref_17_c_7462_n ) capacitor c=0.0043218f \
 //x=55.99 //y=4.88 //x2=56.11 //y2=5.56
cc_4251 ( N_noxref_13_c_5296_n N_noxref_17_M110_noxref_g ) capacitor \
 c=0.00842859f //x=53.545 //y=5.38 //x2=53.44 //y2=6.2
cc_4252 ( N_noxref_13_c_5336_p N_noxref_17_M110_noxref_g ) capacitor \
 c=0.00192712f //x=53.66 //y=5.38 //x2=53.44 //y2=6.2
cc_4253 ( N_noxref_13_c_5424_p N_noxref_17_M110_noxref_g ) capacitor \
 c=0.0178987f //x=53.66 //y=5.56 //x2=53.44 //y2=6.2
cc_4254 ( N_noxref_13_c_5400_p N_noxref_17_M111_noxref_g ) capacitor \
 c=0.0106088f //x=54.055 //y=5.38 //x2=53.88 //y2=6.2
cc_4255 ( N_noxref_13_c_5336_p N_noxref_17_M111_noxref_g ) capacitor \
 c=0.00298276f //x=53.66 //y=5.38 //x2=53.88 //y2=6.2
cc_4256 ( N_noxref_13_c_5424_p N_noxref_17_M111_noxref_g ) capacitor \
 c=0.0178506f //x=53.66 //y=5.56 //x2=53.88 //y2=6.2
cc_4257 ( N_noxref_13_c_5312_n N_noxref_17_c_7407_n ) capacitor c=0.00120406f \
 //x=53.7 //y=1.18 //x2=53.435 //y2=1.085
cc_4258 ( N_noxref_13_M32_noxref_d N_noxref_17_c_7407_n ) capacitor \
 c=0.00137165f //x=53.51 //y=1.085 //x2=53.435 //y2=1.085
cc_4259 ( N_noxref_13_c_5297_n N_noxref_17_c_7410_n ) capacitor c=0.00119008f \
 //x=53.7 //y=1.75 //x2=53.435 //y2=1.43
cc_4260 ( N_noxref_13_c_5312_n N_noxref_17_c_7410_n ) capacitor c=0.00218694f \
 //x=53.7 //y=1.18 //x2=53.435 //y2=1.43
cc_4261 ( N_noxref_13_M32_noxref_d N_noxref_17_c_7410_n ) capacitor \
 c=0.00237422f //x=53.51 //y=1.085 //x2=53.435 //y2=1.43
cc_4262 ( N_noxref_13_c_5297_n N_noxref_17_c_7412_n ) capacitor c=0.00438634f \
 //x=53.7 //y=1.75 //x2=53.435 //y2=1.74
cc_4263 ( N_noxref_13_c_5301_n N_noxref_17_c_7479_n ) capacitor c=0.00845606f \
 //x=54.14 //y=5.295 //x2=53.805 //y2=4.97
cc_4264 ( N_noxref_13_c_5336_p N_noxref_17_c_7479_n ) capacitor c=0.0020909f \
 //x=53.66 //y=5.38 //x2=53.805 //y2=4.97
cc_4265 ( N_noxref_13_c_5424_p N_noxref_17_c_7479_n ) capacitor c=0.00291714f \
 //x=53.66 //y=5.56 //x2=53.805 //y2=4.97
cc_4266 ( N_noxref_13_c_5312_n N_noxref_17_c_7482_n ) capacitor c=5.50523e-19 \
 //x=53.7 //y=1.18 //x2=53.81 //y2=0.93
cc_4267 ( N_noxref_13_M32_noxref_d N_noxref_17_c_7482_n ) capacitor \
 c=0.0020782f //x=53.51 //y=1.085 //x2=53.81 //y2=0.93
cc_4268 ( N_noxref_13_c_5297_n N_noxref_17_c_7484_n ) capacitor c=0.00916852f \
 //x=53.7 //y=1.75 //x2=53.81 //y2=1.585
cc_4269 ( N_noxref_13_c_5392_p N_noxref_17_c_7484_n ) capacitor c=0.00194324f \
 //x=54.055 //y=1.835 //x2=53.81 //y2=1.585
cc_4270 ( N_noxref_13_c_5312_n N_noxref_17_c_7484_n ) capacitor c=5.67071e-19 \
 //x=53.7 //y=1.18 //x2=53.81 //y2=1.585
cc_4271 ( N_noxref_13_M32_noxref_d N_noxref_17_c_7484_n ) capacitor \
 c=0.00356097f //x=53.51 //y=1.085 //x2=53.81 //y2=1.585
cc_4272 ( N_noxref_13_c_5312_n N_noxref_17_c_7415_n ) capacitor c=0.00109205f \
 //x=53.7 //y=1.18 //x2=53.965 //y2=1.085
cc_4273 ( N_noxref_13_M32_noxref_d N_noxref_17_c_7415_n ) capacitor \
 c=8.50095e-19 //x=53.51 //y=1.085 //x2=53.965 //y2=1.085
cc_4274 ( N_noxref_13_c_5297_n N_noxref_17_c_7416_n ) capacitor c=0.003249f \
 //x=53.7 //y=1.75 //x2=53.965 //y2=1.43
cc_4275 ( N_noxref_13_c_5392_p N_noxref_17_c_7416_n ) capacitor c=0.00323005f \
 //x=54.055 //y=1.835 //x2=53.965 //y2=1.43
cc_4276 ( N_noxref_13_c_5312_n N_noxref_17_c_7416_n ) capacitor c=0.00317092f \
 //x=53.7 //y=1.18 //x2=53.965 //y2=1.43
cc_4277 ( N_noxref_13_M32_noxref_d N_noxref_17_c_7416_n ) capacitor \
 c=0.00237422f //x=53.51 //y=1.085 //x2=53.965 //y2=1.43
cc_4278 ( N_noxref_13_c_5299_n N_noxref_17_c_7417_n ) capacitor c=0.00268898f \
 //x=54.14 //y=3.35 //x2=53.4 //y2=2.26
cc_4279 ( N_noxref_13_c_5297_n N_noxref_17_c_7495_n ) capacitor c=0.00341114f \
 //x=53.7 //y=1.75 //x2=53.4 //y2=2.095
cc_4280 ( N_noxref_13_c_5299_n N_noxref_17_c_7495_n ) capacitor c=0.00309058f \
 //x=54.14 //y=3.35 //x2=53.4 //y2=2.095
cc_4281 ( N_noxref_13_c_5296_n N_noxref_17_c_7420_n ) capacitor c=8.41897e-19 \
 //x=53.545 //y=5.38 //x2=53.43 //y2=4.88
cc_4282 ( N_noxref_13_c_5301_n N_noxref_17_c_7420_n ) capacitor c=0.00142201f \
 //x=54.14 //y=5.295 //x2=53.43 //y2=4.88
cc_4283 ( N_noxref_13_c_5298_n N_noxref_19_c_8645_n ) capacitor c=0.0194164f \
 //x=53.785 //y=1.835 //x2=50.285 //y2=2.37
cc_4284 ( N_noxref_13_c_5299_n N_noxref_19_c_8645_n ) capacitor c=0.0307535f \
 //x=54.14 //y=3.35 //x2=50.285 //y2=2.37
cc_4285 ( N_noxref_13_c_5322_p N_noxref_19_c_8645_n ) capacitor c=0.0152578f \
 //x=55.99 //y=3.35 //x2=50.285 //y2=2.37
cc_4286 ( N_noxref_13_c_5312_n N_noxref_19_c_8645_n ) capacitor c=7.09092e-19 \
 //x=53.7 //y=1.18 //x2=50.285 //y2=2.37
cc_4287 ( N_noxref_13_c_5332_p N_noxref_19_c_8645_n ) capacitor c=0.0177708f \
 //x=55.99 //y=2.26 //x2=50.285 //y2=2.37
cc_4288 ( N_noxref_13_c_5371_p N_noxref_19_c_8645_n ) capacitor c=0.00615624f \
 //x=55.825 //y=3.51 //x2=50.285 //y2=2.37
cc_4289 ( N_noxref_13_c_5327_p N_noxref_19_c_8645_n ) capacitor c=2.20453e-19 \
 //x=55.99 //y=2.26 //x2=50.285 //y2=2.37
cc_4290 ( N_noxref_13_c_5334_p N_noxref_19_c_8645_n ) capacitor c=3.61358e-19 \
 //x=55.795 //y=2.095 //x2=50.285 //y2=2.37
cc_4291 ( N_noxref_13_c_5299_n N_noxref_20_c_9447_n ) capacitor c=3.26409e-19 \
 //x=54.14 //y=3.35 //x2=53.76 //y2=3.14
cc_4292 ( N_noxref_13_c_5299_n N_noxref_20_c_9448_n ) capacitor c=0.0253703f \
 //x=54.14 //y=3.35 //x2=54.36 //y2=3.125
cc_4293 ( N_noxref_13_c_5366_p N_noxref_20_c_9448_n ) capacitor c=0.00802082f \
 //x=54.14 //y=3.67 //x2=54.36 //y2=3.125
cc_4294 ( N_noxref_13_c_5371_p N_noxref_20_c_9448_n ) capacitor c=0.126752f \
 //x=55.825 //y=3.51 //x2=54.36 //y2=3.125
cc_4295 ( N_noxref_13_c_5314_n N_noxref_20_c_9448_n ) capacitor c=0.0358686f \
 //x=54.305 //y=3.51 //x2=54.36 //y2=3.125
cc_4296 ( N_noxref_13_c_5322_p N_noxref_20_c_9452_n ) capacitor c=4.98692e-19 \
 //x=55.99 //y=3.35 //x2=55.6 //y2=3.14
cc_4297 ( N_noxref_13_c_5323_p N_noxref_20_c_9452_n ) capacitor c=0.00225452f \
 //x=55.99 //y=3.67 //x2=55.6 //y2=3.14
cc_4298 ( N_noxref_13_c_5371_p N_noxref_20_c_9452_n ) capacitor c=0.010775f \
 //x=55.825 //y=3.51 //x2=55.6 //y2=3.14
cc_4299 ( N_noxref_13_c_5322_p N_noxref_20_c_9455_n ) capacitor c=0.0251626f \
 //x=55.99 //y=3.35 //x2=56.2 //y2=3.125
cc_4300 ( N_noxref_13_c_5323_p N_noxref_20_c_9455_n ) capacitor c=0.0049147f \
 //x=55.99 //y=3.67 //x2=56.2 //y2=3.125
cc_4301 ( N_noxref_13_c_5326_p N_noxref_20_c_9455_n ) capacitor c=0.0358686f \
 //x=55.985 //y=3.51 //x2=56.2 //y2=3.125
cc_4302 ( N_noxref_13_c_5296_n N_VDD_c_10241_n ) capacitor c=0.00648267f \
 //x=53.545 //y=5.38 //x2=65.575 //y2=7.585
cc_4303 ( N_noxref_13_c_5400_p N_VDD_c_10241_n ) capacitor c=0.00492586f \
 //x=54.055 //y=5.38 //x2=65.575 //y2=7.585
cc_4304 ( N_noxref_13_c_5366_p N_VDD_c_10241_n ) capacitor c=4.58912e-19 \
 //x=54.14 //y=3.67 //x2=65.575 //y2=7.585
cc_4305 ( N_noxref_13_c_5323_p N_VDD_c_10241_n ) capacitor c=2.00712e-19 \
 //x=55.99 //y=3.67 //x2=65.575 //y2=7.585
cc_4306 ( N_noxref_13_c_5303_n N_VDD_c_10241_n ) capacitor c=0.00368834f \
 //x=52.78 //y=5.56 //x2=65.575 //y2=7.585
cc_4307 ( N_noxref_13_c_5336_p N_VDD_c_10241_n ) capacitor c=8.42594e-19 \
 //x=53.66 //y=5.38 //x2=65.575 //y2=7.585
cc_4308 ( N_noxref_13_c_5403_p N_VDD_c_10241_n ) capacitor c=0.00285853f \
 //x=53.66 //y=5.56 //x2=65.575 //y2=7.585
cc_4309 ( N_noxref_13_c_5328_p N_VDD_c_10241_n ) capacitor c=9.07241e-19 \
 //x=55.99 //y=4.88 //x2=65.575 //y2=7.585
cc_4310 ( N_noxref_13_c_5315_n N_VDD_c_10241_n ) capacitor c=0.00224881f \
 //x=52.78 //y=5.56 //x2=65.575 //y2=7.585
cc_4311 ( N_noxref_13_c_5424_p N_VDD_c_10241_n ) capacitor c=0.00224881f \
 //x=53.66 //y=5.56 //x2=65.575 //y2=7.585
cc_4312 ( N_noxref_13_c_5330_p N_VDD_c_10241_n ) capacitor c=6.22888e-19 \
 //x=55.99 //y=4.88 //x2=65.575 //y2=7.585
cc_4313 ( N_noxref_13_c_5296_n N_VDD_c_10897_n ) capacitor c=0.00208087f \
 //x=53.545 //y=5.38 //x2=53.135 //y2=7.585
cc_4314 ( N_noxref_13_c_5303_n N_VDD_c_10897_n ) capacitor c=9.41185e-19 \
 //x=52.78 //y=5.56 //x2=53.135 //y2=7.585
cc_4315 ( N_noxref_13_c_5315_n N_VDD_c_10897_n ) capacitor c=0.0136705f \
 //x=52.78 //y=5.56 //x2=53.135 //y2=7.585
cc_4316 ( N_noxref_13_c_5296_n N_VDD_c_10947_n ) capacitor c=0.00180737f \
 //x=53.545 //y=5.38 //x2=54.015 //y2=7.585
cc_4317 ( N_noxref_13_c_5400_p N_VDD_c_10947_n ) capacitor c=0.00208087f \
 //x=54.055 //y=5.38 //x2=54.015 //y2=7.585
cc_4318 ( N_noxref_13_c_5336_p N_VDD_c_10947_n ) capacitor c=4.23719e-19 \
 //x=53.66 //y=5.38 //x2=54.015 //y2=7.585
cc_4319 ( N_noxref_13_c_5403_p N_VDD_c_10947_n ) capacitor c=5.77976e-19 \
 //x=53.66 //y=5.56 //x2=54.015 //y2=7.585
cc_4320 ( N_noxref_13_c_5424_p N_VDD_c_10947_n ) capacitor c=0.0136705f \
 //x=53.66 //y=5.56 //x2=54.015 //y2=7.585
cc_4321 ( N_noxref_13_c_5328_p N_VDD_c_10952_n ) capacitor c=6.28113e-19 \
 //x=55.99 //y=4.88 //x2=56.465 //y2=7.585
cc_4322 ( N_noxref_13_M112_noxref_g N_VDD_c_10952_n ) capacitor c=0.00732618f \
 //x=55.89 //y=6.2 //x2=56.465 //y2=7.585
cc_4323 ( N_noxref_13_M113_noxref_g N_VDD_c_10952_n ) capacitor c=0.00755544f \
 //x=56.33 //y=6.2 //x2=56.465 //y2=7.585
cc_4324 ( N_noxref_13_c_5301_n N_VDD_c_10865_n ) capacitor c=0.0013228f \
 //x=54.14 //y=5.295 //x2=51.55 //y2=7.585
cc_4325 ( N_noxref_13_c_5303_n N_VDD_c_10865_n ) capacitor c=4.91377e-19 \
 //x=52.78 //y=5.56 //x2=51.55 //y2=7.585
cc_4326 ( N_noxref_13_c_5315_n N_VDD_c_10865_n ) capacitor c=0.0064135f \
 //x=52.78 //y=5.56 //x2=51.55 //y2=7.585
cc_4327 ( N_noxref_13_c_5301_n N_VDD_c_10958_n ) capacitor c=0.0285805f \
 //x=54.14 //y=5.295 //x2=54.88 //y2=7.585
cc_4328 ( N_noxref_13_c_5336_p N_VDD_c_10958_n ) capacitor c=0.00240948f \
 //x=53.66 //y=5.38 //x2=54.88 //y2=7.585
cc_4329 ( N_noxref_13_c_5403_p N_VDD_c_10958_n ) capacitor c=4.09141e-19 \
 //x=53.66 //y=5.56 //x2=54.88 //y2=7.585
cc_4330 ( N_noxref_13_c_5328_p N_VDD_c_10958_n ) capacitor c=0.00508547f \
 //x=55.99 //y=4.88 //x2=54.88 //y2=7.585
cc_4331 ( N_noxref_13_c_5325_p N_VDD_c_10958_n ) capacitor c=0.005822f \
 //x=55.992 //y=4.74 //x2=54.88 //y2=7.585
cc_4332 ( N_noxref_13_c_5424_p N_VDD_c_10958_n ) capacitor c=0.0101861f \
 //x=53.66 //y=5.56 //x2=54.88 //y2=7.585
cc_4333 ( N_noxref_13_c_5330_p N_VDD_c_10958_n ) capacitor c=0.00370494f \
 //x=55.99 //y=4.88 //x2=54.88 //y2=7.585
cc_4334 ( N_noxref_13_c_5331_p N_VDD_c_10958_n ) capacitor c=0.0129564f \
 //x=55.99 //y=4.88 //x2=54.88 //y2=7.585
cc_4335 ( N_noxref_13_c_5303_n N_VDD_M108_noxref_s ) capacitor c=0.0572211f \
 //x=52.78 //y=5.56 //x2=52.205 //y2=5.2
cc_4336 ( N_noxref_13_c_5336_p N_VDD_M108_noxref_s ) capacitor c=6.52457e-19 \
 //x=53.66 //y=5.38 //x2=52.205 //y2=5.2
cc_4337 ( N_noxref_13_c_5315_n N_VDD_M108_noxref_s ) capacitor c=0.0887533f \
 //x=52.78 //y=5.56 //x2=52.205 //y2=5.2
cc_4338 ( N_noxref_13_c_5296_n N_VDD_M109_noxref_d ) capacitor c=0.00734094f \
 //x=53.545 //y=5.38 //x2=53.075 //y2=5.2
cc_4339 ( N_noxref_13_c_5303_n N_VDD_M109_noxref_d ) capacitor c=0.0043528f \
 //x=52.78 //y=5.56 //x2=53.075 //y2=5.2
cc_4340 ( N_noxref_13_c_5403_p N_VDD_M109_noxref_d ) capacitor c=0.0043528f \
 //x=53.66 //y=5.56 //x2=53.075 //y2=5.2
cc_4341 ( N_noxref_13_c_5315_n N_VDD_M109_noxref_d ) capacitor c=0.065554f \
 //x=52.78 //y=5.56 //x2=53.075 //y2=5.2
cc_4342 ( N_noxref_13_c_5424_p N_VDD_M109_noxref_d ) capacitor c=0.065554f \
 //x=53.66 //y=5.56 //x2=53.075 //y2=5.2
cc_4343 ( N_noxref_13_c_5400_p N_VDD_M111_noxref_d ) capacitor c=0.00934027f \
 //x=54.055 //y=5.38 //x2=53.955 //y2=5.2
cc_4344 ( N_noxref_13_c_5403_p N_VDD_M111_noxref_d ) capacitor c=0.00587834f \
 //x=53.66 //y=5.56 //x2=53.955 //y2=5.2
cc_4345 ( N_noxref_13_c_5313_n N_VDD_M111_noxref_d ) capacitor c=9.65951e-19 \
 //x=54.14 //y=3.51 //x2=53.955 //y2=5.2
cc_4346 ( N_noxref_13_c_5424_p N_VDD_M111_noxref_d ) capacitor c=0.065554f \
 //x=53.66 //y=5.56 //x2=53.955 //y2=5.2
cc_4347 ( N_noxref_13_c_5400_p N_VDD_M112_noxref_s ) capacitor c=0.00326953f \
 //x=54.055 //y=5.38 //x2=55.535 //y2=5.2
cc_4348 ( N_noxref_13_c_5323_p N_VDD_M112_noxref_s ) capacitor c=0.00111275f \
 //x=55.99 //y=3.67 //x2=55.535 //y2=5.2
cc_4349 ( N_noxref_13_c_5336_p N_VDD_M112_noxref_s ) capacitor c=0.00515461f \
 //x=53.66 //y=5.38 //x2=55.535 //y2=5.2
cc_4350 ( N_noxref_13_c_5403_p N_VDD_M112_noxref_s ) capacitor c=3.28075e-19 \
 //x=53.66 //y=5.56 //x2=55.535 //y2=5.2
cc_4351 ( N_noxref_13_M112_noxref_g N_VDD_M112_noxref_s ) capacitor \
 c=0.0567929f //x=55.89 //y=6.2 //x2=55.535 //y2=5.2
cc_4352 ( N_noxref_13_M113_noxref_g N_VDD_M113_noxref_d ) capacitor \
 c=0.015318f //x=56.33 //y=6.2 //x2=56.405 //y2=5.2
cc_4353 ( N_noxref_13_c_5392_p N_GND_c_12871_n ) capacitor c=0.00608539f \
 //x=54.055 //y=1.835 //x2=55.975 //y2=0.175
cc_4354 ( N_noxref_13_c_5366_p N_GND_c_12871_n ) capacitor c=2.72732e-19 \
 //x=54.14 //y=3.67 //x2=55.975 //y2=0.175
cc_4355 ( N_noxref_13_c_5312_n N_GND_c_12871_n ) capacitor c=0.00928865f \
 //x=53.7 //y=1.18 //x2=55.975 //y2=0.175
cc_4356 ( N_noxref_13_M32_noxref_d N_GND_c_12871_n ) capacitor c=3.01769e-19 \
 //x=53.51 //y=1.085 //x2=55.975 //y2=0.175
cc_4357 ( N_noxref_13_c_5303_n N_GND_c_12836_n ) capacitor c=7.46731e-19 \
 //x=52.78 //y=5.56 //x2=52.73 //y2=1.135
cc_4358 ( N_noxref_13_c_5312_n N_GND_c_12836_n ) capacitor c=0.0140087f \
 //x=53.7 //y=1.18 //x2=52.73 //y2=1.135
cc_4359 ( N_noxref_13_M32_noxref_d N_GND_c_12836_n ) capacitor c=2.93544e-19 \
 //x=53.51 //y=1.085 //x2=52.73 //y2=1.135
cc_4360 ( N_noxref_13_c_5312_n N_GND_c_12878_n ) capacitor c=0.00549186f \
 //x=53.7 //y=1.18 //x2=56.06 //y2=1.135
cc_4361 ( N_noxref_13_c_5332_p N_GND_c_12878_n ) capacitor c=0.00645051f \
 //x=55.99 //y=2.26 //x2=56.06 //y2=1.135
cc_4362 ( N_noxref_13_c_5327_p N_GND_c_12878_n ) capacitor c=2.13705e-19 \
 //x=55.99 //y=2.26 //x2=56.06 //y2=1.135
cc_4363 ( N_noxref_13_c_5351_p N_GND_c_12878_n ) capacitor c=0.00171023f \
 //x=55.795 //y=1.045 //x2=56.06 //y2=1.135
cc_4364 ( N_noxref_13_c_5352_p N_GND_c_12878_n ) capacitor c=0.00357815f \
 //x=55.795 //y=1.39 //x2=56.06 //y2=1.135
cc_4365 ( N_noxref_13_c_5354_p N_GND_c_12878_n ) capacitor c=4.2764e-19 \
 //x=55.795 //y=1.7 //x2=56.06 //y2=1.135
cc_4366 ( N_noxref_13_c_5537_p N_GND_c_12878_n ) capacitor c=9.36995e-19 \
 //x=56.17 //y=0.89 //x2=56.06 //y2=1.135
cc_4367 ( N_noxref_13_c_5538_p N_GND_c_12878_n ) capacitor c=6.38426e-19 \
 //x=56.17 //y=1.545 //x2=56.06 //y2=1.135
cc_4368 ( N_noxref_13_c_5353_p N_GND_c_12878_n ) capacitor c=0.00171721f \
 //x=56.325 //y=1.045 //x2=56.06 //y2=1.135
cc_4369 ( N_noxref_13_c_5355_p N_GND_c_12878_n ) capacitor c=0.00296337f \
 //x=56.325 //y=1.39 //x2=56.06 //y2=1.135
cc_4370 ( N_noxref_13_c_5351_p N_GND_c_12888_n ) capacitor c=3.46594e-19 \
 //x=55.795 //y=1.045 //x2=56.057 //y2=1.005
cc_4371 ( N_noxref_13_c_5537_p N_GND_c_12888_n ) capacitor c=0.00839795f \
 //x=56.17 //y=0.89 //x2=56.057 //y2=1.005
cc_4372 ( N_noxref_13_c_5353_p N_GND_c_12888_n ) capacitor c=4.40641e-19 \
 //x=56.325 //y=1.045 //x2=56.057 //y2=1.005
cc_4373 ( N_noxref_13_c_5392_p N_GND_c_12851_n ) capacitor c=7.75992e-19 \
 //x=54.055 //y=1.835 //x2=54.71 //y2=0.175
cc_4374 ( N_noxref_13_c_5366_p N_GND_c_12851_n ) capacitor c=3.21489e-19 \
 //x=54.14 //y=3.67 //x2=54.71 //y2=0.175
cc_4375 ( N_noxref_13_c_5351_p N_GND_c_12893_n ) capacitor c=0.00688027f \
 //x=55.795 //y=1.045 //x2=58.04 //y2=0.175
cc_4376 ( N_noxref_13_c_5299_n N_GND_c_12825_n ) capacitor c=9.32616e-19 \
 //x=54.14 //y=3.35 //x2=51.55 //y2=0.175
cc_4377 ( N_noxref_13_c_5297_n N_GND_c_12895_n ) capacitor c=0.002973f \
 //x=53.7 //y=1.75 //x2=54.88 //y2=0.175
cc_4378 ( N_noxref_13_c_5392_p N_GND_c_12895_n ) capacitor c=0.0292394f \
 //x=54.055 //y=1.835 //x2=54.88 //y2=0.175
cc_4379 ( N_noxref_13_c_5322_p N_GND_c_12895_n ) capacitor c=0.00781993f \
 //x=55.99 //y=3.35 //x2=54.88 //y2=0.175
cc_4380 ( N_noxref_13_c_5332_p N_GND_c_12895_n ) capacitor c=0.00351582f \
 //x=55.99 //y=2.26 //x2=54.88 //y2=0.175
cc_4381 ( N_noxref_13_c_5327_p N_GND_c_12895_n ) capacitor c=0.00371068f \
 //x=55.99 //y=2.26 //x2=54.88 //y2=0.175
cc_4382 ( N_noxref_13_c_5354_p N_GND_c_12895_n ) capacitor c=0.0015404f \
 //x=55.795 //y=1.7 //x2=54.88 //y2=0.175
cc_4383 ( N_noxref_13_c_5334_p N_GND_c_12895_n ) capacitor c=0.00936534f \
 //x=55.795 //y=2.095 //x2=54.88 //y2=0.175
cc_4384 ( N_noxref_13_c_5312_n N_GND_M31_noxref_d ) capacitor c=2.82748e-19 \
 //x=53.7 //y=1.18 //x2=52.54 //y2=1.045
cc_4385 ( N_noxref_13_c_5332_p N_GND_M33_noxref_d ) capacitor c=2.20438e-19 \
 //x=55.99 //y=2.26 //x2=55.87 //y2=1.045
cc_4386 ( N_noxref_13_c_5351_p N_GND_M33_noxref_d ) capacitor c=0.00192399f \
 //x=55.795 //y=1.045 //x2=55.87 //y2=1.045
cc_4387 ( N_noxref_13_c_5352_p N_GND_M33_noxref_d ) capacitor c=0.00210798f \
 //x=55.795 //y=1.39 //x2=55.87 //y2=1.045
cc_4388 ( N_noxref_13_c_5537_p N_GND_M33_noxref_d ) capacitor c=0.00472259f \
 //x=56.17 //y=0.89 //x2=55.87 //y2=1.045
cc_4389 ( N_noxref_13_c_5538_p N_GND_M33_noxref_d ) capacitor c=0.00166857f \
 //x=56.17 //y=1.545 //x2=55.87 //y2=1.045
cc_4390 ( N_noxref_13_c_5353_p N_GND_M33_noxref_d ) capacitor c=0.00230174f \
 //x=56.325 //y=1.045 //x2=55.87 //y2=1.045
cc_4391 ( N_noxref_13_c_5355_p N_GND_M33_noxref_d ) capacitor c=0.00210798f \
 //x=56.325 //y=1.39 //x2=55.87 //y2=1.045
cc_4392 ( N_noxref_13_c_5298_n N_noxref_45_c_14916_n ) capacitor c=0.00911498f \
 //x=53.785 //y=1.835 //x2=53.215 //y2=1.675
cc_4393 ( N_noxref_13_c_5392_p N_noxref_45_c_14921_n ) capacitor c=0.00399245f \
 //x=54.055 //y=1.835 //x2=54.1 //y2=0.71
cc_4394 ( N_noxref_13_c_5312_n N_noxref_45_c_14921_n ) capacitor c=0.003751f \
 //x=53.7 //y=1.18 //x2=54.1 //y2=0.71
cc_4395 ( N_noxref_13_M32_noxref_d N_noxref_45_c_14921_n ) capacitor \
 c=0.00910163f //x=53.51 //y=1.085 //x2=54.1 //y2=0.71
cc_4396 ( N_noxref_13_c_5297_n N_noxref_45_M31_noxref_s ) capacitor \
 c=0.0162484f //x=53.7 //y=1.75 //x2=52.11 //y2=0.545
cc_4397 ( N_noxref_13_c_5392_p N_noxref_45_M31_noxref_s ) capacitor \
 c=0.00640979f //x=54.055 //y=1.835 //x2=52.11 //y2=0.545
cc_4398 ( N_noxref_13_c_5366_p N_noxref_45_M31_noxref_s ) capacitor \
 c=4.17069e-19 //x=54.14 //y=3.67 //x2=52.11 //y2=0.545
cc_4399 ( N_noxref_13_c_5312_n N_noxref_45_M31_noxref_s ) capacitor \
 c=0.00905169f //x=53.7 //y=1.18 //x2=52.11 //y2=0.545
cc_4400 ( N_noxref_13_c_5313_n N_noxref_45_M31_noxref_s ) capacitor \
 c=0.0010514f //x=54.14 //y=3.51 //x2=52.11 //y2=0.545
cc_4401 ( N_noxref_13_M32_noxref_d N_noxref_45_M31_noxref_s ) capacitor \
 c=0.0275552f //x=53.51 //y=1.085 //x2=52.11 //y2=0.545
cc_4402 ( N_noxref_13_c_5334_p N_noxref_46_c_14977_n ) capacitor c=0.00262672f \
 //x=55.795 //y=2.095 //x2=55.575 //y2=1.675
cc_4403 ( N_noxref_13_c_5323_p N_noxref_46_c_14978_n ) capacitor c=0.00402188f \
 //x=55.99 //y=3.67 //x2=56.46 //y2=1.76
cc_4404 ( N_noxref_13_c_5332_p N_noxref_46_c_14978_n ) capacitor c=0.00509504f \
 //x=55.99 //y=2.26 //x2=56.46 //y2=1.76
cc_4405 ( N_noxref_13_c_5327_p N_noxref_46_c_14978_n ) capacitor c=0.00763108f \
 //x=55.99 //y=2.26 //x2=56.46 //y2=1.76
cc_4406 ( N_noxref_13_c_5354_p N_noxref_46_c_14978_n ) capacitor c=0.00697076f \
 //x=55.795 //y=1.7 //x2=56.46 //y2=1.76
cc_4407 ( N_noxref_13_c_5334_p N_noxref_46_c_14978_n ) capacitor c=0.0170561f \
 //x=55.795 //y=2.095 //x2=56.46 //y2=1.76
cc_4408 ( N_noxref_13_c_5538_p N_noxref_46_c_14978_n ) capacitor c=0.00723574f \
 //x=56.17 //y=1.545 //x2=56.46 //y2=1.76
cc_4409 ( N_noxref_13_c_5355_p N_noxref_46_c_14978_n ) capacitor c=0.00339872f \
 //x=56.325 //y=1.39 //x2=56.46 //y2=1.76
cc_4410 ( N_noxref_13_c_5334_p N_noxref_46_c_14985_n ) capacitor c=6.71402e-19 \
 //x=55.795 //y=2.095 //x2=56.545 //y2=1.675
cc_4411 ( N_noxref_13_c_5351_p N_noxref_46_M33_noxref_s ) capacitor \
 c=0.0294925f //x=55.795 //y=1.045 //x2=55.44 //y2=0.545
cc_4412 ( N_noxref_13_c_5354_p N_noxref_46_M33_noxref_s ) capacitor \
 c=3.48408e-19 //x=55.795 //y=1.7 //x2=55.44 //y2=0.545
cc_4413 ( N_noxref_13_c_5353_p N_noxref_46_M33_noxref_s ) capacitor \
 c=0.0125442f //x=56.325 //y=1.045 //x2=55.44 //y2=0.545
cc_4414 ( N_CLK_c_6121_n N_noxref_15_c_6742_n ) capacitor c=0.0292733f \
 //x=45.63 //y=4.88 //x2=45.7 //y2=5.335
cc_4415 ( N_CLK_c_6124_n N_noxref_15_c_6742_n ) capacitor c=0.0106918f \
 //x=45.63 //y=4.88 //x2=45.7 //y2=5.335
cc_4416 ( N_CLK_c_6136_n N_noxref_15_c_6742_n ) capacitor c=0.00495283f \
 //x=45.63 //y=4.88 //x2=45.7 //y2=5.335
cc_4417 ( N_CLK_M100_noxref_g N_noxref_15_c_6742_n ) capacitor c=0.00853188f \
 //x=45.6 //y=6.2 //x2=45.7 //y2=5.335
cc_4418 ( N_CLK_c_6150_n N_noxref_15_c_6742_n ) capacitor c=3.4353e-19 \
 //x=45.63 //y=4.88 //x2=45.7 //y2=5.335
cc_4419 ( N_CLK_M101_noxref_g N_noxref_15_c_6630_n ) capacitor c=0.00955829f \
 //x=46.04 //y=6.2 //x2=46.585 //y2=5.335
cc_4420 ( N_CLK_c_6110_n N_noxref_15_c_6634_n ) capacitor c=0.0205765f \
 //x=53.275 //y=4.64 //x2=47.395 //y2=5.335
cc_4421 ( CLK N_noxref_15_c_6583_n ) capacitor c=0.00197551f //x=45.63 \
 //y=3.51 //x2=47.48 //y2=3.72
cc_4422 ( CLK N_noxref_15_c_6586_n ) capacitor c=9.69745e-19 //x=45.63 \
 //y=3.51 //x2=47.48 //y2=5.25
cc_4423 ( N_CLK_c_6121_n N_noxref_15_c_6586_n ) capacitor c=9.02672e-19 \
 //x=45.63 //y=4.88 //x2=47.48 //y2=5.25
cc_4424 ( N_CLK_c_6110_n N_noxref_15_c_6586_n ) capacitor c=0.0299085f \
 //x=53.275 //y=4.64 //x2=47.48 //y2=5.25
cc_4425 ( CLK N_noxref_15_c_6753_n ) capacitor c=0.00240151f //x=56.73 \
 //y=3.51 //x2=59.32 //y2=3.725
cc_4426 ( N_CLK_c_6110_n N_noxref_15_c_6754_n ) capacitor c=0.028072f \
 //x=53.275 //y=4.64 //x2=44.942 //y2=5.335
cc_4427 ( N_CLK_c_6110_n N_noxref_15_c_6755_n ) capacitor c=0.0381719f \
 //x=53.275 //y=4.64 //x2=45.82 //y2=5.335
cc_4428 ( N_CLK_c_6136_n N_noxref_15_c_6755_n ) capacitor c=0.00132214f \
 //x=45.63 //y=4.88 //x2=45.82 //y2=5.335
cc_4429 ( N_CLK_M100_noxref_g N_noxref_15_c_6755_n ) capacitor c=0.00229818f \
 //x=45.6 //y=6.2 //x2=45.82 //y2=5.335
cc_4430 ( N_CLK_M101_noxref_g N_noxref_15_c_6755_n ) capacitor c=0.00230699f \
 //x=46.04 //y=6.2 //x2=45.82 //y2=5.335
cc_4431 ( N_CLK_c_6149_n N_noxref_15_c_6755_n ) capacitor c=0.0016987f \
 //x=45.965 //y=4.97 //x2=45.82 //y2=5.335
cc_4432 ( N_CLK_c_6110_n N_noxref_15_c_6599_n ) capacitor c=0.00354963f \
 //x=53.275 //y=4.64 //x2=49.33 //y2=4.88
cc_4433 ( N_CLK_c_6110_n N_noxref_15_c_6602_n ) capacitor c=0.0265157f \
 //x=53.275 //y=4.64 //x2=49.332 //y2=4.74
cc_4434 ( CLK N_noxref_15_c_6762_n ) capacitor c=0.00114799f //x=56.73 \
 //y=3.51 //x2=59.322 //y2=4.74
cc_4435 ( N_CLK_c_6110_n N_noxref_15_c_6693_n ) capacitor c=0.00800202f \
 //x=53.275 //y=4.64 //x2=49.165 //y2=3.88
cc_4436 ( N_CLK_c_6110_n N_noxref_15_c_6697_n ) capacitor c=0.00652937f \
 //x=53.275 //y=4.64 //x2=51.02 //y2=3.895
cc_4437 ( N_CLK_c_6110_n N_noxref_15_c_6603_n ) capacitor c=0.0104903f \
 //x=53.275 //y=4.64 //x2=50.675 //y2=3.895
cc_4438 ( N_CLK_c_6110_n N_noxref_15_c_6704_n ) capacitor c=0.00366688f \
 //x=53.275 //y=4.64 //x2=52.27 //y2=3.88
cc_4439 ( N_CLK_c_6110_n N_noxref_15_c_6708_n ) capacitor c=0.00299053f \
 //x=53.275 //y=4.64 //x2=52.87 //y2=3.89
cc_4440 ( N_CLK_c_6167_n N_noxref_15_c_6730_n ) capacitor c=0.00626771f \
 //x=53.62 //y=4.64 //x2=53.62 //y2=3.87
cc_4441 ( N_CLK_c_6167_n N_noxref_15_c_6733_n ) capacitor c=0.00648f //x=53.62 \
 //y=4.64 //x2=54.36 //y2=3.895
cc_4442 ( N_CLK_c_6167_n N_noxref_15_c_6736_n ) capacitor c=0.00368716f \
 //x=53.62 //y=4.64 //x2=55.6 //y2=3.88
cc_4443 ( CLK N_noxref_15_c_6740_n ) capacitor c=0.0236107f //x=56.73 //y=3.51 \
 //x2=56.2 //y2=3.895
cc_4444 ( N_CLK_c_6167_n N_noxref_15_c_6740_n ) capacitor c=0.0030953f \
 //x=53.62 //y=4.64 //x2=56.2 //y2=3.895
cc_4445 ( N_CLK_c_6121_n N_noxref_15_c_6773_n ) capacitor c=0.00156871f \
 //x=45.63 //y=4.88 //x2=45.82 //y2=5.56
cc_4446 ( N_CLK_M100_noxref_g N_noxref_15_c_6773_n ) capacitor c=0.0179041f \
 //x=45.6 //y=6.2 //x2=45.82 //y2=5.56
cc_4447 ( N_CLK_M101_noxref_g N_noxref_15_c_6773_n ) capacitor c=0.0179041f \
 //x=46.04 //y=6.2 //x2=45.82 //y2=5.56
cc_4448 ( N_CLK_c_6149_n N_noxref_15_c_6773_n ) capacitor c=0.00294585f \
 //x=45.965 //y=4.97 //x2=45.82 //y2=5.56
cc_4449 ( N_CLK_c_6118_n N_noxref_17_c_7499_n ) capacitor c=0.00932261f \
 //x=45.63 //y=2.375 //x2=44.52 //y2=2.375
cc_4450 ( N_CLK_c_6132_n N_noxref_17_c_7499_n ) capacitor c=5.39999e-19 \
 //x=45.63 //y=2.26 //x2=44.52 //y2=2.375
cc_4451 ( N_CLK_c_6145_n N_noxref_17_c_7499_n ) capacitor c=0.00136403f \
 //x=45.72 //y=2.095 //x2=44.52 //y2=2.375
cc_4452 ( CLK N_noxref_17_c_7358_n ) capacitor c=0.0448068f //x=45.63 //y=3.51 \
 //x2=44.52 //y2=4.095
cc_4453 ( N_CLK_c_6132_n N_noxref_17_c_7358_n ) capacitor c=3.9149e-19 \
 //x=45.63 //y=2.26 //x2=44.52 //y2=4.095
cc_4454 ( CLK N_noxref_17_c_7504_n ) capacitor c=0.00774769f //x=45.63 \
 //y=3.51 //x2=44.52 //y2=4.415
cc_4455 ( N_CLK_c_6109_n N_noxref_17_c_7504_n ) capacitor c=0.00120223f \
 //x=44.14 //y=4.62 //x2=44.52 //y2=4.415
cc_4456 ( N_CLK_c_6240_p N_noxref_17_c_7504_n ) capacitor c=0.00655819f \
 //x=44.74 //y=4.64 //x2=44.52 //y2=4.415
cc_4457 ( CLK N_noxref_17_c_7359_n ) capacitor c=0.00604802f //x=45.63 \
 //y=3.51 //x2=44.52 //y2=4.755
cc_4458 ( N_CLK_c_6121_n N_noxref_17_c_7359_n ) capacitor c=0.00757211f \
 //x=45.63 //y=4.88 //x2=44.52 //y2=4.755
cc_4459 ( N_CLK_c_6109_n N_noxref_17_c_7359_n ) capacitor c=6.82947e-19 \
 //x=44.14 //y=4.62 //x2=44.52 //y2=4.755
cc_4460 ( N_CLK_c_6240_p N_noxref_17_c_7359_n ) capacitor c=0.030731f \
 //x=44.74 //y=4.64 //x2=44.52 //y2=4.755
cc_4461 ( N_CLK_c_6124_n N_noxref_17_c_7359_n ) capacitor c=0.00705538f \
 //x=45.63 //y=4.88 //x2=44.52 //y2=4.755
cc_4462 ( N_CLK_c_6110_n N_noxref_17_c_7359_n ) capacitor c=4.99762e-19 \
 //x=53.275 //y=4.64 //x2=44.52 //y2=4.755
cc_4463 ( N_CLK_c_6136_n N_noxref_17_c_7359_n ) capacitor c=2.50501e-19 \
 //x=45.63 //y=4.88 //x2=44.52 //y2=4.755
cc_4464 ( N_CLK_c_6167_n N_noxref_17_c_7376_n ) capacitor c=0.00232598f \
 //x=53.62 //y=4.64 //x2=53.4 //y2=4.415
cc_4465 ( N_CLK_c_6110_n N_noxref_17_c_7376_n ) capacitor c=0.00260076f \
 //x=53.275 //y=4.64 //x2=53.4 //y2=4.415
cc_4466 ( N_CLK_c_6167_n N_noxref_17_c_7377_n ) capacitor c=0.0265174f \
 //x=53.62 //y=4.64 //x2=53.4 //y2=4.735
cc_4467 ( N_CLK_c_6110_n N_noxref_17_c_7377_n ) capacitor c=4.19842e-19 \
 //x=53.275 //y=4.64 //x2=53.4 //y2=4.735
cc_4468 ( N_CLK_c_6160_n N_noxref_17_c_7435_n ) capacitor c=0.0247435f \
 //x=56.755 //y=4.865 //x2=56.875 //y2=5.38
cc_4469 ( N_CLK_c_6167_n N_noxref_17_c_7435_n ) capacitor c=0.00962842f \
 //x=53.62 //y=4.64 //x2=56.875 //y2=5.38
cc_4470 ( N_CLK_c_6177_n N_noxref_17_c_7435_n ) capacitor c=0.00469232f \
 //x=56.76 //y=4.88 //x2=56.875 //y2=5.38
cc_4471 ( N_CLK_M114_noxref_g N_noxref_17_c_7435_n ) capacitor c=0.00842814f \
 //x=56.77 //y=6.2 //x2=56.875 //y2=5.38
cc_4472 ( N_CLK_c_6196_n N_noxref_17_c_7435_n ) capacitor c=7.7763e-19 \
 //x=56.76 //y=4.88 //x2=56.875 //y2=5.38
cc_4473 ( N_CLK_c_6186_n N_noxref_17_c_7436_n ) capacitor c=0.00119008f \
 //x=56.765 //y=1.43 //x2=57.03 //y2=1.75
cc_4474 ( N_CLK_c_6188_n N_noxref_17_c_7436_n ) capacitor c=0.00438634f \
 //x=56.765 //y=1.74 //x2=57.03 //y2=1.75
cc_4475 ( N_CLK_c_6259_p N_noxref_17_c_7436_n ) capacitor c=0.00916852f \
 //x=57.14 //y=1.585 //x2=57.03 //y2=1.75
cc_4476 ( N_CLK_c_6192_n N_noxref_17_c_7436_n ) capacitor c=0.003249f \
 //x=57.295 //y=1.43 //x2=57.03 //y2=1.75
cc_4477 ( N_CLK_c_6261_p N_noxref_17_c_7436_n ) capacitor c=0.00341114f \
 //x=56.73 //y=2.095 //x2=57.03 //y2=1.75
cc_4478 ( N_CLK_M115_noxref_g N_noxref_17_c_7528_n ) capacitor c=0.0108037f \
 //x=57.21 //y=6.2 //x2=57.385 //y2=5.38
cc_4479 ( N_CLK_c_6259_p N_noxref_17_c_7529_n ) capacitor c=0.00194324f \
 //x=57.14 //y=1.585 //x2=57.385 //y2=1.835
cc_4480 ( N_CLK_c_6192_n N_noxref_17_c_7529_n ) capacitor c=0.00323005f \
 //x=57.295 //y=1.43 //x2=57.385 //y2=1.835
cc_4481 ( CLK N_noxref_17_c_7438_n ) capacitor c=0.0699342f //x=56.73 //y=3.51 \
 //x2=57.47 //y2=4.105
cc_4482 ( N_CLK_c_6164_n N_noxref_17_c_7438_n ) capacitor c=0.0138368f \
 //x=56.73 //y=2.26 //x2=57.47 //y2=4.105
cc_4483 ( N_CLK_c_6173_n N_noxref_17_c_7438_n ) capacitor c=9.26054e-19 \
 //x=56.73 //y=2.26 //x2=57.47 //y2=4.105
cc_4484 ( N_CLK_c_6193_n N_noxref_17_c_7438_n ) capacitor c=0.00268898f \
 //x=56.73 //y=2.26 //x2=57.47 //y2=4.105
cc_4485 ( N_CLK_c_6261_p N_noxref_17_c_7438_n ) capacitor c=0.00309058f \
 //x=56.73 //y=2.095 //x2=57.47 //y2=4.105
cc_4486 ( CLK N_noxref_17_c_7536_n ) capacitor c=0.01773f //x=56.73 //y=3.51 \
 //x2=57.47 //y2=4.425
cc_4487 ( N_CLK_c_6271_p N_noxref_17_c_7536_n ) capacitor c=9.17945e-19 \
 //x=57.135 //y=4.97 //x2=57.47 //y2=4.425
cc_4488 ( CLK N_noxref_17_c_7441_n ) capacitor c=0.0103855f //x=56.73 //y=3.51 \
 //x2=57.47 //y2=5.295
cc_4489 ( N_CLK_c_6160_n N_noxref_17_c_7441_n ) capacitor c=0.0154991f \
 //x=56.755 //y=4.865 //x2=57.47 //y2=5.295
cc_4490 ( N_CLK_c_6167_n N_noxref_17_c_7441_n ) capacitor c=0.0121988f \
 //x=53.62 //y=4.64 //x2=57.47 //y2=5.295
cc_4491 ( N_CLK_c_6177_n N_noxref_17_c_7441_n ) capacitor c=5.14671e-19 \
 //x=56.76 //y=4.88 //x2=57.47 //y2=5.295
cc_4492 ( N_CLK_c_6271_p N_noxref_17_c_7441_n ) capacitor c=0.00841383f \
 //x=57.135 //y=4.97 //x2=57.47 //y2=5.295
cc_4493 ( CLK N_noxref_17_c_7360_n ) capacitor c=3.43503e-19 //x=45.63 \
 //y=3.51 //x2=44.52 //y2=4.25
cc_4494 ( N_CLK_c_6167_n N_noxref_17_c_7445_n ) capacitor c=0.0207179f \
 //x=53.62 //y=4.64 //x2=56.11 //y2=5.56
cc_4495 ( N_CLK_M114_noxref_g N_noxref_17_c_7545_n ) capacitor c=0.00192712f \
 //x=56.77 //y=6.2 //x2=56.99 //y2=5.38
cc_4496 ( N_CLK_M115_noxref_g N_noxref_17_c_7545_n ) capacitor c=0.00298276f \
 //x=57.21 //y=6.2 //x2=56.99 //y2=5.38
cc_4497 ( N_CLK_c_6271_p N_noxref_17_c_7545_n ) capacitor c=0.0020909f \
 //x=57.135 //y=4.97 //x2=56.99 //y2=5.38
cc_4498 ( N_CLK_c_6183_n N_noxref_17_c_7454_n ) capacitor c=0.00120406f \
 //x=56.765 //y=1.085 //x2=57.03 //y2=1.18
cc_4499 ( N_CLK_c_6186_n N_noxref_17_c_7454_n ) capacitor c=0.00218694f \
 //x=56.765 //y=1.43 //x2=57.03 //y2=1.18
cc_4500 ( N_CLK_c_6284_p N_noxref_17_c_7454_n ) capacitor c=5.50523e-19 \
 //x=57.14 //y=0.93 //x2=57.03 //y2=1.18
cc_4501 ( N_CLK_c_6259_p N_noxref_17_c_7454_n ) capacitor c=5.67071e-19 \
 //x=57.14 //y=1.585 //x2=57.03 //y2=1.18
cc_4502 ( N_CLK_c_6191_n N_noxref_17_c_7454_n ) capacitor c=0.00109205f \
 //x=57.295 //y=1.085 //x2=57.03 //y2=1.18
cc_4503 ( N_CLK_c_6192_n N_noxref_17_c_7454_n ) capacitor c=0.00317092f \
 //x=57.295 //y=1.43 //x2=57.03 //y2=1.18
cc_4504 ( CLK N_noxref_17_c_7554_n ) capacitor c=9.19401e-19 //x=56.73 \
 //y=3.51 //x2=57.47 //y2=4.25
cc_4505 ( CLK N_noxref_17_c_7363_n ) capacitor c=0.0271902f //x=45.63 //y=3.51 \
 //x2=47.095 //y2=4.25
cc_4506 ( N_CLK_c_6121_n N_noxref_17_c_7363_n ) capacitor c=3.90968e-19 \
 //x=45.63 //y=4.88 //x2=47.095 //y2=4.25
cc_4507 ( N_CLK_c_6240_p N_noxref_17_c_7363_n ) capacitor c=0.0110662f \
 //x=44.74 //y=4.64 //x2=47.095 //y2=4.25
cc_4508 ( N_CLK_c_6110_n N_noxref_17_c_7363_n ) capacitor c=0.274259f \
 //x=53.275 //y=4.64 //x2=47.095 //y2=4.25
cc_4509 ( N_CLK_c_6110_n N_noxref_17_c_7390_n ) capacitor c=0.11637f \
 //x=53.275 //y=4.64 //x2=47.695 //y2=4.265
cc_4510 ( N_CLK_c_6110_n N_noxref_17_c_7391_n ) capacitor c=0.059022f \
 //x=53.275 //y=4.64 //x2=48.94 //y2=4.25
cc_4511 ( CLK N_noxref_17_c_7455_n ) capacitor c=0.0195347f //x=56.73 //y=3.51 \
 //x2=57.3 //y2=4.25
cc_4512 ( N_CLK_c_6160_n N_noxref_17_c_7455_n ) capacitor c=0.00164532f \
 //x=56.755 //y=4.865 //x2=57.3 //y2=4.25
cc_4513 ( N_CLK_c_6167_n N_noxref_17_c_7455_n ) capacitor c=0.305225f \
 //x=53.62 //y=4.64 //x2=57.3 //y2=4.25
cc_4514 ( N_CLK_c_6110_n N_noxref_17_c_7364_n ) capacitor c=0.363793f \
 //x=53.275 //y=4.64 //x2=53.565 //y2=4.25
cc_4515 ( CLK N_noxref_17_c_7565_n ) capacitor c=0.00330634f //x=56.73 \
 //y=3.51 //x2=59.19 //y2=4.27
cc_4516 ( CLK N_noxref_17_c_7361_n ) capacitor c=0.00243311f //x=45.63 \
 //y=3.51 //x2=44.685 //y2=4.255
cc_4517 ( N_CLK_c_6109_n N_noxref_17_c_7361_n ) capacitor c=0.0364798f \
 //x=44.14 //y=4.62 //x2=44.685 //y2=4.255
cc_4518 ( CLK N_noxref_17_c_7568_n ) capacitor c=3.9149e-19 //x=45.63 //y=3.51 \
 //x2=44.52 //y2=2.26
cc_4519 ( N_CLK_c_6118_n N_noxref_17_c_7568_n ) capacitor c=5.40058e-19 \
 //x=45.63 //y=2.375 //x2=44.52 //y2=2.26
cc_4520 ( N_CLK_c_6132_n N_noxref_17_c_7568_n ) capacitor c=0.00125213f \
 //x=45.63 //y=2.26 //x2=44.52 //y2=2.26
cc_4521 ( N_CLK_c_6145_n N_noxref_17_c_7568_n ) capacitor c=0.0020754f \
 //x=45.72 //y=2.095 //x2=44.52 //y2=2.26
cc_4522 ( N_CLK_c_6121_n N_noxref_17_c_7572_n ) capacitor c=5.84784e-19 \
 //x=45.63 //y=4.88 //x2=44.52 //y2=4.88
cc_4523 ( N_CLK_c_6136_n N_noxref_17_c_7572_n ) capacitor c=0.00114249f \
 //x=45.63 //y=4.88 //x2=44.52 //y2=4.88
cc_4524 ( N_CLK_c_6150_n N_noxref_17_c_7572_n ) capacitor c=0.00124807f \
 //x=45.63 //y=4.88 //x2=44.52 //y2=4.88
cc_4525 ( N_CLK_c_6160_n N_noxref_17_c_7575_n ) capacitor c=8.41381e-19 \
 //x=56.755 //y=4.865 //x2=56.99 //y2=5.56
cc_4526 ( N_CLK_M114_noxref_g N_noxref_17_c_7575_n ) capacitor c=0.0178987f \
 //x=56.77 //y=6.2 //x2=56.99 //y2=5.56
cc_4527 ( N_CLK_M115_noxref_g N_noxref_17_c_7575_n ) capacitor c=0.0178506f \
 //x=57.21 //y=6.2 //x2=56.99 //y2=5.56
cc_4528 ( N_CLK_c_6271_p N_noxref_17_c_7575_n ) capacitor c=0.00291714f \
 //x=57.135 //y=4.97 //x2=56.99 //y2=5.56
cc_4529 ( N_CLK_M100_noxref_g N_noxref_17_M98_noxref_g ) capacitor \
 c=0.0106276f //x=45.6 //y=6.2 //x2=44.72 //y2=6.2
cc_4530 ( N_CLK_M100_noxref_g N_noxref_17_M99_noxref_g ) capacitor c=0.107144f \
 //x=45.6 //y=6.2 //x2=45.16 //y2=6.2
cc_4531 ( N_CLK_M101_noxref_g N_noxref_17_M99_noxref_g ) capacitor \
 c=0.0101598f //x=46.04 //y=6.2 //x2=45.16 //y2=6.2
cc_4532 ( N_CLK_c_6316_p N_noxref_17_c_7582_n ) capacitor c=5.72528e-19 \
 //x=45.195 //y=1.09 //x2=44.22 //y2=1.055
cc_4533 ( N_CLK_c_6316_p N_noxref_17_c_7583_n ) capacitor c=0.00150277f \
 //x=45.195 //y=1.09 //x2=44.22 //y2=1.4
cc_4534 ( N_CLK_c_6318_p N_noxref_17_c_7584_n ) capacitor c=0.00111227f \
 //x=45.195 //y=1.4 //x2=44.22 //y2=1.71
cc_4535 ( N_CLK_c_6118_n N_noxref_17_c_7585_n ) capacitor c=0.00142893f \
 //x=45.63 //y=2.375 //x2=44.22 //y2=2.095
cc_4536 ( N_CLK_c_6132_n N_noxref_17_c_7585_n ) capacitor c=0.00214573f \
 //x=45.63 //y=2.26 //x2=44.22 //y2=2.095
cc_4537 ( N_CLK_c_6145_n N_noxref_17_c_7585_n ) capacitor c=0.00964411f \
 //x=45.72 //y=2.095 //x2=44.22 //y2=2.095
cc_4538 ( N_CLK_c_6316_p N_noxref_17_c_7588_n ) capacitor c=0.0160123f \
 //x=45.195 //y=1.09 //x2=44.75 //y2=1.055
cc_4539 ( N_CLK_c_6142_n N_noxref_17_c_7588_n ) capacitor c=9.19165e-19 \
 //x=45.72 //y=1.09 //x2=44.75 //y2=1.055
cc_4540 ( N_CLK_c_6318_p N_noxref_17_c_7590_n ) capacitor c=0.0124075f \
 //x=45.195 //y=1.4 //x2=44.75 //y2=1.4
cc_4541 ( N_CLK_c_6143_n N_noxref_17_c_7590_n ) capacitor c=0.0010154f \
 //x=45.72 //y=1.4 //x2=44.75 //y2=1.4
cc_4542 ( N_CLK_c_6144_n N_noxref_17_c_7590_n ) capacitor c=9.23422e-19 \
 //x=45.72 //y=1.63 //x2=44.75 //y2=1.4
cc_4543 ( N_CLK_c_6121_n N_noxref_17_c_7593_n ) capacitor c=0.00109563f \
 //x=45.63 //y=4.88 //x2=45.085 //y2=4.97
cc_4544 ( N_CLK_c_6136_n N_noxref_17_c_7593_n ) capacitor c=0.00133699f \
 //x=45.63 //y=4.88 //x2=45.085 //y2=4.97
cc_4545 ( N_CLK_c_6150_n N_noxref_17_c_7593_n ) capacitor c=0.0163966f \
 //x=45.63 //y=4.88 //x2=45.085 //y2=4.97
cc_4546 ( N_CLK_c_6121_n N_noxref_17_c_7596_n ) capacitor c=8.39124e-19 \
 //x=45.63 //y=4.88 //x2=44.795 //y2=4.97
cc_4547 ( N_CLK_c_6240_p N_noxref_17_c_7596_n ) capacitor c=0.00101612f \
 //x=44.74 //y=4.64 //x2=44.795 //y2=4.97
cc_4548 ( N_CLK_c_6136_n N_noxref_17_c_7596_n ) capacitor c=0.00129812f \
 //x=45.63 //y=4.88 //x2=44.795 //y2=4.97
cc_4549 ( N_CLK_c_6150_n N_noxref_17_c_7596_n ) capacitor c=0.00409733f \
 //x=45.63 //y=4.88 //x2=44.795 //y2=4.97
cc_4550 ( N_CLK_c_6167_n N_noxref_17_c_7420_n ) capacitor c=7.54771e-19 \
 //x=53.62 //y=4.64 //x2=53.43 //y2=4.88
cc_4551 ( N_CLK_c_6183_n N_noxref_17_M34_noxref_d ) capacitor c=0.00137165f \
 //x=56.765 //y=1.085 //x2=56.84 //y2=1.085
cc_4552 ( N_CLK_c_6186_n N_noxref_17_M34_noxref_d ) capacitor c=0.00237422f \
 //x=56.765 //y=1.43 //x2=56.84 //y2=1.085
cc_4553 ( N_CLK_c_6284_p N_noxref_17_M34_noxref_d ) capacitor c=0.0020782f \
 //x=57.14 //y=0.93 //x2=56.84 //y2=1.085
cc_4554 ( N_CLK_c_6259_p N_noxref_17_M34_noxref_d ) capacitor c=0.00356097f \
 //x=57.14 //y=1.585 //x2=56.84 //y2=1.085
cc_4555 ( N_CLK_c_6191_n N_noxref_17_M34_noxref_d ) capacitor c=8.50095e-19 \
 //x=57.295 //y=1.085 //x2=56.84 //y2=1.085
cc_4556 ( N_CLK_c_6192_n N_noxref_17_M34_noxref_d ) capacitor c=0.00237422f \
 //x=57.295 //y=1.43 //x2=56.84 //y2=1.085
cc_4557 ( N_CLK_c_5953_n N_noxref_19_c_8546_n ) capacitor c=0.0283146f \
 //x=41.545 //y=4.62 //x2=38.6 //y2=4.735
cc_4558 ( CLK N_noxref_19_c_8591_n ) capacitor c=0.0137581f //x=45.63 //y=3.51 \
 //x2=49.685 //y2=2.4
cc_4559 ( N_CLK_c_6118_n N_noxref_19_c_8591_n ) capacitor c=0.0174197f \
 //x=45.63 //y=2.375 //x2=49.685 //y2=2.4
cc_4560 ( N_CLK_c_6132_n N_noxref_19_c_8591_n ) capacitor c=5.2767e-19 \
 //x=45.63 //y=2.26 //x2=49.685 //y2=2.4
cc_4561 ( N_CLK_c_6145_n N_noxref_19_c_8591_n ) capacitor c=4.03361e-19 \
 //x=45.72 //y=2.095 //x2=49.685 //y2=2.4
cc_4562 ( CLK N_noxref_19_c_8645_n ) capacitor c=0.0140253f //x=56.73 //y=3.51 \
 //x2=50.285 //y2=2.37
cc_4563 ( N_CLK_c_6164_n N_noxref_19_c_8645_n ) capacitor c=0.0172402f \
 //x=56.73 //y=2.26 //x2=50.285 //y2=2.37
cc_4564 ( N_CLK_c_6193_n N_noxref_19_c_8645_n ) capacitor c=2.98635e-19 \
 //x=56.73 //y=2.26 //x2=50.285 //y2=2.37
cc_4565 ( N_CLK_c_5716_n N_noxref_20_c_9136_n ) capacitor c=0.00411243f \
 //x=17.32 //y=4.62 //x2=17.14 //y2=4.735
cc_4566 ( N_CLK_c_5698_n N_noxref_20_c_9136_n ) capacitor c=0.0232878f \
 //x=17.235 //y=4.62 //x2=17.14 //y2=4.735
cc_4567 ( N_CLK_c_5711_n N_noxref_20_c_9191_n ) capacitor c=0.00671129f \
 //x=20.085 //y=4.62 //x2=20.615 //y2=5.38
cc_4568 ( N_CLK_c_5998_n N_noxref_20_c_9275_n ) capacitor c=0.00769017f \
 //x=22.68 //y=4.62 //x2=21.125 //y2=5.38
cc_4569 ( CLK N_noxref_20_c_9194_n ) capacitor c=9.2282e-19 //x=24.17 //y=3.51 \
 //x2=21.21 //y2=2.995
cc_4570 ( N_CLK_c_5998_n N_noxref_20_c_9283_n ) capacitor c=0.00279159f \
 //x=22.68 //y=4.62 //x2=21.21 //y2=3.315
cc_4571 ( CLK N_noxref_20_c_9196_n ) capacitor c=0.00139445f //x=24.17 \
 //y=3.51 //x2=21.21 //y2=5.295
cc_4572 ( N_CLK_c_5848_n N_noxref_20_c_9196_n ) capacitor c=4.08516e-19 \
 //x=24.17 //y=4.88 //x2=21.21 //y2=5.295
cc_4573 ( N_CLK_c_5771_n N_noxref_20_c_9196_n ) capacitor c=4.14284e-19 \
 //x=20.685 //y=4.635 //x2=21.21 //y2=5.295
cc_4574 ( N_CLK_c_5998_n N_noxref_20_c_9196_n ) capacitor c=0.0338593f \
 //x=22.68 //y=4.62 //x2=21.21 //y2=5.295
cc_4575 ( N_CLK_c_5711_n N_noxref_20_c_9201_n ) capacitor c=0.0152288f \
 //x=20.085 //y=4.62 //x2=19.85 //y2=5.56
cc_4576 ( N_CLK_c_5771_n N_noxref_20_c_9292_n ) capacitor c=0.0139915f \
 //x=20.685 //y=4.635 //x2=20.73 //y2=5.38
cc_4577 ( N_CLK_c_5711_n N_noxref_20_c_9211_n ) capacitor c=0.00535571f \
 //x=20.085 //y=4.62 //x2=21.04 //y2=3.14
cc_4578 ( N_CLK_c_5716_n N_noxref_20_c_9211_n ) capacitor c=0.00310988f \
 //x=17.32 //y=4.62 //x2=21.04 //y2=3.14
cc_4579 ( N_CLK_c_5771_n N_noxref_20_c_9211_n ) capacitor c=0.00772894f \
 //x=20.685 //y=4.635 //x2=21.04 //y2=3.14
cc_4580 ( CLK N_noxref_20_c_9305_n ) capacitor c=0.0282104f //x=24.17 //y=3.51 \
 //x2=25.07 //y2=3.125
cc_4581 ( N_CLK_c_5998_n N_noxref_20_c_9305_n ) capacitor c=0.0461133f \
 //x=22.68 //y=4.62 //x2=25.07 //y2=3.125
cc_4582 ( N_CLK_c_5852_n N_noxref_20_c_9305_n ) capacitor c=0.00688442f \
 //x=31.815 //y=4.64 //x2=25.07 //y2=3.125
cc_4583 ( CLK N_noxref_20_c_9345_n ) capacitor c=5.32263e-19 //x=35.27 \
 //y=3.51 //x2=34.74 //y2=3.125
cc_4584 ( CLK N_noxref_20_c_9365_n ) capacitor c=0.0230768f //x=35.27 //y=3.51 \
 //x2=46.36 //y2=3.14
cc_4585 ( CLK N_noxref_20_c_9365_n ) capacitor c=0.0283037f //x=45.63 //y=3.51 \
 //x2=46.36 //y2=3.14
cc_4586 ( N_CLK_c_5953_n N_noxref_20_c_9365_n ) capacitor c=0.0111153f \
 //x=41.545 //y=4.62 //x2=46.36 //y2=3.14
cc_4587 ( N_CLK_c_6033_n N_noxref_20_c_9365_n ) capacitor c=0.049612f \
 //x=42.145 //y=4.635 //x2=46.36 //y2=3.14
cc_4588 ( N_CLK_c_6109_n N_noxref_20_c_9365_n ) capacitor c=0.00546002f \
 //x=44.14 //y=4.62 //x2=46.36 //y2=3.14
cc_4589 ( N_CLK_c_6110_n N_noxref_20_c_9365_n ) capacitor c=0.00688269f \
 //x=53.275 //y=4.64 //x2=46.36 //y2=3.14
cc_4590 ( CLK N_noxref_20_c_9455_n ) capacitor c=0.0262572f //x=56.73 //y=3.51 \
 //x2=56.2 //y2=3.125
cc_4591 ( N_CLK_c_5609_n N_VDD_c_10364_n ) capacitor c=4.52718e-19 //x=2.71 \
 //y=4.88 //x2=1.23 //y2=7.58
cc_4592 ( N_CLK_M48_noxref_g N_VDD_c_10369_n ) capacitor c=0.00704788f \
 //x=2.68 //y=6.2 //x2=3.255 //y2=7.585
cc_4593 ( N_CLK_M49_noxref_g N_VDD_c_10369_n ) capacitor c=0.00755544f \
 //x=3.12 //y=6.2 //x2=3.255 //y2=7.585
cc_4594 ( N_CLK_M62_noxref_g N_VDD_c_10487_n ) capacitor c=0.00697352f \
 //x=13.85 //y=6.2 //x2=14.425 //y2=7.585
cc_4595 ( N_CLK_M63_noxref_g N_VDD_c_10487_n ) capacitor c=0.00755544f \
 //x=14.29 //y=6.2 //x2=14.425 //y2=7.585
cc_4596 ( N_CLK_M74_noxref_g N_VDD_c_10673_n ) capacitor c=0.00704788f \
 //x=24.14 //y=6.2 //x2=24.715 //y2=7.585
cc_4597 ( N_CLK_M75_noxref_g N_VDD_c_10673_n ) capacitor c=0.00755544f \
 //x=24.58 //y=6.2 //x2=24.715 //y2=7.585
cc_4598 ( N_CLK_M88_noxref_g N_VDD_c_10789_n ) capacitor c=0.00697352f \
 //x=35.31 //y=6.2 //x2=35.885 //y2=7.585
cc_4599 ( N_CLK_M89_noxref_g N_VDD_c_10789_n ) capacitor c=0.00755544f \
 //x=35.75 //y=6.2 //x2=35.885 //y2=7.585
cc_4600 ( N_CLK_M100_noxref_g N_VDD_c_10993_n ) capacitor c=0.00704788f \
 //x=45.6 //y=6.2 //x2=46.175 //y2=7.585
cc_4601 ( N_CLK_M101_noxref_g N_VDD_c_10993_n ) capacitor c=0.00755544f \
 //x=46.04 //y=6.2 //x2=46.175 //y2=7.585
cc_4602 ( N_CLK_M114_noxref_g N_VDD_c_10995_n ) capacitor c=0.00697352f \
 //x=56.77 //y=6.2 //x2=57.345 //y2=7.585
cc_4603 ( N_CLK_M115_noxref_g N_VDD_c_10995_n ) capacitor c=0.00755544f \
 //x=57.21 //y=6.2 //x2=57.345 //y2=7.585
cc_4604 ( N_CLK_c_5597_n N_VDD_c_10264_n ) capacitor c=0.0263067f //x=10.1 \
 //y=4.62 //x2=5.3 //y2=7.585
cc_4605 ( N_CLK_c_5609_n N_VDD_c_10264_n ) capacitor c=3.15216e-19 //x=2.71 \
 //y=4.88 //x2=5.3 //y2=7.585
cc_4606 ( N_CLK_c_5597_n N_VDD_c_10269_n ) capacitor c=0.0264152f //x=10.1 \
 //y=4.62 //x2=8.63 //y2=7.585
cc_4607 ( N_CLK_c_5643_n N_VDD_c_10322_n ) capacitor c=0.0263693f //x=14.395 \
 //y=4.642 //x2=11.96 //y2=7.585
cc_4608 ( N_CLK_c_5691_n N_VDD_c_10391_n ) capacitor c=5.90547e-19 //x=14.763 \
 //y=4.642 //x2=15.29 //y2=7.585
cc_4609 ( N_CLK_c_5698_n N_VDD_c_10391_n ) capacitor c=0.0254318f //x=17.235 \
 //y=4.62 //x2=15.29 //y2=7.585
cc_4610 ( N_CLK_c_5651_n N_VDD_c_10391_n ) capacitor c=0.00228191f //x=13.84 \
 //y=4.88 //x2=15.29 //y2=7.585
cc_4611 ( N_CLK_c_5815_n N_VDD_c_10391_n ) capacitor c=0.0129149f //x=14.215 \
 //y=4.97 //x2=15.29 //y2=7.585
cc_4612 ( N_CLK_c_5670_n N_VDD_c_10391_n ) capacitor c=2.73429e-19 //x=13.84 \
 //y=4.88 //x2=15.29 //y2=7.585
cc_4613 ( N_CLK_c_5711_n N_VDD_c_10439_n ) capacitor c=0.0263928f //x=20.085 \
 //y=4.62 //x2=18.62 //y2=7.585
cc_4614 ( N_CLK_c_5998_n N_VDD_c_10515_n ) capacitor c=0.0273005f //x=22.68 \
 //y=4.62 //x2=21.95 //y2=7.585
cc_4615 ( N_CLK_c_5863_n N_VDD_c_10515_n ) capacitor c=4.52718e-19 //x=24.17 \
 //y=4.88 //x2=21.95 //y2=7.585
cc_4616 ( N_CLK_c_5852_n N_VDD_c_10570_n ) capacitor c=0.0264949f //x=31.815 \
 //y=4.64 //x2=26.76 //y2=7.585
cc_4617 ( N_CLK_c_5863_n N_VDD_c_10570_n ) capacitor c=3.15216e-19 //x=24.17 \
 //y=4.88 //x2=26.76 //y2=7.585
cc_4618 ( N_CLK_c_5852_n N_VDD_c_10575_n ) capacitor c=0.0264152f //x=31.815 \
 //y=4.64 //x2=30.09 //y2=7.585
cc_4619 ( N_CLK_c_5897_n N_VDD_c_10628_n ) capacitor c=0.026372f //x=35.87 \
 //y=4.65 //x2=33.42 //y2=7.585
cc_4620 ( N_CLK_c_5947_n N_VDD_c_10697_n ) capacitor c=8.19895e-19 //x=36.215 \
 //y=4.65 //x2=36.75 //y2=7.585
cc_4621 ( N_CLK_c_5953_n N_VDD_c_10697_n ) capacitor c=0.0262406f //x=41.545 \
 //y=4.62 //x2=36.75 //y2=7.585
cc_4622 ( N_CLK_c_5905_n N_VDD_c_10697_n ) capacitor c=0.00228191f //x=35.3 \
 //y=4.88 //x2=36.75 //y2=7.585
cc_4623 ( N_CLK_c_6073_n N_VDD_c_10697_n ) capacitor c=0.0129149f //x=35.675 \
 //y=4.97 //x2=36.75 //y2=7.585
cc_4624 ( N_CLK_c_5924_n N_VDD_c_10697_n ) capacitor c=2.73429e-19 //x=35.3 \
 //y=4.88 //x2=36.75 //y2=7.585
cc_4625 ( N_CLK_c_5953_n N_VDD_c_10746_n ) capacitor c=0.0264234f //x=41.545 \
 //y=4.62 //x2=40.08 //y2=7.585
cc_4626 ( N_CLK_c_6109_n N_VDD_c_10822_n ) capacitor c=0.0273005f //x=44.14 \
 //y=4.62 //x2=43.41 //y2=7.585
cc_4627 ( N_CLK_c_6136_n N_VDD_c_10822_n ) capacitor c=4.52718e-19 //x=45.63 \
 //y=4.88 //x2=43.41 //y2=7.585
cc_4628 ( N_CLK_c_6110_n N_VDD_c_10900_n ) capacitor c=0.0264949f //x=53.275 \
 //y=4.64 //x2=48.22 //y2=7.585
cc_4629 ( N_CLK_c_6136_n N_VDD_c_10900_n ) capacitor c=3.15216e-19 //x=45.63 \
 //y=4.88 //x2=48.22 //y2=7.585
cc_4630 ( N_CLK_c_6110_n N_VDD_c_10865_n ) capacitor c=0.0264152f //x=53.275 \
 //y=4.64 //x2=51.55 //y2=7.585
cc_4631 ( N_CLK_c_6167_n N_VDD_c_10958_n ) capacitor c=0.0262153f //x=53.62 \
 //y=4.64 //x2=54.88 //y2=7.585
cc_4632 ( N_CLK_c_6177_n N_VDD_c_11025_n ) capacitor c=0.00228191f //x=56.76 \
 //y=4.88 //x2=58.21 //y2=7.585
cc_4633 ( N_CLK_c_6271_p N_VDD_c_11025_n ) capacitor c=0.0129149f //x=57.135 \
 //y=4.97 //x2=58.21 //y2=7.585
cc_4634 ( N_CLK_c_6196_n N_VDD_c_11025_n ) capacitor c=2.73429e-19 //x=56.76 \
 //y=4.88 //x2=58.21 //y2=7.585
cc_4635 ( N_CLK_M48_noxref_g N_VDD_M47_noxref_d ) capacitor c=0.015318f \
 //x=2.68 //y=6.2 //x2=2.315 //y2=5.2
cc_4636 ( N_CLK_M49_noxref_g N_VDD_M49_noxref_d ) capacitor c=0.015318f \
 //x=3.12 //y=6.2 //x2=3.195 //y2=5.2
cc_4637 ( N_CLK_c_5597_n N_VDD_M52_noxref_s ) capacitor c=0.00752361f //x=10.1 \
 //y=4.62 //x2=5.955 //y2=5.2
cc_4638 ( N_CLK_c_5597_n N_VDD_M56_noxref_s ) capacitor c=0.00765173f //x=10.1 \
 //y=4.62 //x2=9.285 //y2=5.2
cc_4639 ( N_CLK_c_5643_n N_VDD_M60_noxref_s ) capacitor c=0.00765173f \
 //x=14.395 //y=4.642 //x2=12.615 //y2=5.2
cc_4640 ( N_CLK_M62_noxref_g N_VDD_M61_noxref_d ) capacitor c=0.015318f \
 //x=13.85 //y=6.2 //x2=13.485 //y2=5.2
cc_4641 ( N_CLK_c_5670_n N_VDD_M61_noxref_d ) capacitor c=3.50465e-19 \
 //x=13.84 //y=4.88 //x2=13.485 //y2=5.2
cc_4642 ( N_CLK_M63_noxref_g N_VDD_M63_noxref_d ) capacitor c=0.0430452f \
 //x=14.29 //y=6.2 //x2=14.365 //y2=5.2
cc_4643 ( N_CLK_c_5698_n N_VDD_M64_noxref_s ) capacitor c=0.00737279f \
 //x=17.235 //y=4.62 //x2=15.945 //y2=5.2
cc_4644 ( N_CLK_c_5711_n N_VDD_M68_noxref_s ) capacitor c=0.00752472f \
 //x=20.085 //y=4.62 //x2=19.275 //y2=5.2
cc_4645 ( N_CLK_c_5998_n N_VDD_M72_noxref_s ) capacitor c=9.10057e-19 \
 //x=22.68 //y=4.62 //x2=22.905 //y2=5.2
cc_4646 ( N_CLK_M74_noxref_g N_VDD_M73_noxref_d ) capacitor c=0.015318f \
 //x=24.14 //y=6.2 //x2=23.775 //y2=5.2
cc_4647 ( N_CLK_M75_noxref_g N_VDD_M75_noxref_d ) capacitor c=0.015318f \
 //x=24.58 //y=6.2 //x2=24.655 //y2=5.2
cc_4648 ( N_CLK_c_5852_n N_VDD_M78_noxref_s ) capacitor c=0.00752361f \
 //x=31.815 //y=4.64 //x2=27.415 //y2=5.2
cc_4649 ( N_CLK_c_5852_n N_VDD_M82_noxref_s ) capacitor c=0.00765173f \
 //x=31.815 //y=4.64 //x2=30.745 //y2=5.2
cc_4650 ( N_CLK_c_5897_n N_VDD_M86_noxref_s ) capacitor c=0.00765173f \
 //x=35.87 //y=4.65 //x2=34.075 //y2=5.2
cc_4651 ( N_CLK_M88_noxref_g N_VDD_M87_noxref_d ) capacitor c=0.015318f \
 //x=35.31 //y=6.2 //x2=34.945 //y2=5.2
cc_4652 ( N_CLK_c_5924_n N_VDD_M87_noxref_d ) capacitor c=3.50465e-19 //x=35.3 \
 //y=4.88 //x2=34.945 //y2=5.2
cc_4653 ( N_CLK_M89_noxref_g N_VDD_M89_noxref_d ) capacitor c=0.0430452f \
 //x=35.75 //y=6.2 //x2=35.825 //y2=5.2
cc_4654 ( N_CLK_c_5953_n N_VDD_M90_noxref_s ) capacitor c=0.00752342f \
 //x=41.545 //y=4.62 //x2=37.405 //y2=5.2
cc_4655 ( N_CLK_c_5953_n N_VDD_M94_noxref_s ) capacitor c=0.00752472f \
 //x=41.545 //y=4.62 //x2=40.735 //y2=5.2
cc_4656 ( N_CLK_c_6109_n N_VDD_M98_noxref_s ) capacitor c=9.10057e-19 \
 //x=44.14 //y=4.62 //x2=44.365 //y2=5.2
cc_4657 ( N_CLK_M100_noxref_g N_VDD_M99_noxref_d ) capacitor c=0.015318f \
 //x=45.6 //y=6.2 //x2=45.235 //y2=5.2
cc_4658 ( N_CLK_M101_noxref_g N_VDD_M101_noxref_d ) capacitor c=0.015318f \
 //x=46.04 //y=6.2 //x2=46.115 //y2=5.2
cc_4659 ( N_CLK_c_6110_n N_VDD_M104_noxref_s ) capacitor c=0.00752361f \
 //x=53.275 //y=4.64 //x2=48.875 //y2=5.2
cc_4660 ( N_CLK_c_6110_n N_VDD_M108_noxref_s ) capacitor c=0.00765173f \
 //x=53.275 //y=4.64 //x2=52.205 //y2=5.2
cc_4661 ( N_CLK_c_6167_n N_VDD_M112_noxref_s ) capacitor c=0.00765173f \
 //x=53.62 //y=4.64 //x2=55.535 //y2=5.2
cc_4662 ( N_CLK_M114_noxref_g N_VDD_M113_noxref_d ) capacitor c=0.015318f \
 //x=56.77 //y=6.2 //x2=56.405 //y2=5.2
cc_4663 ( N_CLK_c_6196_n N_VDD_M113_noxref_d ) capacitor c=3.50465e-19 \
 //x=56.76 //y=4.88 //x2=56.405 //y2=5.2
cc_4664 ( N_CLK_M115_noxref_g N_VDD_M115_noxref_d ) capacitor c=0.0430452f \
 //x=57.21 //y=6.2 //x2=57.285 //y2=5.2
cc_4665 ( N_CLK_c_5615_n N_noxref_23_c_11678_n ) capacitor c=0.00123426f \
 //x=2.8 //y=1.09 //x2=3.505 //y2=1.175
cc_4666 ( N_CLK_c_5616_n N_noxref_23_c_11678_n ) capacitor c=0.0129288f \
 //x=2.8 //y=1.4 //x2=3.505 //y2=1.175
cc_4667 ( N_CLK_c_5617_n N_noxref_23_c_11678_n ) capacitor c=0.00132209f \
 //x=2.8 //y=1.63 //x2=3.505 //y2=1.175
cc_4668 ( N_CLK_c_5591_n N_noxref_23_M1_noxref_d ) capacitor c=0.00610765f \
 //x=2.71 //y=2.375 //x2=2.35 //y2=1.09
cc_4669 ( N_CLK_c_5605_n N_noxref_23_M1_noxref_d ) capacitor c=2.2052e-19 \
 //x=2.71 //y=2.26 //x2=2.35 //y2=1.09
cc_4670 ( N_CLK_c_5798_n N_noxref_23_M1_noxref_d ) capacitor c=0.00253592f \
 //x=2.275 //y=1.09 //x2=2.35 //y2=1.09
cc_4671 ( N_CLK_c_5801_n N_noxref_23_M1_noxref_d ) capacitor c=0.00604634f \
 //x=2.275 //y=1.4 //x2=2.35 //y2=1.09
cc_4672 ( N_CLK_c_6456_p N_noxref_23_M1_noxref_d ) capacitor c=0.002686f \
 //x=2.645 //y=0.935 //x2=2.35 //y2=1.09
cc_4673 ( N_CLK_c_6457_p N_noxref_23_M1_noxref_d ) capacitor c=0.00251995f \
 //x=2.645 //y=1.555 //x2=2.35 //y2=1.09
cc_4674 ( N_CLK_c_5615_n N_noxref_23_M1_noxref_d ) capacitor c=0.00314523f \
 //x=2.8 //y=1.09 //x2=2.35 //y2=1.09
cc_4675 ( N_CLK_c_5616_n N_noxref_23_M1_noxref_d ) capacitor c=0.00168289f \
 //x=2.8 //y=1.4 //x2=2.35 //y2=1.09
cc_4676 ( N_CLK_c_5617_n N_noxref_23_M1_noxref_d ) capacitor c=0.00111165f \
 //x=2.8 //y=1.63 //x2=2.35 //y2=1.09
cc_4677 ( N_CLK_c_5615_n N_noxref_23_M2_noxref_s ) capacitor c=7.21316e-19 \
 //x=2.8 //y=1.09 //x2=3.455 //y2=0.555
cc_4678 ( N_CLK_c_5616_n N_noxref_23_M2_noxref_s ) capacitor c=0.00365271f \
 //x=2.8 //y=1.4 //x2=3.455 //y2=0.555
cc_4679 ( N_CLK_c_5618_n N_noxref_23_M2_noxref_s ) capacitor c=9.86711e-19 \
 //x=2.8 //y=2.095 //x2=3.455 //y2=0.555
cc_4680 ( N_CLK_c_5869_n N_noxref_24_c_11741_n ) capacitor c=0.00123426f \
 //x=24.26 //y=1.09 //x2=24.965 //y2=1.175
cc_4681 ( N_CLK_c_5870_n N_noxref_24_c_11741_n ) capacitor c=0.0129288f \
 //x=24.26 //y=1.4 //x2=24.965 //y2=1.175
cc_4682 ( N_CLK_c_5871_n N_noxref_24_c_11741_n ) capacitor c=0.00132209f \
 //x=24.26 //y=1.63 //x2=24.965 //y2=1.175
cc_4683 ( N_CLK_c_5845_n N_noxref_24_M14_noxref_d ) capacitor c=0.00604095f \
 //x=24.17 //y=2.375 //x2=23.81 //y2=1.09
cc_4684 ( N_CLK_c_5859_n N_noxref_24_M14_noxref_d ) capacitor c=2.2052e-19 \
 //x=24.17 //y=2.26 //x2=23.81 //y2=1.09
cc_4685 ( N_CLK_c_6056_n N_noxref_24_M14_noxref_d ) capacitor c=0.00253592f \
 //x=23.735 //y=1.09 //x2=23.81 //y2=1.09
cc_4686 ( N_CLK_c_6059_n N_noxref_24_M14_noxref_d ) capacitor c=0.00604066f \
 //x=23.735 //y=1.4 //x2=23.81 //y2=1.09
cc_4687 ( N_CLK_c_6471_p N_noxref_24_M14_noxref_d ) capacitor c=0.002686f \
 //x=24.105 //y=0.935 //x2=23.81 //y2=1.09
cc_4688 ( N_CLK_c_6472_p N_noxref_24_M14_noxref_d ) capacitor c=0.00251995f \
 //x=24.105 //y=1.555 //x2=23.81 //y2=1.09
cc_4689 ( N_CLK_c_5869_n N_noxref_24_M14_noxref_d ) capacitor c=0.00314523f \
 //x=24.26 //y=1.09 //x2=23.81 //y2=1.09
cc_4690 ( N_CLK_c_5870_n N_noxref_24_M14_noxref_d ) capacitor c=0.00168289f \
 //x=24.26 //y=1.4 //x2=23.81 //y2=1.09
cc_4691 ( N_CLK_c_5871_n N_noxref_24_M14_noxref_d ) capacitor c=0.00111165f \
 //x=24.26 //y=1.63 //x2=23.81 //y2=1.09
cc_4692 ( N_CLK_c_5869_n N_noxref_24_M15_noxref_s ) capacitor c=7.21316e-19 \
 //x=24.26 //y=1.09 //x2=24.915 //y2=0.555
cc_4693 ( N_CLK_c_5870_n N_noxref_24_M15_noxref_s ) capacitor c=0.00365271f \
 //x=24.26 //y=1.4 //x2=24.915 //y2=0.555
cc_4694 ( N_CLK_c_5872_n N_noxref_24_M15_noxref_s ) capacitor c=9.86711e-19 \
 //x=24.26 //y=2.095 //x2=24.915 //y2=0.555
cc_4695 ( N_CLK_c_5953_n N_noxref_25_c_11788_n ) capacitor c=0.00671129f \
 //x=41.545 //y=4.62 //x2=42.075 //y2=5.38
cc_4696 ( N_CLK_c_6109_n N_noxref_25_c_11821_n ) capacitor c=0.00774402f \
 //x=44.14 //y=4.62 //x2=42.585 //y2=5.38
cc_4697 ( CLK N_noxref_25_c_11792_n ) capacitor c=0.00206279f //x=45.63 \
 //y=3.51 //x2=42.67 //y2=5.295
cc_4698 ( N_CLK_c_6121_n N_noxref_25_c_11792_n ) capacitor c=4.08516e-19 \
 //x=45.63 //y=4.88 //x2=42.67 //y2=5.295
cc_4699 ( N_CLK_c_6033_n N_noxref_25_c_11792_n ) capacitor c=4.14284e-19 \
 //x=42.145 //y=4.635 //x2=42.67 //y2=5.295
cc_4700 ( N_CLK_c_6109_n N_noxref_25_c_11792_n ) capacitor c=0.0340662f \
 //x=44.14 //y=4.62 //x2=42.67 //y2=5.295
cc_4701 ( N_CLK_c_5953_n N_noxref_25_c_11795_n ) capacitor c=0.0152288f \
 //x=41.545 //y=4.62 //x2=41.31 //y2=5.56
cc_4702 ( N_CLK_c_6033_n N_noxref_25_c_11840_n ) capacitor c=0.0140453f \
 //x=42.145 //y=4.635 //x2=42.19 //y2=5.38
cc_4703 ( N_CLK_c_6142_n N_noxref_26_c_11964_n ) capacitor c=0.00123426f \
 //x=45.72 //y=1.09 //x2=46.425 //y2=1.175
cc_4704 ( N_CLK_c_6143_n N_noxref_26_c_11964_n ) capacitor c=0.0129288f \
 //x=45.72 //y=1.4 //x2=46.425 //y2=1.175
cc_4705 ( N_CLK_c_6144_n N_noxref_26_c_11964_n ) capacitor c=0.00132209f \
 //x=45.72 //y=1.63 //x2=46.425 //y2=1.175
cc_4706 ( N_CLK_c_6118_n N_noxref_26_M27_noxref_d ) capacitor c=0.00600684f \
 //x=45.63 //y=2.375 //x2=45.27 //y2=1.09
cc_4707 ( N_CLK_c_6132_n N_noxref_26_M27_noxref_d ) capacitor c=2.2052e-19 \
 //x=45.63 //y=2.26 //x2=45.27 //y2=1.09
cc_4708 ( N_CLK_c_6316_p N_noxref_26_M27_noxref_d ) capacitor c=0.00253592f \
 //x=45.195 //y=1.09 //x2=45.27 //y2=1.09
cc_4709 ( N_CLK_c_6318_p N_noxref_26_M27_noxref_d ) capacitor c=0.00604066f \
 //x=45.195 //y=1.4 //x2=45.27 //y2=1.09
cc_4710 ( N_CLK_c_6494_p N_noxref_26_M27_noxref_d ) capacitor c=0.002686f \
 //x=45.565 //y=0.935 //x2=45.27 //y2=1.09
cc_4711 ( N_CLK_c_6495_p N_noxref_26_M27_noxref_d ) capacitor c=0.00251995f \
 //x=45.565 //y=1.555 //x2=45.27 //y2=1.09
cc_4712 ( N_CLK_c_6142_n N_noxref_26_M27_noxref_d ) capacitor c=0.00314523f \
 //x=45.72 //y=1.09 //x2=45.27 //y2=1.09
cc_4713 ( N_CLK_c_6143_n N_noxref_26_M27_noxref_d ) capacitor c=0.00168289f \
 //x=45.72 //y=1.4 //x2=45.27 //y2=1.09
cc_4714 ( N_CLK_c_6144_n N_noxref_26_M27_noxref_d ) capacitor c=0.00111165f \
 //x=45.72 //y=1.63 //x2=45.27 //y2=1.09
cc_4715 ( N_CLK_c_6142_n N_noxref_26_M28_noxref_s ) capacitor c=7.21316e-19 \
 //x=45.72 //y=1.09 //x2=46.375 //y2=0.555
cc_4716 ( N_CLK_c_6143_n N_noxref_26_M28_noxref_s ) capacitor c=0.00365271f \
 //x=45.72 //y=1.4 //x2=46.375 //y2=0.555
cc_4717 ( N_CLK_c_6145_n N_noxref_26_M28_noxref_s ) capacitor c=9.86711e-19 \
 //x=45.72 //y=2.095 //x2=46.375 //y2=0.555
cc_4718 ( N_CLK_c_5591_n N_GND_c_12316_n ) capacitor c=9.16623e-19 //x=2.71 \
 //y=2.375 //x2=6.395 //y2=0.175
cc_4719 ( N_CLK_c_5637_n N_GND_c_12502_n ) capacitor c=0.00215229f //x=13.81 \
 //y=2.26 //x2=16.385 //y2=0.175
cc_4720 ( N_CLK_c_5845_n N_GND_c_12546_n ) capacitor c=8.21199e-19 //x=24.17 \
 //y=2.375 //x2=27.855 //y2=0.175
cc_4721 ( N_CLK_c_5891_n N_GND_c_12727_n ) capacitor c=0.00215229f //x=35.27 \
 //y=2.26 //x2=37.845 //y2=0.175
cc_4722 ( N_CLK_c_6118_n N_GND_c_12829_n ) capacitor c=7.99962e-19 //x=45.63 \
 //y=2.375 //x2=49.315 //y2=0.175
cc_4723 ( N_CLK_c_6164_n N_GND_c_12915_n ) capacitor c=0.00210951f //x=56.73 \
 //y=2.26 //x2=59.305 //y2=0.175
cc_4724 ( N_CLK_c_5637_n N_GND_c_12383_n ) capacitor c=3.77328e-19 //x=13.81 \
 //y=2.26 //x2=15.12 //y2=0.175
cc_4725 ( N_CLK_c_5891_n N_GND_c_12610_n ) capacitor c=3.77328e-19 //x=35.27 \
 //y=2.26 //x2=36.58 //y2=0.175
cc_4726 ( N_CLK_c_6164_n N_GND_c_12893_n ) capacitor c=3.77328e-19 //x=56.73 \
 //y=2.26 //x2=58.04 //y2=0.175
cc_4727 ( N_CLK_c_5647_n N_GND_c_12440_n ) capacitor c=0.00224736f //x=13.81 \
 //y=2.26 //x2=15.29 //y2=0.175
cc_4728 ( N_CLK_c_5666_n N_GND_c_12440_n ) capacitor c=0.00275184f //x=14.375 \
 //y=1.43 //x2=15.29 //y2=0.175
cc_4729 ( N_CLK_c_5667_n N_GND_c_12440_n ) capacitor c=2.63786e-19 //x=13.81 \
 //y=2.26 //x2=15.29 //y2=0.175
cc_4730 ( N_CLK_c_5901_n N_GND_c_12666_n ) capacitor c=0.00224736f //x=35.27 \
 //y=2.26 //x2=36.75 //y2=0.175
cc_4731 ( N_CLK_c_5920_n N_GND_c_12666_n ) capacitor c=0.00275184f //x=35.835 \
 //y=1.43 //x2=36.75 //y2=0.175
cc_4732 ( N_CLK_c_5921_n N_GND_c_12666_n ) capacitor c=2.63786e-19 //x=35.27 \
 //y=2.26 //x2=36.75 //y2=0.175
cc_4733 ( N_CLK_c_6173_n N_GND_c_12925_n ) capacitor c=0.00200922f //x=56.73 \
 //y=2.26 //x2=58.21 //y2=0.175
cc_4734 ( N_CLK_c_6192_n N_GND_c_12925_n ) capacitor c=0.00275184f //x=57.295 \
 //y=1.43 //x2=58.21 //y2=0.175
cc_4735 ( N_CLK_c_6193_n N_GND_c_12925_n ) capacitor c=2.63786e-19 //x=56.73 \
 //y=2.26 //x2=58.21 //y2=0.175
cc_4736 ( N_CLK_c_5798_n N_noxref_31_c_13995_n ) capacitor c=0.0167228f \
 //x=2.275 //y=1.09 //x2=2.935 //y2=0.72
cc_4737 ( N_CLK_c_5615_n N_noxref_31_c_13995_n ) capacitor c=0.00534519f \
 //x=2.8 //y=1.09 //x2=2.935 //y2=0.72
cc_4738 ( N_CLK_c_5591_n N_noxref_31_c_13989_n ) capacitor c=0.0048147f \
 //x=2.71 //y=2.375 //x2=2.935 //y2=1.77
cc_4739 ( N_CLK_c_5594_n N_noxref_31_c_13989_n ) capacitor c=9.34338e-19 \
 //x=2.71 //y=4.88 //x2=2.935 //y2=1.77
cc_4740 ( N_CLK_c_5605_n N_noxref_31_c_13989_n ) capacitor c=0.0105652f \
 //x=2.71 //y=2.26 //x2=2.935 //y2=1.77
cc_4741 ( N_CLK_c_5801_n N_noxref_31_c_13989_n ) capacitor c=0.0153476f \
 //x=2.275 //y=1.4 //x2=2.935 //y2=1.77
cc_4742 ( N_CLK_c_5618_n N_noxref_31_c_13989_n ) capacitor c=0.0222131f \
 //x=2.8 //y=2.095 //x2=2.935 //y2=1.77
cc_4743 ( N_CLK_c_5798_n N_noxref_31_M0_noxref_s ) capacitor c=0.00798959f \
 //x=2.275 //y=1.09 //x2=0.945 //y2=0.555
cc_4744 ( N_CLK_c_5617_n N_noxref_31_M0_noxref_s ) capacitor c=0.00212176f \
 //x=2.8 //y=1.63 //x2=0.945 //y2=0.555
cc_4745 ( N_CLK_c_5618_n N_noxref_31_M0_noxref_s ) capacitor c=0.00298115f \
 //x=2.8 //y=2.095 //x2=0.945 //y2=0.555
cc_4746 ( N_CLK_c_5637_n N_noxref_34_c_14181_n ) capacitor c=7.50092e-19 \
 //x=13.81 //y=2.26 //x2=13.625 //y2=1.675
cc_4747 ( N_CLK_c_5662_n N_noxref_34_c_14181_n ) capacitor c=0.00888238f \
 //x=13.845 //y=1.74 //x2=13.625 //y2=1.675
cc_4748 ( N_CLK_c_5667_n N_noxref_34_c_14181_n ) capacitor c=0.00175171f \
 //x=13.81 //y=2.26 //x2=13.625 //y2=1.675
cc_4749 ( N_CLK_c_5637_n N_noxref_34_c_14186_n ) capacitor c=0.001463f \
 //x=13.81 //y=2.26 //x2=14.51 //y2=0.71
cc_4750 ( N_CLK_c_5647_n N_noxref_34_c_14186_n ) capacitor c=8.82141e-19 \
 //x=13.81 //y=2.26 //x2=14.51 //y2=0.71
cc_4751 ( N_CLK_c_5657_n N_noxref_34_c_14186_n ) capacitor c=0.0200738f \
 //x=13.845 //y=1.085 //x2=14.51 //y2=0.71
cc_4752 ( N_CLK_c_5665_n N_noxref_34_c_14186_n ) capacitor c=0.00825432f \
 //x=14.375 //y=1.085 //x2=14.51 //y2=0.71
cc_4753 ( N_CLK_c_5667_n N_noxref_34_c_14186_n ) capacitor c=2.1838e-19 \
 //x=13.81 //y=2.26 //x2=14.51 //y2=0.71
cc_4754 ( N_CLK_c_5657_n N_noxref_34_M7_noxref_s ) capacitor c=0.00888238f \
 //x=13.845 //y=1.085 //x2=12.52 //y2=0.545
cc_4755 ( N_CLK_c_5665_n N_noxref_34_M7_noxref_s ) capacitor c=0.015333f \
 //x=14.375 //y=1.085 //x2=12.52 //y2=0.545
cc_4756 ( N_CLK_c_5666_n N_noxref_34_M7_noxref_s ) capacitor c=0.00248746f \
 //x=14.375 //y=1.43 //x2=12.52 //y2=0.545
cc_4757 ( N_CLK_c_6056_n N_noxref_37_c_14396_n ) capacitor c=0.0167228f \
 //x=23.735 //y=1.09 //x2=24.395 //y2=0.72
cc_4758 ( N_CLK_c_5869_n N_noxref_37_c_14396_n ) capacitor c=0.00534519f \
 //x=24.26 //y=1.09 //x2=24.395 //y2=0.72
cc_4759 ( N_CLK_c_5845_n N_noxref_37_c_14394_n ) capacitor c=0.0048147f \
 //x=24.17 //y=2.375 //x2=24.395 //y2=1.77
cc_4760 ( N_CLK_c_5848_n N_noxref_37_c_14394_n ) capacitor c=9.34338e-19 \
 //x=24.17 //y=4.88 //x2=24.395 //y2=1.77
cc_4761 ( N_CLK_c_5859_n N_noxref_37_c_14394_n ) capacitor c=0.0105652f \
 //x=24.17 //y=2.26 //x2=24.395 //y2=1.77
cc_4762 ( N_CLK_c_6059_n N_noxref_37_c_14394_n ) capacitor c=0.0153476f \
 //x=23.735 //y=1.4 //x2=24.395 //y2=1.77
cc_4763 ( N_CLK_c_5872_n N_noxref_37_c_14394_n ) capacitor c=0.0200931f \
 //x=24.26 //y=2.095 //x2=24.395 //y2=1.77
cc_4764 ( N_CLK_c_6056_n N_noxref_37_M13_noxref_s ) capacitor c=0.00798959f \
 //x=23.735 //y=1.09 //x2=22.405 //y2=0.555
cc_4765 ( N_CLK_c_5871_n N_noxref_37_M13_noxref_s ) capacitor c=0.00212176f \
 //x=24.26 //y=1.63 //x2=22.405 //y2=0.555
cc_4766 ( N_CLK_c_5872_n N_noxref_37_M13_noxref_s ) capacitor c=0.00298115f \
 //x=24.26 //y=2.095 //x2=22.405 //y2=0.555
cc_4767 ( N_CLK_c_5891_n N_noxref_40_c_14584_n ) capacitor c=7.50092e-19 \
 //x=35.27 //y=2.26 //x2=35.085 //y2=1.675
cc_4768 ( N_CLK_c_5916_n N_noxref_40_c_14584_n ) capacitor c=0.00888238f \
 //x=35.305 //y=1.74 //x2=35.085 //y2=1.675
cc_4769 ( N_CLK_c_5921_n N_noxref_40_c_14584_n ) capacitor c=0.00175171f \
 //x=35.27 //y=2.26 //x2=35.085 //y2=1.675
cc_4770 ( N_CLK_c_5891_n N_noxref_40_c_14589_n ) capacitor c=0.001463f \
 //x=35.27 //y=2.26 //x2=35.97 //y2=0.71
cc_4771 ( N_CLK_c_5901_n N_noxref_40_c_14589_n ) capacitor c=8.82141e-19 \
 //x=35.27 //y=2.26 //x2=35.97 //y2=0.71
cc_4772 ( N_CLK_c_5911_n N_noxref_40_c_14589_n ) capacitor c=0.0200738f \
 //x=35.305 //y=1.085 //x2=35.97 //y2=0.71
cc_4773 ( N_CLK_c_5919_n N_noxref_40_c_14589_n ) capacitor c=0.00825432f \
 //x=35.835 //y=1.085 //x2=35.97 //y2=0.71
cc_4774 ( N_CLK_c_5921_n N_noxref_40_c_14589_n ) capacitor c=2.1838e-19 \
 //x=35.27 //y=2.26 //x2=35.97 //y2=0.71
cc_4775 ( N_CLK_c_5911_n N_noxref_40_M20_noxref_s ) capacitor c=0.00888238f \
 //x=35.305 //y=1.085 //x2=33.98 //y2=0.545
cc_4776 ( N_CLK_c_5919_n N_noxref_40_M20_noxref_s ) capacitor c=0.015333f \
 //x=35.835 //y=1.085 //x2=33.98 //y2=0.545
cc_4777 ( N_CLK_c_5920_n N_noxref_40_M20_noxref_s ) capacitor c=0.00248746f \
 //x=35.835 //y=1.43 //x2=33.98 //y2=0.545
cc_4778 ( N_CLK_c_6316_p N_noxref_43_c_14780_n ) capacitor c=0.0167228f \
 //x=45.195 //y=1.09 //x2=45.855 //y2=0.72
cc_4779 ( N_CLK_c_6142_n N_noxref_43_c_14780_n ) capacitor c=0.00534519f \
 //x=45.72 //y=1.09 //x2=45.855 //y2=0.72
cc_4780 ( N_CLK_c_6118_n N_noxref_43_c_14782_n ) capacitor c=0.0048147f \
 //x=45.63 //y=2.375 //x2=45.855 //y2=1.77
cc_4781 ( N_CLK_c_6121_n N_noxref_43_c_14782_n ) capacitor c=9.34338e-19 \
 //x=45.63 //y=4.88 //x2=45.855 //y2=1.77
cc_4782 ( N_CLK_c_6132_n N_noxref_43_c_14782_n ) capacitor c=0.0105652f \
 //x=45.63 //y=2.26 //x2=45.855 //y2=1.77
cc_4783 ( N_CLK_c_6318_p N_noxref_43_c_14782_n ) capacitor c=0.0153476f \
 //x=45.195 //y=1.4 //x2=45.855 //y2=1.77
cc_4784 ( N_CLK_c_6145_n N_noxref_43_c_14782_n ) capacitor c=0.0216832f \
 //x=45.72 //y=2.095 //x2=45.855 //y2=1.77
cc_4785 ( N_CLK_c_6316_p N_noxref_43_M26_noxref_s ) capacitor c=0.00798959f \
 //x=45.195 //y=1.09 //x2=43.865 //y2=0.555
cc_4786 ( N_CLK_c_6144_n N_noxref_43_M26_noxref_s ) capacitor c=0.00212176f \
 //x=45.72 //y=1.63 //x2=43.865 //y2=0.555
cc_4787 ( N_CLK_c_6145_n N_noxref_43_M26_noxref_s ) capacitor c=0.00298115f \
 //x=45.72 //y=2.095 //x2=43.865 //y2=0.555
cc_4788 ( N_CLK_c_6164_n N_noxref_46_c_14985_n ) capacitor c=7.50092e-19 \
 //x=56.73 //y=2.26 //x2=56.545 //y2=1.675
cc_4789 ( N_CLK_c_6188_n N_noxref_46_c_14985_n ) capacitor c=0.00888238f \
 //x=56.765 //y=1.74 //x2=56.545 //y2=1.675
cc_4790 ( N_CLK_c_6193_n N_noxref_46_c_14985_n ) capacitor c=0.00175171f \
 //x=56.73 //y=2.26 //x2=56.545 //y2=1.675
cc_4791 ( N_CLK_c_6164_n N_noxref_46_c_14992_n ) capacitor c=0.001463f \
 //x=56.73 //y=2.26 //x2=57.43 //y2=0.71
cc_4792 ( N_CLK_c_6173_n N_noxref_46_c_14992_n ) capacitor c=8.82141e-19 \
 //x=56.73 //y=2.26 //x2=57.43 //y2=0.71
cc_4793 ( N_CLK_c_6183_n N_noxref_46_c_14992_n ) capacitor c=0.0200738f \
 //x=56.765 //y=1.085 //x2=57.43 //y2=0.71
cc_4794 ( N_CLK_c_6191_n N_noxref_46_c_14992_n ) capacitor c=0.00825432f \
 //x=57.295 //y=1.085 //x2=57.43 //y2=0.71
cc_4795 ( N_CLK_c_6193_n N_noxref_46_c_14992_n ) capacitor c=2.1838e-19 \
 //x=56.73 //y=2.26 //x2=57.43 //y2=0.71
cc_4796 ( N_CLK_c_6183_n N_noxref_46_M33_noxref_s ) capacitor c=0.00888238f \
 //x=56.765 //y=1.085 //x2=55.44 //y2=0.545
cc_4797 ( N_CLK_c_6191_n N_noxref_46_M33_noxref_s ) capacitor c=0.015333f \
 //x=57.295 //y=1.085 //x2=55.44 //y2=0.545
cc_4798 ( N_CLK_c_6192_n N_noxref_46_M33_noxref_s ) capacitor c=0.00248746f \
 //x=57.295 //y=1.43 //x2=55.44 //y2=0.545
cc_4799 ( N_noxref_15_M117_noxref_g N_noxref_16_c_7079_n ) capacitor \
 c=0.00966488f //x=59.66 //y=6.2 //x2=60.205 //y2=5.38
cc_4800 ( N_noxref_15_c_6753_n N_noxref_16_c_7080_n ) capacitor c=0.00325684f \
 //x=59.32 //y=3.725 //x2=60.8 //y2=4.475
cc_4801 ( N_noxref_15_c_6762_n N_noxref_16_c_7080_n ) capacitor c=9.88936e-19 \
 //x=59.322 //y=4.74 //x2=60.8 //y2=4.475
cc_4802 ( N_noxref_15_c_6780_p N_noxref_16_c_7082_n ) capacitor c=8.193e-19 \
 //x=59.32 //y=4.045 //x2=59.44 //y2=5.56
cc_4803 ( N_noxref_15_c_6781_p N_noxref_16_c_7082_n ) capacitor c=0.0118007f \
 //x=59.32 //y=4.88 //x2=59.44 //y2=5.56
cc_4804 ( N_noxref_15_c_6782_p N_noxref_16_c_7082_n ) capacitor c=0.00277154f \
 //x=59.32 //y=4.88 //x2=59.44 //y2=5.56
cc_4805 ( N_noxref_15_M116_noxref_g N_noxref_16_c_7082_n ) capacitor \
 c=0.00201806f //x=59.22 //y=6.2 //x2=59.44 //y2=5.56
cc_4806 ( N_noxref_15_M117_noxref_g N_noxref_16_c_7082_n ) capacitor \
 c=0.00192712f //x=59.66 //y=6.2 //x2=59.44 //y2=5.56
cc_4807 ( N_noxref_15_c_6785_p N_noxref_16_c_7082_n ) capacitor c=0.00187457f \
 //x=59.32 //y=4.88 //x2=59.44 //y2=5.56
cc_4808 ( N_noxref_15_c_6780_p N_noxref_16_c_7088_n ) capacitor c=2.39213e-19 \
 //x=59.32 //y=4.045 //x2=59.44 //y2=5.56
cc_4809 ( N_noxref_15_c_6781_p N_noxref_16_c_7088_n ) capacitor c=0.00104426f \
 //x=59.32 //y=4.88 //x2=59.44 //y2=5.56
cc_4810 ( N_noxref_15_c_6782_p N_noxref_16_c_7088_n ) capacitor c=0.00377369f \
 //x=59.32 //y=4.88 //x2=59.44 //y2=5.56
cc_4811 ( N_noxref_15_M116_noxref_g N_noxref_16_c_7088_n ) capacitor \
 c=0.0158358f //x=59.22 //y=6.2 //x2=59.44 //y2=5.56
cc_4812 ( N_noxref_15_M117_noxref_g N_noxref_16_c_7088_n ) capacitor \
 c=0.0178987f //x=59.66 //y=6.2 //x2=59.44 //y2=5.56
cc_4813 ( N_noxref_15_c_6785_p N_noxref_16_c_7088_n ) capacitor c=0.0043218f \
 //x=59.32 //y=4.88 //x2=59.44 //y2=5.56
cc_4814 ( N_noxref_15_c_6708_n N_noxref_17_c_7368_n ) capacitor c=4.05935e-19 \
 //x=52.87 //y=3.89 //x2=53.4 //y2=4.095
cc_4815 ( N_noxref_15_c_6730_n N_noxref_17_c_7368_n ) capacitor c=0.0228971f \
 //x=53.62 //y=3.87 //x2=53.4 //y2=4.095
cc_4816 ( N_noxref_15_c_6708_n N_noxref_17_c_7376_n ) capacitor c=0.00219434f \
 //x=52.87 //y=3.89 //x2=53.4 //y2=4.415
cc_4817 ( N_noxref_15_c_6730_n N_noxref_17_c_7376_n ) capacitor c=0.00450788f \
 //x=53.62 //y=3.87 //x2=53.4 //y2=4.415
cc_4818 ( N_noxref_15_c_6753_n N_noxref_17_c_7438_n ) capacitor c=0.0200848f \
 //x=59.32 //y=3.725 //x2=57.47 //y2=4.105
cc_4819 ( N_noxref_15_c_6780_p N_noxref_17_c_7438_n ) capacitor c=0.00254581f \
 //x=59.32 //y=4.045 //x2=57.47 //y2=4.105
cc_4820 ( N_noxref_15_c_6798_p N_noxref_17_c_7438_n ) capacitor c=0.00344372f \
 //x=59.32 //y=2.26 //x2=57.47 //y2=4.105
cc_4821 ( N_noxref_15_c_6762_n N_noxref_17_c_7438_n ) capacitor c=0.00103966f \
 //x=59.322 //y=4.74 //x2=57.47 //y2=4.105
cc_4822 ( N_noxref_15_c_6740_n N_noxref_17_c_7438_n ) capacitor c=0.0267862f \
 //x=56.2 //y=3.895 //x2=57.47 //y2=4.105
cc_4823 ( N_noxref_15_c_6762_n N_noxref_17_c_7536_n ) capacitor c=0.00233357f \
 //x=59.322 //y=4.74 //x2=57.47 //y2=4.425
cc_4824 ( N_noxref_15_c_6740_n N_noxref_17_c_7536_n ) capacitor c=0.00650588f \
 //x=56.2 //y=3.895 //x2=57.47 //y2=4.425
cc_4825 ( N_noxref_15_c_6781_p N_noxref_17_c_7441_n ) capacitor c=0.00413257f \
 //x=59.32 //y=4.88 //x2=57.47 //y2=5.295
cc_4826 ( N_noxref_15_c_6762_n N_noxref_17_c_7441_n ) capacitor c=0.00489775f \
 //x=59.322 //y=4.74 //x2=57.47 //y2=5.295
cc_4827 ( N_noxref_15_c_6669_n N_noxref_17_c_7363_n ) capacitor c=0.00127339f \
 //x=47.48 //y=4.04 //x2=47.095 //y2=4.25
cc_4828 ( N_noxref_15_c_6586_n N_noxref_17_c_7363_n ) capacitor c=3.11164e-19 \
 //x=47.48 //y=5.25 //x2=47.095 //y2=4.25
cc_4829 ( N_noxref_15_c_6695_n N_noxref_17_c_7363_n ) capacitor c=0.0358254f \
 //x=47.64 //y=3.88 //x2=47.095 //y2=4.25
cc_4830 ( N_noxref_15_c_6669_n N_noxref_17_c_7390_n ) capacitor c=0.00757046f \
 //x=47.48 //y=4.04 //x2=47.695 //y2=4.265
cc_4831 ( N_noxref_15_c_6586_n N_noxref_17_c_7390_n ) capacitor c=0.0226561f \
 //x=47.48 //y=5.25 //x2=47.695 //y2=4.265
cc_4832 ( N_noxref_15_c_6693_n N_noxref_17_c_7390_n ) capacitor c=0.127147f \
 //x=49.165 //y=3.88 //x2=47.695 //y2=4.265
cc_4833 ( N_noxref_15_c_6594_n N_noxref_17_c_7391_n ) capacitor c=0.00324642f \
 //x=49.33 //y=4.04 //x2=48.94 //y2=4.25
cc_4834 ( N_noxref_15_c_6602_n N_noxref_17_c_7391_n ) capacitor c=4.98743e-19 \
 //x=49.332 //y=4.74 //x2=48.94 //y2=4.25
cc_4835 ( N_noxref_15_c_6693_n N_noxref_17_c_7391_n ) capacitor c=0.0107932f \
 //x=49.165 //y=3.88 //x2=48.94 //y2=4.25
cc_4836 ( N_noxref_15_c_6603_n N_noxref_17_c_7391_n ) capacitor c=0.0358254f \
 //x=50.675 //y=3.895 //x2=48.94 //y2=4.25
cc_4837 ( N_noxref_15_c_6594_n N_noxref_17_c_7392_n ) capacitor c=0.00240423f \
 //x=49.33 //y=4.04 //x2=49.54 //y2=4.265
cc_4838 ( N_noxref_15_c_6602_n N_noxref_17_c_7392_n ) capacitor c=0.0221402f \
 //x=49.332 //y=4.74 //x2=49.54 //y2=4.265
cc_4839 ( N_noxref_15_c_6603_n N_noxref_17_c_7392_n ) capacitor c=0.0116221f \
 //x=50.675 //y=3.895 //x2=49.54 //y2=4.265
cc_4840 ( N_noxref_15_c_6730_n N_noxref_17_c_7455_n ) capacitor c=0.0811622f \
 //x=53.62 //y=3.87 //x2=57.3 //y2=4.25
cc_4841 ( N_noxref_15_c_6733_n N_noxref_17_c_7455_n ) capacitor c=0.11052f \
 //x=54.36 //y=3.895 //x2=57.3 //y2=4.25
cc_4842 ( N_noxref_15_c_6736_n N_noxref_17_c_7455_n ) capacitor c=0.0564053f \
 //x=55.6 //y=3.88 //x2=57.3 //y2=4.25
cc_4843 ( N_noxref_15_c_6740_n N_noxref_17_c_7455_n ) capacitor c=0.0869877f \
 //x=56.2 //y=3.895 //x2=57.3 //y2=4.25
cc_4844 ( N_noxref_15_c_6602_n N_noxref_17_c_7364_n ) capacitor c=3.14882e-19 \
 //x=49.332 //y=4.74 //x2=53.565 //y2=4.25
cc_4845 ( N_noxref_15_c_6697_n N_noxref_17_c_7364_n ) capacitor c=0.111441f \
 //x=51.02 //y=3.895 //x2=53.565 //y2=4.25
cc_4846 ( N_noxref_15_c_6603_n N_noxref_17_c_7364_n ) capacitor c=0.131771f \
 //x=50.675 //y=3.895 //x2=53.565 //y2=4.25
cc_4847 ( N_noxref_15_c_6704_n N_noxref_17_c_7364_n ) capacitor c=0.055806f \
 //x=52.27 //y=3.88 //x2=53.565 //y2=4.25
cc_4848 ( N_noxref_15_c_6708_n N_noxref_17_c_7364_n ) capacitor c=0.0237381f \
 //x=52.87 //y=3.89 //x2=53.565 //y2=4.25
cc_4849 ( N_noxref_15_c_6730_n N_noxref_17_c_7364_n ) capacitor c=0.0358686f \
 //x=53.62 //y=3.87 //x2=53.565 //y2=4.25
cc_4850 ( N_noxref_15_c_6780_p N_noxref_17_c_7643_n ) capacitor c=0.00248847f \
 //x=59.32 //y=4.045 //x2=59.535 //y2=4.27
cc_4851 ( N_noxref_15_c_6781_p N_noxref_17_c_7643_n ) capacitor c=0.00242573f \
 //x=59.32 //y=4.88 //x2=59.535 //y2=4.27
cc_4852 ( N_noxref_15_c_6762_n N_noxref_17_c_7643_n ) capacitor c=0.0263613f \
 //x=59.322 //y=4.74 //x2=59.535 //y2=4.27
cc_4853 ( N_noxref_15_c_6780_p N_noxref_17_c_7565_n ) capacitor c=0.00322776f \
 //x=59.32 //y=4.045 //x2=59.19 //y2=4.27
cc_4854 ( N_noxref_15_c_6762_n N_noxref_17_c_7565_n ) capacitor c=0.00208639f \
 //x=59.322 //y=4.74 //x2=59.19 //y2=4.27
cc_4855 ( N_noxref_15_c_6740_n N_noxref_17_c_7565_n ) capacitor c=0.214677f \
 //x=56.2 //y=3.895 //x2=59.19 //y2=4.27
cc_4856 ( N_noxref_15_c_6754_n N_noxref_17_M98_noxref_g ) capacitor \
 c=0.00461408f //x=44.942 //y=5.335 //x2=44.72 //y2=6.2
cc_4857 ( N_noxref_15_c_6835_p N_noxref_17_M98_noxref_g ) capacitor \
 c=0.0162284f //x=44.94 //y=5.56 //x2=44.72 //y2=6.2
cc_4858 ( N_noxref_15_c_6742_n N_noxref_17_M99_noxref_g ) capacitor \
 c=0.00893512f //x=45.7 //y=5.335 //x2=45.16 //y2=6.2
cc_4859 ( N_noxref_15_c_6754_n N_noxref_17_M99_noxref_g ) capacitor \
 c=0.00229208f //x=44.942 //y=5.335 //x2=45.16 //y2=6.2
cc_4860 ( N_noxref_15_c_6835_p N_noxref_17_M99_noxref_g ) capacitor \
 c=0.0179041f //x=44.94 //y=5.56 //x2=45.16 //y2=6.2
cc_4861 ( N_noxref_15_c_6754_n N_noxref_17_c_7593_n ) capacitor c=0.00171885f \
 //x=44.942 //y=5.335 //x2=45.085 //y2=4.97
cc_4862 ( N_noxref_15_c_6835_p N_noxref_17_c_7593_n ) capacitor c=0.00291477f \
 //x=44.94 //y=5.56 //x2=45.085 //y2=4.97
cc_4863 ( N_noxref_15_c_6753_n N_noxref_18_c_7986_n ) capacitor c=0.0556631f \
 //x=59.32 //y=3.725 //x2=60.06 //y2=3.705
cc_4864 ( N_noxref_15_c_6842_p N_noxref_18_c_7986_n ) capacitor c=3.30333e-19 \
 //x=59.32 //y=2.26 //x2=60.06 //y2=3.705
cc_4865 ( N_noxref_15_c_6753_n N_noxref_18_c_7988_n ) capacitor c=0.00122693f \
 //x=59.32 //y=3.725 //x2=60.06 //y2=4.025
cc_4866 ( N_noxref_15_c_6780_p N_noxref_18_c_7988_n ) capacitor c=0.019045f \
 //x=59.32 //y=4.045 //x2=60.06 //y2=4.025
cc_4867 ( N_noxref_15_c_6845_p N_noxref_18_c_7988_n ) capacitor c=6.606e-19 \
 //x=59.32 //y=3.88 //x2=60.06 //y2=4.025
cc_4868 ( N_noxref_15_c_6740_n N_noxref_18_c_7988_n ) capacitor c=0.00304665f \
 //x=56.2 //y=3.895 //x2=60.06 //y2=4.025
cc_4869 ( N_noxref_15_c_6780_p N_noxref_18_c_7992_n ) capacitor c=0.00115845f \
 //x=59.32 //y=4.045 //x2=60.06 //y2=4.735
cc_4870 ( N_noxref_15_c_6781_p N_noxref_18_c_7992_n ) capacitor c=0.0169717f \
 //x=59.32 //y=4.88 //x2=60.06 //y2=4.735
cc_4871 ( N_noxref_15_c_6762_n N_noxref_18_c_7992_n ) capacitor c=0.0271813f \
 //x=59.322 //y=4.74 //x2=60.06 //y2=4.735
cc_4872 ( N_noxref_15_c_6740_n N_noxref_18_c_7992_n ) capacitor c=5.0367e-19 \
 //x=56.2 //y=3.895 //x2=60.06 //y2=4.735
cc_4873 ( N_noxref_15_c_6782_p N_noxref_18_c_7992_n ) capacitor c=7.76143e-19 \
 //x=59.32 //y=4.88 //x2=60.06 //y2=4.735
cc_4874 ( N_noxref_15_c_6785_p N_noxref_18_c_7992_n ) capacitor c=0.00201171f \
 //x=59.32 //y=4.88 //x2=60.06 //y2=4.735
cc_4875 ( N_noxref_15_c_6798_p N_noxref_18_c_7998_n ) capacitor c=0.0179797f \
 //x=59.32 //y=2.26 //x2=60.06 //y2=2.26
cc_4876 ( N_noxref_15_c_6842_p N_noxref_18_c_7998_n ) capacitor c=5.16867e-19 \
 //x=59.32 //y=2.26 //x2=60.06 //y2=2.26
cc_4877 ( N_noxref_15_c_6855_p N_noxref_18_c_7998_n ) capacitor c=0.00161745f \
 //x=59.125 //y=2.095 //x2=60.06 //y2=2.26
cc_4878 ( N_noxref_15_c_6780_p N_noxref_18_c_8001_n ) capacitor c=7.27831e-19 \
 //x=59.32 //y=4.045 //x2=60.06 //y2=3.88
cc_4879 ( N_noxref_15_c_6845_p N_noxref_18_c_8001_n ) capacitor c=0.0102237f \
 //x=59.32 //y=3.88 //x2=60.06 //y2=3.88
cc_4880 ( N_noxref_15_c_6753_n N_noxref_18_c_8003_n ) capacitor c=5.59436e-19 \
 //x=59.32 //y=3.725 //x2=60.22 //y2=3.865
cc_4881 ( N_noxref_15_c_6780_p N_noxref_18_c_8003_n ) capacitor c=0.00305861f \
 //x=59.32 //y=4.045 //x2=60.22 //y2=3.865
cc_4882 ( N_noxref_15_c_6740_n N_noxref_18_c_8003_n ) capacitor c=0.0213658f \
 //x=56.2 //y=3.895 //x2=60.22 //y2=3.865
cc_4883 ( N_noxref_15_c_6753_n N_noxref_18_c_8006_n ) capacitor c=3.30333e-19 \
 //x=59.32 //y=3.725 //x2=60.06 //y2=2.26
cc_4884 ( N_noxref_15_c_6798_p N_noxref_18_c_8006_n ) capacitor c=5.24723e-19 \
 //x=59.32 //y=2.26 //x2=60.06 //y2=2.26
cc_4885 ( N_noxref_15_c_6842_p N_noxref_18_c_8006_n ) capacitor c=0.00525888f \
 //x=59.32 //y=2.26 //x2=60.06 //y2=2.26
cc_4886 ( N_noxref_15_c_6855_p N_noxref_18_c_8006_n ) capacitor c=0.00190888f \
 //x=59.125 //y=2.095 //x2=60.06 //y2=2.26
cc_4887 ( N_noxref_15_c_6781_p N_noxref_18_c_8010_n ) capacitor c=4.80626e-19 \
 //x=59.32 //y=4.88 //x2=60.09 //y2=4.88
cc_4888 ( N_noxref_15_c_6782_p N_noxref_18_c_8010_n ) capacitor c=0.0043355f \
 //x=59.32 //y=4.88 //x2=60.09 //y2=4.88
cc_4889 ( N_noxref_15_c_6785_p N_noxref_18_c_8010_n ) capacitor c=0.00212168f \
 //x=59.32 //y=4.88 //x2=60.09 //y2=4.88
cc_4890 ( N_noxref_15_M116_noxref_g N_noxref_18_M118_noxref_g ) capacitor \
 c=0.0104892f //x=59.22 //y=6.2 //x2=60.1 //y2=6.2
cc_4891 ( N_noxref_15_M117_noxref_g N_noxref_18_M118_noxref_g ) capacitor \
 c=0.107636f //x=59.66 //y=6.2 //x2=60.1 //y2=6.2
cc_4892 ( N_noxref_15_M117_noxref_g N_noxref_18_M119_noxref_g ) capacitor \
 c=0.0100341f //x=59.66 //y=6.2 //x2=60.54 //y2=6.2
cc_4893 ( N_noxref_15_c_6871_p N_noxref_18_c_8016_n ) capacitor c=4.86545e-19 \
 //x=59.125 //y=1.045 //x2=60.095 //y2=1.085
cc_4894 ( N_noxref_15_c_6872_p N_noxref_18_c_8016_n ) capacitor c=0.00152405f \
 //x=59.125 //y=1.39 //x2=60.095 //y2=1.085
cc_4895 ( N_noxref_15_c_6873_p N_noxref_18_c_8016_n ) capacitor c=0.0151475f \
 //x=59.655 //y=1.045 //x2=60.095 //y2=1.085
cc_4896 ( N_noxref_15_c_6874_p N_noxref_18_c_8019_n ) capacitor c=0.00109982f \
 //x=59.125 //y=1.7 //x2=60.095 //y2=1.43
cc_4897 ( N_noxref_15_c_6875_p N_noxref_18_c_8019_n ) capacitor c=0.0111064f \
 //x=59.655 //y=1.39 //x2=60.095 //y2=1.43
cc_4898 ( N_noxref_15_c_6874_p N_noxref_18_c_8021_n ) capacitor c=9.58243e-19 \
 //x=59.125 //y=1.7 //x2=60.095 //y2=1.74
cc_4899 ( N_noxref_15_c_6855_p N_noxref_18_c_8021_n ) capacitor c=0.00662747f \
 //x=59.125 //y=2.095 //x2=60.095 //y2=1.74
cc_4900 ( N_noxref_15_c_6875_p N_noxref_18_c_8021_n ) capacitor c=0.00862358f \
 //x=59.655 //y=1.39 //x2=60.095 //y2=1.74
cc_4901 ( N_noxref_15_c_6873_p N_noxref_18_c_8024_n ) capacitor c=0.00127211f \
 //x=59.655 //y=1.045 //x2=60.625 //y2=1.085
cc_4902 ( N_noxref_15_c_6875_p N_noxref_18_c_8025_n ) capacitor c=0.00204774f \
 //x=59.655 //y=1.39 //x2=60.625 //y2=1.43
cc_4903 ( N_noxref_15_c_6798_p N_noxref_18_c_8026_n ) capacitor c=0.00161167f \
 //x=59.32 //y=2.26 //x2=60.06 //y2=2.26
cc_4904 ( N_noxref_15_c_6842_p N_noxref_18_c_8026_n ) capacitor c=0.0018937f \
 //x=59.32 //y=2.26 //x2=60.06 //y2=2.26
cc_4905 ( N_noxref_15_c_6855_p N_noxref_18_c_8026_n ) capacitor c=0.0181449f \
 //x=59.125 //y=2.095 //x2=60.06 //y2=2.26
cc_4906 ( N_noxref_15_c_6781_p N_noxref_18_c_8029_n ) capacitor c=0.00158715f \
 //x=59.32 //y=4.88 //x2=60.09 //y2=4.88
cc_4907 ( N_noxref_15_c_6782_p N_noxref_18_c_8029_n ) capacitor c=0.00237977f \
 //x=59.32 //y=4.88 //x2=60.09 //y2=4.88
cc_4908 ( N_noxref_15_c_6785_p N_noxref_18_c_8029_n ) capacitor c=0.0297875f \
 //x=59.32 //y=4.88 //x2=60.09 //y2=4.88
cc_4909 ( N_noxref_15_c_6639_n N_noxref_19_c_8591_n ) capacitor c=6.87632e-19 \
 //x=46.995 //y=1.305 //x2=49.685 //y2=2.4
cc_4910 ( N_noxref_15_c_6657_n N_noxref_19_c_8591_n ) capacitor c=0.0211407f \
 //x=47.08 //y=1.845 //x2=49.685 //y2=2.4
cc_4911 ( N_noxref_15_c_6583_n N_noxref_19_c_8591_n ) capacitor c=0.0278336f \
 //x=47.48 //y=3.72 //x2=49.685 //y2=2.4
cc_4912 ( N_noxref_15_c_6587_n N_noxref_19_c_8591_n ) capacitor c=0.0122508f \
 //x=49.33 //y=3.72 //x2=49.685 //y2=2.4
cc_4913 ( N_noxref_15_c_6596_n N_noxref_19_c_8591_n ) capacitor c=0.0193963f \
 //x=49.33 //y=2.26 //x2=49.685 //y2=2.4
cc_4914 ( N_noxref_15_c_6604_n N_noxref_19_c_8591_n ) capacitor c=2.20453e-19 \
 //x=49.33 //y=2.26 //x2=49.685 //y2=2.4
cc_4915 ( N_noxref_15_c_6618_n N_noxref_19_c_8591_n ) capacitor c=3.61358e-19 \
 //x=49.135 //y=2.095 //x2=49.685 //y2=2.4
cc_4916 ( N_noxref_15_c_6753_n N_noxref_19_c_8645_n ) capacitor c=0.0153108f \
 //x=59.32 //y=3.725 //x2=50.285 //y2=2.37
cc_4917 ( N_noxref_15_c_6798_p N_noxref_19_c_8645_n ) capacitor c=0.0181187f \
 //x=59.32 //y=2.26 //x2=50.285 //y2=2.37
cc_4918 ( N_noxref_15_c_6708_n N_noxref_19_c_8645_n ) capacitor c=0.00266454f \
 //x=52.87 //y=3.89 //x2=50.285 //y2=2.37
cc_4919 ( N_noxref_15_c_6730_n N_noxref_19_c_8645_n ) capacitor c=9.63652e-19 \
 //x=53.62 //y=3.87 //x2=50.285 //y2=2.37
cc_4920 ( N_noxref_15_c_6740_n N_noxref_19_c_8645_n ) capacitor c=0.00780175f \
 //x=56.2 //y=3.895 //x2=50.285 //y2=2.37
cc_4921 ( N_noxref_15_c_6842_p N_noxref_19_c_8645_n ) capacitor c=2.20453e-19 \
 //x=59.32 //y=2.26 //x2=50.285 //y2=2.37
cc_4922 ( N_noxref_15_c_6855_p N_noxref_19_c_8645_n ) capacitor c=3.61358e-19 \
 //x=59.125 //y=2.095 //x2=50.285 //y2=2.37
cc_4923 ( N_noxref_15_c_6583_n N_noxref_20_c_9422_n ) capacitor c=7.10551e-19 \
 //x=47.48 //y=3.72 //x2=46.96 //y2=3.125
cc_4924 ( N_noxref_15_c_6583_n N_noxref_20_c_9423_n ) capacitor c=0.0229937f \
 //x=47.48 //y=3.72 //x2=50.42 //y2=3.14
cc_4925 ( N_noxref_15_c_6587_n N_noxref_20_c_9423_n ) capacitor c=0.0232059f \
 //x=49.33 //y=3.72 //x2=50.42 //y2=3.14
cc_4926 ( N_noxref_15_c_6693_n N_noxref_20_c_9423_n ) capacitor c=0.0104473f \
 //x=49.165 //y=3.88 //x2=50.42 //y2=3.14
cc_4927 ( N_noxref_15_c_6603_n N_noxref_20_c_9423_n ) capacitor c=0.0103764f \
 //x=50.675 //y=3.895 //x2=50.42 //y2=3.14
cc_4928 ( N_noxref_15_c_6697_n N_noxref_20_c_9437_n ) capacitor c=0.00614593f \
 //x=51.02 //y=3.895 //x2=51.02 //y2=3.125
cc_4929 ( N_noxref_15_c_6704_n N_noxref_20_c_9441_n ) capacitor c=0.00868637f \
 //x=52.27 //y=3.88 //x2=52.27 //y2=3.14
cc_4930 ( N_noxref_15_c_6708_n N_noxref_20_c_9444_n ) capacitor c=0.0254348f \
 //x=52.87 //y=3.89 //x2=52.87 //y2=3.12
cc_4931 ( N_noxref_15_c_6730_n N_noxref_20_c_9447_n ) capacitor c=0.0248572f \
 //x=53.62 //y=3.87 //x2=53.76 //y2=3.14
cc_4932 ( N_noxref_15_c_6733_n N_noxref_20_c_9448_n ) capacitor c=0.00855239f \
 //x=54.36 //y=3.895 //x2=54.36 //y2=3.125
cc_4933 ( N_noxref_15_c_6736_n N_noxref_20_c_9452_n ) capacitor c=0.00866164f \
 //x=55.6 //y=3.88 //x2=55.6 //y2=3.14
cc_4934 ( N_noxref_15_c_6753_n N_noxref_20_c_9455_n ) capacitor c=0.0281755f \
 //x=59.32 //y=3.725 //x2=56.2 //y2=3.125
cc_4935 ( N_noxref_15_c_6780_p N_noxref_20_c_9455_n ) capacitor c=0.0041019f \
 //x=59.32 //y=4.045 //x2=56.2 //y2=3.125
cc_4936 ( N_noxref_15_c_6740_n N_noxref_20_c_9455_n ) capacitor c=0.143532f \
 //x=56.2 //y=3.895 //x2=56.2 //y2=3.125
cc_4937 ( N_noxref_15_c_6742_n N_VDD_c_10241_n ) capacitor c=0.00599793f \
 //x=45.7 //y=5.335 //x2=65.575 //y2=7.585
cc_4938 ( N_noxref_15_c_6630_n N_VDD_c_10241_n ) capacitor c=0.00627192f \
 //x=46.585 //y=5.335 //x2=65.575 //y2=7.585
cc_4939 ( N_noxref_15_c_6631_n N_VDD_c_10241_n ) capacitor c=0.00256019f \
 //x=46.7 //y=5.56 //x2=65.575 //y2=7.585
cc_4940 ( N_noxref_15_c_6634_n N_VDD_c_10241_n ) capacitor c=0.00829247f \
 //x=47.395 //y=5.335 //x2=65.575 //y2=7.585
cc_4941 ( N_noxref_15_c_6669_n N_VDD_c_10241_n ) capacitor c=5.12643e-19 \
 //x=47.48 //y=4.04 //x2=65.575 //y2=7.585
cc_4942 ( N_noxref_15_c_6594_n N_VDD_c_10241_n ) capacitor c=2.12476e-19 \
 //x=49.33 //y=4.04 //x2=65.575 //y2=7.585
cc_4943 ( N_noxref_15_c_6780_p N_VDD_c_10241_n ) capacitor c=2.12639e-19 \
 //x=59.32 //y=4.045 //x2=65.575 //y2=7.585
cc_4944 ( N_noxref_15_c_6754_n N_VDD_c_10241_n ) capacitor c=0.00261804f \
 //x=44.942 //y=5.335 //x2=65.575 //y2=7.585
cc_4945 ( N_noxref_15_c_6755_n N_VDD_c_10241_n ) capacitor c=0.00262144f \
 //x=45.82 //y=5.335 //x2=65.575 //y2=7.585
cc_4946 ( N_noxref_15_c_6599_n N_VDD_c_10241_n ) capacitor c=9.07241e-19 \
 //x=49.33 //y=4.88 //x2=65.575 //y2=7.585
cc_4947 ( N_noxref_15_c_6781_p N_VDD_c_10241_n ) capacitor c=9.07241e-19 \
 //x=59.32 //y=4.88 //x2=65.575 //y2=7.585
cc_4948 ( N_noxref_15_c_6835_p N_VDD_c_10241_n ) capacitor c=0.0024232f \
 //x=44.94 //y=5.56 //x2=65.575 //y2=7.585
cc_4949 ( N_noxref_15_c_6773_n N_VDD_c_10241_n ) capacitor c=0.0024232f \
 //x=45.82 //y=5.56 //x2=65.575 //y2=7.585
cc_4950 ( N_noxref_15_c_6710_n N_VDD_c_10241_n ) capacitor c=0.0024232f \
 //x=46.7 //y=5.56 //x2=65.575 //y2=7.585
cc_4951 ( N_noxref_15_c_6608_n N_VDD_c_10241_n ) capacitor c=6.22888e-19 \
 //x=49.33 //y=4.88 //x2=65.575 //y2=7.585
cc_4952 ( N_noxref_15_c_6782_p N_VDD_c_10241_n ) capacitor c=6.22888e-19 \
 //x=59.32 //y=4.88 //x2=65.575 //y2=7.585
cc_4953 ( N_noxref_15_c_6742_n N_VDD_c_11074_n ) capacitor c=0.00202922f \
 //x=45.7 //y=5.335 //x2=45.295 //y2=7.585
cc_4954 ( N_noxref_15_c_6754_n N_VDD_c_11074_n ) capacitor c=9.3757e-19 \
 //x=44.942 //y=5.335 //x2=45.295 //y2=7.585
cc_4955 ( N_noxref_15_c_6835_p N_VDD_c_11074_n ) capacitor c=0.0138074f \
 //x=44.94 //y=5.56 //x2=45.295 //y2=7.585
cc_4956 ( N_noxref_15_c_6742_n N_VDD_c_10993_n ) capacitor c=0.0017701f \
 //x=45.7 //y=5.335 //x2=46.175 //y2=7.585
cc_4957 ( N_noxref_15_c_6630_n N_VDD_c_10993_n ) capacitor c=0.00202922f \
 //x=46.585 //y=5.335 //x2=46.175 //y2=7.585
cc_4958 ( N_noxref_15_c_6755_n N_VDD_c_10993_n ) capacitor c=9.48145e-19 \
 //x=45.82 //y=5.335 //x2=46.175 //y2=7.585
cc_4959 ( N_noxref_15_c_6773_n N_VDD_c_10993_n ) capacitor c=0.0138074f \
 //x=45.82 //y=5.56 //x2=46.175 //y2=7.585
cc_4960 ( N_noxref_15_c_6630_n N_VDD_c_10887_n ) capacitor c=0.00205906f \
 //x=46.585 //y=5.335 //x2=47.055 //y2=7.585
cc_4961 ( N_noxref_15_c_6631_n N_VDD_c_10887_n ) capacitor c=8.49654e-19 \
 //x=46.7 //y=5.56 //x2=47.055 //y2=7.585
cc_4962 ( N_noxref_15_c_6634_n N_VDD_c_10887_n ) capacitor c=0.00204238f \
 //x=47.395 //y=5.335 //x2=47.055 //y2=7.585
cc_4963 ( N_noxref_15_c_6710_n N_VDD_c_10887_n ) capacitor c=0.0138074f \
 //x=46.7 //y=5.56 //x2=47.055 //y2=7.585
cc_4964 ( N_noxref_15_c_6634_n N_VDD_c_11085_n ) capacitor c=0.00183742f \
 //x=47.395 //y=5.335 //x2=48.05 //y2=7.585
cc_4965 ( N_noxref_15_c_6599_n N_VDD_c_10889_n ) capacitor c=6.28113e-19 \
 //x=49.33 //y=4.88 //x2=49.805 //y2=7.585
cc_4966 ( N_noxref_15_M104_noxref_g N_VDD_c_10889_n ) capacitor c=0.00732618f \
 //x=49.23 //y=6.2 //x2=49.805 //y2=7.585
cc_4967 ( N_noxref_15_M105_noxref_g N_VDD_c_10889_n ) capacitor c=0.00755544f \
 //x=49.67 //y=6.2 //x2=49.805 //y2=7.585
cc_4968 ( N_noxref_15_c_6781_p N_VDD_c_11089_n ) capacitor c=6.28113e-19 \
 //x=59.32 //y=4.88 //x2=59.795 //y2=7.585
cc_4969 ( N_noxref_15_M116_noxref_g N_VDD_c_11089_n ) capacitor c=0.00732618f \
 //x=59.22 //y=6.2 //x2=59.795 //y2=7.585
cc_4970 ( N_noxref_15_M117_noxref_g N_VDD_c_11089_n ) capacitor c=0.00755544f \
 //x=59.66 //y=6.2 //x2=59.795 //y2=7.585
cc_4971 ( N_noxref_15_c_6754_n N_VDD_c_10822_n ) capacitor c=0.0022955f \
 //x=44.942 //y=5.335 //x2=43.41 //y2=7.585
cc_4972 ( N_noxref_15_c_6835_p N_VDD_c_10822_n ) capacitor c=0.00508013f \
 //x=44.94 //y=5.56 //x2=43.41 //y2=7.585
cc_4973 ( N_noxref_15_c_6631_n N_VDD_c_10900_n ) capacitor c=0.00269779f \
 //x=46.7 //y=5.56 //x2=48.22 //y2=7.585
cc_4974 ( N_noxref_15_c_6586_n N_VDD_c_10900_n ) capacitor c=0.0311457f \
 //x=47.48 //y=5.25 //x2=48.22 //y2=7.585
cc_4975 ( N_noxref_15_c_6599_n N_VDD_c_10900_n ) capacitor c=0.00447349f \
 //x=49.33 //y=4.88 //x2=48.22 //y2=7.585
cc_4976 ( N_noxref_15_c_6602_n N_VDD_c_10900_n ) capacitor c=0.005882f \
 //x=49.332 //y=4.74 //x2=48.22 //y2=7.585
cc_4977 ( N_noxref_15_c_6710_n N_VDD_c_10900_n ) capacitor c=0.00776541f \
 //x=46.7 //y=5.56 //x2=48.22 //y2=7.585
cc_4978 ( N_noxref_15_c_6608_n N_VDD_c_10900_n ) capacitor c=0.00370494f \
 //x=49.33 //y=4.88 //x2=48.22 //y2=7.585
cc_4979 ( N_noxref_15_c_6627_n N_VDD_c_10900_n ) capacitor c=0.0129731f \
 //x=49.33 //y=4.88 //x2=48.22 //y2=7.585
cc_4980 ( N_noxref_15_c_6781_p N_VDD_c_11025_n ) capacitor c=0.00508547f \
 //x=59.32 //y=4.88 //x2=58.21 //y2=7.585
cc_4981 ( N_noxref_15_c_6762_n N_VDD_c_11025_n ) capacitor c=0.00663802f \
 //x=59.322 //y=4.74 //x2=58.21 //y2=7.585
cc_4982 ( N_noxref_15_c_6782_p N_VDD_c_11025_n ) capacitor c=0.00370494f \
 //x=59.32 //y=4.88 //x2=58.21 //y2=7.585
cc_4983 ( N_noxref_15_c_6785_p N_VDD_c_11025_n ) capacitor c=0.0129564f \
 //x=59.32 //y=4.88 //x2=58.21 //y2=7.585
cc_4984 ( N_noxref_15_c_6754_n N_VDD_M94_noxref_s ) capacitor c=4.22189e-19 \
 //x=44.942 //y=5.335 //x2=40.735 //y2=5.2
cc_4985 ( N_noxref_15_c_6754_n N_VDD_M98_noxref_s ) capacitor c=0.0441176f \
 //x=44.942 //y=5.335 //x2=44.365 //y2=5.2
cc_4986 ( N_noxref_15_c_6755_n N_VDD_M98_noxref_s ) capacitor c=7.80122e-19 \
 //x=45.82 //y=5.335 //x2=44.365 //y2=5.2
cc_4987 ( N_noxref_15_c_6835_p N_VDD_M98_noxref_s ) capacitor c=0.0908457f \
 //x=44.94 //y=5.56 //x2=44.365 //y2=5.2
cc_4988 ( N_noxref_15_c_6742_n N_VDD_M99_noxref_d ) capacitor c=0.00700141f \
 //x=45.7 //y=5.335 //x2=45.235 //y2=5.2
cc_4989 ( N_noxref_15_c_6835_p N_VDD_M99_noxref_d ) capacitor c=0.0673792f \
 //x=44.94 //y=5.56 //x2=45.235 //y2=5.2
cc_4990 ( N_noxref_15_c_6773_n N_VDD_M99_noxref_d ) capacitor c=0.0674762f \
 //x=45.82 //y=5.56 //x2=45.235 //y2=5.2
cc_4991 ( N_noxref_15_c_6630_n N_VDD_M101_noxref_d ) capacitor c=0.00700141f \
 //x=46.585 //y=5.335 //x2=46.115 //y2=5.2
cc_4992 ( N_noxref_15_c_6773_n N_VDD_M101_noxref_d ) capacitor c=0.067493f \
 //x=45.82 //y=5.56 //x2=46.115 //y2=5.2
cc_4993 ( N_noxref_15_c_6710_n N_VDD_M101_noxref_d ) capacitor c=0.0674288f \
 //x=46.7 //y=5.56 //x2=46.115 //y2=5.2
cc_4994 ( N_noxref_15_c_6634_n N_VDD_M103_noxref_d ) capacitor c=0.00700141f \
 //x=47.395 //y=5.335 //x2=46.995 //y2=5.2
cc_4995 ( N_noxref_15_c_6710_n N_VDD_M103_noxref_d ) capacitor c=0.0673824f \
 //x=46.7 //y=5.56 //x2=46.995 //y2=5.2
cc_4996 ( N_noxref_15_c_6631_n N_VDD_M104_noxref_s ) capacitor c=0.00536022f \
 //x=46.7 //y=5.56 //x2=48.875 //y2=5.2
cc_4997 ( N_noxref_15_c_6634_n N_VDD_M104_noxref_s ) capacitor c=0.00211796f \
 //x=47.395 //y=5.335 //x2=48.875 //y2=5.2
cc_4998 ( N_noxref_15_c_6594_n N_VDD_M104_noxref_s ) capacitor c=0.00143547f \
 //x=49.33 //y=4.04 //x2=48.875 //y2=5.2
cc_4999 ( N_noxref_15_M104_noxref_g N_VDD_M104_noxref_s ) capacitor \
 c=0.0567929f //x=49.23 //y=6.2 //x2=48.875 //y2=5.2
cc_5000 ( N_noxref_15_M105_noxref_g N_VDD_M105_noxref_d ) capacitor \
 c=0.015318f //x=49.67 //y=6.2 //x2=49.745 //y2=5.2
cc_5001 ( N_noxref_15_c_6780_p N_VDD_M116_noxref_s ) capacitor c=0.00144559f \
 //x=59.32 //y=4.045 //x2=58.865 //y2=5.2
cc_5002 ( N_noxref_15_M116_noxref_g N_VDD_M116_noxref_s ) capacitor \
 c=0.0567929f //x=59.22 //y=6.2 //x2=58.865 //y2=5.2
cc_5003 ( N_noxref_15_M117_noxref_g N_VDD_M117_noxref_d ) capacitor \
 c=0.015318f //x=59.66 //y=6.2 //x2=59.735 //y2=5.2
cc_5004 ( N_noxref_15_c_6647_n N_noxref_25_c_11822_n ) capacitor c=8.25606e-19 \
 //x=46.995 //y=1.76 //x2=42.585 //y2=1.835
cc_5005 ( N_noxref_15_c_6657_n N_noxref_25_c_11791_n ) capacitor c=8.25606e-19 \
 //x=47.08 //y=1.845 //x2=42.67 //y2=2.285
cc_5006 ( N_noxref_15_c_6754_n N_noxref_25_c_11792_n ) capacitor c=0.00261914f \
 //x=44.942 //y=5.335 //x2=42.67 //y2=5.295
cc_5007 ( N_noxref_15_c_6754_n N_noxref_25_c_11840_n ) capacitor c=5.0812e-19 \
 //x=44.942 //y=5.335 //x2=42.19 //y2=5.38
cc_5008 ( N_noxref_15_c_6639_n N_noxref_26_c_11954_n ) capacitor c=0.0036878f \
 //x=46.995 //y=1.305 //x2=47.395 //y2=0.72
cc_5009 ( N_noxref_15_c_6653_n N_noxref_26_c_11954_n ) capacitor c=0.00399931f \
 //x=47.395 //y=1.845 //x2=47.395 //y2=0.72
cc_5010 ( N_noxref_15_M28_noxref_d N_noxref_26_c_11954_n ) capacitor \
 c=0.00910163f //x=46.805 //y=1.095 //x2=47.395 //y2=0.72
cc_5011 ( N_noxref_15_M28_noxref_d N_noxref_26_c_11959_n ) capacitor \
 c=0.00120711f //x=46.805 //y=1.095 //x2=46.51 //y2=1.175
cc_5012 ( N_noxref_15_c_6742_n N_noxref_26_M27_noxref_d ) capacitor \
 c=0.00150473f //x=45.7 //y=5.335 //x2=45.27 //y2=1.09
cc_5013 ( N_noxref_15_c_6639_n N_noxref_26_M27_noxref_d ) capacitor \
 c=0.00802836f //x=46.995 //y=1.305 //x2=45.27 //y2=1.09
cc_5014 ( N_noxref_15_c_6639_n N_noxref_26_M28_noxref_s ) capacitor \
 c=0.00993092f //x=46.995 //y=1.305 //x2=46.375 //y2=0.555
cc_5015 ( N_noxref_15_c_6647_n N_noxref_26_M28_noxref_s ) capacitor \
 c=0.0270492f //x=46.995 //y=1.76 //x2=46.375 //y2=0.555
cc_5016 ( N_noxref_15_c_6653_n N_noxref_26_M28_noxref_s ) capacitor \
 c=0.00911719f //x=47.395 //y=1.845 //x2=46.375 //y2=0.555
cc_5017 ( N_noxref_15_c_6688_n N_noxref_26_M28_noxref_s ) capacitor \
 c=0.00129723f //x=47.48 //y=3.88 //x2=46.375 //y2=0.555
cc_5018 ( N_noxref_15_M28_noxref_d N_noxref_26_M28_noxref_s ) capacitor \
 c=0.0279003f //x=46.805 //y=1.095 //x2=46.375 //y2=0.555
cc_5019 ( N_noxref_15_c_6639_n N_GND_c_12829_n ) capacitor c=0.00884249f \
 //x=46.995 //y=1.305 //x2=49.315 //y2=0.175
cc_5020 ( N_noxref_15_c_6653_n N_GND_c_12829_n ) capacitor c=0.00662992f \
 //x=47.395 //y=1.845 //x2=49.315 //y2=0.175
cc_5021 ( N_noxref_15_c_6669_n N_GND_c_12829_n ) capacitor c=3.10314e-19 \
 //x=47.48 //y=4.04 //x2=49.315 //y2=0.175
cc_5022 ( N_noxref_15_M28_noxref_d N_GND_c_12829_n ) capacitor c=2.9462e-19 \
 //x=46.805 //y=1.095 //x2=49.315 //y2=0.175
cc_5023 ( N_noxref_15_c_6639_n N_GND_c_12833_n ) capacitor c=0.00488628f \
 //x=46.995 //y=1.305 //x2=49.4 //y2=1.135
cc_5024 ( N_noxref_15_c_6596_n N_GND_c_12833_n ) capacitor c=0.00645051f \
 //x=49.33 //y=2.26 //x2=49.4 //y2=1.135
cc_5025 ( N_noxref_15_c_6604_n N_GND_c_12833_n ) capacitor c=2.13705e-19 \
 //x=49.33 //y=2.26 //x2=49.4 //y2=1.135
cc_5026 ( N_noxref_15_c_6614_n N_GND_c_12833_n ) capacitor c=0.00176535f \
 //x=49.135 //y=1.045 //x2=49.4 //y2=1.135
cc_5027 ( N_noxref_15_c_6615_n N_GND_c_12833_n ) capacitor c=0.0036005f \
 //x=49.135 //y=1.39 //x2=49.4 //y2=1.135
cc_5028 ( N_noxref_15_c_6616_n N_GND_c_12833_n ) capacitor c=4.2764e-19 \
 //x=49.135 //y=1.7 //x2=49.4 //y2=1.135
cc_5029 ( N_noxref_15_c_7007_p N_GND_c_12833_n ) capacitor c=9.36995e-19 \
 //x=49.51 //y=0.89 //x2=49.4 //y2=1.135
cc_5030 ( N_noxref_15_c_7008_p N_GND_c_12833_n ) capacitor c=6.38426e-19 \
 //x=49.51 //y=1.545 //x2=49.4 //y2=1.135
cc_5031 ( N_noxref_15_c_6622_n N_GND_c_12833_n ) capacitor c=0.00171721f \
 //x=49.665 //y=1.045 //x2=49.4 //y2=1.135
cc_5032 ( N_noxref_15_c_6624_n N_GND_c_12833_n ) capacitor c=0.00296337f \
 //x=49.665 //y=1.39 //x2=49.4 //y2=1.135
cc_5033 ( N_noxref_15_c_6614_n N_GND_c_12942_n ) capacitor c=3.51399e-19 \
 //x=49.135 //y=1.045 //x2=49.397 //y2=1.005
cc_5034 ( N_noxref_15_c_7007_p N_GND_c_12942_n ) capacitor c=0.00852202f \
 //x=49.51 //y=0.89 //x2=49.397 //y2=1.005
cc_5035 ( N_noxref_15_c_6622_n N_GND_c_12942_n ) capacitor c=4.40641e-19 \
 //x=49.665 //y=1.045 //x2=49.397 //y2=1.005
cc_5036 ( N_noxref_15_c_6798_p N_GND_c_12945_n ) capacitor c=0.00645051f \
 //x=59.32 //y=2.26 //x2=59.39 //y2=1.135
cc_5037 ( N_noxref_15_c_6842_p N_GND_c_12945_n ) capacitor c=2.13705e-19 \
 //x=59.32 //y=2.26 //x2=59.39 //y2=1.135
cc_5038 ( N_noxref_15_c_6871_p N_GND_c_12945_n ) capacitor c=0.00171023f \
 //x=59.125 //y=1.045 //x2=59.39 //y2=1.135
cc_5039 ( N_noxref_15_c_6872_p N_GND_c_12945_n ) capacitor c=0.00357815f \
 //x=59.125 //y=1.39 //x2=59.39 //y2=1.135
cc_5040 ( N_noxref_15_c_6874_p N_GND_c_12945_n ) capacitor c=4.2764e-19 \
 //x=59.125 //y=1.7 //x2=59.39 //y2=1.135
cc_5041 ( N_noxref_15_c_7019_p N_GND_c_12945_n ) capacitor c=9.36995e-19 \
 //x=59.5 //y=0.89 //x2=59.39 //y2=1.135
cc_5042 ( N_noxref_15_c_7020_p N_GND_c_12945_n ) capacitor c=6.30911e-19 \
 //x=59.5 //y=1.545 //x2=59.39 //y2=1.135
cc_5043 ( N_noxref_15_c_6873_p N_GND_c_12945_n ) capacitor c=0.00171721f \
 //x=59.655 //y=1.045 //x2=59.39 //y2=1.135
cc_5044 ( N_noxref_15_c_6875_p N_GND_c_12945_n ) capacitor c=0.00296337f \
 //x=59.655 //y=1.39 //x2=59.39 //y2=1.135
cc_5045 ( N_noxref_15_c_6871_p N_GND_c_12954_n ) capacitor c=3.46594e-19 \
 //x=59.125 //y=1.045 //x2=59.387 //y2=1.005
cc_5046 ( N_noxref_15_c_7019_p N_GND_c_12954_n ) capacitor c=0.00839795f \
 //x=59.5 //y=0.89 //x2=59.387 //y2=1.005
cc_5047 ( N_noxref_15_c_6873_p N_GND_c_12954_n ) capacitor c=4.40641e-19 \
 //x=59.655 //y=1.045 //x2=59.387 //y2=1.005
cc_5048 ( N_noxref_15_c_6653_n N_GND_c_12849_n ) capacitor c=6.86343e-19 \
 //x=47.395 //y=1.845 //x2=48.05 //y2=0.175
cc_5049 ( N_noxref_15_c_6614_n N_GND_c_12801_n ) capacitor c=0.00688027f \
 //x=49.135 //y=1.045 //x2=51.38 //y2=0.175
cc_5050 ( N_noxref_15_c_6871_p N_GND_c_12959_n ) capacitor c=0.00688027f \
 //x=59.125 //y=1.045 //x2=61.37 //y2=0.175
cc_5051 ( N_noxref_15_c_6647_n N_GND_c_12823_n ) capacitor c=0.00285697f \
 //x=46.995 //y=1.76 //x2=48.22 //y2=0.175
cc_5052 ( N_noxref_15_c_6653_n N_GND_c_12823_n ) capacitor c=0.0297354f \
 //x=47.395 //y=1.845 //x2=48.22 //y2=0.175
cc_5053 ( N_noxref_15_c_6587_n N_GND_c_12823_n ) capacitor c=0.00615382f \
 //x=49.33 //y=3.72 //x2=48.22 //y2=0.175
cc_5054 ( N_noxref_15_c_6596_n N_GND_c_12823_n ) capacitor c=0.00357799f \
 //x=49.33 //y=2.26 //x2=48.22 //y2=0.175
cc_5055 ( N_noxref_15_c_6604_n N_GND_c_12823_n ) capacitor c=0.00371068f \
 //x=49.33 //y=2.26 //x2=48.22 //y2=0.175
cc_5056 ( N_noxref_15_c_6616_n N_GND_c_12823_n ) capacitor c=0.0015404f \
 //x=49.135 //y=1.7 //x2=48.22 //y2=0.175
cc_5057 ( N_noxref_15_c_6618_n N_GND_c_12823_n ) capacitor c=0.0093907f \
 //x=49.135 //y=2.095 //x2=48.22 //y2=0.175
cc_5058 ( N_noxref_15_c_6753_n N_GND_c_12925_n ) capacitor c=0.00781993f \
 //x=59.32 //y=3.725 //x2=58.21 //y2=0.175
cc_5059 ( N_noxref_15_c_6798_p N_GND_c_12925_n ) capacitor c=0.00351582f \
 //x=59.32 //y=2.26 //x2=58.21 //y2=0.175
cc_5060 ( N_noxref_15_c_6842_p N_GND_c_12925_n ) capacitor c=0.00371068f \
 //x=59.32 //y=2.26 //x2=58.21 //y2=0.175
cc_5061 ( N_noxref_15_c_6874_p N_GND_c_12925_n ) capacitor c=0.0015404f \
 //x=59.125 //y=1.7 //x2=58.21 //y2=0.175
cc_5062 ( N_noxref_15_c_6855_p N_GND_c_12925_n ) capacitor c=0.00936534f \
 //x=59.125 //y=2.095 //x2=58.21 //y2=0.175
cc_5063 ( N_noxref_15_c_6596_n N_GND_M29_noxref_d ) capacitor c=2.20438e-19 \
 //x=49.33 //y=2.26 //x2=49.21 //y2=1.045
cc_5064 ( N_noxref_15_c_6614_n N_GND_M29_noxref_d ) capacitor c=0.00192399f \
 //x=49.135 //y=1.045 //x2=49.21 //y2=1.045
cc_5065 ( N_noxref_15_c_6615_n N_GND_M29_noxref_d ) capacitor c=0.00210798f \
 //x=49.135 //y=1.39 //x2=49.21 //y2=1.045
cc_5066 ( N_noxref_15_c_7007_p N_GND_M29_noxref_d ) capacitor c=0.00472259f \
 //x=49.51 //y=0.89 //x2=49.21 //y2=1.045
cc_5067 ( N_noxref_15_c_7008_p N_GND_M29_noxref_d ) capacitor c=0.00166857f \
 //x=49.51 //y=1.545 //x2=49.21 //y2=1.045
cc_5068 ( N_noxref_15_c_6622_n N_GND_M29_noxref_d ) capacitor c=0.00230174f \
 //x=49.665 //y=1.045 //x2=49.21 //y2=1.045
cc_5069 ( N_noxref_15_c_6624_n N_GND_M29_noxref_d ) capacitor c=0.00210798f \
 //x=49.665 //y=1.39 //x2=49.21 //y2=1.045
cc_5070 ( N_noxref_15_c_6798_p N_GND_M35_noxref_d ) capacitor c=2.20438e-19 \
 //x=59.32 //y=2.26 //x2=59.2 //y2=1.045
cc_5071 ( N_noxref_15_c_6871_p N_GND_M35_noxref_d ) capacitor c=0.00192399f \
 //x=59.125 //y=1.045 //x2=59.2 //y2=1.045
cc_5072 ( N_noxref_15_c_6872_p N_GND_M35_noxref_d ) capacitor c=0.00210798f \
 //x=59.125 //y=1.39 //x2=59.2 //y2=1.045
cc_5073 ( N_noxref_15_c_7019_p N_GND_M35_noxref_d ) capacitor c=0.00472259f \
 //x=59.5 //y=0.89 //x2=59.2 //y2=1.045
cc_5074 ( N_noxref_15_c_7020_p N_GND_M35_noxref_d ) capacitor c=0.00166857f \
 //x=59.5 //y=1.545 //x2=59.2 //y2=1.045
cc_5075 ( N_noxref_15_c_6873_p N_GND_M35_noxref_d ) capacitor c=0.00230174f \
 //x=59.655 //y=1.045 //x2=59.2 //y2=1.045
cc_5076 ( N_noxref_15_c_6875_p N_GND_M35_noxref_d ) capacitor c=0.00210798f \
 //x=59.655 //y=1.39 //x2=59.2 //y2=1.045
cc_5077 ( N_noxref_15_c_6618_n N_noxref_44_c_14862_n ) capacitor c=0.00262672f \
 //x=49.135 //y=2.095 //x2=48.915 //y2=1.675
cc_5078 ( N_noxref_15_c_6594_n N_noxref_44_c_14863_n ) capacitor c=0.00361134f \
 //x=49.33 //y=4.04 //x2=49.8 //y2=1.76
cc_5079 ( N_noxref_15_c_6596_n N_noxref_44_c_14863_n ) capacitor c=0.00509504f \
 //x=49.33 //y=2.26 //x2=49.8 //y2=1.76
cc_5080 ( N_noxref_15_c_6604_n N_noxref_44_c_14863_n ) capacitor c=0.00763108f \
 //x=49.33 //y=2.26 //x2=49.8 //y2=1.76
cc_5081 ( N_noxref_15_c_6616_n N_noxref_44_c_14863_n ) capacitor c=0.00697076f \
 //x=49.135 //y=1.7 //x2=49.8 //y2=1.76
cc_5082 ( N_noxref_15_c_6618_n N_noxref_44_c_14863_n ) capacitor c=0.0170561f \
 //x=49.135 //y=2.095 //x2=49.8 //y2=1.76
cc_5083 ( N_noxref_15_c_7008_p N_noxref_44_c_14863_n ) capacitor c=0.00723574f \
 //x=49.51 //y=1.545 //x2=49.8 //y2=1.76
cc_5084 ( N_noxref_15_c_6624_n N_noxref_44_c_14863_n ) capacitor c=0.00339872f \
 //x=49.665 //y=1.39 //x2=49.8 //y2=1.76
cc_5085 ( N_noxref_15_c_6618_n N_noxref_44_c_14839_n ) capacitor c=6.71402e-19 \
 //x=49.135 //y=2.095 //x2=49.885 //y2=1.675
cc_5086 ( N_noxref_15_c_6614_n N_noxref_44_M29_noxref_s ) capacitor \
 c=0.0295366f //x=49.135 //y=1.045 //x2=48.78 //y2=0.545
cc_5087 ( N_noxref_15_c_6616_n N_noxref_44_M29_noxref_s ) capacitor \
 c=3.48408e-19 //x=49.135 //y=1.7 //x2=48.78 //y2=0.545
cc_5088 ( N_noxref_15_c_6622_n N_noxref_44_M29_noxref_s ) capacitor \
 c=0.0125442f //x=49.665 //y=1.045 //x2=48.78 //y2=0.545
cc_5089 ( N_noxref_15_c_6855_p N_noxref_47_c_15045_n ) capacitor c=0.00262672f \
 //x=59.125 //y=2.095 //x2=58.905 //y2=1.675
cc_5090 ( N_noxref_15_c_6780_p N_noxref_47_c_15046_n ) capacitor c=0.00364314f \
 //x=59.32 //y=4.045 //x2=59.79 //y2=1.76
cc_5091 ( N_noxref_15_c_6798_p N_noxref_47_c_15046_n ) capacitor c=0.00509504f \
 //x=59.32 //y=2.26 //x2=59.79 //y2=1.76
cc_5092 ( N_noxref_15_c_6842_p N_noxref_47_c_15046_n ) capacitor c=0.00763108f \
 //x=59.32 //y=2.26 //x2=59.79 //y2=1.76
cc_5093 ( N_noxref_15_c_6874_p N_noxref_47_c_15046_n ) capacitor c=0.00697076f \
 //x=59.125 //y=1.7 //x2=59.79 //y2=1.76
cc_5094 ( N_noxref_15_c_6855_p N_noxref_47_c_15046_n ) capacitor c=0.0170561f \
 //x=59.125 //y=2.095 //x2=59.79 //y2=1.76
cc_5095 ( N_noxref_15_c_7020_p N_noxref_47_c_15046_n ) capacitor c=0.00723574f \
 //x=59.5 //y=1.545 //x2=59.79 //y2=1.76
cc_5096 ( N_noxref_15_c_6875_p N_noxref_47_c_15046_n ) capacitor c=0.00339872f \
 //x=59.655 //y=1.39 //x2=59.79 //y2=1.76
cc_5097 ( N_noxref_15_c_6855_p N_noxref_47_c_15053_n ) capacitor c=6.71402e-19 \
 //x=59.125 //y=2.095 //x2=59.875 //y2=1.675
cc_5098 ( N_noxref_15_c_6871_p N_noxref_47_M35_noxref_s ) capacitor \
 c=0.0294925f //x=59.125 //y=1.045 //x2=58.77 //y2=0.545
cc_5099 ( N_noxref_15_c_6874_p N_noxref_47_M35_noxref_s ) capacitor \
 c=3.48408e-19 //x=59.125 //y=1.7 //x2=58.77 //y2=0.545
cc_5100 ( N_noxref_15_c_6873_p N_noxref_47_M35_noxref_s ) capacitor \
 c=0.0125442f //x=59.655 //y=1.045 //x2=58.77 //y2=0.545
cc_5101 ( N_noxref_16_c_7094_p N_noxref_17_c_7436_n ) capacitor c=0.00324213f \
 //x=60.36 //y=1.75 //x2=57.03 //y2=1.75
cc_5102 ( N_noxref_16_c_7082_n N_noxref_17_c_7528_n ) capacitor c=0.00114153f \
 //x=59.44 //y=5.56 //x2=57.385 //y2=5.38
cc_5103 ( N_noxref_16_c_7096_p N_noxref_17_c_7529_n ) capacitor c=0.00231467f \
 //x=60.445 //y=1.835 //x2=57.385 //y2=1.835
cc_5104 ( N_noxref_16_c_7080_n N_noxref_17_c_7438_n ) capacitor c=0.00204244f \
 //x=60.8 //y=4.475 //x2=57.47 //y2=4.105
cc_5105 ( N_noxref_16_c_7098_p N_noxref_17_c_7441_n ) capacitor c=0.00281705f \
 //x=60.8 //y=5.295 //x2=57.47 //y2=5.295
cc_5106 ( N_noxref_16_c_7080_n N_noxref_17_c_7661_n ) capacitor c=0.00270906f \
 //x=60.8 //y=4.475 //x2=63.39 //y2=4.09
cc_5107 ( N_noxref_16_c_7100_p N_noxref_17_c_7661_n ) capacitor c=0.0699784f \
 //x=62.65 //y=4.705 //x2=63.39 //y2=4.09
cc_5108 ( N_noxref_16_c_7101_p N_noxref_17_c_7661_n ) capacitor c=3.30333e-19 \
 //x=62.65 //y=2.26 //x2=63.39 //y2=4.09
cc_5109 ( N_noxref_16_c_7100_p N_noxref_17_c_7664_n ) capacitor c=0.0173413f \
 //x=62.65 //y=4.705 //x2=63.39 //y2=4.41
cc_5110 ( N_noxref_16_c_7100_p N_noxref_17_c_7665_n ) capacitor c=0.0109797f \
 //x=62.65 //y=4.705 //x2=63.39 //y2=4.735
cc_5111 ( N_noxref_16_c_7104_p N_noxref_17_c_7665_n ) capacitor c=0.0140893f \
 //x=62.65 //y=4.865 //x2=63.39 //y2=4.735
cc_5112 ( N_noxref_16_c_7105_p N_noxref_17_c_7665_n ) capacitor c=0.0116004f \
 //x=62.65 //y=4.62 //x2=63.39 //y2=4.735
cc_5113 ( N_noxref_16_c_7106_p N_noxref_17_c_7665_n ) capacitor c=4.73677e-19 \
 //x=62.65 //y=4.88 //x2=63.39 //y2=4.735
cc_5114 ( N_noxref_16_c_7107_p N_noxref_17_c_7665_n ) capacitor c=9.08746e-19 \
 //x=62.65 //y=4.88 //x2=63.39 //y2=4.735
cc_5115 ( N_noxref_16_c_7082_n N_noxref_17_c_7545_n ) capacitor c=5.29822e-19 \
 //x=59.44 //y=5.56 //x2=56.99 //y2=5.38
cc_5116 ( N_noxref_16_c_7082_n N_noxref_17_c_7671_n ) capacitor c=0.00147119f \
 //x=59.44 //y=5.56 //x2=56.99 //y2=5.56
cc_5117 ( N_noxref_16_c_7110_p N_noxref_17_c_7454_n ) capacitor c=6.99317e-19 \
 //x=60.36 //y=1.18 //x2=57.03 //y2=1.18
cc_5118 ( N_noxref_16_c_7100_p N_noxref_17_c_7673_n ) capacitor c=6.16997e-19 \
 //x=62.65 //y=4.705 //x2=63.39 //y2=4.25
cc_5119 ( N_noxref_16_c_7112_p N_noxref_17_c_7674_n ) capacitor c=0.0179797f \
 //x=62.65 //y=2.26 //x2=63.39 //y2=2.26
cc_5120 ( N_noxref_16_c_7101_p N_noxref_17_c_7674_n ) capacitor c=5.16867e-19 \
 //x=62.65 //y=2.26 //x2=63.39 //y2=2.26
cc_5121 ( N_noxref_16_c_7114_p N_noxref_17_c_7674_n ) capacitor c=0.00161745f \
 //x=62.455 //y=2.095 //x2=63.39 //y2=2.26
cc_5122 ( N_noxref_16_c_7079_n N_noxref_17_c_7643_n ) capacitor c=0.0120431f \
 //x=60.205 //y=5.38 //x2=59.535 //y2=4.27
cc_5123 ( N_noxref_16_c_7080_n N_noxref_17_c_7643_n ) capacitor c=0.0227809f \
 //x=60.8 //y=4.475 //x2=59.535 //y2=4.27
cc_5124 ( N_noxref_16_c_7117_p N_noxref_17_c_7643_n ) capacitor c=0.0095529f \
 //x=60.8 //y=4.795 //x2=59.535 //y2=4.27
cc_5125 ( N_noxref_16_c_7100_p N_noxref_17_c_7643_n ) capacitor c=0.0255306f \
 //x=62.65 //y=4.705 //x2=59.535 //y2=4.27
cc_5126 ( N_noxref_16_c_7082_n N_noxref_17_c_7643_n ) capacitor c=0.00567657f \
 //x=59.44 //y=5.56 //x2=59.535 //y2=4.27
cc_5127 ( N_noxref_16_c_7120_p N_noxref_17_c_7643_n ) capacitor c=0.0138557f \
 //x=60.32 //y=5.38 //x2=59.535 //y2=4.27
cc_5128 ( N_noxref_16_c_7104_p N_noxref_17_c_7643_n ) capacitor c=0.00155364f \
 //x=62.65 //y=4.865 //x2=59.535 //y2=4.27
cc_5129 ( N_noxref_16_c_7122_p N_noxref_17_c_7643_n ) capacitor c=0.163365f \
 //x=62.49 //y=4.62 //x2=59.535 //y2=4.27
cc_5130 ( N_noxref_16_c_7123_p N_noxref_17_c_7643_n ) capacitor c=0.0368432f \
 //x=60.955 //y=4.635 //x2=59.535 //y2=4.27
cc_5131 ( N_noxref_16_c_7105_p N_noxref_17_c_7643_n ) capacitor c=0.0043105f \
 //x=62.65 //y=4.62 //x2=59.535 //y2=4.27
cc_5132 ( N_noxref_16_c_7100_p N_noxref_17_c_7687_n ) capacitor c=3.30333e-19 \
 //x=62.65 //y=4.705 //x2=63.39 //y2=2.26
cc_5133 ( N_noxref_16_c_7112_p N_noxref_17_c_7687_n ) capacitor c=5.24723e-19 \
 //x=62.65 //y=2.26 //x2=63.39 //y2=2.26
cc_5134 ( N_noxref_16_c_7101_p N_noxref_17_c_7687_n ) capacitor c=0.00485709f \
 //x=62.65 //y=2.26 //x2=63.39 //y2=2.26
cc_5135 ( N_noxref_16_c_7114_p N_noxref_17_c_7687_n ) capacitor c=0.00267961f \
 //x=62.455 //y=2.095 //x2=63.39 //y2=2.26
cc_5136 ( N_noxref_16_c_7104_p N_noxref_17_c_7691_n ) capacitor c=5.42697e-19 \
 //x=62.65 //y=4.865 //x2=63.42 //y2=4.88
cc_5137 ( N_noxref_16_c_7106_p N_noxref_17_c_7691_n ) capacitor c=0.00432987f \
 //x=62.65 //y=4.88 //x2=63.42 //y2=4.88
cc_5138 ( N_noxref_16_c_7107_p N_noxref_17_c_7691_n ) capacitor c=0.0018625f \
 //x=62.65 //y=4.88 //x2=63.42 //y2=4.88
cc_5139 ( N_noxref_16_M120_noxref_g N_noxref_17_M122_noxref_g ) capacitor \
 c=0.0104892f //x=62.55 //y=6.2 //x2=63.43 //y2=6.2
cc_5140 ( N_noxref_16_M121_noxref_g N_noxref_17_M122_noxref_g ) capacitor \
 c=0.107636f //x=62.99 //y=6.2 //x2=63.43 //y2=6.2
cc_5141 ( N_noxref_16_M121_noxref_g N_noxref_17_M123_noxref_g ) capacitor \
 c=0.0100341f //x=62.99 //y=6.2 //x2=63.87 //y2=6.2
cc_5142 ( N_noxref_16_c_7135_p N_noxref_17_c_7697_n ) capacitor c=4.86545e-19 \
 //x=62.455 //y=1.045 //x2=63.425 //y2=1.085
cc_5143 ( N_noxref_16_c_7136_p N_noxref_17_c_7697_n ) capacitor c=0.00152405f \
 //x=62.455 //y=1.39 //x2=63.425 //y2=1.085
cc_5144 ( N_noxref_16_c_7137_p N_noxref_17_c_7697_n ) capacitor c=0.0151475f \
 //x=62.985 //y=1.045 //x2=63.425 //y2=1.085
cc_5145 ( N_noxref_16_c_7138_p N_noxref_17_c_7700_n ) capacitor c=0.00109982f \
 //x=62.455 //y=1.7 //x2=63.425 //y2=1.43
cc_5146 ( N_noxref_16_c_7139_p N_noxref_17_c_7700_n ) capacitor c=0.0111064f \
 //x=62.985 //y=1.39 //x2=63.425 //y2=1.43
cc_5147 ( N_noxref_16_c_7138_p N_noxref_17_c_7702_n ) capacitor c=9.58243e-19 \
 //x=62.455 //y=1.7 //x2=63.425 //y2=1.74
cc_5148 ( N_noxref_16_c_7114_p N_noxref_17_c_7702_n ) capacitor c=0.00662747f \
 //x=62.455 //y=2.095 //x2=63.425 //y2=1.74
cc_5149 ( N_noxref_16_c_7139_p N_noxref_17_c_7702_n ) capacitor c=0.00862358f \
 //x=62.985 //y=1.39 //x2=63.425 //y2=1.74
cc_5150 ( N_noxref_16_c_7137_p N_noxref_17_c_7705_n ) capacitor c=0.00127211f \
 //x=62.985 //y=1.045 //x2=63.955 //y2=1.085
cc_5151 ( N_noxref_16_c_7139_p N_noxref_17_c_7706_n ) capacitor c=0.00204774f \
 //x=62.985 //y=1.39 //x2=63.955 //y2=1.43
cc_5152 ( N_noxref_16_c_7112_p N_noxref_17_c_7707_n ) capacitor c=0.00161167f \
 //x=62.65 //y=2.26 //x2=63.39 //y2=2.26
cc_5153 ( N_noxref_16_c_7101_p N_noxref_17_c_7707_n ) capacitor c=0.0018937f \
 //x=62.65 //y=2.26 //x2=63.39 //y2=2.26
cc_5154 ( N_noxref_16_c_7114_p N_noxref_17_c_7707_n ) capacitor c=0.0181449f \
 //x=62.455 //y=2.095 //x2=63.39 //y2=2.26
cc_5155 ( N_noxref_16_c_7104_p N_noxref_17_c_7710_n ) capacitor c=0.00144734f \
 //x=62.65 //y=4.865 //x2=63.42 //y2=4.88
cc_5156 ( N_noxref_16_c_7106_p N_noxref_17_c_7710_n ) capacitor c=0.00237894f \
 //x=62.65 //y=4.88 //x2=63.42 //y2=4.88
cc_5157 ( N_noxref_16_c_7107_p N_noxref_17_c_7710_n ) capacitor c=0.0292875f \
 //x=62.65 //y=4.88 //x2=63.42 //y2=4.88
cc_5158 ( N_noxref_16_c_7080_n N_noxref_18_c_7986_n ) capacitor c=0.0558418f \
 //x=60.8 //y=4.475 //x2=60.06 //y2=3.705
cc_5159 ( N_noxref_16_c_7100_p N_noxref_18_c_7986_n ) capacitor c=0.0020872f \
 //x=62.65 //y=4.705 //x2=60.06 //y2=3.705
cc_5160 ( N_noxref_16_c_7079_n N_noxref_18_c_7988_n ) capacitor c=0.00141453f \
 //x=60.205 //y=5.38 //x2=60.06 //y2=4.025
cc_5161 ( N_noxref_16_c_7096_p N_noxref_18_c_7988_n ) capacitor c=4.23301e-19 \
 //x=60.445 //y=1.835 //x2=60.06 //y2=4.025
cc_5162 ( N_noxref_16_c_7080_n N_noxref_18_c_7988_n ) capacitor c=0.01761f \
 //x=60.8 //y=4.475 //x2=60.06 //y2=4.025
cc_5163 ( N_noxref_16_c_7120_p N_noxref_18_c_7988_n ) capacitor c=0.00168218f \
 //x=60.32 //y=5.38 //x2=60.06 //y2=4.025
cc_5164 ( N_noxref_16_c_7157_p N_noxref_18_c_7988_n ) capacitor c=4.37971e-19 \
 //x=60.32 //y=5.56 //x2=60.06 //y2=4.025
cc_5165 ( N_noxref_16_c_7079_n N_noxref_18_c_7992_n ) capacitor c=0.0221293f \
 //x=60.205 //y=5.38 //x2=60.06 //y2=4.735
cc_5166 ( N_noxref_16_c_7080_n N_noxref_18_c_7992_n ) capacitor c=0.0170525f \
 //x=60.8 //y=4.475 //x2=60.06 //y2=4.735
cc_5167 ( N_noxref_16_c_7117_p N_noxref_18_c_7992_n ) capacitor c=0.0164405f \
 //x=60.8 //y=4.795 //x2=60.06 //y2=4.735
cc_5168 ( N_noxref_16_c_7098_p N_noxref_18_c_7992_n ) capacitor c=0.0127734f \
 //x=60.8 //y=5.295 //x2=60.06 //y2=4.735
cc_5169 ( N_noxref_16_c_7100_p N_noxref_18_c_7992_n ) capacitor c=0.00136642f \
 //x=62.65 //y=4.705 //x2=60.06 //y2=4.735
cc_5170 ( N_noxref_16_c_7163_p N_noxref_18_c_7992_n ) capacitor c=6.69436e-19 \
 //x=60.8 //y=4.62 //x2=60.06 //y2=4.735
cc_5171 ( N_noxref_16_c_7123_p N_noxref_18_c_7992_n ) capacitor c=0.00726744f \
 //x=60.955 //y=4.635 //x2=60.06 //y2=4.735
cc_5172 ( N_noxref_16_M121_noxref_g N_noxref_18_c_8046_n ) capacitor \
 c=0.00967396f //x=62.99 //y=6.2 //x2=63.535 //y2=5.38
cc_5173 ( N_noxref_16_c_7094_p N_noxref_18_c_8047_n ) capacitor c=0.00324213f \
 //x=60.36 //y=1.75 //x2=63.69 //y2=1.75
cc_5174 ( N_noxref_16_c_7167_p N_noxref_18_c_8048_n ) capacitor c=0.00231467f \
 //x=60.715 //y=1.835 //x2=63.775 //y2=1.835
cc_5175 ( N_noxref_16_c_7080_n N_noxref_18_c_8049_n ) capacitor c=0.00204244f \
 //x=60.8 //y=4.475 //x2=64.13 //y2=3.73
cc_5176 ( N_noxref_16_c_7100_p N_noxref_18_c_8049_n ) capacitor c=0.00323711f \
 //x=62.65 //y=4.705 //x2=64.13 //y2=3.73
cc_5177 ( N_noxref_16_c_7098_p N_noxref_18_c_8051_n ) capacitor c=0.00281705f \
 //x=60.8 //y=5.295 //x2=64.13 //y2=5.295
cc_5178 ( N_noxref_16_c_7100_p N_noxref_18_c_8051_n ) capacitor c=0.00223662f \
 //x=62.65 //y=4.705 //x2=64.13 //y2=5.295
cc_5179 ( N_noxref_16_c_7080_n N_noxref_18_c_7998_n ) capacitor c=0.0138368f \
 //x=60.8 //y=4.475 //x2=60.06 //y2=2.26
cc_5180 ( N_noxref_16_c_7080_n N_noxref_18_c_8001_n ) capacitor c=7.6985e-19 \
 //x=60.8 //y=4.475 //x2=60.06 //y2=3.88
cc_5181 ( N_noxref_16_c_7174_p N_noxref_18_c_8055_n ) capacitor c=0.00114153f \
 //x=60.715 //y=5.38 //x2=62.77 //y2=5.56
cc_5182 ( N_noxref_16_c_7120_p N_noxref_18_c_8055_n ) capacitor c=5.29822e-19 \
 //x=60.32 //y=5.38 //x2=62.77 //y2=5.56
cc_5183 ( N_noxref_16_c_7176_p N_noxref_18_c_8055_n ) capacitor c=0.00147119f \
 //x=60.32 //y=5.56 //x2=62.77 //y2=5.56
cc_5184 ( N_noxref_16_c_7104_p N_noxref_18_c_8055_n ) capacitor c=0.0129872f \
 //x=62.65 //y=4.865 //x2=62.77 //y2=5.56
cc_5185 ( N_noxref_16_c_7105_p N_noxref_18_c_8055_n ) capacitor c=0.00431455f \
 //x=62.65 //y=4.62 //x2=62.77 //y2=5.56
cc_5186 ( N_noxref_16_c_7106_p N_noxref_18_c_8055_n ) capacitor c=0.00277154f \
 //x=62.65 //y=4.88 //x2=62.77 //y2=5.56
cc_5187 ( N_noxref_16_M120_noxref_g N_noxref_18_c_8055_n ) capacitor \
 c=0.00201806f //x=62.55 //y=6.2 //x2=62.77 //y2=5.56
cc_5188 ( N_noxref_16_M121_noxref_g N_noxref_18_c_8055_n ) capacitor \
 c=0.00192712f //x=62.99 //y=6.2 //x2=62.77 //y2=5.56
cc_5189 ( N_noxref_16_c_7107_p N_noxref_18_c_8055_n ) capacitor c=0.0018602f \
 //x=62.65 //y=4.88 //x2=62.77 //y2=5.56
cc_5190 ( N_noxref_16_c_7110_p N_noxref_18_c_8064_n ) capacitor c=6.99317e-19 \
 //x=60.36 //y=1.18 //x2=63.69 //y2=1.18
cc_5191 ( N_noxref_16_c_7080_n N_noxref_18_c_8065_n ) capacitor c=0.0249267f \
 //x=60.8 //y=4.475 //x2=63.005 //y2=3.88
cc_5192 ( N_noxref_16_c_7100_p N_noxref_18_c_8065_n ) capacitor c=0.0263404f \
 //x=62.65 //y=4.705 //x2=63.005 //y2=3.88
cc_5193 ( N_noxref_16_c_7122_p N_noxref_18_c_8065_n ) capacitor c=0.008876f \
 //x=62.49 //y=4.62 //x2=63.005 //y2=3.88
cc_5194 ( N_noxref_16_c_7080_n N_noxref_18_c_8003_n ) capacitor c=0.00336755f \
 //x=60.8 //y=4.475 //x2=60.22 //y2=3.865
cc_5195 ( N_noxref_16_c_7080_n N_noxref_18_c_8006_n ) capacitor c=9.26054e-19 \
 //x=60.8 //y=4.475 //x2=60.06 //y2=2.26
cc_5196 ( N_noxref_16_c_7079_n N_noxref_18_c_8010_n ) capacitor c=0.00469257f \
 //x=60.205 //y=5.38 //x2=60.09 //y2=4.88
cc_5197 ( N_noxref_16_c_7098_p N_noxref_18_c_8010_n ) capacitor c=5.14671e-19 \
 //x=60.8 //y=5.295 //x2=60.09 //y2=4.88
cc_5198 ( N_noxref_16_c_7163_p N_noxref_18_c_8010_n ) capacitor c=0.00170912f \
 //x=60.8 //y=4.62 //x2=60.09 //y2=4.88
cc_5199 ( N_noxref_16_c_7104_p N_noxref_18_c_8073_n ) capacitor c=0.00220174f \
 //x=62.65 //y=4.865 //x2=62.77 //y2=5.56
cc_5200 ( N_noxref_16_c_7106_p N_noxref_18_c_8073_n ) capacitor c=0.00377369f \
 //x=62.65 //y=4.88 //x2=62.77 //y2=5.56
cc_5201 ( N_noxref_16_M120_noxref_g N_noxref_18_c_8073_n ) capacitor \
 c=0.0158358f //x=62.55 //y=6.2 //x2=62.77 //y2=5.56
cc_5202 ( N_noxref_16_M121_noxref_g N_noxref_18_c_8073_n ) capacitor \
 c=0.0178987f //x=62.99 //y=6.2 //x2=62.77 //y2=5.56
cc_5203 ( N_noxref_16_c_7107_p N_noxref_18_c_8073_n ) capacitor c=0.00439888f \
 //x=62.65 //y=4.88 //x2=62.77 //y2=5.56
cc_5204 ( N_noxref_16_c_7079_n N_noxref_18_M118_noxref_g ) capacitor \
 c=0.00842859f //x=60.205 //y=5.38 //x2=60.1 //y2=6.2
cc_5205 ( N_noxref_16_c_7120_p N_noxref_18_M118_noxref_g ) capacitor \
 c=0.00192712f //x=60.32 //y=5.38 //x2=60.1 //y2=6.2
cc_5206 ( N_noxref_16_c_7157_p N_noxref_18_M118_noxref_g ) capacitor \
 c=0.0178987f //x=60.32 //y=5.56 //x2=60.1 //y2=6.2
cc_5207 ( N_noxref_16_c_7174_p N_noxref_18_M119_noxref_g ) capacitor \
 c=0.0110279f //x=60.715 //y=5.38 //x2=60.54 //y2=6.2
cc_5208 ( N_noxref_16_c_7120_p N_noxref_18_M119_noxref_g ) capacitor \
 c=0.00298276f //x=60.32 //y=5.38 //x2=60.54 //y2=6.2
cc_5209 ( N_noxref_16_c_7157_p N_noxref_18_M119_noxref_g ) capacitor \
 c=0.0178506f //x=60.32 //y=5.56 //x2=60.54 //y2=6.2
cc_5210 ( N_noxref_16_c_7110_p N_noxref_18_c_8016_n ) capacitor c=0.00120406f \
 //x=60.36 //y=1.18 //x2=60.095 //y2=1.085
cc_5211 ( N_noxref_16_M36_noxref_d N_noxref_18_c_8016_n ) capacitor \
 c=0.00137165f //x=60.17 //y=1.085 //x2=60.095 //y2=1.085
cc_5212 ( N_noxref_16_c_7094_p N_noxref_18_c_8019_n ) capacitor c=0.00119008f \
 //x=60.36 //y=1.75 //x2=60.095 //y2=1.43
cc_5213 ( N_noxref_16_c_7110_p N_noxref_18_c_8019_n ) capacitor c=0.00218694f \
 //x=60.36 //y=1.18 //x2=60.095 //y2=1.43
cc_5214 ( N_noxref_16_M36_noxref_d N_noxref_18_c_8019_n ) capacitor \
 c=0.00237422f //x=60.17 //y=1.085 //x2=60.095 //y2=1.43
cc_5215 ( N_noxref_16_c_7094_p N_noxref_18_c_8021_n ) capacitor c=0.00438634f \
 //x=60.36 //y=1.75 //x2=60.095 //y2=1.74
cc_5216 ( N_noxref_16_c_7098_p N_noxref_18_c_8090_n ) capacitor c=0.00845606f \
 //x=60.8 //y=5.295 //x2=60.465 //y2=4.97
cc_5217 ( N_noxref_16_c_7120_p N_noxref_18_c_8090_n ) capacitor c=0.00183711f \
 //x=60.32 //y=5.38 //x2=60.465 //y2=4.97
cc_5218 ( N_noxref_16_c_7157_p N_noxref_18_c_8090_n ) capacitor c=0.00291714f \
 //x=60.32 //y=5.56 //x2=60.465 //y2=4.97
cc_5219 ( N_noxref_16_c_7110_p N_noxref_18_c_8093_n ) capacitor c=5.50523e-19 \
 //x=60.36 //y=1.18 //x2=60.47 //y2=0.93
cc_5220 ( N_noxref_16_M36_noxref_d N_noxref_18_c_8093_n ) capacitor \
 c=0.0020782f //x=60.17 //y=1.085 //x2=60.47 //y2=0.93
cc_5221 ( N_noxref_16_c_7094_p N_noxref_18_c_8095_n ) capacitor c=0.00916852f \
 //x=60.36 //y=1.75 //x2=60.47 //y2=1.585
cc_5222 ( N_noxref_16_c_7167_p N_noxref_18_c_8095_n ) capacitor c=0.00194324f \
 //x=60.715 //y=1.835 //x2=60.47 //y2=1.585
cc_5223 ( N_noxref_16_c_7110_p N_noxref_18_c_8095_n ) capacitor c=5.31395e-19 \
 //x=60.36 //y=1.18 //x2=60.47 //y2=1.585
cc_5224 ( N_noxref_16_M36_noxref_d N_noxref_18_c_8095_n ) capacitor \
 c=0.00356097f //x=60.17 //y=1.085 //x2=60.47 //y2=1.585
cc_5225 ( N_noxref_16_c_7110_p N_noxref_18_c_8024_n ) capacitor c=0.00109205f \
 //x=60.36 //y=1.18 //x2=60.625 //y2=1.085
cc_5226 ( N_noxref_16_M36_noxref_d N_noxref_18_c_8024_n ) capacitor \
 c=8.50095e-19 //x=60.17 //y=1.085 //x2=60.625 //y2=1.085
cc_5227 ( N_noxref_16_c_7094_p N_noxref_18_c_8025_n ) capacitor c=0.003249f \
 //x=60.36 //y=1.75 //x2=60.625 //y2=1.43
cc_5228 ( N_noxref_16_c_7167_p N_noxref_18_c_8025_n ) capacitor c=0.00323005f \
 //x=60.715 //y=1.835 //x2=60.625 //y2=1.43
cc_5229 ( N_noxref_16_c_7110_p N_noxref_18_c_8025_n ) capacitor c=0.00317092f \
 //x=60.36 //y=1.18 //x2=60.625 //y2=1.43
cc_5230 ( N_noxref_16_M36_noxref_d N_noxref_18_c_8025_n ) capacitor \
 c=0.00237422f //x=60.17 //y=1.085 //x2=60.625 //y2=1.43
cc_5231 ( N_noxref_16_c_7080_n N_noxref_18_c_8026_n ) capacitor c=0.00268898f \
 //x=60.8 //y=4.475 //x2=60.06 //y2=2.26
cc_5232 ( N_noxref_16_c_7094_p N_noxref_18_c_8106_n ) capacitor c=0.00341114f \
 //x=60.36 //y=1.75 //x2=60.06 //y2=2.095
cc_5233 ( N_noxref_16_c_7080_n N_noxref_18_c_8106_n ) capacitor c=0.00309058f \
 //x=60.8 //y=4.475 //x2=60.06 //y2=2.095
cc_5234 ( N_noxref_16_c_7079_n N_noxref_18_c_8029_n ) capacitor c=8.87334e-19 \
 //x=60.205 //y=5.38 //x2=60.09 //y2=4.88
cc_5235 ( N_noxref_16_c_7117_p N_noxref_18_c_8029_n ) capacitor c=0.00112293f \
 //x=60.8 //y=4.795 //x2=60.09 //y2=4.88
cc_5236 ( N_noxref_16_c_7098_p N_noxref_18_c_8029_n ) capacitor c=7.82219e-19 \
 //x=60.8 //y=5.295 //x2=60.09 //y2=4.88
cc_5237 ( N_noxref_16_c_7163_p N_noxref_18_c_8029_n ) capacitor c=0.00119116f \
 //x=60.8 //y=4.62 //x2=60.09 //y2=4.88
cc_5238 ( N_noxref_16_c_7096_p N_noxref_19_c_8645_n ) capacitor c=0.0195945f \
 //x=60.445 //y=1.835 //x2=50.285 //y2=2.37
cc_5239 ( N_noxref_16_c_7080_n N_noxref_19_c_8645_n ) capacitor c=0.0308487f \
 //x=60.8 //y=4.475 //x2=50.285 //y2=2.37
cc_5240 ( N_noxref_16_c_7100_p N_noxref_19_c_8645_n ) capacitor c=0.0153531f \
 //x=62.65 //y=4.705 //x2=50.285 //y2=2.37
cc_5241 ( N_noxref_16_c_7110_p N_noxref_19_c_8645_n ) capacitor c=7.2444e-19 \
 //x=60.36 //y=1.18 //x2=50.285 //y2=2.37
cc_5242 ( N_noxref_16_c_7112_p N_noxref_19_c_8645_n ) capacitor c=0.0187017f \
 //x=62.65 //y=2.26 //x2=50.285 //y2=2.37
cc_5243 ( N_noxref_16_c_7101_p N_noxref_19_c_8645_n ) capacitor c=2.20453e-19 \
 //x=62.65 //y=2.26 //x2=50.285 //y2=2.37
cc_5244 ( N_noxref_16_c_7114_p N_noxref_19_c_8645_n ) capacitor c=3.61358e-19 \
 //x=62.455 //y=2.095 //x2=50.285 //y2=2.37
cc_5245 ( N_noxref_16_c_7080_n N_noxref_20_c_9455_n ) capacitor c=0.0286906f \
 //x=60.8 //y=4.475 //x2=56.2 //y2=3.125
cc_5246 ( N_noxref_16_c_7100_p N_noxref_20_c_9455_n ) capacitor c=0.0286706f \
 //x=62.65 //y=4.705 //x2=56.2 //y2=3.125
cc_5247 ( N_noxref_16_c_7079_n N_VDD_c_10241_n ) capacitor c=0.00648288f \
 //x=60.205 //y=5.38 //x2=65.575 //y2=7.585
cc_5248 ( N_noxref_16_c_7174_p N_VDD_c_10241_n ) capacitor c=0.00492554f \
 //x=60.715 //y=5.38 //x2=65.575 //y2=7.585
cc_5249 ( N_noxref_16_c_7117_p N_VDD_c_10241_n ) capacitor c=5.56378e-19 \
 //x=60.8 //y=4.795 //x2=65.575 //y2=7.585
cc_5250 ( N_noxref_16_c_7082_n N_VDD_c_10241_n ) capacitor c=0.00368834f \
 //x=59.44 //y=5.56 //x2=65.575 //y2=7.585
cc_5251 ( N_noxref_16_c_7120_p N_VDD_c_10241_n ) capacitor c=8.42537e-19 \
 //x=60.32 //y=5.38 //x2=65.575 //y2=7.585
cc_5252 ( N_noxref_16_c_7176_p N_VDD_c_10241_n ) capacitor c=0.00285853f \
 //x=60.32 //y=5.56 //x2=65.575 //y2=7.585
cc_5253 ( N_noxref_16_c_7163_p N_VDD_c_10241_n ) capacitor c=4.39799e-19 \
 //x=60.8 //y=4.62 //x2=65.575 //y2=7.585
cc_5254 ( N_noxref_16_c_7104_p N_VDD_c_10241_n ) capacitor c=2.99997e-19 \
 //x=62.65 //y=4.865 //x2=65.575 //y2=7.585
cc_5255 ( N_noxref_16_c_7105_p N_VDD_c_10241_n ) capacitor c=0.00384386f \
 //x=62.65 //y=4.62 //x2=65.575 //y2=7.585
cc_5256 ( N_noxref_16_c_7088_n N_VDD_c_10241_n ) capacitor c=0.00224881f \
 //x=59.44 //y=5.56 //x2=65.575 //y2=7.585
cc_5257 ( N_noxref_16_c_7157_p N_VDD_c_10241_n ) capacitor c=0.00224881f \
 //x=60.32 //y=5.56 //x2=65.575 //y2=7.585
cc_5258 ( N_noxref_16_c_7106_p N_VDD_c_10241_n ) capacitor c=6.22888e-19 \
 //x=62.65 //y=4.88 //x2=65.575 //y2=7.585
cc_5259 ( N_noxref_16_c_7079_n N_VDD_c_11089_n ) capacitor c=0.00208087f \
 //x=60.205 //y=5.38 //x2=59.795 //y2=7.585
cc_5260 ( N_noxref_16_c_7082_n N_VDD_c_11089_n ) capacitor c=9.41185e-19 \
 //x=59.44 //y=5.56 //x2=59.795 //y2=7.585
cc_5261 ( N_noxref_16_c_7088_n N_VDD_c_11089_n ) capacitor c=0.0136705f \
 //x=59.44 //y=5.56 //x2=59.795 //y2=7.585
cc_5262 ( N_noxref_16_c_7079_n N_VDD_c_11140_n ) capacitor c=0.00180737f \
 //x=60.205 //y=5.38 //x2=60.675 //y2=7.585
cc_5263 ( N_noxref_16_c_7174_p N_VDD_c_11140_n ) capacitor c=0.00208087f \
 //x=60.715 //y=5.38 //x2=60.675 //y2=7.585
cc_5264 ( N_noxref_16_c_7120_p N_VDD_c_11140_n ) capacitor c=4.23719e-19 \
 //x=60.32 //y=5.38 //x2=60.675 //y2=7.585
cc_5265 ( N_noxref_16_c_7176_p N_VDD_c_11140_n ) capacitor c=5.77976e-19 \
 //x=60.32 //y=5.56 //x2=60.675 //y2=7.585
cc_5266 ( N_noxref_16_c_7157_p N_VDD_c_11140_n ) capacitor c=0.0136705f \
 //x=60.32 //y=5.56 //x2=60.675 //y2=7.585
cc_5267 ( N_noxref_16_c_7117_p N_VDD_c_11145_n ) capacitor c=4.62064e-19 \
 //x=60.8 //y=4.795 //x2=61.37 //y2=7.585
cc_5268 ( N_noxref_16_c_7104_p N_VDD_c_11146_n ) capacitor c=4.54053e-19 \
 //x=62.65 //y=4.865 //x2=63.125 //y2=7.585
cc_5269 ( N_noxref_16_M120_noxref_g N_VDD_c_11146_n ) capacitor c=0.00732618f \
 //x=62.55 //y=6.2 //x2=63.125 //y2=7.585
cc_5270 ( N_noxref_16_M121_noxref_g N_VDD_c_11146_n ) capacitor c=0.00755544f \
 //x=62.99 //y=6.2 //x2=63.125 //y2=7.585
cc_5271 ( N_noxref_16_c_7098_p N_VDD_c_11025_n ) capacitor c=0.0013228f \
 //x=60.8 //y=5.295 //x2=58.21 //y2=7.585
cc_5272 ( N_noxref_16_c_7082_n N_VDD_c_11025_n ) capacitor c=4.91377e-19 \
 //x=59.44 //y=5.56 //x2=58.21 //y2=7.585
cc_5273 ( N_noxref_16_c_7163_p N_VDD_c_11025_n ) capacitor c=0.00117195f \
 //x=60.8 //y=4.62 //x2=58.21 //y2=7.585
cc_5274 ( N_noxref_16_c_7088_n N_VDD_c_11025_n ) capacitor c=0.0064135f \
 //x=59.44 //y=5.56 //x2=58.21 //y2=7.585
cc_5275 ( N_noxref_16_c_7080_n N_VDD_c_11153_n ) capacitor c=0.00427409f \
 //x=60.8 //y=4.475 //x2=61.54 //y2=7.585
cc_5276 ( N_noxref_16_c_7117_p N_VDD_c_11153_n ) capacitor c=0.00484809f \
 //x=60.8 //y=4.795 //x2=61.54 //y2=7.585
cc_5277 ( N_noxref_16_c_7098_p N_VDD_c_11153_n ) capacitor c=0.0176779f \
 //x=60.8 //y=5.295 //x2=61.54 //y2=7.585
cc_5278 ( N_noxref_16_c_7100_p N_VDD_c_11153_n ) capacitor c=0.00521677f \
 //x=62.65 //y=4.705 //x2=61.54 //y2=7.585
cc_5279 ( N_noxref_16_c_7120_p N_VDD_c_11153_n ) capacitor c=0.00240948f \
 //x=60.32 //y=5.38 //x2=61.54 //y2=7.585
cc_5280 ( N_noxref_16_c_7176_p N_VDD_c_11153_n ) capacitor c=4.09141e-19 \
 //x=60.32 //y=5.56 //x2=61.54 //y2=7.585
cc_5281 ( N_noxref_16_c_7163_p N_VDD_c_11153_n ) capacitor c=0.0117224f \
 //x=60.8 //y=4.62 //x2=61.54 //y2=7.585
cc_5282 ( N_noxref_16_c_7104_p N_VDD_c_11153_n ) capacitor c=0.00287021f \
 //x=62.65 //y=4.865 //x2=61.54 //y2=7.585
cc_5283 ( N_noxref_16_c_7122_p N_VDD_c_11153_n ) capacitor c=0.0237259f \
 //x=62.49 //y=4.62 //x2=61.54 //y2=7.585
cc_5284 ( N_noxref_16_c_7157_p N_VDD_c_11153_n ) capacitor c=0.0101861f \
 //x=60.32 //y=5.56 //x2=61.54 //y2=7.585
cc_5285 ( N_noxref_16_c_7106_p N_VDD_c_11153_n ) capacitor c=0.0036761f \
 //x=62.65 //y=4.88 //x2=61.54 //y2=7.585
cc_5286 ( N_noxref_16_c_7107_p N_VDD_c_11153_n ) capacitor c=0.0121087f \
 //x=62.65 //y=4.88 //x2=61.54 //y2=7.585
cc_5287 ( N_noxref_16_c_7082_n N_VDD_M116_noxref_s ) capacitor c=0.0572211f \
 //x=59.44 //y=5.56 //x2=58.865 //y2=5.2
cc_5288 ( N_noxref_16_c_7120_p N_VDD_M116_noxref_s ) capacitor c=6.52457e-19 \
 //x=60.32 //y=5.38 //x2=58.865 //y2=5.2
cc_5289 ( N_noxref_16_c_7088_n N_VDD_M116_noxref_s ) capacitor c=0.0887533f \
 //x=59.44 //y=5.56 //x2=58.865 //y2=5.2
cc_5290 ( N_noxref_16_c_7079_n N_VDD_M117_noxref_d ) capacitor c=0.00734094f \
 //x=60.205 //y=5.38 //x2=59.735 //y2=5.2
cc_5291 ( N_noxref_16_c_7082_n N_VDD_M117_noxref_d ) capacitor c=0.0043528f \
 //x=59.44 //y=5.56 //x2=59.735 //y2=5.2
cc_5292 ( N_noxref_16_c_7176_p N_VDD_M117_noxref_d ) capacitor c=0.0043528f \
 //x=60.32 //y=5.56 //x2=59.735 //y2=5.2
cc_5293 ( N_noxref_16_c_7088_n N_VDD_M117_noxref_d ) capacitor c=0.065554f \
 //x=59.44 //y=5.56 //x2=59.735 //y2=5.2
cc_5294 ( N_noxref_16_c_7157_p N_VDD_M117_noxref_d ) capacitor c=0.065554f \
 //x=60.32 //y=5.56 //x2=59.735 //y2=5.2
cc_5295 ( N_noxref_16_c_7174_p N_VDD_M119_noxref_d ) capacitor c=0.00794386f \
 //x=60.715 //y=5.38 //x2=60.615 //y2=5.2
cc_5296 ( N_noxref_16_c_7176_p N_VDD_M119_noxref_d ) capacitor c=0.00587834f \
 //x=60.32 //y=5.56 //x2=60.615 //y2=5.2
cc_5297 ( N_noxref_16_c_7163_p N_VDD_M119_noxref_d ) capacitor c=0.00249021f \
 //x=60.8 //y=4.62 //x2=60.615 //y2=5.2
cc_5298 ( N_noxref_16_c_7157_p N_VDD_M119_noxref_d ) capacitor c=0.065554f \
 //x=60.32 //y=5.56 //x2=60.615 //y2=5.2
cc_5299 ( N_noxref_16_c_7174_p N_VDD_M120_noxref_s ) capacitor c=0.00326953f \
 //x=60.715 //y=5.38 //x2=62.195 //y2=5.2
cc_5300 ( N_noxref_16_c_7120_p N_VDD_M120_noxref_s ) capacitor c=0.00515461f \
 //x=60.32 //y=5.38 //x2=62.195 //y2=5.2
cc_5301 ( N_noxref_16_c_7176_p N_VDD_M120_noxref_s ) capacitor c=3.28075e-19 \
 //x=60.32 //y=5.56 //x2=62.195 //y2=5.2
cc_5302 ( N_noxref_16_c_7122_p N_VDD_M120_noxref_s ) capacitor c=0.00773213f \
 //x=62.49 //y=4.62 //x2=62.195 //y2=5.2
cc_5303 ( N_noxref_16_M120_noxref_g N_VDD_M120_noxref_s ) capacitor \
 c=0.0567929f //x=62.55 //y=6.2 //x2=62.195 //y2=5.2
cc_5304 ( N_noxref_16_M121_noxref_g N_VDD_M121_noxref_d ) capacitor \
 c=0.015318f //x=62.99 //y=6.2 //x2=63.065 //y2=5.2
cc_5305 ( N_noxref_16_c_7167_p N_GND_c_12986_n ) capacitor c=0.00608539f \
 //x=60.715 //y=1.835 //x2=62.635 //y2=0.175
cc_5306 ( N_noxref_16_c_7117_p N_GND_c_12986_n ) capacitor c=2.00462e-19 \
 //x=60.8 //y=4.795 //x2=62.635 //y2=0.175
cc_5307 ( N_noxref_16_c_7110_p N_GND_c_12986_n ) capacitor c=0.00928865f \
 //x=60.36 //y=1.18 //x2=62.635 //y2=0.175
cc_5308 ( N_noxref_16_M36_noxref_d N_GND_c_12986_n ) capacitor c=3.01769e-19 \
 //x=60.17 //y=1.085 //x2=62.635 //y2=0.175
cc_5309 ( N_noxref_16_c_7082_n N_GND_c_12945_n ) capacitor c=5.84037e-19 \
 //x=59.44 //y=5.56 //x2=59.39 //y2=1.135
cc_5310 ( N_noxref_16_c_7110_p N_GND_c_12945_n ) capacitor c=0.0140087f \
 //x=60.36 //y=1.18 //x2=59.39 //y2=1.135
cc_5311 ( N_noxref_16_M36_noxref_d N_GND_c_12945_n ) capacitor c=2.93544e-19 \
 //x=60.17 //y=1.085 //x2=59.39 //y2=1.135
cc_5312 ( N_noxref_16_c_7110_p N_GND_c_12993_n ) capacitor c=0.00549186f \
 //x=60.36 //y=1.18 //x2=62.72 //y2=1.135
cc_5313 ( N_noxref_16_c_7112_p N_GND_c_12993_n ) capacitor c=0.00644213f \
 //x=62.65 //y=2.26 //x2=62.72 //y2=1.135
cc_5314 ( N_noxref_16_c_7101_p N_GND_c_12993_n ) capacitor c=2.13705e-19 \
 //x=62.65 //y=2.26 //x2=62.72 //y2=1.135
cc_5315 ( N_noxref_16_c_7135_p N_GND_c_12993_n ) capacitor c=0.00171023f \
 //x=62.455 //y=1.045 //x2=62.72 //y2=1.135
cc_5316 ( N_noxref_16_c_7136_p N_GND_c_12993_n ) capacitor c=0.00357815f \
 //x=62.455 //y=1.39 //x2=62.72 //y2=1.135
cc_5317 ( N_noxref_16_c_7138_p N_GND_c_12993_n ) capacitor c=4.2764e-19 \
 //x=62.455 //y=1.7 //x2=62.72 //y2=1.135
cc_5318 ( N_noxref_16_c_7311_p N_GND_c_12993_n ) capacitor c=9.36995e-19 \
 //x=62.83 //y=0.89 //x2=62.72 //y2=1.135
cc_5319 ( N_noxref_16_c_7312_p N_GND_c_12993_n ) capacitor c=6.36528e-19 \
 //x=62.83 //y=1.545 //x2=62.72 //y2=1.135
cc_5320 ( N_noxref_16_c_7137_p N_GND_c_12993_n ) capacitor c=0.00171784f \
 //x=62.985 //y=1.045 //x2=62.72 //y2=1.135
cc_5321 ( N_noxref_16_c_7139_p N_GND_c_12993_n ) capacitor c=0.00296337f \
 //x=62.985 //y=1.39 //x2=62.72 //y2=1.135
cc_5322 ( N_noxref_16_c_7135_p N_GND_c_13003_n ) capacitor c=3.46594e-19 \
 //x=62.455 //y=1.045 //x2=62.717 //y2=1.005
cc_5323 ( N_noxref_16_c_7311_p N_GND_c_13003_n ) capacitor c=0.00839795f \
 //x=62.83 //y=0.89 //x2=62.717 //y2=1.005
cc_5324 ( N_noxref_16_c_7137_p N_GND_c_13003_n ) capacitor c=4.40641e-19 \
 //x=62.985 //y=1.045 //x2=62.717 //y2=1.005
cc_5325 ( N_noxref_16_c_7167_p N_GND_c_12959_n ) capacitor c=7.77585e-19 \
 //x=60.715 //y=1.835 //x2=61.37 //y2=0.175
cc_5326 ( N_noxref_16_c_7135_p N_GND_c_13007_n ) capacitor c=0.00688027f \
 //x=62.455 //y=1.045 //x2=64.7 //y2=0.175
cc_5327 ( N_noxref_16_c_7080_n N_GND_c_12925_n ) capacitor c=9.32616e-19 \
 //x=60.8 //y=4.475 //x2=58.21 //y2=0.175
cc_5328 ( N_noxref_16_c_7094_p N_GND_c_13009_n ) capacitor c=0.002973f \
 //x=60.36 //y=1.75 //x2=61.54 //y2=0.175
cc_5329 ( N_noxref_16_c_7167_p N_GND_c_13009_n ) capacitor c=0.0292394f \
 //x=60.715 //y=1.835 //x2=61.54 //y2=0.175
cc_5330 ( N_noxref_16_c_7100_p N_GND_c_13009_n ) capacitor c=0.00781993f \
 //x=62.65 //y=4.705 //x2=61.54 //y2=0.175
cc_5331 ( N_noxref_16_c_7112_p N_GND_c_13009_n ) capacitor c=0.00351582f \
 //x=62.65 //y=2.26 //x2=61.54 //y2=0.175
cc_5332 ( N_noxref_16_c_7101_p N_GND_c_13009_n ) capacitor c=0.00354425f \
 //x=62.65 //y=2.26 //x2=61.54 //y2=0.175
cc_5333 ( N_noxref_16_c_7138_p N_GND_c_13009_n ) capacitor c=0.0015404f \
 //x=62.455 //y=1.7 //x2=61.54 //y2=0.175
cc_5334 ( N_noxref_16_c_7114_p N_GND_c_13009_n ) capacitor c=0.00936534f \
 //x=62.455 //y=2.095 //x2=61.54 //y2=0.175
cc_5335 ( N_noxref_16_c_7110_p N_GND_M35_noxref_d ) capacitor c=2.82748e-19 \
 //x=60.36 //y=1.18 //x2=59.2 //y2=1.045
cc_5336 ( N_noxref_16_c_7112_p N_GND_M37_noxref_d ) capacitor c=2.20438e-19 \
 //x=62.65 //y=2.26 //x2=62.53 //y2=1.045
cc_5337 ( N_noxref_16_c_7135_p N_GND_M37_noxref_d ) capacitor c=0.00192399f \
 //x=62.455 //y=1.045 //x2=62.53 //y2=1.045
cc_5338 ( N_noxref_16_c_7136_p N_GND_M37_noxref_d ) capacitor c=0.00210798f \
 //x=62.455 //y=1.39 //x2=62.53 //y2=1.045
cc_5339 ( N_noxref_16_c_7311_p N_GND_M37_noxref_d ) capacitor c=0.00472259f \
 //x=62.83 //y=0.89 //x2=62.53 //y2=1.045
cc_5340 ( N_noxref_16_c_7312_p N_GND_M37_noxref_d ) capacitor c=0.00166857f \
 //x=62.83 //y=1.545 //x2=62.53 //y2=1.045
cc_5341 ( N_noxref_16_c_7137_p N_GND_M37_noxref_d ) capacitor c=0.00230174f \
 //x=62.985 //y=1.045 //x2=62.53 //y2=1.045
cc_5342 ( N_noxref_16_c_7139_p N_GND_M37_noxref_d ) capacitor c=0.00210798f \
 //x=62.985 //y=1.39 //x2=62.53 //y2=1.045
cc_5343 ( N_noxref_16_c_7096_p N_noxref_47_c_15053_n ) capacitor c=0.00911498f \
 //x=60.445 //y=1.835 //x2=59.875 //y2=1.675
cc_5344 ( N_noxref_16_c_7167_p N_noxref_47_c_15058_n ) capacitor c=0.00399245f \
 //x=60.715 //y=1.835 //x2=60.76 //y2=0.71
cc_5345 ( N_noxref_16_c_7110_p N_noxref_47_c_15058_n ) capacitor c=0.003751f \
 //x=60.36 //y=1.18 //x2=60.76 //y2=0.71
cc_5346 ( N_noxref_16_M36_noxref_d N_noxref_47_c_15058_n ) capacitor \
 c=0.00949319f //x=60.17 //y=1.085 //x2=60.76 //y2=0.71
cc_5347 ( N_noxref_16_c_7094_p N_noxref_47_M35_noxref_s ) capacitor \
 c=0.0162484f //x=60.36 //y=1.75 //x2=58.77 //y2=0.545
cc_5348 ( N_noxref_16_c_7167_p N_noxref_47_M35_noxref_s ) capacitor \
 c=0.00709218f //x=60.715 //y=1.835 //x2=58.77 //y2=0.545
cc_5349 ( N_noxref_16_c_7117_p N_noxref_47_M35_noxref_s ) capacitor \
 c=2.06827e-19 //x=60.8 //y=4.795 //x2=58.77 //y2=0.545
cc_5350 ( N_noxref_16_c_7110_p N_noxref_47_M35_noxref_s ) capacitor \
 c=0.00905169f //x=60.36 //y=1.18 //x2=58.77 //y2=0.545
cc_5351 ( N_noxref_16_c_7163_p N_noxref_47_M35_noxref_s ) capacitor \
 c=6.07835e-19 //x=60.8 //y=4.62 //x2=58.77 //y2=0.545
cc_5352 ( N_noxref_16_M36_noxref_d N_noxref_47_M35_noxref_s ) capacitor \
 c=0.0275552f //x=60.17 //y=1.085 //x2=58.77 //y2=0.545
cc_5353 ( N_noxref_16_c_7114_p N_noxref_48_c_15115_n ) capacitor c=0.00262672f \
 //x=62.455 //y=2.095 //x2=62.235 //y2=1.675
cc_5354 ( N_noxref_16_c_7104_p N_noxref_48_c_15116_n ) capacitor c=9.43383e-19 \
 //x=62.65 //y=4.865 //x2=63.12 //y2=1.76
cc_5355 ( N_noxref_16_c_7112_p N_noxref_48_c_15116_n ) capacitor c=0.00509504f \
 //x=62.65 //y=2.26 //x2=63.12 //y2=1.76
cc_5356 ( N_noxref_16_c_7101_p N_noxref_48_c_15116_n ) capacitor c=0.00763108f \
 //x=62.65 //y=2.26 //x2=63.12 //y2=1.76
cc_5357 ( N_noxref_16_c_7138_p N_noxref_48_c_15116_n ) capacitor c=0.00697076f \
 //x=62.455 //y=1.7 //x2=63.12 //y2=1.76
cc_5358 ( N_noxref_16_c_7114_p N_noxref_48_c_15116_n ) capacitor c=0.0170561f \
 //x=62.455 //y=2.095 //x2=63.12 //y2=1.76
cc_5359 ( N_noxref_16_c_7312_p N_noxref_48_c_15116_n ) capacitor c=0.00723574f \
 //x=62.83 //y=1.545 //x2=63.12 //y2=1.76
cc_5360 ( N_noxref_16_c_7139_p N_noxref_48_c_15116_n ) capacitor c=0.00339872f \
 //x=62.985 //y=1.39 //x2=63.12 //y2=1.76
cc_5361 ( N_noxref_16_c_7114_p N_noxref_48_c_15123_n ) capacitor c=6.71402e-19 \
 //x=62.455 //y=2.095 //x2=63.205 //y2=1.675
cc_5362 ( N_noxref_16_c_7135_p N_noxref_48_M37_noxref_s ) capacitor \
 c=0.0294925f //x=62.455 //y=1.045 //x2=62.1 //y2=0.545
cc_5363 ( N_noxref_16_c_7138_p N_noxref_48_M37_noxref_s ) capacitor \
 c=3.48408e-19 //x=62.455 //y=1.7 //x2=62.1 //y2=0.545
cc_5364 ( N_noxref_16_c_7137_p N_noxref_48_M37_noxref_s ) capacitor \
 c=0.0125442f //x=62.985 //y=1.045 //x2=62.1 //y2=0.545
cc_5365 ( N_noxref_17_c_7438_n N_noxref_18_c_7986_n ) capacitor c=0.00208608f \
 //x=57.47 //y=4.105 //x2=60.06 //y2=3.705
cc_5366 ( N_noxref_17_c_7643_n N_noxref_18_c_7988_n ) capacitor c=0.00533115f \
 //x=59.535 //y=4.27 //x2=60.06 //y2=4.025
cc_5367 ( N_noxref_17_c_7441_n N_noxref_18_c_7992_n ) capacitor c=0.00130218f \
 //x=57.47 //y=5.295 //x2=60.06 //y2=4.735
cc_5368 ( N_noxref_17_c_7643_n N_noxref_18_c_7992_n ) capacitor c=0.0266789f \
 //x=59.535 //y=4.27 //x2=60.06 //y2=4.735
cc_5369 ( N_noxref_17_c_7664_n N_noxref_18_c_8046_n ) capacitor c=0.00425321f \
 //x=63.39 //y=4.41 //x2=63.535 //y2=5.38
cc_5370 ( N_noxref_17_c_7665_n N_noxref_18_c_8046_n ) capacitor c=0.0220569f \
 //x=63.39 //y=4.735 //x2=63.535 //y2=5.38
cc_5371 ( N_noxref_17_c_7643_n N_noxref_18_c_8046_n ) capacitor c=0.00277534f \
 //x=59.535 //y=4.27 //x2=63.535 //y2=5.38
cc_5372 ( N_noxref_17_c_7691_n N_noxref_18_c_8046_n ) capacitor c=0.00469257f \
 //x=63.42 //y=4.88 //x2=63.535 //y2=5.38
cc_5373 ( N_noxref_17_M122_noxref_g N_noxref_18_c_8046_n ) capacitor \
 c=0.00842859f //x=63.43 //y=6.2 //x2=63.535 //y2=5.38
cc_5374 ( N_noxref_17_c_7710_n N_noxref_18_c_8046_n ) capacitor c=8.42507e-19 \
 //x=63.42 //y=4.88 //x2=63.535 //y2=5.38
cc_5375 ( N_noxref_17_c_7700_n N_noxref_18_c_8047_n ) capacitor c=0.00119008f \
 //x=63.425 //y=1.43 //x2=63.69 //y2=1.75
cc_5376 ( N_noxref_17_c_7702_n N_noxref_18_c_8047_n ) capacitor c=0.00438634f \
 //x=63.425 //y=1.74 //x2=63.69 //y2=1.75
cc_5377 ( N_noxref_17_c_7725_p N_noxref_18_c_8047_n ) capacitor c=0.00924417f \
 //x=63.8 //y=1.585 //x2=63.69 //y2=1.75
cc_5378 ( N_noxref_17_c_7706_n N_noxref_18_c_8047_n ) capacitor c=0.00323949f \
 //x=63.955 //y=1.43 //x2=63.69 //y2=1.75
cc_5379 ( N_noxref_17_c_7727_p N_noxref_18_c_8047_n ) capacitor c=0.00341114f \
 //x=63.39 //y=2.095 //x2=63.69 //y2=1.75
cc_5380 ( N_noxref_17_M123_noxref_g N_noxref_18_c_8127_n ) capacitor \
 c=0.0112745f //x=63.87 //y=6.2 //x2=64.045 //y2=5.38
cc_5381 ( N_noxref_17_c_7725_p N_noxref_18_c_8128_n ) capacitor c=0.00194324f \
 //x=63.8 //y=1.585 //x2=64.045 //y2=1.835
cc_5382 ( N_noxref_17_c_7706_n N_noxref_18_c_8128_n ) capacitor c=0.00323005f \
 //x=63.955 //y=1.43 //x2=64.045 //y2=1.835
cc_5383 ( N_noxref_17_c_7661_n N_noxref_18_c_8049_n ) capacitor c=0.0569004f \
 //x=63.39 //y=4.09 //x2=64.13 //y2=3.73
cc_5384 ( N_noxref_17_c_7674_n N_noxref_18_c_8049_n ) capacitor c=0.0138368f \
 //x=63.39 //y=2.26 //x2=64.13 //y2=3.73
cc_5385 ( N_noxref_17_c_7687_n N_noxref_18_c_8049_n ) capacitor c=9.26054e-19 \
 //x=63.39 //y=2.26 //x2=64.13 //y2=3.73
cc_5386 ( N_noxref_17_c_7707_n N_noxref_18_c_8049_n ) capacitor c=0.00268898f \
 //x=63.39 //y=2.26 //x2=64.13 //y2=3.73
cc_5387 ( N_noxref_17_c_7727_p N_noxref_18_c_8049_n ) capacitor c=0.00309058f \
 //x=63.39 //y=2.095 //x2=64.13 //y2=3.73
cc_5388 ( N_noxref_17_c_7661_n N_noxref_18_c_8135_n ) capacitor c=0.0149645f \
 //x=63.39 //y=4.09 //x2=64.13 //y2=4.05
cc_5389 ( N_noxref_17_c_7661_n N_noxref_18_c_8051_n ) capacitor c=0.0018228f \
 //x=63.39 //y=4.09 //x2=64.13 //y2=5.295
cc_5390 ( N_noxref_17_c_7664_n N_noxref_18_c_8051_n ) capacitor c=0.0148501f \
 //x=63.39 //y=4.41 //x2=64.13 //y2=5.295
cc_5391 ( N_noxref_17_c_7665_n N_noxref_18_c_8051_n ) capacitor c=0.0296747f \
 //x=63.39 //y=4.735 //x2=64.13 //y2=5.295
cc_5392 ( N_noxref_17_c_7673_n N_noxref_18_c_8051_n ) capacitor c=5.59368e-19 \
 //x=63.39 //y=4.25 //x2=64.13 //y2=5.295
cc_5393 ( N_noxref_17_c_7643_n N_noxref_18_c_8051_n ) capacitor c=0.00686844f \
 //x=59.535 //y=4.27 //x2=64.13 //y2=5.295
cc_5394 ( N_noxref_17_c_7691_n N_noxref_18_c_8051_n ) capacitor c=0.00386205f \
 //x=63.42 //y=4.88 //x2=64.13 //y2=5.295
cc_5395 ( N_noxref_17_c_7743_p N_noxref_18_c_8051_n ) capacitor c=0.00845606f \
 //x=63.795 //y=4.97 //x2=64.13 //y2=5.295
cc_5396 ( N_noxref_17_c_7710_n N_noxref_18_c_8051_n ) capacitor c=0.00142201f \
 //x=63.42 //y=4.88 //x2=64.13 //y2=5.295
cc_5397 ( N_noxref_17_c_7661_n N_noxref_18_c_8144_n ) capacitor c=0.00227607f \
 //x=63.39 //y=4.09 //x2=65.61 //y2=3.73
cc_5398 ( N_noxref_17_c_7643_n N_noxref_18_c_8055_n ) capacitor c=0.0123713f \
 //x=59.535 //y=4.27 //x2=62.77 //y2=5.56
cc_5399 ( N_noxref_17_c_7643_n N_noxref_18_c_8146_n ) capacitor c=2.42699e-19 \
 //x=59.535 //y=4.27 //x2=63.65 //y2=5.38
cc_5400 ( N_noxref_17_M122_noxref_g N_noxref_18_c_8146_n ) capacitor \
 c=0.00192712f //x=63.43 //y=6.2 //x2=63.65 //y2=5.38
cc_5401 ( N_noxref_17_M123_noxref_g N_noxref_18_c_8146_n ) capacitor \
 c=0.00297999f //x=63.87 //y=6.2 //x2=63.65 //y2=5.38
cc_5402 ( N_noxref_17_c_7743_p N_noxref_18_c_8146_n ) capacitor c=0.0020909f \
 //x=63.795 //y=4.97 //x2=63.65 //y2=5.38
cc_5403 ( N_noxref_17_c_7697_n N_noxref_18_c_8064_n ) capacitor c=0.00120406f \
 //x=63.425 //y=1.085 //x2=63.69 //y2=1.18
cc_5404 ( N_noxref_17_c_7700_n N_noxref_18_c_8064_n ) capacitor c=0.00218694f \
 //x=63.425 //y=1.43 //x2=63.69 //y2=1.18
cc_5405 ( N_noxref_17_c_7753_p N_noxref_18_c_8064_n ) capacitor c=5.50523e-19 \
 //x=63.8 //y=0.93 //x2=63.69 //y2=1.18
cc_5406 ( N_noxref_17_c_7725_p N_noxref_18_c_8064_n ) capacitor c=5.67071e-19 \
 //x=63.8 //y=1.585 //x2=63.69 //y2=1.18
cc_5407 ( N_noxref_17_c_7705_n N_noxref_18_c_8064_n ) capacitor c=0.00109305f \
 //x=63.955 //y=1.085 //x2=63.69 //y2=1.18
cc_5408 ( N_noxref_17_c_7706_n N_noxref_18_c_8064_n ) capacitor c=0.00317556f \
 //x=63.955 //y=1.43 //x2=63.69 //y2=1.18
cc_5409 ( N_noxref_17_c_7661_n N_noxref_18_c_8156_n ) capacitor c=6.92515e-19 \
 //x=63.39 //y=4.09 //x2=64.13 //y2=3.88
cc_5410 ( N_noxref_17_c_7661_n N_noxref_18_c_8065_n ) capacitor c=3.11404e-19 \
 //x=63.39 //y=4.09 //x2=63.005 //y2=3.88
cc_5411 ( N_noxref_17_c_7664_n N_noxref_18_c_8065_n ) capacitor c=0.00207445f \
 //x=63.39 //y=4.41 //x2=63.005 //y2=3.88
cc_5412 ( N_noxref_17_c_7643_n N_noxref_18_c_8065_n ) capacitor c=0.261606f \
 //x=59.535 //y=4.27 //x2=63.005 //y2=3.88
cc_5413 ( N_noxref_17_c_7661_n N_noxref_18_c_8160_n ) capacitor c=0.0217178f \
 //x=63.39 //y=4.09 //x2=63.605 //y2=3.865
cc_5414 ( N_noxref_17_c_7664_n N_noxref_18_c_8160_n ) capacitor c=0.00450608f \
 //x=63.39 //y=4.41 //x2=63.605 //y2=3.865
cc_5415 ( N_noxref_17_c_7643_n N_noxref_18_c_8160_n ) capacitor c=0.0368432f \
 //x=59.535 //y=4.27 //x2=63.605 //y2=3.865
cc_5416 ( N_noxref_17_c_7661_n N_noxref_18_c_8163_n ) capacitor c=0.00328563f \
 //x=63.39 //y=4.09 //x2=64.28 //y2=3.88
cc_5417 ( N_noxref_17_c_7643_n N_noxref_18_c_8003_n ) capacitor c=0.0365231f \
 //x=59.535 //y=4.27 //x2=60.22 //y2=3.865
cc_5418 ( N_noxref_17_M122_noxref_g N_noxref_18_c_8165_n ) capacitor \
 c=0.0178987f //x=63.43 //y=6.2 //x2=63.65 //y2=5.56
cc_5419 ( N_noxref_17_M123_noxref_g N_noxref_18_c_8165_n ) capacitor \
 c=0.0178506f //x=63.87 //y=6.2 //x2=63.65 //y2=5.56
cc_5420 ( N_noxref_17_c_7743_p N_noxref_18_c_8165_n ) capacitor c=0.00291714f \
 //x=63.795 //y=4.97 //x2=63.65 //y2=5.56
cc_5421 ( N_noxref_17_c_7697_n N_noxref_18_M38_noxref_d ) capacitor \
 c=0.00137165f //x=63.425 //y=1.085 //x2=63.5 //y2=1.085
cc_5422 ( N_noxref_17_c_7700_n N_noxref_18_M38_noxref_d ) capacitor \
 c=0.00237422f //x=63.425 //y=1.43 //x2=63.5 //y2=1.085
cc_5423 ( N_noxref_17_c_7753_p N_noxref_18_M38_noxref_d ) capacitor \
 c=0.0020782f //x=63.8 //y=0.93 //x2=63.5 //y2=1.085
cc_5424 ( N_noxref_17_c_7725_p N_noxref_18_M38_noxref_d ) capacitor \
 c=0.00356097f //x=63.8 //y=1.585 //x2=63.5 //y2=1.085
cc_5425 ( N_noxref_17_c_7705_n N_noxref_18_M38_noxref_d ) capacitor \
 c=8.50095e-19 //x=63.955 //y=1.085 //x2=63.5 //y2=1.085
cc_5426 ( N_noxref_17_c_7706_n N_noxref_18_M38_noxref_d ) capacitor \
 c=0.00237422f //x=63.955 //y=1.43 //x2=63.5 //y2=1.085
cc_5427 ( N_noxref_17_c_7499_n N_noxref_19_c_8591_n ) capacitor c=0.0171222f \
 //x=44.52 //y=2.375 //x2=49.685 //y2=2.4
cc_5428 ( N_noxref_17_c_7358_n N_noxref_19_c_8591_n ) capacitor c=0.0143189f \
 //x=44.52 //y=4.095 //x2=49.685 //y2=2.4
cc_5429 ( N_noxref_17_c_7568_n N_noxref_19_c_8591_n ) capacitor c=5.18203e-19 \
 //x=44.52 //y=2.26 //x2=49.685 //y2=2.4
cc_5430 ( N_noxref_17_c_7585_n N_noxref_19_c_8591_n ) capacitor c=3.41298e-19 \
 //x=44.22 //y=2.095 //x2=49.685 //y2=2.4
cc_5431 ( N_noxref_17_c_7368_n N_noxref_19_c_8645_n ) capacitor c=0.0140246f \
 //x=53.4 //y=4.095 //x2=50.285 //y2=2.37
cc_5432 ( N_noxref_17_c_7437_n N_noxref_19_c_8645_n ) capacitor c=0.0195606f \
 //x=57.115 //y=1.835 //x2=50.285 //y2=2.37
cc_5433 ( N_noxref_17_c_7438_n N_noxref_19_c_8645_n ) capacitor c=0.0307864f \
 //x=57.47 //y=4.105 //x2=50.285 //y2=2.37
cc_5434 ( N_noxref_17_c_7661_n N_noxref_19_c_8645_n ) capacitor c=0.0140246f \
 //x=63.39 //y=4.09 //x2=50.285 //y2=2.37
cc_5435 ( N_noxref_17_c_7383_n N_noxref_19_c_8645_n ) capacitor c=0.0170052f \
 //x=53.4 //y=2.26 //x2=50.285 //y2=2.37
cc_5436 ( N_noxref_17_c_7454_n N_noxref_19_c_8645_n ) capacitor c=7.09092e-19 \
 //x=57.03 //y=1.18 //x2=50.285 //y2=2.37
cc_5437 ( N_noxref_17_c_7674_n N_noxref_19_c_8645_n ) capacitor c=0.0170024f \
 //x=63.39 //y=2.26 //x2=50.285 //y2=2.37
cc_5438 ( N_noxref_17_c_7643_n N_noxref_19_c_8645_n ) capacitor c=0.00110317f \
 //x=59.535 //y=4.27 //x2=50.285 //y2=2.37
cc_5439 ( N_noxref_17_c_7417_n N_noxref_19_c_8645_n ) capacitor c=2.98635e-19 \
 //x=53.4 //y=2.26 //x2=50.285 //y2=2.37
cc_5440 ( N_noxref_17_c_7707_n N_noxref_19_c_8645_n ) capacitor c=2.98635e-19 \
 //x=63.39 //y=2.26 //x2=50.285 //y2=2.37
cc_5441 ( N_noxref_17_c_7358_n N_noxref_20_c_9365_n ) capacitor c=0.0287513f \
 //x=44.52 //y=4.095 //x2=46.36 //y2=3.14
cc_5442 ( N_noxref_17_c_7504_n N_noxref_20_c_9365_n ) capacitor c=0.00323333f \
 //x=44.52 //y=4.415 //x2=46.36 //y2=3.14
cc_5443 ( N_noxref_17_c_7363_n N_noxref_20_c_9365_n ) capacitor c=0.0563722f \
 //x=47.095 //y=4.25 //x2=46.36 //y2=3.14
cc_5444 ( N_noxref_17_c_7361_n N_noxref_20_c_9365_n ) capacitor c=0.00806737f \
 //x=44.685 //y=4.255 //x2=46.36 //y2=3.14
cc_5445 ( N_noxref_17_c_7363_n N_noxref_20_c_9422_n ) capacitor c=0.00214266f \
 //x=47.095 //y=4.25 //x2=46.96 //y2=3.125
cc_5446 ( N_noxref_17_c_7368_n N_noxref_20_c_9444_n ) capacitor c=5.28162e-19 \
 //x=53.4 //y=4.095 //x2=52.87 //y2=3.12
cc_5447 ( N_noxref_17_c_7364_n N_noxref_20_c_9444_n ) capacitor c=0.00277047f \
 //x=53.565 //y=4.25 //x2=52.87 //y2=3.12
cc_5448 ( N_noxref_17_c_7368_n N_noxref_20_c_9447_n ) capacitor c=0.0256612f \
 //x=53.4 //y=4.095 //x2=53.76 //y2=3.14
cc_5449 ( N_noxref_17_c_7455_n N_noxref_20_c_9447_n ) capacitor c=0.00313122f \
 //x=57.3 //y=4.25 //x2=53.76 //y2=3.14
cc_5450 ( N_noxref_17_c_7438_n N_noxref_20_c_9455_n ) capacitor c=0.0286202f \
 //x=57.47 //y=4.105 //x2=56.2 //y2=3.125
cc_5451 ( N_noxref_17_c_7661_n N_noxref_20_c_9455_n ) capacitor c=0.0258491f \
 //x=63.39 //y=4.09 //x2=56.2 //y2=3.125
cc_5452 ( N_noxref_17_c_7455_n N_noxref_20_c_9455_n ) capacitor c=0.00691997f \
 //x=57.3 //y=4.25 //x2=56.2 //y2=3.125
cc_5453 ( N_noxref_17_c_7643_n N_noxref_20_c_9455_n ) capacitor c=0.0258965f \
 //x=59.535 //y=4.27 //x2=56.2 //y2=3.125
cc_5454 ( N_noxref_17_c_7565_n N_noxref_20_c_9455_n ) capacitor c=0.0132992f \
 //x=59.19 //y=4.27 //x2=56.2 //y2=3.125
cc_5455 ( N_noxref_17_c_7504_n N_VDD_c_10241_n ) capacitor c=3.76138e-19 \
 //x=44.52 //y=4.415 //x2=65.575 //y2=7.585
cc_5456 ( N_noxref_17_c_7435_n N_VDD_c_10241_n ) capacitor c=0.00621974f \
 //x=56.875 //y=5.38 //x2=65.575 //y2=7.585
cc_5457 ( N_noxref_17_c_7528_n N_VDD_c_10241_n ) capacitor c=0.00492568f \
 //x=57.385 //y=5.38 //x2=65.575 //y2=7.585
cc_5458 ( N_noxref_17_c_7445_n N_VDD_c_10241_n ) capacitor c=0.00368834f \
 //x=56.11 //y=5.56 //x2=65.575 //y2=7.585
cc_5459 ( N_noxref_17_c_7545_n N_VDD_c_10241_n ) capacitor c=8.11516e-19 \
 //x=56.99 //y=5.38 //x2=65.575 //y2=7.585
cc_5460 ( N_noxref_17_c_7671_n N_VDD_c_10241_n ) capacitor c=0.00284979f \
 //x=56.99 //y=5.56 //x2=65.575 //y2=7.585
cc_5461 ( N_noxref_17_c_7554_n N_VDD_c_10241_n ) capacitor c=3.84946e-19 \
 //x=57.47 //y=4.25 //x2=65.575 //y2=7.585
cc_5462 ( N_noxref_17_c_7462_n N_VDD_c_10241_n ) capacitor c=0.00224881f \
 //x=56.11 //y=5.56 //x2=65.575 //y2=7.585
cc_5463 ( N_noxref_17_c_7575_n N_VDD_c_10241_n ) capacitor c=0.00224881f \
 //x=56.99 //y=5.56 //x2=65.575 //y2=7.585
cc_5464 ( N_noxref_17_c_7504_n N_VDD_c_11074_n ) capacitor c=3.24023e-19 \
 //x=44.52 //y=4.415 //x2=45.295 //y2=7.585
cc_5465 ( N_noxref_17_M98_noxref_g N_VDD_c_11074_n ) capacitor c=0.00755614f \
 //x=44.72 //y=6.2 //x2=45.295 //y2=7.585
cc_5466 ( N_noxref_17_M99_noxref_g N_VDD_c_11074_n ) capacitor c=0.00755544f \
 //x=45.16 //y=6.2 //x2=45.295 //y2=7.585
cc_5467 ( N_noxref_17_M110_noxref_g N_VDD_c_10947_n ) capacitor c=0.00697352f \
 //x=53.44 //y=6.2 //x2=54.015 //y2=7.585
cc_5468 ( N_noxref_17_M111_noxref_g N_VDD_c_10947_n ) capacitor c=0.00755544f \
 //x=53.88 //y=6.2 //x2=54.015 //y2=7.585
cc_5469 ( N_noxref_17_c_7435_n N_VDD_c_10952_n ) capacitor c=0.00208087f \
 //x=56.875 //y=5.38 //x2=56.465 //y2=7.585
cc_5470 ( N_noxref_17_c_7445_n N_VDD_c_10952_n ) capacitor c=9.41185e-19 \
 //x=56.11 //y=5.56 //x2=56.465 //y2=7.585
cc_5471 ( N_noxref_17_c_7462_n N_VDD_c_10952_n ) capacitor c=0.0136705f \
 //x=56.11 //y=5.56 //x2=56.465 //y2=7.585
cc_5472 ( N_noxref_17_c_7435_n N_VDD_c_10995_n ) capacitor c=0.00180737f \
 //x=56.875 //y=5.38 //x2=57.345 //y2=7.585
cc_5473 ( N_noxref_17_c_7528_n N_VDD_c_10995_n ) capacitor c=0.00208087f \
 //x=57.385 //y=5.38 //x2=57.345 //y2=7.585
cc_5474 ( N_noxref_17_c_7545_n N_VDD_c_10995_n ) capacitor c=4.23719e-19 \
 //x=56.99 //y=5.38 //x2=57.345 //y2=7.585
cc_5475 ( N_noxref_17_c_7671_n N_VDD_c_10995_n ) capacitor c=5.77976e-19 \
 //x=56.99 //y=5.56 //x2=57.345 //y2=7.585
cc_5476 ( N_noxref_17_c_7575_n N_VDD_c_10995_n ) capacitor c=0.0136705f \
 //x=56.99 //y=5.56 //x2=57.345 //y2=7.585
cc_5477 ( N_noxref_17_M122_noxref_g N_VDD_c_11205_n ) capacitor c=0.00697352f \
 //x=63.43 //y=6.2 //x2=64.005 //y2=7.585
cc_5478 ( N_noxref_17_M123_noxref_g N_VDD_c_11205_n ) capacitor c=0.00755544f \
 //x=63.87 //y=6.2 //x2=64.005 //y2=7.585
cc_5479 ( N_noxref_17_c_7504_n N_VDD_c_10822_n ) capacitor c=0.00117585f \
 //x=44.52 //y=4.415 //x2=43.41 //y2=7.585
cc_5480 ( N_noxref_17_c_7359_n N_VDD_c_10822_n ) capacitor c=0.0101051f \
 //x=44.52 //y=4.755 //x2=43.41 //y2=7.585
cc_5481 ( N_noxref_17_c_7360_n N_VDD_c_10822_n ) capacitor c=0.002687f \
 //x=44.52 //y=4.25 //x2=43.41 //y2=7.585
cc_5482 ( N_noxref_17_c_7572_n N_VDD_c_10822_n ) capacitor c=0.00370784f \
 //x=44.52 //y=4.88 //x2=43.41 //y2=7.585
cc_5483 ( N_noxref_17_c_7596_n N_VDD_c_10822_n ) capacitor c=0.00586228f \
 //x=44.795 //y=4.97 //x2=43.41 //y2=7.585
cc_5484 ( N_noxref_17_c_7390_n N_VDD_c_10900_n ) capacitor c=3.90041e-19 \
 //x=47.695 //y=4.265 //x2=48.22 //y2=7.585
cc_5485 ( N_noxref_17_c_7391_n N_VDD_c_10900_n ) capacitor c=0.00904116f \
 //x=48.94 //y=4.25 //x2=48.22 //y2=7.585
cc_5486 ( N_noxref_17_c_7382_n N_VDD_c_10865_n ) capacitor c=8.50173e-19 \
 //x=53.4 //y=4.25 //x2=51.55 //y2=7.585
cc_5487 ( N_noxref_17_c_7364_n N_VDD_c_10865_n ) capacitor c=0.0087315f \
 //x=53.565 //y=4.25 //x2=51.55 //y2=7.585
cc_5488 ( N_noxref_17_c_7441_n N_VDD_c_10958_n ) capacitor c=0.0013228f \
 //x=57.47 //y=5.295 //x2=54.88 //y2=7.585
cc_5489 ( N_noxref_17_c_7382_n N_VDD_c_10958_n ) capacitor c=0.00133985f \
 //x=53.4 //y=4.25 //x2=54.88 //y2=7.585
cc_5490 ( N_noxref_17_c_7445_n N_VDD_c_10958_n ) capacitor c=4.91377e-19 \
 //x=56.11 //y=5.56 //x2=54.88 //y2=7.585
cc_5491 ( N_noxref_17_c_7554_n N_VDD_c_10958_n ) capacitor c=4.55587e-19 \
 //x=57.47 //y=4.25 //x2=54.88 //y2=7.585
cc_5492 ( N_noxref_17_c_7455_n N_VDD_c_10958_n ) capacitor c=0.0086272f \
 //x=57.3 //y=4.25 //x2=54.88 //y2=7.585
cc_5493 ( N_noxref_17_c_7401_n N_VDD_c_10958_n ) capacitor c=0.00233202f \
 //x=53.43 //y=4.88 //x2=54.88 //y2=7.585
cc_5494 ( N_noxref_17_c_7462_n N_VDD_c_10958_n ) capacitor c=0.0064135f \
 //x=56.11 //y=5.56 //x2=54.88 //y2=7.585
cc_5495 ( N_noxref_17_c_7479_n N_VDD_c_10958_n ) capacitor c=0.0129149f \
 //x=53.805 //y=4.97 //x2=54.88 //y2=7.585
cc_5496 ( N_noxref_17_c_7536_n N_VDD_c_11025_n ) capacitor c=0.00197635f \
 //x=57.47 //y=4.425 //x2=58.21 //y2=7.585
cc_5497 ( N_noxref_17_c_7441_n N_VDD_c_11025_n ) capacitor c=0.0271117f \
 //x=57.47 //y=5.295 //x2=58.21 //y2=7.585
cc_5498 ( N_noxref_17_c_7545_n N_VDD_c_11025_n ) capacitor c=0.00240948f \
 //x=56.99 //y=5.38 //x2=58.21 //y2=7.585
cc_5499 ( N_noxref_17_c_7671_n N_VDD_c_11025_n ) capacitor c=4.09141e-19 \
 //x=56.99 //y=5.56 //x2=58.21 //y2=7.585
cc_5500 ( N_noxref_17_c_7554_n N_VDD_c_11025_n ) capacitor c=0.00494039f \
 //x=57.47 //y=4.25 //x2=58.21 //y2=7.585
cc_5501 ( N_noxref_17_c_7565_n N_VDD_c_11025_n ) capacitor c=0.0195658f \
 //x=59.19 //y=4.27 //x2=58.21 //y2=7.585
cc_5502 ( N_noxref_17_c_7575_n N_VDD_c_11025_n ) capacitor c=0.0101861f \
 //x=56.99 //y=5.56 //x2=58.21 //y2=7.585
cc_5503 ( N_noxref_17_c_7673_n N_VDD_c_11153_n ) capacitor c=8.4651e-19 \
 //x=63.39 //y=4.25 //x2=61.54 //y2=7.585
cc_5504 ( N_noxref_17_c_7643_n N_VDD_c_11153_n ) capacitor c=0.00862991f \
 //x=59.535 //y=4.27 //x2=61.54 //y2=7.585
cc_5505 ( N_noxref_17_c_7673_n N_VDD_c_11233_n ) capacitor c=0.00143077f \
 //x=63.39 //y=4.25 //x2=64.87 //y2=7.585
cc_5506 ( N_noxref_17_c_7691_n N_VDD_c_11233_n ) capacitor c=0.00226427f \
 //x=63.42 //y=4.88 //x2=64.87 //y2=7.585
cc_5507 ( N_noxref_17_c_7743_p N_VDD_c_11233_n ) capacitor c=0.0135027f \
 //x=63.795 //y=4.97 //x2=64.87 //y2=7.585
cc_5508 ( N_noxref_17_c_7710_n N_VDD_c_11233_n ) capacitor c=2.73429e-19 \
 //x=63.42 //y=4.88 //x2=64.87 //y2=7.585
cc_5509 ( N_noxref_17_c_7504_n N_VDD_M98_noxref_s ) capacitor c=9.65142e-19 \
 //x=44.52 //y=4.415 //x2=44.365 //y2=5.2
cc_5510 ( N_noxref_17_c_7359_n N_VDD_M98_noxref_s ) capacitor c=0.0217456f \
 //x=44.52 //y=4.755 //x2=44.365 //y2=5.2
cc_5511 ( N_noxref_17_c_7572_n N_VDD_M98_noxref_s ) capacitor c=0.00983846f \
 //x=44.52 //y=4.88 //x2=44.365 //y2=5.2
cc_5512 ( N_noxref_17_M98_noxref_g N_VDD_M98_noxref_s ) capacitor c=0.053419f \
 //x=44.72 //y=6.2 //x2=44.365 //y2=5.2
cc_5513 ( N_noxref_17_c_7596_n N_VDD_M98_noxref_s ) capacitor c=0.00597659f \
 //x=44.795 //y=4.97 //x2=44.365 //y2=5.2
cc_5514 ( N_noxref_17_M99_noxref_g N_VDD_M99_noxref_d ) capacitor c=0.015318f \
 //x=45.16 //y=6.2 //x2=45.235 //y2=5.2
cc_5515 ( N_noxref_17_M110_noxref_g N_VDD_M109_noxref_d ) capacitor \
 c=0.015318f //x=53.44 //y=6.2 //x2=53.075 //y2=5.2
cc_5516 ( N_noxref_17_c_7420_n N_VDD_M109_noxref_d ) capacitor c=3.50465e-19 \
 //x=53.43 //y=4.88 //x2=53.075 //y2=5.2
cc_5517 ( N_noxref_17_M111_noxref_g N_VDD_M111_noxref_d ) capacitor \
 c=0.0430452f //x=53.88 //y=6.2 //x2=53.955 //y2=5.2
cc_5518 ( N_noxref_17_c_7445_n N_VDD_M112_noxref_s ) capacitor c=0.0572211f \
 //x=56.11 //y=5.56 //x2=55.535 //y2=5.2
cc_5519 ( N_noxref_17_c_7545_n N_VDD_M112_noxref_s ) capacitor c=6.52457e-19 \
 //x=56.99 //y=5.38 //x2=55.535 //y2=5.2
cc_5520 ( N_noxref_17_c_7462_n N_VDD_M112_noxref_s ) capacitor c=0.0887533f \
 //x=56.11 //y=5.56 //x2=55.535 //y2=5.2
cc_5521 ( N_noxref_17_c_7435_n N_VDD_M113_noxref_d ) capacitor c=0.00734094f \
 //x=56.875 //y=5.38 //x2=56.405 //y2=5.2
cc_5522 ( N_noxref_17_c_7445_n N_VDD_M113_noxref_d ) capacitor c=0.0043528f \
 //x=56.11 //y=5.56 //x2=56.405 //y2=5.2
cc_5523 ( N_noxref_17_c_7671_n N_VDD_M113_noxref_d ) capacitor c=0.0043528f \
 //x=56.99 //y=5.56 //x2=56.405 //y2=5.2
cc_5524 ( N_noxref_17_c_7462_n N_VDD_M113_noxref_d ) capacitor c=0.065554f \
 //x=56.11 //y=5.56 //x2=56.405 //y2=5.2
cc_5525 ( N_noxref_17_c_7575_n N_VDD_M113_noxref_d ) capacitor c=0.065554f \
 //x=56.99 //y=5.56 //x2=56.405 //y2=5.2
cc_5526 ( N_noxref_17_c_7528_n N_VDD_M115_noxref_d ) capacitor c=0.00852734f \
 //x=57.385 //y=5.38 //x2=57.285 //y2=5.2
cc_5527 ( N_noxref_17_c_7671_n N_VDD_M115_noxref_d ) capacitor c=0.00587834f \
 //x=56.99 //y=5.56 //x2=57.285 //y2=5.2
cc_5528 ( N_noxref_17_c_7554_n N_VDD_M115_noxref_d ) capacitor c=0.00167175f \
 //x=57.47 //y=4.25 //x2=57.285 //y2=5.2
cc_5529 ( N_noxref_17_c_7575_n N_VDD_M115_noxref_d ) capacitor c=0.065554f \
 //x=56.99 //y=5.56 //x2=57.285 //y2=5.2
cc_5530 ( N_noxref_17_c_7528_n N_VDD_M116_noxref_s ) capacitor c=0.00326953f \
 //x=57.385 //y=5.38 //x2=58.865 //y2=5.2
cc_5531 ( N_noxref_17_c_7545_n N_VDD_M116_noxref_s ) capacitor c=0.00515461f \
 //x=56.99 //y=5.38 //x2=58.865 //y2=5.2
cc_5532 ( N_noxref_17_c_7671_n N_VDD_M116_noxref_s ) capacitor c=3.28075e-19 \
 //x=56.99 //y=5.56 //x2=58.865 //y2=5.2
cc_5533 ( N_noxref_17_c_7565_n N_VDD_M116_noxref_s ) capacitor c=0.00572888f \
 //x=59.19 //y=4.27 //x2=58.865 //y2=5.2
cc_5534 ( N_noxref_17_M122_noxref_g N_VDD_M121_noxref_d ) capacitor \
 c=0.015318f //x=63.43 //y=6.2 //x2=63.065 //y2=5.2
cc_5535 ( N_noxref_17_c_7710_n N_VDD_M121_noxref_d ) capacitor c=3.50465e-19 \
 //x=63.42 //y=4.88 //x2=63.065 //y2=5.2
cc_5536 ( N_noxref_17_M123_noxref_g N_VDD_M123_noxref_d ) capacitor \
 c=0.0430452f //x=63.87 //y=6.2 //x2=63.945 //y2=5.2
cc_5537 ( N_noxref_17_c_7499_n N_noxref_25_c_11791_n ) capacitor c=0.00271041f \
 //x=44.52 //y=2.375 //x2=42.67 //y2=2.285
cc_5538 ( N_noxref_17_c_7499_n N_noxref_25_c_11828_n ) capacitor c=8.56513e-19 \
 //x=44.52 //y=2.375 //x2=42.67 //y2=2.515
cc_5539 ( N_noxref_17_c_7358_n N_noxref_25_c_11828_n ) capacitor c=9.77535e-19 \
 //x=44.52 //y=4.095 //x2=42.67 //y2=2.515
cc_5540 ( N_noxref_17_c_7358_n N_noxref_25_c_11792_n ) capacitor c=0.0243996f \
 //x=44.52 //y=4.095 //x2=42.67 //y2=5.295
cc_5541 ( N_noxref_17_c_7504_n N_noxref_25_c_11792_n ) capacitor c=0.00350086f \
 //x=44.52 //y=4.415 //x2=42.67 //y2=5.295
cc_5542 ( N_noxref_17_c_7359_n N_noxref_25_c_11792_n ) capacitor c=0.00761862f \
 //x=44.52 //y=4.755 //x2=42.67 //y2=5.295
cc_5543 ( N_noxref_17_c_7361_n N_noxref_25_c_11792_n ) capacitor c=0.00222409f \
 //x=44.685 //y=4.255 //x2=42.67 //y2=5.295
cc_5544 ( N_noxref_17_c_7582_n N_GND_c_13024_n ) capacitor c=3.92414e-19 \
 //x=44.22 //y=1.055 //x2=44.485 //y2=1.015
cc_5545 ( N_noxref_17_c_7893_p N_GND_c_13024_n ) capacitor c=0.0085115f \
 //x=44.595 //y=0.9 //x2=44.485 //y2=1.015
cc_5546 ( N_noxref_17_c_7588_n N_GND_c_13024_n ) capacitor c=4.45447e-19 \
 //x=44.75 //y=1.055 //x2=44.485 //y2=1.015
cc_5547 ( N_noxref_17_c_7383_n N_GND_c_12871_n ) capacitor c=0.00210951f \
 //x=53.4 //y=2.26 //x2=55.975 //y2=0.175
cc_5548 ( N_noxref_17_c_7529_n N_GND_c_12915_n ) capacitor c=0.00608539f \
 //x=57.385 //y=1.835 //x2=59.305 //y2=0.175
cc_5549 ( N_noxref_17_c_7454_n N_GND_c_12915_n ) capacitor c=0.00928865f \
 //x=57.03 //y=1.18 //x2=59.305 //y2=0.175
cc_5550 ( N_noxref_17_M34_noxref_d N_GND_c_12915_n ) capacitor c=3.01769e-19 \
 //x=56.84 //y=1.085 //x2=59.305 //y2=0.175
cc_5551 ( N_noxref_17_c_7674_n N_GND_c_13031_n ) capacitor c=0.00210951f \
 //x=63.39 //y=2.26 //x2=65.965 //y2=0.175
cc_5552 ( N_noxref_17_c_7499_n N_GND_c_13032_n ) capacitor c=0.00772482f \
 //x=44.52 //y=2.375 //x2=44.485 //y2=1.145
cc_5553 ( N_noxref_17_c_7504_n N_GND_c_13032_n ) capacitor c=4.525e-19 \
 //x=44.52 //y=4.415 //x2=44.485 //y2=1.145
cc_5554 ( N_noxref_17_c_7568_n N_GND_c_13032_n ) capacitor c=2.22883e-19 \
 //x=44.52 //y=2.26 //x2=44.485 //y2=1.145
cc_5555 ( N_noxref_17_c_7582_n N_GND_c_13032_n ) capacitor c=0.0015128f \
 //x=44.22 //y=1.055 //x2=44.485 //y2=1.145
cc_5556 ( N_noxref_17_c_7583_n N_GND_c_13032_n ) capacitor c=0.00350108f \
 //x=44.22 //y=1.4 //x2=44.485 //y2=1.145
cc_5557 ( N_noxref_17_c_7584_n N_GND_c_13032_n ) capacitor c=4.68816e-19 \
 //x=44.22 //y=1.71 //x2=44.485 //y2=1.145
cc_5558 ( N_noxref_17_c_7893_p N_GND_c_13032_n ) capacitor c=9.36995e-19 \
 //x=44.595 //y=0.9 //x2=44.485 //y2=1.145
cc_5559 ( N_noxref_17_c_7907_p N_GND_c_13032_n ) capacitor c=6.09659e-19 \
 //x=44.595 //y=1.555 //x2=44.485 //y2=1.145
cc_5560 ( N_noxref_17_c_7588_n N_GND_c_13032_n ) capacitor c=0.0017438f \
 //x=44.75 //y=1.055 //x2=44.485 //y2=1.145
cc_5561 ( N_noxref_17_c_7590_n N_GND_c_13032_n ) capacitor c=0.00276804f \
 //x=44.75 //y=1.4 //x2=44.485 //y2=1.145
cc_5562 ( N_noxref_17_c_7445_n N_GND_c_12878_n ) capacitor c=7.46777e-19 \
 //x=56.11 //y=5.56 //x2=56.06 //y2=1.135
cc_5563 ( N_noxref_17_c_7454_n N_GND_c_12878_n ) capacitor c=0.0140087f \
 //x=57.03 //y=1.18 //x2=56.06 //y2=1.135
cc_5564 ( N_noxref_17_M34_noxref_d N_GND_c_12878_n ) capacitor c=2.93544e-19 \
 //x=56.84 //y=1.085 //x2=56.06 //y2=1.135
cc_5565 ( N_noxref_17_c_7454_n N_GND_c_12945_n ) capacitor c=0.00549186f \
 //x=57.03 //y=1.18 //x2=59.39 //y2=1.135
cc_5566 ( N_noxref_17_c_7582_n N_GND_c_12849_n ) capacitor c=0.00677766f \
 //x=44.22 //y=1.055 //x2=48.05 //y2=0.175
cc_5567 ( N_noxref_17_c_7383_n N_GND_c_12851_n ) capacitor c=3.77328e-19 \
 //x=53.4 //y=2.26 //x2=54.71 //y2=0.175
cc_5568 ( N_noxref_17_c_7529_n N_GND_c_12893_n ) capacitor c=7.77585e-19 \
 //x=57.385 //y=1.835 //x2=58.04 //y2=0.175
cc_5569 ( N_noxref_17_c_7674_n N_GND_c_13007_n ) capacitor c=3.77328e-19 \
 //x=63.39 //y=2.26 //x2=64.7 //y2=0.175
cc_5570 ( N_noxref_17_c_7499_n N_GND_c_12760_n ) capacitor c=0.00342498f \
 //x=44.52 //y=2.375 //x2=43.41 //y2=0.175
cc_5571 ( N_noxref_17_c_7358_n N_GND_c_12760_n ) capacitor c=0.00851991f \
 //x=44.52 //y=4.095 //x2=43.41 //y2=0.175
cc_5572 ( N_noxref_17_c_7568_n N_GND_c_12760_n ) capacitor c=0.00396203f \
 //x=44.52 //y=2.26 //x2=43.41 //y2=0.175
cc_5573 ( N_noxref_17_c_7584_n N_GND_c_12760_n ) capacitor c=0.00170145f \
 //x=44.22 //y=1.71 //x2=43.41 //y2=0.175
cc_5574 ( N_noxref_17_c_7585_n N_GND_c_12760_n ) capacitor c=0.0102191f \
 //x=44.22 //y=2.095 //x2=43.41 //y2=0.175
cc_5575 ( N_noxref_17_c_7438_n N_GND_c_12895_n ) capacitor c=9.32616e-19 \
 //x=57.47 //y=4.105 //x2=54.88 //y2=0.175
cc_5576 ( N_noxref_17_c_7397_n N_GND_c_12895_n ) capacitor c=0.00200922f \
 //x=53.4 //y=2.26 //x2=54.88 //y2=0.175
cc_5577 ( N_noxref_17_c_7416_n N_GND_c_12895_n ) capacitor c=0.00275184f \
 //x=53.965 //y=1.43 //x2=54.88 //y2=0.175
cc_5578 ( N_noxref_17_c_7417_n N_GND_c_12895_n ) capacitor c=2.63786e-19 \
 //x=53.4 //y=2.26 //x2=54.88 //y2=0.175
cc_5579 ( N_noxref_17_c_7436_n N_GND_c_12925_n ) capacitor c=0.002973f \
 //x=57.03 //y=1.75 //x2=58.21 //y2=0.175
cc_5580 ( N_noxref_17_c_7529_n N_GND_c_12925_n ) capacitor c=0.0292394f \
 //x=57.385 //y=1.835 //x2=58.21 //y2=0.175
cc_5581 ( N_noxref_17_c_7687_n N_GND_c_13061_n ) capacitor c=0.00207214f \
 //x=63.39 //y=2.26 //x2=64.87 //y2=0.175
cc_5582 ( N_noxref_17_c_7706_n N_GND_c_13061_n ) capacitor c=0.00275184f \
 //x=63.955 //y=1.43 //x2=64.87 //y2=0.175
cc_5583 ( N_noxref_17_c_7707_n N_GND_c_13061_n ) capacitor c=2.63786e-19 \
 //x=63.39 //y=2.26 //x2=64.87 //y2=0.175
cc_5584 ( N_noxref_17_c_7499_n N_GND_M26_noxref_d ) capacitor c=4.4417e-19 \
 //x=44.52 //y=2.375 //x2=44.295 //y2=1.055
cc_5585 ( N_noxref_17_c_7582_n N_GND_M26_noxref_d ) capacitor c=0.00184354f \
 //x=44.22 //y=1.055 //x2=44.295 //y2=1.055
cc_5586 ( N_noxref_17_c_7583_n N_GND_M26_noxref_d ) capacitor c=0.00210798f \
 //x=44.22 //y=1.4 //x2=44.295 //y2=1.055
cc_5587 ( N_noxref_17_c_7893_p N_GND_M26_noxref_d ) capacitor c=0.00474029f \
 //x=44.595 //y=0.9 //x2=44.295 //y2=1.055
cc_5588 ( N_noxref_17_c_7907_p N_GND_M26_noxref_d ) capacitor c=0.00166857f \
 //x=44.595 //y=1.555 //x2=44.295 //y2=1.055
cc_5589 ( N_noxref_17_c_7588_n N_GND_M26_noxref_d ) capacitor c=0.00230174f \
 //x=44.75 //y=1.055 //x2=44.295 //y2=1.055
cc_5590 ( N_noxref_17_c_7590_n N_GND_M26_noxref_d ) capacitor c=0.00210798f \
 //x=44.75 //y=1.4 //x2=44.295 //y2=1.055
cc_5591 ( N_noxref_17_c_7454_n N_GND_M33_noxref_d ) capacitor c=2.82748e-19 \
 //x=57.03 //y=1.18 //x2=55.87 //y2=1.045
cc_5592 ( N_noxref_17_c_7585_n N_noxref_43_c_14790_n ) capacitor c=0.00262672f \
 //x=44.22 //y=2.095 //x2=44 //y2=1.685
cc_5593 ( N_noxref_17_c_7499_n N_noxref_43_c_14791_n ) capacitor c=0.00428451f \
 //x=44.52 //y=2.375 //x2=44.885 //y2=1.77
cc_5594 ( N_noxref_17_c_7504_n N_noxref_43_c_14791_n ) capacitor c=0.00107765f \
 //x=44.52 //y=4.415 //x2=44.885 //y2=1.77
cc_5595 ( N_noxref_17_c_7568_n N_noxref_43_c_14791_n ) capacitor c=0.0104666f \
 //x=44.52 //y=2.26 //x2=44.885 //y2=1.77
cc_5596 ( N_noxref_17_c_7584_n N_noxref_43_c_14791_n ) capacitor c=0.00705077f \
 //x=44.22 //y=1.71 //x2=44.885 //y2=1.77
cc_5597 ( N_noxref_17_c_7585_n N_noxref_43_c_14791_n ) capacitor c=0.020708f \
 //x=44.22 //y=2.095 //x2=44.885 //y2=1.77
cc_5598 ( N_noxref_17_c_7907_p N_noxref_43_c_14791_n ) capacitor c=0.00588627f \
 //x=44.595 //y=1.555 //x2=44.885 //y2=1.77
cc_5599 ( N_noxref_17_c_7590_n N_noxref_43_c_14791_n ) capacitor c=0.00698822f \
 //x=44.75 //y=1.4 //x2=44.885 //y2=1.77
cc_5600 ( N_noxref_17_c_7582_n N_noxref_43_M26_noxref_s ) capacitor \
 c=0.0295256f //x=44.22 //y=1.055 //x2=43.865 //y2=0.555
cc_5601 ( N_noxref_17_c_7584_n N_noxref_43_M26_noxref_s ) capacitor \
 c=7.99997e-19 //x=44.22 //y=1.71 //x2=43.865 //y2=0.555
cc_5602 ( N_noxref_17_c_7585_n N_noxref_43_M26_noxref_s ) capacitor \
 c=0.00122123f //x=44.22 //y=2.095 //x2=43.865 //y2=0.555
cc_5603 ( N_noxref_17_c_7588_n N_noxref_43_M26_noxref_s ) capacitor \
 c=0.0125924f //x=44.75 //y=1.055 //x2=43.865 //y2=0.555
cc_5604 ( N_noxref_17_c_7376_n N_noxref_45_c_14916_n ) capacitor c=9.48063e-19 \
 //x=53.4 //y=4.415 //x2=53.215 //y2=1.675
cc_5605 ( N_noxref_17_c_7383_n N_noxref_45_c_14916_n ) capacitor c=7.50092e-19 \
 //x=53.4 //y=2.26 //x2=53.215 //y2=1.675
cc_5606 ( N_noxref_17_c_7412_n N_noxref_45_c_14916_n ) capacitor c=0.00888238f \
 //x=53.435 //y=1.74 //x2=53.215 //y2=1.675
cc_5607 ( N_noxref_17_c_7417_n N_noxref_45_c_14916_n ) capacitor c=0.00175171f \
 //x=53.4 //y=2.26 //x2=53.215 //y2=1.675
cc_5608 ( N_noxref_17_c_7383_n N_noxref_45_c_14921_n ) capacitor c=0.001463f \
 //x=53.4 //y=2.26 //x2=54.1 //y2=0.71
cc_5609 ( N_noxref_17_c_7397_n N_noxref_45_c_14921_n ) capacitor c=8.82141e-19 \
 //x=53.4 //y=2.26 //x2=54.1 //y2=0.71
cc_5610 ( N_noxref_17_c_7407_n N_noxref_45_c_14921_n ) capacitor c=0.0200738f \
 //x=53.435 //y=1.085 //x2=54.1 //y2=0.71
cc_5611 ( N_noxref_17_c_7415_n N_noxref_45_c_14921_n ) capacitor c=0.00825432f \
 //x=53.965 //y=1.085 //x2=54.1 //y2=0.71
cc_5612 ( N_noxref_17_c_7417_n N_noxref_45_c_14921_n ) capacitor c=2.1838e-19 \
 //x=53.4 //y=2.26 //x2=54.1 //y2=0.71
cc_5613 ( N_noxref_17_c_7407_n N_noxref_45_M31_noxref_s ) capacitor \
 c=0.00888238f //x=53.435 //y=1.085 //x2=52.11 //y2=0.545
cc_5614 ( N_noxref_17_c_7415_n N_noxref_45_M31_noxref_s ) capacitor \
 c=0.015333f //x=53.965 //y=1.085 //x2=52.11 //y2=0.545
cc_5615 ( N_noxref_17_c_7416_n N_noxref_45_M31_noxref_s ) capacitor \
 c=0.00248746f //x=53.965 //y=1.43 //x2=52.11 //y2=0.545
cc_5616 ( N_noxref_17_c_7437_n N_noxref_46_c_14985_n ) capacitor c=0.00911498f \
 //x=57.115 //y=1.835 //x2=56.545 //y2=1.675
cc_5617 ( N_noxref_17_c_7529_n N_noxref_46_c_14992_n ) capacitor c=0.00399245f \
 //x=57.385 //y=1.835 //x2=57.43 //y2=0.71
cc_5618 ( N_noxref_17_c_7454_n N_noxref_46_c_14992_n ) capacitor c=0.003751f \
 //x=57.03 //y=1.18 //x2=57.43 //y2=0.71
cc_5619 ( N_noxref_17_M34_noxref_d N_noxref_46_c_14992_n ) capacitor \
 c=0.00910163f //x=56.84 //y=1.085 //x2=57.43 //y2=0.71
cc_5620 ( N_noxref_17_c_7436_n N_noxref_46_M33_noxref_s ) capacitor \
 c=0.0162484f //x=57.03 //y=1.75 //x2=55.44 //y2=0.545
cc_5621 ( N_noxref_17_c_7529_n N_noxref_46_M33_noxref_s ) capacitor \
 c=0.00692219f //x=57.385 //y=1.835 //x2=55.44 //y2=0.545
cc_5622 ( N_noxref_17_c_7536_n N_noxref_46_M33_noxref_s ) capacitor \
 c=2.52049e-19 //x=57.47 //y=4.425 //x2=55.44 //y2=0.545
cc_5623 ( N_noxref_17_c_7454_n N_noxref_46_M33_noxref_s ) capacitor \
 c=0.00905169f //x=57.03 //y=1.18 //x2=55.44 //y2=0.545
cc_5624 ( N_noxref_17_c_7554_n N_noxref_46_M33_noxref_s ) capacitor \
 c=7.05305e-19 //x=57.47 //y=4.25 //x2=55.44 //y2=0.545
cc_5625 ( N_noxref_17_M34_noxref_d N_noxref_46_M33_noxref_s ) capacitor \
 c=0.0275552f //x=56.84 //y=1.085 //x2=55.44 //y2=0.545
cc_5626 ( N_noxref_17_c_7664_n N_noxref_48_c_15123_n ) capacitor c=9.54772e-19 \
 //x=63.39 //y=4.41 //x2=63.205 //y2=1.675
cc_5627 ( N_noxref_17_c_7674_n N_noxref_48_c_15123_n ) capacitor c=7.50092e-19 \
 //x=63.39 //y=2.26 //x2=63.205 //y2=1.675
cc_5628 ( N_noxref_17_c_7702_n N_noxref_48_c_15123_n ) capacitor c=0.00888238f \
 //x=63.425 //y=1.74 //x2=63.205 //y2=1.675
cc_5629 ( N_noxref_17_c_7707_n N_noxref_48_c_15123_n ) capacitor c=0.00175171f \
 //x=63.39 //y=2.26 //x2=63.205 //y2=1.675
cc_5630 ( N_noxref_17_c_7674_n N_noxref_48_c_15131_n ) capacitor c=0.001463f \
 //x=63.39 //y=2.26 //x2=64.09 //y2=0.71
cc_5631 ( N_noxref_17_c_7687_n N_noxref_48_c_15131_n ) capacitor c=8.82141e-19 \
 //x=63.39 //y=2.26 //x2=64.09 //y2=0.71
cc_5632 ( N_noxref_17_c_7697_n N_noxref_48_c_15131_n ) capacitor c=0.0200738f \
 //x=63.425 //y=1.085 //x2=64.09 //y2=0.71
cc_5633 ( N_noxref_17_c_7705_n N_noxref_48_c_15131_n ) capacitor c=0.00825432f \
 //x=63.955 //y=1.085 //x2=64.09 //y2=0.71
cc_5634 ( N_noxref_17_c_7707_n N_noxref_48_c_15131_n ) capacitor c=2.1838e-19 \
 //x=63.39 //y=2.26 //x2=64.09 //y2=0.71
cc_5635 ( N_noxref_17_c_7697_n N_noxref_48_M37_noxref_s ) capacitor \
 c=0.00888238f //x=63.425 //y=1.085 //x2=62.1 //y2=0.545
cc_5636 ( N_noxref_17_c_7705_n N_noxref_48_M37_noxref_s ) capacitor \
 c=0.015333f //x=63.955 //y=1.085 //x2=62.1 //y2=0.545
cc_5637 ( N_noxref_17_c_7706_n N_noxref_48_M37_noxref_s ) capacitor \
 c=0.00248746f //x=63.955 //y=1.43 //x2=62.1 //y2=0.545
cc_5638 ( N_noxref_18_c_8174_p N_noxref_19_c_8715_n ) capacitor c=0.00651591f \
 //x=65.61 //y=2.375 //x2=66.72 //y2=2.485
cc_5639 ( N_noxref_18_c_8144_n N_noxref_19_c_8715_n ) capacitor c=0.00202597f \
 //x=65.61 //y=3.73 //x2=66.72 //y2=2.485
cc_5640 ( N_noxref_18_c_8176_p N_noxref_19_c_8715_n ) capacitor c=0.00132356f \
 //x=69.31 //y=2.385 //x2=66.72 //y2=2.485
cc_5641 ( N_noxref_18_c_8177_p N_noxref_19_c_8715_n ) capacitor c=5.65313e-19 \
 //x=69.31 //y=4.475 //x2=66.72 //y2=2.485
cc_5642 ( N_noxref_18_c_8178_p N_noxref_19_c_8715_n ) capacitor c=0.00270418f \
 //x=65.61 //y=2.26 //x2=66.72 //y2=2.485
cc_5643 ( N_noxref_18_c_8179_p N_noxref_19_c_8715_n ) capacitor c=0.00131898f \
 //x=65.61 //y=2.26 //x2=66.72 //y2=2.485
cc_5644 ( N_noxref_18_c_8049_n N_noxref_19_c_8721_n ) capacitor c=0.00166324f \
 //x=64.13 //y=3.73 //x2=66.72 //y2=4.045
cc_5645 ( N_noxref_18_c_8144_n N_noxref_19_c_8721_n ) capacitor c=0.0354142f \
 //x=65.61 //y=3.73 //x2=66.72 //y2=4.045
cc_5646 ( N_noxref_18_c_8182_p N_noxref_19_c_8721_n ) capacitor c=0.00752481f \
 //x=65.61 //y=4.05 //x2=66.72 //y2=4.045
cc_5647 ( N_noxref_18_c_8177_p N_noxref_19_c_8721_n ) capacitor c=0.0190119f \
 //x=69.31 //y=4.475 //x2=66.72 //y2=4.045
cc_5648 ( N_noxref_18_c_8184_p N_noxref_19_c_8721_n ) capacitor c=0.00383708f \
 //x=65.61 //y=3.88 //x2=66.72 //y2=4.045
cc_5649 ( N_noxref_18_c_8185_p N_noxref_19_c_8721_n ) capacitor c=0.00497822f \
 //x=65.605 //y=3.89 //x2=66.72 //y2=4.045
cc_5650 ( N_noxref_18_c_8182_p N_noxref_19_c_8727_n ) capacitor c=2.88832e-19 \
 //x=65.61 //y=4.05 //x2=66.72 //y2=4.365
cc_5651 ( N_noxref_18_c_8187_p N_noxref_19_c_8727_n ) capacitor c=0.00767162f \
 //x=65.61 //y=4.46 //x2=66.72 //y2=4.365
cc_5652 ( N_noxref_18_c_8177_p N_noxref_19_c_8727_n ) capacitor c=0.00149249f \
 //x=69.31 //y=4.475 //x2=66.72 //y2=4.365
cc_5653 ( N_noxref_18_c_8189_p N_noxref_19_c_8727_n ) capacitor c=0.00452722f \
 //x=69.155 //y=4.64 //x2=66.72 //y2=4.365
cc_5654 ( N_noxref_18_c_8051_n N_noxref_19_c_8731_n ) capacitor c=0.00202648f \
 //x=64.13 //y=5.295 //x2=66.72 //y2=4.71
cc_5655 ( N_noxref_18_c_8187_p N_noxref_19_c_8731_n ) capacitor c=0.00234994f \
 //x=65.61 //y=4.46 //x2=66.72 //y2=4.71
cc_5656 ( N_noxref_18_c_8177_p N_noxref_19_c_8731_n ) capacitor c=0.00106529f \
 //x=69.31 //y=4.475 //x2=66.72 //y2=4.71
cc_5657 ( N_noxref_18_c_8193_p N_noxref_19_c_8731_n ) capacitor c=0.0101017f \
 //x=65.61 //y=4.62 //x2=66.72 //y2=4.71
cc_5658 ( N_noxref_18_c_8194_p N_noxref_19_c_8731_n ) capacitor c=0.00146299f \
 //x=69.31 //y=4.62 //x2=66.72 //y2=4.71
cc_5659 ( N_noxref_18_c_8195_p N_noxref_19_c_8731_n ) capacitor c=0.00282565f \
 //x=65.775 //y=4.62 //x2=66.72 //y2=4.71
cc_5660 ( N_noxref_18_c_8196_p N_noxref_19_c_8731_n ) capacitor c=0.00206738f \
 //x=69.315 //y=4.64 //x2=66.72 //y2=4.71
cc_5661 ( N_noxref_18_c_8189_p N_noxref_19_c_8731_n ) capacitor c=0.0312701f \
 //x=69.155 //y=4.64 //x2=66.72 //y2=4.71
cc_5662 ( N_noxref_18_c_8198_p N_noxref_19_c_8731_n ) capacitor c=0.00670492f \
 //x=65.61 //y=4.62 //x2=66.72 //y2=4.71
cc_5663 ( N_noxref_18_c_8199_p N_noxref_19_c_8731_n ) capacitor c=0.00117926f \
 //x=66.245 //y=4.975 //x2=66.72 //y2=4.71
cc_5664 ( N_noxref_18_c_8200_p N_noxref_19_c_8731_n ) capacitor c=0.00104403f \
 //x=65.955 //y=4.975 //x2=66.72 //y2=4.71
cc_5665 ( N_noxref_18_c_8187_p N_noxref_19_c_8742_n ) capacitor c=5.51775e-19 \
 //x=65.61 //y=4.46 //x2=66.72 //y2=4.25
cc_5666 ( N_noxref_18_c_7986_n N_noxref_19_c_8645_n ) capacitor c=0.0140221f \
 //x=60.06 //y=3.705 //x2=50.285 //y2=2.37
cc_5667 ( N_noxref_18_c_8048_n N_noxref_19_c_8645_n ) capacitor c=0.0195172f \
 //x=63.775 //y=1.835 //x2=50.285 //y2=2.37
cc_5668 ( N_noxref_18_c_8049_n N_noxref_19_c_8645_n ) capacitor c=0.0304046f \
 //x=64.13 //y=3.73 //x2=50.285 //y2=2.37
cc_5669 ( N_noxref_18_c_8174_p N_noxref_19_c_8645_n ) capacitor c=0.0201572f \
 //x=65.61 //y=2.375 //x2=50.285 //y2=2.37
cc_5670 ( N_noxref_18_c_8144_n N_noxref_19_c_8645_n ) capacitor c=0.0167134f \
 //x=65.61 //y=3.73 //x2=50.285 //y2=2.37
cc_5671 ( N_noxref_18_c_8176_p N_noxref_19_c_8645_n ) capacitor c=0.00373746f \
 //x=69.31 //y=2.385 //x2=50.285 //y2=2.37
cc_5672 ( N_noxref_18_c_8177_p N_noxref_19_c_8645_n ) capacitor c=0.00102526f \
 //x=69.31 //y=4.475 //x2=50.285 //y2=2.37
cc_5673 ( N_noxref_18_c_7998_n N_noxref_19_c_8645_n ) capacitor c=0.0167414f \
 //x=60.06 //y=2.26 //x2=50.285 //y2=2.37
cc_5674 ( N_noxref_18_c_8064_n N_noxref_19_c_8645_n ) capacitor c=7.09092e-19 \
 //x=63.69 //y=1.18 //x2=50.285 //y2=2.37
cc_5675 ( N_noxref_18_c_8065_n N_noxref_19_c_8645_n ) capacitor c=0.00914845f \
 //x=63.005 //y=3.88 //x2=50.285 //y2=2.37
cc_5676 ( N_noxref_18_c_8163_n N_noxref_19_c_8645_n ) capacitor c=9.38115e-19 \
 //x=64.28 //y=3.88 //x2=50.285 //y2=2.37
cc_5677 ( N_noxref_18_c_8213_p N_noxref_19_c_8645_n ) capacitor c=0.00251167f \
 //x=65.445 //y=3.89 //x2=50.285 //y2=2.37
cc_5678 ( N_noxref_18_c_8189_p N_noxref_19_c_8645_n ) capacitor c=0.00107668f \
 //x=69.155 //y=4.64 //x2=50.285 //y2=2.37
cc_5679 ( N_noxref_18_c_8026_n N_noxref_19_c_8645_n ) capacitor c=2.98635e-19 \
 //x=60.06 //y=2.26 //x2=50.285 //y2=2.37
cc_5680 ( N_noxref_18_c_8179_p N_noxref_19_c_8645_n ) capacitor c=4.81811e-19 \
 //x=65.61 //y=2.26 //x2=50.285 //y2=2.37
cc_5681 ( N_noxref_18_c_8187_p N_noxref_19_c_8758_n ) capacitor c=0.00517614f \
 //x=65.61 //y=4.46 //x2=66.88 //y2=4.205
cc_5682 ( N_noxref_18_c_8177_p N_noxref_19_c_8758_n ) capacitor c=0.00110824f \
 //x=69.31 //y=4.475 //x2=66.88 //y2=4.205
cc_5683 ( N_noxref_18_c_8185_p N_noxref_19_c_8758_n ) capacitor c=2.60299e-19 \
 //x=65.605 //y=3.89 //x2=66.88 //y2=4.205
cc_5684 ( N_noxref_18_c_8189_p N_noxref_19_c_8758_n ) capacitor c=0.0336481f \
 //x=69.155 //y=4.64 //x2=66.88 //y2=4.205
cc_5685 ( N_noxref_18_c_8177_p N_noxref_19_c_8762_n ) capacitor c=0.0296991f \
 //x=69.31 //y=4.475 //x2=73.235 //y2=4.21
cc_5686 ( N_noxref_18_c_8194_p N_noxref_19_c_8762_n ) capacitor c=0.0102464f \
 //x=69.31 //y=4.62 //x2=73.235 //y2=4.21
cc_5687 ( N_noxref_18_c_8196_p N_noxref_19_c_8762_n ) capacitor c=0.0369071f \
 //x=69.315 //y=4.64 //x2=73.235 //y2=4.21
cc_5688 ( N_noxref_18_c_8189_p N_noxref_19_c_8762_n ) capacitor c=0.208741f \
 //x=69.155 //y=4.64 //x2=73.235 //y2=4.21
cc_5689 ( N_noxref_18_c_8174_p N_noxref_19_c_8766_n ) capacitor c=7.28747e-19 \
 //x=65.61 //y=2.375 //x2=66.72 //y2=2.26
cc_5690 ( N_noxref_18_c_8178_p N_noxref_19_c_8766_n ) capacitor c=0.00113391f \
 //x=65.61 //y=2.26 //x2=66.72 //y2=2.26
cc_5691 ( N_noxref_18_c_8179_p N_noxref_19_c_8766_n ) capacitor c=0.00201842f \
 //x=65.61 //y=2.26 //x2=66.72 //y2=2.26
cc_5692 ( N_noxref_18_c_8198_p N_noxref_19_c_8769_n ) capacitor c=0.00133991f \
 //x=65.61 //y=4.62 //x2=66.76 //y2=4.885
cc_5693 ( N_noxref_18_c_8199_p N_noxref_19_c_8769_n ) capacitor c=0.00122675f \
 //x=66.245 //y=4.975 //x2=66.76 //y2=4.885
cc_5694 ( N_noxref_18_c_8200_p N_noxref_19_c_8769_n ) capacitor c=0.00114302f \
 //x=65.955 //y=4.975 //x2=66.76 //y2=4.885
cc_5695 ( N_noxref_18_M124_noxref_g N_noxref_19_M126_noxref_g ) capacitor \
 c=0.0106808f //x=65.88 //y=6.205 //x2=66.76 //y2=6.205
cc_5696 ( N_noxref_18_M125_noxref_g N_noxref_19_M126_noxref_g ) capacitor \
 c=0.108153f //x=66.32 //y=6.205 //x2=66.76 //y2=6.205
cc_5697 ( N_noxref_18_M125_noxref_g N_noxref_19_M127_noxref_g ) capacitor \
 c=0.0103194f //x=66.32 //y=6.205 //x2=67.2 //y2=6.205
cc_5698 ( N_noxref_18_c_8234_p N_noxref_19_c_8775_n ) capacitor c=4.86545e-19 \
 //x=65.785 //y=1.045 //x2=66.755 //y2=1.085
cc_5699 ( N_noxref_18_c_8235_p N_noxref_19_c_8775_n ) capacitor c=0.00152405f \
 //x=65.785 //y=1.39 //x2=66.755 //y2=1.085
cc_5700 ( N_noxref_18_c_8236_p N_noxref_19_c_8775_n ) capacitor c=0.0151475f \
 //x=66.315 //y=1.045 //x2=66.755 //y2=1.085
cc_5701 ( N_noxref_18_c_8237_p N_noxref_19_c_8778_n ) capacitor c=0.00109982f \
 //x=65.785 //y=1.7 //x2=66.755 //y2=1.43
cc_5702 ( N_noxref_18_c_8238_p N_noxref_19_c_8778_n ) capacitor c=0.0111064f \
 //x=66.315 //y=1.39 //x2=66.755 //y2=1.43
cc_5703 ( N_noxref_18_c_8237_p N_noxref_19_c_8780_n ) capacitor c=0.00179029f \
 //x=65.785 //y=1.7 //x2=66.755 //y2=1.74
cc_5704 ( N_noxref_18_c_8240_p N_noxref_19_c_8780_n ) capacitor c=0.00662747f \
 //x=65.785 //y=2.095 //x2=66.755 //y2=1.74
cc_5705 ( N_noxref_18_c_8238_p N_noxref_19_c_8780_n ) capacitor c=0.00862358f \
 //x=66.315 //y=1.39 //x2=66.755 //y2=1.74
cc_5706 ( N_noxref_18_c_8236_p N_noxref_19_c_8783_n ) capacitor c=0.00124846f \
 //x=66.315 //y=1.045 //x2=67.285 //y2=1.085
cc_5707 ( N_noxref_18_c_8238_p N_noxref_19_c_8784_n ) capacitor c=0.00161183f \
 //x=66.315 //y=1.39 //x2=67.285 //y2=1.43
cc_5708 ( N_noxref_18_c_8178_p N_noxref_19_c_8785_n ) capacitor c=0.00146735f \
 //x=65.61 //y=2.26 //x2=66.72 //y2=2.26
cc_5709 ( N_noxref_18_c_8179_p N_noxref_19_c_8785_n ) capacitor c=0.00853882f \
 //x=65.61 //y=2.26 //x2=66.72 //y2=2.26
cc_5710 ( N_noxref_18_c_8193_p N_noxref_19_c_8787_n ) capacitor c=2.84639e-19 \
 //x=65.61 //y=4.62 //x2=66.76 //y2=4.885
cc_5711 ( N_noxref_18_c_8198_p N_noxref_19_c_8787_n ) capacitor c=0.00197201f \
 //x=65.61 //y=4.62 //x2=66.76 //y2=4.885
cc_5712 ( N_noxref_18_c_8199_p N_noxref_19_c_8787_n ) capacitor c=0.0203213f \
 //x=66.245 //y=4.975 //x2=66.76 //y2=4.885
cc_5713 ( N_noxref_18_c_8200_p N_noxref_19_c_8787_n ) capacitor c=0.00427779f \
 //x=65.955 //y=4.975 //x2=66.76 //y2=4.885
cc_5714 ( N_noxref_18_c_8176_p N_noxref_20_c_9514_n ) capacitor c=0.0033801f \
 //x=69.31 //y=2.385 //x2=70.79 //y2=2.43
cc_5715 ( N_noxref_18_c_8177_p N_noxref_20_c_9514_n ) capacitor c=5.52227e-19 \
 //x=69.31 //y=4.475 //x2=70.79 //y2=2.43
cc_5716 ( N_noxref_18_c_8252_p N_noxref_20_c_9514_n ) capacitor c=5.86738e-19 \
 //x=69.31 //y=2.26 //x2=70.79 //y2=2.43
cc_5717 ( N_noxref_18_c_8177_p N_noxref_20_c_9517_n ) capacitor c=0.0118208f \
 //x=69.31 //y=4.475 //x2=70.79 //y2=2.98
cc_5718 ( N_noxref_18_c_8177_p N_noxref_20_c_9518_n ) capacitor c=0.00404955f \
 //x=69.31 //y=4.475 //x2=70.79 //y2=3.3
cc_5719 ( N_noxref_18_c_8177_p N_noxref_20_c_9519_n ) capacitor c=0.0254592f \
 //x=69.31 //y=4.475 //x2=70.79 //y2=4.76
cc_5720 ( N_noxref_18_c_8194_p N_noxref_20_c_9519_n ) capacitor c=0.0047666f \
 //x=69.31 //y=4.62 //x2=70.79 //y2=4.76
cc_5721 ( N_noxref_18_c_8196_p N_noxref_20_c_9519_n ) capacitor c=0.00487887f \
 //x=69.315 //y=4.64 //x2=70.79 //y2=4.76
cc_5722 ( N_noxref_18_c_8258_p N_noxref_20_c_9519_n ) capacitor c=0.00414268f \
 //x=69.31 //y=4.62 //x2=70.79 //y2=4.76
cc_5723 ( N_noxref_18_c_8259_p N_noxref_20_c_9519_n ) capacitor c=5.58186e-19 \
 //x=69.31 //y=4.885 //x2=70.79 //y2=4.76
cc_5724 ( N_noxref_18_c_8177_p N_noxref_20_c_9524_n ) capacitor c=0.00234682f \
 //x=69.31 //y=4.475 //x2=72.27 //y2=4.755
cc_5725 ( N_noxref_18_c_8177_p N_noxref_20_c_9525_n ) capacitor c=0.00261642f \
 //x=69.31 //y=4.475 //x2=70.79 //y2=3.14
cc_5726 ( N_noxref_18_c_7986_n N_noxref_20_c_9455_n ) capacitor c=0.0253878f \
 //x=60.06 //y=3.705 //x2=56.2 //y2=3.125
cc_5727 ( N_noxref_18_c_7988_n N_noxref_20_c_9455_n ) capacitor c=0.00353442f \
 //x=60.06 //y=4.025 //x2=56.2 //y2=3.125
cc_5728 ( N_noxref_18_c_8049_n N_noxref_20_c_9455_n ) capacitor c=0.0278529f \
 //x=64.13 //y=3.73 //x2=56.2 //y2=3.125
cc_5729 ( N_noxref_18_c_8135_n N_noxref_20_c_9455_n ) capacitor c=0.00481569f \
 //x=64.13 //y=4.05 //x2=56.2 //y2=3.125
cc_5730 ( N_noxref_18_c_8144_n N_noxref_20_c_9455_n ) capacitor c=0.0292754f \
 //x=65.61 //y=3.73 //x2=56.2 //y2=3.125
cc_5731 ( N_noxref_18_c_8182_p N_noxref_20_c_9455_n ) capacitor c=0.004408f \
 //x=65.61 //y=4.05 //x2=56.2 //y2=3.125
cc_5732 ( N_noxref_18_c_8176_p N_noxref_20_c_9455_n ) capacitor c=0.00270802f \
 //x=69.31 //y=2.385 //x2=56.2 //y2=3.125
cc_5733 ( N_noxref_18_c_8177_p N_noxref_20_c_9455_n ) capacitor c=0.0363854f \
 //x=69.31 //y=4.475 //x2=56.2 //y2=3.125
cc_5734 ( N_noxref_18_c_8193_p N_noxref_20_c_9455_n ) capacitor c=0.00126945f \
 //x=65.61 //y=4.62 //x2=56.2 //y2=3.125
cc_5735 ( N_noxref_18_c_8065_n N_noxref_20_c_9455_n ) capacitor c=0.150761f \
 //x=63.005 //y=3.88 //x2=56.2 //y2=3.125
cc_5736 ( N_noxref_18_c_8163_n N_noxref_20_c_9455_n ) capacitor c=0.027873f \
 //x=64.28 //y=3.88 //x2=56.2 //y2=3.125
cc_5737 ( N_noxref_18_c_8195_p N_noxref_20_c_9455_n ) capacitor c=6.15048e-19 \
 //x=65.775 //y=4.62 //x2=56.2 //y2=3.125
cc_5738 ( N_noxref_18_c_8003_n N_noxref_20_c_9455_n ) capacitor c=0.0161295f \
 //x=60.22 //y=3.865 //x2=56.2 //y2=3.125
cc_5739 ( N_noxref_18_c_8185_p N_noxref_20_c_9455_n ) capacitor c=0.0153494f \
 //x=65.605 //y=3.89 //x2=56.2 //y2=3.125
cc_5740 ( N_noxref_18_c_8213_p N_noxref_20_c_9455_n ) capacitor c=0.0532595f \
 //x=65.445 //y=3.89 //x2=56.2 //y2=3.125
cc_5741 ( N_noxref_18_c_8189_p N_noxref_20_c_9455_n ) capacitor c=0.0291457f \
 //x=69.155 //y=4.64 //x2=56.2 //y2=3.125
cc_5742 ( N_noxref_18_c_8176_p N_noxref_20_c_9542_n ) capacitor c=0.00564826f \
 //x=69.31 //y=2.385 //x2=70.955 //y2=2.27
cc_5743 ( N_noxref_18_c_8177_p N_noxref_20_c_9542_n ) capacitor c=8.70657e-19 \
 //x=69.31 //y=4.475 //x2=70.955 //y2=2.27
cc_5744 ( N_noxref_18_c_8176_p N_noxref_20_c_9544_n ) capacitor c=0.00362942f \
 //x=69.31 //y=2.385 //x2=70.79 //y2=2.26
cc_5745 ( N_noxref_18_c_8177_p N_noxref_20_c_9544_n ) capacitor c=3.10803e-19 \
 //x=69.31 //y=4.475 //x2=70.79 //y2=2.26
cc_5746 ( N_noxref_18_c_8252_p N_noxref_20_c_9544_n ) capacitor c=3.19688e-19 \
 //x=69.31 //y=2.26 //x2=70.79 //y2=2.26
cc_5747 ( N_noxref_18_c_8283_p N_noxref_20_c_9544_n ) capacitor c=2.35599e-19 \
 //x=69.115 //y=2.095 //x2=70.79 //y2=2.26
cc_5748 ( N_noxref_18_c_8194_p N_noxref_20_c_9548_n ) capacitor c=5.34267e-19 \
 //x=69.31 //y=4.62 //x2=70.79 //y2=4.885
cc_5749 ( N_noxref_18_c_8258_p N_noxref_20_c_9548_n ) capacitor c=8.5191e-19 \
 //x=69.31 //y=4.62 //x2=70.79 //y2=4.885
cc_5750 ( N_noxref_18_c_8259_p N_noxref_20_c_9548_n ) capacitor c=2.35599e-19 \
 //x=69.31 //y=4.885 //x2=70.79 //y2=4.885
cc_5751 ( N_noxref_18_M128_noxref_g N_noxref_20_M130_noxref_g ) capacitor \
 c=0.00948424f //x=69.2 //y=6.205 //x2=70.08 //y2=6.205
cc_5752 ( N_noxref_18_M129_noxref_g N_noxref_20_M130_noxref_g ) capacitor \
 c=0.0638434f //x=69.64 //y=6.205 //x2=70.08 //y2=6.205
cc_5753 ( N_noxref_18_M129_noxref_g N_noxref_20_M131_noxref_g ) capacitor \
 c=0.00878567f //x=69.64 //y=6.205 //x2=70.52 //y2=6.205
cc_5754 ( N_noxref_18_c_8290_p N_noxref_20_c_9554_n ) capacitor c=4.86545e-19 \
 //x=69.115 //y=1.045 //x2=70.085 //y2=1.085
cc_5755 ( N_noxref_18_c_8291_p N_noxref_20_c_9554_n ) capacitor c=0.00152104f \
 //x=69.115 //y=1.39 //x2=70.085 //y2=1.085
cc_5756 ( N_noxref_18_c_8292_p N_noxref_20_c_9554_n ) capacitor c=0.0159151f \
 //x=69.645 //y=1.045 //x2=70.085 //y2=1.085
cc_5757 ( N_noxref_18_c_8293_p N_noxref_20_c_9557_n ) capacitor c=0.00109982f \
 //x=69.115 //y=1.7 //x2=70.085 //y2=1.43
cc_5758 ( N_noxref_18_c_8294_p N_noxref_20_c_9557_n ) capacitor c=0.0158526f \
 //x=69.645 //y=1.39 //x2=70.085 //y2=1.43
cc_5759 ( N_noxref_18_c_8258_p N_noxref_20_c_9559_n ) capacitor c=0.00110488f \
 //x=69.31 //y=4.62 //x2=70.155 //y2=4.975
cc_5760 ( N_noxref_18_c_8259_p N_noxref_20_c_9559_n ) capacitor c=0.064577f \
 //x=69.31 //y=4.885 //x2=70.155 //y2=4.975
cc_5761 ( N_noxref_18_c_8258_p N_noxref_20_c_9561_n ) capacitor c=2.35599e-19 \
 //x=69.31 //y=4.62 //x2=70.52 //y2=5.05
cc_5762 ( N_noxref_18_c_8259_p N_noxref_20_c_9561_n ) capacitor c=5.35364e-19 \
 //x=69.31 //y=4.885 //x2=70.52 //y2=5.05
cc_5763 ( N_noxref_18_c_8292_p N_noxref_20_c_9563_n ) capacitor c=0.00124821f \
 //x=69.645 //y=1.045 //x2=70.615 //y2=1.085
cc_5764 ( N_noxref_18_c_8294_p N_noxref_20_c_9564_n ) capacitor c=0.00150765f \
 //x=69.645 //y=1.39 //x2=70.615 //y2=1.43
cc_5765 ( N_noxref_18_c_8294_p N_noxref_20_c_9565_n ) capacitor c=4.38654e-19 \
 //x=69.645 //y=1.39 //x2=70.615 //y2=1.74
cc_5766 ( N_noxref_18_c_8252_p N_noxref_20_c_9566_n ) capacitor c=2.35599e-19 \
 //x=69.31 //y=2.26 //x2=70.615 //y2=2.095
cc_5767 ( N_noxref_18_c_8283_p N_noxref_20_c_9566_n ) capacitor c=4.61972e-19 \
 //x=69.115 //y=2.095 //x2=70.615 //y2=2.095
cc_5768 ( N_noxref_18_c_8047_n N_noxref_21_c_9900_n ) capacitor c=0.00116093f \
 //x=63.69 //y=1.75 //x2=67.02 //y2=1.36
cc_5769 ( N_noxref_18_c_8064_n N_noxref_21_c_9900_n ) capacitor c=2.97884e-19 \
 //x=63.69 //y=1.18 //x2=67.02 //y2=1.36
cc_5770 ( N_noxref_18_c_8176_p N_noxref_21_c_9902_n ) capacitor c=0.0079892f \
 //x=69.31 //y=2.385 //x2=70.22 //y2=1.405
cc_5771 ( N_noxref_18_c_8291_p N_noxref_21_c_9902_n ) capacitor c=0.00242807f \
 //x=69.115 //y=1.39 //x2=70.22 //y2=1.405
cc_5772 ( N_noxref_18_c_8293_p N_noxref_21_c_9902_n ) capacitor c=0.0014011f \
 //x=69.115 //y=1.7 //x2=70.22 //y2=1.405
cc_5773 ( N_noxref_18_c_8294_p N_noxref_21_c_9902_n ) capacitor c=0.00372011f \
 //x=69.645 //y=1.39 //x2=70.22 //y2=1.405
cc_5774 ( N_noxref_18_c_8046_n N_VDD_c_10241_n ) capacitor c=0.00648267f \
 //x=63.535 //y=5.38 //x2=65.575 //y2=7.585
cc_5775 ( N_noxref_18_c_8127_n N_VDD_c_10241_n ) capacitor c=0.00492582f \
 //x=64.045 //y=5.38 //x2=65.575 //y2=7.585
cc_5776 ( N_noxref_18_c_8135_n N_VDD_c_10241_n ) capacitor c=4.58465e-19 \
 //x=64.13 //y=4.05 //x2=65.575 //y2=7.585
cc_5777 ( N_noxref_18_c_8182_p N_VDD_c_10241_n ) capacitor c=2.76064e-19 \
 //x=65.61 //y=4.05 //x2=65.575 //y2=7.585
cc_5778 ( N_noxref_18_c_8055_n N_VDD_c_10241_n ) capacitor c=0.0035487f \
 //x=62.77 //y=5.56 //x2=65.575 //y2=7.585
cc_5779 ( N_noxref_18_c_8146_n N_VDD_c_10241_n ) capacitor c=8.42623e-19 \
 //x=63.65 //y=5.38 //x2=65.575 //y2=7.585
cc_5780 ( N_noxref_18_c_8316_p N_VDD_c_10241_n ) capacitor c=0.00285853f \
 //x=63.65 //y=5.56 //x2=65.575 //y2=7.585
cc_5781 ( N_noxref_18_c_8193_p N_VDD_c_10241_n ) capacitor c=2.8981e-19 \
 //x=65.61 //y=4.62 //x2=65.575 //y2=7.585
cc_5782 ( N_noxref_18_c_8073_n N_VDD_c_10241_n ) capacitor c=0.00224881f \
 //x=62.77 //y=5.56 //x2=65.575 //y2=7.585
cc_5783 ( N_noxref_18_c_8165_n N_VDD_c_10241_n ) capacitor c=0.00224881f \
 //x=63.65 //y=5.56 //x2=65.575 //y2=7.585
cc_5784 ( N_noxref_18_M124_noxref_g N_VDD_c_11275_n ) capacitor c=0.00374549f \
 //x=65.88 //y=6.205 //x2=65.66 //y2=7.035
cc_5785 ( N_noxref_18_M124_noxref_g N_VDD_c_11276_n ) capacitor c=0.00441594f \
 //x=65.88 //y=6.205 //x2=65.66 //y2=7.41
cc_5786 ( N_noxref_18_M125_noxref_g N_VDD_c_11277_n ) capacitor c=0.00123273f \
 //x=66.32 //y=6.205 //x2=66.54 //y2=7.035
cc_5787 ( N_noxref_18_M125_noxref_g N_VDD_c_11278_n ) capacitor c=0.00137209f \
 //x=66.32 //y=6.205 //x2=66.54 //y2=7.41
cc_5788 ( N_noxref_18_M118_noxref_g N_VDD_c_11140_n ) capacitor c=0.00697352f \
 //x=60.1 //y=6.2 //x2=60.675 //y2=7.585
cc_5789 ( N_noxref_18_M119_noxref_g N_VDD_c_11140_n ) capacitor c=0.00755544f \
 //x=60.54 //y=6.2 //x2=60.675 //y2=7.585
cc_5790 ( N_noxref_18_c_8046_n N_VDD_c_11146_n ) capacitor c=0.00208087f \
 //x=63.535 //y=5.38 //x2=63.125 //y2=7.585
cc_5791 ( N_noxref_18_c_8055_n N_VDD_c_11146_n ) capacitor c=9.41185e-19 \
 //x=62.77 //y=5.56 //x2=63.125 //y2=7.585
cc_5792 ( N_noxref_18_c_8073_n N_VDD_c_11146_n ) capacitor c=0.0136705f \
 //x=62.77 //y=5.56 //x2=63.125 //y2=7.585
cc_5793 ( N_noxref_18_c_8046_n N_VDD_c_11205_n ) capacitor c=0.00180737f \
 //x=63.535 //y=5.38 //x2=64.005 //y2=7.585
cc_5794 ( N_noxref_18_c_8127_n N_VDD_c_11205_n ) capacitor c=0.00208087f \
 //x=64.045 //y=5.38 //x2=64.005 //y2=7.585
cc_5795 ( N_noxref_18_c_8146_n N_VDD_c_11205_n ) capacitor c=4.23719e-19 \
 //x=63.65 //y=5.38 //x2=64.005 //y2=7.585
cc_5796 ( N_noxref_18_c_8316_p N_VDD_c_11205_n ) capacitor c=5.77976e-19 \
 //x=63.65 //y=5.56 //x2=64.005 //y2=7.585
cc_5797 ( N_noxref_18_c_8165_n N_VDD_c_11205_n ) capacitor c=0.0136705f \
 //x=63.65 //y=5.56 //x2=64.005 //y2=7.585
cc_5798 ( N_noxref_18_c_8193_p N_VDD_c_11289_n ) capacitor c=5.35585e-19 \
 //x=65.61 //y=4.62 //x2=68.03 //y2=7.585
cc_5799 ( N_noxref_18_M124_noxref_g N_VDD_c_11289_n ) capacitor c=0.00778439f \
 //x=65.88 //y=6.205 //x2=68.03 //y2=7.585
cc_5800 ( N_noxref_18_M125_noxref_g N_VDD_c_11289_n ) capacitor c=0.00778439f \
 //x=66.32 //y=6.205 //x2=68.03 //y2=7.585
cc_5801 ( N_noxref_18_c_8258_p N_VDD_c_11292_n ) capacitor c=2.11259e-19 \
 //x=69.31 //y=4.62 //x2=71.36 //y2=7.585
cc_5802 ( N_noxref_18_M128_noxref_g N_VDD_c_11292_n ) capacitor c=0.00763665f \
 //x=69.2 //y=6.205 //x2=71.36 //y2=7.585
cc_5803 ( N_noxref_18_M129_noxref_g N_VDD_c_11292_n ) capacitor c=0.00782837f \
 //x=69.64 //y=6.205 //x2=71.36 //y2=7.585
cc_5804 ( N_noxref_18_c_8051_n N_VDD_c_11153_n ) capacitor c=0.0013228f \
 //x=64.13 //y=5.295 //x2=61.54 //y2=7.585
cc_5805 ( N_noxref_18_c_8055_n N_VDD_c_11153_n ) capacitor c=4.91377e-19 \
 //x=62.77 //y=5.56 //x2=61.54 //y2=7.585
cc_5806 ( N_noxref_18_c_8010_n N_VDD_c_11153_n ) capacitor c=0.00190423f \
 //x=60.09 //y=4.88 //x2=61.54 //y2=7.585
cc_5807 ( N_noxref_18_c_8073_n N_VDD_c_11153_n ) capacitor c=0.0064135f \
 //x=62.77 //y=5.56 //x2=61.54 //y2=7.585
cc_5808 ( N_noxref_18_c_8090_n N_VDD_c_11153_n ) capacitor c=0.0129149f \
 //x=60.465 //y=4.97 //x2=61.54 //y2=7.585
cc_5809 ( N_noxref_18_c_8051_n N_VDD_c_11233_n ) capacitor c=0.0298637f \
 //x=64.13 //y=5.295 //x2=64.87 //y2=7.585
cc_5810 ( N_noxref_18_c_8187_p N_VDD_c_11233_n ) capacitor c=0.00364769f \
 //x=65.61 //y=4.46 //x2=64.87 //y2=7.585
cc_5811 ( N_noxref_18_c_8146_n N_VDD_c_11233_n ) capacitor c=0.00240666f \
 //x=63.65 //y=5.38 //x2=64.87 //y2=7.585
cc_5812 ( N_noxref_18_c_8316_p N_VDD_c_11233_n ) capacitor c=4.09141e-19 \
 //x=63.65 //y=5.56 //x2=64.87 //y2=7.585
cc_5813 ( N_noxref_18_c_8193_p N_VDD_c_11233_n ) capacitor c=0.00528862f \
 //x=65.61 //y=4.62 //x2=64.87 //y2=7.585
cc_5814 ( N_noxref_18_c_8213_p N_VDD_c_11233_n ) capacitor c=0.00643448f \
 //x=65.445 //y=3.89 //x2=64.87 //y2=7.585
cc_5815 ( N_noxref_18_c_8165_n N_VDD_c_11233_n ) capacitor c=0.0101445f \
 //x=63.65 //y=5.56 //x2=64.87 //y2=7.585
cc_5816 ( N_noxref_18_c_8198_p N_VDD_c_11233_n ) capacitor c=0.0179701f \
 //x=65.61 //y=4.62 //x2=64.87 //y2=7.585
cc_5817 ( N_noxref_18_M124_noxref_g N_VDD_c_11233_n ) capacitor c=0.00973553f \
 //x=65.88 //y=6.205 //x2=64.87 //y2=7.585
cc_5818 ( N_noxref_18_c_8200_p N_VDD_c_11233_n ) capacitor c=0.00774458f \
 //x=65.955 //y=4.975 //x2=64.87 //y2=7.585
cc_5819 ( N_noxref_18_c_8177_p N_VDD_c_11310_n ) capacitor c=0.00285166f \
 //x=69.31 //y=4.475 //x2=68.2 //y2=7.585
cc_5820 ( N_noxref_18_c_8194_p N_VDD_c_11310_n ) capacitor c=0.00331684f \
 //x=69.31 //y=4.62 //x2=68.2 //y2=7.585
cc_5821 ( N_noxref_18_c_8189_p N_VDD_c_11310_n ) capacitor c=0.0167947f \
 //x=69.155 //y=4.64 //x2=68.2 //y2=7.585
cc_5822 ( N_noxref_18_c_8198_p N_VDD_c_11310_n ) capacitor c=0.00117386f \
 //x=65.61 //y=4.62 //x2=68.2 //y2=7.585
cc_5823 ( N_noxref_18_c_8258_p N_VDD_c_11310_n ) capacitor c=0.0104424f \
 //x=69.31 //y=4.62 //x2=68.2 //y2=7.585
cc_5824 ( N_noxref_18_c_8259_p N_VDD_c_11310_n ) capacitor c=0.0137051f \
 //x=69.31 //y=4.885 //x2=68.2 //y2=7.585
cc_5825 ( N_noxref_18_c_8258_p N_VDD_c_11316_n ) capacitor c=0.00221916f \
 //x=69.31 //y=4.62 //x2=71.53 //y2=7.585
cc_5826 ( N_noxref_18_M118_noxref_g N_VDD_M117_noxref_d ) capacitor \
 c=0.015318f //x=60.1 //y=6.2 //x2=59.735 //y2=5.2
cc_5827 ( N_noxref_18_c_8029_n N_VDD_M117_noxref_d ) capacitor c=3.32552e-19 \
 //x=60.09 //y=4.88 //x2=59.735 //y2=5.2
cc_5828 ( N_noxref_18_M119_noxref_g N_VDD_M119_noxref_d ) capacitor \
 c=0.0430452f //x=60.54 //y=6.2 //x2=60.615 //y2=5.2
cc_5829 ( N_noxref_18_c_8055_n N_VDD_M120_noxref_s ) capacitor c=0.0572211f \
 //x=62.77 //y=5.56 //x2=62.195 //y2=5.2
cc_5830 ( N_noxref_18_c_8146_n N_VDD_M120_noxref_s ) capacitor c=6.52457e-19 \
 //x=63.65 //y=5.38 //x2=62.195 //y2=5.2
cc_5831 ( N_noxref_18_c_8073_n N_VDD_M120_noxref_s ) capacitor c=0.0886845f \
 //x=62.77 //y=5.56 //x2=62.195 //y2=5.2
cc_5832 ( N_noxref_18_c_8046_n N_VDD_M121_noxref_d ) capacitor c=0.00734094f \
 //x=63.535 //y=5.38 //x2=63.065 //y2=5.2
cc_5833 ( N_noxref_18_c_8055_n N_VDD_M121_noxref_d ) capacitor c=0.0043528f \
 //x=62.77 //y=5.56 //x2=63.065 //y2=5.2
cc_5834 ( N_noxref_18_c_8316_p N_VDD_M121_noxref_d ) capacitor c=0.0043528f \
 //x=63.65 //y=5.56 //x2=63.065 //y2=5.2
cc_5835 ( N_noxref_18_c_8073_n N_VDD_M121_noxref_d ) capacitor c=0.0654251f \
 //x=62.77 //y=5.56 //x2=63.065 //y2=5.2
cc_5836 ( N_noxref_18_c_8165_n N_VDD_M121_noxref_d ) capacitor c=0.0653541f \
 //x=63.65 //y=5.56 //x2=63.065 //y2=5.2
cc_5837 ( N_noxref_18_c_8127_n N_VDD_M123_noxref_d ) capacitor c=0.00898356f \
 //x=64.045 //y=5.38 //x2=63.945 //y2=5.2
cc_5838 ( N_noxref_18_c_8316_p N_VDD_M123_noxref_d ) capacitor c=0.00979407f \
 //x=63.65 //y=5.56 //x2=63.945 //y2=5.2
cc_5839 ( N_noxref_18_c_8156_n N_VDD_M123_noxref_d ) capacitor c=0.00122238f \
 //x=64.13 //y=3.88 //x2=63.945 //y2=5.2
cc_5840 ( N_noxref_18_c_8165_n N_VDD_M123_noxref_d ) capacitor c=0.0651808f \
 //x=63.65 //y=5.56 //x2=63.945 //y2=5.2
cc_5841 ( N_noxref_18_c_8127_n N_VDD_M124_noxref_s ) capacitor c=0.0030269f \
 //x=64.045 //y=5.38 //x2=65.525 //y2=5.205
cc_5842 ( N_noxref_18_c_8146_n N_VDD_M124_noxref_s ) capacitor c=0.00519954f \
 //x=63.65 //y=5.38 //x2=65.525 //y2=5.205
cc_5843 ( N_noxref_18_c_8316_p N_VDD_M124_noxref_s ) capacitor c=3.28075e-19 \
 //x=63.65 //y=5.56 //x2=65.525 //y2=5.205
cc_5844 ( N_noxref_18_c_8193_p N_VDD_M124_noxref_s ) capacitor c=0.0165048f \
 //x=65.61 //y=4.62 //x2=65.525 //y2=5.205
cc_5845 ( N_noxref_18_c_8195_p N_VDD_M124_noxref_s ) capacitor c=0.00180521f \
 //x=65.775 //y=4.62 //x2=65.525 //y2=5.205
cc_5846 ( N_noxref_18_c_8198_p N_VDD_M124_noxref_s ) capacitor c=0.0122195f \
 //x=65.61 //y=4.62 //x2=65.525 //y2=5.205
cc_5847 ( N_noxref_18_M124_noxref_g N_VDD_M124_noxref_s ) capacitor \
 c=0.0510401f //x=65.88 //y=6.205 //x2=65.525 //y2=5.205
cc_5848 ( N_noxref_18_c_8200_p N_VDD_M124_noxref_s ) capacitor c=0.00621646f \
 //x=65.955 //y=4.975 //x2=65.525 //y2=5.205
cc_5849 ( N_noxref_18_M125_noxref_g N_VDD_M125_noxref_d ) capacitor \
 c=0.0127979f //x=66.32 //y=6.205 //x2=66.395 //y2=5.205
cc_5850 ( N_noxref_18_c_8189_p N_noxref_27_c_12022_n ) capacitor c=0.00314988f \
 //x=69.155 //y=4.64 //x2=66.865 //y2=5.39
cc_5851 ( N_noxref_18_M125_noxref_g N_noxref_27_c_12022_n ) capacitor \
 c=0.00962216f //x=66.32 //y=6.205 //x2=66.865 //y2=5.39
cc_5852 ( N_noxref_18_c_8194_p N_noxref_27_c_12024_n ) capacitor c=0.00378061f \
 //x=69.31 //y=4.62 //x2=68.865 //y2=5.39
cc_5853 ( N_noxref_18_c_8189_p N_noxref_27_c_12024_n ) capacitor c=0.0894443f \
 //x=69.155 //y=4.64 //x2=68.865 //y2=5.39
cc_5854 ( N_noxref_18_M128_noxref_g N_noxref_27_c_12024_n ) capacitor \
 c=0.00366801f //x=69.2 //y=6.205 //x2=68.865 //y2=5.39
cc_5855 ( N_noxref_18_c_8051_n N_noxref_27_c_12027_n ) capacitor c=3.80255e-19 \
 //x=64.13 //y=5.295 //x2=67.095 //y2=5.39
cc_5856 ( N_noxref_18_c_8189_p N_noxref_27_c_12027_n ) capacitor c=0.00878121f \
 //x=69.155 //y=4.64 //x2=67.095 //y2=5.39
cc_5857 ( N_noxref_18_c_8194_p N_noxref_27_c_12029_n ) capacitor c=8.16607e-19 \
 //x=69.31 //y=4.62 //x2=69.74 //y2=7.09
cc_5858 ( N_noxref_18_c_8196_p N_noxref_27_c_12029_n ) capacitor c=0.00566393f \
 //x=69.315 //y=4.64 //x2=69.74 //y2=7.09
cc_5859 ( N_noxref_18_c_8189_p N_noxref_27_c_12029_n ) capacitor c=5.18143e-19 \
 //x=69.155 //y=4.64 //x2=69.74 //y2=7.09
cc_5860 ( N_noxref_18_c_8258_p N_noxref_27_c_12029_n ) capacitor c=0.00134225f \
 //x=69.31 //y=4.62 //x2=69.74 //y2=7.09
cc_5861 ( N_noxref_18_M128_noxref_g N_noxref_27_c_12029_n ) capacitor \
 c=0.00985075f //x=69.2 //y=6.205 //x2=69.74 //y2=7.09
cc_5862 ( N_noxref_18_M129_noxref_g N_noxref_27_c_12029_n ) capacitor \
 c=0.00814026f //x=69.64 //y=6.205 //x2=69.74 //y2=7.09
cc_5863 ( N_noxref_18_c_8127_n N_noxref_27_c_12035_n ) capacitor c=7.7292e-19 \
 //x=64.045 //y=5.38 //x2=66.102 //y2=5.39
cc_5864 ( N_noxref_18_c_8146_n N_noxref_27_c_12035_n ) capacitor c=5.60834e-19 \
 //x=63.65 //y=5.38 //x2=66.102 //y2=5.39
cc_5865 ( N_noxref_18_c_8189_p N_noxref_27_c_12035_n ) capacitor c=0.0262962f \
 //x=69.155 //y=4.64 //x2=66.102 //y2=5.39
cc_5866 ( N_noxref_18_M124_noxref_g N_noxref_27_c_12035_n ) capacitor \
 c=0.0018075f //x=65.88 //y=6.205 //x2=66.102 //y2=5.39
cc_5867 ( N_noxref_18_M125_noxref_g N_noxref_27_c_12035_n ) capacitor \
 c=0.00310294f //x=66.32 //y=6.205 //x2=66.102 //y2=5.39
cc_5868 ( N_noxref_18_c_8199_p N_noxref_27_c_12035_n ) capacitor c=0.00218288f \
 //x=66.245 //y=4.975 //x2=66.102 //y2=5.39
cc_5869 ( N_noxref_18_M128_noxref_g N_noxref_27_c_12041_n ) capacitor \
 c=0.00395967f //x=69.2 //y=6.205 //x2=68.98 //y2=6.92
cc_5870 ( N_noxref_18_M129_noxref_g N_noxref_27_c_12042_n ) capacitor \
 c=0.00179771f //x=69.64 //y=6.205 //x2=69.857 //y2=7.09
cc_5871 ( N_noxref_18_M124_noxref_g N_noxref_27_c_12043_n ) capacitor \
 c=0.0161645f //x=65.88 //y=6.205 //x2=66.1 //y2=5.56
cc_5872 ( N_noxref_18_M125_noxref_g N_noxref_27_c_12043_n ) capacitor \
 c=0.0177598f //x=66.32 //y=6.205 //x2=66.1 //y2=5.56
cc_5873 ( N_noxref_18_c_8199_p N_noxref_27_c_12043_n ) capacitor c=0.00293723f \
 //x=66.245 //y=4.975 //x2=66.1 //y2=5.56
cc_5874 ( N_noxref_18_c_8189_p N_noxref_27_c_12046_n ) capacitor c=0.00371683f \
 //x=69.155 //y=4.64 //x2=66.98 //y2=5.39
cc_5875 ( N_noxref_18_c_8194_p N_noxref_27_c_12047_n ) capacitor c=8.93089e-19 \
 //x=69.31 //y=4.62 //x2=68.98 //y2=5.39
cc_5876 ( N_noxref_18_c_8189_p N_noxref_27_c_12047_n ) capacitor c=0.00277723f \
 //x=69.155 //y=4.64 //x2=68.98 //y2=5.39
cc_5877 ( N_noxref_18_M128_noxref_g N_noxref_27_c_12047_n ) capacitor \
 c=0.0503042f //x=69.2 //y=6.205 //x2=68.98 //y2=5.39
cc_5878 ( N_noxref_18_M124_noxref_g N_noxref_27_M124_noxref_d ) capacitor \
 c=0.00124621f //x=65.88 //y=6.205 //x2=65.955 //y2=5.205
cc_5879 ( N_noxref_18_M125_noxref_g N_noxref_27_M124_noxref_d ) capacitor \
 c=0.00125665f //x=66.32 //y=6.205 //x2=65.955 //y2=5.205
cc_5880 ( N_noxref_18_M129_noxref_g N_noxref_27_M129_noxref_d ) capacitor \
 c=0.0142133f //x=69.64 //y=6.205 //x2=69.715 //y2=5.205
cc_5881 ( N_noxref_18_M129_noxref_g N_noxref_28_c_12183_n ) capacitor \
 c=0.00969072f //x=69.64 //y=6.205 //x2=70.185 //y2=5.39
cc_5882 ( N_noxref_18_c_8194_p N_noxref_28_c_12184_n ) capacitor c=0.00879697f \
 //x=69.31 //y=4.62 //x2=69.42 //y2=5.39
cc_5883 ( N_noxref_18_c_8196_p N_noxref_28_c_12184_n ) capacitor c=0.00708476f \
 //x=69.315 //y=4.64 //x2=69.42 //y2=5.39
cc_5884 ( N_noxref_18_c_8258_p N_noxref_28_c_12184_n ) capacitor c=0.00212816f \
 //x=69.31 //y=4.62 //x2=69.42 //y2=5.39
cc_5885 ( N_noxref_18_M128_noxref_g N_noxref_28_c_12184_n ) capacitor \
 c=0.00349804f //x=69.2 //y=6.205 //x2=69.42 //y2=5.39
cc_5886 ( N_noxref_18_M129_noxref_g N_noxref_28_c_12184_n ) capacitor \
 c=0.00297228f //x=69.64 //y=6.205 //x2=69.42 //y2=5.39
cc_5887 ( N_noxref_18_c_8259_p N_noxref_28_c_12184_n ) capacitor c=0.00149603f \
 //x=69.31 //y=4.885 //x2=69.42 //y2=5.39
cc_5888 ( N_noxref_18_c_8194_p N_noxref_28_c_12190_n ) capacitor c=0.0012994f \
 //x=69.31 //y=4.62 //x2=69.42 //y2=5.56
cc_5889 ( N_noxref_18_c_8258_p N_noxref_28_c_12190_n ) capacitor c=0.00447469f \
 //x=69.31 //y=4.62 //x2=69.42 //y2=5.56
cc_5890 ( N_noxref_18_M128_noxref_g N_noxref_28_c_12190_n ) capacitor \
 c=0.0120591f //x=69.2 //y=6.205 //x2=69.42 //y2=5.56
cc_5891 ( N_noxref_18_M129_noxref_g N_noxref_28_c_12190_n ) capacitor \
 c=0.015288f //x=69.64 //y=6.205 //x2=69.42 //y2=5.56
cc_5892 ( N_noxref_18_c_8259_p N_noxref_28_c_12190_n ) capacitor c=0.00417478f \
 //x=69.31 //y=4.885 //x2=69.42 //y2=5.56
cc_5893 ( N_noxref_18_c_7998_n N_GND_c_12986_n ) capacitor c=0.00210951f \
 //x=60.06 //y=2.26 //x2=62.635 //y2=0.175
cc_5894 ( N_noxref_18_c_8128_n N_GND_c_13031_n ) capacitor c=0.00608539f \
 //x=64.045 //y=1.835 //x2=65.965 //y2=0.175
cc_5895 ( N_noxref_18_c_8135_n N_GND_c_13031_n ) capacitor c=2.81098e-19 \
 //x=64.13 //y=4.05 //x2=65.965 //y2=0.175
cc_5896 ( N_noxref_18_c_8174_p N_GND_c_13031_n ) capacitor c=0.00156887f \
 //x=65.61 //y=2.375 //x2=65.965 //y2=0.175
cc_5897 ( N_noxref_18_c_8182_p N_GND_c_13031_n ) capacitor c=3.04483e-19 \
 //x=65.61 //y=4.05 //x2=65.965 //y2=0.175
cc_5898 ( N_noxref_18_c_8064_n N_GND_c_13031_n ) capacitor c=0.00928865f \
 //x=63.69 //y=1.18 //x2=65.965 //y2=0.175
cc_5899 ( N_noxref_18_M38_noxref_d N_GND_c_13031_n ) capacitor c=3.01769e-19 \
 //x=63.5 //y=1.085 //x2=65.965 //y2=0.175
cc_5900 ( N_noxref_18_c_8064_n N_GND_c_13079_n ) capacitor c=0.00543286f \
 //x=63.69 //y=1.18 //x2=66.05 //y2=1.015
cc_5901 ( N_noxref_18_c_8234_p N_GND_c_13079_n ) capacitor c=0.00173845f \
 //x=65.785 //y=1.045 //x2=66.05 //y2=1.015
cc_5902 ( N_noxref_18_c_8235_p N_GND_c_13079_n ) capacitor c=0.00322563f \
 //x=65.785 //y=1.39 //x2=66.05 //y2=1.015
cc_5903 ( N_noxref_18_c_8237_p N_GND_c_13079_n ) capacitor c=3.46977e-19 \
 //x=65.785 //y=1.7 //x2=66.05 //y2=1.015
cc_5904 ( N_noxref_18_c_8440_p N_GND_c_13079_n ) capacitor c=0.00931467f \
 //x=66.16 //y=0.89 //x2=66.05 //y2=1.015
cc_5905 ( N_noxref_18_c_8441_p N_GND_c_13079_n ) capacitor c=7.91264e-19 \
 //x=66.16 //y=1.545 //x2=66.05 //y2=1.015
cc_5906 ( N_noxref_18_c_8236_p N_GND_c_13079_n ) capacitor c=0.00205853f \
 //x=66.315 //y=1.045 //x2=66.05 //y2=1.015
cc_5907 ( N_noxref_18_c_8238_p N_GND_c_13079_n ) capacitor c=0.00402706f \
 //x=66.315 //y=1.39 //x2=66.05 //y2=1.015
cc_5908 ( N_noxref_18_c_8176_p N_GND_c_13087_n ) capacitor c=0.00456909f \
 //x=69.31 //y=2.385 //x2=69.38 //y2=1.015
cc_5909 ( N_noxref_18_c_8252_p N_GND_c_13087_n ) capacitor c=4.35087e-19 \
 //x=69.31 //y=2.26 //x2=69.38 //y2=1.015
cc_5910 ( N_noxref_18_c_8290_p N_GND_c_13087_n ) capacitor c=0.00174896f \
 //x=69.115 //y=1.045 //x2=69.38 //y2=1.015
cc_5911 ( N_noxref_18_c_8291_p N_GND_c_13087_n ) capacitor c=0.00350537f \
 //x=69.115 //y=1.39 //x2=69.38 //y2=1.015
cc_5912 ( N_noxref_18_c_8293_p N_GND_c_13087_n ) capacitor c=2.39384e-19 \
 //x=69.115 //y=1.7 //x2=69.38 //y2=1.015
cc_5913 ( N_noxref_18_c_8449_p N_GND_c_13087_n ) capacitor c=0.00936969f \
 //x=69.49 //y=0.89 //x2=69.38 //y2=1.015
cc_5914 ( N_noxref_18_c_8450_p N_GND_c_13087_n ) capacitor c=0.00220551f \
 //x=69.49 //y=1.545 //x2=69.38 //y2=1.015
cc_5915 ( N_noxref_18_c_8292_p N_GND_c_13087_n ) capacitor c=0.00197829f \
 //x=69.645 //y=1.045 //x2=69.38 //y2=1.015
cc_5916 ( N_noxref_18_c_8294_p N_GND_c_13087_n ) capacitor c=0.00386809f \
 //x=69.645 //y=1.39 //x2=69.38 //y2=1.015
cc_5917 ( N_noxref_18_c_8055_n N_GND_c_12993_n ) capacitor c=7.5071e-19 \
 //x=62.77 //y=5.56 //x2=62.72 //y2=1.135
cc_5918 ( N_noxref_18_c_8064_n N_GND_c_12993_n ) capacitor c=0.0140087f \
 //x=63.69 //y=1.18 //x2=62.72 //y2=1.135
cc_5919 ( N_noxref_18_M38_noxref_d N_GND_c_12993_n ) capacitor c=2.93544e-19 \
 //x=63.5 //y=1.085 //x2=62.72 //y2=1.135
cc_5920 ( N_noxref_18_c_7998_n N_GND_c_12959_n ) capacitor c=3.77328e-19 \
 //x=60.06 //y=2.26 //x2=61.37 //y2=0.175
cc_5921 ( N_noxref_18_c_8128_n N_GND_c_13007_n ) capacitor c=7.77585e-19 \
 //x=64.045 //y=1.835 //x2=64.7 //y2=0.175
cc_5922 ( N_noxref_18_c_8234_p N_GND_c_13101_n ) capacitor c=0.00694747f \
 //x=65.785 //y=1.045 //x2=68.03 //y2=0.175
cc_5923 ( N_noxref_18_c_8290_p N_GND_c_13102_n ) capacitor c=0.00688463f \
 //x=69.115 //y=1.045 //x2=71.36 //y2=0.175
cc_5924 ( N_noxref_18_c_8049_n N_GND_c_13009_n ) capacitor c=9.32616e-19 \
 //x=64.13 //y=3.73 //x2=61.54 //y2=0.175
cc_5925 ( N_noxref_18_c_8006_n N_GND_c_13009_n ) capacitor c=0.00200922f \
 //x=60.06 //y=2.26 //x2=61.54 //y2=0.175
cc_5926 ( N_noxref_18_c_8025_n N_GND_c_13009_n ) capacitor c=0.00275184f \
 //x=60.625 //y=1.43 //x2=61.54 //y2=0.175
cc_5927 ( N_noxref_18_c_8026_n N_GND_c_13009_n ) capacitor c=2.63786e-19 \
 //x=60.06 //y=2.26 //x2=61.54 //y2=0.175
cc_5928 ( N_noxref_18_c_8047_n N_GND_c_13061_n ) capacitor c=0.00495747f \
 //x=63.69 //y=1.75 //x2=64.87 //y2=0.175
cc_5929 ( N_noxref_18_c_8128_n N_GND_c_13061_n ) capacitor c=0.0302232f \
 //x=64.045 //y=1.835 //x2=64.87 //y2=0.175
cc_5930 ( N_noxref_18_c_8174_p N_GND_c_13061_n ) capacitor c=0.00407579f \
 //x=65.61 //y=2.375 //x2=64.87 //y2=0.175
cc_5931 ( N_noxref_18_c_8144_n N_GND_c_13061_n ) capacitor c=0.0119042f \
 //x=65.61 //y=3.73 //x2=64.87 //y2=0.175
cc_5932 ( N_noxref_18_c_8178_p N_GND_c_13061_n ) capacitor c=0.00812245f \
 //x=65.61 //y=2.26 //x2=64.87 //y2=0.175
cc_5933 ( N_noxref_18_c_8237_p N_GND_c_13061_n ) capacitor c=0.0015404f \
 //x=65.785 //y=1.7 //x2=64.87 //y2=0.175
cc_5934 ( N_noxref_18_c_8240_p N_GND_c_13061_n ) capacitor c=0.00366398f \
 //x=65.785 //y=2.095 //x2=64.87 //y2=0.175
cc_5935 ( N_noxref_18_c_8179_p N_GND_c_13061_n ) capacitor c=0.00790114f \
 //x=65.61 //y=2.26 //x2=64.87 //y2=0.175
cc_5936 ( N_noxref_18_c_8176_p N_GND_c_13115_n ) capacitor c=0.00534575f \
 //x=69.31 //y=2.385 //x2=68.2 //y2=0.175
cc_5937 ( N_noxref_18_c_8177_p N_GND_c_13115_n ) capacitor c=0.00916362f \
 //x=69.31 //y=4.475 //x2=68.2 //y2=0.175
cc_5938 ( N_noxref_18_c_8252_p N_GND_c_13115_n ) capacitor c=0.0038617f \
 //x=69.31 //y=2.26 //x2=68.2 //y2=0.175
cc_5939 ( N_noxref_18_c_8283_p N_GND_c_13115_n ) capacitor c=0.00912096f \
 //x=69.115 //y=2.095 //x2=68.2 //y2=0.175
cc_5940 ( N_noxref_18_c_8064_n N_GND_M37_noxref_d ) capacitor c=2.82748e-19 \
 //x=63.69 //y=1.18 //x2=62.53 //y2=1.045
cc_5941 ( N_noxref_18_c_8234_p N_GND_M39_noxref_d ) capacitor c=0.00192399f \
 //x=65.785 //y=1.045 //x2=65.86 //y2=1.045
cc_5942 ( N_noxref_18_c_8235_p N_GND_M39_noxref_d ) capacitor c=0.00210798f \
 //x=65.785 //y=1.39 //x2=65.86 //y2=1.045
cc_5943 ( N_noxref_18_c_8440_p N_GND_M39_noxref_d ) capacitor c=0.00472259f \
 //x=66.16 //y=0.89 //x2=65.86 //y2=1.045
cc_5944 ( N_noxref_18_c_8441_p N_GND_M39_noxref_d ) capacitor c=0.00166857f \
 //x=66.16 //y=1.545 //x2=65.86 //y2=1.045
cc_5945 ( N_noxref_18_c_8236_p N_GND_M39_noxref_d ) capacitor c=0.00230174f \
 //x=66.315 //y=1.045 //x2=65.86 //y2=1.045
cc_5946 ( N_noxref_18_c_8238_p N_GND_M39_noxref_d ) capacitor c=0.00210798f \
 //x=66.315 //y=1.39 //x2=65.86 //y2=1.045
cc_5947 ( N_noxref_18_c_8176_p N_GND_M41_noxref_d ) capacitor c=4.20217e-19 \
 //x=69.31 //y=2.385 //x2=69.19 //y2=1.045
cc_5948 ( N_noxref_18_c_8290_p N_GND_M41_noxref_d ) capacitor c=0.00192399f \
 //x=69.115 //y=1.045 //x2=69.19 //y2=1.045
cc_5949 ( N_noxref_18_c_8291_p N_GND_M41_noxref_d ) capacitor c=0.00228784f \
 //x=69.115 //y=1.39 //x2=69.19 //y2=1.045
cc_5950 ( N_noxref_18_c_8449_p N_GND_M41_noxref_d ) capacitor c=0.0047434f \
 //x=69.49 //y=0.89 //x2=69.19 //y2=1.045
cc_5951 ( N_noxref_18_c_8450_p N_GND_M41_noxref_d ) capacitor c=0.00172481f \
 //x=69.49 //y=1.545 //x2=69.19 //y2=1.045
cc_5952 ( N_noxref_18_c_8292_p N_GND_M41_noxref_d ) capacitor c=0.00230174f \
 //x=69.645 //y=1.045 //x2=69.19 //y2=1.045
cc_5953 ( N_noxref_18_c_8294_p N_GND_M41_noxref_d ) capacitor c=0.00228784f \
 //x=69.645 //y=1.39 //x2=69.19 //y2=1.045
cc_5954 ( N_noxref_18_c_7988_n N_noxref_47_c_15053_n ) capacitor c=4.28783e-19 \
 //x=60.06 //y=4.025 //x2=59.875 //y2=1.675
cc_5955 ( N_noxref_18_c_7998_n N_noxref_47_c_15053_n ) capacitor c=7.50092e-19 \
 //x=60.06 //y=2.26 //x2=59.875 //y2=1.675
cc_5956 ( N_noxref_18_c_8021_n N_noxref_47_c_15053_n ) capacitor c=0.00888238f \
 //x=60.095 //y=1.74 //x2=59.875 //y2=1.675
cc_5957 ( N_noxref_18_c_8026_n N_noxref_47_c_15053_n ) capacitor c=0.00175171f \
 //x=60.06 //y=2.26 //x2=59.875 //y2=1.675
cc_5958 ( N_noxref_18_c_7988_n N_noxref_47_c_15058_n ) capacitor c=2.38469e-19 \
 //x=60.06 //y=4.025 //x2=60.76 //y2=0.71
cc_5959 ( N_noxref_18_c_7998_n N_noxref_47_c_15058_n ) capacitor c=0.001463f \
 //x=60.06 //y=2.26 //x2=60.76 //y2=0.71
cc_5960 ( N_noxref_18_c_8006_n N_noxref_47_c_15058_n ) capacitor c=8.82141e-19 \
 //x=60.06 //y=2.26 //x2=60.76 //y2=0.71
cc_5961 ( N_noxref_18_c_8016_n N_noxref_47_c_15058_n ) capacitor c=0.0200738f \
 //x=60.095 //y=1.085 //x2=60.76 //y2=0.71
cc_5962 ( N_noxref_18_c_8024_n N_noxref_47_c_15058_n ) capacitor c=0.00825432f \
 //x=60.625 //y=1.085 //x2=60.76 //y2=0.71
cc_5963 ( N_noxref_18_c_8026_n N_noxref_47_c_15058_n ) capacitor c=2.1838e-19 \
 //x=60.06 //y=2.26 //x2=60.76 //y2=0.71
cc_5964 ( N_noxref_18_c_8016_n N_noxref_47_M35_noxref_s ) capacitor \
 c=0.00888238f //x=60.095 //y=1.085 //x2=58.77 //y2=0.545
cc_5965 ( N_noxref_18_c_8024_n N_noxref_47_M35_noxref_s ) capacitor \
 c=0.015333f //x=60.625 //y=1.085 //x2=58.77 //y2=0.545
cc_5966 ( N_noxref_18_c_8025_n N_noxref_47_M35_noxref_s ) capacitor \
 c=0.00248746f //x=60.625 //y=1.43 //x2=58.77 //y2=0.545
cc_5967 ( N_noxref_18_c_8048_n N_noxref_48_c_15123_n ) capacitor c=0.00911498f \
 //x=63.775 //y=1.835 //x2=63.205 //y2=1.675
cc_5968 ( N_noxref_18_c_8128_n N_noxref_48_c_15131_n ) capacitor c=0.00399245f \
 //x=64.045 //y=1.835 //x2=64.09 //y2=0.71
cc_5969 ( N_noxref_18_c_8064_n N_noxref_48_c_15131_n ) capacitor c=0.003751f \
 //x=63.69 //y=1.18 //x2=64.09 //y2=0.71
cc_5970 ( N_noxref_18_M38_noxref_d N_noxref_48_c_15131_n ) capacitor \
 c=0.00910163f //x=63.5 //y=1.085 //x2=64.09 //y2=0.71
cc_5971 ( N_noxref_18_c_8047_n N_noxref_48_M37_noxref_s ) capacitor \
 c=0.0162238f //x=63.69 //y=1.75 //x2=62.1 //y2=0.545
cc_5972 ( N_noxref_18_c_8128_n N_noxref_48_M37_noxref_s ) capacitor \
 c=0.00670006f //x=64.045 //y=1.835 //x2=62.1 //y2=0.545
cc_5973 ( N_noxref_18_c_8135_n N_noxref_48_M37_noxref_s ) capacitor \
 c=3.19088e-19 //x=64.13 //y=4.05 //x2=62.1 //y2=0.545
cc_5974 ( N_noxref_18_c_8064_n N_noxref_48_M37_noxref_s ) capacitor \
 c=0.00906186f //x=63.69 //y=1.18 //x2=62.1 //y2=0.545
cc_5975 ( N_noxref_18_c_8156_n N_noxref_48_M37_noxref_s ) capacitor \
 c=8.42257e-19 //x=64.13 //y=3.88 //x2=62.1 //y2=0.545
cc_5976 ( N_noxref_18_M38_noxref_d N_noxref_48_M37_noxref_s ) capacitor \
 c=0.0275552f //x=63.5 //y=1.085 //x2=62.1 //y2=0.545
cc_5977 ( N_noxref_18_c_8174_p N_noxref_49_c_15184_n ) capacitor c=0.0033606f \
 //x=65.61 //y=2.375 //x2=65.565 //y2=1.675
cc_5978 ( N_noxref_18_c_8178_p N_noxref_49_c_15184_n ) capacitor c=0.00844774f \
 //x=65.61 //y=2.26 //x2=65.565 //y2=1.675
cc_5979 ( N_noxref_18_c_8240_p N_noxref_49_c_15184_n ) capacitor c=0.00262672f \
 //x=65.785 //y=2.095 //x2=65.565 //y2=1.675
cc_5980 ( N_noxref_18_c_8179_p N_noxref_49_c_15184_n ) capacitor c=0.0079898f \
 //x=65.61 //y=2.26 //x2=65.565 //y2=1.675
cc_5981 ( N_noxref_18_c_8174_p N_noxref_49_c_15188_n ) capacitor c=0.00202154f \
 //x=65.61 //y=2.375 //x2=66.45 //y2=1.76
cc_5982 ( N_noxref_18_c_8182_p N_noxref_49_c_15188_n ) capacitor c=9.1358e-19 \
 //x=65.61 //y=4.05 //x2=66.45 //y2=1.76
cc_5983 ( N_noxref_18_c_8193_p N_noxref_49_c_15188_n ) capacitor c=0.00197458f \
 //x=65.61 //y=4.62 //x2=66.45 //y2=1.76
cc_5984 ( N_noxref_18_c_8178_p N_noxref_49_c_15188_n ) capacitor c=0.00302338f \
 //x=65.61 //y=2.26 //x2=66.45 //y2=1.76
cc_5985 ( N_noxref_18_c_8237_p N_noxref_49_c_15188_n ) capacitor c=0.0072172f \
 //x=65.785 //y=1.7 //x2=66.45 //y2=1.76
cc_5986 ( N_noxref_18_c_8240_p N_noxref_49_c_15188_n ) capacitor c=0.0134418f \
 //x=65.785 //y=2.095 //x2=66.45 //y2=1.76
cc_5987 ( N_noxref_18_c_8441_p N_noxref_49_c_15188_n ) capacitor c=0.0094838f \
 //x=66.16 //y=1.545 //x2=66.45 //y2=1.76
cc_5988 ( N_noxref_18_c_8238_p N_noxref_49_c_15188_n ) capacitor c=0.00339872f \
 //x=66.315 //y=1.39 //x2=66.45 //y2=1.76
cc_5989 ( N_noxref_18_c_8179_p N_noxref_49_c_15188_n ) capacitor c=0.00168953f \
 //x=65.61 //y=2.26 //x2=66.45 //y2=1.76
cc_5990 ( N_noxref_18_c_8240_p N_noxref_49_c_15197_n ) capacitor c=6.71402e-19 \
 //x=65.785 //y=2.095 //x2=66.535 //y2=1.675
cc_5991 ( N_noxref_18_c_8234_p N_noxref_49_M39_noxref_s ) capacitor \
 c=0.0294925f //x=65.785 //y=1.045 //x2=65.43 //y2=0.545
cc_5992 ( N_noxref_18_c_8237_p N_noxref_49_M39_noxref_s ) capacitor \
 c=0.00110192f //x=65.785 //y=1.7 //x2=65.43 //y2=0.545
cc_5993 ( N_noxref_18_c_8236_p N_noxref_49_M39_noxref_s ) capacitor \
 c=0.0125442f //x=66.315 //y=1.045 //x2=65.43 //y2=0.545
cc_5994 ( N_noxref_18_c_8283_p N_noxref_51_c_15262_n ) capacitor c=0.0034165f \
 //x=69.115 //y=2.095 //x2=68.895 //y2=1.675
cc_5995 ( N_noxref_18_c_8176_p N_noxref_51_c_15263_n ) capacitor c=0.00541004f \
 //x=69.31 //y=2.385 //x2=69.78 //y2=1.76
cc_5996 ( N_noxref_18_c_8194_p N_noxref_51_c_15263_n ) capacitor c=0.00299239f \
 //x=69.31 //y=4.62 //x2=69.78 //y2=1.76
cc_5997 ( N_noxref_18_c_8252_p N_noxref_51_c_15263_n ) capacitor c=0.00763108f \
 //x=69.31 //y=2.26 //x2=69.78 //y2=1.76
cc_5998 ( N_noxref_18_c_8293_p N_noxref_51_c_15263_n ) capacitor c=0.00688171f \
 //x=69.115 //y=1.7 //x2=69.78 //y2=1.76
cc_5999 ( N_noxref_18_c_8283_p N_noxref_51_c_15263_n ) capacitor c=0.0183998f \
 //x=69.115 //y=2.095 //x2=69.78 //y2=1.76
cc_6000 ( N_noxref_18_c_8450_p N_noxref_51_c_15263_n ) capacitor c=0.00719516f \
 //x=69.49 //y=1.545 //x2=69.78 //y2=1.76
cc_6001 ( N_noxref_18_c_8294_p N_noxref_51_c_15263_n ) capacitor c=0.0059368f \
 //x=69.645 //y=1.39 //x2=69.78 //y2=1.76
cc_6002 ( N_noxref_18_c_8283_p N_noxref_51_c_15270_n ) capacitor c=0.00122123f \
 //x=69.115 //y=2.095 //x2=69.865 //y2=1.675
cc_6003 ( N_noxref_18_c_8290_p N_noxref_51_M41_noxref_s ) capacitor \
 c=0.0303347f //x=69.115 //y=1.045 //x2=68.76 //y2=0.545
cc_6004 ( N_noxref_18_c_8293_p N_noxref_51_M41_noxref_s ) capacitor \
 c=3.48408e-19 //x=69.115 //y=1.7 //x2=68.76 //y2=0.545
cc_6005 ( N_noxref_18_c_8292_p N_noxref_51_M41_noxref_s ) capacitor \
 c=0.012348f //x=69.645 //y=1.045 //x2=68.76 //y2=0.545
cc_6006 ( N_noxref_19_c_8762_n N_noxref_20_c_9514_n ) capacitor c=6.75242e-19 \
 //x=73.235 //y=4.21 //x2=70.79 //y2=2.43
cc_6007 ( N_noxref_19_c_8721_n N_noxref_20_c_9517_n ) capacitor c=8.3401e-19 \
 //x=66.72 //y=4.045 //x2=70.79 //y2=2.98
cc_6008 ( N_noxref_19_c_8793_p N_noxref_20_c_9517_n ) capacitor c=0.00138787f \
 //x=73.38 //y=4.05 //x2=70.79 //y2=2.98
cc_6009 ( N_noxref_19_c_8762_n N_noxref_20_c_9518_n ) capacitor c=0.00252929f \
 //x=73.235 //y=4.21 //x2=70.79 //y2=3.3
cc_6010 ( N_noxref_19_c_8721_n N_noxref_20_c_9519_n ) capacitor c=2.64918e-19 \
 //x=66.72 //y=4.045 //x2=70.79 //y2=4.76
cc_6011 ( N_noxref_19_c_8731_n N_noxref_20_c_9519_n ) capacitor c=0.00166637f \
 //x=66.72 //y=4.71 //x2=70.79 //y2=4.76
cc_6012 ( N_noxref_19_c_8793_p N_noxref_20_c_9519_n ) capacitor c=5.50625e-19 \
 //x=73.38 //y=4.05 //x2=70.79 //y2=4.76
cc_6013 ( N_noxref_19_c_8798_p N_noxref_20_c_9519_n ) capacitor c=9.13182e-19 \
 //x=73.38 //y=4.74 //x2=70.79 //y2=4.76
cc_6014 ( N_noxref_19_c_8762_n N_noxref_20_c_9519_n ) capacitor c=0.0379661f \
 //x=73.235 //y=4.21 //x2=70.79 //y2=4.76
cc_6015 ( N_noxref_19_c_8800_p N_noxref_20_c_9577_n ) capacitor c=0.0061363f \
 //x=73.38 //y=2.38 //x2=72.27 //y2=2.43
cc_6016 ( N_noxref_19_c_8793_p N_noxref_20_c_9577_n ) capacitor c=0.0011922f \
 //x=73.38 //y=4.05 //x2=72.27 //y2=2.43
cc_6017 ( N_noxref_19_c_8762_n N_noxref_20_c_9577_n ) capacitor c=0.00231693f \
 //x=73.235 //y=4.21 //x2=72.27 //y2=2.43
cc_6018 ( N_noxref_19_c_8803_p N_noxref_20_c_9577_n ) capacitor c=7.58956e-19 \
 //x=73.38 //y=2.26 //x2=72.27 //y2=2.43
cc_6019 ( N_noxref_19_c_8804_p N_noxref_20_c_9577_n ) capacitor c=0.00157228f \
 //x=73.38 //y=2.26 //x2=72.27 //y2=2.43
cc_6020 ( N_noxref_19_c_8793_p N_noxref_20_c_9524_n ) capacitor c=0.0502814f \
 //x=73.38 //y=4.05 //x2=72.27 //y2=4.755
cc_6021 ( N_noxref_19_c_8806_p N_noxref_20_c_9524_n ) capacitor c=0.00771726f \
 //x=73.38 //y=4.37 //x2=72.27 //y2=4.755
cc_6022 ( N_noxref_19_c_8798_p N_noxref_20_c_9524_n ) capacitor c=0.021848f \
 //x=73.38 //y=4.74 //x2=72.27 //y2=4.755
cc_6023 ( N_noxref_19_c_8808_p N_noxref_20_c_9524_n ) capacitor c=5.15538e-19 \
 //x=73.38 //y=4.25 //x2=72.27 //y2=4.755
cc_6024 ( N_noxref_19_c_8809_p N_noxref_20_c_9524_n ) capacitor c=0.00250167f \
 //x=73.395 //y=4.21 //x2=72.27 //y2=4.755
cc_6025 ( N_noxref_19_c_8762_n N_noxref_20_c_9524_n ) capacitor c=0.0387859f \
 //x=73.235 //y=4.21 //x2=72.27 //y2=4.755
cc_6026 ( N_noxref_19_c_8811_p N_noxref_20_c_9524_n ) capacitor c=2.02321e-19 \
 //x=73.4 //y=4.885 //x2=72.27 //y2=4.755
cc_6027 ( N_noxref_19_c_8812_p N_noxref_20_c_9524_n ) capacitor c=0.00132485f \
 //x=73.4 //y=4.885 //x2=72.27 //y2=4.755
cc_6028 ( N_noxref_19_c_8546_n N_noxref_20_c_9365_n ) capacitor c=0.0249078f \
 //x=38.6 //y=4.735 //x2=46.36 //y2=3.14
cc_6029 ( N_noxref_19_c_8591_n N_noxref_20_c_9365_n ) capacitor c=0.0507203f \
 //x=49.685 //y=2.4 //x2=46.36 //y2=3.14
cc_6030 ( N_noxref_19_c_8591_n N_noxref_20_c_9422_n ) capacitor c=0.0158678f \
 //x=49.685 //y=2.4 //x2=46.96 //y2=3.125
cc_6031 ( N_noxref_19_c_8591_n N_noxref_20_c_9423_n ) capacitor c=0.00887998f \
 //x=49.685 //y=2.4 //x2=50.42 //y2=3.14
cc_6032 ( N_noxref_19_c_8645_n N_noxref_20_c_9423_n ) capacitor c=0.0366138f \
 //x=50.285 //y=2.37 //x2=50.42 //y2=3.14
cc_6033 ( N_noxref_19_c_8645_n N_noxref_20_c_9437_n ) capacitor c=0.0599907f \
 //x=50.285 //y=2.37 //x2=51.02 //y2=3.125
cc_6034 ( N_noxref_19_c_8645_n N_noxref_20_c_9441_n ) capacitor c=0.0290182f \
 //x=50.285 //y=2.37 //x2=52.27 //y2=3.14
cc_6035 ( N_noxref_19_c_8645_n N_noxref_20_c_9444_n ) capacitor c=0.039176f \
 //x=50.285 //y=2.37 //x2=52.87 //y2=3.12
cc_6036 ( N_noxref_19_c_8645_n N_noxref_20_c_9447_n ) capacitor c=0.0288832f \
 //x=50.285 //y=2.37 //x2=53.76 //y2=3.14
cc_6037 ( N_noxref_19_c_8645_n N_noxref_20_c_9448_n ) capacitor c=0.0594996f \
 //x=50.285 //y=2.37 //x2=54.36 //y2=3.125
cc_6038 ( N_noxref_19_c_8645_n N_noxref_20_c_9452_n ) capacitor c=0.0287902f \
 //x=50.285 //y=2.37 //x2=55.6 //y2=3.14
cc_6039 ( N_noxref_19_c_8715_n N_noxref_20_c_9455_n ) capacitor c=0.00193536f \
 //x=66.72 //y=2.485 //x2=56.2 //y2=3.125
cc_6040 ( N_noxref_19_c_8721_n N_noxref_20_c_9455_n ) capacitor c=0.0315741f \
 //x=66.72 //y=4.045 //x2=56.2 //y2=3.125
cc_6041 ( N_noxref_19_c_8727_n N_noxref_20_c_9455_n ) capacitor c=0.00260236f \
 //x=66.72 //y=4.365 //x2=56.2 //y2=3.125
cc_6042 ( N_noxref_19_c_8645_n N_noxref_20_c_9455_n ) capacitor c=0.475866f \
 //x=50.285 //y=2.37 //x2=56.2 //y2=3.125
cc_6043 ( N_noxref_19_c_8758_n N_noxref_20_c_9455_n ) capacitor c=0.00871941f \
 //x=66.88 //y=4.205 //x2=56.2 //y2=3.125
cc_6044 ( N_noxref_19_c_8762_n N_noxref_20_c_9455_n ) capacitor c=0.123466f \
 //x=73.235 //y=4.21 //x2=56.2 //y2=3.125
cc_6045 ( N_noxref_19_c_8762_n N_noxref_20_c_9542_n ) capacitor c=4.43015e-19 \
 //x=73.235 //y=4.21 //x2=70.955 //y2=2.27
cc_6046 ( N_noxref_19_c_8800_p N_noxref_20_c_9608_n ) capacitor c=0.00602448f \
 //x=73.38 //y=2.38 //x2=72.265 //y2=2.27
cc_6047 ( N_noxref_19_c_8793_p N_noxref_20_c_9608_n ) capacitor c=0.00107415f \
 //x=73.38 //y=4.05 //x2=72.265 //y2=2.27
cc_6048 ( N_noxref_19_c_8762_n N_noxref_20_c_9608_n ) capacitor c=0.00472291f \
 //x=73.235 //y=4.21 //x2=72.265 //y2=2.27
cc_6049 ( N_noxref_19_c_8762_n N_noxref_20_c_9611_n ) capacitor c=0.0202481f \
 //x=73.235 //y=4.21 //x2=72.105 //y2=2.27
cc_6050 ( N_noxref_19_c_8800_p N_noxref_20_c_9612_n ) capacitor c=2.06418e-19 \
 //x=73.38 //y=2.38 //x2=72.27 //y2=2.26
cc_6051 ( N_noxref_19_c_8803_p N_noxref_20_c_9612_n ) capacitor c=0.00113671f \
 //x=73.38 //y=2.26 //x2=72.27 //y2=2.26
cc_6052 ( N_noxref_19_c_8804_p N_noxref_20_c_9612_n ) capacitor c=0.00194209f \
 //x=73.38 //y=2.26 //x2=72.27 //y2=2.26
cc_6053 ( N_noxref_19_c_8798_p N_noxref_20_c_9615_n ) capacitor c=8.06413e-19 \
 //x=73.38 //y=4.74 //x2=72.27 //y2=4.885
cc_6054 ( N_noxref_19_c_8811_p N_noxref_20_c_9615_n ) capacitor c=0.00106454f \
 //x=73.4 //y=4.885 //x2=72.27 //y2=4.885
cc_6055 ( N_noxref_19_c_8812_p N_noxref_20_c_9615_n ) capacitor c=0.00167042f \
 //x=73.4 //y=4.885 //x2=72.27 //y2=4.885
cc_6056 ( N_noxref_19_M134_noxref_g N_noxref_20_M132_noxref_g ) capacitor \
 c=0.00935155f //x=73.42 //y=6.205 //x2=72.54 //y2=6.205
cc_6057 ( N_noxref_19_M134_noxref_g N_noxref_20_M133_noxref_g ) capacitor \
 c=0.111828f //x=73.42 //y=6.205 //x2=72.98 //y2=6.205
cc_6058 ( N_noxref_19_M135_noxref_g N_noxref_20_M133_noxref_g ) capacitor \
 c=0.00876656f //x=73.86 //y=6.205 //x2=72.98 //y2=6.205
cc_6059 ( N_noxref_19_c_8844_p N_noxref_20_c_9621_n ) capacitor c=4.86545e-19 \
 //x=73.415 //y=1.085 //x2=72.445 //y2=1.045
cc_6060 ( N_noxref_19_c_8844_p N_noxref_20_c_9622_n ) capacitor c=0.00152405f \
 //x=73.415 //y=1.085 //x2=72.445 //y2=1.39
cc_6061 ( N_noxref_19_c_8846_p N_noxref_20_c_9623_n ) capacitor c=0.00109722f \
 //x=73.415 //y=1.435 //x2=72.445 //y2=1.7
cc_6062 ( N_noxref_19_c_8847_p N_noxref_20_c_9623_n ) capacitor c=0.00179029f \
 //x=73.415 //y=1.74 //x2=72.445 //y2=1.7
cc_6063 ( N_noxref_19_c_8847_p N_noxref_20_c_9625_n ) capacitor c=0.00662747f \
 //x=73.415 //y=1.74 //x2=72.445 //y2=2.095
cc_6064 ( N_noxref_19_c_8798_p N_noxref_20_c_9626_n ) capacitor c=0.00125146f \
 //x=73.38 //y=4.74 //x2=72.905 //y2=4.975
cc_6065 ( N_noxref_19_c_8811_p N_noxref_20_c_9626_n ) capacitor c=0.00147609f \
 //x=73.4 //y=4.885 //x2=72.905 //y2=4.975
cc_6066 ( N_noxref_19_c_8812_p N_noxref_20_c_9626_n ) capacitor c=0.022796f \
 //x=73.4 //y=4.885 //x2=72.905 //y2=4.975
cc_6067 ( N_noxref_19_c_8798_p N_noxref_20_c_9629_n ) capacitor c=0.00103195f \
 //x=73.38 //y=4.74 //x2=72.615 //y2=4.975
cc_6068 ( N_noxref_19_c_8811_p N_noxref_20_c_9629_n ) capacitor c=0.00127381f \
 //x=73.4 //y=4.885 //x2=72.615 //y2=4.975
cc_6069 ( N_noxref_19_c_8812_p N_noxref_20_c_9629_n ) capacitor c=0.00470299f \
 //x=73.4 //y=4.885 //x2=72.615 //y2=4.975
cc_6070 ( N_noxref_19_c_8844_p N_noxref_20_c_9632_n ) capacitor c=0.0151424f \
 //x=73.415 //y=1.085 //x2=72.975 //y2=1.045
cc_6071 ( N_noxref_19_c_8856_p N_noxref_20_c_9632_n ) capacitor c=0.00130607f \
 //x=73.945 //y=1.085 //x2=72.975 //y2=1.045
cc_6072 ( N_noxref_19_c_8846_p N_noxref_20_c_9634_n ) capacitor c=0.0111013f \
 //x=73.415 //y=1.435 //x2=72.975 //y2=1.39
cc_6073 ( N_noxref_19_c_8847_p N_noxref_20_c_9634_n ) capacitor c=0.00862358f \
 //x=73.415 //y=1.74 //x2=72.975 //y2=1.39
cc_6074 ( N_noxref_19_c_8859_p N_noxref_20_c_9634_n ) capacitor c=4.75927e-19 \
 //x=73.79 //y=1.585 //x2=72.975 //y2=1.39
cc_6075 ( N_noxref_19_c_8860_p N_noxref_20_c_9634_n ) capacitor c=0.00153205f \
 //x=73.945 //y=1.435 //x2=72.975 //y2=1.39
cc_6076 ( N_noxref_19_c_8800_p N_noxref_20_c_9638_n ) capacitor c=6.73725e-19 \
 //x=73.38 //y=2.38 //x2=72.27 //y2=2.26
cc_6077 ( N_noxref_19_c_8803_p N_noxref_20_c_9638_n ) capacitor c=0.00169858f \
 //x=73.38 //y=2.26 //x2=72.27 //y2=2.26
cc_6078 ( N_noxref_19_c_8804_p N_noxref_20_c_9638_n ) capacitor c=0.00887988f \
 //x=73.38 //y=2.26 //x2=72.27 //y2=2.26
cc_6079 ( N_noxref_19_c_8806_p N_noxref_21_c_9906_n ) capacitor c=0.00435926f \
 //x=73.38 //y=4.37 //x2=73.515 //y2=5.39
cc_6080 ( N_noxref_19_c_8798_p N_noxref_21_c_9906_n ) capacitor c=0.0223378f \
 //x=73.38 //y=4.74 //x2=73.515 //y2=5.39
cc_6081 ( N_noxref_19_c_8809_p N_noxref_21_c_9906_n ) capacitor c=7.70643e-19 \
 //x=73.395 //y=4.21 //x2=73.515 //y2=5.39
cc_6082 ( N_noxref_19_c_8762_n N_noxref_21_c_9906_n ) capacitor c=0.0017832f \
 //x=73.235 //y=4.21 //x2=73.515 //y2=5.39
cc_6083 ( N_noxref_19_c_8811_p N_noxref_21_c_9906_n ) capacitor c=0.00459858f \
 //x=73.4 //y=4.885 //x2=73.515 //y2=5.39
cc_6084 ( N_noxref_19_M134_noxref_g N_noxref_21_c_9906_n ) capacitor \
 c=0.00846675f //x=73.42 //y=6.205 //x2=73.515 //y2=5.39
cc_6085 ( N_noxref_19_c_8812_p N_noxref_21_c_9906_n ) capacitor c=7.28626e-19 \
 //x=73.4 //y=4.885 //x2=73.515 //y2=5.39
cc_6086 ( N_noxref_19_c_8800_p N_noxref_21_c_9913_n ) capacitor c=0.00233055f \
 //x=73.38 //y=2.38 //x2=73.68 //y2=1.535
cc_6087 ( N_noxref_19_c_8803_p N_noxref_21_c_9913_n ) capacitor c=8.15893e-19 \
 //x=73.38 //y=2.26 //x2=73.68 //y2=1.535
cc_6088 ( N_noxref_19_c_8844_p N_noxref_21_c_9913_n ) capacitor c=5.01861e-19 \
 //x=73.415 //y=1.085 //x2=73.68 //y2=1.535
cc_6089 ( N_noxref_19_c_8846_p N_noxref_21_c_9913_n ) capacitor c=0.00397521f \
 //x=73.415 //y=1.435 //x2=73.68 //y2=1.535
cc_6090 ( N_noxref_19_c_8847_p N_noxref_21_c_9913_n ) capacitor c=0.00205332f \
 //x=73.415 //y=1.74 //x2=73.68 //y2=1.535
cc_6091 ( N_noxref_19_c_8876_p N_noxref_21_c_9913_n ) capacitor c=3.72732e-19 \
 //x=73.79 //y=0.93 //x2=73.68 //y2=1.535
cc_6092 ( N_noxref_19_c_8859_p N_noxref_21_c_9913_n ) capacitor c=0.00187911f \
 //x=73.79 //y=1.585 //x2=73.68 //y2=1.535
cc_6093 ( N_noxref_19_c_8856_p N_noxref_21_c_9913_n ) capacitor c=2.0901e-19 \
 //x=73.945 //y=1.085 //x2=73.68 //y2=1.535
cc_6094 ( N_noxref_19_c_8860_p N_noxref_21_c_9913_n ) capacitor c=0.00241403f \
 //x=73.945 //y=1.435 //x2=73.68 //y2=1.535
cc_6095 ( N_noxref_19_c_8804_p N_noxref_21_c_9913_n ) capacitor c=2.48891e-19 \
 //x=73.38 //y=2.26 //x2=73.68 //y2=1.535
cc_6096 ( N_noxref_19_c_8847_p N_noxref_21_c_9923_n ) capacitor c=0.0018678f \
 //x=73.415 //y=1.74 //x2=73.68 //y2=1.74
cc_6097 ( N_noxref_19_c_8859_p N_noxref_21_c_9923_n ) capacitor c=0.00592669f \
 //x=73.79 //y=1.585 //x2=73.68 //y2=1.74
cc_6098 ( N_noxref_19_M135_noxref_g N_noxref_21_c_9925_n ) capacitor \
 c=0.0116091f //x=73.86 //y=6.205 //x2=74.035 //y2=5.39
cc_6099 ( N_noxref_19_c_8859_p N_noxref_21_c_9926_n ) capacitor c=0.0048413f \
 //x=73.79 //y=1.585 //x2=74.035 //y2=1.825
cc_6100 ( N_noxref_19_c_8885_p N_noxref_21_c_9927_n ) capacitor c=0.00368358f \
 //x=73.38 //y=2.095 //x2=73.765 //y2=1.825
cc_6101 ( N_noxref_19_c_8800_p N_noxref_21_c_9928_n ) capacitor c=0.0146548f \
 //x=73.38 //y=2.38 //x2=74.12 //y2=4.095
cc_6102 ( N_noxref_19_c_8793_p N_noxref_21_c_9928_n ) capacitor c=0.0756865f \
 //x=73.38 //y=4.05 //x2=74.12 //y2=4.095
cc_6103 ( N_noxref_19_c_8806_p N_noxref_21_c_9928_n ) capacitor c=0.0029642f \
 //x=73.38 //y=4.37 //x2=74.12 //y2=4.095
cc_6104 ( N_noxref_19_c_8809_p N_noxref_21_c_9928_n ) capacitor c=0.00136148f \
 //x=73.395 //y=4.21 //x2=74.12 //y2=4.095
cc_6105 ( N_noxref_19_c_8803_p N_noxref_21_c_9928_n ) capacitor c=0.00137695f \
 //x=73.38 //y=2.26 //x2=74.12 //y2=4.095
cc_6106 ( N_noxref_19_c_8804_p N_noxref_21_c_9928_n ) capacitor c=0.00284078f \
 //x=73.38 //y=2.26 //x2=74.12 //y2=4.095
cc_6107 ( N_noxref_19_c_8885_p N_noxref_21_c_9928_n ) capacitor c=0.00356275f \
 //x=73.38 //y=2.095 //x2=74.12 //y2=4.095
cc_6108 ( N_noxref_19_c_8806_p N_noxref_21_c_9935_n ) capacitor c=0.0169977f \
 //x=73.38 //y=4.37 //x2=74.12 //y2=4.415
cc_6109 ( N_noxref_19_c_8798_p N_noxref_21_c_9935_n ) capacitor c=0.00262509f \
 //x=73.38 //y=4.74 //x2=74.12 //y2=4.415
cc_6110 ( N_noxref_19_c_8808_p N_noxref_21_c_9935_n ) capacitor c=8.95907e-19 \
 //x=73.38 //y=4.25 //x2=74.12 //y2=4.415
cc_6111 ( N_noxref_19_c_8809_p N_noxref_21_c_9935_n ) capacitor c=0.00288053f \
 //x=73.395 //y=4.21 //x2=74.12 //y2=4.415
cc_6112 ( N_noxref_19_c_8798_p N_noxref_21_c_9939_n ) capacitor c=0.0305973f \
 //x=73.38 //y=4.74 //x2=74.12 //y2=5.305
cc_6113 ( N_noxref_19_c_8811_p N_noxref_21_c_9939_n ) capacitor c=0.00179503f \
 //x=73.4 //y=4.885 //x2=74.12 //y2=5.305
cc_6114 ( N_noxref_19_c_8899_p N_noxref_21_c_9939_n ) capacitor c=0.00864287f \
 //x=73.785 //y=4.975 //x2=74.12 //y2=5.305
cc_6115 ( N_noxref_19_c_8812_p N_noxref_21_c_9939_n ) capacitor c=0.00141883f \
 //x=73.4 //y=4.885 //x2=74.12 //y2=5.305
cc_6116 ( N_noxref_19_c_8793_p N_noxref_21_c_9943_n ) capacitor c=0.00300359f \
 //x=73.38 //y=4.05 //x2=75.6 //y2=4.095
cc_6117 ( N_noxref_19_c_8798_p N_noxref_21_c_9944_n ) capacitor c=0.00111022f \
 //x=73.38 //y=4.74 //x2=75.6 //y2=4.76
cc_6118 ( N_noxref_19_c_8715_n N_noxref_21_c_9900_n ) capacitor c=2.22e-19 \
 //x=66.72 //y=2.485 //x2=67.02 //y2=1.36
cc_6119 ( N_noxref_19_c_8775_n N_noxref_21_c_9900_n ) capacitor c=3.77121e-19 \
 //x=66.755 //y=1.085 //x2=67.02 //y2=1.36
cc_6120 ( N_noxref_19_c_8778_n N_noxref_21_c_9900_n ) capacitor c=0.00244881f \
 //x=66.755 //y=1.43 //x2=67.02 //y2=1.36
cc_6121 ( N_noxref_19_c_8780_n N_noxref_21_c_9900_n ) capacitor c=0.00147586f \
 //x=66.755 //y=1.74 //x2=67.02 //y2=1.36
cc_6122 ( N_noxref_19_c_8907_p N_noxref_21_c_9900_n ) capacitor c=3.38306e-19 \
 //x=67.13 //y=0.93 //x2=67.02 //y2=1.36
cc_6123 ( N_noxref_19_c_8908_p N_noxref_21_c_9900_n ) capacitor c=0.0022369f \
 //x=67.13 //y=1.585 //x2=67.02 //y2=1.36
cc_6124 ( N_noxref_19_c_8783_n N_noxref_21_c_9900_n ) capacitor c=3.16128e-19 \
 //x=67.285 //y=1.085 //x2=67.02 //y2=1.36
cc_6125 ( N_noxref_19_c_8784_n N_noxref_21_c_9900_n ) capacitor c=0.00792546f \
 //x=67.285 //y=1.43 //x2=67.02 //y2=1.36
cc_6126 ( N_noxref_19_c_8762_n N_noxref_21_c_9953_n ) capacitor c=0.0169094f \
 //x=73.235 //y=4.21 //x2=72.76 //y2=5.39
cc_6127 ( N_noxref_19_c_8809_p N_noxref_21_c_9954_n ) capacitor c=6.25661e-19 \
 //x=73.395 //y=4.21 //x2=73.637 //y2=5.39
cc_6128 ( N_noxref_19_M134_noxref_g N_noxref_21_c_9954_n ) capacitor \
 c=0.00180711f //x=73.42 //y=6.205 //x2=73.637 //y2=5.39
cc_6129 ( N_noxref_19_M135_noxref_g N_noxref_21_c_9954_n ) capacitor \
 c=0.0027483f //x=73.86 //y=6.205 //x2=73.637 //y2=5.39
cc_6130 ( N_noxref_19_c_8899_p N_noxref_21_c_9954_n ) capacitor c=0.00216603f \
 //x=73.785 //y=4.975 //x2=73.637 //y2=5.39
cc_6131 ( N_noxref_19_c_8806_p N_noxref_21_c_9958_n ) capacitor c=6.9092e-19 \
 //x=73.38 //y=4.37 //x2=74.12 //y2=4.25
cc_6132 ( N_noxref_19_c_8808_p N_noxref_21_c_9958_n ) capacitor c=0.0102219f \
 //x=73.38 //y=4.25 //x2=74.12 //y2=4.25
cc_6133 ( N_noxref_19_c_8645_n N_noxref_21_c_9960_n ) capacitor c=3.84438e-19 \
 //x=50.285 //y=2.37 //x2=67.185 //y2=1.405
cc_6134 ( N_noxref_19_c_8784_n N_noxref_21_c_9902_n ) capacitor c=0.00156453f \
 //x=67.285 //y=1.43 //x2=70.22 //y2=1.405
cc_6135 ( N_noxref_19_c_8847_p N_noxref_21_c_9962_n ) capacitor c=0.00131018f \
 //x=73.415 //y=1.74 //x2=73.675 //y2=1.405
cc_6136 ( N_noxref_19_c_8859_p N_noxref_21_c_9962_n ) capacitor c=0.00184285f \
 //x=73.79 //y=1.585 //x2=73.675 //y2=1.405
cc_6137 ( N_noxref_19_c_8800_p N_noxref_21_c_9964_n ) capacitor c=0.00997796f \
 //x=73.38 //y=2.38 //x2=73.515 //y2=1.405
cc_6138 ( N_noxref_19_c_8846_p N_noxref_21_c_9964_n ) capacitor c=0.00107668f \
 //x=73.415 //y=1.435 //x2=73.515 //y2=1.405
cc_6139 ( N_noxref_19_c_8847_p N_noxref_21_c_9964_n ) capacitor c=8.64037e-19 \
 //x=73.415 //y=1.74 //x2=73.515 //y2=1.405
cc_6140 ( N_noxref_19_c_8806_p N_noxref_21_c_9967_n ) capacitor c=0.0028493f \
 //x=73.38 //y=4.37 //x2=74.28 //y2=4.255
cc_6141 ( N_noxref_19_c_8798_p N_noxref_21_c_9967_n ) capacitor c=0.00114496f \
 //x=73.38 //y=4.74 //x2=74.28 //y2=4.255
cc_6142 ( N_noxref_19_c_8809_p N_noxref_21_c_9967_n ) capacitor c=0.018987f \
 //x=73.395 //y=4.21 //x2=74.28 //y2=4.255
cc_6143 ( N_noxref_19_M134_noxref_g N_noxref_21_c_9970_n ) capacitor \
 c=0.0141401f //x=73.42 //y=6.205 //x2=73.64 //y2=5.56
cc_6144 ( N_noxref_19_M135_noxref_g N_noxref_21_c_9970_n ) capacitor \
 c=0.0139971f //x=73.86 //y=6.205 //x2=73.64 //y2=5.56
cc_6145 ( N_noxref_19_c_8899_p N_noxref_21_c_9970_n ) capacitor c=0.00293135f \
 //x=73.785 //y=4.975 //x2=73.64 //y2=5.56
cc_6146 ( N_noxref_19_c_8775_n N_noxref_21_M40_noxref_d ) capacitor \
 c=0.00218556f //x=66.755 //y=1.085 //x2=66.83 //y2=1.085
cc_6147 ( N_noxref_19_c_8778_n N_noxref_21_M40_noxref_d ) capacitor \
 c=0.00327871f //x=66.755 //y=1.43 //x2=66.83 //y2=1.085
cc_6148 ( N_noxref_19_c_8780_n N_noxref_21_M40_noxref_d ) capacitor \
 c=0.00254845f //x=66.755 //y=1.74 //x2=66.83 //y2=1.085
cc_6149 ( N_noxref_19_c_8907_p N_noxref_21_M40_noxref_d ) capacitor \
 c=0.00235569f //x=67.13 //y=0.93 //x2=66.83 //y2=1.085
cc_6150 ( N_noxref_19_c_8908_p N_noxref_21_M40_noxref_d ) capacitor \
 c=0.00523156f //x=67.13 //y=1.585 //x2=66.83 //y2=1.085
cc_6151 ( N_noxref_19_c_8783_n N_noxref_21_M40_noxref_d ) capacitor \
 c=0.00131413f //x=67.285 //y=1.085 //x2=66.83 //y2=1.085
cc_6152 ( N_noxref_19_c_8784_n N_noxref_21_M40_noxref_d ) capacitor \
 c=0.0065758f //x=67.285 //y=1.43 //x2=66.83 //y2=1.085
cc_6153 ( N_noxref_19_c_8844_p N_noxref_21_M44_noxref_d ) capacitor \
 c=0.00226395f //x=73.415 //y=1.085 //x2=73.49 //y2=1.085
cc_6154 ( N_noxref_19_c_8846_p N_noxref_21_M44_noxref_d ) capacitor \
 c=0.004517f //x=73.415 //y=1.435 //x2=73.49 //y2=1.085
cc_6155 ( N_noxref_19_c_8847_p N_noxref_21_M44_noxref_d ) capacitor \
 c=0.00275912f //x=73.415 //y=1.74 //x2=73.49 //y2=1.085
cc_6156 ( N_noxref_19_c_8876_p N_noxref_21_M44_noxref_d ) capacitor \
 c=0.00234223f //x=73.79 //y=0.93 //x2=73.49 //y2=1.085
cc_6157 ( N_noxref_19_c_8859_p N_noxref_21_M44_noxref_d ) capacitor \
 c=0.00707878f //x=73.79 //y=1.585 //x2=73.49 //y2=1.085
cc_6158 ( N_noxref_19_c_8856_p N_noxref_21_M44_noxref_d ) capacitor \
 c=0.00132831f //x=73.945 //y=1.085 //x2=73.49 //y2=1.085
cc_6159 ( N_noxref_19_c_8860_p N_noxref_21_M44_noxref_d ) capacitor \
 c=0.00330743f //x=73.945 //y=1.435 //x2=73.49 //y2=1.085
cc_6160 ( N_noxref_19_M126_noxref_g N_VDD_c_11277_n ) capacitor c=0.00125343f \
 //x=66.76 //y=6.205 //x2=66.54 //y2=7.035
cc_6161 ( N_noxref_19_M126_noxref_g N_VDD_c_11278_n ) capacitor c=0.00137209f \
 //x=66.76 //y=6.205 //x2=66.54 //y2=7.41
cc_6162 ( N_noxref_19_M127_noxref_g N_VDD_c_11343_n ) capacitor c=0.00373588f \
 //x=67.2 //y=6.205 //x2=67.42 //y2=7.035
cc_6163 ( N_noxref_19_M127_noxref_g N_VDD_c_11344_n ) capacitor c=0.00300944f \
 //x=67.2 //y=6.205 //x2=67.42 //y2=7.41
cc_6164 ( N_noxref_19_M92_noxref_g N_VDD_c_10735_n ) capacitor c=0.00697352f \
 //x=38.64 //y=6.2 //x2=39.215 //y2=7.585
cc_6165 ( N_noxref_19_M93_noxref_g N_VDD_c_10735_n ) capacitor c=0.00755544f \
 //x=39.08 //y=6.2 //x2=39.215 //y2=7.585
cc_6166 ( N_noxref_19_M126_noxref_g N_VDD_c_11289_n ) capacitor c=0.007206f \
 //x=66.76 //y=6.205 //x2=68.03 //y2=7.585
cc_6167 ( N_noxref_19_M127_noxref_g N_VDD_c_11289_n ) capacitor c=0.00778439f \
 //x=67.2 //y=6.205 //x2=68.03 //y2=7.585
cc_6168 ( N_noxref_19_M134_noxref_g N_VDD_c_11349_n ) capacitor c=0.00728344f \
 //x=73.42 //y=6.205 //x2=74.69 //y2=7.585
cc_6169 ( N_noxref_19_M135_noxref_g N_VDD_c_11349_n ) capacitor c=0.00782837f \
 //x=73.86 //y=6.205 //x2=74.69 //y2=7.585
cc_6170 ( N_noxref_19_c_8559_n N_VDD_c_10746_n ) capacitor c=0.00226427f \
 //x=38.63 //y=4.88 //x2=40.08 //y2=7.585
cc_6171 ( N_noxref_19_c_8614_n N_VDD_c_10746_n ) capacitor c=0.0129149f \
 //x=39.005 //y=4.97 //x2=40.08 //y2=7.585
cc_6172 ( N_noxref_19_c_8578_n N_VDD_c_10746_n ) capacitor c=2.73429e-19 \
 //x=38.63 //y=4.88 //x2=40.08 //y2=7.585
cc_6173 ( N_noxref_19_c_8742_n N_VDD_c_11233_n ) capacitor c=9.52781e-19 \
 //x=66.72 //y=4.25 //x2=64.87 //y2=7.585
cc_6174 ( N_noxref_19_c_8727_n N_VDD_c_11310_n ) capacitor c=5.31543e-19 \
 //x=66.72 //y=4.365 //x2=68.2 //y2=7.585
cc_6175 ( N_noxref_19_c_8731_n N_VDD_c_11310_n ) capacitor c=0.00746843f \
 //x=66.72 //y=4.71 //x2=68.2 //y2=7.585
cc_6176 ( N_noxref_19_c_8742_n N_VDD_c_11310_n ) capacitor c=0.00144593f \
 //x=66.72 //y=4.25 //x2=68.2 //y2=7.585
cc_6177 ( N_noxref_19_c_8762_n N_VDD_c_11310_n ) capacitor c=0.00818761f \
 //x=73.235 //y=4.21 //x2=68.2 //y2=7.585
cc_6178 ( N_noxref_19_c_8769_n N_VDD_c_11310_n ) capacitor c=0.00250302f \
 //x=66.76 //y=4.885 //x2=68.2 //y2=7.585
cc_6179 ( N_noxref_19_c_8964_p N_VDD_c_11310_n ) capacitor c=0.0117152f \
 //x=67.125 //y=4.975 //x2=68.2 //y2=7.585
cc_6180 ( N_noxref_19_c_8787_n N_VDD_c_11310_n ) capacitor c=2.76772e-19 \
 //x=66.76 //y=4.885 //x2=68.2 //y2=7.585
cc_6181 ( N_noxref_19_c_8798_p N_VDD_c_11316_n ) capacitor c=5.18027e-19 \
 //x=73.38 //y=4.74 //x2=71.53 //y2=7.585
cc_6182 ( N_noxref_19_c_8808_p N_VDD_c_11316_n ) capacitor c=8.21577e-19 \
 //x=73.38 //y=4.25 //x2=71.53 //y2=7.585
cc_6183 ( N_noxref_19_c_8762_n N_VDD_c_11316_n ) capacitor c=0.0135112f \
 //x=73.235 //y=4.21 //x2=71.53 //y2=7.585
cc_6184 ( N_noxref_19_c_8811_p N_VDD_c_11316_n ) capacitor c=6.64651e-19 \
 //x=73.4 //y=4.885 //x2=71.53 //y2=7.585
cc_6185 ( N_noxref_19_c_8811_p N_VDD_c_11366_n ) capacitor c=0.00237807f \
 //x=73.4 //y=4.885 //x2=74.86 //y2=7.585
cc_6186 ( N_noxref_19_c_8899_p N_VDD_c_11366_n ) capacitor c=0.0170421f \
 //x=73.785 //y=4.975 //x2=74.86 //y2=7.585
cc_6187 ( N_noxref_19_c_8812_p N_VDD_c_11366_n ) capacitor c=2.70151e-19 \
 //x=73.4 //y=4.885 //x2=74.86 //y2=7.585
cc_6188 ( N_noxref_19_M92_noxref_g N_VDD_M91_noxref_d ) capacitor c=0.015318f \
 //x=38.64 //y=6.2 //x2=38.275 //y2=5.2
cc_6189 ( N_noxref_19_c_8578_n N_VDD_M91_noxref_d ) capacitor c=3.32552e-19 \
 //x=38.63 //y=4.88 //x2=38.275 //y2=5.2
cc_6190 ( N_noxref_19_M93_noxref_g N_VDD_M93_noxref_d ) capacitor c=0.0430452f \
 //x=39.08 //y=6.2 //x2=39.155 //y2=5.2
cc_6191 ( N_noxref_19_M126_noxref_g N_VDD_M125_noxref_d ) capacitor \
 c=0.0127979f //x=66.76 //y=6.205 //x2=66.395 //y2=5.205
cc_6192 ( N_noxref_19_M127_noxref_g N_VDD_M127_noxref_d ) capacitor \
 c=0.0463918f //x=67.2 //y=6.205 //x2=67.275 //y2=5.205
cc_6193 ( N_noxref_19_c_8591_n N_noxref_25_c_11822_n ) capacitor c=0.00364973f \
 //x=49.685 //y=2.4 //x2=42.585 //y2=1.835
cc_6194 ( N_noxref_19_c_8591_n N_noxref_25_c_11790_n ) capacitor c=0.0120507f \
 //x=49.685 //y=2.4 //x2=42.315 //y2=1.835
cc_6195 ( N_noxref_19_c_8591_n N_noxref_25_c_11828_n ) capacitor c=0.0388923f \
 //x=49.685 //y=2.4 //x2=42.67 //y2=2.515
cc_6196 ( N_noxref_19_c_8591_n N_noxref_25_c_11804_n ) capacitor c=7.09092e-19 \
 //x=49.685 //y=2.4 //x2=42.23 //y2=1.18
cc_6197 ( N_noxref_19_c_8591_n N_noxref_26_c_11964_n ) capacitor c=0.00601428f \
 //x=49.685 //y=2.4 //x2=46.425 //y2=1.175
cc_6198 ( N_noxref_19_c_8591_n N_noxref_26_c_11954_n ) capacitor c=5.06634e-19 \
 //x=49.685 //y=2.4 //x2=47.395 //y2=0.72
cc_6199 ( N_noxref_19_c_8591_n N_noxref_26_M27_noxref_d ) capacitor \
 c=0.00782404f //x=49.685 //y=2.4 //x2=45.27 //y2=1.09
cc_6200 ( N_noxref_19_c_8591_n N_noxref_26_M28_noxref_s ) capacitor \
 c=0.00447031f //x=49.685 //y=2.4 //x2=46.375 //y2=0.555
cc_6201 ( N_noxref_19_c_8727_n N_noxref_27_c_12022_n ) capacitor c=0.00144109f \
 //x=66.72 //y=4.365 //x2=66.865 //y2=5.39
cc_6202 ( N_noxref_19_c_8731_n N_noxref_27_c_12022_n ) capacitor c=0.0212118f \
 //x=66.72 //y=4.71 //x2=66.865 //y2=5.39
cc_6203 ( N_noxref_19_c_8742_n N_noxref_27_c_12022_n ) capacitor c=3.71828e-19 \
 //x=66.72 //y=4.25 //x2=66.865 //y2=5.39
cc_6204 ( N_noxref_19_c_8769_n N_noxref_27_c_12022_n ) capacitor c=0.004587f \
 //x=66.76 //y=4.885 //x2=66.865 //y2=5.39
cc_6205 ( N_noxref_19_M126_noxref_g N_noxref_27_c_12022_n ) capacitor \
 c=0.00913391f //x=66.76 //y=6.205 //x2=66.865 //y2=5.39
cc_6206 ( N_noxref_19_c_8787_n N_noxref_27_c_12022_n ) capacitor c=6.87087e-19 \
 //x=66.76 //y=4.885 //x2=66.865 //y2=5.39
cc_6207 ( N_noxref_19_M127_noxref_g N_noxref_27_c_12024_n ) capacitor \
 c=0.011434f //x=67.2 //y=6.205 //x2=68.865 //y2=5.39
cc_6208 ( N_noxref_19_c_8727_n N_noxref_27_c_12027_n ) capacitor c=0.00145195f \
 //x=66.72 //y=4.365 //x2=67.095 //y2=5.39
cc_6209 ( N_noxref_19_c_8731_n N_noxref_27_c_12027_n ) capacitor c=0.00252287f \
 //x=66.72 //y=4.71 //x2=67.095 //y2=5.39
cc_6210 ( N_noxref_19_M126_noxref_g N_noxref_27_c_12027_n ) capacitor \
 c=7.30299e-19 //x=66.76 //y=6.205 //x2=67.095 //y2=5.39
cc_6211 ( N_noxref_19_M127_noxref_g N_noxref_27_c_12027_n ) capacitor \
 c=8.30848e-19 //x=67.2 //y=6.205 //x2=67.095 //y2=5.39
cc_6212 ( N_noxref_19_c_8727_n N_noxref_27_c_12046_n ) capacitor c=0.00167023f \
 //x=66.72 //y=4.365 //x2=66.98 //y2=5.39
cc_6213 ( N_noxref_19_M126_noxref_g N_noxref_27_c_12046_n ) capacitor \
 c=0.021802f //x=66.76 //y=6.205 //x2=66.98 //y2=5.39
cc_6214 ( N_noxref_19_M127_noxref_g N_noxref_27_c_12046_n ) capacitor \
 c=0.0189969f //x=67.2 //y=6.205 //x2=66.98 //y2=5.39
cc_6215 ( N_noxref_19_c_8964_p N_noxref_27_c_12046_n ) capacitor c=0.00449628f \
 //x=67.125 //y=4.975 //x2=66.98 //y2=5.39
cc_6216 ( N_noxref_19_M126_noxref_g N_noxref_27_M126_noxref_d ) capacitor \
 c=0.00122946f //x=66.76 //y=6.205 //x2=66.835 //y2=5.205
cc_6217 ( N_noxref_19_M127_noxref_g N_noxref_27_M126_noxref_d ) capacitor \
 c=0.00123972f //x=67.2 //y=6.205 //x2=66.835 //y2=5.205
cc_6218 ( N_noxref_19_c_8762_n N_noxref_28_c_12195_n ) capacitor c=0.0605646f \
 //x=73.235 //y=4.21 //x2=72.205 //y2=5.39
cc_6219 ( N_noxref_19_c_8762_n N_noxref_28_c_12196_n ) capacitor c=0.00869836f \
 //x=73.235 //y=4.21 //x2=70.415 //y2=5.39
cc_6220 ( N_noxref_19_M134_noxref_g N_noxref_28_c_12197_n ) capacitor \
 c=0.00793695f //x=73.42 //y=6.205 //x2=73.95 //y2=7.09
cc_6221 ( N_noxref_19_M135_noxref_g N_noxref_28_c_12197_n ) capacitor \
 c=0.00937408f //x=73.86 //y=6.205 //x2=73.95 //y2=7.09
cc_6222 ( N_noxref_19_c_8762_n N_noxref_28_c_12184_n ) capacitor c=0.0262477f \
 //x=73.235 //y=4.21 //x2=69.42 //y2=5.39
cc_6223 ( N_noxref_19_c_8762_n N_noxref_28_c_12200_n ) capacitor c=0.00272496f \
 //x=73.235 //y=4.21 //x2=70.3 //y2=5.39
cc_6224 ( N_noxref_19_M134_noxref_g N_noxref_28_c_12201_n ) capacitor \
 c=0.00177216f //x=73.42 //y=6.205 //x2=73.2 //y2=7.09
cc_6225 ( N_noxref_19_M135_noxref_g N_noxref_28_c_12202_n ) capacitor \
 c=0.00422002f //x=73.86 //y=6.205 //x2=74.08 //y2=6.92
cc_6226 ( N_noxref_19_c_8762_n N_noxref_28_c_12203_n ) capacitor c=2.11035e-19 \
 //x=73.235 //y=4.21 //x2=72.32 //y2=5.39
cc_6227 ( N_noxref_19_M134_noxref_g N_noxref_28_M133_noxref_d ) capacitor \
 c=0.0142133f //x=73.42 //y=6.205 //x2=73.055 //y2=5.205
cc_6228 ( N_noxref_19_c_8812_p N_noxref_28_M133_noxref_d ) capacitor \
 c=6.61209e-19 //x=73.4 //y=4.885 //x2=73.055 //y2=5.205
cc_6229 ( N_noxref_19_M135_noxref_g N_noxref_28_M135_noxref_d ) capacitor \
 c=0.0365939f //x=73.86 //y=6.205 //x2=73.935 //y2=5.205
cc_6230 ( N_noxref_19_c_8542_n N_GND_c_12685_n ) capacitor c=0.00233652f \
 //x=38.6 //y=2.485 //x2=41.175 //y2=0.175
cc_6231 ( N_noxref_19_c_8591_n N_GND_c_12685_n ) capacitor c=0.0706125f \
 //x=49.685 //y=2.4 //x2=41.175 //y2=0.175
cc_6232 ( N_noxref_19_c_8554_n N_GND_c_12685_n ) capacitor c=0.00575196f \
 //x=38.585 //y=2.325 //x2=41.175 //y2=0.175
cc_6233 ( N_noxref_19_c_8591_n N_GND_c_12730_n ) capacitor c=0.0812099f \
 //x=49.685 //y=2.4 //x2=44.4 //y2=0.175
cc_6234 ( N_noxref_19_c_8591_n N_GND_c_12829_n ) capacitor c=0.129129f \
 //x=49.685 //y=2.4 //x2=49.315 //y2=0.175
cc_6235 ( N_noxref_19_c_8591_n N_GND_c_12788_n ) capacitor c=0.00889614f \
 //x=49.685 //y=2.4 //x2=52.645 //y2=0.175
cc_6236 ( N_noxref_19_c_8645_n N_GND_c_12788_n ) capacitor c=0.0733932f \
 //x=50.285 //y=2.37 //x2=52.645 //y2=0.175
cc_6237 ( N_noxref_19_c_8645_n N_GND_c_12871_n ) capacitor c=0.0848343f \
 //x=50.285 //y=2.37 //x2=55.975 //y2=0.175
cc_6238 ( N_noxref_19_c_8645_n N_GND_c_12915_n ) capacitor c=0.0872755f \
 //x=50.285 //y=2.37 //x2=59.305 //y2=0.175
cc_6239 ( N_noxref_19_c_8645_n N_GND_c_12986_n ) capacitor c=0.0867027f \
 //x=50.285 //y=2.37 //x2=62.635 //y2=0.175
cc_6240 ( N_noxref_19_c_8645_n N_GND_c_13031_n ) capacitor c=0.0805886f \
 //x=50.285 //y=2.37 //x2=65.965 //y2=0.175
cc_6241 ( N_noxref_19_c_8645_n N_GND_c_13079_n ) capacitor c=0.00909714f \
 //x=50.285 //y=2.37 //x2=66.05 //y2=1.015
cc_6242 ( N_noxref_19_c_8715_n N_GND_c_13145_n ) capacitor c=0.00183702f \
 //x=66.72 //y=2.485 //x2=69.295 //y2=0.175
cc_6243 ( N_noxref_19_c_8645_n N_GND_c_13145_n ) capacitor c=0.0140729f \
 //x=50.285 //y=2.37 //x2=69.295 //y2=0.175
cc_6244 ( N_noxref_19_c_8800_p N_GND_c_13147_n ) capacitor c=4.6307e-19 \
 //x=73.38 //y=2.38 //x2=76.34 //y2=0.18
cc_6245 ( N_noxref_19_c_8591_n N_GND_c_12692_n ) capacitor c=0.00602115f \
 //x=49.685 //y=2.4 //x2=41.26 //y2=1.135
cc_6246 ( N_noxref_19_c_8591_n N_GND_c_13032_n ) capacitor c=0.00562607f \
 //x=49.685 //y=2.4 //x2=44.485 //y2=1.145
cc_6247 ( N_noxref_19_c_8591_n N_GND_c_12833_n ) capacitor c=0.00602401f \
 //x=49.685 //y=2.4 //x2=49.4 //y2=1.135
cc_6248 ( N_noxref_19_c_8645_n N_GND_c_12836_n ) capacitor c=0.00594733f \
 //x=50.285 //y=2.37 //x2=52.73 //y2=1.135
cc_6249 ( N_noxref_19_c_8645_n N_GND_c_12878_n ) capacitor c=0.00594843f \
 //x=50.285 //y=2.37 //x2=56.06 //y2=1.135
cc_6250 ( N_noxref_19_c_8645_n N_GND_c_12945_n ) capacitor c=0.00602903f \
 //x=50.285 //y=2.37 //x2=59.39 //y2=1.135
cc_6251 ( N_noxref_19_c_8645_n N_GND_c_12993_n ) capacitor c=0.0061928f \
 //x=50.285 //y=2.37 //x2=62.72 //y2=1.135
cc_6252 ( N_noxref_19_c_8542_n N_GND_c_12658_n ) capacitor c=3.77023e-19 \
 //x=38.6 //y=2.485 //x2=39.91 //y2=0.175
cc_6253 ( N_noxref_19_c_8715_n N_GND_c_13101_n ) capacitor c=2.97053e-19 \
 //x=66.72 //y=2.485 //x2=68.03 //y2=0.175
cc_6254 ( N_noxref_19_c_8800_p N_GND_c_13157_n ) capacitor c=3.29013e-19 \
 //x=73.38 //y=2.38 //x2=74.69 //y2=0.175
cc_6255 ( N_noxref_19_c_8591_n N_GND_c_12708_n ) capacitor c=0.0211731f \
 //x=49.685 //y=2.4 //x2=40.08 //y2=0.175
cc_6256 ( N_noxref_19_c_8556_n N_GND_c_12708_n ) capacitor c=0.00200625f \
 //x=38.6 //y=2.26 //x2=40.08 //y2=0.175
cc_6257 ( N_noxref_19_c_8574_n N_GND_c_12708_n ) capacitor c=0.00275184f \
 //x=39.165 //y=1.43 //x2=40.08 //y2=0.175
cc_6258 ( N_noxref_19_c_8575_n N_GND_c_12708_n ) capacitor c=2.63786e-19 \
 //x=38.6 //y=2.26 //x2=40.08 //y2=0.175
cc_6259 ( N_noxref_19_c_8591_n N_GND_c_12760_n ) capacitor c=0.0198792f \
 //x=49.685 //y=2.4 //x2=43.41 //y2=0.175
cc_6260 ( N_noxref_19_c_8591_n N_GND_c_12823_n ) capacitor c=0.0212702f \
 //x=49.685 //y=2.4 //x2=48.22 //y2=0.175
cc_6261 ( N_noxref_19_c_8645_n N_GND_c_12825_n ) capacitor c=0.0204606f \
 //x=50.285 //y=2.37 //x2=51.55 //y2=0.175
cc_6262 ( N_noxref_19_c_8645_n N_GND_c_12895_n ) capacitor c=0.0205396f \
 //x=50.285 //y=2.37 //x2=54.88 //y2=0.175
cc_6263 ( N_noxref_19_c_8645_n N_GND_c_12925_n ) capacitor c=0.0205396f \
 //x=50.285 //y=2.37 //x2=58.21 //y2=0.175
cc_6264 ( N_noxref_19_c_8645_n N_GND_c_13009_n ) capacitor c=0.0205396f \
 //x=50.285 //y=2.37 //x2=61.54 //y2=0.175
cc_6265 ( N_noxref_19_c_8645_n N_GND_c_13061_n ) capacitor c=0.0200097f \
 //x=50.285 //y=2.37 //x2=64.87 //y2=0.175
cc_6266 ( N_noxref_19_c_8715_n N_GND_c_13115_n ) capacitor c=0.00273701f \
 //x=66.72 //y=2.485 //x2=68.2 //y2=0.175
cc_6267 ( N_noxref_19_c_8721_n N_GND_c_13115_n ) capacitor c=0.00509986f \
 //x=66.72 //y=4.045 //x2=68.2 //y2=0.175
cc_6268 ( N_noxref_19_c_8766_n N_GND_c_13115_n ) capacitor c=0.00250512f \
 //x=66.72 //y=2.26 //x2=68.2 //y2=0.175
cc_6269 ( N_noxref_19_c_8762_n N_GND_c_13172_n ) capacitor c=0.0025451f \
 //x=73.235 //y=4.21 //x2=71.53 //y2=0.175
cc_6270 ( N_noxref_19_c_8803_p N_GND_c_13173_n ) capacitor c=0.00224736f \
 //x=73.38 //y=2.26 //x2=74.86 //y2=0.175
cc_6271 ( N_noxref_19_c_8859_p N_GND_c_13173_n ) capacitor c=0.00264662f \
 //x=73.79 //y=1.585 //x2=74.86 //y2=0.175
cc_6272 ( N_noxref_19_c_8804_p N_GND_c_13173_n ) capacitor c=2.63786e-19 \
 //x=73.38 //y=2.26 //x2=74.86 //y2=0.175
cc_6273 ( N_noxref_19_c_8542_n N_noxref_41_c_14652_n ) capacitor c=0.00340799f \
 //x=38.6 //y=2.485 //x2=38.415 //y2=1.675
cc_6274 ( N_noxref_19_c_8570_n N_noxref_41_c_14652_n ) capacitor c=0.00888238f \
 //x=38.635 //y=1.74 //x2=38.415 //y2=1.675
cc_6275 ( N_noxref_19_c_8575_n N_noxref_41_c_14652_n ) capacitor c=0.00173485f \
 //x=38.6 //y=2.26 //x2=38.415 //y2=1.675
cc_6276 ( N_noxref_19_c_8542_n N_noxref_41_c_14657_n ) capacitor c=0.00173527f \
 //x=38.6 //y=2.485 //x2=39.3 //y2=0.71
cc_6277 ( N_noxref_19_c_8591_n N_noxref_41_c_14657_n ) capacitor c=4.63587e-19 \
 //x=49.685 //y=2.4 //x2=39.3 //y2=0.71
cc_6278 ( N_noxref_19_c_8556_n N_noxref_41_c_14657_n ) capacitor c=8.82141e-19 \
 //x=38.6 //y=2.26 //x2=39.3 //y2=0.71
cc_6279 ( N_noxref_19_c_8565_n N_noxref_41_c_14657_n ) capacitor c=0.0200738f \
 //x=38.635 //y=1.085 //x2=39.3 //y2=0.71
cc_6280 ( N_noxref_19_c_8573_n N_noxref_41_c_14657_n ) capacitor c=0.00825432f \
 //x=39.165 //y=1.085 //x2=39.3 //y2=0.71
cc_6281 ( N_noxref_19_c_8575_n N_noxref_41_c_14657_n ) capacitor c=2.1838e-19 \
 //x=38.6 //y=2.26 //x2=39.3 //y2=0.71
cc_6282 ( N_noxref_19_c_8591_n N_noxref_41_M22_noxref_s ) capacitor \
 c=0.0010705f //x=49.685 //y=2.4 //x2=37.31 //y2=0.545
cc_6283 ( N_noxref_19_c_8565_n N_noxref_41_M22_noxref_s ) capacitor \
 c=0.00888238f //x=38.635 //y=1.085 //x2=37.31 //y2=0.545
cc_6284 ( N_noxref_19_c_8573_n N_noxref_41_M22_noxref_s ) capacitor \
 c=0.015333f //x=39.165 //y=1.085 //x2=37.31 //y2=0.545
cc_6285 ( N_noxref_19_c_8574_n N_noxref_41_M22_noxref_s ) capacitor \
 c=0.00248746f //x=39.165 //y=1.43 //x2=37.31 //y2=0.545
cc_6286 ( N_noxref_19_c_8591_n N_noxref_42_c_14712_n ) capacitor c=0.00442321f \
 //x=49.685 //y=2.4 //x2=40.775 //y2=1.675
cc_6287 ( N_noxref_19_c_8591_n N_noxref_42_c_14713_n ) capacitor c=0.0128243f \
 //x=49.685 //y=2.4 //x2=41.66 //y2=1.76
cc_6288 ( N_noxref_19_c_8591_n N_noxref_42_c_14720_n ) capacitor c=0.00441768f \
 //x=49.685 //y=2.4 //x2=41.745 //y2=1.675
cc_6289 ( N_noxref_19_c_8591_n N_noxref_42_c_14728_n ) capacitor c=9.75929e-19 \
 //x=49.685 //y=2.4 //x2=42.63 //y2=0.71
cc_6290 ( N_noxref_19_c_8591_n N_noxref_43_c_14790_n ) capacitor c=0.00444844f \
 //x=49.685 //y=2.4 //x2=44 //y2=1.685
cc_6291 ( N_noxref_19_c_8591_n N_noxref_43_c_14791_n ) capacitor c=0.0132956f \
 //x=49.685 //y=2.4 //x2=44.885 //y2=1.77
cc_6292 ( N_noxref_19_c_8591_n N_noxref_43_c_14782_n ) capacitor c=0.0118677f \
 //x=49.685 //y=2.4 //x2=45.855 //y2=1.77
cc_6293 ( N_noxref_19_c_8591_n N_noxref_43_M26_noxref_s ) capacitor \
 c=0.00828583f //x=49.685 //y=2.4 //x2=43.865 //y2=0.555
cc_6294 ( N_noxref_19_c_8591_n N_noxref_44_c_14862_n ) capacitor c=0.00442321f \
 //x=49.685 //y=2.4 //x2=48.915 //y2=1.675
cc_6295 ( N_noxref_19_c_8591_n N_noxref_44_c_14863_n ) capacitor c=0.0128724f \
 //x=49.685 //y=2.4 //x2=49.8 //y2=1.76
cc_6296 ( N_noxref_19_c_8591_n N_noxref_44_c_14839_n ) capacitor c=0.00445944f \
 //x=49.685 //y=2.4 //x2=49.885 //y2=1.675
cc_6297 ( N_noxref_19_c_8645_n N_noxref_44_c_14843_n ) capacitor c=9.87114e-19 \
 //x=50.285 //y=2.37 //x2=50.77 //y2=0.71
cc_6298 ( N_noxref_19_c_8645_n N_noxref_44_M29_noxref_s ) capacitor \
 c=0.0010705f //x=50.285 //y=2.37 //x2=48.78 //y2=0.545
cc_6299 ( N_noxref_19_c_8645_n N_noxref_45_c_14908_n ) capacitor c=0.00442321f \
 //x=50.285 //y=2.37 //x2=52.245 //y2=1.675
cc_6300 ( N_noxref_19_c_8645_n N_noxref_45_c_14909_n ) capacitor c=0.0129287f \
 //x=50.285 //y=2.37 //x2=53.13 //y2=1.76
cc_6301 ( N_noxref_19_c_8645_n N_noxref_45_c_14916_n ) capacitor c=0.00441768f \
 //x=50.285 //y=2.37 //x2=53.215 //y2=1.675
cc_6302 ( N_noxref_19_c_8645_n N_noxref_45_c_14921_n ) capacitor c=9.89029e-19 \
 //x=50.285 //y=2.37 //x2=54.1 //y2=0.71
cc_6303 ( N_noxref_19_c_8645_n N_noxref_45_M31_noxref_s ) capacitor \
 c=0.0010705f //x=50.285 //y=2.37 //x2=52.11 //y2=0.545
cc_6304 ( N_noxref_19_c_8645_n N_noxref_46_c_14977_n ) capacitor c=0.00442321f \
 //x=50.285 //y=2.37 //x2=55.575 //y2=1.675
cc_6305 ( N_noxref_19_c_8645_n N_noxref_46_c_14978_n ) capacitor c=0.0128826f \
 //x=50.285 //y=2.37 //x2=56.46 //y2=1.76
cc_6306 ( N_noxref_19_c_8645_n N_noxref_46_c_14985_n ) capacitor c=0.00413037f \
 //x=50.285 //y=2.37 //x2=56.545 //y2=1.675
cc_6307 ( N_noxref_19_c_8645_n N_noxref_46_c_14992_n ) capacitor c=0.00104143f \
 //x=50.285 //y=2.37 //x2=57.43 //y2=0.71
cc_6308 ( N_noxref_19_c_8645_n N_noxref_46_M33_noxref_s ) capacitor \
 c=0.0010705f //x=50.285 //y=2.37 //x2=55.44 //y2=0.545
cc_6309 ( N_noxref_19_c_8645_n N_noxref_47_c_15045_n ) capacitor c=0.00442321f \
 //x=50.285 //y=2.37 //x2=58.905 //y2=1.675
cc_6310 ( N_noxref_19_c_8645_n N_noxref_47_c_15046_n ) capacitor c=0.0129144f \
 //x=50.285 //y=2.37 //x2=59.79 //y2=1.76
cc_6311 ( N_noxref_19_c_8645_n N_noxref_47_c_15053_n ) capacitor c=0.00418562f \
 //x=50.285 //y=2.37 //x2=59.875 //y2=1.675
cc_6312 ( N_noxref_19_c_8645_n N_noxref_47_c_15058_n ) capacitor c=0.00104143f \
 //x=50.285 //y=2.37 //x2=60.76 //y2=0.71
cc_6313 ( N_noxref_19_c_8645_n N_noxref_47_M35_noxref_s ) capacitor \
 c=0.0010705f //x=50.285 //y=2.37 //x2=58.77 //y2=0.545
cc_6314 ( N_noxref_19_c_8645_n N_noxref_48_c_15115_n ) capacitor c=0.00442321f \
 //x=50.285 //y=2.37 //x2=62.235 //y2=1.675
cc_6315 ( N_noxref_19_c_8645_n N_noxref_48_c_15116_n ) capacitor c=0.0127228f \
 //x=50.285 //y=2.37 //x2=63.12 //y2=1.76
cc_6316 ( N_noxref_19_c_8645_n N_noxref_48_c_15123_n ) capacitor c=0.00441768f \
 //x=50.285 //y=2.37 //x2=63.205 //y2=1.675
cc_6317 ( N_noxref_19_c_8645_n N_noxref_48_c_15131_n ) capacitor c=9.75929e-19 \
 //x=50.285 //y=2.37 //x2=64.09 //y2=0.71
cc_6318 ( N_noxref_19_c_8645_n N_noxref_48_M37_noxref_s ) capacitor \
 c=0.0010705f //x=50.285 //y=2.37 //x2=62.1 //y2=0.545
cc_6319 ( N_noxref_19_c_8645_n N_noxref_49_c_15184_n ) capacitor c=4.63368e-19 \
 //x=50.285 //y=2.37 //x2=65.565 //y2=1.675
cc_6320 ( N_noxref_19_c_8645_n N_noxref_49_c_15188_n ) capacitor c=0.0153883f \
 //x=50.285 //y=2.37 //x2=66.45 //y2=1.76
cc_6321 ( N_noxref_19_c_8715_n N_noxref_49_c_15197_n ) capacitor c=0.00307053f \
 //x=66.72 //y=2.485 //x2=66.535 //y2=1.675
cc_6322 ( N_noxref_19_c_8645_n N_noxref_49_c_15197_n ) capacitor c=0.00260189f \
 //x=50.285 //y=2.37 //x2=66.535 //y2=1.675
cc_6323 ( N_noxref_19_c_8780_n N_noxref_49_c_15197_n ) capacitor c=0.00746306f \
 //x=66.755 //y=1.74 //x2=66.535 //y2=1.675
cc_6324 ( N_noxref_19_c_8785_n N_noxref_49_c_15197_n ) capacitor c=0.0017349f \
 //x=66.72 //y=2.26 //x2=66.535 //y2=1.675
cc_6325 ( N_noxref_19_c_8715_n N_noxref_49_c_15207_n ) capacitor c=0.00140299f \
 //x=66.72 //y=2.485 //x2=67.42 //y2=0.71
cc_6326 ( N_noxref_19_c_8766_n N_noxref_49_c_15207_n ) capacitor c=8.82141e-19 \
 //x=66.72 //y=2.26 //x2=67.42 //y2=0.71
cc_6327 ( N_noxref_19_c_8775_n N_noxref_49_c_15207_n ) capacitor c=0.0200392f \
 //x=66.755 //y=1.085 //x2=67.42 //y2=0.71
cc_6328 ( N_noxref_19_c_8783_n N_noxref_49_c_15207_n ) capacitor c=0.00825432f \
 //x=67.285 //y=1.085 //x2=67.42 //y2=0.71
cc_6329 ( N_noxref_19_c_8785_n N_noxref_49_c_15207_n ) capacitor c=2.1838e-19 \
 //x=66.72 //y=2.26 //x2=67.42 //y2=0.71
cc_6330 ( N_noxref_19_c_8775_n N_noxref_49_M39_noxref_s ) capacitor \
 c=0.00746306f //x=66.755 //y=1.085 //x2=65.43 //y2=0.545
cc_6331 ( N_noxref_19_c_8780_n N_noxref_49_M39_noxref_s ) capacitor \
 c=0.00213749f //x=66.755 //y=1.74 //x2=65.43 //y2=0.545
cc_6332 ( N_noxref_19_c_8783_n N_noxref_49_M39_noxref_s ) capacitor \
 c=0.014227f //x=67.285 //y=1.085 //x2=65.43 //y2=0.545
cc_6333 ( N_noxref_19_c_8784_n N_noxref_49_M39_noxref_s ) capacitor \
 c=0.00733269f //x=67.285 //y=1.43 //x2=65.43 //y2=0.545
cc_6334 ( N_noxref_19_c_9119_p N_noxref_49_M39_noxref_s ) capacitor \
 c=0.00287293f //x=66.72 //y=2.095 //x2=65.43 //y2=0.545
cc_6335 ( N_noxref_19_c_8762_n N_noxref_52_c_15326_n ) capacitor c=0.00782785f \
 //x=73.235 //y=4.21 //x2=73.11 //y2=1.76
cc_6336 ( N_noxref_19_c_8800_p N_noxref_52_c_15327_n ) capacitor c=7.26555e-19 \
 //x=73.38 //y=2.38 //x2=73.195 //y2=1.675
cc_6337 ( N_noxref_19_c_8806_p N_noxref_52_c_15327_n ) capacitor c=9.42734e-19 \
 //x=73.38 //y=4.37 //x2=73.195 //y2=1.675
cc_6338 ( N_noxref_19_c_8847_p N_noxref_52_c_15327_n ) capacitor c=0.00830822f \
 //x=73.415 //y=1.74 //x2=73.195 //y2=1.675
cc_6339 ( N_noxref_19_c_8804_p N_noxref_52_c_15327_n ) capacitor c=0.00175172f \
 //x=73.38 //y=2.26 //x2=73.195 //y2=1.675
cc_6340 ( N_noxref_19_c_8800_p N_noxref_52_c_15331_n ) capacitor c=5.72205e-19 \
 //x=73.38 //y=2.38 //x2=74.08 //y2=0.71
cc_6341 ( N_noxref_19_c_8803_p N_noxref_52_c_15331_n ) capacitor c=8.37879e-19 \
 //x=73.38 //y=2.26 //x2=74.08 //y2=0.71
cc_6342 ( N_noxref_19_c_8844_p N_noxref_52_c_15331_n ) capacitor c=0.0202024f \
 //x=73.415 //y=1.085 //x2=74.08 //y2=0.71
cc_6343 ( N_noxref_19_c_8856_p N_noxref_52_c_15331_n ) capacitor c=0.00825432f \
 //x=73.945 //y=1.085 //x2=74.08 //y2=0.71
cc_6344 ( N_noxref_19_c_8804_p N_noxref_52_c_15331_n ) capacitor c=2.1838e-19 \
 //x=73.38 //y=2.26 //x2=74.08 //y2=0.71
cc_6345 ( N_noxref_19_c_8844_p N_noxref_52_M43_noxref_s ) capacitor \
 c=0.00830822f //x=73.415 //y=1.085 //x2=72.09 //y2=0.545
cc_6346 ( N_noxref_19_c_8859_p N_noxref_52_M43_noxref_s ) capacitor \
 c=0.00271091f //x=73.79 //y=1.585 //x2=72.09 //y2=0.545
cc_6347 ( N_noxref_19_c_8856_p N_noxref_52_M43_noxref_s ) capacitor \
 c=0.0142835f //x=73.945 //y=1.085 //x2=72.09 //y2=0.545
cc_6348 ( N_noxref_20_M133_noxref_g N_noxref_21_c_9906_n ) capacitor \
 c=0.00969448f //x=72.98 //y=6.205 //x2=73.515 //y2=5.39
cc_6349 ( N_noxref_20_c_9577_n N_noxref_21_c_9928_n ) capacitor c=8.05281e-19 \
 //x=72.27 //y=2.43 //x2=74.12 //y2=4.095
cc_6350 ( N_noxref_20_c_9524_n N_noxref_21_c_9928_n ) capacitor c=0.00420142f \
 //x=72.27 //y=4.755 //x2=74.12 //y2=4.095
cc_6351 ( N_noxref_20_c_9524_n N_noxref_21_c_9939_n ) capacitor c=0.00136963f \
 //x=72.27 //y=4.755 //x2=74.12 //y2=5.305
cc_6352 ( N_noxref_20_c_9455_n N_noxref_21_c_9900_n ) capacitor c=0.00698348f \
 //x=56.2 //y=3.125 //x2=67.02 //y2=1.36
cc_6353 ( N_noxref_20_c_9455_n N_noxref_21_c_9992_n ) capacitor c=0.00659441f \
 //x=56.2 //y=3.125 //x2=70.35 //y2=1.36
cc_6354 ( N_noxref_20_c_9554_n N_noxref_21_c_9992_n ) capacitor c=5.10033e-19 \
 //x=70.085 //y=1.085 //x2=70.35 //y2=1.36
cc_6355 ( N_noxref_20_c_9557_n N_noxref_21_c_9992_n ) capacitor c=0.00606919f \
 //x=70.085 //y=1.43 //x2=70.35 //y2=1.36
cc_6356 ( N_noxref_20_c_9649_p N_noxref_21_c_9992_n ) capacitor c=4.65567e-19 \
 //x=70.46 //y=0.93 //x2=70.35 //y2=1.36
cc_6357 ( N_noxref_20_c_9650_p N_noxref_21_c_9992_n ) capacitor c=0.00247382f \
 //x=70.46 //y=1.585 //x2=70.35 //y2=1.36
cc_6358 ( N_noxref_20_c_9563_n N_noxref_21_c_9992_n ) capacitor c=2.15736e-19 \
 //x=70.615 //y=1.085 //x2=70.35 //y2=1.36
cc_6359 ( N_noxref_20_c_9564_n N_noxref_21_c_9992_n ) capacitor c=0.00259159f \
 //x=70.615 //y=1.43 //x2=70.35 //y2=1.36
cc_6360 ( N_noxref_20_c_9565_n N_noxref_21_c_9992_n ) capacitor c=0.00150348f \
 //x=70.615 //y=1.74 //x2=70.35 //y2=1.36
cc_6361 ( N_noxref_20_M132_noxref_g N_noxref_21_c_9953_n ) capacitor \
 c=0.00363978f //x=72.54 //y=6.205 //x2=72.76 //y2=5.39
cc_6362 ( N_noxref_20_M133_noxref_g N_noxref_21_c_9953_n ) capacitor \
 c=0.00185829f //x=72.98 //y=6.205 //x2=72.76 //y2=5.39
cc_6363 ( N_noxref_20_c_9626_n N_noxref_21_c_9953_n ) capacitor c=0.0021827f \
 //x=72.905 //y=4.975 //x2=72.76 //y2=5.39
cc_6364 ( N_noxref_20_c_9455_n N_noxref_21_c_9960_n ) capacitor c=0.0053182f \
 //x=56.2 //y=3.125 //x2=67.185 //y2=1.405
cc_6365 ( N_noxref_20_c_9455_n N_noxref_21_c_9902_n ) capacitor c=0.0587935f \
 //x=56.2 //y=3.125 //x2=70.22 //y2=1.405
cc_6366 ( N_noxref_20_c_9557_n N_noxref_21_c_9902_n ) capacitor c=0.00156453f \
 //x=70.085 //y=1.43 //x2=70.22 //y2=1.405
cc_6367 ( N_noxref_20_c_9455_n N_noxref_21_c_10006_n ) capacitor c=0.0043555f \
 //x=56.2 //y=3.125 //x2=70.48 //y2=1.405
cc_6368 ( N_noxref_20_c_9514_n N_noxref_21_c_9964_n ) capacitor c=0.00831555f \
 //x=70.79 //y=2.43 //x2=73.515 //y2=1.405
cc_6369 ( N_noxref_20_c_9518_n N_noxref_21_c_9964_n ) capacitor c=0.00179273f \
 //x=70.79 //y=3.3 //x2=73.515 //y2=1.405
cc_6370 ( N_noxref_20_c_9577_n N_noxref_21_c_9964_n ) capacitor c=0.00831552f \
 //x=72.27 //y=2.43 //x2=73.515 //y2=1.405
cc_6371 ( N_noxref_20_c_9455_n N_noxref_21_c_9964_n ) capacitor c=0.00241588f \
 //x=56.2 //y=3.125 //x2=73.515 //y2=1.405
cc_6372 ( N_noxref_20_c_9542_n N_noxref_21_c_9964_n ) capacitor c=0.0126775f \
 //x=70.955 //y=2.27 //x2=73.515 //y2=1.405
cc_6373 ( N_noxref_20_c_9608_n N_noxref_21_c_9964_n ) capacitor c=0.0128597f \
 //x=72.265 //y=2.27 //x2=73.515 //y2=1.405
cc_6374 ( N_noxref_20_c_9611_n N_noxref_21_c_9964_n ) capacitor c=0.0434154f \
 //x=72.105 //y=2.27 //x2=73.515 //y2=1.405
cc_6375 ( N_noxref_20_c_9564_n N_noxref_21_c_9964_n ) capacitor c=0.00215337f \
 //x=70.615 //y=1.43 //x2=73.515 //y2=1.405
cc_6376 ( N_noxref_20_c_9565_n N_noxref_21_c_9964_n ) capacitor c=0.00132573f \
 //x=70.615 //y=1.74 //x2=73.515 //y2=1.405
cc_6377 ( N_noxref_20_c_9622_n N_noxref_21_c_9964_n ) capacitor c=0.00277413f \
 //x=72.445 //y=1.39 //x2=73.515 //y2=1.405
cc_6378 ( N_noxref_20_c_9623_n N_noxref_21_c_9964_n ) capacitor c=0.00245466f \
 //x=72.445 //y=1.7 //x2=73.515 //y2=1.405
cc_6379 ( N_noxref_20_c_9634_n N_noxref_21_c_9964_n ) capacitor c=0.00460244f \
 //x=72.975 //y=1.39 //x2=73.515 //y2=1.405
cc_6380 ( N_noxref_20_M132_noxref_g N_noxref_21_c_10019_n ) capacitor \
 c=0.0120591f //x=72.54 //y=6.205 //x2=72.76 //y2=5.56
cc_6381 ( N_noxref_20_M133_noxref_g N_noxref_21_c_10019_n ) capacitor \
 c=0.0142133f //x=72.98 //y=6.205 //x2=72.76 //y2=5.56
cc_6382 ( N_noxref_20_c_9626_n N_noxref_21_c_10019_n ) capacitor c=0.00293135f \
 //x=72.905 //y=4.975 //x2=72.76 //y2=5.56
cc_6383 ( N_noxref_20_c_9554_n N_noxref_21_M42_noxref_d ) capacitor \
 c=0.00217566f //x=70.085 //y=1.085 //x2=70.16 //y2=1.085
cc_6384 ( N_noxref_20_c_9557_n N_noxref_21_M42_noxref_d ) capacitor \
 c=0.00693963f //x=70.085 //y=1.43 //x2=70.16 //y2=1.085
cc_6385 ( N_noxref_20_c_9649_p N_noxref_21_M42_noxref_d ) capacitor \
 c=0.00234223f //x=70.46 //y=0.93 //x2=70.16 //y2=1.085
cc_6386 ( N_noxref_20_c_9650_p N_noxref_21_M42_noxref_d ) capacitor \
 c=0.00513213f //x=70.46 //y=1.585 //x2=70.16 //y2=1.085
cc_6387 ( N_noxref_20_c_9563_n N_noxref_21_M42_noxref_d ) capacitor \
 c=0.00132245f //x=70.615 //y=1.085 //x2=70.16 //y2=1.085
cc_6388 ( N_noxref_20_c_9564_n N_noxref_21_M42_noxref_d ) capacitor \
 c=0.00326247f //x=70.615 //y=1.43 //x2=70.16 //y2=1.085
cc_6389 ( N_noxref_20_c_9565_n N_noxref_21_M42_noxref_d ) capacitor \
 c=0.00231463f //x=70.615 //y=1.74 //x2=70.16 //y2=1.085
cc_6390 ( N_noxref_20_c_9191_n N_VDD_c_10241_n ) capacitor c=0.00648267f \
 //x=20.615 //y=5.38 //x2=65.575 //y2=7.585
cc_6391 ( N_noxref_20_c_9275_n N_VDD_c_10241_n ) capacitor c=0.00492582f \
 //x=21.125 //y=5.38 //x2=65.575 //y2=7.585
cc_6392 ( N_noxref_20_c_9283_n N_VDD_c_10241_n ) capacitor c=4.3061e-19 \
 //x=21.21 //y=3.315 //x2=65.575 //y2=7.585
cc_6393 ( N_noxref_20_c_9201_n N_VDD_c_10241_n ) capacitor c=0.00368834f \
 //x=19.85 //y=5.56 //x2=65.575 //y2=7.585
cc_6394 ( N_noxref_20_c_9292_n N_VDD_c_10241_n ) capacitor c=8.42623e-19 \
 //x=20.73 //y=5.38 //x2=65.575 //y2=7.585
cc_6395 ( N_noxref_20_c_9688_p N_VDD_c_10241_n ) capacitor c=0.00285853f \
 //x=20.73 //y=5.56 //x2=65.575 //y2=7.585
cc_6396 ( N_noxref_20_c_9222_n N_VDD_c_10241_n ) capacitor c=0.00224881f \
 //x=19.85 //y=5.56 //x2=65.575 //y2=7.585
cc_6397 ( N_noxref_20_c_9307_n N_VDD_c_10241_n ) capacitor c=0.00224881f \
 //x=20.73 //y=5.56 //x2=65.575 //y2=7.585
cc_6398 ( N_noxref_20_M66_noxref_g N_VDD_c_10428_n ) capacitor c=0.00697352f \
 //x=17.18 //y=6.2 //x2=17.755 //y2=7.585
cc_6399 ( N_noxref_20_M67_noxref_g N_VDD_c_10428_n ) capacitor c=0.00755544f \
 //x=17.62 //y=6.2 //x2=17.755 //y2=7.585
cc_6400 ( N_noxref_20_c_9191_n N_VDD_c_10433_n ) capacitor c=0.00208087f \
 //x=20.615 //y=5.38 //x2=20.205 //y2=7.585
cc_6401 ( N_noxref_20_c_9201_n N_VDD_c_10433_n ) capacitor c=9.41185e-19 \
 //x=19.85 //y=5.56 //x2=20.205 //y2=7.585
cc_6402 ( N_noxref_20_c_9222_n N_VDD_c_10433_n ) capacitor c=0.0136705f \
 //x=19.85 //y=5.56 //x2=20.205 //y2=7.585
cc_6403 ( N_noxref_20_c_9191_n N_VDD_c_10492_n ) capacitor c=0.00180737f \
 //x=20.615 //y=5.38 //x2=21.085 //y2=7.585
cc_6404 ( N_noxref_20_c_9275_n N_VDD_c_10492_n ) capacitor c=0.00208087f \
 //x=21.125 //y=5.38 //x2=21.085 //y2=7.585
cc_6405 ( N_noxref_20_c_9292_n N_VDD_c_10492_n ) capacitor c=4.23719e-19 \
 //x=20.73 //y=5.38 //x2=21.085 //y2=7.585
cc_6406 ( N_noxref_20_c_9688_p N_VDD_c_10492_n ) capacitor c=5.77976e-19 \
 //x=20.73 //y=5.56 //x2=21.085 //y2=7.585
cc_6407 ( N_noxref_20_c_9307_n N_VDD_c_10492_n ) capacitor c=0.0136705f \
 //x=20.73 //y=5.56 //x2=21.085 //y2=7.585
cc_6408 ( N_noxref_20_M130_noxref_g N_VDD_c_11292_n ) capacitor c=0.00782837f \
 //x=70.08 //y=6.205 //x2=71.36 //y2=7.585
cc_6409 ( N_noxref_20_M131_noxref_g N_VDD_c_11292_n ) capacitor c=0.00782837f \
 //x=70.52 //y=6.205 //x2=71.36 //y2=7.585
cc_6410 ( N_noxref_20_M132_noxref_g N_VDD_c_11349_n ) capacitor c=0.00782837f \
 //x=72.54 //y=6.205 //x2=74.69 //y2=7.585
cc_6411 ( N_noxref_20_M133_noxref_g N_VDD_c_11349_n ) capacitor c=0.00782837f \
 //x=72.98 //y=6.205 //x2=74.69 //y2=7.585
cc_6412 ( N_noxref_20_c_9196_n N_VDD_c_10439_n ) capacitor c=0.0013228f \
 //x=21.21 //y=5.295 //x2=18.62 //y2=7.585
cc_6413 ( N_noxref_20_c_9201_n N_VDD_c_10439_n ) capacitor c=4.91377e-19 \
 //x=19.85 //y=5.56 //x2=18.62 //y2=7.585
cc_6414 ( N_noxref_20_c_9153_n N_VDD_c_10439_n ) capacitor c=0.00226427f \
 //x=17.17 //y=4.88 //x2=18.62 //y2=7.585
cc_6415 ( N_noxref_20_c_9222_n N_VDD_c_10439_n ) capacitor c=0.0064135f \
 //x=19.85 //y=5.56 //x2=18.62 //y2=7.585
cc_6416 ( N_noxref_20_c_9240_n N_VDD_c_10439_n ) capacitor c=0.0129149f \
 //x=17.545 //y=4.97 //x2=18.62 //y2=7.585
cc_6417 ( N_noxref_20_c_9172_n N_VDD_c_10439_n ) capacitor c=2.73429e-19 \
 //x=17.17 //y=4.88 //x2=18.62 //y2=7.585
cc_6418 ( N_noxref_20_c_9196_n N_VDD_c_10515_n ) capacitor c=0.0294562f \
 //x=21.21 //y=5.295 //x2=21.95 //y2=7.585
cc_6419 ( N_noxref_20_c_9292_n N_VDD_c_10515_n ) capacitor c=0.0025639f \
 //x=20.73 //y=5.38 //x2=21.95 //y2=7.585
cc_6420 ( N_noxref_20_c_9688_p N_VDD_c_10515_n ) capacitor c=4.19141e-19 \
 //x=20.73 //y=5.56 //x2=21.95 //y2=7.585
cc_6421 ( N_noxref_20_c_9305_n N_VDD_c_10515_n ) capacitor c=0.00265864f \
 //x=25.07 //y=3.125 //x2=21.95 //y2=7.585
cc_6422 ( N_noxref_20_c_9307_n N_VDD_c_10515_n ) capacitor c=0.0101861f \
 //x=20.73 //y=5.56 //x2=21.95 //y2=7.585
cc_6423 ( N_noxref_20_c_9365_n N_VDD_c_10822_n ) capacitor c=0.00265864f \
 //x=46.36 //y=3.14 //x2=43.41 //y2=7.585
cc_6424 ( N_noxref_20_c_9519_n N_VDD_c_11316_n ) capacitor c=0.0156004f \
 //x=70.79 //y=4.76 //x2=71.53 //y2=7.585
cc_6425 ( N_noxref_20_c_9524_n N_VDD_c_11316_n ) capacitor c=0.0163412f \
 //x=72.27 //y=4.755 //x2=71.53 //y2=7.585
cc_6426 ( N_noxref_20_c_9548_n N_VDD_c_11316_n ) capacitor c=0.00790417f \
 //x=70.79 //y=4.885 //x2=71.53 //y2=7.585
cc_6427 ( N_noxref_20_c_9615_n N_VDD_c_11316_n ) capacitor c=0.00790205f \
 //x=72.27 //y=4.885 //x2=71.53 //y2=7.585
cc_6428 ( N_noxref_20_M131_noxref_g N_VDD_c_11316_n ) capacitor c=0.0138263f \
 //x=70.52 //y=6.205 //x2=71.53 //y2=7.585
cc_6429 ( N_noxref_20_M132_noxref_g N_VDD_c_11316_n ) capacitor c=0.00855037f \
 //x=72.54 //y=6.205 //x2=71.53 //y2=7.585
cc_6430 ( N_noxref_20_c_9561_n N_VDD_c_11316_n ) capacitor c=0.00722671f \
 //x=70.52 //y=5.05 //x2=71.53 //y2=7.585
cc_6431 ( N_noxref_20_c_9629_n N_VDD_c_11316_n ) capacitor c=0.00720105f \
 //x=72.615 //y=4.975 //x2=71.53 //y2=7.585
cc_6432 ( N_noxref_20_M66_noxref_g N_VDD_M65_noxref_d ) capacitor c=0.015318f \
 //x=17.18 //y=6.2 //x2=16.815 //y2=5.2
cc_6433 ( N_noxref_20_c_9172_n N_VDD_M65_noxref_d ) capacitor c=3.32552e-19 \
 //x=17.17 //y=4.88 //x2=16.815 //y2=5.2
cc_6434 ( N_noxref_20_M67_noxref_g N_VDD_M67_noxref_d ) capacitor c=0.0430452f \
 //x=17.62 //y=6.2 //x2=17.695 //y2=5.2
cc_6435 ( N_noxref_20_c_9201_n N_VDD_M68_noxref_s ) capacitor c=0.0572211f \
 //x=19.85 //y=5.56 //x2=19.275 //y2=5.2
cc_6436 ( N_noxref_20_c_9292_n N_VDD_M68_noxref_s ) capacitor c=6.52457e-19 \
 //x=20.73 //y=5.38 //x2=19.275 //y2=5.2
cc_6437 ( N_noxref_20_c_9222_n N_VDD_M68_noxref_s ) capacitor c=0.0887533f \
 //x=19.85 //y=5.56 //x2=19.275 //y2=5.2
cc_6438 ( N_noxref_20_c_9191_n N_VDD_M69_noxref_d ) capacitor c=0.00734094f \
 //x=20.615 //y=5.38 //x2=20.145 //y2=5.2
cc_6439 ( N_noxref_20_c_9201_n N_VDD_M69_noxref_d ) capacitor c=0.0043528f \
 //x=19.85 //y=5.56 //x2=20.145 //y2=5.2
cc_6440 ( N_noxref_20_c_9688_p N_VDD_M69_noxref_d ) capacitor c=0.0043528f \
 //x=20.73 //y=5.56 //x2=20.145 //y2=5.2
cc_6441 ( N_noxref_20_c_9222_n N_VDD_M69_noxref_d ) capacitor c=0.065554f \
 //x=19.85 //y=5.56 //x2=20.145 //y2=5.2
cc_6442 ( N_noxref_20_c_9307_n N_VDD_M69_noxref_d ) capacitor c=0.065554f \
 //x=20.73 //y=5.56 //x2=20.145 //y2=5.2
cc_6443 ( N_noxref_20_c_9275_n N_VDD_M71_noxref_d ) capacitor c=0.00961919f \
 //x=21.125 //y=5.38 //x2=21.025 //y2=5.2
cc_6444 ( N_noxref_20_c_9688_p N_VDD_M71_noxref_d ) capacitor c=0.00955781f \
 //x=20.73 //y=5.56 //x2=21.025 //y2=5.2
cc_6445 ( N_noxref_20_c_9301_n N_VDD_M71_noxref_d ) capacitor c=8.01916e-19 \
 //x=21.21 //y=3.14 //x2=21.025 //y2=5.2
cc_6446 ( N_noxref_20_c_9307_n N_VDD_M71_noxref_d ) capacitor c=0.065554f \
 //x=20.73 //y=5.56 //x2=21.025 //y2=5.2
cc_6447 ( N_noxref_20_c_9275_n N_VDD_M72_noxref_s ) capacitor c=0.00220019f \
 //x=21.125 //y=5.38 //x2=22.905 //y2=5.2
cc_6448 ( N_noxref_20_c_9292_n N_VDD_M72_noxref_s ) capacitor c=0.00371125f \
 //x=20.73 //y=5.38 //x2=22.905 //y2=5.2
cc_6449 ( N_noxref_20_c_9688_p N_VDD_M72_noxref_s ) capacitor c=9.52042e-19 \
 //x=20.73 //y=5.56 //x2=22.905 //y2=5.2
cc_6450 ( N_noxref_20_c_9210_n N_noxref_24_M14_noxref_d ) capacitor \
 c=3.39394e-19 //x=20.77 //y=1.18 //x2=23.81 //y2=1.09
cc_6451 ( N_noxref_20_c_9365_n N_noxref_25_c_11792_n ) capacitor c=0.0285512f \
 //x=46.36 //y=3.14 //x2=42.67 //y2=5.295
cc_6452 ( N_noxref_20_M130_noxref_g N_noxref_27_c_12070_n ) capacitor \
 c=0.00814026f //x=70.08 //y=6.205 //x2=70.625 //y2=7.09
cc_6453 ( N_noxref_20_M131_noxref_g N_noxref_27_c_12070_n ) capacitor \
 c=0.00937408f //x=70.52 //y=6.205 //x2=70.625 //y2=7.09
cc_6454 ( N_noxref_20_M130_noxref_g N_noxref_27_c_12042_n ) capacitor \
 c=0.0017976f //x=70.08 //y=6.205 //x2=69.857 //y2=7.09
cc_6455 ( N_noxref_20_M131_noxref_g N_noxref_27_c_12073_n ) capacitor \
 c=0.00395674f //x=70.52 //y=6.205 //x2=70.74 //y2=6.92
cc_6456 ( N_noxref_20_M130_noxref_g N_noxref_27_M129_noxref_d ) capacitor \
 c=0.0142133f //x=70.08 //y=6.205 //x2=69.715 //y2=5.205
cc_6457 ( N_noxref_20_c_9548_n N_noxref_27_M131_noxref_d ) capacitor \
 c=0.00256087f //x=70.79 //y=4.885 //x2=70.595 //y2=5.205
cc_6458 ( N_noxref_20_M131_noxref_g N_noxref_27_M131_noxref_d ) capacitor \
 c=0.0365939f //x=70.52 //y=6.205 //x2=70.595 //y2=5.205
cc_6459 ( N_noxref_20_c_9561_n N_noxref_27_M131_noxref_d ) capacitor \
 c=0.00447202f //x=70.52 //y=5.05 //x2=70.595 //y2=5.205
cc_6460 ( N_noxref_20_M130_noxref_g N_noxref_28_c_12183_n ) capacitor \
 c=0.00998198f //x=70.08 //y=6.205 //x2=70.185 //y2=5.39
cc_6461 ( N_noxref_20_c_9514_n N_noxref_28_c_12195_n ) capacitor c=7.4208e-19 \
 //x=70.79 //y=2.43 //x2=72.205 //y2=5.39
cc_6462 ( N_noxref_20_c_9518_n N_noxref_28_c_12195_n ) capacitor c=0.00159771f \
 //x=70.79 //y=3.3 //x2=72.205 //y2=5.39
cc_6463 ( N_noxref_20_c_9519_n N_noxref_28_c_12195_n ) capacitor c=0.0227143f \
 //x=70.79 //y=4.76 //x2=72.205 //y2=5.39
cc_6464 ( N_noxref_20_c_9577_n N_noxref_28_c_12195_n ) capacitor c=0.00141341f \
 //x=72.27 //y=2.43 //x2=72.205 //y2=5.39
cc_6465 ( N_noxref_20_c_9524_n N_noxref_28_c_12195_n ) capacitor c=0.0274606f \
 //x=72.27 //y=4.755 //x2=72.205 //y2=5.39
cc_6466 ( N_noxref_20_c_9548_n N_noxref_28_c_12195_n ) capacitor c=0.0035251f \
 //x=70.79 //y=4.885 //x2=72.205 //y2=5.39
cc_6467 ( N_noxref_20_c_9615_n N_noxref_28_c_12195_n ) capacitor c=0.00429429f \
 //x=72.27 //y=4.885 //x2=72.205 //y2=5.39
cc_6468 ( N_noxref_20_M131_noxref_g N_noxref_28_c_12195_n ) capacitor \
 c=0.0117303f //x=70.52 //y=6.205 //x2=72.205 //y2=5.39
cc_6469 ( N_noxref_20_M132_noxref_g N_noxref_28_c_12195_n ) capacitor \
 c=0.00372569f //x=72.54 //y=6.205 //x2=72.205 //y2=5.39
cc_6470 ( N_noxref_20_c_9561_n N_noxref_28_c_12195_n ) capacitor c=0.00489042f \
 //x=70.52 //y=5.05 //x2=72.205 //y2=5.39
cc_6471 ( N_noxref_20_c_9629_n N_noxref_28_c_12195_n ) capacitor c=0.00243015f \
 //x=72.615 //y=4.975 //x2=72.205 //y2=5.39
cc_6472 ( N_noxref_20_M130_noxref_g N_noxref_28_c_12196_n ) capacitor \
 c=6.12451e-19 //x=70.08 //y=6.205 //x2=70.415 //y2=5.39
cc_6473 ( N_noxref_20_M131_noxref_g N_noxref_28_c_12196_n ) capacitor \
 c=8.33934e-19 //x=70.52 //y=6.205 //x2=70.415 //y2=5.39
cc_6474 ( N_noxref_20_M132_noxref_g N_noxref_28_c_12221_n ) capacitor \
 c=0.0109238f //x=72.54 //y=6.205 //x2=73.085 //y2=7.09
cc_6475 ( N_noxref_20_M133_noxref_g N_noxref_28_c_12221_n ) capacitor \
 c=0.00814026f //x=72.98 //y=6.205 //x2=73.085 //y2=7.09
cc_6476 ( N_noxref_20_M130_noxref_g N_noxref_28_c_12200_n ) capacitor \
 c=0.00610004f //x=70.08 //y=6.205 //x2=70.3 //y2=5.39
cc_6477 ( N_noxref_20_M131_noxref_g N_noxref_28_c_12200_n ) capacitor \
 c=0.00485827f //x=70.52 //y=6.205 //x2=70.3 //y2=5.39
cc_6478 ( N_noxref_20_c_9771_p N_noxref_28_c_12200_n ) capacitor c=0.00435703f \
 //x=70.445 //y=4.975 //x2=70.3 //y2=5.39
cc_6479 ( N_noxref_20_M132_noxref_g N_noxref_28_c_12226_n ) capacitor \
 c=0.00394587f //x=72.54 //y=6.205 //x2=72.32 //y2=6.92
cc_6480 ( N_noxref_20_M133_noxref_g N_noxref_28_c_12201_n ) capacitor \
 c=0.00179267f //x=72.98 //y=6.205 //x2=73.2 //y2=7.09
cc_6481 ( N_noxref_20_c_9524_n N_noxref_28_c_12203_n ) capacitor c=0.00533094f \
 //x=72.27 //y=4.755 //x2=72.32 //y2=5.39
cc_6482 ( N_noxref_20_c_9615_n N_noxref_28_c_12203_n ) capacitor c=0.013929f \
 //x=72.27 //y=4.885 //x2=72.32 //y2=5.39
cc_6483 ( N_noxref_20_M132_noxref_g N_noxref_28_c_12203_n ) capacitor \
 c=0.0510602f //x=72.54 //y=6.205 //x2=72.32 //y2=5.39
cc_6484 ( N_noxref_20_c_9629_n N_noxref_28_c_12203_n ) capacitor c=0.00827092f \
 //x=72.615 //y=4.975 //x2=72.32 //y2=5.39
cc_6485 ( N_noxref_20_M133_noxref_g N_noxref_28_M133_noxref_d ) capacitor \
 c=0.0142133f //x=72.98 //y=6.205 //x2=73.055 //y2=5.205
cc_6486 ( N_noxref_20_c_9144_n N_GND_c_12460_n ) capacitor c=0.00215229f \
 //x=17.14 //y=2.26 //x2=19.715 //y2=0.175
cc_6487 ( N_noxref_20_c_9276_n N_GND_c_12505_n ) capacitor c=0.00618782f \
 //x=21.125 //y=1.835 //x2=22.94 //y2=0.175
cc_6488 ( N_noxref_20_c_9283_n N_GND_c_12505_n ) capacitor c=3.4449e-19 \
 //x=21.21 //y=3.315 //x2=22.94 //y2=0.175
cc_6489 ( N_noxref_20_c_9210_n N_GND_c_12505_n ) capacitor c=0.00937893f \
 //x=20.77 //y=1.18 //x2=22.94 //y2=0.175
cc_6490 ( N_noxref_20_M12_noxref_d N_GND_c_12505_n ) capacitor c=3.01769e-19 \
 //x=20.58 //y=1.085 //x2=22.94 //y2=0.175
cc_6491 ( N_noxref_20_c_9514_n N_GND_c_13181_n ) capacitor c=9.61977e-19 \
 //x=70.79 //y=2.43 //x2=72.625 //y2=0.175
cc_6492 ( N_noxref_20_c_9577_n N_GND_c_13181_n ) capacitor c=0.00100426f \
 //x=72.27 //y=2.43 //x2=72.625 //y2=0.175
cc_6493 ( N_noxref_20_c_9612_n N_GND_c_13181_n ) capacitor c=2.64659e-19 \
 //x=72.27 //y=2.26 //x2=72.625 //y2=0.175
cc_6494 ( N_noxref_20_c_9621_n N_GND_c_13184_n ) capacitor c=0.00175518f \
 //x=72.445 //y=1.045 //x2=72.71 //y2=1.02
cc_6495 ( N_noxref_20_c_9622_n N_GND_c_13184_n ) capacitor c=0.00372974f \
 //x=72.445 //y=1.39 //x2=72.71 //y2=1.02
cc_6496 ( N_noxref_20_c_9623_n N_GND_c_13184_n ) capacitor c=3.99385e-19 \
 //x=72.445 //y=1.7 //x2=72.71 //y2=1.02
cc_6497 ( N_noxref_20_c_9790_p N_GND_c_13184_n ) capacitor c=0.00924233f \
 //x=72.82 //y=0.89 //x2=72.71 //y2=1.02
cc_6498 ( N_noxref_20_c_9791_p N_GND_c_13184_n ) capacitor c=6.20182e-19 \
 //x=72.82 //y=1.545 //x2=72.71 //y2=1.02
cc_6499 ( N_noxref_20_c_9632_n N_GND_c_13184_n ) capacitor c=0.00181395f \
 //x=72.975 //y=1.045 //x2=72.71 //y2=1.02
cc_6500 ( N_noxref_20_c_9634_n N_GND_c_13184_n ) capacitor c=0.00394995f \
 //x=72.975 //y=1.39 //x2=72.71 //y2=1.02
cc_6501 ( N_noxref_20_c_9201_n N_GND_c_12467_n ) capacitor c=6.6085e-19 \
 //x=19.85 //y=5.56 //x2=19.8 //y2=1.135
cc_6502 ( N_noxref_20_c_9210_n N_GND_c_12467_n ) capacitor c=0.0140087f \
 //x=20.77 //y=1.18 //x2=19.8 //y2=1.135
cc_6503 ( N_noxref_20_M12_noxref_d N_GND_c_12467_n ) capacitor c=2.93544e-19 \
 //x=20.58 //y=1.085 //x2=19.8 //y2=1.135
cc_6504 ( N_noxref_20_c_9210_n N_GND_c_12731_n ) capacitor c=0.00606355f \
 //x=20.77 //y=1.18 //x2=23.025 //y2=1.145
cc_6505 ( N_noxref_20_c_9144_n N_GND_c_12432_n ) capacitor c=3.77328e-19 \
 //x=17.14 //y=2.26 //x2=18.45 //y2=0.175
cc_6506 ( N_noxref_20_c_9276_n N_GND_c_12481_n ) capacitor c=7.75992e-19 \
 //x=21.125 //y=1.835 //x2=21.78 //y2=0.175
cc_6507 ( N_noxref_20_c_9283_n N_GND_c_12481_n ) capacitor c=3.87891e-19 \
 //x=21.21 //y=3.315 //x2=21.78 //y2=0.175
cc_6508 ( N_noxref_20_c_9514_n N_GND_c_13102_n ) capacitor c=9.41779e-19 \
 //x=70.79 //y=2.43 //x2=71.36 //y2=0.175
cc_6509 ( N_noxref_20_c_9577_n N_GND_c_13157_n ) capacitor c=6.59434e-19 \
 //x=72.27 //y=2.43 //x2=74.69 //y2=0.175
cc_6510 ( N_noxref_20_c_9621_n N_GND_c_13157_n ) capacitor c=0.00698682f \
 //x=72.445 //y=1.045 //x2=74.69 //y2=0.175
cc_6511 ( N_noxref_20_c_9194_n N_GND_c_12483_n ) capacitor c=9.32616e-19 \
 //x=21.21 //y=2.995 //x2=18.62 //y2=0.175
cc_6512 ( N_noxref_20_c_9211_n N_GND_c_12483_n ) capacitor c=0.00411812f \
 //x=21.04 //y=3.14 //x2=18.62 //y2=0.175
cc_6513 ( N_noxref_20_c_9149_n N_GND_c_12483_n ) capacitor c=0.00224736f \
 //x=17.14 //y=2.26 //x2=18.62 //y2=0.175
cc_6514 ( N_noxref_20_c_9168_n N_GND_c_12483_n ) capacitor c=0.00275184f \
 //x=17.705 //y=1.43 //x2=18.62 //y2=0.175
cc_6515 ( N_noxref_20_c_9169_n N_GND_c_12483_n ) capacitor c=2.63786e-19 \
 //x=17.14 //y=2.26 //x2=18.62 //y2=0.175
cc_6516 ( N_noxref_20_c_9192_n N_GND_c_12535_n ) capacitor c=0.00460657f \
 //x=20.77 //y=1.75 //x2=21.95 //y2=0.175
cc_6517 ( N_noxref_20_c_9276_n N_GND_c_12535_n ) capacitor c=0.0295392f \
 //x=21.125 //y=1.835 //x2=21.95 //y2=0.175
cc_6518 ( N_noxref_20_c_9305_n N_GND_c_12535_n ) capacitor c=0.00411812f \
 //x=25.07 //y=3.125 //x2=21.95 //y2=0.175
cc_6519 ( N_noxref_20_c_9321_n N_GND_c_12569_n ) capacitor c=0.00411812f \
 //x=28.21 //y=3.14 //x2=26.76 //y2=0.175
cc_6520 ( N_noxref_20_c_9331_n N_GND_c_12573_n ) capacitor c=0.00411812f \
 //x=30.81 //y=3.14 //x2=30.09 //y2=0.175
cc_6521 ( N_noxref_20_c_9342_n N_GND_c_12612_n ) capacitor c=0.00411812f \
 //x=34.14 //y=3.14 //x2=33.42 //y2=0.175
cc_6522 ( N_noxref_20_c_9365_n N_GND_c_12666_n ) capacitor c=0.00411812f \
 //x=46.36 //y=3.14 //x2=36.75 //y2=0.175
cc_6523 ( N_noxref_20_c_9365_n N_GND_c_12708_n ) capacitor c=0.00411812f \
 //x=46.36 //y=3.14 //x2=40.08 //y2=0.175
cc_6524 ( N_noxref_20_c_9365_n N_GND_c_12760_n ) capacitor c=0.00411812f \
 //x=46.36 //y=3.14 //x2=43.41 //y2=0.175
cc_6525 ( N_noxref_20_c_9423_n N_GND_c_12823_n ) capacitor c=0.00411812f \
 //x=50.42 //y=3.14 //x2=48.22 //y2=0.175
cc_6526 ( N_noxref_20_c_9441_n N_GND_c_12825_n ) capacitor c=0.00504399f \
 //x=52.27 //y=3.14 //x2=51.55 //y2=0.175
cc_6527 ( N_noxref_20_c_9452_n N_GND_c_12895_n ) capacitor c=0.00504399f \
 //x=55.6 //y=3.14 //x2=54.88 //y2=0.175
cc_6528 ( N_noxref_20_c_9455_n N_GND_c_12925_n ) capacitor c=0.00504399f \
 //x=56.2 //y=3.125 //x2=58.21 //y2=0.175
cc_6529 ( N_noxref_20_c_9455_n N_GND_c_13009_n ) capacitor c=0.00504399f \
 //x=56.2 //y=3.125 //x2=61.54 //y2=0.175
cc_6530 ( N_noxref_20_c_9455_n N_GND_c_13061_n ) capacitor c=0.00504399f \
 //x=56.2 //y=3.125 //x2=64.87 //y2=0.175
cc_6531 ( N_noxref_20_c_9455_n N_GND_c_13115_n ) capacitor c=0.00661596f \
 //x=56.2 //y=3.125 //x2=68.2 //y2=0.175
cc_6532 ( N_noxref_20_c_9544_n N_GND_c_13115_n ) capacitor c=3.88707e-19 \
 //x=70.79 //y=2.26 //x2=68.2 //y2=0.175
cc_6533 ( N_noxref_20_c_9514_n N_GND_c_13172_n ) capacitor c=0.00414357f \
 //x=70.79 //y=2.43 //x2=71.53 //y2=0.175
cc_6534 ( N_noxref_20_c_9517_n N_GND_c_13172_n ) capacitor c=0.0117547f \
 //x=70.79 //y=2.98 //x2=71.53 //y2=0.175
cc_6535 ( N_noxref_20_c_9577_n N_GND_c_13172_n ) capacitor c=0.00414357f \
 //x=72.27 //y=2.43 //x2=71.53 //y2=0.175
cc_6536 ( N_noxref_20_c_9524_n N_GND_c_13172_n ) capacitor c=0.0117547f \
 //x=72.27 //y=4.755 //x2=71.53 //y2=0.175
cc_6537 ( N_noxref_20_c_9611_n N_GND_c_13172_n ) capacitor c=0.0153655f \
 //x=72.105 //y=2.27 //x2=71.53 //y2=0.175
cc_6538 ( N_noxref_20_c_9544_n N_GND_c_13172_n ) capacitor c=0.00780676f \
 //x=70.79 //y=2.26 //x2=71.53 //y2=0.175
cc_6539 ( N_noxref_20_c_9612_n N_GND_c_13172_n ) capacitor c=0.00780676f \
 //x=72.27 //y=2.26 //x2=71.53 //y2=0.175
cc_6540 ( N_noxref_20_c_9566_n N_GND_c_13172_n ) capacitor c=0.00967557f \
 //x=70.615 //y=2.095 //x2=71.53 //y2=0.175
cc_6541 ( N_noxref_20_c_9625_n N_GND_c_13172_n ) capacitor c=0.00347725f \
 //x=72.445 //y=2.095 //x2=71.53 //y2=0.175
cc_6542 ( N_noxref_20_c_9638_n N_GND_c_13172_n ) capacitor c=0.00619832f \
 //x=72.27 //y=2.26 //x2=71.53 //y2=0.175
cc_6543 ( N_noxref_20_c_9612_n N_GND_c_13173_n ) capacitor c=2.74348e-19 \
 //x=72.27 //y=2.26 //x2=74.86 //y2=0.175
cc_6544 ( N_noxref_20_c_9210_n N_GND_M11_noxref_d ) capacitor c=2.82748e-19 \
 //x=20.77 //y=1.18 //x2=19.61 //y2=1.045
cc_6545 ( N_noxref_20_c_9621_n N_GND_M43_noxref_d ) capacitor c=0.00192399f \
 //x=72.445 //y=1.045 //x2=72.52 //y2=1.045
cc_6546 ( N_noxref_20_c_9622_n N_GND_M43_noxref_d ) capacitor c=0.00210798f \
 //x=72.445 //y=1.39 //x2=72.52 //y2=1.045
cc_6547 ( N_noxref_20_c_9790_p N_GND_M43_noxref_d ) capacitor c=0.00472259f \
 //x=72.82 //y=0.89 //x2=72.52 //y2=1.045
cc_6548 ( N_noxref_20_c_9791_p N_GND_M43_noxref_d ) capacitor c=0.00166857f \
 //x=72.82 //y=1.545 //x2=72.52 //y2=1.045
cc_6549 ( N_noxref_20_c_9632_n N_GND_M43_noxref_d ) capacitor c=0.00230174f \
 //x=72.975 //y=1.045 //x2=72.52 //y2=1.045
cc_6550 ( N_noxref_20_c_9634_n N_GND_M43_noxref_d ) capacitor c=0.00210798f \
 //x=72.975 //y=1.39 //x2=72.52 //y2=1.045
cc_6551 ( N_noxref_20_c_9135_n N_noxref_35_c_14249_n ) capacitor c=0.00105819f \
 //x=17.14 //y=3.315 //x2=16.955 //y2=1.675
cc_6552 ( N_noxref_20_c_9144_n N_noxref_35_c_14249_n ) capacitor c=7.50092e-19 \
 //x=17.14 //y=2.26 //x2=16.955 //y2=1.675
cc_6553 ( N_noxref_20_c_9164_n N_noxref_35_c_14249_n ) capacitor c=0.00888238f \
 //x=17.175 //y=1.74 //x2=16.955 //y2=1.675
cc_6554 ( N_noxref_20_c_9169_n N_noxref_35_c_14249_n ) capacitor c=0.00173991f \
 //x=17.14 //y=2.26 //x2=16.955 //y2=1.675
cc_6555 ( N_noxref_20_c_9135_n N_noxref_35_c_14254_n ) capacitor c=3.48123e-19 \
 //x=17.14 //y=3.315 //x2=17.84 //y2=0.71
cc_6556 ( N_noxref_20_c_9144_n N_noxref_35_c_14254_n ) capacitor c=0.001463f \
 //x=17.14 //y=2.26 //x2=17.84 //y2=0.71
cc_6557 ( N_noxref_20_c_9149_n N_noxref_35_c_14254_n ) capacitor c=8.82141e-19 \
 //x=17.14 //y=2.26 //x2=17.84 //y2=0.71
cc_6558 ( N_noxref_20_c_9159_n N_noxref_35_c_14254_n ) capacitor c=0.0200738f \
 //x=17.175 //y=1.085 //x2=17.84 //y2=0.71
cc_6559 ( N_noxref_20_c_9167_n N_noxref_35_c_14254_n ) capacitor c=0.00825432f \
 //x=17.705 //y=1.085 //x2=17.84 //y2=0.71
cc_6560 ( N_noxref_20_c_9169_n N_noxref_35_c_14254_n ) capacitor c=2.1838e-19 \
 //x=17.14 //y=2.26 //x2=17.84 //y2=0.71
cc_6561 ( N_noxref_20_c_9159_n N_noxref_35_M9_noxref_s ) capacitor \
 c=0.00888238f //x=17.175 //y=1.085 //x2=15.85 //y2=0.545
cc_6562 ( N_noxref_20_c_9167_n N_noxref_35_M9_noxref_s ) capacitor c=0.015333f \
 //x=17.705 //y=1.085 //x2=15.85 //y2=0.545
cc_6563 ( N_noxref_20_c_9168_n N_noxref_35_M9_noxref_s ) capacitor \
 c=0.00248746f //x=17.705 //y=1.43 //x2=15.85 //y2=0.545
cc_6564 ( N_noxref_20_c_9193_n N_noxref_36_c_14319_n ) capacitor c=0.00911498f \
 //x=20.855 //y=1.835 //x2=20.285 //y2=1.675
cc_6565 ( N_noxref_20_c_9276_n N_noxref_36_c_14327_n ) capacitor c=0.00399245f \
 //x=21.125 //y=1.835 //x2=21.17 //y2=0.71
cc_6566 ( N_noxref_20_c_9210_n N_noxref_36_c_14327_n ) capacitor c=0.003751f \
 //x=20.77 //y=1.18 //x2=21.17 //y2=0.71
cc_6567 ( N_noxref_20_M12_noxref_d N_noxref_36_c_14327_n ) capacitor \
 c=0.00910163f //x=20.58 //y=1.085 //x2=21.17 //y2=0.71
cc_6568 ( N_noxref_20_c_9192_n N_noxref_36_M11_noxref_s ) capacitor \
 c=0.0175047f //x=20.77 //y=1.75 //x2=19.18 //y2=0.545
cc_6569 ( N_noxref_20_c_9276_n N_noxref_36_M11_noxref_s ) capacitor \
 c=0.00603051f //x=21.125 //y=1.835 //x2=19.18 //y2=0.545
cc_6570 ( N_noxref_20_c_9283_n N_noxref_36_M11_noxref_s ) capacitor \
 c=5.54596e-19 //x=21.21 //y=3.315 //x2=19.18 //y2=0.545
cc_6571 ( N_noxref_20_c_9210_n N_noxref_36_M11_noxref_s ) capacitor \
 c=0.00894261f //x=20.77 //y=1.18 //x2=19.18 //y2=0.545
cc_6572 ( N_noxref_20_c_9301_n N_noxref_36_M11_noxref_s ) capacitor \
 c=0.00140776f //x=21.21 //y=3.14 //x2=19.18 //y2=0.545
cc_6573 ( N_noxref_20_M12_noxref_d N_noxref_36_M11_noxref_s ) capacitor \
 c=0.0275552f //x=20.58 //y=1.085 //x2=19.18 //y2=0.545
cc_6574 ( N_noxref_20_c_9455_n N_noxref_49_M39_noxref_s ) capacitor \
 c=0.00237459f //x=56.2 //y=3.125 //x2=65.43 //y2=0.545
cc_6575 ( N_noxref_20_M130_noxref_g noxref_50 ) capacitor c=0.00925495f \
 //x=70.08 //y=6.205 //x2=70.155 //y2=5.205
cc_6576 ( N_noxref_20_M131_noxref_g noxref_50 ) capacitor c=0.00925495f \
 //x=70.52 //y=6.205 //x2=70.155 //y2=5.205
cc_6577 ( N_noxref_20_c_9455_n N_noxref_51_c_15262_n ) capacitor c=0.00211705f \
 //x=56.2 //y=3.125 //x2=68.895 //y2=1.675
cc_6578 ( N_noxref_20_c_9455_n N_noxref_51_c_15263_n ) capacitor c=0.00769826f \
 //x=56.2 //y=3.125 //x2=69.78 //y2=1.76
cc_6579 ( N_noxref_20_c_9455_n N_noxref_51_c_15270_n ) capacitor c=0.00237459f \
 //x=56.2 //y=3.125 //x2=69.865 //y2=1.675
cc_6580 ( N_noxref_20_c_9566_n N_noxref_51_c_15270_n ) capacitor c=0.0028747f \
 //x=70.615 //y=2.095 //x2=69.865 //y2=1.675
cc_6581 ( N_noxref_20_c_9514_n N_noxref_51_c_15278_n ) capacitor c=6.64536e-19 \
 //x=70.79 //y=2.43 //x2=70.75 //y2=0.71
cc_6582 ( N_noxref_20_c_9518_n N_noxref_51_c_15278_n ) capacitor c=5.6989e-19 \
 //x=70.79 //y=3.3 //x2=70.75 //y2=0.71
cc_6583 ( N_noxref_20_c_9554_n N_noxref_51_c_15278_n ) capacitor c=0.0214576f \
 //x=70.085 //y=1.085 //x2=70.75 //y2=0.71
cc_6584 ( N_noxref_20_c_9563_n N_noxref_51_c_15278_n ) capacitor c=0.00781103f \
 //x=70.615 //y=1.085 //x2=70.75 //y2=0.71
cc_6585 ( N_noxref_20_c_9514_n N_noxref_51_M41_noxref_s ) capacitor \
 c=0.00472586f //x=70.79 //y=2.43 //x2=68.76 //y2=0.545
cc_6586 ( N_noxref_20_c_9544_n N_noxref_51_M41_noxref_s ) capacitor \
 c=0.010408f //x=70.79 //y=2.26 //x2=68.76 //y2=0.545
cc_6587 ( N_noxref_20_c_9554_n N_noxref_51_M41_noxref_s ) capacitor \
 c=0.00506846f //x=70.085 //y=1.085 //x2=68.76 //y2=0.545
cc_6588 ( N_noxref_20_c_9557_n N_noxref_51_M41_noxref_s ) capacitor \
 c=0.00602248f //x=70.085 //y=1.43 //x2=68.76 //y2=0.545
cc_6589 ( N_noxref_20_c_9563_n N_noxref_51_M41_noxref_s ) capacitor \
 c=0.028957f //x=70.615 //y=1.085 //x2=68.76 //y2=0.545
cc_6590 ( N_noxref_20_c_9565_n N_noxref_51_M41_noxref_s ) capacitor \
 c=0.00369225f //x=70.615 //y=1.74 //x2=68.76 //y2=0.545
cc_6591 ( N_noxref_20_c_9566_n N_noxref_51_M41_noxref_s ) capacitor \
 c=0.00797698f //x=70.615 //y=2.095 //x2=68.76 //y2=0.545
cc_6592 ( N_noxref_20_c_9577_n N_noxref_52_c_15339_n ) capacitor c=0.00472586f \
 //x=72.27 //y=2.43 //x2=72.225 //y2=1.675
cc_6593 ( N_noxref_20_c_9612_n N_noxref_52_c_15339_n ) capacitor c=0.010408f \
 //x=72.27 //y=2.26 //x2=72.225 //y2=1.675
cc_6594 ( N_noxref_20_c_9625_n N_noxref_52_c_15339_n ) capacitor c=0.00262672f \
 //x=72.445 //y=2.095 //x2=72.225 //y2=1.675
cc_6595 ( N_noxref_20_c_9638_n N_noxref_52_c_15339_n ) capacitor c=0.00544234f \
 //x=72.27 //y=2.26 //x2=72.225 //y2=1.675
cc_6596 ( N_noxref_20_c_9577_n N_noxref_52_c_15326_n ) capacitor c=0.00350518f \
 //x=72.27 //y=2.43 //x2=73.11 //y2=1.76
cc_6597 ( N_noxref_20_c_9612_n N_noxref_52_c_15326_n ) capacitor c=0.00305795f \
 //x=72.27 //y=2.26 //x2=73.11 //y2=1.76
cc_6598 ( N_noxref_20_c_9623_n N_noxref_52_c_15326_n ) capacitor c=0.00712798f \
 //x=72.445 //y=1.7 //x2=73.11 //y2=1.76
cc_6599 ( N_noxref_20_c_9625_n N_noxref_52_c_15326_n ) capacitor c=0.013968f \
 //x=72.445 //y=2.095 //x2=73.11 //y2=1.76
cc_6600 ( N_noxref_20_c_9791_p N_noxref_52_c_15326_n ) capacitor c=0.00948889f \
 //x=72.82 //y=1.545 //x2=73.11 //y2=1.76
cc_6601 ( N_noxref_20_c_9634_n N_noxref_52_c_15326_n ) capacitor c=0.00339872f \
 //x=72.975 //y=1.39 //x2=73.11 //y2=1.76
cc_6602 ( N_noxref_20_c_9638_n N_noxref_52_c_15326_n ) capacitor c=0.00168631f \
 //x=72.27 //y=2.26 //x2=73.11 //y2=1.76
cc_6603 ( N_noxref_20_c_9625_n N_noxref_52_c_15327_n ) capacitor c=6.71402e-19 \
 //x=72.445 //y=2.095 //x2=73.195 //y2=1.675
cc_6604 ( N_noxref_20_c_9621_n N_noxref_52_M43_noxref_s ) capacitor \
 c=0.0293163f //x=72.445 //y=1.045 //x2=72.09 //y2=0.545
cc_6605 ( N_noxref_20_c_9623_n N_noxref_52_M43_noxref_s ) capacitor \
 c=0.00110192f //x=72.445 //y=1.7 //x2=72.09 //y2=0.545
cc_6606 ( N_noxref_20_c_9632_n N_noxref_52_M43_noxref_s ) capacitor \
 c=0.0123625f //x=72.975 //y=1.045 //x2=72.09 //y2=0.545
cc_6607 ( N_noxref_21_c_9925_n N_VDD_c_11434_n ) capacitor c=2.26208e-19 \
 //x=74.035 //y=5.39 //x2=76.34 //y2=7.58
cc_6608 ( N_noxref_21_c_9935_n N_VDD_c_11434_n ) capacitor c=4.99801e-19 \
 //x=74.12 //y=4.415 //x2=76.34 //y2=7.58
cc_6609 ( N_noxref_21_c_10031_p N_VDD_c_11434_n ) capacitor c=3.0454e-19 \
 //x=75.6 //y=4.415 //x2=76.34 //y2=7.58
cc_6610 ( N_noxref_21_c_9944_n N_VDD_c_11434_n ) capacitor c=5.73169e-19 \
 //x=75.6 //y=4.76 //x2=76.34 //y2=7.58
cc_6611 ( N_noxref_21_c_10033_p N_VDD_c_11434_n ) capacitor c=3.40755e-19 \
 //x=75.6 //y=4.88 //x2=76.34 //y2=7.58
cc_6612 ( N_noxref_21_c_9925_n N_VDD_c_11349_n ) capacitor c=0.00135523f \
 //x=74.035 //y=5.39 //x2=74.69 //y2=7.585
cc_6613 ( N_noxref_21_c_9935_n N_VDD_c_11349_n ) capacitor c=4.02953e-19 \
 //x=74.12 //y=4.415 //x2=74.69 //y2=7.585
cc_6614 ( N_noxref_21_c_10019_n N_VDD_c_11349_n ) capacitor c=0.00488797f \
 //x=72.76 //y=5.56 //x2=74.69 //y2=7.585
cc_6615 ( N_noxref_21_c_9970_n N_VDD_c_11349_n ) capacitor c=0.00513429f \
 //x=73.64 //y=5.56 //x2=74.69 //y2=7.585
cc_6616 ( N_noxref_21_c_9944_n N_VDD_c_11443_n ) capacitor c=5.48929e-19 \
 //x=75.6 //y=4.76 //x2=76.33 //y2=7.585
cc_6617 ( N_noxref_21_M136_noxref_g N_VDD_c_11443_n ) capacitor c=0.00753931f \
 //x=75.755 //y=6.2 //x2=76.33 //y2=7.585
cc_6618 ( N_noxref_21_M137_noxref_g N_VDD_c_11443_n ) capacitor c=0.00755544f \
 //x=76.195 //y=6.2 //x2=76.33 //y2=7.585
cc_6619 ( N_noxref_21_c_9939_n N_VDD_c_11316_n ) capacitor c=0.00128037f \
 //x=74.12 //y=5.305 //x2=71.53 //y2=7.585
cc_6620 ( N_noxref_21_c_10019_n N_VDD_c_11316_n ) capacitor c=0.00535462f \
 //x=72.76 //y=5.56 //x2=71.53 //y2=7.585
cc_6621 ( N_noxref_21_c_9935_n N_VDD_c_11366_n ) capacitor c=0.0019054f \
 //x=74.12 //y=4.415 //x2=74.86 //y2=7.585
cc_6622 ( N_noxref_21_c_9939_n N_VDD_c_11366_n ) capacitor c=0.0249794f \
 //x=74.12 //y=5.305 //x2=74.86 //y2=7.585
cc_6623 ( N_noxref_21_c_10031_p N_VDD_c_11366_n ) capacitor c=0.0019054f \
 //x=75.6 //y=4.415 //x2=74.86 //y2=7.585
cc_6624 ( N_noxref_21_c_9944_n N_VDD_c_11366_n ) capacitor c=0.0128286f \
 //x=75.6 //y=4.76 //x2=74.86 //y2=7.585
cc_6625 ( N_noxref_21_c_9954_n N_VDD_c_11366_n ) capacitor c=0.00265362f \
 //x=73.637 //y=5.39 //x2=74.86 //y2=7.585
cc_6626 ( N_noxref_21_c_9958_n N_VDD_c_11366_n ) capacitor c=0.00486566f \
 //x=74.12 //y=4.25 //x2=74.86 //y2=7.585
cc_6627 ( N_noxref_21_c_10049_p N_VDD_c_11366_n ) capacitor c=0.00486566f \
 //x=75.6 //y=4.25 //x2=74.86 //y2=7.585
cc_6628 ( N_noxref_21_c_10050_p N_VDD_c_11366_n ) capacitor c=0.0183218f \
 //x=75.44 //y=4.255 //x2=74.86 //y2=7.585
cc_6629 ( N_noxref_21_c_9970_n N_VDD_c_11366_n ) capacitor c=0.00899475f \
 //x=73.64 //y=5.56 //x2=74.86 //y2=7.585
cc_6630 ( N_noxref_21_c_10033_p N_VDD_c_11366_n ) capacitor c=0.0079528f \
 //x=75.6 //y=4.88 //x2=74.86 //y2=7.585
cc_6631 ( N_noxref_21_M136_noxref_g N_VDD_c_11366_n ) capacitor c=0.00873815f \
 //x=75.755 //y=6.2 //x2=74.86 //y2=7.585
cc_6632 ( N_noxref_21_c_10054_p N_VDD_c_11366_n ) capacitor c=0.00799922f \
 //x=75.83 //y=4.97 //x2=74.86 //y2=7.585
cc_6633 ( N_noxref_21_c_10049_p N_VDD_c_11460_n ) capacitor c=0.00143727f \
 //x=75.6 //y=4.25 //x2=76.34 //y2=7.58
cc_6634 ( N_noxref_21_c_10033_p N_VDD_c_11460_n ) capacitor c=0.00235165f \
 //x=75.6 //y=4.88 //x2=76.34 //y2=7.58
cc_6635 ( N_noxref_21_c_10057_p N_VDD_c_11460_n ) capacitor c=0.0195827f \
 //x=76.12 //y=4.97 //x2=76.34 //y2=7.58
cc_6636 ( N_noxref_21_c_10054_p N_VDD_c_11460_n ) capacitor c=2.63786e-19 \
 //x=75.83 //y=4.97 //x2=76.34 //y2=7.58
cc_6637 ( N_noxref_21_c_9925_n N_VDD_M136_noxref_s ) capacitor c=0.00343522f \
 //x=74.035 //y=5.39 //x2=75.4 //y2=5.2
cc_6638 ( N_noxref_21_c_10031_p N_VDD_M136_noxref_s ) capacitor c=0.00247632f \
 //x=75.6 //y=4.415 //x2=75.4 //y2=5.2
cc_6639 ( N_noxref_21_c_9944_n N_VDD_M136_noxref_s ) capacitor c=0.0208734f \
 //x=75.6 //y=4.76 //x2=75.4 //y2=5.2
cc_6640 ( N_noxref_21_c_9954_n N_VDD_M136_noxref_s ) capacitor c=0.00575207f \
 //x=73.637 //y=5.39 //x2=75.4 //y2=5.2
cc_6641 ( N_noxref_21_c_10063_p N_VDD_M136_noxref_s ) capacitor c=6.60267e-19 \
 //x=75.6 //y=4.255 //x2=75.4 //y2=5.2
cc_6642 ( N_noxref_21_c_10050_p N_VDD_M136_noxref_s ) capacitor c=3.46335e-19 \
 //x=75.44 //y=4.255 //x2=75.4 //y2=5.2
cc_6643 ( N_noxref_21_c_10033_p N_VDD_M136_noxref_s ) capacitor c=0.00986169f \
 //x=75.6 //y=4.88 //x2=75.4 //y2=5.2
cc_6644 ( N_noxref_21_M136_noxref_g N_VDD_M136_noxref_s ) capacitor \
 c=0.0573441f //x=75.755 //y=6.2 //x2=75.4 //y2=5.2
cc_6645 ( N_noxref_21_c_10054_p N_VDD_M136_noxref_s ) capacitor c=0.0053173f \
 //x=75.83 //y=4.97 //x2=75.4 //y2=5.2
cc_6646 ( N_noxref_21_M137_noxref_g N_VDD_M137_noxref_d ) capacitor \
 c=0.0572684f //x=76.195 //y=6.2 //x2=76.27 //y2=5.2
cc_6647 ( N_noxref_21_c_9900_n N_noxref_27_c_12024_n ) capacitor c=2.95004e-19 \
 //x=67.02 //y=1.36 //x2=68.865 //y2=5.39
cc_6648 ( N_noxref_21_c_9900_n N_noxref_27_c_12027_n ) capacitor c=3.81263e-19 \
 //x=67.02 //y=1.36 //x2=67.095 //y2=5.39
cc_6649 ( N_noxref_21_c_9939_n N_noxref_28_c_12195_n ) capacitor c=5.76261e-19 \
 //x=74.12 //y=5.305 //x2=72.205 //y2=5.39
cc_6650 ( N_noxref_21_c_9992_n N_noxref_28_c_12195_n ) capacitor c=2.00442e-19 \
 //x=70.35 //y=1.36 //x2=72.205 //y2=5.39
cc_6651 ( N_noxref_21_c_9953_n N_noxref_28_c_12195_n ) capacitor c=0.0327245f \
 //x=72.76 //y=5.39 //x2=72.205 //y2=5.39
cc_6652 ( N_noxref_21_c_10019_n N_noxref_28_c_12195_n ) capacitor \
 c=0.00238429f //x=72.76 //y=5.56 //x2=72.205 //y2=5.39
cc_6653 ( N_noxref_21_c_9992_n N_noxref_28_c_12196_n ) capacitor c=7.9511e-19 \
 //x=70.35 //y=1.36 //x2=70.415 //y2=5.39
cc_6654 ( N_noxref_21_c_9906_n N_noxref_28_c_12221_n ) capacitor c=0.00311493f \
 //x=73.515 //y=5.39 //x2=73.085 //y2=7.09
cc_6655 ( N_noxref_21_c_9953_n N_noxref_28_c_12221_n ) capacitor c=0.00538798f \
 //x=72.76 //y=5.39 //x2=73.085 //y2=7.09
cc_6656 ( N_noxref_21_c_10019_n N_noxref_28_c_12221_n ) capacitor \
 c=0.00406191f //x=72.76 //y=5.56 //x2=73.085 //y2=7.09
cc_6657 ( N_noxref_21_c_9906_n N_noxref_28_c_12197_n ) capacitor c=0.00305195f \
 //x=73.515 //y=5.39 //x2=73.95 //y2=7.09
cc_6658 ( N_noxref_21_c_9925_n N_noxref_28_c_12197_n ) capacitor c=0.00291085f \
 //x=74.035 //y=5.39 //x2=73.95 //y2=7.09
cc_6659 ( N_noxref_21_c_9954_n N_noxref_28_c_12197_n ) capacitor c=0.00559082f \
 //x=73.637 //y=5.39 //x2=73.95 //y2=7.09
cc_6660 ( N_noxref_21_c_9970_n N_noxref_28_c_12197_n ) capacitor c=0.00396177f \
 //x=73.64 //y=5.56 //x2=73.95 //y2=7.09
cc_6661 ( N_noxref_21_c_9953_n N_noxref_28_c_12184_n ) capacitor c=0.00240034f \
 //x=72.76 //y=5.39 //x2=69.42 //y2=5.39
cc_6662 ( N_noxref_21_c_9906_n N_noxref_28_c_12201_n ) capacitor c=0.00459659f \
 //x=73.515 //y=5.39 //x2=73.2 //y2=7.09
cc_6663 ( N_noxref_21_c_9925_n N_noxref_28_c_12202_n ) capacitor c=0.00536247f \
 //x=74.035 //y=5.39 //x2=74.08 //y2=6.92
cc_6664 ( N_noxref_21_c_9939_n N_noxref_28_c_12203_n ) capacitor c=5.23099e-19 \
 //x=74.12 //y=5.305 //x2=72.32 //y2=5.39
cc_6665 ( N_noxref_21_c_9953_n N_noxref_28_c_12203_n ) capacitor c=0.010446f \
 //x=72.76 //y=5.39 //x2=72.32 //y2=5.39
cc_6666 ( N_noxref_21_c_10019_n N_noxref_28_c_12203_n ) capacitor c=0.0649815f \
 //x=72.76 //y=5.56 //x2=72.32 //y2=5.39
cc_6667 ( N_noxref_21_c_9906_n N_noxref_28_M133_noxref_d ) capacitor \
 c=0.00678641f //x=73.515 //y=5.39 //x2=73.055 //y2=5.205
cc_6668 ( N_noxref_21_c_9954_n N_noxref_28_M133_noxref_d ) capacitor \
 c=0.00184359f //x=73.637 //y=5.39 //x2=73.055 //y2=5.205
cc_6669 ( N_noxref_21_c_10019_n N_noxref_28_M133_noxref_d ) capacitor \
 c=0.0476949f //x=72.76 //y=5.56 //x2=73.055 //y2=5.205
cc_6670 ( N_noxref_21_c_9970_n N_noxref_28_M133_noxref_d ) capacitor \
 c=0.0473507f //x=73.64 //y=5.56 //x2=73.055 //y2=5.205
cc_6671 ( N_noxref_21_c_9925_n N_noxref_28_M135_noxref_d ) capacitor \
 c=0.00735506f //x=74.035 //y=5.39 //x2=73.935 //y2=5.205
cc_6672 ( N_noxref_21_c_9954_n N_noxref_28_M135_noxref_d ) capacitor \
 c=0.0012641f //x=73.637 //y=5.39 //x2=73.935 //y2=5.205
cc_6673 ( N_noxref_21_c_9958_n N_noxref_28_M135_noxref_d ) capacitor \
 c=0.00165396f //x=74.12 //y=4.25 //x2=73.935 //y2=5.205
cc_6674 ( N_noxref_21_c_9970_n N_noxref_28_M135_noxref_d ) capacitor \
 c=0.0473507f //x=73.64 //y=5.56 //x2=73.935 //y2=5.205
cc_6675 ( N_noxref_21_c_9900_n N_GND_c_13079_n ) capacitor c=0.00185137f \
 //x=67.02 //y=1.36 //x2=66.05 //y2=1.015
cc_6676 ( N_noxref_21_c_9960_n N_GND_c_13079_n ) capacitor c=7.42708e-19 \
 //x=67.185 //y=1.405 //x2=66.05 //y2=1.015
cc_6677 ( N_noxref_21_M40_noxref_d N_GND_c_13079_n ) capacitor c=2.62581e-19 \
 //x=66.83 //y=1.085 //x2=66.05 //y2=1.015
cc_6678 ( N_noxref_21_c_9900_n N_GND_c_13145_n ) capacitor c=0.00560939f \
 //x=67.02 //y=1.36 //x2=69.295 //y2=0.175
cc_6679 ( N_noxref_21_c_9960_n N_GND_c_13145_n ) capacitor c=0.00701775f \
 //x=67.185 //y=1.405 //x2=69.295 //y2=0.175
cc_6680 ( N_noxref_21_c_9902_n N_GND_c_13145_n ) capacitor c=0.113183f \
 //x=70.22 //y=1.405 //x2=69.295 //y2=0.175
cc_6681 ( N_noxref_21_M40_noxref_d N_GND_c_13145_n ) capacitor c=2.01013e-19 \
 //x=66.83 //y=1.085 //x2=69.295 //y2=0.175
cc_6682 ( N_noxref_21_c_9900_n N_GND_c_13087_n ) capacitor c=3.05744e-19 \
 //x=67.02 //y=1.36 //x2=69.38 //y2=1.015
cc_6683 ( N_noxref_21_c_9992_n N_GND_c_13087_n ) capacitor c=0.00250092f \
 //x=70.35 //y=1.36 //x2=69.38 //y2=1.015
cc_6684 ( N_noxref_21_c_9960_n N_GND_c_13087_n ) capacitor c=4.33564e-19 \
 //x=67.185 //y=1.405 //x2=69.38 //y2=1.015
cc_6685 ( N_noxref_21_c_9902_n N_GND_c_13087_n ) capacitor c=0.0207494f \
 //x=70.22 //y=1.405 //x2=69.38 //y2=1.015
cc_6686 ( N_noxref_21_M42_noxref_d N_GND_c_13087_n ) capacitor c=2.62581e-19 \
 //x=70.16 //y=1.085 //x2=69.38 //y2=1.015
cc_6687 ( N_noxref_21_c_9992_n N_GND_c_13181_n ) capacitor c=0.00848351f \
 //x=70.35 //y=1.36 //x2=72.625 //y2=0.175
cc_6688 ( N_noxref_21_c_9902_n N_GND_c_13181_n ) capacitor c=0.0330907f \
 //x=70.22 //y=1.405 //x2=72.625 //y2=0.175
cc_6689 ( N_noxref_21_c_10006_n N_GND_c_13181_n ) capacitor c=0.00561615f \
 //x=70.48 //y=1.405 //x2=72.625 //y2=0.175
cc_6690 ( N_noxref_21_c_9964_n N_GND_c_13181_n ) capacitor c=0.104345f \
 //x=73.515 //y=1.405 //x2=72.625 //y2=0.175
cc_6691 ( N_noxref_21_M42_noxref_d N_GND_c_13181_n ) capacitor c=2.01013e-19 \
 //x=70.16 //y=1.085 //x2=72.625 //y2=0.175
cc_6692 ( N_noxref_21_c_9913_n N_GND_c_13184_n ) capacitor c=0.00195467f \
 //x=73.68 //y=1.535 //x2=72.71 //y2=1.02
cc_6693 ( N_noxref_21_c_9992_n N_GND_c_13184_n ) capacitor c=8.32974e-19 \
 //x=70.35 //y=1.36 //x2=72.71 //y2=1.02
cc_6694 ( N_noxref_21_c_9953_n N_GND_c_13184_n ) capacitor c=9.01285e-19 \
 //x=72.76 //y=5.39 //x2=72.71 //y2=1.02
cc_6695 ( N_noxref_21_c_9962_n N_GND_c_13184_n ) capacitor c=8.08914e-19 \
 //x=73.675 //y=1.405 //x2=72.71 //y2=1.02
cc_6696 ( N_noxref_21_c_9964_n N_GND_c_13184_n ) capacitor c=0.0204811f \
 //x=73.515 //y=1.405 //x2=72.71 //y2=1.02
cc_6697 ( N_noxref_21_M44_noxref_d N_GND_c_13184_n ) capacitor c=2.62581e-19 \
 //x=73.49 //y=1.085 //x2=72.71 //y2=1.02
cc_6698 ( N_noxref_21_c_9913_n N_GND_c_13147_n ) capacitor c=0.00524308f \
 //x=73.68 //y=1.535 //x2=76.34 //y2=0.18
cc_6699 ( N_noxref_21_c_9926_n N_GND_c_13147_n ) capacitor c=0.0062416f \
 //x=74.035 //y=1.825 //x2=76.34 //y2=0.18
cc_6700 ( N_noxref_21_c_9935_n N_GND_c_13147_n ) capacitor c=3.81645e-19 \
 //x=74.12 //y=4.415 //x2=76.34 //y2=0.18
cc_6701 ( N_noxref_21_c_10031_p N_GND_c_13147_n ) capacitor c=3.80542e-19 \
 //x=75.6 //y=4.415 //x2=76.34 //y2=0.18
cc_6702 ( N_noxref_21_c_10124_p N_GND_c_13147_n ) capacitor c=0.00249122f \
 //x=75.6 //y=2.265 //x2=76.34 //y2=0.18
cc_6703 ( N_noxref_21_c_9962_n N_GND_c_13147_n ) capacitor c=0.00777895f \
 //x=73.675 //y=1.405 //x2=76.34 //y2=0.18
cc_6704 ( N_noxref_21_c_9964_n N_GND_c_13147_n ) capacitor c=0.038217f \
 //x=73.515 //y=1.405 //x2=76.34 //y2=0.18
cc_6705 ( N_noxref_21_c_10127_p N_GND_c_13147_n ) capacitor c=7.5371e-19 \
 //x=75.6 //y=2.265 //x2=76.34 //y2=0.18
cc_6706 ( N_noxref_21_M44_noxref_d N_GND_c_13147_n ) capacitor c=2.01013e-19 \
 //x=73.49 //y=1.085 //x2=76.34 //y2=0.18
cc_6707 ( N_noxref_21_c_9926_n N_GND_c_13157_n ) capacitor c=7.45235e-19 \
 //x=74.035 //y=1.825 //x2=74.69 //y2=0.175
cc_6708 ( N_noxref_21_c_10124_p N_GND_c_13274_n ) capacitor c=0.00114179f \
 //x=75.6 //y=2.265 //x2=75.885 //y2=0.715
cc_6709 ( N_noxref_21_c_10127_p N_GND_c_13274_n ) capacitor c=3.95714e-19 \
 //x=75.6 //y=2.265 //x2=75.885 //y2=0.715
cc_6710 ( N_noxref_21_c_10132_p N_GND_c_13274_n ) capacitor c=0.0125549f \
 //x=75.71 //y=1.09 //x2=75.885 //y2=0.715
cc_6711 ( N_noxref_21_c_10133_p N_GND_c_13274_n ) capacitor c=2.1838e-19 \
 //x=75.6 //y=2.265 //x2=75.885 //y2=0.715
cc_6712 ( N_noxref_21_c_10134_p N_GND_c_13278_n ) capacitor c=0.0134289f \
 //x=76.24 //y=1.09 //x2=76.375 //y2=0.715
cc_6713 ( N_noxref_21_c_9902_n N_GND_c_13115_n ) capacitor c=0.0198667f \
 //x=70.22 //y=1.405 //x2=68.2 //y2=0.175
cc_6714 ( N_noxref_21_M40_noxref_d N_GND_c_13115_n ) capacitor c=0.00128657f \
 //x=66.83 //y=1.085 //x2=68.2 //y2=0.175
cc_6715 ( N_noxref_21_c_9928_n N_GND_c_13172_n ) capacitor c=0.00135353f \
 //x=74.12 //y=4.095 //x2=71.53 //y2=0.175
cc_6716 ( N_noxref_21_c_9964_n N_GND_c_13172_n ) capacitor c=0.0183315f \
 //x=73.515 //y=1.405 //x2=71.53 //y2=0.175
cc_6717 ( N_noxref_21_M42_noxref_d N_GND_c_13172_n ) capacitor c=0.00129142f \
 //x=70.16 //y=1.085 //x2=71.53 //y2=0.175
cc_6718 ( N_noxref_21_c_9923_n N_GND_c_13173_n ) capacitor c=0.00248396f \
 //x=73.68 //y=1.74 //x2=74.86 //y2=0.175
cc_6719 ( N_noxref_21_c_9926_n N_GND_c_13173_n ) capacitor c=0.0274191f \
 //x=74.035 //y=1.825 //x2=74.86 //y2=0.175
cc_6720 ( N_noxref_21_c_9943_n N_GND_c_13173_n ) capacitor c=0.0103129f \
 //x=75.6 //y=4.095 //x2=74.86 //y2=0.175
cc_6721 ( N_noxref_21_c_10124_p N_GND_c_13173_n ) capacitor c=0.00682461f \
 //x=75.6 //y=2.265 //x2=74.86 //y2=0.175
cc_6722 ( N_noxref_21_c_10050_p N_GND_c_13173_n ) capacitor c=0.0035382f \
 //x=75.44 //y=4.255 //x2=74.86 //y2=0.175
cc_6723 ( N_noxref_21_c_10127_p N_GND_c_13173_n ) capacitor c=0.00733236f \
 //x=75.6 //y=2.265 //x2=74.86 //y2=0.175
cc_6724 ( N_noxref_21_c_10146_p N_GND_c_13173_n ) capacitor c=0.00427116f \
 //x=75.71 //y=2.1 //x2=74.86 //y2=0.175
cc_6725 ( N_noxref_21_c_10133_p N_GND_c_13173_n ) capacitor c=0.00786308f \
 //x=75.6 //y=2.265 //x2=74.86 //y2=0.175
cc_6726 ( N_noxref_21_M44_noxref_d N_GND_c_13173_n ) capacitor c=0.00165161f \
 //x=73.49 //y=1.085 //x2=74.86 //y2=0.175
cc_6727 ( N_noxref_21_c_10127_p N_GND_c_13293_n ) capacitor c=0.0022444f \
 //x=75.6 //y=2.265 //x2=76.46 //y2=0.175
cc_6728 ( N_noxref_21_c_10133_p N_GND_c_13293_n ) capacitor c=2.63786e-19 \
 //x=75.6 //y=2.265 //x2=76.46 //y2=0.175
cc_6729 ( N_noxref_21_c_10031_p N_GND_M45_noxref_s ) capacitor c=4.66358e-19 \
 //x=75.6 //y=4.415 //x2=75.355 //y2=0.55
cc_6730 ( N_noxref_21_c_10124_p N_GND_M45_noxref_s ) capacitor c=0.00297876f \
 //x=75.6 //y=2.265 //x2=75.355 //y2=0.55
cc_6731 ( N_noxref_21_c_10127_p N_GND_M45_noxref_s ) capacitor c=0.00651326f \
 //x=75.6 //y=2.265 //x2=75.355 //y2=0.55
cc_6732 ( N_noxref_21_c_10132_p N_GND_M45_noxref_s ) capacitor c=0.0301091f \
 //x=75.71 //y=1.09 //x2=75.355 //y2=0.55
cc_6733 ( N_noxref_21_c_10155_p N_GND_M45_noxref_s ) capacitor c=0.002132f \
 //x=75.71 //y=1.745 //x2=75.355 //y2=0.55
cc_6734 ( N_noxref_21_c_10146_p N_GND_M45_noxref_s ) capacitor c=0.00304786f \
 //x=75.71 //y=2.1 //x2=75.355 //y2=0.55
cc_6735 ( N_noxref_21_c_10157_p N_GND_M45_noxref_s ) capacitor c=0.00517463f \
 //x=76.085 //y=0.935 //x2=75.355 //y2=0.55
cc_6736 ( N_noxref_21_c_10134_p N_GND_M45_noxref_s ) capacitor c=0.0153553f \
 //x=76.24 //y=1.09 //x2=75.355 //y2=0.55
cc_6737 ( N_noxref_21_c_10159_p N_GND_M45_noxref_s ) capacitor c=0.00629878f \
 //x=76.24 //y=1.435 //x2=75.355 //y2=0.55
cc_6738 ( N_noxref_21_c_10133_p N_GND_M45_noxref_s ) capacitor c=0.00660555f \
 //x=75.6 //y=2.265 //x2=75.355 //y2=0.55
cc_6739 ( N_noxref_21_c_9928_n Q ) capacitor c=0.00353207f //x=74.12 //y=4.095 \
 //x2=76.34 //y2=2.4
cc_6740 ( N_noxref_21_c_9939_n Q ) capacitor c=0.00159336f //x=74.12 //y=5.305 \
 //x2=76.34 //y2=2.4
cc_6741 ( N_noxref_21_c_9943_n Q ) capacitor c=0.078466f //x=75.6 //y=4.095 \
 //x2=76.34 //y2=2.4
cc_6742 ( N_noxref_21_c_10031_p Q ) capacitor c=0.0149195f //x=75.6 //y=4.415 \
 //x2=76.34 //y2=2.4
cc_6743 ( N_noxref_21_c_9944_n Q ) capacitor c=0.0217291f //x=75.6 //y=4.76 \
 //x2=76.34 //y2=2.4
cc_6744 ( N_noxref_21_c_10049_p Q ) capacitor c=0.00459089f //x=75.6 //y=4.25 \
 //x2=76.34 //y2=2.4
cc_6745 ( N_noxref_21_c_10124_p Q ) capacitor c=0.00825076f //x=75.6 //y=2.265 \
 //x2=76.34 //y2=2.4
cc_6746 ( N_noxref_21_c_10063_p Q ) capacitor c=0.00699818f //x=75.6 //y=4.255 \
 //x2=76.34 //y2=2.4
cc_6747 ( N_noxref_21_c_10127_p Q ) capacitor c=0.0023016f //x=75.6 //y=2.265 \
 //x2=76.34 //y2=2.4
cc_6748 ( N_noxref_21_c_10033_p Q ) capacitor c=0.00250262f //x=75.6 //y=4.88 \
 //x2=76.34 //y2=2.4
cc_6749 ( N_noxref_21_c_10057_p Q ) capacitor c=4.08297e-19 //x=76.12 //y=4.97 \
 //x2=76.34 //y2=2.4
cc_6750 ( N_noxref_21_c_10054_p Q ) capacitor c=0.00124564f //x=75.83 //y=4.97 \
 //x2=76.34 //y2=2.4
cc_6751 ( N_noxref_21_c_10133_p Q ) capacitor c=0.00112403f //x=75.6 //y=2.265 \
 //x2=76.34 //y2=2.4
cc_6752 ( N_noxref_21_c_9913_n N_Q_c_13913_n ) capacitor c=0.00149649f \
 //x=73.68 //y=1.535 //x2=75.97 //y2=1.935
cc_6753 ( N_noxref_21_c_9923_n N_Q_c_13913_n ) capacitor c=0.00189939f \
 //x=73.68 //y=1.74 //x2=75.97 //y2=1.935
cc_6754 ( N_noxref_21_c_9926_n N_Q_c_13913_n ) capacitor c=0.00329389f \
 //x=74.035 //y=1.825 //x2=75.97 //y2=1.935
cc_6755 ( N_noxref_21_c_9962_n N_Q_c_13913_n ) capacitor c=0.00587899f \
 //x=73.675 //y=1.405 //x2=75.97 //y2=1.935
cc_6756 ( N_noxref_21_c_10178_p N_Q_c_13913_n ) capacitor c=0.0010801f \
 //x=75.71 //y=1.435 //x2=75.97 //y2=1.935
cc_6757 ( N_noxref_21_c_10155_p N_Q_c_13913_n ) capacitor c=0.00523499f \
 //x=75.71 //y=1.745 //x2=75.97 //y2=1.935
cc_6758 ( N_noxref_21_c_10146_p N_Q_c_13913_n ) capacitor c=0.00376062f \
 //x=75.71 //y=2.1 //x2=75.97 //y2=1.935
cc_6759 ( N_noxref_21_c_10181_p N_Q_c_13913_n ) capacitor c=0.00934105f \
 //x=76.085 //y=1.59 //x2=75.97 //y2=1.935
cc_6760 ( N_noxref_21_c_10159_p N_Q_c_13913_n ) capacitor c=0.00362207f \
 //x=76.24 //y=1.435 //x2=75.97 //y2=1.935
cc_6761 ( N_noxref_21_c_9925_n N_Q_c_13922_n ) capacitor c=0.00315048f \
 //x=74.035 //y=5.39 //x2=75.975 //y2=5.42
cc_6762 ( N_noxref_21_c_9954_n N_Q_c_13922_n ) capacitor c=5.82161e-19 \
 //x=73.637 //y=5.39 //x2=75.975 //y2=5.42
cc_6763 ( N_noxref_21_M136_noxref_g N_Q_c_13922_n ) capacitor c=0.00141266f \
 //x=75.755 //y=6.2 //x2=75.975 //y2=5.42
cc_6764 ( N_noxref_21_M137_noxref_g N_Q_c_13922_n ) capacitor c=0.00377331f \
 //x=76.195 //y=6.2 //x2=75.975 //y2=5.42
cc_6765 ( N_noxref_21_c_10181_p N_Q_c_13926_n ) capacitor c=0.00180253f \
 //x=76.085 //y=1.59 //x2=76.255 //y2=2.02
cc_6766 ( N_noxref_21_c_9928_n N_Q_c_13927_n ) capacitor c=0.00329389f \
 //x=74.12 //y=4.095 //x2=76.055 //y2=2.02
cc_6767 ( N_noxref_21_c_10133_p N_Q_c_13927_n ) capacitor c=0.00376062f \
 //x=75.6 //y=2.265 //x2=76.055 //y2=2.02
cc_6768 ( N_noxref_21_M137_noxref_g N_Q_c_13929_n ) capacitor c=0.00966342f \
 //x=76.195 //y=6.2 //x2=76.255 //y2=5.14
cc_6769 ( N_noxref_21_c_9939_n N_Q_c_13930_n ) capacitor c=0.00293539f \
 //x=74.12 //y=5.305 //x2=76.06 //y2=5.14
cc_6770 ( N_noxref_21_M136_noxref_g N_Q_c_13930_n ) capacitor c=0.00427521f \
 //x=75.755 //y=6.2 //x2=76.06 //y2=5.14
cc_6771 ( N_noxref_21_c_10057_p N_Q_c_13930_n ) capacitor c=0.00262283f \
 //x=76.12 //y=4.97 //x2=76.06 //y2=5.14
cc_6772 ( N_noxref_21_c_9913_n N_Q_c_13933_n ) capacitor c=0.00142298f \
 //x=73.68 //y=1.535 //x2=75.97 //y2=1.185
cc_6773 ( N_noxref_21_c_9962_n N_Q_c_13933_n ) capacitor c=0.00109769f \
 //x=73.675 //y=1.405 //x2=75.97 //y2=1.185
cc_6774 ( N_noxref_21_c_10132_p N_Q_c_13933_n ) capacitor c=0.0018223f \
 //x=75.71 //y=1.09 //x2=75.97 //y2=1.185
cc_6775 ( N_noxref_21_c_10178_p N_Q_c_13933_n ) capacitor c=0.00375161f \
 //x=75.71 //y=1.435 //x2=75.97 //y2=1.185
cc_6776 ( N_noxref_21_c_10157_p N_Q_c_13933_n ) capacitor c=5.57924e-19 \
 //x=76.085 //y=0.935 //x2=75.97 //y2=1.185
cc_6777 ( N_noxref_21_c_10181_p N_Q_c_13933_n ) capacitor c=5.75878e-19 \
 //x=76.085 //y=1.59 //x2=75.97 //y2=1.185
cc_6778 ( N_noxref_21_c_10134_p N_Q_c_13933_n ) capacitor c=0.00160969f \
 //x=76.24 //y=1.09 //x2=75.97 //y2=1.185
cc_6779 ( N_noxref_21_c_10159_p N_Q_c_13933_n ) capacitor c=0.00411132f \
 //x=76.24 //y=1.435 //x2=75.97 //y2=1.185
cc_6780 ( N_noxref_21_M136_noxref_g N_Q_c_13941_n ) capacitor c=0.0162066f \
 //x=75.755 //y=6.2 //x2=75.975 //y2=5.56
cc_6781 ( N_noxref_21_M137_noxref_g N_Q_c_13941_n ) capacitor c=0.0162066f \
 //x=76.195 //y=6.2 //x2=75.975 //y2=5.56
cc_6782 ( N_noxref_21_c_10057_p N_Q_c_13941_n ) capacitor c=0.00290963f \
 //x=76.12 //y=4.97 //x2=75.975 //y2=5.56
cc_6783 ( N_noxref_21_c_10132_p N_Q_M45_noxref_d ) capacitor c=0.00137914f \
 //x=75.71 //y=1.09 //x2=75.785 //y2=1.09
cc_6784 ( N_noxref_21_c_10178_p N_Q_M45_noxref_d ) capacitor c=0.0023891f \
 //x=75.71 //y=1.435 //x2=75.785 //y2=1.09
cc_6785 ( N_noxref_21_c_10157_p N_Q_M45_noxref_d ) capacitor c=0.0020782f \
 //x=76.085 //y=0.935 //x2=75.785 //y2=1.09
cc_6786 ( N_noxref_21_c_10181_p N_Q_M45_noxref_d ) capacitor c=0.00356097f \
 //x=76.085 //y=1.59 //x2=75.785 //y2=1.09
cc_6787 ( N_noxref_21_c_10134_p N_Q_M45_noxref_d ) capacitor c=0.00138452f \
 //x=76.24 //y=1.09 //x2=75.785 //y2=1.09
cc_6788 ( N_noxref_21_c_10159_p N_Q_M45_noxref_d ) capacitor c=0.00235934f \
 //x=76.24 //y=1.435 //x2=75.785 //y2=1.09
cc_6789 ( N_noxref_21_c_9900_n N_noxref_49_c_15207_n ) capacitor c=0.00587436f \
 //x=67.02 //y=1.36 //x2=67.42 //y2=0.71
cc_6790 ( N_noxref_21_c_9902_n N_noxref_49_c_15207_n ) capacitor c=0.00227706f \
 //x=70.22 //y=1.405 //x2=67.42 //y2=0.71
cc_6791 ( N_noxref_21_M40_noxref_d N_noxref_49_c_15207_n ) capacitor \
 c=0.0136817f //x=66.83 //y=1.085 //x2=67.42 //y2=0.71
cc_6792 ( N_noxref_21_c_9900_n N_noxref_49_M39_noxref_s ) capacitor \
 c=0.0123518f //x=67.02 //y=1.36 //x2=65.43 //y2=0.545
cc_6793 ( N_noxref_21_c_9902_n N_noxref_49_M39_noxref_s ) capacitor \
 c=0.00825327f //x=70.22 //y=1.405 //x2=65.43 //y2=0.545
cc_6794 ( N_noxref_21_M40_noxref_d N_noxref_49_M39_noxref_s ) capacitor \
 c=0.0446285f //x=66.83 //y=1.085 //x2=65.43 //y2=0.545
cc_6795 ( N_noxref_21_c_9902_n N_noxref_51_c_15263_n ) capacitor c=0.0118655f \
 //x=70.22 //y=1.405 //x2=69.78 //y2=1.76
cc_6796 ( N_noxref_21_c_9992_n N_noxref_51_c_15278_n ) capacitor c=0.0057298f \
 //x=70.35 //y=1.36 //x2=70.75 //y2=0.71
cc_6797 ( N_noxref_21_c_9902_n N_noxref_51_c_15278_n ) capacitor c=0.00227706f \
 //x=70.22 //y=1.405 //x2=70.75 //y2=0.71
cc_6798 ( N_noxref_21_c_9964_n N_noxref_51_c_15278_n ) capacitor c=0.00530355f \
 //x=73.515 //y=1.405 //x2=70.75 //y2=0.71
cc_6799 ( N_noxref_21_M42_noxref_d N_noxref_51_c_15278_n ) capacitor \
 c=0.0130616f //x=70.16 //y=1.085 //x2=70.75 //y2=0.71
cc_6800 ( N_noxref_21_c_9992_n N_noxref_51_M41_noxref_s ) capacitor \
 c=0.0103806f //x=70.35 //y=1.36 //x2=68.76 //y2=0.545
cc_6801 ( N_noxref_21_c_9902_n N_noxref_51_M41_noxref_s ) capacitor \
 c=0.0188707f //x=70.22 //y=1.405 //x2=68.76 //y2=0.545
cc_6802 ( N_noxref_21_c_9964_n N_noxref_51_M41_noxref_s ) capacitor \
 c=0.00742061f //x=73.515 //y=1.405 //x2=68.76 //y2=0.545
cc_6803 ( N_noxref_21_M42_noxref_d N_noxref_51_M41_noxref_s ) capacitor \
 c=0.044119f //x=70.16 //y=1.085 //x2=68.76 //y2=0.545
cc_6804 ( N_noxref_21_c_9964_n N_noxref_52_c_15326_n ) capacitor c=0.0135245f \
 //x=73.515 //y=1.405 //x2=73.11 //y2=1.76
cc_6805 ( N_noxref_21_c_9927_n N_noxref_52_c_15327_n ) capacitor c=0.00714695f \
 //x=73.765 //y=1.825 //x2=73.195 //y2=1.675
cc_6806 ( N_noxref_21_c_9928_n N_noxref_52_c_15327_n ) capacitor c=2.92748e-19 \
 //x=74.12 //y=4.095 //x2=73.195 //y2=1.675
cc_6807 ( N_noxref_21_c_9913_n N_noxref_52_c_15331_n ) capacitor c=0.00515582f \
 //x=73.68 //y=1.535 //x2=74.08 //y2=0.71
cc_6808 ( N_noxref_21_c_9926_n N_noxref_52_c_15331_n ) capacitor c=0.00332518f \
 //x=74.035 //y=1.825 //x2=74.08 //y2=0.71
cc_6809 ( N_noxref_21_c_9962_n N_noxref_52_c_15331_n ) capacitor c=0.00224828f \
 //x=73.675 //y=1.405 //x2=74.08 //y2=0.71
cc_6810 ( N_noxref_21_c_9964_n N_noxref_52_c_15331_n ) capacitor c=0.00185838f \
 //x=73.515 //y=1.405 //x2=74.08 //y2=0.71
cc_6811 ( N_noxref_21_M44_noxref_d N_noxref_52_c_15331_n ) capacitor \
 c=0.0135038f //x=73.49 //y=1.085 //x2=74.08 //y2=0.71
cc_6812 ( N_noxref_21_c_9913_n N_noxref_52_M43_noxref_s ) capacitor \
 c=0.010254f //x=73.68 //y=1.535 //x2=72.09 //y2=0.545
cc_6813 ( N_noxref_21_c_9923_n N_noxref_52_M43_noxref_s ) capacitor \
 c=0.00775201f //x=73.68 //y=1.74 //x2=72.09 //y2=0.545
cc_6814 ( N_noxref_21_c_9926_n N_noxref_52_M43_noxref_s ) capacitor \
 c=0.00706721f //x=74.035 //y=1.825 //x2=72.09 //y2=0.545
cc_6815 ( N_noxref_21_c_9958_n N_noxref_52_M43_noxref_s ) capacitor \
 c=7.05604e-19 //x=74.12 //y=4.25 //x2=72.09 //y2=0.545
cc_6816 ( N_noxref_21_c_9962_n N_noxref_52_M43_noxref_s ) capacitor \
 c=0.0090031f //x=73.675 //y=1.405 //x2=72.09 //y2=0.545
cc_6817 ( N_noxref_21_c_9964_n N_noxref_52_M43_noxref_s ) capacitor \
 c=0.0219823f //x=73.515 //y=1.405 //x2=72.09 //y2=0.545
cc_6818 ( N_noxref_21_M44_noxref_d N_noxref_52_M43_noxref_s ) capacitor \
 c=0.0431094f //x=73.49 //y=1.085 //x2=72.09 //y2=0.545
cc_6819 ( N_VDD_c_10241_n N_noxref_25_c_11788_n ) capacitor c=0.00648267f \
 //x=65.575 //y=7.585 //x2=42.075 //y2=5.38
cc_6820 ( N_VDD_c_10740_n N_noxref_25_c_11788_n ) capacitor c=0.00208087f \
 //x=41.665 //y=7.585 //x2=42.075 //y2=5.38
cc_6821 ( N_VDD_c_10794_n N_noxref_25_c_11788_n ) capacitor c=0.00180737f \
 //x=42.545 //y=7.585 //x2=42.075 //y2=5.38
cc_6822 ( N_VDD_M95_noxref_d N_noxref_25_c_11788_n ) capacitor c=0.00734094f \
 //x=41.605 //y=5.2 //x2=42.075 //y2=5.38
cc_6823 ( N_VDD_c_10241_n N_noxref_25_c_11821_n ) capacitor c=0.00488503f \
 //x=65.575 //y=7.585 //x2=42.585 //y2=5.38
cc_6824 ( N_VDD_c_10794_n N_noxref_25_c_11821_n ) capacitor c=0.00208087f \
 //x=42.545 //y=7.585 //x2=42.585 //y2=5.38
cc_6825 ( N_VDD_M97_noxref_d N_noxref_25_c_11821_n ) capacitor c=0.0100078f \
 //x=42.485 //y=5.2 //x2=42.585 //y2=5.38
cc_6826 ( N_VDD_M98_noxref_s N_noxref_25_c_11821_n ) capacitor c=0.00220019f \
 //x=44.365 //y=5.2 //x2=42.585 //y2=5.38
cc_6827 ( N_VDD_c_10746_n N_noxref_25_c_11792_n ) capacitor c=0.0013228f \
 //x=40.08 //y=7.585 //x2=42.67 //y2=5.295
cc_6828 ( N_VDD_c_10822_n N_noxref_25_c_11792_n ) capacitor c=0.0294562f \
 //x=43.41 //y=7.585 //x2=42.67 //y2=5.295
cc_6829 ( N_VDD_c_10241_n N_noxref_25_c_11795_n ) capacitor c=0.00368834f \
 //x=65.575 //y=7.585 //x2=41.31 //y2=5.56
cc_6830 ( N_VDD_c_10740_n N_noxref_25_c_11795_n ) capacitor c=9.41185e-19 \
 //x=41.665 //y=7.585 //x2=41.31 //y2=5.56
cc_6831 ( N_VDD_c_10746_n N_noxref_25_c_11795_n ) capacitor c=4.91377e-19 \
 //x=40.08 //y=7.585 //x2=41.31 //y2=5.56
cc_6832 ( N_VDD_M94_noxref_s N_noxref_25_c_11795_n ) capacitor c=0.0572211f \
 //x=40.735 //y=5.2 //x2=41.31 //y2=5.56
cc_6833 ( N_VDD_M95_noxref_d N_noxref_25_c_11795_n ) capacitor c=0.0043528f \
 //x=41.605 //y=5.2 //x2=41.31 //y2=5.56
cc_6834 ( N_VDD_c_10241_n N_noxref_25_c_11840_n ) capacitor c=8.42623e-19 \
 //x=65.575 //y=7.585 //x2=42.19 //y2=5.38
cc_6835 ( N_VDD_c_10794_n N_noxref_25_c_11840_n ) capacitor c=4.23719e-19 \
 //x=42.545 //y=7.585 //x2=42.19 //y2=5.38
cc_6836 ( N_VDD_c_10822_n N_noxref_25_c_11840_n ) capacitor c=0.0025639f \
 //x=43.41 //y=7.585 //x2=42.19 //y2=5.38
cc_6837 ( N_VDD_M94_noxref_s N_noxref_25_c_11840_n ) capacitor c=6.52457e-19 \
 //x=40.735 //y=5.2 //x2=42.19 //y2=5.38
cc_6838 ( N_VDD_M98_noxref_s N_noxref_25_c_11840_n ) capacitor c=0.00371125f \
 //x=44.365 //y=5.2 //x2=42.19 //y2=5.38
cc_6839 ( N_VDD_c_10241_n N_noxref_25_c_11908_n ) capacitor c=0.00285853f \
 //x=65.575 //y=7.585 //x2=42.19 //y2=5.56
cc_6840 ( N_VDD_c_10794_n N_noxref_25_c_11908_n ) capacitor c=5.77976e-19 \
 //x=42.545 //y=7.585 //x2=42.19 //y2=5.56
cc_6841 ( N_VDD_c_10822_n N_noxref_25_c_11908_n ) capacitor c=4.19141e-19 \
 //x=43.41 //y=7.585 //x2=42.19 //y2=5.56
cc_6842 ( N_VDD_M95_noxref_d N_noxref_25_c_11908_n ) capacitor c=0.0043528f \
 //x=41.605 //y=5.2 //x2=42.19 //y2=5.56
cc_6843 ( N_VDD_M97_noxref_d N_noxref_25_c_11908_n ) capacitor c=0.00955781f \
 //x=42.485 //y=5.2 //x2=42.19 //y2=5.56
cc_6844 ( N_VDD_M98_noxref_s N_noxref_25_c_11908_n ) capacitor c=9.52042e-19 \
 //x=44.365 //y=5.2 //x2=42.19 //y2=5.56
cc_6845 ( N_VDD_M97_noxref_d N_noxref_25_c_11849_n ) capacitor c=7.24703e-19 \
 //x=42.485 //y=5.2 //x2=42.67 //y2=2.4
cc_6846 ( N_VDD_c_10241_n N_noxref_25_c_11805_n ) capacitor c=0.00224881f \
 //x=65.575 //y=7.585 //x2=41.31 //y2=5.56
cc_6847 ( N_VDD_c_10740_n N_noxref_25_c_11805_n ) capacitor c=0.0136705f \
 //x=41.665 //y=7.585 //x2=41.31 //y2=5.56
cc_6848 ( N_VDD_c_10746_n N_noxref_25_c_11805_n ) capacitor c=0.0064135f \
 //x=40.08 //y=7.585 //x2=41.31 //y2=5.56
cc_6849 ( N_VDD_M94_noxref_s N_noxref_25_c_11805_n ) capacitor c=0.0887533f \
 //x=40.735 //y=5.2 //x2=41.31 //y2=5.56
cc_6850 ( N_VDD_M95_noxref_d N_noxref_25_c_11805_n ) capacitor c=0.065554f \
 //x=41.605 //y=5.2 //x2=41.31 //y2=5.56
cc_6851 ( N_VDD_c_10241_n N_noxref_25_c_11853_n ) capacitor c=0.00224881f \
 //x=65.575 //y=7.585 //x2=42.19 //y2=5.56
cc_6852 ( N_VDD_c_10794_n N_noxref_25_c_11853_n ) capacitor c=0.0136705f \
 //x=42.545 //y=7.585 //x2=42.19 //y2=5.56
cc_6853 ( N_VDD_c_10822_n N_noxref_25_c_11853_n ) capacitor c=0.0101861f \
 //x=43.41 //y=7.585 //x2=42.19 //y2=5.56
cc_6854 ( N_VDD_M95_noxref_d N_noxref_25_c_11853_n ) capacitor c=0.065554f \
 //x=41.605 //y=5.2 //x2=42.19 //y2=5.56
cc_6855 ( N_VDD_M97_noxref_d N_noxref_25_c_11853_n ) capacitor c=0.065554f \
 //x=42.485 //y=5.2 //x2=42.19 //y2=5.56
cc_6856 ( N_VDD_c_11511_p N_noxref_27_c_12022_n ) capacitor c=4.78686e-19 \
 //x=66.455 //y=7.585 //x2=66.865 //y2=5.39
cc_6857 ( N_VDD_c_11277_n N_noxref_27_c_12022_n ) capacitor c=0.00476346f \
 //x=66.54 //y=7.035 //x2=66.865 //y2=5.39
cc_6858 ( N_VDD_c_11513_p N_noxref_27_c_12022_n ) capacitor c=5.98042e-19 \
 //x=67.335 //y=7.585 //x2=66.865 //y2=5.39
cc_6859 ( N_VDD_c_11289_n N_noxref_27_c_12022_n ) capacitor c=0.00734603f \
 //x=68.03 //y=7.585 //x2=66.865 //y2=5.39
cc_6860 ( N_VDD_M125_noxref_d N_noxref_27_c_12022_n ) capacitor c=0.00679741f \
 //x=66.395 //y=5.205 //x2=66.865 //y2=5.39
cc_6861 ( N_VDD_c_11513_p N_noxref_27_c_12024_n ) capacitor c=5.52065e-19 \
 //x=67.335 //y=7.585 //x2=68.865 //y2=5.39
cc_6862 ( N_VDD_c_11343_n N_noxref_27_c_12024_n ) capacitor c=0.0040485f \
 //x=67.42 //y=7.035 //x2=68.865 //y2=5.39
cc_6863 ( N_VDD_c_11434_n N_noxref_27_c_12024_n ) capacitor c=0.0140204f \
 //x=76.34 //y=7.58 //x2=68.865 //y2=5.39
cc_6864 ( N_VDD_c_11289_n N_noxref_27_c_12024_n ) capacitor c=0.00703326f \
 //x=68.03 //y=7.585 //x2=68.865 //y2=5.39
cc_6865 ( N_VDD_c_11292_n N_noxref_27_c_12024_n ) capacitor c=0.00273146f \
 //x=71.36 //y=7.585 //x2=68.865 //y2=5.39
cc_6866 ( N_VDD_c_11310_n N_noxref_27_c_12024_n ) capacitor c=0.039327f \
 //x=68.2 //y=7.585 //x2=68.865 //y2=5.39
cc_6867 ( N_VDD_M127_noxref_d N_noxref_27_c_12024_n ) capacitor c=0.0138307f \
 //x=67.275 //y=5.205 //x2=68.865 //y2=5.39
cc_6868 ( N_VDD_c_11310_n N_noxref_27_c_12027_n ) capacitor c=3.35418e-19 \
 //x=68.2 //y=7.585 //x2=67.095 //y2=5.39
cc_6869 ( N_VDD_M127_noxref_d N_noxref_27_c_12027_n ) capacitor c=6.02701e-19 \
 //x=67.275 //y=5.205 //x2=67.095 //y2=5.39
cc_6870 ( N_VDD_M124_noxref_s N_noxref_27_c_12035_n ) capacitor c=0.0552377f \
 //x=65.525 //y=5.205 //x2=66.102 //y2=5.39
cc_6871 ( N_VDD_c_11343_n N_noxref_27_c_12041_n ) capacitor c=0.00979658f \
 //x=67.42 //y=7.035 //x2=68.98 //y2=6.92
cc_6872 ( N_VDD_c_11344_n N_noxref_27_c_12041_n ) capacitor c=0.00197255f \
 //x=67.42 //y=7.41 //x2=68.98 //y2=6.92
cc_6873 ( N_VDD_c_11434_n N_noxref_27_c_12041_n ) capacitor c=0.172135f \
 //x=76.34 //y=7.58 //x2=68.98 //y2=6.92
cc_6874 ( N_VDD_c_11292_n N_noxref_27_c_12041_n ) capacitor c=0.0401324f \
 //x=71.36 //y=7.585 //x2=68.98 //y2=6.92
cc_6875 ( N_VDD_c_11310_n N_noxref_27_c_12041_n ) capacitor c=0.00739076f \
 //x=68.2 //y=7.585 //x2=68.98 //y2=6.92
cc_6876 ( N_VDD_c_11434_n N_noxref_27_c_12073_n ) capacitor c=0.0021469f \
 //x=76.34 //y=7.58 //x2=70.74 //y2=6.92
cc_6877 ( N_VDD_c_11292_n N_noxref_27_c_12073_n ) capacitor c=4.35699e-19 \
 //x=71.36 //y=7.585 //x2=70.74 //y2=6.92
cc_6878 ( N_VDD_c_11316_n N_noxref_27_c_12073_n ) capacitor c=0.00733935f \
 //x=71.53 //y=7.585 //x2=70.74 //y2=6.92
cc_6879 ( N_VDD_c_11275_n N_noxref_27_c_12043_n ) capacitor c=0.0041288f \
 //x=65.66 //y=7.035 //x2=66.1 //y2=5.56
cc_6880 ( N_VDD_c_11276_n N_noxref_27_c_12043_n ) capacitor c=0.00145923f \
 //x=65.66 //y=7.41 //x2=66.1 //y2=5.56
cc_6881 ( N_VDD_c_11511_p N_noxref_27_c_12043_n ) capacitor c=0.00233559f \
 //x=66.455 //y=7.585 //x2=66.1 //y2=5.56
cc_6882 ( N_VDD_c_11277_n N_noxref_27_c_12043_n ) capacitor c=0.00220869f \
 //x=66.54 //y=7.035 //x2=66.1 //y2=5.56
cc_6883 ( N_VDD_c_11278_n N_noxref_27_c_12043_n ) capacitor c=0.00130452f \
 //x=66.54 //y=7.41 //x2=66.1 //y2=5.56
cc_6884 ( N_VDD_c_11289_n N_noxref_27_c_12043_n ) capacitor c=0.0112616f \
 //x=68.03 //y=7.585 //x2=66.1 //y2=5.56
cc_6885 ( N_VDD_c_11233_n N_noxref_27_c_12043_n ) capacitor c=0.00722375f \
 //x=64.87 //y=7.585 //x2=66.1 //y2=5.56
cc_6886 ( N_VDD_c_11460_n N_noxref_27_c_12043_n ) capacitor c=2.28864e-19 \
 //x=76.34 //y=7.58 //x2=66.1 //y2=5.56
cc_6887 ( N_VDD_M124_noxref_s N_noxref_27_c_12043_n ) capacitor c=0.0895437f \
 //x=65.525 //y=5.205 //x2=66.1 //y2=5.56
cc_6888 ( N_VDD_M125_noxref_d N_noxref_27_c_12043_n ) capacitor c=0.072364f \
 //x=66.395 //y=5.205 //x2=66.1 //y2=5.56
cc_6889 ( N_VDD_c_11277_n N_noxref_27_c_12046_n ) capacitor c=0.00230229f \
 //x=66.54 //y=7.035 //x2=66.98 //y2=5.39
cc_6890 ( N_VDD_c_11278_n N_noxref_27_c_12046_n ) capacitor c=0.00130452f \
 //x=66.54 //y=7.41 //x2=66.98 //y2=5.39
cc_6891 ( N_VDD_c_11513_p N_noxref_27_c_12046_n ) capacitor c=0.00233409f \
 //x=67.335 //y=7.585 //x2=66.98 //y2=5.39
cc_6892 ( N_VDD_c_11343_n N_noxref_27_c_12046_n ) capacitor c=0.00225444f \
 //x=67.42 //y=7.035 //x2=66.98 //y2=5.39
cc_6893 ( N_VDD_c_11344_n N_noxref_27_c_12046_n ) capacitor c=0.00130452f \
 //x=67.42 //y=7.41 //x2=66.98 //y2=5.39
cc_6894 ( N_VDD_c_11289_n N_noxref_27_c_12046_n ) capacitor c=0.0112507f \
 //x=68.03 //y=7.585 //x2=66.98 //y2=5.39
cc_6895 ( N_VDD_c_11233_n N_noxref_27_c_12046_n ) capacitor c=0.00105173f \
 //x=64.87 //y=7.585 //x2=66.98 //y2=5.39
cc_6896 ( N_VDD_c_11310_n N_noxref_27_c_12046_n ) capacitor c=0.00924237f \
 //x=68.2 //y=7.585 //x2=66.98 //y2=5.39
cc_6897 ( N_VDD_c_11460_n N_noxref_27_c_12046_n ) capacitor c=2.28864e-19 \
 //x=76.34 //y=7.58 //x2=66.98 //y2=5.39
cc_6898 ( N_VDD_M124_noxref_s N_noxref_27_c_12046_n ) capacitor c=0.00114869f \
 //x=65.525 //y=5.205 //x2=66.98 //y2=5.39
cc_6899 ( N_VDD_M125_noxref_d N_noxref_27_c_12046_n ) capacitor c=0.0724198f \
 //x=66.395 //y=5.205 //x2=66.98 //y2=5.39
cc_6900 ( N_VDD_M127_noxref_d N_noxref_27_c_12046_n ) capacitor c=0.0886704f \
 //x=67.275 //y=5.205 //x2=66.98 //y2=5.39
cc_6901 ( N_VDD_c_11434_n N_noxref_27_c_12047_n ) capacitor c=0.00204931f \
 //x=76.34 //y=7.58 //x2=68.98 //y2=5.39
cc_6902 ( N_VDD_c_11292_n N_noxref_27_c_12047_n ) capacitor c=0.00853641f \
 //x=71.36 //y=7.585 //x2=68.98 //y2=5.39
cc_6903 ( N_VDD_c_11310_n N_noxref_27_c_12047_n ) capacitor c=0.0602194f \
 //x=68.2 //y=7.585 //x2=68.98 //y2=5.39
cc_6904 ( N_VDD_c_11316_n N_noxref_27_c_12047_n ) capacitor c=6.42159e-19 \
 //x=71.53 //y=7.585 //x2=68.98 //y2=5.39
cc_6905 ( N_VDD_c_11460_n N_noxref_27_c_12047_n ) capacitor c=2.28864e-19 \
 //x=76.34 //y=7.58 //x2=68.98 //y2=5.39
cc_6906 ( N_VDD_M127_noxref_d N_noxref_27_c_12047_n ) capacitor c=0.00230512f \
 //x=67.275 //y=5.205 //x2=68.98 //y2=5.39
cc_6907 ( N_VDD_c_11275_n N_noxref_27_M124_noxref_d ) capacitor c=0.0391448f \
 //x=65.66 //y=7.035 //x2=65.955 //y2=5.205
cc_6908 ( N_VDD_c_11276_n N_noxref_27_M124_noxref_d ) capacitor c=0.00985747f \
 //x=65.66 //y=7.41 //x2=65.955 //y2=5.205
cc_6909 ( N_VDD_c_11511_p N_noxref_27_M124_noxref_d ) capacitor c=0.0238892f \
 //x=66.455 //y=7.585 //x2=65.955 //y2=5.205
cc_6910 ( N_VDD_c_11277_n N_noxref_27_M124_noxref_d ) capacitor c=0.0380657f \
 //x=66.54 //y=7.035 //x2=65.955 //y2=5.205
cc_6911 ( N_VDD_c_11278_n N_noxref_27_M124_noxref_d ) capacitor c=0.0100015f \
 //x=66.54 //y=7.41 //x2=65.955 //y2=5.205
cc_6912 ( N_VDD_c_11289_n N_noxref_27_M124_noxref_d ) capacitor c=0.00302682f \
 //x=68.03 //y=7.585 //x2=65.955 //y2=5.205
cc_6913 ( N_VDD_M124_noxref_s N_noxref_27_M124_noxref_d ) capacitor \
 c=0.00271779f //x=65.525 //y=5.205 //x2=65.955 //y2=5.205
cc_6914 ( N_VDD_M125_noxref_d N_noxref_27_M124_noxref_d ) capacitor \
 c=0.00360728f //x=66.395 //y=5.205 //x2=65.955 //y2=5.205
cc_6915 ( N_VDD_c_11277_n N_noxref_27_M126_noxref_d ) capacitor c=0.0379915f \
 //x=66.54 //y=7.035 //x2=66.835 //y2=5.205
cc_6916 ( N_VDD_c_11278_n N_noxref_27_M126_noxref_d ) capacitor c=0.0100015f \
 //x=66.54 //y=7.41 //x2=66.835 //y2=5.205
cc_6917 ( N_VDD_c_11513_p N_noxref_27_M126_noxref_d ) capacitor c=0.0230655f \
 //x=67.335 //y=7.585 //x2=66.835 //y2=5.205
cc_6918 ( N_VDD_c_11343_n N_noxref_27_M126_noxref_d ) capacitor c=0.0379915f \
 //x=67.42 //y=7.035 //x2=66.835 //y2=5.205
cc_6919 ( N_VDD_c_11344_n N_noxref_27_M126_noxref_d ) capacitor c=0.0100015f \
 //x=67.42 //y=7.41 //x2=66.835 //y2=5.205
cc_6920 ( N_VDD_c_11289_n N_noxref_27_M126_noxref_d ) capacitor c=0.00283306f \
 //x=68.03 //y=7.585 //x2=66.835 //y2=5.205
cc_6921 ( N_VDD_M125_noxref_d N_noxref_27_M126_noxref_d ) capacitor \
 c=0.00351276f //x=66.395 //y=5.205 //x2=66.835 //y2=5.205
cc_6922 ( N_VDD_M127_noxref_d N_noxref_27_M126_noxref_d ) capacitor \
 c=0.00355849f //x=67.275 //y=5.205 //x2=66.835 //y2=5.205
cc_6923 ( N_VDD_c_11434_n N_noxref_27_M129_noxref_d ) capacitor c=0.00206569f \
 //x=76.34 //y=7.58 //x2=69.715 //y2=5.205
cc_6924 ( N_VDD_c_11292_n N_noxref_27_M129_noxref_d ) capacitor c=0.00856914f \
 //x=71.36 //y=7.585 //x2=69.715 //y2=5.205
cc_6925 ( N_VDD_c_11460_n N_noxref_27_M129_noxref_d ) capacitor c=2.28864e-19 \
 //x=76.34 //y=7.58 //x2=69.715 //y2=5.205
cc_6926 ( N_VDD_c_11434_n N_noxref_27_M131_noxref_d ) capacitor c=0.00206569f \
 //x=76.34 //y=7.58 //x2=70.595 //y2=5.205
cc_6927 ( N_VDD_c_11292_n N_noxref_27_M131_noxref_d ) capacitor c=0.00856914f \
 //x=71.36 //y=7.585 //x2=70.595 //y2=5.205
cc_6928 ( N_VDD_c_11316_n N_noxref_27_M131_noxref_d ) capacitor c=0.0448255f \
 //x=71.53 //y=7.585 //x2=70.595 //y2=5.205
cc_6929 ( N_VDD_c_11460_n N_noxref_27_M131_noxref_d ) capacitor c=2.28864e-19 \
 //x=76.34 //y=7.58 //x2=70.595 //y2=5.205
cc_6930 ( N_VDD_c_11434_n N_noxref_28_c_12195_n ) capacitor c=0.0143613f \
 //x=76.34 //y=7.58 //x2=72.205 //y2=5.39
cc_6931 ( N_VDD_c_11292_n N_noxref_28_c_12195_n ) capacitor c=0.00336719f \
 //x=71.36 //y=7.585 //x2=72.205 //y2=5.39
cc_6932 ( N_VDD_c_11349_n N_noxref_28_c_12195_n ) capacitor c=0.00275849f \
 //x=74.69 //y=7.585 //x2=72.205 //y2=5.39
cc_6933 ( N_VDD_c_11316_n N_noxref_28_c_12195_n ) capacitor c=0.042287f \
 //x=71.53 //y=7.585 //x2=72.205 //y2=5.39
cc_6934 ( N_VDD_c_11316_n N_noxref_28_c_12196_n ) capacitor c=6.67754e-19 \
 //x=71.53 //y=7.585 //x2=70.415 //y2=5.39
cc_6935 ( N_VDD_c_11316_n N_noxref_28_c_12184_n ) capacitor c=0.00108821f \
 //x=71.53 //y=7.585 //x2=69.42 //y2=5.39
cc_6936 ( N_VDD_M124_noxref_s N_noxref_28_c_12184_n ) capacitor c=4.98377e-19 \
 //x=65.525 //y=5.205 //x2=69.42 //y2=5.39
cc_6937 ( N_VDD_c_11316_n N_noxref_28_c_12200_n ) capacitor c=0.00456697f \
 //x=71.53 //y=7.585 //x2=70.3 //y2=5.39
cc_6938 ( N_VDD_c_11434_n N_noxref_28_c_12226_n ) capacitor c=0.172244f \
 //x=76.34 //y=7.58 //x2=72.32 //y2=6.92
cc_6939 ( N_VDD_c_11349_n N_noxref_28_c_12226_n ) capacitor c=0.0392376f \
 //x=74.69 //y=7.585 //x2=72.32 //y2=6.92
cc_6940 ( N_VDD_c_11316_n N_noxref_28_c_12226_n ) capacitor c=0.00730382f \
 //x=71.53 //y=7.585 //x2=72.32 //y2=6.92
cc_6941 ( N_VDD_c_11434_n N_noxref_28_c_12202_n ) capacitor c=0.00215296f \
 //x=76.34 //y=7.58 //x2=74.08 //y2=6.92
cc_6942 ( N_VDD_c_11349_n N_noxref_28_c_12202_n ) capacitor c=4.60826e-19 \
 //x=74.69 //y=7.585 //x2=74.08 //y2=6.92
cc_6943 ( N_VDD_c_11366_n N_noxref_28_c_12202_n ) capacitor c=0.0114263f \
 //x=74.86 //y=7.585 //x2=74.08 //y2=6.92
cc_6944 ( N_VDD_c_11292_n N_noxref_28_c_12190_n ) capacitor c=0.00475693f \
 //x=71.36 //y=7.585 //x2=69.42 //y2=5.56
cc_6945 ( N_VDD_c_11310_n N_noxref_28_c_12190_n ) capacitor c=0.00539528f \
 //x=68.2 //y=7.585 //x2=69.42 //y2=5.56
cc_6946 ( N_VDD_c_11316_n N_noxref_28_c_12190_n ) capacitor c=0.00106566f \
 //x=71.53 //y=7.585 //x2=69.42 //y2=5.56
cc_6947 ( N_VDD_c_11434_n N_noxref_28_c_12203_n ) capacitor c=0.00204931f \
 //x=76.34 //y=7.58 //x2=72.32 //y2=5.39
cc_6948 ( N_VDD_c_11349_n N_noxref_28_c_12203_n ) capacitor c=0.00853641f \
 //x=74.69 //y=7.585 //x2=72.32 //y2=5.39
cc_6949 ( N_VDD_c_11316_n N_noxref_28_c_12203_n ) capacitor c=0.0592438f \
 //x=71.53 //y=7.585 //x2=72.32 //y2=5.39
cc_6950 ( N_VDD_c_11366_n N_noxref_28_c_12203_n ) capacitor c=0.00100394f \
 //x=74.86 //y=7.585 //x2=72.32 //y2=5.39
cc_6951 ( N_VDD_c_11460_n N_noxref_28_c_12203_n ) capacitor c=2.28864e-19 \
 //x=76.34 //y=7.58 //x2=72.32 //y2=5.39
cc_6952 ( N_VDD_c_11434_n N_noxref_28_M133_noxref_d ) capacitor c=0.00206569f \
 //x=76.34 //y=7.58 //x2=73.055 //y2=5.205
cc_6953 ( N_VDD_c_11349_n N_noxref_28_M133_noxref_d ) capacitor c=0.00856914f \
 //x=74.69 //y=7.585 //x2=73.055 //y2=5.205
cc_6954 ( N_VDD_c_11460_n N_noxref_28_M133_noxref_d ) capacitor c=2.28864e-19 \
 //x=76.34 //y=7.58 //x2=73.055 //y2=5.205
cc_6955 ( N_VDD_c_11434_n N_noxref_28_M135_noxref_d ) capacitor c=0.00206569f \
 //x=76.34 //y=7.58 //x2=73.935 //y2=5.205
cc_6956 ( N_VDD_c_11349_n N_noxref_28_M135_noxref_d ) capacitor c=0.00856914f \
 //x=74.69 //y=7.585 //x2=73.935 //y2=5.205
cc_6957 ( N_VDD_c_11366_n N_noxref_28_M135_noxref_d ) capacitor c=0.0443649f \
 //x=74.86 //y=7.585 //x2=73.935 //y2=5.205
cc_6958 ( N_VDD_c_11460_n N_noxref_28_M135_noxref_d ) capacitor c=2.28864e-19 \
 //x=76.34 //y=7.58 //x2=73.935 //y2=5.205
cc_6959 ( N_VDD_M136_noxref_s N_noxref_28_M135_noxref_d ) capacitor \
 c=0.00249451f //x=75.4 //y=5.2 //x2=73.935 //y2=5.205
cc_6960 ( N_VDD_c_10364_n N_GND_c_12521_n ) capacitor c=0.00989514f //x=1.23 \
 //y=7.58 //x2=1.23 //y2=0.18
cc_6961 ( N_VDD_c_10264_n N_GND_c_12340_n ) capacitor c=0.00654453f //x=5.3 \
 //y=7.585 //x2=5.3 //y2=0.175
cc_6962 ( N_VDD_c_10269_n N_GND_c_12345_n ) capacitor c=0.00654453f //x=8.63 \
 //y=7.585 //x2=8.63 //y2=0.175
cc_6963 ( N_VDD_c_10322_n N_GND_c_12385_n ) capacitor c=0.00654453f //x=11.96 \
 //y=7.585 //x2=11.96 //y2=0.175
cc_6964 ( N_VDD_c_10391_n N_GND_c_12440_n ) capacitor c=0.00663779f //x=15.29 \
 //y=7.585 //x2=15.29 //y2=0.175
cc_6965 ( N_VDD_c_10439_n N_GND_c_12483_n ) capacitor c=0.00648088f //x=18.62 \
 //y=7.585 //x2=18.62 //y2=0.175
cc_6966 ( N_VDD_c_10515_n N_GND_c_12535_n ) capacitor c=0.00915826f //x=21.95 \
 //y=7.585 //x2=21.95 //y2=0.175
cc_6967 ( N_VDD_c_10570_n N_GND_c_12569_n ) capacitor c=0.00648088f //x=26.76 \
 //y=7.585 //x2=26.76 //y2=0.175
cc_6968 ( N_VDD_c_10575_n N_GND_c_12573_n ) capacitor c=0.00648088f //x=30.09 \
 //y=7.585 //x2=30.09 //y2=0.175
cc_6969 ( N_VDD_c_10628_n N_GND_c_12612_n ) capacitor c=0.00648088f //x=33.42 \
 //y=7.585 //x2=33.42 //y2=0.175
cc_6970 ( N_VDD_c_10697_n N_GND_c_12666_n ) capacitor c=0.00648088f //x=36.75 \
 //y=7.585 //x2=36.75 //y2=0.175
cc_6971 ( N_VDD_c_10746_n N_GND_c_12708_n ) capacitor c=0.00648088f //x=40.08 \
 //y=7.585 //x2=40.08 //y2=0.175
cc_6972 ( N_VDD_c_10822_n N_GND_c_12760_n ) capacitor c=0.00915826f //x=43.41 \
 //y=7.585 //x2=43.41 //y2=0.175
cc_6973 ( N_VDD_c_10900_n N_GND_c_12823_n ) capacitor c=0.00648088f //x=48.22 \
 //y=7.585 //x2=48.22 //y2=0.175
cc_6974 ( N_VDD_c_10865_n N_GND_c_12825_n ) capacitor c=0.00648088f //x=51.55 \
 //y=7.585 //x2=51.55 //y2=0.175
cc_6975 ( N_VDD_c_10958_n N_GND_c_12895_n ) capacitor c=0.00648088f //x=54.88 \
 //y=7.585 //x2=54.88 //y2=0.175
cc_6976 ( N_VDD_c_11025_n N_GND_c_12925_n ) capacitor c=0.00648088f //x=58.21 \
 //y=7.585 //x2=58.21 //y2=0.175
cc_6977 ( N_VDD_c_11153_n N_GND_c_13009_n ) capacitor c=0.00648088f //x=61.54 \
 //y=7.585 //x2=61.54 //y2=0.175
cc_6978 ( N_VDD_c_11233_n N_GND_c_13061_n ) capacitor c=0.00897677f //x=64.87 \
 //y=7.585 //x2=64.87 //y2=0.175
cc_6979 ( N_VDD_c_11310_n N_GND_c_13115_n ) capacitor c=0.00653385f //x=68.2 \
 //y=7.585 //x2=68.2 //y2=0.175
cc_6980 ( N_VDD_c_11316_n N_GND_c_13172_n ) capacitor c=0.00684375f //x=71.53 \
 //y=7.585 //x2=71.53 //y2=0.175
cc_6981 ( N_VDD_c_11366_n N_GND_c_13173_n ) capacitor c=0.00655202f //x=74.86 \
 //y=7.585 //x2=74.86 //y2=0.175
cc_6982 ( N_VDD_c_11460_n N_GND_c_13293_n ) capacitor c=0.00989514f //x=76.34 \
 //y=7.58 //x2=76.46 //y2=0.175
cc_6983 ( N_VDD_c_11460_n Q ) capacitor c=0.0293824f //x=76.34 //y=7.58 \
 //x2=76.34 //y2=2.4
cc_6984 ( N_VDD_c_11434_n N_Q_c_13922_n ) capacitor c=0.00259721f //x=76.34 \
 //y=7.58 //x2=75.975 //y2=5.42
cc_6985 ( N_VDD_c_11443_n N_Q_c_13922_n ) capacitor c=0.00100699f //x=76.33 \
 //y=7.585 //x2=75.975 //y2=5.42
cc_6986 ( N_VDD_c_11460_n N_Q_c_13922_n ) capacitor c=0.00295945f //x=76.34 \
 //y=7.58 //x2=75.975 //y2=5.42
cc_6987 ( N_VDD_M136_noxref_s N_Q_c_13922_n ) capacitor c=0.0465774f //x=75.4 \
 //y=5.2 //x2=75.975 //y2=5.42
cc_6988 ( N_VDD_M137_noxref_d N_Q_c_13922_n ) capacitor c=0.0486749f //x=76.27 \
 //y=5.2 //x2=75.975 //y2=5.42
cc_6989 ( N_VDD_c_11434_n N_Q_c_13929_n ) capacitor c=0.00199795f //x=76.34 \
 //y=7.58 //x2=76.255 //y2=5.14
cc_6990 ( N_VDD_c_11443_n N_Q_c_13929_n ) capacitor c=0.00207379f //x=76.33 \
 //y=7.585 //x2=76.255 //y2=5.14
cc_6991 ( N_VDD_M137_noxref_d N_Q_c_13929_n ) capacitor c=0.0235609f //x=76.27 \
 //y=5.2 //x2=76.255 //y2=5.14
cc_6992 ( N_VDD_c_11366_n N_Q_c_13930_n ) capacitor c=0.00484013f //x=74.86 \
 //y=7.585 //x2=76.06 //y2=5.14
cc_6993 ( N_VDD_c_11434_n N_Q_c_13941_n ) capacitor c=0.00241566f //x=76.34 \
 //y=7.58 //x2=75.975 //y2=5.56
cc_6994 ( N_VDD_c_11443_n N_Q_c_13941_n ) capacitor c=0.0138017f //x=76.33 \
 //y=7.585 //x2=75.975 //y2=5.56
cc_6995 ( N_VDD_c_11366_n N_Q_c_13941_n ) capacitor c=0.00819514f //x=74.86 \
 //y=7.585 //x2=75.975 //y2=5.56
cc_6996 ( N_VDD_c_11460_n N_Q_c_13941_n ) capacitor c=0.00825846f //x=76.34 \
 //y=7.58 //x2=75.975 //y2=5.56
cc_6997 ( N_VDD_M136_noxref_s N_Q_c_13941_n ) capacitor c=0.0897898f //x=75.4 \
 //y=5.2 //x2=75.975 //y2=5.56
cc_6998 ( N_VDD_M137_noxref_d N_Q_c_13941_n ) capacitor c=0.0929254f //x=76.27 \
 //y=5.2 //x2=75.975 //y2=5.56
cc_6999 ( N_VDD_c_11292_n noxref_50 ) capacitor c=0.0048583f //x=71.36 \
 //y=7.585 //x2=70.155 //y2=5.205
cc_7000 ( N_VDD_c_11316_n noxref_50 ) capacitor c=0.00487712f //x=71.53 \
 //y=7.585 //x2=70.155 //y2=5.205
cc_7001 ( N_noxref_23_c_11678_n N_GND_c_12316_n ) capacitor c=0.0079063f \
 //x=3.505 //y=1.175 //x2=6.395 //y2=0.175
cc_7002 ( N_noxref_23_c_11694_p N_GND_c_12316_n ) capacitor c=0.00685901f \
 //x=3.59 //y=0.805 //x2=6.395 //y2=0.175
cc_7003 ( N_noxref_23_c_11656_n N_GND_c_12316_n ) capacitor c=0.00958276f \
 //x=4.475 //y=0.72 //x2=6.395 //y2=0.175
cc_7004 ( N_noxref_23_c_11696_p N_GND_c_12316_n ) capacitor c=0.00232964f \
 //x=4.56 //y=0.805 //x2=6.395 //y2=0.175
cc_7005 ( N_noxref_23_M1_noxref_d N_GND_c_12316_n ) capacitor c=0.0134285f \
 //x=2.35 //y=1.09 //x2=6.395 //y2=0.175
cc_7006 ( N_noxref_23_M1_noxref_d N_GND_c_12506_n ) capacitor c=0.0156367f \
 //x=2.35 //y=1.09 //x2=1.565 //y2=1.145
cc_7007 ( N_noxref_23_c_11678_n N_GND_c_12337_n ) capacitor c=0.0080792f \
 //x=3.505 //y=1.175 //x2=5.13 //y2=0.175
cc_7008 ( N_noxref_23_c_11694_p N_GND_c_12337_n ) capacitor c=0.0140766f \
 //x=3.59 //y=0.805 //x2=5.13 //y2=0.175
cc_7009 ( N_noxref_23_c_11656_n N_GND_c_12337_n ) capacitor c=0.0364997f \
 //x=4.475 //y=0.72 //x2=5.13 //y2=0.175
cc_7010 ( N_noxref_23_c_11696_p N_GND_c_12337_n ) capacitor c=0.013886f \
 //x=4.56 //y=0.805 //x2=5.13 //y2=0.175
cc_7011 ( N_noxref_23_M2_noxref_s N_GND_c_12521_n ) capacitor c=8.16352e-19 \
 //x=3.455 //y=0.555 //x2=1.23 //y2=0.18
cc_7012 ( N_noxref_23_c_11696_p N_GND_c_12340_n ) capacitor c=0.0374312f \
 //x=4.56 //y=0.805 //x2=5.3 //y2=0.175
cc_7013 ( N_noxref_23_M2_noxref_s N_GND_c_12340_n ) capacitor c=0.00519576f \
 //x=3.455 //y=0.555 //x2=5.3 //y2=0.175
cc_7014 ( N_noxref_23_c_11656_n N_GND_c_13293_n ) capacitor c=0.00190243f \
 //x=4.475 //y=0.72 //x2=76.46 //y2=0.175
cc_7015 ( N_noxref_23_M1_noxref_d N_GND_M0_noxref_d ) capacitor c=3.12752e-19 \
 //x=2.35 //y=1.09 //x2=1.375 //y2=1.055
cc_7016 ( N_noxref_23_c_11694_p N_noxref_31_c_14005_n ) capacitor \
 c=2.15937e-19 //x=3.59 //y=0.805 //x2=2.05 //y2=0.805
cc_7017 ( N_noxref_23_c_11678_n N_noxref_31_c_13995_n ) capacitor c=0.0132582f \
 //x=3.505 //y=1.175 //x2=2.935 //y2=0.72
cc_7018 ( N_noxref_23_M1_noxref_d N_noxref_31_c_13995_n ) capacitor \
 c=0.016458f //x=2.35 //y=1.09 //x2=2.935 //y2=0.72
cc_7019 ( N_noxref_23_c_11678_n N_noxref_31_c_13989_n ) capacitor \
 c=0.00954209f //x=3.505 //y=1.175 //x2=2.935 //y2=1.77
cc_7020 ( N_noxref_23_M1_noxref_d N_noxref_31_c_13989_n ) capacitor \
 c=0.015272f //x=2.35 //y=1.09 //x2=2.935 //y2=1.77
cc_7021 ( N_noxref_23_c_11678_n N_noxref_31_M0_noxref_s ) capacitor \
 c=0.023368f //x=3.505 //y=1.175 //x2=0.945 //y2=0.555
cc_7022 ( N_noxref_23_c_11694_p N_noxref_31_M0_noxref_s ) capacitor \
 c=0.0175532f //x=3.59 //y=0.805 //x2=0.945 //y2=0.555
cc_7023 ( N_noxref_23_c_11696_p N_noxref_31_M0_noxref_s ) capacitor \
 c=2.98721e-19 //x=4.56 //y=0.805 //x2=0.945 //y2=0.555
cc_7024 ( N_noxref_23_M1_noxref_d N_noxref_31_M0_noxref_s ) capacitor \
 c=0.0187969f //x=2.35 //y=1.09 //x2=0.945 //y2=0.555
cc_7025 ( N_noxref_23_M2_noxref_s N_noxref_31_M0_noxref_s ) capacitor \
 c=0.021082f //x=3.455 //y=0.555 //x2=0.945 //y2=0.555
cc_7026 ( N_noxref_23_c_11696_p N_noxref_32_M3_noxref_s ) capacitor \
 c=0.00370912f //x=4.56 //y=0.805 //x2=5.86 //y2=0.545
cc_7027 ( N_noxref_23_M2_noxref_s N_noxref_32_M3_noxref_s ) capacitor \
 c=0.00101401f //x=3.455 //y=0.555 //x2=5.86 //y2=0.545
cc_7028 ( N_noxref_24_c_11741_n N_GND_c_12546_n ) capacitor c=0.00533679f \
 //x=24.965 //y=1.175 //x2=27.855 //y2=0.175
cc_7029 ( N_noxref_24_c_11762_p N_GND_c_12546_n ) capacitor c=0.00430725f \
 //x=25.05 //y=0.805 //x2=27.855 //y2=0.175
cc_7030 ( N_noxref_24_c_11720_n N_GND_c_12546_n ) capacitor c=0.00958276f \
 //x=25.935 //y=0.72 //x2=27.855 //y2=0.175
cc_7031 ( N_noxref_24_c_11764_p N_GND_c_12546_n ) capacitor c=0.00232964f \
 //x=26.02 //y=0.805 //x2=27.855 //y2=0.175
cc_7032 ( N_noxref_24_M14_noxref_d N_GND_c_12546_n ) capacitor c=0.0132354f \
 //x=23.81 //y=1.09 //x2=27.855 //y2=0.175
cc_7033 ( N_noxref_24_M14_noxref_d N_GND_c_12731_n ) capacitor c=0.0154456f \
 //x=23.81 //y=1.09 //x2=23.025 //y2=1.145
cc_7034 ( N_noxref_24_c_11741_n N_GND_c_12566_n ) capacitor c=0.00919902f \
 //x=24.965 //y=1.175 //x2=26.59 //y2=0.175
cc_7035 ( N_noxref_24_c_11762_p N_GND_c_12566_n ) capacitor c=0.0142396f \
 //x=25.05 //y=0.805 //x2=26.59 //y2=0.175
cc_7036 ( N_noxref_24_c_11720_n N_GND_c_12566_n ) capacitor c=0.0364875f \
 //x=25.935 //y=0.72 //x2=26.59 //y2=0.175
cc_7037 ( N_noxref_24_c_11764_p N_GND_c_12566_n ) capacitor c=0.013886f \
 //x=26.02 //y=0.805 //x2=26.59 //y2=0.175
cc_7038 ( N_noxref_24_M15_noxref_s N_GND_c_12535_n ) capacitor c=8.16352e-19 \
 //x=24.915 //y=0.555 //x2=21.95 //y2=0.175
cc_7039 ( N_noxref_24_c_11764_p N_GND_c_12569_n ) capacitor c=0.0374312f \
 //x=26.02 //y=0.805 //x2=26.76 //y2=0.175
cc_7040 ( N_noxref_24_M15_noxref_s N_GND_c_12569_n ) capacitor c=0.00519576f \
 //x=24.915 //y=0.555 //x2=26.76 //y2=0.175
cc_7041 ( N_noxref_24_c_11720_n N_GND_c_13293_n ) capacitor c=0.00190243f \
 //x=25.935 //y=0.72 //x2=76.46 //y2=0.175
cc_7042 ( N_noxref_24_M14_noxref_d N_GND_M13_noxref_d ) capacitor \
 c=3.12752e-19 //x=23.81 //y=1.09 //x2=22.835 //y2=1.055
cc_7043 ( N_noxref_24_c_11762_p N_noxref_37_c_14406_n ) capacitor \
 c=2.15937e-19 //x=25.05 //y=0.805 //x2=23.51 //y2=0.805
cc_7044 ( N_noxref_24_c_11741_n N_noxref_37_c_14396_n ) capacitor c=0.0131134f \
 //x=24.965 //y=1.175 //x2=24.395 //y2=0.72
cc_7045 ( N_noxref_24_M14_noxref_d N_noxref_37_c_14396_n ) capacitor \
 c=0.0160925f //x=23.81 //y=1.09 //x2=24.395 //y2=0.72
cc_7046 ( N_noxref_24_c_11741_n N_noxref_37_c_14394_n ) capacitor \
 c=0.00947943f //x=24.965 //y=1.175 //x2=24.395 //y2=1.77
cc_7047 ( N_noxref_24_M14_noxref_d N_noxref_37_c_14394_n ) capacitor \
 c=0.015272f //x=23.81 //y=1.09 //x2=24.395 //y2=1.77
cc_7048 ( N_noxref_24_c_11741_n N_noxref_37_M13_noxref_s ) capacitor \
 c=0.0225712f //x=24.965 //y=1.175 //x2=22.405 //y2=0.555
cc_7049 ( N_noxref_24_c_11762_p N_noxref_37_M13_noxref_s ) capacitor \
 c=0.0175532f //x=25.05 //y=0.805 //x2=22.405 //y2=0.555
cc_7050 ( N_noxref_24_c_11764_p N_noxref_37_M13_noxref_s ) capacitor \
 c=2.98721e-19 //x=26.02 //y=0.805 //x2=22.405 //y2=0.555
cc_7051 ( N_noxref_24_M14_noxref_d N_noxref_37_M13_noxref_s ) capacitor \
 c=0.0187674f //x=23.81 //y=1.09 //x2=22.405 //y2=0.555
cc_7052 ( N_noxref_24_M15_noxref_s N_noxref_37_M13_noxref_s ) capacitor \
 c=0.021082f //x=24.915 //y=0.555 //x2=22.405 //y2=0.555
cc_7053 ( N_noxref_24_c_11764_p N_noxref_38_M16_noxref_s ) capacitor \
 c=0.00370912f //x=26.02 //y=0.805 //x2=27.32 //y2=0.545
cc_7054 ( N_noxref_24_M15_noxref_s N_noxref_38_M16_noxref_s ) capacitor \
 c=0.00101401f //x=24.915 //y=0.555 //x2=27.32 //y2=0.545
cc_7055 ( N_noxref_25_c_11804_n N_noxref_26_M27_noxref_d ) capacitor \
 c=3.39394e-19 //x=42.23 //y=1.18 //x2=45.27 //y2=1.09
cc_7056 ( N_noxref_25_c_11822_n N_GND_c_12730_n ) capacitor c=0.00608539f \
 //x=42.585 //y=1.835 //x2=44.4 //y2=0.175
cc_7057 ( N_noxref_25_c_11828_n N_GND_c_12730_n ) capacitor c=4.00231e-19 \
 //x=42.67 //y=2.515 //x2=44.4 //y2=0.175
cc_7058 ( N_noxref_25_c_11804_n N_GND_c_12730_n ) capacitor c=0.00928865f \
 //x=42.23 //y=1.18 //x2=44.4 //y2=0.175
cc_7059 ( N_noxref_25_M25_noxref_d N_GND_c_12730_n ) capacitor c=3.01769e-19 \
 //x=42.04 //y=1.085 //x2=44.4 //y2=0.175
cc_7060 ( N_noxref_25_c_11795_n N_GND_c_12692_n ) capacitor c=6.49805e-19 \
 //x=41.31 //y=5.56 //x2=41.26 //y2=1.135
cc_7061 ( N_noxref_25_c_11804_n N_GND_c_12692_n ) capacitor c=0.0140087f \
 //x=42.23 //y=1.18 //x2=41.26 //y2=1.135
cc_7062 ( N_noxref_25_M25_noxref_d N_GND_c_12692_n ) capacitor c=2.93544e-19 \
 //x=42.04 //y=1.085 //x2=41.26 //y2=1.135
cc_7063 ( N_noxref_25_c_11804_n N_GND_c_13032_n ) capacitor c=0.00606355f \
 //x=42.23 //y=1.18 //x2=44.485 //y2=1.145
cc_7064 ( N_noxref_25_c_11822_n N_GND_c_12706_n ) capacitor c=7.75992e-19 \
 //x=42.585 //y=1.835 //x2=43.24 //y2=0.175
cc_7065 ( N_noxref_25_c_11791_n N_GND_c_12708_n ) capacitor c=9.32616e-19 \
 //x=42.67 //y=2.285 //x2=40.08 //y2=0.175
cc_7066 ( N_noxref_25_c_11849_n N_GND_c_12708_n ) capacitor c=4.78631e-19 \
 //x=42.67 //y=2.4 //x2=40.08 //y2=0.175
cc_7067 ( N_noxref_25_c_11789_n N_GND_c_12760_n ) capacitor c=0.00460657f \
 //x=42.23 //y=1.75 //x2=43.41 //y2=0.175
cc_7068 ( N_noxref_25_c_11822_n N_GND_c_12760_n ) capacitor c=0.0141927f \
 //x=42.585 //y=1.835 //x2=43.41 //y2=0.175
cc_7069 ( N_noxref_25_c_11791_n N_GND_c_12760_n ) capacitor c=5.09121e-19 \
 //x=42.67 //y=2.285 //x2=43.41 //y2=0.175
cc_7070 ( N_noxref_25_c_11828_n N_GND_c_12760_n ) capacitor c=0.00315935f \
 //x=42.67 //y=2.515 //x2=43.41 //y2=0.175
cc_7071 ( N_noxref_25_c_11792_n N_GND_c_12760_n ) capacitor c=0.00819268f \
 //x=42.67 //y=5.295 //x2=43.41 //y2=0.175
cc_7072 ( N_noxref_25_c_11849_n N_GND_c_12760_n ) capacitor c=0.011748f \
 //x=42.67 //y=2.4 //x2=43.41 //y2=0.175
cc_7073 ( N_noxref_25_c_11804_n N_GND_M24_noxref_d ) capacitor c=2.82748e-19 \
 //x=42.23 //y=1.18 //x2=41.07 //y2=1.045
cc_7074 ( N_noxref_25_c_11790_n N_noxref_42_c_14720_n ) capacitor \
 c=0.00911498f //x=42.315 //y=1.835 //x2=41.745 //y2=1.675
cc_7075 ( N_noxref_25_c_11822_n N_noxref_42_c_14728_n ) capacitor \
 c=0.00399245f //x=42.585 //y=1.835 //x2=42.63 //y2=0.71
cc_7076 ( N_noxref_25_c_11804_n N_noxref_42_c_14728_n ) capacitor c=0.003751f \
 //x=42.23 //y=1.18 //x2=42.63 //y2=0.71
cc_7077 ( N_noxref_25_M25_noxref_d N_noxref_42_c_14728_n ) capacitor \
 c=0.00910163f //x=42.04 //y=1.085 //x2=42.63 //y2=0.71
cc_7078 ( N_noxref_25_c_11789_n N_noxref_42_M24_noxref_s ) capacitor \
 c=0.0175047f //x=42.23 //y=1.75 //x2=40.64 //y2=0.545
cc_7079 ( N_noxref_25_c_11822_n N_noxref_42_M24_noxref_s ) capacitor \
 c=0.00488729f //x=42.585 //y=1.835 //x2=40.64 //y2=0.545
cc_7080 ( N_noxref_25_c_11828_n N_noxref_42_M24_noxref_s ) capacitor \
 c=0.0011364f //x=42.67 //y=2.515 //x2=40.64 //y2=0.545
cc_7081 ( N_noxref_25_c_11804_n N_noxref_42_M24_noxref_s ) capacitor \
 c=0.00894261f //x=42.23 //y=1.18 //x2=40.64 //y2=0.545
cc_7082 ( N_noxref_25_c_11849_n N_noxref_42_M24_noxref_s ) capacitor \
 c=0.00376542f //x=42.67 //y=2.4 //x2=40.64 //y2=0.545
cc_7083 ( N_noxref_25_M25_noxref_d N_noxref_42_M24_noxref_s ) capacitor \
 c=0.0275552f //x=42.04 //y=1.085 //x2=40.64 //y2=0.545
cc_7084 ( N_noxref_26_c_11964_n N_GND_c_12829_n ) capacitor c=0.00533679f \
 //x=46.425 //y=1.175 //x2=49.315 //y2=0.175
cc_7085 ( N_noxref_26_c_11996_p N_GND_c_12829_n ) capacitor c=0.00430725f \
 //x=46.51 //y=0.805 //x2=49.315 //y2=0.175
cc_7086 ( N_noxref_26_c_11954_n N_GND_c_12829_n ) capacitor c=0.00958276f \
 //x=47.395 //y=0.72 //x2=49.315 //y2=0.175
cc_7087 ( N_noxref_26_c_11998_p N_GND_c_12829_n ) capacitor c=0.00232964f \
 //x=47.48 //y=0.805 //x2=49.315 //y2=0.175
cc_7088 ( N_noxref_26_M27_noxref_d N_GND_c_12829_n ) capacitor c=0.0131076f \
 //x=45.27 //y=1.09 //x2=49.315 //y2=0.175
cc_7089 ( N_noxref_26_M27_noxref_d N_GND_c_13032_n ) capacitor c=0.0154456f \
 //x=45.27 //y=1.09 //x2=44.485 //y2=1.145
cc_7090 ( N_noxref_26_c_11964_n N_GND_c_12849_n ) capacitor c=0.0091517f \
 //x=46.425 //y=1.175 //x2=48.05 //y2=0.175
cc_7091 ( N_noxref_26_c_11996_p N_GND_c_12849_n ) capacitor c=0.0141638f \
 //x=46.51 //y=0.805 //x2=48.05 //y2=0.175
cc_7092 ( N_noxref_26_c_11954_n N_GND_c_12849_n ) capacitor c=0.0364778f \
 //x=47.395 //y=0.72 //x2=48.05 //y2=0.175
cc_7093 ( N_noxref_26_c_11998_p N_GND_c_12849_n ) capacitor c=0.013886f \
 //x=47.48 //y=0.805 //x2=48.05 //y2=0.175
cc_7094 ( N_noxref_26_M28_noxref_s N_GND_c_12760_n ) capacitor c=8.16352e-19 \
 //x=46.375 //y=0.555 //x2=43.41 //y2=0.175
cc_7095 ( N_noxref_26_c_11998_p N_GND_c_12823_n ) capacitor c=0.0374312f \
 //x=47.48 //y=0.805 //x2=48.22 //y2=0.175
cc_7096 ( N_noxref_26_M28_noxref_s N_GND_c_12823_n ) capacitor c=0.00519576f \
 //x=46.375 //y=0.555 //x2=48.22 //y2=0.175
cc_7097 ( N_noxref_26_c_11954_n N_GND_c_13293_n ) capacitor c=0.00190243f \
 //x=47.395 //y=0.72 //x2=76.46 //y2=0.175
cc_7098 ( N_noxref_26_M27_noxref_d N_GND_M26_noxref_d ) capacitor \
 c=3.12752e-19 //x=45.27 //y=1.09 //x2=44.295 //y2=1.055
cc_7099 ( N_noxref_26_c_11996_p N_noxref_43_c_14806_n ) capacitor \
 c=2.15937e-19 //x=46.51 //y=0.805 //x2=44.97 //y2=0.805
cc_7100 ( N_noxref_26_c_11964_n N_noxref_43_c_14780_n ) capacitor c=0.0130857f \
 //x=46.425 //y=1.175 //x2=45.855 //y2=0.72
cc_7101 ( N_noxref_26_M27_noxref_d N_noxref_43_c_14780_n ) capacitor \
 c=0.0160925f //x=45.27 //y=1.09 //x2=45.855 //y2=0.72
cc_7102 ( N_noxref_26_c_11964_n N_noxref_43_c_14782_n ) capacitor \
 c=0.00944538f //x=46.425 //y=1.175 //x2=45.855 //y2=1.77
cc_7103 ( N_noxref_26_M27_noxref_d N_noxref_43_c_14782_n ) capacitor \
 c=0.015272f //x=45.27 //y=1.09 //x2=45.855 //y2=1.77
cc_7104 ( N_noxref_26_c_11964_n N_noxref_43_M26_noxref_s ) capacitor \
 c=0.0223986f //x=46.425 //y=1.175 //x2=43.865 //y2=0.555
cc_7105 ( N_noxref_26_c_11996_p N_noxref_43_M26_noxref_s ) capacitor \
 c=0.0175532f //x=46.51 //y=0.805 //x2=43.865 //y2=0.555
cc_7106 ( N_noxref_26_c_11998_p N_noxref_43_M26_noxref_s ) capacitor \
 c=2.98721e-19 //x=47.48 //y=0.805 //x2=43.865 //y2=0.555
cc_7107 ( N_noxref_26_M27_noxref_d N_noxref_43_M26_noxref_s ) capacitor \
 c=0.0187674f //x=45.27 //y=1.09 //x2=43.865 //y2=0.555
cc_7108 ( N_noxref_26_M28_noxref_s N_noxref_43_M26_noxref_s ) capacitor \
 c=0.021082f //x=46.375 //y=0.555 //x2=43.865 //y2=0.555
cc_7109 ( N_noxref_26_c_11998_p N_noxref_44_M29_noxref_s ) capacitor \
 c=0.00370912f //x=47.48 //y=0.805 //x2=48.78 //y2=0.545
cc_7110 ( N_noxref_26_M28_noxref_s N_noxref_44_M29_noxref_s ) capacitor \
 c=0.00101401f //x=46.375 //y=0.555 //x2=48.78 //y2=0.545
cc_7111 ( N_noxref_27_c_12029_n N_noxref_28_c_12183_n ) capacitor \
 c=0.00321697f //x=69.74 //y=7.09 //x2=70.185 //y2=5.39
cc_7112 ( N_noxref_27_c_12070_n N_noxref_28_c_12183_n ) capacitor \
 c=0.00331901f //x=70.625 //y=7.09 //x2=70.185 //y2=5.39
cc_7113 ( N_noxref_27_c_12042_n N_noxref_28_c_12183_n ) capacitor c=0.0047685f \
 //x=69.857 //y=7.09 //x2=70.185 //y2=5.39
cc_7114 ( N_noxref_27_M129_noxref_d N_noxref_28_c_12183_n ) capacitor \
 c=0.00678641f //x=69.715 //y=5.205 //x2=70.185 //y2=5.39
cc_7115 ( N_noxref_27_c_12070_n N_noxref_28_c_12195_n ) capacitor \
 c=0.00331329f //x=70.625 //y=7.09 //x2=72.205 //y2=5.39
cc_7116 ( N_noxref_27_c_12073_n N_noxref_28_c_12195_n ) capacitor \
 c=0.00465918f //x=70.74 //y=6.92 //x2=72.205 //y2=5.39
cc_7117 ( N_noxref_27_M131_noxref_d N_noxref_28_c_12195_n ) capacitor \
 c=0.00491419f //x=70.595 //y=5.205 //x2=72.205 //y2=5.39
cc_7118 ( N_noxref_27_c_12024_n N_noxref_28_c_12196_n ) capacitor c=9.81e-19 \
 //x=68.865 //y=5.39 //x2=70.415 //y2=5.39
cc_7119 ( N_noxref_27_c_12070_n N_noxref_28_c_12196_n ) capacitor \
 c=0.00439275f //x=70.625 //y=7.09 //x2=70.415 //y2=5.39
cc_7120 ( N_noxref_27_c_12024_n N_noxref_28_c_12184_n ) capacitor c=0.033638f \
 //x=68.865 //y=5.39 //x2=69.42 //y2=5.39
cc_7121 ( N_noxref_27_c_12029_n N_noxref_28_c_12184_n ) capacitor c=0.0048075f \
 //x=69.74 //y=7.09 //x2=69.42 //y2=5.39
cc_7122 ( N_noxref_27_c_12035_n N_noxref_28_c_12184_n ) capacitor \
 c=0.00241473f //x=66.102 //y=5.39 //x2=69.42 //y2=5.39
cc_7123 ( N_noxref_27_c_12047_n N_noxref_28_c_12184_n ) capacitor c=0.0100239f \
 //x=68.98 //y=5.39 //x2=69.42 //y2=5.39
cc_7124 ( N_noxref_27_c_12024_n N_noxref_28_c_12200_n ) capacitor \
 c=5.61108e-19 //x=68.865 //y=5.39 //x2=70.3 //y2=5.39
cc_7125 ( N_noxref_27_c_12047_n N_noxref_28_c_12200_n ) capacitor \
 c=0.00225426f //x=68.98 //y=5.39 //x2=70.3 //y2=5.39
cc_7126 ( N_noxref_27_c_12042_n N_noxref_28_c_12226_n ) capacitor \
 c=2.01993e-19 //x=69.857 //y=7.09 //x2=72.32 //y2=6.92
cc_7127 ( N_noxref_27_c_12073_n N_noxref_28_c_12226_n ) capacitor c=0.0130503f \
 //x=70.74 //y=6.92 //x2=72.32 //y2=6.92
cc_7128 ( N_noxref_27_c_12073_n N_noxref_28_c_12201_n ) capacitor \
 c=2.01769e-19 //x=70.74 //y=6.92 //x2=73.2 //y2=7.09
cc_7129 ( N_noxref_27_c_12024_n N_noxref_28_c_12190_n ) capacitor \
 c=0.00238961f //x=68.865 //y=5.39 //x2=69.42 //y2=5.56
cc_7130 ( N_noxref_27_c_12029_n N_noxref_28_c_12190_n ) capacitor \
 c=0.00406191f //x=69.74 //y=7.09 //x2=69.42 //y2=5.56
cc_7131 ( N_noxref_27_c_12047_n N_noxref_28_c_12190_n ) capacitor c=0.0651197f \
 //x=68.98 //y=5.39 //x2=69.42 //y2=5.56
cc_7132 ( N_noxref_27_M129_noxref_d N_noxref_28_c_12190_n ) capacitor \
 c=0.0479141f //x=69.715 //y=5.205 //x2=69.42 //y2=5.56
cc_7133 ( N_noxref_27_M131_noxref_d N_noxref_28_c_12203_n ) capacitor \
 c=0.00143256f //x=70.595 //y=5.205 //x2=72.32 //y2=5.39
cc_7134 ( N_noxref_27_c_12035_n N_GND_c_13079_n ) capacitor c=0.00111773f \
 //x=66.102 //y=5.39 //x2=66.05 //y2=1.015
cc_7135 ( N_noxref_27_c_12024_n N_GND_c_13115_n ) capacitor c=0.00146427f \
 //x=68.865 //y=5.39 //x2=68.2 //y2=0.175
cc_7136 ( N_noxref_27_c_12070_n noxref_50 ) capacitor c=0.00419873f //x=70.625 \
 //y=7.09 //x2=70.155 //y2=5.205
cc_7137 ( N_noxref_27_M129_noxref_d noxref_50 ) capacitor c=0.0489565f \
 //x=69.715 //y=5.205 //x2=70.155 //y2=5.205
cc_7138 ( N_noxref_27_M131_noxref_d noxref_50 ) capacitor c=0.0489382f \
 //x=70.595 //y=5.205 //x2=70.155 //y2=5.205
cc_7139 ( N_noxref_27_c_12047_n N_noxref_51_c_15262_n ) capacitor \
 c=0.00110355f //x=68.98 //y=5.39 //x2=68.895 //y2=1.675
cc_7140 ( N_noxref_28_c_12184_n N_GND_c_13087_n ) capacitor c=2.49441e-19 \
 //x=69.42 //y=5.39 //x2=69.38 //y2=1.015
cc_7141 ( N_noxref_28_c_12195_n N_GND_c_13172_n ) capacitor c=0.00146427f \
 //x=72.205 //y=5.39 //x2=71.53 //y2=0.175
cc_7142 ( N_noxref_28_c_12200_n noxref_50 ) capacitor c=0.0218948f //x=70.3 \
 //y=5.39 //x2=70.155 //y2=5.205
cc_7143 ( N_noxref_28_c_12190_n noxref_50 ) capacitor c=0.00561178f //x=69.42 \
 //y=5.56 //x2=70.155 //y2=5.205
cc_7144 ( N_GND_c_13173_n N_Q_c_13913_n ) capacitor c=0.00272952f //x=74.86 \
 //y=0.175 //x2=75.97 //y2=1.935
cc_7145 ( N_GND_c_13293_n N_Q_c_13913_n ) capacitor c=0.00122336f //x=76.46 \
 //y=0.175 //x2=75.97 //y2=1.935
cc_7146 ( N_GND_M45_noxref_s N_Q_c_13913_n ) capacitor c=0.0325498f //x=75.355 \
 //y=0.55 //x2=75.97 //y2=1.935
cc_7147 ( N_GND_c_13147_n N_Q_c_13926_n ) capacitor c=0.00497604f //x=76.34 \
 //y=0.18 //x2=76.255 //y2=2.02
cc_7148 ( N_GND_c_13278_n N_Q_c_13926_n ) capacitor c=0.00321695f //x=76.375 \
 //y=0.715 //x2=76.255 //y2=2.02
cc_7149 ( N_GND_c_13293_n N_Q_c_13926_n ) capacitor c=0.030726f //x=76.46 \
 //y=0.175 //x2=76.255 //y2=2.02
cc_7150 ( N_GND_M45_noxref_s N_Q_c_13926_n ) capacitor c=0.00565821f \
 //x=75.355 //y=0.55 //x2=76.255 //y2=2.02
cc_7151 ( N_GND_c_13184_n N_Q_c_13933_n ) capacitor c=0.00306788f //x=72.71 \
 //y=1.02 //x2=75.97 //y2=1.185
cc_7152 ( N_GND_c_13147_n N_Q_c_13933_n ) capacitor c=0.00998676f //x=76.34 \
 //y=0.18 //x2=75.97 //y2=1.185
cc_7153 ( N_GND_c_13274_n N_Q_c_13933_n ) capacitor c=0.00124813f //x=75.885 \
 //y=0.715 //x2=75.97 //y2=1.185
cc_7154 ( N_GND_c_13278_n N_Q_c_13933_n ) capacitor c=0.00130539f //x=76.375 \
 //y=0.715 //x2=75.97 //y2=1.185
cc_7155 ( N_GND_M45_noxref_s N_Q_c_13933_n ) capacitor c=0.0161656f //x=75.355 \
 //y=0.55 //x2=75.97 //y2=1.185
cc_7156 ( N_GND_c_13147_n N_Q_M45_noxref_d ) capacitor c=0.00119455f //x=76.34 \
 //y=0.18 //x2=75.785 //y2=1.09
cc_7157 ( N_GND_M45_noxref_s N_Q_M45_noxref_d ) capacitor c=0.0377642f \
 //x=75.355 //y=0.55 //x2=75.785 //y2=1.09
cc_7158 ( N_GND_c_13409_p N_noxref_31_c_13981_n ) capacitor c=0.00293992f \
 //x=1.48 //y=0.175 //x2=1.965 //y2=1.77
cc_7159 ( N_GND_c_12316_n N_noxref_31_c_13981_n ) capacitor c=7.0078e-19 \
 //x=6.395 //y=0.175 //x2=1.965 //y2=1.77
cc_7160 ( N_GND_c_12506_n N_noxref_31_c_13981_n ) capacitor c=0.00379381f \
 //x=1.565 //y=1.145 //x2=1.965 //y2=1.77
cc_7161 ( N_GND_c_12337_n N_noxref_31_c_13981_n ) capacitor c=0.00371813f \
 //x=5.13 //y=0.175 //x2=1.965 //y2=1.77
cc_7162 ( N_GND_M0_noxref_d N_noxref_31_c_13981_n ) capacitor c=0.00578031f \
 //x=1.375 //y=1.055 //x2=1.965 //y2=1.77
cc_7163 ( N_GND_c_12498_n N_noxref_31_c_14005_n ) capacitor c=0.0169052f \
 //x=1.565 //y=1.015 //x2=2.05 //y2=0.805
cc_7164 ( N_GND_c_12316_n N_noxref_31_c_14005_n ) capacitor c=0.00710913f \
 //x=6.395 //y=0.175 //x2=2.05 //y2=0.805
cc_7165 ( N_GND_c_12337_n N_noxref_31_c_14005_n ) capacitor c=0.0140604f \
 //x=5.13 //y=0.175 //x2=2.05 //y2=0.805
cc_7166 ( N_GND_c_12521_n N_noxref_31_c_14005_n ) capacitor c=0.00323118f \
 //x=1.23 //y=0.18 //x2=2.05 //y2=0.805
cc_7167 ( N_GND_c_12316_n N_noxref_31_c_13995_n ) capacitor c=0.0138334f \
 //x=6.395 //y=0.175 //x2=2.935 //y2=0.72
cc_7168 ( N_GND_c_12337_n N_noxref_31_c_13995_n ) capacitor c=0.0356451f \
 //x=5.13 //y=0.175 //x2=2.935 //y2=0.72
cc_7169 ( N_GND_c_13293_n N_noxref_31_c_13995_n ) capacitor c=0.00178095f \
 //x=76.46 //y=0.175 //x2=2.935 //y2=0.72
cc_7170 ( N_GND_c_13409_p N_noxref_31_M0_noxref_s ) capacitor c=0.00710913f \
 //x=1.48 //y=0.175 //x2=0.945 //y2=0.555
cc_7171 ( N_GND_c_12498_n N_noxref_31_M0_noxref_s ) capacitor c=0.0173062f \
 //x=1.565 //y=1.015 //x2=0.945 //y2=0.555
cc_7172 ( N_GND_c_12316_n N_noxref_31_M0_noxref_s ) capacitor c=0.00683407f \
 //x=6.395 //y=0.175 //x2=0.945 //y2=0.555
cc_7173 ( N_GND_c_12506_n N_noxref_31_M0_noxref_s ) capacitor c=0.0113024f \
 //x=1.565 //y=1.145 //x2=0.945 //y2=0.555
cc_7174 ( N_GND_c_12337_n N_noxref_31_M0_noxref_s ) capacitor c=0.0272246f \
 //x=5.13 //y=0.175 //x2=0.945 //y2=0.555
cc_7175 ( N_GND_c_12521_n N_noxref_31_M0_noxref_s ) capacitor c=0.0675506f \
 //x=1.23 //y=0.18 //x2=0.945 //y2=0.555
cc_7176 ( N_GND_c_12340_n N_noxref_31_M0_noxref_s ) capacitor c=0.00166451f \
 //x=5.3 //y=0.175 //x2=0.945 //y2=0.555
cc_7177 ( N_GND_M0_noxref_d N_noxref_31_M0_noxref_s ) capacitor c=0.0271316f \
 //x=1.375 //y=1.055 //x2=0.945 //y2=0.555
cc_7178 ( N_GND_c_12316_n N_noxref_32_c_14036_n ) capacitor c=9.8916e-19 \
 //x=6.395 //y=0.175 //x2=6.88 //y2=1.76
cc_7179 ( N_GND_c_12317_n N_noxref_32_c_14036_n ) capacitor c=7.45647e-19 \
 //x=9.725 //y=0.175 //x2=6.88 //y2=1.76
cc_7180 ( N_GND_c_12320_n N_noxref_32_c_14036_n ) capacitor c=0.00402268f \
 //x=6.48 //y=1.135 //x2=6.88 //y2=1.76
cc_7181 ( N_GND_c_12338_n N_noxref_32_c_14036_n ) capacitor c=0.00392838f \
 //x=8.46 //y=0.175 //x2=6.88 //y2=1.76
cc_7182 ( N_GND_M3_noxref_d N_noxref_32_c_14036_n ) capacitor c=0.00578453f \
 //x=6.29 //y=1.045 //x2=6.88 //y2=1.76
cc_7183 ( N_GND_c_12317_n N_noxref_32_c_14082_n ) capacitor c=0.005761f \
 //x=9.725 //y=0.175 //x2=6.965 //y2=0.795
cc_7184 ( N_GND_c_12415_n N_noxref_32_c_14082_n ) capacitor c=0.0120153f \
 //x=6.477 //y=1.005 //x2=6.965 //y2=0.795
cc_7185 ( N_GND_c_12338_n N_noxref_32_c_14082_n ) capacitor c=0.0146912f \
 //x=8.46 //y=0.175 //x2=6.965 //y2=0.795
cc_7186 ( N_GND_c_12340_n N_noxref_32_c_14082_n ) capacitor c=0.00282583f \
 //x=5.3 //y=0.175 //x2=6.965 //y2=0.795
cc_7187 ( N_GND_c_12345_n N_noxref_32_c_14082_n ) capacitor c=2.99356e-19 \
 //x=8.63 //y=0.175 //x2=6.965 //y2=0.795
cc_7188 ( N_GND_c_12340_n N_noxref_32_c_14038_n ) capacitor c=2.8386e-19 \
 //x=5.3 //y=0.175 //x2=6.965 //y2=1.675
cc_7189 ( N_GND_c_12317_n N_noxref_32_c_14040_n ) capacitor c=0.00962972f \
 //x=9.725 //y=0.175 //x2=7.85 //y2=0.71
cc_7190 ( N_GND_c_12338_n N_noxref_32_c_14040_n ) capacitor c=0.0374802f \
 //x=8.46 //y=0.175 //x2=7.85 //y2=0.71
cc_7191 ( N_GND_c_13293_n N_noxref_32_c_14040_n ) capacitor c=0.00199299f \
 //x=76.46 //y=0.175 //x2=7.85 //y2=0.71
cc_7192 ( N_GND_c_12317_n N_noxref_32_c_14091_n ) capacitor c=0.00250904f \
 //x=9.725 //y=0.175 //x2=7.935 //y2=0.795
cc_7193 ( N_GND_c_12338_n N_noxref_32_c_14091_n ) capacitor c=0.0145518f \
 //x=8.46 //y=0.175 //x2=7.935 //y2=0.795
cc_7194 ( N_GND_c_12345_n N_noxref_32_c_14091_n ) capacitor c=0.0392026f \
 //x=8.63 //y=0.175 //x2=7.935 //y2=0.795
cc_7195 ( N_GND_c_12316_n N_noxref_32_M3_noxref_s ) capacitor c=0.00724992f \
 //x=6.395 //y=0.175 //x2=5.86 //y2=0.545
cc_7196 ( N_GND_c_12320_n N_noxref_32_M3_noxref_s ) capacitor c=0.0100997f \
 //x=6.48 //y=1.135 //x2=5.86 //y2=0.545
cc_7197 ( N_GND_c_12415_n N_noxref_32_M3_noxref_s ) capacitor c=0.0170652f \
 //x=6.477 //y=1.005 //x2=5.86 //y2=0.545
cc_7198 ( N_GND_c_12338_n N_noxref_32_M3_noxref_s ) capacitor c=0.014661f \
 //x=8.46 //y=0.175 //x2=5.86 //y2=0.545
cc_7199 ( N_GND_c_12340_n N_noxref_32_M3_noxref_s ) capacitor c=0.0528206f \
 //x=5.3 //y=0.175 //x2=5.86 //y2=0.545
cc_7200 ( N_GND_c_12345_n N_noxref_32_M3_noxref_s ) capacitor c=0.0064811f \
 //x=8.63 //y=0.175 //x2=5.86 //y2=0.545
cc_7201 ( N_GND_M3_noxref_d N_noxref_32_M3_noxref_s ) capacitor c=0.0271276f \
 //x=6.29 //y=1.045 //x2=5.86 //y2=0.545
cc_7202 ( N_GND_c_12317_n N_noxref_33_c_14105_n ) capacitor c=9.79596e-19 \
 //x=9.725 //y=0.175 //x2=10.21 //y2=1.76
cc_7203 ( N_GND_c_12361_n N_noxref_33_c_14105_n ) capacitor c=7.45647e-19 \
 //x=13.055 //y=0.175 //x2=10.21 //y2=1.76
cc_7204 ( N_GND_c_12324_n N_noxref_33_c_14105_n ) capacitor c=0.00400656f \
 //x=9.81 //y=1.135 //x2=10.21 //y2=1.76
cc_7205 ( N_GND_c_12339_n N_noxref_33_c_14105_n ) capacitor c=0.00395858f \
 //x=11.79 //y=0.175 //x2=10.21 //y2=1.76
cc_7206 ( N_GND_M5_noxref_d N_noxref_33_c_14105_n ) capacitor c=0.00578453f \
 //x=9.62 //y=1.045 //x2=10.21 //y2=1.76
cc_7207 ( N_GND_c_12361_n N_noxref_33_c_14148_n ) capacitor c=0.00310362f \
 //x=13.055 //y=0.175 //x2=10.295 //y2=0.795
cc_7208 ( N_GND_c_12334_n N_noxref_33_c_14148_n ) capacitor c=0.0120153f \
 //x=9.807 //y=1.005 //x2=10.295 //y2=0.795
cc_7209 ( N_GND_c_12339_n N_noxref_33_c_14148_n ) capacitor c=0.0148272f \
 //x=11.79 //y=0.175 //x2=10.295 //y2=0.795
cc_7210 ( N_GND_c_12345_n N_noxref_33_c_14148_n ) capacitor c=0.00282552f \
 //x=8.63 //y=0.175 //x2=10.295 //y2=0.795
cc_7211 ( N_GND_c_12385_n N_noxref_33_c_14148_n ) capacitor c=2.99356e-19 \
 //x=11.96 //y=0.175 //x2=10.295 //y2=0.795
cc_7212 ( N_GND_c_12345_n N_noxref_33_c_14112_n ) capacitor c=2.8386e-19 \
 //x=8.63 //y=0.175 //x2=10.295 //y2=1.675
cc_7213 ( N_GND_c_12361_n N_noxref_33_c_14117_n ) capacitor c=0.00989636f \
 //x=13.055 //y=0.175 //x2=11.18 //y2=0.71
cc_7214 ( N_GND_c_12339_n N_noxref_33_c_14117_n ) capacitor c=0.0374802f \
 //x=11.79 //y=0.175 //x2=11.18 //y2=0.71
cc_7215 ( N_GND_c_13293_n N_noxref_33_c_14117_n ) capacitor c=0.00199299f \
 //x=76.46 //y=0.175 //x2=11.18 //y2=0.71
cc_7216 ( N_GND_c_12361_n N_noxref_33_c_14157_n ) capacitor c=0.00250904f \
 //x=13.055 //y=0.175 //x2=11.265 //y2=0.795
cc_7217 ( N_GND_c_12339_n N_noxref_33_c_14157_n ) capacitor c=0.0145518f \
 //x=11.79 //y=0.175 //x2=11.265 //y2=0.795
cc_7218 ( N_GND_c_12385_n N_noxref_33_c_14157_n ) capacitor c=0.0392026f \
 //x=11.96 //y=0.175 //x2=11.265 //y2=0.795
cc_7219 ( N_GND_c_12317_n N_noxref_33_M5_noxref_s ) capacitor c=0.0045077f \
 //x=9.725 //y=0.175 //x2=9.19 //y2=0.545
cc_7220 ( N_GND_c_12324_n N_noxref_33_M5_noxref_s ) capacitor c=0.0099136f \
 //x=9.81 //y=1.135 //x2=9.19 //y2=0.545
cc_7221 ( N_GND_c_12334_n N_noxref_33_M5_noxref_s ) capacitor c=0.0123761f \
 //x=9.807 //y=1.005 //x2=9.19 //y2=0.545
cc_7222 ( N_GND_c_12339_n N_noxref_33_M5_noxref_s ) capacitor c=0.0148438f \
 //x=11.79 //y=0.175 //x2=9.19 //y2=0.545
cc_7223 ( N_GND_c_12345_n N_noxref_33_M5_noxref_s ) capacitor c=0.0518718f \
 //x=8.63 //y=0.175 //x2=9.19 //y2=0.545
cc_7224 ( N_GND_c_12385_n N_noxref_33_M5_noxref_s ) capacitor c=0.0064811f \
 //x=11.96 //y=0.175 //x2=9.19 //y2=0.545
cc_7225 ( N_GND_M5_noxref_d N_noxref_33_M5_noxref_s ) capacitor c=0.0271276f \
 //x=9.62 //y=1.045 //x2=9.19 //y2=0.545
cc_7226 ( N_GND_c_12361_n N_noxref_34_c_14174_n ) capacitor c=9.79596e-19 \
 //x=13.055 //y=0.175 //x2=13.54 //y2=1.76
cc_7227 ( N_GND_c_12502_n N_noxref_34_c_14174_n ) capacitor c=7.45647e-19 \
 //x=16.385 //y=0.175 //x2=13.54 //y2=1.76
cc_7228 ( N_GND_c_12368_n N_noxref_34_c_14174_n ) capacitor c=0.00400678f \
 //x=13.14 //y=1.135 //x2=13.54 //y2=1.76
cc_7229 ( N_GND_c_12383_n N_noxref_34_c_14174_n ) capacitor c=0.00395858f \
 //x=15.12 //y=0.175 //x2=13.54 //y2=1.76
cc_7230 ( N_GND_M7_noxref_d N_noxref_34_c_14174_n ) capacitor c=0.00578453f \
 //x=12.95 //y=1.045 //x2=13.54 //y2=1.76
cc_7231 ( N_GND_c_12502_n N_noxref_34_c_14216_n ) capacitor c=0.00418312f \
 //x=16.385 //y=0.175 //x2=13.625 //y2=0.795
cc_7232 ( N_GND_c_12378_n N_noxref_34_c_14216_n ) capacitor c=0.0120153f \
 //x=13.137 //y=1.005 //x2=13.625 //y2=0.795
cc_7233 ( N_GND_c_12383_n N_noxref_34_c_14216_n ) capacitor c=0.0148272f \
 //x=15.12 //y=0.175 //x2=13.625 //y2=0.795
cc_7234 ( N_GND_c_12385_n N_noxref_34_c_14216_n ) capacitor c=0.00282552f \
 //x=11.96 //y=0.175 //x2=13.625 //y2=0.795
cc_7235 ( N_GND_c_12440_n N_noxref_34_c_14216_n ) capacitor c=2.99356e-19 \
 //x=15.29 //y=0.175 //x2=13.625 //y2=0.795
cc_7236 ( N_GND_c_12385_n N_noxref_34_c_14181_n ) capacitor c=2.8386e-19 \
 //x=11.96 //y=0.175 //x2=13.625 //y2=1.675
cc_7237 ( N_GND_c_12502_n N_noxref_34_c_14186_n ) capacitor c=0.00980233f \
 //x=16.385 //y=0.175 //x2=14.51 //y2=0.71
cc_7238 ( N_GND_c_12383_n N_noxref_34_c_14186_n ) capacitor c=0.0375602f \
 //x=15.12 //y=0.175 //x2=14.51 //y2=0.71
cc_7239 ( N_GND_c_13293_n N_noxref_34_c_14186_n ) capacitor c=0.00199299f \
 //x=76.46 //y=0.175 //x2=14.51 //y2=0.71
cc_7240 ( N_GND_c_12502_n N_noxref_34_c_14225_n ) capacitor c=0.00256023f \
 //x=16.385 //y=0.175 //x2=14.595 //y2=0.795
cc_7241 ( N_GND_c_12383_n N_noxref_34_c_14225_n ) capacitor c=0.0145518f \
 //x=15.12 //y=0.175 //x2=14.595 //y2=0.795
cc_7242 ( N_GND_c_12440_n N_noxref_34_c_14225_n ) capacitor c=0.0392026f \
 //x=15.29 //y=0.175 //x2=14.595 //y2=0.795
cc_7243 ( N_GND_c_12361_n N_noxref_34_M7_noxref_s ) capacitor c=0.0045077f \
 //x=13.055 //y=0.175 //x2=12.52 //y2=0.545
cc_7244 ( N_GND_c_12368_n N_noxref_34_M7_noxref_s ) capacitor c=0.0099136f \
 //x=13.14 //y=1.135 //x2=12.52 //y2=0.545
cc_7245 ( N_GND_c_12378_n N_noxref_34_M7_noxref_s ) capacitor c=0.0123761f \
 //x=13.137 //y=1.005 //x2=12.52 //y2=0.545
cc_7246 ( N_GND_c_12383_n N_noxref_34_M7_noxref_s ) capacitor c=0.0148438f \
 //x=15.12 //y=0.175 //x2=12.52 //y2=0.545
cc_7247 ( N_GND_c_12385_n N_noxref_34_M7_noxref_s ) capacitor c=0.0518718f \
 //x=11.96 //y=0.175 //x2=12.52 //y2=0.545
cc_7248 ( N_GND_c_12440_n N_noxref_34_M7_noxref_s ) capacitor c=0.0064811f \
 //x=15.29 //y=0.175 //x2=12.52 //y2=0.545
cc_7249 ( N_GND_M7_noxref_d N_noxref_34_M7_noxref_s ) capacitor c=0.0271276f \
 //x=12.95 //y=1.045 //x2=12.52 //y2=0.545
cc_7250 ( N_GND_c_12502_n N_noxref_35_c_14242_n ) capacitor c=9.8916e-19 \
 //x=16.385 //y=0.175 //x2=16.87 //y2=1.76
cc_7251 ( N_GND_c_12460_n N_noxref_35_c_14242_n ) capacitor c=7.45647e-19 \
 //x=19.715 //y=0.175 //x2=16.87 //y2=1.76
cc_7252 ( N_GND_c_12418_n N_noxref_35_c_14242_n ) capacitor c=0.00400855f \
 //x=16.47 //y=1.135 //x2=16.87 //y2=1.76
cc_7253 ( N_GND_c_12432_n N_noxref_35_c_14242_n ) capacitor c=0.00395858f \
 //x=18.45 //y=0.175 //x2=16.87 //y2=1.76
cc_7254 ( N_GND_M9_noxref_d N_noxref_35_c_14242_n ) capacitor c=0.00578453f \
 //x=16.28 //y=1.045 //x2=16.87 //y2=1.76
cc_7255 ( N_GND_c_12460_n N_noxref_35_c_14286_n ) capacitor c=0.00373356f \
 //x=19.715 //y=0.175 //x2=16.955 //y2=0.795
cc_7256 ( N_GND_c_12427_n N_noxref_35_c_14286_n ) capacitor c=0.0120153f \
 //x=16.467 //y=1.005 //x2=16.955 //y2=0.795
cc_7257 ( N_GND_c_12432_n N_noxref_35_c_14286_n ) capacitor c=0.0148272f \
 //x=18.45 //y=0.175 //x2=16.955 //y2=0.795
cc_7258 ( N_GND_c_12440_n N_noxref_35_c_14286_n ) capacitor c=0.00282552f \
 //x=15.29 //y=0.175 //x2=16.955 //y2=0.795
cc_7259 ( N_GND_c_12483_n N_noxref_35_c_14286_n ) capacitor c=2.99356e-19 \
 //x=18.62 //y=0.175 //x2=16.955 //y2=0.795
cc_7260 ( N_GND_c_12440_n N_noxref_35_c_14249_n ) capacitor c=2.8386e-19 \
 //x=15.29 //y=0.175 //x2=16.955 //y2=1.675
cc_7261 ( N_GND_c_12460_n N_noxref_35_c_14254_n ) capacitor c=0.00966815f \
 //x=19.715 //y=0.175 //x2=17.84 //y2=0.71
cc_7262 ( N_GND_c_12432_n N_noxref_35_c_14254_n ) capacitor c=0.0375602f \
 //x=18.45 //y=0.175 //x2=17.84 //y2=0.71
cc_7263 ( N_GND_c_13293_n N_noxref_35_c_14254_n ) capacitor c=0.00199299f \
 //x=76.46 //y=0.175 //x2=17.84 //y2=0.71
cc_7264 ( N_GND_c_12460_n N_noxref_35_c_14295_n ) capacitor c=0.00253402f \
 //x=19.715 //y=0.175 //x2=17.925 //y2=0.795
cc_7265 ( N_GND_c_12432_n N_noxref_35_c_14295_n ) capacitor c=0.0145518f \
 //x=18.45 //y=0.175 //x2=17.925 //y2=0.795
cc_7266 ( N_GND_c_12483_n N_noxref_35_c_14295_n ) capacitor c=0.0392026f \
 //x=18.62 //y=0.175 //x2=17.925 //y2=0.795
cc_7267 ( N_GND_c_12502_n N_noxref_35_M9_noxref_s ) capacitor c=0.0045077f \
 //x=16.385 //y=0.175 //x2=15.85 //y2=0.545
cc_7268 ( N_GND_c_12418_n N_noxref_35_M9_noxref_s ) capacitor c=0.0099136f \
 //x=16.47 //y=1.135 //x2=15.85 //y2=0.545
cc_7269 ( N_GND_c_12427_n N_noxref_35_M9_noxref_s ) capacitor c=0.0123761f \
 //x=16.467 //y=1.005 //x2=15.85 //y2=0.545
cc_7270 ( N_GND_c_12432_n N_noxref_35_M9_noxref_s ) capacitor c=0.0148438f \
 //x=18.45 //y=0.175 //x2=15.85 //y2=0.545
cc_7271 ( N_GND_c_12440_n N_noxref_35_M9_noxref_s ) capacitor c=0.0518718f \
 //x=15.29 //y=0.175 //x2=15.85 //y2=0.545
cc_7272 ( N_GND_c_12483_n N_noxref_35_M9_noxref_s ) capacitor c=0.0064811f \
 //x=18.62 //y=0.175 //x2=15.85 //y2=0.545
cc_7273 ( N_GND_M9_noxref_d N_noxref_35_M9_noxref_s ) capacitor c=0.0271276f \
 //x=16.28 //y=1.045 //x2=15.85 //y2=0.545
cc_7274 ( N_GND_c_12460_n N_noxref_36_c_14312_n ) capacitor c=9.8916e-19 \
 //x=19.715 //y=0.175 //x2=20.2 //y2=1.76
cc_7275 ( N_GND_c_12505_n N_noxref_36_c_14312_n ) capacitor c=7.45647e-19 \
 //x=22.94 //y=0.175 //x2=20.2 //y2=1.76
cc_7276 ( N_GND_c_12467_n N_noxref_36_c_14312_n ) capacitor c=0.00402206f \
 //x=19.8 //y=1.135 //x2=20.2 //y2=1.76
cc_7277 ( N_GND_c_12481_n N_noxref_36_c_14312_n ) capacitor c=0.00395858f \
 //x=21.78 //y=0.175 //x2=20.2 //y2=1.76
cc_7278 ( N_GND_M11_noxref_d N_noxref_36_c_14312_n ) capacitor c=0.00578453f \
 //x=19.61 //y=1.045 //x2=20.2 //y2=1.76
cc_7279 ( N_GND_c_12505_n N_noxref_36_c_14355_n ) capacitor c=0.00310282f \
 //x=22.94 //y=0.175 //x2=20.285 //y2=0.795
cc_7280 ( N_GND_c_12477_n N_noxref_36_c_14355_n ) capacitor c=0.0119573f \
 //x=19.797 //y=1.005 //x2=20.285 //y2=0.795
cc_7281 ( N_GND_c_12481_n N_noxref_36_c_14355_n ) capacitor c=0.0148272f \
 //x=21.78 //y=0.175 //x2=20.285 //y2=0.795
cc_7282 ( N_GND_c_12483_n N_noxref_36_c_14355_n ) capacitor c=0.00282552f \
 //x=18.62 //y=0.175 //x2=20.285 //y2=0.795
cc_7283 ( N_GND_c_12535_n N_noxref_36_c_14355_n ) capacitor c=2.99181e-19 \
 //x=21.95 //y=0.175 //x2=20.285 //y2=0.795
cc_7284 ( N_GND_c_12483_n N_noxref_36_c_14319_n ) capacitor c=2.8386e-19 \
 //x=18.62 //y=0.175 //x2=20.285 //y2=1.675
cc_7285 ( N_GND_c_12505_n N_noxref_36_c_14327_n ) capacitor c=0.00991693f \
 //x=22.94 //y=0.175 //x2=21.17 //y2=0.71
cc_7286 ( N_GND_c_12481_n N_noxref_36_c_14327_n ) capacitor c=0.0374812f \
 //x=21.78 //y=0.175 //x2=21.17 //y2=0.71
cc_7287 ( N_GND_c_13293_n N_noxref_36_c_14327_n ) capacitor c=0.00199299f \
 //x=76.46 //y=0.175 //x2=21.17 //y2=0.71
cc_7288 ( N_GND_c_12505_n N_noxref_36_c_14364_n ) capacitor c=0.00248212f \
 //x=22.94 //y=0.175 //x2=21.255 //y2=0.795
cc_7289 ( N_GND_c_12481_n N_noxref_36_c_14364_n ) capacitor c=0.0145518f \
 //x=21.78 //y=0.175 //x2=21.255 //y2=0.795
cc_7290 ( N_GND_c_12535_n N_noxref_36_c_14364_n ) capacitor c=0.0396774f \
 //x=21.95 //y=0.175 //x2=21.255 //y2=0.795
cc_7291 ( N_GND_c_12460_n N_noxref_36_M11_noxref_s ) capacitor c=0.0045077f \
 //x=19.715 //y=0.175 //x2=19.18 //y2=0.545
cc_7292 ( N_GND_c_12467_n N_noxref_36_M11_noxref_s ) capacitor c=0.00990843f \
 //x=19.8 //y=1.135 //x2=19.18 //y2=0.545
cc_7293 ( N_GND_c_12477_n N_noxref_36_M11_noxref_s ) capacitor c=0.0123717f \
 //x=19.797 //y=1.005 //x2=19.18 //y2=0.545
cc_7294 ( N_GND_c_12481_n N_noxref_36_M11_noxref_s ) capacitor c=0.0148438f \
 //x=21.78 //y=0.175 //x2=19.18 //y2=0.545
cc_7295 ( N_GND_c_12483_n N_noxref_36_M11_noxref_s ) capacitor c=0.0518718f \
 //x=18.62 //y=0.175 //x2=19.18 //y2=0.545
cc_7296 ( N_GND_c_12535_n N_noxref_36_M11_noxref_s ) capacitor c=0.00648063f \
 //x=21.95 //y=0.175 //x2=19.18 //y2=0.545
cc_7297 ( N_GND_M11_noxref_d N_noxref_36_M11_noxref_s ) capacitor c=0.0271276f \
 //x=19.61 //y=1.045 //x2=19.18 //y2=0.545
cc_7298 ( N_GND_c_12505_n N_noxref_37_c_14381_n ) capacitor c=0.0011329f \
 //x=22.94 //y=0.175 //x2=23.425 //y2=1.77
cc_7299 ( N_GND_c_12546_n N_noxref_37_c_14381_n ) capacitor c=6.72491e-19 \
 //x=27.855 //y=0.175 //x2=23.425 //y2=1.77
cc_7300 ( N_GND_c_12731_n N_noxref_37_c_14381_n ) capacitor c=0.00379381f \
 //x=23.025 //y=1.145 //x2=23.425 //y2=1.77
cc_7301 ( N_GND_c_12566_n N_noxref_37_c_14381_n ) capacitor c=0.00392315f \
 //x=26.59 //y=0.175 //x2=23.425 //y2=1.77
cc_7302 ( N_GND_M13_noxref_d N_noxref_37_c_14381_n ) capacitor c=0.00578031f \
 //x=22.835 //y=1.055 //x2=23.425 //y2=1.77
cc_7303 ( N_GND_c_12723_n N_noxref_37_c_14406_n ) capacitor c=0.0169052f \
 //x=23.025 //y=1.015 //x2=23.51 //y2=0.805
cc_7304 ( N_GND_c_12546_n N_noxref_37_c_14406_n ) capacitor c=0.00439789f \
 //x=27.855 //y=0.175 //x2=23.51 //y2=0.805
cc_7305 ( N_GND_c_12566_n N_noxref_37_c_14406_n ) capacitor c=0.0142396f \
 //x=26.59 //y=0.175 //x2=23.51 //y2=0.805
cc_7306 ( N_GND_c_12535_n N_noxref_37_c_14406_n ) capacitor c=0.00322442f \
 //x=21.95 //y=0.175 //x2=23.51 //y2=0.805
cc_7307 ( N_GND_c_12546_n N_noxref_37_c_14396_n ) capacitor c=0.0124129f \
 //x=27.855 //y=0.175 //x2=24.395 //y2=0.72
cc_7308 ( N_GND_c_12566_n N_noxref_37_c_14396_n ) capacitor c=0.0361782f \
 //x=26.59 //y=0.175 //x2=24.395 //y2=0.72
cc_7309 ( N_GND_c_13293_n N_noxref_37_c_14396_n ) capacitor c=0.00178095f \
 //x=76.46 //y=0.175 //x2=24.395 //y2=0.72
cc_7310 ( N_GND_c_12505_n N_noxref_37_M13_noxref_s ) capacitor c=0.00439789f \
 //x=22.94 //y=0.175 //x2=22.405 //y2=0.555
cc_7311 ( N_GND_c_12723_n N_noxref_37_M13_noxref_s ) capacitor c=0.0125586f \
 //x=23.025 //y=1.015 //x2=22.405 //y2=0.555
cc_7312 ( N_GND_c_12546_n N_noxref_37_M13_noxref_s ) capacitor c=0.0044479f \
 //x=27.855 //y=0.175 //x2=22.405 //y2=0.555
cc_7313 ( N_GND_c_12731_n N_noxref_37_M13_noxref_s ) capacitor c=0.00972044f \
 //x=23.025 //y=1.145 //x2=22.405 //y2=0.555
cc_7314 ( N_GND_c_12566_n N_noxref_37_M13_noxref_s ) capacitor c=0.0275237f \
 //x=26.59 //y=0.175 //x2=22.405 //y2=0.555
cc_7315 ( N_GND_c_12535_n N_noxref_37_M13_noxref_s ) capacitor c=0.0624873f \
 //x=21.95 //y=0.175 //x2=22.405 //y2=0.555
cc_7316 ( N_GND_c_12569_n N_noxref_37_M13_noxref_s ) capacitor c=0.00166451f \
 //x=26.76 //y=0.175 //x2=22.405 //y2=0.555
cc_7317 ( N_GND_M13_noxref_d N_noxref_37_M13_noxref_s ) capacitor c=0.0271316f \
 //x=22.835 //y=1.055 //x2=22.405 //y2=0.555
cc_7318 ( N_GND_c_12546_n N_noxref_38_c_14450_n ) capacitor c=9.8916e-19 \
 //x=27.855 //y=0.175 //x2=28.34 //y2=1.76
cc_7319 ( N_GND_c_12547_n N_noxref_38_c_14450_n ) capacitor c=7.45647e-19 \
 //x=31.185 //y=0.175 //x2=28.34 //y2=1.76
cc_7320 ( N_GND_c_12550_n N_noxref_38_c_14450_n ) capacitor c=0.00402268f \
 //x=27.94 //y=1.135 //x2=28.34 //y2=1.76
cc_7321 ( N_GND_c_12567_n N_noxref_38_c_14450_n ) capacitor c=0.00395858f \
 //x=29.92 //y=0.175 //x2=28.34 //y2=1.76
cc_7322 ( N_GND_M16_noxref_d N_noxref_38_c_14450_n ) capacitor c=0.00578453f \
 //x=27.75 //y=1.045 //x2=28.34 //y2=1.76
cc_7323 ( N_GND_c_12547_n N_noxref_38_c_14485_n ) capacitor c=0.00369236f \
 //x=31.185 //y=0.175 //x2=28.425 //y2=0.795
cc_7324 ( N_GND_c_12641_n N_noxref_38_c_14485_n ) capacitor c=0.0120153f \
 //x=27.937 //y=1.005 //x2=28.425 //y2=0.795
cc_7325 ( N_GND_c_12567_n N_noxref_38_c_14485_n ) capacitor c=0.0148082f \
 //x=29.92 //y=0.175 //x2=28.425 //y2=0.795
cc_7326 ( N_GND_c_12569_n N_noxref_38_c_14485_n ) capacitor c=0.00282583f \
 //x=26.76 //y=0.175 //x2=28.425 //y2=0.795
cc_7327 ( N_GND_c_12573_n N_noxref_38_c_14485_n ) capacitor c=2.99356e-19 \
 //x=30.09 //y=0.175 //x2=28.425 //y2=0.795
cc_7328 ( N_GND_c_12569_n N_noxref_38_c_14439_n ) capacitor c=2.8386e-19 \
 //x=26.76 //y=0.175 //x2=28.425 //y2=1.675
cc_7329 ( N_GND_c_12547_n N_noxref_38_c_14440_n ) capacitor c=0.00963144f \
 //x=31.185 //y=0.175 //x2=29.31 //y2=0.71
cc_7330 ( N_GND_c_12567_n N_noxref_38_c_14440_n ) capacitor c=0.0374802f \
 //x=29.92 //y=0.175 //x2=29.31 //y2=0.71
cc_7331 ( N_GND_c_13293_n N_noxref_38_c_14440_n ) capacitor c=0.00199299f \
 //x=76.46 //y=0.175 //x2=29.31 //y2=0.71
cc_7332 ( N_GND_c_12547_n N_noxref_38_c_14494_n ) capacitor c=0.00250904f \
 //x=31.185 //y=0.175 //x2=29.395 //y2=0.795
cc_7333 ( N_GND_c_12567_n N_noxref_38_c_14494_n ) capacitor c=0.0145518f \
 //x=29.92 //y=0.175 //x2=29.395 //y2=0.795
cc_7334 ( N_GND_c_12573_n N_noxref_38_c_14494_n ) capacitor c=0.0392026f \
 //x=30.09 //y=0.175 //x2=29.395 //y2=0.795
cc_7335 ( N_GND_c_12546_n N_noxref_38_M16_noxref_s ) capacitor c=0.0045077f \
 //x=27.855 //y=0.175 //x2=27.32 //y2=0.545
cc_7336 ( N_GND_c_12550_n N_noxref_38_M16_noxref_s ) capacitor c=0.0100997f \
 //x=27.94 //y=1.135 //x2=27.32 //y2=0.545
cc_7337 ( N_GND_c_12641_n N_noxref_38_M16_noxref_s ) capacitor c=0.0170652f \
 //x=27.937 //y=1.005 //x2=27.32 //y2=0.545
cc_7338 ( N_GND_c_12567_n N_noxref_38_M16_noxref_s ) capacitor c=0.0148438f \
 //x=29.92 //y=0.175 //x2=27.32 //y2=0.545
cc_7339 ( N_GND_c_12569_n N_noxref_38_M16_noxref_s ) capacitor c=0.0528206f \
 //x=26.76 //y=0.175 //x2=27.32 //y2=0.545
cc_7340 ( N_GND_c_12573_n N_noxref_38_M16_noxref_s ) capacitor c=0.0064811f \
 //x=30.09 //y=0.175 //x2=27.32 //y2=0.545
cc_7341 ( N_GND_M16_noxref_d N_noxref_38_M16_noxref_s ) capacitor c=0.0271276f \
 //x=27.75 //y=1.045 //x2=27.32 //y2=0.545
cc_7342 ( N_GND_c_12547_n N_noxref_39_c_14508_n ) capacitor c=9.79596e-19 \
 //x=31.185 //y=0.175 //x2=31.67 //y2=1.76
cc_7343 ( N_GND_c_12588_n N_noxref_39_c_14508_n ) capacitor c=7.45647e-19 \
 //x=34.515 //y=0.175 //x2=31.67 //y2=1.76
cc_7344 ( N_GND_c_12553_n N_noxref_39_c_14508_n ) capacitor c=0.00400656f \
 //x=31.27 //y=1.135 //x2=31.67 //y2=1.76
cc_7345 ( N_GND_c_12568_n N_noxref_39_c_14508_n ) capacitor c=0.00395858f \
 //x=33.25 //y=0.175 //x2=31.67 //y2=1.76
cc_7346 ( N_GND_M18_noxref_d N_noxref_39_c_14508_n ) capacitor c=0.00578453f \
 //x=31.08 //y=1.045 //x2=31.67 //y2=1.76
cc_7347 ( N_GND_c_12588_n N_noxref_39_c_14551_n ) capacitor c=0.00310362f \
 //x=34.515 //y=0.175 //x2=31.755 //y2=0.795
cc_7348 ( N_GND_c_12563_n N_noxref_39_c_14551_n ) capacitor c=0.0120153f \
 //x=31.267 //y=1.005 //x2=31.755 //y2=0.795
cc_7349 ( N_GND_c_12568_n N_noxref_39_c_14551_n ) capacitor c=0.0148272f \
 //x=33.25 //y=0.175 //x2=31.755 //y2=0.795
cc_7350 ( N_GND_c_12573_n N_noxref_39_c_14551_n ) capacitor c=0.00282552f \
 //x=30.09 //y=0.175 //x2=31.755 //y2=0.795
cc_7351 ( N_GND_c_12612_n N_noxref_39_c_14551_n ) capacitor c=2.99356e-19 \
 //x=33.42 //y=0.175 //x2=31.755 //y2=0.795
cc_7352 ( N_GND_c_12573_n N_noxref_39_c_14515_n ) capacitor c=2.8386e-19 \
 //x=30.09 //y=0.175 //x2=31.755 //y2=1.675
cc_7353 ( N_GND_c_12588_n N_noxref_39_c_14520_n ) capacitor c=0.00989636f \
 //x=34.515 //y=0.175 //x2=32.64 //y2=0.71
cc_7354 ( N_GND_c_12568_n N_noxref_39_c_14520_n ) capacitor c=0.0374802f \
 //x=33.25 //y=0.175 //x2=32.64 //y2=0.71
cc_7355 ( N_GND_c_13293_n N_noxref_39_c_14520_n ) capacitor c=0.00199299f \
 //x=76.46 //y=0.175 //x2=32.64 //y2=0.71
cc_7356 ( N_GND_c_12588_n N_noxref_39_c_14560_n ) capacitor c=0.00250904f \
 //x=34.515 //y=0.175 //x2=32.725 //y2=0.795
cc_7357 ( N_GND_c_12568_n N_noxref_39_c_14560_n ) capacitor c=0.0145518f \
 //x=33.25 //y=0.175 //x2=32.725 //y2=0.795
cc_7358 ( N_GND_c_12612_n N_noxref_39_c_14560_n ) capacitor c=0.0392026f \
 //x=33.42 //y=0.175 //x2=32.725 //y2=0.795
cc_7359 ( N_GND_c_12547_n N_noxref_39_M18_noxref_s ) capacitor c=0.0045077f \
 //x=31.185 //y=0.175 //x2=30.65 //y2=0.545
cc_7360 ( N_GND_c_12553_n N_noxref_39_M18_noxref_s ) capacitor c=0.0099136f \
 //x=31.27 //y=1.135 //x2=30.65 //y2=0.545
cc_7361 ( N_GND_c_12563_n N_noxref_39_M18_noxref_s ) capacitor c=0.0123761f \
 //x=31.267 //y=1.005 //x2=30.65 //y2=0.545
cc_7362 ( N_GND_c_12568_n N_noxref_39_M18_noxref_s ) capacitor c=0.0148438f \
 //x=33.25 //y=0.175 //x2=30.65 //y2=0.545
cc_7363 ( N_GND_c_12573_n N_noxref_39_M18_noxref_s ) capacitor c=0.0518718f \
 //x=30.09 //y=0.175 //x2=30.65 //y2=0.545
cc_7364 ( N_GND_c_12612_n N_noxref_39_M18_noxref_s ) capacitor c=0.0064811f \
 //x=33.42 //y=0.175 //x2=30.65 //y2=0.545
cc_7365 ( N_GND_M18_noxref_d N_noxref_39_M18_noxref_s ) capacitor c=0.0271276f \
 //x=31.08 //y=1.045 //x2=30.65 //y2=0.545
cc_7366 ( N_GND_c_12588_n N_noxref_40_c_14577_n ) capacitor c=9.79596e-19 \
 //x=34.515 //y=0.175 //x2=35 //y2=1.76
cc_7367 ( N_GND_c_12727_n N_noxref_40_c_14577_n ) capacitor c=7.45647e-19 \
 //x=37.845 //y=0.175 //x2=35 //y2=1.76
cc_7368 ( N_GND_c_12595_n N_noxref_40_c_14577_n ) capacitor c=0.00400678f \
 //x=34.6 //y=1.135 //x2=35 //y2=1.76
cc_7369 ( N_GND_c_12610_n N_noxref_40_c_14577_n ) capacitor c=0.00395858f \
 //x=36.58 //y=0.175 //x2=35 //y2=1.76
cc_7370 ( N_GND_M20_noxref_d N_noxref_40_c_14577_n ) capacitor c=0.00578453f \
 //x=34.41 //y=1.045 //x2=35 //y2=1.76
cc_7371 ( N_GND_c_12727_n N_noxref_40_c_14619_n ) capacitor c=0.00418312f \
 //x=37.845 //y=0.175 //x2=35.085 //y2=0.795
cc_7372 ( N_GND_c_12605_n N_noxref_40_c_14619_n ) capacitor c=0.0120153f \
 //x=34.597 //y=1.005 //x2=35.085 //y2=0.795
cc_7373 ( N_GND_c_12610_n N_noxref_40_c_14619_n ) capacitor c=0.0148272f \
 //x=36.58 //y=0.175 //x2=35.085 //y2=0.795
cc_7374 ( N_GND_c_12612_n N_noxref_40_c_14619_n ) capacitor c=0.00282552f \
 //x=33.42 //y=0.175 //x2=35.085 //y2=0.795
cc_7375 ( N_GND_c_12666_n N_noxref_40_c_14619_n ) capacitor c=2.99356e-19 \
 //x=36.75 //y=0.175 //x2=35.085 //y2=0.795
cc_7376 ( N_GND_c_12612_n N_noxref_40_c_14584_n ) capacitor c=2.8386e-19 \
 //x=33.42 //y=0.175 //x2=35.085 //y2=1.675
cc_7377 ( N_GND_c_12727_n N_noxref_40_c_14589_n ) capacitor c=0.00980233f \
 //x=37.845 //y=0.175 //x2=35.97 //y2=0.71
cc_7378 ( N_GND_c_12610_n N_noxref_40_c_14589_n ) capacitor c=0.0375602f \
 //x=36.58 //y=0.175 //x2=35.97 //y2=0.71
cc_7379 ( N_GND_c_13293_n N_noxref_40_c_14589_n ) capacitor c=0.00199299f \
 //x=76.46 //y=0.175 //x2=35.97 //y2=0.71
cc_7380 ( N_GND_c_12727_n N_noxref_40_c_14628_n ) capacitor c=0.00256023f \
 //x=37.845 //y=0.175 //x2=36.055 //y2=0.795
cc_7381 ( N_GND_c_12610_n N_noxref_40_c_14628_n ) capacitor c=0.0145518f \
 //x=36.58 //y=0.175 //x2=36.055 //y2=0.795
cc_7382 ( N_GND_c_12666_n N_noxref_40_c_14628_n ) capacitor c=0.0392026f \
 //x=36.75 //y=0.175 //x2=36.055 //y2=0.795
cc_7383 ( N_GND_c_12588_n N_noxref_40_M20_noxref_s ) capacitor c=0.0045077f \
 //x=34.515 //y=0.175 //x2=33.98 //y2=0.545
cc_7384 ( N_GND_c_12595_n N_noxref_40_M20_noxref_s ) capacitor c=0.0099136f \
 //x=34.6 //y=1.135 //x2=33.98 //y2=0.545
cc_7385 ( N_GND_c_12605_n N_noxref_40_M20_noxref_s ) capacitor c=0.0123761f \
 //x=34.597 //y=1.005 //x2=33.98 //y2=0.545
cc_7386 ( N_GND_c_12610_n N_noxref_40_M20_noxref_s ) capacitor c=0.0148438f \
 //x=36.58 //y=0.175 //x2=33.98 //y2=0.545
cc_7387 ( N_GND_c_12612_n N_noxref_40_M20_noxref_s ) capacitor c=0.0518718f \
 //x=33.42 //y=0.175 //x2=33.98 //y2=0.545
cc_7388 ( N_GND_c_12666_n N_noxref_40_M20_noxref_s ) capacitor c=0.0064811f \
 //x=36.75 //y=0.175 //x2=33.98 //y2=0.545
cc_7389 ( N_GND_M20_noxref_d N_noxref_40_M20_noxref_s ) capacitor c=0.0271276f \
 //x=34.41 //y=1.045 //x2=33.98 //y2=0.545
cc_7390 ( N_GND_c_12727_n N_noxref_41_c_14645_n ) capacitor c=9.8916e-19 \
 //x=37.845 //y=0.175 //x2=38.33 //y2=1.76
cc_7391 ( N_GND_c_12685_n N_noxref_41_c_14645_n ) capacitor c=7.45647e-19 \
 //x=41.175 //y=0.175 //x2=38.33 //y2=1.76
cc_7392 ( N_GND_c_12644_n N_noxref_41_c_14645_n ) capacitor c=0.00400855f \
 //x=37.93 //y=1.135 //x2=38.33 //y2=1.76
cc_7393 ( N_GND_c_12658_n N_noxref_41_c_14645_n ) capacitor c=0.00395858f \
 //x=39.91 //y=0.175 //x2=38.33 //y2=1.76
cc_7394 ( N_GND_M22_noxref_d N_noxref_41_c_14645_n ) capacitor c=0.00578453f \
 //x=37.74 //y=1.045 //x2=38.33 //y2=1.76
cc_7395 ( N_GND_c_12685_n N_noxref_41_c_14687_n ) capacitor c=0.00363611f \
 //x=41.175 //y=0.175 //x2=38.415 //y2=0.795
cc_7396 ( N_GND_c_12653_n N_noxref_41_c_14687_n ) capacitor c=0.0120153f \
 //x=37.927 //y=1.005 //x2=38.415 //y2=0.795
cc_7397 ( N_GND_c_12658_n N_noxref_41_c_14687_n ) capacitor c=0.0147661f \
 //x=39.91 //y=0.175 //x2=38.415 //y2=0.795
cc_7398 ( N_GND_c_12666_n N_noxref_41_c_14687_n ) capacitor c=0.00282552f \
 //x=36.75 //y=0.175 //x2=38.415 //y2=0.795
cc_7399 ( N_GND_c_12708_n N_noxref_41_c_14687_n ) capacitor c=2.99356e-19 \
 //x=40.08 //y=0.175 //x2=38.415 //y2=0.795
cc_7400 ( N_GND_c_12666_n N_noxref_41_c_14652_n ) capacitor c=2.8386e-19 \
 //x=36.75 //y=0.175 //x2=38.415 //y2=1.675
cc_7401 ( N_GND_c_12685_n N_noxref_41_c_14657_n ) capacitor c=0.00996485f \
 //x=41.175 //y=0.175 //x2=39.3 //y2=0.71
cc_7402 ( N_GND_c_12658_n N_noxref_41_c_14657_n ) capacitor c=0.0375602f \
 //x=39.91 //y=0.175 //x2=39.3 //y2=0.71
cc_7403 ( N_GND_c_13293_n N_noxref_41_c_14657_n ) capacitor c=0.00199299f \
 //x=76.46 //y=0.175 //x2=39.3 //y2=0.71
cc_7404 ( N_GND_c_12685_n N_noxref_41_c_14696_n ) capacitor c=0.00253402f \
 //x=41.175 //y=0.175 //x2=39.385 //y2=0.795
cc_7405 ( N_GND_c_12658_n N_noxref_41_c_14696_n ) capacitor c=0.0145307f \
 //x=39.91 //y=0.175 //x2=39.385 //y2=0.795
cc_7406 ( N_GND_c_12708_n N_noxref_41_c_14696_n ) capacitor c=0.0392026f \
 //x=40.08 //y=0.175 //x2=39.385 //y2=0.795
cc_7407 ( N_GND_c_12727_n N_noxref_41_M22_noxref_s ) capacitor c=0.0045077f \
 //x=37.845 //y=0.175 //x2=37.31 //y2=0.545
cc_7408 ( N_GND_c_12644_n N_noxref_41_M22_noxref_s ) capacitor c=0.0099136f \
 //x=37.93 //y=1.135 //x2=37.31 //y2=0.545
cc_7409 ( N_GND_c_12653_n N_noxref_41_M22_noxref_s ) capacitor c=0.0123761f \
 //x=37.927 //y=1.005 //x2=37.31 //y2=0.545
cc_7410 ( N_GND_c_12658_n N_noxref_41_M22_noxref_s ) capacitor c=0.0148438f \
 //x=39.91 //y=0.175 //x2=37.31 //y2=0.545
cc_7411 ( N_GND_c_12666_n N_noxref_41_M22_noxref_s ) capacitor c=0.0518718f \
 //x=36.75 //y=0.175 //x2=37.31 //y2=0.545
cc_7412 ( N_GND_c_12708_n N_noxref_41_M22_noxref_s ) capacitor c=0.0064811f \
 //x=40.08 //y=0.175 //x2=37.31 //y2=0.545
cc_7413 ( N_GND_M22_noxref_d N_noxref_41_M22_noxref_s ) capacitor c=0.0271276f \
 //x=37.74 //y=1.045 //x2=37.31 //y2=0.545
cc_7414 ( N_GND_c_12685_n N_noxref_42_c_14713_n ) capacitor c=9.8916e-19 \
 //x=41.175 //y=0.175 //x2=41.66 //y2=1.76
cc_7415 ( N_GND_c_12730_n N_noxref_42_c_14713_n ) capacitor c=7.45647e-19 \
 //x=44.4 //y=0.175 //x2=41.66 //y2=1.76
cc_7416 ( N_GND_c_12692_n N_noxref_42_c_14713_n ) capacitor c=0.00402206f \
 //x=41.26 //y=1.135 //x2=41.66 //y2=1.76
cc_7417 ( N_GND_c_12706_n N_noxref_42_c_14713_n ) capacitor c=0.00395774f \
 //x=43.24 //y=0.175 //x2=41.66 //y2=1.76
cc_7418 ( N_GND_M24_noxref_d N_noxref_42_c_14713_n ) capacitor c=0.00578453f \
 //x=41.07 //y=1.045 //x2=41.66 //y2=1.76
cc_7419 ( N_GND_c_12730_n N_noxref_42_c_14755_n ) capacitor c=0.00310282f \
 //x=44.4 //y=0.175 //x2=41.745 //y2=0.795
cc_7420 ( N_GND_c_12702_n N_noxref_42_c_14755_n ) capacitor c=0.0119573f \
 //x=41.257 //y=1.005 //x2=41.745 //y2=0.795
cc_7421 ( N_GND_c_12706_n N_noxref_42_c_14755_n ) capacitor c=0.0147548f \
 //x=43.24 //y=0.175 //x2=41.745 //y2=0.795
cc_7422 ( N_GND_c_12708_n N_noxref_42_c_14755_n ) capacitor c=0.00282552f \
 //x=40.08 //y=0.175 //x2=41.745 //y2=0.795
cc_7423 ( N_GND_c_12760_n N_noxref_42_c_14755_n ) capacitor c=2.99181e-19 \
 //x=43.41 //y=0.175 //x2=41.745 //y2=0.795
cc_7424 ( N_GND_c_12708_n N_noxref_42_c_14720_n ) capacitor c=2.8386e-19 \
 //x=40.08 //y=0.175 //x2=41.745 //y2=1.675
cc_7425 ( N_GND_c_12730_n N_noxref_42_c_14728_n ) capacitor c=0.00991795f \
 //x=44.4 //y=0.175 //x2=42.63 //y2=0.71
cc_7426 ( N_GND_c_12706_n N_noxref_42_c_14728_n ) capacitor c=0.0374845f \
 //x=43.24 //y=0.175 //x2=42.63 //y2=0.71
cc_7427 ( N_GND_c_13293_n N_noxref_42_c_14728_n ) capacitor c=0.00199299f \
 //x=76.46 //y=0.175 //x2=42.63 //y2=0.71
cc_7428 ( N_GND_c_12730_n N_noxref_42_c_14764_n ) capacitor c=0.00242143f \
 //x=44.4 //y=0.175 //x2=42.715 //y2=0.795
cc_7429 ( N_GND_c_12706_n N_noxref_42_c_14764_n ) capacitor c=0.0145154f \
 //x=43.24 //y=0.175 //x2=42.715 //y2=0.795
cc_7430 ( N_GND_c_12760_n N_noxref_42_c_14764_n ) capacitor c=0.0396774f \
 //x=43.41 //y=0.175 //x2=42.715 //y2=0.795
cc_7431 ( N_GND_c_12685_n N_noxref_42_M24_noxref_s ) capacitor c=0.0045077f \
 //x=41.175 //y=0.175 //x2=40.64 //y2=0.545
cc_7432 ( N_GND_c_12692_n N_noxref_42_M24_noxref_s ) capacitor c=0.00990843f \
 //x=41.26 //y=1.135 //x2=40.64 //y2=0.545
cc_7433 ( N_GND_c_12702_n N_noxref_42_M24_noxref_s ) capacitor c=0.0123717f \
 //x=41.257 //y=1.005 //x2=40.64 //y2=0.545
cc_7434 ( N_GND_c_12706_n N_noxref_42_M24_noxref_s ) capacitor c=0.0147643f \
 //x=43.24 //y=0.175 //x2=40.64 //y2=0.545
cc_7435 ( N_GND_c_12708_n N_noxref_42_M24_noxref_s ) capacitor c=0.0518718f \
 //x=40.08 //y=0.175 //x2=40.64 //y2=0.545
cc_7436 ( N_GND_c_12760_n N_noxref_42_M24_noxref_s ) capacitor c=0.00648063f \
 //x=43.41 //y=0.175 //x2=40.64 //y2=0.545
cc_7437 ( N_GND_M24_noxref_d N_noxref_42_M24_noxref_s ) capacitor c=0.0271276f \
 //x=41.07 //y=1.045 //x2=40.64 //y2=0.545
cc_7438 ( N_GND_c_12730_n N_noxref_43_c_14791_n ) capacitor c=0.0011329f \
 //x=44.4 //y=0.175 //x2=44.885 //y2=1.77
cc_7439 ( N_GND_c_12829_n N_noxref_43_c_14791_n ) capacitor c=6.72491e-19 \
 //x=49.315 //y=0.175 //x2=44.885 //y2=1.77
cc_7440 ( N_GND_c_13032_n N_noxref_43_c_14791_n ) capacitor c=0.00379381f \
 //x=44.485 //y=1.145 //x2=44.885 //y2=1.77
cc_7441 ( N_GND_c_12849_n N_noxref_43_c_14791_n ) capacitor c=0.00392232f \
 //x=48.05 //y=0.175 //x2=44.885 //y2=1.77
cc_7442 ( N_GND_M26_noxref_d N_noxref_43_c_14791_n ) capacitor c=0.00578031f \
 //x=44.295 //y=1.055 //x2=44.885 //y2=1.77
cc_7443 ( N_GND_c_13024_n N_noxref_43_c_14806_n ) capacitor c=0.0169052f \
 //x=44.485 //y=1.015 //x2=44.97 //y2=0.805
cc_7444 ( N_GND_c_12829_n N_noxref_43_c_14806_n ) capacitor c=0.00439789f \
 //x=49.315 //y=0.175 //x2=44.97 //y2=0.805
cc_7445 ( N_GND_c_12849_n N_noxref_43_c_14806_n ) capacitor c=0.0141638f \
 //x=48.05 //y=0.175 //x2=44.97 //y2=0.805
cc_7446 ( N_GND_c_12760_n N_noxref_43_c_14806_n ) capacitor c=0.00322442f \
 //x=43.41 //y=0.175 //x2=44.97 //y2=0.805
cc_7447 ( N_GND_c_12829_n N_noxref_43_c_14780_n ) capacitor c=0.0124129f \
 //x=49.315 //y=0.175 //x2=45.855 //y2=0.72
cc_7448 ( N_GND_c_12849_n N_noxref_43_c_14780_n ) capacitor c=0.0361346f \
 //x=48.05 //y=0.175 //x2=45.855 //y2=0.72
cc_7449 ( N_GND_c_13293_n N_noxref_43_c_14780_n ) capacitor c=0.00178095f \
 //x=76.46 //y=0.175 //x2=45.855 //y2=0.72
cc_7450 ( N_GND_c_12730_n N_noxref_43_M26_noxref_s ) capacitor c=0.00439789f \
 //x=44.4 //y=0.175 //x2=43.865 //y2=0.555
cc_7451 ( N_GND_c_13024_n N_noxref_43_M26_noxref_s ) capacitor c=0.0125586f \
 //x=44.485 //y=1.015 //x2=43.865 //y2=0.555
cc_7452 ( N_GND_c_12829_n N_noxref_43_M26_noxref_s ) capacitor c=0.0044479f \
 //x=49.315 //y=0.175 //x2=43.865 //y2=0.555
cc_7453 ( N_GND_c_13032_n N_noxref_43_M26_noxref_s ) capacitor c=0.00972044f \
 //x=44.485 //y=1.145 //x2=43.865 //y2=0.555
cc_7454 ( N_GND_c_12849_n N_noxref_43_M26_noxref_s ) capacitor c=0.0273693f \
 //x=48.05 //y=0.175 //x2=43.865 //y2=0.555
cc_7455 ( N_GND_c_12760_n N_noxref_43_M26_noxref_s ) capacitor c=0.0624873f \
 //x=43.41 //y=0.175 //x2=43.865 //y2=0.555
cc_7456 ( N_GND_c_12823_n N_noxref_43_M26_noxref_s ) capacitor c=0.00166451f \
 //x=48.22 //y=0.175 //x2=43.865 //y2=0.555
cc_7457 ( N_GND_M26_noxref_d N_noxref_43_M26_noxref_s ) capacitor c=0.0271316f \
 //x=44.295 //y=1.055 //x2=43.865 //y2=0.555
cc_7458 ( N_GND_c_12829_n N_noxref_44_c_14863_n ) capacitor c=9.8916e-19 \
 //x=49.315 //y=0.175 //x2=49.8 //y2=1.76
cc_7459 ( N_GND_c_12788_n N_noxref_44_c_14863_n ) capacitor c=7.45647e-19 \
 //x=52.645 //y=0.175 //x2=49.8 //y2=1.76
cc_7460 ( N_GND_c_12833_n N_noxref_44_c_14863_n ) capacitor c=0.00402268f \
 //x=49.4 //y=1.135 //x2=49.8 //y2=1.76
cc_7461 ( N_GND_c_12801_n N_noxref_44_c_14863_n ) capacitor c=0.00395774f \
 //x=51.38 //y=0.175 //x2=49.8 //y2=1.76
cc_7462 ( N_GND_M29_noxref_d N_noxref_44_c_14863_n ) capacitor c=0.00578453f \
 //x=49.21 //y=1.045 //x2=49.8 //y2=1.76
cc_7463 ( N_GND_c_12788_n N_noxref_44_c_14886_n ) capacitor c=0.00274367f \
 //x=52.645 //y=0.175 //x2=49.885 //y2=0.795
cc_7464 ( N_GND_c_12942_n N_noxref_44_c_14886_n ) capacitor c=0.0120153f \
 //x=49.397 //y=1.005 //x2=49.885 //y2=0.795
cc_7465 ( N_GND_c_12801_n N_noxref_44_c_14886_n ) capacitor c=0.0144743f \
 //x=51.38 //y=0.175 //x2=49.885 //y2=0.795
cc_7466 ( N_GND_c_12823_n N_noxref_44_c_14886_n ) capacitor c=0.00282583f \
 //x=48.22 //y=0.175 //x2=49.885 //y2=0.795
cc_7467 ( N_GND_c_12825_n N_noxref_44_c_14886_n ) capacitor c=2.99356e-19 \
 //x=51.55 //y=0.175 //x2=49.885 //y2=0.795
cc_7468 ( N_GND_c_12823_n N_noxref_44_c_14839_n ) capacitor c=2.8386e-19 \
 //x=48.22 //y=0.175 //x2=49.885 //y2=1.675
cc_7469 ( N_GND_c_12788_n N_noxref_44_c_14843_n ) capacitor c=0.00984892f \
 //x=52.645 //y=0.175 //x2=50.77 //y2=0.71
cc_7470 ( N_GND_c_12801_n N_noxref_44_c_14843_n ) capacitor c=0.0374802f \
 //x=51.38 //y=0.175 //x2=50.77 //y2=0.71
cc_7471 ( N_GND_c_13293_n N_noxref_44_c_14843_n ) capacitor c=0.00199299f \
 //x=76.46 //y=0.175 //x2=50.77 //y2=0.71
cc_7472 ( N_GND_c_12788_n N_noxref_44_c_14895_n ) capacitor c=0.00250904f \
 //x=52.645 //y=0.175 //x2=50.855 //y2=0.795
cc_7473 ( N_GND_c_12801_n N_noxref_44_c_14895_n ) capacitor c=0.0145307f \
 //x=51.38 //y=0.175 //x2=50.855 //y2=0.795
cc_7474 ( N_GND_c_12825_n N_noxref_44_c_14895_n ) capacitor c=0.0392026f \
 //x=51.55 //y=0.175 //x2=50.855 //y2=0.795
cc_7475 ( N_GND_c_12829_n N_noxref_44_M29_noxref_s ) capacitor c=0.0045077f \
 //x=49.315 //y=0.175 //x2=48.78 //y2=0.545
cc_7476 ( N_GND_c_12833_n N_noxref_44_M29_noxref_s ) capacitor c=0.0100997f \
 //x=49.4 //y=1.135 //x2=48.78 //y2=0.545
cc_7477 ( N_GND_c_12942_n N_noxref_44_M29_noxref_s ) capacitor c=0.0170652f \
 //x=49.397 //y=1.005 //x2=48.78 //y2=0.545
cc_7478 ( N_GND_c_12801_n N_noxref_44_M29_noxref_s ) capacitor c=0.0147643f \
 //x=51.38 //y=0.175 //x2=48.78 //y2=0.545
cc_7479 ( N_GND_c_12823_n N_noxref_44_M29_noxref_s ) capacitor c=0.0528206f \
 //x=48.22 //y=0.175 //x2=48.78 //y2=0.545
cc_7480 ( N_GND_c_12825_n N_noxref_44_M29_noxref_s ) capacitor c=0.0064811f \
 //x=51.55 //y=0.175 //x2=48.78 //y2=0.545
cc_7481 ( N_GND_M29_noxref_d N_noxref_44_M29_noxref_s ) capacitor c=0.0271276f \
 //x=49.21 //y=1.045 //x2=48.78 //y2=0.545
cc_7482 ( N_GND_c_12788_n N_noxref_45_c_14909_n ) capacitor c=9.79596e-19 \
 //x=52.645 //y=0.175 //x2=53.13 //y2=1.76
cc_7483 ( N_GND_c_12871_n N_noxref_45_c_14909_n ) capacitor c=7.45647e-19 \
 //x=55.975 //y=0.175 //x2=53.13 //y2=1.76
cc_7484 ( N_GND_c_12836_n N_noxref_45_c_14909_n ) capacitor c=0.00400656f \
 //x=52.73 //y=1.135 //x2=53.13 //y2=1.76
cc_7485 ( N_GND_c_12851_n N_noxref_45_c_14909_n ) capacitor c=0.00395774f \
 //x=54.71 //y=0.175 //x2=53.13 //y2=1.76
cc_7486 ( N_GND_M31_noxref_d N_noxref_45_c_14909_n ) capacitor c=0.00578453f \
 //x=52.54 //y=1.045 //x2=53.13 //y2=1.76
cc_7487 ( N_GND_c_12871_n N_noxref_45_c_14952_n ) capacitor c=0.00310362f \
 //x=55.975 //y=0.175 //x2=53.215 //y2=0.795
cc_7488 ( N_GND_c_12846_n N_noxref_45_c_14952_n ) capacitor c=0.0120153f \
 //x=52.727 //y=1.005 //x2=53.215 //y2=0.795
cc_7489 ( N_GND_c_12851_n N_noxref_45_c_14952_n ) capacitor c=0.0147548f \
 //x=54.71 //y=0.175 //x2=53.215 //y2=0.795
cc_7490 ( N_GND_c_12825_n N_noxref_45_c_14952_n ) capacitor c=0.00282552f \
 //x=51.55 //y=0.175 //x2=53.215 //y2=0.795
cc_7491 ( N_GND_c_12895_n N_noxref_45_c_14952_n ) capacitor c=2.99356e-19 \
 //x=54.88 //y=0.175 //x2=53.215 //y2=0.795
cc_7492 ( N_GND_c_12825_n N_noxref_45_c_14916_n ) capacitor c=2.8386e-19 \
 //x=51.55 //y=0.175 //x2=53.215 //y2=1.675
cc_7493 ( N_GND_c_12871_n N_noxref_45_c_14921_n ) capacitor c=0.00989636f \
 //x=55.975 //y=0.175 //x2=54.1 //y2=0.71
cc_7494 ( N_GND_c_12851_n N_noxref_45_c_14921_n ) capacitor c=0.0374802f \
 //x=54.71 //y=0.175 //x2=54.1 //y2=0.71
cc_7495 ( N_GND_c_13293_n N_noxref_45_c_14921_n ) capacitor c=0.00199299f \
 //x=76.46 //y=0.175 //x2=54.1 //y2=0.71
cc_7496 ( N_GND_c_12871_n N_noxref_45_c_14961_n ) capacitor c=0.00250904f \
 //x=55.975 //y=0.175 //x2=54.185 //y2=0.795
cc_7497 ( N_GND_c_12851_n N_noxref_45_c_14961_n ) capacitor c=0.0145307f \
 //x=54.71 //y=0.175 //x2=54.185 //y2=0.795
cc_7498 ( N_GND_c_12895_n N_noxref_45_c_14961_n ) capacitor c=0.0392026f \
 //x=54.88 //y=0.175 //x2=54.185 //y2=0.795
cc_7499 ( N_GND_c_12788_n N_noxref_45_M31_noxref_s ) capacitor c=0.0045077f \
 //x=52.645 //y=0.175 //x2=52.11 //y2=0.545
cc_7500 ( N_GND_c_12836_n N_noxref_45_M31_noxref_s ) capacitor c=0.0099136f \
 //x=52.73 //y=1.135 //x2=52.11 //y2=0.545
cc_7501 ( N_GND_c_12846_n N_noxref_45_M31_noxref_s ) capacitor c=0.0123761f \
 //x=52.727 //y=1.005 //x2=52.11 //y2=0.545
cc_7502 ( N_GND_c_12851_n N_noxref_45_M31_noxref_s ) capacitor c=0.0147643f \
 //x=54.71 //y=0.175 //x2=52.11 //y2=0.545
cc_7503 ( N_GND_c_12825_n N_noxref_45_M31_noxref_s ) capacitor c=0.0518718f \
 //x=51.55 //y=0.175 //x2=52.11 //y2=0.545
cc_7504 ( N_GND_c_12895_n N_noxref_45_M31_noxref_s ) capacitor c=0.0064811f \
 //x=54.88 //y=0.175 //x2=52.11 //y2=0.545
cc_7505 ( N_GND_M31_noxref_d N_noxref_45_M31_noxref_s ) capacitor c=0.0271276f \
 //x=52.54 //y=1.045 //x2=52.11 //y2=0.545
cc_7506 ( N_GND_c_12871_n N_noxref_46_c_14978_n ) capacitor c=9.79596e-19 \
 //x=55.975 //y=0.175 //x2=56.46 //y2=1.76
cc_7507 ( N_GND_c_12915_n N_noxref_46_c_14978_n ) capacitor c=7.45647e-19 \
 //x=59.305 //y=0.175 //x2=56.46 //y2=1.76
cc_7508 ( N_GND_c_12878_n N_noxref_46_c_14978_n ) capacitor c=0.00400678f \
 //x=56.06 //y=1.135 //x2=56.46 //y2=1.76
cc_7509 ( N_GND_c_12893_n N_noxref_46_c_14978_n ) capacitor c=0.00395774f \
 //x=58.04 //y=0.175 //x2=56.46 //y2=1.76
cc_7510 ( N_GND_M33_noxref_d N_noxref_46_c_14978_n ) capacitor c=0.00578453f \
 //x=55.87 //y=1.045 //x2=56.46 //y2=1.76
cc_7511 ( N_GND_c_12915_n N_noxref_46_c_15020_n ) capacitor c=0.00418312f \
 //x=59.305 //y=0.175 //x2=56.545 //y2=0.795
cc_7512 ( N_GND_c_12888_n N_noxref_46_c_15020_n ) capacitor c=0.0120153f \
 //x=56.057 //y=1.005 //x2=56.545 //y2=0.795
cc_7513 ( N_GND_c_12893_n N_noxref_46_c_15020_n ) capacitor c=0.0147548f \
 //x=58.04 //y=0.175 //x2=56.545 //y2=0.795
cc_7514 ( N_GND_c_12895_n N_noxref_46_c_15020_n ) capacitor c=0.00282552f \
 //x=54.88 //y=0.175 //x2=56.545 //y2=0.795
cc_7515 ( N_GND_c_12925_n N_noxref_46_c_15020_n ) capacitor c=2.99356e-19 \
 //x=58.21 //y=0.175 //x2=56.545 //y2=0.795
cc_7516 ( N_GND_c_12895_n N_noxref_46_c_14985_n ) capacitor c=2.8386e-19 \
 //x=54.88 //y=0.175 //x2=56.545 //y2=1.675
cc_7517 ( N_GND_c_12915_n N_noxref_46_c_14992_n ) capacitor c=0.00980233f \
 //x=59.305 //y=0.175 //x2=57.43 //y2=0.71
cc_7518 ( N_GND_c_12893_n N_noxref_46_c_14992_n ) capacitor c=0.0375602f \
 //x=58.04 //y=0.175 //x2=57.43 //y2=0.71
cc_7519 ( N_GND_c_13293_n N_noxref_46_c_14992_n ) capacitor c=0.00199299f \
 //x=76.46 //y=0.175 //x2=57.43 //y2=0.71
cc_7520 ( N_GND_c_12915_n N_noxref_46_c_15029_n ) capacitor c=0.00256023f \
 //x=59.305 //y=0.175 //x2=57.515 //y2=0.795
cc_7521 ( N_GND_c_12893_n N_noxref_46_c_15029_n ) capacitor c=0.0145307f \
 //x=58.04 //y=0.175 //x2=57.515 //y2=0.795
cc_7522 ( N_GND_c_12925_n N_noxref_46_c_15029_n ) capacitor c=0.0392026f \
 //x=58.21 //y=0.175 //x2=57.515 //y2=0.795
cc_7523 ( N_GND_c_12871_n N_noxref_46_M33_noxref_s ) capacitor c=0.0045077f \
 //x=55.975 //y=0.175 //x2=55.44 //y2=0.545
cc_7524 ( N_GND_c_12878_n N_noxref_46_M33_noxref_s ) capacitor c=0.0099136f \
 //x=56.06 //y=1.135 //x2=55.44 //y2=0.545
cc_7525 ( N_GND_c_12888_n N_noxref_46_M33_noxref_s ) capacitor c=0.0123761f \
 //x=56.057 //y=1.005 //x2=55.44 //y2=0.545
cc_7526 ( N_GND_c_12893_n N_noxref_46_M33_noxref_s ) capacitor c=0.0147643f \
 //x=58.04 //y=0.175 //x2=55.44 //y2=0.545
cc_7527 ( N_GND_c_12895_n N_noxref_46_M33_noxref_s ) capacitor c=0.0518718f \
 //x=54.88 //y=0.175 //x2=55.44 //y2=0.545
cc_7528 ( N_GND_c_12925_n N_noxref_46_M33_noxref_s ) capacitor c=0.0064811f \
 //x=58.21 //y=0.175 //x2=55.44 //y2=0.545
cc_7529 ( N_GND_M33_noxref_d N_noxref_46_M33_noxref_s ) capacitor c=0.0271276f \
 //x=55.87 //y=1.045 //x2=55.44 //y2=0.545
cc_7530 ( N_GND_c_12915_n N_noxref_47_c_15046_n ) capacitor c=9.8916e-19 \
 //x=59.305 //y=0.175 //x2=59.79 //y2=1.76
cc_7531 ( N_GND_c_12986_n N_noxref_47_c_15046_n ) capacitor c=7.45647e-19 \
 //x=62.635 //y=0.175 //x2=59.79 //y2=1.76
cc_7532 ( N_GND_c_12945_n N_noxref_47_c_15046_n ) capacitor c=0.00400855f \
 //x=59.39 //y=1.135 //x2=59.79 //y2=1.76
cc_7533 ( N_GND_c_12959_n N_noxref_47_c_15046_n ) capacitor c=0.00395774f \
 //x=61.37 //y=0.175 //x2=59.79 //y2=1.76
cc_7534 ( N_GND_M35_noxref_d N_noxref_47_c_15046_n ) capacitor c=0.00578453f \
 //x=59.2 //y=1.045 //x2=59.79 //y2=1.76
cc_7535 ( N_GND_c_12986_n N_noxref_47_c_15090_n ) capacitor c=0.00393483f \
 //x=62.635 //y=0.175 //x2=59.875 //y2=0.795
cc_7536 ( N_GND_c_12954_n N_noxref_47_c_15090_n ) capacitor c=0.0120153f \
 //x=59.387 //y=1.005 //x2=59.875 //y2=0.795
cc_7537 ( N_GND_c_12959_n N_noxref_47_c_15090_n ) capacitor c=0.0147548f \
 //x=61.37 //y=0.175 //x2=59.875 //y2=0.795
cc_7538 ( N_GND_c_12925_n N_noxref_47_c_15090_n ) capacitor c=0.00282552f \
 //x=58.21 //y=0.175 //x2=59.875 //y2=0.795
cc_7539 ( N_GND_c_13009_n N_noxref_47_c_15090_n ) capacitor c=2.99356e-19 \
 //x=61.54 //y=0.175 //x2=59.875 //y2=0.795
cc_7540 ( N_GND_c_12925_n N_noxref_47_c_15053_n ) capacitor c=2.8386e-19 \
 //x=58.21 //y=0.175 //x2=59.875 //y2=1.675
cc_7541 ( N_GND_c_12986_n N_noxref_47_c_15058_n ) capacitor c=0.00972997f \
 //x=62.635 //y=0.175 //x2=60.76 //y2=0.71
cc_7542 ( N_GND_c_12959_n N_noxref_47_c_15058_n ) capacitor c=0.0375602f \
 //x=61.37 //y=0.175 //x2=60.76 //y2=0.71
cc_7543 ( N_GND_c_13293_n N_noxref_47_c_15058_n ) capacitor c=0.00199299f \
 //x=76.46 //y=0.175 //x2=60.76 //y2=0.71
cc_7544 ( N_GND_c_12986_n N_noxref_47_c_15099_n ) capacitor c=0.00258296f \
 //x=62.635 //y=0.175 //x2=60.845 //y2=0.795
cc_7545 ( N_GND_c_12959_n N_noxref_47_c_15099_n ) capacitor c=0.0145307f \
 //x=61.37 //y=0.175 //x2=60.845 //y2=0.795
cc_7546 ( N_GND_c_13009_n N_noxref_47_c_15099_n ) capacitor c=0.0392026f \
 //x=61.54 //y=0.175 //x2=60.845 //y2=0.795
cc_7547 ( N_GND_c_12915_n N_noxref_47_M35_noxref_s ) capacitor c=0.0045077f \
 //x=59.305 //y=0.175 //x2=58.77 //y2=0.545
cc_7548 ( N_GND_c_12945_n N_noxref_47_M35_noxref_s ) capacitor c=0.0099136f \
 //x=59.39 //y=1.135 //x2=58.77 //y2=0.545
cc_7549 ( N_GND_c_12954_n N_noxref_47_M35_noxref_s ) capacitor c=0.0123761f \
 //x=59.387 //y=1.005 //x2=58.77 //y2=0.545
cc_7550 ( N_GND_c_12959_n N_noxref_47_M35_noxref_s ) capacitor c=0.0147643f \
 //x=61.37 //y=0.175 //x2=58.77 //y2=0.545
cc_7551 ( N_GND_c_12925_n N_noxref_47_M35_noxref_s ) capacitor c=0.0518718f \
 //x=58.21 //y=0.175 //x2=58.77 //y2=0.545
cc_7552 ( N_GND_c_13009_n N_noxref_47_M35_noxref_s ) capacitor c=0.0064811f \
 //x=61.54 //y=0.175 //x2=58.77 //y2=0.545
cc_7553 ( N_GND_M35_noxref_d N_noxref_47_M35_noxref_s ) capacitor c=0.0271276f \
 //x=59.2 //y=1.045 //x2=58.77 //y2=0.545
cc_7554 ( N_GND_c_12986_n N_noxref_48_c_15116_n ) capacitor c=0.0011359f \
 //x=62.635 //y=0.175 //x2=63.12 //y2=1.76
cc_7555 ( N_GND_c_13031_n N_noxref_48_c_15116_n ) capacitor c=7.45647e-19 \
 //x=65.965 //y=0.175 //x2=63.12 //y2=1.76
cc_7556 ( N_GND_c_12993_n N_noxref_48_c_15116_n ) capacitor c=0.00405476f \
 //x=62.72 //y=1.135 //x2=63.12 //y2=1.76
cc_7557 ( N_GND_c_13007_n N_noxref_48_c_15116_n ) capacitor c=0.00395774f \
 //x=64.7 //y=0.175 //x2=63.12 //y2=1.76
cc_7558 ( N_GND_M37_noxref_d N_noxref_48_c_15116_n ) capacitor c=0.00578453f \
 //x=62.53 //y=1.045 //x2=63.12 //y2=1.76
cc_7559 ( N_GND_c_13031_n N_noxref_48_c_15159_n ) capacitor c=0.00310282f \
 //x=65.965 //y=0.175 //x2=63.205 //y2=0.795
cc_7560 ( N_GND_c_13003_n N_noxref_48_c_15159_n ) capacitor c=0.0120153f \
 //x=62.717 //y=1.005 //x2=63.205 //y2=0.795
cc_7561 ( N_GND_c_13007_n N_noxref_48_c_15159_n ) capacitor c=0.0147548f \
 //x=64.7 //y=0.175 //x2=63.205 //y2=0.795
cc_7562 ( N_GND_c_13009_n N_noxref_48_c_15159_n ) capacitor c=0.00282552f \
 //x=61.54 //y=0.175 //x2=63.205 //y2=0.795
cc_7563 ( N_GND_c_13061_n N_noxref_48_c_15159_n ) capacitor c=2.99356e-19 \
 //x=64.87 //y=0.175 //x2=63.205 //y2=0.795
cc_7564 ( N_GND_c_13009_n N_noxref_48_c_15123_n ) capacitor c=2.8386e-19 \
 //x=61.54 //y=0.175 //x2=63.205 //y2=1.675
cc_7565 ( N_GND_c_13031_n N_noxref_48_c_15131_n ) capacitor c=0.00993072f \
 //x=65.965 //y=0.175 //x2=64.09 //y2=0.71
cc_7566 ( N_GND_c_13007_n N_noxref_48_c_15131_n ) capacitor c=0.0375602f \
 //x=64.7 //y=0.175 //x2=64.09 //y2=0.71
cc_7567 ( N_GND_c_13293_n N_noxref_48_c_15131_n ) capacitor c=0.00199299f \
 //x=76.46 //y=0.175 //x2=64.09 //y2=0.71
cc_7568 ( N_GND_c_13031_n N_noxref_48_c_15168_n ) capacitor c=0.00253571f \
 //x=65.965 //y=0.175 //x2=64.175 //y2=0.795
cc_7569 ( N_GND_c_13007_n N_noxref_48_c_15168_n ) capacitor c=0.0145307f \
 //x=64.7 //y=0.175 //x2=64.175 //y2=0.795
cc_7570 ( N_GND_c_13061_n N_noxref_48_c_15168_n ) capacitor c=0.0391997f \
 //x=64.87 //y=0.175 //x2=64.175 //y2=0.795
cc_7571 ( N_GND_c_12986_n N_noxref_48_M37_noxref_s ) capacitor c=0.0045077f \
 //x=62.635 //y=0.175 //x2=62.1 //y2=0.545
cc_7572 ( N_GND_c_12993_n N_noxref_48_M37_noxref_s ) capacitor c=0.00991496f \
 //x=62.72 //y=1.135 //x2=62.1 //y2=0.545
cc_7573 ( N_GND_c_13003_n N_noxref_48_M37_noxref_s ) capacitor c=0.0123761f \
 //x=62.717 //y=1.005 //x2=62.1 //y2=0.545
cc_7574 ( N_GND_c_13007_n N_noxref_48_M37_noxref_s ) capacitor c=0.0147643f \
 //x=64.7 //y=0.175 //x2=62.1 //y2=0.545
cc_7575 ( N_GND_c_13009_n N_noxref_48_M37_noxref_s ) capacitor c=0.0518718f \
 //x=61.54 //y=0.175 //x2=62.1 //y2=0.545
cc_7576 ( N_GND_c_13061_n N_noxref_48_M37_noxref_s ) capacitor c=0.00648111f \
 //x=64.87 //y=0.175 //x2=62.1 //y2=0.545
cc_7577 ( N_GND_M37_noxref_d N_noxref_48_M37_noxref_s ) capacitor c=0.0271276f \
 //x=62.53 //y=1.045 //x2=62.1 //y2=0.545
cc_7578 ( N_GND_c_13031_n N_noxref_49_c_15188_n ) capacitor c=9.43711e-19 \
 //x=65.965 //y=0.175 //x2=66.45 //y2=1.76
cc_7579 ( N_GND_c_13079_n N_noxref_49_c_15188_n ) capacitor c=0.0049241f \
 //x=66.05 //y=1.015 //x2=66.45 //y2=1.76
cc_7580 ( N_GND_c_13145_n N_noxref_49_c_15188_n ) capacitor c=7.45647e-19 \
 //x=69.295 //y=0.175 //x2=66.45 //y2=1.76
cc_7581 ( N_GND_c_13101_n N_noxref_49_c_15188_n ) capacitor c=0.00427835f \
 //x=68.03 //y=0.175 //x2=66.45 //y2=1.76
cc_7582 ( N_GND_M39_noxref_d N_noxref_49_c_15188_n ) capacitor c=0.00579662f \
 //x=65.86 //y=1.045 //x2=66.45 //y2=1.76
cc_7583 ( N_GND_c_13079_n N_noxref_49_c_15229_n ) capacitor c=0.0120153f \
 //x=66.05 //y=1.015 //x2=66.535 //y2=0.795
cc_7584 ( N_GND_c_13145_n N_noxref_49_c_15229_n ) capacitor c=0.00369578f \
 //x=69.295 //y=0.175 //x2=66.535 //y2=0.795
cc_7585 ( N_GND_c_13101_n N_noxref_49_c_15229_n ) capacitor c=0.0147257f \
 //x=68.03 //y=0.175 //x2=66.535 //y2=0.795
cc_7586 ( N_GND_c_13061_n N_noxref_49_c_15229_n ) capacitor c=0.00283156f \
 //x=64.87 //y=0.175 //x2=66.535 //y2=0.795
cc_7587 ( N_GND_c_13115_n N_noxref_49_c_15229_n ) capacitor c=2.99356e-19 \
 //x=68.2 //y=0.175 //x2=66.535 //y2=0.795
cc_7588 ( N_GND_c_13061_n N_noxref_49_c_15197_n ) capacitor c=2.89348e-19 \
 //x=64.87 //y=0.175 //x2=66.535 //y2=1.675
cc_7589 ( N_GND_c_13145_n N_noxref_49_c_15207_n ) capacitor c=0.010903f \
 //x=69.295 //y=0.175 //x2=67.42 //y2=0.71
cc_7590 ( N_GND_c_13101_n N_noxref_49_c_15207_n ) capacitor c=0.0375493f \
 //x=68.03 //y=0.175 //x2=67.42 //y2=0.71
cc_7591 ( N_GND_c_13293_n N_noxref_49_c_15207_n ) capacitor c=0.00199299f \
 //x=76.46 //y=0.175 //x2=67.42 //y2=0.71
cc_7592 ( N_GND_c_13145_n N_noxref_49_c_15238_n ) capacitor c=0.0045077f \
 //x=69.295 //y=0.175 //x2=67.505 //y2=0.795
cc_7593 ( N_GND_c_13101_n N_noxref_49_c_15238_n ) capacitor c=0.0144994f \
 //x=68.03 //y=0.175 //x2=67.505 //y2=0.795
cc_7594 ( N_GND_c_13115_n N_noxref_49_c_15238_n ) capacitor c=0.0540895f \
 //x=68.2 //y=0.175 //x2=67.505 //y2=0.795
cc_7595 ( N_GND_c_13031_n N_noxref_49_M39_noxref_s ) capacitor c=0.00256274f \
 //x=65.965 //y=0.175 //x2=65.43 //y2=0.545
cc_7596 ( N_GND_c_13079_n N_noxref_49_M39_noxref_s ) capacitor c=0.0240655f \
 //x=66.05 //y=1.015 //x2=65.43 //y2=0.545
cc_7597 ( N_GND_c_13101_n N_noxref_49_M39_noxref_s ) capacitor c=0.0146671f \
 //x=68.03 //y=0.175 //x2=65.43 //y2=0.545
cc_7598 ( N_GND_c_13061_n N_noxref_49_M39_noxref_s ) capacitor c=0.0526823f \
 //x=64.87 //y=0.175 //x2=65.43 //y2=0.545
cc_7599 ( N_GND_c_13115_n N_noxref_49_M39_noxref_s ) capacitor c=0.00250794f \
 //x=68.2 //y=0.175 //x2=65.43 //y2=0.545
cc_7600 ( N_GND_M39_noxref_d N_noxref_49_M39_noxref_s ) capacitor c=0.0271433f \
 //x=65.86 //y=1.045 //x2=65.43 //y2=0.545
cc_7601 ( N_GND_c_13145_n N_noxref_51_c_15263_n ) capacitor c=0.0010065f \
 //x=69.295 //y=0.175 //x2=69.78 //y2=1.76
cc_7602 ( N_GND_c_13087_n N_noxref_51_c_15263_n ) capacitor c=0.00389804f \
 //x=69.38 //y=1.015 //x2=69.78 //y2=1.76
cc_7603 ( N_GND_c_13181_n N_noxref_51_c_15263_n ) capacitor c=7.45647e-19 \
 //x=72.625 //y=0.175 //x2=69.78 //y2=1.76
cc_7604 ( N_GND_c_13102_n N_noxref_51_c_15263_n ) capacitor c=0.00358018f \
 //x=71.36 //y=0.175 //x2=69.78 //y2=1.76
cc_7605 ( N_GND_M41_noxref_d N_noxref_51_c_15263_n ) capacitor c=0.00750663f \
 //x=69.19 //y=1.045 //x2=69.78 //y2=1.76
cc_7606 ( N_GND_c_13087_n N_noxref_51_c_15304_n ) capacitor c=0.0120153f \
 //x=69.38 //y=1.015 //x2=69.865 //y2=0.795
cc_7607 ( N_GND_c_13181_n N_noxref_51_c_15304_n ) capacitor c=0.0045077f \
 //x=72.625 //y=0.175 //x2=69.865 //y2=0.795
cc_7608 ( N_GND_c_13102_n N_noxref_51_c_15304_n ) capacitor c=0.0144994f \
 //x=71.36 //y=0.175 //x2=69.865 //y2=0.795
cc_7609 ( N_GND_c_13115_n N_noxref_51_c_15304_n ) capacitor c=0.00226009f \
 //x=68.2 //y=0.175 //x2=69.865 //y2=0.795
cc_7610 ( N_GND_c_13172_n N_noxref_51_c_15304_n ) capacitor c=2.99356e-19 \
 //x=71.53 //y=0.175 //x2=69.865 //y2=0.795
cc_7611 ( N_GND_c_13115_n N_noxref_51_c_15270_n ) capacitor c=2.91423e-19 \
 //x=68.2 //y=0.175 //x2=69.865 //y2=1.675
cc_7612 ( N_GND_c_13181_n N_noxref_51_c_15278_n ) capacitor c=0.0113638f \
 //x=72.625 //y=0.175 //x2=70.75 //y2=0.71
cc_7613 ( N_GND_c_13102_n N_noxref_51_c_15278_n ) capacitor c=0.0374965f \
 //x=71.36 //y=0.175 //x2=70.75 //y2=0.71
cc_7614 ( N_GND_c_13293_n N_noxref_51_c_15278_n ) capacitor c=0.00199299f \
 //x=76.46 //y=0.175 //x2=70.75 //y2=0.71
cc_7615 ( N_GND_c_13181_n N_noxref_51_c_15313_n ) capacitor c=0.00251499f \
 //x=72.625 //y=0.175 //x2=70.835 //y2=0.795
cc_7616 ( N_GND_c_13102_n N_noxref_51_c_15313_n ) capacitor c=0.0144994f \
 //x=71.36 //y=0.175 //x2=70.835 //y2=0.795
cc_7617 ( N_GND_c_13172_n N_noxref_51_c_15313_n ) capacitor c=0.0528148f \
 //x=71.53 //y=0.175 //x2=70.835 //y2=0.795
cc_7618 ( N_GND_c_13145_n N_noxref_51_M41_noxref_s ) capacitor c=0.0045077f \
 //x=69.295 //y=0.175 //x2=68.76 //y2=0.545
cc_7619 ( N_GND_c_13087_n N_noxref_51_M41_noxref_s ) capacitor c=0.0251628f \
 //x=69.38 //y=1.015 //x2=68.76 //y2=0.545
cc_7620 ( N_GND_c_13102_n N_noxref_51_M41_noxref_s ) capacitor c=0.0144994f \
 //x=71.36 //y=0.175 //x2=68.76 //y2=0.545
cc_7621 ( N_GND_c_13115_n N_noxref_51_M41_noxref_s ) capacitor c=0.0536459f \
 //x=68.2 //y=0.175 //x2=68.76 //y2=0.545
cc_7622 ( N_GND_c_13172_n N_noxref_51_M41_noxref_s ) capacitor c=0.00291802f \
 //x=71.53 //y=0.175 //x2=68.76 //y2=0.545
cc_7623 ( N_GND_M41_noxref_d N_noxref_51_M41_noxref_s ) capacitor c=0.0296536f \
 //x=69.19 //y=1.045 //x2=68.76 //y2=0.545
cc_7624 ( N_GND_c_13181_n N_noxref_52_c_15326_n ) capacitor c=9.5216e-19 \
 //x=72.625 //y=0.175 //x2=73.11 //y2=1.76
cc_7625 ( N_GND_c_13184_n N_noxref_52_c_15326_n ) capacitor c=0.0048201f \
 //x=72.71 //y=1.02 //x2=73.11 //y2=1.76
cc_7626 ( N_GND_c_13147_n N_noxref_52_c_15326_n ) capacitor c=0.00204479f \
 //x=76.34 //y=0.18 //x2=73.11 //y2=1.76
cc_7627 ( N_GND_c_13157_n N_noxref_52_c_15326_n ) capacitor c=0.00357558f \
 //x=74.69 //y=0.175 //x2=73.11 //y2=1.76
cc_7628 ( N_GND_M43_noxref_d N_noxref_52_c_15326_n ) capacitor c=0.00579662f \
 //x=72.52 //y=1.045 //x2=73.11 //y2=1.76
cc_7629 ( N_GND_c_13184_n N_noxref_52_c_15374_n ) capacitor c=0.0167642f \
 //x=72.71 //y=1.02 //x2=73.195 //y2=0.795
cc_7630 ( N_GND_c_13147_n N_noxref_52_c_15374_n ) capacitor c=0.00310354f \
 //x=76.34 //y=0.18 //x2=73.195 //y2=0.795
cc_7631 ( N_GND_c_13157_n N_noxref_52_c_15374_n ) capacitor c=0.0144994f \
 //x=74.69 //y=0.175 //x2=73.195 //y2=0.795
cc_7632 ( N_GND_c_13172_n N_noxref_52_c_15374_n ) capacitor c=0.00225073f \
 //x=71.53 //y=0.175 //x2=73.195 //y2=0.795
cc_7633 ( N_GND_c_13173_n N_noxref_52_c_15374_n ) capacitor c=2.21767e-19 \
 //x=74.86 //y=0.175 //x2=73.195 //y2=0.795
cc_7634 ( N_GND_c_13172_n N_noxref_52_c_15327_n ) capacitor c=2.86225e-19 \
 //x=71.53 //y=0.175 //x2=73.195 //y2=1.675
cc_7635 ( N_GND_c_13147_n N_noxref_52_c_15331_n ) capacitor c=0.00939457f \
 //x=76.34 //y=0.18 //x2=74.08 //y2=0.71
cc_7636 ( N_GND_c_13157_n N_noxref_52_c_15331_n ) capacitor c=0.0375173f \
 //x=74.69 //y=0.175 //x2=74.08 //y2=0.71
cc_7637 ( N_GND_c_13293_n N_noxref_52_c_15331_n ) capacitor c=0.00199299f \
 //x=76.46 //y=0.175 //x2=74.08 //y2=0.71
cc_7638 ( N_GND_c_13147_n N_noxref_52_c_15383_n ) capacitor c=0.00326972f \
 //x=76.34 //y=0.18 //x2=74.165 //y2=0.795
cc_7639 ( N_GND_c_13157_n N_noxref_52_c_15383_n ) capacitor c=0.0144881f \
 //x=74.69 //y=0.175 //x2=74.165 //y2=0.795
cc_7640 ( N_GND_c_13891_p N_noxref_52_c_15383_n ) capacitor c=0.00211385f \
 //x=75.49 //y=0.63 //x2=74.165 //y2=0.795
cc_7641 ( N_GND_c_13173_n N_noxref_52_c_15383_n ) capacitor c=0.0406122f \
 //x=74.86 //y=0.175 //x2=74.165 //y2=0.795
cc_7642 ( N_GND_c_13181_n N_noxref_52_M43_noxref_s ) capacitor c=0.00251499f \
 //x=72.625 //y=0.175 //x2=72.09 //y2=0.545
cc_7643 ( N_GND_c_13184_n N_noxref_52_M43_noxref_s ) capacitor c=0.0250649f \
 //x=72.71 //y=1.02 //x2=72.09 //y2=0.545
cc_7644 ( N_GND_c_13157_n N_noxref_52_M43_noxref_s ) capacitor c=0.0144994f \
 //x=74.69 //y=0.175 //x2=72.09 //y2=0.545
cc_7645 ( N_GND_c_13172_n N_noxref_52_M43_noxref_s ) capacitor c=0.0528926f \
 //x=71.53 //y=0.175 //x2=72.09 //y2=0.545
cc_7646 ( N_GND_c_13173_n N_noxref_52_M43_noxref_s ) capacitor c=0.00580588f \
 //x=74.86 //y=0.175 //x2=72.09 //y2=0.545
cc_7647 ( N_GND_M43_noxref_d N_noxref_52_M43_noxref_s ) capacitor c=0.0272383f \
 //x=72.52 //y=1.045 //x2=72.09 //y2=0.545
cc_7648 ( N_GND_M45_noxref_s N_noxref_52_M43_noxref_s ) capacitor \
 c=0.00317066f //x=75.355 //y=0.55 //x2=72.09 //y2=0.545
cc_7649 ( N_noxref_32_c_14038_n N_noxref_33_c_14104_n ) capacitor \
 c=5.34352e-19 //x=6.965 //y=1.675 //x2=9.325 //y2=1.675
cc_7650 ( N_noxref_32_c_14091_n N_noxref_33_M5_noxref_s ) capacitor \
 c=0.0045327f //x=7.935 //y=0.795 //x2=9.19 //y2=0.545
cc_7651 ( N_noxref_32_M3_noxref_s N_noxref_33_M5_noxref_s ) capacitor \
 c=5.34352e-19 //x=5.86 //y=0.545 //x2=9.19 //y2=0.545
cc_7652 ( N_noxref_33_c_14112_n N_noxref_34_c_14173_n ) capacitor \
 c=5.34352e-19 //x=10.295 //y=1.675 //x2=12.655 //y2=1.675
cc_7653 ( N_noxref_33_c_14157_n N_noxref_34_M7_noxref_s ) capacitor \
 c=0.0045327f //x=11.265 //y=0.795 //x2=12.52 //y2=0.545
cc_7654 ( N_noxref_33_M5_noxref_s N_noxref_34_M7_noxref_s ) capacitor \
 c=5.34352e-19 //x=9.19 //y=0.545 //x2=12.52 //y2=0.545
cc_7655 ( N_noxref_34_c_14181_n N_noxref_35_c_14241_n ) capacitor \
 c=5.34352e-19 //x=13.625 //y=1.675 //x2=15.985 //y2=1.675
cc_7656 ( N_noxref_34_c_14225_n N_noxref_35_M9_noxref_s ) capacitor \
 c=0.0045327f //x=14.595 //y=0.795 //x2=15.85 //y2=0.545
cc_7657 ( N_noxref_34_M7_noxref_s N_noxref_35_M9_noxref_s ) capacitor \
 c=5.34352e-19 //x=12.52 //y=0.545 //x2=15.85 //y2=0.545
cc_7658 ( N_noxref_35_c_14249_n N_noxref_36_c_14311_n ) capacitor \
 c=5.34352e-19 //x=16.955 //y=1.675 //x2=19.315 //y2=1.675
cc_7659 ( N_noxref_35_c_14295_n N_noxref_36_M11_noxref_s ) capacitor \
 c=0.0045327f //x=17.925 //y=0.795 //x2=19.18 //y2=0.545
cc_7660 ( N_noxref_35_M9_noxref_s N_noxref_36_M11_noxref_s ) capacitor \
 c=5.34352e-19 //x=15.85 //y=0.545 //x2=19.18 //y2=0.545
cc_7661 ( N_noxref_36_c_14319_n N_noxref_37_c_14380_n ) capacitor \
 c=6.40432e-19 //x=20.285 //y=1.675 //x2=22.54 //y2=1.685
cc_7662 ( N_noxref_36_c_14364_n N_noxref_37_M13_noxref_s ) capacitor \
 c=0.00453771f //x=21.255 //y=0.795 //x2=22.405 //y2=0.555
cc_7663 ( N_noxref_36_M11_noxref_s N_noxref_37_M13_noxref_s ) capacitor \
 c=6.40432e-19 //x=19.18 //y=0.545 //x2=22.405 //y2=0.555
cc_7664 ( N_noxref_38_c_14439_n N_noxref_39_c_14507_n ) capacitor \
 c=5.34352e-19 //x=28.425 //y=1.675 //x2=30.785 //y2=1.675
cc_7665 ( N_noxref_38_c_14494_n N_noxref_39_M18_noxref_s ) capacitor \
 c=0.0045327f //x=29.395 //y=0.795 //x2=30.65 //y2=0.545
cc_7666 ( N_noxref_38_M16_noxref_s N_noxref_39_M18_noxref_s ) capacitor \
 c=5.34352e-19 //x=27.32 //y=0.545 //x2=30.65 //y2=0.545
cc_7667 ( N_noxref_39_c_14515_n N_noxref_40_c_14576_n ) capacitor \
 c=5.34352e-19 //x=31.755 //y=1.675 //x2=34.115 //y2=1.675
cc_7668 ( N_noxref_39_c_14560_n N_noxref_40_M20_noxref_s ) capacitor \
 c=0.0045327f //x=32.725 //y=0.795 //x2=33.98 //y2=0.545
cc_7669 ( N_noxref_39_M18_noxref_s N_noxref_40_M20_noxref_s ) capacitor \
 c=5.34352e-19 //x=30.65 //y=0.545 //x2=33.98 //y2=0.545
cc_7670 ( N_noxref_40_c_14584_n N_noxref_41_c_14644_n ) capacitor \
 c=5.34352e-19 //x=35.085 //y=1.675 //x2=37.445 //y2=1.675
cc_7671 ( N_noxref_40_c_14628_n N_noxref_41_M22_noxref_s ) capacitor \
 c=0.0045327f //x=36.055 //y=0.795 //x2=37.31 //y2=0.545
cc_7672 ( N_noxref_40_M20_noxref_s N_noxref_41_M22_noxref_s ) capacitor \
 c=5.34352e-19 //x=33.98 //y=0.545 //x2=37.31 //y2=0.545
cc_7673 ( N_noxref_41_c_14652_n N_noxref_42_c_14712_n ) capacitor \
 c=5.34352e-19 //x=38.415 //y=1.675 //x2=40.775 //y2=1.675
cc_7674 ( N_noxref_41_c_14696_n N_noxref_42_M24_noxref_s ) capacitor \
 c=0.0045327f //x=39.385 //y=0.795 //x2=40.64 //y2=0.545
cc_7675 ( N_noxref_41_M22_noxref_s N_noxref_42_M24_noxref_s ) capacitor \
 c=5.34352e-19 //x=37.31 //y=0.545 //x2=40.64 //y2=0.545
cc_7676 ( N_noxref_42_c_14720_n N_noxref_43_c_14790_n ) capacitor \
 c=6.40432e-19 //x=41.745 //y=1.675 //x2=44 //y2=1.685
cc_7677 ( N_noxref_42_c_14764_n N_noxref_43_M26_noxref_s ) capacitor \
 c=0.00453771f //x=42.715 //y=0.795 //x2=43.865 //y2=0.555
cc_7678 ( N_noxref_42_M24_noxref_s N_noxref_43_M26_noxref_s ) capacitor \
 c=6.40432e-19 //x=40.64 //y=0.545 //x2=43.865 //y2=0.555
cc_7679 ( N_noxref_44_c_14839_n N_noxref_45_c_14908_n ) capacitor \
 c=5.34352e-19 //x=49.885 //y=1.675 //x2=52.245 //y2=1.675
cc_7680 ( N_noxref_44_c_14895_n N_noxref_45_M31_noxref_s ) capacitor \
 c=0.0045327f //x=50.855 //y=0.795 //x2=52.11 //y2=0.545
cc_7681 ( N_noxref_44_M29_noxref_s N_noxref_45_M31_noxref_s ) capacitor \
 c=5.34352e-19 //x=48.78 //y=0.545 //x2=52.11 //y2=0.545
cc_7682 ( N_noxref_45_c_14916_n N_noxref_46_c_14977_n ) capacitor \
 c=5.34352e-19 //x=53.215 //y=1.675 //x2=55.575 //y2=1.675
cc_7683 ( N_noxref_45_c_14961_n N_noxref_46_M33_noxref_s ) capacitor \
 c=0.0045327f //x=54.185 //y=0.795 //x2=55.44 //y2=0.545
cc_7684 ( N_noxref_45_M31_noxref_s N_noxref_46_M33_noxref_s ) capacitor \
 c=5.34352e-19 //x=52.11 //y=0.545 //x2=55.44 //y2=0.545
cc_7685 ( N_noxref_46_c_14985_n N_noxref_47_c_15045_n ) capacitor \
 c=5.34352e-19 //x=56.545 //y=1.675 //x2=58.905 //y2=1.675
cc_7686 ( N_noxref_46_c_15029_n N_noxref_47_M35_noxref_s ) capacitor \
 c=0.0045327f //x=57.515 //y=0.795 //x2=58.77 //y2=0.545
cc_7687 ( N_noxref_46_M33_noxref_s N_noxref_47_M35_noxref_s ) capacitor \
 c=5.34352e-19 //x=55.44 //y=0.545 //x2=58.77 //y2=0.545
cc_7688 ( N_noxref_47_c_15053_n N_noxref_48_c_15115_n ) capacitor \
 c=5.34352e-19 //x=59.875 //y=1.675 //x2=62.235 //y2=1.675
cc_7689 ( N_noxref_47_c_15099_n N_noxref_48_M37_noxref_s ) capacitor \
 c=0.0045327f //x=60.845 //y=0.795 //x2=62.1 //y2=0.545
cc_7690 ( N_noxref_47_M35_noxref_s N_noxref_48_M37_noxref_s ) capacitor \
 c=5.34352e-19 //x=58.77 //y=0.545 //x2=62.1 //y2=0.545
cc_7691 ( N_noxref_48_c_15123_n N_noxref_49_c_15184_n ) capacitor \
 c=5.34352e-19 //x=63.205 //y=1.675 //x2=65.565 //y2=1.675
cc_7692 ( N_noxref_48_c_15168_n N_noxref_49_M39_noxref_s ) capacitor \
 c=0.00453248f //x=64.175 //y=0.795 //x2=65.43 //y2=0.545
cc_7693 ( N_noxref_48_M37_noxref_s N_noxref_49_M39_noxref_s ) capacitor \
 c=5.34352e-19 //x=62.1 //y=0.545 //x2=65.43 //y2=0.545
cc_7694 ( N_noxref_49_M39_noxref_s N_noxref_51_c_15262_n ) capacitor \
 c=0.00220044f //x=65.43 //y=0.545 //x2=68.895 //y2=1.675
cc_7695 ( N_noxref_49_c_15238_n N_noxref_51_M41_noxref_s ) capacitor \
 c=0.00220044f //x=67.505 //y=0.795 //x2=68.76 //y2=0.545
cc_7696 ( N_noxref_51_M41_noxref_s N_noxref_52_c_15339_n ) capacitor \
 c=0.00244933f //x=68.76 //y=0.545 //x2=72.225 //y2=1.675
cc_7697 ( N_noxref_51_c_15313_n N_noxref_52_M43_noxref_s ) capacitor \
 c=0.00244933f //x=70.835 //y=0.795 //x2=72.09 //y2=0.545
