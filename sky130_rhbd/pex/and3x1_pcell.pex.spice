// File: and3x1_pcell.spi.pex
// Created: Thu Jan 22 07:11:29 2026
// Program "Calibre xRC"
// Version "v2023.2_27.15"
// Nominal Temperature: 30C
// Circuit Temperature: 30C
//
simulator lang=spectre
subckt PM_AND3X1_PCELL\%noxref_1 ( 1 3 6 7 9 10 11 14 15 16 18 19 20 21 24 27 \
 33 36 39 43 44 49 52 60 68 85 94 98 99 100 101 102 103 104 108 109 110 112 \
 118 119 121 129 131 132 133 )
c227 ( 129 0 ) capacitor c=0.00885916f //x=3.395 //y=0.915
c228 ( 121 0 ) capacitor c=0.0569811f //x=5.55 //y=2.085
c229 ( 119 0 ) capacitor c=0.0439576f //x=6.19 //y=1.255
c230 ( 118 0 ) capacitor c=0.0201087f //x=6.19 //y=0.91
c231 ( 112 0 ) capacitor c=0.0161986f //x=6.035 //y=1.41
c232 ( 110 0 ) capacitor c=0.0157807f //x=6.035 //y=0.755
c233 ( 109 0 ) capacitor c=0.0556866f //x=5.78 //y=4.79
c234 ( 108 0 ) capacitor c=0.0406047f //x=6.07 //y=4.79
c235 ( 104 0 ) capacitor c=0.0301471f //x=5.66 //y=1.92
c236 ( 103 0 ) capacitor c=0.0255349f //x=5.66 //y=1.565
c237 ( 102 0 ) capacitor c=0.0234346f //x=5.66 //y=1.255
c238 ( 101 0 ) capacitor c=0.02013f //x=5.66 //y=0.91
c239 ( 100 0 ) capacitor c=0.153839f //x=6.145 //y=6.02
c240 ( 99 0 ) capacitor c=0.15434f //x=5.705 //y=6.02
c241 ( 94 0 ) capacitor c=9.45276e-19 //x=5.55 //y=4.7
c242 ( 85 0 ) capacitor c=9.11699e-19 //x=5.55 //y=2.085
c243 ( 68 0 ) capacitor c=0.029377f //x=3.29 //y=5.38
c244 ( 60 0 ) capacitor c=0.029443f //x=2.41 //y=5.38
c245 ( 52 0 ) capacitor c=0.0282179f //x=1.53 //y=5.38
c246 ( 49 0 ) capacitor c=0.00373909f //x=5.545 //y=3.33
c247 ( 44 0 ) capacitor c=0.00558853f //x=4.235 //y=3.33
c248 ( 43 0 ) capacitor c=0.0605416f //x=5.385 //y=3.33
c249 ( 39 0 ) capacitor c=0.0113197f //x=5.55 //y=2.085
c250 ( 36 0 ) capacitor c=0.0159865f //x=5.545 //y=3.33
c251 ( 33 0 ) capacitor c=0.0166464f //x=4.07 //y=3.33
c252 ( 27 0 ) capacitor c=0.00222577f //x=3.29 //y=5.155
c253 ( 24 0 ) capacitor c=0.0107124f //x=2.41 //y=5.155
c254 ( 21 0 ) capacitor c=0.0155037f //x=1.532 //y=5.155
c255 ( 20 0 ) capacitor c=0.0346503f //x=5.55 //y=4.58
c256 ( 19 0 ) capacitor c=0.0114509f //x=5.55 //y=3.49
c257 ( 18 0 ) capacitor c=0.0241146f //x=5.55 //y=3.17
c258 ( 16 0 ) capacitor c=0.0450113f //x=4.07 //y=5.07
c259 ( 15 0 ) capacitor c=0.0115252f //x=4.07 //y=3.49
c260 ( 14 0 ) capacitor c=0.038752f //x=4.07 //y=3.17
c261 ( 12 0 ) capacitor c=0.0083417f //x=3.67 //y=1.665
c262 ( 11 0 ) capacitor c=0.016015f //x=3.985 //y=1.665
c263 ( 10 0 ) capacitor c=0.0126012f //x=3.585 //y=1.58
c264 ( 9 0 ) capacitor c=0.0112322f //x=3.585 //y=1.125
c265 ( 7 0 ) capacitor c=0.0276489f //x=3.985 //y=5.155
c266 ( 6 0 ) capacitor c=0.00895521f //x=3.29 //y=5.38
c267 ( 3 0 ) capacitor c=0.0255081f //x=3.175 //y=5.155
c268 ( 1 0 ) capacitor c=0.0190573f //x=2.29 //y=5.155
r269 (  121 122 ) resistor r=17.5563 //w=0.302 //l=0.11 //layer=ply \
 //thickness=0.18 //x=5.55 //y=2.085 //x2=5.66 //y2=2.085
r270 (  119 128 ) resistor r=45.1352 //w=0.168 //l=0.173853 //layer=ply \
 //thickness=0.18 //x=6.19 //y=1.255 //x2=6.15 //y2=1.41
r271 (  118 127 ) resistor r=45.1352 //w=0.168 //l=0.173853 //layer=ply \
 //thickness=0.18 //x=6.19 //y=0.91 //x2=6.15 //y2=0.755
r272 (  118 119 ) resistor r=176.904 //w=0.094 //l=0.345 //layer=ply \
 //thickness=0.18 //x=6.19 //y=0.91 //x2=6.19 //y2=1.255
r273 (  113 126 ) resistor r=10.701 //w=0.21 //l=0.115 //layer=ply \
 //thickness=0.18 //x=5.815 //y=1.41 //x2=5.7 //y2=1.41
r274 (  112 128 ) resistor r=5.52526 //w=0.168 //l=0.115 //layer=ply \
 //thickness=0.18 //x=6.035 //y=1.41 //x2=6.15 //y2=1.41
r275 (  111 125 ) resistor r=5.52526 //w=0.168 //l=0.115 //layer=ply \
 //thickness=0.18 //x=5.815 //y=0.755 //x2=5.7 //y2=0.755
r276 (  110 127 ) resistor r=5.52526 //w=0.168 //l=0.115 //layer=ply \
 //thickness=0.18 //x=6.035 //y=0.755 //x2=6.15 //y2=0.755
r277 (  110 111 ) resistor r=112.809 //w=0.094 //l=0.22 //layer=ply \
 //thickness=0.18 //x=6.035 //y=0.755 //x2=5.815 //y2=0.755
r278 (  108 115 ) resistor r=26.9307 //w=0.15 //l=0.106066 //layer=ply \
 //thickness=0.18 //x=6.07 //y=4.79 //x2=6.145 //y2=4.865
r279 (  108 109 ) resistor r=148.702 //w=0.094 //l=0.29 //layer=ply \
 //thickness=0.18 //x=6.07 //y=4.79 //x2=5.78 //y2=4.79
r280 (  105 109 ) resistor r=23.403 //w=0.284 //l=0.106066 //layer=ply \
 //thickness=0.18 //x=5.705 //y=4.865 //x2=5.78 //y2=4.79
r281 (  105 124 ) resistor r=26.3063 //w=0.284 //l=0.229783 //layer=ply \
 //thickness=0.18 //x=5.705 //y=4.865 //x2=5.55 //y2=4.7
r282 (  104 122 ) resistor r=19.1248 //w=0.302 //l=0.165 //layer=ply \
 //thickness=0.18 //x=5.66 //y=1.92 //x2=5.66 //y2=2.085
r283 (  103 126 ) resistor r=39.5823 //w=0.21 //l=0.173853 //layer=ply \
 //thickness=0.18 //x=5.66 //y=1.565 //x2=5.7 //y2=1.41
r284 (  103 104 ) resistor r=182.032 //w=0.094 //l=0.355 //layer=ply \
 //thickness=0.18 //x=5.66 //y=1.565 //x2=5.66 //y2=1.92
r285 (  102 126 ) resistor r=39.5823 //w=0.21 //l=0.173853 //layer=ply \
 //thickness=0.18 //x=5.66 //y=1.255 //x2=5.7 //y2=1.41
r286 (  101 125 ) resistor r=45.1352 //w=0.168 //l=0.173853 //layer=ply \
 //thickness=0.18 //x=5.66 //y=0.91 //x2=5.7 //y2=0.755
r287 (  101 102 ) resistor r=176.904 //w=0.094 //l=0.345 //layer=ply \
 //thickness=0.18 //x=5.66 //y=0.91 //x2=5.66 //y2=1.255
r288 (  100 115 ) resistor r=592.245 //w=0.094 //l=1.155 //layer=ply \
 //thickness=0.18 //x=6.145 //y=6.02 //x2=6.145 //y2=4.865
r289 (  99 105 ) resistor r=592.245 //w=0.094 //l=1.155 //layer=ply \
 //thickness=0.18 //x=5.705 //y=6.02 //x2=5.705 //y2=4.865
r290 (  98 112 ) resistor r=56.4043 //w=0.094 //l=0.11 //layer=ply \
 //thickness=0.18 //x=5.925 //y=1.41 //x2=6.035 //y2=1.41
r291 (  98 113 ) resistor r=56.4043 //w=0.094 //l=0.11 //layer=ply \
 //thickness=0.18 //x=5.925 //y=1.41 //x2=5.815 //y2=1.41
r292 (  94 124 ) resistor r=152 //w=0.17 //l=0.17 //layer=licon //count=1 \
 //x=5.55 //y=4.7 //x2=5.55 //y2=4.7
r293 (  85 121 ) resistor r=152 //w=0.17 //l=0.17 //layer=licon //count=1 \
 //x=5.55 //y=2.085 //x2=5.55 //y2=2.085
r294 (  68 133 ) resistor r=23.615 //w=0.187 //l=0.345 //layer=li \
 //thickness=0.1 //x=3.29 //y=5.38 //x2=3.29 //y2=5.725
r295 (  60 132 ) resistor r=23.615 //w=0.187 //l=0.345 //layer=li \
 //thickness=0.1 //x=2.41 //y=5.38 //x2=2.41 //y2=5.725
r296 (  52 131 ) resistor r=23.615 //w=0.187 //l=0.345 //layer=li \
 //thickness=0.1 //x=1.53 //y=5.38 //x2=1.53 //y2=5.725
r297 (  44 46 ) resistor r=0.10734 //w=0.281 //l=0.16 //layer=m2 \
 //thickness=0.36 //x=4.235 //y=3.33 //x2=4.075 //y2=3.33
r298 (  43 49 ) resistor r=0.10734 //w=0.281 //l=0.16 //layer=m2 \
 //thickness=0.36 //x=5.385 //y=3.33 //x2=5.545 //y2=3.33
r299 (  43 44 ) resistor r=1.09733 //w=0.131 //l=1.15 //layer=m2 \
 //thickness=0.36 //x=5.385 //y=3.33 //x2=4.235 //y2=3.33
r300 (  42 94 ) resistor r=9.3 //w=0.17 //l=0.17 //layer=mcon //count=1 \
 //x=5.55 //y=4.7 //x2=5.55 //y2=4.7
r301 (  39 85 ) resistor r=9.3 //w=0.17 //l=0.17 //layer=mcon //count=1 \
 //x=5.55 //y=2.085 //x2=5.55 //y2=2.085
r302 (  36 49 ) resistor r=4.5 //w=0.15 //l=0.15 //layer=via1 //count=1 \
 //x=5.545 //y=3.33 //x2=5.545 //y2=3.33
r303 (  33 46 ) resistor r=4.5 //w=0.15 //l=0.15 //layer=via1 //count=1 \
 //x=4.075 //y=3.33 //x2=4.075 //y2=3.33
r304 (  31 129 ) resistor r=9.3 //w=0.17 //l=0.17 //layer=mcon //count=1 \
 //x=3.585 //y=1.01 //x2=3.585 //y2=1.01
r305 (  29 68 ) resistor r=9.3 //w=0.17 //l=0.17 //layer=mcon //count=1 \
 //x=3.29 //y=5.38 //x2=3.29 //y2=5.38
r306 (  26 60 ) resistor r=9.3 //w=0.17 //l=0.17 //layer=mcon //count=1 \
 //x=2.41 //y=5.38 //x2=2.41 //y2=5.38
r307 (  24 26 ) resistor r=0.121228 //w=0.232 //l=0.225 //layer=m1 \
 //thickness=0.36 //x=2.41 //y=5.155 //x2=2.41 //y2=5.38
r308 (  23 52 ) resistor r=9.3 //w=0.17 //l=0.17 //layer=mcon //count=1 \
 //x=1.53 //y=5.38 //x2=1.53 //y2=5.38
r309 (  21 23 ) resistor r=0.129608 //w=0.217 //l=0.225 //layer=m1 \
 //thickness=0.36 //x=1.532 //y=5.155 //x2=1.532 //y2=5.38
r310 (  20 42 ) resistor r=0.0732479 //w=0.241 //l=0.122474 //layer=m1 \
 //thickness=0.36 //x=5.55 //y=4.58 //x2=5.555 //y2=4.7
r311 (  19 36 ) resistor r=0.0910802 //w=0.374 //l=0.185472 //layer=m1 \
 //thickness=0.36 //x=5.55 //y=3.49 //x2=5.495 //y2=3.33
r312 (  19 20 ) resistor r=1.04008 //w=0.131 //l=1.09 //layer=m1 \
 //thickness=0.36 //x=5.55 //y=3.49 //x2=5.55 //y2=4.58
r313 (  18 36 ) resistor r=0.0910802 //w=0.374 //l=0.185472 //layer=m1 \
 //thickness=0.36 //x=5.55 //y=3.17 //x2=5.495 //y2=3.33
r314 (  17 39 ) resistor r=0.116051 //w=0.211 //l=0.165 //layer=m1 \
 //thickness=0.36 //x=5.55 //y=2.25 //x2=5.55 //y2=2.085
r315 (  17 18 ) resistor r=0.877863 //w=0.131 //l=0.92 //layer=m1 \
 //thickness=0.36 //x=5.55 //y=2.25 //x2=5.55 //y2=3.17
r316 (  15 33 ) resistor r=0.0910802 //w=0.374 //l=0.185472 //layer=m1 \
 //thickness=0.36 //x=4.07 //y=3.49 //x2=4.125 //y2=3.33
r317 (  15 16 ) resistor r=1.50763 //w=0.131 //l=1.58 //layer=m1 \
 //thickness=0.36 //x=4.07 //y=3.49 //x2=4.07 //y2=5.07
r318 (  14 33 ) resistor r=0.0910802 //w=0.374 //l=0.185472 //layer=m1 \
 //thickness=0.36 //x=4.07 //y=3.17 //x2=4.125 //y2=3.33
r319 (  13 14 ) resistor r=1.35496 //w=0.131 //l=1.42 //layer=m1 \
 //thickness=0.36 //x=4.07 //y=1.75 //x2=4.07 //y2=3.17
r320 (  11 13 ) resistor r=0.0698411 //w=0.17 //l=0.120208 //layer=m1 \
 //thickness=0.36 //x=3.985 //y=1.665 //x2=4.07 //y2=1.75
r321 (  11 12 ) resistor r=0.300573 //w=0.131 //l=0.315 //layer=m1 \
 //thickness=0.36 //x=3.985 //y=1.665 //x2=3.67 //y2=1.665
r322 (  10 12 ) resistor r=0.0698411 //w=0.17 //l=0.120208 //layer=m1 \
 //thickness=0.36 //x=3.585 //y=1.58 //x2=3.67 //y2=1.665
r323 (  9 31 ) resistor r=0.0717383 //w=0.224 //l=0.115 //layer=m1 \
 //thickness=0.36 //x=3.585 //y=1.125 //x2=3.585 //y2=1.01
r324 (  9 10 ) resistor r=0.43416 //w=0.131 //l=0.455 //layer=m1 \
 //thickness=0.36 //x=3.585 //y=1.125 //x2=3.585 //y2=1.58
r325 (  8 27 ) resistor r=0.0675342 //w=0.23 //l=0.115 //layer=m1 \
 //thickness=0.36 //x=3.405 //y=5.155 //x2=3.29 //y2=5.155
r326 (  7 16 ) resistor r=0.0698411 //w=0.17 //l=0.120208 //layer=m1 \
 //thickness=0.36 //x=3.985 //y=5.155 //x2=4.07 //y2=5.07
r327 (  7 8 ) resistor r=0.553435 //w=0.131 //l=0.58 //layer=m1 \
 //thickness=0.36 //x=3.985 //y=5.155 //x2=3.405 //y2=5.155
r328 (  6 29 ) resistor r=0.00118313 //w=0.23 //layer=m1 //thickness=0.36 \
 //x=3.29 //y=5.38 //x2=3.29 //y2=5.38
r329 (  5 27 ) resistor r=0.002872 //w=0.34 //l=0.085 //layer=m1 \
 //thickness=0.36 //x=3.29 //y=5.24 //x2=3.29 //y2=5.155
r330 (  5 6 ) resistor r=0.091623 //w=0.191 //l=0.14 //layer=m1 \
 //thickness=0.36 //x=3.29 //y=5.24 //x2=3.29 //y2=5.38
r331 (  4 24 ) resistor r=0.0262263 //w=0.232 //l=0.12 //layer=m1 \
 //thickness=0.36 //x=2.53 //y=5.155 //x2=2.41 //y2=5.155
r332 (  3 27 ) resistor r=0.0675342 //w=0.23 //l=0.115 //layer=m1 \
 //thickness=0.36 //x=3.175 //y=5.155 //x2=3.29 //y2=5.155
r333 (  3 4 ) resistor r=0.615458 //w=0.131 //l=0.645 //layer=m1 \
 //thickness=0.36 //x=3.175 //y=5.155 //x2=2.53 //y2=5.155
r334 (  2 21 ) resistor r=0.0222262 //w=0.217 //l=0.118 //layer=m1 \
 //thickness=0.36 //x=1.65 //y=5.155 //x2=1.532 //y2=5.155
r335 (  1 24 ) resistor r=0.0262263 //w=0.232 //l=0.12 //layer=m1 \
 //thickness=0.36 //x=2.29 //y=5.155 //x2=2.41 //y2=5.155
r336 (  1 2 ) resistor r=0.610687 //w=0.131 //l=0.64 //layer=m1 \
 //thickness=0.36 //x=2.29 //y=5.155 //x2=1.65 //y2=5.155
ends PM_AND3X1_PCELL\%noxref_1

subckt PM_AND3X1_PCELL\%noxref_2 ( 13 26 35 45 53 63 79 97 101 102 103 104 105 \
 106 107 )
c104 ( 107 0 ) capacitor c=0.0632165f //x=6.22 //y=5.02
c105 ( 106 0 ) capacitor c=0.0587007f //x=5.35 //y=5.02
c106 ( 105 0 ) capacitor c=0.0466888f //x=3.585 //y=5.02
c107 ( 104 0 ) capacitor c=0.0256172f //x=2.705 //y=5.02
c108 ( 103 0 ) capacitor c=0.0256111f //x=1.825 //y=5.02
c109 ( 102 0 ) capacitor c=0.0696958f //x=0.955 //y=5.02
c110 ( 101 0 ) capacitor c=0.240661f //x=6.29 //y=7.4
c111 ( 99 0 ) capacitor c=0.00591168f //x=5.55 //y=7.4
c112 ( 97 0 ) capacitor c=0.140667f //x=4.81 //y=7.4
c113 ( 96 0 ) capacitor c=0.00591168f //x=3.73 //y=7.4
c114 ( 95 0 ) capacitor c=0.00591168f //x=2.85 //y=7.4
c115 ( 94 0 ) capacitor c=0.00591168f //x=1.97 //y=7.4
c116 ( 93 0 ) capacitor c=0.00591168f //x=1.09 //y=7.4
c117 ( 79 0 ) capacitor c=0.028723f //x=6.28 //y=7.4
c118 ( 69 0 ) capacitor c=0.0216067f //x=5.4 //y=7.4
c119 ( 63 0 ) capacitor c=0.0419403f //x=4.64 //y=7.4
c120 ( 53 0 ) capacitor c=0.0286174f //x=3.645 //y=7.4
c121 ( 45 0 ) capacitor c=0.0286648f //x=2.765 //y=7.4
c122 ( 35 0 ) capacitor c=0.0287602f //x=1.885 //y=7.4
c123 ( 26 0 ) capacitor c=0.235596f //x=0.74 //y=7.4
c124 ( 23 0 ) capacitor c=0.0452081f //x=1.005 //y=7.4
c125 ( 13 0 ) capacitor c=0.282663f //x=6.29 //y=7.4
r126 (  81 101 ) resistor r=4.11603 //w=0.68 //l=0.17 //layer=li \
 //thickness=0.1 //x=6.365 //y=7.23 //x2=6.365 //y2=7.4
r127 (  81 107 ) resistor r=56.4706 //w=0.187 //l=0.825 //layer=li \
 //thickness=0.1 //x=6.365 //y=7.23 //x2=6.365 //y2=6.405
r128 (  80 99 ) resistor r=2.94794 //w=0.34 //l=0.085 //layer=li \
 //thickness=0.1 //x=5.57 //y=7.4 //x2=5.485 //y2=7.4
r129 (  79 101 ) resistor r=2.94794 //w=0.34 //l=0.085 //layer=li \
 //thickness=0.1 //x=6.28 //y=7.4 //x2=6.365 //y2=7.4
r130 (  79 80 ) resistor r=25.4566 //w=0.357 //l=0.71 //layer=li \
 //thickness=0.1 //x=6.28 //y=7.4 //x2=5.57 //y2=7.4
r131 (  71 99 ) resistor r=4.11603 //w=0.68 //l=0.17 //layer=li \
 //thickness=0.1 //x=5.485 //y=7.23 //x2=5.485 //y2=7.4
r132 (  71 106 ) resistor r=56.4706 //w=0.187 //l=0.825 //layer=li \
 //thickness=0.1 //x=5.485 //y=7.23 //x2=5.485 //y2=6.405
r133 (  70 97 ) resistor r=5.4201 //w=0.34 //l=0.17 //layer=li //thickness=0.1 \
 //x=4.98 //y=7.4 //x2=4.81 //y2=7.4
r134 (  69 99 ) resistor r=2.94794 //w=0.34 //l=0.085 //layer=li \
 //thickness=0.1 //x=5.4 //y=7.4 //x2=5.485 //y2=7.4
r135 (  69 70 ) resistor r=15.0588 //w=0.357 //l=0.42 //layer=li \
 //thickness=0.1 //x=5.4 //y=7.4 //x2=4.98 //y2=7.4
r136 (  64 96 ) resistor r=2.94794 //w=0.34 //l=0.085 //layer=li \
 //thickness=0.1 //x=3.815 //y=7.4 //x2=3.73 //y2=7.4
r137 (  64 66 ) resistor r=9.14286 //w=0.357 //l=0.255 //layer=li \
 //thickness=0.1 //x=3.815 //y=7.4 //x2=4.07 //y2=7.4
r138 (  63 97 ) resistor r=5.4201 //w=0.34 //l=0.17 //layer=li //thickness=0.1 \
 //x=4.64 //y=7.4 //x2=4.81 //y2=7.4
r139 (  63 66 ) resistor r=20.437 //w=0.357 //l=0.57 //layer=li \
 //thickness=0.1 //x=4.64 //y=7.4 //x2=4.07 //y2=7.4
r140 (  57 96 ) resistor r=4.11603 //w=0.68 //l=0.17 //layer=li \
 //thickness=0.1 //x=3.73 //y=7.23 //x2=3.73 //y2=7.4
r141 (  57 105 ) resistor r=33.1979 //w=0.187 //l=0.485 //layer=li \
 //thickness=0.1 //x=3.73 //y=7.23 //x2=3.73 //y2=6.745
r142 (  54 95 ) resistor r=2.94794 //w=0.34 //l=0.085 //layer=li \
 //thickness=0.1 //x=2.935 //y=7.4 //x2=2.85 //y2=7.4
r143 (  54 56 ) resistor r=0.896359 //w=0.357 //l=0.025 //layer=li \
 //thickness=0.1 //x=2.935 //y=7.4 //x2=2.96 //y2=7.4
r144 (  53 96 ) resistor r=2.94794 //w=0.34 //l=0.085 //layer=li \
 //thickness=0.1 //x=3.645 //y=7.4 //x2=3.73 //y2=7.4
r145 (  53 56 ) resistor r=24.5602 //w=0.357 //l=0.685 //layer=li \
 //thickness=0.1 //x=3.645 //y=7.4 //x2=2.96 //y2=7.4
r146 (  47 95 ) resistor r=4.11603 //w=0.68 //l=0.17 //layer=li \
 //thickness=0.1 //x=2.85 //y=7.23 //x2=2.85 //y2=7.4
r147 (  47 104 ) resistor r=33.1979 //w=0.187 //l=0.485 //layer=li \
 //thickness=0.1 //x=2.85 //y=7.23 //x2=2.85 //y2=6.745
r148 (  46 94 ) resistor r=2.94794 //w=0.34 //l=0.085 //layer=li \
 //thickness=0.1 //x=2.055 //y=7.4 //x2=1.97 //y2=7.4
r149 (  45 95 ) resistor r=2.94794 //w=0.34 //l=0.085 //layer=li \
 //thickness=0.1 //x=2.765 //y=7.4 //x2=2.85 //y2=7.4
r150 (  45 46 ) resistor r=25.4566 //w=0.357 //l=0.71 //layer=li \
 //thickness=0.1 //x=2.765 //y=7.4 //x2=2.055 //y2=7.4
r151 (  39 94 ) resistor r=4.11603 //w=0.68 //l=0.17 //layer=li \
 //thickness=0.1 //x=1.97 //y=7.23 //x2=1.97 //y2=7.4
r152 (  39 103 ) resistor r=33.1979 //w=0.187 //l=0.485 //layer=li \
 //thickness=0.1 //x=1.97 //y=7.23 //x2=1.97 //y2=6.745
r153 (  36 93 ) resistor r=2.94794 //w=0.34 //l=0.085 //layer=li \
 //thickness=0.1 //x=1.175 //y=7.4 //x2=1.09 //y2=7.4
r154 (  36 38 ) resistor r=24.2017 //w=0.357 //l=0.675 //layer=li \
 //thickness=0.1 //x=1.175 //y=7.4 //x2=1.85 //y2=7.4
r155 (  35 94 ) resistor r=2.94794 //w=0.34 //l=0.085 //layer=li \
 //thickness=0.1 //x=1.885 //y=7.4 //x2=1.97 //y2=7.4
r156 (  35 38 ) resistor r=1.2549 //w=0.357 //l=0.035 //layer=li \
 //thickness=0.1 //x=1.885 //y=7.4 //x2=1.85 //y2=7.4
r157 (  27 93 ) resistor r=4.11603 //w=0.68 //l=0.17 //layer=li \
 //thickness=0.1 //x=1.09 //y=7.23 //x2=1.09 //y2=7.4
r158 (  27 102 ) resistor r=56.4706 //w=0.187 //l=0.825 //layer=li \
 //thickness=0.1 //x=1.09 //y=7.23 //x2=1.09 //y2=6.405
r159 (  23 93 ) resistor r=2.94794 //w=0.34 //l=0.085 //layer=li \
 //thickness=0.1 //x=1.005 //y=7.4 //x2=1.09 //y2=7.4
r160 (  23 26 ) resistor r=9.5014 //w=0.357 //l=0.265 //layer=li \
 //thickness=0.1 //x=1.005 //y=7.4 //x2=0.74 //y2=7.4
r161 (  13 101 ) resistor r=4.65 //w=0.17 //l=0.34 //layer=mcon //count=2 \
 //x=6.29 //y=7.4 //x2=6.29 //y2=7.4
r162 (  11 99 ) resistor r=3.1 //w=0.17 //l=0.51 //layer=mcon //count=3 \
 //x=5.55 //y=7.4 //x2=5.55 //y2=7.4
r163 (  11 13 ) resistor r=0.307309 //w=0.301 //l=0.74 //layer=m1 \
 //thickness=0.36 //x=5.55 //y=7.4 //x2=6.29 //y2=7.4
r164 (  9 66 ) resistor r=3.1 //w=0.17 //l=0.51 //layer=mcon //count=3 \
 //x=4.07 //y=7.4 //x2=4.07 //y2=7.4
r165 (  9 11 ) resistor r=0.614618 //w=0.301 //l=1.48 //layer=m1 \
 //thickness=0.36 //x=4.07 //y=7.4 //x2=5.55 //y2=7.4
r166 (  7 56 ) resistor r=3.1 //w=0.17 //l=0.51 //layer=mcon //count=3 \
 //x=2.96 //y=7.4 //x2=2.96 //y2=7.4
r167 (  7 9 ) resistor r=0.460963 //w=0.301 //l=1.11 //layer=m1 \
 //thickness=0.36 //x=2.96 //y=7.4 //x2=4.07 //y2=7.4
r168 (  5 38 ) resistor r=3.1 //w=0.17 //l=0.51 //layer=mcon //count=3 \
 //x=1.85 //y=7.4 //x2=1.85 //y2=7.4
r169 (  5 7 ) resistor r=0.460963 //w=0.301 //l=1.11 //layer=m1 \
 //thickness=0.36 //x=1.85 //y=7.4 //x2=2.96 //y2=7.4
r170 (  2 26 ) resistor r=3.1 //w=0.17 //l=0.51 //layer=mcon //count=3 \
 //x=0.74 //y=7.4 //x2=0.74 //y2=7.4
r171 (  2 5 ) resistor r=0.460963 //w=0.301 //l=1.11 //layer=m1 \
 //thickness=0.36 //x=0.74 //y=7.4 //x2=1.85 //y2=7.4
ends PM_AND3X1_PCELL\%noxref_2

subckt PM_AND3X1_PCELL\%noxref_3 ( 1 6 17 20 25 28 45 50 54 66 73 80 81 )
c127 ( 81 0 ) capacitor c=0.0650789f //x=5.305 //y=0.37
c128 ( 80 0 ) capacitor c=0.00840423f //x=0.885 //y=0.875
c129 ( 73 0 ) capacitor c=0.239201f //x=6.41 //y=0
c130 ( 66 0 ) capacitor c=0.11387f //x=4.81 //y=0
c131 ( 57 0 ) capacitor c=0.00589014f //x=6.41 //y=0.45
c132 ( 54 0 ) capacitor c=0.00625302f //x=6.325 //y=0.535
c133 ( 53 0 ) capacitor c=0.00479851f //x=5.92 //y=0.45
c134 ( 50 0 ) capacitor c=0.00647872f //x=5.835 //y=0.535
c135 ( 45 0 ) capacitor c=0.00590583f //x=5.44 //y=0.45
c136 ( 42 0 ) capacitor c=0.0189058f //x=5.355 //y=0
c137 ( 28 0 ) capacitor c=0.178393f //x=0.74 //y=0
c138 ( 25 0 ) capacitor c=0.177538f //x=4.64 //y=0
c139 ( 22 0 ) capacitor c=0.00509083f //x=1.075 //y=0
c140 ( 20 0 ) capacitor c=0.0165426f //x=1.075 //y=0.965
c141 ( 17 0 ) capacitor c=0.20454f //x=6.29 //y=0
c142 ( 6 0 ) capacitor c=0.0302305f //x=1.075 //y=0.835
c143 ( 1 0 ) capacitor c=0.0533996f //x=0.99 //y=0
r144 (  72 73 ) resistor r=4.30252 //w=0.357 //l=0.12 //layer=li \
 //thickness=0.1 //x=6.29 //y=0 //x2=6.41 //y2=0
r145 (  70 72 ) resistor r=13.2661 //w=0.357 //l=0.37 //layer=li \
 //thickness=0.1 //x=5.92 //y=0 //x2=6.29 //y2=0
r146 (  69 70 ) resistor r=13.2661 //w=0.357 //l=0.37 //layer=li \
 //thickness=0.1 //x=5.55 //y=0 //x2=5.92 //y2=0
r147 (  67 69 ) resistor r=3.94398 //w=0.357 //l=0.11 //layer=li \
 //thickness=0.1 //x=5.44 //y=0 //x2=5.55 //y2=0
r148 (  58 81 ) resistor r=5.4201 //w=0.17 //l=0.085 //layer=li \
 //thickness=0.1 //x=6.41 //y=0.62 //x2=6.41 //y2=0.535
r149 (  58 81 ) resistor r=41.4118 //w=0.187 //l=0.605 //layer=li \
 //thickness=0.1 //x=6.41 //y=0.62 //x2=6.41 //y2=1.225
r150 (  57 81 ) resistor r=5.4201 //w=0.17 //l=0.085 //layer=li \
 //thickness=0.1 //x=6.41 //y=0.45 //x2=6.41 //y2=0.535
r151 (  56 73 ) resistor r=5.03728 //w=0.34 //l=0.17 //layer=li \
 //thickness=0.1 //x=6.41 //y=0.17 //x2=6.41 //y2=0
r152 (  56 57 ) resistor r=19.1658 //w=0.187 //l=0.28 //layer=li \
 //thickness=0.1 //x=6.41 //y=0.17 //x2=6.41 //y2=0.45
r153 (  55 81 ) resistor r=5.4201 //w=0.17 //l=0.085 //layer=li \
 //thickness=0.1 //x=6.005 //y=0.535 //x2=5.92 //y2=0.535
r154 (  54 81 ) resistor r=1.40859 //w=0.34 //l=0.085 //layer=li \
 //thickness=0.1 //x=6.325 //y=0.535 //x2=6.41 //y2=0.535
r155 (  54 55 ) resistor r=21.9037 //w=0.187 //l=0.32 //layer=li \
 //thickness=0.1 //x=6.325 //y=0.535 //x2=6.005 //y2=0.535
r156 (  53 81 ) resistor r=1.40859 //w=0.34 //l=0.085 //layer=li \
 //thickness=0.1 //x=5.92 //y=0.45 //x2=5.92 //y2=0.535
r157 (  52 70 ) resistor r=5.03728 //w=0.34 //l=0.17 //layer=li \
 //thickness=0.1 //x=5.92 //y=0.17 //x2=5.92 //y2=0
r158 (  52 53 ) resistor r=19.1658 //w=0.187 //l=0.28 //layer=li \
 //thickness=0.1 //x=5.92 //y=0.17 //x2=5.92 //y2=0.45
r159 (  51 81 ) resistor r=1.40859 //w=0.34 //l=0.085 //layer=li \
 //thickness=0.1 //x=5.525 //y=0.535 //x2=5.44 //y2=0.535
r160 (  50 81 ) resistor r=5.4201 //w=0.17 //l=0.085 //layer=li \
 //thickness=0.1 //x=5.835 //y=0.535 //x2=5.92 //y2=0.535
r161 (  50 51 ) resistor r=21.2193 //w=0.187 //l=0.31 //layer=li \
 //thickness=0.1 //x=5.835 //y=0.535 //x2=5.525 //y2=0.535
r162 (  46 81 ) resistor r=5.4201 //w=0.17 //l=0.085 //layer=li \
 //thickness=0.1 //x=5.44 //y=0.62 //x2=5.44 //y2=0.535
r163 (  46 81 ) resistor r=41.4118 //w=0.187 //l=0.605 //layer=li \
 //thickness=0.1 //x=5.44 //y=0.62 //x2=5.44 //y2=1.225
r164 (  45 81 ) resistor r=5.4201 //w=0.17 //l=0.085 //layer=li \
 //thickness=0.1 //x=5.44 //y=0.45 //x2=5.44 //y2=0.535
r165 (  44 67 ) resistor r=5.03728 //w=0.34 //l=0.17 //layer=li \
 //thickness=0.1 //x=5.44 //y=0.17 //x2=5.44 //y2=0
r166 (  44 45 ) resistor r=19.1658 //w=0.187 //l=0.28 //layer=li \
 //thickness=0.1 //x=5.44 //y=0.17 //x2=5.44 //y2=0.45
r167 (  43 66 ) resistor r=5.4201 //w=0.34 //l=0.17 //layer=li //thickness=0.1 \
 //x=4.98 //y=0 //x2=4.81 //y2=0
r168 (  42 67 ) resistor r=3.04762 //w=0.357 //l=0.085 //layer=li \
 //thickness=0.1 //x=5.355 //y=0 //x2=5.44 //y2=0
r169 (  42 43 ) resistor r=13.4454 //w=0.357 //l=0.375 //layer=li \
 //thickness=0.1 //x=5.355 //y=0 //x2=4.98 //y2=0
r170 (  32 34 ) resistor r=39.7983 //w=0.357 //l=1.11 //layer=li \
 //thickness=0.1 //x=2.96 //y=0 //x2=4.07 //y2=0
r171 (  30 32 ) resistor r=39.7983 //w=0.357 //l=1.11 //layer=li \
 //thickness=0.1 //x=1.85 //y=0 //x2=2.96 //y2=0
r172 (  28 30 ) resistor r=39.7983 //w=0.357 //l=1.11 //layer=li \
 //thickness=0.1 //x=0.74 //y=0 //x2=1.85 //y2=0
r173 (  25 66 ) resistor r=5.4201 //w=0.34 //l=0.17 //layer=li //thickness=0.1 \
 //x=4.64 //y=0 //x2=4.81 //y2=0
r174 (  25 34 ) resistor r=20.437 //w=0.357 //l=0.57 //layer=li \
 //thickness=0.1 //x=4.64 //y=0 //x2=4.07 //y2=0
r175 (  20 80 ) resistor r=9.3 //w=0.17 //l=0.17 //layer=mcon //count=1 \
 //x=1.075 //y=0.965 //x2=1.075 //y2=0.965
r176 (  17 72 ) resistor r=4.65 //w=0.17 //l=0.34 //layer=mcon //count=2 \
 //x=6.29 //y=0 //x2=6.29 //y2=0
r177 (  15 69 ) resistor r=3.1 //w=0.17 //l=0.51 //layer=mcon //count=3 \
 //x=5.55 //y=0 //x2=5.55 //y2=0
r178 (  15 17 ) resistor r=0.307309 //w=0.301 //l=0.74 //layer=m1 \
 //thickness=0.36 //x=5.55 //y=0 //x2=6.29 //y2=0
r179 (  13 34 ) resistor r=3.1 //w=0.17 //l=0.51 //layer=mcon //count=3 \
 //x=4.07 //y=0 //x2=4.07 //y2=0
r180 (  13 15 ) resistor r=0.614618 //w=0.301 //l=1.48 //layer=m1 \
 //thickness=0.36 //x=4.07 //y=0 //x2=5.55 //y2=0
r181 (  11 32 ) resistor r=3.1 //w=0.17 //l=0.51 //layer=mcon //count=3 \
 //x=2.96 //y=0 //x2=2.96 //y2=0
r182 (  11 13 ) resistor r=0.460963 //w=0.301 //l=1.11 //layer=m1 \
 //thickness=0.36 //x=2.96 //y=0 //x2=4.07 //y2=0
r183 (  9 30 ) resistor r=3.1 //w=0.17 //l=0.51 //layer=mcon //count=3 \
 //x=1.85 //y=0 //x2=1.85 //y2=0
r184 (  9 11 ) resistor r=0.460963 //w=0.301 //l=1.11 //layer=m1 \
 //thickness=0.36 //x=1.85 //y=0 //x2=2.96 //y2=0
r185 (  7 22 ) resistor r=0.0287885 //w=0.34 //l=0.085 //layer=m1 \
 //thickness=0.36 //x=1.16 //y=0 //x2=1.075 //y2=0
r186 (  7 9 ) resistor r=0.286545 //w=0.301 //l=0.69 //layer=m1 \
 //thickness=0.36 //x=1.16 //y=0 //x2=1.85 //y2=0
r187 (  6 20 ) resistor r=0.0942778 //w=0.221 //l=0.13 //layer=m1 \
 //thickness=0.36 //x=1.075 //y=0.835 //x2=1.075 //y2=0.965
r188 (  5 22 ) resistor r=0.0401957 //w=0.68 //l=0.17 //layer=m1 \
 //thickness=0.36 //x=1.075 //y=0.17 //x2=1.075 //y2=0
r189 (  5 6 ) resistor r=0.634542 //w=0.131 //l=0.665 //layer=m1 \
 //thickness=0.36 //x=1.075 //y=0.17 //x2=1.075 //y2=0.835
r190 (  3 28 ) resistor r=3.1 //w=0.17 //l=0.51 //layer=mcon //count=3 \
 //x=0.74 //y=0 //x2=0.74 //y2=0
r191 (  1 22 ) resistor r=0.0287885 //w=0.34 //l=0.085 //layer=m1 \
 //thickness=0.36 //x=0.99 //y=0 //x2=1.075 //y2=0
r192 (  1 3 ) resistor r=0.103821 //w=0.301 //l=0.25 //layer=m1 \
 //thickness=0.36 //x=0.99 //y=0 //x2=0.74 //y2=0
ends PM_AND3X1_PCELL\%noxref_3

subckt PM_AND3X1_PCELL\%noxref_4 ( 1 2 8 13 17 18 19 20 21 22 23 24 26 32 33 \
 34 35 )
c89 ( 35 0 ) capacitor c=0.0612936f //x=1.385 //y=4.79
c90 ( 34 0 ) capacitor c=0.0376642f //x=1.675 //y=4.79
c91 ( 33 0 ) capacitor c=0.0346489f //x=1.34 //y=1.22
c92 ( 32 0 ) capacitor c=0.018692f //x=1.34 //y=0.875
c93 ( 26 0 ) capacitor c=0.0137077f //x=1.185 //y=1.375
c94 ( 24 0 ) capacitor c=0.0158585f //x=1.185 //y=0.72
c95 ( 23 0 ) capacitor c=0.103534f //x=0.81 //y=1.915
c96 ( 22 0 ) capacitor c=0.0229444f //x=0.81 //y=1.53
c97 ( 21 0 ) capacitor c=0.0234359f //x=0.81 //y=1.22
c98 ( 20 0 ) capacitor c=0.019815f //x=0.81 //y=0.875
c99 ( 19 0 ) capacitor c=0.110208f //x=1.75 //y=6.02
c100 ( 18 0 ) capacitor c=0.158957f //x=1.31 //y=6.02
c101 ( 13 0 ) capacitor c=0.0014751f //x=1.11 //y=4.7
c102 ( 8 0 ) capacitor c=0.0012618f //x=1.11 //y=2.08
c103 ( 2 0 ) capacitor c=0.130979f //x=1.11 //y=4.575
c104 ( 1 0 ) capacitor c=0.0113399f //x=1.11 //y=2.195
r105 (  34 36 ) resistor r=26.9307 //w=0.15 //l=0.106066 //layer=ply \
 //thickness=0.18 //x=1.675 //y=4.79 //x2=1.75 //y2=4.865
r106 (  34 35 ) resistor r=148.702 //w=0.094 //l=0.29 //layer=ply \
 //thickness=0.18 //x=1.675 //y=4.79 //x2=1.385 //y2=4.79
r107 (  33 46 ) resistor r=45.1352 //w=0.168 //l=0.173853 //layer=ply \
 //thickness=0.18 //x=1.34 //y=1.22 //x2=1.3 //y2=1.375
r108 (  32 45 ) resistor r=45.1352 //w=0.168 //l=0.173853 //layer=ply \
 //thickness=0.18 //x=1.34 //y=0.875 //x2=1.3 //y2=0.72
r109 (  32 33 ) resistor r=176.904 //w=0.094 //l=0.345 //layer=ply \
 //thickness=0.18 //x=1.34 //y=0.875 //x2=1.34 //y2=1.22
r110 (  29 35 ) resistor r=22.7971 //w=0.269 //l=0.106066 //layer=ply \
 //thickness=0.18 //x=1.31 //y=4.865 //x2=1.385 //y2=4.79
r111 (  29 44 ) resistor r=35.8364 //w=0.269 //l=0.270185 //layer=ply \
 //thickness=0.18 //x=1.31 //y=4.865 //x2=1.11 //y2=4.7
r112 (  27 40 ) resistor r=10.701 //w=0.21 //l=0.115 //layer=ply \
 //thickness=0.18 //x=0.965 //y=1.375 //x2=0.85 //y2=1.375
r113 (  26 46 ) resistor r=5.52526 //w=0.168 //l=0.115 //layer=ply \
 //thickness=0.18 //x=1.185 //y=1.375 //x2=1.3 //y2=1.375
r114 (  25 39 ) resistor r=5.52526 //w=0.168 //l=0.115 //layer=ply \
 //thickness=0.18 //x=0.965 //y=0.72 //x2=0.85 //y2=0.72
r115 (  24 45 ) resistor r=5.52526 //w=0.168 //l=0.115 //layer=ply \
 //thickness=0.18 //x=1.185 //y=0.72 //x2=1.3 //y2=0.72
r116 (  24 25 ) resistor r=112.809 //w=0.094 //l=0.22 //layer=ply \
 //thickness=0.18 //x=1.185 //y=0.72 //x2=0.965 //y2=0.72
r117 (  23 42 ) resistor r=58.7805 //w=0.246 //l=0.373497 //layer=ply \
 //thickness=0.18 //x=0.81 //y=1.915 //x2=1.11 //y2=2.08
r118 (  22 40 ) resistor r=39.5823 //w=0.21 //l=0.173853 //layer=ply \
 //thickness=0.18 //x=0.81 //y=1.53 //x2=0.85 //y2=1.375
r119 (  22 23 ) resistor r=197.415 //w=0.094 //l=0.385 //layer=ply \
 //thickness=0.18 //x=0.81 //y=1.53 //x2=0.81 //y2=1.915
r120 (  21 40 ) resistor r=39.5823 //w=0.21 //l=0.173853 //layer=ply \
 //thickness=0.18 //x=0.81 //y=1.22 //x2=0.85 //y2=1.375
r121 (  20 39 ) resistor r=45.1352 //w=0.168 //l=0.173853 //layer=ply \
 //thickness=0.18 //x=0.81 //y=0.875 //x2=0.85 //y2=0.72
r122 (  20 21 ) resistor r=176.904 //w=0.094 //l=0.345 //layer=ply \
 //thickness=0.18 //x=0.81 //y=0.875 //x2=0.81 //y2=1.22
r123 (  19 36 ) resistor r=592.245 //w=0.094 //l=1.155 //layer=ply \
 //thickness=0.18 //x=1.75 //y=6.02 //x2=1.75 //y2=4.865
r124 (  18 29 ) resistor r=592.245 //w=0.094 //l=1.155 //layer=ply \
 //thickness=0.18 //x=1.31 //y=6.02 //x2=1.31 //y2=4.865
r125 (  17 26 ) resistor r=56.4043 //w=0.094 //l=0.11 //layer=ply \
 //thickness=0.18 //x=1.075 //y=1.375 //x2=1.185 //y2=1.375
r126 (  17 27 ) resistor r=56.4043 //w=0.094 //l=0.11 //layer=ply \
 //thickness=0.18 //x=1.075 //y=1.375 //x2=0.965 //y2=1.375
r127 (  13 44 ) resistor r=152 //w=0.17 //l=0.17 //layer=licon //count=1 \
 //x=1.11 //y=4.7 //x2=1.11 //y2=4.7
r128 (  8 42 ) resistor r=152 //w=0.17 //l=0.17 //layer=licon //count=1 \
 //x=1.11 //y=2.08 //x2=1.11 //y2=2.08
r129 (  6 13 ) resistor r=9.3 //w=0.17 //l=0.17 //layer=mcon //count=1 \
 //x=1.11 //y=4.7 //x2=1.11 //y2=4.7
r130 (  4 8 ) resistor r=9.3 //w=0.17 //l=0.17 //layer=mcon //count=1 //x=1.11 \
 //y=2.08 //x2=1.11 //y2=2.08
r131 (  2 6 ) resistor r=0.0760407 //w=0.238 //l=0.125 //layer=m1 \
 //thickness=0.36 //x=1.11 //y=4.575 //x2=1.11 //y2=4.7
r132 (  1 4 ) resistor r=0.0719237 //w=0.222 //l=0.115 //layer=m1 \
 //thickness=0.36 //x=1.11 //y=2.195 //x2=1.11 //y2=2.08
r133 (  1 2 ) resistor r=2.27099 //w=0.131 //l=2.38 //layer=m1 \
 //thickness=0.36 //x=1.11 //y=2.195 //x2=1.11 //y2=4.575
ends PM_AND3X1_PCELL\%noxref_4

subckt PM_AND3X1_PCELL\%noxref_5 ( 5 7 15 19 30 33 34 )
c66 ( 34 0 ) capacitor c=0.0484847f //x=2.965 //y=0.375
c67 ( 33 0 ) capacitor c=0.0198656f //x=1.86 //y=0.91
c68 ( 30 0 ) capacitor c=0.00141302f //x=3.1 //y=0.995
c69 ( 19 0 ) capacitor c=0.00745448f //x=4.07 //y=0.625
c70 ( 15 0 ) capacitor c=0.0155041f //x=3.985 //y=0.54
c71 ( 7 0 ) capacitor c=0.00681713f //x=3.1 //y=0.625
c72 ( 5 0 ) capacitor c=0.0288646f //x=3.015 //y=0.995
r73 (  19 34 ) resistor r=3.57586 //w=0.17 //l=0.125 //layer=li \
 //thickness=0.1 //x=4.07 //y=0.625 //x2=4.07 //y2=0.5
r74 (  19 34 ) resistor r=18.139 //w=0.187 //l=0.265 //layer=li \
 //thickness=0.1 //x=4.07 //y=0.625 //x2=4.07 //y2=0.89
r75 (  16 34 ) resistor r=3.57586 //w=0.17 //l=0.103078 //layer=li \
 //thickness=0.1 //x=3.185 //y=0.54 //x2=3.1 //y2=0.5
r76 (  16 34 ) resistor r=27.3797 //w=0.187 //l=0.4 //layer=li //thickness=0.1 \
 //x=3.185 //y=0.54 //x2=3.585 //y2=0.54
r77 (  15 34 ) resistor r=3.57586 //w=0.17 //l=0.103078 //layer=li \
 //thickness=0.1 //x=3.985 //y=0.54 //x2=4.07 //y2=0.5
r78 (  15 34 ) resistor r=27.3797 //w=0.187 //l=0.4 //layer=li //thickness=0.1 \
 //x=3.985 //y=0.54 //x2=3.585 //y2=0.54
r79 (  11 30 ) resistor r=5.4201 //w=0.17 //l=0.085 //layer=li //thickness=0.1 \
 //x=3.1 //y=1.08 //x2=3.1 //y2=0.995
r80 (  11 34 ) resistor r=10.2674 //w=0.187 //l=0.15 //layer=li \
 //thickness=0.1 //x=3.1 //y=1.08 //x2=3.1 //y2=1.23
r81 (  8 30 ) resistor r=5.4201 //w=0.17 //l=0.085 //layer=li //thickness=0.1 \
 //x=3.1 //y=0.91 //x2=3.1 //y2=0.995
r82 (  8 34 ) resistor r=1.36898 //w=0.187 //l=0.02 //layer=li //thickness=0.1 \
 //x=3.1 //y=0.91 //x2=3.1 //y2=0.89
r83 (  7 34 ) resistor r=3.57586 //w=0.17 //l=0.125 //layer=li //thickness=0.1 \
 //x=3.1 //y=0.625 //x2=3.1 //y2=0.5
r84 (  7 34 ) resistor r=18.139 //w=0.187 //l=0.265 //layer=li //thickness=0.1 \
 //x=3.1 //y=0.625 //x2=3.1 //y2=0.89
r85 (  6 33 ) resistor r=0.751729 //w=0.17 //l=0.085 //layer=li \
 //thickness=0.1 //x=2.135 //y=0.995 //x2=2.05 //y2=0.995
r86 (  5 30 ) resistor r=1.40859 //w=0.34 //l=0.085 //layer=li //thickness=0.1 \
 //x=3.015 //y=0.995 //x2=3.1 //y2=0.995
r87 (  5 6 ) resistor r=60.2353 //w=0.187 //l=0.88 //layer=li //thickness=0.1 \
 //x=3.015 //y=0.995 //x2=2.135 //y2=0.995
ends PM_AND3X1_PCELL\%noxref_5

subckt PM_AND3X1_PCELL\%noxref_6 ( 1 2 8 13 17 18 19 20 21 22 24 30 31 32 33 \
 34 42 )
c107 ( 42 0 ) capacitor c=0.0369044f //x=2.22 //y=4.7
c108 ( 34 0 ) capacitor c=0.0309248f //x=2.555 //y=4.79
c109 ( 33 0 ) capacitor c=0.0863671f //x=2.31 //y=1.915
c110 ( 32 0 ) capacitor c=0.0170266f //x=2.31 //y=1.45
c111 ( 31 0 ) capacitor c=0.018609f //x=2.31 //y=1.22
c112 ( 30 0 ) capacitor c=0.0186599f //x=2.31 //y=0.91
c113 ( 24 0 ) capacitor c=0.0146988f //x=2.155 //y=1.375
c114 ( 22 0 ) capacitor c=0.0148531f //x=2.155 //y=0.755
c115 ( 21 0 ) capacitor c=0.0334406f //x=1.785 //y=1.22
c116 ( 20 0 ) capacitor c=0.0173191f //x=1.785 //y=0.91
c117 ( 19 0 ) capacitor c=0.110208f //x=2.63 //y=6.02
c118 ( 18 0 ) capacitor c=0.110214f //x=2.19 //y=6.02
c119 ( 13 0 ) capacitor c=0.00129934f //x=2.22 //y=4.7
c120 ( 8 0 ) capacitor c=0.00121786f //x=2.22 //y=2.08
c121 ( 2 0 ) capacitor c=0.0822135f //x=2.22 //y=4.585
c122 ( 1 0 ) capacitor c=0.00579363f //x=2.22 //y=2.195
r123 (  44 45 ) resistor r=32.4568 //w=0.214 //l=0.075 //layer=ply \
 //thickness=0.18 //x=2.22 //y=4.79 //x2=2.22 //y2=4.865
r124 (  42 44 ) resistor r=20.271 //w=0.214 //l=0.09 //layer=ply \
 //thickness=0.18 //x=2.22 //y=4.7 //x2=2.22 //y2=4.79
r125 (  35 44 ) resistor r=16.5046 //w=0.27 //l=0.135 //layer=ply \
 //thickness=0.18 //x=2.355 //y=4.79 //x2=2.22 //y2=4.79
r126 (  34 36 ) resistor r=26.9307 //w=0.15 //l=0.106066 //layer=ply \
 //thickness=0.18 //x=2.555 //y=4.79 //x2=2.63 //y2=4.865
r127 (  34 35 ) resistor r=102.553 //w=0.094 //l=0.2 //layer=ply \
 //thickness=0.18 //x=2.555 //y=4.79 //x2=2.355 //y2=4.79
r128 (  33 49 ) resistor r=38.6777 //w=0.284 //l=0.198997 //layer=ply \
 //thickness=0.18 //x=2.31 //y=1.915 //x2=2.235 //y2=2.08
r129 (  32 47 ) resistor r=21.2976 //w=0.217 //l=0.0928709 //layer=ply \
 //thickness=0.18 //x=2.31 //y=1.45 //x2=2.27 //y2=1.375
r130 (  32 33 ) resistor r=238.436 //w=0.094 //l=0.465 //layer=ply \
 //thickness=0.18 //x=2.31 //y=1.45 //x2=2.31 //y2=1.915
r131 (  31 47 ) resistor r=39.0671 //w=0.217 //l=0.173853 //layer=ply \
 //thickness=0.18 //x=2.31 //y=1.22 //x2=2.27 //y2=1.375
r132 (  30 46 ) resistor r=45.1352 //w=0.168 //l=0.173853 //layer=ply \
 //thickness=0.18 //x=2.31 //y=0.91 //x2=2.27 //y2=0.755
r133 (  30 31 ) resistor r=158.957 //w=0.094 //l=0.31 //layer=ply \
 //thickness=0.18 //x=2.31 //y=0.91 //x2=2.31 //y2=1.22
r134 (  25 40 ) resistor r=5.52526 //w=0.168 //l=0.115 //layer=ply \
 //thickness=0.18 //x=1.94 //y=1.375 //x2=1.825 //y2=1.375
r135 (  24 47 ) resistor r=11.4558 //w=0.217 //l=0.115 //layer=ply \
 //thickness=0.18 //x=2.155 //y=1.375 //x2=2.27 //y2=1.375
r136 (  23 39 ) resistor r=5.52526 //w=0.168 //l=0.115 //layer=ply \
 //thickness=0.18 //x=1.94 //y=0.755 //x2=1.825 //y2=0.755
r137 (  22 46 ) resistor r=5.52526 //w=0.168 //l=0.115 //layer=ply \
 //thickness=0.18 //x=2.155 //y=0.755 //x2=2.27 //y2=0.755
r138 (  22 23 ) resistor r=110.245 //w=0.094 //l=0.215 //layer=ply \
 //thickness=0.18 //x=2.155 //y=0.755 //x2=1.94 //y2=0.755
r139 (  21 40 ) resistor r=45.1352 //w=0.168 //l=0.173853 //layer=ply \
 //thickness=0.18 //x=1.785 //y=1.22 //x2=1.825 //y2=1.375
r140 (  20 39 ) resistor r=45.1352 //w=0.168 //l=0.173853 //layer=ply \
 //thickness=0.18 //x=1.785 //y=0.91 //x2=1.825 //y2=0.755
r141 (  20 21 ) resistor r=158.957 //w=0.094 //l=0.31 //layer=ply \
 //thickness=0.18 //x=1.785 //y=0.91 //x2=1.785 //y2=1.22
r142 (  19 36 ) resistor r=592.245 //w=0.094 //l=1.155 //layer=ply \
 //thickness=0.18 //x=2.63 //y=6.02 //x2=2.63 //y2=4.865
r143 (  18 45 ) resistor r=592.245 //w=0.094 //l=1.155 //layer=ply \
 //thickness=0.18 //x=2.19 //y=6.02 //x2=2.19 //y2=4.865
r144 (  17 24 ) resistor r=55.3787 //w=0.094 //l=0.108 //layer=ply \
 //thickness=0.18 //x=2.047 //y=1.375 //x2=2.155 //y2=1.375
r145 (  17 25 ) resistor r=54.866 //w=0.094 //l=0.107 //layer=ply \
 //thickness=0.18 //x=2.047 //y=1.375 //x2=1.94 //y2=1.375
r146 (  13 42 ) resistor r=152 //w=0.17 //l=0.17 //layer=licon //count=1 \
 //x=2.22 //y=4.7 //x2=2.22 //y2=4.7
r147 (  8 49 ) resistor r=152 //w=0.17 //l=0.17 //layer=licon //count=1 \
 //x=2.22 //y=2.08 //x2=2.22 //y2=2.08
r148 (  6 13 ) resistor r=9.3 //w=0.17 //l=0.17 //layer=mcon //count=1 \
 //x=2.22 //y=4.7 //x2=2.22 //y2=4.7
r149 (  4 8 ) resistor r=9.3 //w=0.17 //l=0.17 //layer=mcon //count=1 //x=2.22 \
 //y=2.08 //x2=2.22 //y2=2.08
r150 (  2 6 ) resistor r=0.0717383 //w=0.224 //l=0.115 //layer=m1 \
 //thickness=0.36 //x=2.22 //y=4.585 //x2=2.22 //y2=4.7
r151 (  1 4 ) resistor r=0.0715665 //w=0.226 //l=0.115996 //layer=m1 \
 //thickness=0.36 //x=2.22 //y=2.195 //x2=2.222 //y2=2.08
r152 (  1 2 ) resistor r=2.28053 //w=0.131 //l=2.39 //layer=m1 \
 //thickness=0.36 //x=2.22 //y=2.195 //x2=2.22 //y2=4.585
ends PM_AND3X1_PCELL\%noxref_6

subckt PM_AND3X1_PCELL\%noxref_7 ( 1 2 8 13 17 18 19 23 24 25 30 32 35 36 38 \
 39 44 )
c95 ( 44 0 ) capacitor c=0.0710579f //x=3.33 //y=4.7
c96 ( 39 0 ) capacitor c=0.0278202f //x=3.33 //y=1.915
c97 ( 38 0 ) capacitor c=0.0503043f //x=3.33 //y=2.08
c98 ( 36 0 ) capacitor c=0.0443175f //x=3.85 //y=1.26
c99 ( 35 0 ) capacitor c=0.0199703f //x=3.85 //y=0.915
c100 ( 32 0 ) capacitor c=0.0162526f //x=3.695 //y=1.415
c101 ( 30 0 ) capacitor c=0.0157807f //x=3.695 //y=0.76
c102 ( 25 0 ) capacitor c=0.0220935f //x=3.32 //y=1.57
c103 ( 24 0 ) capacitor c=0.0207489f //x=3.32 //y=1.26
c104 ( 23 0 ) capacitor c=0.0194091f //x=3.32 //y=0.915
c105 ( 19 0 ) capacitor c=0.159671f //x=3.51 //y=6.02
c106 ( 18 0 ) capacitor c=0.110208f //x=3.07 //y=6.02
c107 ( 13 0 ) capacitor c=7.74199e-19 //x=3.33 //y=4.7
c108 ( 8 0 ) capacitor c=0.00101179f //x=3.33 //y=2.08
c109 ( 2 0 ) capacitor c=0.0725307f //x=3.33 //y=4.57
c110 ( 1 0 ) capacitor c=0.00724641f //x=3.33 //y=2.195
r111 (  38 39 ) resistor r=52.7279 //w=0.214 //l=0.165 //layer=ply \
 //thickness=0.18 //x=3.33 //y=2.08 //x2=3.33 //y2=1.915
r112 (  36 46 ) resistor r=45.1352 //w=0.168 //l=0.173853 //layer=ply \
 //thickness=0.18 //x=3.85 //y=1.26 //x2=3.81 //y2=1.415
r113 (  35 45 ) resistor r=45.1352 //w=0.168 //l=0.173853 //layer=ply \
 //thickness=0.18 //x=3.85 //y=0.915 //x2=3.81 //y2=0.76
r114 (  35 36 ) resistor r=176.904 //w=0.094 //l=0.345 //layer=ply \
 //thickness=0.18 //x=3.85 //y=0.915 //x2=3.85 //y2=1.26
r115 (  33 42 ) resistor r=10.701 //w=0.21 //l=0.115 //layer=ply \
 //thickness=0.18 //x=3.475 //y=1.415 //x2=3.36 //y2=1.415
r116 (  32 46 ) resistor r=5.52526 //w=0.168 //l=0.115 //layer=ply \
 //thickness=0.18 //x=3.695 //y=1.415 //x2=3.81 //y2=1.415
r117 (  31 41 ) resistor r=5.52526 //w=0.168 //l=0.115 //layer=ply \
 //thickness=0.18 //x=3.475 //y=0.76 //x2=3.36 //y2=0.76
r118 (  30 45 ) resistor r=5.52526 //w=0.168 //l=0.115 //layer=ply \
 //thickness=0.18 //x=3.695 //y=0.76 //x2=3.81 //y2=0.76
r119 (  30 31 ) resistor r=112.809 //w=0.094 //l=0.22 //layer=ply \
 //thickness=0.18 //x=3.695 //y=0.76 //x2=3.475 //y2=0.76
r120 (  27 44 ) resistor r=37.236 //w=0.233 //l=0.249199 //layer=ply \
 //thickness=0.18 //x=3.51 //y=4.865 //x2=3.33 //y2=4.7
r121 (  25 42 ) resistor r=39.5823 //w=0.21 //l=0.173853 //layer=ply \
 //thickness=0.18 //x=3.32 //y=1.57 //x2=3.36 //y2=1.415
r122 (  25 39 ) resistor r=176.904 //w=0.094 //l=0.345 //layer=ply \
 //thickness=0.18 //x=3.32 //y=1.57 //x2=3.32 //y2=1.915
r123 (  24 42 ) resistor r=39.5823 //w=0.21 //l=0.173853 //layer=ply \
 //thickness=0.18 //x=3.32 //y=1.26 //x2=3.36 //y2=1.415
r124 (  23 41 ) resistor r=45.1352 //w=0.168 //l=0.173853 //layer=ply \
 //thickness=0.18 //x=3.32 //y=0.915 //x2=3.36 //y2=0.76
r125 (  23 24 ) resistor r=176.904 //w=0.094 //l=0.345 //layer=ply \
 //thickness=0.18 //x=3.32 //y=0.915 //x2=3.32 //y2=1.26
r126 (  20 44 ) resistor r=53.7854 //w=0.233 //l=0.332415 //layer=ply \
 //thickness=0.18 //x=3.07 //y=4.865 //x2=3.33 //y2=4.7
r127 (  19 27 ) resistor r=592.245 //w=0.094 //l=1.155 //layer=ply \
 //thickness=0.18 //x=3.51 //y=6.02 //x2=3.51 //y2=4.865
r128 (  18 20 ) resistor r=592.245 //w=0.094 //l=1.155 //layer=ply \
 //thickness=0.18 //x=3.07 //y=6.02 //x2=3.07 //y2=4.865
r129 (  17 32 ) resistor r=56.4043 //w=0.094 //l=0.11 //layer=ply \
 //thickness=0.18 //x=3.585 //y=1.415 //x2=3.695 //y2=1.415
r130 (  17 33 ) resistor r=56.4043 //w=0.094 //l=0.11 //layer=ply \
 //thickness=0.18 //x=3.585 //y=1.415 //x2=3.475 //y2=1.415
r131 (  13 44 ) resistor r=152 //w=0.17 //l=0.17 //layer=licon //count=1 \
 //x=3.33 //y=4.7 //x2=3.33 //y2=4.7
r132 (  8 38 ) resistor r=152 //w=0.17 //l=0.17 //layer=licon //count=1 \
 //x=3.33 //y=2.08 //x2=3.33 //y2=2.08
r133 (  6 13 ) resistor r=9.3 //w=0.17 //l=0.17 //layer=mcon //count=1 \
 //x=3.33 //y=4.7 //x2=3.33 //y2=4.7
r134 (  4 8 ) resistor r=9.3 //w=0.17 //l=0.17 //layer=mcon //count=1 //x=3.33 \
 //y=2.08 //x2=3.33 //y2=2.08
r135 (  2 6 ) resistor r=0.0801089 //w=0.224 //l=0.13 //layer=m1 \
 //thickness=0.36 //x=3.33 //y=4.57 //x2=3.33 //y2=4.7
r136 (  1 4 ) resistor r=0.0719237 //w=0.222 //l=0.115 //layer=m1 \
 //thickness=0.36 //x=3.33 //y=2.195 //x2=3.33 //y2=2.08
r137 (  1 2 ) resistor r=2.26622 //w=0.131 //l=2.375 //layer=m1 \
 //thickness=0.36 //x=3.33 //y=2.195 //x2=3.33 //y2=4.57
ends PM_AND3X1_PCELL\%noxref_7

subckt PM_AND3X1_PCELL\%noxref_8 ( 2 4 5 6 7 8 10 12 22 29 31 )
c79 ( 29 0 ) capacitor c=0.00869746f //x=5.735 //y=0.91
c80 ( 22 0 ) capacitor c=0.0263113f //x=5.925 //y=5.38
c81 ( 12 0 ) capacitor c=0.0191069f //x=5.92 //y=1.005
c82 ( 10 0 ) capacitor c=0.115695f //x=6.29 //y=4.875
c83 ( 8 0 ) capacitor c=0.00557311f //x=6.01 //y=4.96
c84 ( 7 0 ) capacitor c=0.00944012f //x=6.205 //y=4.96
c85 ( 6 0 ) capacitor c=0.00724565f //x=6.005 //y=1.84
c86 ( 5 0 ) capacitor c=0.0145753f //x=6.205 //y=1.84
c87 ( 4 0 ) capacitor c=0.0117594f //x=5.925 //y=5.24
c88 ( 2 0 ) capacitor c=0.0170651f //x=5.92 //y=1.755
r89 (  22 31 ) resistor r=23.615 //w=0.187 //l=0.345 //layer=li \
 //thickness=0.1 //x=5.925 //y=5.38 //x2=5.925 //y2=5.725
r90 (  15 22 ) resistor r=9.3 //w=0.17 //l=0.17 //layer=mcon //count=1 \
 //x=5.925 //y=5.38 //x2=5.925 //y2=5.38
r91 (  12 29 ) resistor r=9.3 //w=0.17 //l=0.17 //layer=mcon //count=1 \
 //x=5.92 //y=1.005 //x2=5.92 //y2=1.005
r92 (  9 10 ) resistor r=2.81489 //w=0.131 //l=2.95 //layer=m1 \
 //thickness=0.36 //x=6.29 //y=1.925 //x2=6.29 //y2=4.875
r93 (  7 10 ) resistor r=0.0698411 //w=0.17 //l=0.120208 //layer=m1 \
 //thickness=0.36 //x=6.205 //y=4.96 //x2=6.29 //y2=4.875
r94 (  7 8 ) resistor r=0.186069 //w=0.131 //l=0.195 //layer=m1 \
 //thickness=0.36 //x=6.205 //y=4.96 //x2=6.01 //y2=4.96
r95 (  5 9 ) resistor r=0.0698411 //w=0.17 //l=0.120208 //layer=m1 \
 //thickness=0.36 //x=6.205 //y=1.84 //x2=6.29 //y2=1.925
r96 (  5 6 ) resistor r=0.19084 //w=0.131 //l=0.2 //layer=m1 //thickness=0.36 \
 //x=6.205 //y=1.84 //x2=6.005 //y2=1.84
r97 (  4 15 ) resistor r=0.086672 //w=0.218 //l=0.14 //layer=m1 \
 //thickness=0.36 //x=5.925 //y=5.24 //x2=5.925 //y2=5.38
r98 (  3 8 ) resistor r=0.0698411 //w=0.17 //l=0.120208 //layer=m1 \
 //thickness=0.36 //x=5.925 //y=5.045 //x2=6.01 //y2=4.96
r99 (  3 4 ) resistor r=0.186069 //w=0.131 //l=0.195 //layer=m1 \
 //thickness=0.36 //x=5.925 //y=5.045 //x2=5.925 //y2=5.24
r100 (  2 6 ) resistor r=0.0698411 //w=0.17 //l=0.120208 //layer=m1 \
 //thickness=0.36 //x=5.92 //y=1.755 //x2=6.005 //y2=1.84
r101 (  1 12 ) resistor r=0.105739 //w=0.201 //l=0.145 //layer=m1 \
 //thickness=0.36 //x=5.92 //y=1.15 //x2=5.92 //y2=1.005
r102 (  1 2 ) resistor r=0.57729 //w=0.131 //l=0.605 //layer=m1 \
 //thickness=0.36 //x=5.92 //y=1.15 //x2=5.92 //y2=1.755
ends PM_AND3X1_PCELL\%noxref_8

subckt PM_AND3X1_PCELL\%noxref_9 ( 1 5 9 13 17 35 )
c52 ( 35 0 ) capacitor c=0.0765395f //x=0.455 //y=0.375
c53 ( 17 0 ) capacitor c=0.026218f //x=2.445 //y=1.59
c54 ( 13 0 ) capacitor c=0.0153941f //x=2.445 //y=0.54
c55 ( 9 0 ) capacitor c=0.00772076f //x=1.56 //y=0.625
c56 ( 5 0 ) capacitor c=0.0224109f //x=1.475 //y=1.59
c57 ( 1 0 ) capacitor c=0.0109947f //x=0.59 //y=1.505
r58 (  18 35 ) resistor r=5.4201 //w=0.17 //l=0.103078 //layer=li \
 //thickness=0.1 //x=1.645 //y=1.59 //x2=1.56 //y2=1.63
r59 (  18 35 ) resistor r=27.3797 //w=0.187 //l=0.4 //layer=li //thickness=0.1 \
 //x=1.645 //y=1.59 //x2=2.045 //y2=1.59
r60 (  17 35 ) resistor r=0.751729 //w=0.17 //l=0.085 //layer=li \
 //thickness=0.1 //x=2.445 //y=1.59 //x2=2.53 //y2=1.59
r61 (  17 35 ) resistor r=27.3797 //w=0.187 //l=0.4 //layer=li //thickness=0.1 \
 //x=2.445 //y=1.59 //x2=2.045 //y2=1.59
r62 (  14 35 ) resistor r=3.57586 //w=0.17 //l=0.103078 //layer=li \
 //thickness=0.1 //x=1.645 //y=0.54 //x2=1.56 //y2=0.5
r63 (  14 35 ) resistor r=27.3797 //w=0.187 //l=0.4 //layer=li //thickness=0.1 \
 //x=1.645 //y=0.54 //x2=2.045 //y2=0.54
r64 (  13 35 ) resistor r=0.751729 //w=0.17 //l=0.085 //layer=li \
 //thickness=0.1 //x=2.445 //y=0.54 //x2=2.53 //y2=0.54
r65 (  13 35 ) resistor r=27.3797 //w=0.187 //l=0.4 //layer=li //thickness=0.1 \
 //x=2.445 //y=0.54 //x2=2.045 //y2=0.54
r66 (  10 35 ) resistor r=1.40859 //w=0.34 //l=0.125 //layer=li \
 //thickness=0.1 //x=1.56 //y=1.505 //x2=1.56 //y2=1.63
r67 (  10 35 ) resistor r=42.0963 //w=0.187 //l=0.615 //layer=li \
 //thickness=0.1 //x=1.56 //y=1.505 //x2=1.56 //y2=0.89
r68 (  9 35 ) resistor r=3.57586 //w=0.17 //l=0.125 //layer=li //thickness=0.1 \
 //x=1.56 //y=0.625 //x2=1.56 //y2=0.5
r69 (  9 35 ) resistor r=18.139 //w=0.187 //l=0.265 //layer=li //thickness=0.1 \
 //x=1.56 //y=0.625 //x2=1.56 //y2=0.89
r70 (  6 35 ) resistor r=3.57586 //w=0.17 //l=0.103078 //layer=li \
 //thickness=0.1 //x=0.675 //y=1.59 //x2=0.59 //y2=1.63
r71 (  6 35 ) resistor r=27.3797 //w=0.187 //l=0.4 //layer=li //thickness=0.1 \
 //x=0.675 //y=1.59 //x2=1.075 //y2=1.59
r72 (  5 35 ) resistor r=5.4201 //w=0.17 //l=0.103078 //layer=li \
 //thickness=0.1 //x=1.475 //y=1.59 //x2=1.56 //y2=1.63
r73 (  5 35 ) resistor r=27.3797 //w=0.187 //l=0.4 //layer=li //thickness=0.1 \
 //x=1.475 //y=1.59 //x2=1.075 //y2=1.59
r74 (  1 35 ) resistor r=3.57586 //w=0.17 //l=0.125 //layer=li //thickness=0.1 \
 //x=0.59 //y=1.505 //x2=0.59 //y2=1.63
r75 (  1 35 ) resistor r=42.0963 //w=0.187 //l=0.615 //layer=li \
 //thickness=0.1 //x=0.59 //y=1.505 //x2=0.59 //y2=0.89
ends PM_AND3X1_PCELL\%noxref_9
