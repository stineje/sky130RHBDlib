// File: mux2x1_pcell.spi.pex
// Created: Sun Apr 12 08:41:07 2026
// Program "Calibre xRC"
// Version "v2023.2_27.15"
// Nominal Temperature: 30C
// Circuit Temperature: 30C
//
simulator lang=spectre
subckt PM_MUX2X1_PCELL\%noxref_1 ( 2 3 4 6 7 10 15 20 22 25 26 29 34 35 38 47 \
 52 61 65 66 67 68 69 70 71 72 73 74 78 79 80 82 88 89 90 91 92 93 97 99 102 \
 103 108 122 )
c218 ( 122 0 ) capacitor c=0.0682508f //x=3.33 //y=4.7
c219 ( 108 0 ) capacitor c=0.0526948f //x=0.74 //y=2.085
c220 ( 103 0 ) capacitor c=0.0318956f //x=3.665 //y=1.21
c221 ( 102 0 ) capacitor c=0.0186809f //x=3.665 //y=0.865
c222 ( 99 0 ) capacitor c=0.0141821f //x=3.51 //y=1.365
c223 ( 97 0 ) capacitor c=0.0158553f //x=3.51 //y=0.71
c224 ( 93 0 ) capacitor c=0.0818195f //x=3.135 //y=1.915
c225 ( 92 0 ) capacitor c=0.0229235f //x=3.135 //y=1.52
c226 ( 91 0 ) capacitor c=0.0234359f //x=3.135 //y=1.21
c227 ( 90 0 ) capacitor c=0.0198759f //x=3.135 //y=0.865
c228 ( 89 0 ) capacitor c=0.0439576f //x=1.38 //y=1.255
c229 ( 88 0 ) capacitor c=0.0201087f //x=1.38 //y=0.91
c230 ( 82 0 ) capacitor c=0.0161986f //x=1.225 //y=1.41
c231 ( 80 0 ) capacitor c=0.0157807f //x=1.225 //y=0.755
c232 ( 79 0 ) capacitor c=0.0554306f //x=0.97 //y=4.79
c233 ( 78 0 ) capacitor c=0.0406047f //x=1.26 //y=4.79
c234 ( 74 0 ) capacitor c=0.0301471f //x=0.85 //y=1.92
c235 ( 73 0 ) capacitor c=0.0255349f //x=0.85 //y=1.565
c236 ( 72 0 ) capacitor c=0.0234346f //x=0.85 //y=1.255
c237 ( 71 0 ) capacitor c=0.02013f //x=0.85 //y=0.91
c238 ( 70 0 ) capacitor c=0.110369f //x=3.67 //y=6.02
c239 ( 69 0 ) capacitor c=0.154619f //x=3.23 //y=6.02
c240 ( 68 0 ) capacitor c=0.153944f //x=1.335 //y=6.02
c241 ( 67 0 ) capacitor c=0.154411f //x=0.895 //y=6.02
c242 ( 61 0 ) capacitor c=8.13451e-19 //x=3.33 //y=4.7
c243 ( 52 0 ) capacitor c=5.17312e-19 //x=3.33 //y=2.08
c244 ( 47 0 ) capacitor c=9.45276e-19 //x=0.74 //y=4.7
c245 ( 38 0 ) capacitor c=6.43121e-19 //x=0.74 //y=2.085
c246 ( 35 0 ) capacitor c=0.0693034f //x=3.17 //y=2.94
c247 ( 34 0 ) capacitor c=0.00206083f //x=3.33 //y=2.94
c248 ( 29 0 ) capacitor c=0.0127448f //x=0.9 //y=2.96
c249 ( 26 0 ) capacitor c=0.0442006f //x=3.332 //y=4.56
c250 ( 25 0 ) capacitor c=0.00624278f //x=3.33 //y=4.7
c251 ( 22 0 ) capacitor c=0.00567042f //x=3.33 //y=2.08
c252 ( 20 0 ) capacitor c=0.0164384f //x=3.33 //y=2.96
c253 ( 15 0 ) capacitor c=0.0184047f //x=0.74 //y=2.96
c254 ( 10 0 ) capacitor c=0.01346f //x=0.74 //y=2.085
c255 ( 7 0 ) capacitor c=0.0131844f //x=3.33 //y=3.1
c256 ( 6 0 ) capacitor c=0.0141802f //x=3.33 //y=2.78
c257 ( 4 0 ) capacitor c=0.0724039f //x=0.74 //y=4.58
c258 ( 3 0 ) capacitor c=0.0123553f //x=0.74 //y=3.12
c259 ( 2 0 ) capacitor c=0.0179469f //x=0.74 //y=2.8
r260 (  120 122 ) resistor r=20.6867 //w=0.233 //l=0.1 //layer=ply \
 //thickness=0.18 //x=3.23 //y=4.7 //x2=3.33 //y2=4.7
r261 (  108 109 ) resistor r=17.5563 //w=0.302 //l=0.11 //layer=ply \
 //thickness=0.18 //x=0.74 //y=2.085 //x2=0.85 //y2=2.085
r262 (  104 122 ) resistor r=70.3348 //w=0.233 //l=0.414367 //layer=ply \
 //thickness=0.18 //x=3.67 //y=4.865 //x2=3.33 //y2=4.7
r263 (  103 124 ) resistor r=45.1352 //w=0.168 //l=0.173853 //layer=ply \
 //thickness=0.18 //x=3.665 //y=1.21 //x2=3.625 //y2=1.365
r264 (  102 123 ) resistor r=45.1352 //w=0.168 //l=0.173853 //layer=ply \
 //thickness=0.18 //x=3.665 //y=0.865 //x2=3.625 //y2=0.71
r265 (  102 103 ) resistor r=176.904 //w=0.094 //l=0.345 //layer=ply \
 //thickness=0.18 //x=3.665 //y=0.865 //x2=3.665 //y2=1.21
r266 (  100 119 ) resistor r=10.701 //w=0.21 //l=0.115 //layer=ply \
 //thickness=0.18 //x=3.29 //y=1.365 //x2=3.175 //y2=1.365
r267 (  99 124 ) resistor r=5.52526 //w=0.168 //l=0.115 //layer=ply \
 //thickness=0.18 //x=3.51 //y=1.365 //x2=3.625 //y2=1.365
r268 (  98 118 ) resistor r=5.52526 //w=0.168 //l=0.115 //layer=ply \
 //thickness=0.18 //x=3.29 //y=0.71 //x2=3.175 //y2=0.71
r269 (  97 123 ) resistor r=5.52526 //w=0.168 //l=0.115 //layer=ply \
 //thickness=0.18 //x=3.51 //y=0.71 //x2=3.625 //y2=0.71
r270 (  97 98 ) resistor r=112.809 //w=0.094 //l=0.22 //layer=ply \
 //thickness=0.18 //x=3.51 //y=0.71 //x2=3.29 //y2=0.71
r271 (  94 120 ) resistor r=13.0941 //w=0.233 //l=0.165 //layer=ply \
 //thickness=0.18 //x=3.23 //y=4.865 //x2=3.23 //y2=4.7
r272 (  93 117 ) resistor r=34.8111 //w=0.27 //l=0.264953 //layer=ply \
 //thickness=0.18 //x=3.135 //y=1.915 //x2=3.33 //y2=2.08
r273 (  92 119 ) resistor r=39.5823 //w=0.21 //l=0.173853 //layer=ply \
 //thickness=0.18 //x=3.135 //y=1.52 //x2=3.175 //y2=1.365
r274 (  92 93 ) resistor r=202.543 //w=0.094 //l=0.395 //layer=ply \
 //thickness=0.18 //x=3.135 //y=1.52 //x2=3.135 //y2=1.915
r275 (  91 119 ) resistor r=39.5823 //w=0.21 //l=0.173853 //layer=ply \
 //thickness=0.18 //x=3.135 //y=1.21 //x2=3.175 //y2=1.365
r276 (  90 118 ) resistor r=45.1352 //w=0.168 //l=0.173853 //layer=ply \
 //thickness=0.18 //x=3.135 //y=0.865 //x2=3.175 //y2=0.71
r277 (  90 91 ) resistor r=176.904 //w=0.094 //l=0.345 //layer=ply \
 //thickness=0.18 //x=3.135 //y=0.865 //x2=3.135 //y2=1.21
r278 (  89 115 ) resistor r=45.1352 //w=0.168 //l=0.173853 //layer=ply \
 //thickness=0.18 //x=1.38 //y=1.255 //x2=1.34 //y2=1.41
r279 (  88 114 ) resistor r=45.1352 //w=0.168 //l=0.173853 //layer=ply \
 //thickness=0.18 //x=1.38 //y=0.91 //x2=1.34 //y2=0.755
r280 (  88 89 ) resistor r=176.904 //w=0.094 //l=0.345 //layer=ply \
 //thickness=0.18 //x=1.38 //y=0.91 //x2=1.38 //y2=1.255
r281 (  83 113 ) resistor r=10.701 //w=0.21 //l=0.115 //layer=ply \
 //thickness=0.18 //x=1.005 //y=1.41 //x2=0.89 //y2=1.41
r282 (  82 115 ) resistor r=5.52526 //w=0.168 //l=0.115 //layer=ply \
 //thickness=0.18 //x=1.225 //y=1.41 //x2=1.34 //y2=1.41
r283 (  81 112 ) resistor r=5.52526 //w=0.168 //l=0.115 //layer=ply \
 //thickness=0.18 //x=1.005 //y=0.755 //x2=0.89 //y2=0.755
r284 (  80 114 ) resistor r=5.52526 //w=0.168 //l=0.115 //layer=ply \
 //thickness=0.18 //x=1.225 //y=0.755 //x2=1.34 //y2=0.755
r285 (  80 81 ) resistor r=112.809 //w=0.094 //l=0.22 //layer=ply \
 //thickness=0.18 //x=1.225 //y=0.755 //x2=1.005 //y2=0.755
r286 (  78 85 ) resistor r=26.9307 //w=0.15 //l=0.106066 //layer=ply \
 //thickness=0.18 //x=1.26 //y=4.79 //x2=1.335 //y2=4.865
r287 (  78 79 ) resistor r=148.702 //w=0.094 //l=0.29 //layer=ply \
 //thickness=0.18 //x=1.26 //y=4.79 //x2=0.97 //y2=4.79
r288 (  75 79 ) resistor r=23.403 //w=0.284 //l=0.106066 //layer=ply \
 //thickness=0.18 //x=0.895 //y=4.865 //x2=0.97 //y2=4.79
r289 (  75 111 ) resistor r=26.3063 //w=0.284 //l=0.229783 //layer=ply \
 //thickness=0.18 //x=0.895 //y=4.865 //x2=0.74 //y2=4.7
r290 (  74 109 ) resistor r=19.1248 //w=0.302 //l=0.165 //layer=ply \
 //thickness=0.18 //x=0.85 //y=1.92 //x2=0.85 //y2=2.085
r291 (  73 113 ) resistor r=39.5823 //w=0.21 //l=0.173853 //layer=ply \
 //thickness=0.18 //x=0.85 //y=1.565 //x2=0.89 //y2=1.41
r292 (  73 74 ) resistor r=182.032 //w=0.094 //l=0.355 //layer=ply \
 //thickness=0.18 //x=0.85 //y=1.565 //x2=0.85 //y2=1.92
r293 (  72 113 ) resistor r=39.5823 //w=0.21 //l=0.173853 //layer=ply \
 //thickness=0.18 //x=0.85 //y=1.255 //x2=0.89 //y2=1.41
r294 (  71 112 ) resistor r=45.1352 //w=0.168 //l=0.173853 //layer=ply \
 //thickness=0.18 //x=0.85 //y=0.91 //x2=0.89 //y2=0.755
r295 (  71 72 ) resistor r=176.904 //w=0.094 //l=0.345 //layer=ply \
 //thickness=0.18 //x=0.85 //y=0.91 //x2=0.85 //y2=1.255
r296 (  70 104 ) resistor r=592.245 //w=0.094 //l=1.155 //layer=ply \
 //thickness=0.18 //x=3.67 //y=6.02 //x2=3.67 //y2=4.865
r297 (  69 94 ) resistor r=592.245 //w=0.094 //l=1.155 //layer=ply \
 //thickness=0.18 //x=3.23 //y=6.02 //x2=3.23 //y2=4.865
r298 (  68 85 ) resistor r=592.245 //w=0.094 //l=1.155 //layer=ply \
 //thickness=0.18 //x=1.335 //y=6.02 //x2=1.335 //y2=4.865
r299 (  67 75 ) resistor r=592.245 //w=0.094 //l=1.155 //layer=ply \
 //thickness=0.18 //x=0.895 //y=6.02 //x2=0.895 //y2=4.865
r300 (  66 99 ) resistor r=56.4043 //w=0.094 //l=0.11 //layer=ply \
 //thickness=0.18 //x=3.4 //y=1.365 //x2=3.51 //y2=1.365
r301 (  66 100 ) resistor r=56.4043 //w=0.094 //l=0.11 //layer=ply \
 //thickness=0.18 //x=3.4 //y=1.365 //x2=3.29 //y2=1.365
r302 (  65 82 ) resistor r=56.4043 //w=0.094 //l=0.11 //layer=ply \
 //thickness=0.18 //x=1.115 //y=1.41 //x2=1.225 //y2=1.41
r303 (  65 83 ) resistor r=56.4043 //w=0.094 //l=0.11 //layer=ply \
 //thickness=0.18 //x=1.115 //y=1.41 //x2=1.005 //y2=1.41
r304 (  61 122 ) resistor r=152 //w=0.17 //l=0.17 //layer=licon //count=1 \
 //x=3.33 //y=4.7 //x2=3.33 //y2=4.7
r305 (  52 117 ) resistor r=152 //w=0.17 //l=0.17 //layer=licon //count=1 \
 //x=3.33 //y=2.08 //x2=3.33 //y2=2.08
r306 (  47 111 ) resistor r=152 //w=0.17 //l=0.17 //layer=licon //count=1 \
 //x=0.74 //y=4.7 //x2=0.74 //y2=4.7
r307 (  38 108 ) resistor r=152 //w=0.17 //l=0.17 //layer=licon //count=1 \
 //x=0.74 //y=2.085 //x2=0.74 //y2=2.085
r308 (  34 35 ) resistor r=0.10734 //w=0.281 //l=0.16 //layer=m2 \
 //thickness=0.36 //x=3.33 //y=2.94 //x2=3.17 //y2=2.94
r309 (  29 31 ) resistor r=0.10734 //w=0.281 //l=0.16 //layer=m2 \
 //thickness=0.36 //x=0.9 //y=2.96 //x2=0.74 //y2=2.96
r310 (  29 35 ) resistor r=2.16603 //w=0.131 //l=2.27 //layer=m2 \
 //thickness=0.36 //x=0.9 //y=2.96 //x2=3.17 //y2=2.96
r311 (  25 61 ) resistor r=9.3 //w=0.17 //l=0.17 //layer=mcon //count=1 \
 //x=3.33 //y=4.7 //x2=3.33 //y2=4.7
r312 (  25 26 ) resistor r=0.103207 //w=0.196 //l=0.14 //layer=m1 \
 //thickness=0.36 //x=3.332 //y=4.7 //x2=3.332 //y2=4.56
r313 (  22 52 ) resistor r=9.3 //w=0.17 //l=0.17 //layer=mcon //count=1 \
 //x=3.33 //y=2.08 //x2=3.33 //y2=2.08
r314 (  18 34 ) resistor r=4.5 //w=0.15 //l=0.15 //layer=via1 //count=1 \
 //x=3.33 //y=2.94 //x2=3.33 //y2=2.94
r315 (  18 20 ) resistor r=0.00664894 //w=0.376 //l=0.02 //layer=m1 \
 //thickness=0.36 //x=3.277 //y=2.94 //x2=3.277 //y2=2.96
r316 (  15 31 ) resistor r=4.5 //w=0.15 //l=0.15 //layer=via1 //count=1 \
 //x=0.74 //y=2.96 //x2=0.74 //y2=2.96
r317 (  13 47 ) resistor r=9.3 //w=0.17 //l=0.17 //layer=mcon //count=1 \
 //x=0.74 //y=4.7 //x2=0.74 //y2=4.7
r318 (  10 38 ) resistor r=9.3 //w=0.17 //l=0.17 //layer=mcon //count=1 \
 //x=0.74 //y=2.085 //x2=0.74 //y2=2.085
r319 (  7 20 ) resistor r=0.0845104 //w=0.376 //l=0.164378 //layer=m1 \
 //thickness=0.36 //x=3.33 //y=3.1 //x2=3.277 //y2=2.96
r320 (  7 26 ) resistor r=1.39313 //w=0.131 //l=1.46 //layer=m1 \
 //thickness=0.36 //x=3.33 //y=3.1 //x2=3.33 //y2=4.56
r321 (  6 18 ) resistor r=0.0911593 //w=0.376 //l=0.184608 //layer=m1 \
 //thickness=0.36 //x=3.33 //y=2.78 //x2=3.277 //y2=2.94
r322 (  5 22 ) resistor r=0.0933015 //w=0.201 //l=0.125 //layer=m1 \
 //thickness=0.36 //x=3.33 //y=2.205 //x2=3.33 //y2=2.08
r323 (  5 6 ) resistor r=0.548664 //w=0.131 //l=0.575 //layer=m1 \
 //thickness=0.36 //x=3.33 //y=2.205 //x2=3.33 //y2=2.78
r324 (  4 13 ) resistor r=0.0732479 //w=0.241 //l=0.122474 //layer=m1 \
 //thickness=0.36 //x=0.74 //y=4.58 //x2=0.745 //y2=4.7
r325 (  3 15 ) resistor r=0.0911593 //w=0.376 //l=0.184174 //layer=m1 \
 //thickness=0.36 //x=0.74 //y=3.12 //x2=0.792 //y2=2.96
r326 (  3 4 ) resistor r=1.39313 //w=0.131 //l=1.46 //layer=m1 \
 //thickness=0.36 //x=0.74 //y=3.12 //x2=0.74 //y2=4.58
r327 (  2 15 ) resistor r=0.0911593 //w=0.376 //l=0.184174 //layer=m1 \
 //thickness=0.36 //x=0.74 //y=2.8 //x2=0.792 //y2=2.96
r328 (  1 10 ) resistor r=0.116051 //w=0.211 //l=0.165 //layer=m1 \
 //thickness=0.36 //x=0.74 //y=2.25 //x2=0.74 //y2=2.085
r329 (  1 2 ) resistor r=0.524809 //w=0.131 //l=0.55 //layer=m1 \
 //thickness=0.36 //x=0.74 //y=2.25 //x2=0.74 //y2=2.8
ends PM_MUX2X1_PCELL\%noxref_1

subckt PM_MUX2X1_PCELL\%noxref_2 ( 2 4 5 6 7 8 10 11 12 14 15 18 23 27 31 34 \
 35 42 44 45 53 65 74 78 79 80 81 82 83 84 88 90 93 94 104 107 109 )
c252 ( 107 0 ) capacitor c=0.00869746f //x=0.925 //y=0.91
c253 ( 104 0 ) capacitor c=0.0682508f //x=6.66 //y=4.7
c254 ( 94 0 ) capacitor c=0.0318956f //x=6.995 //y=1.21
c255 ( 93 0 ) capacitor c=0.0186809f //x=6.995 //y=0.865
c256 ( 90 0 ) capacitor c=0.0141821f //x=6.84 //y=1.365
c257 ( 88 0 ) capacitor c=0.0158553f //x=6.84 //y=0.71
c258 ( 84 0 ) capacitor c=0.0854244f //x=6.465 //y=1.915
c259 ( 83 0 ) capacitor c=0.0229235f //x=6.465 //y=1.52
c260 ( 82 0 ) capacitor c=0.0234359f //x=6.465 //y=1.21
c261 ( 81 0 ) capacitor c=0.0198759f //x=6.465 //y=0.865
c262 ( 80 0 ) capacitor c=0.110369f //x=7 //y=6.02
c263 ( 79 0 ) capacitor c=0.154619f //x=6.56 //y=6.02
c264 ( 74 0 ) capacitor c=8.13451e-19 //x=6.66 //y=4.7
c265 ( 65 0 ) capacitor c=7.85889e-19 //x=6.66 //y=2.08
c266 ( 53 0 ) capacitor c=0.0262474f //x=1.115 //y=5.38
c267 ( 45 0 ) capacitor c=0.154161f //x=6.5 //y=3.34
c268 ( 44 0 ) capacitor c=0.00238894f //x=6.66 //y=3.34
c269 ( 42 0 ) capacitor c=0.00127082f //x=1.64 //y=3.35
c270 ( 35 0 ) capacitor c=0.0340357f //x=6.662 //y=4.56
c271 ( 34 0 ) capacitor c=0.00610769f //x=6.66 //y=4.7
c272 ( 31 0 ) capacitor c=0.00641515f //x=6.66 //y=2.08
c273 ( 27 0 ) capacitor c=0.0160819f //x=6.66 //y=3.33
c274 ( 23 0 ) capacitor c=0.0156888f //x=1.48 //y=3.33
c275 ( 18 0 ) capacitor c=0.0190609f //x=1.11 //y=1.005
c276 ( 15 0 ) capacitor c=0.0126734f //x=6.66 //y=3.5
c277 ( 14 0 ) capacitor c=0.0246383f //x=6.66 //y=3.18
c278 ( 12 0 ) capacitor c=0.0368518f //x=1.48 //y=4.875
c279 ( 11 0 ) capacitor c=0.0123771f //x=1.48 //y=3.51
c280 ( 10 0 ) capacitor c=0.0271897f //x=1.48 //y=3.19
c281 ( 8 0 ) capacitor c=0.00703409f //x=1.2 //y=4.96
c282 ( 7 0 ) capacitor c=0.00776478f //x=1.395 //y=4.96
c283 ( 6 0 ) capacitor c=0.00807721f //x=1.195 //y=1.84
c284 ( 5 0 ) capacitor c=0.0120876f //x=1.395 //y=1.84
c285 ( 4 0 ) capacitor c=0.0121131f //x=1.115 //y=5.24
c286 ( 2 0 ) capacitor c=0.0184708f //x=1.11 //y=1.755
r287 (  102 104 ) resistor r=20.6867 //w=0.233 //l=0.1 //layer=ply \
 //thickness=0.18 //x=6.56 //y=4.7 //x2=6.66 //y2=4.7
r288 (  95 104 ) resistor r=70.3348 //w=0.233 //l=0.414367 //layer=ply \
 //thickness=0.18 //x=7 //y=4.865 //x2=6.66 //y2=4.7
r289 (  94 106 ) resistor r=45.1352 //w=0.168 //l=0.173853 //layer=ply \
 //thickness=0.18 //x=6.995 //y=1.21 //x2=6.955 //y2=1.365
r290 (  93 105 ) resistor r=45.1352 //w=0.168 //l=0.173853 //layer=ply \
 //thickness=0.18 //x=6.995 //y=0.865 //x2=6.955 //y2=0.71
r291 (  93 94 ) resistor r=176.904 //w=0.094 //l=0.345 //layer=ply \
 //thickness=0.18 //x=6.995 //y=0.865 //x2=6.995 //y2=1.21
r292 (  91 101 ) resistor r=10.701 //w=0.21 //l=0.115 //layer=ply \
 //thickness=0.18 //x=6.62 //y=1.365 //x2=6.505 //y2=1.365
r293 (  90 106 ) resistor r=5.52526 //w=0.168 //l=0.115 //layer=ply \
 //thickness=0.18 //x=6.84 //y=1.365 //x2=6.955 //y2=1.365
r294 (  89 100 ) resistor r=5.52526 //w=0.168 //l=0.115 //layer=ply \
 //thickness=0.18 //x=6.62 //y=0.71 //x2=6.505 //y2=0.71
r295 (  88 105 ) resistor r=5.52526 //w=0.168 //l=0.115 //layer=ply \
 //thickness=0.18 //x=6.84 //y=0.71 //x2=6.955 //y2=0.71
r296 (  88 89 ) resistor r=112.809 //w=0.094 //l=0.22 //layer=ply \
 //thickness=0.18 //x=6.84 //y=0.71 //x2=6.62 //y2=0.71
r297 (  85 102 ) resistor r=13.0941 //w=0.233 //l=0.165 //layer=ply \
 //thickness=0.18 //x=6.56 //y=4.865 //x2=6.56 //y2=4.7
r298 (  84 99 ) resistor r=34.8111 //w=0.27 //l=0.264953 //layer=ply \
 //thickness=0.18 //x=6.465 //y=1.915 //x2=6.66 //y2=2.08
r299 (  83 101 ) resistor r=39.5823 //w=0.21 //l=0.173853 //layer=ply \
 //thickness=0.18 //x=6.465 //y=1.52 //x2=6.505 //y2=1.365
r300 (  83 84 ) resistor r=202.543 //w=0.094 //l=0.395 //layer=ply \
 //thickness=0.18 //x=6.465 //y=1.52 //x2=6.465 //y2=1.915
r301 (  82 101 ) resistor r=39.5823 //w=0.21 //l=0.173853 //layer=ply \
 //thickness=0.18 //x=6.465 //y=1.21 //x2=6.505 //y2=1.365
r302 (  81 100 ) resistor r=45.1352 //w=0.168 //l=0.173853 //layer=ply \
 //thickness=0.18 //x=6.465 //y=0.865 //x2=6.505 //y2=0.71
r303 (  81 82 ) resistor r=176.904 //w=0.094 //l=0.345 //layer=ply \
 //thickness=0.18 //x=6.465 //y=0.865 //x2=6.465 //y2=1.21
r304 (  80 95 ) resistor r=592.245 //w=0.094 //l=1.155 //layer=ply \
 //thickness=0.18 //x=7 //y=6.02 //x2=7 //y2=4.865
r305 (  79 85 ) resistor r=592.245 //w=0.094 //l=1.155 //layer=ply \
 //thickness=0.18 //x=6.56 //y=6.02 //x2=6.56 //y2=4.865
r306 (  78 90 ) resistor r=56.4043 //w=0.094 //l=0.11 //layer=ply \
 //thickness=0.18 //x=6.73 //y=1.365 //x2=6.84 //y2=1.365
r307 (  78 91 ) resistor r=56.4043 //w=0.094 //l=0.11 //layer=ply \
 //thickness=0.18 //x=6.73 //y=1.365 //x2=6.62 //y2=1.365
r308 (  74 104 ) resistor r=152 //w=0.17 //l=0.17 //layer=licon //count=1 \
 //x=6.66 //y=4.7 //x2=6.66 //y2=4.7
r309 (  65 99 ) resistor r=152 //w=0.17 //l=0.17 //layer=licon //count=1 \
 //x=6.66 //y=2.08 //x2=6.66 //y2=2.08
r310 (  53 109 ) resistor r=23.615 //w=0.187 //l=0.345 //layer=li \
 //thickness=0.1 //x=1.115 //y=5.38 //x2=1.115 //y2=5.725
r311 (  44 45 ) resistor r=0.10734 //w=0.281 //l=0.16 //layer=m2 \
 //thickness=0.36 //x=6.66 //y=3.34 //x2=6.5 //y2=3.34
r312 (  42 45 ) resistor r=4.6374 //w=0.131 //l=4.86 //layer=m2 \
 //thickness=0.36 //x=1.64 //y=3.33 //x2=6.5 //y2=3.33
r313 (  40 42 ) resistor r=0.10734 //w=0.281 //l=0.16 //layer=m2 \
 //thickness=0.36 //x=1.48 //y=3.35 //x2=1.64 //y2=3.35
r314 (  34 74 ) resistor r=9.3 //w=0.17 //l=0.17 //layer=mcon //count=1 \
 //x=6.66 //y=4.7 //x2=6.66 //y2=4.7
r315 (  34 35 ) resistor r=0.103207 //w=0.196 //l=0.14 //layer=m1 \
 //thickness=0.36 //x=6.662 //y=4.7 //x2=6.662 //y2=4.56
r316 (  31 65 ) resistor r=9.3 //w=0.17 //l=0.17 //layer=mcon //count=1 \
 //x=6.66 //y=2.08 //x2=6.66 //y2=2.08
r317 (  29 44 ) resistor r=4.5 //w=0.15 //l=0.15 //layer=via1 //count=1 \
 //x=6.66 //y=3.34 //x2=6.66 //y2=3.34
r318 (  27 29 ) resistor r=0.00332447 //w=0.376 //l=0.01 //layer=m1 \
 //thickness=0.36 //x=6.607 //y=3.33 //x2=6.607 //y2=3.34
r319 (  25 40 ) resistor r=4.5 //w=0.15 //l=0.15 //layer=via1 //count=1 \
 //x=1.48 //y=3.35 //x2=1.48 //y2=3.35
r320 (  23 25 ) resistor r=0.00664894 //w=0.376 //l=0.02 //layer=m1 \
 //thickness=0.36 //x=1.532 //y=3.33 //x2=1.532 //y2=3.35
r321 (  21 53 ) resistor r=9.3 //w=0.17 //l=0.17 //layer=mcon //count=1 \
 //x=1.115 //y=5.38 //x2=1.115 //y2=5.38
r322 (  18 107 ) resistor r=9.3 //w=0.17 //l=0.17 //layer=mcon //count=1 \
 //x=1.11 //y=1.005 //x2=1.11 //y2=1.005
r323 (  15 29 ) resistor r=0.0911593 //w=0.376 //l=0.184608 //layer=m1 \
 //thickness=0.36 //x=6.66 //y=3.5 //x2=6.607 //y2=3.34
r324 (  15 35 ) resistor r=1.01145 //w=0.131 //l=1.06 //layer=m1 \
 //thickness=0.36 //x=6.66 //y=3.5 //x2=6.66 //y2=4.56
r325 (  14 27 ) resistor r=0.0878349 //w=0.376 //l=0.174499 //layer=m1 \
 //thickness=0.36 //x=6.66 //y=3.18 //x2=6.607 //y2=3.33
r326 (  13 31 ) resistor r=0.0933015 //w=0.201 //l=0.125 //layer=m1 \
 //thickness=0.36 //x=6.66 //y=2.205 //x2=6.66 //y2=2.08
r327 (  13 14 ) resistor r=0.930344 //w=0.131 //l=0.975 //layer=m1 \
 //thickness=0.36 //x=6.66 //y=2.205 //x2=6.66 //y2=3.18
r328 (  11 25 ) resistor r=0.0911593 //w=0.376 //l=0.184174 //layer=m1 \
 //thickness=0.36 //x=1.48 //y=3.51 //x2=1.532 //y2=3.35
r329 (  11 12 ) resistor r=1.30248 //w=0.131 //l=1.365 //layer=m1 \
 //thickness=0.36 //x=1.48 //y=3.51 //x2=1.48 //y2=4.875
r330 (  10 23 ) resistor r=0.0845104 //w=0.376 //l=0.163951 //layer=m1 \
 //thickness=0.36 //x=1.48 //y=3.19 //x2=1.532 //y2=3.33
r331 (  9 10 ) resistor r=1.20706 //w=0.131 //l=1.265 //layer=m1 \
 //thickness=0.36 //x=1.48 //y=1.925 //x2=1.48 //y2=3.19
r332 (  7 12 ) resistor r=0.0698411 //w=0.17 //l=0.120208 //layer=m1 \
 //thickness=0.36 //x=1.395 //y=4.96 //x2=1.48 //y2=4.875
r333 (  7 8 ) resistor r=0.186069 //w=0.131 //l=0.195 //layer=m1 \
 //thickness=0.36 //x=1.395 //y=4.96 //x2=1.2 //y2=4.96
r334 (  5 9 ) resistor r=0.0698411 //w=0.17 //l=0.120208 //layer=m1 \
 //thickness=0.36 //x=1.395 //y=1.84 //x2=1.48 //y2=1.925
r335 (  5 6 ) resistor r=0.19084 //w=0.131 //l=0.2 //layer=m1 //thickness=0.36 \
 //x=1.395 //y=1.84 //x2=1.195 //y2=1.84
r336 (  4 21 ) resistor r=0.086672 //w=0.218 //l=0.14 //layer=m1 \
 //thickness=0.36 //x=1.115 //y=5.24 //x2=1.115 //y2=5.38
r337 (  3 8 ) resistor r=0.0698411 //w=0.17 //l=0.120208 //layer=m1 \
 //thickness=0.36 //x=1.115 //y=5.045 //x2=1.2 //y2=4.96
r338 (  3 4 ) resistor r=0.186069 //w=0.131 //l=0.195 //layer=m1 \
 //thickness=0.36 //x=1.115 //y=5.045 //x2=1.115 //y2=5.24
r339 (  2 6 ) resistor r=0.0698411 //w=0.17 //l=0.120208 //layer=m1 \
 //thickness=0.36 //x=1.11 //y=1.755 //x2=1.195 //y2=1.84
r340 (  1 18 ) resistor r=0.105739 //w=0.201 //l=0.145 //layer=m1 \
 //thickness=0.36 //x=1.11 //y=1.15 //x2=1.11 //y2=1.005
r341 (  1 2 ) resistor r=0.57729 //w=0.131 //l=0.605 //layer=m1 \
 //thickness=0.36 //x=1.11 //y=1.15 //x2=1.11 //y2=1.755
ends PM_MUX2X1_PCELL\%noxref_2

subckt PM_MUX2X1_PCELL\%noxref_3 ( 3 8 9 11 12 14 15 16 18 19 23 24 27 29 34 \
 38 40 43 44 46 48 50 52 57 61 69 86 95 99 100 101 102 103 104 105 109 111 114 \
 115 125 128 130 131 )
c304 ( 128 0 ) capacitor c=0.00878249f //x=4.18 //y=0.905
c305 ( 125 0 ) capacitor c=0.0682508f //x=9.99 //y=4.7
c306 ( 115 0 ) capacitor c=0.0318956f //x=10.325 //y=1.21
c307 ( 114 0 ) capacitor c=0.0186809f //x=10.325 //y=0.865
c308 ( 111 0 ) capacitor c=0.0141821f //x=10.17 //y=1.365
c309 ( 109 0 ) capacitor c=0.0158553f //x=10.17 //y=0.71
c310 ( 105 0 ) capacitor c=0.0818149f //x=9.795 //y=1.915
c311 ( 104 0 ) capacitor c=0.0229235f //x=9.795 //y=1.52
c312 ( 103 0 ) capacitor c=0.0234359f //x=9.795 //y=1.21
c313 ( 102 0 ) capacitor c=0.0198759f //x=9.795 //y=0.865
c314 ( 101 0 ) capacitor c=0.110369f //x=10.33 //y=6.02
c315 ( 100 0 ) capacitor c=0.154619f //x=9.89 //y=6.02
c316 ( 95 0 ) capacitor c=8.13451e-19 //x=9.99 //y=4.7
c317 ( 86 0 ) capacitor c=5.17312e-19 //x=9.99 //y=2.08
c318 ( 69 0 ) capacitor c=0.0321204f //x=4.33 //y=5.38
c319 ( 61 0 ) capacitor c=0.0289608f //x=3.45 //y=5.38
c320 ( 57 0 ) capacitor c=0.00245975f //x=4.97 //y=2.94
c321 ( 52 0 ) capacitor c=0.059142f //x=8.355 //y=2.95
c322 ( 50 0 ) capacitor c=0.0343373f //x=7.755 //y=2.96
c323 ( 48 0 ) capacitor c=0.0220123f //x=6.875 //y=2.95
c324 ( 46 0 ) capacitor c=0.0492234f //x=6.275 //y=2.96
c325 ( 44 0 ) capacitor c=0.0428591f //x=9.992 //y=4.56
c326 ( 43 0 ) capacitor c=0.00624278f //x=9.99 //y=4.7
c327 ( 40 0 ) capacitor c=0.00627028f //x=9.99 //y=2.08
c328 ( 38 0 ) capacitor c=0.0145644f //x=9.99 //y=2.96
c329 ( 34 0 ) capacitor c=0.0167172f //x=4.81 //y=2.96
c330 ( 29 0 ) capacitor c=0.0114441f //x=4.37 //y=1
c331 ( 27 0 ) capacitor c=6.70882e-19 //x=4.33 //y=5.38
c332 ( 24 0 ) capacitor c=0.0119196f //x=4.33 //y=5.2
c333 ( 23 0 ) capacitor c=0.00964616f //x=3.45 //y=5.38
c334 ( 19 0 ) capacitor c=0.0133942f //x=9.99 //y=3.1
c335 ( 18 0 ) capacitor c=0.0141802f //x=9.99 //y=2.78
c336 ( 16 0 ) capacitor c=0.0571372f //x=4.81 //y=5.115
c337 ( 15 0 ) capacitor c=0.0138111f //x=4.81 //y=3.1
c338 ( 14 0 ) capacitor c=0.0251585f //x=4.81 //y=2.78
c339 ( 12 0 ) capacitor c=0.00662006f //x=4.455 //y=1.655
c340 ( 11 0 ) capacitor c=0.0138229f //x=4.725 //y=1.655
c341 ( 9 0 ) capacitor c=0.0120533f //x=4.725 //y=5.2
c342 ( 8 0 ) capacitor c=0.0101031f //x=4.37 //y=1.57
c343 ( 3 0 ) capacitor c=0.0158797f //x=4.215 //y=5.2
r344 (  123 125 ) resistor r=20.6867 //w=0.233 //l=0.1 //layer=ply \
 //thickness=0.18 //x=9.89 //y=4.7 //x2=9.99 //y2=4.7
r345 (  116 125 ) resistor r=70.3348 //w=0.233 //l=0.414367 //layer=ply \
 //thickness=0.18 //x=10.33 //y=4.865 //x2=9.99 //y2=4.7
r346 (  115 127 ) resistor r=45.1352 //w=0.168 //l=0.173853 //layer=ply \
 //thickness=0.18 //x=10.325 //y=1.21 //x2=10.285 //y2=1.365
r347 (  114 126 ) resistor r=45.1352 //w=0.168 //l=0.173853 //layer=ply \
 //thickness=0.18 //x=10.325 //y=0.865 //x2=10.285 //y2=0.71
r348 (  114 115 ) resistor r=176.904 //w=0.094 //l=0.345 //layer=ply \
 //thickness=0.18 //x=10.325 //y=0.865 //x2=10.325 //y2=1.21
r349 (  112 122 ) resistor r=10.701 //w=0.21 //l=0.115 //layer=ply \
 //thickness=0.18 //x=9.95 //y=1.365 //x2=9.835 //y2=1.365
r350 (  111 127 ) resistor r=5.52526 //w=0.168 //l=0.115 //layer=ply \
 //thickness=0.18 //x=10.17 //y=1.365 //x2=10.285 //y2=1.365
r351 (  110 121 ) resistor r=5.52526 //w=0.168 //l=0.115 //layer=ply \
 //thickness=0.18 //x=9.95 //y=0.71 //x2=9.835 //y2=0.71
r352 (  109 126 ) resistor r=5.52526 //w=0.168 //l=0.115 //layer=ply \
 //thickness=0.18 //x=10.17 //y=0.71 //x2=10.285 //y2=0.71
r353 (  109 110 ) resistor r=112.809 //w=0.094 //l=0.22 //layer=ply \
 //thickness=0.18 //x=10.17 //y=0.71 //x2=9.95 //y2=0.71
r354 (  106 123 ) resistor r=13.0941 //w=0.233 //l=0.165 //layer=ply \
 //thickness=0.18 //x=9.89 //y=4.865 //x2=9.89 //y2=4.7
r355 (  105 120 ) resistor r=34.8111 //w=0.27 //l=0.264953 //layer=ply \
 //thickness=0.18 //x=9.795 //y=1.915 //x2=9.99 //y2=2.08
r356 (  104 122 ) resistor r=39.5823 //w=0.21 //l=0.173853 //layer=ply \
 //thickness=0.18 //x=9.795 //y=1.52 //x2=9.835 //y2=1.365
r357 (  104 105 ) resistor r=202.543 //w=0.094 //l=0.395 //layer=ply \
 //thickness=0.18 //x=9.795 //y=1.52 //x2=9.795 //y2=1.915
r358 (  103 122 ) resistor r=39.5823 //w=0.21 //l=0.173853 //layer=ply \
 //thickness=0.18 //x=9.795 //y=1.21 //x2=9.835 //y2=1.365
r359 (  102 121 ) resistor r=45.1352 //w=0.168 //l=0.173853 //layer=ply \
 //thickness=0.18 //x=9.795 //y=0.865 //x2=9.835 //y2=0.71
r360 (  102 103 ) resistor r=176.904 //w=0.094 //l=0.345 //layer=ply \
 //thickness=0.18 //x=9.795 //y=0.865 //x2=9.795 //y2=1.21
r361 (  101 116 ) resistor r=592.245 //w=0.094 //l=1.155 //layer=ply \
 //thickness=0.18 //x=10.33 //y=6.02 //x2=10.33 //y2=4.865
r362 (  100 106 ) resistor r=592.245 //w=0.094 //l=1.155 //layer=ply \
 //thickness=0.18 //x=9.89 //y=6.02 //x2=9.89 //y2=4.865
r363 (  99 111 ) resistor r=56.4043 //w=0.094 //l=0.11 //layer=ply \
 //thickness=0.18 //x=10.06 //y=1.365 //x2=10.17 //y2=1.365
r364 (  99 112 ) resistor r=56.4043 //w=0.094 //l=0.11 //layer=ply \
 //thickness=0.18 //x=10.06 //y=1.365 //x2=9.95 //y2=1.365
r365 (  95 125 ) resistor r=152 //w=0.17 //l=0.17 //layer=licon //count=1 \
 //x=9.99 //y=4.7 //x2=9.99 //y2=4.7
r366 (  86 120 ) resistor r=152 //w=0.17 //l=0.17 //layer=licon //count=1 \
 //x=9.99 //y=2.08 //x2=9.99 //y2=2.08
r367 (  69 131 ) resistor r=23.615 //w=0.187 //l=0.345 //layer=li \
 //thickness=0.1 //x=4.33 //y=5.38 //x2=4.33 //y2=5.725
r368 (  61 130 ) resistor r=23.615 //w=0.187 //l=0.345 //layer=li \
 //thickness=0.1 //x=3.45 //y=5.38 //x2=3.45 //y2=5.725
r369 (  55 57 ) resistor r=0.10734 //w=0.281 //l=0.16 //layer=m2 \
 //thickness=0.36 //x=4.81 //y=2.94 //x2=4.97 //y2=2.94
r370 (  52 59 ) resistor r=1.03378 //w=0.197 //l=1.62999 //layer=m2 \
 //thickness=0.36 //x=8.355 //y=2.95 //x2=9.98 //y2=2.94
r371 (  52 53 ) resistor r=0.410305 //w=0.131 //l=0.43 //layer=m2 \
 //thickness=0.36 //x=8.355 //y=2.95 //x2=7.925 //y2=2.95
r372 (  50 53 ) resistor r=0.125 //w=0.17 //l=0.174929 //layer=m2 \
 //thickness=0.36 //x=7.755 //y=2.96 //x2=7.925 //y2=2.95
r373 (  50 51 ) resistor r=0.596374 //w=0.131 //l=0.625 //layer=m2 \
 //thickness=0.36 //x=7.755 //y=2.96 //x2=7.13 //y2=2.96
r374 (  48 51 ) resistor r=0.1875 //w=0.17 //l=0.259952 //layer=m2 \
 //thickness=0.36 //x=6.875 //y=2.95 //x2=7.13 //y2=2.96
r375 (  48 49 ) resistor r=0.410305 //w=0.131 //l=0.43 //layer=m2 \
 //thickness=0.36 //x=6.875 //y=2.95 //x2=6.445 //y2=2.95
r376 (  46 49 ) resistor r=0.125 //w=0.17 //l=0.174929 //layer=m2 \
 //thickness=0.36 //x=6.275 //y=2.96 //x2=6.445 //y2=2.95
r377 (  46 57 ) resistor r=1.24523 //w=0.131 //l=1.305 //layer=m2 \
 //thickness=0.36 //x=6.275 //y=2.96 //x2=4.97 //y2=2.96
r378 (  43 95 ) resistor r=9.3 //w=0.17 //l=0.17 //layer=mcon //count=1 \
 //x=9.99 //y=4.7 //x2=9.99 //y2=4.7
r379 (  43 44 ) resistor r=0.103207 //w=0.196 //l=0.14 //layer=m1 \
 //thickness=0.36 //x=9.992 //y=4.7 //x2=9.992 //y2=4.56
r380 (  40 86 ) resistor r=9.3 //w=0.17 //l=0.17 //layer=mcon //count=1 \
 //x=9.99 //y=2.08 //x2=9.99 //y2=2.08
r381 (  36 59 ) resistor r=4.5 //w=0.15 //l=0.15 //layer=via1 //count=1 \
 //x=9.98 //y=2.94 //x2=9.98 //y2=2.94
r382 (  36 38 ) resistor r=0.00673854 //w=0.371 //l=0.02 //layer=m1 \
 //thickness=0.36 //x=9.932 //y=2.94 //x2=9.932 //y2=2.96
r383 (  32 55 ) resistor r=4.5 //w=0.15 //l=0.15 //layer=via1 //count=1 \
 //x=4.81 //y=2.94 //x2=4.81 //y2=2.94
r384 (  32 34 ) resistor r=0.00664894 //w=0.376 //l=0.02 //layer=m1 \
 //thickness=0.36 //x=4.862 //y=2.94 //x2=4.862 //y2=2.96
r385 (  29 128 ) resistor r=9.3 //w=0.17 //l=0.17 //layer=mcon //count=1 \
 //x=4.37 //y=1 //x2=4.37 //y2=1
r386 (  27 69 ) resistor r=9.3 //w=0.17 //l=0.17 //layer=mcon //count=1 \
 //x=4.33 //y=5.38 //x2=4.33 //y2=5.38
r387 (  24 27 ) resistor r=0.117801 //w=0.191 //l=0.18 //layer=m1 \
 //thickness=0.36 //x=4.33 //y=5.2 //x2=4.33 //y2=5.38
r388 (  23 61 ) resistor r=9.3 //w=0.17 //l=0.17 //layer=mcon //count=1 \
 //x=3.45 //y=5.38 //x2=3.45 //y2=5.38
r389 (  21 23 ) resistor r=0.10274 //w=0.219 //l=0.18 //layer=m1 \
 //thickness=0.36 //x=3.45 //y=5.2 //x2=3.45 //y2=5.38
r390 (  19 38 ) resistor r=0.0842262 //w=0.371 //l=0.166493 //layer=m1 \
 //thickness=0.36 //x=9.99 //y=3.1 //x2=9.932 //y2=2.96
r391 (  19 44 ) resistor r=1.39313 //w=0.131 //l=1.46 //layer=m1 \
 //thickness=0.36 //x=9.99 //y=3.1 //x2=9.99 //y2=4.56
r392 (  18 36 ) resistor r=0.0909648 //w=0.371 //l=0.186762 //layer=m1 \
 //thickness=0.36 //x=9.99 //y=2.78 //x2=9.932 //y2=2.94
r393 (  17 40 ) resistor r=0.0933015 //w=0.201 //l=0.125 //layer=m1 \
 //thickness=0.36 //x=9.99 //y=2.205 //x2=9.99 //y2=2.08
r394 (  17 18 ) resistor r=0.548664 //w=0.131 //l=0.575 //layer=m1 \
 //thickness=0.36 //x=9.99 //y=2.205 //x2=9.99 //y2=2.78
r395 (  15 34 ) resistor r=0.0845104 //w=0.376 //l=0.163951 //layer=m1 \
 //thickness=0.36 //x=4.81 //y=3.1 //x2=4.862 //y2=2.96
r396 (  15 16 ) resistor r=1.92271 //w=0.131 //l=2.015 //layer=m1 \
 //thickness=0.36 //x=4.81 //y=3.1 //x2=4.81 //y2=5.115
r397 (  14 32 ) resistor r=0.0911593 //w=0.376 //l=0.184174 //layer=m1 \
 //thickness=0.36 //x=4.81 //y=2.78 //x2=4.862 //y2=2.94
r398 (  13 14 ) resistor r=0.992366 //w=0.131 //l=1.04 //layer=m1 \
 //thickness=0.36 //x=4.81 //y=1.74 //x2=4.81 //y2=2.78
r399 (  11 13 ) resistor r=0.0698411 //w=0.17 //l=0.120208 //layer=m1 \
 //thickness=0.36 //x=4.725 //y=1.655 //x2=4.81 //y2=1.74
r400 (  11 12 ) resistor r=0.257634 //w=0.131 //l=0.27 //layer=m1 \
 //thickness=0.36 //x=4.725 //y=1.655 //x2=4.455 //y2=1.655
r401 (  10 24 ) resistor r=0.0257089 //w=0.23 //l=0.115 //layer=m1 \
 //thickness=0.36 //x=4.445 //y=5.2 //x2=4.33 //y2=5.2
r402 (  9 16 ) resistor r=0.0698411 //w=0.17 //l=0.120208 //layer=m1 \
 //thickness=0.36 //x=4.725 //y=5.2 //x2=4.81 //y2=5.115
r403 (  9 10 ) resistor r=0.267176 //w=0.131 //l=0.28 //layer=m1 \
 //thickness=0.36 //x=4.725 //y=5.2 //x2=4.445 //y2=5.2
r404 (  8 12 ) resistor r=0.0698411 //w=0.17 //l=0.120208 //layer=m1 \
 //thickness=0.36 //x=4.37 //y=1.57 //x2=4.455 //y2=1.655
r405 (  7 29 ) resistor r=0.0913624 //w=0.191 //l=0.12 //layer=m1 \
 //thickness=0.36 //x=4.37 //y=1.12 //x2=4.37 //y2=1
r406 (  7 8 ) resistor r=0.429389 //w=0.131 //l=0.45 //layer=m1 \
 //thickness=0.36 //x=4.37 //y=1.12 //x2=4.37 //y2=1.57
r407 (  4 21 ) resistor r=0.0227762 //w=0.219 //l=0.115 //layer=m1 \
 //thickness=0.36 //x=3.565 //y=5.2 //x2=3.45 //y2=5.2
r408 (  3 24 ) resistor r=0.0257089 //w=0.23 //l=0.115 //layer=m1 \
 //thickness=0.36 //x=4.215 //y=5.2 //x2=4.33 //y2=5.2
r409 (  3 4 ) resistor r=0.620229 //w=0.131 //l=0.65 //layer=m1 \
 //thickness=0.36 //x=4.215 //y=5.2 //x2=3.565 //y2=5.2
ends PM_MUX2X1_PCELL\%noxref_3

subckt PM_MUX2X1_PCELL\%noxref_4 ( 3 8 9 11 12 14 15 16 18 19 20 23 24 27 29 \
 32 36 39 44 49 51 54 62 79 88 92 93 94 95 96 97 102 104 106 112 113 115 116 \
 119 127 129 130 )
c275 ( 127 0 ) capacitor c=0.00878249f //x=7.51 //y=0.905
c276 ( 119 0 ) capacitor c=0.0393541f //x=10.76 //y=4.7
c277 ( 116 0 ) capacitor c=0.0303735f //x=10.73 //y=1.915
c278 ( 115 0 ) capacitor c=0.045117f //x=10.73 //y=2.08
c279 ( 113 0 ) capacitor c=0.0439708f //x=11.295 //y=1.25
c280 ( 112 0 ) capacitor c=0.0192582f //x=11.295 //y=0.905
c281 ( 106 0 ) capacitor c=0.0162526f //x=11.14 //y=1.405
c282 ( 104 0 ) capacitor c=0.0157807f //x=11.14 //y=0.75
c283 ( 102 0 ) capacitor c=0.0372668f //x=11.135 //y=4.79
c284 ( 97 0 ) capacitor c=0.0210762f //x=10.765 //y=1.56
c285 ( 96 0 ) capacitor c=0.0168511f //x=10.765 //y=1.25
c286 ( 95 0 ) capacitor c=0.0175485f //x=10.765 //y=0.905
c287 ( 94 0 ) capacitor c=0.155269f //x=11.21 //y=6.02
c288 ( 93 0 ) capacitor c=0.110375f //x=10.77 //y=6.02
c289 ( 88 0 ) capacitor c=8.9038e-19 //x=10.76 //y=4.7
c290 ( 79 0 ) capacitor c=5.78095e-19 //x=10.73 //y=2.08
c291 ( 62 0 ) capacitor c=0.0326476f //x=7.66 //y=5.38
c292 ( 54 0 ) capacitor c=0.029418f //x=6.78 //y=5.38
c293 ( 51 0 ) capacitor c=0.00358268f //x=10.73 //y=3.33
c294 ( 49 0 ) capacitor c=0.00298797f //x=8.3 //y=3.34
c295 ( 44 0 ) capacitor c=0.0694867f //x=10.57 //y=3.33
c296 ( 39 0 ) capacitor c=0.00637966f //x=10.73 //y=2.08
c297 ( 36 0 ) capacitor c=0.0158758f //x=10.73 //y=3.33
c298 ( 32 0 ) capacitor c=0.0175241f //x=8.14 //y=3.33
c299 ( 29 0 ) capacitor c=0.011403f //x=7.7 //y=1
c300 ( 27 0 ) capacitor c=6.70882e-19 //x=7.66 //y=5.38
c301 ( 24 0 ) capacitor c=0.0127386f //x=7.66 //y=5.2
c302 ( 23 0 ) capacitor c=0.0100037f //x=6.78 //y=5.38
c303 ( 20 0 ) capacitor c=0.031346f //x=10.73 //y=4.555
c304 ( 19 0 ) capacitor c=0.0101286f //x=10.73 //y=3.49
c305 ( 18 0 ) capacitor c=0.0196935f //x=10.73 //y=3.17
c306 ( 16 0 ) capacitor c=0.0481967f //x=8.14 //y=5.115
c307 ( 15 0 ) capacitor c=0.0121613f //x=8.14 //y=3.5
c308 ( 14 0 ) capacitor c=0.0367664f //x=8.14 //y=3.18
c309 ( 12 0 ) capacitor c=0.00619099f //x=7.785 //y=1.655
c310 ( 11 0 ) capacitor c=0.0136643f //x=8.055 //y=1.655
c311 ( 9 0 ) capacitor c=0.011962f //x=8.055 //y=5.2
c312 ( 8 0 ) capacitor c=0.0101547f //x=7.7 //y=1.57
c313 ( 3 0 ) capacitor c=0.0195602f //x=7.545 //y=5.2
r314 (  121 122 ) resistor r=32.4568 //w=0.214 //l=0.075 //layer=ply \
 //thickness=0.18 //x=10.76 //y=4.79 //x2=10.76 //y2=4.865
r315 (  119 121 ) resistor r=20.271 //w=0.214 //l=0.09 //layer=ply \
 //thickness=0.18 //x=10.76 //y=4.7 //x2=10.76 //y2=4.79
r316 (  115 116 ) resistor r=52.7279 //w=0.214 //l=0.165 //layer=ply \
 //thickness=0.18 //x=10.73 //y=2.08 //x2=10.73 //y2=1.915
r317 (  113 126 ) resistor r=45.1352 //w=0.168 //l=0.173853 //layer=ply \
 //thickness=0.18 //x=11.295 //y=1.25 //x2=11.255 //y2=1.405
r318 (  112 125 ) resistor r=45.1352 //w=0.168 //l=0.173853 //layer=ply \
 //thickness=0.18 //x=11.295 //y=0.905 //x2=11.255 //y2=0.75
r319 (  112 113 ) resistor r=176.904 //w=0.094 //l=0.345 //layer=ply \
 //thickness=0.18 //x=11.295 //y=0.905 //x2=11.295 //y2=1.25
r320 (  107 124 ) resistor r=10.701 //w=0.21 //l=0.115 //layer=ply \
 //thickness=0.18 //x=10.92 //y=1.405 //x2=10.805 //y2=1.405
r321 (  106 126 ) resistor r=5.52526 //w=0.168 //l=0.115 //layer=ply \
 //thickness=0.18 //x=11.14 //y=1.405 //x2=11.255 //y2=1.405
r322 (  105 123 ) resistor r=5.52526 //w=0.168 //l=0.115 //layer=ply \
 //thickness=0.18 //x=10.92 //y=0.75 //x2=10.805 //y2=0.75
r323 (  104 125 ) resistor r=5.52526 //w=0.168 //l=0.115 //layer=ply \
 //thickness=0.18 //x=11.14 //y=0.75 //x2=11.255 //y2=0.75
r324 (  104 105 ) resistor r=112.809 //w=0.094 //l=0.22 //layer=ply \
 //thickness=0.18 //x=11.14 //y=0.75 //x2=10.92 //y2=0.75
r325 (  103 121 ) resistor r=16.5046 //w=0.27 //l=0.135 //layer=ply \
 //thickness=0.18 //x=10.895 //y=4.79 //x2=10.76 //y2=4.79
r326 (  102 109 ) resistor r=26.9307 //w=0.15 //l=0.106066 //layer=ply \
 //thickness=0.18 //x=11.135 //y=4.79 //x2=11.21 //y2=4.865
r327 (  102 103 ) resistor r=123.064 //w=0.094 //l=0.24 //layer=ply \
 //thickness=0.18 //x=11.135 //y=4.79 //x2=10.895 //y2=4.79
r328 (  97 124 ) resistor r=39.5823 //w=0.21 //l=0.173853 //layer=ply \
 //thickness=0.18 //x=10.765 //y=1.56 //x2=10.805 //y2=1.405
r329 (  97 116 ) resistor r=182.032 //w=0.094 //l=0.355 //layer=ply \
 //thickness=0.18 //x=10.765 //y=1.56 //x2=10.765 //y2=1.915
r330 (  96 124 ) resistor r=39.5823 //w=0.21 //l=0.173853 //layer=ply \
 //thickness=0.18 //x=10.765 //y=1.25 //x2=10.805 //y2=1.405
r331 (  95 123 ) resistor r=45.1352 //w=0.168 //l=0.173853 //layer=ply \
 //thickness=0.18 //x=10.765 //y=0.905 //x2=10.805 //y2=0.75
r332 (  95 96 ) resistor r=176.904 //w=0.094 //l=0.345 //layer=ply \
 //thickness=0.18 //x=10.765 //y=0.905 //x2=10.765 //y2=1.25
r333 (  94 109 ) resistor r=592.245 //w=0.094 //l=1.155 //layer=ply \
 //thickness=0.18 //x=11.21 //y=6.02 //x2=11.21 //y2=4.865
r334 (  93 122 ) resistor r=592.245 //w=0.094 //l=1.155 //layer=ply \
 //thickness=0.18 //x=10.77 //y=6.02 //x2=10.77 //y2=4.865
r335 (  92 106 ) resistor r=56.4043 //w=0.094 //l=0.11 //layer=ply \
 //thickness=0.18 //x=11.03 //y=1.405 //x2=11.14 //y2=1.405
r336 (  92 107 ) resistor r=56.4043 //w=0.094 //l=0.11 //layer=ply \
 //thickness=0.18 //x=11.03 //y=1.405 //x2=10.92 //y2=1.405
r337 (  88 119 ) resistor r=152 //w=0.17 //l=0.17 //layer=licon //count=1 \
 //x=10.76 //y=4.7 //x2=10.76 //y2=4.7
r338 (  79 115 ) resistor r=152 //w=0.17 //l=0.17 //layer=licon //count=1 \
 //x=10.73 //y=2.08 //x2=10.73 //y2=2.08
r339 (  62 130 ) resistor r=23.615 //w=0.187 //l=0.345 //layer=li \
 //thickness=0.1 //x=7.66 //y=5.38 //x2=7.66 //y2=5.725
r340 (  54 129 ) resistor r=23.615 //w=0.187 //l=0.345 //layer=li \
 //thickness=0.1 //x=6.78 //y=5.38 //x2=6.78 //y2=5.725
r341 (  47 49 ) resistor r=0.10734 //w=0.281 //l=0.16 //layer=m2 \
 //thickness=0.36 //x=8.14 //y=3.34 //x2=8.3 //y2=3.34
r342 (  44 51 ) resistor r=0.10734 //w=0.281 //l=0.16 //layer=m2 \
 //thickness=0.36 //x=10.57 //y=3.33 //x2=10.73 //y2=3.33
r343 (  44 49 ) resistor r=2.16603 //w=0.131 //l=2.27 //layer=m2 \
 //thickness=0.36 //x=10.57 //y=3.33 //x2=8.3 //y2=3.33
r344 (  43 88 ) resistor r=9.3 //w=0.17 //l=0.17 //layer=mcon //count=1 \
 //x=10.76 //y=4.7 //x2=10.76 //y2=4.7
r345 (  39 79 ) resistor r=9.3 //w=0.17 //l=0.17 //layer=mcon //count=1 \
 //x=10.73 //y=2.08 //x2=10.73 //y2=2.08
r346 (  39 41 ) resistor r=0.0936408 //w=0.196 //l=0.125 //layer=m1 \
 //thickness=0.36 //x=10.732 //y=2.08 //x2=10.732 //y2=2.205
r347 (  36 51 ) resistor r=4.5 //w=0.15 //l=0.15 //layer=via1 //count=1 \
 //x=10.73 //y=3.33 //x2=10.73 //y2=3.33
r348 (  34 47 ) resistor r=4.5 //w=0.15 //l=0.15 //layer=via1 //count=1 \
 //x=8.14 //y=3.34 //x2=8.14 //y2=3.34
r349 (  32 34 ) resistor r=0.00332447 //w=0.376 //l=0.01 //layer=m1 \
 //thickness=0.36 //x=8.192 //y=3.33 //x2=8.192 //y2=3.34
r350 (  29 127 ) resistor r=9.3 //w=0.17 //l=0.17 //layer=mcon //count=1 \
 //x=7.7 //y=1 //x2=7.7 //y2=1
r351 (  27 62 ) resistor r=9.3 //w=0.17 //l=0.17 //layer=mcon //count=1 \
 //x=7.66 //y=5.38 //x2=7.66 //y2=5.38
r352 (  24 27 ) resistor r=0.117801 //w=0.191 //l=0.18 //layer=m1 \
 //thickness=0.36 //x=7.66 //y=5.2 //x2=7.66 //y2=5.38
r353 (  23 54 ) resistor r=9.3 //w=0.17 //l=0.17 //layer=mcon //count=1 \
 //x=6.78 //y=5.38 //x2=6.78 //y2=5.38
r354 (  21 23 ) resistor r=0.10274 //w=0.219 //l=0.18 //layer=m1 \
 //thickness=0.36 //x=6.78 //y=5.2 //x2=6.78 //y2=5.38
r355 (  20 43 ) resistor r=0.0878548 //w=0.228 //l=0.159295 //layer=m1 \
 //thickness=0.36 //x=10.73 //y=4.555 //x2=10.76 //y2=4.7
r356 (  19 36 ) resistor r=0.0911593 //w=0.376 //l=0.184608 //layer=m1 \
 //thickness=0.36 //x=10.73 //y=3.49 //x2=10.677 //y2=3.33
r357 (  19 20 ) resistor r=1.01622 //w=0.131 //l=1.065 //layer=m1 \
 //thickness=0.36 //x=10.73 //y=3.49 //x2=10.73 //y2=4.555
r358 (  18 36 ) resistor r=0.0911593 //w=0.376 //l=0.184608 //layer=m1 \
 //thickness=0.36 //x=10.73 //y=3.17 //x2=10.677 //y2=3.33
r359 (  18 41 ) resistor r=0.920802 //w=0.131 //l=0.965 //layer=m1 \
 //thickness=0.36 //x=10.73 //y=3.17 //x2=10.73 //y2=2.205
r360 (  15 34 ) resistor r=0.0911593 //w=0.376 //l=0.184174 //layer=m1 \
 //thickness=0.36 //x=8.14 //y=3.5 //x2=8.192 //y2=3.34
r361 (  15 16 ) resistor r=1.54103 //w=0.131 //l=1.615 //layer=m1 \
 //thickness=0.36 //x=8.14 //y=3.5 //x2=8.14 //y2=5.115
r362 (  14 32 ) resistor r=0.0878349 //w=0.376 //l=0.174069 //layer=m1 \
 //thickness=0.36 //x=8.14 //y=3.18 //x2=8.192 //y2=3.33
r363 (  13 14 ) resistor r=1.37405 //w=0.131 //l=1.44 //layer=m1 \
 //thickness=0.36 //x=8.14 //y=1.74 //x2=8.14 //y2=3.18
r364 (  11 13 ) resistor r=0.0698411 //w=0.17 //l=0.120208 //layer=m1 \
 //thickness=0.36 //x=8.055 //y=1.655 //x2=8.14 //y2=1.74
r365 (  11 12 ) resistor r=0.257634 //w=0.131 //l=0.27 //layer=m1 \
 //thickness=0.36 //x=8.055 //y=1.655 //x2=7.785 //y2=1.655
r366 (  10 24 ) resistor r=0.0257089 //w=0.23 //l=0.115 //layer=m1 \
 //thickness=0.36 //x=7.775 //y=5.2 //x2=7.66 //y2=5.2
r367 (  9 16 ) resistor r=0.0698411 //w=0.17 //l=0.120208 //layer=m1 \
 //thickness=0.36 //x=8.055 //y=5.2 //x2=8.14 //y2=5.115
r368 (  9 10 ) resistor r=0.267176 //w=0.131 //l=0.28 //layer=m1 \
 //thickness=0.36 //x=8.055 //y=5.2 //x2=7.775 //y2=5.2
r369 (  8 12 ) resistor r=0.0698411 //w=0.17 //l=0.120208 //layer=m1 \
 //thickness=0.36 //x=7.7 //y=1.57 //x2=7.785 //y2=1.655
r370 (  7 29 ) resistor r=0.0913624 //w=0.191 //l=0.12 //layer=m1 \
 //thickness=0.36 //x=7.7 //y=1.12 //x2=7.7 //y2=1
r371 (  7 8 ) resistor r=0.429389 //w=0.131 //l=0.45 //layer=m1 \
 //thickness=0.36 //x=7.7 //y=1.12 //x2=7.7 //y2=1.57
r372 (  4 21 ) resistor r=0.0227762 //w=0.219 //l=0.115 //layer=m1 \
 //thickness=0.36 //x=6.895 //y=5.2 //x2=6.78 //y2=5.2
r373 (  3 24 ) resistor r=0.0257089 //w=0.23 //l=0.115 //layer=m1 \
 //thickness=0.36 //x=7.545 //y=5.2 //x2=7.66 //y2=5.2
r374 (  3 4 ) resistor r=0.620229 //w=0.131 //l=0.65 //layer=m1 \
 //thickness=0.36 //x=7.545 //y=5.2 //x2=6.895 //y2=5.2
ends PM_MUX2X1_PCELL\%noxref_4

subckt PM_MUX2X1_PCELL\%noxref_5 ( 21 45 71 81 107 117 139 147 162 164 168 173 \
 178 179 180 181 182 183 184 185 186 187 188 189 )
c228 ( 189 0 ) capacitor c=0.039252f //x=11.285 //y=5.02
c229 ( 188 0 ) capacitor c=0.0248171f //x=10.405 //y=5.02
c230 ( 187 0 ) capacitor c=0.0631162f //x=9.535 //y=5.02
c231 ( 186 0 ) capacitor c=0.0395436f //x=7.955 //y=5.02
c232 ( 185 0 ) capacitor c=0.0248171f //x=7.075 //y=5.02
c233 ( 184 0 ) capacitor c=0.063031f //x=6.205 //y=5.02
c234 ( 183 0 ) capacitor c=0.0397408f //x=4.625 //y=5.02
c235 ( 182 0 ) capacitor c=0.0248171f //x=3.745 //y=5.02
c236 ( 181 0 ) capacitor c=0.059553f //x=2.875 //y=5.02
c237 ( 180 0 ) capacitor c=0.0544221f //x=1.41 //y=5.02
c238 ( 179 0 ) capacitor c=0.0611141f //x=0.54 //y=5.02
c239 ( 178 0 ) capacitor c=0.250096f //x=11.47 //y=7.4
c240 ( 176 0 ) capacitor c=0.00591168f //x=10.55 //y=7.4
c241 ( 175 0 ) capacitor c=0.00591168f //x=9.62 //y=7.4
c242 ( 173 0 ) capacitor c=0.130502f //x=8.88 //y=7.4
c243 ( 172 0 ) capacitor c=0.00591168f //x=8.14 //y=7.4
c244 ( 170 0 ) capacitor c=0.00591168f //x=7.22 //y=7.4
c245 ( 169 0 ) capacitor c=0.00591168f //x=6.34 //y=7.4
c246 ( 168 0 ) capacitor c=0.130448f //x=5.55 //y=7.4
c247 ( 167 0 ) capacitor c=0.00591168f //x=4.77 //y=7.4
c248 ( 166 0 ) capacitor c=0.00591168f //x=3.89 //y=7.4
c249 ( 165 0 ) capacitor c=0.00591168f //x=3.01 //y=7.4
c250 ( 164 0 ) capacitor c=0.128107f //x=2.22 //y=7.4
c251 ( 163 0 ) capacitor c=0.00591168f //x=1.555 //y=7.4
c252 ( 162 0 ) capacitor c=0.238972f //x=0.74 //y=7.4
c253 ( 147 0 ) capacitor c=0.0284687f //x=11.345 //y=7.4
c254 ( 139 0 ) capacitor c=0.0288404f //x=10.465 //y=7.4
c255 ( 129 0 ) capacitor c=0.0281468f //x=9.585 //y=7.4
c256 ( 125 0 ) capacitor c=0.0275781f //x=8.71 //y=7.4
c257 ( 117 0 ) capacitor c=0.0284687f //x=8.015 //y=7.4
c258 ( 107 0 ) capacitor c=0.0288404f //x=7.135 //y=7.4
c259 ( 95 0 ) capacitor c=0.0281468f //x=6.255 //y=7.4
c260 ( 91 0 ) capacitor c=0.0275781f //x=5.38 //y=7.4
c261 ( 81 0 ) capacitor c=0.0284687f //x=4.685 //y=7.4
c262 ( 71 0 ) capacitor c=0.0288404f //x=3.805 //y=7.4
c263 ( 61 0 ) capacitor c=0.0281468f //x=2.925 //y=7.4
c264 ( 55 0 ) capacitor c=0.0210379f //x=2.05 //y=7.4
c265 ( 45 0 ) capacitor c=0.028723f //x=1.47 //y=7.4
c266 ( 21 0 ) capacitor c=0.46312f //x=11.47 //y=7.4
r267 (  151 178 ) resistor r=4.11603 //w=0.68 //l=0.17 //layer=li \
 //thickness=0.1 //x=11.43 //y=7.23 //x2=11.43 //y2=7.4
r268 (  151 189 ) resistor r=33.1979 //w=0.187 //l=0.485 //layer=li \
 //thickness=0.1 //x=11.43 //y=7.23 //x2=11.43 //y2=6.745
r269 (  148 176 ) resistor r=2.94794 //w=0.34 //l=0.085 //layer=li \
 //thickness=0.1 //x=10.635 //y=7.4 //x2=10.55 //y2=7.4
r270 (  148 150 ) resistor r=3.40616 //w=0.357 //l=0.095 //layer=li \
 //thickness=0.1 //x=10.635 //y=7.4 //x2=10.73 //y2=7.4
r271 (  147 178 ) resistor r=2.94794 //w=0.34 //l=0.085 //layer=li \
 //thickness=0.1 //x=11.345 //y=7.4 //x2=11.43 //y2=7.4
r272 (  147 150 ) resistor r=22.0504 //w=0.357 //l=0.615 //layer=li \
 //thickness=0.1 //x=11.345 //y=7.4 //x2=10.73 //y2=7.4
r273 (  141 176 ) resistor r=4.11603 //w=0.68 //l=0.17 //layer=li \
 //thickness=0.1 //x=10.55 //y=7.23 //x2=10.55 //y2=7.4
r274 (  141 188 ) resistor r=33.1979 //w=0.187 //l=0.485 //layer=li \
 //thickness=0.1 //x=10.55 //y=7.23 //x2=10.55 //y2=6.745
r275 (  140 175 ) resistor r=2.94794 //w=0.34 //l=0.085 //layer=li \
 //thickness=0.1 //x=9.755 //y=7.4 //x2=9.67 //y2=7.4
r276 (  139 176 ) resistor r=2.94794 //w=0.34 //l=0.085 //layer=li \
 //thickness=0.1 //x=10.465 //y=7.4 //x2=10.55 //y2=7.4
r277 (  139 140 ) resistor r=25.4566 //w=0.357 //l=0.71 //layer=li \
 //thickness=0.1 //x=10.465 //y=7.4 //x2=9.755 //y2=7.4
r278 (  131 175 ) resistor r=4.11603 //w=0.68 //l=0.17 //layer=li \
 //thickness=0.1 //x=9.67 //y=7.23 //x2=9.67 //y2=7.4
r279 (  131 187 ) resistor r=56.4706 //w=0.187 //l=0.825 //layer=li \
 //thickness=0.1 //x=9.67 //y=7.23 //x2=9.67 //y2=6.405
r280 (  130 173 ) resistor r=5.4201 //w=0.34 //l=0.17 //layer=li \
 //thickness=0.1 //x=9.05 //y=7.4 //x2=8.88 //y2=7.4
r281 (  129 175 ) resistor r=2.94794 //w=0.34 //l=0.085 //layer=li \
 //thickness=0.1 //x=9.585 //y=7.4 //x2=9.67 //y2=7.4
r282 (  129 130 ) resistor r=19.1821 //w=0.357 //l=0.535 //layer=li \
 //thickness=0.1 //x=9.585 //y=7.4 //x2=9.05 //y2=7.4
r283 (  126 172 ) resistor r=2.94794 //w=0.34 //l=0.085 //layer=li \
 //thickness=0.1 //x=8.185 //y=7.4 //x2=8.1 //y2=7.4
r284 (  125 173 ) resistor r=5.4201 //w=0.34 //l=0.17 //layer=li \
 //thickness=0.1 //x=8.71 //y=7.4 //x2=8.88 //y2=7.4
r285 (  125 126 ) resistor r=18.8235 //w=0.357 //l=0.525 //layer=li \
 //thickness=0.1 //x=8.71 //y=7.4 //x2=8.185 //y2=7.4
r286 (  119 172 ) resistor r=4.11603 //w=0.68 //l=0.17 //layer=li \
 //thickness=0.1 //x=8.1 //y=7.23 //x2=8.1 //y2=7.4
r287 (  119 186 ) resistor r=33.1979 //w=0.187 //l=0.485 //layer=li \
 //thickness=0.1 //x=8.1 //y=7.23 //x2=8.1 //y2=6.745
r288 (  118 170 ) resistor r=2.94794 //w=0.34 //l=0.085 //layer=li \
 //thickness=0.1 //x=7.305 //y=7.4 //x2=7.22 //y2=7.4
r289 (  117 172 ) resistor r=2.94794 //w=0.34 //l=0.085 //layer=li \
 //thickness=0.1 //x=8.015 //y=7.4 //x2=8.1 //y2=7.4
r290 (  117 118 ) resistor r=25.4566 //w=0.357 //l=0.71 //layer=li \
 //thickness=0.1 //x=8.015 //y=7.4 //x2=7.305 //y2=7.4
r291 (  111 170 ) resistor r=4.11603 //w=0.68 //l=0.17 //layer=li \
 //thickness=0.1 //x=7.22 //y=7.23 //x2=7.22 //y2=7.4
r292 (  111 185 ) resistor r=33.1979 //w=0.187 //l=0.485 //layer=li \
 //thickness=0.1 //x=7.22 //y=7.23 //x2=7.22 //y2=6.745
r293 (  108 169 ) resistor r=2.94794 //w=0.34 //l=0.085 //layer=li \
 //thickness=0.1 //x=6.425 //y=7.4 //x2=6.34 //y2=7.4
r294 (  108 110 ) resistor r=21.6919 //w=0.357 //l=0.605 //layer=li \
 //thickness=0.1 //x=6.425 //y=7.4 //x2=7.03 //y2=7.4
r295 (  107 170 ) resistor r=2.94794 //w=0.34 //l=0.085 //layer=li \
 //thickness=0.1 //x=7.135 //y=7.4 //x2=7.22 //y2=7.4
r296 (  107 110 ) resistor r=3.76471 //w=0.357 //l=0.105 //layer=li \
 //thickness=0.1 //x=7.135 //y=7.4 //x2=7.03 //y2=7.4
r297 (  99 169 ) resistor r=4.11603 //w=0.68 //l=0.17 //layer=li \
 //thickness=0.1 //x=6.34 //y=7.23 //x2=6.34 //y2=7.4
r298 (  99 184 ) resistor r=56.4706 //w=0.187 //l=0.825 //layer=li \
 //thickness=0.1 //x=6.34 //y=7.23 //x2=6.34 //y2=6.405
r299 (  96 168 ) resistor r=5.4201 //w=0.34 //l=0.17 //layer=li \
 //thickness=0.1 //x=5.72 //y=7.4 //x2=5.55 //y2=7.4
r300 (  96 98 ) resistor r=7.17087 //w=0.357 //l=0.2 //layer=li \
 //thickness=0.1 //x=5.72 //y=7.4 //x2=5.92 //y2=7.4
r301 (  95 169 ) resistor r=2.94794 //w=0.34 //l=0.085 //layer=li \
 //thickness=0.1 //x=6.255 //y=7.4 //x2=6.34 //y2=7.4
r302 (  95 98 ) resistor r=12.0112 //w=0.357 //l=0.335 //layer=li \
 //thickness=0.1 //x=6.255 //y=7.4 //x2=5.92 //y2=7.4
r303 (  92 167 ) resistor r=2.94794 //w=0.34 //l=0.085 //layer=li \
 //thickness=0.1 //x=4.855 //y=7.4 //x2=4.77 //y2=7.4
r304 (  91 168 ) resistor r=5.4201 //w=0.34 //l=0.17 //layer=li \
 //thickness=0.1 //x=5.38 //y=7.4 //x2=5.55 //y2=7.4
r305 (  91 92 ) resistor r=18.8235 //w=0.357 //l=0.525 //layer=li \
 //thickness=0.1 //x=5.38 //y=7.4 //x2=4.855 //y2=7.4
r306 (  85 167 ) resistor r=4.11603 //w=0.68 //l=0.17 //layer=li \
 //thickness=0.1 //x=4.77 //y=7.23 //x2=4.77 //y2=7.4
r307 (  85 183 ) resistor r=33.1979 //w=0.187 //l=0.485 //layer=li \
 //thickness=0.1 //x=4.77 //y=7.23 //x2=4.77 //y2=6.745
r308 (  82 166 ) resistor r=2.94794 //w=0.34 //l=0.085 //layer=li \
 //thickness=0.1 //x=3.975 //y=7.4 //x2=3.89 //y2=7.4
r309 (  82 84 ) resistor r=16.6723 //w=0.357 //l=0.465 //layer=li \
 //thickness=0.1 //x=3.975 //y=7.4 //x2=4.44 //y2=7.4
r310 (  81 167 ) resistor r=2.94794 //w=0.34 //l=0.085 //layer=li \
 //thickness=0.1 //x=4.685 //y=7.4 //x2=4.77 //y2=7.4
r311 (  81 84 ) resistor r=8.78431 //w=0.357 //l=0.245 //layer=li \
 //thickness=0.1 //x=4.685 //y=7.4 //x2=4.44 //y2=7.4
r312 (  75 166 ) resistor r=4.11603 //w=0.68 //l=0.17 //layer=li \
 //thickness=0.1 //x=3.89 //y=7.23 //x2=3.89 //y2=7.4
r313 (  75 182 ) resistor r=33.1979 //w=0.187 //l=0.485 //layer=li \
 //thickness=0.1 //x=3.89 //y=7.23 //x2=3.89 //y2=6.745
r314 (  72 165 ) resistor r=2.94794 //w=0.34 //l=0.085 //layer=li \
 //thickness=0.1 //x=3.095 //y=7.4 //x2=3.01 //y2=7.4
r315 (  72 74 ) resistor r=8.42577 //w=0.357 //l=0.235 //layer=li \
 //thickness=0.1 //x=3.095 //y=7.4 //x2=3.33 //y2=7.4
r316 (  71 166 ) resistor r=2.94794 //w=0.34 //l=0.085 //layer=li \
 //thickness=0.1 //x=3.805 //y=7.4 //x2=3.89 //y2=7.4
r317 (  71 74 ) resistor r=17.0308 //w=0.357 //l=0.475 //layer=li \
 //thickness=0.1 //x=3.805 //y=7.4 //x2=3.33 //y2=7.4
r318 (  63 165 ) resistor r=4.11603 //w=0.68 //l=0.17 //layer=li \
 //thickness=0.1 //x=3.01 //y=7.23 //x2=3.01 //y2=7.4
r319 (  63 181 ) resistor r=56.4706 //w=0.187 //l=0.825 //layer=li \
 //thickness=0.1 //x=3.01 //y=7.23 //x2=3.01 //y2=6.405
r320 (  62 164 ) resistor r=5.4201 //w=0.34 //l=0.17 //layer=li \
 //thickness=0.1 //x=2.39 //y=7.4 //x2=2.22 //y2=7.4
r321 (  61 165 ) resistor r=2.94794 //w=0.34 //l=0.085 //layer=li \
 //thickness=0.1 //x=2.925 //y=7.4 //x2=3.01 //y2=7.4
r322 (  61 62 ) resistor r=19.1821 //w=0.357 //l=0.535 //layer=li \
 //thickness=0.1 //x=2.925 //y=7.4 //x2=2.39 //y2=7.4
r323 (  56 163 ) resistor r=2.94794 //w=0.34 //l=0.085 //layer=li \
 //thickness=0.1 //x=1.64 //y=7.4 //x2=1.555 //y2=7.4
r324 (  56 58 ) resistor r=7.52941 //w=0.357 //l=0.21 //layer=li \
 //thickness=0.1 //x=1.64 //y=7.4 //x2=1.85 //y2=7.4
r325 (  55 164 ) resistor r=5.4201 //w=0.34 //l=0.17 //layer=li \
 //thickness=0.1 //x=2.05 //y=7.4 //x2=2.22 //y2=7.4
r326 (  55 58 ) resistor r=7.17087 //w=0.357 //l=0.2 //layer=li \
 //thickness=0.1 //x=2.05 //y=7.4 //x2=1.85 //y2=7.4
r327 (  47 163 ) resistor r=4.11603 //w=0.68 //l=0.17 //layer=li \
 //thickness=0.1 //x=1.555 //y=7.23 //x2=1.555 //y2=7.4
r328 (  47 180 ) resistor r=56.4706 //w=0.187 //l=0.825 //layer=li \
 //thickness=0.1 //x=1.555 //y=7.23 //x2=1.555 //y2=6.405
r329 (  46 162 ) resistor r=2.94794 //w=0.34 //l=0.085 //layer=li \
 //thickness=0.1 //x=0.76 //y=7.4 //x2=0.675 //y2=7.4
r330 (  45 163 ) resistor r=2.94794 //w=0.34 //l=0.085 //layer=li \
 //thickness=0.1 //x=1.47 //y=7.4 //x2=1.555 //y2=7.4
r331 (  45 46 ) resistor r=25.4566 //w=0.357 //l=0.71 //layer=li \
 //thickness=0.1 //x=1.47 //y=7.4 //x2=0.76 //y2=7.4
r332 (  37 162 ) resistor r=4.11603 //w=0.68 //l=0.17 //layer=li \
 //thickness=0.1 //x=0.675 //y=7.23 //x2=0.675 //y2=7.4
r333 (  37 179 ) resistor r=56.4706 //w=0.187 //l=0.825 //layer=li \
 //thickness=0.1 //x=0.675 //y=7.23 //x2=0.675 //y2=6.405
r334 (  21 178 ) resistor r=4.65 //w=0.17 //l=0.34 //layer=mcon //count=2 \
 //x=11.47 //y=7.4 //x2=11.47 //y2=7.4
r335 (  19 150 ) resistor r=3.1 //w=0.17 //l=0.51 //layer=mcon //count=3 \
 //x=10.73 //y=7.4 //x2=10.73 //y2=7.4
r336 (  19 21 ) resistor r=0.307309 //w=0.301 //l=0.74 //layer=m1 \
 //thickness=0.36 //x=10.73 //y=7.4 //x2=11.47 //y2=7.4
r337 (  17 175 ) resistor r=3.1 //w=0.17 //l=0.51 //layer=mcon //count=3 \
 //x=9.62 //y=7.4 //x2=9.62 //y2=7.4
r338 (  17 19 ) resistor r=0.460963 //w=0.301 //l=1.11 //layer=m1 \
 //thickness=0.36 //x=9.62 //y=7.4 //x2=10.73 //y2=7.4
r339 (  15 172 ) resistor r=3.1 //w=0.17 //l=0.51 //layer=mcon //count=3 \
 //x=8.14 //y=7.4 //x2=8.14 //y2=7.4
r340 (  15 17 ) resistor r=0.614618 //w=0.301 //l=1.48 //layer=m1 \
 //thickness=0.36 //x=8.14 //y=7.4 //x2=9.62 //y2=7.4
r341 (  13 110 ) resistor r=3.1 //w=0.17 //l=0.51 //layer=mcon //count=3 \
 //x=7.03 //y=7.4 //x2=7.03 //y2=7.4
r342 (  13 15 ) resistor r=0.460963 //w=0.301 //l=1.11 //layer=m1 \
 //thickness=0.36 //x=7.03 //y=7.4 //x2=8.14 //y2=7.4
r343 (  11 98 ) resistor r=3.1 //w=0.17 //l=0.51 //layer=mcon //count=3 \
 //x=5.92 //y=7.4 //x2=5.92 //y2=7.4
r344 (  11 13 ) resistor r=0.460963 //w=0.301 //l=1.11 //layer=m1 \
 //thickness=0.36 //x=5.92 //y=7.4 //x2=7.03 //y2=7.4
r345 (  9 84 ) resistor r=3.1 //w=0.17 //l=0.51 //layer=mcon //count=3 \
 //x=4.44 //y=7.4 //x2=4.44 //y2=7.4
r346 (  9 11 ) resistor r=0.614618 //w=0.301 //l=1.48 //layer=m1 \
 //thickness=0.36 //x=4.44 //y=7.4 //x2=5.92 //y2=7.4
r347 (  7 74 ) resistor r=3.1 //w=0.17 //l=0.51 //layer=mcon //count=3 \
 //x=3.33 //y=7.4 //x2=3.33 //y2=7.4
r348 (  7 9 ) resistor r=0.460963 //w=0.301 //l=1.11 //layer=m1 \
 //thickness=0.36 //x=3.33 //y=7.4 //x2=4.44 //y2=7.4
r349 (  5 58 ) resistor r=3.1 //w=0.17 //l=0.51 //layer=mcon //count=3 \
 //x=1.85 //y=7.4 //x2=1.85 //y2=7.4
r350 (  5 7 ) resistor r=0.614618 //w=0.301 //l=1.48 //layer=m1 \
 //thickness=0.36 //x=1.85 //y=7.4 //x2=3.33 //y2=7.4
r351 (  2 162 ) resistor r=3.1 //w=0.17 //l=0.51 //layer=mcon //count=3 \
 //x=0.74 //y=7.4 //x2=0.74 //y2=7.4
r352 (  2 5 ) resistor r=0.460963 //w=0.301 //l=1.11 //layer=m1 \
 //thickness=0.36 //x=0.74 //y=7.4 //x2=1.85 //y2=7.4
ends PM_MUX2X1_PCELL\%noxref_5

subckt PM_MUX2X1_PCELL\%noxref_6 ( 2 4 10 15 19 20 21 22 23 24 29 31 33 39 40 \
 42 43 46 )
c111 ( 46 0 ) capacitor c=0.0393541f //x=4.1 //y=4.7
c112 ( 43 0 ) capacitor c=0.0284095f //x=4.07 //y=1.915
c113 ( 42 0 ) capacitor c=0.0476356f //x=4.07 //y=2.08
c114 ( 40 0 ) capacitor c=0.0439708f //x=4.635 //y=1.25
c115 ( 39 0 ) capacitor c=0.0192582f //x=4.635 //y=0.905
c116 ( 33 0 ) capacitor c=0.0162526f //x=4.48 //y=1.405
c117 ( 31 0 ) capacitor c=0.0157807f //x=4.48 //y=0.75
c118 ( 29 0 ) capacitor c=0.0372668f //x=4.475 //y=4.79
c119 ( 24 0 ) capacitor c=0.0210762f //x=4.105 //y=1.56
c120 ( 23 0 ) capacitor c=0.0168511f //x=4.105 //y=1.25
c121 ( 22 0 ) capacitor c=0.0175485f //x=4.105 //y=0.905
c122 ( 21 0 ) capacitor c=0.155269f //x=4.55 //y=6.02
c123 ( 20 0 ) capacitor c=0.110375f //x=4.11 //y=6.02
c124 ( 15 0 ) capacitor c=8.9038e-19 //x=4.1 //y=4.7
c125 ( 10 0 ) capacitor c=7.72439e-19 //x=4.07 //y=2.08
c126 ( 4 0 ) capacitor c=0.00687137f //x=4.07 //y=2.08
c127 ( 2 0 ) capacitor c=0.0563391f //x=4.07 //y=4.555
r128 (  48 49 ) resistor r=32.4568 //w=0.214 //l=0.075 //layer=ply \
 //thickness=0.18 //x=4.1 //y=4.79 //x2=4.1 //y2=4.865
r129 (  46 48 ) resistor r=20.271 //w=0.214 //l=0.09 //layer=ply \
 //thickness=0.18 //x=4.1 //y=4.7 //x2=4.1 //y2=4.79
r130 (  42 43 ) resistor r=52.7279 //w=0.214 //l=0.165 //layer=ply \
 //thickness=0.18 //x=4.07 //y=2.08 //x2=4.07 //y2=1.915
r131 (  40 53 ) resistor r=45.1352 //w=0.168 //l=0.173853 //layer=ply \
 //thickness=0.18 //x=4.635 //y=1.25 //x2=4.595 //y2=1.405
r132 (  39 52 ) resistor r=45.1352 //w=0.168 //l=0.173853 //layer=ply \
 //thickness=0.18 //x=4.635 //y=0.905 //x2=4.595 //y2=0.75
r133 (  39 40 ) resistor r=176.904 //w=0.094 //l=0.345 //layer=ply \
 //thickness=0.18 //x=4.635 //y=0.905 //x2=4.635 //y2=1.25
r134 (  34 51 ) resistor r=10.701 //w=0.21 //l=0.115 //layer=ply \
 //thickness=0.18 //x=4.26 //y=1.405 //x2=4.145 //y2=1.405
r135 (  33 53 ) resistor r=5.52526 //w=0.168 //l=0.115 //layer=ply \
 //thickness=0.18 //x=4.48 //y=1.405 //x2=4.595 //y2=1.405
r136 (  32 50 ) resistor r=5.52526 //w=0.168 //l=0.115 //layer=ply \
 //thickness=0.18 //x=4.26 //y=0.75 //x2=4.145 //y2=0.75
r137 (  31 52 ) resistor r=5.52526 //w=0.168 //l=0.115 //layer=ply \
 //thickness=0.18 //x=4.48 //y=0.75 //x2=4.595 //y2=0.75
r138 (  31 32 ) resistor r=112.809 //w=0.094 //l=0.22 //layer=ply \
 //thickness=0.18 //x=4.48 //y=0.75 //x2=4.26 //y2=0.75
r139 (  30 48 ) resistor r=16.5046 //w=0.27 //l=0.135 //layer=ply \
 //thickness=0.18 //x=4.235 //y=4.79 //x2=4.1 //y2=4.79
r140 (  29 36 ) resistor r=26.9307 //w=0.15 //l=0.106066 //layer=ply \
 //thickness=0.18 //x=4.475 //y=4.79 //x2=4.55 //y2=4.865
r141 (  29 30 ) resistor r=123.064 //w=0.094 //l=0.24 //layer=ply \
 //thickness=0.18 //x=4.475 //y=4.79 //x2=4.235 //y2=4.79
r142 (  24 51 ) resistor r=39.5823 //w=0.21 //l=0.173853 //layer=ply \
 //thickness=0.18 //x=4.105 //y=1.56 //x2=4.145 //y2=1.405
r143 (  24 43 ) resistor r=182.032 //w=0.094 //l=0.355 //layer=ply \
 //thickness=0.18 //x=4.105 //y=1.56 //x2=4.105 //y2=1.915
r144 (  23 51 ) resistor r=39.5823 //w=0.21 //l=0.173853 //layer=ply \
 //thickness=0.18 //x=4.105 //y=1.25 //x2=4.145 //y2=1.405
r145 (  22 50 ) resistor r=45.1352 //w=0.168 //l=0.173853 //layer=ply \
 //thickness=0.18 //x=4.105 //y=0.905 //x2=4.145 //y2=0.75
r146 (  22 23 ) resistor r=176.904 //w=0.094 //l=0.345 //layer=ply \
 //thickness=0.18 //x=4.105 //y=0.905 //x2=4.105 //y2=1.25
r147 (  21 36 ) resistor r=592.245 //w=0.094 //l=1.155 //layer=ply \
 //thickness=0.18 //x=4.55 //y=6.02 //x2=4.55 //y2=4.865
r148 (  20 49 ) resistor r=592.245 //w=0.094 //l=1.155 //layer=ply \
 //thickness=0.18 //x=4.11 //y=6.02 //x2=4.11 //y2=4.865
r149 (  19 33 ) resistor r=56.4043 //w=0.094 //l=0.11 //layer=ply \
 //thickness=0.18 //x=4.37 //y=1.405 //x2=4.48 //y2=1.405
r150 (  19 34 ) resistor r=56.4043 //w=0.094 //l=0.11 //layer=ply \
 //thickness=0.18 //x=4.37 //y=1.405 //x2=4.26 //y2=1.405
r151 (  15 46 ) resistor r=152 //w=0.17 //l=0.17 //layer=licon //count=1 \
 //x=4.1 //y=4.7 //x2=4.1 //y2=4.7
r152 (  10 42 ) resistor r=152 //w=0.17 //l=0.17 //layer=licon //count=1 \
 //x=4.07 //y=2.08 //x2=4.07 //y2=2.08
r153 (  8 15 ) resistor r=9.3 //w=0.17 //l=0.17 //layer=mcon //count=1 //x=4.1 \
 //y=4.7 //x2=4.1 //y2=4.7
r154 (  4 10 ) resistor r=9.3 //w=0.17 //l=0.17 //layer=mcon //count=1 \
 //x=4.07 //y=2.08 //x2=4.07 //y2=2.08
r155 (  4 6 ) resistor r=0.0936408 //w=0.196 //l=0.125 //layer=m1 \
 //thickness=0.36 //x=4.072 //y=2.08 //x2=4.072 //y2=2.205
r156 (  2 8 ) resistor r=0.0878548 //w=0.228 //l=0.159295 //layer=m1 \
 //thickness=0.36 //x=4.07 //y=4.555 //x2=4.1 //y2=4.7
r157 (  2 6 ) resistor r=2.24237 //w=0.131 //l=2.35 //layer=m1 \
 //thickness=0.36 //x=4.07 //y=4.555 //x2=4.07 //y2=2.205
ends PM_MUX2X1_PCELL\%noxref_6

subckt PM_MUX2X1_PCELL\%noxref_7 ( 2 4 10 15 19 20 21 22 23 24 29 31 33 39 40 \
 42 43 46 )
c110 ( 46 0 ) capacitor c=0.0393541f //x=7.43 //y=4.7
c111 ( 43 0 ) capacitor c=0.0284095f //x=7.4 //y=1.915
c112 ( 42 0 ) capacitor c=0.0476356f //x=7.4 //y=2.08
c113 ( 40 0 ) capacitor c=0.0439708f //x=7.965 //y=1.25
c114 ( 39 0 ) capacitor c=0.0192582f //x=7.965 //y=0.905
c115 ( 33 0 ) capacitor c=0.0162526f //x=7.81 //y=1.405
c116 ( 31 0 ) capacitor c=0.0157807f //x=7.81 //y=0.75
c117 ( 29 0 ) capacitor c=0.0372668f //x=7.805 //y=4.79
c118 ( 24 0 ) capacitor c=0.0210762f //x=7.435 //y=1.56
c119 ( 23 0 ) capacitor c=0.0168511f //x=7.435 //y=1.25
c120 ( 22 0 ) capacitor c=0.0175485f //x=7.435 //y=0.905
c121 ( 21 0 ) capacitor c=0.155269f //x=7.88 //y=6.02
c122 ( 20 0 ) capacitor c=0.110375f //x=7.44 //y=6.02
c123 ( 15 0 ) capacitor c=8.9038e-19 //x=7.43 //y=4.7
c124 ( 10 0 ) capacitor c=7.72439e-19 //x=7.4 //y=2.08
c125 ( 4 0 ) capacitor c=0.00706954f //x=7.4 //y=2.08
c126 ( 2 0 ) capacitor c=0.0565329f //x=7.4 //y=4.555
r127 (  48 49 ) resistor r=32.4568 //w=0.214 //l=0.075 //layer=ply \
 //thickness=0.18 //x=7.43 //y=4.79 //x2=7.43 //y2=4.865
r128 (  46 48 ) resistor r=20.271 //w=0.214 //l=0.09 //layer=ply \
 //thickness=0.18 //x=7.43 //y=4.7 //x2=7.43 //y2=4.79
r129 (  42 43 ) resistor r=52.7279 //w=0.214 //l=0.165 //layer=ply \
 //thickness=0.18 //x=7.4 //y=2.08 //x2=7.4 //y2=1.915
r130 (  40 53 ) resistor r=45.1352 //w=0.168 //l=0.173853 //layer=ply \
 //thickness=0.18 //x=7.965 //y=1.25 //x2=7.925 //y2=1.405
r131 (  39 52 ) resistor r=45.1352 //w=0.168 //l=0.173853 //layer=ply \
 //thickness=0.18 //x=7.965 //y=0.905 //x2=7.925 //y2=0.75
r132 (  39 40 ) resistor r=176.904 //w=0.094 //l=0.345 //layer=ply \
 //thickness=0.18 //x=7.965 //y=0.905 //x2=7.965 //y2=1.25
r133 (  34 51 ) resistor r=10.701 //w=0.21 //l=0.115 //layer=ply \
 //thickness=0.18 //x=7.59 //y=1.405 //x2=7.475 //y2=1.405
r134 (  33 53 ) resistor r=5.52526 //w=0.168 //l=0.115 //layer=ply \
 //thickness=0.18 //x=7.81 //y=1.405 //x2=7.925 //y2=1.405
r135 (  32 50 ) resistor r=5.52526 //w=0.168 //l=0.115 //layer=ply \
 //thickness=0.18 //x=7.59 //y=0.75 //x2=7.475 //y2=0.75
r136 (  31 52 ) resistor r=5.52526 //w=0.168 //l=0.115 //layer=ply \
 //thickness=0.18 //x=7.81 //y=0.75 //x2=7.925 //y2=0.75
r137 (  31 32 ) resistor r=112.809 //w=0.094 //l=0.22 //layer=ply \
 //thickness=0.18 //x=7.81 //y=0.75 //x2=7.59 //y2=0.75
r138 (  30 48 ) resistor r=16.5046 //w=0.27 //l=0.135 //layer=ply \
 //thickness=0.18 //x=7.565 //y=4.79 //x2=7.43 //y2=4.79
r139 (  29 36 ) resistor r=26.9307 //w=0.15 //l=0.106066 //layer=ply \
 //thickness=0.18 //x=7.805 //y=4.79 //x2=7.88 //y2=4.865
r140 (  29 30 ) resistor r=123.064 //w=0.094 //l=0.24 //layer=ply \
 //thickness=0.18 //x=7.805 //y=4.79 //x2=7.565 //y2=4.79
r141 (  24 51 ) resistor r=39.5823 //w=0.21 //l=0.173853 //layer=ply \
 //thickness=0.18 //x=7.435 //y=1.56 //x2=7.475 //y2=1.405
r142 (  24 43 ) resistor r=182.032 //w=0.094 //l=0.355 //layer=ply \
 //thickness=0.18 //x=7.435 //y=1.56 //x2=7.435 //y2=1.915
r143 (  23 51 ) resistor r=39.5823 //w=0.21 //l=0.173853 //layer=ply \
 //thickness=0.18 //x=7.435 //y=1.25 //x2=7.475 //y2=1.405
r144 (  22 50 ) resistor r=45.1352 //w=0.168 //l=0.173853 //layer=ply \
 //thickness=0.18 //x=7.435 //y=0.905 //x2=7.475 //y2=0.75
r145 (  22 23 ) resistor r=176.904 //w=0.094 //l=0.345 //layer=ply \
 //thickness=0.18 //x=7.435 //y=0.905 //x2=7.435 //y2=1.25
r146 (  21 36 ) resistor r=592.245 //w=0.094 //l=1.155 //layer=ply \
 //thickness=0.18 //x=7.88 //y=6.02 //x2=7.88 //y2=4.865
r147 (  20 49 ) resistor r=592.245 //w=0.094 //l=1.155 //layer=ply \
 //thickness=0.18 //x=7.44 //y=6.02 //x2=7.44 //y2=4.865
r148 (  19 33 ) resistor r=56.4043 //w=0.094 //l=0.11 //layer=ply \
 //thickness=0.18 //x=7.7 //y=1.405 //x2=7.81 //y2=1.405
r149 (  19 34 ) resistor r=56.4043 //w=0.094 //l=0.11 //layer=ply \
 //thickness=0.18 //x=7.7 //y=1.405 //x2=7.59 //y2=1.405
r150 (  15 46 ) resistor r=152 //w=0.17 //l=0.17 //layer=licon //count=1 \
 //x=7.43 //y=4.7 //x2=7.43 //y2=4.7
r151 (  10 42 ) resistor r=152 //w=0.17 //l=0.17 //layer=licon //count=1 \
 //x=7.4 //y=2.08 //x2=7.4 //y2=2.08
r152 (  8 15 ) resistor r=9.3 //w=0.17 //l=0.17 //layer=mcon //count=1 \
 //x=7.43 //y=4.7 //x2=7.43 //y2=4.7
r153 (  4 10 ) resistor r=9.3 //w=0.17 //l=0.17 //layer=mcon //count=1 //x=7.4 \
 //y=2.08 //x2=7.4 //y2=2.08
r154 (  4 6 ) resistor r=0.0936408 //w=0.196 //l=0.125 //layer=m1 \
 //thickness=0.36 //x=7.402 //y=2.08 //x2=7.402 //y2=2.205
r155 (  2 8 ) resistor r=0.0878548 //w=0.228 //l=0.159295 //layer=m1 \
 //thickness=0.36 //x=7.4 //y=4.555 //x2=7.43 //y2=4.7
r156 (  2 6 ) resistor r=2.24237 //w=0.131 //l=2.35 //layer=m1 \
 //thickness=0.36 //x=7.4 //y=4.555 //x2=7.4 //y2=2.205
ends PM_MUX2X1_PCELL\%noxref_7

subckt PM_MUX2X1_PCELL\%noxref_8 ( 1 9 17 31 34 35 40 41 45 46 59 63 66 77 90 \
 112 120 131 132 133 134 135 136 137 )
c269 ( 137 0 ) capacitor c=0.00843555f //x=9.87 //y=0.865
c270 ( 136 0 ) capacitor c=0.00843555f //x=6.54 //y=0.865
c271 ( 135 0 ) capacitor c=0.00843555f //x=3.21 //y=0.865
c272 ( 134 0 ) capacitor c=0.0634793f //x=0.495 //y=0.37
c273 ( 133 0 ) capacitor c=0.117462f //x=8.88 //y=0
c274 ( 132 0 ) capacitor c=0.117411f //x=5.55 //y=0
c275 ( 131 0 ) capacitor c=0.11221f //x=2.22 //y=0
c276 ( 120 0 ) capacitor c=0.197793f //x=0.63 //y=0
c277 ( 112 0 ) capacitor c=0.315352f //x=11.47 //y=0
c278 ( 90 0 ) capacitor c=0.123883f //x=8.71 //y=0
c279 ( 77 0 ) capacitor c=0.123829f //x=5.38 //y=0
c280 ( 72 0 ) capacitor c=0.0360826f //x=1.685 //y=0
c281 ( 71 0 ) capacitor c=0.0184079f //x=2.05 //y=0
c282 ( 66 0 ) capacitor c=0.00585268f //x=1.6 //y=0.45
c283 ( 63 0 ) capacitor c=0.0061439f //x=1.515 //y=0.535
c284 ( 62 0 ) capacitor c=0.00479851f //x=1.11 //y=0.45
c285 ( 59 0 ) capacitor c=0.00599877f //x=1.025 //y=0.535
c286 ( 54 0 ) capacitor c=0.00590583f //x=0.63 //y=0.45
c287 ( 48 0 ) capacitor c=0.0050875f //x=10.06 //y=0
c288 ( 46 0 ) capacitor c=0.0232551f //x=10.057 //y=0.825
c289 ( 45 0 ) capacitor c=0.0129317f //x=10.06 //y=0.955
c290 ( 43 0 ) capacitor c=0.0050875f //x=6.73 //y=0
c291 ( 41 0 ) capacitor c=0.0188922f //x=6.727 //y=0.825
c292 ( 40 0 ) capacitor c=0.0125287f //x=6.73 //y=0.955
c293 ( 38 0 ) capacitor c=0.0050875f //x=3.33 //y=0
c294 ( 35 0 ) capacitor c=0.0235363f //x=3.397 //y=0.825
c295 ( 34 0 ) capacitor c=0.0126338f //x=3.4 //y=0.955
c296 ( 31 0 ) capacitor c=0.0847673f //x=11.47 //y=0
c297 ( 17 0 ) capacitor c=0.110597f //x=9.975 //y=0
c298 ( 9 0 ) capacitor c=0.110417f //x=6.645 //y=0
c299 ( 1 0 ) capacitor c=0.136124f //x=3.315 //y=0
r300 (  123 124 ) resistor r=17.5686 //w=0.357 //l=0.49 //layer=li \
 //thickness=0.1 //x=1.11 //y=0 //x2=1.6 //y2=0
r301 (  122 123 ) resistor r=13.2661 //w=0.357 //l=0.37 //layer=li \
 //thickness=0.1 //x=0.74 //y=0 //x2=1.11 //y2=0
r302 (  120 122 ) resistor r=3.94398 //w=0.357 //l=0.11 //layer=li \
 //thickness=0.1 //x=0.63 //y=0 //x2=0.74 //y2=0
r303 (  110 112 ) resistor r=26.5322 //w=0.357 //l=0.74 //layer=li \
 //thickness=0.1 //x=10.73 //y=0 //x2=11.47 //y2=0
r304 (  108 110 ) resistor r=39.7983 //w=0.357 //l=1.11 //layer=li \
 //thickness=0.1 //x=9.62 //y=0 //x2=10.73 //y2=0
r305 (  106 133 ) resistor r=5.4201 //w=0.34 //l=0.17 //layer=li \
 //thickness=0.1 //x=9.05 //y=0 //x2=8.88 //y2=0
r306 (  106 108 ) resistor r=20.437 //w=0.357 //l=0.57 //layer=li \
 //thickness=0.1 //x=9.05 //y=0 //x2=9.62 //y2=0
r307 (  95 97 ) resistor r=39.7983 //w=0.357 //l=1.11 //layer=li \
 //thickness=0.1 //x=7.03 //y=0 //x2=8.14 //y2=0
r308 (  93 95 ) resistor r=39.7983 //w=0.357 //l=1.11 //layer=li \
 //thickness=0.1 //x=5.92 //y=0 //x2=7.03 //y2=0
r309 (  91 132 ) resistor r=5.4201 //w=0.34 //l=0.17 //layer=li \
 //thickness=0.1 //x=5.72 //y=0 //x2=5.55 //y2=0
r310 (  91 93 ) resistor r=7.17087 //w=0.357 //l=0.2 //layer=li \
 //thickness=0.1 //x=5.72 //y=0 //x2=5.92 //y2=0
r311 (  90 133 ) resistor r=5.4201 //w=0.34 //l=0.17 //layer=li \
 //thickness=0.1 //x=8.71 //y=0 //x2=8.88 //y2=0
r312 (  90 97 ) resistor r=20.437 //w=0.357 //l=0.57 //layer=li \
 //thickness=0.1 //x=8.71 //y=0 //x2=8.14 //y2=0
r313 (  80 82 ) resistor r=39.7983 //w=0.357 //l=1.11 //layer=li \
 //thickness=0.1 //x=3.33 //y=0 //x2=4.44 //y2=0
r314 (  78 131 ) resistor r=5.4201 //w=0.34 //l=0.17 //layer=li \
 //thickness=0.1 //x=2.39 //y=0 //x2=2.22 //y2=0
r315 (  78 80 ) resistor r=33.7031 //w=0.357 //l=0.94 //layer=li \
 //thickness=0.1 //x=2.39 //y=0 //x2=3.33 //y2=0
r316 (  77 132 ) resistor r=5.4201 //w=0.34 //l=0.17 //layer=li \
 //thickness=0.1 //x=5.38 //y=0 //x2=5.55 //y2=0
r317 (  77 82 ) resistor r=33.7031 //w=0.357 //l=0.94 //layer=li \
 //thickness=0.1 //x=5.38 //y=0 //x2=4.44 //y2=0
r318 (  72 124 ) resistor r=3.04762 //w=0.357 //l=0.085 //layer=li \
 //thickness=0.1 //x=1.685 //y=0 //x2=1.6 //y2=0
r319 (  72 74 ) resistor r=5.91597 //w=0.357 //l=0.165 //layer=li \
 //thickness=0.1 //x=1.685 //y=0 //x2=1.85 //y2=0
r320 (  71 131 ) resistor r=5.4201 //w=0.34 //l=0.17 //layer=li \
 //thickness=0.1 //x=2.05 //y=0 //x2=2.22 //y2=0
r321 (  71 74 ) resistor r=7.17087 //w=0.357 //l=0.2 //layer=li \
 //thickness=0.1 //x=2.05 //y=0 //x2=1.85 //y2=0
r322 (  67 134 ) resistor r=5.4201 //w=0.17 //l=0.085 //layer=li \
 //thickness=0.1 //x=1.6 //y=0.62 //x2=1.6 //y2=0.535
r323 (  67 134 ) resistor r=41.4118 //w=0.187 //l=0.605 //layer=li \
 //thickness=0.1 //x=1.6 //y=0.62 //x2=1.6 //y2=1.225
r324 (  66 134 ) resistor r=5.4201 //w=0.17 //l=0.085 //layer=li \
 //thickness=0.1 //x=1.6 //y=0.45 //x2=1.6 //y2=0.535
r325 (  65 124 ) resistor r=5.03728 //w=0.34 //l=0.17 //layer=li \
 //thickness=0.1 //x=1.6 //y=0.17 //x2=1.6 //y2=0
r326 (  65 66 ) resistor r=19.1658 //w=0.187 //l=0.28 //layer=li \
 //thickness=0.1 //x=1.6 //y=0.17 //x2=1.6 //y2=0.45
r327 (  64 134 ) resistor r=5.4201 //w=0.17 //l=0.085 //layer=li \
 //thickness=0.1 //x=1.195 //y=0.535 //x2=1.11 //y2=0.535
r328 (  63 134 ) resistor r=1.40859 //w=0.34 //l=0.085 //layer=li \
 //thickness=0.1 //x=1.515 //y=0.535 //x2=1.6 //y2=0.535
r329 (  63 64 ) resistor r=21.9037 //w=0.187 //l=0.32 //layer=li \
 //thickness=0.1 //x=1.515 //y=0.535 //x2=1.195 //y2=0.535
r330 (  62 134 ) resistor r=1.40859 //w=0.34 //l=0.085 //layer=li \
 //thickness=0.1 //x=1.11 //y=0.45 //x2=1.11 //y2=0.535
r331 (  61 123 ) resistor r=5.03728 //w=0.34 //l=0.17 //layer=li \
 //thickness=0.1 //x=1.11 //y=0.17 //x2=1.11 //y2=0
r332 (  61 62 ) resistor r=19.1658 //w=0.187 //l=0.28 //layer=li \
 //thickness=0.1 //x=1.11 //y=0.17 //x2=1.11 //y2=0.45
r333 (  60 134 ) resistor r=1.40859 //w=0.34 //l=0.085 //layer=li \
 //thickness=0.1 //x=0.715 //y=0.535 //x2=0.63 //y2=0.535
r334 (  59 134 ) resistor r=5.4201 //w=0.17 //l=0.085 //layer=li \
 //thickness=0.1 //x=1.025 //y=0.535 //x2=1.11 //y2=0.535
r335 (  59 60 ) resistor r=21.2193 //w=0.187 //l=0.31 //layer=li \
 //thickness=0.1 //x=1.025 //y=0.535 //x2=0.715 //y2=0.535
r336 (  55 134 ) resistor r=5.4201 //w=0.17 //l=0.085 //layer=li \
 //thickness=0.1 //x=0.63 //y=0.62 //x2=0.63 //y2=0.535
r337 (  55 134 ) resistor r=41.4118 //w=0.187 //l=0.605 //layer=li \
 //thickness=0.1 //x=0.63 //y=0.62 //x2=0.63 //y2=1.225
r338 (  54 134 ) resistor r=5.4201 //w=0.17 //l=0.085 //layer=li \
 //thickness=0.1 //x=0.63 //y=0.45 //x2=0.63 //y2=0.535
r339 (  53 120 ) resistor r=5.03728 //w=0.34 //l=0.17 //layer=li \
 //thickness=0.1 //x=0.63 //y=0.17 //x2=0.63 //y2=0
r340 (  53 54 ) resistor r=19.1658 //w=0.187 //l=0.28 //layer=li \
 //thickness=0.1 //x=0.63 //y=0.17 //x2=0.63 //y2=0.45
r341 (  45 137 ) resistor r=9.3 //w=0.17 //l=0.17 //layer=mcon //count=1 \
 //x=10.06 //y=0.955 //x2=10.06 //y2=0.955
r342 (  45 46 ) resistor r=0.0939994 //w=0.226 //l=0.13 //layer=m1 \
 //thickness=0.36 //x=10.057 //y=0.955 //x2=10.057 //y2=0.825
r343 (  40 136 ) resistor r=9.3 //w=0.17 //l=0.17 //layer=mcon //count=1 \
 //x=6.73 //y=0.955 //x2=6.73 //y2=0.955
r344 (  40 41 ) resistor r=0.0939994 //w=0.226 //l=0.13 //layer=m1 \
 //thickness=0.36 //x=6.727 //y=0.955 //x2=6.727 //y2=0.825
r345 (  38 80 ) resistor r=3.1 //w=0.17 //l=0.51 //layer=mcon //count=3 \
 //x=3.33 //y=0 //x2=3.33 //y2=0
r346 (  34 135 ) resistor r=9.3 //w=0.17 //l=0.17 //layer=mcon //count=1 \
 //x=3.4 //y=0.955 //x2=3.4 //y2=0.955
r347 (  34 35 ) resistor r=0.0939994 //w=0.226 //l=0.13 //layer=m1 \
 //thickness=0.36 //x=3.397 //y=0.955 //x2=3.397 //y2=0.825
r348 (  31 112 ) resistor r=4.65 //w=0.17 //l=0.34 //layer=mcon //count=2 \
 //x=11.47 //y=0 //x2=11.47 //y2=0
r349 (  29 110 ) resistor r=3.1 //w=0.17 //l=0.51 //layer=mcon //count=3 \
 //x=10.73 //y=0 //x2=10.73 //y2=0
r350 (  29 31 ) resistor r=0.307309 //w=0.301 //l=0.74 //layer=m1 \
 //thickness=0.36 //x=10.73 //y=0 //x2=11.47 //y2=0
r351 (  27 48 ) resistor r=0.0287885 //w=0.34 //l=0.085 //layer=m1 \
 //thickness=0.36 //x=10.145 //y=0 //x2=10.06 //y2=0
r352 (  27 29 ) resistor r=0.24294 //w=0.301 //l=0.585 //layer=m1 \
 //thickness=0.36 //x=10.145 //y=0 //x2=10.73 //y2=0
r353 (  25 48 ) resistor r=0.0401957 //w=0.68 //l=0.17 //layer=m1 \
 //thickness=0.36 //x=10.06 //y=0.17 //x2=10.06 //y2=0
r354 (  25 46 ) resistor r=0.625 //w=0.131 //l=0.655 //layer=m1 \
 //thickness=0.36 //x=10.06 //y=0.17 //x2=10.06 //y2=0.825
r355 (  24 108 ) resistor r=3.1 //w=0.17 //l=0.51 //layer=mcon //count=3 \
 //x=9.62 //y=0 //x2=9.62 //y2=0
r356 (  22 97 ) resistor r=3.1 //w=0.17 //l=0.51 //layer=mcon //count=3 \
 //x=8.14 //y=0 //x2=8.14 //y2=0
r357 (  22 24 ) resistor r=0.614618 //w=0.301 //l=1.48 //layer=m1 \
 //thickness=0.36 //x=8.14 //y=0 //x2=9.62 //y2=0
r358 (  20 95 ) resistor r=3.1 //w=0.17 //l=0.51 //layer=mcon //count=3 \
 //x=7.03 //y=0 //x2=7.03 //y2=0
r359 (  20 22 ) resistor r=0.460963 //w=0.301 //l=1.11 //layer=m1 \
 //thickness=0.36 //x=7.03 //y=0 //x2=8.14 //y2=0
r360 (  18 43 ) resistor r=0.0287885 //w=0.34 //l=0.085 //layer=m1 \
 //thickness=0.36 //x=6.815 //y=0 //x2=6.73 //y2=0
r361 (  18 20 ) resistor r=0.0892857 //w=0.301 //l=0.215 //layer=m1 \
 //thickness=0.36 //x=6.815 //y=0 //x2=7.03 //y2=0
r362 (  17 48 ) resistor r=0.0287885 //w=0.34 //l=0.085 //layer=m1 \
 //thickness=0.36 //x=9.975 //y=0 //x2=10.06 //y2=0
r363 (  17 24 ) resistor r=0.147425 //w=0.301 //l=0.355 //layer=m1 \
 //thickness=0.36 //x=9.975 //y=0 //x2=9.62 //y2=0
r364 (  15 43 ) resistor r=0.0401957 //w=0.68 //l=0.17 //layer=m1 \
 //thickness=0.36 //x=6.73 //y=0.17 //x2=6.73 //y2=0
r365 (  15 41 ) resistor r=0.625 //w=0.131 //l=0.655 //layer=m1 \
 //thickness=0.36 //x=6.73 //y=0.17 //x2=6.73 //y2=0.825
r366 (  14 93 ) resistor r=3.1 //w=0.17 //l=0.51 //layer=mcon //count=3 \
 //x=5.92 //y=0 //x2=5.92 //y2=0
r367 (  12 82 ) resistor r=3.1 //w=0.17 //l=0.51 //layer=mcon //count=3 \
 //x=4.44 //y=0 //x2=4.44 //y2=0
r368 (  12 14 ) resistor r=0.614618 //w=0.301 //l=1.48 //layer=m1 \
 //thickness=0.36 //x=4.44 //y=0 //x2=5.92 //y2=0
r369 (  10 38 ) resistor r=0.0287885 //w=0.34 //l=0.085 //layer=m1 \
 //thickness=0.36 //x=3.485 //y=0 //x2=3.4 //y2=0
r370 (  10 12 ) resistor r=0.396595 //w=0.301 //l=0.955 //layer=m1 \
 //thickness=0.36 //x=3.485 //y=0 //x2=4.44 //y2=0
r371 (  9 43 ) resistor r=0.0287885 //w=0.34 //l=0.085 //layer=m1 \
 //thickness=0.36 //x=6.645 //y=0 //x2=6.73 //y2=0
r372 (  9 14 ) resistor r=0.30108 //w=0.301 //l=0.725 //layer=m1 \
 //thickness=0.36 //x=6.645 //y=0 //x2=5.92 //y2=0
r373 (  7 38 ) resistor r=0.0401957 //w=0.68 //l=0.17 //layer=m1 \
 //thickness=0.36 //x=3.4 //y=0.17 //x2=3.4 //y2=0
r374 (  7 35 ) resistor r=0.625 //w=0.131 //l=0.655 //layer=m1 \
 //thickness=0.36 //x=3.4 //y=0.17 //x2=3.4 //y2=0.825
r375 (  6 74 ) resistor r=3.1 //w=0.17 //l=0.51 //layer=mcon //count=3 \
 //x=1.85 //y=0 //x2=1.85 //y2=0
r376 (  3 122 ) resistor r=3.1 //w=0.17 //l=0.51 //layer=mcon //count=3 \
 //x=0.74 //y=0 //x2=0.74 //y2=0
r377 (  3 6 ) resistor r=0.460963 //w=0.301 //l=1.11 //layer=m1 \
 //thickness=0.36 //x=0.74 //y=0 //x2=1.85 //y2=0
r378 (  1 38 ) resistor r=0.0287885 //w=0.34 //l=0.085 //layer=m1 \
 //thickness=0.36 //x=3.315 //y=0 //x2=3.4 //y2=0
r379 (  1 6 ) resistor r=0.608389 //w=0.301 //l=1.465 //layer=m1 \
 //thickness=0.36 //x=3.315 //y=0 //x2=1.85 //y2=0
ends PM_MUX2X1_PCELL\%noxref_8

subckt PM_MUX2X1_PCELL\%noxref_9 ( 3 8 9 11 12 14 17 18 21 23 26 34 46 48 49 )
c119 ( 46 0 ) capacitor c=0.00878249f //x=10.84 //y=0.905
c120 ( 34 0 ) capacitor c=0.0326476f //x=10.99 //y=5.38
c121 ( 26 0 ) capacitor c=0.0290186f //x=10.11 //y=5.38
c122 ( 23 0 ) capacitor c=0.014893f //x=11.03 //y=1
c123 ( 21 0 ) capacitor c=6.70882e-19 //x=10.99 //y=5.38
c124 ( 18 0 ) capacitor c=0.0157742f //x=10.99 //y=5.2
c125 ( 17 0 ) capacitor c=0.00950636f //x=10.11 //y=5.38
c126 ( 14 0 ) capacitor c=0.129787f //x=11.47 //y=5.115
c127 ( 12 0 ) capacitor c=0.0069619f //x=11.115 //y=1.655
c128 ( 11 0 ) capacitor c=0.0165738f //x=11.385 //y=1.655
c129 ( 9 0 ) capacitor c=0.0143926f //x=11.385 //y=5.2
c130 ( 8 0 ) capacitor c=0.0133876f //x=11.03 //y=1.57
c131 ( 3 0 ) capacitor c=0.0145661f //x=10.875 //y=5.2
r132 (  34 49 ) resistor r=23.615 //w=0.187 //l=0.345 //layer=li \
 //thickness=0.1 //x=10.99 //y=5.38 //x2=10.99 //y2=5.725
r133 (  26 48 ) resistor r=23.615 //w=0.187 //l=0.345 //layer=li \
 //thickness=0.1 //x=10.11 //y=5.38 //x2=10.11 //y2=5.725
r134 (  23 46 ) resistor r=9.3 //w=0.17 //l=0.17 //layer=mcon //count=1 \
 //x=11.03 //y=1 //x2=11.03 //y2=1
r135 (  21 34 ) resistor r=9.3 //w=0.17 //l=0.17 //layer=mcon //count=1 \
 //x=10.99 //y=5.38 //x2=10.99 //y2=5.38
r136 (  18 21 ) resistor r=0.117801 //w=0.191 //l=0.18 //layer=m1 \
 //thickness=0.36 //x=10.99 //y=5.2 //x2=10.99 //y2=5.38
r137 (  17 26 ) resistor r=9.3 //w=0.17 //l=0.17 //layer=mcon //count=1 \
 //x=10.11 //y=5.38 //x2=10.11 //y2=5.38
r138 (  15 17 ) resistor r=0.10274 //w=0.219 //l=0.18 //layer=m1 \
 //thickness=0.36 //x=10.11 //y=5.2 //x2=10.11 //y2=5.38
r139 (  13 14 ) resistor r=3.22042 //w=0.131 //l=3.375 //layer=m1 \
 //thickness=0.36 //x=11.47 //y=1.74 //x2=11.47 //y2=5.115
r140 (  11 13 ) resistor r=0.0698411 //w=0.17 //l=0.120208 //layer=m1 \
 //thickness=0.36 //x=11.385 //y=1.655 //x2=11.47 //y2=1.74
r141 (  11 12 ) resistor r=0.257634 //w=0.131 //l=0.27 //layer=m1 \
 //thickness=0.36 //x=11.385 //y=1.655 //x2=11.115 //y2=1.655
r142 (  10 18 ) resistor r=0.0257089 //w=0.23 //l=0.115 //layer=m1 \
 //thickness=0.36 //x=11.105 //y=5.2 //x2=10.99 //y2=5.2
r143 (  9 14 ) resistor r=0.0698411 //w=0.17 //l=0.120208 //layer=m1 \
 //thickness=0.36 //x=11.385 //y=5.2 //x2=11.47 //y2=5.115
r144 (  9 10 ) resistor r=0.267176 //w=0.131 //l=0.28 //layer=m1 \
 //thickness=0.36 //x=11.385 //y=5.2 //x2=11.105 //y2=5.2
r145 (  8 12 ) resistor r=0.0698411 //w=0.17 //l=0.120208 //layer=m1 \
 //thickness=0.36 //x=11.03 //y=1.57 //x2=11.115 //y2=1.655
r146 (  7 23 ) resistor r=0.0913624 //w=0.191 //l=0.12 //layer=m1 \
 //thickness=0.36 //x=11.03 //y=1.12 //x2=11.03 //y2=1
r147 (  7 8 ) resistor r=0.429389 //w=0.131 //l=0.45 //layer=m1 \
 //thickness=0.36 //x=11.03 //y=1.12 //x2=11.03 //y2=1.57
r148 (  4 15 ) resistor r=0.0227762 //w=0.219 //l=0.115 //layer=m1 \
 //thickness=0.36 //x=10.225 //y=5.2 //x2=10.11 //y2=5.2
r149 (  3 18 ) resistor r=0.0257089 //w=0.23 //l=0.115 //layer=m1 \
 //thickness=0.36 //x=10.875 //y=5.2 //x2=10.99 //y2=5.2
r150 (  3 4 ) resistor r=0.620229 //w=0.131 //l=0.65 //layer=m1 \
 //thickness=0.36 //x=10.875 //y=5.2 //x2=10.225 //y2=5.2
ends PM_MUX2X1_PCELL\%noxref_9

subckt PM_MUX2X1_PCELL\%noxref_10 ( 1 5 9 10 13 17 29 )
c69 ( 29 0 ) capacitor c=0.0665721f //x=2.78 //y=0.365
c70 ( 17 0 ) capacitor c=0.0067865f //x=4.855 //y=0.615
c71 ( 13 0 ) capacitor c=0.0157877f //x=4.77 //y=0.53
c72 ( 10 0 ) capacitor c=0.0072478f //x=3.885 //y=1.495
c73 ( 9 0 ) capacitor c=0.00770028f //x=3.885 //y=0.615
c74 ( 5 0 ) capacitor c=0.0191851f //x=3.8 //y=1.58
c75 ( 1 0 ) capacitor c=0.00806643f //x=2.915 //y=1.495
r76 (  17 29 ) resistor r=3.57586 //w=0.17 //l=0.125 //layer=li \
 //thickness=0.1 //x=4.855 //y=0.615 //x2=4.855 //y2=0.49
r77 (  17 29 ) resistor r=18.139 //w=0.187 //l=0.265 //layer=li \
 //thickness=0.1 //x=4.855 //y=0.615 //x2=4.855 //y2=0.88
r78 (  14 29 ) resistor r=3.57586 //w=0.17 //l=0.103078 //layer=li \
 //thickness=0.1 //x=3.97 //y=0.53 //x2=3.885 //y2=0.49
r79 (  14 29 ) resistor r=27.3797 //w=0.187 //l=0.4 //layer=li //thickness=0.1 \
 //x=3.97 //y=0.53 //x2=4.37 //y2=0.53
r80 (  13 29 ) resistor r=3.57586 //w=0.17 //l=0.103078 //layer=li \
 //thickness=0.1 //x=4.77 //y=0.53 //x2=4.855 //y2=0.49
r81 (  13 29 ) resistor r=27.3797 //w=0.187 //l=0.4 //layer=li //thickness=0.1 \
 //x=4.77 //y=0.53 //x2=4.37 //y2=0.53
r82 (  10 29 ) resistor r=3.57586 //w=0.17 //l=0.125 //layer=li \
 //thickness=0.1 //x=3.885 //y=1.495 //x2=3.885 //y2=1.62
r83 (  10 29 ) resistor r=42.0963 //w=0.187 //l=0.615 //layer=li \
 //thickness=0.1 //x=3.885 //y=1.495 //x2=3.885 //y2=0.88
r84 (  9 29 ) resistor r=3.57586 //w=0.17 //l=0.125 //layer=li //thickness=0.1 \
 //x=3.885 //y=0.615 //x2=3.885 //y2=0.49
r85 (  9 29 ) resistor r=18.139 //w=0.187 //l=0.265 //layer=li //thickness=0.1 \
 //x=3.885 //y=0.615 //x2=3.885 //y2=0.88
r86 (  6 29 ) resistor r=3.57586 //w=0.17 //l=0.103078 //layer=li \
 //thickness=0.1 //x=3 //y=1.58 //x2=2.915 //y2=1.62
r87 (  6 29 ) resistor r=27.3797 //w=0.187 //l=0.4 //layer=li //thickness=0.1 \
 //x=3 //y=1.58 //x2=3.4 //y2=1.58
r88 (  5 29 ) resistor r=3.57586 //w=0.17 //l=0.103078 //layer=li \
 //thickness=0.1 //x=3.8 //y=1.58 //x2=3.885 //y2=1.62
r89 (  5 29 ) resistor r=27.3797 //w=0.187 //l=0.4 //layer=li //thickness=0.1 \
 //x=3.8 //y=1.58 //x2=3.4 //y2=1.58
r90 (  1 29 ) resistor r=3.57586 //w=0.17 //l=0.125 //layer=li //thickness=0.1 \
 //x=2.915 //y=1.495 //x2=2.915 //y2=1.62
r91 (  1 29 ) resistor r=42.0963 //w=0.187 //l=0.615 //layer=li \
 //thickness=0.1 //x=2.915 //y=1.495 //x2=2.915 //y2=0.88
ends PM_MUX2X1_PCELL\%noxref_10

subckt PM_MUX2X1_PCELL\%noxref_11 ( 1 5 9 10 13 17 29 )
c71 ( 29 0 ) capacitor c=0.0667959f //x=6.11 //y=0.365
c72 ( 17 0 ) capacitor c=0.0067865f //x=8.185 //y=0.615
c73 ( 13 0 ) capacitor c=0.0157877f //x=8.1 //y=0.53
c74 ( 10 0 ) capacitor c=0.00705387f //x=7.215 //y=1.495
c75 ( 9 0 ) capacitor c=0.00770028f //x=7.215 //y=0.615
c76 ( 5 0 ) capacitor c=0.0188663f //x=7.13 //y=1.58
c77 ( 1 0 ) capacitor c=0.00798633f //x=6.245 //y=1.495
r78 (  17 29 ) resistor r=3.57586 //w=0.17 //l=0.125 //layer=li \
 //thickness=0.1 //x=8.185 //y=0.615 //x2=8.185 //y2=0.49
r79 (  17 29 ) resistor r=18.139 //w=0.187 //l=0.265 //layer=li \
 //thickness=0.1 //x=8.185 //y=0.615 //x2=8.185 //y2=0.88
r80 (  14 29 ) resistor r=3.57586 //w=0.17 //l=0.103078 //layer=li \
 //thickness=0.1 //x=7.3 //y=0.53 //x2=7.215 //y2=0.49
r81 (  14 29 ) resistor r=27.3797 //w=0.187 //l=0.4 //layer=li //thickness=0.1 \
 //x=7.3 //y=0.53 //x2=7.7 //y2=0.53
r82 (  13 29 ) resistor r=3.57586 //w=0.17 //l=0.103078 //layer=li \
 //thickness=0.1 //x=8.1 //y=0.53 //x2=8.185 //y2=0.49
r83 (  13 29 ) resistor r=27.3797 //w=0.187 //l=0.4 //layer=li //thickness=0.1 \
 //x=8.1 //y=0.53 //x2=7.7 //y2=0.53
r84 (  10 29 ) resistor r=3.57586 //w=0.17 //l=0.125 //layer=li \
 //thickness=0.1 //x=7.215 //y=1.495 //x2=7.215 //y2=1.62
r85 (  10 29 ) resistor r=42.0963 //w=0.187 //l=0.615 //layer=li \
 //thickness=0.1 //x=7.215 //y=1.495 //x2=7.215 //y2=0.88
r86 (  9 29 ) resistor r=3.57586 //w=0.17 //l=0.125 //layer=li //thickness=0.1 \
 //x=7.215 //y=0.615 //x2=7.215 //y2=0.49
r87 (  9 29 ) resistor r=18.139 //w=0.187 //l=0.265 //layer=li //thickness=0.1 \
 //x=7.215 //y=0.615 //x2=7.215 //y2=0.88
r88 (  6 29 ) resistor r=3.57586 //w=0.17 //l=0.103078 //layer=li \
 //thickness=0.1 //x=6.33 //y=1.58 //x2=6.245 //y2=1.62
r89 (  6 29 ) resistor r=27.3797 //w=0.187 //l=0.4 //layer=li //thickness=0.1 \
 //x=6.33 //y=1.58 //x2=6.73 //y2=1.58
r90 (  5 29 ) resistor r=3.57586 //w=0.17 //l=0.103078 //layer=li \
 //thickness=0.1 //x=7.13 //y=1.58 //x2=7.215 //y2=1.62
r91 (  5 29 ) resistor r=27.3797 //w=0.187 //l=0.4 //layer=li //thickness=0.1 \
 //x=7.13 //y=1.58 //x2=6.73 //y2=1.58
r92 (  1 29 ) resistor r=3.57586 //w=0.17 //l=0.125 //layer=li //thickness=0.1 \
 //x=6.245 //y=1.495 //x2=6.245 //y2=1.62
r93 (  1 29 ) resistor r=42.0963 //w=0.187 //l=0.615 //layer=li \
 //thickness=0.1 //x=6.245 //y=1.495 //x2=6.245 //y2=0.88
ends PM_MUX2X1_PCELL\%noxref_11

subckt PM_MUX2X1_PCELL\%noxref_12 ( 1 5 9 10 13 17 29 )
c58 ( 29 0 ) capacitor c=0.0681699f //x=9.44 //y=0.365
c59 ( 17 0 ) capacitor c=0.00709791f //x=11.515 //y=0.615
c60 ( 13 0 ) capacitor c=0.0157752f //x=11.43 //y=0.53
c61 ( 10 0 ) capacitor c=0.00708541f //x=10.545 //y=1.495
c62 ( 9 0 ) capacitor c=0.00770028f //x=10.545 //y=0.615
c63 ( 5 0 ) capacitor c=0.019147f //x=10.46 //y=1.58
c64 ( 1 0 ) capacitor c=0.00798655f //x=9.575 //y=1.495
r65 (  17 29 ) resistor r=3.57586 //w=0.17 //l=0.125 //layer=li \
 //thickness=0.1 //x=11.515 //y=0.615 //x2=11.515 //y2=0.49
r66 (  17 29 ) resistor r=18.139 //w=0.187 //l=0.265 //layer=li \
 //thickness=0.1 //x=11.515 //y=0.615 //x2=11.515 //y2=0.88
r67 (  14 29 ) resistor r=3.57586 //w=0.17 //l=0.103078 //layer=li \
 //thickness=0.1 //x=10.63 //y=0.53 //x2=10.545 //y2=0.49
r68 (  14 29 ) resistor r=27.3797 //w=0.187 //l=0.4 //layer=li //thickness=0.1 \
 //x=10.63 //y=0.53 //x2=11.03 //y2=0.53
r69 (  13 29 ) resistor r=3.57586 //w=0.17 //l=0.103078 //layer=li \
 //thickness=0.1 //x=11.43 //y=0.53 //x2=11.515 //y2=0.49
r70 (  13 29 ) resistor r=27.3797 //w=0.187 //l=0.4 //layer=li //thickness=0.1 \
 //x=11.43 //y=0.53 //x2=11.03 //y2=0.53
r71 (  10 29 ) resistor r=3.57586 //w=0.17 //l=0.125 //layer=li \
 //thickness=0.1 //x=10.545 //y=1.495 //x2=10.545 //y2=1.62
r72 (  10 29 ) resistor r=42.0963 //w=0.187 //l=0.615 //layer=li \
 //thickness=0.1 //x=10.545 //y=1.495 //x2=10.545 //y2=0.88
r73 (  9 29 ) resistor r=3.57586 //w=0.17 //l=0.125 //layer=li //thickness=0.1 \
 //x=10.545 //y=0.615 //x2=10.545 //y2=0.49
r74 (  9 29 ) resistor r=18.139 //w=0.187 //l=0.265 //layer=li //thickness=0.1 \
 //x=10.545 //y=0.615 //x2=10.545 //y2=0.88
r75 (  6 29 ) resistor r=3.57586 //w=0.17 //l=0.103078 //layer=li \
 //thickness=0.1 //x=9.66 //y=1.58 //x2=9.575 //y2=1.62
r76 (  6 29 ) resistor r=27.3797 //w=0.187 //l=0.4 //layer=li //thickness=0.1 \
 //x=9.66 //y=1.58 //x2=10.06 //y2=1.58
r77 (  5 29 ) resistor r=3.57586 //w=0.17 //l=0.103078 //layer=li \
 //thickness=0.1 //x=10.46 //y=1.58 //x2=10.545 //y2=1.62
r78 (  5 29 ) resistor r=27.3797 //w=0.187 //l=0.4 //layer=li //thickness=0.1 \
 //x=10.46 //y=1.58 //x2=10.06 //y2=1.58
r79 (  1 29 ) resistor r=3.57586 //w=0.17 //l=0.125 //layer=li //thickness=0.1 \
 //x=9.575 //y=1.495 //x2=9.575 //y2=1.62
r80 (  1 29 ) resistor r=42.0963 //w=0.187 //l=0.615 //layer=li \
 //thickness=0.1 //x=9.575 //y=1.495 //x2=9.575 //y2=0.88
ends PM_MUX2X1_PCELL\%noxref_12
