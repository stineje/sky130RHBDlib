// File: AOAI4X1.spi.pex
// Created: Tue Apr 29 10:38:47 2025
// Program "Calibre xRC"
// Version "v2023.2_27.15"
// Nominal Temperature: 30C
// Circuit Temperature: 30C
//
simulator lang=spectre
subckt PM_AOAI4X1\%GND ( 1 19 23 26 31 42 47 51 59 63 66 75 88 92 112 114 115 \
 116 )
c130 ( 116 0 ) capacitor c=0.0207704f //x=8.14 //y=1.045
c131 ( 115 0 ) capacitor c=0.0699505f //x=4.38 //y=0.545
c132 ( 114 0 ) capacitor c=0.0208405f //x=1.48 //y=1.045
c133 ( 113 0 ) capacitor c=0.00446416f //x=8.33 //y=0.175
c134 ( 112 0 ) capacitor c=0.104406f //x=7.15 //y=0.175
c135 ( 92 0 ) capacitor c=0.107188f //x=3.82 //y=0.175
c136 ( 91 0 ) capacitor c=0.00446416f //x=1.67 //y=0.175
c137 ( 88 0 ) capacitor c=0.278723f //x=9.74 //y=0.18
c138 ( 75 0 ) capacitor c=0.0430284f //x=8.245 //y=0.175
c139 ( 72 0 ) capacitor c=0.0670931f //x=6.54 //y=0.175
c140 ( 71 0 ) capacitor c=0.0229116f //x=6.98 //y=0.175
c141 ( 66 0 ) capacitor c=0.00609805f //x=6.455 //y=0.625
c142 ( 63 0 ) capacitor c=0.00508078f //x=6.37 //y=0.71
c143 ( 62 0 ) capacitor c=0.00468234f //x=5.97 //y=0.625
c144 ( 59 0 ) capacitor c=0.00556167f //x=5.885 //y=0.71
c145 ( 54 0 ) capacitor c=0.00468234f //x=5.485 //y=0.625
c146 ( 51 0 ) capacitor c=0.00556167f //x=5.4 //y=0.71
c147 ( 50 0 ) capacitor c=0.00468234f //x=5 //y=0.625
c148 ( 47 0 ) capacitor c=0.00692583f //x=4.915 //y=0.71
c149 ( 42 0 ) capacitor c=0.00609805f //x=4.515 //y=0.625
c150 ( 39 0 ) capacitor c=0.0229116f //x=4.43 //y=0.175
c151 ( 31 0 ) capacitor c=0.0760254f //x=3.65 //y=0.175
c152 ( 26 0 ) capacitor c=0.198174f //x=1.23 //y=0.18
c153 ( 23 0 ) capacitor c=0.0430284f //x=1.585 //y=0.175
c154 ( 19 0 ) capacitor c=0.415118f //x=9.74 //y=0.18
r155 (  100 101 ) resistor r=14.4741 //w=0.367 //l=0.415 //layer=li \
 //thickness=0.1 //x=6.04 //y=0.175 //x2=6.455 //y2=0.175
r156 (  98 100 ) resistor r=2.44142 //w=0.367 //l=0.07 //layer=li \
 //thickness=0.1 //x=5.97 //y=0.175 //x2=6.04 //y2=0.175
r157 (  97 98 ) resistor r=16.9155 //w=0.367 //l=0.485 //layer=li \
 //thickness=0.1 //x=5.485 //y=0.175 //x2=5.97 //y2=0.175
r158 (  96 97 ) resistor r=16.9155 //w=0.367 //l=0.485 //layer=li \
 //thickness=0.1 //x=5 //y=0.175 //x2=5.485 //y2=0.175
r159 (  95 96 ) resistor r=2.44142 //w=0.367 //l=0.07 //layer=li \
 //thickness=0.1 //x=4.93 //y=0.175 //x2=5 //y2=0.175
r160 (  93 95 ) resistor r=14.4741 //w=0.367 //l=0.415 //layer=li \
 //thickness=0.1 //x=4.515 //y=0.175 //x2=4.93 //y2=0.175
r161 (  86 88 ) resistor r=38.7139 //w=0.367 //l=1.11 //layer=li \
 //thickness=0.1 //x=8.63 //y=0.175 //x2=9.74 //y2=0.175
r162 (  84 113 ) resistor r=2.87058 //w=0.35 //l=0.085 //layer=li \
 //thickness=0.1 //x=8.415 //y=0.175 //x2=8.33 //y2=0.175
r163 (  84 86 ) resistor r=7.49864 //w=0.367 //l=0.215 //layer=li \
 //thickness=0.1 //x=8.415 //y=0.175 //x2=8.63 //y2=0.175
r164 (  79 113 ) resistor r=4.23183 //w=0.7 //l=0.175 //layer=li \
 //thickness=0.1 //x=8.33 //y=0.35 //x2=8.33 //y2=0.175
r165 (  79 116 ) resistor r=53.7326 //w=0.187 //l=0.785 //layer=li \
 //thickness=0.1 //x=8.33 //y=0.35 //x2=8.33 //y2=1.135
r166 (  76 112 ) resistor r=5.29055 //w=0.35 //l=0.17 //layer=li \
 //thickness=0.1 //x=7.32 //y=0.175 //x2=7.15 //y2=0.175
r167 (  76 78 ) resistor r=6.97548 //w=0.367 //l=0.2 //layer=li \
 //thickness=0.1 //x=7.32 //y=0.175 //x2=7.52 //y2=0.175
r168 (  75 113 ) resistor r=2.87058 //w=0.35 //l=0.085 //layer=li \
 //thickness=0.1 //x=8.245 //y=0.175 //x2=8.33 //y2=0.175
r169 (  75 78 ) resistor r=25.2861 //w=0.367 //l=0.725 //layer=li \
 //thickness=0.1 //x=8.245 //y=0.175 //x2=7.52 //y2=0.175
r170 (  72 101 ) resistor r=2.96458 //w=0.367 //l=0.085 //layer=li \
 //thickness=0.1 //x=6.54 //y=0.175 //x2=6.455 //y2=0.175
r171 (  71 112 ) resistor r=5.29055 //w=0.35 //l=0.17 //layer=li \
 //thickness=0.1 //x=6.98 //y=0.175 //x2=7.15 //y2=0.175
r172 (  71 72 ) resistor r=15.346 //w=0.367 //l=0.44 //layer=li \
 //thickness=0.1 //x=6.98 //y=0.175 //x2=6.54 //y2=0.175
r173 (  67 115 ) resistor r=5.4201 //w=0.17 //l=0.085 //layer=li \
 //thickness=0.1 //x=6.455 //y=0.795 //x2=6.455 //y2=0.71
r174 (  67 115 ) resistor r=18.139 //w=0.187 //l=0.265 //layer=li \
 //thickness=0.1 //x=6.455 //y=0.795 //x2=6.455 //y2=1.06
r175 (  66 115 ) resistor r=5.4201 //w=0.17 //l=0.085 //layer=li \
 //thickness=0.1 //x=6.455 //y=0.625 //x2=6.455 //y2=0.71
r176 (  65 101 ) resistor r=5.21862 //w=0.35 //l=0.175 //layer=li \
 //thickness=0.1 //x=6.455 //y=0.35 //x2=6.455 //y2=0.175
r177 (  65 66 ) resistor r=18.8235 //w=0.187 //l=0.275 //layer=li \
 //thickness=0.1 //x=6.455 //y=0.35 //x2=6.455 //y2=0.625
r178 (  64 115 ) resistor r=5.4201 //w=0.17 //l=0.085 //layer=li \
 //thickness=0.1 //x=6.055 //y=0.71 //x2=5.97 //y2=0.71
r179 (  63 115 ) resistor r=1.40859 //w=0.34 //l=0.085 //layer=li \
 //thickness=0.1 //x=6.37 //y=0.71 //x2=6.455 //y2=0.71
r180 (  63 64 ) resistor r=21.5615 //w=0.187 //l=0.315 //layer=li \
 //thickness=0.1 //x=6.37 //y=0.71 //x2=6.055 //y2=0.71
r181 (  62 115 ) resistor r=1.40859 //w=0.34 //l=0.085 //layer=li \
 //thickness=0.1 //x=5.97 //y=0.625 //x2=5.97 //y2=0.71
r182 (  61 98 ) resistor r=5.21862 //w=0.35 //l=0.175 //layer=li \
 //thickness=0.1 //x=5.97 //y=0.35 //x2=5.97 //y2=0.175
r183 (  61 62 ) resistor r=18.8235 //w=0.187 //l=0.275 //layer=li \
 //thickness=0.1 //x=5.97 //y=0.35 //x2=5.97 //y2=0.625
r184 (  60 115 ) resistor r=6.4 //w=0.17 //l=0.085 //layer=li //thickness=0.1 \
 //x=5.57 //y=0.71 //x2=5.485 //y2=0.71
r185 (  59 115 ) resistor r=5.4201 //w=0.17 //l=0.085 //layer=li \
 //thickness=0.1 //x=5.885 //y=0.71 //x2=5.97 //y2=0.71
r186 (  59 60 ) resistor r=21.5615 //w=0.187 //l=0.315 //layer=li \
 //thickness=0.1 //x=5.885 //y=0.71 //x2=5.57 //y2=0.71
r187 (  55 115 ) resistor r=6.4 //w=0.17 //l=0.085 //layer=li //thickness=0.1 \
 //x=5.485 //y=0.795 //x2=5.485 //y2=0.71
r188 (  55 115 ) resistor r=18.139 //w=0.187 //l=0.265 //layer=li \
 //thickness=0.1 //x=5.485 //y=0.795 //x2=5.485 //y2=1.06
r189 (  54 115 ) resistor r=6.4 //w=0.17 //l=0.085 //layer=li //thickness=0.1 \
 //x=5.485 //y=0.625 //x2=5.485 //y2=0.71
r190 (  53 97 ) resistor r=5.21862 //w=0.35 //l=0.175 //layer=li \
 //thickness=0.1 //x=5.485 //y=0.35 //x2=5.485 //y2=0.175
r191 (  53 54 ) resistor r=18.8235 //w=0.187 //l=0.275 //layer=li \
 //thickness=0.1 //x=5.485 //y=0.35 //x2=5.485 //y2=0.625
r192 (  52 115 ) resistor r=5.4201 //w=0.17 //l=0.085 //layer=li \
 //thickness=0.1 //x=5.085 //y=0.71 //x2=5 //y2=0.71
r193 (  51 115 ) resistor r=6.4 //w=0.17 //l=0.085 //layer=li //thickness=0.1 \
 //x=5.4 //y=0.71 //x2=5.485 //y2=0.71
r194 (  51 52 ) resistor r=21.5615 //w=0.187 //l=0.315 //layer=li \
 //thickness=0.1 //x=5.4 //y=0.71 //x2=5.085 //y2=0.71
r195 (  50 115 ) resistor r=1.40859 //w=0.34 //l=0.085 //layer=li \
 //thickness=0.1 //x=5 //y=0.625 //x2=5 //y2=0.71
r196 (  49 96 ) resistor r=5.21862 //w=0.35 //l=0.175 //layer=li \
 //thickness=0.1 //x=5 //y=0.35 //x2=5 //y2=0.175
r197 (  49 50 ) resistor r=18.8235 //w=0.187 //l=0.275 //layer=li \
 //thickness=0.1 //x=5 //y=0.35 //x2=5 //y2=0.625
r198 (  48 115 ) resistor r=1.40859 //w=0.34 //l=0.085 //layer=li \
 //thickness=0.1 //x=4.6 //y=0.71 //x2=4.515 //y2=0.71
r199 (  47 115 ) resistor r=5.4201 //w=0.17 //l=0.085 //layer=li \
 //thickness=0.1 //x=4.915 //y=0.71 //x2=5 //y2=0.71
r200 (  47 48 ) resistor r=21.5615 //w=0.187 //l=0.315 //layer=li \
 //thickness=0.1 //x=4.915 //y=0.71 //x2=4.6 //y2=0.71
r201 (  43 115 ) resistor r=5.4201 //w=0.17 //l=0.085 //layer=li \
 //thickness=0.1 //x=4.515 //y=0.795 //x2=4.515 //y2=0.71
r202 (  43 115 ) resistor r=41.4118 //w=0.187 //l=0.605 //layer=li \
 //thickness=0.1 //x=4.515 //y=0.795 //x2=4.515 //y2=1.4
r203 (  42 115 ) resistor r=5.4201 //w=0.17 //l=0.085 //layer=li \
 //thickness=0.1 //x=4.515 //y=0.625 //x2=4.515 //y2=0.71
r204 (  41 93 ) resistor r=5.21862 //w=0.35 //l=0.175 //layer=li \
 //thickness=0.1 //x=4.515 //y=0.35 //x2=4.515 //y2=0.175
r205 (  41 42 ) resistor r=18.8235 //w=0.187 //l=0.275 //layer=li \
 //thickness=0.1 //x=4.515 //y=0.35 //x2=4.515 //y2=0.625
r206 (  40 92 ) resistor r=5.29055 //w=0.35 //l=0.17 //layer=li \
 //thickness=0.1 //x=3.99 //y=0.175 //x2=3.82 //y2=0.175
r207 (  39 93 ) resistor r=2.96458 //w=0.367 //l=0.085 //layer=li \
 //thickness=0.1 //x=4.43 //y=0.175 //x2=4.515 //y2=0.175
r208 (  39 40 ) resistor r=15.346 //w=0.367 //l=0.44 //layer=li \
 //thickness=0.1 //x=4.43 //y=0.175 //x2=3.99 //y2=0.175
r209 (  34 36 ) resistor r=38.7139 //w=0.367 //l=1.11 //layer=li \
 //thickness=0.1 //x=2.34 //y=0.175 //x2=3.45 //y2=0.175
r210 (  32 91 ) resistor r=2.87058 //w=0.35 //l=0.085 //layer=li \
 //thickness=0.1 //x=1.755 //y=0.175 //x2=1.67 //y2=0.175
r211 (  32 34 ) resistor r=20.4033 //w=0.367 //l=0.585 //layer=li \
 //thickness=0.1 //x=1.755 //y=0.175 //x2=2.34 //y2=0.175
r212 (  31 92 ) resistor r=5.29055 //w=0.35 //l=0.17 //layer=li \
 //thickness=0.1 //x=3.65 //y=0.175 //x2=3.82 //y2=0.175
r213 (  31 36 ) resistor r=6.97548 //w=0.367 //l=0.2 //layer=li \
 //thickness=0.1 //x=3.65 //y=0.175 //x2=3.45 //y2=0.175
r214 (  27 91 ) resistor r=4.23183 //w=0.7 //l=0.175 //layer=li \
 //thickness=0.1 //x=1.67 //y=0.35 //x2=1.67 //y2=0.175
r215 (  27 114 ) resistor r=53.7326 //w=0.187 //l=0.785 //layer=li \
 //thickness=0.1 //x=1.67 //y=0.35 //x2=1.67 //y2=1.135
r216 (  23 91 ) resistor r=2.87058 //w=0.35 //l=0.085 //layer=li \
 //thickness=0.1 //x=1.585 //y=0.175 //x2=1.67 //y2=0.175
r217 (  23 26 ) resistor r=12.3815 //w=0.367 //l=0.355 //layer=li \
 //thickness=0.1 //x=1.585 //y=0.175 //x2=1.23 //y2=0.175
r218 (  19 88 ) resistor r=3.1 //w=0.17 //l=0.51 //layer=mcon //count=3 \
 //x=9.74 //y=0.18 //x2=9.74 //y2=0.18
r219 (  17 86 ) resistor r=3.1 //w=0.17 //l=0.51 //layer=mcon //count=3 \
 //x=8.63 //y=0.18 //x2=8.63 //y2=0.18
r220 (  17 19 ) resistor r=0.446141 //w=0.311 //l=1.11 //layer=m1 \
 //thickness=0.36 //x=8.63 //y=0.175 //x2=9.74 //y2=0.175
r221 (  15 78 ) resistor r=3.1 //w=0.17 //l=0.51 //layer=mcon //count=3 \
 //x=7.52 //y=0.18 //x2=7.52 //y2=0.18
r222 (  15 17 ) resistor r=0.446141 //w=0.311 //l=1.11 //layer=m1 \
 //thickness=0.36 //x=7.52 //y=0.175 //x2=8.63 //y2=0.175
r223 (  13 100 ) resistor r=3.1 //w=0.17 //l=0.51 //layer=mcon //count=3 \
 //x=6.04 //y=0.18 //x2=6.04 //y2=0.18
r224 (  13 15 ) resistor r=0.594855 //w=0.311 //l=1.48 //layer=m1 \
 //thickness=0.36 //x=6.04 //y=0.175 //x2=7.52 //y2=0.175
r225 (  10 95 ) resistor r=3.1 //w=0.17 //l=0.51 //layer=mcon //count=3 \
 //x=4.93 //y=0.18 //x2=4.93 //y2=0.18
r226 (  8 36 ) resistor r=3.1 //w=0.17 //l=0.51 //layer=mcon //count=3 \
 //x=3.45 //y=0.18 //x2=3.45 //y2=0.18
r227 (  8 10 ) resistor r=0.594855 //w=0.311 //l=1.48 //layer=m1 \
 //thickness=0.36 //x=3.45 //y=0.175 //x2=4.93 //y2=0.175
r228 (  6 34 ) resistor r=3.1 //w=0.17 //l=0.51 //layer=mcon //count=3 \
 //x=2.34 //y=0.18 //x2=2.34 //y2=0.18
r229 (  6 8 ) resistor r=0.446141 //w=0.311 //l=1.11 //layer=m1 \
 //thickness=0.36 //x=2.34 //y=0.175 //x2=3.45 //y2=0.175
r230 (  3 26 ) resistor r=3.1 //w=0.17 //l=0.51 //layer=mcon //count=3 \
 //x=1.23 //y=0.18 //x2=1.23 //y2=0.18
r231 (  3 6 ) resistor r=0.446141 //w=0.311 //l=1.11 //layer=m1 \
 //thickness=0.36 //x=1.23 //y=0.175 //x2=2.34 //y2=0.175
r232 (  1 13 ) resistor r=0.223071 //w=0.311 //l=0.555 //layer=m1 \
 //thickness=0.36 //x=5.485 //y=0.175 //x2=6.04 //y2=0.175
r233 (  1 10 ) resistor r=0.223071 //w=0.311 //l=0.555 //layer=m1 \
 //thickness=0.36 //x=5.485 //y=0.175 //x2=4.93 //y2=0.175
ends PM_AOAI4X1\%GND

subckt PM_AOAI4X1\%VDD ( 1 19 31 39 55 65 81 91 104 107 109 113 114 115 116 \
 117 118 119 120 )
c115 ( 120 0 ) capacitor c=0.0383754f //x=9.555 //y=5.2
c116 ( 119 0 ) capacitor c=0.0243053f //x=8.675 //y=5.2
c117 ( 118 0 ) capacitor c=0.0531988f //x=7.805 //y=5.2
c118 ( 117 0 ) capacitor c=0.0256797f //x=4.905 //y=5.205
c119 ( 116 0 ) capacitor c=0.0383754f //x=2.895 //y=5.2
c120 ( 115 0 ) capacitor c=0.0243053f //x=2.015 //y=5.2
c121 ( 114 0 ) capacitor c=0.0531988f //x=1.145 //y=5.2
c122 ( 113 0 ) capacitor c=0.262707f //x=9.74 //y=7.58
c123 ( 111 0 ) capacitor c=0.00597439f //x=8.82 //y=7.585
c124 ( 110 0 ) capacitor c=0.00597439f //x=7.94 //y=7.585
c125 ( 109 0 ) capacitor c=0.11941f //x=7.15 //y=7.585
c126 ( 108 0 ) capacitor c=0.00597439f //x=5.05 //y=7.585
c127 ( 107 0 ) capacitor c=0.11613f //x=3.82 //y=7.585
c128 ( 106 0 ) capacitor c=0.00597439f //x=3.04 //y=7.585
c129 ( 105 0 ) capacitor c=0.00597439f //x=2.16 //y=7.585
c130 ( 104 0 ) capacitor c=0.267398f //x=1.23 //y=7.58
c131 ( 91 0 ) capacitor c=0.0287734f //x=9.615 //y=7.585
c132 ( 81 0 ) capacitor c=0.0289072f //x=8.735 //y=7.585
c133 ( 71 0 ) capacitor c=0.0283511f //x=7.855 //y=7.585
c134 ( 65 0 ) capacitor c=0.0785214f //x=6.98 //y=7.585
c135 ( 55 0 ) capacitor c=0.046953f //x=4.965 //y=7.585
c136 ( 49 0 ) capacitor c=0.0277785f //x=3.65 //y=7.585
c137 ( 39 0 ) capacitor c=0.0287734f //x=2.955 //y=7.585
c138 ( 31 0 ) capacitor c=0.0289072f //x=2.075 //y=7.585
c139 ( 19 0 ) capacitor c=0.432117f //x=9.74 //y=7.58
r140 (  93 113 ) resistor r=4.23183 //w=0.7 //l=0.175 //layer=li \
 //thickness=0.1 //x=9.7 //y=7.41 //x2=9.7 //y2=7.585
r141 (  93 120 ) resistor r=33.1979 //w=0.187 //l=0.485 //layer=li \
 //thickness=0.1 //x=9.7 //y=7.41 //x2=9.7 //y2=6.925
r142 (  92 111 ) resistor r=2.87058 //w=0.35 //l=0.085 //layer=li \
 //thickness=0.1 //x=8.905 //y=7.585 //x2=8.82 //y2=7.585
r143 (  91 113 ) resistor r=2.87058 //w=0.35 //l=0.085 //layer=li \
 //thickness=0.1 //x=9.615 //y=7.585 //x2=9.7 //y2=7.585
r144 (  91 92 ) resistor r=24.7629 //w=0.367 //l=0.71 //layer=li \
 //thickness=0.1 //x=9.615 //y=7.585 //x2=8.905 //y2=7.585
r145 (  85 111 ) resistor r=4.23183 //w=0.7 //l=0.175 //layer=li \
 //thickness=0.1 //x=8.82 //y=7.41 //x2=8.82 //y2=7.585
r146 (  85 119 ) resistor r=33.1979 //w=0.187 //l=0.485 //layer=li \
 //thickness=0.1 //x=8.82 //y=7.41 //x2=8.82 //y2=6.925
r147 (  82 110 ) resistor r=2.87058 //w=0.35 //l=0.085 //layer=li \
 //thickness=0.1 //x=8.025 //y=7.585 //x2=7.94 //y2=7.585
r148 (  82 84 ) resistor r=21.1008 //w=0.367 //l=0.605 //layer=li \
 //thickness=0.1 //x=8.025 //y=7.585 //x2=8.63 //y2=7.585
r149 (  81 111 ) resistor r=2.87058 //w=0.35 //l=0.085 //layer=li \
 //thickness=0.1 //x=8.735 //y=7.585 //x2=8.82 //y2=7.585
r150 (  81 84 ) resistor r=3.66213 //w=0.367 //l=0.105 //layer=li \
 //thickness=0.1 //x=8.735 //y=7.585 //x2=8.63 //y2=7.585
r151 (  75 110 ) resistor r=4.23183 //w=0.7 //l=0.175 //layer=li \
 //thickness=0.1 //x=7.94 //y=7.41 //x2=7.94 //y2=7.585
r152 (  75 118 ) resistor r=56.4706 //w=0.187 //l=0.825 //layer=li \
 //thickness=0.1 //x=7.94 //y=7.41 //x2=7.94 //y2=6.585
r153 (  72 109 ) resistor r=5.29055 //w=0.35 //l=0.17 //layer=li \
 //thickness=0.1 //x=7.32 //y=7.585 //x2=7.15 //y2=7.585
r154 (  72 74 ) resistor r=6.97548 //w=0.367 //l=0.2 //layer=li \
 //thickness=0.1 //x=7.32 //y=7.585 //x2=7.52 //y2=7.585
r155 (  71 110 ) resistor r=2.87058 //w=0.35 //l=0.085 //layer=li \
 //thickness=0.1 //x=7.855 //y=7.585 //x2=7.94 //y2=7.585
r156 (  71 74 ) resistor r=11.6839 //w=0.367 //l=0.335 //layer=li \
 //thickness=0.1 //x=7.855 //y=7.585 //x2=7.52 //y2=7.585
r157 (  66 108 ) resistor r=2.87058 //w=0.35 //l=0.085 //layer=li \
 //thickness=0.1 //x=5.135 //y=7.585 //x2=5.05 //y2=7.585
r158 (  66 68 ) resistor r=31.564 //w=0.367 //l=0.905 //layer=li \
 //thickness=0.1 //x=5.135 //y=7.585 //x2=6.04 //y2=7.585
r159 (  65 109 ) resistor r=5.29055 //w=0.35 //l=0.17 //layer=li \
 //thickness=0.1 //x=6.98 //y=7.585 //x2=7.15 //y2=7.585
r160 (  65 68 ) resistor r=32.7847 //w=0.367 //l=0.94 //layer=li \
 //thickness=0.1 //x=6.98 //y=7.585 //x2=6.04 //y2=7.585
r161 (  59 108 ) resistor r=4.23183 //w=0.7 //l=0.175 //layer=li \
 //thickness=0.1 //x=5.05 //y=7.41 //x2=5.05 //y2=7.585
r162 (  59 117 ) resistor r=33.5401 //w=0.187 //l=0.49 //layer=li \
 //thickness=0.1 //x=5.05 //y=7.41 //x2=5.05 //y2=6.92
r163 (  56 107 ) resistor r=5.29055 //w=0.35 //l=0.17 //layer=li \
 //thickness=0.1 //x=3.99 //y=7.585 //x2=3.82 //y2=7.585
r164 (  56 58 ) resistor r=32.7847 //w=0.367 //l=0.94 //layer=li \
 //thickness=0.1 //x=3.99 //y=7.585 //x2=4.93 //y2=7.585
r165 (  55 108 ) resistor r=2.87058 //w=0.35 //l=0.085 //layer=li \
 //thickness=0.1 //x=4.965 //y=7.585 //x2=5.05 //y2=7.585
r166 (  55 58 ) resistor r=1.22071 //w=0.367 //l=0.035 //layer=li \
 //thickness=0.1 //x=4.965 //y=7.585 //x2=4.93 //y2=7.585
r167 (  50 106 ) resistor r=2.87058 //w=0.35 //l=0.085 //layer=li \
 //thickness=0.1 //x=3.125 //y=7.585 //x2=3.04 //y2=7.585
r168 (  50 52 ) resistor r=11.3351 //w=0.367 //l=0.325 //layer=li \
 //thickness=0.1 //x=3.125 //y=7.585 //x2=3.45 //y2=7.585
r169 (  49 107 ) resistor r=5.29055 //w=0.35 //l=0.17 //layer=li \
 //thickness=0.1 //x=3.65 //y=7.585 //x2=3.82 //y2=7.585
r170 (  49 52 ) resistor r=6.97548 //w=0.367 //l=0.2 //layer=li \
 //thickness=0.1 //x=3.65 //y=7.585 //x2=3.45 //y2=7.585
r171 (  43 106 ) resistor r=4.23183 //w=0.7 //l=0.175 //layer=li \
 //thickness=0.1 //x=3.04 //y=7.41 //x2=3.04 //y2=7.585
r172 (  43 116 ) resistor r=33.1979 //w=0.187 //l=0.485 //layer=li \
 //thickness=0.1 //x=3.04 //y=7.41 //x2=3.04 //y2=6.925
r173 (  40 105 ) resistor r=2.87058 //w=0.35 //l=0.085 //layer=li \
 //thickness=0.1 //x=2.245 //y=7.585 //x2=2.16 //y2=7.585
r174 (  40 42 ) resistor r=3.31335 //w=0.367 //l=0.095 //layer=li \
 //thickness=0.1 //x=2.245 //y=7.585 //x2=2.34 //y2=7.585
r175 (  39 106 ) resistor r=2.87058 //w=0.35 //l=0.085 //layer=li \
 //thickness=0.1 //x=2.955 //y=7.585 //x2=3.04 //y2=7.585
r176 (  39 42 ) resistor r=21.4496 //w=0.367 //l=0.615 //layer=li \
 //thickness=0.1 //x=2.955 //y=7.585 //x2=2.34 //y2=7.585
r177 (  33 105 ) resistor r=4.23183 //w=0.7 //l=0.175 //layer=li \
 //thickness=0.1 //x=2.16 //y=7.41 //x2=2.16 //y2=7.585
r178 (  33 115 ) resistor r=33.1979 //w=0.187 //l=0.485 //layer=li \
 //thickness=0.1 //x=2.16 //y=7.41 //x2=2.16 //y2=6.925
r179 (  32 104 ) resistor r=2.87058 //w=0.35 //l=0.085 //layer=li \
 //thickness=0.1 //x=1.365 //y=7.585 //x2=1.28 //y2=7.585
r180 (  31 105 ) resistor r=2.87058 //w=0.35 //l=0.085 //layer=li \
 //thickness=0.1 //x=2.075 //y=7.585 //x2=2.16 //y2=7.585
r181 (  31 32 ) resistor r=24.7629 //w=0.367 //l=0.71 //layer=li \
 //thickness=0.1 //x=2.075 //y=7.585 //x2=1.365 //y2=7.585
r182 (  25 104 ) resistor r=4.23183 //w=0.7 //l=0.175 //layer=li \
 //thickness=0.1 //x=1.28 //y=7.41 //x2=1.28 //y2=7.585
r183 (  25 114 ) resistor r=56.4706 //w=0.187 //l=0.825 //layer=li \
 //thickness=0.1 //x=1.28 //y=7.41 //x2=1.28 //y2=6.585
r184 (  19 113 ) resistor r=3.1 //w=0.17 //l=0.51 //layer=mcon //count=3 \
 //x=9.74 //y=7.58 //x2=9.74 //y2=7.58
r185 (  17 84 ) resistor r=3.1 //w=0.17 //l=0.51 //layer=mcon //count=3 \
 //x=8.63 //y=7.58 //x2=8.63 //y2=7.58
r186 (  17 19 ) resistor r=0.446141 //w=0.311 //l=1.11 //layer=m1 \
 //thickness=0.36 //x=8.63 //y=7.585 //x2=9.74 //y2=7.585
r187 (  15 74 ) resistor r=3.1 //w=0.17 //l=0.51 //layer=mcon //count=3 \
 //x=7.52 //y=7.58 //x2=7.52 //y2=7.58
r188 (  15 17 ) resistor r=0.446141 //w=0.311 //l=1.11 //layer=m1 \
 //thickness=0.36 //x=7.52 //y=7.585 //x2=8.63 //y2=7.585
r189 (  13 68 ) resistor r=3.1 //w=0.17 //l=0.51 //layer=mcon //count=3 \
 //x=6.04 //y=7.58 //x2=6.04 //y2=7.58
r190 (  13 15 ) resistor r=0.594855 //w=0.311 //l=1.48 //layer=m1 \
 //thickness=0.36 //x=6.04 //y=7.585 //x2=7.52 //y2=7.585
r191 (  10 58 ) resistor r=3.1 //w=0.17 //l=0.51 //layer=mcon //count=3 \
 //x=4.93 //y=7.58 //x2=4.93 //y2=7.58
r192 (  8 52 ) resistor r=3.1 //w=0.17 //l=0.51 //layer=mcon //count=3 \
 //x=3.45 //y=7.58 //x2=3.45 //y2=7.58
r193 (  8 10 ) resistor r=0.594855 //w=0.311 //l=1.48 //layer=m1 \
 //thickness=0.36 //x=3.45 //y=7.585 //x2=4.93 //y2=7.585
r194 (  6 42 ) resistor r=3.1 //w=0.17 //l=0.51 //layer=mcon //count=3 \
 //x=2.34 //y=7.58 //x2=2.34 //y2=7.58
r195 (  6 8 ) resistor r=0.446141 //w=0.311 //l=1.11 //layer=m1 \
 //thickness=0.36 //x=2.34 //y=7.585 //x2=3.45 //y2=7.585
r196 (  3 104 ) resistor r=3.1 //w=0.17 //l=0.51 //layer=mcon //count=3 \
 //x=1.23 //y=7.58 //x2=1.23 //y2=7.58
r197 (  3 6 ) resistor r=0.446141 //w=0.311 //l=1.11 //layer=m1 \
 //thickness=0.36 //x=1.23 //y=7.585 //x2=2.34 //y2=7.585
r198 (  1 13 ) resistor r=0.223071 //w=0.311 //l=0.555 //layer=m1 \
 //thickness=0.36 //x=5.485 //y=7.585 //x2=6.04 //y2=7.585
r199 (  1 10 ) resistor r=0.223071 //w=0.311 //l=0.555 //layer=m1 \
 //thickness=0.36 //x=5.485 //y=7.585 //x2=4.93 //y2=7.585
ends PM_AOAI4X1\%VDD

subckt PM_AOAI4X1\%noxref_3 ( 1 2 13 14 25 27 28 32 35 39 41 43 44 45 46 47 48 \
 49 53 55 58 60 61 66 76 78 79 )
c144 ( 79 0 ) capacitor c=0.0220291f //x=2.455 //y=5.2
c145 ( 78 0 ) capacitor c=0.0217503f //x=1.575 //y=5.2
c146 ( 76 0 ) capacitor c=0.00865153f //x=2.45 //y=1.085
c147 ( 66 0 ) capacitor c=0.04214f //x=4.775 //y=4.885
c148 ( 61 0 ) capacitor c=0.0321911f //x=5.265 //y=1.43
c149 ( 60 0 ) capacitor c=0.0185201f //x=5.265 //y=1.085
c150 ( 58 0 ) capacitor c=0.0344254f //x=5.195 //y=4.975
c151 ( 55 0 ) capacitor c=0.0133656f //x=5.11 //y=1.585
c152 ( 53 0 ) capacitor c=0.0157804f //x=5.11 //y=0.93
c153 ( 49 0 ) capacitor c=0.0785055f //x=4.735 //y=2.095
c154 ( 48 0 ) capacitor c=0.022867f //x=4.735 //y=1.74
c155 ( 47 0 ) capacitor c=0.0234318f //x=4.735 //y=1.43
c156 ( 46 0 ) capacitor c=0.0192004f //x=4.735 //y=1.085
c157 ( 45 0 ) capacitor c=0.110795f //x=5.27 //y=6.205
c158 ( 44 0 ) capacitor c=0.153847f //x=4.83 //y=6.205
c159 ( 41 0 ) capacitor c=0.00995068f //x=4.775 //y=4.885
c160 ( 39 0 ) capacitor c=0.00427536f //x=2.6 //y=5.38
c161 ( 35 0 ) capacitor c=0.0968481f //x=4.93 //y=2.26
c162 ( 32 0 ) capacitor c=0.117241f //x=3.08 //y=2.77
c163 ( 28 0 ) capacitor c=0.00781917f //x=2.725 //y=1.835
c164 ( 27 0 ) capacitor c=0.0159132f //x=2.995 //y=1.835
c165 ( 25 0 ) capacitor c=0.017841f //x=2.995 //y=5.38
c166 ( 14 0 ) capacitor c=0.00387264f //x=1.805 //y=5.38
c167 ( 13 0 ) capacitor c=0.0222171f //x=2.515 //y=5.38
c168 ( 2 0 ) capacitor c=0.0173935f //x=3.195 //y=2.77
c169 ( 1 0 ) capacitor c=0.111807f //x=4.815 //y=2.77
r170 (  68 69 ) resistor r=32.4568 //w=0.214 //l=0.075 //layer=ply \
 //thickness=0.18 //x=4.775 //y=4.975 //x2=4.775 //y2=5.05
r171 (  66 68 ) resistor r=20.271 //w=0.214 //l=0.09 //layer=ply \
 //thickness=0.18 //x=4.775 //y=4.885 //x2=4.775 //y2=4.975
r172 (  61 75 ) resistor r=45.1352 //w=0.168 //l=0.173853 //layer=ply \
 //thickness=0.18 //x=5.265 //y=1.43 //x2=5.225 //y2=1.585
r173 (  60 74 ) resistor r=45.1352 //w=0.168 //l=0.173853 //layer=ply \
 //thickness=0.18 //x=5.265 //y=1.085 //x2=5.225 //y2=0.93
r174 (  60 61 ) resistor r=176.904 //w=0.094 //l=0.345 //layer=ply \
 //thickness=0.18 //x=5.265 //y=1.085 //x2=5.265 //y2=1.43
r175 (  59 68 ) resistor r=16.5046 //w=0.27 //l=0.135 //layer=ply \
 //thickness=0.18 //x=4.91 //y=4.975 //x2=4.775 //y2=4.975
r176 (  58 62 ) resistor r=26.9307 //w=0.15 //l=0.106066 //layer=ply \
 //thickness=0.18 //x=5.195 //y=4.975 //x2=5.27 //y2=5.05
r177 (  58 59 ) resistor r=146.138 //w=0.094 //l=0.285 //layer=ply \
 //thickness=0.18 //x=5.195 //y=4.975 //x2=4.91 //y2=4.975
r178 (  56 73 ) resistor r=10.701 //w=0.21 //l=0.115 //layer=ply \
 //thickness=0.18 //x=4.89 //y=1.585 //x2=4.775 //y2=1.585
r179 (  55 75 ) resistor r=5.52526 //w=0.168 //l=0.115 //layer=ply \
 //thickness=0.18 //x=5.11 //y=1.585 //x2=5.225 //y2=1.585
r180 (  54 72 ) resistor r=5.52526 //w=0.168 //l=0.115 //layer=ply \
 //thickness=0.18 //x=4.89 //y=0.93 //x2=4.775 //y2=0.93
r181 (  53 74 ) resistor r=5.52526 //w=0.168 //l=0.115 //layer=ply \
 //thickness=0.18 //x=5.11 //y=0.93 //x2=5.225 //y2=0.93
r182 (  53 54 ) resistor r=112.809 //w=0.094 //l=0.22 //layer=ply \
 //thickness=0.18 //x=5.11 //y=0.93 //x2=4.89 //y2=0.93
r183 (  49 71 ) resistor r=34.8111 //w=0.27 //l=0.264953 //layer=ply \
 //thickness=0.18 //x=4.735 //y=2.095 //x2=4.93 //y2=2.26
r184 (  48 73 ) resistor r=39.5823 //w=0.21 //l=0.173853 //layer=ply \
 //thickness=0.18 //x=4.735 //y=1.74 //x2=4.775 //y2=1.585
r185 (  48 49 ) resistor r=182.032 //w=0.094 //l=0.355 //layer=ply \
 //thickness=0.18 //x=4.735 //y=1.74 //x2=4.735 //y2=2.095
r186 (  47 73 ) resistor r=39.5823 //w=0.21 //l=0.173853 //layer=ply \
 //thickness=0.18 //x=4.735 //y=1.43 //x2=4.775 //y2=1.585
r187 (  46 72 ) resistor r=45.1352 //w=0.168 //l=0.173853 //layer=ply \
 //thickness=0.18 //x=4.735 //y=1.085 //x2=4.775 //y2=0.93
r188 (  46 47 ) resistor r=176.904 //w=0.094 //l=0.345 //layer=ply \
 //thickness=0.18 //x=4.735 //y=1.085 //x2=4.735 //y2=1.43
r189 (  45 62 ) resistor r=592.245 //w=0.094 //l=1.155 //layer=ply \
 //thickness=0.18 //x=5.27 //y=6.205 //x2=5.27 //y2=5.05
r190 (  44 69 ) resistor r=592.245 //w=0.094 //l=1.155 //layer=ply \
 //thickness=0.18 //x=4.83 //y=6.205 //x2=4.83 //y2=5.05
r191 (  43 55 ) resistor r=56.4043 //w=0.094 //l=0.11 //layer=ply \
 //thickness=0.18 //x=5 //y=1.585 //x2=5.11 //y2=1.585
r192 (  43 56 ) resistor r=56.4043 //w=0.094 //l=0.11 //layer=ply \
 //thickness=0.18 //x=5 //y=1.585 //x2=4.89 //y2=1.585
r193 (  41 66 ) resistor r=152 //w=0.17 //l=0.17 //layer=licon //count=1 \
 //x=4.775 //y=4.885 //x2=4.775 //y2=4.885
r194 (  41 42 ) resistor r=7.81102 //w=0.254 //l=0.155 //layer=li \
 //thickness=0.1 //x=4.775 //y=4.885 //x2=4.93 //y2=4.885
r195 (  35 71 ) resistor r=152 //w=0.17 //l=0.17 //layer=licon //count=1 \
 //x=4.93 //y=2.26 //x2=4.93 //y2=2.26
r196 (  35 38 ) resistor r=34.9091 //w=0.187 //l=0.51 //layer=li \
 //thickness=0.1 //x=4.93 //y=2.26 //x2=4.93 //y2=2.77
r197 (  33 42 ) resistor r=3.23951 //w=0.254 //l=0.165 //layer=li \
 //thickness=0.1 //x=4.93 //y=4.72 //x2=4.93 //y2=4.885
r198 (  33 38 ) resistor r=133.476 //w=0.187 //l=1.95 //layer=li \
 //thickness=0.1 //x=4.93 //y=4.72 //x2=4.93 //y2=2.77
r199 (  30 32 ) resistor r=172.834 //w=0.187 //l=2.525 //layer=li \
 //thickness=0.1 //x=3.08 //y=5.295 //x2=3.08 //y2=2.77
r200 (  29 32 ) resistor r=58.1818 //w=0.187 //l=0.85 //layer=li \
 //thickness=0.1 //x=3.08 //y=1.92 //x2=3.08 //y2=2.77
r201 (  27 29 ) resistor r=7.15173 //w=0.17 //l=0.120208 //layer=li \
 //thickness=0.1 //x=2.995 //y=1.835 //x2=3.08 //y2=1.92
r202 (  27 28 ) resistor r=18.4813 //w=0.187 //l=0.27 //layer=li \
 //thickness=0.1 //x=2.995 //y=1.835 //x2=2.725 //y2=1.835
r203 (  26 39 ) resistor r=5.4201 //w=0.17 //l=0.085 //layer=li \
 //thickness=0.1 //x=2.685 //y=5.38 //x2=2.6 //y2=5.38
r204 (  25 30 ) resistor r=7.15173 //w=0.17 //l=0.120208 //layer=li \
 //thickness=0.1 //x=2.995 //y=5.38 //x2=3.08 //y2=5.295
r205 (  25 26 ) resistor r=21.2193 //w=0.187 //l=0.31 //layer=li \
 //thickness=0.1 //x=2.995 //y=5.38 //x2=2.685 //y2=5.38
r206 (  21 28 ) resistor r=7.15173 //w=0.17 //l=0.120208 //layer=li \
 //thickness=0.1 //x=2.64 //y=1.75 //x2=2.725 //y2=1.835
r207 (  21 76 ) resistor r=39.016 //w=0.187 //l=0.57 //layer=li \
 //thickness=0.1 //x=2.64 //y=1.75 //x2=2.64 //y2=1.18
r208 (  15 39 ) resistor r=1.40859 //w=0.34 //l=0.085 //layer=li \
 //thickness=0.1 //x=2.6 //y=5.465 //x2=2.6 //y2=5.38
r209 (  15 79 ) resistor r=30.1176 //w=0.187 //l=0.44 //layer=li \
 //thickness=0.1 //x=2.6 //y=5.465 //x2=2.6 //y2=5.905
r210 (  13 39 ) resistor r=5.4201 //w=0.17 //l=0.085 //layer=li \
 //thickness=0.1 //x=2.515 //y=5.38 //x2=2.6 //y2=5.38
r211 (  13 14 ) resistor r=48.5989 //w=0.187 //l=0.71 //layer=li \
 //thickness=0.1 //x=2.515 //y=5.38 //x2=1.805 //y2=5.38
r212 (  7 14 ) resistor r=7.15173 //w=0.17 //l=0.120208 //layer=li \
 //thickness=0.1 //x=1.72 //y=5.465 //x2=1.805 //y2=5.38
r213 (  7 78 ) resistor r=30.1176 //w=0.187 //l=0.44 //layer=li \
 //thickness=0.1 //x=1.72 //y=5.465 //x2=1.72 //y2=5.905
r214 (  6 38 ) resistor r=9.3 //w=0.17 //l=0.17 //layer=mcon //count=1 \
 //x=4.93 //y=2.77 //x2=4.93 //y2=2.77
r215 (  4 32 ) resistor r=9.3 //w=0.17 //l=0.17 //layer=mcon //count=1 \
 //x=3.08 //y=2.77 //x2=3.08 //y2=2.77
r216 (  2 4 ) resistor r=0.0717383 //w=0.224 //l=0.115 //layer=m1 \
 //thickness=0.36 //x=3.195 //y=2.77 //x2=3.08 //y2=2.77
r217 (  1 6 ) resistor r=0.0717383 //w=0.224 //l=0.115 //layer=m1 \
 //thickness=0.36 //x=4.815 //y=2.77 //x2=4.93 //y2=2.77
r218 (  1 2 ) resistor r=1.5458 //w=0.131 //l=1.62 //layer=m1 //thickness=0.36 \
 //x=4.815 //y=2.77 //x2=3.195 //y2=2.77
ends PM_AOAI4X1\%noxref_3

subckt PM_AOAI4X1\%noxref_4 ( 1 2 11 12 23 24 25 30 32 40 41 42 43 44 45 46 50 \
 52 55 56 66 69 70 73 )
c141 ( 73 0 ) capacitor c=0.0159573f //x=5.785 //y=5.205
c142 ( 70 0 ) capacitor c=0.00925154f //x=5.78 //y=1.085
c143 ( 69 0 ) capacitor c=0.007684f //x=4.81 //y=1.085
c144 ( 66 0 ) capacitor c=0.0667949f //x=8.26 //y=4.88
c145 ( 56 0 ) capacitor c=0.0318948f //x=8.595 //y=1.39
c146 ( 55 0 ) capacitor c=0.0187384f //x=8.595 //y=1.045
c147 ( 52 0 ) capacitor c=0.0141798f //x=8.44 //y=1.545
c148 ( 50 0 ) capacitor c=0.0149844f //x=8.44 //y=0.89
c149 ( 46 0 ) capacitor c=0.0816272f //x=8.065 //y=2.095
c150 ( 45 0 ) capacitor c=0.0229531f //x=8.065 //y=1.7
c151 ( 44 0 ) capacitor c=0.0234352f //x=8.065 //y=1.39
c152 ( 43 0 ) capacitor c=0.0199343f //x=8.065 //y=1.045
c153 ( 42 0 ) capacitor c=0.110275f //x=8.6 //y=6.2
c154 ( 41 0 ) capacitor c=0.154305f //x=8.16 //y=6.2
c155 ( 39 0 ) capacitor c=0.00710337f //x=5.97 //y=1.835
c156 ( 32 0 ) capacitor c=0.100655f //x=8.26 //y=2.26
c157 ( 30 0 ) capacitor c=0.117944f //x=6.41 //y=2.77
c158 ( 25 0 ) capacitor c=0.0160526f //x=6.325 //y=1.835
c159 ( 24 0 ) capacitor c=0.00499395f //x=6.015 //y=5.39
c160 ( 23 0 ) capacitor c=0.0164583f //x=6.325 //y=5.39
c161 ( 12 0 ) capacitor c=0.00220849f //x=5.085 //y=1.835
c162 ( 11 0 ) capacitor c=0.0280953f //x=5.885 //y=1.835
c163 ( 2 0 ) capacitor c=0.0120303f //x=6.525 //y=2.77
c164 ( 1 0 ) capacitor c=0.117815f //x=8.145 //y=2.77
r165 (  64 66 ) resistor r=20.6867 //w=0.233 //l=0.1 //layer=ply \
 //thickness=0.18 //x=8.16 //y=4.88 //x2=8.26 //y2=4.88
r166 (  57 66 ) resistor r=70.3348 //w=0.233 //l=0.414367 //layer=ply \
 //thickness=0.18 //x=8.6 //y=5.045 //x2=8.26 //y2=4.88
r167 (  56 68 ) resistor r=45.1352 //w=0.168 //l=0.173853 //layer=ply \
 //thickness=0.18 //x=8.595 //y=1.39 //x2=8.555 //y2=1.545
r168 (  55 67 ) resistor r=45.1352 //w=0.168 //l=0.173853 //layer=ply \
 //thickness=0.18 //x=8.595 //y=1.045 //x2=8.555 //y2=0.89
r169 (  55 56 ) resistor r=176.904 //w=0.094 //l=0.345 //layer=ply \
 //thickness=0.18 //x=8.595 //y=1.045 //x2=8.595 //y2=1.39
r170 (  53 63 ) resistor r=10.701 //w=0.21 //l=0.115 //layer=ply \
 //thickness=0.18 //x=8.22 //y=1.545 //x2=8.105 //y2=1.545
r171 (  52 68 ) resistor r=5.52526 //w=0.168 //l=0.115 //layer=ply \
 //thickness=0.18 //x=8.44 //y=1.545 //x2=8.555 //y2=1.545
r172 (  51 62 ) resistor r=5.52526 //w=0.168 //l=0.115 //layer=ply \
 //thickness=0.18 //x=8.22 //y=0.89 //x2=8.105 //y2=0.89
r173 (  50 67 ) resistor r=5.52526 //w=0.168 //l=0.115 //layer=ply \
 //thickness=0.18 //x=8.44 //y=0.89 //x2=8.555 //y2=0.89
r174 (  50 51 ) resistor r=112.809 //w=0.094 //l=0.22 //layer=ply \
 //thickness=0.18 //x=8.44 //y=0.89 //x2=8.22 //y2=0.89
r175 (  47 64 ) resistor r=13.0941 //w=0.233 //l=0.165 //layer=ply \
 //thickness=0.18 //x=8.16 //y=5.045 //x2=8.16 //y2=4.88
r176 (  46 61 ) resistor r=34.8111 //w=0.27 //l=0.264953 //layer=ply \
 //thickness=0.18 //x=8.065 //y=2.095 //x2=8.26 //y2=2.26
r177 (  45 63 ) resistor r=39.5823 //w=0.21 //l=0.173853 //layer=ply \
 //thickness=0.18 //x=8.065 //y=1.7 //x2=8.105 //y2=1.545
r178 (  45 46 ) resistor r=202.543 //w=0.094 //l=0.395 //layer=ply \
 //thickness=0.18 //x=8.065 //y=1.7 //x2=8.065 //y2=2.095
r179 (  44 63 ) resistor r=39.5823 //w=0.21 //l=0.173853 //layer=ply \
 //thickness=0.18 //x=8.065 //y=1.39 //x2=8.105 //y2=1.545
r180 (  43 62 ) resistor r=45.1352 //w=0.168 //l=0.173853 //layer=ply \
 //thickness=0.18 //x=8.065 //y=1.045 //x2=8.105 //y2=0.89
r181 (  43 44 ) resistor r=176.904 //w=0.094 //l=0.345 //layer=ply \
 //thickness=0.18 //x=8.065 //y=1.045 //x2=8.065 //y2=1.39
r182 (  42 57 ) resistor r=592.245 //w=0.094 //l=1.155 //layer=ply \
 //thickness=0.18 //x=8.6 //y=6.2 //x2=8.6 //y2=5.045
r183 (  41 47 ) resistor r=592.245 //w=0.094 //l=1.155 //layer=ply \
 //thickness=0.18 //x=8.16 //y=6.2 //x2=8.16 //y2=5.045
r184 (  40 52 ) resistor r=56.4043 //w=0.094 //l=0.11 //layer=ply \
 //thickness=0.18 //x=8.33 //y=1.545 //x2=8.44 //y2=1.545
r185 (  40 53 ) resistor r=56.4043 //w=0.094 //l=0.11 //layer=ply \
 //thickness=0.18 //x=8.33 //y=1.545 //x2=8.22 //y2=1.545
r186 (  37 66 ) resistor r=152 //w=0.17 //l=0.17 //layer=licon //count=1 \
 //x=8.26 //y=4.88 //x2=8.26 //y2=4.88
r187 (  35 37 ) resistor r=144.428 //w=0.187 //l=2.11 //layer=li \
 //thickness=0.1 //x=8.26 //y=2.77 //x2=8.26 //y2=4.88
r188 (  32 61 ) resistor r=152 //w=0.17 //l=0.17 //layer=licon //count=1 \
 //x=8.26 //y=2.26 //x2=8.26 //y2=2.26
r189 (  32 35 ) resistor r=34.9091 //w=0.187 //l=0.51 //layer=li \
 //thickness=0.1 //x=8.26 //y=2.26 //x2=8.26 //y2=2.77
r190 (  28 30 ) resistor r=173.519 //w=0.187 //l=2.535 //layer=li \
 //thickness=0.1 //x=6.41 //y=5.305 //x2=6.41 //y2=2.77
r191 (  27 30 ) resistor r=58.1818 //w=0.187 //l=0.85 //layer=li \
 //thickness=0.1 //x=6.41 //y=1.92 //x2=6.41 //y2=2.77
r192 (  26 39 ) resistor r=5.4201 //w=0.17 //l=0.085 //layer=li \
 //thickness=0.1 //x=6.055 //y=1.835 //x2=5.97 //y2=1.835
r193 (  25 27 ) resistor r=7.15173 //w=0.17 //l=0.120208 //layer=li \
 //thickness=0.1 //x=6.325 //y=1.835 //x2=6.41 //y2=1.92
r194 (  25 26 ) resistor r=18.4813 //w=0.187 //l=0.27 //layer=li \
 //thickness=0.1 //x=6.325 //y=1.835 //x2=6.055 //y2=1.835
r195 (  23 28 ) resistor r=7.15173 //w=0.17 //l=0.120208 //layer=li \
 //thickness=0.1 //x=6.325 //y=5.39 //x2=6.41 //y2=5.305
r196 (  23 24 ) resistor r=21.2193 //w=0.187 //l=0.31 //layer=li \
 //thickness=0.1 //x=6.325 //y=5.39 //x2=6.015 //y2=5.39
r197 (  19 39 ) resistor r=1.40859 //w=0.34 //l=0.085 //layer=li \
 //thickness=0.1 //x=5.97 //y=1.75 //x2=5.97 //y2=1.835
r198 (  19 70 ) resistor r=39.016 //w=0.187 //l=0.57 //layer=li \
 //thickness=0.1 //x=5.97 //y=1.75 //x2=5.97 //y2=1.18
r199 (  13 24 ) resistor r=7.15173 //w=0.17 //l=0.120208 //layer=li \
 //thickness=0.1 //x=5.93 //y=5.475 //x2=6.015 //y2=5.39
r200 (  13 73 ) resistor r=29.0909 //w=0.187 //l=0.425 //layer=li \
 //thickness=0.1 //x=5.93 //y=5.475 //x2=5.93 //y2=5.9
r201 (  11 39 ) resistor r=5.4201 //w=0.17 //l=0.085 //layer=li \
 //thickness=0.1 //x=5.885 //y=1.835 //x2=5.97 //y2=1.835
r202 (  11 12 ) resistor r=54.7594 //w=0.187 //l=0.8 //layer=li \
 //thickness=0.1 //x=5.885 //y=1.835 //x2=5.085 //y2=1.835
r203 (  7 12 ) resistor r=7.15173 //w=0.17 //l=0.120208 //layer=li \
 //thickness=0.1 //x=5 //y=1.75 //x2=5.085 //y2=1.835
r204 (  7 69 ) resistor r=39.016 //w=0.187 //l=0.57 //layer=li //thickness=0.1 \
 //x=5 //y=1.75 //x2=5 //y2=1.18
r205 (  6 35 ) resistor r=9.3 //w=0.17 //l=0.17 //layer=mcon //count=1 \
 //x=8.26 //y=2.77 //x2=8.26 //y2=2.77
r206 (  4 30 ) resistor r=9.3 //w=0.17 //l=0.17 //layer=mcon //count=1 \
 //x=6.41 //y=2.77 //x2=6.41 //y2=2.77
r207 (  2 4 ) resistor r=0.0717383 //w=0.224 //l=0.115 //layer=m1 \
 //thickness=0.36 //x=6.525 //y=2.77 //x2=6.41 //y2=2.77
r208 (  1 6 ) resistor r=0.0717383 //w=0.224 //l=0.115 //layer=m1 \
 //thickness=0.36 //x=8.145 //y=2.77 //x2=8.26 //y2=2.77
r209 (  1 2 ) resistor r=1.5458 //w=0.131 //l=1.62 //layer=m1 //thickness=0.36 \
 //x=8.145 //y=2.77 //x2=6.525 //y2=2.77
ends PM_AOAI4X1\%noxref_4

subckt PM_AOAI4X1\%A ( 1 2 3 4 5 6 7 9 21 22 23 24 25 26 27 31 33 36 37 47 )
c55 ( 47 0 ) capacitor c=0.0667949f //x=1.6 //y=4.88
c56 ( 37 0 ) capacitor c=0.0318948f //x=1.935 //y=1.39
c57 ( 36 0 ) capacitor c=0.0187384f //x=1.935 //y=1.045
c58 ( 33 0 ) capacitor c=0.0141798f //x=1.78 //y=1.545
c59 ( 31 0 ) capacitor c=0.0149844f //x=1.78 //y=0.89
c60 ( 27 0 ) capacitor c=0.0860049f //x=1.405 //y=2.095
c61 ( 26 0 ) capacitor c=0.0229722f //x=1.405 //y=1.7
c62 ( 25 0 ) capacitor c=0.0234352f //x=1.405 //y=1.39
c63 ( 24 0 ) capacitor c=0.0199343f //x=1.405 //y=1.045
c64 ( 23 0 ) capacitor c=0.110275f //x=1.94 //y=6.2
c65 ( 22 0 ) capacitor c=0.154305f //x=1.5 //y=6.2
c66 ( 9 0 ) capacitor c=0.116498f //x=1.6 //y=2.26
r67 (  45 47 ) resistor r=20.6867 //w=0.233 //l=0.1 //layer=ply \
 //thickness=0.18 //x=1.5 //y=4.88 //x2=1.6 //y2=4.88
r68 (  38 47 ) resistor r=70.3348 //w=0.233 //l=0.414367 //layer=ply \
 //thickness=0.18 //x=1.94 //y=5.045 //x2=1.6 //y2=4.88
r69 (  37 49 ) resistor r=45.1352 //w=0.168 //l=0.173853 //layer=ply \
 //thickness=0.18 //x=1.935 //y=1.39 //x2=1.895 //y2=1.545
r70 (  36 48 ) resistor r=45.1352 //w=0.168 //l=0.173853 //layer=ply \
 //thickness=0.18 //x=1.935 //y=1.045 //x2=1.895 //y2=0.89
r71 (  36 37 ) resistor r=176.904 //w=0.094 //l=0.345 //layer=ply \
 //thickness=0.18 //x=1.935 //y=1.045 //x2=1.935 //y2=1.39
r72 (  34 44 ) resistor r=10.701 //w=0.21 //l=0.115 //layer=ply \
 //thickness=0.18 //x=1.56 //y=1.545 //x2=1.445 //y2=1.545
r73 (  33 49 ) resistor r=5.52526 //w=0.168 //l=0.115 //layer=ply \
 //thickness=0.18 //x=1.78 //y=1.545 //x2=1.895 //y2=1.545
r74 (  32 43 ) resistor r=5.52526 //w=0.168 //l=0.115 //layer=ply \
 //thickness=0.18 //x=1.56 //y=0.89 //x2=1.445 //y2=0.89
r75 (  31 48 ) resistor r=5.52526 //w=0.168 //l=0.115 //layer=ply \
 //thickness=0.18 //x=1.78 //y=0.89 //x2=1.895 //y2=0.89
r76 (  31 32 ) resistor r=112.809 //w=0.094 //l=0.22 //layer=ply \
 //thickness=0.18 //x=1.78 //y=0.89 //x2=1.56 //y2=0.89
r77 (  28 45 ) resistor r=13.0941 //w=0.233 //l=0.165 //layer=ply \
 //thickness=0.18 //x=1.5 //y=5.045 //x2=1.5 //y2=4.88
r78 (  27 42 ) resistor r=34.8111 //w=0.27 //l=0.264953 //layer=ply \
 //thickness=0.18 //x=1.405 //y=2.095 //x2=1.6 //y2=2.26
r79 (  26 44 ) resistor r=39.5823 //w=0.21 //l=0.173853 //layer=ply \
 //thickness=0.18 //x=1.405 //y=1.7 //x2=1.445 //y2=1.545
r80 (  26 27 ) resistor r=202.543 //w=0.094 //l=0.395 //layer=ply \
 //thickness=0.18 //x=1.405 //y=1.7 //x2=1.405 //y2=2.095
r81 (  25 44 ) resistor r=39.5823 //w=0.21 //l=0.173853 //layer=ply \
 //thickness=0.18 //x=1.405 //y=1.39 //x2=1.445 //y2=1.545
r82 (  24 43 ) resistor r=45.1352 //w=0.168 //l=0.173853 //layer=ply \
 //thickness=0.18 //x=1.405 //y=1.045 //x2=1.445 //y2=0.89
r83 (  24 25 ) resistor r=176.904 //w=0.094 //l=0.345 //layer=ply \
 //thickness=0.18 //x=1.405 //y=1.045 //x2=1.405 //y2=1.39
r84 (  23 38 ) resistor r=592.245 //w=0.094 //l=1.155 //layer=ply \
 //thickness=0.18 //x=1.94 //y=6.2 //x2=1.94 //y2=5.045
r85 (  22 28 ) resistor r=592.245 //w=0.094 //l=1.155 //layer=ply \
 //thickness=0.18 //x=1.5 //y=6.2 //x2=1.5 //y2=5.045
r86 (  21 33 ) resistor r=56.4043 //w=0.094 //l=0.11 //layer=ply \
 //thickness=0.18 //x=1.67 //y=1.545 //x2=1.78 //y2=1.545
r87 (  21 34 ) resistor r=56.4043 //w=0.094 //l=0.11 //layer=ply \
 //thickness=0.18 //x=1.67 //y=1.545 //x2=1.56 //y2=1.545
r88 (  19 47 ) resistor r=152 //w=0.17 //l=0.17 //layer=licon //count=1 \
 //x=1.6 //y=4.88 //x2=1.6 //y2=4.88
r89 (  9 42 ) resistor r=152 //w=0.17 //l=0.17 //layer=licon //count=1 //x=1.6 \
 //y=2.26 //x2=1.6 //y2=2.26
r90 (  7 19 ) resistor r=17.7968 //w=0.187 //l=0.26 //layer=li //thickness=0.1 \
 //x=1.6 //y=4.62 //x2=1.6 //y2=4.88
r91 (  6 7 ) resistor r=25.3262 //w=0.187 //l=0.37 //layer=li //thickness=0.1 \
 //x=1.6 //y=4.25 //x2=1.6 //y2=4.62
r92 (  5 6 ) resistor r=25.3262 //w=0.187 //l=0.37 //layer=li //thickness=0.1 \
 //x=1.6 //y=3.88 //x2=1.6 //y2=4.25
r93 (  4 5 ) resistor r=25.3262 //w=0.187 //l=0.37 //layer=li //thickness=0.1 \
 //x=1.6 //y=3.51 //x2=1.6 //y2=3.88
r94 (  3 4 ) resistor r=25.3262 //w=0.187 //l=0.37 //layer=li //thickness=0.1 \
 //x=1.6 //y=3.14 //x2=1.6 //y2=3.51
r95 (  2 3 ) resistor r=25.3262 //w=0.187 //l=0.37 //layer=li //thickness=0.1 \
 //x=1.6 //y=2.77 //x2=1.6 //y2=3.14
r96 (  1 2 ) resistor r=25.3262 //w=0.187 //l=0.37 //layer=li //thickness=0.1 \
 //x=1.6 //y=2.4 //x2=1.6 //y2=2.77
r97 (  1 9 ) resistor r=9.58289 //w=0.187 //l=0.14 //layer=li //thickness=0.1 \
 //x=1.6 //y=2.4 //x2=1.6 //y2=2.26
ends PM_AOAI4X1\%A

subckt PM_AOAI4X1\%B ( 1 2 3 4 5 6 7 8 10 21 22 23 24 25 26 31 33 35 41 42 44 \
 45 48 )
c64 ( 48 0 ) capacitor c=0.034715f //x=2.37 //y=4.88
c65 ( 45 0 ) capacitor c=0.0279499f //x=2.34 //y=2.095
c66 ( 44 0 ) capacitor c=0.0437302f //x=2.34 //y=2.26
c67 ( 42 0 ) capacitor c=0.0429696f //x=2.905 //y=1.43
c68 ( 41 0 ) capacitor c=0.0192208f //x=2.905 //y=1.085
c69 ( 35 0 ) capacitor c=0.0158629f //x=2.75 //y=1.585
c70 ( 33 0 ) capacitor c=0.0157803f //x=2.75 //y=0.93
c71 ( 31 0 ) capacitor c=0.0366192f //x=2.745 //y=4.97
c72 ( 26 0 ) capacitor c=0.0205163f //x=2.375 //y=1.74
c73 ( 25 0 ) capacitor c=0.0168481f //x=2.375 //y=1.43
c74 ( 24 0 ) capacitor c=0.0174783f //x=2.375 //y=1.085
c75 ( 23 0 ) capacitor c=0.15358f //x=2.82 //y=6.2
c76 ( 22 0 ) capacitor c=0.110281f //x=2.38 //y=6.2
c77 ( 10 0 ) capacitor c=0.0813556f //x=2.34 //y=2.26
c78 ( 8 0 ) capacitor c=0.00453889f //x=2.34 //y=4.715
r79 (  50 51 ) resistor r=32.4568 //w=0.214 //l=0.075 //layer=ply \
 //thickness=0.18 //x=2.37 //y=4.97 //x2=2.37 //y2=5.045
r80 (  48 50 ) resistor r=20.271 //w=0.214 //l=0.09 //layer=ply \
 //thickness=0.18 //x=2.37 //y=4.88 //x2=2.37 //y2=4.97
r81 (  44 45 ) resistor r=52.7279 //w=0.214 //l=0.165 //layer=ply \
 //thickness=0.18 //x=2.34 //y=2.26 //x2=2.34 //y2=2.095
r82 (  42 55 ) resistor r=45.1352 //w=0.168 //l=0.173853 //layer=ply \
 //thickness=0.18 //x=2.905 //y=1.43 //x2=2.865 //y2=1.585
r83 (  41 54 ) resistor r=45.1352 //w=0.168 //l=0.173853 //layer=ply \
 //thickness=0.18 //x=2.905 //y=1.085 //x2=2.865 //y2=0.93
r84 (  41 42 ) resistor r=176.904 //w=0.094 //l=0.345 //layer=ply \
 //thickness=0.18 //x=2.905 //y=1.085 //x2=2.905 //y2=1.43
r85 (  36 53 ) resistor r=10.701 //w=0.21 //l=0.115 //layer=ply \
 //thickness=0.18 //x=2.53 //y=1.585 //x2=2.415 //y2=1.585
r86 (  35 55 ) resistor r=5.52526 //w=0.168 //l=0.115 //layer=ply \
 //thickness=0.18 //x=2.75 //y=1.585 //x2=2.865 //y2=1.585
r87 (  34 52 ) resistor r=5.52526 //w=0.168 //l=0.115 //layer=ply \
 //thickness=0.18 //x=2.53 //y=0.93 //x2=2.415 //y2=0.93
r88 (  33 54 ) resistor r=5.52526 //w=0.168 //l=0.115 //layer=ply \
 //thickness=0.18 //x=2.75 //y=0.93 //x2=2.865 //y2=0.93
r89 (  33 34 ) resistor r=112.809 //w=0.094 //l=0.22 //layer=ply \
 //thickness=0.18 //x=2.75 //y=0.93 //x2=2.53 //y2=0.93
r90 (  32 50 ) resistor r=16.5046 //w=0.27 //l=0.135 //layer=ply \
 //thickness=0.18 //x=2.505 //y=4.97 //x2=2.37 //y2=4.97
r91 (  31 38 ) resistor r=26.9307 //w=0.15 //l=0.106066 //layer=ply \
 //thickness=0.18 //x=2.745 //y=4.97 //x2=2.82 //y2=5.045
r92 (  31 32 ) resistor r=123.064 //w=0.094 //l=0.24 //layer=ply \
 //thickness=0.18 //x=2.745 //y=4.97 //x2=2.505 //y2=4.97
r93 (  26 53 ) resistor r=39.5823 //w=0.21 //l=0.173853 //layer=ply \
 //thickness=0.18 //x=2.375 //y=1.74 //x2=2.415 //y2=1.585
r94 (  26 45 ) resistor r=182.032 //w=0.094 //l=0.355 //layer=ply \
 //thickness=0.18 //x=2.375 //y=1.74 //x2=2.375 //y2=2.095
r95 (  25 53 ) resistor r=39.5823 //w=0.21 //l=0.173853 //layer=ply \
 //thickness=0.18 //x=2.375 //y=1.43 //x2=2.415 //y2=1.585
r96 (  24 52 ) resistor r=45.1352 //w=0.168 //l=0.173853 //layer=ply \
 //thickness=0.18 //x=2.375 //y=1.085 //x2=2.415 //y2=0.93
r97 (  24 25 ) resistor r=176.904 //w=0.094 //l=0.345 //layer=ply \
 //thickness=0.18 //x=2.375 //y=1.085 //x2=2.375 //y2=1.43
r98 (  23 38 ) resistor r=592.245 //w=0.094 //l=1.155 //layer=ply \
 //thickness=0.18 //x=2.82 //y=6.2 //x2=2.82 //y2=5.045
r99 (  22 51 ) resistor r=592.245 //w=0.094 //l=1.155 //layer=ply \
 //thickness=0.18 //x=2.38 //y=6.2 //x2=2.38 //y2=5.045
r100 (  21 35 ) resistor r=56.4043 //w=0.094 //l=0.11 //layer=ply \
 //thickness=0.18 //x=2.64 //y=1.585 //x2=2.75 //y2=1.585
r101 (  21 36 ) resistor r=56.4043 //w=0.094 //l=0.11 //layer=ply \
 //thickness=0.18 //x=2.64 //y=1.585 //x2=2.53 //y2=1.585
r102 (  20 48 ) resistor r=152 //w=0.17 //l=0.17 //layer=licon //count=1 \
 //x=2.37 //y=4.88 //x2=2.37 //y2=4.88
r103 (  10 44 ) resistor r=152 //w=0.17 //l=0.17 //layer=licon //count=1 \
 //x=2.34 //y=2.26 //x2=2.34 //y2=2.26
r104 (  8 20 ) resistor r=11.4737 //w=0.186 //l=0.172337 //layer=li \
 //thickness=0.1 //x=2.34 //y=4.715 //x2=2.355 //y2=4.88
r105 (  7 8 ) resistor r=6.50267 //w=0.187 //l=0.095 //layer=li \
 //thickness=0.1 //x=2.34 //y=4.62 //x2=2.34 //y2=4.715
r106 (  6 7 ) resistor r=25.3262 //w=0.187 //l=0.37 //layer=li //thickness=0.1 \
 //x=2.34 //y=4.25 //x2=2.34 //y2=4.62
r107 (  5 6 ) resistor r=25.3262 //w=0.187 //l=0.37 //layer=li //thickness=0.1 \
 //x=2.34 //y=3.88 //x2=2.34 //y2=4.25
r108 (  4 5 ) resistor r=25.3262 //w=0.187 //l=0.37 //layer=li //thickness=0.1 \
 //x=2.34 //y=3.51 //x2=2.34 //y2=3.88
r109 (  3 4 ) resistor r=25.3262 //w=0.187 //l=0.37 //layer=li //thickness=0.1 \
 //x=2.34 //y=3.14 //x2=2.34 //y2=3.51
r110 (  2 3 ) resistor r=25.3262 //w=0.187 //l=0.37 //layer=li //thickness=0.1 \
 //x=2.34 //y=2.77 //x2=2.34 //y2=3.14
r111 (  1 2 ) resistor r=25.3262 //w=0.187 //l=0.37 //layer=li //thickness=0.1 \
 //x=2.34 //y=2.4 //x2=2.34 //y2=2.77
r112 (  1 10 ) resistor r=9.58289 //w=0.187 //l=0.14 //layer=li \
 //thickness=0.1 //x=2.34 //y=2.4 //x2=2.34 //y2=2.26
ends PM_AOAI4X1\%B

subckt PM_AOAI4X1\%noxref_7 ( 1 5 9 10 13 17 29 )
c51 ( 29 0 ) capacitor c=0.0632971f //x=1.05 //y=0.545
c52 ( 17 0 ) capacitor c=0.00722223f //x=3.125 //y=0.795
c53 ( 13 0 ) capacitor c=0.0154397f //x=3.04 //y=0.71
c54 ( 10 0 ) capacitor c=0.0092508f //x=2.155 //y=1.675
c55 ( 9 0 ) capacitor c=0.006761f //x=2.155 //y=0.795
c56 ( 5 0 ) capacitor c=0.0255599f //x=2.07 //y=1.76
c57 ( 1 0 ) capacitor c=0.0113547f //x=1.185 //y=1.675
r58 (  17 29 ) resistor r=3.57586 //w=0.17 //l=0.125 //layer=li \
 //thickness=0.1 //x=3.125 //y=0.795 //x2=3.125 //y2=0.67
r59 (  17 29 ) resistor r=18.139 //w=0.187 //l=0.265 //layer=li \
 //thickness=0.1 //x=3.125 //y=0.795 //x2=3.125 //y2=1.06
r60 (  14 29 ) resistor r=3.57586 //w=0.17 //l=0.103078 //layer=li \
 //thickness=0.1 //x=2.24 //y=0.71 //x2=2.155 //y2=0.67
r61 (  14 29 ) resistor r=27.3797 //w=0.187 //l=0.4 //layer=li //thickness=0.1 \
 //x=2.24 //y=0.71 //x2=2.64 //y2=0.71
r62 (  13 29 ) resistor r=3.57586 //w=0.17 //l=0.103078 //layer=li \
 //thickness=0.1 //x=3.04 //y=0.71 //x2=3.125 //y2=0.67
r63 (  13 29 ) resistor r=27.3797 //w=0.187 //l=0.4 //layer=li //thickness=0.1 \
 //x=3.04 //y=0.71 //x2=2.64 //y2=0.71
r64 (  10 29 ) resistor r=3.57586 //w=0.17 //l=0.125 //layer=li \
 //thickness=0.1 //x=2.155 //y=1.675 //x2=2.155 //y2=1.8
r65 (  10 29 ) resistor r=42.0963 //w=0.187 //l=0.615 //layer=li \
 //thickness=0.1 //x=2.155 //y=1.675 //x2=2.155 //y2=1.06
r66 (  9 29 ) resistor r=3.57586 //w=0.17 //l=0.125 //layer=li //thickness=0.1 \
 //x=2.155 //y=0.795 //x2=2.155 //y2=0.67
r67 (  9 29 ) resistor r=18.139 //w=0.187 //l=0.265 //layer=li //thickness=0.1 \
 //x=2.155 //y=0.795 //x2=2.155 //y2=1.06
r68 (  6 29 ) resistor r=3.57586 //w=0.17 //l=0.103078 //layer=li \
 //thickness=0.1 //x=1.27 //y=1.76 //x2=1.185 //y2=1.8
r69 (  6 29 ) resistor r=27.3797 //w=0.187 //l=0.4 //layer=li //thickness=0.1 \
 //x=1.27 //y=1.76 //x2=1.67 //y2=1.76
r70 (  5 29 ) resistor r=3.57586 //w=0.17 //l=0.103078 //layer=li \
 //thickness=0.1 //x=2.07 //y=1.76 //x2=2.155 //y2=1.8
r71 (  5 29 ) resistor r=27.3797 //w=0.187 //l=0.4 //layer=li //thickness=0.1 \
 //x=2.07 //y=1.76 //x2=1.67 //y2=1.76
r72 (  1 29 ) resistor r=3.57586 //w=0.17 //l=0.125 //layer=li //thickness=0.1 \
 //x=1.185 //y=1.675 //x2=1.185 //y2=1.8
r73 (  1 29 ) resistor r=42.0963 //w=0.187 //l=0.615 //layer=li \
 //thickness=0.1 //x=1.185 //y=1.675 //x2=1.185 //y2=1.06
ends PM_AOAI4X1\%noxref_7

subckt PM_AOAI4X1\%C ( 1 2 3 4 5 6 7 8 10 21 22 23 24 25 26 31 33 35 41 42 44 \
 45 48 )
c71 ( 48 0 ) capacitor c=0.0369822f //x=5.705 //y=4.885
c72 ( 45 0 ) capacitor c=0.0279572f //x=5.67 //y=2.095
c73 ( 44 0 ) capacitor c=0.0422144f //x=5.67 //y=2.26
c74 ( 42 0 ) capacitor c=0.0237734f //x=6.235 //y=1.435
c75 ( 41 0 ) capacitor c=0.0191782f //x=6.235 //y=1.085
c76 ( 35 0 ) capacitor c=0.0346941f //x=6.08 //y=1.585
c77 ( 33 0 ) capacitor c=0.0157803f //x=6.08 //y=0.93
c78 ( 31 0 ) capacitor c=0.0359964f //x=6.075 //y=4.975
c79 ( 26 0 ) capacitor c=0.0199921f //x=5.705 //y=1.74
c80 ( 25 0 ) capacitor c=0.0169608f //x=5.705 //y=1.435
c81 ( 24 0 ) capacitor c=0.0185462f //x=5.705 //y=1.085
c82 ( 23 0 ) capacitor c=0.15325f //x=6.15 //y=6.205
c83 ( 22 0 ) capacitor c=0.110232f //x=5.71 //y=6.205
c84 ( 10 0 ) capacitor c=0.0800125f //x=5.67 //y=2.26
c85 ( 8 0 ) capacitor c=0.00521267f //x=5.67 //y=4.72
r86 (  50 51 ) resistor r=32.4568 //w=0.214 //l=0.075 //layer=ply \
 //thickness=0.18 //x=5.705 //y=4.975 //x2=5.705 //y2=5.05
r87 (  48 50 ) resistor r=20.271 //w=0.214 //l=0.09 //layer=ply \
 //thickness=0.18 //x=5.705 //y=4.885 //x2=5.705 //y2=4.975
r88 (  44 45 ) resistor r=52.7279 //w=0.214 //l=0.165 //layer=ply \
 //thickness=0.18 //x=5.67 //y=2.26 //x2=5.67 //y2=2.095
r89 (  42 55 ) resistor r=4.95774 //w=0.164 //l=0.112 //layer=ply \
 //thickness=0.18 //x=6.235 //y=1.435 //x2=6.235 //y2=1.547
r90 (  41 54 ) resistor r=45.1352 //w=0.168 //l=0.173853 //layer=ply \
 //thickness=0.18 //x=6.235 //y=1.085 //x2=6.195 //y2=0.93
r91 (  41 42 ) resistor r=179.468 //w=0.094 //l=0.35 //layer=ply \
 //thickness=0.18 //x=6.235 //y=1.085 //x2=6.235 //y2=1.435
r92 (  36 53 ) resistor r=10.8103 //w=0.211 //l=0.115 //layer=ply \
 //thickness=0.18 //x=5.86 //y=1.585 //x2=5.745 //y2=1.585
r93 (  35 55 ) resistor r=45.9962 //w=0.164 //l=0.17296 //layer=ply \
 //thickness=0.18 //x=6.08 //y=1.585 //x2=6.235 //y2=1.547
r94 (  34 52 ) resistor r=5.52526 //w=0.168 //l=0.115 //layer=ply \
 //thickness=0.18 //x=5.86 //y=0.93 //x2=5.745 //y2=0.93
r95 (  33 54 ) resistor r=5.52526 //w=0.168 //l=0.115 //layer=ply \
 //thickness=0.18 //x=6.08 //y=0.93 //x2=6.195 //y2=0.93
r96 (  33 34 ) resistor r=112.809 //w=0.094 //l=0.22 //layer=ply \
 //thickness=0.18 //x=6.08 //y=0.93 //x2=5.86 //y2=0.93
r97 (  32 50 ) resistor r=16.5046 //w=0.27 //l=0.135 //layer=ply \
 //thickness=0.18 //x=5.84 //y=4.975 //x2=5.705 //y2=4.975
r98 (  31 38 ) resistor r=26.9307 //w=0.15 //l=0.106066 //layer=ply \
 //thickness=0.18 //x=6.075 //y=4.975 //x2=6.15 //y2=5.05
r99 (  31 32 ) resistor r=120.5 //w=0.094 //l=0.235 //layer=ply \
 //thickness=0.18 //x=6.075 //y=4.975 //x2=5.84 //y2=4.975
r100 (  26 53 ) resistor r=39.5036 //w=0.211 //l=0.173853 //layer=ply \
 //thickness=0.18 //x=5.705 //y=1.74 //x2=5.745 //y2=1.585
r101 (  26 45 ) resistor r=182.032 //w=0.094 //l=0.355 //layer=ply \
 //thickness=0.18 //x=5.705 //y=1.74 //x2=5.705 //y2=2.095
r102 (  25 53 ) resistor r=38.3614 //w=0.211 //l=0.168819 //layer=ply \
 //thickness=0.18 //x=5.705 //y=1.435 //x2=5.745 //y2=1.585
r103 (  24 52 ) resistor r=45.1352 //w=0.168 //l=0.173853 //layer=ply \
 //thickness=0.18 //x=5.705 //y=1.085 //x2=5.745 //y2=0.93
r104 (  24 25 ) resistor r=179.468 //w=0.094 //l=0.35 //layer=ply \
 //thickness=0.18 //x=5.705 //y=1.085 //x2=5.705 //y2=1.435
r105 (  23 38 ) resistor r=592.245 //w=0.094 //l=1.155 //layer=ply \
 //thickness=0.18 //x=6.15 //y=6.205 //x2=6.15 //y2=5.05
r106 (  22 51 ) resistor r=592.245 //w=0.094 //l=1.155 //layer=ply \
 //thickness=0.18 //x=5.71 //y=6.205 //x2=5.71 //y2=5.05
r107 (  21 35 ) resistor r=56.4043 //w=0.094 //l=0.11 //layer=ply \
 //thickness=0.18 //x=5.97 //y=1.585 //x2=6.08 //y2=1.585
r108 (  21 36 ) resistor r=56.4043 //w=0.094 //l=0.11 //layer=ply \
 //thickness=0.18 //x=5.97 //y=1.585 //x2=5.86 //y2=1.585
r109 (  20 48 ) resistor r=152 //w=0.17 //l=0.17 //layer=licon //count=1 \
 //x=5.705 //y=4.885 //x2=5.705 //y2=4.885
r110 (  10 44 ) resistor r=152 //w=0.17 //l=0.17 //layer=licon //count=1 \
 //x=5.67 //y=2.26 //x2=5.67 //y2=2.26
r111 (  8 20 ) resistor r=11.332 //w=0.189 //l=0.173292 //layer=li \
 //thickness=0.1 //x=5.67 //y=4.72 //x2=5.687 //y2=4.885
r112 (  7 8 ) resistor r=6.84492 //w=0.187 //l=0.1 //layer=li //thickness=0.1 \
 //x=5.67 //y=4.62 //x2=5.67 //y2=4.72
r113 (  6 7 ) resistor r=25.3262 //w=0.187 //l=0.37 //layer=li //thickness=0.1 \
 //x=5.67 //y=4.25 //x2=5.67 //y2=4.62
r114 (  5 6 ) resistor r=25.3262 //w=0.187 //l=0.37 //layer=li //thickness=0.1 \
 //x=5.67 //y=3.88 //x2=5.67 //y2=4.25
r115 (  4 5 ) resistor r=25.3262 //w=0.187 //l=0.37 //layer=li //thickness=0.1 \
 //x=5.67 //y=3.51 //x2=5.67 //y2=3.88
r116 (  3 4 ) resistor r=25.3262 //w=0.187 //l=0.37 //layer=li //thickness=0.1 \
 //x=5.67 //y=3.14 //x2=5.67 //y2=3.51
r117 (  2 3 ) resistor r=25.3262 //w=0.187 //l=0.37 //layer=li //thickness=0.1 \
 //x=5.67 //y=2.77 //x2=5.67 //y2=3.14
r118 (  1 2 ) resistor r=25.3262 //w=0.187 //l=0.37 //layer=li //thickness=0.1 \
 //x=5.67 //y=2.4 //x2=5.67 //y2=2.77
r119 (  1 10 ) resistor r=9.58289 //w=0.187 //l=0.14 //layer=li \
 //thickness=0.1 //x=5.67 //y=2.4 //x2=5.67 //y2=2.26
ends PM_AOAI4X1\%C

subckt PM_AOAI4X1\%noxref_9 ( 7 8 15 16 23 24 25 )
c43 ( 25 0 ) capacitor c=0.0308836f //x=6.225 //y=5.205
c44 ( 24 0 ) capacitor c=0.0185379f //x=5.345 //y=5.205
c45 ( 23 0 ) capacitor c=0.0409962f //x=4.475 //y=5.205
c46 ( 16 0 ) capacitor c=0.00193672f //x=5.575 //y=7.09
c47 ( 15 0 ) capacitor c=0.01354f //x=6.285 //y=7.09
c48 ( 8 0 ) capacitor c=0.00844339f //x=4.695 //y=5.39
c49 ( 7 0 ) capacitor c=0.0252644f //x=5.405 //y=5.39
r50 (  17 25 ) resistor r=5.81818 //w=0.187 //l=0.085 //layer=li \
 //thickness=0.1 //x=6.37 //y=7.005 //x2=6.37 //y2=6.92
r51 (  15 17 ) resistor r=7.15173 //w=0.17 //l=0.120208 //layer=li \
 //thickness=0.1 //x=6.285 //y=7.09 //x2=6.37 //y2=7.005
r52 (  15 16 ) resistor r=48.5989 //w=0.187 //l=0.71 //layer=li \
 //thickness=0.1 //x=6.285 //y=7.09 //x2=5.575 //y2=7.09
r53 (  10 16 ) resistor r=7.15173 //w=0.17 //l=0.120208 //layer=li \
 //thickness=0.1 //x=5.49 //y=7.005 //x2=5.575 //y2=7.09
r54 (  10 24 ) resistor r=29.0909 //w=0.187 //l=0.425 //layer=li \
 //thickness=0.1 //x=5.49 //y=7.005 //x2=5.49 //y2=6.58
r55 (  9 24 ) resistor r=29.0909 //w=0.187 //l=0.425 //layer=li \
 //thickness=0.1 //x=5.49 //y=5.475 //x2=5.49 //y2=5.9
r56 (  7 9 ) resistor r=7.15173 //w=0.17 //l=0.120208 //layer=li \
 //thickness=0.1 //x=5.405 //y=5.39 //x2=5.49 //y2=5.475
r57 (  7 8 ) resistor r=48.5989 //w=0.187 //l=0.71 //layer=li //thickness=0.1 \
 //x=5.405 //y=5.39 //x2=4.695 //y2=5.39
r58 (  1 8 ) resistor r=7.15173 //w=0.17 //l=0.120208 //layer=li \
 //thickness=0.1 //x=4.61 //y=5.475 //x2=4.695 //y2=5.39
r59 (  1 23 ) resistor r=29.0909 //w=0.187 //l=0.425 //layer=li \
 //thickness=0.1 //x=4.61 //y=5.475 //x2=4.61 //y2=5.9
ends PM_AOAI4X1\%noxref_9

subckt PM_AOAI4X1\%D ( 1 2 3 4 5 6 7 8 10 21 22 23 24 25 26 31 33 35 41 42 44 \
 45 48 )
c64 ( 48 0 ) capacitor c=0.034715f //x=9.03 //y=4.88
c65 ( 45 0 ) capacitor c=0.0279499f //x=9 //y=2.095
c66 ( 44 0 ) capacitor c=0.0437302f //x=9 //y=2.26
c67 ( 42 0 ) capacitor c=0.0429696f //x=9.565 //y=1.43
c68 ( 41 0 ) capacitor c=0.0192208f //x=9.565 //y=1.085
c69 ( 35 0 ) capacitor c=0.0158629f //x=9.41 //y=1.585
c70 ( 33 0 ) capacitor c=0.0157803f //x=9.41 //y=0.93
c71 ( 31 0 ) capacitor c=0.0366192f //x=9.405 //y=4.97
c72 ( 26 0 ) capacitor c=0.0205163f //x=9.035 //y=1.74
c73 ( 25 0 ) capacitor c=0.0168481f //x=9.035 //y=1.43
c74 ( 24 0 ) capacitor c=0.0174783f //x=9.035 //y=1.085
c75 ( 23 0 ) capacitor c=0.15358f //x=9.48 //y=6.2
c76 ( 22 0 ) capacitor c=0.110281f //x=9.04 //y=6.2
c77 ( 10 0 ) capacitor c=0.0813556f //x=9 //y=2.26
c78 ( 8 0 ) capacitor c=0.00453889f //x=9 //y=4.715
r79 (  50 51 ) resistor r=32.4568 //w=0.214 //l=0.075 //layer=ply \
 //thickness=0.18 //x=9.03 //y=4.97 //x2=9.03 //y2=5.045
r80 (  48 50 ) resistor r=20.271 //w=0.214 //l=0.09 //layer=ply \
 //thickness=0.18 //x=9.03 //y=4.88 //x2=9.03 //y2=4.97
r81 (  44 45 ) resistor r=52.7279 //w=0.214 //l=0.165 //layer=ply \
 //thickness=0.18 //x=9 //y=2.26 //x2=9 //y2=2.095
r82 (  42 55 ) resistor r=45.1352 //w=0.168 //l=0.173853 //layer=ply \
 //thickness=0.18 //x=9.565 //y=1.43 //x2=9.525 //y2=1.585
r83 (  41 54 ) resistor r=45.1352 //w=0.168 //l=0.173853 //layer=ply \
 //thickness=0.18 //x=9.565 //y=1.085 //x2=9.525 //y2=0.93
r84 (  41 42 ) resistor r=176.904 //w=0.094 //l=0.345 //layer=ply \
 //thickness=0.18 //x=9.565 //y=1.085 //x2=9.565 //y2=1.43
r85 (  36 53 ) resistor r=10.701 //w=0.21 //l=0.115 //layer=ply \
 //thickness=0.18 //x=9.19 //y=1.585 //x2=9.075 //y2=1.585
r86 (  35 55 ) resistor r=5.52526 //w=0.168 //l=0.115 //layer=ply \
 //thickness=0.18 //x=9.41 //y=1.585 //x2=9.525 //y2=1.585
r87 (  34 52 ) resistor r=5.52526 //w=0.168 //l=0.115 //layer=ply \
 //thickness=0.18 //x=9.19 //y=0.93 //x2=9.075 //y2=0.93
r88 (  33 54 ) resistor r=5.52526 //w=0.168 //l=0.115 //layer=ply \
 //thickness=0.18 //x=9.41 //y=0.93 //x2=9.525 //y2=0.93
r89 (  33 34 ) resistor r=112.809 //w=0.094 //l=0.22 //layer=ply \
 //thickness=0.18 //x=9.41 //y=0.93 //x2=9.19 //y2=0.93
r90 (  32 50 ) resistor r=16.5046 //w=0.27 //l=0.135 //layer=ply \
 //thickness=0.18 //x=9.165 //y=4.97 //x2=9.03 //y2=4.97
r91 (  31 38 ) resistor r=26.9307 //w=0.15 //l=0.106066 //layer=ply \
 //thickness=0.18 //x=9.405 //y=4.97 //x2=9.48 //y2=5.045
r92 (  31 32 ) resistor r=123.064 //w=0.094 //l=0.24 //layer=ply \
 //thickness=0.18 //x=9.405 //y=4.97 //x2=9.165 //y2=4.97
r93 (  26 53 ) resistor r=39.5823 //w=0.21 //l=0.173853 //layer=ply \
 //thickness=0.18 //x=9.035 //y=1.74 //x2=9.075 //y2=1.585
r94 (  26 45 ) resistor r=182.032 //w=0.094 //l=0.355 //layer=ply \
 //thickness=0.18 //x=9.035 //y=1.74 //x2=9.035 //y2=2.095
r95 (  25 53 ) resistor r=39.5823 //w=0.21 //l=0.173853 //layer=ply \
 //thickness=0.18 //x=9.035 //y=1.43 //x2=9.075 //y2=1.585
r96 (  24 52 ) resistor r=45.1352 //w=0.168 //l=0.173853 //layer=ply \
 //thickness=0.18 //x=9.035 //y=1.085 //x2=9.075 //y2=0.93
r97 (  24 25 ) resistor r=176.904 //w=0.094 //l=0.345 //layer=ply \
 //thickness=0.18 //x=9.035 //y=1.085 //x2=9.035 //y2=1.43
r98 (  23 38 ) resistor r=592.245 //w=0.094 //l=1.155 //layer=ply \
 //thickness=0.18 //x=9.48 //y=6.2 //x2=9.48 //y2=5.045
r99 (  22 51 ) resistor r=592.245 //w=0.094 //l=1.155 //layer=ply \
 //thickness=0.18 //x=9.04 //y=6.2 //x2=9.04 //y2=5.045
r100 (  21 35 ) resistor r=56.4043 //w=0.094 //l=0.11 //layer=ply \
 //thickness=0.18 //x=9.3 //y=1.585 //x2=9.41 //y2=1.585
r101 (  21 36 ) resistor r=56.4043 //w=0.094 //l=0.11 //layer=ply \
 //thickness=0.18 //x=9.3 //y=1.585 //x2=9.19 //y2=1.585
r102 (  20 48 ) resistor r=152 //w=0.17 //l=0.17 //layer=licon //count=1 \
 //x=9.03 //y=4.88 //x2=9.03 //y2=4.88
r103 (  10 44 ) resistor r=152 //w=0.17 //l=0.17 //layer=licon //count=1 //x=9 \
 //y=2.26 //x2=9 //y2=2.26
r104 (  8 20 ) resistor r=11.4737 //w=0.186 //l=0.172337 //layer=li \
 //thickness=0.1 //x=9 //y=4.715 //x2=9.015 //y2=4.88
r105 (  7 8 ) resistor r=6.50267 //w=0.187 //l=0.095 //layer=li \
 //thickness=0.1 //x=9 //y=4.62 //x2=9 //y2=4.715
r106 (  6 7 ) resistor r=25.3262 //w=0.187 //l=0.37 //layer=li //thickness=0.1 \
 //x=9 //y=4.25 //x2=9 //y2=4.62
r107 (  5 6 ) resistor r=25.3262 //w=0.187 //l=0.37 //layer=li //thickness=0.1 \
 //x=9 //y=3.88 //x2=9 //y2=4.25
r108 (  4 5 ) resistor r=25.3262 //w=0.187 //l=0.37 //layer=li //thickness=0.1 \
 //x=9 //y=3.51 //x2=9 //y2=3.88
r109 (  3 4 ) resistor r=25.3262 //w=0.187 //l=0.37 //layer=li //thickness=0.1 \
 //x=9 //y=3.14 //x2=9 //y2=3.51
r110 (  2 3 ) resistor r=25.3262 //w=0.187 //l=0.37 //layer=li //thickness=0.1 \
 //x=9 //y=2.77 //x2=9 //y2=3.14
r111 (  1 2 ) resistor r=25.3262 //w=0.187 //l=0.37 //layer=li //thickness=0.1 \
 //x=9 //y=2.4 //x2=9 //y2=2.77
r112 (  1 10 ) resistor r=9.58289 //w=0.187 //l=0.14 //layer=li \
 //thickness=0.1 //x=9 //y=2.4 //x2=9 //y2=2.26
ends PM_AOAI4X1\%D

subckt PM_AOAI4X1\%YN ( 1 2 3 4 5 6 7 8 15 16 27 29 30 41 42 44 45 )
c60 ( 45 0 ) capacitor c=0.0220291f //x=9.115 //y=5.2
c61 ( 44 0 ) capacitor c=0.0217503f //x=8.235 //y=5.2
c62 ( 42 0 ) capacitor c=0.0084702f //x=9.11 //y=1.085
c63 ( 41 0 ) capacitor c=0.00427536f //x=9.26 //y=5.38
c64 ( 30 0 ) capacitor c=0.00781917f //x=9.385 //y=1.835
c65 ( 29 0 ) capacitor c=0.0167625f //x=9.655 //y=1.835
c66 ( 27 0 ) capacitor c=0.017841f //x=9.655 //y=5.38
c67 ( 16 0 ) capacitor c=0.00391676f //x=8.465 //y=5.38
c68 ( 15 0 ) capacitor c=0.0222171f //x=9.175 //y=5.38
c69 ( 1 0 ) capacitor c=0.133125f //x=9.74 //y=2.4
r70 (  29 31 ) resistor r=7.15173 //w=0.17 //l=0.120208 //layer=li \
 //thickness=0.1 //x=9.655 //y=1.835 //x2=9.74 //y2=1.92
r71 (  29 30 ) resistor r=18.4813 //w=0.187 //l=0.27 //layer=li \
 //thickness=0.1 //x=9.655 //y=1.835 //x2=9.385 //y2=1.835
r72 (  28 41 ) resistor r=5.4201 //w=0.17 //l=0.085 //layer=li //thickness=0.1 \
 //x=9.345 //y=5.38 //x2=9.26 //y2=5.38
r73 (  27 32 ) resistor r=7.15173 //w=0.17 //l=0.120208 //layer=li \
 //thickness=0.1 //x=9.655 //y=5.38 //x2=9.74 //y2=5.295
r74 (  27 28 ) resistor r=21.2193 //w=0.187 //l=0.31 //layer=li \
 //thickness=0.1 //x=9.655 //y=5.38 //x2=9.345 //y2=5.38
r75 (  23 30 ) resistor r=7.15173 //w=0.17 //l=0.120208 //layer=li \
 //thickness=0.1 //x=9.3 //y=1.75 //x2=9.385 //y2=1.835
r76 (  23 42 ) resistor r=39.016 //w=0.187 //l=0.57 //layer=li //thickness=0.1 \
 //x=9.3 //y=1.75 //x2=9.3 //y2=1.18
r77 (  17 41 ) resistor r=1.40859 //w=0.34 //l=0.085 //layer=li \
 //thickness=0.1 //x=9.26 //y=5.465 //x2=9.26 //y2=5.38
r78 (  17 45 ) resistor r=30.1176 //w=0.187 //l=0.44 //layer=li \
 //thickness=0.1 //x=9.26 //y=5.465 //x2=9.26 //y2=5.905
r79 (  15 41 ) resistor r=5.4201 //w=0.17 //l=0.085 //layer=li //thickness=0.1 \
 //x=9.175 //y=5.38 //x2=9.26 //y2=5.38
r80 (  15 16 ) resistor r=48.5989 //w=0.187 //l=0.71 //layer=li \
 //thickness=0.1 //x=9.175 //y=5.38 //x2=8.465 //y2=5.38
r81 (  9 16 ) resistor r=7.15173 //w=0.17 //l=0.120208 //layer=li \
 //thickness=0.1 //x=8.38 //y=5.465 //x2=8.465 //y2=5.38
r82 (  9 44 ) resistor r=30.1176 //w=0.187 //l=0.44 //layer=li //thickness=0.1 \
 //x=8.38 //y=5.465 //x2=8.38 //y2=5.905
r83 (  8 32 ) resistor r=20.877 //w=0.187 //l=0.305 //layer=li //thickness=0.1 \
 //x=9.74 //y=4.99 //x2=9.74 //y2=5.295
r84 (  7 8 ) resistor r=25.3262 //w=0.187 //l=0.37 //layer=li //thickness=0.1 \
 //x=9.74 //y=4.62 //x2=9.74 //y2=4.99
r85 (  6 7 ) resistor r=25.3262 //w=0.187 //l=0.37 //layer=li //thickness=0.1 \
 //x=9.74 //y=4.25 //x2=9.74 //y2=4.62
r86 (  5 6 ) resistor r=25.3262 //w=0.187 //l=0.37 //layer=li //thickness=0.1 \
 //x=9.74 //y=3.88 //x2=9.74 //y2=4.25
r87 (  4 5 ) resistor r=25.3262 //w=0.187 //l=0.37 //layer=li //thickness=0.1 \
 //x=9.74 //y=3.51 //x2=9.74 //y2=3.88
r88 (  3 4 ) resistor r=25.3262 //w=0.187 //l=0.37 //layer=li //thickness=0.1 \
 //x=9.74 //y=3.14 //x2=9.74 //y2=3.51
r89 (  2 3 ) resistor r=25.3262 //w=0.187 //l=0.37 //layer=li //thickness=0.1 \
 //x=9.74 //y=2.77 //x2=9.74 //y2=3.14
r90 (  1 2 ) resistor r=25.3262 //w=0.187 //l=0.37 //layer=li //thickness=0.1 \
 //x=9.74 //y=2.4 //x2=9.74 //y2=2.77
r91 (  1 31 ) resistor r=32.8556 //w=0.187 //l=0.48 //layer=li //thickness=0.1 \
 //x=9.74 //y=2.4 //x2=9.74 //y2=1.92
ends PM_AOAI4X1\%YN

subckt PM_AOAI4X1\%noxref_12 ( 1 5 9 10 13 17 29 )
c46 ( 29 0 ) capacitor c=0.0644466f //x=7.71 //y=0.545
c47 ( 17 0 ) capacitor c=0.00722223f //x=9.785 //y=0.795
c48 ( 13 0 ) capacitor c=0.0154622f //x=9.7 //y=0.71
c49 ( 10 0 ) capacitor c=0.0092508f //x=8.815 //y=1.675
c50 ( 9 0 ) capacitor c=0.006761f //x=8.815 //y=0.795
c51 ( 5 0 ) capacitor c=0.0235093f //x=8.73 //y=1.76
c52 ( 1 0 ) capacitor c=0.00765941f //x=7.845 //y=1.675
r53 (  17 29 ) resistor r=3.57586 //w=0.17 //l=0.125 //layer=li \
 //thickness=0.1 //x=9.785 //y=0.795 //x2=9.785 //y2=0.67
r54 (  17 29 ) resistor r=18.139 //w=0.187 //l=0.265 //layer=li \
 //thickness=0.1 //x=9.785 //y=0.795 //x2=9.785 //y2=1.06
r55 (  14 29 ) resistor r=3.57586 //w=0.17 //l=0.103078 //layer=li \
 //thickness=0.1 //x=8.9 //y=0.71 //x2=8.815 //y2=0.67
r56 (  14 29 ) resistor r=27.3797 //w=0.187 //l=0.4 //layer=li //thickness=0.1 \
 //x=8.9 //y=0.71 //x2=9.3 //y2=0.71
r57 (  13 29 ) resistor r=3.57586 //w=0.17 //l=0.103078 //layer=li \
 //thickness=0.1 //x=9.7 //y=0.71 //x2=9.785 //y2=0.67
r58 (  13 29 ) resistor r=27.3797 //w=0.187 //l=0.4 //layer=li //thickness=0.1 \
 //x=9.7 //y=0.71 //x2=9.3 //y2=0.71
r59 (  10 29 ) resistor r=3.57586 //w=0.17 //l=0.125 //layer=li \
 //thickness=0.1 //x=8.815 //y=1.675 //x2=8.815 //y2=1.8
r60 (  10 29 ) resistor r=42.0963 //w=0.187 //l=0.615 //layer=li \
 //thickness=0.1 //x=8.815 //y=1.675 //x2=8.815 //y2=1.06
r61 (  9 29 ) resistor r=3.57586 //w=0.17 //l=0.125 //layer=li //thickness=0.1 \
 //x=8.815 //y=0.795 //x2=8.815 //y2=0.67
r62 (  9 29 ) resistor r=18.139 //w=0.187 //l=0.265 //layer=li //thickness=0.1 \
 //x=8.815 //y=0.795 //x2=8.815 //y2=1.06
r63 (  6 29 ) resistor r=3.57586 //w=0.17 //l=0.103078 //layer=li \
 //thickness=0.1 //x=7.93 //y=1.76 //x2=7.845 //y2=1.8
r64 (  6 29 ) resistor r=27.3797 //w=0.187 //l=0.4 //layer=li //thickness=0.1 \
 //x=7.93 //y=1.76 //x2=8.33 //y2=1.76
r65 (  5 29 ) resistor r=3.57586 //w=0.17 //l=0.103078 //layer=li \
 //thickness=0.1 //x=8.73 //y=1.76 //x2=8.815 //y2=1.8
r66 (  5 29 ) resistor r=27.3797 //w=0.187 //l=0.4 //layer=li //thickness=0.1 \
 //x=8.73 //y=1.76 //x2=8.33 //y2=1.76
r67 (  1 29 ) resistor r=3.57586 //w=0.17 //l=0.125 //layer=li //thickness=0.1 \
 //x=7.845 //y=1.675 //x2=7.845 //y2=1.8
r68 (  1 29 ) resistor r=42.0963 //w=0.187 //l=0.615 //layer=li \
 //thickness=0.1 //x=7.845 //y=1.675 //x2=7.845 //y2=1.06
ends PM_AOAI4X1\%noxref_12
