// File: AOAI4X1.spi.pex
// Created: Thu Jan 22 07:02:35 2026
// Program "Calibre xRC"
// Version "v2023.2_27.15"
// Nominal Temperature: 30C
// Circuit Temperature: 30C
//
simulator lang=spectre
subckt PM_AOAI4X1\%noxref_1 ( 3 8 9 11 12 14 15 16 18 19 20 23 24 27 29 34 38 \
 40 44 51 53 54 57 65 82 87 95 96 97 98 99 100 101 105 107 110 112 113 118 128 \
 130 131 )
c264 ( 128 0 ) capacitor c=0.00878249f //x=2.45 //y=1.085
c265 ( 118 0 ) capacitor c=0.0426341f //x=4.775 //y=4.885
c266 ( 113 0 ) capacitor c=0.0337825f //x=5.265 //y=1.43
c267 ( 112 0 ) capacitor c=0.0183823f //x=5.265 //y=1.085
c268 ( 110 0 ) capacitor c=0.0350928f //x=5.195 //y=4.975
c269 ( 107 0 ) capacitor c=0.013578f //x=5.11 //y=1.585
c270 ( 105 0 ) capacitor c=0.0157803f //x=5.11 //y=0.93
c271 ( 101 0 ) capacitor c=0.0787231f //x=4.735 //y=2.095
c272 ( 100 0 ) capacitor c=0.0230165f //x=4.735 //y=1.74
c273 ( 99 0 ) capacitor c=0.0234348f //x=4.735 //y=1.43
c274 ( 98 0 ) capacitor c=0.019134f //x=4.735 //y=1.085
c275 ( 97 0 ) capacitor c=0.110994f //x=5.27 //y=6.205
c276 ( 96 0 ) capacitor c=0.154777f //x=4.83 //y=6.205
c277 ( 87 0 ) capacitor c=4.74639e-19 //x=4.93 //y=2.26
c278 ( 82 0 ) capacitor c=0.0070524f //x=4.775 //y=4.885
c279 ( 65 0 ) capacitor c=0.0325392f //x=2.6 //y=5.56
c280 ( 57 0 ) capacitor c=0.0291911f //x=1.72 //y=5.56
c281 ( 54 0 ) capacitor c=0.0774598f //x=4.765 //y=2.765
c282 ( 53 0 ) capacitor c=0.00528707f //x=4.925 //y=2.765
c283 ( 51 0 ) capacitor c=0.00557932f //x=3.24 //y=2.765
c284 ( 44 0 ) capacitor c=0.00772734f //x=4.775 //y=4.885
c285 ( 40 0 ) capacitor c=0.0063606f //x=4.93 //y=2.26
c286 ( 38 0 ) capacitor c=0.0141822f //x=4.93 //y=2.77
c287 ( 34 0 ) capacitor c=0.0148986f //x=3.08 //y=2.77
c288 ( 29 0 ) capacitor c=0.011771f //x=2.64 //y=1.18
c289 ( 27 0 ) capacitor c=6.70882e-19 //x=2.6 //y=5.56
c290 ( 24 0 ) capacitor c=0.0129472f //x=2.6 //y=5.38
c291 ( 23 0 ) capacitor c=0.0106213f //x=1.72 //y=5.56
c292 ( 20 0 ) capacitor c=0.0626275f //x=4.93 //y=4.765
c293 ( 19 0 ) capacitor c=0.0110376f //x=4.93 //y=2.925
c294 ( 18 0 ) capacitor c=0.00428329f //x=4.93 //y=2.605
c295 ( 16 0 ) capacitor c=0.0762425f //x=3.08 //y=5.295
c296 ( 15 0 ) capacitor c=0.0117766f //x=3.08 //y=2.925
c297 ( 14 0 ) capacitor c=0.0169876f //x=3.08 //y=2.605
c298 ( 12 0 ) capacitor c=0.00837358f //x=2.725 //y=1.835
c299 ( 11 0 ) capacitor c=0.0136795f //x=2.995 //y=1.835
c300 ( 9 0 ) capacitor c=0.0123394f //x=2.995 //y=5.38
c301 ( 8 0 ) capacitor c=0.012699f //x=2.64 //y=1.75
c302 ( 3 0 ) capacitor c=0.019362f //x=2.485 //y=5.38
r303 (  120 121 ) resistor r=32.4568 //w=0.214 //l=0.075 //layer=ply \
 //thickness=0.18 //x=4.775 //y=4.975 //x2=4.775 //y2=5.05
r304 (  118 120 ) resistor r=20.271 //w=0.214 //l=0.09 //layer=ply \
 //thickness=0.18 //x=4.775 //y=4.885 //x2=4.775 //y2=4.975
r305 (  113 127 ) resistor r=45.1352 //w=0.168 //l=0.173853 //layer=ply \
 //thickness=0.18 //x=5.265 //y=1.43 //x2=5.225 //y2=1.585
r306 (  112 126 ) resistor r=45.1352 //w=0.168 //l=0.173853 //layer=ply \
 //thickness=0.18 //x=5.265 //y=1.085 //x2=5.225 //y2=0.93
r307 (  112 113 ) resistor r=176.904 //w=0.094 //l=0.345 //layer=ply \
 //thickness=0.18 //x=5.265 //y=1.085 //x2=5.265 //y2=1.43
r308 (  111 120 ) resistor r=16.5046 //w=0.27 //l=0.135 //layer=ply \
 //thickness=0.18 //x=4.91 //y=4.975 //x2=4.775 //y2=4.975
r309 (  110 114 ) resistor r=26.9307 //w=0.15 //l=0.106066 //layer=ply \
 //thickness=0.18 //x=5.195 //y=4.975 //x2=5.27 //y2=5.05
r310 (  110 111 ) resistor r=146.138 //w=0.094 //l=0.285 //layer=ply \
 //thickness=0.18 //x=5.195 //y=4.975 //x2=4.91 //y2=4.975
r311 (  108 125 ) resistor r=10.701 //w=0.21 //l=0.115 //layer=ply \
 //thickness=0.18 //x=4.89 //y=1.585 //x2=4.775 //y2=1.585
r312 (  107 127 ) resistor r=5.52526 //w=0.168 //l=0.115 //layer=ply \
 //thickness=0.18 //x=5.11 //y=1.585 //x2=5.225 //y2=1.585
r313 (  106 124 ) resistor r=5.52526 //w=0.168 //l=0.115 //layer=ply \
 //thickness=0.18 //x=4.89 //y=0.93 //x2=4.775 //y2=0.93
r314 (  105 126 ) resistor r=5.52526 //w=0.168 //l=0.115 //layer=ply \
 //thickness=0.18 //x=5.11 //y=0.93 //x2=5.225 //y2=0.93
r315 (  105 106 ) resistor r=112.809 //w=0.094 //l=0.22 //layer=ply \
 //thickness=0.18 //x=5.11 //y=0.93 //x2=4.89 //y2=0.93
r316 (  101 123 ) resistor r=34.8111 //w=0.27 //l=0.264953 //layer=ply \
 //thickness=0.18 //x=4.735 //y=2.095 //x2=4.93 //y2=2.26
r317 (  100 125 ) resistor r=39.5823 //w=0.21 //l=0.173853 //layer=ply \
 //thickness=0.18 //x=4.735 //y=1.74 //x2=4.775 //y2=1.585
r318 (  100 101 ) resistor r=182.032 //w=0.094 //l=0.355 //layer=ply \
 //thickness=0.18 //x=4.735 //y=1.74 //x2=4.735 //y2=2.095
r319 (  99 125 ) resistor r=39.5823 //w=0.21 //l=0.173853 //layer=ply \
 //thickness=0.18 //x=4.735 //y=1.43 //x2=4.775 //y2=1.585
r320 (  98 124 ) resistor r=45.1352 //w=0.168 //l=0.173853 //layer=ply \
 //thickness=0.18 //x=4.735 //y=1.085 //x2=4.775 //y2=0.93
r321 (  98 99 ) resistor r=176.904 //w=0.094 //l=0.345 //layer=ply \
 //thickness=0.18 //x=4.735 //y=1.085 //x2=4.735 //y2=1.43
r322 (  97 114 ) resistor r=592.245 //w=0.094 //l=1.155 //layer=ply \
 //thickness=0.18 //x=5.27 //y=6.205 //x2=5.27 //y2=5.05
r323 (  96 121 ) resistor r=592.245 //w=0.094 //l=1.155 //layer=ply \
 //thickness=0.18 //x=4.83 //y=6.205 //x2=4.83 //y2=5.05
r324 (  95 107 ) resistor r=56.4043 //w=0.094 //l=0.11 //layer=ply \
 //thickness=0.18 //x=5 //y=1.585 //x2=5.11 //y2=1.585
r325 (  95 108 ) resistor r=56.4043 //w=0.094 //l=0.11 //layer=ply \
 //thickness=0.18 //x=5 //y=1.585 //x2=4.89 //y2=1.585
r326 (  87 123 ) resistor r=152 //w=0.17 //l=0.17 //layer=licon //count=1 \
 //x=4.93 //y=2.26 //x2=4.93 //y2=2.26
r327 (  82 118 ) resistor r=152 //w=0.17 //l=0.17 //layer=licon //count=1 \
 //x=4.775 //y=4.885 //x2=4.775 //y2=4.885
r328 (  65 131 ) resistor r=23.615 //w=0.187 //l=0.345 //layer=li \
 //thickness=0.1 //x=2.6 //y=5.56 //x2=2.6 //y2=5.905
r329 (  57 130 ) resistor r=23.615 //w=0.187 //l=0.345 //layer=li \
 //thickness=0.1 //x=1.72 //y=5.56 //x2=1.72 //y2=5.905
r330 (  53 54 ) resistor r=0.10734 //w=0.281 //l=0.16 //layer=m2 \
 //thickness=0.36 //x=4.925 //y=2.765 //x2=4.765 //y2=2.765
r331 (  51 54 ) resistor r=1.45515 //w=0.131 //l=1.525 //layer=m2 \
 //thickness=0.36 //x=3.24 //y=2.77 //x2=4.765 //y2=2.77
r332 (  49 51 ) resistor r=0.10734 //w=0.281 //l=0.16 //layer=m2 \
 //thickness=0.36 //x=3.08 //y=2.765 //x2=3.24 //y2=2.765
r333 (  44 82 ) resistor r=9.3 //w=0.17 //l=0.17 //layer=mcon //count=1 \
 //x=4.775 //y=4.885 //x2=4.775 //y2=4.885
r334 (  44 45 ) resistor r=0.0853524 //w=0.227 //l=0.155 //layer=m1 \
 //thickness=0.36 //x=4.775 //y=4.882 //x2=4.93 //y2=4.882
r335 (  40 87 ) resistor r=9.3 //w=0.17 //l=0.17 //layer=mcon //count=1 \
 //x=4.93 //y=2.26 //x2=4.93 //y2=2.26
r336 (  40 42 ) resistor r=0.0985786 //w=0.206 //l=0.135 //layer=m1 \
 //thickness=0.36 //x=4.927 //y=2.26 //x2=4.927 //y2=2.395
r337 (  36 53 ) resistor r=4.5 //w=0.15 //l=0.15 //layer=via1 //count=1 \
 //x=4.925 //y=2.765 //x2=4.925 //y2=2.765
r338 (  36 38 ) resistor r=0.00167112 //w=0.374 //l=0.005 //layer=m1 \
 //thickness=0.36 //x=4.875 //y=2.765 //x2=4.875 //y2=2.77
r339 (  32 49 ) resistor r=4.5 //w=0.15 //l=0.15 //layer=via1 //count=1 \
 //x=3.08 //y=2.765 //x2=3.08 //y2=2.765
r340 (  32 34 ) resistor r=0.00166223 //w=0.376 //l=0.005 //layer=m1 \
 //thickness=0.36 //x=3.132 //y=2.765 //x2=3.132 //y2=2.77
r341 (  29 128 ) resistor r=9.3 //w=0.17 //l=0.17 //layer=mcon //count=1 \
 //x=2.64 //y=1.18 //x2=2.64 //y2=1.18
r342 (  27 65 ) resistor r=9.3 //w=0.17 //l=0.17 //layer=mcon //count=1 \
 //x=2.6 //y=5.56 //x2=2.6 //y2=5.56
r343 (  24 27 ) resistor r=0.117801 //w=0.191 //l=0.18 //layer=m1 \
 //thickness=0.36 //x=2.6 //y=5.38 //x2=2.6 //y2=5.56
r344 (  23 57 ) resistor r=9.3 //w=0.17 //l=0.17 //layer=mcon //count=1 \
 //x=1.72 //y=5.56 //x2=1.72 //y2=5.56
r345 (  21 23 ) resistor r=0.10274 //w=0.219 //l=0.18 //layer=m1 \
 //thickness=0.36 //x=1.72 //y=5.38 //x2=1.72 //y2=5.56
r346 (  20 45 ) resistor r=0.0249239 //w=0.227 //l=0.117 //layer=m1 \
 //thickness=0.36 //x=4.93 //y=4.765 //x2=4.93 //y2=4.882
r347 (  19 38 ) resistor r=0.089409 //w=0.374 //l=0.180416 //layer=m1 \
 //thickness=0.36 //x=4.93 //y=2.925 //x2=4.875 //y2=2.77
r348 (  19 20 ) resistor r=1.75573 //w=0.131 //l=1.84 //layer=m1 \
 //thickness=0.36 //x=4.93 //y=2.925 //x2=4.93 //y2=4.765
r349 (  18 36 ) resistor r=0.0910802 //w=0.374 //l=0.185472 //layer=m1 \
 //thickness=0.36 //x=4.93 //y=2.605 //x2=4.875 //y2=2.765
r350 (  18 42 ) resistor r=0.200382 //w=0.131 //l=0.21 //layer=m1 \
 //thickness=0.36 //x=4.93 //y=2.605 //x2=4.93 //y2=2.395
r351 (  15 34 ) resistor r=0.0894971 //w=0.376 //l=0.179123 //layer=m1 \
 //thickness=0.36 //x=3.08 //y=2.925 //x2=3.132 //y2=2.77
r352 (  15 16 ) resistor r=2.26145 //w=0.131 //l=2.37 //layer=m1 \
 //thickness=0.36 //x=3.08 //y=2.925 //x2=3.08 //y2=5.295
r353 (  14 32 ) resistor r=0.0911593 //w=0.376 //l=0.184174 //layer=m1 \
 //thickness=0.36 //x=3.08 //y=2.605 //x2=3.132 //y2=2.765
r354 (  13 14 ) resistor r=0.653626 //w=0.131 //l=0.685 //layer=m1 \
 //thickness=0.36 //x=3.08 //y=1.92 //x2=3.08 //y2=2.605
r355 (  11 13 ) resistor r=0.0698411 //w=0.17 //l=0.120208 //layer=m1 \
 //thickness=0.36 //x=2.995 //y=1.835 //x2=3.08 //y2=1.92
r356 (  11 12 ) resistor r=0.257634 //w=0.131 //l=0.27 //layer=m1 \
 //thickness=0.36 //x=2.995 //y=1.835 //x2=2.725 //y2=1.835
r357 (  10 24 ) resistor r=0.0257089 //w=0.23 //l=0.115 //layer=m1 \
 //thickness=0.36 //x=2.715 //y=5.38 //x2=2.6 //y2=5.38
r358 (  9 16 ) resistor r=0.0698411 //w=0.17 //l=0.120208 //layer=m1 \
 //thickness=0.36 //x=2.995 //y=5.38 //x2=3.08 //y2=5.295
r359 (  9 10 ) resistor r=0.267176 //w=0.131 //l=0.28 //layer=m1 \
 //thickness=0.36 //x=2.995 //y=5.38 //x2=2.715 //y2=5.38
r360 (  8 12 ) resistor r=0.0698411 //w=0.17 //l=0.120208 //layer=m1 \
 //thickness=0.36 //x=2.64 //y=1.75 //x2=2.725 //y2=1.835
r361 (  7 29 ) resistor r=0.0913624 //w=0.191 //l=0.12 //layer=m1 \
 //thickness=0.36 //x=2.64 //y=1.3 //x2=2.64 //y2=1.18
r362 (  7 8 ) resistor r=0.429389 //w=0.131 //l=0.45 //layer=m1 \
 //thickness=0.36 //x=2.64 //y=1.3 //x2=2.64 //y2=1.75
r363 (  4 21 ) resistor r=0.0227762 //w=0.219 //l=0.115 //layer=m1 \
 //thickness=0.36 //x=1.835 //y=5.38 //x2=1.72 //y2=5.38
r364 (  3 24 ) resistor r=0.0257089 //w=0.23 //l=0.115 //layer=m1 \
 //thickness=0.36 //x=2.485 //y=5.38 //x2=2.6 //y2=5.38
r365 (  3 4 ) resistor r=0.620229 //w=0.131 //l=0.65 //layer=m1 \
 //thickness=0.36 //x=2.485 //y=5.38 //x2=1.835 //y2=5.38
ends PM_AOAI4X1\%noxref_1

subckt PM_AOAI4X1\%noxref_2 ( 1 2 3 4 5 6 7 9 12 13 14 16 17 22 30 34 36 39 40 \
 47 49 50 58 75 84 88 89 90 91 92 93 94 98 100 103 104 114 117 118 121 )
c269 ( 118 0 ) capacitor c=0.00901091f //x=5.78 //y=1.085
c270 ( 117 0 ) capacitor c=0.00876479f //x=4.81 //y=1.085
c271 ( 114 0 ) capacitor c=0.0682508f //x=8.26 //y=4.88
c272 ( 104 0 ) capacitor c=0.0318956f //x=8.595 //y=1.39
c273 ( 103 0 ) capacitor c=0.0186809f //x=8.595 //y=1.045
c274 ( 100 0 ) capacitor c=0.0141821f //x=8.44 //y=1.545
c275 ( 98 0 ) capacitor c=0.0158553f //x=8.44 //y=0.89
c276 ( 94 0 ) capacitor c=0.0815046f //x=8.065 //y=2.095
c277 ( 93 0 ) capacitor c=0.0229235f //x=8.065 //y=1.7
c278 ( 92 0 ) capacitor c=0.0234359f //x=8.065 //y=1.39
c279 ( 91 0 ) capacitor c=0.0198759f //x=8.065 //y=1.045
c280 ( 90 0 ) capacitor c=0.110369f //x=8.6 //y=6.2
c281 ( 89 0 ) capacitor c=0.154619f //x=8.16 //y=6.2
c282 ( 84 0 ) capacitor c=8.13425e-19 //x=8.26 //y=4.88
c283 ( 75 0 ) capacitor c=5.17312e-19 //x=8.26 //y=2.26
c284 ( 58 0 ) capacitor c=0.0245539f //x=5.93 //y=5.56
c285 ( 50 0 ) capacitor c=0.0772176f //x=8.09 //y=2.765
c286 ( 49 0 ) capacitor c=0.00407557f //x=8.25 //y=2.765
c287 ( 47 0 ) capacitor c=0.00547085f //x=6.565 //y=2.765
c288 ( 40 0 ) capacitor c=0.0619196f //x=8.262 //y=4.74
c289 ( 39 0 ) capacitor c=0.00635496f //x=8.26 //y=4.88
c290 ( 36 0 ) capacitor c=0.00617935f //x=8.26 //y=2.26
c291 ( 34 0 ) capacitor c=0.0145932f //x=8.26 //y=2.77
c292 ( 30 0 ) capacitor c=0.0143422f //x=6.41 //y=2.77
c293 ( 22 0 ) capacitor c=0.0136691f //x=5.925 //y=5.39
c294 ( 21 0 ) capacitor c=0.00513603f //x=5.97 //y=1.835
c295 ( 17 0 ) capacitor c=0.0114695f //x=8.26 //y=2.925
c296 ( 16 0 ) capacitor c=0.0044026f //x=8.26 //y=2.605
c297 ( 14 0 ) capacitor c=0.0761917f //x=6.41 //y=5.305
c298 ( 13 0 ) capacitor c=0.0124328f //x=6.41 //y=2.925
c299 ( 12 0 ) capacitor c=0.0173317f //x=6.41 //y=2.605
c300 ( 9 0 ) capacitor c=0.0141638f //x=6.325 //y=1.835
c301 ( 7 0 ) capacitor c=0.0112568f //x=6.325 //y=5.39
c302 ( 6 0 ) capacitor c=0.00792854f //x=5.97 //y=1.75
c303 ( 5 0 ) capacitor c=0.00855942f //x=5.97 //y=1.3
c304 ( 4 0 ) capacitor c=0.00230949f //x=5.085 //y=1.835
c305 ( 3 0 ) capacitor c=0.0217217f //x=5.885 //y=1.835
c306 ( 2 0 ) capacitor c=0.00638036f //x=5 //y=1.75
c307 ( 1 0 ) capacitor c=0.00825276f //x=5 //y=1.305
r308 (  112 114 ) resistor r=20.6867 //w=0.233 //l=0.1 //layer=ply \
 //thickness=0.18 //x=8.16 //y=4.88 //x2=8.26 //y2=4.88
r309 (  105 114 ) resistor r=70.3348 //w=0.233 //l=0.414367 //layer=ply \
 //thickness=0.18 //x=8.6 //y=5.045 //x2=8.26 //y2=4.88
r310 (  104 116 ) resistor r=45.1352 //w=0.168 //l=0.173853 //layer=ply \
 //thickness=0.18 //x=8.595 //y=1.39 //x2=8.555 //y2=1.545
r311 (  103 115 ) resistor r=45.1352 //w=0.168 //l=0.173853 //layer=ply \
 //thickness=0.18 //x=8.595 //y=1.045 //x2=8.555 //y2=0.89
r312 (  103 104 ) resistor r=176.904 //w=0.094 //l=0.345 //layer=ply \
 //thickness=0.18 //x=8.595 //y=1.045 //x2=8.595 //y2=1.39
r313 (  101 111 ) resistor r=10.701 //w=0.21 //l=0.115 //layer=ply \
 //thickness=0.18 //x=8.22 //y=1.545 //x2=8.105 //y2=1.545
r314 (  100 116 ) resistor r=5.52526 //w=0.168 //l=0.115 //layer=ply \
 //thickness=0.18 //x=8.44 //y=1.545 //x2=8.555 //y2=1.545
r315 (  99 110 ) resistor r=5.52526 //w=0.168 //l=0.115 //layer=ply \
 //thickness=0.18 //x=8.22 //y=0.89 //x2=8.105 //y2=0.89
r316 (  98 115 ) resistor r=5.52526 //w=0.168 //l=0.115 //layer=ply \
 //thickness=0.18 //x=8.44 //y=0.89 //x2=8.555 //y2=0.89
r317 (  98 99 ) resistor r=112.809 //w=0.094 //l=0.22 //layer=ply \
 //thickness=0.18 //x=8.44 //y=0.89 //x2=8.22 //y2=0.89
r318 (  95 112 ) resistor r=13.0941 //w=0.233 //l=0.165 //layer=ply \
 //thickness=0.18 //x=8.16 //y=5.045 //x2=8.16 //y2=4.88
r319 (  94 109 ) resistor r=34.8111 //w=0.27 //l=0.264953 //layer=ply \
 //thickness=0.18 //x=8.065 //y=2.095 //x2=8.26 //y2=2.26
r320 (  93 111 ) resistor r=39.5823 //w=0.21 //l=0.173853 //layer=ply \
 //thickness=0.18 //x=8.065 //y=1.7 //x2=8.105 //y2=1.545
r321 (  93 94 ) resistor r=202.543 //w=0.094 //l=0.395 //layer=ply \
 //thickness=0.18 //x=8.065 //y=1.7 //x2=8.065 //y2=2.095
r322 (  92 111 ) resistor r=39.5823 //w=0.21 //l=0.173853 //layer=ply \
 //thickness=0.18 //x=8.065 //y=1.39 //x2=8.105 //y2=1.545
r323 (  91 110 ) resistor r=45.1352 //w=0.168 //l=0.173853 //layer=ply \
 //thickness=0.18 //x=8.065 //y=1.045 //x2=8.105 //y2=0.89
r324 (  91 92 ) resistor r=176.904 //w=0.094 //l=0.345 //layer=ply \
 //thickness=0.18 //x=8.065 //y=1.045 //x2=8.065 //y2=1.39
r325 (  90 105 ) resistor r=592.245 //w=0.094 //l=1.155 //layer=ply \
 //thickness=0.18 //x=8.6 //y=6.2 //x2=8.6 //y2=5.045
r326 (  89 95 ) resistor r=592.245 //w=0.094 //l=1.155 //layer=ply \
 //thickness=0.18 //x=8.16 //y=6.2 //x2=8.16 //y2=5.045
r327 (  88 100 ) resistor r=56.4043 //w=0.094 //l=0.11 //layer=ply \
 //thickness=0.18 //x=8.33 //y=1.545 //x2=8.44 //y2=1.545
r328 (  88 101 ) resistor r=56.4043 //w=0.094 //l=0.11 //layer=ply \
 //thickness=0.18 //x=8.33 //y=1.545 //x2=8.22 //y2=1.545
r329 (  84 114 ) resistor r=152 //w=0.17 //l=0.17 //layer=licon //count=1 \
 //x=8.26 //y=4.88 //x2=8.26 //y2=4.88
r330 (  75 109 ) resistor r=152 //w=0.17 //l=0.17 //layer=licon //count=1 \
 //x=8.26 //y=2.26 //x2=8.26 //y2=2.26
r331 (  58 121 ) resistor r=23.2727 //w=0.187 //l=0.34 //layer=li \
 //thickness=0.1 //x=5.93 //y=5.56 //x2=5.93 //y2=5.9
r332 (  49 50 ) resistor r=0.104807 //w=0.281 //l=0.16 //layer=m2 \
 //thickness=0.36 //x=8.25 //y=2.765 //x2=8.09 //y2=2.765
r333 (  47 50 ) resistor r=1.40165 //w=0.136 //l=1.525 //layer=m2 \
 //thickness=0.36 //x=6.565 //y=2.767 //x2=8.09 //y2=2.767
r334 (  45 47 ) resistor r=0.104807 //w=0.281 //l=0.16 //layer=m2 \
 //thickness=0.36 //x=6.405 //y=2.765 //x2=6.565 //y2=2.765
r335 (  39 84 ) resistor r=9.3 //w=0.17 //l=0.17 //layer=mcon //count=1 \
 //x=8.26 //y=4.88 //x2=8.26 //y2=4.88
r336 (  39 40 ) resistor r=0.103207 //w=0.196 //l=0.14 //layer=m1 \
 //thickness=0.36 //x=8.262 //y=4.88 //x2=8.262 //y2=4.74
r337 (  36 75 ) resistor r=9.3 //w=0.17 //l=0.17 //layer=mcon //count=1 \
 //x=8.26 //y=2.26 //x2=8.26 //y2=2.26
r338 (  32 49 ) resistor r=4.5 //w=0.15 //l=0.15 //layer=via1 //count=1 \
 //x=8.25 //y=2.765 //x2=8.25 //y2=2.765
r339 (  32 34 ) resistor r=0.00168464 //w=0.371 //l=0.005 //layer=m1 \
 //thickness=0.36 //x=8.202 //y=2.765 //x2=8.202 //y2=2.77
r340 (  28 45 ) resistor r=4.5 //w=0.15 //l=0.15 //layer=via1 //count=1 \
 //x=6.405 //y=2.765 //x2=6.405 //y2=2.765
r341 (  28 30 ) resistor r=0.00164908 //w=0.379 //l=0.005 //layer=m1 \
 //thickness=0.36 //x=6.46 //y=2.765 //x2=6.46 //y2=2.77
r342 (  26 118 ) resistor r=9.3 //w=0.17 //l=0.17 //layer=mcon //count=1 \
 //x=5.97 //y=1.18 //x2=5.97 //y2=1.18
r343 (  24 58 ) resistor r=9.3 //w=0.17 //l=0.17 //layer=mcon //count=1 \
 //x=5.93 //y=5.56 //x2=5.93 //y2=5.56
r344 (  22 24 ) resistor r=0.0974771 //w=0.218 //l=0.17 //layer=m1 \
 //thickness=0.36 //x=5.925 //y=5.39 //x2=5.925 //y2=5.56
r345 (  20 117 ) resistor r=9.3 //w=0.17 //l=0.17 //layer=mcon //count=1 //x=5 \
 //y=1.18 //x2=5 //y2=1.18
r346 (  17 34 ) resistor r=0.0892801 //w=0.371 //l=0.1817 //layer=m1 \
 //thickness=0.36 //x=8.26 //y=2.925 //x2=8.202 //y2=2.77
r347 (  17 40 ) resistor r=1.73187 //w=0.131 //l=1.815 //layer=m1 \
 //thickness=0.36 //x=8.26 //y=2.925 //x2=8.26 //y2=4.74
r348 (  16 32 ) resistor r=0.0909648 //w=0.371 //l=0.186762 //layer=m1 \
 //thickness=0.36 //x=8.26 //y=2.605 //x2=8.202 //y2=2.765
r349 (  15 36 ) resistor r=0.0933015 //w=0.201 //l=0.125 //layer=m1 \
 //thickness=0.36 //x=8.26 //y=2.385 //x2=8.26 //y2=2.26
r350 (  15 16 ) resistor r=0.209924 //w=0.131 //l=0.22 //layer=m1 \
 //thickness=0.36 //x=8.26 //y=2.385 //x2=8.26 //y2=2.605
r351 (  13 30 ) resistor r=0.0896323 //w=0.379 //l=0.178255 //layer=m1 \
 //thickness=0.36 //x=6.41 //y=2.925 //x2=6.46 //y2=2.77
r352 (  13 14 ) resistor r=2.27099 //w=0.131 //l=2.38 //layer=m1 \
 //thickness=0.36 //x=6.41 //y=2.925 //x2=6.41 //y2=5.305
r353 (  12 28 ) resistor r=0.0912814 //w=0.379 //l=0.183303 //layer=m1 \
 //thickness=0.36 //x=6.41 //y=2.605 //x2=6.46 //y2=2.765
r354 (  11 12 ) resistor r=0.653626 //w=0.131 //l=0.685 //layer=m1 \
 //thickness=0.36 //x=6.41 //y=1.92 //x2=6.41 //y2=2.605
r355 (  10 21 ) resistor r=0.0529306 //w=0.17 //l=0.085 //layer=m1 \
 //thickness=0.36 //x=6.055 //y=1.835 //x2=5.97 //y2=1.835
r356 (  9 11 ) resistor r=0.0698411 //w=0.17 //l=0.120208 //layer=m1 \
 //thickness=0.36 //x=6.325 //y=1.835 //x2=6.41 //y2=1.92
r357 (  9 10 ) resistor r=0.257634 //w=0.131 //l=0.27 //layer=m1 \
 //thickness=0.36 //x=6.325 //y=1.835 //x2=6.055 //y2=1.835
r358 (  8 22 ) resistor r=0.0225019 //w=0.218 //l=0.12 //layer=m1 \
 //thickness=0.36 //x=6.045 //y=5.39 //x2=5.925 //y2=5.39
r359 (  7 14 ) resistor r=0.0698411 //w=0.17 //l=0.120208 //layer=m1 \
 //thickness=0.36 //x=6.325 //y=5.39 //x2=6.41 //y2=5.305
r360 (  7 8 ) resistor r=0.267176 //w=0.131 //l=0.28 //layer=m1 \
 //thickness=0.36 //x=6.325 //y=5.39 //x2=6.045 //y2=5.39
r361 (  6 21 ) resistor r=0.0137558 //w=0.34 //l=0.085 //layer=m1 \
 //thickness=0.36 //x=5.97 //y=1.75 //x2=5.97 //y2=1.835
r362 (  5 26 ) resistor r=0.0728765 //w=0.25 //l=0.121491 //layer=m1 \
 //thickness=0.36 //x=5.97 //y=1.3 //x2=5.967 //y2=1.18
r363 (  5 6 ) resistor r=0.429389 //w=0.131 //l=0.45 //layer=m1 \
 //thickness=0.36 //x=5.97 //y=1.3 //x2=5.97 //y2=1.75
r364 (  3 21 ) resistor r=0.0529306 //w=0.17 //l=0.085 //layer=m1 \
 //thickness=0.36 //x=5.885 //y=1.835 //x2=5.97 //y2=1.835
r365 (  3 4 ) resistor r=0.763359 //w=0.131 //l=0.8 //layer=m1 \
 //thickness=0.36 //x=5.885 //y=1.835 //x2=5.085 //y2=1.835
r366 (  2 4 ) resistor r=0.0698411 //w=0.17 //l=0.120208 //layer=m1 \
 //thickness=0.36 //x=5 //y=1.75 //x2=5.085 //y2=1.835
r367 (  1 20 ) resistor r=0.0764279 //w=0.233 //l=0.126491 //layer=m1 \
 //thickness=0.36 //x=5 //y=1.305 //x2=4.997 //y2=1.18
r368 (  1 2 ) resistor r=0.424618 //w=0.131 //l=0.445 //layer=m1 \
 //thickness=0.36 //x=5 //y=1.305 //x2=5 //y2=1.75
ends PM_AOAI4X1\%noxref_2

subckt PM_AOAI4X1\%VDD ( 1 2 12 13 23 44 52 68 95 105 118 121 122 126 127 128 \
 129 130 131 132 133 )
c193 ( 133 0 ) capacitor c=0.0392198f //x=9.555 //y=5.2
c194 ( 132 0 ) capacitor c=0.0247473f //x=8.675 //y=5.2
c195 ( 131 0 ) capacitor c=0.0652534f //x=7.805 //y=5.2
c196 ( 130 0 ) capacitor c=0.0230094f //x=4.905 //y=5.205
c197 ( 129 0 ) capacitor c=0.0399069f //x=2.895 //y=5.2
c198 ( 128 0 ) capacitor c=0.0247434f //x=2.015 //y=5.2
c199 ( 127 0 ) capacitor c=0.0678024f //x=1.145 //y=5.2
c200 ( 126 0 ) capacitor c=0.268827f //x=9.74 //y=7.58
c201 ( 124 0 ) capacitor c=0.00597439f //x=8.82 //y=7.585
c202 ( 123 0 ) capacitor c=0.00597439f //x=7.94 //y=7.585
c203 ( 122 0 ) capacitor c=0.130678f //x=7.15 //y=7.585
c204 ( 121 0 ) capacitor c=0.126563f //x=3.82 //y=7.585
c205 ( 120 0 ) capacitor c=0.00597439f //x=3.04 //y=7.585
c206 ( 119 0 ) capacitor c=0.00597439f //x=2.16 //y=7.585
c207 ( 118 0 ) capacitor c=0.272077f //x=1.23 //y=7.58
c208 ( 105 0 ) capacitor c=0.0287375f //x=9.615 //y=7.585
c209 ( 95 0 ) capacitor c=0.0291078f //x=8.735 //y=7.585
c210 ( 83 0 ) capacitor c=0.0283511f //x=7.855 //y=7.585
c211 ( 68 0 ) capacitor c=0.139031f //x=6.98 //y=7.585
c212 ( 62 0 ) capacitor c=0.0277785f //x=3.65 //y=7.585
c213 ( 52 0 ) capacitor c=0.0287375f //x=2.955 //y=7.585
c214 ( 44 0 ) capacitor c=0.0291078f //x=2.075 //y=7.585
c215 ( 27 0 ) capacitor c=0.00499323f //x=5.05 //y=7.585
c216 ( 23 0 ) capacitor c=0.221112f //x=9.74 //y=7.58
c217 ( 13 0 ) capacitor c=0.00916089f //x=5.05 //y=7.41
c218 ( 12 0 ) capacitor c=0.00572492f //x=5.05 //y=7.035
c219 ( 2 0 ) capacitor c=0.19705f //x=4.965 //y=7.585
r220 (  107 126 ) resistor r=4.23183 //w=0.7 //l=0.175 //layer=li \
 //thickness=0.1 //x=9.7 //y=7.41 //x2=9.7 //y2=7.585
r221 (  107 133 ) resistor r=33.1979 //w=0.187 //l=0.485 //layer=li \
 //thickness=0.1 //x=9.7 //y=7.41 //x2=9.7 //y2=6.925
r222 (  106 124 ) resistor r=2.87058 //w=0.35 //l=0.085 //layer=li \
 //thickness=0.1 //x=8.905 //y=7.585 //x2=8.82 //y2=7.585
r223 (  105 126 ) resistor r=2.87058 //w=0.35 //l=0.085 //layer=li \
 //thickness=0.1 //x=9.615 //y=7.585 //x2=9.7 //y2=7.585
r224 (  105 106 ) resistor r=24.7629 //w=0.367 //l=0.71 //layer=li \
 //thickness=0.1 //x=9.615 //y=7.585 //x2=8.905 //y2=7.585
r225 (  99 124 ) resistor r=4.23183 //w=0.7 //l=0.175 //layer=li \
 //thickness=0.1 //x=8.82 //y=7.41 //x2=8.82 //y2=7.585
r226 (  99 132 ) resistor r=33.1979 //w=0.187 //l=0.485 //layer=li \
 //thickness=0.1 //x=8.82 //y=7.41 //x2=8.82 //y2=6.925
r227 (  96 123 ) resistor r=2.87058 //w=0.35 //l=0.085 //layer=li \
 //thickness=0.1 //x=8.025 //y=7.585 //x2=7.94 //y2=7.585
r228 (  96 98 ) resistor r=21.1008 //w=0.367 //l=0.605 //layer=li \
 //thickness=0.1 //x=8.025 //y=7.585 //x2=8.63 //y2=7.585
r229 (  95 124 ) resistor r=2.87058 //w=0.35 //l=0.085 //layer=li \
 //thickness=0.1 //x=8.735 //y=7.585 //x2=8.82 //y2=7.585
r230 (  95 98 ) resistor r=3.66213 //w=0.367 //l=0.105 //layer=li \
 //thickness=0.1 //x=8.735 //y=7.585 //x2=8.63 //y2=7.585
r231 (  87 123 ) resistor r=4.23183 //w=0.7 //l=0.175 //layer=li \
 //thickness=0.1 //x=7.94 //y=7.41 //x2=7.94 //y2=7.585
r232 (  87 131 ) resistor r=56.4706 //w=0.187 //l=0.825 //layer=li \
 //thickness=0.1 //x=7.94 //y=7.41 //x2=7.94 //y2=6.585
r233 (  84 122 ) resistor r=5.29055 //w=0.35 //l=0.17 //layer=li \
 //thickness=0.1 //x=7.32 //y=7.585 //x2=7.15 //y2=7.585
r234 (  84 86 ) resistor r=6.97548 //w=0.367 //l=0.2 //layer=li \
 //thickness=0.1 //x=7.32 //y=7.585 //x2=7.52 //y2=7.585
r235 (  83 123 ) resistor r=2.87058 //w=0.35 //l=0.085 //layer=li \
 //thickness=0.1 //x=7.855 //y=7.585 //x2=7.94 //y2=7.585
r236 (  83 86 ) resistor r=11.6839 //w=0.367 //l=0.335 //layer=li \
 //thickness=0.1 //x=7.855 //y=7.585 //x2=7.52 //y2=7.585
r237 (  71 73 ) resistor r=38.7139 //w=0.367 //l=1.11 //layer=li \
 //thickness=0.1 //x=4.93 //y=7.585 //x2=6.04 //y2=7.585
r238 (  69 121 ) resistor r=5.29055 //w=0.35 //l=0.17 //layer=li \
 //thickness=0.1 //x=3.99 //y=7.585 //x2=3.82 //y2=7.585
r239 (  69 71 ) resistor r=32.7847 //w=0.367 //l=0.94 //layer=li \
 //thickness=0.1 //x=3.99 //y=7.585 //x2=4.93 //y2=7.585
r240 (  68 122 ) resistor r=5.29055 //w=0.35 //l=0.17 //layer=li \
 //thickness=0.1 //x=6.98 //y=7.585 //x2=7.15 //y2=7.585
r241 (  68 73 ) resistor r=32.7847 //w=0.367 //l=0.94 //layer=li \
 //thickness=0.1 //x=6.98 //y=7.585 //x2=6.04 //y2=7.585
r242 (  63 120 ) resistor r=2.87058 //w=0.35 //l=0.085 //layer=li \
 //thickness=0.1 //x=3.125 //y=7.585 //x2=3.04 //y2=7.585
r243 (  63 65 ) resistor r=11.3351 //w=0.367 //l=0.325 //layer=li \
 //thickness=0.1 //x=3.125 //y=7.585 //x2=3.45 //y2=7.585
r244 (  62 121 ) resistor r=5.29055 //w=0.35 //l=0.17 //layer=li \
 //thickness=0.1 //x=3.65 //y=7.585 //x2=3.82 //y2=7.585
r245 (  62 65 ) resistor r=6.97548 //w=0.367 //l=0.2 //layer=li \
 //thickness=0.1 //x=3.65 //y=7.585 //x2=3.45 //y2=7.585
r246 (  56 120 ) resistor r=4.23183 //w=0.7 //l=0.175 //layer=li \
 //thickness=0.1 //x=3.04 //y=7.41 //x2=3.04 //y2=7.585
r247 (  56 129 ) resistor r=33.1979 //w=0.187 //l=0.485 //layer=li \
 //thickness=0.1 //x=3.04 //y=7.41 //x2=3.04 //y2=6.925
r248 (  53 119 ) resistor r=2.87058 //w=0.35 //l=0.085 //layer=li \
 //thickness=0.1 //x=2.245 //y=7.585 //x2=2.16 //y2=7.585
r249 (  53 55 ) resistor r=3.31335 //w=0.367 //l=0.095 //layer=li \
 //thickness=0.1 //x=2.245 //y=7.585 //x2=2.34 //y2=7.585
r250 (  52 120 ) resistor r=2.87058 //w=0.35 //l=0.085 //layer=li \
 //thickness=0.1 //x=2.955 //y=7.585 //x2=3.04 //y2=7.585
r251 (  52 55 ) resistor r=21.4496 //w=0.367 //l=0.615 //layer=li \
 //thickness=0.1 //x=2.955 //y=7.585 //x2=2.34 //y2=7.585
r252 (  46 119 ) resistor r=4.23183 //w=0.7 //l=0.175 //layer=li \
 //thickness=0.1 //x=2.16 //y=7.41 //x2=2.16 //y2=7.585
r253 (  46 128 ) resistor r=33.1979 //w=0.187 //l=0.485 //layer=li \
 //thickness=0.1 //x=2.16 //y=7.41 //x2=2.16 //y2=6.925
r254 (  45 118 ) resistor r=2.87058 //w=0.35 //l=0.085 //layer=li \
 //thickness=0.1 //x=1.365 //y=7.585 //x2=1.28 //y2=7.585
r255 (  44 119 ) resistor r=2.87058 //w=0.35 //l=0.085 //layer=li \
 //thickness=0.1 //x=2.075 //y=7.585 //x2=2.16 //y2=7.585
r256 (  44 45 ) resistor r=24.7629 //w=0.367 //l=0.71 //layer=li \
 //thickness=0.1 //x=2.075 //y=7.585 //x2=1.365 //y2=7.585
r257 (  36 118 ) resistor r=4.23183 //w=0.7 //l=0.175 //layer=li \
 //thickness=0.1 //x=1.28 //y=7.41 //x2=1.28 //y2=7.585
r258 (  36 127 ) resistor r=56.4706 //w=0.187 //l=0.825 //layer=li \
 //thickness=0.1 //x=1.28 //y=7.41 //x2=1.28 //y2=6.585
r259 (  29 130 ) resistor r=9.3 //w=0.17 //l=0.17 //layer=mcon //count=1 \
 //x=5.05 //y=6.92 //x2=5.05 //y2=6.92
r260 (  23 126 ) resistor r=3.1 //w=0.17 //l=0.51 //layer=mcon //count=3 \
 //x=9.74 //y=7.58 //x2=9.74 //y2=7.58
r261 (  21 98 ) resistor r=3.1 //w=0.17 //l=0.51 //layer=mcon //count=3 \
 //x=8.63 //y=7.58 //x2=8.63 //y2=7.58
r262 (  21 23 ) resistor r=0.446141 //w=0.311 //l=1.11 //layer=m1 \
 //thickness=0.36 //x=8.63 //y=7.585 //x2=9.74 //y2=7.585
r263 (  19 86 ) resistor r=3.1 //w=0.17 //l=0.51 //layer=mcon //count=3 \
 //x=7.52 //y=7.58 //x2=7.52 //y2=7.58
r264 (  19 21 ) resistor r=0.446141 //w=0.311 //l=1.11 //layer=m1 \
 //thickness=0.36 //x=7.52 //y=7.585 //x2=8.63 //y2=7.585
r265 (  17 73 ) resistor r=3.1 //w=0.17 //l=0.51 //layer=mcon //count=3 \
 //x=6.04 //y=7.58 //x2=6.04 //y2=7.58
r266 (  17 19 ) resistor r=0.594855 //w=0.311 //l=1.48 //layer=m1 \
 //thickness=0.36 //x=6.04 //y=7.585 //x2=7.52 //y2=7.585
r267 (  14 27 ) resistor r=0.028033 //w=0.35 //l=0.085 //layer=m1 \
 //thickness=0.36 //x=5.135 //y=7.585 //x2=5.05 //y2=7.585
r268 (  13 27 ) resistor r=0.0413265 //w=0.7 //l=0.175 //layer=m1 \
 //thickness=0.36 //x=5.05 //y=7.41 //x2=5.05 //y2=7.585
r269 (  12 29 ) resistor r=0.0723371 //w=0.218 //l=0.115 //layer=m1 \
 //thickness=0.36 //x=5.05 //y=7.035 //x2=5.05 //y2=6.92
r270 (  12 13 ) resistor r=0.357824 //w=0.131 //l=0.375 //layer=m1 \
 //thickness=0.36 //x=5.05 //y=7.035 //x2=5.05 //y2=7.41
r271 (  11 71 ) resistor r=3.1 //w=0.17 //l=0.51 //layer=mcon //count=3 \
 //x=4.93 //y=7.58 //x2=4.93 //y2=7.58
r272 (  9 65 ) resistor r=3.1 //w=0.17 //l=0.51 //layer=mcon //count=3 \
 //x=3.45 //y=7.58 //x2=3.45 //y2=7.58
r273 (  9 11 ) resistor r=0.594855 //w=0.311 //l=1.48 //layer=m1 \
 //thickness=0.36 //x=3.45 //y=7.585 //x2=4.93 //y2=7.585
r274 (  7 55 ) resistor r=3.1 //w=0.17 //l=0.51 //layer=mcon //count=3 \
 //x=2.34 //y=7.58 //x2=2.34 //y2=7.58
r275 (  7 9 ) resistor r=0.446141 //w=0.311 //l=1.11 //layer=m1 \
 //thickness=0.36 //x=2.34 //y=7.585 //x2=3.45 //y2=7.585
r276 (  4 118 ) resistor r=3.1 //w=0.17 //l=0.51 //layer=mcon //count=3 \
 //x=1.23 //y=7.58 //x2=1.23 //y2=7.58
r277 (  4 7 ) resistor r=0.446141 //w=0.311 //l=1.11 //layer=m1 \
 //thickness=0.36 //x=1.23 //y=7.585 //x2=2.34 //y2=7.585
r278 (  2 27 ) resistor r=0.028033 //w=0.35 //l=0.085 //layer=m1 \
 //thickness=0.36 //x=4.965 //y=7.585 //x2=5.05 //y2=7.585
r279 (  2 11 ) resistor r=0.0140675 //w=0.311 //l=0.035 //layer=m1 \
 //thickness=0.36 //x=4.965 //y=7.585 //x2=4.93 //y2=7.585
r280 (  1 17 ) resistor r=0.223071 //w=0.311 //l=0.555 //layer=m1 \
 //thickness=0.36 //x=5.485 //y=7.585 //x2=6.04 //y2=7.585
r281 (  1 14 ) resistor r=0.140675 //w=0.311 //l=0.35 //layer=m1 \
 //thickness=0.36 //x=5.485 //y=7.585 //x2=5.135 //y2=7.585
ends PM_AOAI4X1\%VDD

subckt PM_AOAI4X1\%A ( 1 2 3 4 5 6 7 18 21 25 30 34 35 36 37 38 39 40 44 46 49 \
 50 60 )
c98 ( 60 0 ) capacitor c=0.0682508f //x=1.6 //y=4.88
c99 ( 50 0 ) capacitor c=0.0318956f //x=1.935 //y=1.39
c100 ( 49 0 ) capacitor c=0.0186809f //x=1.935 //y=1.045
c101 ( 46 0 ) capacitor c=0.0141821f //x=1.78 //y=1.545
c102 ( 44 0 ) capacitor c=0.0158553f //x=1.78 //y=0.89
c103 ( 40 0 ) capacitor c=0.088055f //x=1.405 //y=2.095
c104 ( 39 0 ) capacitor c=0.0229235f //x=1.405 //y=1.7
c105 ( 38 0 ) capacitor c=0.0234359f //x=1.405 //y=1.39
c106 ( 37 0 ) capacitor c=0.0198759f //x=1.405 //y=1.045
c107 ( 36 0 ) capacitor c=0.110369f //x=1.94 //y=6.2
c108 ( 35 0 ) capacitor c=0.154619f //x=1.5 //y=6.2
c109 ( 30 0 ) capacitor c=8.13425e-19 //x=1.6 //y=4.88
c110 ( 25 0 ) capacitor c=7.85889e-19 //x=1.6 //y=2.26
c111 ( 21 0 ) capacitor c=0.0113945f //x=1.6 //y=4.88
c112 ( 18 0 ) capacitor c=0.0108617f //x=1.6 //y=2.26
c113 ( 1 0 ) capacitor c=0.10646f //x=1.6 //y=2.4
r114 (  58 60 ) resistor r=20.6867 //w=0.233 //l=0.1 //layer=ply \
 //thickness=0.18 //x=1.5 //y=4.88 //x2=1.6 //y2=4.88
r115 (  51 60 ) resistor r=70.3348 //w=0.233 //l=0.414367 //layer=ply \
 //thickness=0.18 //x=1.94 //y=5.045 //x2=1.6 //y2=4.88
r116 (  50 62 ) resistor r=45.1352 //w=0.168 //l=0.173853 //layer=ply \
 //thickness=0.18 //x=1.935 //y=1.39 //x2=1.895 //y2=1.545
r117 (  49 61 ) resistor r=45.1352 //w=0.168 //l=0.173853 //layer=ply \
 //thickness=0.18 //x=1.935 //y=1.045 //x2=1.895 //y2=0.89
r118 (  49 50 ) resistor r=176.904 //w=0.094 //l=0.345 //layer=ply \
 //thickness=0.18 //x=1.935 //y=1.045 //x2=1.935 //y2=1.39
r119 (  47 57 ) resistor r=10.701 //w=0.21 //l=0.115 //layer=ply \
 //thickness=0.18 //x=1.56 //y=1.545 //x2=1.445 //y2=1.545
r120 (  46 62 ) resistor r=5.52526 //w=0.168 //l=0.115 //layer=ply \
 //thickness=0.18 //x=1.78 //y=1.545 //x2=1.895 //y2=1.545
r121 (  45 56 ) resistor r=5.52526 //w=0.168 //l=0.115 //layer=ply \
 //thickness=0.18 //x=1.56 //y=0.89 //x2=1.445 //y2=0.89
r122 (  44 61 ) resistor r=5.52526 //w=0.168 //l=0.115 //layer=ply \
 //thickness=0.18 //x=1.78 //y=0.89 //x2=1.895 //y2=0.89
r123 (  44 45 ) resistor r=112.809 //w=0.094 //l=0.22 //layer=ply \
 //thickness=0.18 //x=1.78 //y=0.89 //x2=1.56 //y2=0.89
r124 (  41 58 ) resistor r=13.0941 //w=0.233 //l=0.165 //layer=ply \
 //thickness=0.18 //x=1.5 //y=5.045 //x2=1.5 //y2=4.88
r125 (  40 55 ) resistor r=34.8111 //w=0.27 //l=0.264953 //layer=ply \
 //thickness=0.18 //x=1.405 //y=2.095 //x2=1.6 //y2=2.26
r126 (  39 57 ) resistor r=39.5823 //w=0.21 //l=0.173853 //layer=ply \
 //thickness=0.18 //x=1.405 //y=1.7 //x2=1.445 //y2=1.545
r127 (  39 40 ) resistor r=202.543 //w=0.094 //l=0.395 //layer=ply \
 //thickness=0.18 //x=1.405 //y=1.7 //x2=1.405 //y2=2.095
r128 (  38 57 ) resistor r=39.5823 //w=0.21 //l=0.173853 //layer=ply \
 //thickness=0.18 //x=1.405 //y=1.39 //x2=1.445 //y2=1.545
r129 (  37 56 ) resistor r=45.1352 //w=0.168 //l=0.173853 //layer=ply \
 //thickness=0.18 //x=1.405 //y=1.045 //x2=1.445 //y2=0.89
r130 (  37 38 ) resistor r=176.904 //w=0.094 //l=0.345 //layer=ply \
 //thickness=0.18 //x=1.405 //y=1.045 //x2=1.405 //y2=1.39
r131 (  36 51 ) resistor r=592.245 //w=0.094 //l=1.155 //layer=ply \
 //thickness=0.18 //x=1.94 //y=6.2 //x2=1.94 //y2=5.045
r132 (  35 41 ) resistor r=592.245 //w=0.094 //l=1.155 //layer=ply \
 //thickness=0.18 //x=1.5 //y=6.2 //x2=1.5 //y2=5.045
r133 (  34 46 ) resistor r=56.4043 //w=0.094 //l=0.11 //layer=ply \
 //thickness=0.18 //x=1.67 //y=1.545 //x2=1.78 //y2=1.545
r134 (  34 47 ) resistor r=56.4043 //w=0.094 //l=0.11 //layer=ply \
 //thickness=0.18 //x=1.67 //y=1.545 //x2=1.56 //y2=1.545
r135 (  30 60 ) resistor r=152 //w=0.17 //l=0.17 //layer=licon //count=1 \
 //x=1.6 //y=4.88 //x2=1.6 //y2=4.88
r136 (  25 55 ) resistor r=152 //w=0.17 //l=0.17 //layer=licon //count=1 \
 //x=1.6 //y=2.26 //x2=1.6 //y2=2.26
r137 (  21 30 ) resistor r=9.3 //w=0.17 //l=0.17 //layer=mcon //count=1 \
 //x=1.6 //y=4.88 //x2=1.6 //y2=4.88
r138 (  21 22 ) resistor r=0.103207 //w=0.196 //l=0.14 //layer=m1 \
 //thickness=0.36 //x=1.602 //y=4.88 //x2=1.602 //y2=4.74
r139 (  18 25 ) resistor r=9.3 //w=0.17 //l=0.17 //layer=mcon //count=1 \
 //x=1.6 //y=2.26 //x2=1.6 //y2=2.26
r140 (  8 18 ) resistor r=0.0933015 //w=0.201 //l=0.125 //layer=m1 \
 //thickness=0.36 //x=1.6 //y=2.385 //x2=1.6 //y2=2.26
r141 (  7 22 ) resistor r=0.114504 //w=0.131 //l=0.12 //layer=m1 \
 //thickness=0.36 //x=1.6 //y=4.62 //x2=1.6 //y2=4.74
r142 (  6 7 ) resistor r=0.353053 //w=0.131 //l=0.37 //layer=m1 \
 //thickness=0.36 //x=1.6 //y=4.25 //x2=1.6 //y2=4.62
r143 (  5 6 ) resistor r=0.353053 //w=0.131 //l=0.37 //layer=m1 \
 //thickness=0.36 //x=1.6 //y=3.88 //x2=1.6 //y2=4.25
r144 (  4 5 ) resistor r=0.353053 //w=0.131 //l=0.37 //layer=m1 \
 //thickness=0.36 //x=1.6 //y=3.51 //x2=1.6 //y2=3.88
r145 (  3 4 ) resistor r=0.353053 //w=0.131 //l=0.37 //layer=m1 \
 //thickness=0.36 //x=1.6 //y=3.14 //x2=1.6 //y2=3.51
r146 (  2 3 ) resistor r=0.353053 //w=0.131 //l=0.37 //layer=m1 \
 //thickness=0.36 //x=1.6 //y=2.77 //x2=1.6 //y2=3.14
r147 (  1 2 ) resistor r=0.353053 //w=0.131 //l=0.37 //layer=m1 \
 //thickness=0.36 //x=1.6 //y=2.4 //x2=1.6 //y2=2.77
r148 (  1 8 ) resistor r=0.014313 //w=0.131 //l=0.015 //layer=m1 \
 //thickness=0.36 //x=1.6 //y=2.4 //x2=1.6 //y2=2.385
ends PM_AOAI4X1\%A

subckt PM_AOAI4X1\%B ( 1 2 3 4 5 6 7 9 18 24 29 33 34 35 36 37 38 43 45 47 53 \
 54 56 57 60 )
c107 ( 60 0 ) capacitor c=0.0393541f //x=2.37 //y=4.88
c108 ( 57 0 ) capacitor c=0.0284095f //x=2.34 //y=2.095
c109 ( 56 0 ) capacitor c=0.0476356f //x=2.34 //y=2.26
c110 ( 54 0 ) capacitor c=0.0439708f //x=2.905 //y=1.43
c111 ( 53 0 ) capacitor c=0.0192582f //x=2.905 //y=1.085
c112 ( 47 0 ) capacitor c=0.0162526f //x=2.75 //y=1.585
c113 ( 45 0 ) capacitor c=0.0157807f //x=2.75 //y=0.93
c114 ( 43 0 ) capacitor c=0.0372668f //x=2.745 //y=4.97
c115 ( 38 0 ) capacitor c=0.0210762f //x=2.375 //y=1.74
c116 ( 37 0 ) capacitor c=0.0168511f //x=2.375 //y=1.43
c117 ( 36 0 ) capacitor c=0.0175485f //x=2.375 //y=1.085
c118 ( 35 0 ) capacitor c=0.155269f //x=2.82 //y=6.2
c119 ( 34 0 ) capacitor c=0.110375f //x=2.38 //y=6.2
c120 ( 29 0 ) capacitor c=8.90417e-19 //x=2.37 //y=4.88
c121 ( 24 0 ) capacitor c=7.72439e-19 //x=2.34 //y=2.26
c122 ( 18 0 ) capacitor c=0.00687137f //x=2.34 //y=2.26
c123 ( 9 0 ) capacitor c=0.00493417f //x=2.34 //y=4.735
c124 ( 1 0 ) capacitor c=0.0590889f //x=2.34 //y=2.4
r125 (  62 63 ) resistor r=32.4568 //w=0.214 //l=0.075 //layer=ply \
 //thickness=0.18 //x=2.37 //y=4.97 //x2=2.37 //y2=5.045
r126 (  60 62 ) resistor r=20.271 //w=0.214 //l=0.09 //layer=ply \
 //thickness=0.18 //x=2.37 //y=4.88 //x2=2.37 //y2=4.97
r127 (  56 57 ) resistor r=52.7279 //w=0.214 //l=0.165 //layer=ply \
 //thickness=0.18 //x=2.34 //y=2.26 //x2=2.34 //y2=2.095
r128 (  54 67 ) resistor r=45.1352 //w=0.168 //l=0.173853 //layer=ply \
 //thickness=0.18 //x=2.905 //y=1.43 //x2=2.865 //y2=1.585
r129 (  53 66 ) resistor r=45.1352 //w=0.168 //l=0.173853 //layer=ply \
 //thickness=0.18 //x=2.905 //y=1.085 //x2=2.865 //y2=0.93
r130 (  53 54 ) resistor r=176.904 //w=0.094 //l=0.345 //layer=ply \
 //thickness=0.18 //x=2.905 //y=1.085 //x2=2.905 //y2=1.43
r131 (  48 65 ) resistor r=10.701 //w=0.21 //l=0.115 //layer=ply \
 //thickness=0.18 //x=2.53 //y=1.585 //x2=2.415 //y2=1.585
r132 (  47 67 ) resistor r=5.52526 //w=0.168 //l=0.115 //layer=ply \
 //thickness=0.18 //x=2.75 //y=1.585 //x2=2.865 //y2=1.585
r133 (  46 64 ) resistor r=5.52526 //w=0.168 //l=0.115 //layer=ply \
 //thickness=0.18 //x=2.53 //y=0.93 //x2=2.415 //y2=0.93
r134 (  45 66 ) resistor r=5.52526 //w=0.168 //l=0.115 //layer=ply \
 //thickness=0.18 //x=2.75 //y=0.93 //x2=2.865 //y2=0.93
r135 (  45 46 ) resistor r=112.809 //w=0.094 //l=0.22 //layer=ply \
 //thickness=0.18 //x=2.75 //y=0.93 //x2=2.53 //y2=0.93
r136 (  44 62 ) resistor r=16.5046 //w=0.27 //l=0.135 //layer=ply \
 //thickness=0.18 //x=2.505 //y=4.97 //x2=2.37 //y2=4.97
r137 (  43 50 ) resistor r=26.9307 //w=0.15 //l=0.106066 //layer=ply \
 //thickness=0.18 //x=2.745 //y=4.97 //x2=2.82 //y2=5.045
r138 (  43 44 ) resistor r=123.064 //w=0.094 //l=0.24 //layer=ply \
 //thickness=0.18 //x=2.745 //y=4.97 //x2=2.505 //y2=4.97
r139 (  38 65 ) resistor r=39.5823 //w=0.21 //l=0.173853 //layer=ply \
 //thickness=0.18 //x=2.375 //y=1.74 //x2=2.415 //y2=1.585
r140 (  38 57 ) resistor r=182.032 //w=0.094 //l=0.355 //layer=ply \
 //thickness=0.18 //x=2.375 //y=1.74 //x2=2.375 //y2=2.095
r141 (  37 65 ) resistor r=39.5823 //w=0.21 //l=0.173853 //layer=ply \
 //thickness=0.18 //x=2.375 //y=1.43 //x2=2.415 //y2=1.585
r142 (  36 64 ) resistor r=45.1352 //w=0.168 //l=0.173853 //layer=ply \
 //thickness=0.18 //x=2.375 //y=1.085 //x2=2.415 //y2=0.93
r143 (  36 37 ) resistor r=176.904 //w=0.094 //l=0.345 //layer=ply \
 //thickness=0.18 //x=2.375 //y=1.085 //x2=2.375 //y2=1.43
r144 (  35 50 ) resistor r=592.245 //w=0.094 //l=1.155 //layer=ply \
 //thickness=0.18 //x=2.82 //y=6.2 //x2=2.82 //y2=5.045
r145 (  34 63 ) resistor r=592.245 //w=0.094 //l=1.155 //layer=ply \
 //thickness=0.18 //x=2.38 //y=6.2 //x2=2.38 //y2=5.045
r146 (  33 47 ) resistor r=56.4043 //w=0.094 //l=0.11 //layer=ply \
 //thickness=0.18 //x=2.64 //y=1.585 //x2=2.75 //y2=1.585
r147 (  33 48 ) resistor r=56.4043 //w=0.094 //l=0.11 //layer=ply \
 //thickness=0.18 //x=2.64 //y=1.585 //x2=2.53 //y2=1.585
r148 (  29 60 ) resistor r=152 //w=0.17 //l=0.17 //layer=licon //count=1 \
 //x=2.37 //y=4.88 //x2=2.37 //y2=4.88
r149 (  24 56 ) resistor r=152 //w=0.17 //l=0.17 //layer=licon //count=1 \
 //x=2.34 //y=2.26 //x2=2.34 //y2=2.26
r150 (  22 29 ) resistor r=9.3 //w=0.17 //l=0.17 //layer=mcon //count=1 \
 //x=2.37 //y=4.88 //x2=2.37 //y2=4.88
r151 (  18 24 ) resistor r=9.3 //w=0.17 //l=0.17 //layer=mcon //count=1 \
 //x=2.34 //y=2.26 //x2=2.34 //y2=2.26
r152 (  18 20 ) resistor r=0.0936408 //w=0.196 //l=0.125 //layer=m1 \
 //thickness=0.36 //x=2.342 //y=2.26 //x2=2.342 //y2=2.385
r153 (  9 22 ) resistor r=0.0878548 //w=0.228 //l=0.159295 //layer=m1 \
 //thickness=0.36 //x=2.34 //y=4.735 //x2=2.37 //y2=4.88
r154 (  7 9 ) resistor r=0.109733 //w=0.131 //l=0.115 //layer=m1 \
 //thickness=0.36 //x=2.34 //y=4.62 //x2=2.34 //y2=4.735
r155 (  6 7 ) resistor r=0.353053 //w=0.131 //l=0.37 //layer=m1 \
 //thickness=0.36 //x=2.34 //y=4.25 //x2=2.34 //y2=4.62
r156 (  5 6 ) resistor r=0.353053 //w=0.131 //l=0.37 //layer=m1 \
 //thickness=0.36 //x=2.34 //y=3.88 //x2=2.34 //y2=4.25
r157 (  4 5 ) resistor r=0.353053 //w=0.131 //l=0.37 //layer=m1 \
 //thickness=0.36 //x=2.34 //y=3.51 //x2=2.34 //y2=3.88
r158 (  3 4 ) resistor r=0.353053 //w=0.131 //l=0.37 //layer=m1 \
 //thickness=0.36 //x=2.34 //y=3.14 //x2=2.34 //y2=3.51
r159 (  2 3 ) resistor r=0.353053 //w=0.131 //l=0.37 //layer=m1 \
 //thickness=0.36 //x=2.34 //y=2.77 //x2=2.34 //y2=3.14
r160 (  1 2 ) resistor r=0.353053 //w=0.131 //l=0.37 //layer=m1 \
 //thickness=0.36 //x=2.34 //y=2.4 //x2=2.34 //y2=2.77
r161 (  1 20 ) resistor r=0.014313 //w=0.131 //l=0.015 //layer=m1 \
 //thickness=0.36 //x=2.34 //y=2.4 //x2=2.34 //y2=2.385
ends PM_AOAI4X1\%B

subckt PM_AOAI4X1\%noxref_6 ( 1 3 5 10 14 17 20 30 46 47 48 )
c94 ( 48 0 ) capacitor c=0.0348842f //x=6.225 //y=5.205
c95 ( 46 0 ) capacitor c=0.0118024f //x=4.475 //y=5.205
c96 ( 30 0 ) capacitor c=0.0302598f //x=5.49 //y=5.56
c97 ( 20 0 ) capacitor c=0.045655f //x=4.61 //y=5.56
c98 ( 17 0 ) capacitor c=0.0164155f //x=6.37 //y=6.92
c99 ( 14 0 ) capacitor c=0.00604334f //x=5.49 //y=6.92
c100 ( 10 0 ) capacitor c=0.0112444f //x=5.49 //y=5.39
c101 ( 5 0 ) capacitor c=0.012947f //x=4.61 //y=5.39
c102 ( 3 0 ) capacitor c=0.00694548f //x=6.24 //y=7.09
c103 ( 1 0 ) capacitor c=0.0131356f //x=5.37 //y=5.39
r104 (  37 47 ) resistor r=23.2727 //w=0.187 //l=0.34 //layer=li \
 //thickness=0.1 //x=5.49 //y=6.92 //x2=5.49 //y2=6.58
r105 (  30 47 ) resistor r=23.2727 //w=0.187 //l=0.34 //layer=li \
 //thickness=0.1 //x=5.49 //y=5.56 //x2=5.49 //y2=5.9
r106 (  20 46 ) resistor r=23.2727 //w=0.187 //l=0.34 //layer=li \
 //thickness=0.1 //x=4.61 //y=5.56 //x2=4.61 //y2=5.9
r107 (  17 48 ) resistor r=9.3 //w=0.17 //l=0.17 //layer=mcon //count=1 \
 //x=6.37 //y=6.92 //x2=6.37 //y2=6.92
r108 (  17 18 ) resistor r=0.0932018 //w=0.228 //l=0.17 //layer=m1 \
 //thickness=0.36 //x=6.362 //y=6.92 //x2=6.362 //y2=7.09
r109 (  14 37 ) resistor r=9.3 //w=0.17 //l=0.17 //layer=mcon //count=1 \
 //x=5.49 //y=6.92 //x2=5.49 //y2=6.92
r110 (  14 15 ) resistor r=0.0992991 //w=0.214 //l=0.17 //layer=m1 \
 //thickness=0.36 //x=5.49 //y=6.92 //x2=5.49 //y2=7.09
r111 (  12 30 ) resistor r=9.3 //w=0.17 //l=0.17 //layer=mcon //count=1 \
 //x=5.49 //y=5.56 //x2=5.49 //y2=5.56
r112 (  10 12 ) resistor r=0.097032 //w=0.219 //l=0.17 //layer=m1 \
 //thickness=0.36 //x=5.49 //y=5.39 //x2=5.49 //y2=5.56
r113 (  7 20 ) resistor r=9.3 //w=0.17 //l=0.17 //layer=mcon //count=1 \
 //x=4.61 //y=5.56 //x2=4.61 //y2=5.56
r114 (  5 7 ) resistor r=0.0997653 //w=0.213 //l=0.17 //layer=m1 \
 //thickness=0.36 //x=4.61 //y=5.39 //x2=4.61 //y2=5.56
r115 (  4 15 ) resistor r=0.0213909 //w=0.214 //l=0.115 //layer=m1 \
 //thickness=0.36 //x=5.605 //y=7.09 //x2=5.49 //y2=7.09
r116 (  3 18 ) resistor r=0.0251868 //w=0.228 //l=0.122 //layer=m1 \
 //thickness=0.36 //x=6.24 //y=7.09 //x2=6.362 //y2=7.09
r117 (  3 4 ) resistor r=0.605916 //w=0.131 //l=0.635 //layer=m1 \
 //thickness=0.36 //x=6.24 //y=7.09 //x2=5.605 //y2=7.09
r118 (  2 5 ) resistor r=0.0211096 //w=0.213 //l=0.115 //layer=m1 \
 //thickness=0.36 //x=4.725 //y=5.39 //x2=4.61 //y2=5.39
r119 (  1 10 ) resistor r=0.0227762 //w=0.219 //l=0.12 //layer=m1 \
 //thickness=0.36 //x=5.37 //y=5.39 //x2=5.49 //y2=5.39
r120 (  1 2 ) resistor r=0.615458 //w=0.131 //l=0.645 //layer=m1 \
 //thickness=0.36 //x=5.37 //y=5.39 //x2=4.725 //y2=5.39
ends PM_AOAI4X1\%noxref_6

subckt PM_AOAI4X1\%C ( 1 2 3 4 5 6 7 18 22 26 31 35 36 37 38 39 40 45 47 49 55 \
 56 58 59 62 )
c119 ( 62 0 ) capacitor c=0.0404287f //x=5.705 //y=4.885
c120 ( 59 0 ) capacitor c=0.0292709f //x=5.67 //y=2.095
c121 ( 58 0 ) capacitor c=0.0468503f //x=5.67 //y=2.26
c122 ( 56 0 ) capacitor c=0.0237765f //x=6.235 //y=1.435
c123 ( 55 0 ) capacitor c=0.0191782f //x=6.235 //y=1.085
c124 ( 49 0 ) capacitor c=0.035988f //x=6.08 //y=1.585
c125 ( 47 0 ) capacitor c=0.0157803f //x=6.08 //y=0.93
c126 ( 45 0 ) capacitor c=0.036638f //x=6.075 //y=4.975
c127 ( 40 0 ) capacitor c=0.0206674f //x=5.705 //y=1.74
c128 ( 39 0 ) capacitor c=0.0169638f //x=5.705 //y=1.435
c129 ( 38 0 ) capacitor c=0.0185462f //x=5.705 //y=1.085
c130 ( 37 0 ) capacitor c=0.155887f //x=6.15 //y=6.205
c131 ( 36 0 ) capacitor c=0.110534f //x=5.71 //y=6.205
c132 ( 31 0 ) capacitor c=0.0011312f //x=5.705 //y=4.885
c133 ( 26 0 ) capacitor c=9.45497e-19 //x=5.67 //y=2.26
c134 ( 22 0 ) capacitor c=0.0061903f //x=5.705 //y=4.885
c135 ( 18 0 ) capacitor c=0.00573992f //x=5.67 //y=2.26
c136 ( 1 0 ) capacitor c=0.0570424f //x=5.67 //y=2.4
r137 (  64 65 ) resistor r=32.4568 //w=0.214 //l=0.075 //layer=ply \
 //thickness=0.18 //x=5.705 //y=4.975 //x2=5.705 //y2=5.05
r138 (  62 64 ) resistor r=20.271 //w=0.214 //l=0.09 //layer=ply \
 //thickness=0.18 //x=5.705 //y=4.885 //x2=5.705 //y2=4.975
r139 (  58 59 ) resistor r=52.7279 //w=0.214 //l=0.165 //layer=ply \
 //thickness=0.18 //x=5.67 //y=2.26 //x2=5.67 //y2=2.095
r140 (  56 69 ) resistor r=4.95774 //w=0.164 //l=0.112 //layer=ply \
 //thickness=0.18 //x=6.235 //y=1.435 //x2=6.235 //y2=1.547
r141 (  55 68 ) resistor r=45.1352 //w=0.168 //l=0.173853 //layer=ply \
 //thickness=0.18 //x=6.235 //y=1.085 //x2=6.195 //y2=0.93
r142 (  55 56 ) resistor r=179.468 //w=0.094 //l=0.35 //layer=ply \
 //thickness=0.18 //x=6.235 //y=1.085 //x2=6.235 //y2=1.435
r143 (  50 67 ) resistor r=10.8103 //w=0.211 //l=0.115 //layer=ply \
 //thickness=0.18 //x=5.86 //y=1.585 //x2=5.745 //y2=1.585
r144 (  49 69 ) resistor r=45.9962 //w=0.164 //l=0.17296 //layer=ply \
 //thickness=0.18 //x=6.08 //y=1.585 //x2=6.235 //y2=1.547
r145 (  48 66 ) resistor r=5.52526 //w=0.168 //l=0.115 //layer=ply \
 //thickness=0.18 //x=5.86 //y=0.93 //x2=5.745 //y2=0.93
r146 (  47 68 ) resistor r=5.52526 //w=0.168 //l=0.115 //layer=ply \
 //thickness=0.18 //x=6.08 //y=0.93 //x2=6.195 //y2=0.93
r147 (  47 48 ) resistor r=112.809 //w=0.094 //l=0.22 //layer=ply \
 //thickness=0.18 //x=6.08 //y=0.93 //x2=5.86 //y2=0.93
r148 (  46 64 ) resistor r=16.5046 //w=0.27 //l=0.135 //layer=ply \
 //thickness=0.18 //x=5.84 //y=4.975 //x2=5.705 //y2=4.975
r149 (  45 52 ) resistor r=26.9307 //w=0.15 //l=0.106066 //layer=ply \
 //thickness=0.18 //x=6.075 //y=4.975 //x2=6.15 //y2=5.05
r150 (  45 46 ) resistor r=120.5 //w=0.094 //l=0.235 //layer=ply \
 //thickness=0.18 //x=6.075 //y=4.975 //x2=5.84 //y2=4.975
r151 (  40 67 ) resistor r=39.5036 //w=0.211 //l=0.173853 //layer=ply \
 //thickness=0.18 //x=5.705 //y=1.74 //x2=5.745 //y2=1.585
r152 (  40 59 ) resistor r=182.032 //w=0.094 //l=0.355 //layer=ply \
 //thickness=0.18 //x=5.705 //y=1.74 //x2=5.705 //y2=2.095
r153 (  39 67 ) resistor r=38.3614 //w=0.211 //l=0.168819 //layer=ply \
 //thickness=0.18 //x=5.705 //y=1.435 //x2=5.745 //y2=1.585
r154 (  38 66 ) resistor r=45.1352 //w=0.168 //l=0.173853 //layer=ply \
 //thickness=0.18 //x=5.705 //y=1.085 //x2=5.745 //y2=0.93
r155 (  38 39 ) resistor r=179.468 //w=0.094 //l=0.35 //layer=ply \
 //thickness=0.18 //x=5.705 //y=1.085 //x2=5.705 //y2=1.435
r156 (  37 52 ) resistor r=592.245 //w=0.094 //l=1.155 //layer=ply \
 //thickness=0.18 //x=6.15 //y=6.205 //x2=6.15 //y2=5.05
r157 (  36 65 ) resistor r=592.245 //w=0.094 //l=1.155 //layer=ply \
 //thickness=0.18 //x=5.71 //y=6.205 //x2=5.71 //y2=5.05
r158 (  35 49 ) resistor r=56.4043 //w=0.094 //l=0.11 //layer=ply \
 //thickness=0.18 //x=5.97 //y=1.585 //x2=6.08 //y2=1.585
r159 (  35 50 ) resistor r=56.4043 //w=0.094 //l=0.11 //layer=ply \
 //thickness=0.18 //x=5.97 //y=1.585 //x2=5.86 //y2=1.585
r160 (  31 62 ) resistor r=152 //w=0.17 //l=0.17 //layer=licon //count=1 \
 //x=5.705 //y=4.885 //x2=5.705 //y2=4.885
r161 (  26 58 ) resistor r=152 //w=0.17 //l=0.17 //layer=licon //count=1 \
 //x=5.67 //y=2.26 //x2=5.67 //y2=2.26
r162 (  22 31 ) resistor r=9.3 //w=0.17 //l=0.17 //layer=mcon //count=1 \
 //x=5.705 //y=4.885 //x2=5.705 //y2=4.885
r163 (  22 23 ) resistor r=0.105739 //w=0.201 //l=0.145 //layer=m1 \
 //thickness=0.36 //x=5.705 //y=4.885 //x2=5.705 //y2=4.74
r164 (  18 26 ) resistor r=9.3 //w=0.17 //l=0.17 //layer=mcon //count=1 \
 //x=5.67 //y=2.26 //x2=5.67 //y2=2.26
r165 (  18 20 ) resistor r=0.0977888 //w=0.216 //l=0.135 //layer=m1 \
 //thickness=0.36 //x=5.667 //y=2.26 //x2=5.667 //y2=2.395
r166 (  7 23 ) resistor r=0.114504 //w=0.131 //l=0.12 //layer=m1 \
 //thickness=0.36 //x=5.67 //y=4.62 //x2=5.67 //y2=4.74
r167 (  6 7 ) resistor r=0.353053 //w=0.131 //l=0.37 //layer=m1 \
 //thickness=0.36 //x=5.67 //y=4.25 //x2=5.67 //y2=4.62
r168 (  5 6 ) resistor r=0.353053 //w=0.131 //l=0.37 //layer=m1 \
 //thickness=0.36 //x=5.67 //y=3.88 //x2=5.67 //y2=4.25
r169 (  4 5 ) resistor r=0.353053 //w=0.131 //l=0.37 //layer=m1 \
 //thickness=0.36 //x=5.67 //y=3.51 //x2=5.67 //y2=3.88
r170 (  3 4 ) resistor r=0.353053 //w=0.131 //l=0.37 //layer=m1 \
 //thickness=0.36 //x=5.67 //y=3.14 //x2=5.67 //y2=3.51
r171 (  2 3 ) resistor r=0.353053 //w=0.131 //l=0.37 //layer=m1 \
 //thickness=0.36 //x=5.67 //y=2.77 //x2=5.67 //y2=3.14
r172 (  1 2 ) resistor r=0.353053 //w=0.131 //l=0.37 //layer=m1 \
 //thickness=0.36 //x=5.67 //y=2.4 //x2=5.67 //y2=2.77
r173 (  1 20 ) resistor r=0.00477099 //w=0.131 //l=0.005 //layer=m1 \
 //thickness=0.36 //x=5.67 //y=2.4 //x2=5.67 //y2=2.395
ends PM_AOAI4X1\%C

subckt PM_AOAI4X1\%GND ( 1 2 8 27 30 31 35 36 41 44 59 68 82 87 92 103 111 121 \
 122 123 124 )
c215 ( 124 0 ) capacitor c=0.00843555f //x=8.14 //y=1.045
c216 ( 123 0 ) capacitor c=0.0737492f //x=4.38 //y=0.545
c217 ( 122 0 ) capacitor c=0.00843555f //x=1.48 //y=1.045
c218 ( 121 0 ) capacitor c=0.112626f //x=7.15 //y=0.175
c219 ( 118 0 ) capacitor c=0.00597439f //x=6.455 //y=0.175
c220 ( 115 0 ) capacitor c=0.00597439f //x=5.485 //y=0.175
c221 ( 112 0 ) capacitor c=0.00597439f //x=4.515 //y=0.175
c222 ( 111 0 ) capacitor c=0.112772f //x=3.82 //y=0.175
c223 ( 103 0 ) capacitor c=0.335023f //x=9.74 //y=0.18
c224 ( 92 0 ) capacitor c=0.0221206f //x=6.98 //y=0.175
c225 ( 87 0 ) capacitor c=0.00739123f //x=6.455 //y=0.625
c226 ( 82 0 ) capacitor c=0.0152893f //x=6.37 //y=0.71
c227 ( 78 0 ) capacitor c=0.0258125f //x=6.37 //y=0.175
c228 ( 73 0 ) capacitor c=0.00726869f //x=5.485 //y=0.625
c229 ( 68 0 ) capacitor c=0.0165507f //x=5.4 //y=0.71
c230 ( 64 0 ) capacitor c=0.0257966f //x=5.4 //y=0.175
c231 ( 59 0 ) capacitor c=0.00739123f //x=4.515 //y=0.625
c232 ( 56 0 ) capacitor c=0.0229116f //x=4.43 //y=0.175
c233 ( 44 0 ) capacitor c=0.201723f //x=1.23 //y=0.18
c234 ( 41 0 ) capacitor c=0.12525f //x=3.65 //y=0.175
c235 ( 38 0 ) capacitor c=0.00509083f //x=8.33 //y=0.175
c236 ( 36 0 ) capacitor c=0.0278993f //x=8.327 //y=1.005
c237 ( 35 0 ) capacitor c=0.0137458f //x=8.33 //y=1.135
c238 ( 33 0 ) capacitor c=0.00509083f //x=1.67 //y=0.175
c239 ( 31 0 ) capacitor c=0.0278993f //x=1.667 //y=1.005
c240 ( 30 0 ) capacitor c=0.0168135f //x=1.67 //y=1.135
c241 ( 27 0 ) capacitor c=0.102568f //x=9.74 //y=0.18
c242 ( 8 0 ) capacitor c=0.221041f //x=8.245 //y=0.175
c243 ( 2 0 ) capacitor c=0.0764176f //x=1.585 //y=0.175
r244 (  101 103 ) resistor r=38.7139 //w=0.367 //l=1.11 //layer=li \
 //thickness=0.1 //x=8.63 //y=0.175 //x2=9.74 //y2=0.175
r245 (  99 101 ) resistor r=38.7139 //w=0.367 //l=1.11 //layer=li \
 //thickness=0.1 //x=7.52 //y=0.175 //x2=8.63 //y2=0.175
r246 (  97 121 ) resistor r=5.29055 //w=0.35 //l=0.17 //layer=li \
 //thickness=0.1 //x=7.32 //y=0.175 //x2=7.15 //y2=0.175
r247 (  97 99 ) resistor r=6.97548 //w=0.367 //l=0.2 //layer=li \
 //thickness=0.1 //x=7.32 //y=0.175 //x2=7.52 //y2=0.175
r248 (  93 118 ) resistor r=2.87058 //w=0.35 //l=0.085 //layer=li \
 //thickness=0.1 //x=6.54 //y=0.175 //x2=6.455 //y2=0.175
r249 (  92 121 ) resistor r=5.29055 //w=0.35 //l=0.17 //layer=li \
 //thickness=0.1 //x=6.98 //y=0.175 //x2=7.15 //y2=0.175
r250 (  92 93 ) resistor r=15.346 //w=0.367 //l=0.44 //layer=li \
 //thickness=0.1 //x=6.98 //y=0.175 //x2=6.54 //y2=0.175
r251 (  88 123 ) resistor r=5.4201 //w=0.17 //l=0.085 //layer=li \
 //thickness=0.1 //x=6.455 //y=0.795 //x2=6.455 //y2=0.71
r252 (  88 123 ) resistor r=18.139 //w=0.187 //l=0.265 //layer=li \
 //thickness=0.1 //x=6.455 //y=0.795 //x2=6.455 //y2=1.06
r253 (  87 123 ) resistor r=5.4201 //w=0.17 //l=0.085 //layer=li \
 //thickness=0.1 //x=6.455 //y=0.625 //x2=6.455 //y2=0.71
r254 (  86 118 ) resistor r=4.23183 //w=0.7 //l=0.175 //layer=li \
 //thickness=0.1 //x=6.455 //y=0.35 //x2=6.455 //y2=0.175
r255 (  86 87 ) resistor r=18.8235 //w=0.187 //l=0.275 //layer=li \
 //thickness=0.1 //x=6.455 //y=0.35 //x2=6.455 //y2=0.625
r256 (  83 123 ) resistor r=6.4 //w=0.17 //l=0.085 //layer=li //thickness=0.1 \
 //x=5.57 //y=0.71 //x2=5.485 //y2=0.71
r257 (  83 123 ) resistor r=27.3797 //w=0.187 //l=0.4 //layer=li \
 //thickness=0.1 //x=5.57 //y=0.71 //x2=5.97 //y2=0.71
r258 (  82 123 ) resistor r=1.40859 //w=0.34 //l=0.085 //layer=li \
 //thickness=0.1 //x=6.37 //y=0.71 //x2=6.455 //y2=0.71
r259 (  82 123 ) resistor r=27.3797 //w=0.187 //l=0.4 //layer=li \
 //thickness=0.1 //x=6.37 //y=0.71 //x2=5.97 //y2=0.71
r260 (  79 115 ) resistor r=2.87058 //w=0.35 //l=0.085 //layer=li \
 //thickness=0.1 //x=5.57 //y=0.175 //x2=5.485 //y2=0.175
r261 (  79 81 ) resistor r=16.3924 //w=0.367 //l=0.47 //layer=li \
 //thickness=0.1 //x=5.57 //y=0.175 //x2=6.04 //y2=0.175
r262 (  78 118 ) resistor r=2.87058 //w=0.35 //l=0.085 //layer=li \
 //thickness=0.1 //x=6.37 //y=0.175 //x2=6.455 //y2=0.175
r263 (  78 81 ) resistor r=11.5095 //w=0.367 //l=0.33 //layer=li \
 //thickness=0.1 //x=6.37 //y=0.175 //x2=6.04 //y2=0.175
r264 (  74 123 ) resistor r=6.4 //w=0.17 //l=0.085 //layer=li //thickness=0.1 \
 //x=5.485 //y=0.795 //x2=5.485 //y2=0.71
r265 (  74 123 ) resistor r=18.139 //w=0.187 //l=0.265 //layer=li \
 //thickness=0.1 //x=5.485 //y=0.795 //x2=5.485 //y2=1.06
r266 (  73 123 ) resistor r=6.4 //w=0.17 //l=0.085 //layer=li //thickness=0.1 \
 //x=5.485 //y=0.625 //x2=5.485 //y2=0.71
r267 (  72 115 ) resistor r=4.23183 //w=0.7 //l=0.175 //layer=li \
 //thickness=0.1 //x=5.485 //y=0.35 //x2=5.485 //y2=0.175
r268 (  72 73 ) resistor r=18.8235 //w=0.187 //l=0.275 //layer=li \
 //thickness=0.1 //x=5.485 //y=0.35 //x2=5.485 //y2=0.625
r269 (  69 123 ) resistor r=1.40859 //w=0.34 //l=0.085 //layer=li \
 //thickness=0.1 //x=4.6 //y=0.71 //x2=4.515 //y2=0.71
r270 (  69 123 ) resistor r=27.3797 //w=0.187 //l=0.4 //layer=li \
 //thickness=0.1 //x=4.6 //y=0.71 //x2=5 //y2=0.71
r271 (  68 123 ) resistor r=6.4 //w=0.17 //l=0.085 //layer=li //thickness=0.1 \
 //x=5.4 //y=0.71 //x2=5.485 //y2=0.71
r272 (  68 123 ) resistor r=27.3797 //w=0.187 //l=0.4 //layer=li \
 //thickness=0.1 //x=5.4 //y=0.71 //x2=5 //y2=0.71
r273 (  65 112 ) resistor r=2.87058 //w=0.35 //l=0.085 //layer=li \
 //thickness=0.1 //x=4.6 //y=0.175 //x2=4.515 //y2=0.175
r274 (  65 67 ) resistor r=11.5095 //w=0.367 //l=0.33 //layer=li \
 //thickness=0.1 //x=4.6 //y=0.175 //x2=4.93 //y2=0.175
r275 (  64 115 ) resistor r=2.87058 //w=0.35 //l=0.085 //layer=li \
 //thickness=0.1 //x=5.4 //y=0.175 //x2=5.485 //y2=0.175
r276 (  64 67 ) resistor r=16.3924 //w=0.367 //l=0.47 //layer=li \
 //thickness=0.1 //x=5.4 //y=0.175 //x2=4.93 //y2=0.175
r277 (  60 123 ) resistor r=5.4201 //w=0.17 //l=0.085 //layer=li \
 //thickness=0.1 //x=4.515 //y=0.795 //x2=4.515 //y2=0.71
r278 (  60 123 ) resistor r=41.4118 //w=0.187 //l=0.605 //layer=li \
 //thickness=0.1 //x=4.515 //y=0.795 //x2=4.515 //y2=1.4
r279 (  59 123 ) resistor r=5.4201 //w=0.17 //l=0.085 //layer=li \
 //thickness=0.1 //x=4.515 //y=0.625 //x2=4.515 //y2=0.71
r280 (  58 112 ) resistor r=4.23183 //w=0.7 //l=0.175 //layer=li \
 //thickness=0.1 //x=4.515 //y=0.35 //x2=4.515 //y2=0.175
r281 (  58 59 ) resistor r=18.8235 //w=0.187 //l=0.275 //layer=li \
 //thickness=0.1 //x=4.515 //y=0.35 //x2=4.515 //y2=0.625
r282 (  57 111 ) resistor r=5.29055 //w=0.35 //l=0.17 //layer=li \
 //thickness=0.1 //x=3.99 //y=0.175 //x2=3.82 //y2=0.175
r283 (  56 112 ) resistor r=2.87058 //w=0.35 //l=0.085 //layer=li \
 //thickness=0.1 //x=4.43 //y=0.175 //x2=4.515 //y2=0.175
r284 (  56 57 ) resistor r=15.346 //w=0.367 //l=0.44 //layer=li \
 //thickness=0.1 //x=4.43 //y=0.175 //x2=3.99 //y2=0.175
r285 (  46 48 ) resistor r=38.7139 //w=0.367 //l=1.11 //layer=li \
 //thickness=0.1 //x=2.34 //y=0.175 //x2=3.45 //y2=0.175
r286 (  44 46 ) resistor r=38.7139 //w=0.367 //l=1.11 //layer=li \
 //thickness=0.1 //x=1.23 //y=0.175 //x2=2.34 //y2=0.175
r287 (  41 111 ) resistor r=5.29055 //w=0.35 //l=0.17 //layer=li \
 //thickness=0.1 //x=3.65 //y=0.175 //x2=3.82 //y2=0.175
r288 (  41 48 ) resistor r=6.97548 //w=0.367 //l=0.2 //layer=li \
 //thickness=0.1 //x=3.65 //y=0.175 //x2=3.45 //y2=0.175
r289 (  35 124 ) resistor r=9.3 //w=0.17 //l=0.17 //layer=mcon //count=1 \
 //x=8.33 //y=1.135 //x2=8.33 //y2=1.135
r290 (  35 36 ) resistor r=0.0939994 //w=0.226 //l=0.13 //layer=m1 \
 //thickness=0.36 //x=8.327 //y=1.135 //x2=8.327 //y2=1.005
r291 (  30 122 ) resistor r=9.3 //w=0.17 //l=0.17 //layer=mcon //count=1 \
 //x=1.67 //y=1.135 //x2=1.67 //y2=1.135
r292 (  30 31 ) resistor r=0.0939994 //w=0.226 //l=0.13 //layer=m1 \
 //thickness=0.36 //x=1.667 //y=1.135 //x2=1.667 //y2=1.005
r293 (  27 103 ) resistor r=3.1 //w=0.17 //l=0.51 //layer=mcon //count=3 \
 //x=9.74 //y=0.18 //x2=9.74 //y2=0.18
r294 (  25 101 ) resistor r=3.1 //w=0.17 //l=0.51 //layer=mcon //count=3 \
 //x=8.63 //y=0.18 //x2=8.63 //y2=0.18
r295 (  25 27 ) resistor r=0.446141 //w=0.311 //l=1.11 //layer=m1 \
 //thickness=0.36 //x=8.63 //y=0.175 //x2=9.74 //y2=0.175
r296 (  23 38 ) resistor r=0.028033 //w=0.35 //l=0.085 //layer=m1 \
 //thickness=0.36 //x=8.415 //y=0.175 //x2=8.33 //y2=0.175
r297 (  23 25 ) resistor r=0.0864148 //w=0.311 //l=0.215 //layer=m1 \
 //thickness=0.36 //x=8.415 //y=0.175 //x2=8.63 //y2=0.175
r298 (  21 38 ) resistor r=0.0413265 //w=0.7 //l=0.175 //layer=m1 \
 //thickness=0.36 //x=8.33 //y=0.35 //x2=8.33 //y2=0.175
r299 (  21 36 ) resistor r=0.625 //w=0.131 //l=0.655 //layer=m1 \
 //thickness=0.36 //x=8.33 //y=0.35 //x2=8.33 //y2=1.005
r300 (  20 99 ) resistor r=3.1 //w=0.17 //l=0.51 //layer=mcon //count=3 \
 //x=7.52 //y=0.18 //x2=7.52 //y2=0.18
r301 (  18 81 ) resistor r=3.1 //w=0.17 //l=0.51 //layer=mcon //count=3 \
 //x=6.04 //y=0.18 //x2=6.04 //y2=0.18
r302 (  18 20 ) resistor r=0.594855 //w=0.311 //l=1.48 //layer=m1 \
 //thickness=0.36 //x=6.04 //y=0.175 //x2=7.52 //y2=0.175
r303 (  15 67 ) resistor r=3.1 //w=0.17 //l=0.51 //layer=mcon //count=3 \
 //x=4.93 //y=0.18 //x2=4.93 //y2=0.18
r304 (  13 48 ) resistor r=3.1 //w=0.17 //l=0.51 //layer=mcon //count=3 \
 //x=3.45 //y=0.18 //x2=3.45 //y2=0.18
r305 (  13 15 ) resistor r=0.594855 //w=0.311 //l=1.48 //layer=m1 \
 //thickness=0.36 //x=3.45 //y=0.175 //x2=4.93 //y2=0.175
r306 (  11 46 ) resistor r=3.1 //w=0.17 //l=0.51 //layer=mcon //count=3 \
 //x=2.34 //y=0.18 //x2=2.34 //y2=0.18
r307 (  11 13 ) resistor r=0.446141 //w=0.311 //l=1.11 //layer=m1 \
 //thickness=0.36 //x=2.34 //y=0.175 //x2=3.45 //y2=0.175
r308 (  9 33 ) resistor r=0.028033 //w=0.35 //l=0.085 //layer=m1 \
 //thickness=0.36 //x=1.755 //y=0.175 //x2=1.67 //y2=0.175
r309 (  9 11 ) resistor r=0.235129 //w=0.311 //l=0.585 //layer=m1 \
 //thickness=0.36 //x=1.755 //y=0.175 //x2=2.34 //y2=0.175
r310 (  8 38 ) resistor r=0.028033 //w=0.35 //l=0.085 //layer=m1 \
 //thickness=0.36 //x=8.245 //y=0.175 //x2=8.33 //y2=0.175
r311 (  8 20 ) resistor r=0.291399 //w=0.311 //l=0.725 //layer=m1 \
 //thickness=0.36 //x=8.245 //y=0.175 //x2=7.52 //y2=0.175
r312 (  6 33 ) resistor r=0.0413265 //w=0.7 //l=0.175 //layer=m1 \
 //thickness=0.36 //x=1.67 //y=0.35 //x2=1.67 //y2=0.175
r313 (  6 31 ) resistor r=0.625 //w=0.131 //l=0.655 //layer=m1 \
 //thickness=0.36 //x=1.67 //y=0.35 //x2=1.67 //y2=1.005
r314 (  4 44 ) resistor r=3.1 //w=0.17 //l=0.51 //layer=mcon //count=3 \
 //x=1.23 //y=0.18 //x2=1.23 //y2=0.18
r315 (  2 33 ) resistor r=0.028033 //w=0.35 //l=0.085 //layer=m1 \
 //thickness=0.36 //x=1.585 //y=0.175 //x2=1.67 //y2=0.175
r316 (  2 4 ) resistor r=0.142685 //w=0.311 //l=0.355 //layer=m1 \
 //thickness=0.36 //x=1.585 //y=0.175 //x2=1.23 //y2=0.175
r317 (  1 18 ) resistor r=0.223071 //w=0.311 //l=0.555 //layer=m1 \
 //thickness=0.36 //x=5.485 //y=0.175 //x2=6.04 //y2=0.175
r318 (  1 15 ) resistor r=0.223071 //w=0.311 //l=0.555 //layer=m1 \
 //thickness=0.36 //x=5.485 //y=0.175 //x2=4.93 //y2=0.175
ends PM_AOAI4X1\%GND

subckt PM_AOAI4X1\%D ( 1 2 3 4 5 6 7 9 18 24 29 33 34 35 36 37 38 43 45 47 53 \
 54 56 57 60 )
c105 ( 60 0 ) capacitor c=0.0393541f //x=9.03 //y=4.88
c106 ( 57 0 ) capacitor c=0.0303735f //x=9 //y=2.095
c107 ( 56 0 ) capacitor c=0.0476996f //x=9 //y=2.26
c108 ( 54 0 ) capacitor c=0.0439708f //x=9.565 //y=1.43
c109 ( 53 0 ) capacitor c=0.0192582f //x=9.565 //y=1.085
c110 ( 47 0 ) capacitor c=0.0162526f //x=9.41 //y=1.585
c111 ( 45 0 ) capacitor c=0.0157807f //x=9.41 //y=0.93
c112 ( 43 0 ) capacitor c=0.0372668f //x=9.405 //y=4.97
c113 ( 38 0 ) capacitor c=0.0210762f //x=9.035 //y=1.74
c114 ( 37 0 ) capacitor c=0.0168511f //x=9.035 //y=1.43
c115 ( 36 0 ) capacitor c=0.0175485f //x=9.035 //y=1.085
c116 ( 35 0 ) capacitor c=0.155269f //x=9.48 //y=6.2
c117 ( 34 0 ) capacitor c=0.110375f //x=9.04 //y=6.2
c118 ( 29 0 ) capacitor c=8.90417e-19 //x=9.03 //y=4.88
c119 ( 24 0 ) capacitor c=7.72439e-19 //x=9 //y=2.26
c120 ( 18 0 ) capacitor c=0.00687137f //x=9 //y=2.26
c121 ( 9 0 ) capacitor c=0.00493417f //x=9 //y=4.735
c122 ( 1 0 ) capacitor c=0.0587982f //x=9 //y=2.4
r123 (  62 63 ) resistor r=32.4568 //w=0.214 //l=0.075 //layer=ply \
 //thickness=0.18 //x=9.03 //y=4.97 //x2=9.03 //y2=5.045
r124 (  60 62 ) resistor r=20.271 //w=0.214 //l=0.09 //layer=ply \
 //thickness=0.18 //x=9.03 //y=4.88 //x2=9.03 //y2=4.97
r125 (  56 57 ) resistor r=52.7279 //w=0.214 //l=0.165 //layer=ply \
 //thickness=0.18 //x=9 //y=2.26 //x2=9 //y2=2.095
r126 (  54 67 ) resistor r=45.1352 //w=0.168 //l=0.173853 //layer=ply \
 //thickness=0.18 //x=9.565 //y=1.43 //x2=9.525 //y2=1.585
r127 (  53 66 ) resistor r=45.1352 //w=0.168 //l=0.173853 //layer=ply \
 //thickness=0.18 //x=9.565 //y=1.085 //x2=9.525 //y2=0.93
r128 (  53 54 ) resistor r=176.904 //w=0.094 //l=0.345 //layer=ply \
 //thickness=0.18 //x=9.565 //y=1.085 //x2=9.565 //y2=1.43
r129 (  48 65 ) resistor r=10.701 //w=0.21 //l=0.115 //layer=ply \
 //thickness=0.18 //x=9.19 //y=1.585 //x2=9.075 //y2=1.585
r130 (  47 67 ) resistor r=5.52526 //w=0.168 //l=0.115 //layer=ply \
 //thickness=0.18 //x=9.41 //y=1.585 //x2=9.525 //y2=1.585
r131 (  46 64 ) resistor r=5.52526 //w=0.168 //l=0.115 //layer=ply \
 //thickness=0.18 //x=9.19 //y=0.93 //x2=9.075 //y2=0.93
r132 (  45 66 ) resistor r=5.52526 //w=0.168 //l=0.115 //layer=ply \
 //thickness=0.18 //x=9.41 //y=0.93 //x2=9.525 //y2=0.93
r133 (  45 46 ) resistor r=112.809 //w=0.094 //l=0.22 //layer=ply \
 //thickness=0.18 //x=9.41 //y=0.93 //x2=9.19 //y2=0.93
r134 (  44 62 ) resistor r=16.5046 //w=0.27 //l=0.135 //layer=ply \
 //thickness=0.18 //x=9.165 //y=4.97 //x2=9.03 //y2=4.97
r135 (  43 50 ) resistor r=26.9307 //w=0.15 //l=0.106066 //layer=ply \
 //thickness=0.18 //x=9.405 //y=4.97 //x2=9.48 //y2=5.045
r136 (  43 44 ) resistor r=123.064 //w=0.094 //l=0.24 //layer=ply \
 //thickness=0.18 //x=9.405 //y=4.97 //x2=9.165 //y2=4.97
r137 (  38 65 ) resistor r=39.5823 //w=0.21 //l=0.173853 //layer=ply \
 //thickness=0.18 //x=9.035 //y=1.74 //x2=9.075 //y2=1.585
r138 (  38 57 ) resistor r=182.032 //w=0.094 //l=0.355 //layer=ply \
 //thickness=0.18 //x=9.035 //y=1.74 //x2=9.035 //y2=2.095
r139 (  37 65 ) resistor r=39.5823 //w=0.21 //l=0.173853 //layer=ply \
 //thickness=0.18 //x=9.035 //y=1.43 //x2=9.075 //y2=1.585
r140 (  36 64 ) resistor r=45.1352 //w=0.168 //l=0.173853 //layer=ply \
 //thickness=0.18 //x=9.035 //y=1.085 //x2=9.075 //y2=0.93
r141 (  36 37 ) resistor r=176.904 //w=0.094 //l=0.345 //layer=ply \
 //thickness=0.18 //x=9.035 //y=1.085 //x2=9.035 //y2=1.43
r142 (  35 50 ) resistor r=592.245 //w=0.094 //l=1.155 //layer=ply \
 //thickness=0.18 //x=9.48 //y=6.2 //x2=9.48 //y2=5.045
r143 (  34 63 ) resistor r=592.245 //w=0.094 //l=1.155 //layer=ply \
 //thickness=0.18 //x=9.04 //y=6.2 //x2=9.04 //y2=5.045
r144 (  33 47 ) resistor r=56.4043 //w=0.094 //l=0.11 //layer=ply \
 //thickness=0.18 //x=9.3 //y=1.585 //x2=9.41 //y2=1.585
r145 (  33 48 ) resistor r=56.4043 //w=0.094 //l=0.11 //layer=ply \
 //thickness=0.18 //x=9.3 //y=1.585 //x2=9.19 //y2=1.585
r146 (  29 60 ) resistor r=152 //w=0.17 //l=0.17 //layer=licon //count=1 \
 //x=9.03 //y=4.88 //x2=9.03 //y2=4.88
r147 (  24 56 ) resistor r=152 //w=0.17 //l=0.17 //layer=licon //count=1 //x=9 \
 //y=2.26 //x2=9 //y2=2.26
r148 (  22 29 ) resistor r=9.3 //w=0.17 //l=0.17 //layer=mcon //count=1 \
 //x=9.03 //y=4.88 //x2=9.03 //y2=4.88
r149 (  18 24 ) resistor r=9.3 //w=0.17 //l=0.17 //layer=mcon //count=1 //x=9 \
 //y=2.26 //x2=9 //y2=2.26
r150 (  18 20 ) resistor r=0.0936408 //w=0.196 //l=0.125 //layer=m1 \
 //thickness=0.36 //x=9.002 //y=2.26 //x2=9.002 //y2=2.385
r151 (  9 22 ) resistor r=0.0878548 //w=0.228 //l=0.159295 //layer=m1 \
 //thickness=0.36 //x=9 //y=4.735 //x2=9.03 //y2=4.88
r152 (  7 9 ) resistor r=0.109733 //w=0.131 //l=0.115 //layer=m1 \
 //thickness=0.36 //x=9 //y=4.62 //x2=9 //y2=4.735
r153 (  6 7 ) resistor r=0.353053 //w=0.131 //l=0.37 //layer=m1 \
 //thickness=0.36 //x=9 //y=4.25 //x2=9 //y2=4.62
r154 (  5 6 ) resistor r=0.353053 //w=0.131 //l=0.37 //layer=m1 \
 //thickness=0.36 //x=9 //y=3.88 //x2=9 //y2=4.25
r155 (  4 5 ) resistor r=0.353053 //w=0.131 //l=0.37 //layer=m1 \
 //thickness=0.36 //x=9 //y=3.51 //x2=9 //y2=3.88
r156 (  3 4 ) resistor r=0.353053 //w=0.131 //l=0.37 //layer=m1 \
 //thickness=0.36 //x=9 //y=3.14 //x2=9 //y2=3.51
r157 (  2 3 ) resistor r=0.353053 //w=0.131 //l=0.37 //layer=m1 \
 //thickness=0.36 //x=9 //y=2.77 //x2=9 //y2=3.14
r158 (  1 2 ) resistor r=0.353053 //w=0.131 //l=0.37 //layer=m1 \
 //thickness=0.36 //x=9 //y=2.4 //x2=9 //y2=2.77
r159 (  1 20 ) resistor r=0.014313 //w=0.131 //l=0.015 //layer=m1 \
 //thickness=0.36 //x=9 //y=2.4 //x2=9 //y2=2.385
ends PM_AOAI4X1\%D

subckt PM_AOAI4X1\%YN ( 1 2 3 4 5 6 7 8 11 16 17 19 20 33 34 37 39 42 50 62 64 \
 65 )
c112 ( 62 0 ) capacitor c=0.00878249f //x=9.11 //y=1.085
c113 ( 50 0 ) capacitor c=0.0325998f //x=9.26 //y=5.56
c114 ( 42 0 ) capacitor c=0.0291371f //x=8.38 //y=5.56
c115 ( 39 0 ) capacitor c=0.0149056f //x=9.3 //y=1.18
c116 ( 37 0 ) capacitor c=6.70882e-19 //x=9.26 //y=5.56
c117 ( 34 0 ) capacitor c=0.0159641f //x=9.26 //y=5.38
c118 ( 33 0 ) capacitor c=0.0102556f //x=8.38 //y=5.56
c119 ( 20 0 ) capacitor c=0.0069619f //x=9.385 //y=1.835
c120 ( 19 0 ) capacitor c=0.0165738f //x=9.655 //y=1.835
c121 ( 17 0 ) capacitor c=0.0143926f //x=9.655 //y=5.38
c122 ( 16 0 ) capacitor c=0.0133876f //x=9.3 //y=1.75
c123 ( 11 0 ) capacitor c=0.019362f //x=9.145 //y=5.38
c124 ( 1 0 ) capacitor c=0.133979f //x=9.74 //y=2.4
r125 (  50 65 ) resistor r=23.615 //w=0.187 //l=0.345 //layer=li \
 //thickness=0.1 //x=9.26 //y=5.56 //x2=9.26 //y2=5.905
r126 (  42 64 ) resistor r=23.615 //w=0.187 //l=0.345 //layer=li \
 //thickness=0.1 //x=8.38 //y=5.56 //x2=8.38 //y2=5.905
r127 (  39 62 ) resistor r=9.3 //w=0.17 //l=0.17 //layer=mcon //count=1 \
 //x=9.3 //y=1.18 //x2=9.3 //y2=1.18
r128 (  37 50 ) resistor r=9.3 //w=0.17 //l=0.17 //layer=mcon //count=1 \
 //x=9.26 //y=5.56 //x2=9.26 //y2=5.56
r129 (  34 37 ) resistor r=0.117801 //w=0.191 //l=0.18 //layer=m1 \
 //thickness=0.36 //x=9.26 //y=5.38 //x2=9.26 //y2=5.56
r130 (  33 42 ) resistor r=9.3 //w=0.17 //l=0.17 //layer=mcon //count=1 \
 //x=8.38 //y=5.56 //x2=8.38 //y2=5.56
r131 (  31 33 ) resistor r=0.10274 //w=0.219 //l=0.18 //layer=m1 \
 //thickness=0.36 //x=8.38 //y=5.38 //x2=8.38 //y2=5.56
r132 (  19 21 ) resistor r=0.0698411 //w=0.17 //l=0.120208 //layer=m1 \
 //thickness=0.36 //x=9.655 //y=1.835 //x2=9.74 //y2=1.92
r133 (  19 20 ) resistor r=0.257634 //w=0.131 //l=0.27 //layer=m1 \
 //thickness=0.36 //x=9.655 //y=1.835 //x2=9.385 //y2=1.835
r134 (  18 34 ) resistor r=0.0257089 //w=0.23 //l=0.115 //layer=m1 \
 //thickness=0.36 //x=9.375 //y=5.38 //x2=9.26 //y2=5.38
r135 (  17 22 ) resistor r=0.0698411 //w=0.17 //l=0.120208 //layer=m1 \
 //thickness=0.36 //x=9.655 //y=5.38 //x2=9.74 //y2=5.295
r136 (  17 18 ) resistor r=0.267176 //w=0.131 //l=0.28 //layer=m1 \
 //thickness=0.36 //x=9.655 //y=5.38 //x2=9.375 //y2=5.38
r137 (  16 20 ) resistor r=0.0698411 //w=0.17 //l=0.120208 //layer=m1 \
 //thickness=0.36 //x=9.3 //y=1.75 //x2=9.385 //y2=1.835
r138 (  15 39 ) resistor r=0.0913624 //w=0.191 //l=0.12 //layer=m1 \
 //thickness=0.36 //x=9.3 //y=1.3 //x2=9.3 //y2=1.18
r139 (  15 16 ) resistor r=0.429389 //w=0.131 //l=0.45 //layer=m1 \
 //thickness=0.36 //x=9.3 //y=1.3 //x2=9.3 //y2=1.75
r140 (  12 31 ) resistor r=0.0227762 //w=0.219 //l=0.115 //layer=m1 \
 //thickness=0.36 //x=8.495 //y=5.38 //x2=8.38 //y2=5.38
r141 (  11 34 ) resistor r=0.0257089 //w=0.23 //l=0.115 //layer=m1 \
 //thickness=0.36 //x=9.145 //y=5.38 //x2=9.26 //y2=5.38
r142 (  11 12 ) resistor r=0.620229 //w=0.131 //l=0.65 //layer=m1 \
 //thickness=0.36 //x=9.145 //y=5.38 //x2=8.495 //y2=5.38
r143 (  8 22 ) resistor r=0.291031 //w=0.131 //l=0.305 //layer=m1 \
 //thickness=0.36 //x=9.74 //y=4.99 //x2=9.74 //y2=5.295
r144 (  7 8 ) resistor r=0.353053 //w=0.131 //l=0.37 //layer=m1 \
 //thickness=0.36 //x=9.74 //y=4.62 //x2=9.74 //y2=4.99
r145 (  6 7 ) resistor r=0.353053 //w=0.131 //l=0.37 //layer=m1 \
 //thickness=0.36 //x=9.74 //y=4.25 //x2=9.74 //y2=4.62
r146 (  5 6 ) resistor r=0.353053 //w=0.131 //l=0.37 //layer=m1 \
 //thickness=0.36 //x=9.74 //y=3.88 //x2=9.74 //y2=4.25
r147 (  4 5 ) resistor r=0.353053 //w=0.131 //l=0.37 //layer=m1 \
 //thickness=0.36 //x=9.74 //y=3.51 //x2=9.74 //y2=3.88
r148 (  3 4 ) resistor r=0.353053 //w=0.131 //l=0.37 //layer=m1 \
 //thickness=0.36 //x=9.74 //y=3.14 //x2=9.74 //y2=3.51
r149 (  2 3 ) resistor r=0.353053 //w=0.131 //l=0.37 //layer=m1 \
 //thickness=0.36 //x=9.74 //y=2.77 //x2=9.74 //y2=3.14
r150 (  1 2 ) resistor r=0.353053 //w=0.131 //l=0.37 //layer=m1 \
 //thickness=0.36 //x=9.74 //y=2.4 //x2=9.74 //y2=2.77
r151 (  1 21 ) resistor r=0.458015 //w=0.131 //l=0.48 //layer=m1 \
 //thickness=0.36 //x=9.74 //y=2.4 //x2=9.74 //y2=1.92
ends PM_AOAI4X1\%YN

subckt PM_AOAI4X1\%noxref_11 ( 1 5 9 10 13 17 29 )
c61 ( 29 0 ) capacitor c=0.0672366f //x=1.05 //y=0.545
c62 ( 17 0 ) capacitor c=0.00709791f //x=3.125 //y=0.795
c63 ( 13 0 ) capacitor c=0.0157877f //x=3.04 //y=0.71
c64 ( 10 0 ) capacitor c=0.00963509f //x=2.155 //y=1.675
c65 ( 9 0 ) capacitor c=0.00770028f //x=2.155 //y=0.795
c66 ( 5 0 ) capacitor c=0.0246013f //x=2.07 //y=1.76
c67 ( 1 0 ) capacitor c=0.0115037f //x=1.185 //y=1.675
r68 (  17 29 ) resistor r=3.57586 //w=0.17 //l=0.125 //layer=li \
 //thickness=0.1 //x=3.125 //y=0.795 //x2=3.125 //y2=0.67
r69 (  17 29 ) resistor r=18.139 //w=0.187 //l=0.265 //layer=li \
 //thickness=0.1 //x=3.125 //y=0.795 //x2=3.125 //y2=1.06
r70 (  14 29 ) resistor r=3.57586 //w=0.17 //l=0.103078 //layer=li \
 //thickness=0.1 //x=2.24 //y=0.71 //x2=2.155 //y2=0.67
r71 (  14 29 ) resistor r=27.3797 //w=0.187 //l=0.4 //layer=li //thickness=0.1 \
 //x=2.24 //y=0.71 //x2=2.64 //y2=0.71
r72 (  13 29 ) resistor r=3.57586 //w=0.17 //l=0.103078 //layer=li \
 //thickness=0.1 //x=3.04 //y=0.71 //x2=3.125 //y2=0.67
r73 (  13 29 ) resistor r=27.3797 //w=0.187 //l=0.4 //layer=li //thickness=0.1 \
 //x=3.04 //y=0.71 //x2=2.64 //y2=0.71
r74 (  10 29 ) resistor r=3.57586 //w=0.17 //l=0.125 //layer=li \
 //thickness=0.1 //x=2.155 //y=1.675 //x2=2.155 //y2=1.8
r75 (  10 29 ) resistor r=42.0963 //w=0.187 //l=0.615 //layer=li \
 //thickness=0.1 //x=2.155 //y=1.675 //x2=2.155 //y2=1.06
r76 (  9 29 ) resistor r=3.57586 //w=0.17 //l=0.125 //layer=li //thickness=0.1 \
 //x=2.155 //y=0.795 //x2=2.155 //y2=0.67
r77 (  9 29 ) resistor r=18.139 //w=0.187 //l=0.265 //layer=li //thickness=0.1 \
 //x=2.155 //y=0.795 //x2=2.155 //y2=1.06
r78 (  6 29 ) resistor r=3.57586 //w=0.17 //l=0.103078 //layer=li \
 //thickness=0.1 //x=1.27 //y=1.76 //x2=1.185 //y2=1.8
r79 (  6 29 ) resistor r=27.3797 //w=0.187 //l=0.4 //layer=li //thickness=0.1 \
 //x=1.27 //y=1.76 //x2=1.67 //y2=1.76
r80 (  5 29 ) resistor r=3.57586 //w=0.17 //l=0.103078 //layer=li \
 //thickness=0.1 //x=2.07 //y=1.76 //x2=2.155 //y2=1.8
r81 (  5 29 ) resistor r=27.3797 //w=0.187 //l=0.4 //layer=li //thickness=0.1 \
 //x=2.07 //y=1.76 //x2=1.67 //y2=1.76
r82 (  1 29 ) resistor r=3.57586 //w=0.17 //l=0.125 //layer=li //thickness=0.1 \
 //x=1.185 //y=1.675 //x2=1.185 //y2=1.8
r83 (  1 29 ) resistor r=42.0963 //w=0.187 //l=0.615 //layer=li \
 //thickness=0.1 //x=1.185 //y=1.675 //x2=1.185 //y2=1.06
ends PM_AOAI4X1\%noxref_11

subckt PM_AOAI4X1\%noxref_12 ( 1 5 9 10 13 17 29 )
c55 ( 29 0 ) capacitor c=0.0684023f //x=7.71 //y=0.545
c56 ( 17 0 ) capacitor c=0.00709791f //x=9.785 //y=0.795
c57 ( 13 0 ) capacitor c=0.0157877f //x=9.7 //y=0.71
c58 ( 10 0 ) capacitor c=0.00955329f //x=8.815 //y=1.675
c59 ( 9 0 ) capacitor c=0.00770028f //x=8.815 //y=0.795
c60 ( 5 0 ) capacitor c=0.0229059f //x=8.73 //y=1.76
c61 ( 1 0 ) capacitor c=0.00776706f //x=7.845 //y=1.675
r62 (  17 29 ) resistor r=3.57586 //w=0.17 //l=0.125 //layer=li \
 //thickness=0.1 //x=9.785 //y=0.795 //x2=9.785 //y2=0.67
r63 (  17 29 ) resistor r=18.139 //w=0.187 //l=0.265 //layer=li \
 //thickness=0.1 //x=9.785 //y=0.795 //x2=9.785 //y2=1.06
r64 (  14 29 ) resistor r=3.57586 //w=0.17 //l=0.103078 //layer=li \
 //thickness=0.1 //x=8.9 //y=0.71 //x2=8.815 //y2=0.67
r65 (  14 29 ) resistor r=27.3797 //w=0.187 //l=0.4 //layer=li //thickness=0.1 \
 //x=8.9 //y=0.71 //x2=9.3 //y2=0.71
r66 (  13 29 ) resistor r=3.57586 //w=0.17 //l=0.103078 //layer=li \
 //thickness=0.1 //x=9.7 //y=0.71 //x2=9.785 //y2=0.67
r67 (  13 29 ) resistor r=27.3797 //w=0.187 //l=0.4 //layer=li //thickness=0.1 \
 //x=9.7 //y=0.71 //x2=9.3 //y2=0.71
r68 (  10 29 ) resistor r=3.57586 //w=0.17 //l=0.125 //layer=li \
 //thickness=0.1 //x=8.815 //y=1.675 //x2=8.815 //y2=1.8
r69 (  10 29 ) resistor r=42.0963 //w=0.187 //l=0.615 //layer=li \
 //thickness=0.1 //x=8.815 //y=1.675 //x2=8.815 //y2=1.06
r70 (  9 29 ) resistor r=3.57586 //w=0.17 //l=0.125 //layer=li //thickness=0.1 \
 //x=8.815 //y=0.795 //x2=8.815 //y2=0.67
r71 (  9 29 ) resistor r=18.139 //w=0.187 //l=0.265 //layer=li //thickness=0.1 \
 //x=8.815 //y=0.795 //x2=8.815 //y2=1.06
r72 (  6 29 ) resistor r=3.57586 //w=0.17 //l=0.103078 //layer=li \
 //thickness=0.1 //x=7.93 //y=1.76 //x2=7.845 //y2=1.8
r73 (  6 29 ) resistor r=27.3797 //w=0.187 //l=0.4 //layer=li //thickness=0.1 \
 //x=7.93 //y=1.76 //x2=8.33 //y2=1.76
r74 (  5 29 ) resistor r=3.57586 //w=0.17 //l=0.103078 //layer=li \
 //thickness=0.1 //x=8.73 //y=1.76 //x2=8.815 //y2=1.8
r75 (  5 29 ) resistor r=27.3797 //w=0.187 //l=0.4 //layer=li //thickness=0.1 \
 //x=8.73 //y=1.76 //x2=8.33 //y2=1.76
r76 (  1 29 ) resistor r=3.57586 //w=0.17 //l=0.125 //layer=li //thickness=0.1 \
 //x=7.845 //y=1.675 //x2=7.845 //y2=1.8
r77 (  1 29 ) resistor r=42.0963 //w=0.187 //l=0.615 //layer=li \
 //thickness=0.1 //x=7.845 //y=1.675 //x2=7.845 //y2=1.06
ends PM_AOAI4X1\%noxref_12
