// File: xnor2x1_pcell.spi.XNOR2X1_PCELL.pxi
// Created: Sun Mar 15 12:53:19 2026
//
simulator lang=spectre
x_PM_XNOR2X1_PCELL\%noxref_1 ( N_noxref_1_c_15_p N_noxref_1_c_25_p \
 N_noxref_1_c_26_p N_noxref_1_c_16_p N_noxref_1_c_17_p N_noxref_1_c_28_p \
 N_noxref_1_c_29_p N_noxref_1_c_18_p N_noxref_1_c_30_p N_noxref_1_c_31_p \
 N_noxref_1_c_32_p N_noxref_1_c_33_p N_noxref_1_c_6_p N_noxref_1_c_19_p \
 N_noxref_1_c_35_p N_noxref_1_c_70_p N_noxref_1_c_97_p N_noxref_1_M0_noxref_g \
 N_noxref_1_M1_noxref_g N_noxref_1_M6_noxref_g N_noxref_1_M7_noxref_g \
 N_noxref_1_M8_noxref_g N_noxref_1_M9_noxref_g N_noxref_1_c_39_p \
 N_noxref_1_c_1_p N_noxref_1_c_2_p N_noxref_1_c_3_p N_noxref_1_c_14_p \
 N_noxref_1_c_37_p N_noxref_1_c_41_p N_noxref_1_c_4_p N_noxref_1_c_43_p \
 N_noxref_1_c_5_p N_noxref_1_c_79_p N_noxref_1_c_80_p N_noxref_1_c_82_p \
 N_noxref_1_c_71_p N_noxref_1_c_180_p N_noxref_1_c_181_p N_noxref_1_c_81_p \
 N_noxref_1_c_83_p N_noxref_1_c_10_p N_noxref_1_c_98_p )  \
 PM_XNOR2X1_PCELL\%noxref_1
x_PM_XNOR2X1_PCELL\%noxref_2 ( N_noxref_2_c_231_n N_noxref_2_c_236_n \
 N_noxref_2_c_239_n N_noxref_2_c_240_n N_noxref_2_c_241_n N_noxref_2_c_242_n \
 N_noxref_2_c_245_n N_noxref_2_c_251_n N_noxref_2_c_254_n N_noxref_2_c_299_p \
 N_noxref_2_c_268_n N_noxref_2_c_323_p N_noxref_2_c_300_p N_noxref_2_c_269_n \
 N_noxref_2_c_275_n N_noxref_2_c_337_p N_noxref_2_c_276_n N_noxref_2_c_307_p \
 N_noxref_2_c_279_n N_noxref_2_c_284_n N_noxref_2_c_325_p N_noxref_2_c_320_p \
 N_noxref_2_M4_noxref_g N_noxref_2_M14_noxref_g N_noxref_2_M15_noxref_g \
 N_noxref_2_c_308_p N_noxref_2_c_309_p N_noxref_2_c_315_p N_noxref_2_c_316_p \
 N_noxref_2_c_310_p N_noxref_2_c_311_p N_noxref_2_c_312_p N_noxref_2_c_313_p \
 N_noxref_2_c_343_p N_noxref_2_M0_noxref_d N_noxref_2_M6_noxref_d )  \
 PM_XNOR2X1_PCELL\%noxref_2
x_PM_XNOR2X1_PCELL\%noxref_3 ( N_noxref_3_c_519_n N_noxref_3_c_520_n \
 N_noxref_3_c_666_p N_noxref_3_c_522_n N_noxref_3_c_523_n N_noxref_3_c_513_n \
 N_noxref_3_c_514_n N_noxref_3_c_515_n N_noxref_3_c_532_n N_noxref_3_c_540_n \
 N_noxref_3_c_545_n N_noxref_3_c_548_n N_noxref_3_c_554_n N_noxref_3_c_559_n \
 N_noxref_3_c_567_n N_noxref_3_c_570_n N_noxref_3_c_573_n N_noxref_3_c_517_n \
 N_noxref_3_c_574_n N_noxref_3_c_579_n N_noxref_3_c_518_n N_noxref_3_c_580_n \
 N_noxref_3_c_581_n N_noxref_3_c_671_p N_noxref_3_c_583_n \
 N_noxref_3_M2_noxref_d N_noxref_3_M4_noxref_d N_noxref_3_M10_noxref_d \
 N_noxref_3_M14_noxref_d )  PM_XNOR2X1_PCELL\%noxref_3
x_PM_XNOR2X1_PCELL\%noxref_4 ( N_noxref_4_c_812_n N_noxref_4_c_815_n \
 N_noxref_4_c_838_n N_noxref_4_c_866_n N_noxref_4_c_839_n N_noxref_4_c_840_n \
 N_noxref_4_c_873_n N_noxref_4_c_977_p N_noxref_4_c_874_n N_noxref_4_c_971_p \
 N_noxref_4_c_986_p N_noxref_4_c_875_n N_noxref_4_c_877_n N_noxref_4_c_817_n \
 N_noxref_4_c_842_n N_noxref_4_c_886_n N_noxref_4_c_947_p N_noxref_4_c_887_n \
 N_noxref_4_c_844_n N_noxref_4_c_818_n N_noxref_4_c_846_n N_noxref_4_c_895_n \
 N_noxref_4_c_896_n N_noxref_4_c_847_n N_noxref_4_c_819_n N_noxref_4_c_852_n \
 N_noxref_4_c_988_p N_noxref_4_M2_noxref_g N_noxref_4_M12_noxref_g \
 N_noxref_4_M13_noxref_g N_noxref_4_c_822_n N_noxref_4_c_825_n \
 N_noxref_4_c_827_n N_noxref_4_c_830_n N_noxref_4_c_918_n N_noxref_4_c_920_n \
 N_noxref_4_c_833_n N_noxref_4_c_834_n N_noxref_4_c_858_n \
 N_noxref_4_M5_noxref_d N_noxref_4_M16_noxref_d )  PM_XNOR2X1_PCELL\%noxref_4
x_PM_XNOR2X1_PCELL\%noxref_5 ( N_noxref_5_c_1110_n N_noxref_5_c_1114_n \
 N_noxref_5_c_1133_n N_noxref_5_c_1137_n N_noxref_5_c_1179_n \
 N_noxref_5_c_1230_n N_noxref_5_c_1231_n N_noxref_5_c_1232_n \
 N_noxref_5_c_1180_n N_noxref_5_c_1117_n N_noxref_5_c_1142_n \
 N_noxref_5_c_1242_n N_noxref_5_c_1243_n N_noxref_5_c_1244_n \
 N_noxref_5_c_1143_n N_noxref_5_c_1191_n N_noxref_5_c_1120_n \
 N_noxref_5_c_1145_n N_noxref_5_c_1200_n N_noxref_5_c_1257_n \
 N_noxref_5_c_1258_n N_noxref_5_c_1201_n N_noxref_5_c_1146_n \
 N_noxref_5_c_1123_n N_noxref_5_c_1148_n N_noxref_5_c_1270_n \
 N_noxref_5_c_1271_n N_noxref_5_M3_noxref_g N_noxref_5_M5_noxref_g \
 N_noxref_5_M10_noxref_g N_noxref_5_M11_noxref_g N_noxref_5_M16_noxref_g \
 N_noxref_5_M17_noxref_g N_noxref_5_c_1152_n N_noxref_5_c_1153_n \
 N_noxref_5_c_1154_n N_noxref_5_c_1156_n N_noxref_5_c_1355_p \
 N_noxref_5_c_1356_p N_noxref_5_c_1160_n N_noxref_5_c_1162_n \
 N_noxref_5_c_1281_n N_noxref_5_c_1283_n N_noxref_5_c_1287_n \
 N_noxref_5_c_1289_n N_noxref_5_c_1292_n N_noxref_5_c_1294_n \
 N_noxref_5_c_1297_n N_noxref_5_c_1299_n N_noxref_5_c_1301_n \
 N_noxref_5_c_1304_n N_noxref_5_c_1305_n N_noxref_5_c_1129_n \
 N_noxref_5_c_1306_n )  PM_XNOR2X1_PCELL\%noxref_5
x_PM_XNOR2X1_PCELL\%noxref_6 ( N_noxref_6_c_1411_n N_noxref_6_c_1414_n \
 N_noxref_6_c_1416_n N_noxref_6_c_1477_n N_noxref_6_c_1499_n \
 N_noxref_6_c_1501_n N_noxref_6_c_1478_n N_noxref_6_c_1418_n \
 N_noxref_6_c_1422_n N_noxref_6_c_1458_n N_noxref_6_c_1509_n \
 N_noxref_6_c_1424_n N_noxref_6_c_1430_n N_noxref_6_c_1467_n \
 N_noxref_6_c_1468_n N_noxref_6_c_1470_n N_noxref_6_M6_noxref_s \
 N_noxref_6_M7_noxref_d N_noxref_6_M8_noxref_d N_noxref_6_M12_noxref_d \
 N_noxref_6_M16_noxref_s N_noxref_6_M17_noxref_d )  PM_XNOR2X1_PCELL\%noxref_6
x_PM_XNOR2X1_PCELL\%noxref_7 ( N_noxref_7_c_1665_n N_noxref_7_c_1682_n \
 N_noxref_7_c_1672_n N_noxref_7_c_1675_n N_noxref_7_c_1676_n \
 N_noxref_7_c_1688_n N_noxref_7_c_1677_n N_noxref_7_c_1679_n \
 N_noxref_7_M8_noxref_s N_noxref_7_M9_noxref_d N_noxref_7_M11_noxref_d )  \
 PM_XNOR2X1_PCELL\%noxref_7
x_PM_XNOR2X1_PCELL\%noxref_8 ( N_noxref_8_c_1771_n N_noxref_8_c_1750_n \
 N_noxref_8_c_1760_n N_noxref_8_c_1752_n N_noxref_8_c_1753_n \
 N_noxref_8_c_1754_n N_noxref_8_c_1783_n N_noxref_8_c_1755_n \
 N_noxref_8_M12_noxref_s N_noxref_8_M13_noxref_d N_noxref_8_M15_noxref_d )  \
 PM_XNOR2X1_PCELL\%noxref_8
x_PM_XNOR2X1_PCELL\%noxref_9 ( N_noxref_9_c_1836_n N_noxref_9_c_1841_n \
 N_noxref_9_c_1919_n N_noxref_9_c_1891_n N_noxref_9_c_1926_n \
 N_noxref_9_c_1849_n N_noxref_9_c_1853_n N_noxref_9_c_2045_p \
 N_noxref_9_c_1854_n N_noxref_9_c_1931_n N_noxref_9_c_2068_p \
 N_noxref_9_c_1946_n N_noxref_9_c_1949_n N_noxref_9_c_1855_n \
 N_noxref_9_c_1860_n N_noxref_9_c_1903_n N_noxref_9_c_1905_n \
 N_noxref_9_c_1909_n N_noxref_9_M0_noxref_s N_noxref_9_M1_noxref_d \
 N_noxref_9_M3_noxref_d N_noxref_9_M5_noxref_s )  PM_XNOR2X1_PCELL\%noxref_9
x_PM_XNOR2X1_PCELL\%noxref_10 ( N_noxref_10_c_2079_n N_noxref_10_c_2080_n \
 N_noxref_10_c_2118_n N_noxref_10_c_2087_n N_noxref_10_c_2094_n \
 N_noxref_10_c_2128_n N_noxref_10_M1_noxref_s )  PM_XNOR2X1_PCELL\%noxref_10
x_PM_XNOR2X1_PCELL\%noxref_11 ( N_noxref_11_c_2143_n N_noxref_11_c_2144_n \
 N_noxref_11_c_2185_n N_noxref_11_c_2145_n N_noxref_11_c_2147_n \
 N_noxref_11_c_2195_n N_noxref_11_M3_noxref_s )  PM_XNOR2X1_PCELL\%noxref_11
cc_1 ( N_noxref_1_c_1_p N_noxref_2_c_231_n ) capacitor c=0.0012792f //x=0.85 \
 //y=1.255 //x2=1.11 //y2=1.755
cc_2 ( N_noxref_1_c_2_p N_noxref_2_c_231_n ) capacitor c=0.00561986f //x=0.85 \
 //y=1.565 //x2=1.11 //y2=1.755
cc_3 ( N_noxref_1_c_3_p N_noxref_2_c_231_n ) capacitor c=0.00440271f //x=0.85 \
 //y=1.92 //x2=1.11 //y2=1.755
cc_4 ( N_noxref_1_c_4_p N_noxref_2_c_231_n ) capacitor c=0.00953922f //x=1.225 \
 //y=1.41 //x2=1.11 //y2=1.755
cc_5 ( N_noxref_1_c_5_p N_noxref_2_c_231_n ) capacitor c=0.00344663f //x=1.38 \
 //y=1.255 //x2=1.11 //y2=1.755
cc_6 ( N_noxref_1_c_6_p N_noxref_2_c_236_n ) capacitor c=6.95554e-19 //x=3.175 \
 //y=4.115 //x2=1.115 //y2=5.24
cc_7 ( N_noxref_1_M6_noxref_g N_noxref_2_c_236_n ) capacitor c=0.00141266f \
 //x=0.895 //y=6.02 //x2=1.115 //y2=5.24
cc_8 ( N_noxref_1_M7_noxref_g N_noxref_2_c_236_n ) capacitor c=0.00352414f \
 //x=1.335 //y=6.02 //x2=1.115 //y2=5.24
cc_9 ( N_noxref_1_c_4_p N_noxref_2_c_239_n ) capacitor c=0.00180253f //x=1.225 \
 //y=1.41 //x2=1.395 //y2=1.84
cc_10 ( N_noxref_1_c_10_p N_noxref_2_c_240_n ) capacitor c=0.00440271f \
 //x=0.74 //y=2.085 //x2=1.195 //y2=1.84
cc_11 ( N_noxref_1_M7_noxref_g N_noxref_2_c_241_n ) capacitor c=0.0095893f \
 //x=1.335 //y=6.02 //x2=1.395 //y2=4.96
cc_12 ( N_noxref_1_c_6_p N_noxref_2_c_242_n ) capacitor c=0.0134563f //x=3.175 \
 //y=4.115 //x2=1.2 //y2=4.96
cc_13 ( N_noxref_1_M6_noxref_g N_noxref_2_c_242_n ) capacitor c=0.00534267f \
 //x=0.895 //y=6.02 //x2=1.2 //y2=4.96
cc_14 ( N_noxref_1_c_14_p N_noxref_2_c_242_n ) capacitor c=0.00262283f \
 //x=1.26 //y=4.79 //x2=1.2 //y2=4.96
cc_15 ( N_noxref_1_c_15_p N_noxref_2_c_245_n ) capacitor c=0.008006f //x=0.74 \
 //y=3.955 //x2=1.48 //y2=2.435
cc_16 ( N_noxref_1_c_16_p N_noxref_2_c_245_n ) capacitor c=0.00491431f \
 //x=3.33 //y=2.23 //x2=1.48 //y2=2.435
cc_17 ( N_noxref_1_c_17_p N_noxref_2_c_245_n ) capacitor c=0.00317586f \
 //x=3.33 //y=3.955 //x2=1.48 //y2=2.435
cc_18 ( N_noxref_1_c_18_p N_noxref_2_c_245_n ) capacitor c=0.0181783f //x=0.74 \
 //y=2.085 //x2=1.48 //y2=2.435
cc_19 ( N_noxref_1_c_19_p N_noxref_2_c_245_n ) capacitor c=4.71798e-19 \
 //x=0.74 //y=2.085 //x2=1.48 //y2=2.435
cc_20 ( N_noxref_1_c_10_p N_noxref_2_c_245_n ) capacitor c=0.00275704f \
 //x=0.74 //y=2.085 //x2=1.48 //y2=2.435
cc_21 ( N_noxref_1_c_15_p N_noxref_2_c_251_n ) capacitor c=0.0147607f //x=0.74 \
 //y=3.955 //x2=1.48 //y2=2.755
cc_22 ( N_noxref_1_c_17_p N_noxref_2_c_251_n ) capacitor c=0.00251745f \
 //x=3.33 //y=3.955 //x2=1.48 //y2=2.755
cc_23 ( N_noxref_1_c_6_p N_noxref_2_c_251_n ) capacitor c=0.00251873f \
 //x=3.175 //y=4.115 //x2=1.48 //y2=2.755
cc_24 ( N_noxref_1_c_15_p N_noxref_2_c_254_n ) capacitor c=0.0578343f //x=0.74 \
 //y=3.955 //x2=1.48 //y2=4.875
cc_25 ( N_noxref_1_c_25_p N_noxref_2_c_254_n ) capacitor c=0.0178943f //x=0.74 \
 //y=4.275 //x2=1.48 //y2=4.875
cc_26 ( N_noxref_1_c_26_p N_noxref_2_c_254_n ) capacitor c=0.0301276f //x=0.74 \
 //y=4.58 //x2=1.48 //y2=4.875
cc_27 ( N_noxref_1_c_17_p N_noxref_2_c_254_n ) capacitor c=0.0228091f //x=3.33 \
 //y=3.955 //x2=1.48 //y2=4.875
cc_28 ( N_noxref_1_c_28_p N_noxref_2_c_254_n ) capacitor c=0.00247347f \
 //x=3.33 //y=4.275 //x2=1.48 //y2=4.875
cc_29 ( N_noxref_1_c_29_p N_noxref_2_c_254_n ) capacitor c=0.00908829f \
 //x=3.33 //y=4.58 //x2=1.48 //y2=4.875
cc_30 ( N_noxref_1_c_30_p N_noxref_2_c_254_n ) capacitor c=9.78797e-19 \
 //x=0.74 //y=4.07 //x2=1.48 //y2=4.875
cc_31 ( N_noxref_1_c_31_p N_noxref_2_c_254_n ) capacitor c=2.45384e-19 \
 //x=3.33 //y=4.07 //x2=1.48 //y2=4.875
cc_32 ( N_noxref_1_c_32_p N_noxref_2_c_254_n ) capacitor c=0.0032735f //x=0.9 \
 //y=4.115 //x2=1.48 //y2=4.875
cc_33 ( N_noxref_1_c_33_p N_noxref_2_c_254_n ) capacitor c=0.00157696f \
 //x=3.335 //y=4.115 //x2=1.48 //y2=4.875
cc_34 ( N_noxref_1_c_6_p N_noxref_2_c_254_n ) capacitor c=0.0319178f //x=3.175 \
 //y=4.115 //x2=1.48 //y2=4.875
cc_35 ( N_noxref_1_c_35_p N_noxref_2_c_254_n ) capacitor c=0.00160039f \
 //x=0.74 //y=4.7 //x2=1.48 //y2=4.875
cc_36 ( N_noxref_1_c_14_p N_noxref_2_c_254_n ) capacitor c=0.00208891f \
 //x=1.26 //y=4.79 //x2=1.48 //y2=4.875
cc_37 ( N_noxref_1_c_37_p N_noxref_2_c_254_n ) capacitor c=0.00140024f \
 //x=0.97 //y=4.79 //x2=1.48 //y2=4.875
cc_38 ( N_noxref_1_c_17_p N_noxref_2_c_268_n ) capacitor c=3.84525e-19 \
 //x=3.33 //y=3.955 //x2=7.64 //y2=4.445
cc_39 ( N_noxref_1_c_39_p N_noxref_2_c_269_n ) capacitor c=0.00187726f \
 //x=0.85 //y=0.91 //x2=1.11 //y2=1.005
cc_40 ( N_noxref_1_c_1_p N_noxref_2_c_269_n ) capacitor c=0.00414335f //x=0.85 \
 //y=1.255 //x2=1.11 //y2=1.005
cc_41 ( N_noxref_1_c_41_p N_noxref_2_c_269_n ) capacitor c=5.57924e-19 \
 //x=1.225 //y=0.755 //x2=1.11 //y2=1.005
cc_42 ( N_noxref_1_c_4_p N_noxref_2_c_269_n ) capacitor c=5.75878e-19 \
 //x=1.225 //y=1.41 //x2=1.11 //y2=1.005
cc_43 ( N_noxref_1_c_43_p N_noxref_2_c_269_n ) capacitor c=0.00148359f \
 //x=1.38 //y=0.91 //x2=1.11 //y2=1.005
cc_44 ( N_noxref_1_c_5_p N_noxref_2_c_269_n ) capacitor c=0.00354805f //x=1.38 \
 //y=1.255 //x2=1.11 //y2=1.005
cc_45 ( N_noxref_1_c_15_p N_noxref_2_c_275_n ) capacitor c=0.00349355f \
 //x=0.74 //y=3.955 //x2=1.48 //y2=2.59
cc_46 ( N_noxref_1_c_15_p N_noxref_2_c_276_n ) capacitor c=0.0068343f //x=0.74 \
 //y=3.955 //x2=1.645 //y2=2.595
cc_47 ( N_noxref_1_c_17_p N_noxref_2_c_276_n ) capacitor c=0.00158465f \
 //x=3.33 //y=3.955 //x2=1.645 //y2=2.595
cc_48 ( N_noxref_1_c_6_p N_noxref_2_c_276_n ) capacitor c=0.00526669f \
 //x=3.175 //y=4.115 //x2=1.645 //y2=2.595
cc_49 ( N_noxref_1_c_16_p N_noxref_2_c_279_n ) capacitor c=0.00460402f \
 //x=3.33 //y=2.23 //x2=7.595 //y2=2.57
cc_50 ( N_noxref_1_c_17_p N_noxref_2_c_279_n ) capacitor c=0.0336374f //x=3.33 \
 //y=3.955 //x2=7.595 //y2=2.57
cc_51 ( N_noxref_1_c_28_p N_noxref_2_c_279_n ) capacitor c=0.0021643f //x=3.33 \
 //y=4.275 //x2=7.595 //y2=2.57
cc_52 ( N_noxref_1_c_33_p N_noxref_2_c_279_n ) capacitor c=0.00500245f \
 //x=3.335 //y=4.115 //x2=7.595 //y2=2.57
cc_53 ( N_noxref_1_c_6_p N_noxref_2_c_279_n ) capacitor c=0.0375329f //x=3.175 \
 //y=4.115 //x2=7.595 //y2=2.57
cc_54 ( N_noxref_1_M6_noxref_g N_noxref_2_c_284_n ) capacitor c=0.0162066f \
 //x=0.895 //y=6.02 //x2=1.115 //y2=5.38
cc_55 ( N_noxref_1_M7_noxref_g N_noxref_2_c_284_n ) capacitor c=0.0162066f \
 //x=1.335 //y=6.02 //x2=1.115 //y2=5.38
cc_56 ( N_noxref_1_c_14_p N_noxref_2_c_284_n ) capacitor c=0.00290963f \
 //x=1.26 //y=4.79 //x2=1.115 //y2=5.38
cc_57 ( N_noxref_1_c_39_p N_noxref_2_M0_noxref_d ) capacitor c=0.00137914f \
 //x=0.85 //y=0.91 //x2=0.925 //y2=0.91
cc_58 ( N_noxref_1_c_1_p N_noxref_2_M0_noxref_d ) capacitor c=0.0023891f \
 //x=0.85 //y=1.255 //x2=0.925 //y2=0.91
cc_59 ( N_noxref_1_c_41_p N_noxref_2_M0_noxref_d ) capacitor c=0.0020782f \
 //x=1.225 //y=0.755 //x2=0.925 //y2=0.91
cc_60 ( N_noxref_1_c_4_p N_noxref_2_M0_noxref_d ) capacitor c=0.00356097f \
 //x=1.225 //y=1.41 //x2=0.925 //y2=0.91
cc_61 ( N_noxref_1_c_43_p N_noxref_2_M0_noxref_d ) capacitor c=0.00138452f \
 //x=1.38 //y=0.91 //x2=0.925 //y2=0.91
cc_62 ( N_noxref_1_c_5_p N_noxref_2_M0_noxref_d ) capacitor c=0.00235934f \
 //x=1.38 //y=1.255 //x2=0.925 //y2=0.91
cc_63 ( N_noxref_1_c_17_p N_noxref_3_c_513_n ) capacitor c=0.00969277f \
 //x=3.33 //y=3.955 //x2=4.93 //y2=3.465
cc_64 ( N_noxref_1_c_17_p N_noxref_3_c_514_n ) capacitor c=0.00562008f \
 //x=3.33 //y=3.955 //x2=4.93 //y2=3.815
cc_65 ( N_noxref_1_c_17_p N_noxref_3_c_515_n ) capacitor c=0.00233906f \
 //x=3.33 //y=3.955 //x2=4.93 //y2=5.12
cc_66 ( N_noxref_1_c_29_p N_noxref_3_c_515_n ) capacitor c=0.00164653f \
 //x=3.33 //y=4.58 //x2=4.93 //y2=5.12
cc_67 ( N_noxref_1_c_17_p N_noxref_3_c_517_n ) capacitor c=8.31378e-19 \
 //x=3.33 //y=3.955 //x2=4.81 //y2=3.7
cc_68 ( N_noxref_1_c_17_p N_noxref_3_c_518_n ) capacitor c=0.00417565f \
 //x=3.33 //y=3.955 //x2=4.975 //y2=3.655
cc_69 ( N_noxref_1_c_16_p N_noxref_4_c_812_n ) capacitor c=0.0111189f //x=3.33 \
 //y=2.23 //x2=4.44 //y2=2.205
cc_70 ( N_noxref_1_c_70_p N_noxref_4_c_812_n ) capacitor c=3.31511e-19 \
 //x=3.33 //y=2.08 //x2=4.44 //y2=2.205
cc_71 ( N_noxref_1_c_71_p N_noxref_4_c_812_n ) capacitor c=0.00133617f \
 //x=3.135 //y=1.915 //x2=4.44 //y2=2.205
cc_72 ( N_noxref_1_c_16_p N_noxref_4_c_815_n ) capacitor c=0.00108096f \
 //x=3.33 //y=2.23 //x2=4.44 //y2=2.845
cc_73 ( N_noxref_1_c_17_p N_noxref_4_c_815_n ) capacitor c=0.0144142f //x=3.33 \
 //y=3.955 //x2=4.44 //y2=2.845
cc_74 ( N_noxref_1_c_17_p N_noxref_4_c_817_n ) capacitor c=0.00898808f \
 //x=3.33 //y=3.955 //x2=4.44 //y2=2.96
cc_75 ( N_noxref_1_c_17_p N_noxref_4_c_818_n ) capacitor c=0.0053872f //x=3.33 \
 //y=3.955 //x2=4.585 //y2=3.005
cc_76 ( N_noxref_1_c_16_p N_noxref_4_c_819_n ) capacitor c=8.83803e-19 \
 //x=3.33 //y=2.23 //x2=4.44 //y2=2.08
cc_77 ( N_noxref_1_c_70_p N_noxref_4_c_819_n ) capacitor c=0.00114266f \
 //x=3.33 //y=2.08 //x2=4.44 //y2=2.08
cc_78 ( N_noxref_1_c_71_p N_noxref_4_c_819_n ) capacitor c=0.00190275f \
 //x=3.135 //y=1.915 //x2=4.44 //y2=2.08
cc_79 ( N_noxref_1_c_79_p N_noxref_4_c_822_n ) capacitor c=4.86545e-19 \
 //x=3.135 //y=0.865 //x2=4.105 //y2=0.905
cc_80 ( N_noxref_1_c_80_p N_noxref_4_c_822_n ) capacitor c=0.00152104f \
 //x=3.135 //y=1.21 //x2=4.105 //y2=0.905
cc_81 ( N_noxref_1_c_81_p N_noxref_4_c_822_n ) capacitor c=0.0157772f \
 //x=3.665 //y=0.865 //x2=4.105 //y2=0.905
cc_82 ( N_noxref_1_c_82_p N_noxref_4_c_825_n ) capacitor c=0.00109982f \
 //x=3.135 //y=1.52 //x2=4.105 //y2=1.25
cc_83 ( N_noxref_1_c_83_p N_noxref_4_c_825_n ) capacitor c=0.0117362f \
 //x=3.665 //y=1.21 //x2=4.105 //y2=1.25
cc_84 ( N_noxref_1_c_82_p N_noxref_4_c_827_n ) capacitor c=9.58243e-19 \
 //x=3.135 //y=1.52 //x2=4.105 //y2=1.56
cc_85 ( N_noxref_1_c_71_p N_noxref_4_c_827_n ) capacitor c=0.00662747f \
 //x=3.135 //y=1.915 //x2=4.105 //y2=1.56
cc_86 ( N_noxref_1_c_83_p N_noxref_4_c_827_n ) capacitor c=0.00862358f \
 //x=3.665 //y=1.21 //x2=4.105 //y2=1.56
cc_87 ( N_noxref_1_c_16_p N_noxref_4_c_830_n ) capacitor c=0.00175374f \
 //x=3.33 //y=2.23 //x2=4.105 //y2=1.915
cc_88 ( N_noxref_1_c_70_p N_noxref_4_c_830_n ) capacitor c=0.00214703f \
 //x=3.33 //y=2.08 //x2=4.105 //y2=1.915
cc_89 ( N_noxref_1_c_71_p N_noxref_4_c_830_n ) capacitor c=0.0121683f \
 //x=3.135 //y=1.915 //x2=4.105 //y2=1.915
cc_90 ( N_noxref_1_c_81_p N_noxref_4_c_833_n ) capacitor c=0.00124821f \
 //x=3.665 //y=0.865 //x2=4.635 //y2=0.905
cc_91 ( N_noxref_1_c_83_p N_noxref_4_c_834_n ) capacitor c=0.00204774f \
 //x=3.665 //y=1.21 //x2=4.635 //y2=1.25
cc_92 ( N_noxref_1_c_28_p N_noxref_5_c_1110_n ) capacitor c=0.0086964f \
 //x=3.33 //y=4.275 //x2=4.44 //y2=4.31
cc_93 ( N_noxref_1_c_29_p N_noxref_5_c_1110_n ) capacitor c=0.00113548f \
 //x=3.33 //y=4.58 //x2=4.44 //y2=4.31
cc_94 ( N_noxref_1_c_31_p N_noxref_5_c_1110_n ) capacitor c=2.4008e-19 \
 //x=3.33 //y=4.07 //x2=4.44 //y2=4.31
cc_95 ( N_noxref_1_c_33_p N_noxref_5_c_1110_n ) capacitor c=0.00267334f \
 //x=3.335 //y=4.115 //x2=4.44 //y2=4.31
cc_96 ( N_noxref_1_c_29_p N_noxref_5_c_1114_n ) capacitor c=0.0182584f \
 //x=3.33 //y=4.58 //x2=4.44 //y2=4.58
cc_97 ( N_noxref_1_c_97_p N_noxref_5_c_1114_n ) capacitor c=8.31633e-19 \
 //x=3.33 //y=4.7 //x2=4.44 //y2=4.58
cc_98 ( N_noxref_1_c_98_p N_noxref_5_c_1114_n ) capacitor c=0.00131752f \
 //x=3.33 //y=4.7 //x2=4.44 //y2=4.58
cc_99 ( N_noxref_1_c_17_p N_noxref_5_c_1117_n ) capacitor c=3.5216e-19 \
 //x=3.33 //y=3.955 //x2=4.42 //y2=4.15
cc_100 ( N_noxref_1_c_28_p N_noxref_5_c_1117_n ) capacitor c=2.32092e-19 \
 //x=3.33 //y=4.275 //x2=4.42 //y2=4.15
cc_101 ( N_noxref_1_c_31_p N_noxref_5_c_1117_n ) capacitor c=0.00541312f \
 //x=3.33 //y=4.07 //x2=4.42 //y2=4.15
cc_102 ( N_noxref_1_c_28_p N_noxref_5_c_1120_n ) capacitor c=0.00217482f \
 //x=3.33 //y=4.275 //x2=4.42 //y2=4.07
cc_103 ( N_noxref_1_c_29_p N_noxref_5_c_1120_n ) capacitor c=5.6846e-19 \
 //x=3.33 //y=4.58 //x2=4.42 //y2=4.07
cc_104 ( N_noxref_1_c_33_p N_noxref_5_c_1120_n ) capacitor c=0.00977878f \
 //x=3.335 //y=4.115 //x2=4.42 //y2=4.07
cc_105 ( N_noxref_1_c_29_p N_noxref_5_c_1123_n ) capacitor c=8.31633e-19 \
 //x=3.33 //y=4.58 //x2=4.44 //y2=4.7
cc_106 ( N_noxref_1_c_97_p N_noxref_5_c_1123_n ) capacitor c=0.00114285f \
 //x=3.33 //y=4.7 //x2=4.44 //y2=4.7
cc_107 ( N_noxref_1_c_98_p N_noxref_5_c_1123_n ) capacitor c=0.00195576f \
 //x=3.33 //y=4.7 //x2=4.44 //y2=4.7
cc_108 ( N_noxref_1_M8_noxref_g N_noxref_5_M10_noxref_g ) capacitor \
 c=0.010199f //x=3.23 //y=6.02 //x2=4.11 //y2=6.02
cc_109 ( N_noxref_1_M9_noxref_g N_noxref_5_M10_noxref_g ) capacitor \
 c=0.0618855f //x=3.67 //y=6.02 //x2=4.11 //y2=6.02
cc_110 ( N_noxref_1_M9_noxref_g N_noxref_5_M11_noxref_g ) capacitor \
 c=0.00945236f //x=3.67 //y=6.02 //x2=4.55 //y2=6.02
cc_111 ( N_noxref_1_c_29_p N_noxref_5_c_1129_n ) capacitor c=0.00131186f \
 //x=3.33 //y=4.58 //x2=4.44 //y2=4.7
cc_112 ( N_noxref_1_c_97_p N_noxref_5_c_1129_n ) capacitor c=0.0019442f \
 //x=3.33 //y=4.7 //x2=4.44 //y2=4.7
cc_113 ( N_noxref_1_c_98_p N_noxref_5_c_1129_n ) capacitor c=0.067621f \
 //x=3.33 //y=4.7 //x2=4.44 //y2=4.7
cc_114 ( N_noxref_1_c_25_p N_noxref_6_c_1411_n ) capacitor c=3.16668e-19 \
 //x=0.74 //y=4.275 //x2=3.365 //y2=7.4
cc_115 ( N_noxref_1_c_26_p N_noxref_6_c_1411_n ) capacitor c=5.72118e-19 \
 //x=0.74 //y=4.58 //x2=3.365 //y2=7.4
cc_116 ( N_noxref_1_c_35_p N_noxref_6_c_1411_n ) capacitor c=3.40875e-19 \
 //x=0.74 //y=4.7 //x2=3.365 //y2=7.4
cc_117 ( N_noxref_1_M8_noxref_g N_noxref_6_c_1414_n ) capacitor c=0.00421585f \
 //x=3.23 //y=6.02 //x2=3.45 //y2=6.52
cc_118 ( N_noxref_1_M9_noxref_g N_noxref_6_c_1414_n ) capacitor c=0.00397605f \
 //x=3.67 //y=6.02 //x2=3.45 //y2=6.52
cc_119 ( N_noxref_1_M8_noxref_g N_noxref_6_c_1416_n ) capacitor c=0.00555236f \
 //x=3.23 //y=6.02 //x2=3.45 //y2=7.23
cc_120 ( N_noxref_1_M9_noxref_g N_noxref_6_c_1416_n ) capacitor c=0.00559783f \
 //x=3.67 //y=6.02 //x2=3.45 //y2=7.23
cc_121 ( N_noxref_1_c_25_p N_noxref_6_c_1418_n ) capacitor c=2.92084e-19 \
 //x=0.74 //y=4.275 //x2=1.47 //y2=7.4
cc_122 ( N_noxref_1_c_26_p N_noxref_6_c_1418_n ) capacitor c=5.4912e-19 \
 //x=0.74 //y=4.58 //x2=1.47 //y2=7.4
cc_123 ( N_noxref_1_M6_noxref_g N_noxref_6_c_1418_n ) capacitor c=0.00748034f \
 //x=0.895 //y=6.02 //x2=1.47 //y2=7.4
cc_124 ( N_noxref_1_M7_noxref_g N_noxref_6_c_1418_n ) capacitor c=0.00749619f \
 //x=1.335 //y=6.02 //x2=1.47 //y2=7.4
cc_125 ( N_noxref_1_M8_noxref_g N_noxref_6_c_1422_n ) capacitor c=0.0072715f \
 //x=3.23 //y=6.02 //x2=5.38 //y2=7.4
cc_126 ( N_noxref_1_M9_noxref_g N_noxref_6_c_1422_n ) capacitor c=0.00767575f \
 //x=3.67 //y=6.02 //x2=5.38 //y2=7.4
cc_127 ( N_noxref_1_c_25_p N_noxref_6_c_1424_n ) capacitor c=0.00394762f \
 //x=0.74 //y=4.275 //x2=0.74 //y2=7.4
cc_128 ( N_noxref_1_c_26_p N_noxref_6_c_1424_n ) capacitor c=0.0175685f \
 //x=0.74 //y=4.58 //x2=0.74 //y2=7.4
cc_129 ( N_noxref_1_c_30_p N_noxref_6_c_1424_n ) capacitor c=0.00440981f \
 //x=0.74 //y=4.07 //x2=0.74 //y2=7.4
cc_130 ( N_noxref_1_c_35_p N_noxref_6_c_1424_n ) capacitor c=0.00795505f \
 //x=0.74 //y=4.7 //x2=0.74 //y2=7.4
cc_131 ( N_noxref_1_M6_noxref_g N_noxref_6_c_1424_n ) capacitor c=0.0150194f \
 //x=0.895 //y=6.02 //x2=0.74 //y2=7.4
cc_132 ( N_noxref_1_c_37_p N_noxref_6_c_1424_n ) capacitor c=0.00799922f \
 //x=0.97 //y=4.79 //x2=0.74 //y2=7.4
cc_133 ( N_noxref_1_c_28_p N_noxref_6_c_1430_n ) capacitor c=0.00192032f \
 //x=3.33 //y=4.275 //x2=2.22 //y2=7.4
cc_134 ( N_noxref_1_c_29_p N_noxref_6_c_1430_n ) capacitor c=0.00863356f \
 //x=3.33 //y=4.58 //x2=2.22 //y2=7.4
cc_135 ( N_noxref_1_c_30_p N_noxref_6_c_1430_n ) capacitor c=0.00133985f \
 //x=0.74 //y=4.07 //x2=2.22 //y2=7.4
cc_136 ( N_noxref_1_c_31_p N_noxref_6_c_1430_n ) capacitor c=0.00247563f \
 //x=3.33 //y=4.07 //x2=2.22 //y2=7.4
cc_137 ( N_noxref_1_c_6_p N_noxref_6_c_1430_n ) capacitor c=0.0192133f \
 //x=3.175 //y=4.115 //x2=2.22 //y2=7.4
cc_138 ( N_noxref_1_c_35_p N_noxref_6_c_1430_n ) capacitor c=0.00235165f \
 //x=0.74 //y=4.7 //x2=2.22 //y2=7.4
cc_139 ( N_noxref_1_c_97_p N_noxref_6_c_1430_n ) capacitor c=0.00370683f \
 //x=3.33 //y=4.7 //x2=2.22 //y2=7.4
cc_140 ( N_noxref_1_c_14_p N_noxref_6_c_1430_n ) capacitor c=0.00838585f \
 //x=1.26 //y=4.79 //x2=2.22 //y2=7.4
cc_141 ( N_noxref_1_c_37_p N_noxref_6_c_1430_n ) capacitor c=2.63786e-19 \
 //x=0.97 //y=4.79 //x2=2.22 //y2=7.4
cc_142 ( N_noxref_1_c_98_p N_noxref_6_c_1430_n ) capacitor c=0.0160742f \
 //x=3.33 //y=4.7 //x2=2.22 //y2=7.4
cc_143 ( N_noxref_1_c_25_p N_noxref_6_M6_noxref_s ) capacitor c=0.00195119f \
 //x=0.74 //y=4.275 //x2=0.54 //y2=5.02
cc_144 ( N_noxref_1_c_26_p N_noxref_6_M6_noxref_s ) capacitor c=0.0220878f \
 //x=0.74 //y=4.58 //x2=0.54 //y2=5.02
cc_145 ( N_noxref_1_c_32_p N_noxref_6_M6_noxref_s ) capacitor c=5.9996e-19 \
 //x=0.9 //y=4.115 //x2=0.54 //y2=5.02
cc_146 ( N_noxref_1_c_35_p N_noxref_6_M6_noxref_s ) capacitor c=0.00986151f \
 //x=0.74 //y=4.7 //x2=0.54 //y2=5.02
cc_147 ( N_noxref_1_M6_noxref_g N_noxref_6_M6_noxref_s ) capacitor \
 c=0.0573441f //x=0.895 //y=6.02 //x2=0.54 //y2=5.02
cc_148 ( N_noxref_1_c_37_p N_noxref_6_M6_noxref_s ) capacitor c=0.00529703f \
 //x=0.97 //y=4.79 //x2=0.54 //y2=5.02
cc_149 ( N_noxref_1_c_6_p N_noxref_6_M7_noxref_d ) capacitor c=0.00270279f \
 //x=3.175 //y=4.115 //x2=1.41 //y2=5.02
cc_150 ( N_noxref_1_M7_noxref_g N_noxref_6_M7_noxref_d ) capacitor \
 c=0.0572684f //x=1.335 //y=6.02 //x2=1.41 //y2=5.02
cc_151 ( N_noxref_1_c_97_p N_noxref_6_M8_noxref_d ) capacitor c=0.0015298f \
 //x=3.33 //y=4.7 //x2=3.305 //y2=5.02
cc_152 ( N_noxref_1_M8_noxref_g N_noxref_6_M8_noxref_d ) capacitor \
 c=0.00917375f //x=3.23 //y=6.02 //x2=3.305 //y2=5.02
cc_153 ( N_noxref_1_M9_noxref_g N_noxref_6_M8_noxref_d ) capacitor \
 c=0.00917375f //x=3.67 //y=6.02 //x2=3.305 //y2=5.02
cc_154 ( N_noxref_1_c_98_p N_noxref_6_M8_noxref_d ) capacitor c=0.00331893f \
 //x=3.33 //y=4.7 //x2=3.305 //y2=5.02
cc_155 ( N_noxref_1_c_28_p N_noxref_7_c_1665_n ) capacitor c=0.00192699f \
 //x=3.33 //y=4.275 //x2=3.775 //y2=5.205
cc_156 ( N_noxref_1_c_29_p N_noxref_7_c_1665_n ) capacitor c=0.0209222f \
 //x=3.33 //y=4.58 //x2=3.775 //y2=5.205
cc_157 ( N_noxref_1_c_33_p N_noxref_7_c_1665_n ) capacitor c=0.00174202f \
 //x=3.335 //y=4.115 //x2=3.775 //y2=5.205
cc_158 ( N_noxref_1_c_97_p N_noxref_7_c_1665_n ) capacitor c=0.00412201f \
 //x=3.33 //y=4.7 //x2=3.775 //y2=5.205
cc_159 ( N_noxref_1_M8_noxref_g N_noxref_7_c_1665_n ) capacitor c=0.0102413f \
 //x=3.23 //y=6.02 //x2=3.775 //y2=5.205
cc_160 ( N_noxref_1_M9_noxref_g N_noxref_7_c_1665_n ) capacitor c=0.0136407f \
 //x=3.67 //y=6.02 //x2=3.775 //y2=5.205
cc_161 ( N_noxref_1_c_98_p N_noxref_7_c_1665_n ) capacitor c=0.00183061f \
 //x=3.33 //y=4.7 //x2=3.775 //y2=5.205
cc_162 ( N_noxref_1_c_28_p N_noxref_7_c_1672_n ) capacitor c=0.00220276f \
 //x=3.33 //y=4.275 //x2=3.015 //y2=5.205
cc_163 ( N_noxref_1_c_6_p N_noxref_7_c_1672_n ) capacitor c=0.00647784f \
 //x=3.175 //y=4.115 //x2=3.015 //y2=5.205
cc_164 ( N_noxref_1_M8_noxref_g N_noxref_7_c_1672_n ) capacitor c=0.00428908f \
 //x=3.23 //y=6.02 //x2=3.015 //y2=5.205
cc_165 ( N_noxref_1_M9_noxref_g N_noxref_7_c_1675_n ) capacitor c=0.00178392f \
 //x=3.67 //y=6.02 //x2=3.892 //y2=5.205
cc_166 ( N_noxref_1_M9_noxref_g N_noxref_7_c_1676_n ) capacitor c=0.00188042f \
 //x=3.67 //y=6.02 //x2=3.89 //y2=6.735
cc_167 ( N_noxref_1_c_28_p N_noxref_7_c_1677_n ) capacitor c=3.5629e-19 \
 //x=3.33 //y=4.275 //x2=3.01 //y2=5.375
cc_168 ( N_noxref_1_M8_noxref_g N_noxref_7_c_1677_n ) capacitor c=0.0466274f \
 //x=3.23 //y=6.02 //x2=3.01 //y2=5.375
cc_169 ( N_noxref_1_M9_noxref_g N_noxref_7_c_1679_n ) capacitor c=0.0183685f \
 //x=3.67 //y=6.02 //x2=3.89 //y2=5.375
cc_170 ( N_noxref_1_M8_noxref_g N_noxref_7_M8_noxref_s ) capacitor \
 c=0.00518103f //x=3.23 //y=6.02 //x2=2.875 //y2=5.02
cc_171 ( N_noxref_1_c_25_p N_noxref_9_c_1836_n ) capacitor c=2.70582e-19 \
 //x=0.74 //y=4.275 //x2=3.315 //y2=0
cc_172 ( N_noxref_1_c_16_p N_noxref_9_c_1836_n ) capacitor c=7.50959e-19 \
 //x=3.33 //y=2.23 //x2=3.315 //y2=0
cc_173 ( N_noxref_1_c_28_p N_noxref_9_c_1836_n ) capacitor c=2.74927e-19 \
 //x=3.33 //y=4.275 //x2=3.315 //y2=0
cc_174 ( N_noxref_1_c_18_p N_noxref_9_c_1836_n ) capacitor c=0.00248634f \
 //x=0.74 //y=2.085 //x2=3.315 //y2=0
cc_175 ( N_noxref_1_c_19_p N_noxref_9_c_1836_n ) capacitor c=7.53892e-19 \
 //x=0.74 //y=2.085 //x2=3.315 //y2=0
cc_176 ( N_noxref_1_c_16_p N_noxref_9_c_1841_n ) capacitor c=0.00608438f \
 //x=3.33 //y=2.23 //x2=3.4 //y2=0.84
cc_177 ( N_noxref_1_c_70_p N_noxref_9_c_1841_n ) capacitor c=4.27717e-19 \
 //x=3.33 //y=2.08 //x2=3.4 //y2=0.84
cc_178 ( N_noxref_1_c_79_p N_noxref_9_c_1841_n ) capacitor c=0.00147588f \
 //x=3.135 //y=0.865 //x2=3.4 //y2=0.84
cc_179 ( N_noxref_1_c_80_p N_noxref_9_c_1841_n ) capacitor c=0.00298332f \
 //x=3.135 //y=1.21 //x2=3.4 //y2=0.84
cc_180 ( N_noxref_1_c_180_p N_noxref_9_c_1841_n ) capacitor c=0.0092698f \
 //x=3.51 //y=0.71 //x2=3.4 //y2=0.84
cc_181 ( N_noxref_1_c_181_p N_noxref_9_c_1841_n ) capacitor c=5.99853e-19 \
 //x=3.51 //y=1.365 //x2=3.4 //y2=0.84
cc_182 ( N_noxref_1_c_81_p N_noxref_9_c_1841_n ) capacitor c=0.00166772f \
 //x=3.665 //y=0.865 //x2=3.4 //y2=0.84
cc_183 ( N_noxref_1_c_83_p N_noxref_9_c_1841_n ) capacitor c=0.00229582f \
 //x=3.665 //y=1.21 //x2=3.4 //y2=0.84
cc_184 ( N_noxref_1_c_18_p N_noxref_9_c_1849_n ) capacitor c=0.00108343f \
 //x=0.74 //y=2.085 //x2=1.025 //y2=0.535
cc_185 ( N_noxref_1_c_19_p N_noxref_9_c_1849_n ) capacitor c=3.95714e-19 \
 //x=0.74 //y=2.085 //x2=1.025 //y2=0.535
cc_186 ( N_noxref_1_c_39_p N_noxref_9_c_1849_n ) capacitor c=0.0124783f \
 //x=0.85 //y=0.91 //x2=1.025 //y2=0.535
cc_187 ( N_noxref_1_c_10_p N_noxref_9_c_1849_n ) capacitor c=2.1838e-19 \
 //x=0.74 //y=2.085 //x2=1.025 //y2=0.535
cc_188 ( N_noxref_1_c_43_p N_noxref_9_c_1853_n ) capacitor c=0.0130723f \
 //x=1.38 //y=0.91 //x2=1.515 //y2=0.535
cc_189 ( N_noxref_1_c_79_p N_noxref_9_c_1854_n ) capacitor c=0.00688628f \
 //x=3.135 //y=0.865 //x2=5.38 //y2=0
cc_190 ( N_noxref_1_c_15_p N_noxref_9_c_1855_n ) capacitor c=0.0137596f \
 //x=0.74 //y=3.955 //x2=0.63 //y2=0
cc_191 ( N_noxref_1_c_18_p N_noxref_9_c_1855_n ) capacitor c=0.0100674f \
 //x=0.74 //y=2.085 //x2=0.63 //y2=0
cc_192 ( N_noxref_1_c_19_p N_noxref_9_c_1855_n ) capacitor c=0.00733542f \
 //x=0.74 //y=2.085 //x2=0.63 //y2=0
cc_193 ( N_noxref_1_c_3_p N_noxref_9_c_1855_n ) capacitor c=0.00552086f \
 //x=0.85 //y=1.92 //x2=0.63 //y2=0
cc_194 ( N_noxref_1_c_10_p N_noxref_9_c_1855_n ) capacitor c=0.00785621f \
 //x=0.74 //y=2.085 //x2=0.63 //y2=0
cc_195 ( N_noxref_1_c_16_p N_noxref_9_c_1860_n ) capacitor c=0.00459806f \
 //x=3.33 //y=2.23 //x2=2.22 //y2=0
cc_196 ( N_noxref_1_c_17_p N_noxref_9_c_1860_n ) capacitor c=0.00691543f \
 //x=3.33 //y=3.955 //x2=2.22 //y2=0
cc_197 ( N_noxref_1_c_6_p N_noxref_9_c_1860_n ) capacitor c=0.0022439f \
 //x=3.175 //y=4.115 //x2=2.22 //y2=0
cc_198 ( N_noxref_1_c_19_p N_noxref_9_c_1860_n ) capacitor c=0.0022444f \
 //x=0.74 //y=2.085 //x2=2.22 //y2=0
cc_199 ( N_noxref_1_c_70_p N_noxref_9_c_1860_n ) capacitor c=0.00385846f \
 //x=3.33 //y=2.08 //x2=2.22 //y2=0
cc_200 ( N_noxref_1_c_71_p N_noxref_9_c_1860_n ) capacitor c=0.00887431f \
 //x=3.135 //y=1.915 //x2=2.22 //y2=0
cc_201 ( N_noxref_1_c_10_p N_noxref_9_c_1860_n ) capacitor c=2.63786e-19 \
 //x=0.74 //y=2.085 //x2=2.22 //y2=0
cc_202 ( N_noxref_1_c_25_p N_noxref_9_M0_noxref_s ) capacitor c=2.04683e-19 \
 //x=0.74 //y=4.275 //x2=0.495 //y2=0.37
cc_203 ( N_noxref_1_c_18_p N_noxref_9_M0_noxref_s ) capacitor c=0.00297844f \
 //x=0.74 //y=2.085 //x2=0.495 //y2=0.37
cc_204 ( N_noxref_1_c_19_p N_noxref_9_M0_noxref_s ) capacitor c=0.00651272f \
 //x=0.74 //y=2.085 //x2=0.495 //y2=0.37
cc_205 ( N_noxref_1_c_39_p N_noxref_9_M0_noxref_s ) capacitor c=0.0300221f \
 //x=0.85 //y=0.91 //x2=0.495 //y2=0.37
cc_206 ( N_noxref_1_c_2_p N_noxref_9_M0_noxref_s ) capacitor c=0.002132f \
 //x=0.85 //y=1.565 //x2=0.495 //y2=0.37
cc_207 ( N_noxref_1_c_3_p N_noxref_9_M0_noxref_s ) capacitor c=0.00304786f \
 //x=0.85 //y=1.92 //x2=0.495 //y2=0.37
cc_208 ( N_noxref_1_c_41_p N_noxref_9_M0_noxref_s ) capacitor c=0.00517157f \
 //x=1.225 //y=0.755 //x2=0.495 //y2=0.37
cc_209 ( N_noxref_1_c_43_p N_noxref_9_M0_noxref_s ) capacitor c=0.0153553f \
 //x=1.38 //y=0.91 //x2=0.495 //y2=0.37
cc_210 ( N_noxref_1_c_5_p N_noxref_9_M0_noxref_s ) capacitor c=0.00629878f \
 //x=1.38 //y=1.255 //x2=0.495 //y2=0.37
cc_211 ( N_noxref_1_c_10_p N_noxref_9_M0_noxref_s ) capacitor c=0.00660494f \
 //x=0.74 //y=2.085 //x2=0.495 //y2=0.37
cc_212 ( N_noxref_1_c_16_p N_noxref_9_M1_noxref_d ) capacitor c=4.2739e-19 \
 //x=3.33 //y=2.23 //x2=3.21 //y2=0.865
cc_213 ( N_noxref_1_c_79_p N_noxref_9_M1_noxref_d ) capacitor c=0.00192399f \
 //x=3.135 //y=0.865 //x2=3.21 //y2=0.865
cc_214 ( N_noxref_1_c_80_p N_noxref_9_M1_noxref_d ) capacitor c=0.00228784f \
 //x=3.135 //y=1.21 //x2=3.21 //y2=0.865
cc_215 ( N_noxref_1_c_180_p N_noxref_9_M1_noxref_d ) capacitor c=0.0047434f \
 //x=3.51 //y=0.71 //x2=3.21 //y2=0.865
cc_216 ( N_noxref_1_c_181_p N_noxref_9_M1_noxref_d ) capacitor c=0.00172481f \
 //x=3.51 //y=1.365 //x2=3.21 //y2=0.865
cc_217 ( N_noxref_1_c_81_p N_noxref_9_M1_noxref_d ) capacitor c=0.00230174f \
 //x=3.665 //y=0.865 //x2=3.21 //y2=0.865
cc_218 ( N_noxref_1_c_83_p N_noxref_9_M1_noxref_d ) capacitor c=0.00228784f \
 //x=3.665 //y=1.21 //x2=3.21 //y2=0.865
cc_219 ( N_noxref_1_c_71_p N_noxref_10_c_2079_n ) capacitor c=0.00262672f \
 //x=3.135 //y=1.915 //x2=2.915 //y2=1.495
cc_220 ( N_noxref_1_c_16_p N_noxref_10_c_2080_n ) capacitor c=0.00501576f \
 //x=3.33 //y=2.23 //x2=3.8 //y2=1.58
cc_221 ( N_noxref_1_c_28_p N_noxref_10_c_2080_n ) capacitor c=0.00315352f \
 //x=3.33 //y=4.275 //x2=3.8 //y2=1.58
cc_222 ( N_noxref_1_c_70_p N_noxref_10_c_2080_n ) capacitor c=0.00763108f \
 //x=3.33 //y=2.08 //x2=3.8 //y2=1.58
cc_223 ( N_noxref_1_c_82_p N_noxref_10_c_2080_n ) capacitor c=0.0069585f \
 //x=3.135 //y=1.52 //x2=3.8 //y2=1.58
cc_224 ( N_noxref_1_c_71_p N_noxref_10_c_2080_n ) capacitor c=0.0175627f \
 //x=3.135 //y=1.915 //x2=3.8 //y2=1.58
cc_225 ( N_noxref_1_c_181_p N_noxref_10_c_2080_n ) capacitor c=0.00720058f \
 //x=3.51 //y=1.365 //x2=3.8 //y2=1.58
cc_226 ( N_noxref_1_c_83_p N_noxref_10_c_2080_n ) capacitor c=0.00339872f \
 //x=3.665 //y=1.21 //x2=3.8 //y2=1.58
cc_227 ( N_noxref_1_c_71_p N_noxref_10_c_2087_n ) capacitor c=6.71402e-19 \
 //x=3.135 //y=1.915 //x2=3.885 //y2=1.495
cc_228 ( N_noxref_1_c_79_p N_noxref_10_M1_noxref_s ) capacitor c=0.0293797f \
 //x=3.135 //y=0.865 //x2=2.78 //y2=0.365
cc_229 ( N_noxref_1_c_82_p N_noxref_10_M1_noxref_s ) capacitor c=3.48408e-19 \
 //x=3.135 //y=1.52 //x2=2.78 //y2=0.365
cc_230 ( N_noxref_1_c_81_p N_noxref_10_M1_noxref_s ) capacitor c=0.0124314f \
 //x=3.665 //y=0.865 //x2=2.78 //y2=0.365
cc_231 ( N_noxref_2_c_279_n N_noxref_3_c_519_n ) capacitor c=4.97573e-19 \
 //x=7.595 //y=2.57 //x2=4.37 //y2=1.115
cc_232 ( N_noxref_2_c_231_n N_noxref_3_c_520_n ) capacitor c=0.00493811f \
 //x=1.11 //y=1.755 //x2=4.37 //y2=1.565
cc_233 ( N_noxref_2_c_269_n N_noxref_3_c_520_n ) capacitor c=4.17953e-19 \
 //x=1.11 //y=1.005 //x2=4.37 //y2=1.565
cc_234 ( N_noxref_2_c_279_n N_noxref_3_c_522_n ) capacitor c=0.00739595f \
 //x=7.595 //y=2.57 //x2=4.845 //y2=1.65
cc_235 ( N_noxref_2_c_279_n N_noxref_3_c_523_n ) capacitor c=0.00107797f \
 //x=7.595 //y=2.57 //x2=4.455 //y2=1.65
cc_236 ( N_noxref_2_c_239_n N_noxref_3_c_513_n ) capacitor c=0.00189597f \
 //x=1.395 //y=1.84 //x2=4.93 //y2=3.465
cc_237 ( N_noxref_2_c_299_p N_noxref_3_c_513_n ) capacitor c=0.00136571f \
 //x=7.64 //y=2.735 //x2=4.93 //y2=3.465
cc_238 ( N_noxref_2_c_300_p N_noxref_3_c_513_n ) capacitor c=4.8287e-19 \
 //x=7.77 //y=2.415 //x2=4.93 //y2=3.465
cc_239 ( N_noxref_2_c_279_n N_noxref_3_c_513_n ) capacitor c=0.027366f \
 //x=7.595 //y=2.57 //x2=4.93 //y2=3.465
cc_240 ( N_noxref_2_c_268_n N_noxref_3_c_514_n ) capacitor c=0.00767831f \
 //x=7.64 //y=4.445 //x2=4.93 //y2=3.815
cc_241 ( N_noxref_2_c_236_n N_noxref_3_c_515_n ) capacitor c=6.97655e-19 \
 //x=1.115 //y=5.24 //x2=4.93 //y2=5.12
cc_242 ( N_noxref_2_c_254_n N_noxref_3_c_515_n ) capacitor c=0.00223299f \
 //x=1.48 //y=4.875 //x2=4.93 //y2=5.12
cc_243 ( N_noxref_2_c_268_n N_noxref_3_c_515_n ) capacitor c=4.82377e-19 \
 //x=7.64 //y=4.445 //x2=4.93 //y2=5.12
cc_244 ( N_noxref_2_c_299_p N_noxref_3_c_532_n ) capacitor c=4.73637e-19 \
 //x=7.64 //y=2.735 //x2=7.7 //y2=1.12
cc_245 ( N_noxref_2_c_307_p N_noxref_3_c_532_n ) capacitor c=2.49761e-19 \
 //x=7.755 //y=2.57 //x2=7.7 //y2=1.12
cc_246 ( N_noxref_2_c_308_p N_noxref_3_c_532_n ) capacitor c=8.07133e-19 \
 //x=7.435 //y=0.905 //x2=7.7 //y2=1.12
cc_247 ( N_noxref_2_c_309_p N_noxref_3_c_532_n ) capacitor c=0.0020872f \
 //x=7.435 //y=1.25 //x2=7.7 //y2=1.12
cc_248 ( N_noxref_2_c_310_p N_noxref_3_c_532_n ) capacitor c=5.3577e-19 \
 //x=7.81 //y=0.75 //x2=7.7 //y2=1.12
cc_249 ( N_noxref_2_c_311_p N_noxref_3_c_532_n ) capacitor c=4.55105e-19 \
 //x=7.81 //y=1.405 //x2=7.7 //y2=1.12
cc_250 ( N_noxref_2_c_312_p N_noxref_3_c_532_n ) capacitor c=6.55329e-19 \
 //x=7.965 //y=0.905 //x2=7.7 //y2=1.12
cc_251 ( N_noxref_2_c_313_p N_noxref_3_c_532_n ) capacitor c=0.00312902f \
 //x=7.965 //y=1.25 //x2=7.7 //y2=1.12
cc_252 ( N_noxref_2_c_309_p N_noxref_3_c_540_n ) capacitor c=0.00119008f \
 //x=7.435 //y=1.25 //x2=7.7 //y2=1.565
cc_253 ( N_noxref_2_c_315_p N_noxref_3_c_540_n ) capacitor c=0.00410123f \
 //x=7.435 //y=1.56 //x2=7.7 //y2=1.565
cc_254 ( N_noxref_2_c_316_p N_noxref_3_c_540_n ) capacitor c=0.00329274f \
 //x=7.435 //y=1.915 //x2=7.7 //y2=1.565
cc_255 ( N_noxref_2_c_311_p N_noxref_3_c_540_n ) capacitor c=0.00743418f \
 //x=7.81 //y=1.405 //x2=7.7 //y2=1.565
cc_256 ( N_noxref_2_c_313_p N_noxref_3_c_540_n ) capacitor c=0.00303393f \
 //x=7.965 //y=1.25 //x2=7.7 //y2=1.565
cc_257 ( N_noxref_2_c_268_n N_noxref_3_c_545_n ) capacitor c=0.00404703f \
 //x=7.64 //y=4.445 //x2=8.055 //y2=5.205
cc_258 ( N_noxref_2_c_320_p N_noxref_3_c_545_n ) capacitor c=0.00104675f \
 //x=7.77 //y=4.7 //x2=8.055 //y2=5.205
cc_259 ( N_noxref_2_M15_noxref_g N_noxref_3_c_545_n ) capacitor c=0.00979435f \
 //x=7.88 //y=6.02 //x2=8.055 //y2=5.205
cc_260 ( N_noxref_2_c_299_p N_noxref_3_c_548_n ) capacitor c=7.47623e-19 \
 //x=7.64 //y=2.735 //x2=8.055 //y2=1.65
cc_261 ( N_noxref_2_c_323_p N_noxref_3_c_548_n ) capacitor c=0.00327978f \
 //x=7.77 //y=2.205 //x2=8.055 //y2=1.65
cc_262 ( N_noxref_2_c_307_p N_noxref_3_c_548_n ) capacitor c=3.70779e-19 \
 //x=7.755 //y=2.57 //x2=8.055 //y2=1.65
cc_263 ( N_noxref_2_c_325_p N_noxref_3_c_548_n ) capacitor c=0.00147657f \
 //x=7.77 //y=2.08 //x2=8.055 //y2=1.65
cc_264 ( N_noxref_2_c_311_p N_noxref_3_c_548_n ) capacitor c=0.00124426f \
 //x=7.81 //y=1.405 //x2=8.055 //y2=1.65
cc_265 ( N_noxref_2_c_313_p N_noxref_3_c_548_n ) capacitor c=0.00300259f \
 //x=7.965 //y=1.25 //x2=8.055 //y2=1.65
cc_266 ( N_noxref_2_c_299_p N_noxref_3_c_554_n ) capacitor c=0.00136672f \
 //x=7.64 //y=2.735 //x2=7.785 //y2=1.65
cc_267 ( N_noxref_2_c_323_p N_noxref_3_c_554_n ) capacitor c=0.0234751f \
 //x=7.77 //y=2.205 //x2=7.785 //y2=1.65
cc_268 ( N_noxref_2_c_307_p N_noxref_3_c_554_n ) capacitor c=6.62009e-19 \
 //x=7.755 //y=2.57 //x2=7.785 //y2=1.65
cc_269 ( N_noxref_2_c_325_p N_noxref_3_c_554_n ) capacitor c=0.00408137f \
 //x=7.77 //y=2.08 //x2=7.785 //y2=1.65
cc_270 ( N_noxref_2_c_316_p N_noxref_3_c_554_n ) capacitor c=0.00193155f \
 //x=7.435 //y=1.915 //x2=7.785 //y2=1.65
cc_271 ( N_noxref_2_c_299_p N_noxref_3_c_559_n ) capacitor c=0.0345936f \
 //x=7.64 //y=2.735 //x2=8.14 //y2=3.555
cc_272 ( N_noxref_2_c_268_n N_noxref_3_c_559_n ) capacitor c=0.0508488f \
 //x=7.64 //y=4.445 //x2=8.14 //y2=3.555
cc_273 ( N_noxref_2_c_323_p N_noxref_3_c_559_n ) capacitor c=0.0315493f \
 //x=7.77 //y=2.205 //x2=8.14 //y2=3.555
cc_274 ( N_noxref_2_c_300_p N_noxref_3_c_559_n ) capacitor c=0.0178085f \
 //x=7.77 //y=2.415 //x2=8.14 //y2=3.555
cc_275 ( N_noxref_2_c_337_p N_noxref_3_c_559_n ) capacitor c=0.00287239f \
 //x=7.77 //y=2.59 //x2=8.14 //y2=3.555
cc_276 ( N_noxref_2_c_307_p N_noxref_3_c_559_n ) capacitor c=0.0126551f \
 //x=7.755 //y=2.57 //x2=8.14 //y2=3.555
cc_277 ( N_noxref_2_c_325_p N_noxref_3_c_559_n ) capacitor c=0.00291366f \
 //x=7.77 //y=2.08 //x2=8.14 //y2=3.555
cc_278 ( N_noxref_2_c_316_p N_noxref_3_c_559_n ) capacitor c=0.0084769f \
 //x=7.435 //y=1.915 //x2=8.14 //y2=3.555
cc_279 ( N_noxref_2_c_299_p N_noxref_3_c_567_n ) capacitor c=0.00114284f \
 //x=7.64 //y=2.735 //x2=8.14 //y2=3.935
cc_280 ( N_noxref_2_c_268_n N_noxref_3_c_567_n ) capacitor c=0.037021f \
 //x=7.64 //y=4.445 //x2=8.14 //y2=3.935
cc_281 ( N_noxref_2_c_343_p N_noxref_3_c_567_n ) capacitor c=7.32551e-19 \
 //x=7.77 //y=4.7 //x2=8.14 //y2=3.935
cc_282 ( N_noxref_2_c_268_n N_noxref_3_c_570_n ) capacitor c=0.0750066f \
 //x=7.64 //y=4.445 //x2=8.14 //y2=5.12
cc_283 ( N_noxref_2_c_320_p N_noxref_3_c_570_n ) capacitor c=0.00242208f \
 //x=7.77 //y=4.7 //x2=8.14 //y2=5.12
cc_284 ( N_noxref_2_c_343_p N_noxref_3_c_570_n ) capacitor c=0.00933199f \
 //x=7.77 //y=4.7 //x2=8.14 //y2=5.12
cc_285 ( N_noxref_2_c_236_n N_noxref_3_c_573_n ) capacitor c=3.86497e-19 \
 //x=1.115 //y=5.24 //x2=4.33 //y2=5.205
cc_286 ( N_noxref_2_c_268_n N_noxref_3_c_574_n ) capacitor c=0.027931f \
 //x=7.64 //y=4.445 //x2=7.66 //y2=5.205
cc_287 ( N_noxref_2_c_320_p N_noxref_3_c_574_n ) capacitor c=0.00390963f \
 //x=7.77 //y=4.7 //x2=7.66 //y2=5.205
cc_288 ( N_noxref_2_M14_noxref_g N_noxref_3_c_574_n ) capacitor c=0.00194596f \
 //x=7.44 //y=6.02 //x2=7.66 //y2=5.205
cc_289 ( N_noxref_2_M15_noxref_g N_noxref_3_c_574_n ) capacitor c=0.00286922f \
 //x=7.88 //y=6.02 //x2=7.66 //y2=5.205
cc_290 ( N_noxref_2_c_343_p N_noxref_3_c_574_n ) capacitor c=0.00191226f \
 //x=7.77 //y=4.7 //x2=7.66 //y2=5.205
cc_291 ( N_noxref_2_c_268_n N_noxref_3_c_579_n ) capacitor c=0.00513879f \
 //x=7.64 //y=4.445 //x2=8.14 //y2=3.7
cc_292 ( N_noxref_2_c_268_n N_noxref_3_c_580_n ) capacitor c=0.00590878f \
 //x=7.64 //y=4.445 //x2=8.185 //y2=3.745
cc_293 ( N_noxref_2_c_268_n N_noxref_3_c_581_n ) capacitor c=0.0206982f \
 //x=7.64 //y=4.445 //x2=7.995 //y2=3.745
cc_294 ( N_noxref_2_c_279_n N_noxref_3_c_581_n ) capacitor c=0.0053728f \
 //x=7.595 //y=2.57 //x2=7.995 //y2=3.745
cc_295 ( N_noxref_2_c_268_n N_noxref_3_c_583_n ) capacitor c=0.00419694f \
 //x=7.64 //y=4.445 //x2=7.66 //y2=5.375
cc_296 ( N_noxref_2_c_320_p N_noxref_3_c_583_n ) capacitor c=0.00419714f \
 //x=7.77 //y=4.7 //x2=7.66 //y2=5.375
cc_297 ( N_noxref_2_M14_noxref_g N_noxref_3_c_583_n ) capacitor c=0.0120591f \
 //x=7.44 //y=6.02 //x2=7.66 //y2=5.375
cc_298 ( N_noxref_2_M15_noxref_g N_noxref_3_c_583_n ) capacitor c=0.0140704f \
 //x=7.88 //y=6.02 //x2=7.66 //y2=5.375
cc_299 ( N_noxref_2_c_343_p N_noxref_3_c_583_n ) capacitor c=0.00438806f \
 //x=7.77 //y=4.7 //x2=7.66 //y2=5.375
cc_300 ( N_noxref_2_c_299_p N_noxref_3_M4_noxref_d ) capacitor c=3.37013e-19 \
 //x=7.64 //y=2.735 //x2=7.51 //y2=0.905
cc_301 ( N_noxref_2_c_323_p N_noxref_3_M4_noxref_d ) capacitor c=9.14309e-19 \
 //x=7.77 //y=2.205 //x2=7.51 //y2=0.905
cc_302 ( N_noxref_2_c_325_p N_noxref_3_M4_noxref_d ) capacitor c=0.00150225f \
 //x=7.77 //y=2.08 //x2=7.51 //y2=0.905
cc_303 ( N_noxref_2_c_308_p N_noxref_3_M4_noxref_d ) capacitor c=0.00209865f \
 //x=7.435 //y=0.905 //x2=7.51 //y2=0.905
cc_304 ( N_noxref_2_c_309_p N_noxref_3_M4_noxref_d ) capacitor c=0.00237422f \
 //x=7.435 //y=1.25 //x2=7.51 //y2=0.905
cc_305 ( N_noxref_2_c_310_p N_noxref_3_M4_noxref_d ) capacitor c=0.00213893f \
 //x=7.81 //y=0.75 //x2=7.51 //y2=0.905
cc_306 ( N_noxref_2_c_311_p N_noxref_3_M4_noxref_d ) capacitor c=0.00345753f \
 //x=7.81 //y=1.405 //x2=7.51 //y2=0.905
cc_307 ( N_noxref_2_c_312_p N_noxref_3_M4_noxref_d ) capacitor c=0.00124544f \
 //x=7.965 //y=0.905 //x2=7.51 //y2=0.905
cc_308 ( N_noxref_2_c_313_p N_noxref_3_M4_noxref_d ) capacitor c=0.00237422f \
 //x=7.965 //y=1.25 //x2=7.51 //y2=0.905
cc_309 ( N_noxref_2_c_279_n N_noxref_4_c_812_n ) capacitor c=0.00250792f \
 //x=7.595 //y=2.57 //x2=4.44 //y2=2.205
cc_310 ( N_noxref_2_c_245_n N_noxref_4_c_815_n ) capacitor c=5.23847e-19 \
 //x=1.48 //y=2.435 //x2=4.44 //y2=2.845
cc_311 ( N_noxref_2_c_279_n N_noxref_4_c_815_n ) capacitor c=0.0233255f \
 //x=7.595 //y=2.57 //x2=4.44 //y2=2.845
cc_312 ( N_noxref_2_c_300_p N_noxref_4_c_838_n ) capacitor c=0.00108584f \
 //x=7.77 //y=2.415 //x2=9.62 //y2=2.785
cc_313 ( N_noxref_2_c_268_n N_noxref_4_c_839_n ) capacitor c=0.0026964f \
 //x=7.64 //y=4.445 //x2=9.62 //y2=4.325
cc_314 ( N_noxref_2_c_268_n N_noxref_4_c_840_n ) capacitor c=4.39865e-19 \
 //x=7.64 //y=4.445 //x2=9.62 //y2=4.735
cc_315 ( N_noxref_2_c_279_n N_noxref_4_c_817_n ) capacitor c=0.00509077f \
 //x=7.595 //y=2.57 //x2=4.44 //y2=2.96
cc_316 ( N_noxref_2_c_268_n N_noxref_4_c_842_n ) capacitor c=0.0148957f \
 //x=7.64 //y=4.445 //x2=6.66 //y2=4.44
cc_317 ( N_noxref_2_c_320_p N_noxref_4_c_842_n ) capacitor c=2.21237e-19 \
 //x=7.77 //y=4.7 //x2=6.66 //y2=4.44
cc_318 ( N_noxref_2_c_268_n N_noxref_4_c_844_n ) capacitor c=0.0355012f \
 //x=7.64 //y=4.445 //x2=9.46 //y2=4.497
cc_319 ( N_noxref_2_c_279_n N_noxref_4_c_818_n ) capacitor c=0.0336483f \
 //x=7.595 //y=2.57 //x2=4.585 //y2=3.005
cc_320 ( N_noxref_2_c_268_n N_noxref_4_c_846_n ) capacitor c=0.00286826f \
 //x=7.64 //y=4.445 //x2=6.645 //y2=4.497
cc_321 ( N_noxref_2_c_299_p N_noxref_4_c_847_n ) capacitor c=0.00802588f \
 //x=7.64 //y=2.735 //x2=9.47 //y2=2.945
cc_322 ( N_noxref_2_c_268_n N_noxref_4_c_847_n ) capacitor c=0.0195174f \
 //x=7.64 //y=4.445 //x2=9.47 //y2=2.945
cc_323 ( N_noxref_2_c_337_p N_noxref_4_c_847_n ) capacitor c=0.00161456f \
 //x=7.77 //y=2.59 //x2=9.47 //y2=2.945
cc_324 ( N_noxref_2_c_307_p N_noxref_4_c_847_n ) capacitor c=0.0367566f \
 //x=7.755 //y=2.57 //x2=9.47 //y2=2.945
cc_325 ( N_noxref_2_c_279_n N_noxref_4_c_847_n ) capacitor c=0.274723f \
 //x=7.595 //y=2.57 //x2=9.47 //y2=2.945
cc_326 ( N_noxref_2_c_268_n N_noxref_4_c_852_n ) capacitor c=0.00337162f \
 //x=7.64 //y=4.445 //x2=6.66 //y2=4.44
cc_327 ( N_noxref_2_c_320_p N_noxref_4_c_852_n ) capacitor c=0.00157085f \
 //x=7.77 //y=4.7 //x2=6.66 //y2=4.44
cc_328 ( N_noxref_2_c_343_p N_noxref_4_c_852_n ) capacitor c=0.00183f //x=7.77 \
 //y=4.7 //x2=6.66 //y2=4.44
cc_329 ( N_noxref_2_M14_noxref_g N_noxref_4_M12_noxref_g ) capacitor \
 c=0.0102018f //x=7.44 //y=6.02 //x2=6.56 //y2=6.02
cc_330 ( N_noxref_2_M14_noxref_g N_noxref_4_M13_noxref_g ) capacitor \
 c=0.0618273f //x=7.44 //y=6.02 //x2=7 //y2=6.02
cc_331 ( N_noxref_2_M15_noxref_g N_noxref_4_M13_noxref_g ) capacitor \
 c=0.00945236f //x=7.88 //y=6.02 //x2=7 //y2=6.02
cc_332 ( N_noxref_2_c_268_n N_noxref_4_c_858_n ) capacitor c=7.74131e-19 \
 //x=7.64 //y=4.445 //x2=6.66 //y2=4.7
cc_333 ( N_noxref_2_c_320_p N_noxref_4_c_858_n ) capacitor c=0.00165977f \
 //x=7.77 //y=4.7 //x2=6.66 //y2=4.7
cc_334 ( N_noxref_2_c_343_p N_noxref_4_c_858_n ) capacitor c=0.0663512f \
 //x=7.77 //y=4.7 //x2=6.66 //y2=4.7
cc_335 ( N_noxref_2_c_254_n N_noxref_5_c_1114_n ) capacitor c=6.27081e-19 \
 //x=1.48 //y=4.875 //x2=4.44 //y2=4.58
cc_336 ( N_noxref_2_c_323_p N_noxref_5_c_1133_n ) capacitor c=0.0115204f \
 //x=7.77 //y=2.205 //x2=6.66 //y2=2.205
cc_337 ( N_noxref_2_c_279_n N_noxref_5_c_1133_n ) capacitor c=0.00307438f \
 //x=7.595 //y=2.57 //x2=6.66 //y2=2.205
cc_338 ( N_noxref_2_c_325_p N_noxref_5_c_1133_n ) capacitor c=3.73267e-19 \
 //x=7.77 //y=2.08 //x2=6.66 //y2=2.205
cc_339 ( N_noxref_2_c_316_p N_noxref_5_c_1133_n ) capacitor c=0.00148195f \
 //x=7.435 //y=1.915 //x2=6.66 //y2=2.205
cc_340 ( N_noxref_2_c_299_p N_noxref_5_c_1137_n ) capacitor c=0.0206435f \
 //x=7.64 //y=2.735 //x2=6.66 //y2=3.18
cc_341 ( N_noxref_2_c_300_p N_noxref_5_c_1137_n ) capacitor c=0.00540306f \
 //x=7.77 //y=2.415 //x2=6.66 //y2=3.18
cc_342 ( N_noxref_2_c_307_p N_noxref_5_c_1137_n ) capacitor c=0.0015359f \
 //x=7.755 //y=2.57 //x2=6.66 //y2=3.18
cc_343 ( N_noxref_2_c_279_n N_noxref_5_c_1137_n ) capacitor c=0.027872f \
 //x=7.595 //y=2.57 //x2=6.66 //y2=3.18
cc_344 ( N_noxref_2_c_325_p N_noxref_5_c_1137_n ) capacitor c=3.33331e-19 \
 //x=7.77 //y=2.08 //x2=6.66 //y2=3.18
cc_345 ( N_noxref_2_c_268_n N_noxref_5_c_1142_n ) capacitor c=0.0105627f \
 //x=7.64 //y=4.445 //x2=6.66 //y2=3.33
cc_346 ( N_noxref_2_c_268_n N_noxref_5_c_1143_n ) capacitor c=0.0257858f \
 //x=7.64 //y=4.445 //x2=7.715 //y2=4.07
cc_347 ( N_noxref_2_c_279_n N_noxref_5_c_1120_n ) capacitor c=6.57891e-19 \
 //x=7.595 //y=2.57 //x2=4.42 //y2=4.07
cc_348 ( N_noxref_2_c_268_n N_noxref_5_c_1145_n ) capacitor c=0.00270765f \
 //x=7.64 //y=4.445 //x2=6.825 //y2=3.34
cc_349 ( N_noxref_2_c_268_n N_noxref_5_c_1146_n ) capacitor c=0.0196581f \
 //x=7.64 //y=4.445 //x2=10.245 //y2=3.405
cc_350 ( N_noxref_2_c_279_n N_noxref_5_c_1146_n ) capacitor c=0.00459184f \
 //x=7.595 //y=2.57 //x2=10.245 //y2=3.405
cc_351 ( N_noxref_2_c_323_p N_noxref_5_c_1148_n ) capacitor c=5.11751e-19 \
 //x=7.77 //y=2.205 //x2=6.66 //y2=2.08
cc_352 ( N_noxref_2_c_300_p N_noxref_5_c_1148_n ) capacitor c=3.33331e-19 \
 //x=7.77 //y=2.415 //x2=6.66 //y2=2.08
cc_353 ( N_noxref_2_c_325_p N_noxref_5_c_1148_n ) capacitor c=0.00114285f \
 //x=7.77 //y=2.08 //x2=6.66 //y2=2.08
cc_354 ( N_noxref_2_c_316_p N_noxref_5_c_1148_n ) capacitor c=0.00230486f \
 //x=7.435 //y=1.915 //x2=6.66 //y2=2.08
cc_355 ( N_noxref_2_c_308_p N_noxref_5_c_1152_n ) capacitor c=4.86545e-19 \
 //x=7.435 //y=0.905 //x2=6.465 //y2=0.865
cc_356 ( N_noxref_2_c_308_p N_noxref_5_c_1153_n ) capacitor c=0.00152104f \
 //x=7.435 //y=0.905 //x2=6.465 //y2=1.21
cc_357 ( N_noxref_2_c_309_p N_noxref_5_c_1154_n ) capacitor c=0.00109982f \
 //x=7.435 //y=1.25 //x2=6.465 //y2=1.52
cc_358 ( N_noxref_2_c_315_p N_noxref_5_c_1154_n ) capacitor c=9.57794e-19 \
 //x=7.435 //y=1.56 //x2=6.465 //y2=1.52
cc_359 ( N_noxref_2_c_323_p N_noxref_5_c_1156_n ) capacitor c=0.00139976f \
 //x=7.77 //y=2.205 //x2=6.465 //y2=1.915
cc_360 ( N_noxref_2_c_325_p N_noxref_5_c_1156_n ) capacitor c=0.00187625f \
 //x=7.77 //y=2.08 //x2=6.465 //y2=1.915
cc_361 ( N_noxref_2_c_315_p N_noxref_5_c_1156_n ) capacitor c=0.00662747f \
 //x=7.435 //y=1.56 //x2=6.465 //y2=1.915
cc_362 ( N_noxref_2_c_316_p N_noxref_5_c_1156_n ) capacitor c=0.0121418f \
 //x=7.435 //y=1.915 //x2=6.465 //y2=1.915
cc_363 ( N_noxref_2_c_308_p N_noxref_5_c_1160_n ) capacitor c=0.0157772f \
 //x=7.435 //y=0.905 //x2=6.995 //y2=0.865
cc_364 ( N_noxref_2_c_312_p N_noxref_5_c_1160_n ) capacitor c=0.00124821f \
 //x=7.965 //y=0.905 //x2=6.995 //y2=0.865
cc_365 ( N_noxref_2_c_309_p N_noxref_5_c_1162_n ) capacitor c=0.0117362f \
 //x=7.435 //y=1.25 //x2=6.995 //y2=1.21
cc_366 ( N_noxref_2_c_315_p N_noxref_5_c_1162_n ) capacitor c=0.00862358f \
 //x=7.435 //y=1.56 //x2=6.995 //y2=1.21
cc_367 ( N_noxref_2_c_313_p N_noxref_5_c_1162_n ) capacitor c=0.00204774f \
 //x=7.965 //y=1.25 //x2=6.995 //y2=1.21
cc_368 ( N_noxref_2_c_236_n N_noxref_6_c_1411_n ) capacitor c=0.00259272f \
 //x=1.115 //y=5.24 //x2=3.365 //y2=7.4
cc_369 ( N_noxref_2_c_241_n N_noxref_6_c_1411_n ) capacitor c=0.00199455f \
 //x=1.395 //y=4.96 //x2=3.365 //y2=7.4
cc_370 ( N_noxref_2_c_284_n N_noxref_6_c_1411_n ) capacitor c=0.0024144f \
 //x=1.115 //y=5.38 //x2=3.365 //y2=7.4
cc_371 ( N_noxref_2_c_236_n N_noxref_6_c_1418_n ) capacitor c=8.9666e-19 \
 //x=1.115 //y=5.24 //x2=1.47 //y2=7.4
cc_372 ( N_noxref_2_c_241_n N_noxref_6_c_1418_n ) capacitor c=0.00197518f \
 //x=1.395 //y=4.96 //x2=1.47 //y2=7.4
cc_373 ( N_noxref_2_c_284_n N_noxref_6_c_1418_n ) capacitor c=0.0137788f \
 //x=1.115 //y=5.38 //x2=1.47 //y2=7.4
cc_374 ( N_noxref_2_M14_noxref_g N_noxref_6_c_1458_n ) capacitor c=0.00772064f \
 //x=7.44 //y=6.02 //x2=8.71 //y2=7.4
cc_375 ( N_noxref_2_M15_noxref_g N_noxref_6_c_1458_n ) capacitor c=0.0075333f \
 //x=7.88 //y=6.02 //x2=8.71 //y2=7.4
cc_376 ( N_noxref_2_c_242_n N_noxref_6_c_1424_n ) capacitor c=0.00685597f \
 //x=1.2 //y=4.96 //x2=0.74 //y2=7.4
cc_377 ( N_noxref_2_c_254_n N_noxref_6_c_1424_n ) capacitor c=2.43252e-19 \
 //x=1.48 //y=4.875 //x2=0.74 //y2=7.4
cc_378 ( N_noxref_2_c_284_n N_noxref_6_c_1424_n ) capacitor c=0.00822773f \
 //x=1.115 //y=5.38 //x2=0.74 //y2=7.4
cc_379 ( N_noxref_2_c_236_n N_noxref_6_c_1430_n ) capacitor c=0.00232499f \
 //x=1.115 //y=5.24 //x2=2.22 //y2=7.4
cc_380 ( N_noxref_2_c_254_n N_noxref_6_c_1430_n ) capacitor c=0.0218431f \
 //x=1.48 //y=4.875 //x2=2.22 //y2=7.4
cc_381 ( N_noxref_2_c_279_n N_noxref_6_c_1430_n ) capacitor c=0.00182447f \
 //x=7.595 //y=2.57 //x2=2.22 //y2=7.4
cc_382 ( N_noxref_2_c_284_n N_noxref_6_c_1430_n ) capacitor c=0.00820644f \
 //x=1.115 //y=5.38 //x2=2.22 //y2=7.4
cc_383 ( N_noxref_2_c_268_n N_noxref_6_c_1467_n ) capacitor c=9.69738e-19 \
 //x=7.64 //y=4.445 //x2=5.55 //y2=7.4
cc_384 ( N_noxref_2_c_320_p N_noxref_6_c_1468_n ) capacitor c=0.00356451f \
 //x=7.77 //y=4.7 //x2=8.88 //y2=7.4
cc_385 ( N_noxref_2_c_343_p N_noxref_6_c_1468_n ) capacitor c=0.0193101f \
 //x=7.77 //y=4.7 //x2=8.88 //y2=7.4
cc_386 ( N_noxref_2_c_284_n N_noxref_6_c_1470_n ) capacitor c=0.00135089f \
 //x=1.115 //y=5.38 //x2=10.36 //y2=7.4
cc_387 ( N_noxref_2_c_236_n N_noxref_6_M6_noxref_s ) capacitor c=0.0480012f \
 //x=1.115 //y=5.24 //x2=0.54 //y2=5.02
cc_388 ( N_noxref_2_c_284_n N_noxref_6_M6_noxref_s ) capacitor c=0.0920717f \
 //x=1.115 //y=5.38 //x2=0.54 //y2=5.02
cc_389 ( N_noxref_2_c_236_n N_noxref_6_M7_noxref_d ) capacitor c=0.0474638f \
 //x=1.115 //y=5.24 //x2=1.41 //y2=5.02
cc_390 ( N_noxref_2_c_241_n N_noxref_6_M7_noxref_d ) capacitor c=0.021356f \
 //x=1.395 //y=4.96 //x2=1.41 //y2=5.02
cc_391 ( N_noxref_2_c_251_n N_noxref_6_M7_noxref_d ) capacitor c=0.00162903f \
 //x=1.48 //y=2.755 //x2=1.41 //y2=5.02
cc_392 ( N_noxref_2_c_284_n N_noxref_6_M7_noxref_d ) capacitor c=0.0908278f \
 //x=1.115 //y=5.38 //x2=1.41 //y2=5.02
cc_393 ( N_noxref_2_c_236_n N_noxref_7_c_1672_n ) capacitor c=0.00196278f \
 //x=1.115 //y=5.24 //x2=3.015 //y2=5.205
cc_394 ( N_noxref_2_M14_noxref_g N_noxref_8_c_1750_n ) capacitor c=0.00902452f \
 //x=7.44 //y=6.02 //x2=7.98 //y2=6.905
cc_395 ( N_noxref_2_M15_noxref_g N_noxref_8_c_1750_n ) capacitor c=0.00932765f \
 //x=7.88 //y=6.02 //x2=7.98 //y2=6.905
cc_396 ( N_noxref_2_M14_noxref_g N_noxref_8_c_1752_n ) capacitor c=0.00187506f \
 //x=7.44 //y=6.02 //x2=7.22 //y2=5.205
cc_397 ( N_noxref_2_M14_noxref_g N_noxref_8_c_1753_n ) capacitor c=0.00184755f \
 //x=7.44 //y=6.02 //x2=7.22 //y2=6.735
cc_398 ( N_noxref_2_M15_noxref_g N_noxref_8_c_1754_n ) capacitor c=0.00406946f \
 //x=7.88 //y=6.02 //x2=8.1 //y2=6.735
cc_399 ( N_noxref_2_M14_noxref_g N_noxref_8_c_1755_n ) capacitor c=0.0171015f \
 //x=7.44 //y=6.02 //x2=7.22 //y2=5.375
cc_400 ( N_noxref_2_M15_noxref_g N_noxref_8_M15_noxref_d ) capacitor \
 c=0.0365939f //x=7.88 //y=6.02 //x2=7.955 //y2=5.02
cc_401 ( N_noxref_2_c_239_n N_noxref_9_c_1836_n ) capacitor c=0.00498313f \
 //x=1.395 //y=1.84 //x2=3.315 //y2=0
cc_402 ( N_noxref_2_c_251_n N_noxref_9_c_1836_n ) capacitor c=6.43099e-19 \
 //x=1.48 //y=2.755 //x2=3.315 //y2=0
cc_403 ( N_noxref_2_c_269_n N_noxref_9_c_1836_n ) capacitor c=0.00996824f \
 //x=1.11 //y=1.005 //x2=3.315 //y2=0
cc_404 ( N_noxref_2_c_275_n N_noxref_9_c_1836_n ) capacitor c=4.4656e-19 \
 //x=1.48 //y=2.59 //x2=3.315 //y2=0
cc_405 ( N_noxref_2_M0_noxref_d N_noxref_9_c_1836_n ) capacitor c=0.00119583f \
 //x=0.925 //y=0.91 //x2=3.315 //y2=0
cc_406 ( N_noxref_2_c_269_n N_noxref_9_c_1841_n ) capacitor c=0.00548656f \
 //x=1.11 //y=1.005 //x2=3.4 //y2=0.84
cc_407 ( N_noxref_2_c_279_n N_noxref_9_c_1841_n ) capacitor c=0.00339002f \
 //x=7.595 //y=2.57 //x2=3.4 //y2=0.84
cc_408 ( N_noxref_2_c_279_n N_noxref_9_c_1891_n ) capacitor c=0.00403936f \
 //x=7.595 //y=2.57 //x2=6.73 //y2=0.84
cc_409 ( N_noxref_2_c_269_n N_noxref_9_c_1849_n ) capacitor c=0.00124697f \
 //x=1.11 //y=1.005 //x2=1.025 //y2=0.535
cc_410 ( N_noxref_2_c_239_n N_noxref_9_c_1853_n ) capacitor c=0.0030645f \
 //x=1.395 //y=1.84 //x2=1.515 //y2=0.535
cc_411 ( N_noxref_2_c_269_n N_noxref_9_c_1853_n ) capacitor c=0.00130436f \
 //x=1.11 //y=1.005 //x2=1.515 //y2=0.535
cc_412 ( N_noxref_2_c_275_n N_noxref_9_c_1853_n ) capacitor c=4.2833e-19 \
 //x=1.48 //y=2.59 //x2=1.515 //y2=0.535
cc_413 ( N_noxref_2_c_231_n N_noxref_9_c_1855_n ) capacitor c=0.00520602f \
 //x=1.11 //y=1.755 //x2=0.63 //y2=0
cc_414 ( N_noxref_2_c_245_n N_noxref_9_c_1855_n ) capacitor c=2.14154e-19 \
 //x=1.48 //y=2.435 //x2=0.63 //y2=0
cc_415 ( N_noxref_2_c_275_n N_noxref_9_c_1855_n ) capacitor c=0.00313158f \
 //x=1.48 //y=2.59 //x2=0.63 //y2=0
cc_416 ( N_noxref_2_c_239_n N_noxref_9_c_1860_n ) capacitor c=0.0160813f \
 //x=1.395 //y=1.84 //x2=2.22 //y2=0
cc_417 ( N_noxref_2_c_251_n N_noxref_9_c_1860_n ) capacitor c=0.00433472f \
 //x=1.48 //y=2.755 //x2=2.22 //y2=0
cc_418 ( N_noxref_2_c_275_n N_noxref_9_c_1860_n ) capacitor c=0.0101807f \
 //x=1.48 //y=2.59 //x2=2.22 //y2=0
cc_419 ( N_noxref_2_c_279_n N_noxref_9_c_1860_n ) capacitor c=0.0241204f \
 //x=7.595 //y=2.57 //x2=2.22 //y2=0
cc_420 ( N_noxref_2_c_337_p N_noxref_9_c_1903_n ) capacitor c=0.00118906f \
 //x=7.77 //y=2.59 //x2=5.55 //y2=0
cc_421 ( N_noxref_2_c_279_n N_noxref_9_c_1903_n ) capacitor c=0.023659f \
 //x=7.595 //y=2.57 //x2=5.55 //y2=0
cc_422 ( N_noxref_2_c_337_p N_noxref_9_c_1905_n ) capacitor c=0.00499198f \
 //x=7.77 //y=2.59 //x2=8.88 //y2=0
cc_423 ( N_noxref_2_c_325_p N_noxref_9_c_1905_n ) capacitor c=0.00371073f \
 //x=7.77 //y=2.08 //x2=8.88 //y2=0
cc_424 ( N_noxref_2_c_316_p N_noxref_9_c_1905_n ) capacitor c=0.00535915f \
 //x=7.435 //y=1.915 //x2=8.88 //y2=0
cc_425 ( N_noxref_2_c_313_p N_noxref_9_c_1905_n ) capacitor c=0.00230557f \
 //x=7.965 //y=1.25 //x2=8.88 //y2=0
cc_426 ( N_noxref_2_c_269_n N_noxref_9_c_1909_n ) capacitor c=2.8029e-19 \
 //x=1.11 //y=1.005 //x2=10.47 //y2=0
cc_427 ( N_noxref_2_M0_noxref_d N_noxref_9_c_1909_n ) capacitor c=2.70835e-19 \
 //x=0.925 //y=0.91 //x2=10.47 //y2=0
cc_428 ( N_noxref_2_c_231_n N_noxref_9_M0_noxref_s ) capacitor c=0.0339487f \
 //x=1.11 //y=1.755 //x2=0.495 //y2=0.37
cc_429 ( N_noxref_2_c_239_n N_noxref_9_M0_noxref_s ) capacitor c=0.00316664f \
 //x=1.395 //y=1.84 //x2=0.495 //y2=0.37
cc_430 ( N_noxref_2_c_251_n N_noxref_9_M0_noxref_s ) capacitor c=0.00298401f \
 //x=1.48 //y=2.755 //x2=0.495 //y2=0.37
cc_431 ( N_noxref_2_c_269_n N_noxref_9_M0_noxref_s ) capacitor c=0.0157009f \
 //x=1.11 //y=1.005 //x2=0.495 //y2=0.37
cc_432 ( N_noxref_2_c_275_n N_noxref_9_M0_noxref_s ) capacitor c=0.00227181f \
 //x=1.48 //y=2.59 //x2=0.495 //y2=0.37
cc_433 ( N_noxref_2_M0_noxref_d N_noxref_9_M0_noxref_s ) capacitor \
 c=0.0377604f //x=0.925 //y=0.91 //x2=0.495 //y2=0.37
cc_434 ( N_noxref_2_c_279_n N_noxref_10_c_2079_n ) capacitor c=0.00353446f \
 //x=7.595 //y=2.57 //x2=2.915 //y2=1.495
cc_435 ( N_noxref_2_c_279_n N_noxref_10_c_2080_n ) capacitor c=0.0112499f \
 //x=7.595 //y=2.57 //x2=3.8 //y2=1.58
cc_436 ( N_noxref_2_c_279_n N_noxref_10_c_2087_n ) capacitor c=0.00353446f \
 //x=7.595 //y=2.57 //x2=3.885 //y2=1.495
cc_437 ( N_noxref_2_c_279_n N_noxref_10_c_2094_n ) capacitor c=0.00225188f \
 //x=7.595 //y=2.57 //x2=4.77 //y2=0.53
cc_438 ( N_noxref_2_c_279_n N_noxref_11_c_2143_n ) capacitor c=0.00374141f \
 //x=7.595 //y=2.57 //x2=6.245 //y2=1.495
cc_439 ( N_noxref_2_c_279_n N_noxref_11_c_2144_n ) capacitor c=0.0117989f \
 //x=7.595 //y=2.57 //x2=7.13 //y2=1.58
cc_440 ( N_noxref_2_c_279_n N_noxref_11_c_2145_n ) capacitor c=0.00374141f \
 //x=7.595 //y=2.57 //x2=7.215 //y2=1.495
cc_441 ( N_noxref_2_c_315_p N_noxref_11_c_2145_n ) capacitor c=0.00882422f \
 //x=7.435 //y=1.56 //x2=7.215 //y2=1.495
cc_442 ( N_noxref_2_c_299_p N_noxref_11_c_2147_n ) capacitor c=5.02788e-19 \
 //x=7.64 //y=2.735 //x2=8.1 //y2=0.53
cc_443 ( N_noxref_2_c_279_n N_noxref_11_c_2147_n ) capacitor c=0.00148528f \
 //x=7.595 //y=2.57 //x2=8.1 //y2=0.53
cc_444 ( N_noxref_2_c_325_p N_noxref_11_c_2147_n ) capacitor c=4.19248e-19 \
 //x=7.77 //y=2.08 //x2=8.1 //y2=0.53
cc_445 ( N_noxref_2_c_308_p N_noxref_11_c_2147_n ) capacitor c=0.0204192f \
 //x=7.435 //y=0.905 //x2=8.1 //y2=0.53
cc_446 ( N_noxref_2_c_316_p N_noxref_11_c_2147_n ) capacitor c=2.1838e-19 \
 //x=7.435 //y=1.915 //x2=8.1 //y2=0.53
cc_447 ( N_noxref_2_c_312_p N_noxref_11_c_2147_n ) capacitor c=0.00825432f \
 //x=7.965 //y=0.905 //x2=8.1 //y2=0.53
cc_448 ( N_noxref_2_c_308_p N_noxref_11_M3_noxref_s ) capacitor c=0.00882422f \
 //x=7.435 //y=0.905 //x2=6.11 //y2=0.365
cc_449 ( N_noxref_2_c_312_p N_noxref_11_M3_noxref_s ) capacitor c=0.0152167f \
 //x=7.965 //y=0.905 //x2=6.11 //y2=0.365
cc_450 ( N_noxref_2_c_313_p N_noxref_11_M3_noxref_s ) capacitor c=0.00248746f \
 //x=7.965 //y=1.25 //x2=6.11 //y2=0.365
cc_451 ( N_noxref_3_c_522_n N_noxref_4_c_812_n ) capacitor c=0.00241258f \
 //x=4.845 //y=1.65 //x2=4.44 //y2=2.205
cc_452 ( N_noxref_3_c_523_n N_noxref_4_c_812_n ) capacitor c=0.0234589f \
 //x=4.455 //y=1.65 //x2=4.44 //y2=2.205
cc_453 ( N_noxref_3_c_513_n N_noxref_4_c_812_n ) capacitor c=0.0239555f \
 //x=4.93 //y=3.465 //x2=4.44 //y2=2.205
cc_454 ( N_noxref_3_M2_noxref_d N_noxref_4_c_812_n ) capacitor c=4.63726e-19 \
 //x=4.18 //y=0.905 //x2=4.44 //y2=2.205
cc_455 ( N_noxref_3_c_513_n N_noxref_4_c_815_n ) capacitor c=0.0408178f \
 //x=4.93 //y=3.465 //x2=4.44 //y2=2.845
cc_456 ( N_noxref_3_c_559_n N_noxref_4_c_866_n ) capacitor c=0.00416973f \
 //x=8.14 //y=3.555 //x2=9.62 //y2=3.11
cc_457 ( N_noxref_3_c_559_n N_noxref_4_c_839_n ) capacitor c=0.0067674f \
 //x=8.14 //y=3.555 //x2=9.62 //y2=4.325
cc_458 ( N_noxref_3_c_567_n N_noxref_4_c_839_n ) capacitor c=0.00668443f \
 //x=8.14 //y=3.935 //x2=9.62 //y2=4.325
cc_459 ( N_noxref_3_c_570_n N_noxref_4_c_839_n ) capacitor c=0.0050433f \
 //x=8.14 //y=5.12 //x2=9.62 //y2=4.325
cc_460 ( N_noxref_3_c_579_n N_noxref_4_c_839_n ) capacitor c=2.63678e-19 \
 //x=8.14 //y=3.7 //x2=9.62 //y2=4.325
cc_461 ( N_noxref_3_c_580_n N_noxref_4_c_839_n ) capacitor c=0.00500598f \
 //x=8.185 //y=3.745 //x2=9.62 //y2=4.325
cc_462 ( N_noxref_3_c_570_n N_noxref_4_c_840_n ) capacitor c=0.00637317f \
 //x=8.14 //y=5.12 //x2=9.62 //y2=4.735
cc_463 ( N_noxref_3_c_570_n N_noxref_4_c_873_n ) capacitor c=0.00653269f \
 //x=8.14 //y=5.12 //x2=9.62 //y2=4.875
cc_464 ( N_noxref_3_c_559_n N_noxref_4_c_874_n ) capacitor c=0.0208241f \
 //x=8.14 //y=3.555 //x2=9.705 //y2=1.84
cc_465 ( N_noxref_3_c_570_n N_noxref_4_c_875_n ) capacitor c=0.00270091f \
 //x=8.14 //y=5.12 //x2=9.985 //y2=5.24
cc_466 ( N_noxref_3_c_574_n N_noxref_4_c_875_n ) capacitor c=5.24591e-19 \
 //x=7.66 //y=5.205 //x2=9.985 //y2=5.24
cc_467 ( N_noxref_3_c_540_n N_noxref_4_c_877_n ) capacitor c=0.00459956f \
 //x=7.7 //y=1.565 //x2=9.99 //y2=1.755
cc_468 ( N_noxref_3_c_548_n N_noxref_4_c_877_n ) capacitor c=0.00337985f \
 //x=8.055 //y=1.65 //x2=9.99 //y2=1.755
cc_469 ( N_noxref_3_c_522_n N_noxref_4_c_817_n ) capacitor c=0.00237006f \
 //x=4.845 //y=1.65 //x2=4.44 //y2=2.96
cc_470 ( N_noxref_3_c_523_n N_noxref_4_c_817_n ) capacitor c=8.19809e-19 \
 //x=4.455 //y=1.65 //x2=4.44 //y2=2.96
cc_471 ( N_noxref_3_c_513_n N_noxref_4_c_817_n ) capacitor c=0.0350575f \
 //x=4.93 //y=3.465 //x2=4.44 //y2=2.96
cc_472 ( N_noxref_3_c_514_n N_noxref_4_c_817_n ) capacitor c=0.00209369f \
 //x=4.93 //y=3.815 //x2=4.44 //y2=2.96
cc_473 ( N_noxref_3_c_518_n N_noxref_4_c_817_n ) capacitor c=4.58007e-19 \
 //x=4.975 //y=3.655 //x2=4.44 //y2=2.96
cc_474 ( N_noxref_3_c_515_n N_noxref_4_c_842_n ) capacitor c=0.00574532f \
 //x=4.93 //y=5.12 //x2=6.66 //y2=4.44
cc_475 ( N_noxref_3_c_570_n N_noxref_4_c_842_n ) capacitor c=5.23264e-19 \
 //x=8.14 //y=5.12 //x2=6.66 //y2=4.44
cc_476 ( N_noxref_3_c_559_n N_noxref_4_c_886_n ) capacitor c=3.33906e-19 \
 //x=8.14 //y=3.555 //x2=9.62 //y2=2.96
cc_477 ( N_noxref_3_c_532_n N_noxref_4_c_887_n ) capacitor c=0.00594237f \
 //x=7.7 //y=1.12 //x2=9.99 //y2=1.005
cc_478 ( N_noxref_3_c_540_n N_noxref_4_c_887_n ) capacitor c=6.23317e-19 \
 //x=7.7 //y=1.565 //x2=9.99 //y2=1.005
cc_479 ( N_noxref_3_c_545_n N_noxref_4_c_844_n ) capacitor c=0.00477221f \
 //x=8.055 //y=5.205 //x2=9.46 //y2=4.497
cc_480 ( N_noxref_3_c_570_n N_noxref_4_c_844_n ) capacitor c=0.0243353f \
 //x=8.14 //y=5.12 //x2=9.46 //y2=4.497
cc_481 ( N_noxref_3_c_574_n N_noxref_4_c_844_n ) capacitor c=5.20373e-19 \
 //x=7.66 //y=5.205 //x2=9.46 //y2=4.497
cc_482 ( N_noxref_3_c_581_n N_noxref_4_c_844_n ) capacitor c=0.0083515f \
 //x=7.995 //y=3.745 //x2=9.46 //y2=4.497
cc_483 ( N_noxref_3_c_513_n N_noxref_4_c_818_n ) capacitor c=0.00497477f \
 //x=4.93 //y=3.465 //x2=4.585 //y2=3.005
cc_484 ( N_noxref_3_c_515_n N_noxref_4_c_846_n ) capacitor c=0.00354512f \
 //x=4.93 //y=5.12 //x2=6.645 //y2=4.497
cc_485 ( N_noxref_3_c_570_n N_noxref_4_c_895_n ) capacitor c=0.00198563f \
 //x=8.14 //y=5.12 //x2=9.62 //y2=4.497
cc_486 ( N_noxref_3_c_559_n N_noxref_4_c_896_n ) capacitor c=0.00194025f \
 //x=8.14 //y=3.555 //x2=9.63 //y2=2.945
cc_487 ( N_noxref_3_c_513_n N_noxref_4_c_847_n ) capacitor c=0.0220543f \
 //x=4.93 //y=3.465 //x2=9.47 //y2=2.945
cc_488 ( N_noxref_3_c_514_n N_noxref_4_c_847_n ) capacitor c=0.00541814f \
 //x=4.93 //y=3.815 //x2=9.47 //y2=2.945
cc_489 ( N_noxref_3_c_548_n N_noxref_4_c_847_n ) capacitor c=0.00271448f \
 //x=8.055 //y=1.65 //x2=9.47 //y2=2.945
cc_490 ( N_noxref_3_c_559_n N_noxref_4_c_847_n ) capacitor c=0.0269697f \
 //x=8.14 //y=3.555 //x2=9.47 //y2=2.945
cc_491 ( N_noxref_3_c_518_n N_noxref_4_c_847_n ) capacitor c=0.0169345f \
 //x=4.975 //y=3.655 //x2=9.47 //y2=2.945
cc_492 ( N_noxref_3_c_581_n N_noxref_4_c_847_n ) capacitor c=0.0755129f \
 //x=7.995 //y=3.745 //x2=9.47 //y2=2.945
cc_493 ( N_noxref_3_c_522_n N_noxref_4_c_819_n ) capacitor c=0.00147657f \
 //x=4.845 //y=1.65 //x2=4.44 //y2=2.08
cc_494 ( N_noxref_3_c_523_n N_noxref_4_c_819_n ) capacitor c=0.00408612f \
 //x=4.455 //y=1.65 //x2=4.44 //y2=2.08
cc_495 ( N_noxref_3_c_513_n N_noxref_4_c_819_n ) capacitor c=0.00208077f \
 //x=4.93 //y=3.465 //x2=4.44 //y2=2.08
cc_496 ( N_noxref_3_M2_noxref_d N_noxref_4_c_819_n ) capacitor c=0.00152066f \
 //x=4.18 //y=0.905 //x2=4.44 //y2=2.08
cc_497 ( N_noxref_3_c_570_n N_noxref_4_c_852_n ) capacitor c=2.5871e-19 \
 //x=8.14 //y=5.12 //x2=6.66 //y2=4.44
cc_498 ( N_noxref_3_c_519_n N_noxref_4_c_822_n ) capacitor c=4.12337e-19 \
 //x=4.37 //y=1.115 //x2=4.105 //y2=0.905
cc_499 ( N_noxref_3_M2_noxref_d N_noxref_4_c_822_n ) capacitor c=0.00209865f \
 //x=4.18 //y=0.905 //x2=4.105 //y2=0.905
cc_500 ( N_noxref_3_c_519_n N_noxref_4_c_825_n ) capacitor c=0.00203341f \
 //x=4.37 //y=1.115 //x2=4.105 //y2=1.25
cc_501 ( N_noxref_3_c_520_n N_noxref_4_c_825_n ) capacitor c=0.00118531f \
 //x=4.37 //y=1.565 //x2=4.105 //y2=1.25
cc_502 ( N_noxref_3_M2_noxref_d N_noxref_4_c_825_n ) capacitor c=0.00237422f \
 //x=4.18 //y=0.905 //x2=4.105 //y2=1.25
cc_503 ( N_noxref_3_c_520_n N_noxref_4_c_827_n ) capacitor c=0.00409175f \
 //x=4.37 //y=1.565 //x2=4.105 //y2=1.56
cc_504 ( N_noxref_3_c_520_n N_noxref_4_c_830_n ) capacitor c=0.00341876f \
 //x=4.37 //y=1.565 //x2=4.105 //y2=1.915
cc_505 ( N_noxref_3_c_523_n N_noxref_4_c_830_n ) capacitor c=0.00212262f \
 //x=4.455 //y=1.65 //x2=4.105 //y2=1.915
cc_506 ( N_noxref_3_c_513_n N_noxref_4_c_830_n ) capacitor c=0.0080874f \
 //x=4.93 //y=3.465 //x2=4.105 //y2=1.915
cc_507 ( N_noxref_3_M2_noxref_d N_noxref_4_c_830_n ) capacitor c=4.64713e-19 \
 //x=4.18 //y=0.905 //x2=4.105 //y2=1.915
cc_508 ( N_noxref_3_c_519_n N_noxref_4_c_918_n ) capacitor c=5.26869e-19 \
 //x=4.37 //y=1.115 //x2=4.48 //y2=0.75
cc_509 ( N_noxref_3_M2_noxref_d N_noxref_4_c_918_n ) capacitor c=0.00213893f \
 //x=4.18 //y=0.905 //x2=4.48 //y2=0.75
cc_510 ( N_noxref_3_c_519_n N_noxref_4_c_920_n ) capacitor c=4.90979e-19 \
 //x=4.37 //y=1.115 //x2=4.48 //y2=1.405
cc_511 ( N_noxref_3_c_520_n N_noxref_4_c_920_n ) capacitor c=0.00761559f \
 //x=4.37 //y=1.565 //x2=4.48 //y2=1.405
cc_512 ( N_noxref_3_c_522_n N_noxref_4_c_920_n ) capacitor c=0.00124531f \
 //x=4.845 //y=1.65 //x2=4.48 //y2=1.405
cc_513 ( N_noxref_3_M2_noxref_d N_noxref_4_c_920_n ) capacitor c=0.00345426f \
 //x=4.18 //y=0.905 //x2=4.48 //y2=1.405
cc_514 ( N_noxref_3_c_519_n N_noxref_4_c_833_n ) capacitor c=4.45278e-19 \
 //x=4.37 //y=1.115 //x2=4.635 //y2=0.905
cc_515 ( N_noxref_3_M2_noxref_d N_noxref_4_c_833_n ) capacitor c=0.00124544f \
 //x=4.18 //y=0.905 //x2=4.635 //y2=0.905
cc_516 ( N_noxref_3_c_519_n N_noxref_4_c_834_n ) capacitor c=0.00307857f \
 //x=4.37 //y=1.115 //x2=4.635 //y2=1.25
cc_517 ( N_noxref_3_c_520_n N_noxref_4_c_834_n ) capacitor c=0.003249f \
 //x=4.37 //y=1.565 //x2=4.635 //y2=1.25
cc_518 ( N_noxref_3_c_522_n N_noxref_4_c_834_n ) capacitor c=0.00300259f \
 //x=4.845 //y=1.65 //x2=4.635 //y2=1.25
cc_519 ( N_noxref_3_M2_noxref_d N_noxref_4_c_834_n ) capacitor c=0.00237422f \
 //x=4.18 //y=0.905 //x2=4.635 //y2=1.25
cc_520 ( N_noxref_3_c_666_p N_noxref_5_c_1110_n ) capacitor c=0.00261073f \
 //x=4.845 //y=5.205 //x2=4.44 //y2=4.31
cc_521 ( N_noxref_3_c_514_n N_noxref_5_c_1110_n ) capacitor c=0.00427316f \
 //x=4.93 //y=3.815 //x2=4.44 //y2=4.31
cc_522 ( N_noxref_3_c_515_n N_noxref_5_c_1110_n ) capacitor c=0.0352681f \
 //x=4.93 //y=5.12 //x2=4.44 //y2=4.31
cc_523 ( N_noxref_3_c_573_n N_noxref_5_c_1110_n ) capacitor c=0.00200698f \
 //x=4.33 //y=5.205 //x2=4.44 //y2=4.31
cc_524 ( N_noxref_3_c_518_n N_noxref_5_c_1110_n ) capacitor c=6.19174e-19 \
 //x=4.975 //y=3.655 //x2=4.44 //y2=4.31
cc_525 ( N_noxref_3_c_671_p N_noxref_5_c_1110_n ) capacitor c=6.31328e-19 \
 //x=4.33 //y=5.375 //x2=4.44 //y2=4.31
cc_526 ( N_noxref_3_c_666_p N_noxref_5_c_1114_n ) capacitor c=0.00213356f \
 //x=4.845 //y=5.205 //x2=4.44 //y2=4.58
cc_527 ( N_noxref_3_c_515_n N_noxref_5_c_1114_n ) capacitor c=0.0407681f \
 //x=4.93 //y=5.12 //x2=4.44 //y2=4.58
cc_528 ( N_noxref_3_c_573_n N_noxref_5_c_1114_n ) capacitor c=0.0199113f \
 //x=4.33 //y=5.205 //x2=4.44 //y2=4.58
cc_529 ( N_noxref_3_c_671_p N_noxref_5_c_1114_n ) capacitor c=0.00134103f \
 //x=4.33 //y=5.375 //x2=4.44 //y2=4.58
cc_530 ( N_noxref_3_c_513_n N_noxref_5_c_1133_n ) capacitor c=0.00513041f \
 //x=4.93 //y=3.465 //x2=6.66 //y2=2.205
cc_531 ( N_noxref_3_c_559_n N_noxref_5_c_1133_n ) capacitor c=4.5875e-19 \
 //x=8.14 //y=3.555 //x2=6.66 //y2=2.205
cc_532 ( N_noxref_3_c_513_n N_noxref_5_c_1137_n ) capacitor c=0.012683f \
 //x=4.93 //y=3.465 //x2=6.66 //y2=3.18
cc_533 ( N_noxref_3_c_559_n N_noxref_5_c_1137_n ) capacitor c=0.00389145f \
 //x=8.14 //y=3.555 //x2=6.66 //y2=3.18
cc_534 ( N_noxref_3_c_559_n N_noxref_5_c_1179_n ) capacitor c=0.00297528f \
 //x=8.14 //y=3.555 //x2=10.36 //y2=3.215
cc_535 ( N_noxref_3_c_570_n N_noxref_5_c_1180_n ) capacitor c=4.66514e-19 \
 //x=8.14 //y=5.12 //x2=10.36 //y2=4.58
cc_536 ( N_noxref_3_c_515_n N_noxref_5_c_1117_n ) capacitor c=0.00685003f \
 //x=4.93 //y=5.12 //x2=4.42 //y2=4.15
cc_537 ( N_noxref_3_c_513_n N_noxref_5_c_1142_n ) capacitor c=0.00394835f \
 //x=4.93 //y=3.465 //x2=6.66 //y2=3.33
cc_538 ( N_noxref_3_c_581_n N_noxref_5_c_1142_n ) capacitor c=0.00495379f \
 //x=7.995 //y=3.745 //x2=6.66 //y2=3.33
cc_539 ( N_noxref_3_c_666_p N_noxref_5_c_1143_n ) capacitor c=0.00511972f \
 //x=4.845 //y=5.205 //x2=7.715 //y2=4.07
cc_540 ( N_noxref_3_c_514_n N_noxref_5_c_1143_n ) capacitor c=0.00673958f \
 //x=4.93 //y=3.815 //x2=7.715 //y2=4.07
cc_541 ( N_noxref_3_c_515_n N_noxref_5_c_1143_n ) capacitor c=0.0268007f \
 //x=4.93 //y=5.12 //x2=7.715 //y2=4.07
cc_542 ( N_noxref_3_c_570_n N_noxref_5_c_1143_n ) capacitor c=0.00167703f \
 //x=8.14 //y=5.12 //x2=7.715 //y2=4.07
cc_543 ( N_noxref_3_c_517_n N_noxref_5_c_1143_n ) capacitor c=0.00148331f \
 //x=4.81 //y=3.7 //x2=7.715 //y2=4.07
cc_544 ( N_noxref_3_c_518_n N_noxref_5_c_1143_n ) capacitor c=0.0337385f \
 //x=4.975 //y=3.655 //x2=7.715 //y2=4.07
cc_545 ( N_noxref_3_c_581_n N_noxref_5_c_1143_n ) capacitor c=0.271601f \
 //x=7.995 //y=3.745 //x2=7.715 //y2=4.07
cc_546 ( N_noxref_3_c_567_n N_noxref_5_c_1191_n ) capacitor c=0.00788654f \
 //x=8.14 //y=3.935 //x2=8.515 //y2=4.16
cc_547 ( N_noxref_3_c_570_n N_noxref_5_c_1191_n ) capacitor c=0.0192042f \
 //x=8.14 //y=5.12 //x2=8.515 //y2=4.16
cc_548 ( N_noxref_3_c_580_n N_noxref_5_c_1191_n ) capacitor c=0.0416028f \
 //x=8.185 //y=3.745 //x2=8.515 //y2=4.16
cc_549 ( N_noxref_3_c_581_n N_noxref_5_c_1191_n ) capacitor c=0.0100949f \
 //x=7.995 //y=3.745 //x2=8.515 //y2=4.16
cc_550 ( N_noxref_3_c_666_p N_noxref_5_c_1120_n ) capacitor c=5.8188e-19 \
 //x=4.845 //y=5.205 //x2=4.42 //y2=4.07
cc_551 ( N_noxref_3_c_515_n N_noxref_5_c_1120_n ) capacitor c=0.0045505f \
 //x=4.93 //y=5.12 //x2=4.42 //y2=4.07
cc_552 ( N_noxref_3_c_573_n N_noxref_5_c_1120_n ) capacitor c=0.00110921f \
 //x=4.33 //y=5.205 //x2=4.42 //y2=4.07
cc_553 ( N_noxref_3_c_513_n N_noxref_5_c_1145_n ) capacitor c=0.00352878f \
 //x=4.93 //y=3.465 //x2=6.825 //y2=3.34
cc_554 ( N_noxref_3_c_581_n N_noxref_5_c_1145_n ) capacitor c=0.0355767f \
 //x=7.995 //y=3.745 //x2=6.825 //y2=3.34
cc_555 ( N_noxref_3_c_570_n N_noxref_5_c_1200_n ) capacitor c=0.00233696f \
 //x=8.14 //y=5.12 //x2=8.602 //y2=4.07
cc_556 ( N_noxref_3_c_580_n N_noxref_5_c_1201_n ) capacitor c=3.78661e-19 \
 //x=8.185 //y=3.745 //x2=10.435 //y2=3.405
cc_557 ( N_noxref_3_c_559_n N_noxref_5_c_1146_n ) capacitor c=0.0208051f \
 //x=8.14 //y=3.555 //x2=10.245 //y2=3.405
cc_558 ( N_noxref_3_c_567_n N_noxref_5_c_1146_n ) capacitor c=0.0101082f \
 //x=8.14 //y=3.935 //x2=10.245 //y2=3.405
cc_559 ( N_noxref_3_c_580_n N_noxref_5_c_1146_n ) capacitor c=0.0416028f \
 //x=8.185 //y=3.745 //x2=10.245 //y2=3.405
cc_560 ( N_noxref_3_c_581_n N_noxref_5_c_1146_n ) capacitor c=0.0929227f \
 //x=7.995 //y=3.745 //x2=10.245 //y2=3.405
cc_561 ( N_noxref_3_c_666_p N_noxref_5_c_1123_n ) capacitor c=0.00104675f \
 //x=4.845 //y=5.205 //x2=4.44 //y2=4.7
cc_562 ( N_noxref_3_c_515_n N_noxref_5_c_1123_n ) capacitor c=0.00448211f \
 //x=4.93 //y=5.12 //x2=4.44 //y2=4.7
cc_563 ( N_noxref_3_c_573_n N_noxref_5_c_1123_n ) capacitor c=0.00390431f \
 //x=4.33 //y=5.205 //x2=4.44 //y2=4.7
cc_564 ( N_noxref_3_c_671_p N_noxref_5_c_1123_n ) capacitor c=0.00341371f \
 //x=4.33 //y=5.375 //x2=4.44 //y2=4.7
cc_565 ( N_noxref_3_c_559_n N_noxref_5_c_1148_n ) capacitor c=2.0676e-19 \
 //x=8.14 //y=3.555 //x2=6.66 //y2=2.08
cc_566 ( N_noxref_3_c_573_n N_noxref_5_M10_noxref_g ) capacitor c=0.00182501f \
 //x=4.33 //y=5.205 //x2=4.11 //y2=6.02
cc_567 ( N_noxref_3_c_671_p N_noxref_5_M10_noxref_g ) capacitor c=0.0120591f \
 //x=4.33 //y=5.375 //x2=4.11 //y2=6.02
cc_568 ( N_noxref_3_c_666_p N_noxref_5_M11_noxref_g ) capacitor c=0.00993231f \
 //x=4.845 //y=5.205 //x2=4.55 //y2=6.02
cc_569 ( N_noxref_3_c_573_n N_noxref_5_M11_noxref_g ) capacitor c=0.00284403f \
 //x=4.33 //y=5.205 //x2=4.55 //y2=6.02
cc_570 ( N_noxref_3_c_671_p N_noxref_5_M11_noxref_g ) capacitor c=0.0140704f \
 //x=4.33 //y=5.375 //x2=4.55 //y2=6.02
cc_571 ( N_noxref_3_c_515_n N_noxref_5_c_1129_n ) capacitor c=0.0103069f \
 //x=4.93 //y=5.12 //x2=4.44 //y2=4.7
cc_572 ( N_noxref_3_c_573_n N_noxref_5_c_1129_n ) capacitor c=0.0020575f \
 //x=4.33 //y=5.205 //x2=4.44 //y2=4.7
cc_573 ( N_noxref_3_c_671_p N_noxref_5_c_1129_n ) capacitor c=0.00438277f \
 //x=4.33 //y=5.375 //x2=4.44 //y2=4.7
cc_574 ( N_noxref_3_c_666_p N_noxref_6_c_1477_n ) capacitor c=0.00189437f \
 //x=4.845 //y=5.205 //x2=6.695 //y2=7.4
cc_575 ( N_noxref_3_c_545_n N_noxref_6_c_1478_n ) capacitor c=2.24038e-19 \
 //x=8.055 //y=5.205 //x2=10.36 //y2=7.4
cc_576 ( N_noxref_3_c_567_n N_noxref_6_c_1478_n ) capacitor c=4.03095e-19 \
 //x=8.14 //y=3.935 //x2=10.36 //y2=7.4
cc_577 ( N_noxref_3_c_666_p N_noxref_6_c_1422_n ) capacitor c=9.34952e-19 \
 //x=4.845 //y=5.205 //x2=5.38 //y2=7.4
cc_578 ( N_noxref_3_c_671_p N_noxref_6_c_1422_n ) capacitor c=0.00508598f \
 //x=4.33 //y=5.375 //x2=5.38 //y2=7.4
cc_579 ( N_noxref_3_c_567_n N_noxref_6_c_1458_n ) capacitor c=2.94729e-19 \
 //x=8.14 //y=3.935 //x2=8.71 //y2=7.4
cc_580 ( N_noxref_3_c_583_n N_noxref_6_c_1458_n ) capacitor c=0.00484213f \
 //x=7.66 //y=5.375 //x2=8.71 //y2=7.4
cc_581 ( N_noxref_3_c_515_n N_noxref_6_c_1430_n ) capacitor c=0.00127957f \
 //x=4.93 //y=5.12 //x2=2.22 //y2=7.4
cc_582 ( N_noxref_3_c_515_n N_noxref_6_c_1467_n ) capacitor c=0.03407f \
 //x=4.93 //y=5.12 //x2=5.55 //y2=7.4
cc_583 ( N_noxref_3_c_570_n N_noxref_6_c_1467_n ) capacitor c=0.00124531f \
 //x=8.14 //y=5.12 //x2=5.55 //y2=7.4
cc_584 ( N_noxref_3_c_573_n N_noxref_6_c_1467_n ) capacitor c=0.00270997f \
 //x=4.33 //y=5.205 //x2=5.55 //y2=7.4
cc_585 ( N_noxref_3_c_671_p N_noxref_6_c_1467_n ) capacitor c=0.00917967f \
 //x=4.33 //y=5.375 //x2=5.55 //y2=7.4
cc_586 ( N_noxref_3_c_570_n N_noxref_6_c_1468_n ) capacitor c=0.024753f \
 //x=8.14 //y=5.12 //x2=8.88 //y2=7.4
cc_587 ( N_noxref_3_c_574_n N_noxref_6_c_1468_n ) capacitor c=0.00267424f \
 //x=7.66 //y=5.205 //x2=8.88 //y2=7.4
cc_588 ( N_noxref_3_c_583_n N_noxref_6_c_1468_n ) capacitor c=0.00920296f \
 //x=7.66 //y=5.375 //x2=8.88 //y2=7.4
cc_589 ( N_noxref_3_c_671_p N_noxref_6_c_1470_n ) capacitor c=2.29347e-19 \
 //x=4.33 //y=5.375 //x2=10.36 //y2=7.4
cc_590 ( N_noxref_3_c_583_n N_noxref_6_c_1470_n ) capacitor c=2.29347e-19 \
 //x=7.66 //y=5.375 //x2=10.36 //y2=7.4
cc_591 ( N_noxref_3_c_573_n N_noxref_6_M7_noxref_d ) capacitor c=2.46201e-19 \
 //x=4.33 //y=5.205 //x2=1.41 //y2=5.02
cc_592 ( N_noxref_3_c_671_p N_noxref_6_M8_noxref_d ) capacitor c=0.00464126f \
 //x=4.33 //y=5.375 //x2=3.305 //y2=5.02
cc_593 ( N_noxref_3_c_583_n N_noxref_6_M12_noxref_d ) capacitor c=0.00464102f \
 //x=7.66 //y=5.375 //x2=6.635 //y2=5.02
cc_594 ( N_noxref_3_c_545_n N_noxref_6_M16_noxref_s ) capacitor c=0.00326151f \
 //x=8.055 //y=5.205 //x2=9.42 //y2=5.02
cc_595 ( N_noxref_3_c_574_n N_noxref_6_M16_noxref_s ) capacitor c=0.00581388f \
 //x=7.66 //y=5.205 //x2=9.42 //y2=5.02
cc_596 ( N_noxref_3_c_666_p N_noxref_7_c_1682_n ) capacitor c=0.00314935f \
 //x=4.845 //y=5.205 //x2=4.65 //y2=6.905
cc_597 ( N_noxref_3_c_573_n N_noxref_7_c_1682_n ) capacitor c=0.00483895f \
 //x=4.33 //y=5.205 //x2=4.65 //y2=6.905
cc_598 ( N_noxref_3_c_671_p N_noxref_7_c_1682_n ) capacitor c=0.00407104f \
 //x=4.33 //y=5.375 //x2=4.65 //y2=6.905
cc_599 ( N_noxref_3_c_573_n N_noxref_7_c_1672_n ) capacitor c=6.31772e-19 \
 //x=4.33 //y=5.205 //x2=3.015 //y2=5.205
cc_600 ( N_noxref_3_c_573_n N_noxref_7_c_1675_n ) capacitor c=0.0508622f \
 //x=4.33 //y=5.205 //x2=3.892 //y2=5.205
cc_601 ( N_noxref_3_c_671_p N_noxref_7_c_1675_n ) capacitor c=0.00265537f \
 //x=4.33 //y=5.375 //x2=3.892 //y2=5.205
cc_602 ( N_noxref_3_c_666_p N_noxref_7_c_1688_n ) capacitor c=0.00509624f \
 //x=4.845 //y=5.205 //x2=4.77 //y2=6.735
cc_603 ( N_noxref_3_c_573_n N_noxref_7_c_1679_n ) capacitor c=0.00256534f \
 //x=4.33 //y=5.205 //x2=3.89 //y2=5.375
cc_604 ( N_noxref_3_c_671_p N_noxref_7_c_1679_n ) capacitor c=0.0673888f \
 //x=4.33 //y=5.375 //x2=3.89 //y2=5.375
cc_605 ( N_noxref_3_c_666_p N_noxref_7_M11_noxref_d ) capacitor c=0.00596205f \
 //x=4.845 //y=5.205 //x2=4.625 //y2=5.02
cc_606 ( N_noxref_3_c_517_n N_noxref_7_M11_noxref_d ) capacitor c=0.00225613f \
 //x=4.81 //y=3.7 //x2=4.625 //y2=5.02
cc_607 ( N_noxref_3_c_671_p N_noxref_7_M11_noxref_d ) capacitor c=0.0471918f \
 //x=4.33 //y=5.375 //x2=4.625 //y2=5.02
cc_608 ( N_noxref_3_c_545_n N_noxref_8_c_1750_n ) capacitor c=0.00305745f \
 //x=8.055 //y=5.205 //x2=7.98 //y2=6.905
cc_609 ( N_noxref_3_c_574_n N_noxref_8_c_1750_n ) capacitor c=0.00506747f \
 //x=7.66 //y=5.205 //x2=7.98 //y2=6.905
cc_610 ( N_noxref_3_c_583_n N_noxref_8_c_1750_n ) capacitor c=0.00407104f \
 //x=7.66 //y=5.375 //x2=7.98 //y2=6.905
cc_611 ( N_noxref_3_c_666_p N_noxref_8_c_1760_n ) capacitor c=0.00525273f \
 //x=4.845 //y=5.205 //x2=6.34 //y2=5.205
cc_612 ( N_noxref_3_c_573_n N_noxref_8_c_1760_n ) capacitor c=0.00499619f \
 //x=4.33 //y=5.205 //x2=6.34 //y2=5.205
cc_613 ( N_noxref_3_c_574_n N_noxref_8_c_1760_n ) capacitor c=6.57436e-19 \
 //x=7.66 //y=5.205 //x2=6.34 //y2=5.205
cc_614 ( N_noxref_3_c_574_n N_noxref_8_c_1752_n ) capacitor c=0.0519034f \
 //x=7.66 //y=5.205 //x2=7.22 //y2=5.205
cc_615 ( N_noxref_3_c_583_n N_noxref_8_c_1752_n ) capacitor c=0.00247636f \
 //x=7.66 //y=5.375 //x2=7.22 //y2=5.205
cc_616 ( N_noxref_3_c_545_n N_noxref_8_c_1754_n ) capacitor c=0.00502035f \
 //x=8.055 //y=5.205 //x2=8.1 //y2=6.735
cc_617 ( N_noxref_3_c_574_n N_noxref_8_c_1755_n ) capacitor c=0.0025396f \
 //x=7.66 //y=5.205 //x2=7.22 //y2=5.375
cc_618 ( N_noxref_3_c_583_n N_noxref_8_c_1755_n ) capacitor c=0.0673446f \
 //x=7.66 //y=5.375 //x2=7.22 //y2=5.375
cc_619 ( N_noxref_3_c_545_n N_noxref_8_M15_noxref_d ) capacitor c=0.00776857f \
 //x=8.055 //y=5.205 //x2=7.955 //y2=5.02
cc_620 ( N_noxref_3_c_579_n N_noxref_8_M15_noxref_d ) capacitor c=0.0012136f \
 //x=8.14 //y=3.7 //x2=7.955 //y2=5.02
cc_621 ( N_noxref_3_c_583_n N_noxref_8_M15_noxref_d ) capacitor c=0.0473254f \
 //x=7.66 //y=5.375 //x2=7.955 //y2=5.02
cc_622 ( N_noxref_3_c_519_n N_noxref_9_c_1841_n ) capacitor c=0.0155245f \
 //x=4.37 //y=1.115 //x2=3.4 //y2=0.84
cc_623 ( N_noxref_3_M2_noxref_d N_noxref_9_c_1841_n ) capacitor c=5.48773e-19 \
 //x=4.18 //y=0.905 //x2=3.4 //y2=0.84
cc_624 ( N_noxref_3_c_519_n N_noxref_9_c_1919_n ) capacitor c=0.0094658f \
 //x=4.37 //y=1.115 //x2=6.645 //y2=0
cc_625 ( N_noxref_3_c_522_n N_noxref_9_c_1919_n ) capacitor c=0.00845832f \
 //x=4.845 //y=1.65 //x2=6.645 //y2=0
cc_626 ( N_noxref_3_c_514_n N_noxref_9_c_1919_n ) capacitor c=3.89661e-19 \
 //x=4.93 //y=3.815 //x2=6.645 //y2=0
cc_627 ( N_noxref_3_M2_noxref_d N_noxref_9_c_1919_n ) capacitor c=3.01654e-19 \
 //x=4.18 //y=0.905 //x2=6.645 //y2=0
cc_628 ( N_noxref_3_c_519_n N_noxref_9_c_1891_n ) capacitor c=0.00587017f \
 //x=4.37 //y=1.115 //x2=6.73 //y2=0.84
cc_629 ( N_noxref_3_c_532_n N_noxref_9_c_1891_n ) capacitor c=0.016074f \
 //x=7.7 //y=1.12 //x2=6.73 //y2=0.84
cc_630 ( N_noxref_3_M4_noxref_d N_noxref_9_c_1891_n ) capacitor c=5.55977e-19 \
 //x=7.51 //y=0.905 //x2=6.73 //y2=0.84
cc_631 ( N_noxref_3_c_532_n N_noxref_9_c_1926_n ) capacitor c=0.00966122f \
 //x=7.7 //y=1.12 //x2=10.36 //y2=0
cc_632 ( N_noxref_3_c_548_n N_noxref_9_c_1926_n ) capacitor c=0.00655891f \
 //x=8.055 //y=1.65 //x2=10.36 //y2=0
cc_633 ( N_noxref_3_c_567_n N_noxref_9_c_1926_n ) capacitor c=3.78562e-19 \
 //x=8.14 //y=3.935 //x2=10.36 //y2=0
cc_634 ( N_noxref_3_M4_noxref_d N_noxref_9_c_1926_n ) capacitor c=3.01654e-19 \
 //x=7.51 //y=0.905 //x2=10.36 //y2=0
cc_635 ( N_noxref_3_c_522_n N_noxref_9_c_1854_n ) capacitor c=0.00137386f \
 //x=4.845 //y=1.65 //x2=5.38 //y2=0
cc_636 ( N_noxref_3_c_548_n N_noxref_9_c_1931_n ) capacitor c=7.80693e-19 \
 //x=8.055 //y=1.65 //x2=8.71 //y2=0
cc_637 ( N_noxref_3_c_513_n N_noxref_9_c_1860_n ) capacitor c=8.42561e-19 \
 //x=4.93 //y=3.465 //x2=2.22 //y2=0
cc_638 ( N_noxref_3_c_520_n N_noxref_9_c_1903_n ) capacitor c=0.00289817f \
 //x=4.37 //y=1.565 //x2=5.55 //y2=0
cc_639 ( N_noxref_3_c_522_n N_noxref_9_c_1903_n ) capacitor c=0.0327177f \
 //x=4.845 //y=1.65 //x2=5.55 //y2=0
cc_640 ( N_noxref_3_c_559_n N_noxref_9_c_1903_n ) capacitor c=8.23221e-19 \
 //x=8.14 //y=3.555 //x2=5.55 //y2=0
cc_641 ( N_noxref_3_c_540_n N_noxref_9_c_1905_n ) capacitor c=0.00262965f \
 //x=7.7 //y=1.565 //x2=8.88 //y2=0
cc_642 ( N_noxref_3_c_548_n N_noxref_9_c_1905_n ) capacitor c=0.0238079f \
 //x=8.055 //y=1.65 //x2=8.88 //y2=0
cc_643 ( N_noxref_3_c_519_n N_noxref_9_c_1909_n ) capacitor c=3.01891e-19 \
 //x=4.37 //y=1.115 //x2=10.47 //y2=0
cc_644 ( N_noxref_3_c_532_n N_noxref_9_c_1909_n ) capacitor c=3.01891e-19 \
 //x=7.7 //y=1.12 //x2=10.47 //y2=0
cc_645 ( N_noxref_3_c_519_n N_noxref_9_M1_noxref_d ) capacitor c=5.45329e-19 \
 //x=4.37 //y=1.115 //x2=3.21 //y2=0.865
cc_646 ( N_noxref_3_c_532_n N_noxref_9_M3_noxref_d ) capacitor c=5.48773e-19 \
 //x=7.7 //y=1.12 //x2=6.54 //y2=0.865
cc_647 ( N_noxref_3_c_523_n N_noxref_10_c_2087_n ) capacitor c=0.00898362f \
 //x=4.455 //y=1.65 //x2=3.885 //y2=1.495
cc_648 ( N_noxref_3_c_519_n N_noxref_10_c_2094_n ) capacitor c=0.00342795f \
 //x=4.37 //y=1.115 //x2=4.77 //y2=0.53
cc_649 ( N_noxref_3_c_522_n N_noxref_10_c_2094_n ) capacitor c=0.00367592f \
 //x=4.845 //y=1.65 //x2=4.77 //y2=0.53
cc_650 ( N_noxref_3_M2_noxref_d N_noxref_10_c_2094_n ) capacitor c=0.0122548f \
 //x=4.18 //y=0.905 //x2=4.77 //y2=0.53
cc_651 ( N_noxref_3_c_519_n N_noxref_10_M1_noxref_s ) capacitor c=0.00880873f \
 //x=4.37 //y=1.115 //x2=2.78 //y2=0.365
cc_652 ( N_noxref_3_c_520_n N_noxref_10_M1_noxref_s ) capacitor c=0.0162314f \
 //x=4.37 //y=1.565 //x2=2.78 //y2=0.365
cc_653 ( N_noxref_3_c_522_n N_noxref_10_M1_noxref_s ) capacitor c=0.00832408f \
 //x=4.845 //y=1.65 //x2=2.78 //y2=0.365
cc_654 ( N_noxref_3_c_517_n N_noxref_10_M1_noxref_s ) capacitor c=8.7263e-19 \
 //x=4.81 //y=3.7 //x2=2.78 //y2=0.365
cc_655 ( N_noxref_3_M2_noxref_d N_noxref_10_M1_noxref_s ) capacitor \
 c=0.0297733f //x=4.18 //y=0.905 //x2=2.78 //y2=0.365
cc_656 ( N_noxref_3_c_554_n N_noxref_11_c_2145_n ) capacitor c=0.00902033f \
 //x=7.785 //y=1.65 //x2=7.215 //y2=1.495
cc_657 ( N_noxref_3_c_532_n N_noxref_11_c_2147_n ) capacitor c=0.00361131f \
 //x=7.7 //y=1.12 //x2=8.1 //y2=0.53
cc_658 ( N_noxref_3_c_548_n N_noxref_11_c_2147_n ) capacitor c=0.00367648f \
 //x=8.055 //y=1.65 //x2=8.1 //y2=0.53
cc_659 ( N_noxref_3_M4_noxref_d N_noxref_11_c_2147_n ) capacitor c=0.0122548f \
 //x=7.51 //y=0.905 //x2=8.1 //y2=0.53
cc_660 ( N_noxref_3_c_532_n N_noxref_11_M3_noxref_s ) capacitor c=0.00924101f \
 //x=7.7 //y=1.12 //x2=6.11 //y2=0.365
cc_661 ( N_noxref_3_c_540_n N_noxref_11_M3_noxref_s ) capacitor c=0.0156555f \
 //x=7.7 //y=1.565 //x2=6.11 //y2=0.365
cc_662 ( N_noxref_3_c_548_n N_noxref_11_M3_noxref_s ) capacitor c=0.00674411f \
 //x=8.055 //y=1.65 //x2=6.11 //y2=0.365
cc_663 ( N_noxref_3_c_567_n N_noxref_11_M3_noxref_s ) capacitor c=3.27628e-19 \
 //x=8.14 //y=3.935 //x2=6.11 //y2=0.365
cc_664 ( N_noxref_3_c_579_n N_noxref_11_M3_noxref_s ) capacitor c=8.41716e-19 \
 //x=8.14 //y=3.7 //x2=6.11 //y2=0.365
cc_665 ( N_noxref_3_M4_noxref_d N_noxref_11_M3_noxref_s ) capacitor \
 c=0.029767f //x=7.51 //y=0.905 //x2=6.11 //y2=0.365
cc_666 ( N_noxref_4_c_817_n N_noxref_5_c_1110_n ) capacitor c=0.0123308f \
 //x=4.44 //y=2.96 //x2=4.44 //y2=4.31
cc_667 ( N_noxref_4_c_818_n N_noxref_5_c_1110_n ) capacitor c=0.00388693f \
 //x=4.585 //y=3.005 //x2=4.44 //y2=4.31
cc_668 ( N_noxref_4_c_847_n N_noxref_5_c_1110_n ) capacitor c=4.93016e-19 \
 //x=9.47 //y=2.945 //x2=4.44 //y2=4.31
cc_669 ( N_noxref_4_c_842_n N_noxref_5_c_1114_n ) capacitor c=3.71793e-19 \
 //x=6.66 //y=4.44 //x2=4.44 //y2=4.58
cc_670 ( N_noxref_4_c_815_n N_noxref_5_c_1137_n ) capacitor c=0.00177537f \
 //x=4.44 //y=2.845 //x2=6.66 //y2=3.18
cc_671 ( N_noxref_4_c_847_n N_noxref_5_c_1137_n ) capacitor c=0.0235865f \
 //x=9.47 //y=2.945 //x2=6.66 //y2=3.18
cc_672 ( N_noxref_4_c_838_n N_noxref_5_c_1179_n ) capacitor c=0.0235892f \
 //x=9.62 //y=2.785 //x2=10.36 //y2=3.215
cc_673 ( N_noxref_4_c_866_n N_noxref_5_c_1179_n ) capacitor c=0.0158655f \
 //x=9.62 //y=3.11 //x2=10.36 //y2=3.215
cc_674 ( N_noxref_4_c_839_n N_noxref_5_c_1179_n ) capacitor c=0.00451109f \
 //x=9.62 //y=4.325 //x2=10.36 //y2=3.215
cc_675 ( N_noxref_4_c_886_n N_noxref_5_c_1179_n ) capacitor c=0.00556422f \
 //x=9.62 //y=2.96 //x2=10.36 //y2=3.215
cc_676 ( N_noxref_4_c_896_n N_noxref_5_c_1179_n ) capacitor c=0.00704249f \
 //x=9.63 //y=2.945 //x2=10.36 //y2=3.215
cc_677 ( N_noxref_4_c_839_n N_noxref_5_c_1230_n ) capacitor c=0.0197352f \
 //x=9.62 //y=4.325 //x2=10.36 //y2=3.595
cc_678 ( N_noxref_4_c_839_n N_noxref_5_c_1231_n ) capacitor c=0.0160124f \
 //x=9.62 //y=4.325 //x2=10.36 //y2=3.955
cc_679 ( N_noxref_4_c_839_n N_noxref_5_c_1232_n ) capacitor c=0.0176456f \
 //x=9.62 //y=4.325 //x2=10.36 //y2=4.275
cc_680 ( N_noxref_4_c_839_n N_noxref_5_c_1180_n ) capacitor c=0.00188951f \
 //x=9.62 //y=4.325 //x2=10.36 //y2=4.58
cc_681 ( N_noxref_4_c_840_n N_noxref_5_c_1180_n ) capacitor c=0.0213445f \
 //x=9.62 //y=4.735 //x2=10.36 //y2=4.58
cc_682 ( N_noxref_4_c_873_n N_noxref_5_c_1180_n ) capacitor c=0.00772912f \
 //x=9.62 //y=4.875 //x2=10.36 //y2=4.58
cc_683 ( N_noxref_4_c_947_p N_noxref_5_c_1180_n ) capacitor c=0.00324315f \
 //x=9.62 //y=4.44 //x2=10.36 //y2=4.58
cc_684 ( N_noxref_4_c_895_n N_noxref_5_c_1180_n ) capacitor c=0.00778315f \
 //x=9.62 //y=4.497 //x2=10.36 //y2=4.58
cc_685 ( N_noxref_4_c_817_n N_noxref_5_c_1117_n ) capacitor c=0.00759032f \
 //x=4.44 //y=2.96 //x2=4.42 //y2=4.15
cc_686 ( N_noxref_4_c_842_n N_noxref_5_c_1142_n ) capacitor c=0.0101755f \
 //x=6.66 //y=4.44 //x2=6.66 //y2=3.33
cc_687 ( N_noxref_4_c_847_n N_noxref_5_c_1142_n ) capacitor c=0.00656124f \
 //x=9.47 //y=2.945 //x2=6.66 //y2=3.33
cc_688 ( N_noxref_4_c_852_n N_noxref_5_c_1142_n ) capacitor c=0.00773567f \
 //x=6.66 //y=4.44 //x2=6.66 //y2=3.33
cc_689 ( N_noxref_4_c_839_n N_noxref_5_c_1242_n ) capacitor c=0.00138341f \
 //x=9.62 //y=4.325 //x2=10.36 //y2=4.07
cc_690 ( N_noxref_4_c_838_n N_noxref_5_c_1243_n ) capacitor c=0.0181783f \
 //x=9.62 //y=2.785 //x2=10.36 //y2=2.085
cc_691 ( N_noxref_4_c_839_n N_noxref_5_c_1244_n ) capacitor c=0.00123386f \
 //x=9.62 //y=4.325 //x2=10.36 //y2=3.33
cc_692 ( N_noxref_4_c_817_n N_noxref_5_c_1143_n ) capacitor c=4.93016e-19 \
 //x=4.44 //y=2.96 //x2=7.715 //y2=4.07
cc_693 ( N_noxref_4_c_842_n N_noxref_5_c_1143_n ) capacitor c=0.0102699f \
 //x=6.66 //y=4.44 //x2=7.715 //y2=4.07
cc_694 ( N_noxref_4_c_844_n N_noxref_5_c_1143_n ) capacitor c=0.144574f \
 //x=9.46 //y=4.497 //x2=7.715 //y2=4.07
cc_695 ( N_noxref_4_c_846_n N_noxref_5_c_1143_n ) capacitor c=0.0481199f \
 //x=6.645 //y=4.497 //x2=7.715 //y2=4.07
cc_696 ( N_noxref_4_c_847_n N_noxref_5_c_1143_n ) capacitor c=0.00927047f \
 //x=9.47 //y=2.945 //x2=7.715 //y2=4.07
cc_697 ( N_noxref_4_c_852_n N_noxref_5_c_1143_n ) capacitor c=0.00164847f \
 //x=6.66 //y=4.44 //x2=7.715 //y2=4.07
cc_698 ( N_noxref_4_c_847_n N_noxref_5_c_1191_n ) capacitor c=4.43371e-19 \
 //x=9.47 //y=2.945 //x2=8.515 //y2=4.16
cc_699 ( N_noxref_4_c_817_n N_noxref_5_c_1120_n ) capacitor c=7.94193e-19 \
 //x=4.44 //y=2.96 //x2=4.42 //y2=4.07
cc_700 ( N_noxref_4_c_818_n N_noxref_5_c_1120_n ) capacitor c=0.00847078f \
 //x=4.585 //y=3.005 //x2=4.42 //y2=4.07
cc_701 ( N_noxref_4_c_847_n N_noxref_5_c_1145_n ) capacitor c=0.0358686f \
 //x=9.47 //y=2.945 //x2=6.825 //y2=3.34
cc_702 ( N_noxref_4_c_839_n N_noxref_5_c_1200_n ) capacitor c=0.00149931f \
 //x=9.62 //y=4.325 //x2=8.602 //y2=4.07
cc_703 ( N_noxref_4_c_847_n N_noxref_5_c_1200_n ) capacitor c=0.00452617f \
 //x=9.47 //y=2.945 //x2=8.602 //y2=4.07
cc_704 ( N_noxref_4_c_839_n N_noxref_5_c_1257_n ) capacitor c=0.0023574f \
 //x=9.62 //y=4.325 //x2=10.38 //y2=4.115
cc_705 ( N_noxref_4_c_839_n N_noxref_5_c_1258_n ) capacitor c=0.024867f \
 //x=9.62 //y=4.325 //x2=10.22 //y2=4.115
cc_706 ( N_noxref_4_c_840_n N_noxref_5_c_1258_n ) capacitor c=0.00653709f \
 //x=9.62 //y=4.735 //x2=10.22 //y2=4.115
cc_707 ( N_noxref_4_c_971_p N_noxref_5_c_1258_n ) capacitor c=0.0100884f \
 //x=9.9 //y=4.96 //x2=10.22 //y2=4.115
cc_708 ( N_noxref_4_c_875_n N_noxref_5_c_1258_n ) capacitor c=6.95554e-19 \
 //x=9.985 //y=5.24 //x2=10.22 //y2=4.115
cc_709 ( N_noxref_4_c_844_n N_noxref_5_c_1258_n ) capacitor c=0.0858117f \
 //x=9.46 //y=4.497 //x2=10.22 //y2=4.115
cc_710 ( N_noxref_4_c_839_n N_noxref_5_c_1201_n ) capacitor c=0.00440076f \
 //x=9.62 //y=4.325 //x2=10.435 //y2=3.405
cc_711 ( N_noxref_4_c_866_n N_noxref_5_c_1146_n ) capacitor c=0.00735142f \
 //x=9.62 //y=3.11 //x2=10.245 //y2=3.405
cc_712 ( N_noxref_4_c_839_n N_noxref_5_c_1146_n ) capacitor c=0.0234201f \
 //x=9.62 //y=4.325 //x2=10.245 //y2=3.405
cc_713 ( N_noxref_4_c_977_p N_noxref_5_c_1146_n ) capacitor c=0.00570424f \
 //x=9.905 //y=1.84 //x2=10.245 //y2=3.405
cc_714 ( N_noxref_4_c_844_n N_noxref_5_c_1146_n ) capacitor c=0.00351804f \
 //x=9.46 //y=4.497 //x2=10.245 //y2=3.405
cc_715 ( N_noxref_4_c_896_n N_noxref_5_c_1146_n ) capacitor c=0.0368427f \
 //x=9.63 //y=2.945 //x2=10.245 //y2=3.405
cc_716 ( N_noxref_4_c_847_n N_noxref_5_c_1146_n ) capacitor c=0.230398f \
 //x=9.47 //y=2.945 //x2=10.245 //y2=3.405
cc_717 ( N_noxref_4_c_838_n N_noxref_5_c_1270_n ) capacitor c=4.71798e-19 \
 //x=9.62 //y=2.785 //x2=10.36 //y2=2.085
cc_718 ( N_noxref_4_c_840_n N_noxref_5_c_1271_n ) capacitor c=9.76098e-19 \
 //x=9.62 //y=4.735 //x2=10.36 //y2=4.7
cc_719 ( N_noxref_4_c_873_n N_noxref_5_c_1271_n ) capacitor c=0.00101709f \
 //x=9.62 //y=4.875 //x2=10.36 //y2=4.7
cc_720 ( N_noxref_4_c_947_p N_noxref_5_c_1271_n ) capacitor c=0.00170133f \
 //x=9.62 //y=4.44 //x2=10.36 //y2=4.7
cc_721 ( N_noxref_4_c_971_p N_noxref_5_M16_noxref_g ) capacitor c=0.0069321f \
 //x=9.9 //y=4.96 //x2=9.765 //y2=6.02
cc_722 ( N_noxref_4_c_986_p N_noxref_5_M16_noxref_g ) capacitor c=0.00222545f \
 //x=9.705 //y=4.96 //x2=9.765 //y2=6.02
cc_723 ( N_noxref_4_c_875_n N_noxref_5_M16_noxref_g ) capacitor c=0.00332234f \
 //x=9.985 //y=5.24 //x2=9.765 //y2=6.02
cc_724 ( N_noxref_4_c_988_p N_noxref_5_M16_noxref_g ) capacitor c=0.0162066f \
 //x=9.985 //y=5.38 //x2=9.765 //y2=6.02
cc_725 ( N_noxref_4_c_971_p N_noxref_5_M17_noxref_g ) capacitor c=0.00534267f \
 //x=9.9 //y=4.96 //x2=10.205 //y2=6.02
cc_726 ( N_noxref_4_c_875_n N_noxref_5_M17_noxref_g ) capacitor c=0.00141266f \
 //x=9.985 //y=5.24 //x2=10.205 //y2=6.02
cc_727 ( N_noxref_4_c_988_p N_noxref_5_M17_noxref_g ) capacitor c=0.0162066f \
 //x=9.985 //y=5.38 //x2=10.205 //y2=6.02
cc_728 ( N_noxref_4_c_887_n N_noxref_5_c_1281_n ) capacitor c=0.0014717f \
 //x=9.99 //y=1.005 //x2=9.72 //y2=0.91
cc_729 ( N_noxref_4_M5_noxref_d N_noxref_5_c_1281_n ) capacitor c=0.00136418f \
 //x=9.795 //y=0.91 //x2=9.72 //y2=0.91
cc_730 ( N_noxref_4_c_977_p N_noxref_5_c_1283_n ) capacitor c=0.00180253f \
 //x=9.905 //y=1.84 //x2=9.72 //y2=1.255
cc_731 ( N_noxref_4_c_877_n N_noxref_5_c_1283_n ) capacitor c=0.00322824f \
 //x=9.99 //y=1.755 //x2=9.72 //y2=1.255
cc_732 ( N_noxref_4_c_887_n N_noxref_5_c_1283_n ) capacitor c=0.00350441f \
 //x=9.99 //y=1.005 //x2=9.72 //y2=1.255
cc_733 ( N_noxref_4_M5_noxref_d N_noxref_5_c_1283_n ) capacitor c=0.00235934f \
 //x=9.795 //y=0.91 //x2=9.72 //y2=1.255
cc_734 ( N_noxref_4_c_971_p N_noxref_5_c_1287_n ) capacitor c=0.00262283f \
 //x=9.9 //y=4.96 //x2=10.13 //y2=4.79
cc_735 ( N_noxref_4_c_988_p N_noxref_5_c_1287_n ) capacitor c=0.00290963f \
 //x=9.985 //y=5.38 //x2=10.13 //y2=4.79
cc_736 ( N_noxref_4_c_840_n N_noxref_5_c_1289_n ) capacitor c=0.00202157f \
 //x=9.62 //y=4.735 //x2=9.84 //y2=4.79
cc_737 ( N_noxref_4_c_873_n N_noxref_5_c_1289_n ) capacitor c=0.00154279f \
 //x=9.62 //y=4.875 //x2=9.84 //y2=4.79
cc_738 ( N_noxref_4_c_947_p N_noxref_5_c_1289_n ) capacitor c=5.77529e-19 \
 //x=9.62 //y=4.44 //x2=9.84 //y2=4.79
cc_739 ( N_noxref_4_c_887_n N_noxref_5_c_1292_n ) capacitor c=5.57924e-19 \
 //x=9.99 //y=1.005 //x2=10.095 //y2=0.755
cc_740 ( N_noxref_4_M5_noxref_d N_noxref_5_c_1292_n ) capacitor c=0.0020782f \
 //x=9.795 //y=0.91 //x2=10.095 //y2=0.755
cc_741 ( N_noxref_4_c_877_n N_noxref_5_c_1294_n ) capacitor c=0.00935661f \
 //x=9.99 //y=1.755 //x2=10.095 //y2=1.41
cc_742 ( N_noxref_4_c_887_n N_noxref_5_c_1294_n ) capacitor c=5.75878e-19 \
 //x=9.99 //y=1.005 //x2=10.095 //y2=1.41
cc_743 ( N_noxref_4_M5_noxref_d N_noxref_5_c_1294_n ) capacitor c=0.00356097f \
 //x=9.795 //y=0.91 //x2=10.095 //y2=1.41
cc_744 ( N_noxref_4_c_840_n N_noxref_5_c_1297_n ) capacitor c=0.00186493f \
 //x=9.62 //y=4.735 //x2=10.205 //y2=4.865
cc_745 ( N_noxref_4_c_947_p N_noxref_5_c_1297_n ) capacitor c=0.00115199f \
 //x=9.62 //y=4.44 //x2=10.205 //y2=4.865
cc_746 ( N_noxref_4_c_887_n N_noxref_5_c_1299_n ) capacitor c=0.0018901f \
 //x=9.99 //y=1.005 //x2=10.25 //y2=0.91
cc_747 ( N_noxref_4_M5_noxref_d N_noxref_5_c_1299_n ) capacitor c=0.00139961f \
 //x=9.795 //y=0.91 //x2=10.25 //y2=0.91
cc_748 ( N_noxref_4_c_877_n N_noxref_5_c_1301_n ) capacitor c=0.0012792f \
 //x=9.99 //y=1.755 //x2=10.25 //y2=1.255
cc_749 ( N_noxref_4_c_887_n N_noxref_5_c_1301_n ) capacitor c=0.00414335f \
 //x=9.99 //y=1.005 //x2=10.25 //y2=1.255
cc_750 ( N_noxref_4_M5_noxref_d N_noxref_5_c_1301_n ) capacitor c=0.0023891f \
 //x=9.795 //y=0.91 //x2=10.25 //y2=1.255
cc_751 ( N_noxref_4_c_877_n N_noxref_5_c_1304_n ) capacitor c=0.0056351f \
 //x=9.99 //y=1.755 //x2=10.25 //y2=1.565
cc_752 ( N_noxref_4_c_877_n N_noxref_5_c_1305_n ) capacitor c=0.00440271f \
 //x=9.99 //y=1.755 //x2=10.25 //y2=1.92
cc_753 ( N_noxref_4_c_838_n N_noxref_5_c_1306_n ) capacitor c=0.00275704f \
 //x=9.62 //y=2.785 //x2=10.25 //y2=2.085
cc_754 ( N_noxref_4_c_977_p N_noxref_5_c_1306_n ) capacitor c=0.00440271f \
 //x=9.905 //y=1.84 //x2=10.25 //y2=2.085
cc_755 ( N_noxref_4_M12_noxref_g N_noxref_6_c_1499_n ) capacitor c=0.00366759f \
 //x=6.56 //y=6.02 //x2=6.78 //y2=6.51
cc_756 ( N_noxref_4_M13_noxref_g N_noxref_6_c_1499_n ) capacitor c=0.00390412f \
 //x=7 //y=6.02 //x2=6.78 //y2=6.51
cc_757 ( N_noxref_4_M12_noxref_g N_noxref_6_c_1501_n ) capacitor c=0.00504618f \
 //x=6.56 //y=6.02 //x2=6.78 //y2=7.23
cc_758 ( N_noxref_4_M13_noxref_g N_noxref_6_c_1501_n ) capacitor c=0.00586893f \
 //x=7 //y=6.02 //x2=6.78 //y2=7.23
cc_759 ( N_noxref_4_c_840_n N_noxref_6_c_1478_n ) capacitor c=2.10982e-19 \
 //x=9.62 //y=4.735 //x2=10.36 //y2=7.4
cc_760 ( N_noxref_4_c_986_p N_noxref_6_c_1478_n ) capacitor c=0.00199794f \
 //x=9.705 //y=4.96 //x2=10.36 //y2=7.4
cc_761 ( N_noxref_4_c_875_n N_noxref_6_c_1478_n ) capacitor c=0.00259272f \
 //x=9.985 //y=5.24 //x2=10.36 //y2=7.4
cc_762 ( N_noxref_4_c_988_p N_noxref_6_c_1478_n ) capacitor c=0.0024144f \
 //x=9.985 //y=5.38 //x2=10.36 //y2=7.4
cc_763 ( N_noxref_4_M12_noxref_g N_noxref_6_c_1458_n ) capacitor c=0.00744813f \
 //x=6.56 //y=6.02 //x2=8.71 //y2=7.4
cc_764 ( N_noxref_4_M13_noxref_g N_noxref_6_c_1458_n ) capacitor c=0.00749619f \
 //x=7 //y=6.02 //x2=8.71 //y2=7.4
cc_765 ( N_noxref_4_c_986_p N_noxref_6_c_1509_n ) capacitor c=0.00193883f \
 //x=9.705 //y=4.96 //x2=10.34 //y2=7.4
cc_766 ( N_noxref_4_c_875_n N_noxref_6_c_1509_n ) capacitor c=8.9666e-19 \
 //x=9.985 //y=5.24 //x2=10.34 //y2=7.4
cc_767 ( N_noxref_4_c_988_p N_noxref_6_c_1509_n ) capacitor c=0.0137788f \
 //x=9.985 //y=5.38 //x2=10.34 //y2=7.4
cc_768 ( N_noxref_4_c_842_n N_noxref_6_c_1467_n ) capacitor c=0.00424081f \
 //x=6.66 //y=4.44 //x2=5.55 //y2=7.4
cc_769 ( N_noxref_4_c_852_n N_noxref_6_c_1467_n ) capacitor c=0.00994313f \
 //x=6.66 //y=4.44 //x2=5.55 //y2=7.4
cc_770 ( N_noxref_4_c_858_n N_noxref_6_c_1467_n ) capacitor c=0.0157659f \
 //x=6.66 //y=4.7 //x2=5.55 //y2=7.4
cc_771 ( N_noxref_4_c_839_n N_noxref_6_c_1468_n ) capacitor c=0.00363828f \
 //x=9.62 //y=4.325 //x2=8.88 //y2=7.4
cc_772 ( N_noxref_4_c_840_n N_noxref_6_c_1468_n ) capacitor c=0.00657295f \
 //x=9.62 //y=4.735 //x2=8.88 //y2=7.4
cc_773 ( N_noxref_4_c_873_n N_noxref_6_c_1468_n ) capacitor c=0.00666218f \
 //x=9.62 //y=4.875 //x2=8.88 //y2=7.4
cc_774 ( N_noxref_4_c_875_n N_noxref_6_c_1468_n ) capacitor c=0.00203464f \
 //x=9.985 //y=5.24 //x2=8.88 //y2=7.4
cc_775 ( N_noxref_4_c_947_p N_noxref_6_c_1468_n ) capacitor c=0.011595f \
 //x=9.62 //y=4.44 //x2=8.88 //y2=7.4
cc_776 ( N_noxref_4_c_844_n N_noxref_6_c_1468_n ) capacitor c=0.023836f \
 //x=9.46 //y=4.497 //x2=8.88 //y2=7.4
cc_777 ( N_noxref_4_c_852_n N_noxref_6_c_1468_n ) capacitor c=0.00171757f \
 //x=6.66 //y=4.44 //x2=8.88 //y2=7.4
cc_778 ( N_noxref_4_c_988_p N_noxref_6_c_1468_n ) capacitor c=0.00821734f \
 //x=9.985 //y=5.38 //x2=8.88 //y2=7.4
cc_779 ( N_noxref_4_c_873_n N_noxref_6_c_1470_n ) capacitor c=2.43252e-19 \
 //x=9.62 //y=4.875 //x2=10.36 //y2=7.4
cc_780 ( N_noxref_4_c_971_p N_noxref_6_c_1470_n ) capacitor c=0.00685597f \
 //x=9.9 //y=4.96 //x2=10.36 //y2=7.4
cc_781 ( N_noxref_4_c_947_p N_noxref_6_c_1470_n ) capacitor c=0.00288508f \
 //x=9.62 //y=4.44 //x2=10.36 //y2=7.4
cc_782 ( N_noxref_4_c_988_p N_noxref_6_c_1470_n ) capacitor c=0.00958319f \
 //x=9.985 //y=5.38 //x2=10.36 //y2=7.4
cc_783 ( N_noxref_4_c_852_n N_noxref_6_M12_noxref_d ) capacitor c=0.00176891f \
 //x=6.66 //y=4.44 //x2=6.635 //y2=5.02
cc_784 ( N_noxref_4_M12_noxref_g N_noxref_6_M12_noxref_d ) capacitor \
 c=0.00896756f //x=6.56 //y=6.02 //x2=6.635 //y2=5.02
cc_785 ( N_noxref_4_M13_noxref_g N_noxref_6_M12_noxref_d ) capacitor \
 c=0.00896756f //x=7 //y=6.02 //x2=6.635 //y2=5.02
cc_786 ( N_noxref_4_c_858_n N_noxref_6_M12_noxref_d ) capacitor c=0.00302778f \
 //x=6.66 //y=4.7 //x2=6.635 //y2=5.02
cc_787 ( N_noxref_4_c_840_n N_noxref_6_M16_noxref_s ) capacitor c=0.00797506f \
 //x=9.62 //y=4.735 //x2=9.42 //y2=5.02
cc_788 ( N_noxref_4_c_986_p N_noxref_6_M16_noxref_s ) capacitor c=0.0199504f \
 //x=9.705 //y=4.96 //x2=9.42 //y2=5.02
cc_789 ( N_noxref_4_c_875_n N_noxref_6_M16_noxref_s ) capacitor c=0.0474638f \
 //x=9.985 //y=5.24 //x2=9.42 //y2=5.02
cc_790 ( N_noxref_4_c_947_p N_noxref_6_M16_noxref_s ) capacitor c=0.00349093f \
 //x=9.62 //y=4.44 //x2=9.42 //y2=5.02
cc_791 ( N_noxref_4_c_844_n N_noxref_6_M16_noxref_s ) capacitor c=6.44015e-19 \
 //x=9.46 //y=4.497 //x2=9.42 //y2=5.02
cc_792 ( N_noxref_4_c_895_n N_noxref_6_M16_noxref_s ) capacitor c=0.00172219f \
 //x=9.62 //y=4.497 //x2=9.42 //y2=5.02
cc_793 ( N_noxref_4_c_988_p N_noxref_6_M16_noxref_s ) capacitor c=0.0909213f \
 //x=9.985 //y=5.38 //x2=9.42 //y2=5.02
cc_794 ( N_noxref_4_c_875_n N_noxref_6_M17_noxref_d ) capacitor c=0.0480012f \
 //x=9.985 //y=5.24 //x2=10.28 //y2=5.02
cc_795 ( N_noxref_4_c_988_p N_noxref_6_M17_noxref_d ) capacitor c=0.0921592f \
 //x=9.985 //y=5.38 //x2=10.28 //y2=5.02
cc_796 ( N_noxref_4_c_842_n N_noxref_8_c_1771_n ) capacitor c=0.0213208f \
 //x=6.66 //y=4.44 //x2=7.1 //y2=5.205
cc_797 ( N_noxref_4_c_844_n N_noxref_8_c_1771_n ) capacitor c=0.0207296f \
 //x=9.46 //y=4.497 //x2=7.1 //y2=5.205
cc_798 ( N_noxref_4_c_846_n N_noxref_8_c_1771_n ) capacitor c=0.0083836f \
 //x=6.645 //y=4.497 //x2=7.1 //y2=5.205
cc_799 ( N_noxref_4_c_852_n N_noxref_8_c_1771_n ) capacitor c=0.00466928f \
 //x=6.66 //y=4.44 //x2=7.1 //y2=5.205
cc_800 ( N_noxref_4_M12_noxref_g N_noxref_8_c_1771_n ) capacitor c=0.011159f \
 //x=6.56 //y=6.02 //x2=7.1 //y2=5.205
cc_801 ( N_noxref_4_M13_noxref_g N_noxref_8_c_1771_n ) capacitor c=0.00878308f \
 //x=7 //y=6.02 //x2=7.1 //y2=5.205
cc_802 ( N_noxref_4_c_858_n N_noxref_8_c_1771_n ) capacitor c=0.00140241f \
 //x=6.66 //y=4.7 //x2=7.1 //y2=5.205
cc_803 ( N_noxref_4_M12_noxref_g N_noxref_8_c_1760_n ) capacitor c=0.00413602f \
 //x=6.56 //y=6.02 //x2=6.34 //y2=5.205
cc_804 ( N_noxref_4_c_875_n N_noxref_8_c_1752_n ) capacitor c=4.00761e-19 \
 //x=9.985 //y=5.24 //x2=7.22 //y2=5.205
cc_805 ( N_noxref_4_c_844_n N_noxref_8_c_1752_n ) capacitor c=0.00110484f \
 //x=9.46 //y=4.497 //x2=7.22 //y2=5.205
cc_806 ( N_noxref_4_M13_noxref_g N_noxref_8_c_1752_n ) capacitor c=0.00189987f \
 //x=7 //y=6.02 //x2=7.22 //y2=5.205
cc_807 ( N_noxref_4_M13_noxref_g N_noxref_8_c_1753_n ) capacitor c=0.00196943f \
 //x=7 //y=6.02 //x2=7.22 //y2=6.735
cc_808 ( N_noxref_4_M12_noxref_g N_noxref_8_c_1783_n ) capacitor c=0.0467392f \
 //x=6.56 //y=6.02 //x2=6.34 //y2=5.375
cc_809 ( N_noxref_4_M13_noxref_g N_noxref_8_c_1755_n ) capacitor c=0.0185551f \
 //x=7 //y=6.02 //x2=7.22 //y2=5.375
cc_810 ( N_noxref_4_M12_noxref_g N_noxref_8_M12_noxref_s ) capacitor \
 c=0.00606105f //x=6.56 //y=6.02 //x2=6.205 //y2=5.02
cc_811 ( N_noxref_4_c_866_n N_noxref_9_c_1926_n ) capacitor c=5.51749e-19 \
 //x=9.62 //y=3.11 //x2=10.36 //y2=0
cc_812 ( N_noxref_4_c_874_n N_noxref_9_c_1926_n ) capacitor c=0.00497512f \
 //x=9.705 //y=1.84 //x2=10.36 //y2=0
cc_813 ( N_noxref_4_c_887_n N_noxref_9_c_1926_n ) capacitor c=0.00981066f \
 //x=9.99 //y=1.005 //x2=10.36 //y2=0
cc_814 ( N_noxref_4_M5_noxref_d N_noxref_9_c_1926_n ) capacitor c=0.00119583f \
 //x=9.795 //y=0.91 //x2=10.36 //y2=0
cc_815 ( N_noxref_4_c_874_n N_noxref_9_c_1946_n ) capacitor c=0.00314731f \
 //x=9.705 //y=1.84 //x2=9.905 //y2=0.535
cc_816 ( N_noxref_4_c_886_n N_noxref_9_c_1946_n ) capacitor c=3.38432e-19 \
 //x=9.62 //y=2.96 //x2=9.905 //y2=0.535
cc_817 ( N_noxref_4_c_887_n N_noxref_9_c_1946_n ) capacitor c=0.00130436f \
 //x=9.99 //y=1.005 //x2=9.905 //y2=0.535
cc_818 ( N_noxref_4_c_887_n N_noxref_9_c_1949_n ) capacitor c=0.00127229f \
 //x=9.99 //y=1.005 //x2=10.385 //y2=0.535
cc_819 ( N_noxref_4_c_819_n N_noxref_9_c_1860_n ) capacitor c=3.96461e-19 \
 //x=4.44 //y=2.08 //x2=2.22 //y2=0
cc_820 ( N_noxref_4_c_847_n N_noxref_9_c_1903_n ) capacitor c=0.00412626f \
 //x=9.47 //y=2.945 //x2=5.55 //y2=0
cc_821 ( N_noxref_4_c_819_n N_noxref_9_c_1903_n ) capacitor c=0.00354768f \
 //x=4.44 //y=2.08 //x2=5.55 //y2=0
cc_822 ( N_noxref_4_c_830_n N_noxref_9_c_1903_n ) capacitor c=0.00582212f \
 //x=4.105 //y=1.915 //x2=5.55 //y2=0
cc_823 ( N_noxref_4_c_834_n N_noxref_9_c_1903_n ) capacitor c=0.00230557f \
 //x=4.635 //y=1.25 //x2=5.55 //y2=0
cc_824 ( N_noxref_4_c_874_n N_noxref_9_c_1905_n ) capacitor c=0.0208341f \
 //x=9.705 //y=1.84 //x2=8.88 //y2=0
cc_825 ( N_noxref_4_c_847_n N_noxref_9_c_1905_n ) capacitor c=0.00728069f \
 //x=9.47 //y=2.945 //x2=8.88 //y2=0
cc_826 ( N_noxref_4_c_838_n N_noxref_9_c_1909_n ) capacitor c=2.14154e-19 \
 //x=9.62 //y=2.785 //x2=10.47 //y2=0
cc_827 ( N_noxref_4_c_877_n N_noxref_9_c_1909_n ) capacitor c=0.00520602f \
 //x=9.99 //y=1.755 //x2=10.47 //y2=0
cc_828 ( N_noxref_4_c_887_n N_noxref_9_c_1909_n ) capacitor c=2.8029e-19 \
 //x=9.99 //y=1.005 //x2=10.47 //y2=0
cc_829 ( N_noxref_4_M5_noxref_d N_noxref_9_c_1909_n ) capacitor c=2.70835e-19 \
 //x=9.795 //y=0.91 //x2=10.47 //y2=0
cc_830 ( N_noxref_4_c_866_n N_noxref_9_M5_noxref_s ) capacitor c=0.002012f \
 //x=9.62 //y=3.11 //x2=9.375 //y2=0.37
cc_831 ( N_noxref_4_c_874_n N_noxref_9_M5_noxref_s ) capacitor c=0.00344219f \
 //x=9.705 //y=1.84 //x2=9.375 //y2=0.37
cc_832 ( N_noxref_4_c_877_n N_noxref_9_M5_noxref_s ) capacitor c=0.0325033f \
 //x=9.99 //y=1.755 //x2=9.375 //y2=0.37
cc_833 ( N_noxref_4_c_886_n N_noxref_9_M5_noxref_s ) capacitor c=0.00117207f \
 //x=9.62 //y=2.96 //x2=9.375 //y2=0.37
cc_834 ( N_noxref_4_c_887_n N_noxref_9_M5_noxref_s ) capacitor c=0.0156172f \
 //x=9.99 //y=1.005 //x2=9.375 //y2=0.37
cc_835 ( N_noxref_4_M5_noxref_d N_noxref_9_M5_noxref_s ) capacitor \
 c=0.0377604f //x=9.795 //y=0.91 //x2=9.375 //y2=0.37
cc_836 ( N_noxref_4_c_827_n N_noxref_10_c_2087_n ) capacitor c=0.00882422f \
 //x=4.105 //y=1.56 //x2=3.885 //y2=1.495
cc_837 ( N_noxref_4_c_819_n N_noxref_10_c_2094_n ) capacitor c=4.21808e-19 \
 //x=4.44 //y=2.08 //x2=4.77 //y2=0.53
cc_838 ( N_noxref_4_c_822_n N_noxref_10_c_2094_n ) capacitor c=0.020405f \
 //x=4.105 //y=0.905 //x2=4.77 //y2=0.53
cc_839 ( N_noxref_4_c_830_n N_noxref_10_c_2094_n ) capacitor c=2.1838e-19 \
 //x=4.105 //y=1.915 //x2=4.77 //y2=0.53
cc_840 ( N_noxref_4_c_833_n N_noxref_10_c_2094_n ) capacitor c=0.00825432f \
 //x=4.635 //y=0.905 //x2=4.77 //y2=0.53
cc_841 ( N_noxref_4_c_822_n N_noxref_10_M1_noxref_s ) capacitor c=0.00882422f \
 //x=4.105 //y=0.905 //x2=2.78 //y2=0.365
cc_842 ( N_noxref_4_c_833_n N_noxref_10_M1_noxref_s ) capacitor c=0.0152167f \
 //x=4.635 //y=0.905 //x2=2.78 //y2=0.365
cc_843 ( N_noxref_4_c_834_n N_noxref_10_M1_noxref_s ) capacitor c=0.00248746f \
 //x=4.635 //y=1.25 //x2=2.78 //y2=0.365
cc_844 ( N_noxref_4_c_842_n N_noxref_11_c_2144_n ) capacitor c=3.98532e-19 \
 //x=6.66 //y=4.44 //x2=7.13 //y2=1.58
cc_845 ( N_noxref_4_c_847_n N_noxref_11_M3_noxref_s ) capacitor c=6.422e-19 \
 //x=9.47 //y=2.945 //x2=6.11 //y2=0.365
cc_846 ( N_noxref_5_c_1230_n N_noxref_6_c_1478_n ) capacitor c=2.13368e-19 \
 //x=10.36 //y=3.595 //x2=10.36 //y2=7.4
cc_847 ( N_noxref_5_c_1232_n N_noxref_6_c_1478_n ) capacitor c=3.13086e-19 \
 //x=10.36 //y=4.275 //x2=10.36 //y2=7.4
cc_848 ( N_noxref_5_c_1180_n N_noxref_6_c_1478_n ) capacitor c=5.72118e-19 \
 //x=10.36 //y=4.58 //x2=10.36 //y2=7.4
cc_849 ( N_noxref_5_c_1271_n N_noxref_6_c_1478_n ) capacitor c=3.40875e-19 \
 //x=10.36 //y=4.7 //x2=10.36 //y2=7.4
cc_850 ( N_noxref_5_M10_noxref_g N_noxref_6_c_1422_n ) capacitor c=0.00772064f \
 //x=4.11 //y=6.02 //x2=5.38 //y2=7.4
cc_851 ( N_noxref_5_M11_noxref_g N_noxref_6_c_1422_n ) capacitor c=0.00753389f \
 //x=4.55 //y=6.02 //x2=5.38 //y2=7.4
cc_852 ( N_noxref_5_c_1232_n N_noxref_6_c_1509_n ) capacitor c=2.8985e-19 \
 //x=10.36 //y=4.275 //x2=10.34 //y2=7.4
cc_853 ( N_noxref_5_c_1180_n N_noxref_6_c_1509_n ) capacitor c=5.4912e-19 \
 //x=10.36 //y=4.58 //x2=10.34 //y2=7.4
cc_854 ( N_noxref_5_M16_noxref_g N_noxref_6_c_1509_n ) capacitor c=0.00744583f \
 //x=9.765 //y=6.02 //x2=10.34 //y2=7.4
cc_855 ( N_noxref_5_M17_noxref_g N_noxref_6_c_1509_n ) capacitor c=0.00748034f \
 //x=10.205 //y=6.02 //x2=10.34 //y2=7.4
cc_856 ( N_noxref_5_c_1117_n N_noxref_6_c_1467_n ) capacitor c=0.00228729f \
 //x=4.42 //y=4.15 //x2=5.55 //y2=7.4
cc_857 ( N_noxref_5_c_1143_n N_noxref_6_c_1467_n ) capacitor c=0.0193201f \
 //x=7.715 //y=4.07 //x2=5.55 //y2=7.4
cc_858 ( N_noxref_5_c_1123_n N_noxref_6_c_1467_n ) capacitor c=0.00347959f \
 //x=4.44 //y=4.7 //x2=5.55 //y2=7.4
cc_859 ( N_noxref_5_c_1129_n N_noxref_6_c_1467_n ) capacitor c=0.0200066f \
 //x=4.44 //y=4.7 //x2=5.55 //y2=7.4
cc_860 ( N_noxref_5_c_1242_n N_noxref_6_c_1468_n ) capacitor c=0.00133985f \
 //x=10.36 //y=4.07 //x2=8.88 //y2=7.4
cc_861 ( N_noxref_5_c_1200_n N_noxref_6_c_1468_n ) capacitor c=0.00290871f \
 //x=8.602 //y=4.07 //x2=8.88 //y2=7.4
cc_862 ( N_noxref_5_c_1258_n N_noxref_6_c_1468_n ) capacitor c=0.00889529f \
 //x=10.22 //y=4.115 //x2=8.88 //y2=7.4
cc_863 ( N_noxref_5_c_1271_n N_noxref_6_c_1468_n ) capacitor c=0.00186252f \
 //x=10.36 //y=4.7 //x2=8.88 //y2=7.4
cc_864 ( N_noxref_5_c_1289_n N_noxref_6_c_1468_n ) capacitor c=0.00914963f \
 //x=9.84 //y=4.79 //x2=8.88 //y2=7.4
cc_865 ( N_noxref_5_c_1297_n N_noxref_6_c_1468_n ) capacitor c=2.63786e-19 \
 //x=10.205 //y=4.865 //x2=8.88 //y2=7.4
cc_866 ( N_noxref_5_c_1232_n N_noxref_6_c_1470_n ) capacitor c=0.00408483f \
 //x=10.36 //y=4.275 //x2=10.36 //y2=7.4
cc_867 ( N_noxref_5_c_1180_n N_noxref_6_c_1470_n ) capacitor c=0.0166224f \
 //x=10.36 //y=4.58 //x2=10.36 //y2=7.4
cc_868 ( N_noxref_5_c_1242_n N_noxref_6_c_1470_n ) capacitor c=0.00440289f \
 //x=10.36 //y=4.07 //x2=10.36 //y2=7.4
cc_869 ( N_noxref_5_c_1271_n N_noxref_6_c_1470_n ) capacitor c=0.00795821f \
 //x=10.36 //y=4.7 //x2=10.36 //y2=7.4
cc_870 ( N_noxref_5_M17_noxref_g N_noxref_6_c_1470_n ) capacitor c=0.0181495f \
 //x=10.205 //y=6.02 //x2=10.36 //y2=7.4
cc_871 ( N_noxref_5_c_1297_n N_noxref_6_c_1470_n ) capacitor c=0.00800599f \
 //x=10.205 //y=4.865 //x2=10.36 //y2=7.4
cc_872 ( N_noxref_5_M16_noxref_g N_noxref_6_M16_noxref_s ) capacitor \
 c=0.0572684f //x=9.765 //y=6.02 //x2=9.42 //y2=5.02
cc_873 ( N_noxref_5_c_1232_n N_noxref_6_M17_noxref_d ) capacitor c=0.0021799f \
 //x=10.36 //y=4.275 //x2=10.28 //y2=5.02
cc_874 ( N_noxref_5_c_1180_n N_noxref_6_M17_noxref_d ) capacitor c=0.0208699f \
 //x=10.36 //y=4.58 //x2=10.28 //y2=5.02
cc_875 ( N_noxref_5_c_1257_n N_noxref_6_M17_noxref_d ) capacitor c=9.3589e-19 \
 //x=10.38 //y=4.115 //x2=10.28 //y2=5.02
cc_876 ( N_noxref_5_c_1271_n N_noxref_6_M17_noxref_d ) capacitor c=0.00986045f \
 //x=10.36 //y=4.7 //x2=10.28 //y2=5.02
cc_877 ( N_noxref_5_M17_noxref_g N_noxref_6_M17_noxref_d ) capacitor \
 c=0.0573441f //x=10.205 //y=6.02 //x2=10.28 //y2=5.02
cc_878 ( N_noxref_5_c_1297_n N_noxref_6_M17_noxref_d ) capacitor c=0.00531404f \
 //x=10.205 //y=4.865 //x2=10.28 //y2=5.02
cc_879 ( N_noxref_5_M10_noxref_g N_noxref_7_c_1682_n ) capacitor c=0.00908041f \
 //x=4.11 //y=6.02 //x2=4.65 //y2=6.905
cc_880 ( N_noxref_5_M11_noxref_g N_noxref_7_c_1682_n ) capacitor c=0.00931785f \
 //x=4.55 //y=6.02 //x2=4.65 //y2=6.905
cc_881 ( N_noxref_5_M10_noxref_g N_noxref_7_c_1675_n ) capacitor c=0.0018225f \
 //x=4.11 //y=6.02 //x2=3.892 //y2=5.205
cc_882 ( N_noxref_5_M10_noxref_g N_noxref_7_c_1676_n ) capacitor c=0.00184265f \
 //x=4.11 //y=6.02 //x2=3.89 //y2=6.735
cc_883 ( N_noxref_5_M11_noxref_g N_noxref_7_c_1688_n ) capacitor c=0.00415884f \
 //x=4.55 //y=6.02 //x2=4.77 //y2=6.735
cc_884 ( N_noxref_5_M10_noxref_g N_noxref_7_c_1679_n ) capacitor c=0.0170175f \
 //x=4.11 //y=6.02 //x2=3.89 //y2=5.375
cc_885 ( N_noxref_5_M11_noxref_g N_noxref_7_M11_noxref_d ) capacitor \
 c=0.0365939f //x=4.55 //y=6.02 //x2=4.625 //y2=5.02
cc_886 ( N_noxref_5_c_1143_n N_noxref_8_c_1760_n ) capacitor c=0.00663912f \
 //x=7.715 //y=4.07 //x2=6.34 //y2=5.205
cc_887 ( N_noxref_5_c_1133_n N_noxref_9_c_1891_n ) capacitor c=0.00616944f \
 //x=6.66 //y=2.205 //x2=6.73 //y2=0.84
cc_888 ( N_noxref_5_c_1142_n N_noxref_9_c_1891_n ) capacitor c=4.75689e-19 \
 //x=6.66 //y=3.33 //x2=6.73 //y2=0.84
cc_889 ( N_noxref_5_c_1148_n N_noxref_9_c_1891_n ) capacitor c=4.27717e-19 \
 //x=6.66 //y=2.08 //x2=6.73 //y2=0.84
cc_890 ( N_noxref_5_c_1152_n N_noxref_9_c_1891_n ) capacitor c=0.00164549f \
 //x=6.465 //y=0.865 //x2=6.73 //y2=0.84
cc_891 ( N_noxref_5_c_1153_n N_noxref_9_c_1891_n ) capacitor c=0.00307659f \
 //x=6.465 //y=1.21 //x2=6.73 //y2=0.84
cc_892 ( N_noxref_5_c_1154_n N_noxref_9_c_1891_n ) capacitor c=2.34235e-19 \
 //x=6.465 //y=1.52 //x2=6.73 //y2=0.84
cc_893 ( N_noxref_5_c_1355_p N_noxref_9_c_1891_n ) capacitor c=0.0092698f \
 //x=6.84 //y=0.71 //x2=6.73 //y2=0.84
cc_894 ( N_noxref_5_c_1356_p N_noxref_9_c_1891_n ) capacitor c=5.55831e-19 \
 //x=6.84 //y=1.365 //x2=6.73 //y2=0.84
cc_895 ( N_noxref_5_c_1160_n N_noxref_9_c_1891_n ) capacitor c=0.00166642f \
 //x=6.995 //y=0.865 //x2=6.73 //y2=0.84
cc_896 ( N_noxref_5_c_1162_n N_noxref_9_c_1891_n ) capacitor c=0.00258519f \
 //x=6.995 //y=1.21 //x2=6.73 //y2=0.84
cc_897 ( N_noxref_5_c_1230_n N_noxref_9_c_1926_n ) capacitor c=6.30207e-19 \
 //x=10.36 //y=3.595 //x2=10.36 //y2=0
cc_898 ( N_noxref_5_c_1243_n N_noxref_9_c_1926_n ) capacitor c=0.00248634f \
 //x=10.36 //y=2.085 //x2=10.36 //y2=0
cc_899 ( N_noxref_5_c_1270_n N_noxref_9_c_1926_n ) capacitor c=7.53892e-19 \
 //x=10.36 //y=2.085 //x2=10.36 //y2=0
cc_900 ( N_noxref_5_c_1152_n N_noxref_9_c_1931_n ) capacitor c=0.0068949f \
 //x=6.465 //y=0.865 //x2=8.71 //y2=0
cc_901 ( N_noxref_5_c_1281_n N_noxref_9_c_1946_n ) capacitor c=0.0131983f \
 //x=9.72 //y=0.91 //x2=9.905 //y2=0.535
cc_902 ( N_noxref_5_c_1230_n N_noxref_9_c_1949_n ) capacitor c=3.61022e-19 \
 //x=10.36 //y=3.595 //x2=10.385 //y2=0.535
cc_903 ( N_noxref_5_c_1243_n N_noxref_9_c_1949_n ) capacitor c=0.00114179f \
 //x=10.36 //y=2.085 //x2=10.385 //y2=0.535
cc_904 ( N_noxref_5_c_1270_n N_noxref_9_c_1949_n ) capacitor c=3.95714e-19 \
 //x=10.36 //y=2.085 //x2=10.385 //y2=0.535
cc_905 ( N_noxref_5_c_1299_n N_noxref_9_c_1949_n ) capacitor c=0.0126436f \
 //x=10.25 //y=0.91 //x2=10.385 //y2=0.535
cc_906 ( N_noxref_5_c_1306_n N_noxref_9_c_1949_n ) capacitor c=2.1838e-19 \
 //x=10.25 //y=2.085 //x2=10.385 //y2=0.535
cc_907 ( N_noxref_5_c_1133_n N_noxref_9_c_1903_n ) capacitor c=0.00409555f \
 //x=6.66 //y=2.205 //x2=5.55 //y2=0
cc_908 ( N_noxref_5_c_1137_n N_noxref_9_c_1903_n ) capacitor c=0.00668731f \
 //x=6.66 //y=3.18 //x2=5.55 //y2=0
cc_909 ( N_noxref_5_c_1148_n N_noxref_9_c_1903_n ) capacitor c=0.00412987f \
 //x=6.66 //y=2.08 //x2=5.55 //y2=0
cc_910 ( N_noxref_5_c_1154_n N_noxref_9_c_1903_n ) capacitor c=0.0015404f \
 //x=6.465 //y=1.52 //x2=5.55 //y2=0
cc_911 ( N_noxref_5_c_1156_n N_noxref_9_c_1903_n ) capacitor c=0.008955f \
 //x=6.465 //y=1.915 //x2=5.55 //y2=0
cc_912 ( N_noxref_5_c_1148_n N_noxref_9_c_1905_n ) capacitor c=4.3717e-19 \
 //x=6.66 //y=2.08 //x2=8.88 //y2=0
cc_913 ( N_noxref_5_c_1270_n N_noxref_9_c_1905_n ) capacitor c=0.0022444f \
 //x=10.36 //y=2.085 //x2=8.88 //y2=0
cc_914 ( N_noxref_5_c_1306_n N_noxref_9_c_1905_n ) capacitor c=2.63786e-19 \
 //x=10.25 //y=2.085 //x2=8.88 //y2=0
cc_915 ( N_noxref_5_c_1179_n N_noxref_9_c_1909_n ) capacitor c=0.0146622f \
 //x=10.36 //y=3.215 //x2=10.47 //y2=0
cc_916 ( N_noxref_5_c_1243_n N_noxref_9_c_1909_n ) capacitor c=0.0100674f \
 //x=10.36 //y=2.085 //x2=10.47 //y2=0
cc_917 ( N_noxref_5_c_1270_n N_noxref_9_c_1909_n ) capacitor c=0.00733542f \
 //x=10.36 //y=2.085 //x2=10.47 //y2=0
cc_918 ( N_noxref_5_c_1305_n N_noxref_9_c_1909_n ) capacitor c=0.0055761f \
 //x=10.25 //y=1.92 //x2=10.47 //y2=0
cc_919 ( N_noxref_5_c_1306_n N_noxref_9_c_1909_n ) capacitor c=0.00785621f \
 //x=10.25 //y=2.085 //x2=10.47 //y2=0
cc_920 ( N_noxref_5_c_1133_n N_noxref_9_M3_noxref_d ) capacitor c=4.28437e-19 \
 //x=6.66 //y=2.205 //x2=6.54 //y2=0.865
cc_921 ( N_noxref_5_c_1152_n N_noxref_9_M3_noxref_d ) capacitor c=0.00192399f \
 //x=6.465 //y=0.865 //x2=6.54 //y2=0.865
cc_922 ( N_noxref_5_c_1153_n N_noxref_9_M3_noxref_d ) capacitor c=0.00228784f \
 //x=6.465 //y=1.21 //x2=6.54 //y2=0.865
cc_923 ( N_noxref_5_c_1355_p N_noxref_9_M3_noxref_d ) capacitor c=0.0047434f \
 //x=6.84 //y=0.71 //x2=6.54 //y2=0.865
cc_924 ( N_noxref_5_c_1356_p N_noxref_9_M3_noxref_d ) capacitor c=0.00172481f \
 //x=6.84 //y=1.365 //x2=6.54 //y2=0.865
cc_925 ( N_noxref_5_c_1160_n N_noxref_9_M3_noxref_d ) capacitor c=0.00230174f \
 //x=6.995 //y=0.865 //x2=6.54 //y2=0.865
cc_926 ( N_noxref_5_c_1162_n N_noxref_9_M3_noxref_d ) capacitor c=0.00228784f \
 //x=6.995 //y=1.21 //x2=6.54 //y2=0.865
cc_927 ( N_noxref_5_c_1230_n N_noxref_9_M5_noxref_s ) capacitor c=8.8604e-19 \
 //x=10.36 //y=3.595 //x2=9.375 //y2=0.37
cc_928 ( N_noxref_5_c_1243_n N_noxref_9_M5_noxref_s ) capacitor c=0.00297844f \
 //x=10.36 //y=2.085 //x2=9.375 //y2=0.37
cc_929 ( N_noxref_5_c_1270_n N_noxref_9_M5_noxref_s ) capacitor c=0.00651272f \
 //x=10.36 //y=2.085 //x2=9.375 //y2=0.37
cc_930 ( N_noxref_5_c_1281_n N_noxref_9_M5_noxref_s ) capacitor c=0.0153553f \
 //x=9.72 //y=0.91 //x2=9.375 //y2=0.37
cc_931 ( N_noxref_5_c_1283_n N_noxref_9_M5_noxref_s ) capacitor c=0.00629878f \
 //x=9.72 //y=1.255 //x2=9.375 //y2=0.37
cc_932 ( N_noxref_5_c_1292_n N_noxref_9_M5_noxref_s ) capacitor c=0.0052107f \
 //x=10.095 //y=0.755 //x2=9.375 //y2=0.37
cc_933 ( N_noxref_5_c_1299_n N_noxref_9_M5_noxref_s ) capacitor c=0.0301049f \
 //x=10.25 //y=0.91 //x2=9.375 //y2=0.37
cc_934 ( N_noxref_5_c_1304_n N_noxref_9_M5_noxref_s ) capacitor c=0.002132f \
 //x=10.25 //y=1.565 //x2=9.375 //y2=0.37
cc_935 ( N_noxref_5_c_1305_n N_noxref_9_M5_noxref_s ) capacitor c=0.00304786f \
 //x=10.25 //y=1.92 //x2=9.375 //y2=0.37
cc_936 ( N_noxref_5_c_1306_n N_noxref_9_M5_noxref_s ) capacitor c=0.00660494f \
 //x=10.25 //y=2.085 //x2=9.375 //y2=0.37
cc_937 ( N_noxref_5_c_1156_n N_noxref_11_c_2143_n ) capacitor c=0.00262672f \
 //x=6.465 //y=1.915 //x2=6.245 //y2=1.495
cc_938 ( N_noxref_5_c_1133_n N_noxref_11_c_2144_n ) capacitor c=0.00501755f \
 //x=6.66 //y=2.205 //x2=7.13 //y2=1.58
cc_939 ( N_noxref_5_c_1142_n N_noxref_11_c_2144_n ) capacitor c=0.00225097f \
 //x=6.66 //y=3.33 //x2=7.13 //y2=1.58
cc_940 ( N_noxref_5_c_1148_n N_noxref_11_c_2144_n ) capacitor c=0.0100501f \
 //x=6.66 //y=2.08 //x2=7.13 //y2=1.58
cc_941 ( N_noxref_5_c_1154_n N_noxref_11_c_2144_n ) capacitor c=0.00697093f \
 //x=6.465 //y=1.52 //x2=7.13 //y2=1.58
cc_942 ( N_noxref_5_c_1156_n N_noxref_11_c_2144_n ) capacitor c=0.0176366f \
 //x=6.465 //y=1.915 //x2=7.13 //y2=1.58
cc_943 ( N_noxref_5_c_1356_p N_noxref_11_c_2144_n ) capacitor c=0.00718985f \
 //x=6.84 //y=1.365 //x2=7.13 //y2=1.58
cc_944 ( N_noxref_5_c_1162_n N_noxref_11_c_2144_n ) capacitor c=0.00339872f \
 //x=6.995 //y=1.21 //x2=7.13 //y2=1.58
cc_945 ( N_noxref_5_c_1156_n N_noxref_11_c_2145_n ) capacitor c=6.71402e-19 \
 //x=6.465 //y=1.915 //x2=7.215 //y2=1.495
cc_946 ( N_noxref_5_c_1152_n N_noxref_11_M3_noxref_s ) capacitor c=0.0293797f \
 //x=6.465 //y=0.865 //x2=6.11 //y2=0.365
cc_947 ( N_noxref_5_c_1154_n N_noxref_11_M3_noxref_s ) capacitor c=3.48408e-19 \
 //x=6.465 //y=1.52 //x2=6.11 //y2=0.365
cc_948 ( N_noxref_5_c_1160_n N_noxref_11_M3_noxref_s ) capacitor c=0.0124314f \
 //x=6.995 //y=0.865 //x2=6.11 //y2=0.365
cc_949 ( N_noxref_6_c_1411_n N_noxref_7_c_1665_n ) capacitor c=0.0018715f \
 //x=3.365 //y=7.4 //x2=3.775 //y2=5.205
cc_950 ( N_noxref_6_c_1414_n N_noxref_7_c_1665_n ) capacitor c=0.00656212f \
 //x=3.45 //y=6.52 //x2=3.775 //y2=5.205
cc_951 ( N_noxref_6_c_1477_n N_noxref_7_c_1665_n ) capacitor c=5.95793e-19 \
 //x=6.695 //y=7.4 //x2=3.775 //y2=5.205
cc_952 ( N_noxref_6_c_1422_n N_noxref_7_c_1665_n ) capacitor c=0.00603596f \
 //x=5.38 //y=7.4 //x2=3.775 //y2=5.205
cc_953 ( N_noxref_6_M8_noxref_d N_noxref_7_c_1665_n ) capacitor c=0.00555899f \
 //x=3.305 //y=5.02 //x2=3.775 //y2=5.205
cc_954 ( N_noxref_6_c_1470_n N_noxref_7_c_1682_n ) capacitor c=0.00218824f \
 //x=10.36 //y=7.4 //x2=4.65 //y2=6.905
cc_955 ( N_noxref_6_c_1430_n N_noxref_7_c_1672_n ) capacitor c=0.00744512f \
 //x=2.22 //y=7.4 //x2=3.015 //y2=5.205
cc_956 ( N_noxref_6_M7_noxref_d N_noxref_7_c_1672_n ) capacitor c=0.0125893f \
 //x=1.41 //y=5.02 //x2=3.015 //y2=5.205
cc_957 ( N_noxref_6_c_1416_n N_noxref_7_c_1676_n ) capacitor c=0.0392008f \
 //x=3.45 //y=7.23 //x2=3.89 //y2=6.735
cc_958 ( N_noxref_6_c_1477_n N_noxref_7_c_1676_n ) capacitor c=0.0963848f \
 //x=6.695 //y=7.4 //x2=3.89 //y2=6.735
cc_959 ( N_noxref_6_c_1422_n N_noxref_7_c_1676_n ) capacitor c=0.0204174f \
 //x=5.38 //y=7.4 //x2=3.89 //y2=6.735
cc_960 ( N_noxref_6_c_1470_n N_noxref_7_c_1676_n ) capacitor c=0.0011052f \
 //x=10.36 //y=7.4 //x2=3.89 //y2=6.735
cc_961 ( N_noxref_6_M8_noxref_d N_noxref_7_c_1676_n ) capacitor c=2.33785e-19 \
 //x=3.305 //y=5.02 //x2=3.89 //y2=6.735
cc_962 ( N_noxref_6_c_1416_n N_noxref_7_c_1688_n ) capacitor c=0.00108205f \
 //x=3.45 //y=7.23 //x2=4.77 //y2=6.735
cc_963 ( N_noxref_6_c_1477_n N_noxref_7_c_1688_n ) capacitor c=0.00182407f \
 //x=6.695 //y=7.4 //x2=4.77 //y2=6.735
cc_964 ( N_noxref_6_c_1501_n N_noxref_7_c_1688_n ) capacitor c=0.0024891f \
 //x=6.78 //y=7.23 //x2=4.77 //y2=6.735
cc_965 ( N_noxref_6_c_1422_n N_noxref_7_c_1688_n ) capacitor c=5.77475e-19 \
 //x=5.38 //y=7.4 //x2=4.77 //y2=6.735
cc_966 ( N_noxref_6_c_1467_n N_noxref_7_c_1688_n ) capacitor c=0.00746631f \
 //x=5.55 //y=7.4 //x2=4.77 //y2=6.735
cc_967 ( N_noxref_6_c_1470_n N_noxref_7_c_1688_n ) capacitor c=0.00110341f \
 //x=10.36 //y=7.4 //x2=4.77 //y2=6.735
cc_968 ( N_noxref_6_c_1411_n N_noxref_7_c_1677_n ) capacitor c=0.00216001f \
 //x=3.365 //y=7.4 //x2=3.01 //y2=5.375
cc_969 ( N_noxref_6_c_1414_n N_noxref_7_c_1677_n ) capacitor c=0.00720093f \
 //x=3.45 //y=6.52 //x2=3.01 //y2=5.375
cc_970 ( N_noxref_6_c_1416_n N_noxref_7_c_1677_n ) capacitor c=0.00206125f \
 //x=3.45 //y=7.23 //x2=3.01 //y2=5.375
cc_971 ( N_noxref_6_c_1422_n N_noxref_7_c_1677_n ) capacitor c=0.00846946f \
 //x=5.38 //y=7.4 //x2=3.01 //y2=5.375
cc_972 ( N_noxref_6_c_1430_n N_noxref_7_c_1677_n ) capacitor c=0.0521809f \
 //x=2.22 //y=7.4 //x2=3.01 //y2=5.375
cc_973 ( N_noxref_6_c_1470_n N_noxref_7_c_1677_n ) capacitor c=9.85326e-19 \
 //x=10.36 //y=7.4 //x2=3.01 //y2=5.375
cc_974 ( N_noxref_6_M7_noxref_d N_noxref_7_c_1677_n ) capacitor c=0.00275426f \
 //x=1.41 //y=5.02 //x2=3.01 //y2=5.375
cc_975 ( N_noxref_6_M8_noxref_d N_noxref_7_c_1677_n ) capacitor c=0.0490499f \
 //x=3.305 //y=5.02 //x2=3.01 //y2=5.375
cc_976 ( N_noxref_6_c_1414_n N_noxref_7_c_1679_n ) capacitor c=0.00635282f \
 //x=3.45 //y=6.52 //x2=3.89 //y2=5.375
cc_977 ( N_noxref_6_c_1416_n N_noxref_7_c_1679_n ) capacitor c=0.00298186f \
 //x=3.45 //y=7.23 //x2=3.89 //y2=5.375
cc_978 ( N_noxref_6_c_1477_n N_noxref_7_c_1679_n ) capacitor c=0.00203518f \
 //x=6.695 //y=7.4 //x2=3.89 //y2=5.375
cc_979 ( N_noxref_6_c_1422_n N_noxref_7_c_1679_n ) capacitor c=0.00843215f \
 //x=5.38 //y=7.4 //x2=3.89 //y2=5.375
cc_980 ( N_noxref_6_c_1470_n N_noxref_7_c_1679_n ) capacitor c=9.85326e-19 \
 //x=10.36 //y=7.4 //x2=3.89 //y2=5.375
cc_981 ( N_noxref_6_M8_noxref_d N_noxref_7_c_1679_n ) capacitor c=0.0489791f \
 //x=3.305 //y=5.02 //x2=3.89 //y2=5.375
cc_982 ( N_noxref_6_c_1411_n N_noxref_7_M8_noxref_s ) capacitor c=0.0199803f \
 //x=3.365 //y=7.4 //x2=2.875 //y2=5.02
cc_983 ( N_noxref_6_c_1416_n N_noxref_7_M8_noxref_s ) capacitor c=0.0364051f \
 //x=3.45 //y=7.23 //x2=2.875 //y2=5.02
cc_984 ( N_noxref_6_c_1422_n N_noxref_7_M8_noxref_s ) capacitor c=0.00353438f \
 //x=5.38 //y=7.4 //x2=2.875 //y2=5.02
cc_985 ( N_noxref_6_c_1430_n N_noxref_7_M8_noxref_s ) capacitor c=0.00864701f \
 //x=2.22 //y=7.4 //x2=2.875 //y2=5.02
cc_986 ( N_noxref_6_c_1470_n N_noxref_7_M8_noxref_s ) capacitor c=7.76446e-19 \
 //x=10.36 //y=7.4 //x2=2.875 //y2=5.02
cc_987 ( N_noxref_6_M8_noxref_d N_noxref_7_M8_noxref_s ) capacitor \
 c=5.61083e-19 //x=3.305 //y=5.02 //x2=2.875 //y2=5.02
cc_988 ( N_noxref_6_c_1477_n N_noxref_7_M11_noxref_d ) capacitor c=0.00204666f \
 //x=6.695 //y=7.4 //x2=4.625 //y2=5.02
cc_989 ( N_noxref_6_c_1422_n N_noxref_7_M11_noxref_d ) capacitor c=0.00845514f \
 //x=5.38 //y=7.4 //x2=4.625 //y2=5.02
cc_990 ( N_noxref_6_c_1467_n N_noxref_7_M11_noxref_d ) capacitor c=0.0449126f \
 //x=5.55 //y=7.4 //x2=4.625 //y2=5.02
cc_991 ( N_noxref_6_c_1470_n N_noxref_7_M11_noxref_d ) capacitor c=9.81989e-19 \
 //x=10.36 //y=7.4 //x2=4.625 //y2=5.02
cc_992 ( N_noxref_6_c_1477_n N_noxref_8_c_1771_n ) capacitor c=5.50113e-19 \
 //x=6.695 //y=7.4 //x2=7.1 //y2=5.205
cc_993 ( N_noxref_6_c_1499_n N_noxref_8_c_1771_n ) capacitor c=0.00626239f \
 //x=6.78 //y=6.51 //x2=7.1 //y2=5.205
cc_994 ( N_noxref_6_c_1478_n N_noxref_8_c_1771_n ) capacitor c=0.00187914f \
 //x=10.36 //y=7.4 //x2=7.1 //y2=5.205
cc_995 ( N_noxref_6_c_1458_n N_noxref_8_c_1771_n ) capacitor c=0.00587093f \
 //x=8.71 //y=7.4 //x2=7.1 //y2=5.205
cc_996 ( N_noxref_6_M12_noxref_d N_noxref_8_c_1771_n ) capacitor c=0.00560574f \
 //x=6.635 //y=5.02 //x2=7.1 //y2=5.205
cc_997 ( N_noxref_6_c_1470_n N_noxref_8_c_1750_n ) capacitor c=0.00218824f \
 //x=10.36 //y=7.4 //x2=7.98 //y2=6.905
cc_998 ( N_noxref_6_c_1467_n N_noxref_8_c_1760_n ) capacitor c=0.00765055f \
 //x=5.55 //y=7.4 //x2=6.34 //y2=5.205
cc_999 ( N_noxref_6_M16_noxref_s N_noxref_8_c_1752_n ) capacitor c=8.13769e-19 \
 //x=9.42 //y=5.02 //x2=7.22 //y2=5.205
cc_1000 ( N_noxref_6_c_1501_n N_noxref_8_c_1753_n ) capacitor c=0.0400183f \
 //x=6.78 //y=7.23 //x2=7.22 //y2=6.735
cc_1001 ( N_noxref_6_c_1478_n N_noxref_8_c_1753_n ) capacitor c=0.0967448f \
 //x=10.36 //y=7.4 //x2=7.22 //y2=6.735
cc_1002 ( N_noxref_6_c_1458_n N_noxref_8_c_1753_n ) capacitor c=0.0205791f \
 //x=8.71 //y=7.4 //x2=7.22 //y2=6.735
cc_1003 ( N_noxref_6_c_1470_n N_noxref_8_c_1753_n ) capacitor c=0.0011052f \
 //x=10.36 //y=7.4 //x2=7.22 //y2=6.735
cc_1004 ( N_noxref_6_c_1501_n N_noxref_8_c_1754_n ) capacitor c=0.00106865f \
 //x=6.78 //y=7.23 //x2=8.1 //y2=6.735
cc_1005 ( N_noxref_6_c_1478_n N_noxref_8_c_1754_n ) capacitor c=0.00222712f \
 //x=10.36 //y=7.4 //x2=8.1 //y2=6.735
cc_1006 ( N_noxref_6_c_1458_n N_noxref_8_c_1754_n ) capacitor c=6.92166e-19 \
 //x=8.71 //y=7.4 //x2=8.1 //y2=6.735
cc_1007 ( N_noxref_6_c_1468_n N_noxref_8_c_1754_n ) capacitor c=0.0114707f \
 //x=8.88 //y=7.4 //x2=8.1 //y2=6.735
cc_1008 ( N_noxref_6_c_1470_n N_noxref_8_c_1754_n ) capacitor c=0.00110321f \
 //x=10.36 //y=7.4 //x2=8.1 //y2=6.735
cc_1009 ( N_noxref_6_c_1477_n N_noxref_8_c_1783_n ) capacitor c=0.00208737f \
 //x=6.695 //y=7.4 //x2=6.34 //y2=5.375
cc_1010 ( N_noxref_6_c_1499_n N_noxref_8_c_1783_n ) capacitor c=0.00603066f \
 //x=6.78 //y=6.51 //x2=6.34 //y2=5.375
cc_1011 ( N_noxref_6_c_1501_n N_noxref_8_c_1783_n ) capacitor c=0.0019759f \
 //x=6.78 //y=7.23 //x2=6.34 //y2=5.375
cc_1012 ( N_noxref_6_c_1458_n N_noxref_8_c_1783_n ) capacitor c=0.00845676f \
 //x=8.71 //y=7.4 //x2=6.34 //y2=5.375
cc_1013 ( N_noxref_6_c_1467_n N_noxref_8_c_1783_n ) capacitor c=0.0531681f \
 //x=5.55 //y=7.4 //x2=6.34 //y2=5.375
cc_1014 ( N_noxref_6_c_1470_n N_noxref_8_c_1783_n ) capacitor c=9.85326e-19 \
 //x=10.36 //y=7.4 //x2=6.34 //y2=5.375
cc_1015 ( N_noxref_6_M12_noxref_d N_noxref_8_c_1783_n ) capacitor c=0.0480037f \
 //x=6.635 //y=5.02 //x2=6.34 //y2=5.375
cc_1016 ( N_noxref_6_c_1499_n N_noxref_8_c_1755_n ) capacitor c=0.00693978f \
 //x=6.78 //y=6.51 //x2=7.22 //y2=5.375
cc_1017 ( N_noxref_6_c_1501_n N_noxref_8_c_1755_n ) capacitor c=0.00340774f \
 //x=6.78 //y=7.23 //x2=7.22 //y2=5.375
cc_1018 ( N_noxref_6_c_1478_n N_noxref_8_c_1755_n ) capacitor c=0.00203503f \
 //x=10.36 //y=7.4 //x2=7.22 //y2=5.375
cc_1019 ( N_noxref_6_c_1458_n N_noxref_8_c_1755_n ) capacitor c=0.00843187f \
 //x=8.71 //y=7.4 //x2=7.22 //y2=5.375
cc_1020 ( N_noxref_6_c_1467_n N_noxref_8_c_1755_n ) capacitor c=0.00122422f \
 //x=5.55 //y=7.4 //x2=7.22 //y2=5.375
cc_1021 ( N_noxref_6_c_1468_n N_noxref_8_c_1755_n ) capacitor c=0.00100823f \
 //x=8.88 //y=7.4 //x2=7.22 //y2=5.375
cc_1022 ( N_noxref_6_c_1470_n N_noxref_8_c_1755_n ) capacitor c=9.8537e-19 \
 //x=10.36 //y=7.4 //x2=7.22 //y2=5.375
cc_1023 ( N_noxref_6_M12_noxref_d N_noxref_8_c_1755_n ) capacitor c=0.0478637f \
 //x=6.635 //y=5.02 //x2=7.22 //y2=5.375
cc_1024 ( N_noxref_6_c_1416_n N_noxref_8_M12_noxref_s ) capacitor \
 c=6.12118e-19 //x=3.45 //y=7.23 //x2=6.205 //y2=5.02
cc_1025 ( N_noxref_6_c_1477_n N_noxref_8_M12_noxref_s ) capacitor c=0.0224017f \
 //x=6.695 //y=7.4 //x2=6.205 //y2=5.02
cc_1026 ( N_noxref_6_c_1501_n N_noxref_8_M12_noxref_s ) capacitor c=0.0371326f \
 //x=6.78 //y=7.23 //x2=6.205 //y2=5.02
cc_1027 ( N_noxref_6_c_1458_n N_noxref_8_M12_noxref_s ) capacitor \
 c=0.00364009f //x=8.71 //y=7.4 //x2=6.205 //y2=5.02
cc_1028 ( N_noxref_6_c_1467_n N_noxref_8_M12_noxref_s ) capacitor \
 c=0.00616009f //x=5.55 //y=7.4 //x2=6.205 //y2=5.02
cc_1029 ( N_noxref_6_c_1470_n N_noxref_8_M12_noxref_s ) capacitor \
 c=8.68951e-19 //x=10.36 //y=7.4 //x2=6.205 //y2=5.02
cc_1030 ( N_noxref_6_M12_noxref_d N_noxref_8_M12_noxref_s ) capacitor \
 c=2.80542e-19 //x=6.635 //y=5.02 //x2=6.205 //y2=5.02
cc_1031 ( N_noxref_6_c_1478_n N_noxref_8_M15_noxref_d ) capacitor \
 c=0.00204666f //x=10.36 //y=7.4 //x2=7.955 //y2=5.02
cc_1032 ( N_noxref_6_c_1458_n N_noxref_8_M15_noxref_d ) capacitor \
 c=0.00845514f //x=8.71 //y=7.4 //x2=7.955 //y2=5.02
cc_1033 ( N_noxref_6_c_1468_n N_noxref_8_M15_noxref_d ) capacitor c=0.0442363f \
 //x=8.88 //y=7.4 //x2=7.955 //y2=5.02
cc_1034 ( N_noxref_6_c_1470_n N_noxref_8_M15_noxref_d ) capacitor \
 c=9.81989e-19 //x=10.36 //y=7.4 //x2=7.955 //y2=5.02
cc_1035 ( N_noxref_6_M16_noxref_s N_noxref_8_M15_noxref_d ) capacitor \
 c=0.00279795f //x=9.42 //y=5.02 //x2=7.955 //y2=5.02
cc_1036 ( N_noxref_6_c_1424_n N_noxref_9_c_1855_n ) capacitor c=0.00989031f \
 //x=0.74 //y=7.4 //x2=0.63 //y2=0
cc_1037 ( N_noxref_6_c_1430_n N_noxref_9_c_1860_n ) capacitor c=0.00680476f \
 //x=2.22 //y=7.4 //x2=2.22 //y2=0
cc_1038 ( N_noxref_6_c_1467_n N_noxref_9_c_1903_n ) capacitor c=0.00647681f \
 //x=5.55 //y=7.4 //x2=5.55 //y2=0
cc_1039 ( N_noxref_6_c_1468_n N_noxref_9_c_1905_n ) capacitor c=0.00650162f \
 //x=8.88 //y=7.4 //x2=8.88 //y2=0
cc_1040 ( N_noxref_6_c_1470_n N_noxref_9_c_1909_n ) capacitor c=0.00989031f \
 //x=10.36 //y=7.4 //x2=10.47 //y2=0
cc_1041 ( N_noxref_7_c_1675_n N_noxref_8_c_1760_n ) capacitor c=0.00121759f \
 //x=3.892 //y=5.205 //x2=6.34 //y2=5.205
cc_1042 ( N_noxref_7_c_1688_n N_noxref_8_c_1753_n ) capacitor c=3.7734e-19 \
 //x=4.77 //y=6.735 //x2=7.22 //y2=6.735
cc_1043 ( N_noxref_7_M11_noxref_d N_noxref_8_c_1783_n ) capacitor \
 c=0.00205908f //x=4.625 //y=5.02 //x2=6.34 //y2=5.375
cc_1044 ( N_noxref_7_c_1676_n N_noxref_8_M12_noxref_s ) capacitor \
 c=2.09567e-19 //x=3.89 //y=6.735 //x2=6.205 //y2=5.02
cc_1045 ( N_noxref_7_c_1688_n N_noxref_8_M12_noxref_s ) capacitor c=0.0118386f \
 //x=4.77 //y=6.735 //x2=6.205 //y2=5.02
cc_1046 ( N_noxref_7_c_1665_n N_noxref_9_c_1841_n ) capacitor c=2.23763e-19 \
 //x=3.775 //y=5.205 //x2=3.4 //y2=0.84
cc_1047 ( N_noxref_9_M0_noxref_s N_noxref_10_c_2079_n ) capacitor \
 c=0.00297559f //x=0.495 //y=0.37 //x2=2.915 //y2=1.495
cc_1048 ( N_noxref_9_c_1836_n N_noxref_10_c_2080_n ) capacitor c=0.00252347f \
 //x=3.315 //y=0 //x2=3.8 //y2=1.58
cc_1049 ( N_noxref_9_c_1841_n N_noxref_10_c_2080_n ) capacitor c=0.00327352f \
 //x=3.4 //y=0.84 //x2=3.8 //y2=1.58
cc_1050 ( N_noxref_9_c_1919_n N_noxref_10_c_2080_n ) capacitor c=7.45312e-19 \
 //x=6.645 //y=0 //x2=3.8 //y2=1.58
cc_1051 ( N_noxref_9_c_1854_n N_noxref_10_c_2080_n ) capacitor c=0.00377938f \
 //x=5.38 //y=0 //x2=3.8 //y2=1.58
cc_1052 ( N_noxref_9_M1_noxref_d N_noxref_10_c_2080_n ) capacitor \
 c=0.00751163f //x=3.21 //y=0.865 //x2=3.8 //y2=1.58
cc_1053 ( N_noxref_9_c_1841_n N_noxref_10_c_2118_n ) capacitor c=0.0120153f \
 //x=3.4 //y=0.84 //x2=3.885 //y2=0.615
cc_1054 ( N_noxref_9_c_1919_n N_noxref_10_c_2118_n ) capacitor c=0.00723598f \
 //x=6.645 //y=0 //x2=3.885 //y2=0.615
cc_1055 ( N_noxref_9_c_1854_n N_noxref_10_c_2118_n ) capacitor c=0.0146208f \
 //x=5.38 //y=0 //x2=3.885 //y2=0.615
cc_1056 ( N_noxref_9_c_1860_n N_noxref_10_c_2118_n ) capacitor c=0.00275521f \
 //x=2.22 //y=0 //x2=3.885 //y2=0.615
cc_1057 ( N_noxref_9_c_1903_n N_noxref_10_c_2118_n ) capacitor c=2.99356e-19 \
 //x=5.55 //y=0 //x2=3.885 //y2=0.615
cc_1058 ( N_noxref_9_c_1909_n N_noxref_10_c_2118_n ) capacitor c=0.00145873f \
 //x=10.47 //y=0 //x2=3.885 //y2=0.615
cc_1059 ( N_noxref_9_c_1860_n N_noxref_10_c_2087_n ) capacitor c=2.8481e-19 \
 //x=2.22 //y=0 //x2=3.885 //y2=1.495
cc_1060 ( N_noxref_9_c_1919_n N_noxref_10_c_2094_n ) capacitor c=0.0132204f \
 //x=6.645 //y=0 //x2=4.77 //y2=0.53
cc_1061 ( N_noxref_9_c_1854_n N_noxref_10_c_2094_n ) capacitor c=0.0372865f \
 //x=5.38 //y=0 //x2=4.77 //y2=0.53
cc_1062 ( N_noxref_9_c_1909_n N_noxref_10_c_2094_n ) capacitor c=0.00199432f \
 //x=10.47 //y=0 //x2=4.77 //y2=0.53
cc_1063 ( N_noxref_9_c_1919_n N_noxref_10_c_2128_n ) capacitor c=0.00236056f \
 //x=6.645 //y=0 //x2=4.855 //y2=0.615
cc_1064 ( N_noxref_9_c_1854_n N_noxref_10_c_2128_n ) capacitor c=0.0144477f \
 //x=5.38 //y=0 //x2=4.855 //y2=0.615
cc_1065 ( N_noxref_9_c_1903_n N_noxref_10_c_2128_n ) capacitor c=0.0391763f \
 //x=5.55 //y=0 //x2=4.855 //y2=0.615
cc_1066 ( N_noxref_9_c_1909_n N_noxref_10_c_2128_n ) capacitor c=0.00145015f \
 //x=10.47 //y=0 //x2=4.855 //y2=0.615
cc_1067 ( N_noxref_9_c_1836_n N_noxref_10_M1_noxref_s ) capacitor \
 c=0.00723598f //x=3.315 //y=0 //x2=2.78 //y2=0.365
cc_1068 ( N_noxref_9_c_1841_n N_noxref_10_M1_noxref_s ) capacitor c=0.026477f \
 //x=3.4 //y=0.84 //x2=2.78 //y2=0.365
cc_1069 ( N_noxref_9_c_2045_p N_noxref_10_M1_noxref_s ) capacitor \
 c=0.00297559f //x=1.6 //y=0.45 //x2=2.78 //y2=0.365
cc_1070 ( N_noxref_9_c_1854_n N_noxref_10_M1_noxref_s ) capacitor c=0.0146208f \
 //x=5.38 //y=0 //x2=2.78 //y2=0.365
cc_1071 ( N_noxref_9_c_1860_n N_noxref_10_M1_noxref_s ) capacitor c=0.052807f \
 //x=2.22 //y=0 //x2=2.78 //y2=0.365
cc_1072 ( N_noxref_9_c_1903_n N_noxref_10_M1_noxref_s ) capacitor \
 c=0.00638766f //x=5.55 //y=0 //x2=2.78 //y2=0.365
cc_1073 ( N_noxref_9_c_1909_n N_noxref_10_M1_noxref_s ) capacitor \
 c=0.00145873f //x=10.47 //y=0 //x2=2.78 //y2=0.365
cc_1074 ( N_noxref_9_M1_noxref_d N_noxref_10_M1_noxref_s ) capacitor \
 c=0.0294112f //x=3.21 //y=0.865 //x2=2.78 //y2=0.365
cc_1075 ( N_noxref_9_c_1919_n N_noxref_11_c_2144_n ) capacitor c=0.00113613f \
 //x=6.645 //y=0 //x2=7.13 //y2=1.58
cc_1076 ( N_noxref_9_c_1891_n N_noxref_11_c_2144_n ) capacitor c=0.00356816f \
 //x=6.73 //y=0.84 //x2=7.13 //y2=1.58
cc_1077 ( N_noxref_9_c_1926_n N_noxref_11_c_2144_n ) capacitor c=0.00186398f \
 //x=10.36 //y=0 //x2=7.13 //y2=1.58
cc_1078 ( N_noxref_9_c_1931_n N_noxref_11_c_2144_n ) capacitor c=0.00388126f \
 //x=8.71 //y=0 //x2=7.13 //y2=1.58
cc_1079 ( N_noxref_9_M3_noxref_d N_noxref_11_c_2144_n ) capacitor \
 c=0.00751163f //x=6.54 //y=0.865 //x2=7.13 //y2=1.58
cc_1080 ( N_noxref_9_c_1891_n N_noxref_11_c_2185_n ) capacitor c=0.0167642f \
 //x=6.73 //y=0.84 //x2=7.215 //y2=0.615
cc_1081 ( N_noxref_9_c_1926_n N_noxref_11_c_2185_n ) capacitor c=0.00723598f \
 //x=10.36 //y=0 //x2=7.215 //y2=0.615
cc_1082 ( N_noxref_9_c_1931_n N_noxref_11_c_2185_n ) capacitor c=0.0146208f \
 //x=8.71 //y=0 //x2=7.215 //y2=0.615
cc_1083 ( N_noxref_9_c_1903_n N_noxref_11_c_2185_n ) capacitor c=0.00275571f \
 //x=5.55 //y=0 //x2=7.215 //y2=0.615
cc_1084 ( N_noxref_9_c_1905_n N_noxref_11_c_2185_n ) capacitor c=2.21767e-19 \
 //x=8.88 //y=0 //x2=7.215 //y2=0.615
cc_1085 ( N_noxref_9_c_1909_n N_noxref_11_c_2185_n ) capacitor c=0.00145873f \
 //x=10.47 //y=0 //x2=7.215 //y2=0.615
cc_1086 ( N_noxref_9_c_1903_n N_noxref_11_c_2145_n ) capacitor c=2.83682e-19 \
 //x=5.55 //y=0 //x2=7.215 //y2=1.495
cc_1087 ( N_noxref_9_c_1926_n N_noxref_11_c_2147_n ) capacitor c=0.012494f \
 //x=10.36 //y=0 //x2=8.1 //y2=0.53
cc_1088 ( N_noxref_9_c_1931_n N_noxref_11_c_2147_n ) capacitor c=0.0373653f \
 //x=8.71 //y=0 //x2=8.1 //y2=0.53
cc_1089 ( N_noxref_9_c_1909_n N_noxref_11_c_2147_n ) capacitor c=0.00199432f \
 //x=10.47 //y=0 //x2=8.1 //y2=0.53
cc_1090 ( N_noxref_9_c_1926_n N_noxref_11_c_2195_n ) capacitor c=0.00253376f \
 //x=10.36 //y=0 //x2=8.185 //y2=0.615
cc_1091 ( N_noxref_9_c_1931_n N_noxref_11_c_2195_n ) capacitor c=0.0144628f \
 //x=8.71 //y=0 //x2=8.185 //y2=0.615
cc_1092 ( N_noxref_9_c_2068_p N_noxref_11_c_2195_n ) capacitor c=0.00211803f \
 //x=9.5 //y=0.45 //x2=8.185 //y2=0.615
cc_1093 ( N_noxref_9_c_1905_n N_noxref_11_c_2195_n ) capacitor c=0.0401867f \
 //x=8.88 //y=0 //x2=8.185 //y2=0.615
cc_1094 ( N_noxref_9_c_1909_n N_noxref_11_c_2195_n ) capacitor c=0.00145015f \
 //x=10.47 //y=0 //x2=8.185 //y2=0.615
cc_1095 ( N_noxref_9_c_1919_n N_noxref_11_M3_noxref_s ) capacitor \
 c=0.00723598f //x=6.645 //y=0 //x2=6.11 //y2=0.365
cc_1096 ( N_noxref_9_c_1891_n N_noxref_11_M3_noxref_s ) capacitor c=0.0220962f \
 //x=6.73 //y=0.84 //x2=6.11 //y2=0.365
cc_1097 ( N_noxref_9_c_1931_n N_noxref_11_M3_noxref_s ) capacitor c=0.0146208f \
 //x=8.71 //y=0 //x2=6.11 //y2=0.365
cc_1098 ( N_noxref_9_c_1903_n N_noxref_11_M3_noxref_s ) capacitor c=0.0518032f \
 //x=5.55 //y=0 //x2=6.11 //y2=0.365
cc_1099 ( N_noxref_9_c_1905_n N_noxref_11_M3_noxref_s ) capacitor \
 c=0.00635619f //x=8.88 //y=0 //x2=6.11 //y2=0.365
cc_1100 ( N_noxref_9_c_1909_n N_noxref_11_M3_noxref_s ) capacitor \
 c=0.00145873f //x=10.47 //y=0 //x2=6.11 //y2=0.365
cc_1101 ( N_noxref_9_M3_noxref_d N_noxref_11_M3_noxref_s ) capacitor \
 c=0.0293978f //x=6.54 //y=0.865 //x2=6.11 //y2=0.365
cc_1102 ( N_noxref_9_M5_noxref_s N_noxref_11_M3_noxref_s ) capacitor \
 c=0.00320428f //x=9.375 //y=0.37 //x2=6.11 //y2=0.365
cc_1103 ( N_noxref_10_c_2087_n N_noxref_11_c_2143_n ) capacitor c=5.32163e-19 \
 //x=3.885 //y=1.495 //x2=6.245 //y2=1.495
cc_1104 ( N_noxref_10_c_2128_n N_noxref_11_M3_noxref_s ) capacitor \
 c=0.00453102f //x=4.855 //y=0.615 //x2=6.11 //y2=0.365
cc_1105 ( N_noxref_10_M1_noxref_s N_noxref_11_M3_noxref_s ) capacitor \
 c=5.32163e-19 //x=2.78 //y=0.365 //x2=6.11 //y2=0.365
