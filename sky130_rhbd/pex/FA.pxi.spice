// File: FA.spi.FA.pxi
// Created: Thu Jan 22 07:06:06 2026
//
simulator lang=spectre
x_PM_FA\%A ( A A A A A A A A A A A A A A A A A A N_A_c_31_p N_A_c_32_p \
 N_A_c_33_p N_A_c_34_p N_A_c_104_p N_A_c_19_p N_A_c_35_p N_A_c_41_p N_A_c_36_p \
 N_A_c_6_p N_A_c_9_p N_A_c_102_p N_A_c_21_p N_A_c_38_p N_A_c_110_p N_A_c_77_p \
 N_A_c_119_p N_A_c_105_p N_A_M0_noxref_g N_A_M1_noxref_g N_A_M16_noxref_g \
 N_A_M21_noxref_g N_A_M22_noxref_g N_A_M23_noxref_g N_A_M24_noxref_g \
 N_A_M53_noxref_g N_A_M54_noxref_g N_A_c_44_p N_A_c_1_p N_A_c_2_p N_A_c_3_p \
 N_A_c_15_p N_A_c_40_p N_A_c_46_p N_A_c_4_p N_A_c_48_p N_A_c_5_p N_A_c_137_p \
 N_A_c_138_p N_A_c_140_p N_A_c_126_p N_A_c_362_p N_A_c_363_p N_A_c_139_p \
 N_A_c_141_p N_A_c_150_p N_A_c_152_p N_A_c_153_p N_A_c_247_p N_A_c_256_p \
 N_A_c_231_p N_A_c_159_p N_A_c_162_p N_A_c_11_p N_A_c_78_p N_A_c_129_p \
 N_A_c_233_p N_A_c_106_p )  PM_FA\%A
x_PM_FA\%noxref_2 ( N_noxref_2_c_484_n N_noxref_2_c_489_n N_noxref_2_c_492_n \
 N_noxref_2_c_494_n N_noxref_2_c_495_n N_noxref_2_c_496_n N_noxref_2_c_499_n \
 N_noxref_2_c_506_n N_noxref_2_c_509_n N_noxref_2_c_524_n N_noxref_2_c_525_n \
 N_noxref_2_c_526_n N_noxref_2_c_561_p N_noxref_2_c_527_n N_noxref_2_c_533_n \
 N_noxref_2_c_653_p N_noxref_2_c_602_p N_noxref_2_c_534_n N_noxref_2_c_537_n \
 N_noxref_2_c_538_n N_noxref_2_c_545_n N_noxref_2_c_557_p N_noxref_2_c_593_p \
 N_noxref_2_M4_noxref_g N_noxref_2_M29_noxref_g N_noxref_2_M30_noxref_g \
 N_noxref_2_c_578_p N_noxref_2_c_580_p N_noxref_2_c_581_p N_noxref_2_c_558_p \
 N_noxref_2_c_628_p N_noxref_2_c_629_p N_noxref_2_c_587_p N_noxref_2_c_590_p \
 N_noxref_2_c_607_p N_noxref_2_M0_noxref_d N_noxref_2_M21_noxref_d )  \
 PM_FA\%noxref_2
x_PM_FA\%noxref_3 ( N_noxref_3_c_763_n N_noxref_3_c_767_n N_noxref_3_c_771_n \
 N_noxref_3_c_797_n N_noxref_3_c_772_n N_noxref_3_c_831_p N_noxref_3_c_804_n \
 N_noxref_3_c_833_p N_noxref_3_c_805_n N_noxref_3_c_773_n N_noxref_3_c_774_n \
 N_noxref_3_c_845_p N_noxref_3_c_878_p N_noxref_3_c_870_p N_noxref_3_c_887_p \
 N_noxref_3_c_775_n N_noxref_3_c_806_n N_noxref_3_c_835_p N_noxref_3_c_836_p \
 N_noxref_3_c_777_n N_noxref_3_c_778_n N_noxref_3_c_807_n N_noxref_3_c_837_p \
 N_noxref_3_c_809_n N_noxref_3_c_838_p N_noxref_3_c_781_n N_noxref_3_c_782_n \
 N_noxref_3_c_813_n N_noxref_3_c_880_p N_noxref_3_M3_noxref_g \
 N_noxref_3_M25_noxref_g N_noxref_3_M26_noxref_g N_noxref_3_c_816_n \
 N_noxref_3_c_817_n N_noxref_3_c_818_n N_noxref_3_c_820_n N_noxref_3_c_1034_p \
 N_noxref_3_c_1035_p N_noxref_3_c_824_n N_noxref_3_c_826_n N_noxref_3_c_789_n \
 N_noxref_3_M5_noxref_d N_noxref_3_M31_noxref_d )  PM_FA\%noxref_3
x_PM_FA\%B ( B B B B B B B B B B B B B B B N_B_c_1087_n N_B_c_1091_n \
 N_B_c_1094_n N_B_c_1095_n N_B_c_1096_n N_B_c_1100_n N_B_c_1101_n N_B_c_1201_n \
 N_B_c_1157_n N_B_c_1296_p N_B_c_1209_n N_B_c_1355_p N_B_c_1365_p N_B_c_1357_p \
 N_B_c_1359_p N_B_c_1352_p N_B_c_1356_p N_B_c_1370_p N_B_c_1371_p N_B_c_1361_p \
 N_B_c_1494_p N_B_c_1382_p N_B_c_1373_p N_B_c_1102_n N_B_c_1103_n N_B_c_1104_n \
 N_B_c_1160_n N_B_c_1216_n N_B_c_1217_n N_B_c_1107_n N_B_c_1110_n \
 N_B_M2_noxref_g N_B_M5_noxref_g N_B_M15_noxref_g N_B_M27_noxref_g \
 N_B_M28_noxref_g N_B_M31_noxref_g N_B_M32_noxref_g N_B_M51_noxref_g \
 N_B_M52_noxref_g N_B_c_1117_n N_B_c_1120_n N_B_c_1122_n N_B_c_1125_n \
 N_B_c_1253_p N_B_c_1254_p N_B_c_1128_n N_B_c_1129_n N_B_c_1225_n N_B_c_1227_n \
 N_B_c_1231_n N_B_c_1233_n N_B_c_1236_n N_B_c_1238_n N_B_c_1334_p N_B_c_1242_n \
 N_B_c_1244_n N_B_c_1247_n N_B_c_1248_n N_B_c_1130_n N_B_c_1131_n N_B_c_1132_n \
 N_B_c_1134_n N_B_c_1557_p N_B_c_1558_p N_B_c_1138_n N_B_c_1140_n N_B_c_1167_n \
 N_B_c_1249_n N_B_c_1143_n )  PM_FA\%B
x_PM_FA\%noxref_5 ( N_noxref_5_c_1624_n N_noxref_5_c_1651_n \
 N_noxref_5_c_1727_n N_noxref_5_c_1733_n N_noxref_5_c_1625_n \
 N_noxref_5_c_1626_n N_noxref_5_c_1629_n N_noxref_5_c_1630_n \
 N_noxref_5_c_1634_n N_noxref_5_c_1668_n N_noxref_5_c_1673_n \
 N_noxref_5_c_1676_n N_noxref_5_c_1635_n N_noxref_5_c_1636_n \
 N_noxref_5_c_1693_n N_noxref_5_c_1697_n N_noxref_5_c_1637_n \
 N_noxref_5_c_1768_n N_noxref_5_c_1638_n N_noxref_5_c_1849_n \
 N_noxref_5_c_1850_n N_noxref_5_c_1770_n N_noxref_5_c_1639_n \
 N_noxref_5_c_1916_p N_noxref_5_c_1856_n N_noxref_5_c_1857_n \
 N_noxref_5_c_1640_n N_noxref_5_c_1858_n N_noxref_5_c_1701_n \
 N_noxref_5_c_2324_p N_noxref_5_c_1702_n N_noxref_5_c_1707_n \
 N_noxref_5_c_1779_n N_noxref_5_c_1780_n N_noxref_5_c_1987_p \
 N_noxref_5_c_1781_n N_noxref_5_c_1641_n N_noxref_5_c_1642_n \
 N_noxref_5_c_1643_n N_noxref_5_c_1644_n N_noxref_5_c_1645_n \
 N_noxref_5_c_1709_n N_noxref_5_c_1711_n N_noxref_5_c_1646_n \
 N_noxref_5_c_1647_n N_noxref_5_c_1648_n N_noxref_5_c_1797_n \
 N_noxref_5_c_1881_n N_noxref_5_c_1882_n N_noxref_5_c_1649_n \
 N_noxref_5_c_1798_n N_noxref_5_c_1712_n N_noxref_5_c_1920_p \
 N_noxref_5_c_1884_n N_noxref_5_c_2024_p N_noxref_5_c_1885_n \
 N_noxref_5_c_2032_p N_noxref_5_c_2020_p N_noxref_5_M6_noxref_g \
 N_noxref_5_M7_noxref_g N_noxref_5_M13_noxref_g N_noxref_5_M33_noxref_g \
 N_noxref_5_M34_noxref_g N_noxref_5_M35_noxref_g N_noxref_5_M36_noxref_g \
 N_noxref_5_M47_noxref_g N_noxref_5_M48_noxref_g N_noxref_5_c_1949_p \
 N_noxref_5_c_1898_p N_noxref_5_c_1899_p N_noxref_5_c_1900_p \
 N_noxref_5_c_1912_p N_noxref_5_c_1886_n N_noxref_5_c_1951_p \
 N_noxref_5_c_1901_p N_noxref_5_c_1953_p N_noxref_5_c_1902_p \
 N_noxref_5_c_2054_p N_noxref_5_c_2055_p N_noxref_5_c_2057_p \
 N_noxref_5_c_2025_p N_noxref_5_c_2257_p N_noxref_5_c_2258_p \
 N_noxref_5_c_2056_p N_noxref_5_c_2058_p N_noxref_5_c_2067_p \
 N_noxref_5_c_2069_p N_noxref_5_c_2070_p N_noxref_5_c_2105_p \
 N_noxref_5_c_2114_p N_noxref_5_c_2090_p N_noxref_5_c_2076_p \
 N_noxref_5_c_2079_p N_noxref_5_c_1887_n N_noxref_5_c_1991_p \
 N_noxref_5_c_2033_p N_noxref_5_c_2092_p N_noxref_5_c_2021_p \
 N_noxref_5_M2_noxref_d N_noxref_5_M4_noxref_d N_noxref_5_M25_noxref_d \
 N_noxref_5_M29_noxref_d )  PM_FA\%noxref_5
x_PM_FA\%noxref_6 ( N_noxref_6_c_2365_n N_noxref_6_c_2366_n \
 N_noxref_6_c_2359_n N_noxref_6_c_2360_n N_noxref_6_c_2371_n \
 N_noxref_6_c_2368_n N_noxref_6_c_2361_n N_noxref_6_c_2404_n \
 N_noxref_6_c_2374_n N_noxref_6_c_2425_n N_noxref_6_c_2427_n \
 N_noxref_6_c_2362_n N_noxref_6_c_2429_n N_noxref_6_c_2363_n \
 N_noxref_6_c_2437_n N_noxref_6_c_2469_p N_noxref_6_c_2376_n \
 N_noxref_6_c_2438_n N_noxref_6_c_2442_n N_noxref_6_c_2364_n \
 N_noxref_6_c_2449_n N_noxref_6_c_2471_p N_noxref_6_c_2491_p \
 N_noxref_6_M10_noxref_g N_noxref_6_M41_noxref_g N_noxref_6_M42_noxref_g \
 N_noxref_6_c_2479_p N_noxref_6_c_2480_p N_noxref_6_c_2486_p \
 N_noxref_6_c_2472_p N_noxref_6_c_2481_p N_noxref_6_c_2482_p \
 N_noxref_6_c_2483_p N_noxref_6_c_2484_p N_noxref_6_c_2505_p \
 N_noxref_6_M6_noxref_d N_noxref_6_M33_noxref_d )  PM_FA\%noxref_6
x_PM_FA\%SUM ( SUM SUM SUM SUM SUM N_SUM_c_2663_n N_SUM_c_2705_n \
 N_SUM_c_2670_n N_SUM_c_2766_p N_SUM_c_2664_n N_SUM_c_2686_n N_SUM_c_2665_n \
 N_SUM_c_2715_n N_SUM_c_2720_n N_SUM_c_2723_n N_SUM_c_2666_n N_SUM_c_2732_n \
 N_SUM_c_2671_n N_SUM_c_2675_n N_SUM_c_2676_n N_SUM_c_2687_n N_SUM_c_2747_n \
 N_SUM_c_2677_n N_SUM_c_2771_p N_SUM_c_2750_n N_SUM_M8_noxref_d \
 N_SUM_M10_noxref_d N_SUM_M37_noxref_d N_SUM_M41_noxref_d )  PM_FA\%SUM
x_PM_FA\%noxref_8 ( N_noxref_8_c_2966_n N_noxref_8_c_2967_n \
 N_noxref_8_c_2961_n N_noxref_8_c_2989_n N_noxref_8_c_2962_n \
 N_noxref_8_c_3054_n N_noxref_8_c_3018_n N_noxref_8_c_3060_n \
 N_noxref_8_c_2968_n N_noxref_8_c_2963_n N_noxref_8_c_2964_n \
 N_noxref_8_c_2969_n N_noxref_8_c_2974_n N_noxref_8_c_2975_n \
 N_noxref_8_c_3066_n N_noxref_8_c_2991_n N_noxref_8_c_3020_n \
 N_noxref_8_c_3071_n N_noxref_8_c_3072_n N_noxref_8_c_2965_n \
 N_noxref_8_c_2977_n N_noxref_8_c_3021_n N_noxref_8_c_3078_n \
 N_noxref_8_c_2978_n N_noxref_8_c_3086_n N_noxref_8_c_2996_n \
 N_noxref_8_c_2997_n N_noxref_8_c_3000_n N_noxref_8_c_3159_p \
 N_noxref_8_M9_noxref_g N_noxref_8_M37_noxref_g N_noxref_8_M38_noxref_g \
 N_noxref_8_c_3030_n N_noxref_8_c_3031_n N_noxref_8_c_3032_n \
 N_noxref_8_c_3034_n N_noxref_8_c_3236_p N_noxref_8_c_3237_p \
 N_noxref_8_c_3038_n N_noxref_8_c_3040_n N_noxref_8_c_3004_n \
 N_noxref_8_M11_noxref_d N_noxref_8_M43_noxref_d )  PM_FA\%noxref_8
x_PM_FA\%CIN ( CIN CIN CIN CIN CIN CIN CIN CIN CIN CIN CIN CIN CIN CIN \
 N_CIN_c_3283_n N_CIN_c_3328_n N_CIN_c_3330_n N_CIN_c_3291_n N_CIN_c_3284_n \
 N_CIN_c_3285_n N_CIN_c_3286_n N_CIN_c_3287_n N_CIN_c_3492_n N_CIN_c_3297_n \
 N_CIN_c_3300_n N_CIN_c_3303_n N_CIN_c_3304_n N_CIN_c_3305_n N_CIN_c_3306_n \
 N_CIN_c_3343_n N_CIN_c_3309_n N_CIN_c_3509_n N_CIN_c_3510_n N_CIN_c_3346_n \
 N_CIN_c_3312_n N_CIN_M8_noxref_g N_CIN_M11_noxref_g N_CIN_M12_noxref_g \
 N_CIN_M39_noxref_g N_CIN_M40_noxref_g N_CIN_M43_noxref_g N_CIN_M44_noxref_g \
 N_CIN_M45_noxref_g N_CIN_M46_noxref_g N_CIN_c_3356_n N_CIN_c_3359_n \
 N_CIN_c_3361_n N_CIN_c_3364_n N_CIN_c_3446_n N_CIN_c_3448_n N_CIN_c_3367_n \
 N_CIN_c_3368_n N_CIN_c_3518_n N_CIN_c_3520_n N_CIN_c_3524_n N_CIN_c_3526_n \
 N_CIN_c_3529_n N_CIN_c_3531_n N_CIN_c_3579_p N_CIN_c_3535_n N_CIN_c_3537_n \
 N_CIN_c_3540_n N_CIN_c_3541_n N_CIN_c_3369_n N_CIN_c_3370_n N_CIN_c_3371_n \
 N_CIN_c_3373_n N_CIN_c_3623_p N_CIN_c_3624_p N_CIN_c_3377_n N_CIN_c_3379_n \
 N_CIN_c_3404_n N_CIN_c_3542_n N_CIN_c_3382_n )  PM_FA\%CIN
x_PM_FA\%noxref_10 ( N_noxref_10_c_3700_n N_noxref_10_c_3718_n \
 N_noxref_10_c_3723_n N_noxref_10_c_3724_n N_noxref_10_c_3691_n \
 N_noxref_10_c_3692_n N_noxref_10_c_3693_n N_noxref_10_c_3702_n \
 N_noxref_10_c_3703_n N_noxref_10_c_3694_n N_noxref_10_c_3705_n \
 N_noxref_10_c_3707_n N_noxref_10_c_3739_n N_noxref_10_c_3838_p \
 N_noxref_10_c_3695_n N_noxref_10_c_3748_n N_noxref_10_c_3807_p \
 N_noxref_10_c_3696_n N_noxref_10_c_3697_n N_noxref_10_c_3698_n \
 N_noxref_10_c_3699_n N_noxref_10_c_3773_n N_noxref_10_c_3750_n \
 N_noxref_10_c_3800_p N_noxref_10_c_3712_n N_noxref_10_M14_noxref_g \
 N_noxref_10_M49_noxref_g N_noxref_10_M50_noxref_g N_noxref_10_c_3814_p \
 N_noxref_10_c_3780_p N_noxref_10_c_3781_p N_noxref_10_c_3782_p \
 N_noxref_10_c_3796_p N_noxref_10_c_3811_p N_noxref_10_c_3816_p \
 N_noxref_10_c_3783_p N_noxref_10_c_3818_p N_noxref_10_c_3784_p \
 N_noxref_10_c_3792_p N_noxref_10_M13_noxref_d N_noxref_10_M45_noxref_d \
 N_noxref_10_M47_noxref_d )  PM_FA\%noxref_10
x_PM_FA\%noxref_11 ( N_noxref_11_c_3938_n N_noxref_11_c_3943_n \
 N_noxref_11_c_3948_n N_noxref_11_c_3949_n N_noxref_11_c_4011_p \
 N_noxref_11_c_3951_n N_noxref_11_c_3957_n N_noxref_11_c_3958_n \
 N_noxref_11_c_3963_n N_noxref_11_c_4019_p N_noxref_11_c_3964_n \
 N_noxref_11_c_3990_n N_noxref_11_c_3965_n N_noxref_11_c_4086_p \
 N_noxref_11_c_3968_n N_noxref_11_c_3974_n N_noxref_11_c_4049_p \
 N_noxref_11_c_4023_p N_noxref_11_c_4016_p N_noxref_11_c_3975_n \
 N_noxref_11_c_4024_p N_noxref_11_c_3996_n N_noxref_11_c_3976_n \
 N_noxref_11_c_4046_p N_noxref_11_c_4053_p N_noxref_11_M17_noxref_g \
 N_noxref_11_M55_noxref_g N_noxref_11_M56_noxref_g N_noxref_11_c_4058_p \
 N_noxref_11_c_4027_p N_noxref_11_c_4028_p N_noxref_11_c_4029_p \
 N_noxref_11_c_4042_p N_noxref_11_c_4055_p N_noxref_11_c_4060_p \
 N_noxref_11_c_4030_p N_noxref_11_c_4062_p N_noxref_11_c_4031_p \
 N_noxref_11_c_4038_p N_noxref_11_M16_noxref_d N_noxref_11_M51_noxref_d \
 N_noxref_11_M53_noxref_d )  PM_FA\%noxref_11
x_PM_FA\%noxref_12 ( N_noxref_12_c_4216_n N_noxref_12_c_4200_n \
 N_noxref_12_c_4187_n N_noxref_12_c_4188_n N_noxref_12_c_4201_n \
 N_noxref_12_c_4202_n N_noxref_12_c_4189_n N_noxref_12_c_4191_n \
 N_noxref_12_c_4192_n N_noxref_12_c_4274_n N_noxref_12_c_4298_p \
 N_noxref_12_c_4275_n N_noxref_12_c_4193_n N_noxref_12_c_4258_n \
 N_noxref_12_c_4310_p N_noxref_12_c_4300_p N_noxref_12_c_4306_p \
 N_noxref_12_c_4194_n N_noxref_12_c_4282_n N_noxref_12_c_4286_n \
 N_noxref_12_c_4289_n N_noxref_12_c_4293_p N_noxref_12_c_4199_n \
 N_noxref_12_c_4260_n N_noxref_12_c_4320_p N_noxref_12_c_4312_p \
 N_noxref_12_M18_noxref_g N_noxref_12_M57_noxref_g N_noxref_12_M58_noxref_g \
 N_noxref_12_c_4342_p N_noxref_12_c_4344_p N_noxref_12_c_4345_p \
 N_noxref_12_c_4318_p N_noxref_12_c_4365_p N_noxref_12_c_4366_p \
 N_noxref_12_c_4321_p N_noxref_12_c_4343_p N_noxref_12_c_4346_p \
 N_noxref_12_c_4338_p N_noxref_12_M14_noxref_d N_noxref_12_M49_noxref_d )  \
 PM_FA\%noxref_12
x_PM_FA\%noxref_13 ( N_noxref_13_c_4489_n N_noxref_13_c_4496_n \
 N_noxref_13_c_4500_n N_noxref_13_c_4501_n N_noxref_13_c_4503_n \
 N_noxref_13_c_4504_n N_noxref_13_c_4507_n N_noxref_13_c_4512_n \
 N_noxref_13_c_4515_n N_noxref_13_c_4555_n N_noxref_13_c_4561_n \
 N_noxref_13_c_4520_n N_noxref_13_c_4528_n N_noxref_13_c_4563_n \
 N_noxref_13_c_4564_n N_noxref_13_c_4567_n N_noxref_13_c_4570_n \
 N_noxref_13_c_4571_n N_noxref_13_c_4530_n N_noxref_13_c_4578_n \
 N_noxref_13_c_4532_n N_noxref_13_c_4579_n N_noxref_13_c_4583_n \
 N_noxref_13_M19_noxref_g N_noxref_13_M59_noxref_g N_noxref_13_M60_noxref_g \
 N_noxref_13_c_4590_n N_noxref_13_c_4592_n N_noxref_13_c_4595_n \
 N_noxref_13_c_4649_p N_noxref_13_c_4622_p N_noxref_13_c_4597_n \
 N_noxref_13_c_4598_n N_noxref_13_c_4599_n N_noxref_13_c_4600_n \
 N_noxref_13_c_4603_n N_noxref_13_c_4604_n N_noxref_13_M17_noxref_d \
 N_noxref_13_M55_noxref_d )  PM_FA\%noxref_13
x_PM_FA\%noxref_14 ( N_noxref_14_c_4745_n N_noxref_14_c_4743_n \
 N_noxref_14_c_4758_n N_noxref_14_c_4744_n N_noxref_14_c_4788_n \
 N_noxref_14_c_4764_n N_noxref_14_c_4799_n N_noxref_14_c_4800_n \
 N_noxref_14_c_4765_n N_noxref_14_c_4808_n N_noxref_14_c_4766_n \
 N_noxref_14_c_4819_n N_noxref_14_c_4841_p N_noxref_14_c_4820_n \
 N_noxref_14_c_4821_n N_noxref_14_c_4826_n N_noxref_14_c_4946_p \
 N_noxref_14_c_4879_p N_noxref_14_c_4828_n N_noxref_14_c_4866_p \
 N_noxref_14_c_4855_p N_noxref_14_c_4830_n N_noxref_14_c_4880_p \
 N_noxref_14_c_4843_p N_noxref_14_M20_noxref_g N_noxref_14_M61_noxref_g \
 N_noxref_14_M62_noxref_g N_noxref_14_c_4892_p N_noxref_14_c_4957_p \
 N_noxref_14_c_4920_p N_noxref_14_c_4904_p N_noxref_14_c_4850_p \
 N_noxref_14_c_4859_p N_noxref_14_c_4922_p N_noxref_14_c_4960_p \
 N_noxref_14_c_4894_p N_noxref_14_c_4924_p N_noxref_14_c_4893_p \
 N_noxref_14_M18_noxref_d N_noxref_14_M19_noxref_d N_noxref_14_M59_noxref_d )  \
 PM_FA\%noxref_14
x_PM_FA\%VDD ( VDD N_VDD_c_4990_n N_VDD_c_4993_n N_VDD_c_4995_n N_VDD_c_5169_n \
 N_VDD_c_5094_n N_VDD_c_5096_n N_VDD_c_5065_n N_VDD_c_5177_n N_VDD_c_5179_n \
 N_VDD_c_5101_n N_VDD_c_5103_n N_VDD_c_5313_n N_VDD_c_5104_n N_VDD_c_5479_n \
 N_VDD_c_5481_n N_VDD_c_5539_n N_VDD_c_4997_n N_VDD_c_5001_n N_VDD_c_5047_n \
 N_VDD_c_5070_n N_VDD_c_5184_n N_VDD_c_5187_n N_VDD_c_5245_n N_VDD_c_5287_n \
 N_VDD_c_5323_n N_VDD_c_5189_n N_VDD_c_5377_n N_VDD_c_5114_n N_VDD_c_5003_n \
 N_VDD_c_5435_n N_VDD_c_5486_n N_VDD_c_5546_n N_VDD_c_5549_n N_VDD_c_5005_n \
 N_VDD_c_5012_n N_VDD_c_5056_n N_VDD_c_5057_n N_VDD_c_5083_n N_VDD_c_5131_n \
 N_VDD_c_5132_n N_VDD_c_5135_n N_VDD_c_5137_n N_VDD_c_5139_n N_VDD_c_5140_n \
 N_VDD_c_5023_n N_VDD_c_5450_n N_VDD_c_5499_n N_VDD_M21_noxref_s \
 N_VDD_M22_noxref_d N_VDD_M23_noxref_d N_VDD_M27_noxref_d N_VDD_M31_noxref_s \
 N_VDD_M32_noxref_d N_VDD_M33_noxref_s N_VDD_M34_noxref_d N_VDD_M35_noxref_d \
 N_VDD_M39_noxref_d N_VDD_M43_noxref_s N_VDD_M44_noxref_d N_VDD_M45_noxref_s \
 N_VDD_M46_noxref_d N_VDD_M48_noxref_d N_VDD_M49_noxref_s N_VDD_M50_noxref_d \
 N_VDD_M51_noxref_s N_VDD_M52_noxref_d N_VDD_M54_noxref_d N_VDD_M55_noxref_s \
 N_VDD_M56_noxref_d N_VDD_M57_noxref_d N_VDD_M61_noxref_s N_VDD_M62_noxref_d ) \
 PM_FA\%VDD
x_PM_FA\%noxref_16 ( N_noxref_16_c_5802_n N_noxref_16_c_5819_n \
 N_noxref_16_c_5809_n N_noxref_16_c_5812_n N_noxref_16_c_5813_n \
 N_noxref_16_c_5823_n N_noxref_16_c_5814_n N_noxref_16_c_5816_n \
 N_noxref_16_M23_noxref_s N_noxref_16_M24_noxref_d N_noxref_16_M26_noxref_d )  \
 PM_FA\%noxref_16
x_PM_FA\%noxref_17 ( N_noxref_17_c_5891_n N_noxref_17_c_5882_n \
 N_noxref_17_c_5889_n N_noxref_17_c_5884_n N_noxref_17_c_5885_n \
 N_noxref_17_c_5886_n N_noxref_17_c_5901_n N_noxref_17_c_5887_n \
 N_noxref_17_M27_noxref_s N_noxref_17_M28_noxref_d N_noxref_17_M30_noxref_d )  \
 PM_FA\%noxref_17
x_PM_FA\%noxref_18 ( N_noxref_18_c_5963_n N_noxref_18_c_5960_n \
 N_noxref_18_c_5961_n N_noxref_18_c_5962_n N_noxref_18_c_5972_n \
 N_noxref_18_c_5984_n N_noxref_18_c_5973_n N_noxref_18_c_5975_n \
 N_noxref_18_M35_noxref_s N_noxref_18_M36_noxref_d N_noxref_18_M38_noxref_d )  \
 PM_FA\%noxref_18
x_PM_FA\%noxref_19 ( N_noxref_19_c_6041_n N_noxref_19_c_6042_n \
 N_noxref_19_c_6043_n N_noxref_19_c_6045_n N_noxref_19_c_6051_n \
 N_noxref_19_c_6052_n N_noxref_19_c_6077_n N_noxref_19_c_6053_n \
 N_noxref_19_M39_noxref_s N_noxref_19_M40_noxref_d N_noxref_19_M42_noxref_d )  \
 PM_FA\%noxref_19
x_PM_FA\%GND ( GND N_GND_c_6122_n N_GND_c_6127_n N_GND_c_6137_n N_GND_c_6138_n \
 N_GND_c_6139_n N_GND_c_6140_n N_GND_c_6141_n N_GND_c_6142_n N_GND_c_6143_n \
 N_GND_c_6144_n N_GND_c_6145_n N_GND_c_6148_n N_GND_c_6511_n N_GND_c_6149_n \
 N_GND_c_6286_n N_GND_c_6150_n N_GND_c_6154_n N_GND_c_6804_p N_GND_c_6155_n \
 N_GND_c_6248_n N_GND_c_6825_p N_GND_c_6249_n N_GND_c_6156_n N_GND_c_6157_n \
 N_GND_c_6359_n N_GND_c_6854_p N_GND_c_6360_n N_GND_c_6450_n N_GND_c_6875_p \
 N_GND_c_6474_n N_GND_c_6158_n N_GND_c_6906_p N_GND_c_6361_n N_GND_c_6901_p \
 N_GND_c_6159_n N_GND_c_6571_n N_GND_c_6934_p N_GND_c_6160_n N_GND_c_6929_p \
 N_GND_c_6606_n N_GND_c_6610_n N_GND_c_6644_n N_GND_c_6681_n N_GND_c_6718_n \
 N_GND_c_6722_n N_GND_c_6723_n N_GND_c_6161_n N_GND_c_6166_n N_GND_c_6173_n \
 N_GND_c_6175_n N_GND_c_6176_n N_GND_c_6177_n N_GND_c_6178_n N_GND_c_6179_n \
 N_GND_c_6180_n N_GND_c_6181_n N_GND_c_6182_n N_GND_c_6183_n N_GND_c_6619_n \
 N_GND_c_6688_n N_GND_M0_noxref_s N_GND_M1_noxref_d N_GND_M3_noxref_d \
 N_GND_M5_noxref_s N_GND_M6_noxref_s N_GND_M7_noxref_d N_GND_M9_noxref_d \
 N_GND_M11_noxref_s N_GND_M12_noxref_d N_GND_M14_noxref_s N_GND_M15_noxref_d \
 N_GND_M17_noxref_s N_GND_M18_noxref_s N_GND_M20_noxref_s )  PM_FA\%GND
x_PM_FA\%noxref_21 ( N_noxref_21_c_6940_n N_noxref_21_c_6960_n \
 N_noxref_21_c_6947_n N_noxref_21_c_6951_n N_noxref_21_c_6952_n \
 N_noxref_21_c_6973_n N_noxref_21_c_6953_n N_noxref_21_c_6957_n \
 N_noxref_21_M57_noxref_s N_noxref_21_M58_noxref_d N_noxref_21_M60_noxref_d )  \
 PM_FA\%noxref_21
x_PM_FA\%COUT ( COUT COUT COUT COUT COUT COUT COUT N_COUT_c_7048_n \
 N_COUT_c_7056_n N_COUT_c_7060_n N_COUT_c_7061_n N_COUT_c_7063_n \
 N_COUT_c_7064_n N_COUT_c_7067_n N_COUT_c_7075_n N_COUT_M20_noxref_d \
 N_COUT_M61_noxref_d )  PM_FA\%COUT
x_PM_FA\%noxref_23 ( N_noxref_23_c_7114_n N_noxref_23_c_7115_n \
 N_noxref_23_c_7154_n N_noxref_23_c_7123_n N_noxref_23_c_7125_n \
 N_noxref_23_c_7163_n N_noxref_23_M1_noxref_s )  PM_FA\%noxref_23
x_PM_FA\%noxref_24 ( N_noxref_24_c_7176_n N_noxref_24_c_7177_n \
 N_noxref_24_c_7217_n N_noxref_24_c_7178_n N_noxref_24_c_7179_n \
 N_noxref_24_c_7226_n N_noxref_24_M3_noxref_s )  PM_FA\%noxref_24
x_PM_FA\%noxref_25 ( N_noxref_25_c_7240_n N_noxref_25_c_7241_n \
 N_noxref_25_c_7279_n N_noxref_25_c_7242_n N_noxref_25_c_7243_n \
 N_noxref_25_c_7288_n N_noxref_25_M7_noxref_s )  PM_FA\%noxref_25
x_PM_FA\%noxref_26 ( N_noxref_26_c_7301_n N_noxref_26_c_7302_n \
 N_noxref_26_c_7342_n N_noxref_26_c_7303_n N_noxref_26_c_7304_n \
 N_noxref_26_c_7351_n N_noxref_26_M9_noxref_s )  PM_FA\%noxref_26
x_PM_FA\%noxref_27 ( N_noxref_27_c_7365_n N_noxref_27_c_7366_n \
 N_noxref_27_c_7409_n N_noxref_27_c_7367_n N_noxref_27_c_7368_n \
 N_noxref_27_c_7418_n N_noxref_27_M12_noxref_s )  PM_FA\%noxref_27
x_PM_FA\%noxref_28 ( N_noxref_28_c_7431_n N_noxref_28_c_7432_n \
 N_noxref_28_c_7475_n N_noxref_28_c_7433_n N_noxref_28_c_7437_n \
 N_noxref_28_c_7484_n N_noxref_28_M15_noxref_s )  PM_FA\%noxref_28
cc_1 ( N_A_c_1_p N_noxref_2_c_484_n ) capacitor c=0.0012792f //x=1.34 \
 //y=1.435 //x2=1.6 //y2=1.935
cc_2 ( N_A_c_2_p N_noxref_2_c_484_n ) capacitor c=0.00561986f //x=1.34 \
 //y=1.745 //x2=1.6 //y2=1.935
cc_3 ( N_A_c_3_p N_noxref_2_c_484_n ) capacitor c=0.00440271f //x=1.34 //y=2.1 \
 //x2=1.6 //y2=1.935
cc_4 ( N_A_c_4_p N_noxref_2_c_484_n ) capacitor c=0.00953922f //x=1.715 \
 //y=1.59 //x2=1.6 //y2=1.935
cc_5 ( N_A_c_5_p N_noxref_2_c_484_n ) capacitor c=0.00344663f //x=1.87 \
 //y=1.435 //x2=1.6 //y2=1.935
cc_6 ( N_A_c_6_p N_noxref_2_c_489_n ) capacitor c=6.95554e-19 //x=3.655 \
 //y=4.255 //x2=1.605 //y2=5.42
cc_7 ( N_A_M21_noxref_g N_noxref_2_c_489_n ) capacitor c=0.00141266f //x=1.385 \
 //y=6.2 //x2=1.605 //y2=5.42
cc_8 ( N_A_M22_noxref_g N_noxref_2_c_489_n ) capacitor c=0.00352414f //x=1.825 \
 //y=6.2 //x2=1.605 //y2=5.42
cc_9 ( N_A_c_9_p N_noxref_2_c_492_n ) capacitor c=0.00303911f //x=3.815 \
 //y=2.03 //x2=1.885 //y2=2.02
cc_10 ( N_A_c_4_p N_noxref_2_c_492_n ) capacitor c=0.00180253f //x=1.715 \
 //y=1.59 //x2=1.885 //y2=2.02
cc_11 ( N_A_c_11_p N_noxref_2_c_494_n ) capacitor c=0.00440271f //x=1.23 \
 //y=2.265 //x2=1.685 //y2=2.02
cc_12 ( N_A_M22_noxref_g N_noxref_2_c_495_n ) capacitor c=0.00958461f \
 //x=1.825 //y=6.2 //x2=1.885 //y2=5.14
cc_13 ( N_A_c_6_p N_noxref_2_c_496_n ) capacitor c=0.0134401f //x=3.655 \
 //y=4.255 //x2=1.69 //y2=5.14
cc_14 ( N_A_M21_noxref_g N_noxref_2_c_496_n ) capacitor c=0.00534267f \
 //x=1.385 //y=6.2 //x2=1.69 //y2=5.14
cc_15 ( N_A_c_15_p N_noxref_2_c_496_n ) capacitor c=0.00262283f //x=1.75 \
 //y=4.97 //x2=1.69 //y2=5.14
cc_16 ( A N_noxref_2_c_499_n ) capacitor c=0.0078132f //x=1.23 //y=2.77 \
 //x2=1.97 //y2=2.61
cc_17 ( A N_noxref_2_c_499_n ) capacitor c=0.00278467f //x=3.82 //y=3.14 \
 //x2=1.97 //y2=2.61
cc_18 ( A N_noxref_2_c_499_n ) capacitor c=0.00324793f //x=3.82 //y=2.4 \
 //x2=1.97 //y2=2.61
cc_19 ( N_A_c_19_p N_noxref_2_c_499_n ) capacitor c=0.0181783f //x=1.23 \
 //y=2.265 //x2=1.97 //y2=2.61
cc_20 ( N_A_c_9_p N_noxref_2_c_499_n ) capacitor c=0.00338059f //x=3.815 \
 //y=2.03 //x2=1.97 //y2=2.61
cc_21 ( N_A_c_21_p N_noxref_2_c_499_n ) capacitor c=4.71798e-19 //x=1.23 \
 //y=2.265 //x2=1.97 //y2=2.61
cc_22 ( N_A_c_11_p N_noxref_2_c_499_n ) capacitor c=0.00275704f //x=1.23 \
 //y=2.265 //x2=1.97 //y2=2.61
cc_23 ( A N_noxref_2_c_506_n ) capacitor c=0.0149195f //x=1.23 //y=2.77 \
 //x2=1.97 //y2=2.93
cc_24 ( A N_noxref_2_c_506_n ) capacitor c=0.00251111f //x=3.82 //y=3.14 \
 //x2=1.97 //y2=2.93
cc_25 ( N_A_c_6_p N_noxref_2_c_506_n ) capacitor c=0.00255477f //x=3.655 \
 //y=4.255 //x2=1.97 //y2=2.93
cc_26 ( A N_noxref_2_c_509_n ) capacitor c=0.0562085f //x=1.23 //y=2.77 \
 //x2=1.97 //y2=5.055
cc_27 ( A N_noxref_2_c_509_n ) capacitor c=0.015132f //x=1.23 //y=4.62 \
 //x2=1.97 //y2=5.055
cc_28 ( A N_noxref_2_c_509_n ) capacitor c=0.0228969f //x=3.82 //y=3.14 \
 //x2=1.97 //y2=5.055
cc_29 ( A N_noxref_2_c_509_n ) capacitor c=0.00539064f //x=3.82 //y=4.62 \
 //x2=1.97 //y2=5.055
cc_30 ( A N_noxref_2_c_509_n ) capacitor c=5.56854e-19 //x=1.23 //y=4.25 \
 //x2=1.97 //y2=5.055
cc_31 ( N_A_c_31_p N_noxref_2_c_509_n ) capacitor c=0.0176785f //x=1.23 \
 //y=4.41 //x2=1.97 //y2=5.055
cc_32 ( N_A_c_32_p N_noxref_2_c_509_n ) capacitor c=0.0169788f //x=1.23 \
 //y=4.76 //x2=1.97 //y2=5.055
cc_33 ( N_A_c_33_p N_noxref_2_c_509_n ) capacitor c=0.00250563f //x=3.82 \
 //y=4.415 //x2=1.97 //y2=5.055
cc_34 ( N_A_c_34_p N_noxref_2_c_509_n ) capacitor c=0.0043276f //x=3.82 \
 //y=4.765 //x2=1.97 //y2=5.055
cc_35 ( N_A_c_35_p N_noxref_2_c_509_n ) capacitor c=0.0032735f //x=1.39 \
 //y=4.25 //x2=1.97 //y2=5.055
cc_36 ( N_A_c_36_p N_noxref_2_c_509_n ) capacitor c=0.00158465f //x=3.815 \
 //y=4.255 //x2=1.97 //y2=5.055
cc_37 ( N_A_c_6_p N_noxref_2_c_509_n ) capacitor c=0.0318589f //x=3.655 \
 //y=4.255 //x2=1.97 //y2=5.055
cc_38 ( N_A_c_38_p N_noxref_2_c_509_n ) capacitor c=0.00152249f //x=1.23 \
 //y=4.88 //x2=1.97 //y2=5.055
cc_39 ( N_A_c_15_p N_noxref_2_c_509_n ) capacitor c=0.00208693f //x=1.75 \
 //y=4.97 //x2=1.97 //y2=5.055
cc_40 ( N_A_c_40_p N_noxref_2_c_509_n ) capacitor c=0.00140024f //x=1.46 \
 //y=4.97 //x2=1.97 //y2=5.055
cc_41 ( N_A_c_41_p N_noxref_2_c_524_n ) capacitor c=0.0020377f //x=29.93 \
 //y=2.03 //x2=8.14 //y2=2.915
cc_42 ( A N_noxref_2_c_525_n ) capacitor c=5.03125e-19 //x=3.82 //y=3.14 \
 //x2=8.14 //y2=4.73
cc_43 ( N_A_c_41_p N_noxref_2_c_526_n ) capacitor c=0.00521323f //x=29.93 \
 //y=2.03 //x2=8.26 //y2=2.41
cc_44 ( N_A_c_44_p N_noxref_2_c_527_n ) capacitor c=0.00187726f //x=1.34 \
 //y=1.09 //x2=1.6 //y2=1.185
cc_45 ( N_A_c_1_p N_noxref_2_c_527_n ) capacitor c=0.00414335f //x=1.34 \
 //y=1.435 //x2=1.6 //y2=1.185
cc_46 ( N_A_c_46_p N_noxref_2_c_527_n ) capacitor c=5.57924e-19 //x=1.715 \
 //y=0.935 //x2=1.6 //y2=1.185
cc_47 ( N_A_c_4_p N_noxref_2_c_527_n ) capacitor c=5.75878e-19 //x=1.715 \
 //y=1.59 //x2=1.6 //y2=1.185
cc_48 ( N_A_c_48_p N_noxref_2_c_527_n ) capacitor c=0.00148359f //x=1.87 \
 //y=1.09 //x2=1.6 //y2=1.185
cc_49 ( N_A_c_5_p N_noxref_2_c_527_n ) capacitor c=0.00356717f //x=1.87 \
 //y=1.435 //x2=1.6 //y2=1.185
cc_50 ( A N_noxref_2_c_533_n ) capacitor c=0.00350918f //x=1.23 //y=2.77 \
 //x2=1.97 //y2=2.77
cc_51 ( A N_noxref_2_c_534_n ) capacitor c=0.00686827f //x=1.23 //y=2.77 \
 //x2=2.13 //y2=2.77
cc_52 ( A N_noxref_2_c_534_n ) capacitor c=0.0015808f //x=3.82 //y=3.14 \
 //x2=2.13 //y2=2.77
cc_53 ( N_A_c_6_p N_noxref_2_c_534_n ) capacitor c=0.00523905f //x=3.655 \
 //y=4.255 //x2=2.13 //y2=2.77
cc_54 ( N_A_c_41_p N_noxref_2_c_537_n ) capacitor c=0.0162109f //x=29.93 \
 //y=2.03 //x2=8.245 //y2=2.755
cc_55 ( A N_noxref_2_c_538_n ) capacitor c=0.0300884f //x=3.82 //y=3.14 \
 //x2=8.085 //y2=2.755
cc_56 ( A N_noxref_2_c_538_n ) capacitor c=0.00147344f //x=3.82 //y=2.4 \
 //x2=8.085 //y2=2.755
cc_57 ( N_A_c_33_p N_noxref_2_c_538_n ) capacitor c=0.00204002f //x=3.82 \
 //y=4.415 //x2=8.085 //y2=2.755
cc_58 ( N_A_c_41_p N_noxref_2_c_538_n ) capacitor c=0.185739f //x=29.93 \
 //y=2.03 //x2=8.085 //y2=2.755
cc_59 ( N_A_c_36_p N_noxref_2_c_538_n ) capacitor c=0.00521078f //x=3.815 \
 //y=4.255 //x2=8.085 //y2=2.755
cc_60 ( N_A_c_6_p N_noxref_2_c_538_n ) capacitor c=0.0374485f //x=3.655 \
 //y=4.255 //x2=8.085 //y2=2.755
cc_61 ( N_A_c_9_p N_noxref_2_c_538_n ) capacitor c=0.0289958f //x=3.815 \
 //y=2.03 //x2=8.085 //y2=2.755
cc_62 ( N_A_M21_noxref_g N_noxref_2_c_545_n ) capacitor c=0.0162066f //x=1.385 \
 //y=6.2 //x2=1.605 //y2=5.56
cc_63 ( N_A_M22_noxref_g N_noxref_2_c_545_n ) capacitor c=0.0162066f //x=1.825 \
 //y=6.2 //x2=1.605 //y2=5.56
cc_64 ( N_A_c_15_p N_noxref_2_c_545_n ) capacitor c=0.00290963f //x=1.75 \
 //y=4.97 //x2=1.605 //y2=5.56
cc_65 ( N_A_c_44_p N_noxref_2_M0_noxref_d ) capacitor c=0.00137914f //x=1.34 \
 //y=1.09 //x2=1.415 //y2=1.09
cc_66 ( N_A_c_1_p N_noxref_2_M0_noxref_d ) capacitor c=0.0023891f //x=1.34 \
 //y=1.435 //x2=1.415 //y2=1.09
cc_67 ( N_A_c_46_p N_noxref_2_M0_noxref_d ) capacitor c=0.0020782f //x=1.715 \
 //y=0.935 //x2=1.415 //y2=1.09
cc_68 ( N_A_c_4_p N_noxref_2_M0_noxref_d ) capacitor c=0.00356097f //x=1.715 \
 //y=1.59 //x2=1.415 //y2=1.09
cc_69 ( N_A_c_48_p N_noxref_2_M0_noxref_d ) capacitor c=0.00138452f //x=1.87 \
 //y=1.09 //x2=1.415 //y2=1.09
cc_70 ( N_A_c_5_p N_noxref_2_M0_noxref_d ) capacitor c=0.00235934f //x=1.87 \
 //y=1.435 //x2=1.415 //y2=1.09
cc_71 ( A N_noxref_3_c_763_n ) capacitor c=0.00332107f //x=3.82 //y=4.62 \
 //x2=4.93 //y2=4.575
cc_72 ( A N_noxref_3_c_763_n ) capacitor c=2.20462e-19 //x=3.82 //y=4.25 \
 //x2=4.93 //y2=4.575
cc_73 ( N_A_c_33_p N_noxref_3_c_763_n ) capacitor c=0.0104777f //x=3.82 \
 //y=4.415 //x2=4.93 //y2=4.575
cc_74 ( N_A_c_36_p N_noxref_3_c_763_n ) capacitor c=0.00277624f //x=3.815 \
 //y=4.255 //x2=4.93 //y2=4.575
cc_75 ( A N_noxref_3_c_767_n ) capacitor c=0.00479726f //x=3.82 //y=4.62 \
 //x2=4.93 //y2=4.765
cc_76 ( N_A_c_34_p N_noxref_3_c_767_n ) capacitor c=0.0113118f //x=3.82 \
 //y=4.765 //x2=4.93 //y2=4.765
cc_77 ( N_A_c_77_p N_noxref_3_c_767_n ) capacitor c=9.57294e-19 //x=3.82 \
 //y=4.88 //x2=4.93 //y2=4.765
cc_78 ( N_A_c_78_p N_noxref_3_c_767_n ) capacitor c=0.00138908f //x=3.82 \
 //y=4.88 //x2=4.93 //y2=4.765
cc_79 ( N_A_c_41_p N_noxref_3_c_771_n ) capacitor c=0.0107f //x=29.93 //y=2.03 \
 //x2=7.15 //y2=2.385
cc_80 ( N_A_c_41_p N_noxref_3_c_772_n ) capacitor c=0.00833911f //x=29.93 \
 //y=2.03 //x2=10.11 //y2=3.335
cc_81 ( N_A_c_41_p N_noxref_3_c_773_n ) capacitor c=0.0360057f //x=29.93 \
 //y=2.03 //x2=10.395 //y2=2.02
cc_82 ( N_A_c_41_p N_noxref_3_c_774_n ) capacitor c=0.0143639f //x=29.93 \
 //y=2.03 //x2=10.195 //y2=2.02
cc_83 ( A N_noxref_3_c_775_n ) capacitor c=0.00540988f //x=3.82 //y=4.25 \
 //x2=4.975 //y2=4.415
cc_84 ( N_A_c_33_p N_noxref_3_c_775_n ) capacitor c=5.21732e-19 //x=3.82 \
 //y=4.415 //x2=4.975 //y2=4.415
cc_85 ( N_A_c_41_p N_noxref_3_c_777_n ) capacitor c=0.00188895f //x=29.93 \
 //y=2.03 //x2=10.48 //y2=1.185
cc_86 ( A N_noxref_3_c_778_n ) capacitor c=0.00250264f //x=3.82 //y=4.62 \
 //x2=4.975 //y2=4.28
cc_87 ( N_A_c_33_p N_noxref_3_c_778_n ) capacitor c=6.43301e-19 //x=3.82 \
 //y=4.415 //x2=4.975 //y2=4.28
cc_88 ( N_A_c_36_p N_noxref_3_c_778_n ) capacitor c=0.00709734f //x=3.815 \
 //y=4.255 //x2=4.975 //y2=4.28
cc_89 ( N_A_c_41_p N_noxref_3_c_781_n ) capacitor c=0.0054137f //x=29.93 \
 //y=2.03 //x2=9.985 //y2=3.495
cc_90 ( A N_noxref_3_c_782_n ) capacitor c=4.16726e-19 //x=3.82 //y=4.62 \
 //x2=4.93 //y2=4.88
cc_91 ( N_A_c_34_p N_noxref_3_c_782_n ) capacitor c=3.31511e-19 //x=3.82 \
 //y=4.765 //x2=4.93 //y2=4.88
cc_92 ( N_A_c_77_p N_noxref_3_c_782_n ) capacitor c=0.00113699f //x=3.82 \
 //y=4.88 //x2=4.93 //y2=4.88
cc_93 ( N_A_c_78_p N_noxref_3_c_782_n ) capacitor c=0.00195576f //x=3.82 \
 //y=4.88 //x2=4.93 //y2=4.88
cc_94 ( N_A_M23_noxref_g N_noxref_3_M25_noxref_g ) capacitor c=0.0102032f \
 //x=3.72 //y=6.2 //x2=4.6 //y2=6.2
cc_95 ( N_A_M24_noxref_g N_noxref_3_M25_noxref_g ) capacitor c=0.0618855f \
 //x=4.16 //y=6.2 //x2=4.6 //y2=6.2
cc_96 ( N_A_M24_noxref_g N_noxref_3_M26_noxref_g ) capacitor c=0.00945236f \
 //x=4.16 //y=6.2 //x2=5.04 //y2=6.2
cc_97 ( N_A_c_34_p N_noxref_3_c_789_n ) capacitor c=0.0012806f //x=3.82 \
 //y=4.765 //x2=4.93 //y2=4.88
cc_98 ( N_A_c_77_p N_noxref_3_c_789_n ) capacitor c=0.0019442f //x=3.82 \
 //y=4.88 //x2=4.93 //y2=4.88
cc_99 ( N_A_c_78_p N_noxref_3_c_789_n ) capacitor c=0.067621f //x=3.82 \
 //y=4.88 //x2=4.93 //y2=4.88
cc_100 ( A B ) capacitor c=0.0992825f //x=30.09 //y=2.77 //x2=29.35 //y2=2.77
cc_101 ( A B ) capacitor c=0.00286121f //x=30.09 //y=2.4 //x2=29.35 //y2=2.77
cc_102 ( N_A_c_102_p B ) capacitor c=0.00123494f //x=30.09 //y=2.03 //x2=29.35 \
 //y2=2.77
cc_103 ( A B ) capacitor c=0.00832877f //x=3.82 //y=3.14 //x2=4.93 //y2=3.14
cc_104 ( N_A_c_104_p B ) capacitor c=0.0123633f //x=30.09 //y=4.735 //x2=29.35 \
 //y2=4.99
cc_105 ( N_A_c_105_p B ) capacitor c=5.42697e-19 //x=30.12 //y=4.88 //x2=29.35 \
 //y2=4.99
cc_106 ( N_A_c_106_p B ) capacitor c=0.00150024f //x=30.12 //y=4.88 //x2=29.35 \
 //y2=4.99
cc_107 ( A N_B_c_1087_n ) capacitor c=0.00737225f //x=3.82 //y=2.4 //x2=4.93 \
 //y2=2.415
cc_108 ( N_A_c_41_p N_B_c_1087_n ) capacitor c=0.00551183f //x=29.93 //y=2.03 \
 //x2=4.93 //y2=2.415
cc_109 ( N_A_c_9_p N_B_c_1087_n ) capacitor c=0.0067663f //x=3.815 //y=2.03 \
 //x2=4.93 //y2=2.415
cc_110 ( N_A_c_110_p N_B_c_1087_n ) capacitor c=2.11086e-19 //x=3.82 //y=2.265 \
 //x2=4.93 //y2=2.415
cc_111 ( A N_B_c_1091_n ) capacitor c=0.0131688f //x=3.82 //y=3.14 //x2=4.93 \
 //y2=2.995
cc_112 ( A N_B_c_1091_n ) capacitor c=5.09892e-19 //x=3.82 //y=2.4 //x2=4.93 \
 //y2=2.995
cc_113 ( N_A_c_9_p N_B_c_1091_n ) capacitor c=4.04115e-19 //x=3.815 //y=2.03 \
 //x2=4.93 //y2=2.995
cc_114 ( N_A_c_41_p N_B_c_1094_n ) capacitor c=0.00178514f //x=29.93 //y=2.03 \
 //x2=10.85 //y2=3.3
cc_115 ( N_A_c_41_p N_B_c_1095_n ) capacitor c=0.013423f //x=29.93 //y=2.03 \
 //x2=10.85 //y2=2.265
cc_116 ( A N_B_c_1096_n ) capacitor c=0.0147962f //x=30.09 //y=2.4 //x2=29.35 \
 //y2=2.26
cc_117 ( N_A_c_41_p N_B_c_1096_n ) capacitor c=0.0115418f //x=29.93 //y=2.03 \
 //x2=29.35 //y2=2.26
cc_118 ( N_A_c_102_p N_B_c_1096_n ) capacitor c=0.00713268f //x=30.09 //y=2.03 \
 //x2=29.35 //y2=2.26
cc_119 ( N_A_c_119_p N_B_c_1096_n ) capacitor c=5.24723e-19 //x=30.09 //y=2.26 \
 //x2=29.35 //y2=2.26
cc_120 ( N_A_c_41_p N_B_c_1100_n ) capacitor c=0.0784311f //x=29.93 //y=2.03 \
 //x2=9.76 //y2=3.14
cc_121 ( N_A_c_41_p N_B_c_1101_n ) capacitor c=0.0154959f //x=29.93 //y=2.03 \
 //x2=10.36 //y2=3.11
cc_122 ( N_A_c_104_p N_B_c_1102_n ) capacitor c=0.00617112f //x=30.09 \
 //y=4.735 //x2=24.01 //y2=5.01
cc_123 ( A N_B_c_1103_n ) capacitor c=0.00513442f //x=3.82 //y=3.14 //x2=5.09 \
 //y2=3.155
cc_124 ( A N_B_c_1104_n ) capacitor c=5.80837e-19 //x=3.82 //y=2.4 //x2=4.93 \
 //y2=2.265
cc_125 ( N_A_c_110_p N_B_c_1104_n ) capacitor c=0.00113671f //x=3.82 //y=2.265 \
 //x2=4.93 //y2=2.265
cc_126 ( N_A_c_126_p N_B_c_1104_n ) capacitor c=0.00137085f //x=3.625 //y=2.1 \
 //x2=4.93 //y2=2.265
cc_127 ( A N_B_c_1107_n ) capacitor c=9.33949e-19 //x=30.09 //y=2.4 //x2=29.35 \
 //y2=2.26
cc_128 ( N_A_c_119_p N_B_c_1107_n ) capacitor c=0.00485134f //x=30.09 //y=2.26 \
 //x2=29.35 //y2=2.26
cc_129 ( N_A_c_129_p N_B_c_1107_n ) capacitor c=0.00146289f //x=30.09 //y=2.26 \
 //x2=29.35 //y2=2.26
cc_130 ( A N_B_c_1110_n ) capacitor c=3.02466e-19 //x=30.09 //y=2.77 \
 //x2=29.35 //y2=4.88
cc_131 ( N_A_c_104_p N_B_c_1110_n ) capacitor c=4.73677e-19 //x=30.09 \
 //y=4.735 //x2=29.35 //y2=4.88
cc_132 ( N_A_c_105_p N_B_c_1110_n ) capacitor c=0.0043355f //x=30.12 //y=4.88 \
 //x2=29.35 //y2=4.88
cc_133 ( N_A_c_106_p N_B_c_1110_n ) capacitor c=0.00251395f //x=30.12 //y=4.88 \
 //x2=29.35 //y2=4.88
cc_134 ( N_A_M53_noxref_g N_B_M51_noxref_g ) capacitor c=0.0105162f //x=30.13 \
 //y=6.2 //x2=29.25 //y2=6.2
cc_135 ( N_A_M53_noxref_g N_B_M52_noxref_g ) capacitor c=0.107404f //x=30.13 \
 //y=6.2 //x2=29.69 //y2=6.2
cc_136 ( N_A_M54_noxref_g N_B_M52_noxref_g ) capacitor c=0.0100341f //x=30.57 \
 //y=6.2 //x2=29.69 //y2=6.2
cc_137 ( N_A_c_137_p N_B_c_1117_n ) capacitor c=4.86545e-19 //x=3.625 //y=1.05 \
 //x2=4.595 //y2=1.09
cc_138 ( N_A_c_138_p N_B_c_1117_n ) capacitor c=0.00152405f //x=3.625 \
 //y=1.395 //x2=4.595 //y2=1.09
cc_139 ( N_A_c_139_p N_B_c_1117_n ) capacitor c=0.0157772f //x=4.155 //y=1.05 \
 //x2=4.595 //y2=1.09
cc_140 ( N_A_c_140_p N_B_c_1120_n ) capacitor c=0.00109982f //x=3.625 \
 //y=1.705 //x2=4.595 //y2=1.435
cc_141 ( N_A_c_141_p N_B_c_1120_n ) capacitor c=0.0117362f //x=4.155 //y=1.395 \
 //x2=4.595 //y2=1.435
cc_142 ( N_A_c_140_p N_B_c_1122_n ) capacitor c=9.58131e-19 //x=3.625 \
 //y=1.705 //x2=4.595 //y2=1.745
cc_143 ( N_A_c_126_p N_B_c_1122_n ) capacitor c=0.00662747f //x=3.625 //y=2.1 \
 //x2=4.595 //y2=1.745
cc_144 ( N_A_c_141_p N_B_c_1122_n ) capacitor c=0.00862358f //x=4.155 \
 //y=1.395 //x2=4.595 //y2=1.745
cc_145 ( A N_B_c_1125_n ) capacitor c=0.00168f //x=3.82 //y=2.4 //x2=4.595 \
 //y2=2.1
cc_146 ( N_A_c_110_p N_B_c_1125_n ) capacitor c=0.00218576f //x=3.82 //y=2.265 \
 //x2=4.595 //y2=2.1
cc_147 ( N_A_c_126_p N_B_c_1125_n ) capacitor c=0.0107744f //x=3.625 //y=2.1 \
 //x2=4.595 //y2=2.1
cc_148 ( N_A_c_139_p N_B_c_1128_n ) capacitor c=0.00127211f //x=4.155 //y=1.05 \
 //x2=5.125 //y2=1.09
cc_149 ( N_A_c_141_p N_B_c_1129_n ) capacitor c=0.00204774f //x=4.155 \
 //y=1.395 //x2=5.125 //y2=1.435
cc_150 ( N_A_c_150_p N_B_c_1130_n ) capacitor c=4.86545e-19 //x=30.125 \
 //y=1.085 //x2=29.155 //y2=1.045
cc_151 ( N_A_c_150_p N_B_c_1131_n ) capacitor c=0.00152405f //x=30.125 \
 //y=1.085 //x2=29.155 //y2=1.39
cc_152 ( N_A_c_152_p N_B_c_1132_n ) capacitor c=0.00109982f //x=30.125 \
 //y=1.43 //x2=29.155 //y2=1.7
cc_153 ( N_A_c_153_p N_B_c_1132_n ) capacitor c=9.58243e-19 //x=30.125 \
 //y=1.74 //x2=29.155 //y2=1.7
cc_154 ( A N_B_c_1134_n ) capacitor c=0.00153109f //x=30.09 //y=2.4 \
 //x2=29.155 //y2=2.095
cc_155 ( N_A_c_119_p N_B_c_1134_n ) capacitor c=0.00267875f //x=30.09 //y=2.26 \
 //x2=29.155 //y2=2.095
cc_156 ( N_A_c_153_p N_B_c_1134_n ) capacitor c=0.00662747f //x=30.125 \
 //y=1.74 //x2=29.155 //y2=2.095
cc_157 ( N_A_c_129_p N_B_c_1134_n ) capacitor c=0.0170936f //x=30.09 //y=2.26 \
 //x2=29.155 //y2=2.095
cc_158 ( N_A_c_150_p N_B_c_1138_n ) capacitor c=0.0151475f //x=30.125 \
 //y=1.085 //x2=29.685 //y2=1.045
cc_159 ( N_A_c_159_p N_B_c_1138_n ) capacitor c=0.00127211f //x=30.655 \
 //y=1.085 //x2=29.685 //y2=1.045
cc_160 ( N_A_c_152_p N_B_c_1140_n ) capacitor c=0.0111064f //x=30.125 //y=1.43 \
 //x2=29.685 //y2=1.39
cc_161 ( N_A_c_153_p N_B_c_1140_n ) capacitor c=0.00862358f //x=30.125 \
 //y=1.74 //x2=29.685 //y2=1.39
cc_162 ( N_A_c_162_p N_B_c_1140_n ) capacitor c=0.00204774f //x=30.655 \
 //y=1.43 //x2=29.685 //y2=1.39
cc_163 ( A N_B_c_1143_n ) capacitor c=4.17552e-19 //x=30.09 //y=2.77 \
 //x2=29.35 //y2=4.88
cc_164 ( N_A_c_104_p N_B_c_1143_n ) capacitor c=9.08746e-19 //x=30.09 \
 //y=4.735 //x2=29.35 //y2=4.88
cc_165 ( N_A_c_105_p N_B_c_1143_n ) capacitor c=0.00196409f //x=30.12 //y=4.88 \
 //x2=29.35 //y2=4.88
cc_166 ( N_A_c_106_p N_B_c_1143_n ) capacitor c=0.029212f //x=30.12 //y=4.88 \
 //x2=29.35 //y2=4.88
cc_167 ( N_A_c_41_p N_noxref_5_c_1624_n ) capacitor c=0.00102186f //x=29.93 \
 //y=2.03 //x2=4.86 //y2=1.305
cc_168 ( N_A_c_41_p N_noxref_5_c_1625_n ) capacitor c=0.0297141f //x=29.93 \
 //y=2.03 //x2=4.945 //y2=1.835
cc_169 ( A N_noxref_5_c_1626_n ) capacitor c=0.0126225f //x=3.82 //y=3.14 \
 //x2=5.42 //y2=3.735
cc_170 ( A N_noxref_5_c_1626_n ) capacitor c=0.00126718f //x=3.82 //y=2.4 \
 //x2=5.42 //y2=3.735
cc_171 ( N_A_c_41_p N_noxref_5_c_1626_n ) capacitor c=0.0319201f //x=29.93 \
 //y=2.03 //x2=5.42 //y2=3.735
cc_172 ( A N_noxref_5_c_1629_n ) capacitor c=0.00382991f //x=3.82 //y=3.14 \
 //x2=5.42 //y2=4.055
cc_173 ( A N_noxref_5_c_1630_n ) capacitor c=8.27091e-19 //x=3.82 //y=3.14 \
 //x2=5.42 //y2=5.3
cc_174 ( A N_noxref_5_c_1630_n ) capacitor c=0.00194983f //x=3.82 //y=4.62 \
 //x2=5.42 //y2=5.3
cc_175 ( N_A_c_33_p N_noxref_5_c_1630_n ) capacitor c=0.00100476f //x=3.82 \
 //y=4.415 //x2=5.42 //y2=5.3
cc_176 ( N_A_c_36_p N_noxref_5_c_1630_n ) capacitor c=4.77997e-19 //x=3.815 \
 //y=4.255 //x2=5.42 //y2=5.3
cc_177 ( N_A_c_41_p N_noxref_5_c_1634_n ) capacitor c=8.7937e-19 //x=29.93 \
 //y=2.03 //x2=8.19 //y2=1.3
cc_178 ( N_A_c_41_p N_noxref_5_c_1635_n ) capacitor c=0.0221365f //x=29.93 \
 //y=2.03 //x2=8.275 //y2=1.835
cc_179 ( N_A_c_41_p N_noxref_5_c_1636_n ) capacitor c=0.0333709f //x=29.93 \
 //y=2.03 //x2=8.63 //y2=3.735
cc_180 ( N_A_c_41_p N_noxref_5_c_1637_n ) capacitor c=0.0124617f //x=29.93 \
 //y=2.03 //x2=12.33 //y2=2.575
cc_181 ( N_A_c_41_p N_noxref_5_c_1638_n ) capacitor c=0.00115043f //x=29.93 \
 //y=2.03 //x2=12.33 //y2=3.92
cc_182 ( N_A_c_41_p N_noxref_5_c_1639_n ) capacitor c=0.00863183f //x=29.93 \
 //y=2.03 //x2=14.92 //y2=2.42
cc_183 ( N_A_c_41_p N_noxref_5_c_1640_n ) capacitor c=0.0123125f //x=29.93 \
 //y=2.03 //x2=24.54 //y2=2.575
cc_184 ( N_A_c_41_p N_noxref_5_c_1641_n ) capacitor c=0.0831861f //x=29.93 \
 //y=2.03 //x2=12.685 //y2=2.4
cc_185 ( N_A_c_41_p N_noxref_5_c_1642_n ) capacitor c=0.509734f //x=29.93 \
 //y=2.03 //x2=13.285 //y2=2.385
cc_186 ( N_A_c_41_p N_noxref_5_c_1643_n ) capacitor c=0.0588119f //x=29.93 \
 //y=2.03 //x2=18.96 //y2=2.4
cc_187 ( N_A_c_41_p N_noxref_5_c_1644_n ) capacitor c=0.468375f //x=29.93 \
 //y=2.03 //x2=19.56 //y2=2.37
cc_188 ( A N_noxref_5_c_1645_n ) capacitor c=0.00373852f //x=3.82 //y=3.14 \
 //x2=5.625 //y2=3.895
cc_189 ( N_A_c_41_p N_noxref_5_c_1646_n ) capacitor c=0.0170284f //x=29.93 \
 //y=2.03 //x2=11.765 //y2=3.842
cc_190 ( N_A_c_41_p N_noxref_5_c_1647_n ) capacitor c=0.00855544f //x=29.93 \
 //y=2.03 //x2=11.905 //y2=3.842
cc_191 ( N_A_c_41_p N_noxref_5_c_1648_n ) capacitor c=0.0355626f //x=29.93 \
 //y=2.03 //x2=12.495 //y2=2.415
cc_192 ( N_A_c_41_p N_noxref_5_c_1649_n ) capacitor c=0.00128424f //x=29.93 \
 //y=2.03 //x2=14.755 //y2=4.255
cc_193 ( N_A_c_41_p N_noxref_6_c_2359_n ) capacitor c=0.0277136f //x=29.93 \
 //y=2.03 //x2=12.985 //y2=2.02
cc_194 ( N_A_c_41_p N_noxref_6_c_2360_n ) capacitor c=0.0230254f //x=29.93 \
 //y=2.03 //x2=12.785 //y2=2.02
cc_195 ( N_A_c_41_p N_noxref_6_c_2361_n ) capacitor c=0.00407116f //x=29.93 \
 //y=2.03 //x2=13.07 //y2=2.61
cc_196 ( N_A_c_41_p N_noxref_6_c_2362_n ) capacitor c=0.00319821f //x=29.93 \
 //y=2.03 //x2=19.36 //y2=2.41
cc_197 ( N_A_c_41_p N_noxref_6_c_2363_n ) capacitor c=0.00190772f //x=29.93 \
 //y=2.03 //x2=12.7 //y2=1.185
cc_198 ( N_A_c_41_p N_noxref_6_c_2364_n ) capacitor c=0.034562f //x=29.93 \
 //y=2.03 //x2=19.185 //y2=2.755
cc_199 ( N_A_c_41_p SUM ) capacitor c=0.0298822f //x=29.93 //y=2.03 //x2=16.52 \
 //y2=3.51
cc_200 ( N_A_c_41_p SUM ) capacitor c=0.0290946f //x=29.93 //y=2.03 //x2=19.73 \
 //y2=2.77
cc_201 ( N_A_c_41_p N_SUM_c_2663_n ) capacitor c=0.00102186f //x=29.93 \
 //y=2.03 //x2=15.96 //y2=1.305
cc_202 ( N_A_c_41_p N_SUM_c_2664_n ) capacitor c=0.0297141f //x=29.93 //y=2.03 \
 //x2=16.045 //y2=1.835
cc_203 ( N_A_c_41_p N_SUM_c_2665_n ) capacitor c=8.7937e-19 //x=29.93 //y=2.03 \
 //x2=19.29 //y2=1.3
cc_204 ( N_A_c_41_p N_SUM_c_2666_n ) capacitor c=0.0221365f //x=29.93 //y=2.03 \
 //x2=19.375 //y2=1.835
cc_205 ( N_A_c_41_p N_noxref_8_c_2961_n ) capacitor c=0.0085156f //x=29.93 \
 //y=2.03 //x2=18.25 //y2=2.385
cc_206 ( N_A_c_41_p N_noxref_8_c_2962_n ) capacitor c=0.00417397f //x=29.93 \
 //y=2.03 //x2=21.21 //y2=3.335
cc_207 ( N_A_c_41_p N_noxref_8_c_2963_n ) capacitor c=0.0362427f //x=29.93 \
 //y=2.03 //x2=21.495 //y2=2.02
cc_208 ( N_A_c_41_p N_noxref_8_c_2964_n ) capacitor c=0.0143639f //x=29.93 \
 //y=2.03 //x2=21.295 //y2=2.02
cc_209 ( N_A_c_41_p N_noxref_8_c_2965_n ) capacitor c=0.00188895f //x=29.93 \
 //y=2.03 //x2=21.58 //y2=1.185
cc_210 ( N_A_c_41_p N_CIN_c_3283_n ) capacitor c=0.00330343f //x=29.93 \
 //y=2.03 //x2=16.03 //y2=2.415
cc_211 ( N_A_c_41_p N_CIN_c_3284_n ) capacitor c=0.0100495f //x=29.93 //y=2.03 \
 //x2=21.95 //y2=2.265
cc_212 ( N_A_c_41_p N_CIN_c_3285_n ) capacitor c=0.00803084f //x=29.93 \
 //y=2.03 //x2=23.8 //y2=2.26
cc_213 ( N_A_c_41_p N_CIN_c_3286_n ) capacitor c=0.00740591f //x=29.93 \
 //y=2.03 //x2=20.86 //y2=3.14
cc_214 ( N_A_c_41_p N_CIN_c_3287_n ) capacitor c=0.00118209f //x=29.93 \
 //y=2.03 //x2=21.46 //y2=3.11
cc_215 ( N_A_c_41_p N_noxref_10_c_3691_n ) capacitor c=0.0298483f //x=29.93 \
 //y=2.03 //x2=24.925 //y2=1.835
cc_216 ( N_A_c_41_p N_noxref_10_c_3692_n ) capacitor c=0.0345889f //x=29.93 \
 //y=2.03 //x2=25.28 //y2=3.35
cc_217 ( N_A_c_41_p N_noxref_10_c_3693_n ) capacitor c=0.00209788f //x=29.93 \
 //y=2.03 //x2=25.28 //y2=3.67
cc_218 ( N_A_c_41_p N_noxref_10_c_3694_n ) capacitor c=0.0014301f //x=29.93 \
 //y=2.03 //x2=26.76 //y2=3.67
cc_219 ( N_A_c_41_p N_noxref_10_c_3695_n ) capacitor c=0.00104311f //x=29.93 \
 //y=2.03 //x2=24.84 //y2=1.18
cc_220 ( N_A_c_41_p N_noxref_10_c_3696_n ) capacitor c=0.0145974f //x=29.93 \
 //y=2.03 //x2=26.76 //y2=2.265
cc_221 ( N_A_c_41_p N_noxref_10_c_3697_n ) capacitor c=0.0272742f //x=29.93 \
 //y=2.03 //x2=26.595 //y2=3.51
cc_222 ( N_A_c_41_p N_noxref_10_c_3698_n ) capacitor c=0.0052379f //x=29.93 \
 //y=2.03 //x2=25.44 //y2=3.51
cc_223 ( N_A_c_41_p N_noxref_10_c_3699_n ) capacitor c=0.00617554f //x=29.93 \
 //y=2.03 //x2=26.755 //y2=3.51
cc_224 ( A N_noxref_11_c_3938_n ) capacitor c=6.89827e-19 //x=30.09 //y=2.4 \
 //x2=30.235 //y2=5.38
cc_225 ( N_A_c_104_p N_noxref_11_c_3938_n ) capacitor c=0.0227954f //x=30.09 \
 //y=4.735 //x2=30.235 //y2=5.38
cc_226 ( N_A_c_105_p N_noxref_11_c_3938_n ) capacitor c=0.00469257f //x=30.12 \
 //y=4.88 //x2=30.235 //y2=5.38
cc_227 ( N_A_M53_noxref_g N_noxref_11_c_3938_n ) capacitor c=0.00842859f \
 //x=30.13 //y=6.2 //x2=30.235 //y2=5.38
cc_228 ( N_A_c_106_p N_noxref_11_c_3938_n ) capacitor c=9.80377e-19 //x=30.12 \
 //y=4.88 //x2=30.235 //y2=5.38
cc_229 ( N_A_c_152_p N_noxref_11_c_3943_n ) capacitor c=0.00118531f //x=30.125 \
 //y=1.43 //x2=30.39 //y2=1.75
cc_230 ( N_A_c_153_p N_noxref_11_c_3943_n ) capacitor c=0.00466238f //x=30.125 \
 //y=1.74 //x2=30.39 //y2=1.75
cc_231 ( N_A_c_231_p N_noxref_11_c_3943_n ) capacitor c=0.00897029f //x=30.5 \
 //y=1.585 //x2=30.39 //y2=1.75
cc_232 ( N_A_c_162_p N_noxref_11_c_3943_n ) capacitor c=0.00303393f //x=30.655 \
 //y=1.43 //x2=30.39 //y2=1.75
cc_233 ( N_A_c_233_p N_noxref_11_c_3943_n ) capacitor c=0.00348382f //x=30.09 \
 //y=2.095 //x2=30.39 //y2=1.75
cc_234 ( N_A_M54_noxref_g N_noxref_11_c_3948_n ) capacitor c=0.0115937f \
 //x=30.57 //y=6.2 //x2=30.745 //y2=5.38
cc_235 ( N_A_c_231_p N_noxref_11_c_3949_n ) capacitor c=0.00194324f //x=30.5 \
 //y=1.585 //x2=30.745 //y2=1.835
cc_236 ( N_A_c_162_p N_noxref_11_c_3949_n ) capacitor c=0.00323005f //x=30.655 \
 //y=1.43 //x2=30.745 //y2=1.835
cc_237 ( A N_noxref_11_c_3951_n ) capacitor c=0.0374963f //x=30.09 //y=2.77 \
 //x2=30.83 //y2=3.35
cc_238 ( A N_noxref_11_c_3951_n ) capacitor c=0.0150595f //x=30.09 //y=2.4 \
 //x2=30.83 //y2=3.35
cc_239 ( N_A_c_102_p N_noxref_11_c_3951_n ) capacitor c=0.0138184f //x=30.09 \
 //y=2.03 //x2=30.83 //y2=3.35
cc_240 ( N_A_c_119_p N_noxref_11_c_3951_n ) capacitor c=4.71798e-19 //x=30.09 \
 //y=2.26 //x2=30.83 //y2=3.35
cc_241 ( N_A_c_129_p N_noxref_11_c_3951_n ) capacitor c=0.00245815f //x=30.09 \
 //y=2.26 //x2=30.83 //y2=3.35
cc_242 ( N_A_c_233_p N_noxref_11_c_3951_n ) capacitor c=0.00309858f //x=30.09 \
 //y=2.095 //x2=30.83 //y2=3.35
cc_243 ( A N_noxref_11_c_3957_n ) capacitor c=0.0148501f //x=30.09 //y=2.77 \
 //x2=30.83 //y2=3.67
cc_244 ( A N_noxref_11_c_3958_n ) capacitor c=0.0481496f //x=30.09 //y=2.77 \
 //x2=30.83 //y2=5.295
cc_245 ( N_A_c_104_p N_noxref_11_c_3958_n ) capacitor c=0.0166198f //x=30.09 \
 //y=4.735 //x2=30.83 //y2=5.295
cc_246 ( N_A_c_105_p N_noxref_11_c_3958_n ) capacitor c=7.76118e-19 //x=30.12 \
 //y=4.88 //x2=30.83 //y2=5.295
cc_247 ( N_A_c_247_p N_noxref_11_c_3958_n ) capacitor c=0.00816062f //x=30.495 \
 //y=4.97 //x2=30.83 //y2=5.295
cc_248 ( N_A_c_106_p N_noxref_11_c_3958_n ) capacitor c=0.00142201f //x=30.12 \
 //y=4.88 //x2=30.83 //y2=5.295
cc_249 ( A N_noxref_11_c_3963_n ) capacitor c=0.00205201f //x=30.09 //y=2.77 \
 //x2=32.31 //y2=3.35
cc_250 ( A N_noxref_11_c_3964_n ) capacitor c=0.00225537f //x=30.09 //y=2.77 \
 //x2=32.31 //y2=4.76
cc_251 ( N_A_M53_noxref_g N_noxref_11_c_3965_n ) capacitor c=0.00192712f \
 //x=30.13 //y=6.2 //x2=30.35 //y2=5.38
cc_252 ( N_A_M54_noxref_g N_noxref_11_c_3965_n ) capacitor c=0.00291595f \
 //x=30.57 //y=6.2 //x2=30.35 //y2=5.38
cc_253 ( N_A_c_247_p N_noxref_11_c_3965_n ) capacitor c=0.0020909f //x=30.495 \
 //y=4.97 //x2=30.35 //y2=5.38
cc_254 ( N_A_c_150_p N_noxref_11_c_3968_n ) capacitor c=0.00120406f //x=30.125 \
 //y=1.085 //x2=30.39 //y2=1.18
cc_255 ( N_A_c_152_p N_noxref_11_c_3968_n ) capacitor c=0.00218558f //x=30.125 \
 //y=1.43 //x2=30.39 //y2=1.18
cc_256 ( N_A_c_256_p N_noxref_11_c_3968_n ) capacitor c=5.50523e-19 //x=30.5 \
 //y=0.93 //x2=30.39 //y2=1.18
cc_257 ( N_A_c_231_p N_noxref_11_c_3968_n ) capacitor c=5.67071e-19 //x=30.5 \
 //y=1.585 //x2=30.39 //y2=1.18
cc_258 ( N_A_c_159_p N_noxref_11_c_3968_n ) capacitor c=0.00109715f //x=30.655 \
 //y=1.085 //x2=30.39 //y2=1.18
cc_259 ( N_A_c_162_p N_noxref_11_c_3968_n ) capacitor c=0.00312043f //x=30.655 \
 //y=1.43 //x2=30.39 //y2=1.18
cc_260 ( A N_noxref_11_c_3974_n ) capacitor c=6.03895e-19 //x=30.09 //y=2.77 \
 //x2=30.83 //y2=3.51
cc_261 ( A N_noxref_11_c_3975_n ) capacitor c=0.00687742f //x=30.09 //y=2.77 \
 //x2=30.99 //y2=3.51
cc_262 ( N_A_M53_noxref_g N_noxref_11_c_3976_n ) capacitor c=0.0178987f \
 //x=30.13 //y=6.2 //x2=30.35 //y2=5.56
cc_263 ( N_A_M54_noxref_g N_noxref_11_c_3976_n ) capacitor c=0.0178506f \
 //x=30.57 //y=6.2 //x2=30.35 //y2=5.56
cc_264 ( N_A_c_247_p N_noxref_11_c_3976_n ) capacitor c=0.00291714f //x=30.495 \
 //y=4.97 //x2=30.35 //y2=5.56
cc_265 ( N_A_c_150_p N_noxref_11_M16_noxref_d ) capacitor c=0.00137165f \
 //x=30.125 //y=1.085 //x2=30.2 //y2=1.085
cc_266 ( N_A_c_152_p N_noxref_11_M16_noxref_d ) capacitor c=0.00237422f \
 //x=30.125 //y=1.43 //x2=30.2 //y2=1.085
cc_267 ( N_A_c_256_p N_noxref_11_M16_noxref_d ) capacitor c=0.0020782f \
 //x=30.5 //y=0.93 //x2=30.2 //y2=1.085
cc_268 ( N_A_c_231_p N_noxref_11_M16_noxref_d ) capacitor c=0.00356097f \
 //x=30.5 //y=1.585 //x2=30.2 //y2=1.085
cc_269 ( N_A_c_159_p N_noxref_11_M16_noxref_d ) capacitor c=8.50095e-19 \
 //x=30.655 //y=1.085 //x2=30.2 //y2=1.085
cc_270 ( N_A_c_162_p N_noxref_11_M16_noxref_d ) capacitor c=0.00237422f \
 //x=30.655 //y=1.43 //x2=30.2 //y2=1.085
cc_271 ( N_A_c_41_p N_noxref_12_c_4187_n ) capacitor c=0.0274696f //x=29.93 \
 //y=2.03 //x2=27.415 //y2=2.02
cc_272 ( N_A_c_41_p N_noxref_12_c_4188_n ) capacitor c=0.0228856f //x=29.93 \
 //y=2.03 //x2=27.215 //y2=2.02
cc_273 ( A N_noxref_12_c_4189_n ) capacitor c=0.00172352f //x=30.09 //y=2.77 \
 //x2=27.5 //y2=2.99
cc_274 ( N_A_c_41_p N_noxref_12_c_4189_n ) capacitor c=0.0082027f //x=29.93 \
 //y=2.03 //x2=27.5 //y2=2.99
cc_275 ( N_A_c_41_p N_noxref_12_c_4191_n ) capacitor c=0.00254835f //x=29.93 \
 //y=2.03 //x2=27.5 //y2=3.31
cc_276 ( A N_noxref_12_c_4192_n ) capacitor c=0.00349835f //x=30.09 //y=2.77 \
 //x2=27.5 //y2=5.055
cc_277 ( N_A_c_41_p N_noxref_12_c_4193_n ) capacitor c=0.00196949f //x=29.93 \
 //y=2.03 //x2=27.13 //y2=1.185
cc_278 ( A N_noxref_12_c_4194_n ) capacitor c=0.0297844f //x=30.09 //y=2.77 \
 //x2=30.445 //y2=3.14
cc_279 ( A N_noxref_12_c_4194_n ) capacitor c=0.00223598f //x=30.09 //y=2.4 \
 //x2=30.445 //y2=3.14
cc_280 ( N_A_c_104_p N_noxref_12_c_4194_n ) capacitor c=0.00167652f //x=30.09 \
 //y=4.735 //x2=30.445 //y2=3.14
cc_281 ( N_A_c_41_p N_noxref_12_c_4194_n ) capacitor c=0.0712866f //x=29.93 \
 //y=2.03 //x2=30.445 //y2=3.14
cc_282 ( N_A_c_102_p N_noxref_12_c_4194_n ) capacitor c=0.0127505f //x=30.09 \
 //y=2.03 //x2=30.445 //y2=3.14
cc_283 ( N_A_c_41_p N_noxref_12_c_4199_n ) capacitor c=0.00845953f //x=29.93 \
 //y=2.03 //x2=27.66 //y2=3.15
cc_284 ( N_A_c_31_p N_VDD_c_4990_n ) capacitor c=3.15774e-19 //x=1.23 //y=4.41 \
 //x2=3.855 //y2=7.585
cc_285 ( N_A_c_32_p N_VDD_c_4990_n ) capacitor c=5.73987e-19 //x=1.23 //y=4.76 \
 //x2=3.855 //y2=7.585
cc_286 ( N_A_c_38_p N_VDD_c_4990_n ) capacitor c=3.40755e-19 //x=1.23 //y=4.88 \
 //x2=3.855 //y2=7.585
cc_287 ( N_A_M23_noxref_g N_VDD_c_4993_n ) capacitor c=0.00404722f //x=3.72 \
 //y=6.2 //x2=3.94 //y2=6.7
cc_288 ( N_A_M24_noxref_g N_VDD_c_4993_n ) capacitor c=0.00381678f //x=4.16 \
 //y=6.2 //x2=3.94 //y2=6.7
cc_289 ( N_A_M23_noxref_g N_VDD_c_4995_n ) capacitor c=0.00543844f //x=3.72 \
 //y=6.2 //x2=3.94 //y2=7.41
cc_290 ( N_A_M24_noxref_g N_VDD_c_4995_n ) capacitor c=0.00573531f //x=4.16 \
 //y=6.2 //x2=3.94 //y2=7.41
cc_291 ( N_A_c_31_p N_VDD_c_4997_n ) capacitor c=2.9011e-19 //x=1.23 //y=4.41 \
 //x2=1.96 //y2=7.585
cc_292 ( N_A_c_32_p N_VDD_c_4997_n ) capacitor c=5.49211e-19 //x=1.23 //y=4.76 \
 //x2=1.96 //y2=7.585
cc_293 ( N_A_M21_noxref_g N_VDD_c_4997_n ) capacitor c=0.00753931f //x=1.385 \
 //y=6.2 //x2=1.96 //y2=7.585
cc_294 ( N_A_M22_noxref_g N_VDD_c_4997_n ) capacitor c=0.00755544f //x=1.825 \
 //y=6.2 //x2=1.96 //y2=7.585
cc_295 ( N_A_M23_noxref_g N_VDD_c_5001_n ) capacitor c=0.00732618f //x=3.72 \
 //y=6.2 //x2=5.87 //y2=7.585
cc_296 ( N_A_M24_noxref_g N_VDD_c_5001_n ) capacitor c=0.00773472f //x=4.16 \
 //y=6.2 //x2=5.87 //y2=7.585
cc_297 ( N_A_M53_noxref_g N_VDD_c_5003_n ) capacitor c=0.00697352f //x=30.13 \
 //y=6.2 //x2=30.705 //y2=7.585
cc_298 ( N_A_M54_noxref_g N_VDD_c_5003_n ) capacitor c=0.00755544f //x=30.57 \
 //y=6.2 //x2=30.705 //y2=7.585
cc_299 ( A N_VDD_c_5005_n ) capacitor c=0.0101939f //x=1.23 //y=4.62 //x2=1.23 \
 //y2=7.58
cc_300 ( A N_VDD_c_5005_n ) capacitor c=0.00438735f //x=1.23 //y=4.25 \
 //x2=1.23 //y2=7.58
cc_301 ( N_A_c_31_p N_VDD_c_5005_n ) capacitor c=0.002608f //x=1.23 //y=4.41 \
 //x2=1.23 //y2=7.58
cc_302 ( N_A_c_32_p N_VDD_c_5005_n ) capacitor c=0.00877359f //x=1.23 //y=4.76 \
 //x2=1.23 //y2=7.58
cc_303 ( N_A_c_38_p N_VDD_c_5005_n ) capacitor c=0.00795776f //x=1.23 //y=4.88 \
 //x2=1.23 //y2=7.58
cc_304 ( N_A_M21_noxref_g N_VDD_c_5005_n ) capacitor c=0.0150194f //x=1.385 \
 //y=6.2 //x2=1.23 //y2=7.58
cc_305 ( N_A_c_40_p N_VDD_c_5005_n ) capacitor c=0.00799922f //x=1.46 //y=4.97 \
 //x2=1.23 //y2=7.58
cc_306 ( A N_VDD_c_5012_n ) capacitor c=0.00542852f //x=3.82 //y=4.62 \
 //x2=2.71 //y2=7.585
cc_307 ( A N_VDD_c_5012_n ) capacitor c=0.00133334f //x=1.23 //y=4.25 \
 //x2=2.71 //y2=7.585
cc_308 ( A N_VDD_c_5012_n ) capacitor c=0.00247452f //x=3.82 //y=4.25 \
 //x2=2.71 //y2=7.585
cc_309 ( N_A_c_33_p N_VDD_c_5012_n ) capacitor c=0.00129292f //x=3.82 \
 //y=4.415 //x2=2.71 //y2=7.585
cc_310 ( N_A_c_34_p N_VDD_c_5012_n ) capacitor c=0.00383877f //x=3.82 \
 //y=4.765 //x2=2.71 //y2=7.585
cc_311 ( N_A_c_6_p N_VDD_c_5012_n ) capacitor c=0.0192133f //x=3.655 //y=4.255 \
 //x2=2.71 //y2=7.585
cc_312 ( N_A_c_38_p N_VDD_c_5012_n ) capacitor c=0.00235165f //x=1.23 //y=4.88 \
 //x2=2.71 //y2=7.585
cc_313 ( N_A_c_77_p N_VDD_c_5012_n ) capacitor c=0.00370212f //x=3.82 //y=4.88 \
 //x2=2.71 //y2=7.585
cc_314 ( N_A_c_15_p N_VDD_c_5012_n ) capacitor c=0.00838585f //x=1.75 //y=4.97 \
 //x2=2.71 //y2=7.585
cc_315 ( N_A_c_40_p N_VDD_c_5012_n ) capacitor c=2.63786e-19 //x=1.46 //y=4.97 \
 //x2=2.71 //y2=7.585
cc_316 ( N_A_c_78_p N_VDD_c_5012_n ) capacitor c=0.0160934f //x=3.82 //y=4.88 \
 //x2=2.71 //y2=7.585
cc_317 ( N_A_c_105_p N_VDD_c_5023_n ) capacitor c=0.00226427f //x=30.12 \
 //y=4.88 //x2=31.57 //y2=7.585
cc_318 ( N_A_c_247_p N_VDD_c_5023_n ) capacitor c=0.0128988f //x=30.495 \
 //y=4.97 //x2=31.57 //y2=7.585
cc_319 ( N_A_c_106_p N_VDD_c_5023_n ) capacitor c=2.73429e-19 //x=30.12 \
 //y=4.88 //x2=31.57 //y2=7.585
cc_320 ( N_A_c_31_p N_VDD_M21_noxref_s ) capacitor c=0.0021098f //x=1.23 \
 //y=4.41 //x2=1.03 //y2=5.2
cc_321 ( N_A_c_32_p N_VDD_M21_noxref_s ) capacitor c=0.0209128f //x=1.23 \
 //y=4.76 //x2=1.03 //y2=5.2
cc_322 ( N_A_c_35_p N_VDD_M21_noxref_s ) capacitor c=6.57934e-19 //x=1.39 \
 //y=4.25 //x2=1.03 //y2=5.2
cc_323 ( N_A_c_38_p N_VDD_M21_noxref_s ) capacitor c=0.00986169f //x=1.23 \
 //y=4.88 //x2=1.03 //y2=5.2
cc_324 ( N_A_M21_noxref_g N_VDD_M21_noxref_s ) capacitor c=0.0573441f \
 //x=1.385 //y=6.2 //x2=1.03 //y2=5.2
cc_325 ( N_A_c_40_p N_VDD_M21_noxref_s ) capacitor c=0.00531638f //x=1.46 \
 //y=4.97 //x2=1.03 //y2=5.2
cc_326 ( N_A_c_6_p N_VDD_M22_noxref_d ) capacitor c=0.00270385f //x=3.655 \
 //y=4.255 //x2=1.9 //y2=5.2
cc_327 ( N_A_M22_noxref_g N_VDD_M22_noxref_d ) capacitor c=0.0572684f \
 //x=1.825 //y=6.2 //x2=1.9 //y2=5.2
cc_328 ( N_A_c_77_p N_VDD_M23_noxref_d ) capacitor c=0.00152867f //x=3.82 \
 //y=4.88 //x2=3.795 //y2=5.2
cc_329 ( N_A_M23_noxref_g N_VDD_M23_noxref_d ) capacitor c=0.00896756f \
 //x=3.72 //y=6.2 //x2=3.795 //y2=5.2
cc_330 ( N_A_M24_noxref_g N_VDD_M23_noxref_d ) capacitor c=0.00896756f \
 //x=4.16 //y=6.2 //x2=3.795 //y2=5.2
cc_331 ( N_A_c_78_p N_VDD_M23_noxref_d ) capacitor c=0.00340537f //x=3.82 \
 //y=4.88 //x2=3.795 //y2=5.2
cc_332 ( N_A_M53_noxref_g N_VDD_M52_noxref_d ) capacitor c=0.015318f //x=30.13 \
 //y=6.2 //x2=29.765 //y2=5.2
cc_333 ( N_A_c_106_p N_VDD_M52_noxref_d ) capacitor c=3.32552e-19 //x=30.12 \
 //y=4.88 //x2=29.765 //y2=5.2
cc_334 ( N_A_M54_noxref_g N_VDD_M54_noxref_d ) capacitor c=0.0430452f \
 //x=30.57 //y=6.2 //x2=30.645 //y2=5.2
cc_335 ( N_A_c_33_p N_noxref_16_c_5802_n ) capacitor c=0.00177848f //x=3.82 \
 //y=4.415 //x2=4.26 //y2=5.385
cc_336 ( N_A_c_34_p N_noxref_16_c_5802_n ) capacitor c=0.0209584f //x=3.82 \
 //y=4.765 //x2=4.26 //y2=5.385
cc_337 ( N_A_c_36_p N_noxref_16_c_5802_n ) capacitor c=0.00177887f //x=3.815 \
 //y=4.255 //x2=4.26 //y2=5.385
cc_338 ( N_A_c_77_p N_noxref_16_c_5802_n ) capacitor c=0.00412201f //x=3.82 \
 //y=4.88 //x2=4.26 //y2=5.385
cc_339 ( N_A_M23_noxref_g N_noxref_16_c_5802_n ) capacitor c=0.0102378f \
 //x=3.72 //y=6.2 //x2=4.26 //y2=5.385
cc_340 ( N_A_M24_noxref_g N_noxref_16_c_5802_n ) capacitor c=0.0136385f \
 //x=4.16 //y=6.2 //x2=4.26 //y2=5.385
cc_341 ( N_A_c_78_p N_noxref_16_c_5802_n ) capacitor c=0.00186993f //x=3.82 \
 //y=4.88 //x2=4.26 //y2=5.385
cc_342 ( N_A_c_33_p N_noxref_16_c_5809_n ) capacitor c=0.00206409f //x=3.82 \
 //y=4.415 //x2=3.507 //y2=5.385
cc_343 ( N_A_c_6_p N_noxref_16_c_5809_n ) capacitor c=0.00635846f //x=3.655 \
 //y=4.255 //x2=3.507 //y2=5.385
cc_344 ( N_A_M23_noxref_g N_noxref_16_c_5809_n ) capacitor c=0.00402951f \
 //x=3.72 //y=6.2 //x2=3.507 //y2=5.385
cc_345 ( N_A_M24_noxref_g N_noxref_16_c_5812_n ) capacitor c=0.00178158f \
 //x=4.16 //y=6.2 //x2=4.38 //y2=5.385
cc_346 ( N_A_M24_noxref_g N_noxref_16_c_5813_n ) capacitor c=0.00182026f \
 //x=4.16 //y=6.2 //x2=4.38 //y2=6.915
cc_347 ( N_A_c_33_p N_noxref_16_c_5814_n ) capacitor c=3.5629e-19 //x=3.82 \
 //y=4.415 //x2=3.5 //y2=5.555
cc_348 ( N_A_M23_noxref_g N_noxref_16_c_5814_n ) capacitor c=0.0467484f \
 //x=3.72 //y=6.2 //x2=3.5 //y2=5.555
cc_349 ( N_A_M24_noxref_g N_noxref_16_c_5816_n ) capacitor c=0.0184757f \
 //x=4.16 //y=6.2 //x2=4.38 //y2=5.555
cc_350 ( N_A_M23_noxref_g N_noxref_16_M23_noxref_s ) capacitor c=0.0057176f \
 //x=3.72 //y=6.2 //x2=3.365 //y2=5.2
cc_351 ( A N_GND_c_6122_n ) capacitor c=3.742e-19 //x=3.82 //y=2.4 //x2=3.805 \
 //y2=0.175
cc_352 ( N_A_c_31_p N_GND_c_6122_n ) capacitor c=2.72213e-19 //x=1.23 //y=4.41 \
 //x2=3.805 //y2=0.175
cc_353 ( N_A_c_19_p N_GND_c_6122_n ) capacitor c=0.00249122f //x=1.23 \
 //y=2.265 //x2=3.805 //y2=0.175
cc_354 ( N_A_c_9_p N_GND_c_6122_n ) capacitor c=0.00264656f //x=3.815 //y=2.03 \
 //x2=3.805 //y2=0.175
cc_355 ( N_A_c_21_p N_GND_c_6122_n ) capacitor c=7.5371e-19 //x=1.23 //y=2.265 \
 //x2=3.805 //y2=0.175
cc_356 ( A N_GND_c_6127_n ) capacitor c=0.00397998f //x=3.82 //y=2.4 //x2=3.89 \
 //y2=1.025
cc_357 ( N_A_c_41_p N_GND_c_6127_n ) capacitor c=0.00111714f //x=29.93 \
 //y=2.03 //x2=3.89 //y2=1.025
cc_358 ( N_A_c_9_p N_GND_c_6127_n ) capacitor c=0.00738307f //x=3.815 //y=2.03 \
 //x2=3.89 //y2=1.025
cc_359 ( N_A_c_110_p N_GND_c_6127_n ) capacitor c=4.20185e-19 //x=3.82 \
 //y=2.265 //x2=3.89 //y2=1.025
cc_360 ( N_A_c_137_p N_GND_c_6127_n ) capacitor c=0.00146326f //x=3.625 \
 //y=1.05 //x2=3.89 //y2=1.025
cc_361 ( N_A_c_138_p N_GND_c_6127_n ) capacitor c=0.00305617f //x=3.625 \
 //y=1.395 //x2=3.89 //y2=1.025
cc_362 ( N_A_c_362_p N_GND_c_6127_n ) capacitor c=0.00923673f //x=4 //y=0.895 \
 //x2=3.89 //y2=1.025
cc_363 ( N_A_c_363_p N_GND_c_6127_n ) capacitor c=6.12665e-19 //x=4 //y=1.55 \
 //x2=3.89 //y2=1.025
cc_364 ( N_A_c_139_p N_GND_c_6127_n ) capacitor c=0.00176231f //x=4.155 \
 //y=1.05 //x2=3.89 //y2=1.025
cc_365 ( N_A_c_141_p N_GND_c_6127_n ) capacitor c=0.00234543f //x=4.155 \
 //y=1.395 //x2=3.89 //y2=1.025
cc_366 ( N_A_c_41_p N_GND_c_6137_n ) capacitor c=0.096622f //x=29.93 //y=2.03 \
 //x2=7.135 //y2=0.175
cc_367 ( N_A_c_41_p N_GND_c_6138_n ) capacitor c=0.00794268f //x=29.93 \
 //y=2.03 //x2=7.22 //y2=1.025
cc_368 ( N_A_c_41_p N_GND_c_6139_n ) capacitor c=0.249608f //x=29.93 //y=2.03 \
 //x2=14.905 //y2=0.175
cc_369 ( N_A_c_41_p N_GND_c_6140_n ) capacitor c=0.00817918f //x=29.93 \
 //y=2.03 //x2=14.99 //y2=1.025
cc_370 ( N_A_c_41_p N_GND_c_6141_n ) capacitor c=0.096622f //x=29.93 //y=2.03 \
 //x2=18.235 //y2=0.175
cc_371 ( N_A_c_41_p N_GND_c_6142_n ) capacitor c=0.00794268f //x=29.93 \
 //y=2.03 //x2=18.32 //y2=1.025
cc_372 ( N_A_c_41_p N_GND_c_6143_n ) capacitor c=0.17557f //x=29.93 //y=2.03 \
 //x2=23.785 //y2=0.175
cc_373 ( N_A_c_41_p N_GND_c_6144_n ) capacitor c=0.170957f //x=29.93 //y=2.03 \
 //x2=29.335 //y2=0.175
cc_374 ( A N_GND_c_6145_n ) capacitor c=8.49153e-19 //x=30.09 //y=2.4 \
 //x2=38.97 //y2=0.18
cc_375 ( N_A_c_41_p N_GND_c_6145_n ) capacitor c=0.0214127f //x=29.93 //y=2.03 \
 //x2=38.97 //y2=0.18
cc_376 ( N_A_c_102_p N_GND_c_6145_n ) capacitor c=0.00137556f //x=30.09 \
 //y=2.03 //x2=38.97 //y2=0.18
cc_377 ( N_A_c_41_p N_GND_c_6148_n ) capacitor c=0.00912669f //x=29.93 \
 //y=2.03 //x2=23.87 //y2=1.135
cc_378 ( N_A_c_41_p N_GND_c_6149_n ) capacitor c=0.00916389f //x=29.93 \
 //y=2.03 //x2=29.42 //y2=1.135
cc_379 ( N_A_c_19_p N_GND_c_6150_n ) capacitor c=0.00114179f //x=1.23 \
 //y=2.265 //x2=1.515 //y2=0.715
cc_380 ( N_A_c_21_p N_GND_c_6150_n ) capacitor c=3.95714e-19 //x=1.23 \
 //y=2.265 //x2=1.515 //y2=0.715
cc_381 ( N_A_c_44_p N_GND_c_6150_n ) capacitor c=0.0125549f //x=1.34 //y=1.09 \
 //x2=1.515 //y2=0.715
cc_382 ( N_A_c_11_p N_GND_c_6150_n ) capacitor c=2.1838e-19 //x=1.23 //y=2.265 \
 //x2=1.515 //y2=0.715
cc_383 ( N_A_c_48_p N_GND_c_6154_n ) capacitor c=0.0130753f //x=1.87 //y=1.09 \
 //x2=2.005 //y2=0.715
cc_384 ( N_A_c_137_p N_GND_c_6155_n ) capacitor c=0.00686606f //x=3.625 \
 //y=1.05 //x2=5.87 //y2=0.175
cc_385 ( N_A_c_41_p N_GND_c_6156_n ) capacitor c=0.0035335f //x=29.93 //y=2.03 \
 //x2=10.875 //y2=0.715
cc_386 ( N_A_c_41_p N_GND_c_6157_n ) capacitor c=0.00326922f //x=29.93 \
 //y=2.03 //x2=12.615 //y2=0.715
cc_387 ( N_A_c_41_p N_GND_c_6158_n ) capacitor c=0.0035335f //x=29.93 //y=2.03 \
 //x2=21.975 //y2=0.715
cc_388 ( N_A_c_41_p N_GND_c_6159_n ) capacitor c=0.00288644f //x=29.93 \
 //y=2.03 //x2=27.045 //y2=0.715
cc_389 ( A N_GND_c_6160_n ) capacitor c=2.82937e-19 //x=30.09 //y=2.4 \
 //x2=31.4 //y2=0.175
cc_390 ( A N_GND_c_6161_n ) capacitor c=0.0137647f //x=1.23 //y=2.77 //x2=1.12 \
 //y2=0.175
cc_391 ( N_A_c_19_p N_GND_c_6161_n ) capacitor c=0.0100674f //x=1.23 //y=2.265 \
 //x2=1.12 //y2=0.175
cc_392 ( N_A_c_21_p N_GND_c_6161_n ) capacitor c=0.00733542f //x=1.23 \
 //y=2.265 //x2=1.12 //y2=0.175
cc_393 ( N_A_c_3_p N_GND_c_6161_n ) capacitor c=0.00552086f //x=1.34 //y=2.1 \
 //x2=1.12 //y2=0.175
cc_394 ( N_A_c_11_p N_GND_c_6161_n ) capacitor c=0.00785621f //x=1.23 \
 //y=2.265 //x2=1.12 //y2=0.175
cc_395 ( A N_GND_c_6166_n ) capacitor c=0.00662563f //x=3.82 //y=3.14 \
 //x2=2.71 //y2=0.175
cc_396 ( A N_GND_c_6166_n ) capacitor c=0.00285151f //x=3.82 //y=2.4 //x2=2.71 \
 //y2=0.175
cc_397 ( N_A_c_6_p N_GND_c_6166_n ) capacitor c=0.00224398f //x=3.655 \
 //y=4.255 //x2=2.71 //y2=0.175
cc_398 ( N_A_c_9_p N_GND_c_6166_n ) capacitor c=0.0039187f //x=3.815 //y=2.03 \
 //x2=2.71 //y2=0.175
cc_399 ( N_A_c_21_p N_GND_c_6166_n ) capacitor c=0.00230732f //x=1.23 \
 //y=2.265 //x2=2.71 //y2=0.175
cc_400 ( N_A_c_110_p N_GND_c_6166_n ) capacitor c=0.00389754f //x=3.82 \
 //y=2.265 //x2=2.71 //y2=0.175
cc_401 ( N_A_c_126_p N_GND_c_6166_n ) capacitor c=0.00800313f //x=3.625 \
 //y=2.1 //x2=2.71 //y2=0.175
cc_402 ( N_A_c_41_p N_GND_c_6173_n ) capacitor c=0.023823f //x=29.93 //y=2.03 \
 //x2=6.04 //y2=0.175
cc_403 ( N_A_c_110_p N_GND_c_6173_n ) capacitor c=3.67777e-19 //x=3.82 \
 //y=2.265 //x2=6.04 //y2=0.175
cc_404 ( N_A_c_41_p N_GND_c_6175_n ) capacitor c=0.0229203f //x=29.93 //y=2.03 \
 //x2=9.37 //y2=0.175
cc_405 ( N_A_c_41_p N_GND_c_6176_n ) capacitor c=0.0237645f //x=29.93 //y=2.03 \
 //x2=11.59 //y2=0.175
cc_406 ( N_A_c_41_p N_GND_c_6177_n ) capacitor c=0.0214814f //x=29.93 //y=2.03 \
 //x2=13.81 //y2=0.175
cc_407 ( N_A_c_41_p N_GND_c_6178_n ) capacitor c=0.0217617f //x=29.93 //y=2.03 \
 //x2=17.14 //y2=0.175
cc_408 ( N_A_c_41_p N_GND_c_6179_n ) capacitor c=0.0214814f //x=29.93 //y=2.03 \
 //x2=20.47 //y2=0.175
cc_409 ( N_A_c_41_p N_GND_c_6180_n ) capacitor c=0.0214814f //x=29.93 //y=2.03 \
 //x2=22.69 //y2=0.175
cc_410 ( N_A_c_41_p N_GND_c_6181_n ) capacitor c=0.0235202f //x=29.93 //y=2.03 \
 //x2=26.02 //y2=0.175
cc_411 ( N_A_c_41_p N_GND_c_6182_n ) capacitor c=0.0227355f //x=29.93 //y=2.03 \
 //x2=28.24 //y2=0.175
cc_412 ( N_A_c_119_p N_GND_c_6183_n ) capacitor c=0.00230732f //x=30.09 \
 //y=2.26 //x2=31.57 //y2=0.175
cc_413 ( N_A_c_162_p N_GND_c_6183_n ) capacitor c=0.00275184f //x=30.655 \
 //y=1.43 //x2=31.57 //y2=0.175
cc_414 ( N_A_c_31_p N_GND_M0_noxref_s ) capacitor c=2.12547e-19 //x=1.23 \
 //y=4.41 //x2=0.985 //y2=0.55
cc_415 ( N_A_c_19_p N_GND_M0_noxref_s ) capacitor c=0.00297876f //x=1.23 \
 //y=2.265 //x2=0.985 //y2=0.55
cc_416 ( N_A_c_21_p N_GND_M0_noxref_s ) capacitor c=0.00651326f //x=1.23 \
 //y=2.265 //x2=0.985 //y2=0.55
cc_417 ( N_A_c_44_p N_GND_M0_noxref_s ) capacitor c=0.0300238f //x=1.34 \
 //y=1.09 //x2=0.985 //y2=0.55
cc_418 ( N_A_c_2_p N_GND_M0_noxref_s ) capacitor c=0.002132f //x=1.34 \
 //y=1.745 //x2=0.985 //y2=0.55
cc_419 ( N_A_c_3_p N_GND_M0_noxref_s ) capacitor c=0.00304786f //x=1.34 \
 //y=2.1 //x2=0.985 //y2=0.55
cc_420 ( N_A_c_46_p N_GND_M0_noxref_s ) capacitor c=0.00517463f //x=1.715 \
 //y=0.935 //x2=0.985 //y2=0.55
cc_421 ( N_A_c_48_p N_GND_M0_noxref_s ) capacitor c=0.0153553f //x=1.87 \
 //y=1.09 //x2=0.985 //y2=0.55
cc_422 ( N_A_c_5_p N_GND_M0_noxref_s ) capacitor c=0.00629878f //x=1.87 \
 //y=1.435 //x2=0.985 //y2=0.55
cc_423 ( N_A_c_11_p N_GND_M0_noxref_s ) capacitor c=0.00660555f //x=1.23 \
 //y=2.265 //x2=0.985 //y2=0.55
cc_424 ( A N_GND_M1_noxref_d ) capacitor c=2.22842e-19 //x=3.82 //y=2.4 \
 //x2=3.7 //y2=1.05
cc_425 ( N_A_c_137_p N_GND_M1_noxref_d ) capacitor c=0.00192399f //x=3.625 \
 //y=1.05 //x2=3.7 //y2=1.05
cc_426 ( N_A_c_138_p N_GND_M1_noxref_d ) capacitor c=0.00210798f //x=3.625 \
 //y=1.395 //x2=3.7 //y2=1.05
cc_427 ( N_A_c_362_p N_GND_M1_noxref_d ) capacitor c=0.00473146f //x=4 \
 //y=0.895 //x2=3.7 //y2=1.05
cc_428 ( N_A_c_363_p N_GND_M1_noxref_d ) capacitor c=0.00166857f //x=4 \
 //y=1.55 //x2=3.7 //y2=1.05
cc_429 ( N_A_c_139_p N_GND_M1_noxref_d ) capacitor c=0.00230174f //x=4.155 \
 //y=1.05 //x2=3.7 //y2=1.05
cc_430 ( N_A_c_141_p N_GND_M1_noxref_d ) capacitor c=0.00210798f //x=4.155 \
 //y=1.395 //x2=3.7 //y2=1.05
cc_431 ( N_A_c_41_p N_GND_M5_noxref_s ) capacitor c=0.00881561f //x=29.93 \
 //y=2.03 //x2=9.865 //y2=0.55
cc_432 ( N_A_c_41_p N_GND_M6_noxref_s ) capacitor c=0.00890542f //x=29.93 \
 //y=2.03 //x2=12.085 //y2=0.55
cc_433 ( N_A_c_41_p N_GND_M11_noxref_s ) capacitor c=0.00881561f //x=29.93 \
 //y=2.03 //x2=20.965 //y2=0.55
cc_434 ( N_A_c_41_p N_GND_M14_noxref_s ) capacitor c=0.00890542f //x=29.93 \
 //y=2.03 //x2=26.515 //y2=0.55
cc_435 ( N_A_c_126_p N_noxref_23_c_7114_n ) capacitor c=0.00262672f //x=3.625 \
 //y=2.1 //x2=3.405 //y2=1.68
cc_436 ( A N_noxref_23_c_7115_n ) capacitor c=0.00713503f //x=3.82 //y=2.4 \
 //x2=4.29 //y2=1.765
cc_437 ( N_A_c_33_p N_noxref_23_c_7115_n ) capacitor c=0.00209719f //x=3.82 \
 //y=4.415 //x2=4.29 //y2=1.765
cc_438 ( N_A_c_9_p N_noxref_23_c_7115_n ) capacitor c=0.0127895f //x=3.815 \
 //y=2.03 //x2=4.29 //y2=1.765
cc_439 ( N_A_c_110_p N_noxref_23_c_7115_n ) capacitor c=0.00774821f //x=3.82 \
 //y=2.265 //x2=4.29 //y2=1.765
cc_440 ( N_A_c_140_p N_noxref_23_c_7115_n ) capacitor c=0.00696355f //x=3.625 \
 //y=1.705 //x2=4.29 //y2=1.765
cc_441 ( N_A_c_126_p N_noxref_23_c_7115_n ) capacitor c=0.0168516f //x=3.625 \
 //y=2.1 //x2=4.29 //y2=1.765
cc_442 ( N_A_c_363_p N_noxref_23_c_7115_n ) capacitor c=0.00729332f //x=4 \
 //y=1.55 //x2=4.29 //y2=1.765
cc_443 ( N_A_c_141_p N_noxref_23_c_7115_n ) capacitor c=0.0034036f //x=4.155 \
 //y=1.395 //x2=4.29 //y2=1.765
cc_444 ( N_A_c_41_p N_noxref_23_c_7123_n ) capacitor c=0.00528868f //x=29.93 \
 //y=2.03 //x2=4.375 //y2=1.68
cc_445 ( N_A_c_126_p N_noxref_23_c_7123_n ) capacitor c=6.71402e-19 //x=3.625 \
 //y=2.1 //x2=4.375 //y2=1.68
cc_446 ( N_A_c_41_p N_noxref_23_c_7125_n ) capacitor c=0.00326568f //x=29.93 \
 //y=2.03 //x2=5.26 //y2=0.715
cc_447 ( N_A_c_137_p N_noxref_23_M1_noxref_s ) capacitor c=0.0294925f \
 //x=3.625 //y=1.05 //x2=3.27 //y2=0.55
cc_448 ( N_A_c_140_p N_noxref_23_M1_noxref_s ) capacitor c=3.48408e-19 \
 //x=3.625 //y=1.705 //x2=3.27 //y2=0.55
cc_449 ( N_A_c_139_p N_noxref_23_M1_noxref_s ) capacitor c=0.0125442f \
 //x=4.155 //y=1.05 //x2=3.27 //y2=0.55
cc_450 ( N_A_c_41_p N_noxref_24_c_7176_n ) capacitor c=0.00528868f //x=29.93 \
 //y=2.03 //x2=6.735 //y2=1.68
cc_451 ( N_A_c_41_p N_noxref_24_c_7177_n ) capacitor c=0.0195015f //x=29.93 \
 //y=2.03 //x2=7.62 //y2=1.765
cc_452 ( N_A_c_41_p N_noxref_24_c_7178_n ) capacitor c=0.00528868f //x=29.93 \
 //y=2.03 //x2=7.705 //y2=1.68
cc_453 ( N_A_c_41_p N_noxref_24_c_7179_n ) capacitor c=0.00350679f //x=29.93 \
 //y=2.03 //x2=8.59 //y2=0.715
cc_454 ( N_A_c_41_p N_noxref_24_M3_noxref_s ) capacitor c=0.00126386f \
 //x=29.93 //y=2.03 //x2=6.6 //y2=0.55
cc_455 ( N_A_c_41_p N_noxref_25_c_7240_n ) capacitor c=0.00528868f //x=29.93 \
 //y=2.03 //x2=14.505 //y2=1.68
cc_456 ( N_A_c_41_p N_noxref_25_c_7241_n ) capacitor c=0.0188692f //x=29.93 \
 //y=2.03 //x2=15.39 //y2=1.765
cc_457 ( N_A_c_41_p N_noxref_25_c_7242_n ) capacitor c=0.00528868f //x=29.93 \
 //y=2.03 //x2=15.475 //y2=1.68
cc_458 ( N_A_c_41_p N_noxref_25_c_7243_n ) capacitor c=0.00326568f //x=29.93 \
 //y=2.03 //x2=16.36 //y2=0.715
cc_459 ( N_A_c_41_p N_noxref_26_c_7301_n ) capacitor c=0.00528868f //x=29.93 \
 //y=2.03 //x2=17.835 //y2=1.68
cc_460 ( N_A_c_41_p N_noxref_26_c_7302_n ) capacitor c=0.0193964f //x=29.93 \
 //y=2.03 //x2=18.72 //y2=1.765
cc_461 ( N_A_c_41_p N_noxref_26_c_7303_n ) capacitor c=0.00528868f //x=29.93 \
 //y=2.03 //x2=18.805 //y2=1.68
cc_462 ( N_A_c_41_p N_noxref_26_c_7304_n ) capacitor c=0.00350679f //x=29.93 \
 //y=2.03 //x2=19.69 //y2=0.715
cc_463 ( N_A_c_41_p N_noxref_26_M9_noxref_s ) capacitor c=0.00126386f \
 //x=29.93 //y=2.03 //x2=17.7 //y2=0.55
cc_464 ( N_A_c_41_p N_noxref_27_c_7365_n ) capacitor c=0.00527352f //x=29.93 \
 //y=2.03 //x2=23.385 //y2=1.675
cc_465 ( N_A_c_41_p N_noxref_27_c_7366_n ) capacitor c=0.0187993f //x=29.93 \
 //y=2.03 //x2=24.27 //y2=1.76
cc_466 ( N_A_c_41_p N_noxref_27_c_7367_n ) capacitor c=0.0054187f //x=29.93 \
 //y=2.03 //x2=24.355 //y2=1.675
cc_467 ( N_A_c_41_p N_noxref_27_c_7368_n ) capacitor c=0.00306082f //x=29.93 \
 //y=2.03 //x2=25.24 //y2=0.71
cc_468 ( N_A_c_41_p N_noxref_27_M12_noxref_s ) capacitor c=0.00126107f \
 //x=29.93 //y=2.03 //x2=23.25 //y2=0.545
cc_469 ( N_A_c_41_p N_noxref_28_c_7431_n ) capacitor c=0.00527352f //x=29.93 \
 //y=2.03 //x2=28.935 //y2=1.675
cc_470 ( N_A_c_41_p N_noxref_28_c_7432_n ) capacitor c=0.0191487f //x=29.93 \
 //y=2.03 //x2=29.82 //y2=1.76
cc_471 ( A N_noxref_28_c_7433_n ) capacitor c=0.00279605f //x=30.09 //y=2.4 \
 //x2=29.905 //y2=1.675
cc_472 ( N_A_c_41_p N_noxref_28_c_7433_n ) capacitor c=0.0060086f //x=29.93 \
 //y=2.03 //x2=29.905 //y2=1.675
cc_473 ( N_A_c_153_p N_noxref_28_c_7433_n ) capacitor c=0.00888238f //x=30.125 \
 //y=1.74 //x2=29.905 //y2=1.675
cc_474 ( N_A_c_129_p N_noxref_28_c_7433_n ) capacitor c=0.0017348f //x=30.09 \
 //y=2.26 //x2=29.905 //y2=1.675
cc_475 ( A N_noxref_28_c_7437_n ) capacitor c=0.00153432f //x=30.09 //y=2.4 \
 //x2=30.79 //y2=0.71
cc_476 ( N_A_c_102_p N_noxref_28_c_7437_n ) capacitor c=0.0017768f //x=30.09 \
 //y=2.03 //x2=30.79 //y2=0.71
cc_477 ( N_A_c_119_p N_noxref_28_c_7437_n ) capacitor c=8.82141e-19 //x=30.09 \
 //y=2.26 //x2=30.79 //y2=0.71
cc_478 ( N_A_c_150_p N_noxref_28_c_7437_n ) capacitor c=0.0200262f //x=30.125 \
 //y=1.085 //x2=30.79 //y2=0.71
cc_479 ( N_A_c_159_p N_noxref_28_c_7437_n ) capacitor c=0.00825432f //x=30.655 \
 //y=1.085 //x2=30.79 //y2=0.71
cc_480 ( N_A_c_129_p N_noxref_28_c_7437_n ) capacitor c=2.1838e-19 //x=30.09 \
 //y=2.26 //x2=30.79 //y2=0.71
cc_481 ( N_A_c_150_p N_noxref_28_M15_noxref_s ) capacitor c=0.00888238f \
 //x=30.125 //y=1.085 //x2=28.8 //y2=0.545
cc_482 ( N_A_c_159_p N_noxref_28_M15_noxref_s ) capacitor c=0.015333f \
 //x=30.655 //y=1.085 //x2=28.8 //y2=0.545
cc_483 ( N_A_c_162_p N_noxref_28_M15_noxref_s ) capacitor c=0.00248746f \
 //x=30.655 //y=1.43 //x2=28.8 //y2=0.545
cc_484 ( N_noxref_2_c_509_n N_noxref_3_c_767_n ) capacitor c=4.10384e-19 \
 //x=1.97 //y=5.055 //x2=4.93 //y2=4.765
cc_485 ( N_noxref_2_c_526_n N_noxref_3_c_771_n ) capacitor c=0.0111982f \
 //x=8.26 //y=2.41 //x2=7.15 //y2=2.385
cc_486 ( N_noxref_2_c_538_n N_noxref_3_c_771_n ) capacitor c=0.00201441f \
 //x=8.085 //y=2.755 //x2=7.15 //y2=2.385
cc_487 ( N_noxref_2_c_557_p N_noxref_3_c_771_n ) capacitor c=3.75556e-19 \
 //x=8.26 //y=2.265 //x2=7.15 //y2=2.385
cc_488 ( N_noxref_2_c_558_p N_noxref_3_c_771_n ) capacitor c=0.00152667f \
 //x=7.925 //y=2.1 //x2=7.15 //y2=2.385
cc_489 ( N_noxref_2_c_524_n N_noxref_3_c_797_n ) capacitor c=0.0214146f \
 //x=8.14 //y=2.915 //x2=7.15 //y2=3.385
cc_490 ( N_noxref_2_c_526_n N_noxref_3_c_797_n ) capacitor c=0.00108959f \
 //x=8.26 //y=2.41 //x2=7.15 //y2=3.385
cc_491 ( N_noxref_2_c_561_p N_noxref_3_c_797_n ) capacitor c=0.00492906f \
 //x=8.26 //y=2.595 //x2=7.15 //y2=3.385
cc_492 ( N_noxref_2_c_537_n N_noxref_3_c_797_n ) capacitor c=0.00147011f \
 //x=8.245 //y=2.755 //x2=7.15 //y2=3.385
cc_493 ( N_noxref_2_c_538_n N_noxref_3_c_797_n ) capacitor c=0.0245826f \
 //x=8.085 //y=2.755 //x2=7.15 //y2=3.385
cc_494 ( N_noxref_2_c_525_n N_noxref_3_c_772_n ) capacitor c=8.64336e-19 \
 //x=8.14 //y=4.73 //x2=10.11 //y2=3.335
cc_495 ( N_noxref_2_c_561_p N_noxref_3_c_772_n ) capacitor c=0.00105161f \
 //x=8.26 //y=2.595 //x2=10.11 //y2=3.335
cc_496 ( N_noxref_2_c_525_n N_noxref_3_c_804_n ) capacitor c=0.00112373f \
 //x=8.14 //y=4.73 //x2=10.11 //y2=4.135
cc_497 ( N_noxref_2_c_525_n N_noxref_3_c_805_n ) capacitor c=6.04659e-19 \
 //x=8.14 //y=4.73 //x2=10.11 //y2=5.055
cc_498 ( N_noxref_2_c_525_n N_noxref_3_c_806_n ) capacitor c=0.0100855f \
 //x=8.14 //y=4.73 //x2=7.15 //y2=3.51
cc_499 ( N_noxref_2_c_525_n N_noxref_3_c_807_n ) capacitor c=0.00284758f \
 //x=8.14 //y=4.73 //x2=7.31 //y2=3.525
cc_500 ( N_noxref_2_c_538_n N_noxref_3_c_807_n ) capacitor c=0.0011786f \
 //x=8.085 //y=2.755 //x2=7.31 //y2=3.525
cc_501 ( N_noxref_2_c_525_n N_noxref_3_c_809_n ) capacitor c=0.0217961f \
 //x=8.14 //y=4.73 //x2=9.955 //y2=4.27
cc_502 ( N_noxref_2_c_538_n N_noxref_3_c_809_n ) capacitor c=0.00109024f \
 //x=8.085 //y=2.755 //x2=9.955 //y2=4.27
cc_503 ( N_noxref_2_c_525_n N_noxref_3_c_781_n ) capacitor c=0.0196397f \
 //x=8.14 //y=4.73 //x2=9.985 //y2=3.495
cc_504 ( N_noxref_2_c_538_n N_noxref_3_c_781_n ) capacitor c=0.0046655f \
 //x=8.085 //y=2.755 //x2=9.985 //y2=3.495
cc_505 ( N_noxref_2_c_526_n N_noxref_3_c_813_n ) capacitor c=7.23736e-19 \
 //x=8.26 //y=2.41 //x2=7.15 //y2=2.265
cc_506 ( N_noxref_2_c_557_p N_noxref_3_c_813_n ) capacitor c=0.00114264f \
 //x=8.26 //y=2.265 //x2=7.15 //y2=2.265
cc_507 ( N_noxref_2_c_558_p N_noxref_3_c_813_n ) capacitor c=0.00214703f \
 //x=7.925 //y=2.1 //x2=7.15 //y2=2.265
cc_508 ( N_noxref_2_c_578_p N_noxref_3_c_816_n ) capacitor c=4.86545e-19 \
 //x=7.925 //y=1.09 //x2=6.955 //y2=1.05
cc_509 ( N_noxref_2_c_578_p N_noxref_3_c_817_n ) capacitor c=0.00152405f \
 //x=7.925 //y=1.09 //x2=6.955 //y2=1.395
cc_510 ( N_noxref_2_c_580_p N_noxref_3_c_818_n ) capacitor c=0.00109982f \
 //x=7.925 //y=1.435 //x2=6.955 //y2=1.705
cc_511 ( N_noxref_2_c_581_p N_noxref_3_c_818_n ) capacitor c=9.58243e-19 \
 //x=7.925 //y=1.745 //x2=6.955 //y2=1.705
cc_512 ( N_noxref_2_c_526_n N_noxref_3_c_820_n ) capacitor c=0.00153002f \
 //x=8.26 //y=2.41 //x2=6.955 //y2=2.1
cc_513 ( N_noxref_2_c_557_p N_noxref_3_c_820_n ) capacitor c=0.00187625f \
 //x=8.26 //y=2.265 //x2=6.955 //y2=2.1
cc_514 ( N_noxref_2_c_581_p N_noxref_3_c_820_n ) capacitor c=0.00662747f \
 //x=7.925 //y=1.745 //x2=6.955 //y2=2.1
cc_515 ( N_noxref_2_c_558_p N_noxref_3_c_820_n ) capacitor c=0.012184f \
 //x=7.925 //y=2.1 //x2=6.955 //y2=2.1
cc_516 ( N_noxref_2_c_578_p N_noxref_3_c_824_n ) capacitor c=0.0157772f \
 //x=7.925 //y=1.09 //x2=7.485 //y2=1.05
cc_517 ( N_noxref_2_c_587_p N_noxref_3_c_824_n ) capacitor c=0.00127211f \
 //x=8.455 //y=1.09 //x2=7.485 //y2=1.05
cc_518 ( N_noxref_2_c_580_p N_noxref_3_c_826_n ) capacitor c=0.0117362f \
 //x=7.925 //y=1.435 //x2=7.485 //y2=1.395
cc_519 ( N_noxref_2_c_581_p N_noxref_3_c_826_n ) capacitor c=0.00862358f \
 //x=7.925 //y=1.745 //x2=7.485 //y2=1.395
cc_520 ( N_noxref_2_c_590_p N_noxref_3_c_826_n ) capacitor c=0.00204774f \
 //x=8.455 //y=1.435 //x2=7.485 //y2=1.395
cc_521 ( N_noxref_2_c_538_n B ) capacitor c=0.00512176f //x=8.085 //y=2.755 \
 //x2=4.93 //y2=3.14
cc_522 ( N_noxref_2_c_525_n B ) capacitor c=0.0128176f //x=8.14 //y=4.73 \
 //x2=7.15 //y2=4.62
cc_523 ( N_noxref_2_c_593_p B ) capacitor c=2.2865e-19 //x=8.26 //y=4.88 \
 //x2=7.15 //y2=4.62
cc_524 ( N_noxref_2_c_538_n N_B_c_1087_n ) capacitor c=0.00170133f //x=8.085 \
 //y=2.755 //x2=4.93 //y2=2.415
cc_525 ( N_noxref_2_c_499_n N_B_c_1091_n ) capacitor c=4.65427e-19 //x=1.97 \
 //y=2.61 //x2=4.93 //y2=2.995
cc_526 ( N_noxref_2_c_538_n N_B_c_1091_n ) capacitor c=0.0203973f //x=8.085 \
 //y=2.755 //x2=4.93 //y2=2.995
cc_527 ( N_noxref_2_c_524_n N_B_c_1100_n ) capacitor c=0.00753295f //x=8.14 \
 //y=2.915 //x2=9.76 //y2=3.14
cc_528 ( N_noxref_2_c_525_n N_B_c_1100_n ) capacitor c=0.0196093f //x=8.14 \
 //y=4.73 //x2=9.76 //y2=3.14
cc_529 ( N_noxref_2_c_537_n N_B_c_1100_n ) capacitor c=0.035713f //x=8.245 \
 //y=2.755 //x2=9.76 //y2=3.14
cc_530 ( N_noxref_2_c_538_n N_B_c_1100_n ) capacitor c=0.259621f //x=8.085 \
 //y=2.755 //x2=9.76 //y2=3.14
cc_531 ( N_noxref_2_c_525_n N_B_c_1157_n ) capacitor c=0.0248503f //x=8.14 \
 //y=4.73 //x2=9.985 //y2=4.655
cc_532 ( N_noxref_2_c_602_p N_B_c_1157_n ) capacitor c=0.0107356f //x=8.14 \
 //y=4.877 //x2=9.985 //y2=4.655
cc_533 ( N_noxref_2_c_538_n N_B_c_1103_n ) capacitor c=0.0360847f //x=8.085 \
 //y=2.755 //x2=5.09 //y2=3.155
cc_534 ( N_noxref_2_c_525_n N_B_c_1160_n ) capacitor c=9.46427e-19 //x=8.14 \
 //y=4.73 //x2=7.15 //y2=4.62
cc_535 ( N_noxref_2_c_602_p N_B_c_1160_n ) capacitor c=0.00297256f //x=8.14 \
 //y=4.877 //x2=7.15 //y2=4.62
cc_536 ( N_noxref_2_c_593_p N_B_c_1160_n ) capacitor c=0.00150017f //x=8.26 \
 //y=4.88 //x2=7.15 //y2=4.62
cc_537 ( N_noxref_2_c_607_p N_B_c_1160_n ) capacitor c=0.00186624f //x=8.26 \
 //y=4.88 //x2=7.15 //y2=4.62
cc_538 ( N_noxref_2_M29_noxref_g N_B_M27_noxref_g ) capacitor c=0.0102032f \
 //x=7.93 //y=6.2 //x2=7.05 //y2=6.2
cc_539 ( N_noxref_2_M29_noxref_g N_B_M28_noxref_g ) capacitor c=0.0618439f \
 //x=7.93 //y=6.2 //x2=7.49 //y2=6.2
cc_540 ( N_noxref_2_M30_noxref_g N_B_M28_noxref_g ) capacitor c=0.00945236f \
 //x=8.37 //y=6.2 //x2=7.49 //y2=6.2
cc_541 ( N_noxref_2_c_602_p N_B_c_1167_n ) capacitor c=0.00105639f //x=8.14 \
 //y=4.877 //x2=7.15 //y2=4.88
cc_542 ( N_noxref_2_c_593_p N_B_c_1167_n ) capacitor c=0.00166675f //x=8.26 \
 //y=4.88 //x2=7.15 //y2=4.88
cc_543 ( N_noxref_2_c_607_p N_B_c_1167_n ) capacitor c=0.0664454f //x=8.26 \
 //y=4.88 //x2=7.15 //y2=4.88
cc_544 ( N_noxref_2_c_527_n N_noxref_5_c_1624_n ) capacitor c=7.0089e-19 \
 //x=1.6 //y=1.185 //x2=4.86 //y2=1.305
cc_545 ( N_noxref_2_c_484_n N_noxref_5_c_1651_n ) capacitor c=0.00493745f \
 //x=1.6 //y=1.935 //x2=4.86 //y2=1.75
cc_546 ( N_noxref_2_c_527_n N_noxref_5_c_1651_n ) capacitor c=3.46581e-19 \
 //x=1.6 //y=1.185 //x2=4.86 //y2=1.75
cc_547 ( N_noxref_2_c_492_n N_noxref_5_c_1626_n ) capacitor c=0.00108051f \
 //x=1.885 //y=2.02 //x2=5.42 //y2=3.735
cc_548 ( N_noxref_2_c_524_n N_noxref_5_c_1626_n ) capacitor c=0.00174515f \
 //x=8.14 //y=2.915 //x2=5.42 //y2=3.735
cc_549 ( N_noxref_2_c_561_p N_noxref_5_c_1626_n ) capacitor c=4.56327e-19 \
 //x=8.26 //y=2.595 //x2=5.42 //y2=3.735
cc_550 ( N_noxref_2_c_538_n N_noxref_5_c_1626_n ) capacitor c=0.0242455f \
 //x=8.085 //y=2.755 //x2=5.42 //y2=3.735
cc_551 ( N_noxref_2_c_525_n N_noxref_5_c_1629_n ) capacitor c=0.00197512f \
 //x=8.14 //y=4.73 //x2=5.42 //y2=4.055
cc_552 ( N_noxref_2_c_489_n N_noxref_5_c_1630_n ) capacitor c=6.97655e-19 \
 //x=1.605 //y=5.42 //x2=5.42 //y2=5.3
cc_553 ( N_noxref_2_c_509_n N_noxref_5_c_1630_n ) capacitor c=0.00217756f \
 //x=1.97 //y=5.055 //x2=5.42 //y2=5.3
cc_554 ( N_noxref_2_c_525_n N_noxref_5_c_1630_n ) capacitor c=0.00526544f \
 //x=8.14 //y=4.73 //x2=5.42 //y2=5.3
cc_555 ( N_noxref_2_c_524_n N_noxref_5_c_1634_n ) capacitor c=3.87127e-19 \
 //x=8.14 //y=2.915 //x2=8.19 //y2=1.3
cc_556 ( N_noxref_2_c_578_p N_noxref_5_c_1634_n ) capacitor c=4.13109e-19 \
 //x=7.925 //y=1.09 //x2=8.19 //y2=1.3
cc_557 ( N_noxref_2_c_580_p N_noxref_5_c_1634_n ) capacitor c=0.00213f \
 //x=7.925 //y=1.435 //x2=8.19 //y2=1.3
cc_558 ( N_noxref_2_c_628_p N_noxref_5_c_1634_n ) capacitor c=5.28423e-19 \
 //x=8.3 //y=0.935 //x2=8.19 //y2=1.3
cc_559 ( N_noxref_2_c_629_p N_noxref_5_c_1634_n ) capacitor c=4.49341e-19 \
 //x=8.3 //y=1.59 //x2=8.19 //y2=1.3
cc_560 ( N_noxref_2_c_587_p N_noxref_5_c_1634_n ) capacitor c=4.42805e-19 \
 //x=8.455 //y=1.09 //x2=8.19 //y2=1.3
cc_561 ( N_noxref_2_c_590_p N_noxref_5_c_1634_n ) capacitor c=0.00304778f \
 //x=8.455 //y=1.435 //x2=8.19 //y2=1.3
cc_562 ( N_noxref_2_c_580_p N_noxref_5_c_1668_n ) capacitor c=0.00119008f \
 //x=7.925 //y=1.435 //x2=8.19 //y2=1.75
cc_563 ( N_noxref_2_c_581_p N_noxref_5_c_1668_n ) capacitor c=0.00410123f \
 //x=7.925 //y=1.745 //x2=8.19 //y2=1.75
cc_564 ( N_noxref_2_c_558_p N_noxref_5_c_1668_n ) capacitor c=0.00329274f \
 //x=7.925 //y=2.1 //x2=8.19 //y2=1.75
cc_565 ( N_noxref_2_c_629_p N_noxref_5_c_1668_n ) capacitor c=0.00740116f \
 //x=8.3 //y=1.59 //x2=8.19 //y2=1.75
cc_566 ( N_noxref_2_c_590_p N_noxref_5_c_1668_n ) capacitor c=0.00303393f \
 //x=8.455 //y=1.435 //x2=8.19 //y2=1.75
cc_567 ( N_noxref_2_c_602_p N_noxref_5_c_1673_n ) capacitor c=0.00245563f \
 //x=8.14 //y=4.877 //x2=8.545 //y2=5.385
cc_568 ( N_noxref_2_c_593_p N_noxref_5_c_1673_n ) capacitor c=0.00104675f \
 //x=8.26 //y=4.88 //x2=8.545 //y2=5.385
cc_569 ( N_noxref_2_M30_noxref_g N_noxref_5_c_1673_n ) capacitor c=0.00983704f \
 //x=8.37 //y=6.2 //x2=8.545 //y2=5.385
cc_570 ( N_noxref_2_c_524_n N_noxref_5_c_1676_n ) capacitor c=7.11423e-19 \
 //x=8.14 //y=2.915 //x2=8.545 //y2=1.835
cc_571 ( N_noxref_2_c_526_n N_noxref_5_c_1676_n ) capacitor c=0.00261995f \
 //x=8.26 //y=2.41 //x2=8.545 //y2=1.835
cc_572 ( N_noxref_2_c_557_p N_noxref_5_c_1676_n ) capacitor c=0.00147657f \
 //x=8.26 //y=2.265 //x2=8.545 //y2=1.835
cc_573 ( N_noxref_2_c_629_p N_noxref_5_c_1676_n ) capacitor c=0.00124662f \
 //x=8.3 //y=1.59 //x2=8.545 //y2=1.835
cc_574 ( N_noxref_2_c_590_p N_noxref_5_c_1676_n ) capacitor c=0.00300547f \
 //x=8.455 //y=1.435 //x2=8.545 //y2=1.835
cc_575 ( N_noxref_2_c_524_n N_noxref_5_c_1635_n ) capacitor c=0.00102687f \
 //x=8.14 //y=2.915 //x2=8.275 //y2=1.835
cc_576 ( N_noxref_2_c_526_n N_noxref_5_c_1635_n ) capacitor c=0.0198189f \
 //x=8.26 //y=2.41 //x2=8.275 //y2=1.835
cc_577 ( N_noxref_2_c_557_p N_noxref_5_c_1635_n ) capacitor c=0.00408056f \
 //x=8.26 //y=2.265 //x2=8.275 //y2=1.835
cc_578 ( N_noxref_2_c_558_p N_noxref_5_c_1635_n ) capacitor c=0.00189997f \
 //x=7.925 //y=2.1 //x2=8.275 //y2=1.835
cc_579 ( N_noxref_2_c_524_n N_noxref_5_c_1636_n ) capacitor c=0.0345487f \
 //x=8.14 //y=2.915 //x2=8.63 //y2=3.735
cc_580 ( N_noxref_2_c_525_n N_noxref_5_c_1636_n ) capacitor c=0.0520611f \
 //x=8.14 //y=4.73 //x2=8.63 //y2=3.735
cc_581 ( N_noxref_2_c_526_n N_noxref_5_c_1636_n ) capacitor c=0.0335163f \
 //x=8.26 //y=2.41 //x2=8.63 //y2=3.735
cc_582 ( N_noxref_2_c_561_p N_noxref_5_c_1636_n ) capacitor c=0.015798f \
 //x=8.26 //y=2.595 //x2=8.63 //y2=3.735
cc_583 ( N_noxref_2_c_653_p N_noxref_5_c_1636_n ) capacitor c=0.00268185f \
 //x=8.26 //y=2.77 //x2=8.63 //y2=3.735
cc_584 ( N_noxref_2_c_537_n N_noxref_5_c_1636_n ) capacitor c=0.0127171f \
 //x=8.245 //y=2.755 //x2=8.63 //y2=3.735
cc_585 ( N_noxref_2_c_557_p N_noxref_5_c_1636_n ) capacitor c=0.00263396f \
 //x=8.26 //y=2.265 //x2=8.63 //y2=3.735
cc_586 ( N_noxref_2_c_558_p N_noxref_5_c_1636_n ) capacitor c=0.00799183f \
 //x=7.925 //y=2.1 //x2=8.63 //y2=3.735
cc_587 ( N_noxref_2_c_524_n N_noxref_5_c_1693_n ) capacitor c=0.0011496f \
 //x=8.14 //y=2.915 //x2=8.63 //y2=4.055
cc_588 ( N_noxref_2_c_525_n N_noxref_5_c_1693_n ) capacitor c=0.0328751f \
 //x=8.14 //y=4.73 //x2=8.63 //y2=4.055
cc_589 ( N_noxref_2_c_602_p N_noxref_5_c_1693_n ) capacitor c=2.21717e-19 \
 //x=8.14 //y=4.877 //x2=8.63 //y2=4.055
cc_590 ( N_noxref_2_c_607_p N_noxref_5_c_1693_n ) capacitor c=0.00109921f \
 //x=8.26 //y=4.88 //x2=8.63 //y2=4.055
cc_591 ( N_noxref_2_c_525_n N_noxref_5_c_1697_n ) capacitor c=0.0421585f \
 //x=8.14 //y=4.73 //x2=8.63 //y2=5.3
cc_592 ( N_noxref_2_c_602_p N_noxref_5_c_1697_n ) capacitor c=0.033569f \
 //x=8.14 //y=4.877 //x2=8.63 //y2=5.3
cc_593 ( N_noxref_2_c_593_p N_noxref_5_c_1697_n ) capacitor c=0.00262905f \
 //x=8.26 //y=4.88 //x2=8.63 //y2=5.3
cc_594 ( N_noxref_2_c_607_p N_noxref_5_c_1697_n ) capacitor c=0.0109587f \
 //x=8.26 //y=4.88 //x2=8.63 //y2=5.3
cc_595 ( N_noxref_2_c_489_n N_noxref_5_c_1701_n ) capacitor c=3.86497e-19 \
 //x=1.605 //y=5.42 //x2=4.82 //y2=5.385
cc_596 ( N_noxref_2_c_602_p N_noxref_5_c_1702_n ) capacitor c=0.0275415f \
 //x=8.14 //y=4.877 //x2=8.15 //y2=5.385
cc_597 ( N_noxref_2_c_593_p N_noxref_5_c_1702_n ) capacitor c=0.0039033f \
 //x=8.26 //y=4.88 //x2=8.15 //y2=5.385
cc_598 ( N_noxref_2_M29_noxref_g N_noxref_5_c_1702_n ) capacitor c=0.00179079f \
 //x=7.93 //y=6.2 //x2=8.15 //y2=5.385
cc_599 ( N_noxref_2_M30_noxref_g N_noxref_5_c_1702_n ) capacitor c=0.00270394f \
 //x=8.37 //y=6.2 //x2=8.15 //y2=5.385
cc_600 ( N_noxref_2_c_607_p N_noxref_5_c_1702_n ) capacitor c=0.00190838f \
 //x=8.26 //y=4.88 //x2=8.15 //y2=5.385
cc_601 ( N_noxref_2_c_525_n N_noxref_5_c_1707_n ) capacitor c=0.00518857f \
 //x=8.14 //y=4.73 //x2=8.63 //y2=3.88
cc_602 ( N_noxref_2_c_538_n N_noxref_5_c_1645_n ) capacitor c=7.7387e-19 \
 //x=8.085 //y=2.755 //x2=5.625 //y2=3.895
cc_603 ( N_noxref_2_c_525_n N_noxref_5_c_1709_n ) capacitor c=0.0208701f \
 //x=8.14 //y=4.73 //x2=8.485 //y2=3.895
cc_604 ( N_noxref_2_c_538_n N_noxref_5_c_1709_n ) capacitor c=0.0049308f \
 //x=8.085 //y=2.755 //x2=8.485 //y2=3.895
cc_605 ( N_noxref_2_c_525_n N_noxref_5_c_1711_n ) capacitor c=0.00368778f \
 //x=8.14 //y=4.73 //x2=8.805 //y2=3.895
cc_606 ( N_noxref_2_c_602_p N_noxref_5_c_1712_n ) capacitor c=0.00369516f \
 //x=8.14 //y=4.877 //x2=8.15 //y2=5.555
cc_607 ( N_noxref_2_c_593_p N_noxref_5_c_1712_n ) capacitor c=0.00414273f \
 //x=8.26 //y=4.88 //x2=8.15 //y2=5.555
cc_608 ( N_noxref_2_M29_noxref_g N_noxref_5_c_1712_n ) capacitor c=0.0120591f \
 //x=7.93 //y=6.2 //x2=8.15 //y2=5.555
cc_609 ( N_noxref_2_M30_noxref_g N_noxref_5_c_1712_n ) capacitor c=0.0140704f \
 //x=8.37 //y=6.2 //x2=8.15 //y2=5.555
cc_610 ( N_noxref_2_c_607_p N_noxref_5_c_1712_n ) capacitor c=0.0044017f \
 //x=8.26 //y=4.88 //x2=8.15 //y2=5.555
cc_611 ( N_noxref_2_c_524_n N_noxref_5_M4_noxref_d ) capacitor c=2.74358e-19 \
 //x=8.14 //y=2.915 //x2=8 //y2=1.09
cc_612 ( N_noxref_2_c_526_n N_noxref_5_M4_noxref_d ) capacitor c=9.49603e-19 \
 //x=8.26 //y=2.41 //x2=8 //y2=1.09
cc_613 ( N_noxref_2_c_557_p N_noxref_5_M4_noxref_d ) capacitor c=0.00150031f \
 //x=8.26 //y=2.265 //x2=8 //y2=1.09
cc_614 ( N_noxref_2_c_578_p N_noxref_5_M4_noxref_d ) capacitor c=0.00137165f \
 //x=7.925 //y=1.09 //x2=8 //y2=1.09
cc_615 ( N_noxref_2_c_580_p N_noxref_5_M4_noxref_d ) capacitor c=0.00237422f \
 //x=7.925 //y=1.435 //x2=8 //y2=1.09
cc_616 ( N_noxref_2_c_558_p N_noxref_5_M4_noxref_d ) capacitor c=4.64071e-19 \
 //x=7.925 //y=2.1 //x2=8 //y2=1.09
cc_617 ( N_noxref_2_c_628_p N_noxref_5_M4_noxref_d ) capacitor c=0.0020782f \
 //x=8.3 //y=0.935 //x2=8 //y2=1.09
cc_618 ( N_noxref_2_c_629_p N_noxref_5_M4_noxref_d ) capacitor c=0.00344131f \
 //x=8.3 //y=1.59 //x2=8 //y2=1.09
cc_619 ( N_noxref_2_c_587_p N_noxref_5_M4_noxref_d ) capacitor c=8.50094e-19 \
 //x=8.455 //y=1.09 //x2=8 //y2=1.09
cc_620 ( N_noxref_2_c_590_p N_noxref_5_M4_noxref_d ) capacitor c=0.00237422f \
 //x=8.455 //y=1.435 //x2=8 //y2=1.09
cc_621 ( N_noxref_2_c_489_n N_VDD_c_4990_n ) capacitor c=0.00259718f //x=1.605 \
 //y=5.42 //x2=3.855 //y2=7.585
cc_622 ( N_noxref_2_c_495_n N_VDD_c_4990_n ) capacitor c=0.00199795f //x=1.885 \
 //y=5.14 //x2=3.855 //y2=7.585
cc_623 ( N_noxref_2_c_545_n N_VDD_c_4990_n ) capacitor c=0.00241566f //x=1.605 \
 //y=5.56 //x2=3.855 //y2=7.585
cc_624 ( N_noxref_2_c_489_n N_VDD_c_4997_n ) capacitor c=8.96756e-19 //x=1.605 \
 //y=5.42 //x2=1.96 //y2=7.585
cc_625 ( N_noxref_2_c_495_n N_VDD_c_4997_n ) capacitor c=0.00197507f //x=1.885 \
 //y=5.14 //x2=1.96 //y2=7.585
cc_626 ( N_noxref_2_c_545_n N_VDD_c_4997_n ) capacitor c=0.0138017f //x=1.605 \
 //y=5.56 //x2=1.96 //y2=7.585
cc_627 ( N_noxref_2_M29_noxref_g N_VDD_c_5047_n ) capacitor c=0.00777954f \
 //x=7.93 //y=6.2 //x2=9.2 //y2=7.585
cc_628 ( N_noxref_2_M30_noxref_g N_VDD_c_5047_n ) capacitor c=0.00758899f \
 //x=8.37 //y=6.2 //x2=9.2 //y2=7.585
cc_629 ( N_noxref_2_c_496_n N_VDD_c_5005_n ) capacitor c=0.00685597f //x=1.69 \
 //y=5.14 //x2=1.23 //y2=7.58
cc_630 ( N_noxref_2_c_509_n N_VDD_c_5005_n ) capacitor c=2.43252e-19 //x=1.97 \
 //y=5.055 //x2=1.23 //y2=7.58
cc_631 ( N_noxref_2_c_545_n N_VDD_c_5005_n ) capacitor c=0.00822762f //x=1.605 \
 //y=5.56 //x2=1.23 //y2=7.58
cc_632 ( N_noxref_2_c_489_n N_VDD_c_5012_n ) capacitor c=0.00232499f //x=1.605 \
 //y=5.42 //x2=2.71 //y2=7.585
cc_633 ( N_noxref_2_c_509_n N_VDD_c_5012_n ) capacitor c=0.021852f //x=1.97 \
 //y=5.055 //x2=2.71 //y2=7.585
cc_634 ( N_noxref_2_c_538_n N_VDD_c_5012_n ) capacitor c=0.00182463f //x=8.085 \
 //y=2.755 //x2=2.71 //y2=7.585
cc_635 ( N_noxref_2_c_545_n N_VDD_c_5012_n ) capacitor c=0.00820601f //x=1.605 \
 //y=5.56 //x2=2.71 //y2=7.585
cc_636 ( N_noxref_2_c_525_n N_VDD_c_5056_n ) capacitor c=8.19548e-19 //x=8.14 \
 //y=4.73 //x2=6.04 //y2=7.585
cc_637 ( N_noxref_2_c_593_p N_VDD_c_5057_n ) capacitor c=0.00347772f //x=8.26 \
 //y=4.88 //x2=9.37 //y2=7.585
cc_638 ( N_noxref_2_c_607_p N_VDD_c_5057_n ) capacitor c=0.0199669f //x=8.26 \
 //y=4.88 //x2=9.37 //y2=7.585
cc_639 ( N_noxref_2_c_489_n N_VDD_M21_noxref_s ) capacitor c=0.0480012f \
 //x=1.605 //y=5.42 //x2=1.03 //y2=5.2
cc_640 ( N_noxref_2_c_545_n N_VDD_M21_noxref_s ) capacitor c=0.0920695f \
 //x=1.605 //y=5.56 //x2=1.03 //y2=5.2
cc_641 ( N_noxref_2_c_489_n N_VDD_M22_noxref_d ) capacitor c=0.0474638f \
 //x=1.605 //y=5.42 //x2=1.9 //y2=5.2
cc_642 ( N_noxref_2_c_495_n N_VDD_M22_noxref_d ) capacitor c=0.021356f \
 //x=1.885 //y=5.14 //x2=1.9 //y2=5.2
cc_643 ( N_noxref_2_c_506_n N_VDD_M22_noxref_d ) capacitor c=0.00162327f \
 //x=1.97 //y=2.93 //x2=1.9 //y2=5.2
cc_644 ( N_noxref_2_c_545_n N_VDD_M22_noxref_d ) capacitor c=0.0908242f \
 //x=1.605 //y=5.56 //x2=1.9 //y2=5.2
cc_645 ( N_noxref_2_c_489_n N_noxref_16_c_5809_n ) capacitor c=0.001884f \
 //x=1.605 //y=5.42 //x2=3.507 //y2=5.385
cc_646 ( N_noxref_2_M29_noxref_g N_noxref_17_c_5882_n ) capacitor \
 c=0.00901373f //x=7.93 //y=6.2 //x2=8.47 //y2=7.085
cc_647 ( N_noxref_2_M30_noxref_g N_noxref_17_c_5882_n ) capacitor \
 c=0.00932531f //x=8.37 //y=6.2 //x2=8.47 //y2=7.085
cc_648 ( N_noxref_2_M29_noxref_g N_noxref_17_c_5884_n ) capacitor \
 c=0.00175157f //x=7.93 //y=6.2 //x2=7.71 //y2=5.385
cc_649 ( N_noxref_2_M29_noxref_g N_noxref_17_c_5885_n ) capacitor \
 c=0.00178586f //x=7.93 //y=6.2 //x2=7.71 //y2=6.915
cc_650 ( N_noxref_2_M30_noxref_g N_noxref_17_c_5886_n ) capacitor \
 c=0.00406674f //x=8.37 //y=6.2 //x2=8.59 //y2=6.915
cc_651 ( N_noxref_2_M29_noxref_g N_noxref_17_c_5887_n ) capacitor c=0.0170175f \
 //x=7.93 //y=6.2 //x2=7.71 //y2=5.555
cc_652 ( N_noxref_2_M30_noxref_g N_noxref_17_M30_noxref_d ) capacitor \
 c=0.0365939f //x=8.37 //y=6.2 //x2=8.445 //y2=5.2
cc_653 ( N_noxref_2_c_492_n N_GND_c_6122_n ) capacitor c=0.00499594f //x=1.885 \
 //y=2.02 //x2=3.805 //y2=0.175
cc_654 ( N_noxref_2_c_506_n N_GND_c_6122_n ) capacitor c=6.43251e-19 //x=1.97 \
 //y=2.93 //x2=3.805 //y2=0.175
cc_655 ( N_noxref_2_c_527_n N_GND_c_6122_n ) capacitor c=0.00998676f //x=1.6 \
 //y=1.185 //x2=3.805 //y2=0.175
cc_656 ( N_noxref_2_c_533_n N_GND_c_6122_n ) capacitor c=4.46354e-19 //x=1.97 \
 //y=2.77 //x2=3.805 //y2=0.175
cc_657 ( N_noxref_2_M0_noxref_d N_GND_c_6122_n ) capacitor c=0.00119455f \
 //x=1.415 //y=1.09 //x2=3.805 //y2=0.175
cc_658 ( N_noxref_2_c_527_n N_GND_c_6127_n ) capacitor c=0.0052977f //x=1.6 \
 //y=1.185 //x2=3.89 //y2=1.025
cc_659 ( N_noxref_2_c_527_n N_GND_c_6150_n ) capacitor c=0.00124813f //x=1.6 \
 //y=1.185 //x2=1.515 //y2=0.715
cc_660 ( N_noxref_2_c_492_n N_GND_c_6154_n ) capacitor c=0.0030723f //x=1.885 \
 //y=2.02 //x2=2.005 //y2=0.715
cc_661 ( N_noxref_2_c_527_n N_GND_c_6154_n ) capacitor c=0.00130539f //x=1.6 \
 //y=1.185 //x2=2.005 //y2=0.715
cc_662 ( N_noxref_2_c_533_n N_GND_c_6154_n ) capacitor c=4.2833e-19 //x=1.97 \
 //y=2.77 //x2=2.005 //y2=0.715
cc_663 ( N_noxref_2_c_484_n N_GND_c_6161_n ) capacitor c=0.00520602f //x=1.6 \
 //y=1.935 //x2=1.12 //y2=0.175
cc_664 ( N_noxref_2_c_499_n N_GND_c_6161_n ) capacitor c=2.14154e-19 //x=1.97 \
 //y=2.61 //x2=1.12 //y2=0.175
cc_665 ( N_noxref_2_c_533_n N_GND_c_6161_n ) capacitor c=0.00313158f //x=1.97 \
 //y=2.77 //x2=1.12 //y2=0.175
cc_666 ( N_noxref_2_c_492_n N_GND_c_6166_n ) capacitor c=0.0160435f //x=1.885 \
 //y=2.02 //x2=2.71 //y2=0.175
cc_667 ( N_noxref_2_c_506_n N_GND_c_6166_n ) capacitor c=0.00439621f //x=1.97 \
 //y=2.93 //x2=2.71 //y2=0.175
cc_668 ( N_noxref_2_c_533_n N_GND_c_6166_n ) capacitor c=0.0101813f //x=1.97 \
 //y=2.77 //x2=2.71 //y2=0.175
cc_669 ( N_noxref_2_c_538_n N_GND_c_6166_n ) capacitor c=0.0241204f //x=8.085 \
 //y=2.755 //x2=2.71 //y2=0.175
cc_670 ( N_noxref_2_c_653_p N_GND_c_6173_n ) capacitor c=0.00118906f //x=8.26 \
 //y=2.77 //x2=6.04 //y2=0.175
cc_671 ( N_noxref_2_c_538_n N_GND_c_6173_n ) capacitor c=0.0149976f //x=8.085 \
 //y=2.755 //x2=6.04 //y2=0.175
cc_672 ( N_noxref_2_c_653_p N_GND_c_6175_n ) capacitor c=0.00499198f //x=8.26 \
 //y=2.77 //x2=9.37 //y2=0.175
cc_673 ( N_noxref_2_c_557_p N_GND_c_6175_n ) capacitor c=0.00354429f //x=8.26 \
 //y=2.265 //x2=9.37 //y2=0.175
cc_674 ( N_noxref_2_c_558_p N_GND_c_6175_n ) capacitor c=0.00579278f //x=7.925 \
 //y=2.1 //x2=9.37 //y2=0.175
cc_675 ( N_noxref_2_c_590_p N_GND_c_6175_n ) capacitor c=0.00230557f //x=8.455 \
 //y=1.435 //x2=9.37 //y2=0.175
cc_676 ( N_noxref_2_c_484_n N_GND_M0_noxref_s ) capacitor c=0.0339444f //x=1.6 \
 //y=1.935 //x2=0.985 //y2=0.55
cc_677 ( N_noxref_2_c_492_n N_GND_M0_noxref_s ) capacitor c=0.00316907f \
 //x=1.885 //y=2.02 //x2=0.985 //y2=0.55
cc_678 ( N_noxref_2_c_506_n N_GND_M0_noxref_s ) capacitor c=0.00297082f \
 //x=1.97 //y=2.93 //x2=0.985 //y2=0.55
cc_679 ( N_noxref_2_c_527_n N_GND_M0_noxref_s ) capacitor c=0.0157394f //x=1.6 \
 //y=1.185 //x2=0.985 //y2=0.55
cc_680 ( N_noxref_2_c_533_n N_GND_M0_noxref_s ) capacitor c=0.00227202f \
 //x=1.97 //y=2.77 //x2=0.985 //y2=0.55
cc_681 ( N_noxref_2_M0_noxref_d N_GND_M0_noxref_s ) capacitor c=0.0377642f \
 //x=1.415 //y=1.09 //x2=0.985 //y2=0.55
cc_682 ( N_noxref_2_c_538_n N_noxref_23_c_7114_n ) capacitor c=0.00354349f \
 //x=8.085 //y=2.755 //x2=3.405 //y2=1.68
cc_683 ( N_noxref_2_c_538_n N_noxref_23_c_7115_n ) capacitor c=0.00577782f \
 //x=8.085 //y=2.755 //x2=4.29 //y2=1.765
cc_684 ( N_noxref_2_c_581_p N_noxref_24_c_7178_n ) capacitor c=0.00888238f \
 //x=7.925 //y=1.745 //x2=7.705 //y2=1.68
cc_685 ( N_noxref_2_c_524_n N_noxref_24_c_7179_n ) capacitor c=5.34835e-19 \
 //x=8.14 //y=2.915 //x2=8.59 //y2=0.715
cc_686 ( N_noxref_2_c_557_p N_noxref_24_c_7179_n ) capacitor c=4.1952e-19 \
 //x=8.26 //y=2.265 //x2=8.59 //y2=0.715
cc_687 ( N_noxref_2_c_578_p N_noxref_24_c_7179_n ) capacitor c=0.0204604f \
 //x=7.925 //y=1.09 //x2=8.59 //y2=0.715
cc_688 ( N_noxref_2_c_558_p N_noxref_24_c_7179_n ) capacitor c=2.1838e-19 \
 //x=7.925 //y=2.1 //x2=8.59 //y2=0.715
cc_689 ( N_noxref_2_c_587_p N_noxref_24_c_7179_n ) capacitor c=0.00825432f \
 //x=8.455 //y=1.09 //x2=8.59 //y2=0.715
cc_690 ( N_noxref_2_c_578_p N_noxref_24_M3_noxref_s ) capacitor c=0.00888238f \
 //x=7.925 //y=1.09 //x2=6.6 //y2=0.55
cc_691 ( N_noxref_2_c_587_p N_noxref_24_M3_noxref_s ) capacitor c=0.015333f \
 //x=8.455 //y=1.09 //x2=6.6 //y2=0.55
cc_692 ( N_noxref_2_c_590_p N_noxref_24_M3_noxref_s ) capacitor c=0.00248746f \
 //x=8.455 //y=1.435 //x2=6.6 //y2=0.55
cc_693 ( N_noxref_3_c_772_n B ) capacitor c=0.0229725f //x=10.11 //y=3.335 \
 //x2=10.85 //y2=2.77
cc_694 ( N_noxref_3_c_772_n B ) capacitor c=0.00158373f //x=10.11 //y=3.335 \
 //x2=10.85 //y2=3.51
cc_695 ( N_noxref_3_c_831_p B ) capacitor c=0.0163214f //x=10.11 //y=3.655 \
 //x2=10.85 //y2=3.51
cc_696 ( N_noxref_3_c_804_n B ) capacitor c=0.0181325f //x=10.11 //y=4.135 \
 //x2=10.85 //y2=3.51
cc_697 ( N_noxref_3_c_833_p B ) capacitor c=0.014272f //x=10.11 //y=4.43 \
 //x2=10.85 //y2=3.51
cc_698 ( N_noxref_3_c_805_n B ) capacitor c=0.010183f //x=10.11 //y=5.055 \
 //x2=10.85 //y2=3.51
cc_699 ( N_noxref_3_c_835_p B ) capacitor c=6.64093e-19 //x=10.11 //y=3.51 \
 //x2=10.85 //y2=3.51
cc_700 ( N_noxref_3_c_836_p B ) capacitor c=9.61116e-19 //x=10.11 //y=4.25 \
 //x2=10.85 //y2=3.51
cc_701 ( N_noxref_3_c_837_p B ) capacitor c=0.00441745f //x=10.115 //y=4.27 \
 //x2=10.85 //y2=3.51
cc_702 ( N_noxref_3_c_838_p B ) capacitor c=0.00668495f //x=10.145 //y=3.495 \
 //x2=10.85 //y2=3.51
cc_703 ( N_noxref_3_c_763_n B ) capacitor c=0.0132081f //x=4.93 //y=4.575 \
 //x2=4.93 //y2=3.14
cc_704 ( N_noxref_3_c_775_n B ) capacitor c=0.0075172f //x=4.975 //y=4.415 \
 //x2=4.93 //y2=3.14
cc_705 ( N_noxref_3_c_806_n B ) capacitor c=0.0092811f //x=7.15 //y=3.51 \
 //x2=7.15 //y2=4.62
cc_706 ( N_noxref_3_c_809_n B ) capacitor c=0.00931051f //x=9.955 //y=4.27 \
 //x2=7.15 //y2=4.62
cc_707 ( N_noxref_3_c_772_n B ) capacitor c=6.78671e-19 //x=10.11 //y=3.335 \
 //x2=10.85 //y2=3.14
cc_708 ( N_noxref_3_c_805_n B ) capacitor c=0.0139393f //x=10.11 //y=5.055 \
 //x2=10.85 //y2=4.99
cc_709 ( N_noxref_3_c_845_p B ) capacitor c=0.00153154f //x=10.39 //y=5.14 \
 //x2=10.85 //y2=4.99
cc_710 ( N_noxref_3_c_797_n N_B_c_1091_n ) capacitor c=0.00171814f //x=7.15 \
 //y=3.385 //x2=4.93 //y2=2.995
cc_711 ( N_noxref_3_c_772_n N_B_c_1094_n ) capacitor c=0.017255f //x=10.11 \
 //y=3.335 //x2=10.85 //y2=3.3
cc_712 ( N_noxref_3_c_772_n N_B_c_1095_n ) capacitor c=0.0173509f //x=10.11 \
 //y=3.335 //x2=10.85 //y2=2.265
cc_713 ( N_noxref_3_c_763_n N_B_c_1100_n ) capacitor c=8.94562e-19 //x=4.93 \
 //y=4.575 //x2=9.76 //y2=3.14
cc_714 ( N_noxref_3_c_797_n N_B_c_1100_n ) capacitor c=0.0236671f //x=7.15 \
 //y=3.385 //x2=9.76 //y2=3.14
cc_715 ( N_noxref_3_c_772_n N_B_c_1100_n ) capacitor c=9.10138e-19 //x=10.11 \
 //y=3.335 //x2=9.76 //y2=3.14
cc_716 ( N_noxref_3_c_831_p N_B_c_1100_n ) capacitor c=0.00252824f //x=10.11 \
 //y=3.655 //x2=9.76 //y2=3.14
cc_717 ( N_noxref_3_c_806_n N_B_c_1100_n ) capacitor c=0.00442261f //x=7.15 \
 //y=3.51 //x2=9.76 //y2=3.14
cc_718 ( N_noxref_3_c_778_n N_B_c_1100_n ) capacitor c=0.0128325f //x=4.975 \
 //y=4.28 //x2=9.76 //y2=3.14
cc_719 ( N_noxref_3_c_807_n N_B_c_1100_n ) capacitor c=0.0368037f //x=7.31 \
 //y=3.525 //x2=9.76 //y2=3.14
cc_720 ( N_noxref_3_c_781_n N_B_c_1100_n ) capacitor c=0.229568f //x=9.985 \
 //y=3.495 //x2=9.76 //y2=3.14
cc_721 ( N_noxref_3_c_772_n N_B_c_1101_n ) capacitor c=0.0279091f //x=10.11 \
 //y=3.335 //x2=10.36 //y2=3.11
cc_722 ( N_noxref_3_c_831_p N_B_c_1101_n ) capacitor c=0.00405043f //x=10.11 \
 //y=3.655 //x2=10.36 //y2=3.11
cc_723 ( N_noxref_3_c_838_p N_B_c_1101_n ) capacitor c=0.0358686f //x=10.145 \
 //y=3.495 //x2=10.36 //y2=3.11
cc_724 ( N_noxref_3_c_833_p N_B_c_1201_n ) capacitor c=0.00242768f //x=10.11 \
 //y=4.43 //x2=10.33 //y2=4.655
cc_725 ( N_noxref_3_c_805_n N_B_c_1201_n ) capacitor c=0.0247733f //x=10.11 \
 //y=5.055 //x2=10.33 //y2=4.655
cc_726 ( N_noxref_3_c_845_p N_B_c_1201_n ) capacitor c=0.00981692f //x=10.39 \
 //y=5.14 //x2=10.33 //y2=4.655
cc_727 ( N_noxref_3_c_833_p N_B_c_1157_n ) capacitor c=0.00285949f //x=10.11 \
 //y=4.43 //x2=9.985 //y2=4.655
cc_728 ( N_noxref_3_c_805_n N_B_c_1157_n ) capacitor c=0.00100708f //x=10.11 \
 //y=5.055 //x2=9.985 //y2=4.655
cc_729 ( N_noxref_3_c_778_n N_B_c_1157_n ) capacitor c=2.60705e-19 //x=4.975 \
 //y=4.28 //x2=9.985 //y2=4.655
cc_730 ( N_noxref_3_c_837_p N_B_c_1157_n ) capacitor c=0.0364799f //x=10.115 \
 //y=4.27 //x2=9.985 //y2=4.655
cc_731 ( N_noxref_3_c_809_n N_B_c_1157_n ) capacitor c=0.285501f //x=9.955 \
 //y=4.27 //x2=9.985 //y2=4.655
cc_732 ( N_noxref_3_c_805_n N_B_c_1209_n ) capacitor c=0.00842621f //x=10.11 \
 //y=5.055 //x2=11.02 //y2=4.99
cc_733 ( N_noxref_3_c_845_p N_B_c_1209_n ) capacitor c=0.00784963f //x=10.39 \
 //y=5.14 //x2=11.02 //y2=4.99
cc_734 ( N_noxref_3_c_870_p N_B_c_1209_n ) capacitor c=0.00103017f //x=10.475 \
 //y=5.42 //x2=11.02 //y2=4.99
cc_735 ( N_noxref_3_c_763_n N_B_c_1103_n ) capacitor c=0.00406614f //x=4.93 \
 //y=4.575 //x2=5.09 //y2=3.155
cc_736 ( N_noxref_3_c_778_n N_B_c_1103_n ) capacitor c=0.00735888f //x=4.975 \
 //y=4.28 //x2=5.09 //y2=3.155
cc_737 ( N_noxref_3_c_806_n N_B_c_1160_n ) capacitor c=0.00778656f //x=7.15 \
 //y=3.51 //x2=7.15 //y2=4.62
cc_738 ( N_noxref_3_c_809_n N_B_c_1160_n ) capacitor c=0.00158244f //x=9.955 \
 //y=4.27 //x2=7.15 //y2=4.62
cc_739 ( N_noxref_3_c_772_n N_B_c_1216_n ) capacitor c=4.71798e-19 //x=10.11 \
 //y=3.335 //x2=10.85 //y2=2.265
cc_740 ( N_noxref_3_c_805_n N_B_c_1217_n ) capacitor c=5.88334e-19 //x=10.11 \
 //y=5.055 //x2=10.85 //y2=4.88
cc_741 ( N_noxref_3_c_845_p N_B_M31_noxref_g ) capacitor c=0.00681176f \
 //x=10.39 //y=5.14 //x2=10.255 //y2=6.2
cc_742 ( N_noxref_3_c_878_p N_B_M31_noxref_g ) capacitor c=0.00229751f \
 //x=10.195 //y=5.14 //x2=10.255 //y2=6.2
cc_743 ( N_noxref_3_c_870_p N_B_M31_noxref_g ) capacitor c=0.00332234f \
 //x=10.475 //y=5.42 //x2=10.255 //y2=6.2
cc_744 ( N_noxref_3_c_880_p N_B_M31_noxref_g ) capacitor c=0.0162066f \
 //x=10.475 //y=5.56 //x2=10.255 //y2=6.2
cc_745 ( N_noxref_3_c_845_p N_B_M32_noxref_g ) capacitor c=0.00437347f \
 //x=10.39 //y=5.14 //x2=10.695 //y2=6.2
cc_746 ( N_noxref_3_c_870_p N_B_M32_noxref_g ) capacitor c=0.00141266f \
 //x=10.475 //y=5.42 //x2=10.695 //y2=6.2
cc_747 ( N_noxref_3_c_880_p N_B_M32_noxref_g ) capacitor c=0.0162066f \
 //x=10.475 //y=5.56 //x2=10.695 //y2=6.2
cc_748 ( N_noxref_3_c_777_n N_B_c_1225_n ) capacitor c=0.00147264f //x=10.48 \
 //y=1.185 //x2=10.21 //y2=1.09
cc_749 ( N_noxref_3_M5_noxref_d N_B_c_1225_n ) capacitor c=0.00136418f \
 //x=10.285 //y=1.09 //x2=10.21 //y2=1.09
cc_750 ( N_noxref_3_c_773_n N_B_c_1227_n ) capacitor c=0.00153269f //x=10.395 \
 //y=2.02 //x2=10.21 //y2=1.435
cc_751 ( N_noxref_3_c_887_p N_B_c_1227_n ) capacitor c=0.00322824f //x=10.48 \
 //y=1.935 //x2=10.21 //y2=1.435
cc_752 ( N_noxref_3_c_777_n N_B_c_1227_n ) capacitor c=0.00350441f //x=10.48 \
 //y=1.185 //x2=10.21 //y2=1.435
cc_753 ( N_noxref_3_M5_noxref_d N_B_c_1227_n ) capacitor c=0.00235934f \
 //x=10.285 //y=1.09 //x2=10.21 //y2=1.435
cc_754 ( N_noxref_3_c_845_p N_B_c_1231_n ) capacitor c=0.00262283f //x=10.39 \
 //y=5.14 //x2=10.62 //y2=4.97
cc_755 ( N_noxref_3_c_880_p N_B_c_1231_n ) capacitor c=0.00290963f //x=10.475 \
 //y=5.56 //x2=10.62 //y2=4.97
cc_756 ( N_noxref_3_c_833_p N_B_c_1233_n ) capacitor c=0.00105397f //x=10.11 \
 //y=4.43 //x2=10.33 //y2=4.97
cc_757 ( N_noxref_3_c_805_n N_B_c_1233_n ) capacitor c=0.00203237f //x=10.11 \
 //y=5.055 //x2=10.33 //y2=4.97
cc_758 ( N_noxref_3_c_836_p N_B_c_1233_n ) capacitor c=2.84121e-19 //x=10.11 \
 //y=4.25 //x2=10.33 //y2=4.97
cc_759 ( N_noxref_3_c_777_n N_B_c_1236_n ) capacitor c=5.57924e-19 //x=10.48 \
 //y=1.185 //x2=10.585 //y2=0.935
cc_760 ( N_noxref_3_M5_noxref_d N_B_c_1236_n ) capacitor c=0.0020782f \
 //x=10.285 //y=1.09 //x2=10.585 //y2=0.935
cc_761 ( N_noxref_3_c_773_n N_B_c_1238_n ) capacitor c=2.8493e-19 //x=10.395 \
 //y=2.02 //x2=10.585 //y2=1.59
cc_762 ( N_noxref_3_c_887_p N_B_c_1238_n ) capacitor c=0.0089845f //x=10.48 \
 //y=1.935 //x2=10.585 //y2=1.59
cc_763 ( N_noxref_3_c_777_n N_B_c_1238_n ) capacitor c=5.77693e-19 //x=10.48 \
 //y=1.185 //x2=10.585 //y2=1.59
cc_764 ( N_noxref_3_M5_noxref_d N_B_c_1238_n ) capacitor c=0.00356097f \
 //x=10.285 //y=1.09 //x2=10.585 //y2=1.59
cc_765 ( N_noxref_3_c_777_n N_B_c_1242_n ) capacitor c=0.00175772f //x=10.48 \
 //y=1.185 //x2=10.74 //y2=1.09
cc_766 ( N_noxref_3_M5_noxref_d N_B_c_1242_n ) capacitor c=0.00139961f \
 //x=10.285 //y=1.09 //x2=10.74 //y2=1.09
cc_767 ( N_noxref_3_c_887_p N_B_c_1244_n ) capacitor c=0.00107851f //x=10.48 \
 //y=1.935 //x2=10.74 //y2=1.435
cc_768 ( N_noxref_3_c_777_n N_B_c_1244_n ) capacitor c=0.00350474f //x=10.48 \
 //y=1.185 //x2=10.74 //y2=1.435
cc_769 ( N_noxref_3_M5_noxref_d N_B_c_1244_n ) capacitor c=0.0023891f \
 //x=10.285 //y=1.09 //x2=10.74 //y2=1.435
cc_770 ( N_noxref_3_c_887_p N_B_c_1247_n ) capacitor c=0.00523977f //x=10.48 \
 //y=1.935 //x2=10.74 //y2=1.745
cc_771 ( N_noxref_3_c_887_p N_B_c_1248_n ) capacitor c=0.00366751f //x=10.48 \
 //y=1.935 //x2=10.74 //y2=2.1
cc_772 ( N_noxref_3_c_772_n N_B_c_1249_n ) capacitor c=0.00269121f //x=10.11 \
 //y=3.335 //x2=10.74 //y2=2.265
cc_773 ( N_noxref_3_c_773_n N_B_c_1249_n ) capacitor c=0.00366751f //x=10.395 \
 //y=2.02 //x2=10.74 //y2=2.265
cc_774 ( N_noxref_3_c_763_n N_noxref_5_c_1727_n ) capacitor c=0.00303165f \
 //x=4.93 //y=4.575 //x2=5.335 //y2=5.385
cc_775 ( N_noxref_3_c_767_n N_noxref_5_c_1727_n ) capacitor c=0.00292208f \
 //x=4.93 //y=4.765 //x2=5.335 //y2=5.385
cc_776 ( N_noxref_3_c_778_n N_noxref_5_c_1727_n ) capacitor c=0.00178776f \
 //x=4.975 //y=4.28 //x2=5.335 //y2=5.385
cc_777 ( N_noxref_3_c_809_n N_noxref_5_c_1727_n ) capacitor c=0.00420305f \
 //x=9.955 //y=4.27 //x2=5.335 //y2=5.385
cc_778 ( N_noxref_3_c_782_n N_noxref_5_c_1727_n ) capacitor c=0.00104675f \
 //x=4.93 //y=4.88 //x2=5.335 //y2=5.385
cc_779 ( N_noxref_3_M26_noxref_g N_noxref_5_c_1727_n ) capacitor c=0.00982401f \
 //x=5.04 //y=6.2 //x2=5.335 //y2=5.385
cc_780 ( N_noxref_3_c_763_n N_noxref_5_c_1733_n ) capacitor c=2.47143e-19 \
 //x=4.93 //y=4.575 //x2=5.335 //y2=1.835
cc_781 ( N_noxref_3_c_771_n N_noxref_5_c_1626_n ) capacitor c=0.00484003f \
 //x=7.15 //y=2.385 //x2=5.42 //y2=3.735
cc_782 ( N_noxref_3_c_797_n N_noxref_5_c_1626_n ) capacitor c=0.0129604f \
 //x=7.15 //y=3.385 //x2=5.42 //y2=3.735
cc_783 ( N_noxref_3_c_806_n N_noxref_5_c_1626_n ) capacitor c=0.00403661f \
 //x=7.15 //y=3.51 //x2=5.42 //y2=3.735
cc_784 ( N_noxref_3_c_807_n N_noxref_5_c_1626_n ) capacitor c=0.00354109f \
 //x=7.31 //y=3.525 //x2=5.42 //y2=3.735
cc_785 ( N_noxref_3_c_809_n N_noxref_5_c_1629_n ) capacitor c=0.00907117f \
 //x=9.955 //y=4.27 //x2=5.42 //y2=4.055
cc_786 ( N_noxref_3_c_763_n N_noxref_5_c_1630_n ) capacitor c=0.0458811f \
 //x=4.93 //y=4.575 //x2=5.42 //y2=5.3
cc_787 ( N_noxref_3_c_767_n N_noxref_5_c_1630_n ) capacitor c=0.0358146f \
 //x=4.93 //y=4.765 //x2=5.42 //y2=5.3
cc_788 ( N_noxref_3_c_775_n N_noxref_5_c_1630_n ) capacitor c=0.00654928f \
 //x=4.975 //y=4.415 //x2=5.42 //y2=5.3
cc_789 ( N_noxref_3_c_778_n N_noxref_5_c_1630_n ) capacitor c=0.00664189f \
 //x=4.975 //y=4.28 //x2=5.42 //y2=5.3
cc_790 ( N_noxref_3_c_809_n N_noxref_5_c_1630_n ) capacitor c=0.0265986f \
 //x=9.955 //y=4.27 //x2=5.42 //y2=5.3
cc_791 ( N_noxref_3_c_782_n N_noxref_5_c_1630_n ) capacitor c=0.00463729f \
 //x=4.93 //y=4.88 //x2=5.42 //y2=5.3
cc_792 ( N_noxref_3_c_789_n N_noxref_5_c_1630_n ) capacitor c=0.0102862f \
 //x=4.93 //y=4.88 //x2=5.42 //y2=5.3
cc_793 ( N_noxref_3_c_777_n N_noxref_5_c_1634_n ) capacitor c=0.00581196f \
 //x=10.48 //y=1.185 //x2=8.19 //y2=1.3
cc_794 ( N_noxref_3_c_887_p N_noxref_5_c_1668_n ) capacitor c=0.00446867f \
 //x=10.48 //y=1.935 //x2=8.19 //y2=1.75
cc_795 ( N_noxref_3_c_777_n N_noxref_5_c_1668_n ) capacitor c=6.23317e-19 \
 //x=10.48 //y=1.185 //x2=8.19 //y2=1.75
cc_796 ( N_noxref_3_c_887_p N_noxref_5_c_1676_n ) capacitor c=0.00312244f \
 //x=10.48 //y=1.935 //x2=8.545 //y2=1.835
cc_797 ( N_noxref_3_c_797_n N_noxref_5_c_1636_n ) capacitor c=0.00378988f \
 //x=7.15 //y=3.385 //x2=8.63 //y2=3.735
cc_798 ( N_noxref_3_c_831_p N_noxref_5_c_1636_n ) capacitor c=0.00398704f \
 //x=10.11 //y=3.655 //x2=8.63 //y2=3.735
cc_799 ( N_noxref_3_c_804_n N_noxref_5_c_1636_n ) capacitor c=0.0016325f \
 //x=10.11 //y=4.135 //x2=8.63 //y2=3.735
cc_800 ( N_noxref_3_c_773_n N_noxref_5_c_1636_n ) capacitor c=2.25293e-19 \
 //x=10.395 //y=2.02 //x2=8.63 //y2=3.735
cc_801 ( N_noxref_3_c_774_n N_noxref_5_c_1636_n ) capacitor c=0.0232879f \
 //x=10.195 //y=2.02 //x2=8.63 //y2=3.735
cc_802 ( N_noxref_3_c_835_p N_noxref_5_c_1636_n ) capacitor c=2.17715e-19 \
 //x=10.11 //y=3.51 //x2=8.63 //y2=3.735
cc_803 ( N_noxref_3_c_838_p N_noxref_5_c_1636_n ) capacitor c=0.00191229f \
 //x=10.145 //y=3.495 //x2=8.63 //y2=3.735
cc_804 ( N_noxref_3_c_781_n N_noxref_5_c_1636_n ) capacitor c=0.0203568f \
 //x=9.985 //y=3.495 //x2=8.63 //y2=3.735
cc_805 ( N_noxref_3_c_804_n N_noxref_5_c_1693_n ) capacitor c=0.00369257f \
 //x=10.11 //y=4.135 //x2=8.63 //y2=4.055
cc_806 ( N_noxref_3_c_809_n N_noxref_5_c_1693_n ) capacitor c=0.00540116f \
 //x=9.955 //y=4.27 //x2=8.63 //y2=4.055
cc_807 ( N_noxref_3_c_781_n N_noxref_5_c_1693_n ) capacitor c=0.0076014f \
 //x=9.985 //y=3.495 //x2=8.63 //y2=4.055
cc_808 ( N_noxref_3_c_804_n N_noxref_5_c_1697_n ) capacitor c=0.00139895f \
 //x=10.11 //y=4.135 //x2=8.63 //y2=5.3
cc_809 ( N_noxref_3_c_833_p N_noxref_5_c_1697_n ) capacitor c=0.00436509f \
 //x=10.11 //y=4.43 //x2=8.63 //y2=5.3
cc_810 ( N_noxref_3_c_805_n N_noxref_5_c_1697_n ) capacitor c=0.0134106f \
 //x=10.11 //y=5.055 //x2=8.63 //y2=5.3
cc_811 ( N_noxref_3_c_870_p N_noxref_5_c_1697_n ) capacitor c=0.00257504f \
 //x=10.475 //y=5.42 //x2=8.63 //y2=5.3
cc_812 ( N_noxref_3_c_836_p N_noxref_5_c_1697_n ) capacitor c=5.93415e-19 \
 //x=10.11 //y=4.25 //x2=8.63 //y2=5.3
cc_813 ( N_noxref_3_c_837_p N_noxref_5_c_1697_n ) capacitor c=0.0016766f \
 //x=10.115 //y=4.27 //x2=8.63 //y2=5.3
cc_814 ( N_noxref_3_c_809_n N_noxref_5_c_1697_n ) capacitor c=0.0201136f \
 //x=9.955 //y=4.27 //x2=8.63 //y2=5.3
cc_815 ( N_noxref_3_c_772_n N_noxref_5_c_1768_n ) capacitor c=0.0019531f \
 //x=10.11 //y=3.335 //x2=12.33 //y2=3.6
cc_816 ( N_noxref_3_c_804_n N_noxref_5_c_1638_n ) capacitor c=3.20105e-19 \
 //x=10.11 //y=4.135 //x2=12.33 //y2=3.92
cc_817 ( N_noxref_3_c_805_n N_noxref_5_c_1770_n ) capacitor c=7.00021e-19 \
 //x=10.11 //y=5.055 //x2=12.33 //y2=4.76
cc_818 ( N_noxref_3_c_763_n N_noxref_5_c_1701_n ) capacitor c=6.66577e-19 \
 //x=4.93 //y=4.575 //x2=4.82 //y2=5.385
cc_819 ( N_noxref_3_c_767_n N_noxref_5_c_1701_n ) capacitor c=0.0207548f \
 //x=4.93 //y=4.765 //x2=4.82 //y2=5.385
cc_820 ( N_noxref_3_c_782_n N_noxref_5_c_1701_n ) capacitor c=0.00390413f \
 //x=4.93 //y=4.88 //x2=4.82 //y2=5.385
cc_821 ( N_noxref_3_M25_noxref_g N_noxref_5_c_1701_n ) capacitor c=0.00179689f \
 //x=4.6 //y=6.2 //x2=4.82 //y2=5.385
cc_822 ( N_noxref_3_M26_noxref_g N_noxref_5_c_1701_n ) capacitor c=0.00277466f \
 //x=5.04 //y=6.2 //x2=4.82 //y2=5.385
cc_823 ( N_noxref_3_c_789_n N_noxref_5_c_1701_n ) capacitor c=0.00203067f \
 //x=4.93 //y=4.88 //x2=4.82 //y2=5.385
cc_824 ( N_noxref_3_c_870_p N_noxref_5_c_1702_n ) capacitor c=4.99083e-19 \
 //x=10.475 //y=5.42 //x2=8.15 //y2=5.385
cc_825 ( N_noxref_3_c_804_n N_noxref_5_c_1707_n ) capacitor c=2.63678e-19 \
 //x=10.11 //y=4.135 //x2=8.63 //y2=3.88
cc_826 ( N_noxref_3_c_835_p N_noxref_5_c_1779_n ) capacitor c=3.56947e-19 \
 //x=10.11 //y=3.51 //x2=12.33 //y2=3.715
cc_827 ( N_noxref_3_c_836_p N_noxref_5_c_1780_n ) capacitor c=5.25391e-19 \
 //x=10.11 //y=4.25 //x2=12.33 //y2=4.25
cc_828 ( N_noxref_3_c_837_p N_noxref_5_c_1781_n ) capacitor c=0.00276402f \
 //x=10.115 //y=4.27 //x2=12.49 //y2=4.25
cc_829 ( N_noxref_3_c_809_n N_noxref_5_c_1645_n ) capacitor c=0.0365231f \
 //x=9.955 //y=4.27 //x2=5.625 //y2=3.895
cc_830 ( N_noxref_3_c_806_n N_noxref_5_c_1709_n ) capacitor c=0.00760299f \
 //x=7.15 //y=3.51 //x2=8.485 //y2=3.895
cc_831 ( N_noxref_3_c_807_n N_noxref_5_c_1709_n ) capacitor c=0.0349865f \
 //x=7.31 //y=3.525 //x2=8.485 //y2=3.895
cc_832 ( N_noxref_3_c_809_n N_noxref_5_c_1709_n ) capacitor c=0.252326f \
 //x=9.955 //y=4.27 //x2=8.485 //y2=3.895
cc_833 ( N_noxref_3_c_781_n N_noxref_5_c_1709_n ) capacitor c=0.0922798f \
 //x=9.985 //y=3.495 //x2=8.485 //y2=3.895
cc_834 ( N_noxref_3_c_804_n N_noxref_5_c_1711_n ) capacitor c=0.00270629f \
 //x=10.11 //y=4.135 //x2=8.805 //y2=3.895
cc_835 ( N_noxref_3_c_809_n N_noxref_5_c_1711_n ) capacitor c=0.0360345f \
 //x=9.955 //y=4.27 //x2=8.805 //y2=3.895
cc_836 ( N_noxref_3_c_781_n N_noxref_5_c_1711_n ) capacitor c=0.0360345f \
 //x=9.985 //y=3.495 //x2=8.805 //y2=3.895
cc_837 ( N_noxref_3_c_831_p N_noxref_5_c_1646_n ) capacitor c=0.00515051f \
 //x=10.11 //y=3.655 //x2=11.765 //y2=3.842
cc_838 ( N_noxref_3_c_804_n N_noxref_5_c_1646_n ) capacitor c=0.0216183f \
 //x=10.11 //y=4.135 //x2=11.765 //y2=3.842
cc_839 ( N_noxref_3_c_833_p N_noxref_5_c_1646_n ) capacitor c=0.00280495f \
 //x=10.11 //y=4.43 //x2=11.765 //y2=3.842
cc_840 ( N_noxref_3_c_837_p N_noxref_5_c_1646_n ) capacitor c=0.0364491f \
 //x=10.115 //y=4.27 //x2=11.765 //y2=3.842
cc_841 ( N_noxref_3_c_809_n N_noxref_5_c_1646_n ) capacitor c=0.094932f \
 //x=9.955 //y=4.27 //x2=11.765 //y2=3.842
cc_842 ( N_noxref_3_c_838_p N_noxref_5_c_1646_n ) capacitor c=0.0361555f \
 //x=10.145 //y=3.495 //x2=11.765 //y2=3.842
cc_843 ( N_noxref_3_c_781_n N_noxref_5_c_1646_n ) capacitor c=0.104061f \
 //x=9.985 //y=3.495 //x2=11.765 //y2=3.842
cc_844 ( N_noxref_3_c_838_p N_noxref_5_c_1797_n ) capacitor c=4.38256e-19 \
 //x=10.145 //y=3.495 //x2=12.335 //y2=3.76
cc_845 ( N_noxref_3_c_767_n N_noxref_5_c_1798_n ) capacitor c=0.00137304f \
 //x=4.93 //y=4.765 //x2=4.82 //y2=5.555
cc_846 ( N_noxref_3_c_782_n N_noxref_5_c_1798_n ) capacitor c=0.00414188f \
 //x=4.93 //y=4.88 //x2=4.82 //y2=5.555
cc_847 ( N_noxref_3_M25_noxref_g N_noxref_5_c_1798_n ) capacitor c=0.0120591f \
 //x=4.6 //y=6.2 //x2=4.82 //y2=5.555
cc_848 ( N_noxref_3_M26_noxref_g N_noxref_5_c_1798_n ) capacitor c=0.0140704f \
 //x=5.04 //y=6.2 //x2=4.82 //y2=5.555
cc_849 ( N_noxref_3_c_789_n N_noxref_5_c_1798_n ) capacitor c=0.00435839f \
 //x=4.93 //y=4.88 //x2=4.82 //y2=5.555
cc_850 ( N_noxref_3_c_887_p N_noxref_6_c_2365_n ) capacitor c=0.00377614f \
 //x=10.48 //y=1.935 //x2=12.7 //y2=1.935
cc_851 ( N_noxref_3_c_870_p N_noxref_6_c_2366_n ) capacitor c=0.00236401f \
 //x=10.475 //y=5.42 //x2=12.705 //y2=5.42
cc_852 ( N_noxref_3_c_773_n N_noxref_6_c_2360_n ) capacitor c=0.00377614f \
 //x=10.395 //y=2.02 //x2=12.785 //y2=2.02
cc_853 ( N_noxref_3_c_845_p N_noxref_6_c_2368_n ) capacitor c=0.00228249f \
 //x=10.39 //y=5.14 //x2=12.79 //y2=5.14
cc_854 ( N_noxref_3_c_777_n N_noxref_6_c_2363_n ) capacitor c=0.00705205f \
 //x=10.48 //y=1.185 //x2=12.7 //y2=1.185
cc_855 ( N_noxref_3_c_878_p N_VDD_c_5065_n ) capacitor c=0.00200154f \
 //x=10.195 //y=5.14 //x2=14.955 //y2=7.585
cc_856 ( N_noxref_3_c_870_p N_VDD_c_5065_n ) capacitor c=0.00259718f \
 //x=10.475 //y=5.42 //x2=14.955 //y2=7.585
cc_857 ( N_noxref_3_c_880_p N_VDD_c_5065_n ) capacitor c=0.00241566f \
 //x=10.475 //y=5.56 //x2=14.955 //y2=7.585
cc_858 ( N_noxref_3_M25_noxref_g N_VDD_c_5001_n ) capacitor c=0.00777954f \
 //x=4.6 //y=6.2 //x2=5.87 //y2=7.585
cc_859 ( N_noxref_3_M26_noxref_g N_VDD_c_5001_n ) capacitor c=0.00758899f \
 //x=5.04 //y=6.2 //x2=5.87 //y2=7.585
cc_860 ( N_noxref_3_c_878_p N_VDD_c_5070_n ) capacitor c=0.0019409f //x=10.195 \
 //y=5.14 //x2=10.83 //y2=7.585
cc_861 ( N_noxref_3_c_870_p N_VDD_c_5070_n ) capacitor c=8.96756e-19 \
 //x=10.475 //y=5.42 //x2=10.83 //y2=7.585
cc_862 ( N_noxref_3_c_880_p N_VDD_c_5070_n ) capacitor c=0.0138017f //x=10.475 \
 //y=5.56 //x2=10.83 //y2=7.585
cc_863 ( N_noxref_3_c_775_n N_VDD_c_5056_n ) capacitor c=0.00225757f //x=4.975 \
 //y=4.415 //x2=6.04 //y2=7.585
cc_864 ( N_noxref_3_c_809_n N_VDD_c_5056_n ) capacitor c=0.020338f //x=9.955 \
 //y=4.27 //x2=6.04 //y2=7.585
cc_865 ( N_noxref_3_c_782_n N_VDD_c_5056_n ) capacitor c=0.00347829f //x=4.93 \
 //y=4.88 //x2=6.04 //y2=7.585
cc_866 ( N_noxref_3_c_789_n N_VDD_c_5056_n ) capacitor c=0.0200066f //x=4.93 \
 //y=4.88 //x2=6.04 //y2=7.585
cc_867 ( N_noxref_3_c_833_p N_VDD_c_5057_n ) capacitor c=0.00193791f //x=10.11 \
 //y=4.43 //x2=9.37 //y2=7.585
cc_868 ( N_noxref_3_c_805_n N_VDD_c_5057_n ) capacitor c=0.0163254f //x=10.11 \
 //y=5.055 //x2=9.37 //y2=7.585
cc_869 ( N_noxref_3_c_870_p N_VDD_c_5057_n ) capacitor c=0.00203464f \
 //x=10.475 //y=5.42 //x2=9.37 //y2=7.585
cc_870 ( N_noxref_3_c_836_p N_VDD_c_5057_n ) capacitor c=0.00491566f //x=10.11 \
 //y=4.25 //x2=9.37 //y2=7.585
cc_871 ( N_noxref_3_c_809_n N_VDD_c_5057_n ) capacitor c=0.00928993f //x=9.955 \
 //y=4.27 //x2=9.37 //y2=7.585
cc_872 ( N_noxref_3_c_880_p N_VDD_c_5057_n ) capacitor c=0.00821754f \
 //x=10.475 //y=5.56 //x2=9.37 //y2=7.585
cc_873 ( N_noxref_3_c_845_p N_VDD_c_5083_n ) capacitor c=0.00464104f //x=10.39 \
 //y=5.14 //x2=11.59 //y2=7.585
cc_874 ( N_noxref_3_c_836_p N_VDD_c_5083_n ) capacitor c=0.00143727f //x=10.11 \
 //y=4.25 //x2=11.59 //y2=7.585
cc_875 ( N_noxref_3_c_880_p N_VDD_c_5083_n ) capacitor c=0.00823054f \
 //x=10.475 //y=5.56 //x2=11.59 //y2=7.585
cc_876 ( N_noxref_3_c_833_p N_VDD_M31_noxref_s ) capacitor c=0.00402344f \
 //x=10.11 //y=4.43 //x2=9.91 //y2=5.2
cc_877 ( N_noxref_3_c_878_p N_VDD_M31_noxref_s ) capacitor c=0.0201079f \
 //x=10.195 //y=5.14 //x2=9.91 //y2=5.2
cc_878 ( N_noxref_3_c_870_p N_VDD_M31_noxref_s ) capacitor c=0.0474638f \
 //x=10.475 //y=5.42 //x2=9.91 //y2=5.2
cc_879 ( N_noxref_3_c_836_p N_VDD_M31_noxref_s ) capacitor c=0.00133028f \
 //x=10.11 //y=4.25 //x2=9.91 //y2=5.2
cc_880 ( N_noxref_3_c_880_p N_VDD_M31_noxref_s ) capacitor c=0.0905537f \
 //x=10.475 //y=5.56 //x2=9.91 //y2=5.2
cc_881 ( N_noxref_3_c_870_p N_VDD_M32_noxref_d ) capacitor c=0.0465737f \
 //x=10.475 //y=5.42 //x2=10.77 //y2=5.2
cc_882 ( N_noxref_3_c_880_p N_VDD_M32_noxref_d ) capacitor c=0.0899709f \
 //x=10.475 //y=5.56 //x2=10.77 //y2=5.2
cc_883 ( N_noxref_3_c_870_p N_VDD_M33_noxref_s ) capacitor c=8.21385e-19 \
 //x=10.475 //y=5.42 //x2=12.13 //y2=5.2
cc_884 ( N_noxref_3_M25_noxref_g N_noxref_16_c_5819_n ) capacitor c=0.0090785f \
 //x=4.6 //y=6.2 //x2=5.145 //y2=7.085
cc_885 ( N_noxref_3_M26_noxref_g N_noxref_16_c_5819_n ) capacitor \
 c=0.00931972f //x=5.04 //y=6.2 //x2=5.145 //y2=7.085
cc_886 ( N_noxref_3_M25_noxref_g N_noxref_16_c_5812_n ) capacitor \
 c=0.00179653f //x=4.6 //y=6.2 //x2=4.38 //y2=5.385
cc_887 ( N_noxref_3_M25_noxref_g N_noxref_16_c_5813_n ) capacitor \
 c=0.00179267f //x=4.6 //y=6.2 //x2=4.38 //y2=6.915
cc_888 ( N_noxref_3_M26_noxref_g N_noxref_16_c_5823_n ) capacitor \
 c=0.00394587f //x=5.04 //y=6.2 //x2=5.26 //y2=6.915
cc_889 ( N_noxref_3_M25_noxref_g N_noxref_16_c_5816_n ) capacitor c=0.0170175f \
 //x=4.6 //y=6.2 //x2=4.38 //y2=5.555
cc_890 ( N_noxref_3_M26_noxref_g N_noxref_16_M26_noxref_d ) capacitor \
 c=0.0365939f //x=5.04 //y=6.2 //x2=5.115 //y2=5.2
cc_891 ( N_noxref_3_c_809_n N_noxref_17_c_5889_n ) capacitor c=0.00758358f \
 //x=9.955 //y=4.27 //x2=6.83 //y2=5.385
cc_892 ( N_noxref_3_c_870_p N_noxref_17_c_5884_n ) capacitor c=4.00761e-19 \
 //x=10.475 //y=5.42 //x2=7.71 //y2=5.385
cc_893 ( N_noxref_3_c_771_n N_GND_c_6138_n ) capacitor c=0.00270311f //x=7.15 \
 //y=2.385 //x2=7.22 //y2=1.025
cc_894 ( N_noxref_3_c_806_n N_GND_c_6138_n ) capacitor c=2.93809e-19 //x=7.15 \
 //y=3.51 //x2=7.22 //y2=1.025
cc_895 ( N_noxref_3_c_813_n N_GND_c_6138_n ) capacitor c=4.17987e-19 //x=7.15 \
 //y=2.265 //x2=7.22 //y2=1.025
cc_896 ( N_noxref_3_c_816_n N_GND_c_6138_n ) capacitor c=0.00144305f //x=6.955 \
 //y=1.05 //x2=7.22 //y2=1.025
cc_897 ( N_noxref_3_c_817_n N_GND_c_6138_n ) capacitor c=0.00300481f //x=6.955 \
 //y=1.395 //x2=7.22 //y2=1.025
cc_898 ( N_noxref_3_c_1034_p N_GND_c_6138_n ) capacitor c=0.00942865f //x=7.33 \
 //y=0.895 //x2=7.22 //y2=1.025
cc_899 ( N_noxref_3_c_1035_p N_GND_c_6138_n ) capacitor c=5.58852e-19 //x=7.33 \
 //y=1.55 //x2=7.22 //y2=1.025
cc_900 ( N_noxref_3_c_824_n N_GND_c_6138_n ) capacitor c=0.00170944f //x=7.485 \
 //y=1.05 //x2=7.22 //y2=1.025
cc_901 ( N_noxref_3_c_826_n N_GND_c_6138_n ) capacitor c=0.00212338f //x=7.485 \
 //y=1.395 //x2=7.22 //y2=1.025
cc_902 ( N_noxref_3_c_831_p N_GND_c_6139_n ) capacitor c=2.90073e-19 //x=10.11 \
 //y=3.655 //x2=14.905 //y2=0.175
cc_903 ( N_noxref_3_c_774_n N_GND_c_6139_n ) capacitor c=0.00145429f \
 //x=10.195 //y=2.02 //x2=14.905 //y2=0.175
cc_904 ( N_noxref_3_c_777_n N_GND_c_6139_n ) capacitor c=0.00957658f //x=10.48 \
 //y=1.185 //x2=14.905 //y2=0.175
cc_905 ( N_noxref_3_M5_noxref_d N_GND_c_6139_n ) capacitor c=0.00119455f \
 //x=10.285 //y=1.09 //x2=14.905 //y2=0.175
cc_906 ( N_noxref_3_c_816_n N_GND_c_6248_n ) capacitor c=0.00684115f //x=6.955 \
 //y=1.05 //x2=9.2 //y2=0.175
cc_907 ( N_noxref_3_c_774_n N_GND_c_6249_n ) capacitor c=0.00258806f \
 //x=10.195 //y=2.02 //x2=10.395 //y2=0.715
cc_908 ( N_noxref_3_c_835_p N_GND_c_6249_n ) capacitor c=2.56972e-19 //x=10.11 \
 //y=3.51 //x2=10.395 //y2=0.715
cc_909 ( N_noxref_3_c_777_n N_GND_c_6249_n ) capacitor c=0.00130539f //x=10.48 \
 //y=1.185 //x2=10.395 //y2=0.715
cc_910 ( N_noxref_3_c_777_n N_GND_c_6156_n ) capacitor c=0.00130539f //x=10.48 \
 //y=1.185 //x2=10.875 //y2=0.715
cc_911 ( N_noxref_3_c_771_n N_GND_c_6173_n ) capacitor c=0.00394736f //x=7.15 \
 //y=2.385 //x2=6.04 //y2=0.175
cc_912 ( N_noxref_3_c_797_n N_GND_c_6173_n ) capacitor c=0.00664422f //x=7.15 \
 //y=3.385 //x2=6.04 //y2=0.175
cc_913 ( N_noxref_3_c_813_n N_GND_c_6173_n ) capacitor c=0.00369503f //x=7.15 \
 //y=2.265 //x2=6.04 //y2=0.175
cc_914 ( N_noxref_3_c_818_n N_GND_c_6173_n ) capacitor c=0.0015404f //x=6.955 \
 //y=1.705 //x2=6.04 //y2=0.175
cc_915 ( N_noxref_3_c_820_n N_GND_c_6173_n ) capacitor c=0.00905324f //x=6.955 \
 //y=2.1 //x2=6.04 //y2=0.175
cc_916 ( N_noxref_3_c_773_n N_GND_c_6175_n ) capacitor c=2.4805e-19 //x=10.395 \
 //y=2.02 //x2=9.37 //y2=0.175
cc_917 ( N_noxref_3_c_774_n N_GND_c_6175_n ) capacitor c=0.0197233f //x=10.195 \
 //y=2.02 //x2=9.37 //y2=0.175
cc_918 ( N_noxref_3_c_887_p N_GND_c_6176_n ) capacitor c=0.00168596f //x=10.48 \
 //y=1.935 //x2=11.59 //y2=0.175
cc_919 ( N_noxref_3_c_771_n N_GND_M3_noxref_d ) capacitor c=4.23034e-19 \
 //x=7.15 //y=2.385 //x2=7.03 //y2=1.05
cc_920 ( N_noxref_3_c_816_n N_GND_M3_noxref_d ) capacitor c=0.00192399f \
 //x=6.955 //y=1.05 //x2=7.03 //y2=1.05
cc_921 ( N_noxref_3_c_817_n N_GND_M3_noxref_d ) capacitor c=0.00210798f \
 //x=6.955 //y=1.395 //x2=7.03 //y2=1.05
cc_922 ( N_noxref_3_c_1034_p N_GND_M3_noxref_d ) capacitor c=0.00473146f \
 //x=7.33 //y=0.895 //x2=7.03 //y2=1.05
cc_923 ( N_noxref_3_c_1035_p N_GND_M3_noxref_d ) capacitor c=0.00166857f \
 //x=7.33 //y=1.55 //x2=7.03 //y2=1.05
cc_924 ( N_noxref_3_c_824_n N_GND_M3_noxref_d ) capacitor c=0.00230174f \
 //x=7.485 //y=1.05 //x2=7.03 //y2=1.05
cc_925 ( N_noxref_3_c_826_n N_GND_M3_noxref_d ) capacitor c=0.00210798f \
 //x=7.485 //y=1.395 //x2=7.03 //y2=1.05
cc_926 ( N_noxref_3_c_831_p N_GND_M5_noxref_s ) capacitor c=0.00134951f \
 //x=10.11 //y=3.655 //x2=9.865 //y2=0.55
cc_927 ( N_noxref_3_c_774_n N_GND_M5_noxref_s ) capacitor c=0.0033702f \
 //x=10.195 //y=2.02 //x2=9.865 //y2=0.55
cc_928 ( N_noxref_3_c_887_p N_GND_M5_noxref_s ) capacitor c=0.0286241f \
 //x=10.48 //y=1.935 //x2=9.865 //y2=0.55
cc_929 ( N_noxref_3_c_835_p N_GND_M5_noxref_s ) capacitor c=7.24953e-19 \
 //x=10.11 //y=3.51 //x2=9.865 //y2=0.55
cc_930 ( N_noxref_3_c_777_n N_GND_M5_noxref_s ) capacitor c=0.0138671f \
 //x=10.48 //y=1.185 //x2=9.865 //y2=0.55
cc_931 ( N_noxref_3_M5_noxref_d N_GND_M5_noxref_s ) capacitor c=0.0373268f \
 //x=10.285 //y=1.09 //x2=9.865 //y2=0.55
cc_932 ( N_noxref_3_c_820_n N_noxref_24_c_7176_n ) capacitor c=0.00262672f \
 //x=6.955 //y=2.1 //x2=6.735 //y2=1.68
cc_933 ( N_noxref_3_c_771_n N_noxref_24_c_7177_n ) capacitor c=0.00528521f \
 //x=7.15 //y=2.385 //x2=7.62 //y2=1.765
cc_934 ( N_noxref_3_c_806_n N_noxref_24_c_7177_n ) capacitor c=0.00242244f \
 //x=7.15 //y=3.51 //x2=7.62 //y2=1.765
cc_935 ( N_noxref_3_c_813_n N_noxref_24_c_7177_n ) capacitor c=0.00763108f \
 //x=7.15 //y=2.265 //x2=7.62 //y2=1.765
cc_936 ( N_noxref_3_c_818_n N_noxref_24_c_7177_n ) capacitor c=0.00697569f \
 //x=6.955 //y=1.705 //x2=7.62 //y2=1.765
cc_937 ( N_noxref_3_c_820_n N_noxref_24_c_7177_n ) capacitor c=0.0167993f \
 //x=6.955 //y=2.1 //x2=7.62 //y2=1.765
cc_938 ( N_noxref_3_c_1035_p N_noxref_24_c_7177_n ) capacitor c=0.00725634f \
 //x=7.33 //y=1.55 //x2=7.62 //y2=1.765
cc_939 ( N_noxref_3_c_826_n N_noxref_24_c_7177_n ) capacitor c=0.0034036f \
 //x=7.485 //y=1.395 //x2=7.62 //y2=1.765
cc_940 ( N_noxref_3_c_820_n N_noxref_24_c_7178_n ) capacitor c=6.71402e-19 \
 //x=6.955 //y=2.1 //x2=7.705 //y2=1.68
cc_941 ( N_noxref_3_c_816_n N_noxref_24_M3_noxref_s ) capacitor c=0.0294925f \
 //x=6.955 //y=1.05 //x2=6.6 //y2=0.55
cc_942 ( N_noxref_3_c_818_n N_noxref_24_M3_noxref_s ) capacitor c=3.48408e-19 \
 //x=6.955 //y=1.705 //x2=6.6 //y2=0.55
cc_943 ( N_noxref_3_c_824_n N_noxref_24_M3_noxref_s ) capacitor c=0.0125442f \
 //x=7.485 //y=1.05 //x2=6.6 //y2=0.55
cc_944 ( N_B_c_1117_n N_noxref_5_c_1624_n ) capacitor c=5.45132e-19 //x=4.595 \
 //y=1.09 //x2=4.86 //y2=1.305
cc_945 ( N_B_c_1120_n N_noxref_5_c_1624_n ) capacitor c=0.00220865f //x=4.595 \
 //y=1.435 //x2=4.86 //y2=1.305
cc_946 ( N_B_c_1253_p N_noxref_5_c_1624_n ) capacitor c=5.33629e-19 //x=4.97 \
 //y=0.935 //x2=4.86 //y2=1.305
cc_947 ( N_B_c_1254_p N_noxref_5_c_1624_n ) capacitor c=5.44173e-19 //x=4.97 \
 //y=1.59 //x2=4.86 //y2=1.305
cc_948 ( N_B_c_1128_n N_noxref_5_c_1624_n ) capacitor c=6.34991e-19 //x=5.125 \
 //y=1.09 //x2=4.86 //y2=1.305
cc_949 ( N_B_c_1129_n N_noxref_5_c_1624_n ) capacitor c=0.00320504f //x=5.125 \
 //y=1.435 //x2=4.86 //y2=1.305
cc_950 ( N_B_c_1120_n N_noxref_5_c_1651_n ) capacitor c=0.00118531f //x=4.595 \
 //y=1.435 //x2=4.86 //y2=1.75
cc_951 ( N_B_c_1122_n N_noxref_5_c_1651_n ) capacitor c=0.00409175f //x=4.595 \
 //y=1.745 //x2=4.86 //y2=1.75
cc_952 ( N_B_c_1125_n N_noxref_5_c_1651_n ) capacitor c=0.00341876f //x=4.595 \
 //y=2.1 //x2=4.86 //y2=1.75
cc_953 ( N_B_c_1254_p N_noxref_5_c_1651_n ) capacitor c=0.00758256f //x=4.97 \
 //y=1.59 //x2=4.86 //y2=1.75
cc_954 ( N_B_c_1129_n N_noxref_5_c_1651_n ) capacitor c=0.003249f //x=5.125 \
 //y=1.435 //x2=4.86 //y2=1.75
cc_955 ( B N_noxref_5_c_1733_n ) capacitor c=0.00220819f //x=4.93 //y=3.14 \
 //x2=5.335 //y2=1.835
cc_956 ( N_B_c_1087_n N_noxref_5_c_1733_n ) capacitor c=0.00221754f //x=4.93 \
 //y=2.415 //x2=5.335 //y2=1.835
cc_957 ( N_B_c_1104_n N_noxref_5_c_1733_n ) capacitor c=0.00147657f //x=4.93 \
 //y=2.265 //x2=5.335 //y2=1.835
cc_958 ( N_B_c_1254_p N_noxref_5_c_1733_n ) capacitor c=0.00122055f //x=4.97 \
 //y=1.59 //x2=5.335 //y2=1.835
cc_959 ( N_B_c_1129_n N_noxref_5_c_1733_n ) capacitor c=0.00300547f //x=5.125 \
 //y=1.435 //x2=5.335 //y2=1.835
cc_960 ( B N_noxref_5_c_1625_n ) capacitor c=6.73583e-19 //x=4.93 //y=3.14 \
 //x2=4.945 //y2=1.835
cc_961 ( N_B_c_1087_n N_noxref_5_c_1625_n ) capacitor c=0.0193088f //x=4.93 \
 //y=2.415 //x2=4.945 //y2=1.835
cc_962 ( N_B_c_1104_n N_noxref_5_c_1625_n ) capacitor c=0.00408056f //x=4.93 \
 //y=2.265 //x2=4.945 //y2=1.835
cc_963 ( N_B_c_1125_n N_noxref_5_c_1625_n ) capacitor c=0.00203544f //x=4.595 \
 //y=2.1 //x2=4.945 //y2=1.835
cc_964 ( B N_noxref_5_c_1626_n ) capacitor c=0.0348988f //x=4.93 //y=3.14 \
 //x2=5.42 //y2=3.735
cc_965 ( N_B_c_1087_n N_noxref_5_c_1626_n ) capacitor c=0.0253033f //x=4.93 \
 //y=2.415 //x2=5.42 //y2=3.735
cc_966 ( N_B_c_1091_n N_noxref_5_c_1626_n ) capacitor c=0.0370372f //x=4.93 \
 //y=2.995 //x2=5.42 //y2=3.735
cc_967 ( N_B_c_1100_n N_noxref_5_c_1626_n ) capacitor c=0.0222476f //x=9.76 \
 //y=3.14 //x2=5.42 //y2=3.735
cc_968 ( N_B_c_1103_n N_noxref_5_c_1626_n ) capacitor c=0.00470736f //x=5.09 \
 //y=3.155 //x2=5.42 //y2=3.735
cc_969 ( N_B_c_1104_n N_noxref_5_c_1626_n ) capacitor c=0.00169572f //x=4.93 \
 //y=2.265 //x2=5.42 //y2=3.735
cc_970 ( N_B_c_1125_n N_noxref_5_c_1626_n ) capacitor c=0.0075151f //x=4.595 \
 //y=2.1 //x2=5.42 //y2=3.735
cc_971 ( N_B_c_1100_n N_noxref_5_c_1629_n ) capacitor c=0.00652184f //x=9.76 \
 //y=3.14 //x2=5.42 //y2=4.055
cc_972 ( B N_noxref_5_c_1630_n ) capacitor c=0.00459954f //x=7.15 //y=4.62 \
 //x2=5.42 //y2=5.3
cc_973 ( N_B_c_1157_n N_noxref_5_c_1630_n ) capacitor c=0.00345096f //x=9.985 \
 //y=4.655 //x2=5.42 //y2=5.3
cc_974 ( N_B_c_1157_n N_noxref_5_c_1673_n ) capacitor c=0.00552068f //x=9.985 \
 //y=4.655 //x2=8.545 //y2=5.385
cc_975 ( B N_noxref_5_c_1636_n ) capacitor c=0.00186903f //x=10.85 //y=2.77 \
 //x2=8.63 //y2=3.735
cc_976 ( B N_noxref_5_c_1636_n ) capacitor c=0.00118611f //x=10.85 //y=3.51 \
 //x2=8.63 //y2=3.735
cc_977 ( N_B_c_1100_n N_noxref_5_c_1636_n ) capacitor c=0.0261587f //x=9.76 \
 //y=3.14 //x2=8.63 //y2=3.735
cc_978 ( B N_noxref_5_c_1697_n ) capacitor c=0.00142372f //x=10.85 //y=3.51 \
 //x2=8.63 //y2=5.3
cc_979 ( N_B_c_1157_n N_noxref_5_c_1697_n ) capacitor c=0.0271386f //x=9.985 \
 //y=4.655 //x2=8.63 //y2=5.3
cc_980 ( N_B_c_1160_n N_noxref_5_c_1697_n ) capacitor c=3.44947e-19 //x=7.15 \
 //y=4.62 //x2=8.63 //y2=5.3
cc_981 ( B N_noxref_5_c_1637_n ) capacitor c=0.00212694f //x=10.85 //y=2.77 \
 //x2=12.33 //y2=2.575
cc_982 ( N_B_c_1095_n N_noxref_5_c_1637_n ) capacitor c=0.0051604f //x=10.85 \
 //y=2.265 //x2=12.33 //y2=2.575
cc_983 ( N_B_c_1216_n N_noxref_5_c_1637_n ) capacitor c=2.10068e-19 //x=10.85 \
 //y=2.265 //x2=12.33 //y2=2.575
cc_984 ( B N_noxref_5_c_1768_n ) capacitor c=0.00814766f //x=10.85 //y=2.77 \
 //x2=12.33 //y2=3.6
cc_985 ( B N_noxref_5_c_1768_n ) capacitor c=0.00646212f //x=10.85 //y=3.51 \
 //x2=12.33 //y2=3.6
cc_986 ( N_B_c_1094_n N_noxref_5_c_1768_n ) capacitor c=0.004883f //x=10.85 \
 //y=3.3 //x2=12.33 //y2=3.6
cc_987 ( N_B_c_1101_n N_noxref_5_c_1768_n ) capacitor c=0.00408521f //x=10.36 \
 //y=3.11 //x2=12.33 //y2=3.6
cc_988 ( B N_noxref_5_c_1638_n ) capacitor c=0.00598468f //x=10.85 //y=3.51 \
 //x2=12.33 //y2=3.92
cc_989 ( N_B_c_1296_p N_noxref_5_c_1638_n ) capacitor c=0.00124804f //x=17.78 \
 //y=4.99 //x2=12.33 //y2=3.92
cc_990 ( B N_noxref_5_c_1849_n ) capacitor c=0.00362262f //x=10.85 //y=3.51 \
 //x2=12.33 //y2=4.09
cc_991 ( B N_noxref_5_c_1850_n ) capacitor c=0.00483937f //x=10.85 //y=3.51 \
 //x2=12.33 //y2=4.41
cc_992 ( N_B_c_1296_p N_noxref_5_c_1850_n ) capacitor c=0.0032004f //x=17.78 \
 //y=4.99 //x2=12.33 //y2=4.41
cc_993 ( B N_noxref_5_c_1770_n ) capacitor c=0.0045739f //x=10.85 //y=3.51 \
 //x2=12.33 //y2=4.76
cc_994 ( B N_noxref_5_c_1770_n ) capacitor c=0.00339605f //x=10.85 //y=4.99 \
 //x2=12.33 //y2=4.76
cc_995 ( N_B_c_1296_p N_noxref_5_c_1770_n ) capacitor c=0.0244312f //x=17.78 \
 //y=4.99 //x2=12.33 //y2=4.76
cc_996 ( N_B_c_1209_n N_noxref_5_c_1770_n ) capacitor c=0.00610644f //x=11.02 \
 //y=4.99 //x2=12.33 //y2=4.76
cc_997 ( N_B_c_1296_p N_noxref_5_c_1856_n ) capacitor c=0.0022825f //x=17.78 \
 //y=4.99 //x2=14.92 //y2=4.415
cc_998 ( N_B_c_1296_p N_noxref_5_c_1857_n ) capacitor c=0.0209092f //x=17.78 \
 //y=4.99 //x2=14.92 //y2=4.765
cc_999 ( N_B_c_1102_n N_noxref_5_c_1858_n ) capacitor c=0.0241753f //x=24.01 \
 //y=5.01 //x2=24.54 //y2=4.735
cc_1000 ( B N_noxref_5_c_1701_n ) capacitor c=2.9596e-19 //x=4.93 //y=3.14 \
 //x2=4.82 //y2=5.385
cc_1001 ( N_B_c_1157_n N_noxref_5_c_1702_n ) capacitor c=6.46296e-19 //x=9.985 \
 //y=4.655 //x2=8.15 //y2=5.385
cc_1002 ( B N_noxref_5_c_1779_n ) capacitor c=3.90689e-19 //x=10.85 //y=3.51 \
 //x2=12.33 //y2=3.715
cc_1003 ( B N_noxref_5_c_1781_n ) capacitor c=0.00263221f //x=10.85 //y=3.51 \
 //x2=12.49 //y2=4.25
cc_1004 ( N_B_c_1296_p N_noxref_5_c_1781_n ) capacitor c=0.0155254f //x=17.78 \
 //y=4.99 //x2=12.49 //y2=4.25
cc_1005 ( N_B_c_1100_n N_noxref_5_c_1645_n ) capacitor c=0.0157015f //x=9.76 \
 //y=3.14 //x2=5.625 //y2=3.895
cc_1006 ( N_B_c_1100_n N_noxref_5_c_1709_n ) capacitor c=0.0680498f //x=9.76 \
 //y=3.14 //x2=8.485 //y2=3.895
cc_1007 ( N_B_c_1157_n N_noxref_5_c_1709_n ) capacitor c=0.00744882f //x=9.985 \
 //y=4.655 //x2=8.485 //y2=3.895
cc_1008 ( N_B_c_1100_n N_noxref_5_c_1711_n ) capacitor c=7.21807e-19 //x=9.76 \
 //y=3.14 //x2=8.805 //y2=3.895
cc_1009 ( N_B_c_1157_n N_noxref_5_c_1711_n ) capacitor c=7.60969e-19 //x=9.985 \
 //y=4.655 //x2=8.805 //y2=3.895
cc_1010 ( B N_noxref_5_c_1646_n ) capacitor c=0.027601f //x=10.85 //y=3.51 \
 //x2=11.765 //y2=3.842
cc_1011 ( B N_noxref_5_c_1646_n ) capacitor c=0.00134474f //x=10.85 //y=4.99 \
 //x2=11.765 //y2=3.842
cc_1012 ( N_B_c_1094_n N_noxref_5_c_1646_n ) capacitor c=0.0043454f //x=10.85 \
 //y=3.3 //x2=11.765 //y2=3.842
cc_1013 ( N_B_c_1100_n N_noxref_5_c_1646_n ) capacitor c=0.0153505f //x=9.76 \
 //y=3.14 //x2=11.765 //y2=3.842
cc_1014 ( N_B_c_1101_n N_noxref_5_c_1646_n ) capacitor c=0.0254087f //x=10.36 \
 //y=3.11 //x2=11.765 //y2=3.842
cc_1015 ( N_B_c_1157_n N_noxref_5_c_1646_n ) capacitor c=0.0136116f //x=9.985 \
 //y=4.655 //x2=11.765 //y2=3.842
cc_1016 ( N_B_c_1296_p N_noxref_5_c_1646_n ) capacitor c=0.0292484f //x=17.78 \
 //y=4.99 //x2=11.765 //y2=3.842
cc_1017 ( N_B_c_1209_n N_noxref_5_c_1646_n ) capacitor c=0.0269704f //x=11.02 \
 //y=4.99 //x2=11.765 //y2=3.842
cc_1018 ( B N_noxref_5_c_1647_n ) capacitor c=0.00190137f //x=10.85 //y=3.51 \
 //x2=11.905 //y2=3.842
cc_1019 ( B N_noxref_5_c_1648_n ) capacitor c=0.00183885f //x=10.85 //y=2.77 \
 //x2=12.495 //y2=2.415
cc_1020 ( N_B_c_1095_n N_noxref_5_c_1648_n ) capacitor c=0.00367037f //x=10.85 \
 //y=2.265 //x2=12.495 //y2=2.415
cc_1021 ( B N_noxref_5_c_1797_n ) capacitor c=3.91328e-19 //x=10.85 //y=3.51 \
 //x2=12.335 //y2=3.76
cc_1022 ( N_B_c_1296_p N_noxref_5_c_1881_n ) capacitor c=0.00851908f //x=17.78 \
 //y=4.99 //x2=12.175 //y2=3.76
cc_1023 ( N_B_c_1296_p N_noxref_5_c_1882_n ) capacitor c=0.015747f //x=17.78 \
 //y=4.99 //x2=14.915 //y2=4.255
cc_1024 ( N_B_c_1296_p N_noxref_5_c_1649_n ) capacitor c=0.10315f //x=17.78 \
 //y=4.99 //x2=14.755 //y2=4.255
cc_1025 ( N_B_c_1296_p N_noxref_5_c_1884_n ) capacitor c=2.33679e-19 //x=17.78 \
 //y=4.99 //x2=12.33 //y2=4.88
cc_1026 ( N_B_c_1296_p N_noxref_5_c_1885_n ) capacitor c=2.57524e-19 //x=17.78 \
 //y=4.99 //x2=14.92 //y2=4.88
cc_1027 ( N_B_c_1334_p N_noxref_5_c_1886_n ) capacitor c=2.80896e-19 \
 //x=10.695 //y=5.045 //x2=12.56 //y2=4.97
cc_1028 ( N_B_c_1249_n N_noxref_5_c_1887_n ) capacitor c=2.82709e-19 //x=10.74 \
 //y=2.265 //x2=12.33 //y2=2.265
cc_1029 ( N_B_c_1087_n N_noxref_5_M2_noxref_d ) capacitor c=4.61207e-19 \
 //x=4.93 //y=2.415 //x2=4.67 //y2=1.09
cc_1030 ( N_B_c_1104_n N_noxref_5_M2_noxref_d ) capacitor c=0.00150031f \
 //x=4.93 //y=2.265 //x2=4.67 //y2=1.09
cc_1031 ( N_B_c_1117_n N_noxref_5_M2_noxref_d ) capacitor c=0.00137165f \
 //x=4.595 //y=1.09 //x2=4.67 //y2=1.09
cc_1032 ( N_B_c_1120_n N_noxref_5_M2_noxref_d ) capacitor c=0.00237422f \
 //x=4.595 //y=1.435 //x2=4.67 //y2=1.09
cc_1033 ( N_B_c_1125_n N_noxref_5_M2_noxref_d ) capacitor c=4.64071e-19 \
 //x=4.595 //y=2.1 //x2=4.67 //y2=1.09
cc_1034 ( N_B_c_1253_p N_noxref_5_M2_noxref_d ) capacitor c=0.0020782f \
 //x=4.97 //y=0.935 //x2=4.67 //y2=1.09
cc_1035 ( N_B_c_1254_p N_noxref_5_M2_noxref_d ) capacitor c=0.00344131f \
 //x=4.97 //y=1.59 //x2=4.67 //y2=1.09
cc_1036 ( N_B_c_1128_n N_noxref_5_M2_noxref_d ) capacitor c=8.50094e-19 \
 //x=5.125 //y=1.09 //x2=4.67 //y2=1.09
cc_1037 ( N_B_c_1129_n N_noxref_5_M2_noxref_d ) capacitor c=0.00237422f \
 //x=5.125 //y=1.435 //x2=4.67 //y2=1.09
cc_1038 ( N_B_c_1296_p N_noxref_6_c_2366_n ) capacitor c=0.00145243f //x=17.78 \
 //y=4.99 //x2=12.705 //y2=5.42
cc_1039 ( N_B_c_1296_p N_noxref_6_c_2371_n ) capacitor c=0.00869095f //x=17.78 \
 //y=4.99 //x2=12.985 //y2=5.14
cc_1040 ( N_B_c_1296_p N_noxref_6_c_2368_n ) capacitor c=0.0258676f //x=17.78 \
 //y=4.99 //x2=12.79 //y2=5.14
cc_1041 ( B N_noxref_6_c_2361_n ) capacitor c=5.41561e-19 //x=10.85 //y=2.77 \
 //x2=13.07 //y2=2.61
cc_1042 ( B N_noxref_6_c_2374_n ) capacitor c=0.0028702f //x=10.85 //y=3.51 \
 //x2=13.07 //y2=5.055
cc_1043 ( N_B_c_1296_p N_noxref_6_c_2374_n ) capacitor c=0.0206273f //x=17.78 \
 //y=4.99 //x2=13.07 //y2=5.055
cc_1044 ( N_B_c_1296_p N_noxref_6_c_2376_n ) capacitor c=0.00188561f //x=17.78 \
 //y=4.99 //x2=19.24 //y2=4.877
cc_1045 ( N_B_c_1352_p N_noxref_6_c_2376_n ) capacitor c=0.0179016f //x=21.34 \
 //y=4.99 //x2=19.24 //y2=4.877
cc_1046 ( N_B_c_1296_p N_noxref_6_c_2364_n ) capacitor c=0.0167808f //x=17.78 \
 //y=4.99 //x2=19.185 //y2=2.755
cc_1047 ( N_B_c_1296_p SUM ) capacitor c=0.0315755f //x=17.78 //y=4.99 \
 //x2=16.52 //y2=4.62
cc_1048 ( N_B_c_1355_p SUM ) capacitor c=0.00345372f //x=17.865 //y=5.215 \
 //x2=16.52 //y2=4.62
cc_1049 ( N_B_c_1356_p SUM ) capacitor c=8.38841e-19 //x=18.72 //y=4.99 \
 //x2=16.52 //y2=4.62
cc_1050 ( N_B_c_1357_p N_SUM_c_2670_n ) capacitor c=0.00345372f //x=17.95 \
 //y=5.3 //x2=16.435 //y2=5.385
cc_1051 ( N_B_c_1296_p N_SUM_c_2671_n ) capacitor c=2.47639e-19 //x=17.78 \
 //y=4.99 //x2=19.73 //y2=5.3
cc_1052 ( N_B_c_1359_p N_SUM_c_2671_n ) capacitor c=0.00611325f //x=18.635 \
 //y=5.215 //x2=19.73 //y2=5.3
cc_1053 ( N_B_c_1352_p N_SUM_c_2671_n ) capacitor c=0.0263015f //x=21.34 \
 //y=4.99 //x2=19.73 //y2=5.3
cc_1054 ( N_B_c_1361_p N_SUM_c_2671_n ) capacitor c=0.00244655f //x=21.51 \
 //y=5.3 //x2=19.73 //y2=5.3
cc_1055 ( N_B_c_1296_p N_SUM_c_2675_n ) capacitor c=0.0271405f //x=17.78 \
 //y=4.99 //x2=15.92 //y2=5.385
cc_1056 ( N_B_c_1352_p N_SUM_c_2676_n ) capacitor c=0.0205028f //x=21.34 \
 //y=4.99 //x2=19.25 //y2=5.385
cc_1057 ( N_B_c_1296_p N_SUM_c_2677_n ) capacitor c=0.00528092f //x=17.78 \
 //y=4.99 //x2=19.585 //y2=3.895
cc_1058 ( N_B_c_1365_p N_SUM_c_2677_n ) capacitor c=7.86672e-19 //x=18.55 \
 //y=5.3 //x2=19.585 //y2=3.895
cc_1059 ( N_B_c_1296_p N_noxref_8_c_2966_n ) capacitor c=0.00243668f //x=17.78 \
 //y=4.99 //x2=16.03 //y2=4.575
cc_1060 ( N_B_c_1296_p N_noxref_8_c_2967_n ) capacitor c=0.0178095f //x=17.78 \
 //y=4.99 //x2=16.03 //y2=4.765
cc_1061 ( N_B_c_1352_p N_noxref_8_c_2968_n ) capacitor c=0.0155829f //x=21.34 \
 //y=4.99 //x2=21.21 //y2=5.055
cc_1062 ( N_B_c_1352_p N_noxref_8_c_2969_n ) capacitor c=0.00840778f //x=21.34 \
 //y=4.99 //x2=21.49 //y2=5.14
cc_1063 ( N_B_c_1370_p N_noxref_8_c_2969_n ) capacitor c=0.0110002f //x=21.425 \
 //y=5.215 //x2=21.49 //y2=5.14
cc_1064 ( N_B_c_1371_p N_noxref_8_c_2969_n ) capacitor c=0.00258272f \
 //x=22.325 //y=5.3 //x2=21.49 //y2=5.14
cc_1065 ( N_B_c_1361_p N_noxref_8_c_2969_n ) capacitor c=0.00522528f //x=21.51 \
 //y=5.3 //x2=21.49 //y2=5.14
cc_1066 ( N_B_c_1373_p N_noxref_8_c_2969_n ) capacitor c=0.00387436f \
 //x=22.495 //y=4.99 //x2=21.49 //y2=5.14
cc_1067 ( N_B_c_1352_p N_noxref_8_c_2974_n ) capacitor c=0.00730722f //x=21.34 \
 //y=4.99 //x2=21.295 //y2=5.14
cc_1068 ( N_B_c_1371_p N_noxref_8_c_2975_n ) capacitor c=0.0177696f //x=22.325 \
 //y=5.3 //x2=21.575 //y2=5.42
cc_1069 ( N_B_c_1361_p N_noxref_8_c_2975_n ) capacitor c=0.00662886f //x=21.51 \
 //y=5.3 //x2=21.575 //y2=5.42
cc_1070 ( N_B_c_1296_p N_noxref_8_c_2977_n ) capacitor c=0.0227361f //x=17.78 \
 //y=4.99 //x2=16.075 //y2=4.28
cc_1071 ( N_B_c_1296_p N_noxref_8_c_2978_n ) capacitor c=0.0831536f //x=17.78 \
 //y=4.99 //x2=21.055 //y2=4.27
cc_1072 ( N_B_c_1365_p N_noxref_8_c_2978_n ) capacitor c=0.00772592f //x=18.55 \
 //y=5.3 //x2=21.055 //y2=4.27
cc_1073 ( N_B_c_1356_p N_noxref_8_c_2978_n ) capacitor c=0.0119048f //x=18.72 \
 //y=4.99 //x2=21.055 //y2=4.27
cc_1074 ( N_B_c_1365_p CIN ) capacitor c=0.00547127f //x=18.55 //y=5.3 \
 //x2=18.25 //y2=4.62
cc_1075 ( N_B_c_1382_p CIN ) capacitor c=0.00485111f //x=23.41 //y=4.99 \
 //x2=23.8 //y2=4.62
cc_1076 ( N_B_c_1102_n CIN ) capacitor c=0.0209344f //x=24.01 //y=5.01 \
 //x2=23.8 //y2=4.62
cc_1077 ( N_B_c_1352_p N_CIN_c_3291_n ) capacitor c=0.00272652f //x=21.34 \
 //y=4.99 //x2=21.95 //y2=4.88
cc_1078 ( N_B_c_1371_p N_CIN_c_3291_n ) capacitor c=0.00649899f //x=22.325 \
 //y=5.3 //x2=21.95 //y2=4.88
cc_1079 ( N_B_c_1373_p N_CIN_c_3291_n ) capacitor c=0.00330054f //x=22.495 \
 //y=4.99 //x2=21.95 //y2=4.88
cc_1080 ( N_B_c_1296_p N_CIN_c_3286_n ) capacitor c=4.51847e-19 //x=17.78 \
 //y=4.99 //x2=20.86 //y2=3.14
cc_1081 ( N_B_c_1352_p N_CIN_c_3287_n ) capacitor c=4.30112e-19 //x=21.34 \
 //y=4.99 //x2=21.46 //y2=3.11
cc_1082 ( N_B_c_1371_p N_CIN_c_3287_n ) capacitor c=4.33334e-19 //x=22.325 \
 //y=5.3 //x2=21.46 //y2=3.11
cc_1083 ( N_B_c_1365_p N_CIN_c_3297_n ) capacitor c=0.0300507f //x=18.55 \
 //y=5.3 //x2=21.085 //y2=4.655
cc_1084 ( N_B_c_1352_p N_CIN_c_3297_n ) capacitor c=0.0771414f //x=21.34 \
 //y=4.99 //x2=21.085 //y2=4.655
cc_1085 ( N_B_c_1356_p N_CIN_c_3297_n ) capacitor c=0.202589f //x=18.72 \
 //y=4.99 //x2=21.085 //y2=4.655
cc_1086 ( N_B_c_1352_p N_CIN_c_3300_n ) capacitor c=0.0101924f //x=21.34 \
 //y=4.99 //x2=21.96 //y2=4.885
cc_1087 ( N_B_c_1371_p N_CIN_c_3300_n ) capacitor c=0.0336108f //x=22.325 \
 //y=5.3 //x2=21.96 //y2=4.885
cc_1088 ( N_B_c_1373_p N_CIN_c_3300_n ) capacitor c=0.01246f //x=22.495 \
 //y=4.99 //x2=21.96 //y2=4.885
cc_1089 ( N_B_c_1371_p N_CIN_c_3303_n ) capacitor c=0.0136379f //x=22.325 \
 //y=5.3 //x2=22.12 //y2=4.62
cc_1090 ( N_B_c_1296_p N_CIN_c_3304_n ) capacitor c=8.46736e-19 //x=17.78 \
 //y=4.99 //x2=16.19 //y2=3.155
cc_1091 ( N_B_c_1382_p N_CIN_c_3305_n ) capacitor c=0.0375722f //x=23.41 \
 //y=4.99 //x2=23.795 //y2=4.625
cc_1092 ( N_B_c_1371_p N_CIN_c_3306_n ) capacitor c=0.0111972f //x=22.325 \
 //y=5.3 //x2=23.635 //y2=4.625
cc_1093 ( N_B_c_1382_p N_CIN_c_3306_n ) capacitor c=0.0114545f //x=23.41 \
 //y=4.99 //x2=23.635 //y2=4.625
cc_1094 ( N_B_c_1373_p N_CIN_c_3306_n ) capacitor c=0.118431f //x=22.495 \
 //y=4.99 //x2=23.635 //y2=4.625
cc_1095 ( N_B_c_1296_p N_CIN_c_3309_n ) capacitor c=0.00183566f //x=17.78 \
 //y=4.99 //x2=18.25 //y2=4.62
cc_1096 ( N_B_c_1365_p N_CIN_c_3309_n ) capacitor c=0.0026143f //x=18.55 \
 //y=5.3 //x2=18.25 //y2=4.62
cc_1097 ( N_B_c_1356_p N_CIN_c_3309_n ) capacitor c=0.00199778f //x=18.72 \
 //y=4.99 //x2=18.25 //y2=4.62
cc_1098 ( N_B_c_1102_n N_CIN_c_3312_n ) capacitor c=3.42989e-19 //x=24.01 \
 //y=5.01 //x2=23.8 //y2=4.62
cc_1099 ( N_B_c_1102_n N_noxref_10_c_3700_n ) capacitor c=0.0572142f //x=24.01 \
 //y=5.01 //x2=24.685 //y2=5.38
cc_1100 ( N_B_c_1102_n N_noxref_10_c_3693_n ) capacitor c=0.0026568f //x=24.01 \
 //y=5.01 //x2=25.28 //y2=3.67
cc_1101 ( N_B_c_1102_n N_noxref_10_c_3702_n ) capacitor c=0.0340325f //x=24.01 \
 //y=5.01 //x2=25.28 //y2=5.295
cc_1102 ( B N_noxref_10_c_3703_n ) capacitor c=0.00270042f //x=29.35 //y=2.77 \
 //x2=26.76 //y2=3.35
cc_1103 ( N_B_c_1102_n N_noxref_10_c_3694_n ) capacitor c=0.00171219f \
 //x=24.01 //y=5.01 //x2=26.76 //y2=3.67
cc_1104 ( B N_noxref_10_c_3705_n ) capacitor c=0.00210739f //x=29.35 //y=2.77 \
 //x2=26.76 //y2=4.76
cc_1105 ( N_B_c_1102_n N_noxref_10_c_3705_n ) capacitor c=0.0282167f //x=24.01 \
 //y=5.01 //x2=26.76 //y2=4.76
cc_1106 ( N_B_c_1371_p N_noxref_10_c_3707_n ) capacitor c=5.27708e-19 \
 //x=22.325 //y=5.3 //x2=23.92 //y2=5.56
cc_1107 ( N_B_c_1102_n N_noxref_10_c_3707_n ) capacitor c=0.0141283f //x=24.01 \
 //y=5.01 //x2=23.92 //y2=5.56
cc_1108 ( N_B_c_1102_n N_noxref_10_c_3697_n ) capacitor c=0.0272975f //x=24.01 \
 //y=5.01 //x2=26.595 //y2=3.51
cc_1109 ( N_B_c_1102_n N_noxref_10_c_3698_n ) capacitor c=0.00523861f \
 //x=24.01 //y=5.01 //x2=25.44 //y2=3.51
cc_1110 ( N_B_c_1102_n N_noxref_10_c_3699_n ) capacitor c=0.00461653f \
 //x=24.01 //y=5.01 //x2=26.755 //y2=3.51
cc_1111 ( N_B_c_1102_n N_noxref_10_c_3712_n ) capacitor c=2.54658e-19 \
 //x=24.01 //y=5.01 //x2=26.76 //y2=4.88
cc_1112 ( N_B_M52_noxref_g N_noxref_11_c_3938_n ) capacitor c=0.0129249f \
 //x=29.69 //y=6.2 //x2=30.235 //y2=5.38
cc_1113 ( B N_noxref_11_c_3951_n ) capacitor c=0.00328049f //x=29.35 //y=2.77 \
 //x2=30.83 //y2=3.35
cc_1114 ( B N_noxref_11_c_3958_n ) capacitor c=0.00327281f //x=29.35 //y=2.77 \
 //x2=30.83 //y2=5.295
cc_1115 ( B N_noxref_11_c_3958_n ) capacitor c=0.0018681f //x=29.35 //y=4.99 \
 //x2=30.83 //y2=5.295
cc_1116 ( N_B_c_1102_n N_noxref_11_c_3958_n ) capacitor c=0.00100831f \
 //x=24.01 //y=5.01 //x2=30.83 //y2=5.295
cc_1117 ( B N_noxref_11_c_3990_n ) capacitor c=0.0183637f //x=29.35 //y=4.99 \
 //x2=29.47 //y2=5.56
cc_1118 ( N_B_c_1102_n N_noxref_11_c_3990_n ) capacitor c=0.00501492f \
 //x=24.01 //y=5.01 //x2=29.47 //y2=5.56
cc_1119 ( N_B_c_1110_n N_noxref_11_c_3990_n ) capacitor c=0.00109201f \
 //x=29.35 //y=4.88 //x2=29.47 //y2=5.56
cc_1120 ( N_B_M51_noxref_g N_noxref_11_c_3990_n ) capacitor c=0.00203628f \
 //x=29.25 //y=6.2 //x2=29.47 //y2=5.56
cc_1121 ( N_B_M52_noxref_g N_noxref_11_c_3990_n ) capacitor c=0.00192712f \
 //x=29.69 //y=6.2 //x2=29.47 //y2=5.56
cc_1122 ( N_B_c_1143_n N_noxref_11_c_3990_n ) capacitor c=0.00115816f \
 //x=29.35 //y=4.88 //x2=29.47 //y2=5.56
cc_1123 ( B N_noxref_11_c_3996_n ) capacitor c=0.00266273f //x=29.35 //y=4.99 \
 //x2=29.47 //y2=5.56
cc_1124 ( N_B_c_1110_n N_noxref_11_c_3996_n ) capacitor c=0.00459951f \
 //x=29.35 //y=4.88 //x2=29.47 //y2=5.56
cc_1125 ( N_B_M51_noxref_g N_noxref_11_c_3996_n ) capacitor c=0.0158358f \
 //x=29.25 //y=6.2 //x2=29.47 //y2=5.56
cc_1126 ( N_B_M52_noxref_g N_noxref_11_c_3996_n ) capacitor c=0.0178987f \
 //x=29.69 //y=6.2 //x2=29.47 //y2=5.56
cc_1127 ( N_B_c_1143_n N_noxref_11_c_3996_n ) capacitor c=0.00380751f \
 //x=29.35 //y=4.88 //x2=29.47 //y2=5.56
cc_1128 ( N_B_c_1102_n N_noxref_12_c_4200_n ) capacitor c=0.00151451f \
 //x=24.01 //y=5.01 //x2=27.135 //y2=5.42
cc_1129 ( N_B_c_1102_n N_noxref_12_c_4201_n ) capacitor c=0.00966289f \
 //x=24.01 //y=5.01 //x2=27.415 //y2=5.14
cc_1130 ( N_B_c_1102_n N_noxref_12_c_4202_n ) capacitor c=0.025621f //x=24.01 \
 //y=5.01 //x2=27.22 //y2=5.14
cc_1131 ( B N_noxref_12_c_4189_n ) capacitor c=0.00979326f //x=29.35 //y=2.77 \
 //x2=27.5 //y2=2.99
cc_1132 ( N_B_c_1096_n N_noxref_12_c_4189_n ) capacitor c=0.00457386f \
 //x=29.35 //y=2.26 //x2=27.5 //y2=2.99
cc_1133 ( B N_noxref_12_c_4191_n ) capacitor c=0.00254639f //x=29.35 //y=2.77 \
 //x2=27.5 //y2=3.31
cc_1134 ( N_B_c_1102_n N_noxref_12_c_4191_n ) capacitor c=0.00185333f \
 //x=24.01 //y=5.01 //x2=27.5 //y2=3.31
cc_1135 ( B N_noxref_12_c_4192_n ) capacitor c=0.0258796f //x=29.35 //y=2.77 \
 //x2=27.5 //y2=5.055
cc_1136 ( B N_noxref_12_c_4192_n ) capacitor c=0.00274708f //x=29.35 //y=4.99 \
 //x2=27.5 //y2=5.055
cc_1137 ( N_B_c_1102_n N_noxref_12_c_4192_n ) capacitor c=0.0248374f //x=24.01 \
 //y=5.01 //x2=27.5 //y2=5.055
cc_1138 ( B N_noxref_12_c_4194_n ) capacitor c=0.0330376f //x=29.35 //y=2.77 \
 //x2=30.445 //y2=3.14
cc_1139 ( B N_noxref_12_c_4194_n ) capacitor c=0.00259757f //x=29.35 //y=4.99 \
 //x2=30.445 //y2=3.14
cc_1140 ( N_B_c_1096_n N_noxref_12_c_4194_n ) capacitor c=0.00241527f \
 //x=29.35 //y=2.26 //x2=30.445 //y2=3.14
cc_1141 ( N_B_c_1102_n N_noxref_12_c_4194_n ) capacitor c=0.0351917f //x=24.01 \
 //y=5.01 //x2=30.445 //y2=3.14
cc_1142 ( B N_noxref_12_c_4199_n ) capacitor c=0.00158959f //x=29.35 //y=2.77 \
 //x2=27.66 //y2=3.15
cc_1143 ( N_B_c_1102_n N_noxref_12_c_4199_n ) capacitor c=0.00381797f \
 //x=24.01 //y=5.01 //x2=27.66 //y2=3.15
cc_1144 ( N_B_M27_noxref_g N_VDD_c_5094_n ) capacitor c=0.00365752f //x=7.05 \
 //y=6.2 //x2=7.27 //y2=6.69
cc_1145 ( N_B_M28_noxref_g N_VDD_c_5094_n ) capacitor c=0.00387858f //x=7.49 \
 //y=6.2 //x2=7.27 //y2=6.69
cc_1146 ( N_B_M27_noxref_g N_VDD_c_5096_n ) capacitor c=0.00522062f //x=7.05 \
 //y=6.2 //x2=7.27 //y2=7.41
cc_1147 ( N_B_M28_noxref_g N_VDD_c_5096_n ) capacitor c=0.00588679f //x=7.49 \
 //y=6.2 //x2=7.27 //y2=7.41
cc_1148 ( B N_VDD_c_5065_n ) capacitor c=3.17638e-19 //x=10.85 //y=4.99 \
 //x2=14.955 //y2=7.585
cc_1149 ( N_B_c_1094_n N_VDD_c_5065_n ) capacitor c=2.15335e-19 //x=10.85 \
 //y=3.3 //x2=14.955 //y2=7.585
cc_1150 ( N_B_c_1217_n N_VDD_c_5065_n ) capacitor c=3.40603e-19 //x=10.85 \
 //y=4.88 //x2=14.955 //y2=7.585
cc_1151 ( N_B_c_1365_p N_VDD_c_5101_n ) capacitor c=0.00151161f //x=18.55 \
 //y=5.3 //x2=18.285 //y2=7.585
cc_1152 ( N_B_c_1357_p N_VDD_c_5101_n ) capacitor c=0.00101443f //x=17.95 \
 //y=5.3 //x2=18.285 //y2=7.585
cc_1153 ( N_B_c_1365_p N_VDD_c_5103_n ) capacitor c=0.00435193f //x=18.55 \
 //y=5.3 //x2=18.37 //y2=6.69
cc_1154 ( B N_VDD_c_5104_n ) capacitor c=5.24651e-19 //x=29.35 //y=4.99 \
 //x2=34.935 //y2=7.585
cc_1155 ( N_B_c_1365_p N_VDD_c_5104_n ) capacitor c=0.00108284f //x=18.55 \
 //y=5.3 //x2=34.935 //y2=7.585
cc_1156 ( N_B_c_1371_p N_VDD_c_5104_n ) capacitor c=0.0215761f //x=22.325 \
 //y=5.3 //x2=34.935 //y2=7.585
cc_1157 ( N_B_c_1361_p N_VDD_c_5104_n ) capacitor c=0.00575244f //x=21.51 \
 //y=5.3 //x2=34.935 //y2=7.585
cc_1158 ( N_B_c_1110_n N_VDD_c_5104_n ) capacitor c=6.23566e-19 //x=29.35 \
 //y=4.88 //x2=34.935 //y2=7.585
cc_1159 ( N_B_M27_noxref_g N_VDD_c_5047_n ) capacitor c=0.00750251f //x=7.05 \
 //y=6.2 //x2=9.2 //y2=7.585
cc_1160 ( N_B_M28_noxref_g N_VDD_c_5047_n ) capacitor c=0.00773472f //x=7.49 \
 //y=6.2 //x2=9.2 //y2=7.585
cc_1161 ( B N_VDD_c_5070_n ) capacitor c=2.22801e-19 //x=10.85 //y=4.99 \
 //x2=10.83 //y2=7.585
cc_1162 ( N_B_M31_noxref_g N_VDD_c_5070_n ) capacitor c=0.00751326f //x=10.255 \
 //y=6.2 //x2=10.83 //y2=7.585
cc_1163 ( N_B_M32_noxref_g N_VDD_c_5070_n ) capacitor c=0.00753931f //x=10.695 \
 //y=6.2 //x2=10.83 //y2=7.585
cc_1164 ( B N_VDD_c_5114_n ) capacitor c=3.98196e-19 //x=29.35 //y=4.99 \
 //x2=29.825 //y2=7.585
cc_1165 ( N_B_M51_noxref_g N_VDD_c_5114_n ) capacitor c=0.00732332f //x=29.25 \
 //y=6.2 //x2=29.825 //y2=7.585
cc_1166 ( N_B_M52_noxref_g N_VDD_c_5114_n ) capacitor c=0.00755544f //x=29.69 \
 //y=6.2 //x2=29.825 //y2=7.585
cc_1167 ( B N_VDD_c_5056_n ) capacitor c=0.00343839f //x=7.15 //y=4.62 \
 //x2=6.04 //y2=7.585
cc_1168 ( N_B_c_1160_n N_VDD_c_5056_n ) capacitor c=0.0101962f //x=7.15 \
 //y=4.62 //x2=6.04 //y2=7.585
cc_1169 ( N_B_c_1167_n N_VDD_c_5056_n ) capacitor c=0.016029f //x=7.15 \
 //y=4.88 //x2=6.04 //y2=7.585
cc_1170 ( N_B_c_1157_n N_VDD_c_5057_n ) capacitor c=0.0259477f //x=9.985 \
 //y=4.655 //x2=9.37 //y2=7.585
cc_1171 ( N_B_c_1160_n N_VDD_c_5057_n ) capacitor c=0.00169109f //x=7.15 \
 //y=4.62 //x2=9.37 //y2=7.585
cc_1172 ( N_B_c_1217_n N_VDD_c_5057_n ) capacitor c=0.00235165f //x=10.85 \
 //y=4.88 //x2=9.37 //y2=7.585
cc_1173 ( N_B_c_1233_n N_VDD_c_5057_n ) capacitor c=0.00915756f //x=10.33 \
 //y=4.97 //x2=9.37 //y2=7.585
cc_1174 ( N_B_c_1334_p N_VDD_c_5057_n ) capacitor c=2.63786e-19 //x=10.695 \
 //y=5.045 //x2=9.37 //y2=7.585
cc_1175 ( B N_VDD_c_5083_n ) capacitor c=0.00813721f //x=10.85 //y=3.51 \
 //x2=11.59 //y2=7.585
cc_1176 ( B N_VDD_c_5083_n ) capacitor c=0.00440659f //x=10.85 //y=4.99 \
 //x2=11.59 //y2=7.585
cc_1177 ( N_B_c_1296_p N_VDD_c_5083_n ) capacitor c=0.0238254f //x=17.78 \
 //y=4.99 //x2=11.59 //y2=7.585
cc_1178 ( N_B_c_1217_n N_VDD_c_5083_n ) capacitor c=0.00830745f //x=10.85 \
 //y=4.88 //x2=11.59 //y2=7.585
cc_1179 ( N_B_M32_noxref_g N_VDD_c_5083_n ) capacitor c=0.00615479f //x=10.695 \
 //y=6.2 //x2=11.59 //y2=7.585
cc_1180 ( N_B_c_1334_p N_VDD_c_5083_n ) capacitor c=0.00606577f //x=10.695 \
 //y=5.045 //x2=11.59 //y2=7.585
cc_1181 ( N_B_c_1296_p N_VDD_c_5131_n ) capacitor c=0.0270745f //x=17.78 \
 //y=4.99 //x2=13.81 //y2=7.585
cc_1182 ( N_B_c_1296_p N_VDD_c_5132_n ) capacitor c=0.0261548f //x=17.78 \
 //y=4.99 //x2=17.14 //y2=7.585
cc_1183 ( N_B_c_1355_p N_VDD_c_5132_n ) capacitor c=0.00803446f //x=17.865 \
 //y=5.215 //x2=17.14 //y2=7.585
cc_1184 ( N_B_c_1356_p N_VDD_c_5132_n ) capacitor c=2.21837e-19 //x=18.72 \
 //y=4.99 //x2=17.14 //y2=7.585
cc_1185 ( N_B_c_1352_p N_VDD_c_5135_n ) capacitor c=0.0245547f //x=21.34 \
 //y=4.99 //x2=20.47 //y2=7.585
cc_1186 ( N_B_c_1361_p N_VDD_c_5135_n ) capacitor c=0.00324495f //x=21.51 \
 //y=5.3 //x2=20.47 //y2=7.585
cc_1187 ( N_B_c_1494_p N_VDD_c_5137_n ) capacitor c=0.00890404f //x=22.41 \
 //y=5.215 //x2=22.69 //y2=7.585
cc_1188 ( N_B_c_1382_p N_VDD_c_5137_n ) capacitor c=0.02335f //x=23.41 \
 //y=4.99 //x2=22.69 //y2=7.585
cc_1189 ( N_B_c_1102_n N_VDD_c_5139_n ) capacitor c=0.025612f //x=24.01 \
 //y=5.01 //x2=26.02 //y2=7.585
cc_1190 ( B N_VDD_c_5140_n ) capacitor c=0.00733791f //x=29.35 //y=2.77 \
 //x2=28.24 //y2=7.585
cc_1191 ( B N_VDD_c_5140_n ) capacitor c=0.00344038f //x=29.35 //y=4.99 \
 //x2=28.24 //y2=7.585
cc_1192 ( N_B_c_1102_n N_VDD_c_5140_n ) capacitor c=0.026548f //x=24.01 \
 //y=5.01 //x2=28.24 //y2=7.585
cc_1193 ( N_B_c_1110_n N_VDD_c_5140_n ) capacitor c=0.00378111f //x=29.35 \
 //y=4.88 //x2=28.24 //y2=7.585
cc_1194 ( N_B_c_1143_n N_VDD_c_5140_n ) capacitor c=0.0112232f //x=29.35 \
 //y=4.88 //x2=28.24 //y2=7.585
cc_1195 ( N_B_c_1110_n N_VDD_c_5023_n ) capacitor c=3.42631e-19 //x=29.35 \
 //y=4.88 //x2=31.57 //y2=7.585
cc_1196 ( N_B_c_1160_n N_VDD_M27_noxref_d ) capacitor c=0.00176891f //x=7.15 \
 //y=4.62 //x2=7.125 //y2=5.2
cc_1197 ( N_B_M27_noxref_g N_VDD_M27_noxref_d ) capacitor c=0.00896756f \
 //x=7.05 //y=6.2 //x2=7.125 //y2=5.2
cc_1198 ( N_B_M28_noxref_g N_VDD_M27_noxref_d ) capacitor c=0.00896756f \
 //x=7.49 //y=6.2 //x2=7.125 //y2=5.2
cc_1199 ( N_B_c_1167_n N_VDD_M27_noxref_d ) capacitor c=0.00318882f //x=7.15 \
 //y=4.88 //x2=7.125 //y2=5.2
cc_1200 ( N_B_c_1157_n N_VDD_M31_noxref_s ) capacitor c=0.00303281f //x=9.985 \
 //y=4.655 //x2=9.91 //y2=5.2
cc_1201 ( N_B_M31_noxref_g N_VDD_M31_noxref_s ) capacitor c=0.0572684f \
 //x=10.255 //y=6.2 //x2=9.91 //y2=5.2
cc_1202 ( B N_VDD_M32_noxref_d ) capacitor c=0.0260784f //x=10.85 //y=4.99 \
 //x2=10.77 //y2=5.2
cc_1203 ( N_B_c_1209_n N_VDD_M32_noxref_d ) capacitor c=0.00719596f //x=11.02 \
 //y=4.99 //x2=10.77 //y2=5.2
cc_1204 ( N_B_c_1217_n N_VDD_M32_noxref_d ) capacitor c=0.0079618f //x=10.85 \
 //y=4.88 //x2=10.77 //y2=5.2
cc_1205 ( N_B_M32_noxref_g N_VDD_M32_noxref_d ) capacitor c=0.0573441f \
 //x=10.695 //y=6.2 //x2=10.77 //y2=5.2
cc_1206 ( N_B_c_1334_p N_VDD_M32_noxref_d ) capacitor c=0.00463894f //x=10.695 \
 //y=5.045 //x2=10.77 //y2=5.2
cc_1207 ( N_B_c_1296_p N_VDD_M33_noxref_s ) capacitor c=0.00805235f //x=17.78 \
 //y=4.99 //x2=12.13 //y2=5.2
cc_1208 ( N_B_c_1296_p N_VDD_M34_noxref_d ) capacitor c=0.00538082f //x=17.78 \
 //y=4.99 //x2=13 //y2=5.2
cc_1209 ( N_B_c_1352_p N_VDD_M43_noxref_s ) capacitor c=0.00451154f //x=21.34 \
 //y=4.99 //x2=21.01 //y2=5.2
cc_1210 ( N_B_c_1361_p N_VDD_M43_noxref_s ) capacitor c=8.23993e-19 //x=21.51 \
 //y=5.3 //x2=21.01 //y2=5.2
cc_1211 ( N_B_c_1371_p N_VDD_M44_noxref_d ) capacitor c=0.012095f //x=22.325 \
 //y=5.3 //x2=21.87 //y2=5.2
cc_1212 ( N_B_c_1371_p N_VDD_M45_noxref_s ) capacitor c=0.00180251f //x=22.325 \
 //y=5.3 //x2=23.345 //y2=5.2
cc_1213 ( N_B_c_1382_p N_VDD_M45_noxref_s ) capacitor c=0.0105884f //x=23.41 \
 //y=4.99 //x2=23.345 //y2=5.2
cc_1214 ( N_B_c_1102_n N_VDD_M49_noxref_s ) capacitor c=0.00832962f //x=24.01 \
 //y=5.01 //x2=26.56 //y2=5.2
cc_1215 ( N_B_c_1102_n N_VDD_M50_noxref_d ) capacitor c=0.00555029f //x=24.01 \
 //y=5.01 //x2=27.43 //y2=5.2
cc_1216 ( N_B_c_1102_n N_VDD_M51_noxref_s ) capacitor c=0.0126087f //x=24.01 \
 //y=5.01 //x2=28.895 //y2=5.2
cc_1217 ( N_B_M51_noxref_g N_VDD_M51_noxref_s ) capacitor c=0.0567929f \
 //x=29.25 //y=6.2 //x2=28.895 //y2=5.2
cc_1218 ( N_B_M52_noxref_g N_VDD_M52_noxref_d ) capacitor c=0.015318f \
 //x=29.69 //y=6.2 //x2=29.765 //y2=5.2
cc_1219 ( B N_noxref_17_c_5891_n ) capacitor c=0.0192046f //x=7.15 //y=4.62 \
 //x2=7.595 //y2=5.385
cc_1220 ( N_B_c_1157_n N_noxref_17_c_5891_n ) capacitor c=0.0271887f //x=9.985 \
 //y=4.655 //x2=7.595 //y2=5.385
cc_1221 ( N_B_c_1160_n N_noxref_17_c_5891_n ) capacitor c=0.00477026f //x=7.15 \
 //y=4.62 //x2=7.595 //y2=5.385
cc_1222 ( N_B_M27_noxref_g N_noxref_17_c_5891_n ) capacitor c=0.0111298f \
 //x=7.05 //y=6.2 //x2=7.595 //y2=5.385
cc_1223 ( N_B_M28_noxref_g N_noxref_17_c_5891_n ) capacitor c=0.00961301f \
 //x=7.49 //y=6.2 //x2=7.595 //y2=5.385
cc_1224 ( N_B_c_1167_n N_noxref_17_c_5891_n ) capacitor c=0.00140744f //x=7.15 \
 //y=4.88 //x2=7.595 //y2=5.385
cc_1225 ( N_B_M27_noxref_g N_noxref_17_c_5889_n ) capacitor c=0.00394587f \
 //x=7.05 //y=6.2 //x2=6.83 //y2=5.385
cc_1226 ( N_B_c_1157_n N_noxref_17_c_5884_n ) capacitor c=9.55296e-19 \
 //x=9.985 //y=4.655 //x2=7.71 //y2=5.385
cc_1227 ( N_B_M28_noxref_g N_noxref_17_c_5884_n ) capacitor c=0.00179267f \
 //x=7.49 //y=6.2 //x2=7.71 //y2=5.385
cc_1228 ( N_B_M28_noxref_g N_noxref_17_c_5885_n ) capacitor c=0.00182026f \
 //x=7.49 //y=6.2 //x2=7.71 //y2=6.915
cc_1229 ( N_B_M27_noxref_g N_noxref_17_c_5901_n ) capacitor c=0.046753f \
 //x=7.05 //y=6.2 //x2=6.83 //y2=5.555
cc_1230 ( N_B_M28_noxref_g N_noxref_17_c_5887_n ) capacitor c=0.0184757f \
 //x=7.49 //y=6.2 //x2=7.71 //y2=5.555
cc_1231 ( N_B_M27_noxref_g N_noxref_17_M27_noxref_s ) capacitor c=0.00526487f \
 //x=7.05 //y=6.2 //x2=6.695 //y2=5.2
cc_1232 ( N_B_c_1296_p N_noxref_18_c_5960_n ) capacitor c=0.00699725f \
 //x=17.78 //y=4.99 //x2=16.245 //y2=7.085
cc_1233 ( N_B_c_1296_p N_noxref_18_c_5961_n ) capacitor c=0.0539208f //x=17.78 \
 //y=4.99 //x2=14.607 //y2=5.385
cc_1234 ( N_B_c_1296_p N_noxref_18_c_5962_n ) capacitor c=0.00172623f \
 //x=17.78 //y=4.99 //x2=15.48 //y2=5.385
cc_1235 ( N_B_c_1365_p N_noxref_19_c_6041_n ) capacitor c=0.0454203f //x=18.55 \
 //y=5.3 //x2=18.695 //y2=5.385
cc_1236 ( N_B_c_1352_p N_noxref_19_c_6042_n ) capacitor c=0.00691059f \
 //x=21.34 //y=4.99 //x2=19.57 //y2=7.085
cc_1237 ( N_B_c_1365_p N_noxref_19_c_6043_n ) capacitor c=0.00911527f \
 //x=18.55 //y=5.3 //x2=17.93 //y2=5.385
cc_1238 ( N_B_c_1357_p N_noxref_19_c_6043_n ) capacitor c=0.0149796f //x=17.95 \
 //y=5.3 //x2=17.93 //y2=5.385
cc_1239 ( N_B_c_1365_p N_noxref_19_c_6045_n ) capacitor c=0.00518717f \
 //x=18.55 //y=5.3 //x2=18.81 //y2=5.385
cc_1240 ( N_B_c_1352_p N_noxref_19_c_6045_n ) capacitor c=0.0102485f //x=21.34 \
 //y=4.99 //x2=18.81 //y2=5.385
cc_1241 ( N_B_c_1357_p N_noxref_19_M39_noxref_s ) capacitor c=2.17687e-19 \
 //x=17.95 //y=5.3 //x2=17.795 //y2=5.2
cc_1242 ( N_B_c_1094_n N_GND_c_6139_n ) capacitor c=2.28791e-19 //x=10.85 \
 //y=3.3 //x2=14.905 //y2=0.175
cc_1243 ( N_B_c_1095_n N_GND_c_6139_n ) capacitor c=7.3712e-19 //x=10.85 \
 //y=2.265 //x2=14.905 //y2=0.175
cc_1244 ( N_B_c_1216_n N_GND_c_6139_n ) capacitor c=7.5371e-19 //x=10.85 \
 //y=2.265 //x2=14.905 //y2=0.175
cc_1245 ( N_B_c_1096_n N_GND_c_6149_n ) capacitor c=0.00388088f //x=29.35 \
 //y=2.26 //x2=29.42 //y2=1.135
cc_1246 ( N_B_c_1107_n N_GND_c_6149_n ) capacitor c=2.13705e-19 //x=29.35 \
 //y=2.26 //x2=29.42 //y2=1.135
cc_1247 ( N_B_c_1130_n N_GND_c_6149_n ) capacitor c=0.00175094f //x=29.155 \
 //y=1.045 //x2=29.42 //y2=1.135
cc_1248 ( N_B_c_1131_n N_GND_c_6149_n ) capacitor c=0.00354198f //x=29.155 \
 //y=1.39 //x2=29.42 //y2=1.135
cc_1249 ( N_B_c_1132_n N_GND_c_6149_n ) capacitor c=4.2764e-19 //x=29.155 \
 //y=1.7 //x2=29.42 //y2=1.135
cc_1250 ( N_B_c_1557_p N_GND_c_6149_n ) capacitor c=7.35788e-19 //x=29.53 \
 //y=0.89 //x2=29.42 //y2=1.135
cc_1251 ( N_B_c_1558_p N_GND_c_6149_n ) capacitor c=6.36835e-19 //x=29.53 \
 //y=1.545 //x2=29.42 //y2=1.135
cc_1252 ( N_B_c_1138_n N_GND_c_6149_n ) capacitor c=0.00158609f //x=29.685 \
 //y=1.045 //x2=29.42 //y2=1.135
cc_1253 ( N_B_c_1140_n N_GND_c_6149_n ) capacitor c=0.00296337f //x=29.685 \
 //y=1.39 //x2=29.42 //y2=1.135
cc_1254 ( N_B_c_1130_n N_GND_c_6286_n ) capacitor c=3.51399e-19 //x=29.155 \
 //y=1.045 //x2=29.417 //y2=1.005
cc_1255 ( N_B_c_1557_p N_GND_c_6286_n ) capacitor c=0.00864609f //x=29.53 \
 //y=0.89 //x2=29.417 //y2=1.005
cc_1256 ( N_B_c_1138_n N_GND_c_6286_n ) capacitor c=4.45447e-19 //x=29.685 \
 //y=1.045 //x2=29.417 //y2=1.005
cc_1257 ( N_B_c_1225_n N_GND_c_6249_n ) capacitor c=0.0132669f //x=10.21 \
 //y=1.09 //x2=10.395 //y2=0.715
cc_1258 ( N_B_c_1094_n N_GND_c_6156_n ) capacitor c=6.82669e-19 //x=10.85 \
 //y=3.3 //x2=10.875 //y2=0.715
cc_1259 ( N_B_c_1095_n N_GND_c_6156_n ) capacitor c=0.00114179f //x=10.85 \
 //y=2.265 //x2=10.875 //y2=0.715
cc_1260 ( N_B_c_1216_n N_GND_c_6156_n ) capacitor c=3.95714e-19 //x=10.85 \
 //y=2.265 //x2=10.875 //y2=0.715
cc_1261 ( N_B_c_1242_n N_GND_c_6156_n ) capacitor c=0.0126466f //x=10.74 \
 //y=1.09 //x2=10.875 //y2=0.715
cc_1262 ( N_B_c_1249_n N_GND_c_6156_n ) capacitor c=2.1838e-19 //x=10.74 \
 //y=2.265 //x2=10.875 //y2=0.715
cc_1263 ( N_B_c_1130_n N_GND_c_6160_n ) capacitor c=0.00691994f //x=29.155 \
 //y=1.045 //x2=31.4 //y2=0.175
cc_1264 ( N_B_c_1100_n N_GND_c_6173_n ) capacitor c=0.00411812f //x=9.76 \
 //y=3.14 //x2=6.04 //y2=0.175
cc_1265 ( N_B_c_1104_n N_GND_c_6173_n ) capacitor c=0.00348382f //x=4.93 \
 //y=2.265 //x2=6.04 //y2=0.175
cc_1266 ( N_B_c_1125_n N_GND_c_6173_n ) capacitor c=0.00578449f //x=4.595 \
 //y=2.1 //x2=6.04 //y2=0.175
cc_1267 ( N_B_c_1129_n N_GND_c_6173_n ) capacitor c=0.00230557f //x=5.125 \
 //y=1.435 //x2=6.04 //y2=0.175
cc_1268 ( N_B_c_1100_n N_GND_c_6175_n ) capacitor c=0.00574654f //x=9.76 \
 //y=3.14 //x2=9.37 //y2=0.175
cc_1269 ( N_B_c_1216_n N_GND_c_6175_n ) capacitor c=0.0022444f //x=10.85 \
 //y=2.265 //x2=9.37 //y2=0.175
cc_1270 ( N_B_c_1249_n N_GND_c_6175_n ) capacitor c=2.63786e-19 //x=10.74 \
 //y=2.265 //x2=9.37 //y2=0.175
cc_1271 ( B N_GND_c_6176_n ) capacitor c=0.0102609f //x=10.85 //y=2.77 \
 //x2=11.59 //y2=0.175
cc_1272 ( N_B_c_1095_n N_GND_c_6176_n ) capacitor c=0.00621026f //x=10.85 \
 //y=2.265 //x2=11.59 //y2=0.175
cc_1273 ( N_B_c_1216_n N_GND_c_6176_n ) capacitor c=0.00733227f //x=10.85 \
 //y=2.265 //x2=11.59 //y2=0.175
cc_1274 ( N_B_c_1248_n N_GND_c_6176_n ) capacitor c=0.00310608f //x=10.74 \
 //y=2.1 //x2=11.59 //y2=0.175
cc_1275 ( N_B_c_1249_n N_GND_c_6176_n ) capacitor c=0.00781545f //x=10.74 \
 //y=2.265 //x2=11.59 //y2=0.175
cc_1276 ( B N_GND_c_6182_n ) capacitor c=0.00829739f //x=29.35 //y=2.77 \
 //x2=28.24 //y2=0.175
cc_1277 ( N_B_c_1096_n N_GND_c_6182_n ) capacitor c=0.00483281f //x=29.35 \
 //y=2.26 //x2=28.24 //y2=0.175
cc_1278 ( N_B_c_1107_n N_GND_c_6182_n ) capacitor c=0.00369427f //x=29.35 \
 //y=2.26 //x2=28.24 //y2=0.175
cc_1279 ( N_B_c_1134_n N_GND_c_6182_n ) capacitor c=0.00886018f //x=29.155 \
 //y=2.095 //x2=28.24 //y2=0.175
cc_1280 ( N_B_c_1094_n N_GND_M5_noxref_s ) capacitor c=5.465e-19 //x=10.85 \
 //y=3.3 //x2=9.865 //y2=0.55
cc_1281 ( N_B_c_1095_n N_GND_M5_noxref_s ) capacitor c=0.00297789f //x=10.85 \
 //y=2.265 //x2=9.865 //y2=0.55
cc_1282 ( N_B_c_1216_n N_GND_M5_noxref_s ) capacitor c=0.00651326f //x=10.85 \
 //y=2.265 //x2=9.865 //y2=0.55
cc_1283 ( N_B_c_1225_n N_GND_M5_noxref_s ) capacitor c=0.0153553f //x=10.21 \
 //y=1.09 //x2=9.865 //y2=0.55
cc_1284 ( N_B_c_1227_n N_GND_M5_noxref_s ) capacitor c=0.00629878f //x=10.21 \
 //y=1.435 //x2=9.865 //y2=0.55
cc_1285 ( N_B_c_1236_n N_GND_M5_noxref_s ) capacitor c=0.00521375f //x=10.585 \
 //y=0.935 //x2=9.865 //y2=0.55
cc_1286 ( N_B_c_1242_n N_GND_M5_noxref_s ) capacitor c=0.030052f //x=10.74 \
 //y=1.09 //x2=9.865 //y2=0.55
cc_1287 ( N_B_c_1247_n N_GND_M5_noxref_s ) capacitor c=0.002132f //x=10.74 \
 //y=1.745 //x2=9.865 //y2=0.55
cc_1288 ( N_B_c_1248_n N_GND_M5_noxref_s ) capacitor c=0.00304786f //x=10.74 \
 //y=2.1 //x2=9.865 //y2=0.55
cc_1289 ( N_B_c_1249_n N_GND_M5_noxref_s ) capacitor c=0.00404577f //x=10.74 \
 //y=2.265 //x2=9.865 //y2=0.55
cc_1290 ( N_B_c_1096_n N_GND_M15_noxref_d ) capacitor c=2.20516e-19 //x=29.35 \
 //y=2.26 //x2=29.23 //y2=1.045
cc_1291 ( N_B_c_1130_n N_GND_M15_noxref_d ) capacitor c=0.00192399f //x=29.155 \
 //y=1.045 //x2=29.23 //y2=1.045
cc_1292 ( N_B_c_1131_n N_GND_M15_noxref_d ) capacitor c=0.00210798f //x=29.155 \
 //y=1.39 //x2=29.23 //y2=1.045
cc_1293 ( N_B_c_1557_p N_GND_M15_noxref_d ) capacitor c=0.00472259f //x=29.53 \
 //y=0.89 //x2=29.23 //y2=1.045
cc_1294 ( N_B_c_1558_p N_GND_M15_noxref_d ) capacitor c=0.00166857f //x=29.53 \
 //y=1.545 //x2=29.23 //y2=1.045
cc_1295 ( N_B_c_1138_n N_GND_M15_noxref_d ) capacitor c=0.00230174f //x=29.685 \
 //y=1.045 //x2=29.23 //y2=1.045
cc_1296 ( N_B_c_1140_n N_GND_M15_noxref_d ) capacitor c=0.00210798f //x=29.685 \
 //y=1.39 //x2=29.23 //y2=1.045
cc_1297 ( N_B_c_1122_n N_noxref_23_c_7123_n ) capacitor c=0.00888238f \
 //x=4.595 //y=1.745 //x2=4.375 //y2=1.68
cc_1298 ( N_B_c_1104_n N_noxref_23_c_7125_n ) capacitor c=4.16328e-19 //x=4.93 \
 //y=2.265 //x2=5.26 //y2=0.715
cc_1299 ( N_B_c_1117_n N_noxref_23_c_7125_n ) capacitor c=0.0204604f //x=4.595 \
 //y=1.09 //x2=5.26 //y2=0.715
cc_1300 ( N_B_c_1125_n N_noxref_23_c_7125_n ) capacitor c=2.1838e-19 //x=4.595 \
 //y=2.1 //x2=5.26 //y2=0.715
cc_1301 ( N_B_c_1128_n N_noxref_23_c_7125_n ) capacitor c=0.00825432f \
 //x=5.125 //y=1.09 //x2=5.26 //y2=0.715
cc_1302 ( N_B_c_1117_n N_noxref_23_M1_noxref_s ) capacitor c=0.00888238f \
 //x=4.595 //y=1.09 //x2=3.27 //y2=0.55
cc_1303 ( N_B_c_1128_n N_noxref_23_M1_noxref_s ) capacitor c=0.015333f \
 //x=5.125 //y=1.09 //x2=3.27 //y2=0.55
cc_1304 ( N_B_c_1129_n N_noxref_23_M1_noxref_s ) capacitor c=0.00248746f \
 //x=5.125 //y=1.435 //x2=3.27 //y2=0.55
cc_1305 ( N_B_c_1134_n N_noxref_28_c_7431_n ) capacitor c=0.00262672f \
 //x=29.155 //y=2.095 //x2=28.935 //y2=1.675
cc_1306 ( B N_noxref_28_c_7432_n ) capacitor c=9.1268e-19 //x=29.35 //y=4.99 \
 //x2=29.82 //y2=1.76
cc_1307 ( N_B_c_1096_n N_noxref_28_c_7432_n ) capacitor c=0.00454295f \
 //x=29.35 //y=2.26 //x2=29.82 //y2=1.76
cc_1308 ( N_B_c_1107_n N_noxref_28_c_7432_n ) capacitor c=0.00763108f \
 //x=29.35 //y=2.26 //x2=29.82 //y2=1.76
cc_1309 ( N_B_c_1132_n N_noxref_28_c_7432_n ) capacitor c=0.00697076f \
 //x=29.155 //y=1.7 //x2=29.82 //y2=1.76
cc_1310 ( N_B_c_1134_n N_noxref_28_c_7432_n ) capacitor c=0.0168006f \
 //x=29.155 //y=2.095 //x2=29.82 //y2=1.76
cc_1311 ( N_B_c_1558_p N_noxref_28_c_7432_n ) capacitor c=0.00723574f \
 //x=29.53 //y=1.545 //x2=29.82 //y2=1.76
cc_1312 ( N_B_c_1140_n N_noxref_28_c_7432_n ) capacitor c=0.00339872f \
 //x=29.685 //y=1.39 //x2=29.82 //y2=1.76
cc_1313 ( N_B_c_1134_n N_noxref_28_c_7433_n ) capacitor c=6.71402e-19 \
 //x=29.155 //y=2.095 //x2=29.905 //y2=1.675
cc_1314 ( N_B_c_1130_n N_noxref_28_M15_noxref_s ) capacitor c=0.0294925f \
 //x=29.155 //y=1.045 //x2=28.8 //y2=0.545
cc_1315 ( N_B_c_1132_n N_noxref_28_M15_noxref_s ) capacitor c=3.48408e-19 \
 //x=29.155 //y=1.7 //x2=28.8 //y2=0.545
cc_1316 ( N_B_c_1138_n N_noxref_28_M15_noxref_s ) capacitor c=0.0125442f \
 //x=29.685 //y=1.045 //x2=28.8 //y2=0.545
cc_1317 ( N_noxref_5_c_1668_n N_noxref_6_c_2365_n ) capacitor c=3.54968e-19 \
 //x=8.19 //y=1.75 //x2=12.7 //y2=1.935
cc_1318 ( N_noxref_5_c_1898_p N_noxref_6_c_2365_n ) capacitor c=0.00107851f \
 //x=12.44 //y=1.435 //x2=12.7 //y2=1.935
cc_1319 ( N_noxref_5_c_1899_p N_noxref_6_c_2365_n ) capacitor c=0.00522452f \
 //x=12.44 //y=1.745 //x2=12.7 //y2=1.935
cc_1320 ( N_noxref_5_c_1900_p N_noxref_6_c_2365_n ) capacitor c=0.00366751f \
 //x=12.44 //y=2.1 //x2=12.7 //y2=1.935
cc_1321 ( N_noxref_5_c_1901_p N_noxref_6_c_2365_n ) capacitor c=0.0091671f \
 //x=12.815 //y=1.59 //x2=12.7 //y2=1.935
cc_1322 ( N_noxref_5_c_1902_p N_noxref_6_c_2365_n ) capacitor c=0.00344663f \
 //x=12.97 //y=1.435 //x2=12.7 //y2=1.935
cc_1323 ( N_noxref_5_c_1673_n N_noxref_6_c_2366_n ) capacitor c=2.75334e-19 \
 //x=8.545 //y=5.385 //x2=12.705 //y2=5.42
cc_1324 ( N_noxref_5_M33_noxref_g N_noxref_6_c_2366_n ) capacitor \
 c=0.00141266f //x=12.485 //y=6.2 //x2=12.705 //y2=5.42
cc_1325 ( N_noxref_5_M34_noxref_g N_noxref_6_c_2366_n ) capacitor \
 c=0.00352414f //x=12.925 //y=6.2 //x2=12.705 //y2=5.42
cc_1326 ( N_noxref_5_c_1901_p N_noxref_6_c_2359_n ) capacitor c=0.00153269f \
 //x=12.815 //y=1.59 //x2=12.985 //y2=2.02
cc_1327 ( N_noxref_5_c_1901_p N_noxref_6_c_2360_n ) capacitor c=2.8493e-19 \
 //x=12.815 //y=1.59 //x2=12.785 //y2=2.02
cc_1328 ( N_noxref_5_c_1887_n N_noxref_6_c_2360_n ) capacitor c=0.00366751f \
 //x=12.33 //y=2.265 //x2=12.785 //y2=2.02
cc_1329 ( N_noxref_5_M34_noxref_g N_noxref_6_c_2371_n ) capacitor c=0.0091982f \
 //x=12.925 //y=6.2 //x2=12.985 //y2=5.14
cc_1330 ( N_noxref_5_c_1697_n N_noxref_6_c_2368_n ) capacitor c=2.75334e-19 \
 //x=8.63 //y=5.3 //x2=12.79 //y2=5.14
cc_1331 ( N_noxref_5_M33_noxref_g N_noxref_6_c_2368_n ) capacitor \
 c=0.00448328f //x=12.485 //y=6.2 //x2=12.79 //y2=5.14
cc_1332 ( N_noxref_5_c_1912_p N_noxref_6_c_2368_n ) capacitor c=0.00224237f \
 //x=12.85 //y=4.97 //x2=12.79 //y2=5.14
cc_1333 ( N_noxref_5_c_1637_n N_noxref_6_c_2361_n ) capacitor c=0.0214075f \
 //x=12.33 //y=2.575 //x2=13.07 //y2=2.61
cc_1334 ( N_noxref_5_c_1768_n N_noxref_6_c_2361_n ) capacitor c=0.00139735f \
 //x=12.33 //y=3.6 //x2=13.07 //y2=2.61
cc_1335 ( N_noxref_5_c_1639_n N_noxref_6_c_2361_n ) capacitor c=0.00326871f \
 //x=14.92 //y=2.42 //x2=13.07 //y2=2.61
cc_1336 ( N_noxref_5_c_1916_p N_noxref_6_c_2361_n ) capacitor c=0.00224949f \
 //x=14.92 //y=4.095 //x2=13.07 //y2=2.61
cc_1337 ( N_noxref_5_c_1641_n N_noxref_6_c_2361_n ) capacitor c=3.00003e-19 \
 //x=12.685 //y=2.4 //x2=13.07 //y2=2.61
cc_1338 ( N_noxref_5_c_1642_n N_noxref_6_c_2361_n ) capacitor c=0.0221057f \
 //x=13.285 //y=2.385 //x2=13.07 //y2=2.61
cc_1339 ( N_noxref_5_c_1648_n N_noxref_6_c_2361_n ) capacitor c=0.00308371f \
 //x=12.495 //y=2.415 //x2=13.07 //y2=2.61
cc_1340 ( N_noxref_5_c_1920_p N_noxref_6_c_2361_n ) capacitor c=4.71798e-19 \
 //x=12.33 //y=2.265 //x2=13.07 //y2=2.61
cc_1341 ( N_noxref_5_c_1887_n N_noxref_6_c_2361_n ) capacitor c=0.00133463f \
 //x=12.33 //y=2.265 //x2=13.07 //y2=2.61
cc_1342 ( N_noxref_5_c_1768_n N_noxref_6_c_2404_n ) capacitor c=0.0148501f \
 //x=12.33 //y=3.6 //x2=13.07 //y2=2.93
cc_1343 ( N_noxref_5_c_1916_p N_noxref_6_c_2404_n ) capacitor c=0.00251111f \
 //x=14.92 //y=4.095 //x2=13.07 //y2=2.93
cc_1344 ( N_noxref_5_c_1642_n N_noxref_6_c_2404_n ) capacitor c=0.00641274f \
 //x=13.285 //y=2.385 //x2=13.07 //y2=2.93
cc_1345 ( N_noxref_5_c_1649_n N_noxref_6_c_2404_n ) capacitor c=0.00255477f \
 //x=14.755 //y=4.255 //x2=13.07 //y2=2.93
cc_1346 ( N_noxref_5_c_1768_n N_noxref_6_c_2374_n ) capacitor c=0.029864f \
 //x=12.33 //y=3.6 //x2=13.07 //y2=5.055
cc_1347 ( N_noxref_5_c_1638_n N_noxref_6_c_2374_n ) capacitor c=0.0153302f \
 //x=12.33 //y=3.92 //x2=13.07 //y2=5.055
cc_1348 ( N_noxref_5_c_1849_n N_noxref_6_c_2374_n ) capacitor c=0.00785935f \
 //x=12.33 //y=4.09 //x2=13.07 //y2=5.055
cc_1349 ( N_noxref_5_c_1850_n N_noxref_6_c_2374_n ) capacitor c=0.0173413f \
 //x=12.33 //y=4.41 //x2=13.07 //y2=5.055
cc_1350 ( N_noxref_5_c_1770_n N_noxref_6_c_2374_n ) capacitor c=0.027613f \
 //x=12.33 //y=4.76 //x2=13.07 //y2=5.055
cc_1351 ( N_noxref_5_c_1916_p N_noxref_6_c_2374_n ) capacitor c=0.0223777f \
 //x=14.92 //y=4.095 //x2=13.07 //y2=5.055
cc_1352 ( N_noxref_5_c_1856_n N_noxref_6_c_2374_n ) capacitor c=0.00250563f \
 //x=14.92 //y=4.415 //x2=13.07 //y2=5.055
cc_1353 ( N_noxref_5_c_1857_n N_noxref_6_c_2374_n ) capacitor c=0.0080636f \
 //x=14.92 //y=4.765 //x2=13.07 //y2=5.055
cc_1354 ( N_noxref_5_c_1779_n N_noxref_6_c_2374_n ) capacitor c=0.00123386f \
 //x=12.33 //y=3.715 //x2=13.07 //y2=5.055
cc_1355 ( N_noxref_5_c_1780_n N_noxref_6_c_2374_n ) capacitor c=5.56854e-19 \
 //x=12.33 //y=4.25 //x2=13.07 //y2=5.055
cc_1356 ( N_noxref_5_c_1781_n N_noxref_6_c_2374_n ) capacitor c=0.0032735f \
 //x=12.49 //y=4.25 //x2=13.07 //y2=5.055
cc_1357 ( N_noxref_5_c_1797_n N_noxref_6_c_2374_n ) capacitor c=0.0070458f \
 //x=12.335 //y=3.76 //x2=13.07 //y2=5.055
cc_1358 ( N_noxref_5_c_1882_n N_noxref_6_c_2374_n ) capacitor c=0.00158465f \
 //x=14.915 //y=4.255 //x2=13.07 //y2=5.055
cc_1359 ( N_noxref_5_c_1649_n N_noxref_6_c_2374_n ) capacitor c=0.0296904f \
 //x=14.755 //y=4.255 //x2=13.07 //y2=5.055
cc_1360 ( N_noxref_5_c_1884_n N_noxref_6_c_2374_n ) capacitor c=0.00137188f \
 //x=12.33 //y=4.88 //x2=13.07 //y2=5.055
cc_1361 ( N_noxref_5_c_1912_p N_noxref_6_c_2374_n ) capacitor c=0.00211091f \
 //x=12.85 //y=4.97 //x2=13.07 //y2=5.055
cc_1362 ( N_noxref_5_c_1886_n N_noxref_6_c_2374_n ) capacitor c=0.00140024f \
 //x=12.56 //y=4.97 //x2=13.07 //y2=5.055
cc_1363 ( N_noxref_5_c_1643_n N_noxref_6_c_2425_n ) capacitor c=0.00147459f \
 //x=18.96 //y=2.4 //x2=19.24 //y2=2.915
cc_1364 ( N_noxref_5_c_1644_n N_noxref_6_c_2425_n ) capacitor c=0.00314719f \
 //x=19.56 //y=2.37 //x2=19.24 //y2=2.915
cc_1365 ( N_noxref_5_c_1916_p N_noxref_6_c_2427_n ) capacitor c=5.03125e-19 \
 //x=14.92 //y=4.095 //x2=19.24 //y2=4.73
cc_1366 ( N_noxref_5_c_1644_n N_noxref_6_c_2362_n ) capacitor c=0.0115799f \
 //x=19.56 //y=2.37 //x2=19.36 //y2=2.41
cc_1367 ( N_noxref_5_c_1643_n N_noxref_6_c_2429_n ) capacitor c=7.368e-19 \
 //x=18.96 //y=2.4 //x2=19.36 //y2=2.595
cc_1368 ( N_noxref_5_c_1644_n N_noxref_6_c_2429_n ) capacitor c=0.00602801f \
 //x=19.56 //y=2.37 //x2=19.36 //y2=2.595
cc_1369 ( N_noxref_5_c_1949_p N_noxref_6_c_2363_n ) capacitor c=0.00174488f \
 //x=12.44 //y=1.09 //x2=12.7 //y2=1.185
cc_1370 ( N_noxref_5_c_1898_p N_noxref_6_c_2363_n ) capacitor c=0.00350474f \
 //x=12.44 //y=1.435 //x2=12.7 //y2=1.185
cc_1371 ( N_noxref_5_c_1951_p N_noxref_6_c_2363_n ) capacitor c=5.57924e-19 \
 //x=12.815 //y=0.935 //x2=12.7 //y2=1.185
cc_1372 ( N_noxref_5_c_1901_p N_noxref_6_c_2363_n ) capacitor c=5.77693e-19 \
 //x=12.815 //y=1.59 //x2=12.7 //y2=1.185
cc_1373 ( N_noxref_5_c_1953_p N_noxref_6_c_2363_n ) capacitor c=0.00148359f \
 //x=12.97 //y=1.09 //x2=12.7 //y2=1.185
cc_1374 ( N_noxref_5_c_1902_p N_noxref_6_c_2363_n ) capacitor c=0.00356717f \
 //x=12.97 //y=1.435 //x2=12.7 //y2=1.185
cc_1375 ( N_noxref_5_c_1768_n N_noxref_6_c_2437_n ) capacitor c=6.15063e-19 \
 //x=12.33 //y=3.6 //x2=13.07 //y2=2.77
cc_1376 ( N_noxref_5_c_1768_n N_noxref_6_c_2438_n ) capacitor c=0.00686827f \
 //x=12.33 //y=3.6 //x2=13.23 //y2=2.77
cc_1377 ( N_noxref_5_c_1916_p N_noxref_6_c_2438_n ) capacitor c=0.0015808f \
 //x=14.92 //y=4.095 //x2=13.23 //y2=2.77
cc_1378 ( N_noxref_5_c_1642_n N_noxref_6_c_2438_n ) capacitor c=0.0360686f \
 //x=13.285 //y=2.385 //x2=13.23 //y2=2.77
cc_1379 ( N_noxref_5_c_1649_n N_noxref_6_c_2438_n ) capacitor c=0.00503714f \
 //x=14.755 //y=4.255 //x2=13.23 //y2=2.77
cc_1380 ( N_noxref_5_c_1644_n N_noxref_6_c_2442_n ) capacitor c=0.0367782f \
 //x=19.56 //y=2.37 //x2=19.345 //y2=2.755
cc_1381 ( N_noxref_5_c_1916_p N_noxref_6_c_2364_n ) capacitor c=0.0296494f \
 //x=14.92 //y=4.095 //x2=19.185 //y2=2.755
cc_1382 ( N_noxref_5_c_1856_n N_noxref_6_c_2364_n ) capacitor c=0.00236295f \
 //x=14.92 //y=4.415 //x2=19.185 //y2=2.755
cc_1383 ( N_noxref_5_c_1642_n N_noxref_6_c_2364_n ) capacitor c=0.515518f \
 //x=13.285 //y=2.385 //x2=19.185 //y2=2.755
cc_1384 ( N_noxref_5_c_1643_n N_noxref_6_c_2364_n ) capacitor c=0.0106197f \
 //x=18.96 //y=2.4 //x2=19.185 //y2=2.755
cc_1385 ( N_noxref_5_c_1882_n N_noxref_6_c_2364_n ) capacitor c=0.00501333f \
 //x=14.915 //y=4.255 //x2=19.185 //y2=2.755
cc_1386 ( N_noxref_5_c_1649_n N_noxref_6_c_2364_n ) capacitor c=0.0363654f \
 //x=14.755 //y=4.255 //x2=19.185 //y2=2.755
cc_1387 ( N_noxref_5_M33_noxref_g N_noxref_6_c_2449_n ) capacitor c=0.0162066f \
 //x=12.485 //y=6.2 //x2=12.705 //y2=5.56
cc_1388 ( N_noxref_5_M34_noxref_g N_noxref_6_c_2449_n ) capacitor c=0.0162066f \
 //x=12.925 //y=6.2 //x2=12.705 //y2=5.56
cc_1389 ( N_noxref_5_c_1912_p N_noxref_6_c_2449_n ) capacitor c=0.00290963f \
 //x=12.85 //y=4.97 //x2=12.705 //y2=5.56
cc_1390 ( N_noxref_5_c_1949_p N_noxref_6_M6_noxref_d ) capacitor c=0.00137914f \
 //x=12.44 //y=1.09 //x2=12.515 //y2=1.09
cc_1391 ( N_noxref_5_c_1898_p N_noxref_6_M6_noxref_d ) capacitor c=0.0023891f \
 //x=12.44 //y=1.435 //x2=12.515 //y2=1.09
cc_1392 ( N_noxref_5_c_1951_p N_noxref_6_M6_noxref_d ) capacitor c=0.0020782f \
 //x=12.815 //y=0.935 //x2=12.515 //y2=1.09
cc_1393 ( N_noxref_5_c_1901_p N_noxref_6_M6_noxref_d ) capacitor c=0.00356097f \
 //x=12.815 //y=1.59 //x2=12.515 //y2=1.09
cc_1394 ( N_noxref_5_c_1953_p N_noxref_6_M6_noxref_d ) capacitor c=0.00138452f \
 //x=12.97 //y=1.09 //x2=12.515 //y2=1.09
cc_1395 ( N_noxref_5_c_1902_p N_noxref_6_M6_noxref_d ) capacitor c=0.00235934f \
 //x=12.97 //y=1.435 //x2=12.515 //y2=1.09
cc_1396 ( N_noxref_5_c_1916_p SUM ) capacitor c=0.0123381f //x=14.92 //y=4.095 \
 //x2=16.52 //y2=3.51
cc_1397 ( N_noxref_5_c_1643_n SUM ) capacitor c=0.0214021f //x=18.96 //y=2.4 \
 //x2=16.52 //y2=3.51
cc_1398 ( N_noxref_5_c_1916_p SUM ) capacitor c=8.27091e-19 //x=14.92 \
 //y=4.095 //x2=16.52 //y2=4.62
cc_1399 ( N_noxref_5_c_1856_n SUM ) capacitor c=0.00100476f //x=14.92 \
 //y=4.415 //x2=16.52 //y2=4.62
cc_1400 ( N_noxref_5_c_1857_n SUM ) capacitor c=0.00194983f //x=14.92 \
 //y=4.765 //x2=16.52 //y2=4.62
cc_1401 ( N_noxref_5_c_1882_n SUM ) capacitor c=4.77997e-19 //x=14.915 \
 //y=4.255 //x2=16.52 //y2=4.62
cc_1402 ( N_noxref_5_c_1644_n SUM ) capacitor c=0.0238733f //x=19.56 //y=2.37 \
 //x2=19.73 //y2=2.77
cc_1403 ( N_noxref_5_c_1916_p N_SUM_c_2686_n ) capacitor c=0.00383446f \
 //x=14.92 //y=4.095 //x2=16.52 //y2=4.055
cc_1404 ( N_noxref_5_c_1916_p N_SUM_c_2687_n ) capacitor c=0.00373013f \
 //x=14.92 //y=4.095 //x2=16.725 //y2=3.895
cc_1405 ( N_noxref_5_c_1856_n N_noxref_8_c_2966_n ) capacitor c=0.0104777f \
 //x=14.92 //y=4.415 //x2=16.03 //y2=4.575
cc_1406 ( N_noxref_5_c_1857_n N_noxref_8_c_2966_n ) capacitor c=0.00332107f \
 //x=14.92 //y=4.765 //x2=16.03 //y2=4.575
cc_1407 ( N_noxref_5_c_1987_p N_noxref_8_c_2966_n ) capacitor c=2.20462e-19 \
 //x=14.92 //y=4.25 //x2=16.03 //y2=4.575
cc_1408 ( N_noxref_5_c_1882_n N_noxref_8_c_2966_n ) capacitor c=0.00277624f \
 //x=14.915 //y=4.255 //x2=16.03 //y2=4.575
cc_1409 ( N_noxref_5_c_1857_n N_noxref_8_c_2967_n ) capacitor c=0.0128297f \
 //x=14.92 //y=4.765 //x2=16.03 //y2=4.765
cc_1410 ( N_noxref_5_c_1885_n N_noxref_8_c_2967_n ) capacitor c=8.48688e-19 \
 //x=14.92 //y=4.88 //x2=16.03 //y2=4.765
cc_1411 ( N_noxref_5_c_1991_p N_noxref_8_c_2967_n ) capacitor c=0.00132086f \
 //x=14.92 //y=4.88 //x2=16.03 //y2=4.765
cc_1412 ( N_noxref_5_c_1643_n N_noxref_8_c_2961_n ) capacitor c=0.0120993f \
 //x=18.96 //y=2.4 //x2=18.25 //y2=2.385
cc_1413 ( N_noxref_5_c_1643_n N_noxref_8_c_2989_n ) capacitor c=0.0132831f \
 //x=18.96 //y=2.4 //x2=18.25 //y2=3.385
cc_1414 ( N_noxref_5_c_1644_n N_noxref_8_c_2962_n ) capacitor c=0.0252075f \
 //x=19.56 //y=2.37 //x2=21.21 //y2=3.335
cc_1415 ( N_noxref_5_c_1856_n N_noxref_8_c_2991_n ) capacitor c=5.21732e-19 \
 //x=14.92 //y=4.415 //x2=16.075 //y2=4.415
cc_1416 ( N_noxref_5_c_1987_p N_noxref_8_c_2991_n ) capacitor c=0.00540988f \
 //x=14.92 //y=4.25 //x2=16.075 //y2=4.415
cc_1417 ( N_noxref_5_c_1856_n N_noxref_8_c_2977_n ) capacitor c=6.43301e-19 \
 //x=14.92 //y=4.415 //x2=16.075 //y2=4.28
cc_1418 ( N_noxref_5_c_1857_n N_noxref_8_c_2977_n ) capacitor c=0.00250264f \
 //x=14.92 //y=4.765 //x2=16.075 //y2=4.28
cc_1419 ( N_noxref_5_c_1882_n N_noxref_8_c_2977_n ) capacitor c=0.00709734f \
 //x=14.915 //y=4.255 //x2=16.075 //y2=4.28
cc_1420 ( N_noxref_5_c_1644_n N_noxref_8_c_2996_n ) capacitor c=0.0060161f \
 //x=19.56 //y=2.37 //x2=21.085 //y2=3.495
cc_1421 ( N_noxref_5_c_1857_n N_noxref_8_c_2997_n ) capacitor c=7.40512e-19 \
 //x=14.92 //y=4.765 //x2=16.03 //y2=4.88
cc_1422 ( N_noxref_5_c_1885_n N_noxref_8_c_2997_n ) capacitor c=0.00113699f \
 //x=14.92 //y=4.88 //x2=16.03 //y2=4.88
cc_1423 ( N_noxref_5_c_1991_p N_noxref_8_c_2997_n ) capacitor c=0.00195576f \
 //x=14.92 //y=4.88 //x2=16.03 //y2=4.88
cc_1424 ( N_noxref_5_c_1643_n N_noxref_8_c_3000_n ) capacitor c=3.65975e-19 \
 //x=18.96 //y=2.4 //x2=18.25 //y2=2.265
cc_1425 ( N_noxref_5_M35_noxref_g N_noxref_8_M37_noxref_g ) capacitor \
 c=0.0102032f //x=14.82 //y=6.2 //x2=15.7 //y2=6.2
cc_1426 ( N_noxref_5_M36_noxref_g N_noxref_8_M37_noxref_g ) capacitor \
 c=0.0618855f //x=15.26 //y=6.2 //x2=15.7 //y2=6.2
cc_1427 ( N_noxref_5_M36_noxref_g N_noxref_8_M38_noxref_g ) capacitor \
 c=0.00945236f //x=15.26 //y=6.2 //x2=16.14 //y2=6.2
cc_1428 ( N_noxref_5_c_1857_n N_noxref_8_c_3004_n ) capacitor c=0.00121997f \
 //x=14.92 //y=4.765 //x2=16.03 //y2=4.88
cc_1429 ( N_noxref_5_c_1885_n N_noxref_8_c_3004_n ) capacitor c=0.0019442f \
 //x=14.92 //y=4.88 //x2=16.03 //y2=4.88
cc_1430 ( N_noxref_5_c_1991_p N_noxref_8_c_3004_n ) capacitor c=0.067621f \
 //x=14.92 //y=4.88 //x2=16.03 //y2=4.88
cc_1431 ( N_noxref_5_c_1858_n CIN ) capacitor c=0.00121298f //x=24.54 \
 //y=4.735 //x2=21.95 //y2=2.77
cc_1432 ( N_noxref_5_c_1644_n CIN ) capacitor c=0.0107623f //x=19.56 //y=2.37 \
 //x2=21.95 //y2=2.77
cc_1433 ( N_noxref_5_c_1858_n CIN ) capacitor c=0.00346785f //x=24.54 \
 //y=4.735 //x2=21.95 //y2=3.51
cc_1434 ( N_noxref_5_c_1640_n CIN ) capacitor c=0.00866121f //x=24.54 \
 //y=2.575 //x2=23.8 //y2=2.77
cc_1435 ( N_noxref_5_c_1858_n CIN ) capacitor c=0.0837399f //x=24.54 //y=4.735 \
 //x2=23.8 //y2=2.77
cc_1436 ( N_noxref_5_c_1644_n CIN ) capacitor c=0.0205701f //x=19.56 //y=2.37 \
 //x2=23.8 //y2=2.77
cc_1437 ( N_noxref_5_c_1916_p CIN ) capacitor c=0.00832877f //x=14.92 \
 //y=4.095 //x2=16.03 //y2=3.14
cc_1438 ( N_noxref_5_c_1858_n CIN ) capacitor c=0.0241494f //x=24.54 //y=4.735 \
 //x2=23.8 //y2=4.62
cc_1439 ( N_noxref_5_c_1644_n CIN ) capacitor c=0.00167014f //x=19.56 //y=2.37 \
 //x2=23.8 //y2=4.62
cc_1440 ( N_noxref_5_c_2020_p CIN ) capacitor c=4.80626e-19 //x=24.57 //y=4.88 \
 //x2=23.8 //y2=4.62
cc_1441 ( N_noxref_5_c_2021_p CIN ) capacitor c=0.00156516f //x=24.57 //y=4.88 \
 //x2=23.8 //y2=4.62
cc_1442 ( N_noxref_5_c_1639_n N_CIN_c_3283_n ) capacitor c=0.00937884f \
 //x=14.92 //y=2.42 //x2=16.03 //y2=2.415
cc_1443 ( N_noxref_5_c_1643_n N_CIN_c_3283_n ) capacitor c=0.011587f //x=18.96 \
 //y=2.4 //x2=16.03 //y2=2.415
cc_1444 ( N_noxref_5_c_2024_p N_CIN_c_3283_n ) capacitor c=4.19574e-19 \
 //x=14.92 //y=2.265 //x2=16.03 //y2=2.415
cc_1445 ( N_noxref_5_c_2025_p N_CIN_c_3283_n ) capacitor c=0.00142903f \
 //x=14.725 //y=2.1 //x2=16.03 //y2=2.415
cc_1446 ( N_noxref_5_c_1916_p N_CIN_c_3328_n ) capacitor c=0.0125303f \
 //x=14.92 //y=4.095 //x2=16.03 //y2=2.995
cc_1447 ( N_noxref_5_c_1643_n N_CIN_c_3328_n ) capacitor c=0.00860211f \
 //x=18.96 //y=2.4 //x2=16.03 //y2=2.995
cc_1448 ( N_noxref_5_c_1644_n N_CIN_c_3330_n ) capacitor c=0.00324759f \
 //x=19.56 //y=2.37 //x2=21.95 //y2=3.3
cc_1449 ( N_noxref_5_c_1644_n N_CIN_c_3284_n ) capacitor c=0.0149421f \
 //x=19.56 //y=2.37 //x2=21.95 //y2=2.265
cc_1450 ( N_noxref_5_c_1640_n N_CIN_c_3285_n ) capacitor c=0.016971f //x=24.54 \
 //y=2.575 //x2=23.8 //y2=2.26
cc_1451 ( N_noxref_5_c_1644_n N_CIN_c_3285_n ) capacitor c=0.0127754f \
 //x=19.56 //y=2.37 //x2=23.8 //y2=2.26
cc_1452 ( N_noxref_5_c_2032_p N_CIN_c_3285_n ) capacitor c=0.00201815f \
 //x=24.54 //y=2.26 //x2=23.8 //y2=2.26
cc_1453 ( N_noxref_5_c_2033_p N_CIN_c_3285_n ) capacitor c=8.67505e-19 \
 //x=24.54 //y=2.26 //x2=23.8 //y2=2.26
cc_1454 ( N_noxref_5_c_1643_n N_CIN_c_3286_n ) capacitor c=0.0243945f \
 //x=18.96 //y=2.4 //x2=20.86 //y2=3.14
cc_1455 ( N_noxref_5_c_1644_n N_CIN_c_3286_n ) capacitor c=0.0863108f \
 //x=19.56 //y=2.37 //x2=20.86 //y2=3.14
cc_1456 ( N_noxref_5_c_1644_n N_CIN_c_3287_n ) capacitor c=0.0260397f \
 //x=19.56 //y=2.37 //x2=21.46 //y2=3.11
cc_1457 ( N_noxref_5_c_1644_n N_CIN_c_3303_n ) capacitor c=0.0253944f \
 //x=19.56 //y=2.37 //x2=22.12 //y2=4.62
cc_1458 ( N_noxref_5_c_1916_p N_CIN_c_3304_n ) capacitor c=0.00513442f \
 //x=14.92 //y=4.095 //x2=16.19 //y2=3.155
cc_1459 ( N_noxref_5_c_1858_n N_CIN_c_3305_n ) capacitor c=0.00712593f \
 //x=24.54 //y=4.735 //x2=23.795 //y2=4.625
cc_1460 ( N_noxref_5_c_1644_n N_CIN_c_3305_n ) capacitor c=0.00305238f \
 //x=19.56 //y=2.37 //x2=23.795 //y2=4.625
cc_1461 ( N_noxref_5_c_1639_n N_CIN_c_3343_n ) capacitor c=5.22383e-19 \
 //x=14.92 //y=2.42 //x2=16.03 //y2=2.265
cc_1462 ( N_noxref_5_c_2024_p N_CIN_c_3343_n ) capacitor c=0.00114269f \
 //x=14.92 //y=2.265 //x2=16.03 //y2=2.265
cc_1463 ( N_noxref_5_c_2025_p N_CIN_c_3343_n ) capacitor c=0.00187625f \
 //x=14.725 //y=2.1 //x2=16.03 //y2=2.265
cc_1464 ( N_noxref_5_c_1640_n N_CIN_c_3346_n ) capacitor c=0.00146167f \
 //x=24.54 //y=2.575 //x2=23.8 //y2=2.26
cc_1465 ( N_noxref_5_c_1644_n N_CIN_c_3346_n ) capacitor c=2.20452e-19 \
 //x=19.56 //y=2.37 //x2=23.8 //y2=2.26
cc_1466 ( N_noxref_5_c_2032_p N_CIN_c_3346_n ) capacitor c=0.00444948f \
 //x=24.54 //y=2.26 //x2=23.8 //y2=2.26
cc_1467 ( N_noxref_5_c_2033_p N_CIN_c_3346_n ) capacitor c=0.00242818f \
 //x=24.54 //y=2.26 //x2=23.8 //y2=2.26
cc_1468 ( N_noxref_5_c_1858_n N_CIN_c_3312_n ) capacitor c=0.00103725f \
 //x=24.54 //y=4.735 //x2=23.8 //y2=4.62
cc_1469 ( N_noxref_5_c_2020_p N_CIN_c_3312_n ) capacitor c=0.00409934f \
 //x=24.57 //y=4.88 //x2=23.8 //y2=4.62
cc_1470 ( N_noxref_5_c_2021_p N_CIN_c_3312_n ) capacitor c=0.00237894f \
 //x=24.57 //y=4.88 //x2=23.8 //y2=4.62
cc_1471 ( N_noxref_5_M47_noxref_g N_CIN_M45_noxref_g ) capacitor c=0.0104892f \
 //x=24.58 //y=6.2 //x2=23.7 //y2=6.2
cc_1472 ( N_noxref_5_M47_noxref_g N_CIN_M46_noxref_g ) capacitor c=0.107636f \
 //x=24.58 //y=6.2 //x2=24.14 //y2=6.2
cc_1473 ( N_noxref_5_M48_noxref_g N_CIN_M46_noxref_g ) capacitor c=0.0100341f \
 //x=25.02 //y=6.2 //x2=24.14 //y2=6.2
cc_1474 ( N_noxref_5_c_2054_p N_CIN_c_3356_n ) capacitor c=4.86545e-19 \
 //x=14.725 //y=1.05 //x2=15.695 //y2=1.09
cc_1475 ( N_noxref_5_c_2055_p N_CIN_c_3356_n ) capacitor c=0.00152405f \
 //x=14.725 //y=1.395 //x2=15.695 //y2=1.09
cc_1476 ( N_noxref_5_c_2056_p N_CIN_c_3356_n ) capacitor c=0.0157772f \
 //x=15.255 //y=1.05 //x2=15.695 //y2=1.09
cc_1477 ( N_noxref_5_c_2057_p N_CIN_c_3359_n ) capacitor c=0.00109982f \
 //x=14.725 //y=1.705 //x2=15.695 //y2=1.435
cc_1478 ( N_noxref_5_c_2058_p N_CIN_c_3359_n ) capacitor c=0.0117362f \
 //x=15.255 //y=1.395 //x2=15.695 //y2=1.435
cc_1479 ( N_noxref_5_c_2057_p N_CIN_c_3361_n ) capacitor c=9.58243e-19 \
 //x=14.725 //y=1.705 //x2=15.695 //y2=1.745
cc_1480 ( N_noxref_5_c_2025_p N_CIN_c_3361_n ) capacitor c=0.00662747f \
 //x=14.725 //y=2.1 //x2=15.695 //y2=1.745
cc_1481 ( N_noxref_5_c_2058_p N_CIN_c_3361_n ) capacitor c=0.00862358f \
 //x=15.255 //y=1.395 //x2=15.695 //y2=1.745
cc_1482 ( N_noxref_5_c_1639_n N_CIN_c_3364_n ) capacitor c=0.00162984f \
 //x=14.92 //y=2.42 //x2=15.695 //y2=2.1
cc_1483 ( N_noxref_5_c_2024_p N_CIN_c_3364_n ) capacitor c=0.00214703f \
 //x=14.92 //y=2.265 //x2=15.695 //y2=2.1
cc_1484 ( N_noxref_5_c_2025_p N_CIN_c_3364_n ) capacitor c=0.012184f \
 //x=14.725 //y=2.1 //x2=15.695 //y2=2.1
cc_1485 ( N_noxref_5_c_2056_p N_CIN_c_3367_n ) capacitor c=0.00127211f \
 //x=15.255 //y=1.05 //x2=16.225 //y2=1.09
cc_1486 ( N_noxref_5_c_2058_p N_CIN_c_3368_n ) capacitor c=0.00204774f \
 //x=15.255 //y=1.395 //x2=16.225 //y2=1.435
cc_1487 ( N_noxref_5_c_2067_p N_CIN_c_3369_n ) capacitor c=4.86545e-19 \
 //x=24.575 //y=1.085 //x2=23.605 //y2=1.045
cc_1488 ( N_noxref_5_c_2067_p N_CIN_c_3370_n ) capacitor c=0.00152405f \
 //x=24.575 //y=1.085 //x2=23.605 //y2=1.39
cc_1489 ( N_noxref_5_c_2069_p N_CIN_c_3371_n ) capacitor c=0.00109982f \
 //x=24.575 //y=1.43 //x2=23.605 //y2=1.7
cc_1490 ( N_noxref_5_c_2070_p N_CIN_c_3371_n ) capacitor c=9.58243e-19 \
 //x=24.575 //y=1.74 //x2=23.605 //y2=1.7
cc_1491 ( N_noxref_5_c_1640_n N_CIN_c_3373_n ) capacitor c=0.00170651f \
 //x=24.54 //y=2.575 //x2=23.605 //y2=2.095
cc_1492 ( N_noxref_5_c_2032_p N_CIN_c_3373_n ) capacitor c=0.00267875f \
 //x=24.54 //y=2.26 //x2=23.605 //y2=2.095
cc_1493 ( N_noxref_5_c_2070_p N_CIN_c_3373_n ) capacitor c=0.00662747f \
 //x=24.575 //y=1.74 //x2=23.605 //y2=2.095
cc_1494 ( N_noxref_5_c_2033_p N_CIN_c_3373_n ) capacitor c=0.0175667f \
 //x=24.54 //y=2.26 //x2=23.605 //y2=2.095
cc_1495 ( N_noxref_5_c_2067_p N_CIN_c_3377_n ) capacitor c=0.0151475f \
 //x=24.575 //y=1.085 //x2=24.135 //y2=1.045
cc_1496 ( N_noxref_5_c_2076_p N_CIN_c_3377_n ) capacitor c=0.00127211f \
 //x=25.105 //y=1.085 //x2=24.135 //y2=1.045
cc_1497 ( N_noxref_5_c_2069_p N_CIN_c_3379_n ) capacitor c=0.0111064f \
 //x=24.575 //y=1.43 //x2=24.135 //y2=1.39
cc_1498 ( N_noxref_5_c_2070_p N_CIN_c_3379_n ) capacitor c=0.00862358f \
 //x=24.575 //y=1.74 //x2=24.135 //y2=1.39
cc_1499 ( N_noxref_5_c_2079_p N_CIN_c_3379_n ) capacitor c=0.00204774f \
 //x=25.105 //y=1.43 //x2=24.135 //y2=1.39
cc_1500 ( N_noxref_5_c_1858_n N_CIN_c_3382_n ) capacitor c=0.00145962f \
 //x=24.54 //y=4.735 //x2=23.8 //y2=4.88
cc_1501 ( N_noxref_5_c_2020_p N_CIN_c_3382_n ) capacitor c=0.00273783f \
 //x=24.57 //y=4.88 //x2=23.8 //y2=4.88
cc_1502 ( N_noxref_5_c_2021_p N_CIN_c_3382_n ) capacitor c=0.0295931f \
 //x=24.57 //y=4.88 //x2=23.8 //y2=4.88
cc_1503 ( N_noxref_5_c_1640_n N_noxref_10_c_3700_n ) capacitor c=6.70472e-19 \
 //x=24.54 //y=2.575 //x2=24.685 //y2=5.38
cc_1504 ( N_noxref_5_c_1858_n N_noxref_10_c_3700_n ) capacitor c=0.0178804f \
 //x=24.54 //y=4.735 //x2=24.685 //y2=5.38
cc_1505 ( N_noxref_5_c_2020_p N_noxref_10_c_3700_n ) capacitor c=0.00469257f \
 //x=24.57 //y=4.88 //x2=24.685 //y2=5.38
cc_1506 ( N_noxref_5_M47_noxref_g N_noxref_10_c_3700_n ) capacitor \
 c=0.00842771f //x=24.58 //y=6.2 //x2=24.685 //y2=5.38
cc_1507 ( N_noxref_5_c_2021_p N_noxref_10_c_3700_n ) capacitor c=9.56469e-19 \
 //x=24.57 //y=4.88 //x2=24.685 //y2=5.38
cc_1508 ( N_noxref_5_c_2069_p N_noxref_10_c_3718_n ) capacitor c=0.00118531f \
 //x=24.575 //y=1.43 //x2=24.84 //y2=1.75
cc_1509 ( N_noxref_5_c_2070_p N_noxref_10_c_3718_n ) capacitor c=0.00460528f \
 //x=24.575 //y=1.74 //x2=24.84 //y2=1.75
cc_1510 ( N_noxref_5_c_2090_p N_noxref_10_c_3718_n ) capacitor c=0.00897029f \
 //x=24.95 //y=1.585 //x2=24.84 //y2=1.75
cc_1511 ( N_noxref_5_c_2079_p N_noxref_10_c_3718_n ) capacitor c=0.00303393f \
 //x=25.105 //y=1.43 //x2=24.84 //y2=1.75
cc_1512 ( N_noxref_5_c_2092_p N_noxref_10_c_3718_n ) capacitor c=0.00348382f \
 //x=24.54 //y=2.095 //x2=24.84 //y2=1.75
cc_1513 ( N_noxref_5_M48_noxref_g N_noxref_10_c_3723_n ) capacitor c=0.010005f \
 //x=25.02 //y=6.2 //x2=25.195 //y2=5.38
cc_1514 ( N_noxref_5_c_2090_p N_noxref_10_c_3724_n ) capacitor c=0.00194324f \
 //x=24.95 //y=1.585 //x2=25.195 //y2=1.835
cc_1515 ( N_noxref_5_c_2079_p N_noxref_10_c_3724_n ) capacitor c=0.00323005f \
 //x=25.105 //y=1.43 //x2=25.195 //y2=1.835
cc_1516 ( N_noxref_5_c_1640_n N_noxref_10_c_3692_n ) capacitor c=0.0215625f \
 //x=24.54 //y=2.575 //x2=25.28 //y2=3.35
cc_1517 ( N_noxref_5_c_1858_n N_noxref_10_c_3692_n ) capacitor c=0.0333039f \
 //x=24.54 //y=4.735 //x2=25.28 //y2=3.35
cc_1518 ( N_noxref_5_c_1644_n N_noxref_10_c_3692_n ) capacitor c=0.00685861f \
 //x=19.56 //y=2.37 //x2=25.28 //y2=3.35
cc_1519 ( N_noxref_5_c_2032_p N_noxref_10_c_3692_n ) capacitor c=4.71798e-19 \
 //x=24.54 //y=2.26 //x2=25.28 //y2=3.35
cc_1520 ( N_noxref_5_c_2033_p N_noxref_10_c_3692_n ) capacitor c=0.0014195f \
 //x=24.54 //y=2.26 //x2=25.28 //y2=3.35
cc_1521 ( N_noxref_5_c_2092_p N_noxref_10_c_3692_n ) capacitor c=0.0026292f \
 //x=24.54 //y=2.095 //x2=25.28 //y2=3.35
cc_1522 ( N_noxref_5_c_1858_n N_noxref_10_c_3693_n ) capacitor c=0.0148501f \
 //x=24.54 //y=4.735 //x2=25.28 //y2=3.67
cc_1523 ( N_noxref_5_c_1858_n N_noxref_10_c_3702_n ) capacitor c=0.0623903f \
 //x=24.54 //y=4.735 //x2=25.28 //y2=5.295
cc_1524 ( N_noxref_5_c_2020_p N_noxref_10_c_3702_n ) capacitor c=7.76118e-19 \
 //x=24.57 //y=4.88 //x2=25.28 //y2=5.295
cc_1525 ( N_noxref_5_c_2105_p N_noxref_10_c_3702_n ) capacitor c=0.00818335f \
 //x=24.945 //y=4.97 //x2=25.28 //y2=5.295
cc_1526 ( N_noxref_5_c_2021_p N_noxref_10_c_3702_n ) capacitor c=0.00142201f \
 //x=24.57 //y=4.88 //x2=25.28 //y2=5.295
cc_1527 ( N_noxref_5_c_1858_n N_noxref_10_c_3703_n ) capacitor c=0.00226199f \
 //x=24.54 //y=4.735 //x2=26.76 //y2=3.35
cc_1528 ( N_noxref_5_c_1858_n N_noxref_10_c_3705_n ) capacitor c=0.00225537f \
 //x=24.54 //y=4.735 //x2=26.76 //y2=4.76
cc_1529 ( N_noxref_5_M47_noxref_g N_noxref_10_c_3739_n ) capacitor \
 c=0.00192712f //x=24.58 //y=6.2 //x2=24.8 //y2=5.38
cc_1530 ( N_noxref_5_M48_noxref_g N_noxref_10_c_3739_n ) capacitor \
 c=0.00291595f //x=25.02 //y=6.2 //x2=24.8 //y2=5.38
cc_1531 ( N_noxref_5_c_2105_p N_noxref_10_c_3739_n ) capacitor c=0.0020909f \
 //x=24.945 //y=4.97 //x2=24.8 //y2=5.38
cc_1532 ( N_noxref_5_c_2067_p N_noxref_10_c_3695_n ) capacitor c=0.00120406f \
 //x=24.575 //y=1.085 //x2=24.84 //y2=1.18
cc_1533 ( N_noxref_5_c_2069_p N_noxref_10_c_3695_n ) capacitor c=0.00218558f \
 //x=24.575 //y=1.43 //x2=24.84 //y2=1.18
cc_1534 ( N_noxref_5_c_2114_p N_noxref_10_c_3695_n ) capacitor c=5.50523e-19 \
 //x=24.95 //y=0.93 //x2=24.84 //y2=1.18
cc_1535 ( N_noxref_5_c_2090_p N_noxref_10_c_3695_n ) capacitor c=5.67071e-19 \
 //x=24.95 //y=1.585 //x2=24.84 //y2=1.18
cc_1536 ( N_noxref_5_c_2076_p N_noxref_10_c_3695_n ) capacitor c=0.00109707f \
 //x=25.105 //y=1.085 //x2=24.84 //y2=1.18
cc_1537 ( N_noxref_5_c_2079_p N_noxref_10_c_3695_n ) capacitor c=0.00312043f \
 //x=25.105 //y=1.43 //x2=24.84 //y2=1.18
cc_1538 ( N_noxref_5_c_1858_n N_noxref_10_c_3748_n ) capacitor c=6.03895e-19 \
 //x=24.54 //y=4.735 //x2=25.28 //y2=3.51
cc_1539 ( N_noxref_5_c_1858_n N_noxref_10_c_3698_n ) capacitor c=0.00687742f \
 //x=24.54 //y=4.735 //x2=25.44 //y2=3.51
cc_1540 ( N_noxref_5_M47_noxref_g N_noxref_10_c_3750_n ) capacitor \
 c=0.0178987f //x=24.58 //y=6.2 //x2=24.8 //y2=5.56
cc_1541 ( N_noxref_5_M48_noxref_g N_noxref_10_c_3750_n ) capacitor \
 c=0.0178506f //x=25.02 //y=6.2 //x2=24.8 //y2=5.56
cc_1542 ( N_noxref_5_c_2105_p N_noxref_10_c_3750_n ) capacitor c=0.00291714f \
 //x=24.945 //y=4.97 //x2=24.8 //y2=5.56
cc_1543 ( N_noxref_5_c_2067_p N_noxref_10_M13_noxref_d ) capacitor \
 c=0.00137165f //x=24.575 //y=1.085 //x2=24.65 //y2=1.085
cc_1544 ( N_noxref_5_c_2069_p N_noxref_10_M13_noxref_d ) capacitor \
 c=0.00237422f //x=24.575 //y=1.43 //x2=24.65 //y2=1.085
cc_1545 ( N_noxref_5_c_2114_p N_noxref_10_M13_noxref_d ) capacitor \
 c=0.0020782f //x=24.95 //y=0.93 //x2=24.65 //y2=1.085
cc_1546 ( N_noxref_5_c_2090_p N_noxref_10_M13_noxref_d ) capacitor \
 c=0.00356097f //x=24.95 //y=1.585 //x2=24.65 //y2=1.085
cc_1547 ( N_noxref_5_c_2076_p N_noxref_10_M13_noxref_d ) capacitor \
 c=8.50095e-19 //x=25.105 //y=1.085 //x2=24.65 //y2=1.085
cc_1548 ( N_noxref_5_c_2079_p N_noxref_10_M13_noxref_d ) capacitor \
 c=0.00237422f //x=25.105 //y=1.43 //x2=24.65 //y2=1.085
cc_1549 ( N_noxref_5_c_1727_n N_VDD_c_5169_n ) capacitor c=0.00189842f \
 //x=5.335 //y=5.385 //x2=7.185 //y2=7.585
cc_1550 ( N_noxref_5_c_1629_n N_VDD_c_5169_n ) capacitor c=6.60328e-19 \
 //x=5.42 //y=4.055 //x2=7.185 //y2=7.585
cc_1551 ( N_noxref_5_c_1673_n N_VDD_c_5065_n ) capacitor c=2.88396e-19 \
 //x=8.545 //y=5.385 //x2=14.955 //y2=7.585
cc_1552 ( N_noxref_5_c_1693_n N_VDD_c_5065_n ) capacitor c=2.35309e-19 \
 //x=8.63 //y=4.055 //x2=14.955 //y2=7.585
cc_1553 ( N_noxref_5_c_1638_n N_VDD_c_5065_n ) capacitor c=2.32403e-19 \
 //x=12.33 //y=3.92 //x2=14.955 //y2=7.585
cc_1554 ( N_noxref_5_c_1850_n N_VDD_c_5065_n ) capacitor c=3.15774e-19 \
 //x=12.33 //y=4.41 //x2=14.955 //y2=7.585
cc_1555 ( N_noxref_5_c_1770_n N_VDD_c_5065_n ) capacitor c=2.02991e-19 \
 //x=12.33 //y=4.76 //x2=14.955 //y2=7.585
cc_1556 ( N_noxref_5_c_1884_n N_VDD_c_5065_n ) capacitor c=3.40755e-19 \
 //x=12.33 //y=4.88 //x2=14.955 //y2=7.585
cc_1557 ( N_noxref_5_M35_noxref_g N_VDD_c_5177_n ) capacitor c=0.00404722f \
 //x=14.82 //y=6.2 //x2=15.04 //y2=6.7
cc_1558 ( N_noxref_5_M36_noxref_g N_VDD_c_5177_n ) capacitor c=0.00381678f \
 //x=15.26 //y=6.2 //x2=15.04 //y2=6.7
cc_1559 ( N_noxref_5_M35_noxref_g N_VDD_c_5179_n ) capacitor c=0.00543844f \
 //x=14.82 //y=6.2 //x2=15.04 //y2=7.41
cc_1560 ( N_noxref_5_M36_noxref_g N_VDD_c_5179_n ) capacitor c=0.00573531f \
 //x=15.26 //y=6.2 //x2=15.04 //y2=7.41
cc_1561 ( N_noxref_5_c_1727_n N_VDD_c_5001_n ) capacitor c=9.37362e-19 \
 //x=5.335 //y=5.385 //x2=5.87 //y2=7.585
cc_1562 ( N_noxref_5_c_1798_n N_VDD_c_5001_n ) capacitor c=0.00509706f \
 //x=4.82 //y=5.555 //x2=5.87 //y2=7.585
cc_1563 ( N_noxref_5_c_1712_n N_VDD_c_5047_n ) capacitor c=0.00472214f \
 //x=8.15 //y=5.555 //x2=9.2 //y2=7.585
cc_1564 ( N_noxref_5_c_1850_n N_VDD_c_5184_n ) capacitor c=2.90014e-19 \
 //x=12.33 //y=4.41 //x2=13.06 //y2=7.585
cc_1565 ( N_noxref_5_M33_noxref_g N_VDD_c_5184_n ) capacitor c=0.00753931f \
 //x=12.485 //y=6.2 //x2=13.06 //y2=7.585
cc_1566 ( N_noxref_5_M34_noxref_g N_VDD_c_5184_n ) capacitor c=0.00755544f \
 //x=12.925 //y=6.2 //x2=13.06 //y2=7.585
cc_1567 ( N_noxref_5_M35_noxref_g N_VDD_c_5187_n ) capacitor c=0.00750537f \
 //x=14.82 //y=6.2 //x2=16.97 //y2=7.585
cc_1568 ( N_noxref_5_M36_noxref_g N_VDD_c_5187_n ) capacitor c=0.00773472f \
 //x=15.26 //y=6.2 //x2=16.97 //y2=7.585
cc_1569 ( N_noxref_5_M47_noxref_g N_VDD_c_5189_n ) capacitor c=0.00697352f \
 //x=24.58 //y=6.2 //x2=25.155 //y2=7.585
cc_1570 ( N_noxref_5_M48_noxref_g N_VDD_c_5189_n ) capacitor c=0.00755544f \
 //x=25.02 //y=6.2 //x2=25.155 //y2=7.585
cc_1571 ( N_noxref_5_c_1630_n N_VDD_c_5012_n ) capacitor c=0.00127493f \
 //x=5.42 //y=5.3 //x2=2.71 //y2=7.585
cc_1572 ( N_noxref_5_c_1630_n N_VDD_c_5056_n ) capacitor c=0.0340468f //x=5.42 \
 //y=5.3 //x2=6.04 //y2=7.585
cc_1573 ( N_noxref_5_c_1697_n N_VDD_c_5056_n ) capacitor c=0.00124961f \
 //x=8.63 //y=5.3 //x2=6.04 //y2=7.585
cc_1574 ( N_noxref_5_c_1701_n N_VDD_c_5056_n ) capacitor c=0.00269155f \
 //x=4.82 //y=5.385 //x2=6.04 //y2=7.585
cc_1575 ( N_noxref_5_c_1798_n N_VDD_c_5056_n ) capacitor c=0.0091804f //x=4.82 \
 //y=5.555 //x2=6.04 //y2=7.585
cc_1576 ( N_noxref_5_c_1697_n N_VDD_c_5057_n ) capacitor c=0.0251234f //x=8.63 \
 //y=5.3 //x2=9.37 //y2=7.585
cc_1577 ( N_noxref_5_c_1702_n N_VDD_c_5057_n ) capacitor c=0.00261447f \
 //x=8.15 //y=5.385 //x2=9.37 //y2=7.585
cc_1578 ( N_noxref_5_c_1712_n N_VDD_c_5057_n ) capacitor c=0.00920443f \
 //x=8.15 //y=5.555 //x2=9.37 //y2=7.585
cc_1579 ( N_noxref_5_c_1850_n N_VDD_c_5083_n ) capacitor c=0.00158408f \
 //x=12.33 //y=4.41 //x2=11.59 //y2=7.585
cc_1580 ( N_noxref_5_c_1770_n N_VDD_c_5083_n ) capacitor c=0.0109198f \
 //x=12.33 //y=4.76 //x2=11.59 //y2=7.585
cc_1581 ( N_noxref_5_c_1780_n N_VDD_c_5083_n ) capacitor c=0.00480807f \
 //x=12.33 //y=4.25 //x2=11.59 //y2=7.585
cc_1582 ( N_noxref_5_c_1646_n N_VDD_c_5083_n ) capacitor c=0.00480093f \
 //x=11.765 //y=3.842 //x2=11.59 //y2=7.585
cc_1583 ( N_noxref_5_c_1884_n N_VDD_c_5083_n ) capacitor c=0.00878438f \
 //x=12.33 //y=4.88 //x2=11.59 //y2=7.585
cc_1584 ( N_noxref_5_M33_noxref_g N_VDD_c_5083_n ) capacitor c=0.00628055f \
 //x=12.485 //y=6.2 //x2=11.59 //y2=7.585
cc_1585 ( N_noxref_5_c_1886_n N_VDD_c_5083_n ) capacitor c=0.00786559f \
 //x=12.56 //y=4.97 //x2=11.59 //y2=7.585
cc_1586 ( N_noxref_5_c_1856_n N_VDD_c_5131_n ) capacitor c=0.00129292f \
 //x=14.92 //y=4.415 //x2=13.81 //y2=7.585
cc_1587 ( N_noxref_5_c_1857_n N_VDD_c_5131_n ) capacitor c=0.00823813f \
 //x=14.92 //y=4.765 //x2=13.81 //y2=7.585
cc_1588 ( N_noxref_5_c_1780_n N_VDD_c_5131_n ) capacitor c=0.00133334f \
 //x=12.33 //y=4.25 //x2=13.81 //y2=7.585
cc_1589 ( N_noxref_5_c_1987_p N_VDD_c_5131_n ) capacitor c=0.00247452f \
 //x=14.92 //y=4.25 //x2=13.81 //y2=7.585
cc_1590 ( N_noxref_5_c_1649_n N_VDD_c_5131_n ) capacitor c=0.010534f \
 //x=14.755 //y=4.255 //x2=13.81 //y2=7.585
cc_1591 ( N_noxref_5_c_1884_n N_VDD_c_5131_n ) capacitor c=0.00209414f \
 //x=12.33 //y=4.88 //x2=13.81 //y2=7.585
cc_1592 ( N_noxref_5_c_1885_n N_VDD_c_5131_n ) capacitor c=0.00354184f \
 //x=14.92 //y=4.88 //x2=13.81 //y2=7.585
cc_1593 ( N_noxref_5_c_1912_p N_VDD_c_5131_n ) capacitor c=0.00805559f \
 //x=12.85 //y=4.97 //x2=13.81 //y2=7.585
cc_1594 ( N_noxref_5_c_1886_n N_VDD_c_5131_n ) capacitor c=2.63786e-19 \
 //x=12.56 //y=4.97 //x2=13.81 //y2=7.585
cc_1595 ( N_noxref_5_c_1991_p N_VDD_c_5131_n ) capacitor c=0.015795f //x=14.92 \
 //y=4.88 //x2=13.81 //y2=7.585
cc_1596 ( N_noxref_5_c_1644_n N_VDD_c_5137_n ) capacitor c=0.00160831f \
 //x=19.56 //y=2.37 //x2=22.69 //y2=7.585
cc_1597 ( N_noxref_5_c_2020_p N_VDD_c_5139_n ) capacitor c=0.00204366f \
 //x=24.57 //y=4.88 //x2=26.02 //y2=7.585
cc_1598 ( N_noxref_5_c_2105_p N_VDD_c_5139_n ) capacitor c=0.012589f \
 //x=24.945 //y=4.97 //x2=26.02 //y2=7.585
cc_1599 ( N_noxref_5_c_2021_p N_VDD_c_5139_n ) capacitor c=2.73429e-19 \
 //x=24.57 //y=4.88 //x2=26.02 //y2=7.585
cc_1600 ( N_noxref_5_c_1701_n N_VDD_M22_noxref_d ) capacitor c=2.46246e-19 \
 //x=4.82 //y=5.385 //x2=1.9 //y2=5.2
cc_1601 ( N_noxref_5_c_1798_n N_VDD_M23_noxref_d ) capacitor c=0.00464138f \
 //x=4.82 //y=5.555 //x2=3.795 //y2=5.2
cc_1602 ( N_noxref_5_c_1712_n N_VDD_M27_noxref_d ) capacitor c=0.00464146f \
 //x=8.15 //y=5.555 //x2=7.125 //y2=5.2
cc_1603 ( N_noxref_5_c_1673_n N_VDD_M31_noxref_s ) capacitor c=0.0032599f \
 //x=8.545 //y=5.385 //x2=9.91 //y2=5.2
cc_1604 ( N_noxref_5_c_1702_n N_VDD_M31_noxref_s ) capacitor c=0.0057075f \
 //x=8.15 //y=5.385 //x2=9.91 //y2=5.2
cc_1605 ( N_noxref_5_c_1638_n N_VDD_M33_noxref_s ) capacitor c=2.74932e-19 \
 //x=12.33 //y=3.92 //x2=12.13 //y2=5.2
cc_1606 ( N_noxref_5_c_1850_n N_VDD_M33_noxref_s ) capacitor c=0.00171932f \
 //x=12.33 //y=4.41 //x2=12.13 //y2=5.2
cc_1607 ( N_noxref_5_c_1770_n N_VDD_M33_noxref_s ) capacitor c=0.0180752f \
 //x=12.33 //y=4.76 //x2=12.13 //y2=5.2
cc_1608 ( N_noxref_5_c_1884_n N_VDD_M33_noxref_s ) capacitor c=0.00986169f \
 //x=12.33 //y=4.88 //x2=12.13 //y2=5.2
cc_1609 ( N_noxref_5_M33_noxref_g N_VDD_M33_noxref_s ) capacitor c=0.0573441f \
 //x=12.485 //y=6.2 //x2=12.13 //y2=5.2
cc_1610 ( N_noxref_5_c_1886_n N_VDD_M33_noxref_s ) capacitor c=0.00531638f \
 //x=12.56 //y=4.97 //x2=12.13 //y2=5.2
cc_1611 ( N_noxref_5_M34_noxref_g N_VDD_M34_noxref_d ) capacitor c=0.0572684f \
 //x=12.925 //y=6.2 //x2=13 //y2=5.2
cc_1612 ( N_noxref_5_c_1885_n N_VDD_M35_noxref_d ) capacitor c=0.0013074f \
 //x=14.92 //y=4.88 //x2=14.895 //y2=5.2
cc_1613 ( N_noxref_5_M35_noxref_g N_VDD_M35_noxref_d ) capacitor c=0.00896756f \
 //x=14.82 //y=6.2 //x2=14.895 //y2=5.2
cc_1614 ( N_noxref_5_M36_noxref_g N_VDD_M35_noxref_d ) capacitor c=0.00896756f \
 //x=15.26 //y=6.2 //x2=14.895 //y2=5.2
cc_1615 ( N_noxref_5_c_1991_p N_VDD_M35_noxref_d ) capacitor c=0.00329802f \
 //x=14.92 //y=4.88 //x2=14.895 //y2=5.2
cc_1616 ( N_noxref_5_M47_noxref_g N_VDD_M46_noxref_d ) capacitor c=0.015318f \
 //x=24.58 //y=6.2 //x2=24.215 //y2=5.2
cc_1617 ( N_noxref_5_c_2021_p N_VDD_M46_noxref_d ) capacitor c=3.32552e-19 \
 //x=24.57 //y=4.88 //x2=24.215 //y2=5.2
cc_1618 ( N_noxref_5_M48_noxref_g N_VDD_M48_noxref_d ) capacitor c=0.0430452f \
 //x=25.02 //y=6.2 //x2=25.095 //y2=5.2
cc_1619 ( N_noxref_5_c_1727_n N_noxref_16_c_5819_n ) capacitor c=0.00325084f \
 //x=5.335 //y=5.385 //x2=5.145 //y2=7.085
cc_1620 ( N_noxref_5_c_1701_n N_noxref_16_c_5819_n ) capacitor c=0.00483367f \
 //x=4.82 //y=5.385 //x2=5.145 //y2=7.085
cc_1621 ( N_noxref_5_c_1798_n N_noxref_16_c_5819_n ) capacitor c=0.00407104f \
 //x=4.82 //y=5.555 //x2=5.145 //y2=7.085
cc_1622 ( N_noxref_5_c_1701_n N_noxref_16_c_5809_n ) capacitor c=6.22227e-19 \
 //x=4.82 //y=5.385 //x2=3.507 //y2=5.385
cc_1623 ( N_noxref_5_c_1701_n N_noxref_16_c_5812_n ) capacitor c=0.0507834f \
 //x=4.82 //y=5.385 //x2=4.38 //y2=5.385
cc_1624 ( N_noxref_5_c_1798_n N_noxref_16_c_5812_n ) capacitor c=0.00270385f \
 //x=4.82 //y=5.555 //x2=4.38 //y2=5.385
cc_1625 ( N_noxref_5_c_1727_n N_noxref_16_c_5823_n ) capacitor c=0.00501306f \
 //x=5.335 //y=5.385 //x2=5.26 //y2=6.915
cc_1626 ( N_noxref_5_c_1701_n N_noxref_16_c_5816_n ) capacitor c=0.00261471f \
 //x=4.82 //y=5.385 //x2=4.38 //y2=5.555
cc_1627 ( N_noxref_5_c_1798_n N_noxref_16_c_5816_n ) capacitor c=0.0673924f \
 //x=4.82 //y=5.555 //x2=4.38 //y2=5.555
cc_1628 ( N_noxref_5_c_1727_n N_noxref_16_M26_noxref_d ) capacitor \
 c=0.00704645f //x=5.335 //y=5.385 //x2=5.115 //y2=5.2
cc_1629 ( N_noxref_5_c_1798_n N_noxref_16_M26_noxref_d ) capacitor \
 c=0.0472015f //x=4.82 //y=5.555 //x2=5.115 //y2=5.2
cc_1630 ( N_noxref_5_c_1673_n N_noxref_17_c_5882_n ) capacitor c=0.00314935f \
 //x=8.545 //y=5.385 //x2=8.47 //y2=7.085
cc_1631 ( N_noxref_5_c_1702_n N_noxref_17_c_5882_n ) capacitor c=0.00482905f \
 //x=8.15 //y=5.385 //x2=8.47 //y2=7.085
cc_1632 ( N_noxref_5_c_1712_n N_noxref_17_c_5882_n ) capacitor c=0.00407104f \
 //x=8.15 //y=5.555 //x2=8.47 //y2=7.085
cc_1633 ( N_noxref_5_c_1727_n N_noxref_17_c_5889_n ) capacitor c=0.00476373f \
 //x=5.335 //y=5.385 //x2=6.83 //y2=5.385
cc_1634 ( N_noxref_5_c_1701_n N_noxref_17_c_5889_n ) capacitor c=0.00509041f \
 //x=4.82 //y=5.385 //x2=6.83 //y2=5.385
cc_1635 ( N_noxref_5_c_1702_n N_noxref_17_c_5889_n ) capacitor c=6.06937e-19 \
 //x=8.15 //y=5.385 //x2=6.83 //y2=5.385
cc_1636 ( N_noxref_5_c_1702_n N_noxref_17_c_5884_n ) capacitor c=0.0501053f \
 //x=8.15 //y=5.385 //x2=7.71 //y2=5.385
cc_1637 ( N_noxref_5_c_1712_n N_noxref_17_c_5884_n ) capacitor c=0.0026584f \
 //x=8.15 //y=5.555 //x2=7.71 //y2=5.385
cc_1638 ( N_noxref_5_c_1673_n N_noxref_17_c_5886_n ) capacitor c=0.00500806f \
 //x=8.545 //y=5.385 //x2=8.59 //y2=6.915
cc_1639 ( N_noxref_5_c_1702_n N_noxref_17_c_5887_n ) capacitor c=0.00266093f \
 //x=8.15 //y=5.385 //x2=7.71 //y2=5.555
cc_1640 ( N_noxref_5_c_1712_n N_noxref_17_c_5887_n ) capacitor c=0.0674619f \
 //x=8.15 //y=5.555 //x2=7.71 //y2=5.555
cc_1641 ( N_noxref_5_c_1673_n N_noxref_17_M30_noxref_d ) capacitor \
 c=0.00776833f //x=8.545 //y=5.385 //x2=8.445 //y2=5.2
cc_1642 ( N_noxref_5_c_1707_n N_noxref_17_M30_noxref_d ) capacitor \
 c=0.0012136f //x=8.63 //y=3.88 //x2=8.445 //y2=5.2
cc_1643 ( N_noxref_5_c_1712_n N_noxref_17_M30_noxref_d ) capacitor \
 c=0.0473277f //x=8.15 //y=5.555 //x2=8.445 //y2=5.2
cc_1644 ( N_noxref_5_c_1856_n N_noxref_18_c_5963_n ) capacitor c=0.00148651f \
 //x=14.92 //y=4.415 //x2=15.36 //y2=5.385
cc_1645 ( N_noxref_5_c_1857_n N_noxref_18_c_5963_n ) capacitor c=0.0168605f \
 //x=14.92 //y=4.765 //x2=15.36 //y2=5.385
cc_1646 ( N_noxref_5_c_1885_n N_noxref_18_c_5963_n ) capacitor c=0.00412201f \
 //x=14.92 //y=4.88 //x2=15.36 //y2=5.385
cc_1647 ( N_noxref_5_M35_noxref_g N_noxref_18_c_5963_n ) capacitor \
 c=0.0108618f //x=14.82 //y=6.2 //x2=15.36 //y2=5.385
cc_1648 ( N_noxref_5_M36_noxref_g N_noxref_18_c_5963_n ) capacitor \
 c=0.00879139f //x=15.26 //y=6.2 //x2=15.36 //y2=5.385
cc_1649 ( N_noxref_5_c_1991_p N_noxref_18_c_5963_n ) capacitor c=0.00186066f \
 //x=14.92 //y=4.88 //x2=15.36 //y2=5.385
cc_1650 ( N_noxref_5_c_1856_n N_noxref_18_c_5961_n ) capacitor c=0.00194243f \
 //x=14.92 //y=4.415 //x2=14.607 //y2=5.385
cc_1651 ( N_noxref_5_M35_noxref_g N_noxref_18_c_5961_n ) capacitor \
 c=0.00402951f //x=14.82 //y=6.2 //x2=14.607 //y2=5.385
cc_1652 ( N_noxref_5_M36_noxref_g N_noxref_18_c_5962_n ) capacitor \
 c=0.00178158f //x=15.26 //y=6.2 //x2=15.48 //y2=5.385
cc_1653 ( N_noxref_5_M36_noxref_g N_noxref_18_c_5972_n ) capacitor \
 c=0.00182026f //x=15.26 //y=6.2 //x2=15.48 //y2=6.915
cc_1654 ( N_noxref_5_c_1856_n N_noxref_18_c_5973_n ) capacitor c=3.5629e-19 \
 //x=14.92 //y=4.415 //x2=14.6 //y2=5.555
cc_1655 ( N_noxref_5_M35_noxref_g N_noxref_18_c_5973_n ) capacitor \
 c=0.0467484f //x=14.82 //y=6.2 //x2=14.6 //y2=5.555
cc_1656 ( N_noxref_5_M36_noxref_g N_noxref_18_c_5975_n ) capacitor \
 c=0.0184757f //x=15.26 //y=6.2 //x2=15.48 //y2=5.555
cc_1657 ( N_noxref_5_M35_noxref_g N_noxref_18_M35_noxref_s ) capacitor \
 c=0.0057176f //x=14.82 //y=6.2 //x2=14.465 //y2=5.2
cc_1658 ( N_noxref_5_c_1624_n N_GND_c_6127_n ) capacitor c=0.0136681f //x=4.86 \
 //y=1.305 //x2=3.89 //y2=1.025
cc_1659 ( N_noxref_5_M2_noxref_d N_GND_c_6127_n ) capacitor c=5.48773e-19 \
 //x=4.67 //y=1.09 //x2=3.89 //y2=1.025
cc_1660 ( N_noxref_5_c_1624_n N_GND_c_6137_n ) capacitor c=0.00890018f \
 //x=4.86 //y=1.305 //x2=7.135 //y2=0.175
cc_1661 ( N_noxref_5_c_1733_n N_GND_c_6137_n ) capacitor c=0.00870172f \
 //x=5.335 //y=1.835 //x2=7.135 //y2=0.175
cc_1662 ( N_noxref_5_c_1629_n N_GND_c_6137_n ) capacitor c=7.35675e-19 \
 //x=5.42 //y=4.055 //x2=7.135 //y2=0.175
cc_1663 ( N_noxref_5_M2_noxref_d N_GND_c_6137_n ) capacitor c=2.98166e-19 \
 //x=4.67 //y=1.09 //x2=7.135 //y2=0.175
cc_1664 ( N_noxref_5_c_1624_n N_GND_c_6138_n ) capacitor c=0.00519351f \
 //x=4.86 //y=1.305 //x2=7.22 //y2=1.025
cc_1665 ( N_noxref_5_c_1634_n N_GND_c_6138_n ) capacitor c=0.0136059f //x=8.19 \
 //y=1.3 //x2=7.22 //y2=1.025
cc_1666 ( N_noxref_5_M4_noxref_d N_GND_c_6138_n ) capacitor c=5.45329e-19 \
 //x=8 //y=1.09 //x2=7.22 //y2=1.025
cc_1667 ( N_noxref_5_c_1634_n N_GND_c_6139_n ) capacitor c=0.00877894f \
 //x=8.19 //y=1.3 //x2=14.905 //y2=0.175
cc_1668 ( N_noxref_5_c_1676_n N_GND_c_6139_n ) capacitor c=0.00686142f \
 //x=8.545 //y=1.835 //x2=14.905 //y2=0.175
cc_1669 ( N_noxref_5_c_1637_n N_GND_c_6139_n ) capacitor c=9.29428e-19 \
 //x=12.33 //y=2.575 //x2=14.905 //y2=0.175
cc_1670 ( N_noxref_5_c_1638_n N_GND_c_6139_n ) capacitor c=6.36013e-19 \
 //x=12.33 //y=3.92 //x2=14.905 //y2=0.175
cc_1671 ( N_noxref_5_c_1920_p N_GND_c_6139_n ) capacitor c=7.5371e-19 \
 //x=12.33 //y=2.265 //x2=14.905 //y2=0.175
cc_1672 ( N_noxref_5_M4_noxref_d N_GND_c_6139_n ) capacitor c=2.98166e-19 \
 //x=8 //y=1.09 //x2=14.905 //y2=0.175
cc_1673 ( N_noxref_5_c_1639_n N_GND_c_6140_n ) capacitor c=0.00274892f \
 //x=14.92 //y=2.42 //x2=14.99 //y2=1.025
cc_1674 ( N_noxref_5_c_2024_p N_GND_c_6140_n ) capacitor c=4.20185e-19 \
 //x=14.92 //y=2.265 //x2=14.99 //y2=1.025
cc_1675 ( N_noxref_5_c_2054_p N_GND_c_6140_n ) capacitor c=0.00146326f \
 //x=14.725 //y=1.05 //x2=14.99 //y2=1.025
cc_1676 ( N_noxref_5_c_2055_p N_GND_c_6140_n ) capacitor c=0.00305617f \
 //x=14.725 //y=1.395 //x2=14.99 //y2=1.025
cc_1677 ( N_noxref_5_c_2257_p N_GND_c_6140_n ) capacitor c=0.00943115f \
 //x=15.1 //y=0.895 //x2=14.99 //y2=1.025
cc_1678 ( N_noxref_5_c_2258_p N_GND_c_6140_n ) capacitor c=6.13264e-19 \
 //x=15.1 //y=1.55 //x2=14.99 //y2=1.025
cc_1679 ( N_noxref_5_c_2056_p N_GND_c_6140_n ) capacitor c=0.00176231f \
 //x=15.255 //y=1.05 //x2=14.99 //y2=1.025
cc_1680 ( N_noxref_5_c_2058_p N_GND_c_6140_n ) capacitor c=0.00234543f \
 //x=15.255 //y=1.395 //x2=14.99 //y2=1.025
cc_1681 ( N_noxref_5_c_1640_n N_GND_c_6144_n ) capacitor c=7.35495e-19 \
 //x=24.54 //y=2.575 //x2=29.335 //y2=0.175
cc_1682 ( N_noxref_5_c_1733_n N_GND_c_6155_n ) capacitor c=0.001371f //x=5.335 \
 //y=1.835 //x2=5.87 //y2=0.175
cc_1683 ( N_noxref_5_c_1676_n N_GND_c_6248_n ) capacitor c=7.81285e-19 \
 //x=8.545 //y=1.835 //x2=9.2 //y2=0.175
cc_1684 ( N_noxref_5_c_1637_n N_GND_c_6157_n ) capacitor c=0.00153582f \
 //x=12.33 //y=2.575 //x2=12.615 //y2=0.715
cc_1685 ( N_noxref_5_c_1920_p N_GND_c_6157_n ) capacitor c=3.95714e-19 \
 //x=12.33 //y=2.265 //x2=12.615 //y2=0.715
cc_1686 ( N_noxref_5_c_1949_p N_GND_c_6157_n ) capacitor c=0.0126466f \
 //x=12.44 //y=1.09 //x2=12.615 //y2=0.715
cc_1687 ( N_noxref_5_c_1887_n N_GND_c_6157_n ) capacitor c=2.1838e-19 \
 //x=12.33 //y=2.265 //x2=12.615 //y2=0.715
cc_1688 ( N_noxref_5_c_1953_p N_GND_c_6359_n ) capacitor c=0.0131144f \
 //x=12.97 //y=1.09 //x2=13.105 //y2=0.715
cc_1689 ( N_noxref_5_c_2054_p N_GND_c_6360_n ) capacitor c=0.00684005f \
 //x=14.725 //y=1.05 //x2=16.97 //y2=0.175
cc_1690 ( N_noxref_5_c_1640_n N_GND_c_6361_n ) capacitor c=2.44898e-19 \
 //x=24.54 //y=2.575 //x2=25.85 //y2=0.175
cc_1691 ( N_noxref_5_c_1626_n N_GND_c_6166_n ) capacitor c=4.97832e-19 \
 //x=5.42 //y=3.735 //x2=2.71 //y2=0.175
cc_1692 ( N_noxref_5_c_1651_n N_GND_c_6173_n ) capacitor c=0.00289817f \
 //x=4.86 //y=1.75 //x2=6.04 //y2=0.175
cc_1693 ( N_noxref_5_c_1733_n N_GND_c_6173_n ) capacitor c=0.0311093f \
 //x=5.335 //y=1.835 //x2=6.04 //y2=0.175
cc_1694 ( N_noxref_5_c_1636_n N_GND_c_6173_n ) capacitor c=2.24186e-19 \
 //x=8.63 //y=3.735 //x2=6.04 //y2=0.175
cc_1695 ( N_noxref_5_c_1668_n N_GND_c_6175_n ) capacitor c=0.00262965f \
 //x=8.19 //y=1.75 //x2=9.37 //y2=0.175
cc_1696 ( N_noxref_5_c_1676_n N_GND_c_6175_n ) capacitor c=0.0225468f \
 //x=8.545 //y=1.835 //x2=9.37 //y2=0.175
cc_1697 ( N_noxref_5_c_1637_n N_GND_c_6176_n ) capacitor c=0.00840609f \
 //x=12.33 //y=2.575 //x2=11.59 //y2=0.175
cc_1698 ( N_noxref_5_c_1768_n N_GND_c_6176_n ) capacitor c=0.00626739f \
 //x=12.33 //y=3.6 //x2=11.59 //y2=0.175
cc_1699 ( N_noxref_5_c_1646_n N_GND_c_6176_n ) capacitor c=0.00334341f \
 //x=11.765 //y=3.842 //x2=11.59 //y2=0.175
cc_1700 ( N_noxref_5_c_1920_p N_GND_c_6176_n ) capacitor c=0.00731874f \
 //x=12.33 //y=2.265 //x2=11.59 //y2=0.175
cc_1701 ( N_noxref_5_c_1900_p N_GND_c_6176_n ) capacitor c=0.00310608f \
 //x=12.44 //y=2.1 //x2=11.59 //y2=0.175
cc_1702 ( N_noxref_5_c_1887_n N_GND_c_6176_n ) capacitor c=0.00697721f \
 //x=12.33 //y=2.265 //x2=11.59 //y2=0.175
cc_1703 ( N_noxref_5_c_1639_n N_GND_c_6177_n ) capacitor c=0.00347336f \
 //x=14.92 //y=2.42 //x2=13.81 //y2=0.175
cc_1704 ( N_noxref_5_c_1916_p N_GND_c_6177_n ) capacitor c=0.00641166f \
 //x=14.92 //y=4.095 //x2=13.81 //y2=0.175
cc_1705 ( N_noxref_5_c_1642_n N_GND_c_6177_n ) capacitor c=3.88581e-19 \
 //x=13.285 //y=2.385 //x2=13.81 //y2=0.175
cc_1706 ( N_noxref_5_c_1643_n N_GND_c_6177_n ) capacitor c=0.0135922f \
 //x=18.96 //y=2.4 //x2=13.81 //y2=0.175
cc_1707 ( N_noxref_5_c_1649_n N_GND_c_6177_n ) capacitor c=0.00224398f \
 //x=14.755 //y=4.255 //x2=13.81 //y2=0.175
cc_1708 ( N_noxref_5_c_1920_p N_GND_c_6177_n ) capacitor c=0.00199543f \
 //x=12.33 //y=2.265 //x2=13.81 //y2=0.175
cc_1709 ( N_noxref_5_c_2024_p N_GND_c_6177_n ) capacitor c=0.00353752f \
 //x=14.92 //y=2.265 //x2=13.81 //y2=0.175
cc_1710 ( N_noxref_5_c_2025_p N_GND_c_6177_n ) capacitor c=0.00871837f \
 //x=14.725 //y=2.1 //x2=13.81 //y2=0.175
cc_1711 ( N_noxref_5_c_1887_n N_GND_c_6177_n ) capacitor c=2.63786e-19 \
 //x=12.33 //y=2.265 //x2=13.81 //y2=0.175
cc_1712 ( N_noxref_5_c_1643_n N_GND_c_6178_n ) capacitor c=0.0138369f \
 //x=18.96 //y=2.4 //x2=17.14 //y2=0.175
cc_1713 ( N_noxref_5_c_1644_n N_GND_c_6179_n ) capacitor c=0.0132145f \
 //x=19.56 //y=2.37 //x2=20.47 //y2=0.175
cc_1714 ( N_noxref_5_c_1644_n N_GND_c_6180_n ) capacitor c=0.0146625f \
 //x=19.56 //y=2.37 //x2=22.69 //y2=0.175
cc_1715 ( N_noxref_5_c_2032_p N_GND_c_6181_n ) capacitor c=0.0022444f \
 //x=24.54 //y=2.26 //x2=26.02 //y2=0.175
cc_1716 ( N_noxref_5_c_2079_p N_GND_c_6181_n ) capacitor c=0.00275184f \
 //x=25.105 //y=1.43 //x2=26.02 //y2=0.175
cc_1717 ( N_noxref_5_c_2033_p N_GND_c_6181_n ) capacitor c=2.63786e-19 \
 //x=24.54 //y=2.26 //x2=26.02 //y2=0.175
cc_1718 ( N_noxref_5_c_1624_n N_GND_M1_noxref_d ) capacitor c=5.45409e-19 \
 //x=4.86 //y=1.305 //x2=3.7 //y2=1.05
cc_1719 ( N_noxref_5_c_1634_n N_GND_M3_noxref_d ) capacitor c=5.45329e-19 \
 //x=8.19 //y=1.3 //x2=7.03 //y2=1.05
cc_1720 ( N_noxref_5_c_1637_n N_GND_M6_noxref_s ) capacitor c=0.00427982f \
 //x=12.33 //y=2.575 //x2=12.085 //y2=0.55
cc_1721 ( N_noxref_5_c_1638_n N_GND_M6_noxref_s ) capacitor c=4.72348e-19 \
 //x=12.33 //y=3.92 //x2=12.085 //y2=0.55
cc_1722 ( N_noxref_5_c_1920_p N_GND_M6_noxref_s ) capacitor c=0.00651326f \
 //x=12.33 //y=2.265 //x2=12.085 //y2=0.55
cc_1723 ( N_noxref_5_c_1949_p N_GND_M6_noxref_s ) capacitor c=0.0300238f \
 //x=12.44 //y=1.09 //x2=12.085 //y2=0.55
cc_1724 ( N_noxref_5_c_1899_p N_GND_M6_noxref_s ) capacitor c=0.002132f \
 //x=12.44 //y=1.745 //x2=12.085 //y2=0.55
cc_1725 ( N_noxref_5_c_1900_p N_GND_M6_noxref_s ) capacitor c=0.00304786f \
 //x=12.44 //y=2.1 //x2=12.085 //y2=0.55
cc_1726 ( N_noxref_5_c_1951_p N_GND_M6_noxref_s ) capacitor c=0.00521375f \
 //x=12.815 //y=0.935 //x2=12.085 //y2=0.55
cc_1727 ( N_noxref_5_c_1953_p N_GND_M6_noxref_s ) capacitor c=0.0153553f \
 //x=12.97 //y=1.09 //x2=12.085 //y2=0.55
cc_1728 ( N_noxref_5_c_1902_p N_GND_M6_noxref_s ) capacitor c=0.00629878f \
 //x=12.97 //y=1.435 //x2=12.085 //y2=0.55
cc_1729 ( N_noxref_5_c_1887_n N_GND_M6_noxref_s ) capacitor c=0.00659724f \
 //x=12.33 //y=2.265 //x2=12.085 //y2=0.55
cc_1730 ( N_noxref_5_c_1639_n N_GND_M7_noxref_d ) capacitor c=4.22955e-19 \
 //x=14.92 //y=2.42 //x2=14.8 //y2=1.05
cc_1731 ( N_noxref_5_c_2054_p N_GND_M7_noxref_d ) capacitor c=0.00192399f \
 //x=14.725 //y=1.05 //x2=14.8 //y2=1.05
cc_1732 ( N_noxref_5_c_2055_p N_GND_M7_noxref_d ) capacitor c=0.00210798f \
 //x=14.725 //y=1.395 //x2=14.8 //y2=1.05
cc_1733 ( N_noxref_5_c_2257_p N_GND_M7_noxref_d ) capacitor c=0.00473146f \
 //x=15.1 //y=0.895 //x2=14.8 //y2=1.05
cc_1734 ( N_noxref_5_c_2258_p N_GND_M7_noxref_d ) capacitor c=0.00166857f \
 //x=15.1 //y=1.55 //x2=14.8 //y2=1.05
cc_1735 ( N_noxref_5_c_2056_p N_GND_M7_noxref_d ) capacitor c=0.00230174f \
 //x=15.255 //y=1.05 //x2=14.8 //y2=1.05
cc_1736 ( N_noxref_5_c_2058_p N_GND_M7_noxref_d ) capacitor c=0.00210798f \
 //x=15.255 //y=1.395 //x2=14.8 //y2=1.05
cc_1737 ( N_noxref_5_c_1625_n N_noxref_23_c_7123_n ) capacitor c=0.00898362f \
 //x=4.945 //y=1.835 //x2=4.375 //y2=1.68
cc_1738 ( N_noxref_5_c_1624_n N_noxref_23_c_7125_n ) capacitor c=0.00352617f \
 //x=4.86 //y=1.305 //x2=5.26 //y2=0.715
cc_1739 ( N_noxref_5_c_1733_n N_noxref_23_c_7125_n ) capacitor c=0.00362992f \
 //x=5.335 //y=1.835 //x2=5.26 //y2=0.715
cc_1740 ( N_noxref_5_M2_noxref_d N_noxref_23_c_7125_n ) capacitor \
 c=0.00910163f //x=4.67 //y=1.09 //x2=5.26 //y2=0.715
cc_1741 ( N_noxref_5_c_1624_n N_noxref_23_M1_noxref_s ) capacitor \
 c=0.00888619f //x=4.86 //y=1.305 //x2=3.27 //y2=0.55
cc_1742 ( N_noxref_5_c_1651_n N_noxref_23_M1_noxref_s ) capacitor c=0.0161119f \
 //x=4.86 //y=1.75 //x2=3.27 //y2=0.55
cc_1743 ( N_noxref_5_c_1733_n N_noxref_23_M1_noxref_s ) capacitor \
 c=0.00879038f //x=5.335 //y=1.835 //x2=3.27 //y2=0.55
cc_1744 ( N_noxref_5_c_2324_p N_noxref_23_M1_noxref_s ) capacitor \
 c=4.48997e-19 //x=5.47 //y=3.88 //x2=3.27 //y2=0.55
cc_1745 ( N_noxref_5_M2_noxref_d N_noxref_23_M1_noxref_s ) capacitor \
 c=0.0275562f //x=4.67 //y=1.09 //x2=3.27 //y2=0.55
cc_1746 ( N_noxref_5_c_1635_n N_noxref_24_c_7178_n ) capacitor c=0.00902033f \
 //x=8.275 //y=1.835 //x2=7.705 //y2=1.68
cc_1747 ( N_noxref_5_c_1634_n N_noxref_24_c_7179_n ) capacitor c=0.00340242f \
 //x=8.19 //y=1.3 //x2=8.59 //y2=0.715
cc_1748 ( N_noxref_5_c_1676_n N_noxref_24_c_7179_n ) capacitor c=0.00367965f \
 //x=8.545 //y=1.835 //x2=8.59 //y2=0.715
cc_1749 ( N_noxref_5_M4_noxref_d N_noxref_24_c_7179_n ) capacitor \
 c=0.00910163f //x=8 //y=1.09 //x2=8.59 //y2=0.715
cc_1750 ( N_noxref_5_c_1634_n N_noxref_24_M3_noxref_s ) capacitor \
 c=0.00845391f //x=8.19 //y=1.3 //x2=6.6 //y2=0.55
cc_1751 ( N_noxref_5_c_1668_n N_noxref_24_M3_noxref_s ) capacitor c=0.0157899f \
 //x=8.19 //y=1.75 //x2=6.6 //y2=0.55
cc_1752 ( N_noxref_5_c_1676_n N_noxref_24_M3_noxref_s ) capacitor \
 c=0.00674704f //x=8.545 //y=1.835 //x2=6.6 //y2=0.55
cc_1753 ( N_noxref_5_c_1693_n N_noxref_24_M3_noxref_s ) capacitor \
 c=3.19116e-19 //x=8.63 //y=4.055 //x2=6.6 //y2=0.55
cc_1754 ( N_noxref_5_c_1707_n N_noxref_24_M3_noxref_s ) capacitor \
 c=8.43954e-19 //x=8.63 //y=3.88 //x2=6.6 //y2=0.55
cc_1755 ( N_noxref_5_M4_noxref_d N_noxref_24_M3_noxref_s ) capacitor \
 c=0.0275615f //x=8 //y=1.09 //x2=6.6 //y2=0.55
cc_1756 ( N_noxref_5_c_2025_p N_noxref_25_c_7240_n ) capacitor c=0.00262672f \
 //x=14.725 //y=2.1 //x2=14.505 //y2=1.68
cc_1757 ( N_noxref_5_c_1639_n N_noxref_25_c_7241_n ) capacitor c=0.0055766f \
 //x=14.92 //y=2.42 //x2=15.39 //y2=1.765
cc_1758 ( N_noxref_5_c_1856_n N_noxref_25_c_7241_n ) capacitor c=0.0031725f \
 //x=14.92 //y=4.415 //x2=15.39 //y2=1.765
cc_1759 ( N_noxref_5_c_2024_p N_noxref_25_c_7241_n ) capacitor c=0.00763108f \
 //x=14.92 //y=2.265 //x2=15.39 //y2=1.765
cc_1760 ( N_noxref_5_c_2057_p N_noxref_25_c_7241_n ) capacitor c=0.00697581f \
 //x=14.725 //y=1.705 //x2=15.39 //y2=1.765
cc_1761 ( N_noxref_5_c_2025_p N_noxref_25_c_7241_n ) capacitor c=0.0167383f \
 //x=14.725 //y=2.1 //x2=15.39 //y2=1.765
cc_1762 ( N_noxref_5_c_2258_p N_noxref_25_c_7241_n ) capacitor c=0.00725092f \
 //x=15.1 //y=1.55 //x2=15.39 //y2=1.765
cc_1763 ( N_noxref_5_c_2058_p N_noxref_25_c_7241_n ) capacitor c=0.0034036f \
 //x=15.255 //y=1.395 //x2=15.39 //y2=1.765
cc_1764 ( N_noxref_5_c_2025_p N_noxref_25_c_7242_n ) capacitor c=6.71402e-19 \
 //x=14.725 //y=2.1 //x2=15.475 //y2=1.68
cc_1765 ( N_noxref_5_c_2054_p N_noxref_25_M7_noxref_s ) capacitor c=0.0294925f \
 //x=14.725 //y=1.05 //x2=14.37 //y2=0.55
cc_1766 ( N_noxref_5_c_2057_p N_noxref_25_M7_noxref_s ) capacitor \
 c=3.48408e-19 //x=14.725 //y=1.705 //x2=14.37 //y2=0.55
cc_1767 ( N_noxref_5_c_2056_p N_noxref_25_M7_noxref_s ) capacitor c=0.0125442f \
 //x=15.255 //y=1.05 //x2=14.37 //y2=0.55
cc_1768 ( N_noxref_5_c_1640_n N_noxref_27_c_7367_n ) capacitor c=0.00273736f \
 //x=24.54 //y=2.575 //x2=24.355 //y2=1.675
cc_1769 ( N_noxref_5_c_2070_p N_noxref_27_c_7367_n ) capacitor c=0.00888238f \
 //x=24.575 //y=1.74 //x2=24.355 //y2=1.675
cc_1770 ( N_noxref_5_c_2033_p N_noxref_27_c_7367_n ) capacitor c=0.0017351f \
 //x=24.54 //y=2.26 //x2=24.355 //y2=1.675
cc_1771 ( N_noxref_5_c_1640_n N_noxref_27_c_7368_n ) capacitor c=0.00144955f \
 //x=24.54 //y=2.575 //x2=25.24 //y2=0.71
cc_1772 ( N_noxref_5_c_2032_p N_noxref_27_c_7368_n ) capacitor c=8.82141e-19 \
 //x=24.54 //y=2.26 //x2=25.24 //y2=0.71
cc_1773 ( N_noxref_5_c_2067_p N_noxref_27_c_7368_n ) capacitor c=0.0200738f \
 //x=24.575 //y=1.085 //x2=25.24 //y2=0.71
cc_1774 ( N_noxref_5_c_2076_p N_noxref_27_c_7368_n ) capacitor c=0.00825432f \
 //x=25.105 //y=1.085 //x2=25.24 //y2=0.71
cc_1775 ( N_noxref_5_c_2033_p N_noxref_27_c_7368_n ) capacitor c=2.1838e-19 \
 //x=24.54 //y=2.26 //x2=25.24 //y2=0.71
cc_1776 ( N_noxref_5_c_2067_p N_noxref_27_M12_noxref_s ) capacitor \
 c=0.00888238f //x=24.575 //y=1.085 //x2=23.25 //y2=0.545
cc_1777 ( N_noxref_5_c_2076_p N_noxref_27_M12_noxref_s ) capacitor c=0.015333f \
 //x=25.105 //y=1.085 //x2=23.25 //y2=0.545
cc_1778 ( N_noxref_5_c_2079_p N_noxref_27_M12_noxref_s ) capacitor \
 c=0.00248746f //x=25.105 //y=1.43 //x2=23.25 //y2=0.545
cc_1779 ( N_noxref_6_c_2359_n SUM ) capacitor c=2.55862e-19 //x=12.985 \
 //y=2.02 //x2=16.52 //y2=3.51
cc_1780 ( N_noxref_6_c_2425_n SUM ) capacitor c=0.00174515f //x=19.24 \
 //y=2.915 //x2=16.52 //y2=3.51
cc_1781 ( N_noxref_6_c_2429_n SUM ) capacitor c=3.32328e-19 //x=19.36 \
 //y=2.595 //x2=16.52 //y2=3.51
cc_1782 ( N_noxref_6_c_2364_n SUM ) capacitor c=0.0215834f //x=19.185 \
 //y=2.755 //x2=16.52 //y2=3.51
cc_1783 ( N_noxref_6_c_2366_n SUM ) capacitor c=6.97655e-19 //x=12.705 \
 //y=5.42 //x2=16.52 //y2=4.62
cc_1784 ( N_noxref_6_c_2374_n SUM ) capacitor c=0.00177988f //x=13.07 \
 //y=5.055 //x2=16.52 //y2=4.62
cc_1785 ( N_noxref_6_c_2427_n SUM ) capacitor c=0.00451783f //x=19.24 //y=4.73 \
 //x2=16.52 //y2=4.62
cc_1786 ( N_noxref_6_c_2425_n SUM ) capacitor c=0.0345487f //x=19.24 //y=2.915 \
 //x2=19.73 //y2=2.77
cc_1787 ( N_noxref_6_c_2427_n SUM ) capacitor c=0.0520611f //x=19.24 //y=4.73 \
 //x2=19.73 //y2=2.77
cc_1788 ( N_noxref_6_c_2362_n SUM ) capacitor c=0.0324108f //x=19.36 //y=2.41 \
 //x2=19.73 //y2=2.77
cc_1789 ( N_noxref_6_c_2429_n SUM ) capacitor c=0.0152721f //x=19.36 //y=2.595 \
 //x2=19.73 //y2=2.77
cc_1790 ( N_noxref_6_c_2469_p SUM ) capacitor c=0.00268185f //x=19.36 //y=2.77 \
 //x2=19.73 //y2=2.77
cc_1791 ( N_noxref_6_c_2442_n SUM ) capacitor c=0.0127171f //x=19.345 \
 //y=2.755 //x2=19.73 //y2=2.77
cc_1792 ( N_noxref_6_c_2471_p SUM ) capacitor c=0.00261863f //x=19.36 \
 //y=2.265 //x2=19.73 //y2=2.77
cc_1793 ( N_noxref_6_c_2472_p SUM ) capacitor c=0.00790867f //x=19.025 //y=2.1 \
 //x2=19.73 //y2=2.77
cc_1794 ( N_noxref_6_c_2427_n SUM ) capacitor c=0.00518857f //x=19.24 //y=4.73 \
 //x2=19.73 //y2=3.88
cc_1795 ( N_noxref_6_c_2363_n N_SUM_c_2663_n ) capacitor c=7.0089e-19 //x=12.7 \
 //y=1.185 //x2=15.96 //y2=1.305
cc_1796 ( N_noxref_6_c_2365_n N_SUM_c_2705_n ) capacitor c=0.00496974f \
 //x=12.7 //y=1.935 //x2=15.96 //y2=1.75
cc_1797 ( N_noxref_6_c_2363_n N_SUM_c_2705_n ) capacitor c=3.46581e-19 \
 //x=12.7 //y=1.185 //x2=15.96 //y2=1.75
cc_1798 ( N_noxref_6_c_2427_n N_SUM_c_2686_n ) capacitor c=0.00197512f \
 //x=19.24 //y=4.73 //x2=16.52 //y2=4.055
cc_1799 ( N_noxref_6_c_2425_n N_SUM_c_2665_n ) capacitor c=3.87127e-19 \
 //x=19.24 //y=2.915 //x2=19.29 //y2=1.3
cc_1800 ( N_noxref_6_c_2479_p N_SUM_c_2665_n ) capacitor c=4.13109e-19 \
 //x=19.025 //y=1.09 //x2=19.29 //y2=1.3
cc_1801 ( N_noxref_6_c_2480_p N_SUM_c_2665_n ) capacitor c=0.00213f //x=19.025 \
 //y=1.435 //x2=19.29 //y2=1.3
cc_1802 ( N_noxref_6_c_2481_p N_SUM_c_2665_n ) capacitor c=5.28423e-19 \
 //x=19.4 //y=0.935 //x2=19.29 //y2=1.3
cc_1803 ( N_noxref_6_c_2482_p N_SUM_c_2665_n ) capacitor c=4.49341e-19 \
 //x=19.4 //y=1.59 //x2=19.29 //y2=1.3
cc_1804 ( N_noxref_6_c_2483_p N_SUM_c_2665_n ) capacitor c=4.42805e-19 \
 //x=19.555 //y=1.09 //x2=19.29 //y2=1.3
cc_1805 ( N_noxref_6_c_2484_p N_SUM_c_2665_n ) capacitor c=0.00304778f \
 //x=19.555 //y=1.435 //x2=19.29 //y2=1.3
cc_1806 ( N_noxref_6_c_2480_p N_SUM_c_2715_n ) capacitor c=0.00119008f \
 //x=19.025 //y=1.435 //x2=19.29 //y2=1.75
cc_1807 ( N_noxref_6_c_2486_p N_SUM_c_2715_n ) capacitor c=0.00410123f \
 //x=19.025 //y=1.745 //x2=19.29 //y2=1.75
cc_1808 ( N_noxref_6_c_2472_p N_SUM_c_2715_n ) capacitor c=0.00329274f \
 //x=19.025 //y=2.1 //x2=19.29 //y2=1.75
cc_1809 ( N_noxref_6_c_2482_p N_SUM_c_2715_n ) capacitor c=0.00740116f \
 //x=19.4 //y=1.59 //x2=19.29 //y2=1.75
cc_1810 ( N_noxref_6_c_2484_p N_SUM_c_2715_n ) capacitor c=0.00303393f \
 //x=19.555 //y=1.435 //x2=19.29 //y2=1.75
cc_1811 ( N_noxref_6_c_2376_n N_SUM_c_2720_n ) capacitor c=0.00194388f \
 //x=19.24 //y=4.877 //x2=19.645 //y2=5.385
cc_1812 ( N_noxref_6_c_2491_p N_SUM_c_2720_n ) capacitor c=0.00104675f \
 //x=19.36 //y=4.88 //x2=19.645 //y2=5.385
cc_1813 ( N_noxref_6_M42_noxref_g N_SUM_c_2720_n ) capacitor c=0.00967333f \
 //x=19.47 //y=6.2 //x2=19.645 //y2=5.385
cc_1814 ( N_noxref_6_c_2425_n N_SUM_c_2723_n ) capacitor c=7.11423e-19 \
 //x=19.24 //y=2.915 //x2=19.645 //y2=1.835
cc_1815 ( N_noxref_6_c_2362_n N_SUM_c_2723_n ) capacitor c=0.00261995f \
 //x=19.36 //y=2.41 //x2=19.645 //y2=1.835
cc_1816 ( N_noxref_6_c_2471_p N_SUM_c_2723_n ) capacitor c=0.00147657f \
 //x=19.36 //y=2.265 //x2=19.645 //y2=1.835
cc_1817 ( N_noxref_6_c_2482_p N_SUM_c_2723_n ) capacitor c=0.00124662f \
 //x=19.4 //y=1.59 //x2=19.645 //y2=1.835
cc_1818 ( N_noxref_6_c_2484_p N_SUM_c_2723_n ) capacitor c=0.00300547f \
 //x=19.555 //y=1.435 //x2=19.645 //y2=1.835
cc_1819 ( N_noxref_6_c_2425_n N_SUM_c_2666_n ) capacitor c=0.00102687f \
 //x=19.24 //y=2.915 //x2=19.375 //y2=1.835
cc_1820 ( N_noxref_6_c_2362_n N_SUM_c_2666_n ) capacitor c=0.0198189f \
 //x=19.36 //y=2.41 //x2=19.375 //y2=1.835
cc_1821 ( N_noxref_6_c_2471_p N_SUM_c_2666_n ) capacitor c=0.00408056f \
 //x=19.36 //y=2.265 //x2=19.375 //y2=1.835
cc_1822 ( N_noxref_6_c_2472_p N_SUM_c_2666_n ) capacitor c=0.00189997f \
 //x=19.025 //y=2.1 //x2=19.375 //y2=1.835
cc_1823 ( N_noxref_6_c_2425_n N_SUM_c_2732_n ) capacitor c=0.0011496f \
 //x=19.24 //y=2.915 //x2=19.73 //y2=4.055
cc_1824 ( N_noxref_6_c_2427_n N_SUM_c_2732_n ) capacitor c=0.0328751f \
 //x=19.24 //y=4.73 //x2=19.73 //y2=4.055
cc_1825 ( N_noxref_6_c_2376_n N_SUM_c_2732_n ) capacitor c=2.21717e-19 \
 //x=19.24 //y=4.877 //x2=19.73 //y2=4.055
cc_1826 ( N_noxref_6_c_2505_p N_SUM_c_2732_n ) capacitor c=0.00109921f \
 //x=19.36 //y=4.88 //x2=19.73 //y2=4.055
cc_1827 ( N_noxref_6_c_2427_n N_SUM_c_2671_n ) capacitor c=0.0421585f \
 //x=19.24 //y=4.73 //x2=19.73 //y2=5.3
cc_1828 ( N_noxref_6_c_2376_n N_SUM_c_2671_n ) capacitor c=0.0324593f \
 //x=19.24 //y=4.877 //x2=19.73 //y2=5.3
cc_1829 ( N_noxref_6_c_2491_p N_SUM_c_2671_n ) capacitor c=0.00260989f \
 //x=19.36 //y=4.88 //x2=19.73 //y2=5.3
cc_1830 ( N_noxref_6_c_2505_p N_SUM_c_2671_n ) capacitor c=0.010713f //x=19.36 \
 //y=4.88 //x2=19.73 //y2=5.3
cc_1831 ( N_noxref_6_c_2366_n N_SUM_c_2675_n ) capacitor c=3.86497e-19 \
 //x=12.705 //y=5.42 //x2=15.92 //y2=5.385
cc_1832 ( N_noxref_6_c_2376_n N_SUM_c_2676_n ) capacitor c=0.0231864f \
 //x=19.24 //y=4.877 //x2=19.25 //y2=5.385
cc_1833 ( N_noxref_6_c_2491_p N_SUM_c_2676_n ) capacitor c=0.0039033f \
 //x=19.36 //y=4.88 //x2=19.25 //y2=5.385
cc_1834 ( N_noxref_6_M41_noxref_g N_SUM_c_2676_n ) capacitor c=0.00179079f \
 //x=19.03 //y=6.2 //x2=19.25 //y2=5.385
cc_1835 ( N_noxref_6_M42_noxref_g N_SUM_c_2676_n ) capacitor c=0.00270394f \
 //x=19.47 //y=6.2 //x2=19.25 //y2=5.385
cc_1836 ( N_noxref_6_c_2505_p N_SUM_c_2676_n ) capacitor c=0.00190838f \
 //x=19.36 //y=4.88 //x2=19.25 //y2=5.385
cc_1837 ( N_noxref_6_c_2364_n N_SUM_c_2687_n ) capacitor c=7.7387e-19 \
 //x=19.185 //y=2.755 //x2=16.725 //y2=3.895
cc_1838 ( N_noxref_6_c_2427_n N_SUM_c_2747_n ) capacitor c=0.00368778f \
 //x=19.24 //y=4.73 //x2=19.745 //y2=3.895
cc_1839 ( N_noxref_6_c_2427_n N_SUM_c_2677_n ) capacitor c=0.0208701f \
 //x=19.24 //y=4.73 //x2=19.585 //y2=3.895
cc_1840 ( N_noxref_6_c_2364_n N_SUM_c_2677_n ) capacitor c=0.0049308f \
 //x=19.185 //y=2.755 //x2=19.585 //y2=3.895
cc_1841 ( N_noxref_6_c_2376_n N_SUM_c_2750_n ) capacitor c=0.00350006f \
 //x=19.24 //y=4.877 //x2=19.25 //y2=5.555
cc_1842 ( N_noxref_6_c_2491_p N_SUM_c_2750_n ) capacitor c=0.00414273f \
 //x=19.36 //y=4.88 //x2=19.25 //y2=5.555
cc_1843 ( N_noxref_6_M41_noxref_g N_SUM_c_2750_n ) capacitor c=0.0120591f \
 //x=19.03 //y=6.2 //x2=19.25 //y2=5.555
cc_1844 ( N_noxref_6_M42_noxref_g N_SUM_c_2750_n ) capacitor c=0.0140704f \
 //x=19.47 //y=6.2 //x2=19.25 //y2=5.555
cc_1845 ( N_noxref_6_c_2505_p N_SUM_c_2750_n ) capacitor c=0.0044017f \
 //x=19.36 //y=4.88 //x2=19.25 //y2=5.555
cc_1846 ( N_noxref_6_c_2425_n N_SUM_M10_noxref_d ) capacitor c=2.74358e-19 \
 //x=19.24 //y=2.915 //x2=19.1 //y2=1.09
cc_1847 ( N_noxref_6_c_2362_n N_SUM_M10_noxref_d ) capacitor c=9.49603e-19 \
 //x=19.36 //y=2.41 //x2=19.1 //y2=1.09
cc_1848 ( N_noxref_6_c_2471_p N_SUM_M10_noxref_d ) capacitor c=0.00150031f \
 //x=19.36 //y=2.265 //x2=19.1 //y2=1.09
cc_1849 ( N_noxref_6_c_2479_p N_SUM_M10_noxref_d ) capacitor c=0.00137165f \
 //x=19.025 //y=1.09 //x2=19.1 //y2=1.09
cc_1850 ( N_noxref_6_c_2480_p N_SUM_M10_noxref_d ) capacitor c=0.00237422f \
 //x=19.025 //y=1.435 //x2=19.1 //y2=1.09
cc_1851 ( N_noxref_6_c_2481_p N_SUM_M10_noxref_d ) capacitor c=0.0020782f \
 //x=19.4 //y=0.935 //x2=19.1 //y2=1.09
cc_1852 ( N_noxref_6_c_2482_p N_SUM_M10_noxref_d ) capacitor c=0.00344131f \
 //x=19.4 //y=1.59 //x2=19.1 //y2=1.09
cc_1853 ( N_noxref_6_c_2483_p N_SUM_M10_noxref_d ) capacitor c=8.50094e-19 \
 //x=19.555 //y=1.09 //x2=19.1 //y2=1.09
cc_1854 ( N_noxref_6_c_2484_p N_SUM_M10_noxref_d ) capacitor c=0.00237422f \
 //x=19.555 //y=1.435 //x2=19.1 //y2=1.09
cc_1855 ( N_noxref_6_c_2374_n N_noxref_8_c_2967_n ) capacitor c=4.10384e-19 \
 //x=13.07 //y=5.055 //x2=16.03 //y2=4.765
cc_1856 ( N_noxref_6_c_2362_n N_noxref_8_c_2961_n ) capacitor c=0.00854705f \
 //x=19.36 //y=2.41 //x2=18.25 //y2=2.385
cc_1857 ( N_noxref_6_c_2471_p N_noxref_8_c_2961_n ) capacitor c=3.75556e-19 \
 //x=19.36 //y=2.265 //x2=18.25 //y2=2.385
cc_1858 ( N_noxref_6_c_2472_p N_noxref_8_c_2961_n ) capacitor c=0.00147853f \
 //x=19.025 //y=2.1 //x2=18.25 //y2=2.385
cc_1859 ( N_noxref_6_c_2425_n N_noxref_8_c_2989_n ) capacitor c=0.0214146f \
 //x=19.24 //y=2.915 //x2=18.25 //y2=3.385
cc_1860 ( N_noxref_6_c_2362_n N_noxref_8_c_2989_n ) capacitor c=3.80972e-19 \
 //x=19.36 //y=2.41 //x2=18.25 //y2=3.385
cc_1861 ( N_noxref_6_c_2429_n N_noxref_8_c_2989_n ) capacitor c=0.00398361f \
 //x=19.36 //y=2.595 //x2=18.25 //y2=3.385
cc_1862 ( N_noxref_6_c_2442_n N_noxref_8_c_2989_n ) capacitor c=0.00147011f \
 //x=19.345 //y=2.755 //x2=18.25 //y2=3.385
cc_1863 ( N_noxref_6_c_2364_n N_noxref_8_c_2989_n ) capacitor c=0.024016f \
 //x=19.185 //y=2.755 //x2=18.25 //y2=3.385
cc_1864 ( N_noxref_6_c_2427_n N_noxref_8_c_2962_n ) capacitor c=8.64336e-19 \
 //x=19.24 //y=4.73 //x2=21.21 //y2=3.335
cc_1865 ( N_noxref_6_c_2429_n N_noxref_8_c_2962_n ) capacitor c=8.11758e-19 \
 //x=19.36 //y=2.595 //x2=21.21 //y2=3.335
cc_1866 ( N_noxref_6_c_2427_n N_noxref_8_c_3018_n ) capacitor c=0.00112373f \
 //x=19.24 //y=4.73 //x2=21.21 //y2=4.135
cc_1867 ( N_noxref_6_c_2427_n N_noxref_8_c_2968_n ) capacitor c=6.04659e-19 \
 //x=19.24 //y=4.73 //x2=21.21 //y2=5.055
cc_1868 ( N_noxref_6_c_2427_n N_noxref_8_c_3020_n ) capacitor c=0.0100855f \
 //x=19.24 //y=4.73 //x2=18.25 //y2=3.51
cc_1869 ( N_noxref_6_c_2427_n N_noxref_8_c_3021_n ) capacitor c=0.00284758f \
 //x=19.24 //y=4.73 //x2=18.41 //y2=3.525
cc_1870 ( N_noxref_6_c_2364_n N_noxref_8_c_3021_n ) capacitor c=0.0011786f \
 //x=19.185 //y=2.755 //x2=18.41 //y2=3.525
cc_1871 ( N_noxref_6_c_2427_n N_noxref_8_c_2978_n ) capacitor c=0.0217961f \
 //x=19.24 //y=4.73 //x2=21.055 //y2=4.27
cc_1872 ( N_noxref_6_c_2364_n N_noxref_8_c_2978_n ) capacitor c=0.00109024f \
 //x=19.185 //y=2.755 //x2=21.055 //y2=4.27
cc_1873 ( N_noxref_6_c_2427_n N_noxref_8_c_2996_n ) capacitor c=0.0196397f \
 //x=19.24 //y=4.73 //x2=21.085 //y2=3.495
cc_1874 ( N_noxref_6_c_2364_n N_noxref_8_c_2996_n ) capacitor c=0.0046655f \
 //x=19.185 //y=2.755 //x2=21.085 //y2=3.495
cc_1875 ( N_noxref_6_c_2362_n N_noxref_8_c_3000_n ) capacitor c=5.5616e-19 \
 //x=19.36 //y=2.41 //x2=18.25 //y2=2.265
cc_1876 ( N_noxref_6_c_2471_p N_noxref_8_c_3000_n ) capacitor c=0.00114264f \
 //x=19.36 //y=2.265 //x2=18.25 //y2=2.265
cc_1877 ( N_noxref_6_c_2472_p N_noxref_8_c_3000_n ) capacitor c=0.00214703f \
 //x=19.025 //y=2.1 //x2=18.25 //y2=2.265
cc_1878 ( N_noxref_6_c_2479_p N_noxref_8_c_3030_n ) capacitor c=4.86545e-19 \
 //x=19.025 //y=1.09 //x2=18.055 //y2=1.05
cc_1879 ( N_noxref_6_c_2479_p N_noxref_8_c_3031_n ) capacitor c=0.00152405f \
 //x=19.025 //y=1.09 //x2=18.055 //y2=1.395
cc_1880 ( N_noxref_6_c_2480_p N_noxref_8_c_3032_n ) capacitor c=0.00109982f \
 //x=19.025 //y=1.435 //x2=18.055 //y2=1.705
cc_1881 ( N_noxref_6_c_2486_p N_noxref_8_c_3032_n ) capacitor c=9.58243e-19 \
 //x=19.025 //y=1.745 //x2=18.055 //y2=1.705
cc_1882 ( N_noxref_6_c_2362_n N_noxref_8_c_3034_n ) capacitor c=0.00144544f \
 //x=19.36 //y=2.41 //x2=18.055 //y2=2.1
cc_1883 ( N_noxref_6_c_2471_p N_noxref_8_c_3034_n ) capacitor c=0.00187625f \
 //x=19.36 //y=2.265 //x2=18.055 //y2=2.1
cc_1884 ( N_noxref_6_c_2486_p N_noxref_8_c_3034_n ) capacitor c=0.00662747f \
 //x=19.025 //y=1.745 //x2=18.055 //y2=2.1
cc_1885 ( N_noxref_6_c_2472_p N_noxref_8_c_3034_n ) capacitor c=0.012184f \
 //x=19.025 //y=2.1 //x2=18.055 //y2=2.1
cc_1886 ( N_noxref_6_c_2479_p N_noxref_8_c_3038_n ) capacitor c=0.0157772f \
 //x=19.025 //y=1.09 //x2=18.585 //y2=1.05
cc_1887 ( N_noxref_6_c_2483_p N_noxref_8_c_3038_n ) capacitor c=0.00127211f \
 //x=19.555 //y=1.09 //x2=18.585 //y2=1.05
cc_1888 ( N_noxref_6_c_2480_p N_noxref_8_c_3040_n ) capacitor c=0.0117362f \
 //x=19.025 //y=1.435 //x2=18.585 //y2=1.395
cc_1889 ( N_noxref_6_c_2486_p N_noxref_8_c_3040_n ) capacitor c=0.00862358f \
 //x=19.025 //y=1.745 //x2=18.585 //y2=1.395
cc_1890 ( N_noxref_6_c_2484_p N_noxref_8_c_3040_n ) capacitor c=0.00204774f \
 //x=19.555 //y=1.435 //x2=18.585 //y2=1.395
cc_1891 ( N_noxref_6_c_2364_n CIN ) capacitor c=0.00512176f //x=19.185 \
 //y=2.755 //x2=16.03 //y2=3.14
cc_1892 ( N_noxref_6_c_2427_n CIN ) capacitor c=0.0128176f //x=19.24 //y=4.73 \
 //x2=18.25 //y2=4.62
cc_1893 ( N_noxref_6_c_2491_p CIN ) capacitor c=2.2865e-19 //x=19.36 //y=4.88 \
 //x2=18.25 //y2=4.62
cc_1894 ( N_noxref_6_c_2361_n N_CIN_c_3328_n ) capacitor c=3.32832e-19 \
 //x=13.07 //y=2.61 //x2=16.03 //y2=2.995
cc_1895 ( N_noxref_6_c_2364_n N_CIN_c_3328_n ) capacitor c=0.0198491f \
 //x=19.185 //y=2.755 //x2=16.03 //y2=2.995
cc_1896 ( N_noxref_6_c_2425_n N_CIN_c_3286_n ) capacitor c=0.00753295f \
 //x=19.24 //y=2.915 //x2=20.86 //y2=3.14
cc_1897 ( N_noxref_6_c_2427_n N_CIN_c_3286_n ) capacitor c=0.0196093f \
 //x=19.24 //y=4.73 //x2=20.86 //y2=3.14
cc_1898 ( N_noxref_6_c_2442_n N_CIN_c_3286_n ) capacitor c=0.035713f \
 //x=19.345 //y=2.755 //x2=20.86 //y2=3.14
cc_1899 ( N_noxref_6_c_2364_n N_CIN_c_3286_n ) capacitor c=0.259621f \
 //x=19.185 //y=2.755 //x2=20.86 //y2=3.14
cc_1900 ( N_noxref_6_c_2427_n N_CIN_c_3297_n ) capacitor c=0.0219663f \
 //x=19.24 //y=4.73 //x2=21.085 //y2=4.655
cc_1901 ( N_noxref_6_c_2376_n N_CIN_c_3297_n ) capacitor c=0.00597144f \
 //x=19.24 //y=4.877 //x2=21.085 //y2=4.655
cc_1902 ( N_noxref_6_c_2364_n N_CIN_c_3304_n ) capacitor c=0.0358686f \
 //x=19.185 //y=2.755 //x2=16.19 //y2=3.155
cc_1903 ( N_noxref_6_c_2427_n N_CIN_c_3309_n ) capacitor c=9.46427e-19 \
 //x=19.24 //y=4.73 //x2=18.25 //y2=4.62
cc_1904 ( N_noxref_6_c_2376_n N_CIN_c_3309_n ) capacitor c=0.0021063f \
 //x=19.24 //y=4.877 //x2=18.25 //y2=4.62
cc_1905 ( N_noxref_6_c_2491_p N_CIN_c_3309_n ) capacitor c=0.00149942f \
 //x=19.36 //y=4.88 //x2=18.25 //y2=4.62
cc_1906 ( N_noxref_6_c_2505_p N_CIN_c_3309_n ) capacitor c=0.00186624f \
 //x=19.36 //y=4.88 //x2=18.25 //y2=4.62
cc_1907 ( N_noxref_6_M41_noxref_g N_CIN_M39_noxref_g ) capacitor c=0.0102032f \
 //x=19.03 //y=6.2 //x2=18.15 //y2=6.2
cc_1908 ( N_noxref_6_M41_noxref_g N_CIN_M40_noxref_g ) capacitor c=0.0618439f \
 //x=19.03 //y=6.2 //x2=18.59 //y2=6.2
cc_1909 ( N_noxref_6_M42_noxref_g N_CIN_M40_noxref_g ) capacitor c=0.00945236f \
 //x=19.47 //y=6.2 //x2=18.59 //y2=6.2
cc_1910 ( N_noxref_6_c_2376_n N_CIN_c_3404_n ) capacitor c=0.00107621f \
 //x=19.24 //y=4.877 //x2=18.25 //y2=4.88
cc_1911 ( N_noxref_6_c_2491_p N_CIN_c_3404_n ) capacitor c=0.00166675f \
 //x=19.36 //y=4.88 //x2=18.25 //y2=4.88
cc_1912 ( N_noxref_6_c_2505_p N_CIN_c_3404_n ) capacitor c=0.0664454f \
 //x=19.36 //y=4.88 //x2=18.25 //y2=4.88
cc_1913 ( N_noxref_6_c_2366_n N_VDD_c_5065_n ) capacitor c=0.00259718f \
 //x=12.705 //y=5.42 //x2=14.955 //y2=7.585
cc_1914 ( N_noxref_6_c_2371_n N_VDD_c_5065_n ) capacitor c=0.00220877f \
 //x=12.985 //y=5.14 //x2=14.955 //y2=7.585
cc_1915 ( N_noxref_6_c_2449_n N_VDD_c_5065_n ) capacitor c=0.00241566f \
 //x=12.705 //y=5.56 //x2=14.955 //y2=7.585
cc_1916 ( N_noxref_6_c_2366_n N_VDD_c_5184_n ) capacitor c=8.96756e-19 \
 //x=12.705 //y=5.42 //x2=13.06 //y2=7.585
cc_1917 ( N_noxref_6_c_2371_n N_VDD_c_5184_n ) capacitor c=0.00197507f \
 //x=12.985 //y=5.14 //x2=13.06 //y2=7.585
cc_1918 ( N_noxref_6_c_2449_n N_VDD_c_5184_n ) capacitor c=0.0138017f \
 //x=12.705 //y=5.56 //x2=13.06 //y2=7.585
cc_1919 ( N_noxref_6_M41_noxref_g N_VDD_c_5245_n ) capacitor c=0.00777954f \
 //x=19.03 //y=6.2 //x2=20.3 //y2=7.585
cc_1920 ( N_noxref_6_M42_noxref_g N_VDD_c_5245_n ) capacitor c=0.00758899f \
 //x=19.47 //y=6.2 //x2=20.3 //y2=7.585
cc_1921 ( N_noxref_6_c_2368_n N_VDD_c_5083_n ) capacitor c=0.0048083f \
 //x=12.79 //y=5.14 //x2=11.59 //y2=7.585
cc_1922 ( N_noxref_6_c_2449_n N_VDD_c_5083_n ) capacitor c=0.00822581f \
 //x=12.705 //y=5.56 //x2=11.59 //y2=7.585
cc_1923 ( N_noxref_6_c_2366_n N_VDD_c_5131_n ) capacitor c=0.00232499f \
 //x=12.705 //y=5.42 //x2=13.81 //y2=7.585
cc_1924 ( N_noxref_6_c_2374_n N_VDD_c_5131_n ) capacitor c=0.0207628f \
 //x=13.07 //y=5.055 //x2=13.81 //y2=7.585
cc_1925 ( N_noxref_6_c_2449_n N_VDD_c_5131_n ) capacitor c=0.00820601f \
 //x=12.705 //y=5.56 //x2=13.81 //y2=7.585
cc_1926 ( N_noxref_6_c_2427_n N_VDD_c_5132_n ) capacitor c=8.19548e-19 \
 //x=19.24 //y=4.73 //x2=17.14 //y2=7.585
cc_1927 ( N_noxref_6_c_2491_p N_VDD_c_5135_n ) capacitor c=0.00354581f \
 //x=19.36 //y=4.88 //x2=20.47 //y2=7.585
cc_1928 ( N_noxref_6_c_2505_p N_VDD_c_5135_n ) capacitor c=0.0192374f \
 //x=19.36 //y=4.88 //x2=20.47 //y2=7.585
cc_1929 ( N_noxref_6_c_2366_n N_VDD_M32_noxref_d ) capacitor c=8.21385e-19 \
 //x=12.705 //y=5.42 //x2=10.77 //y2=5.2
cc_1930 ( N_noxref_6_c_2366_n N_VDD_M33_noxref_s ) capacitor c=0.0465737f \
 //x=12.705 //y=5.42 //x2=12.13 //y2=5.2
cc_1931 ( N_noxref_6_c_2449_n N_VDD_M33_noxref_s ) capacitor c=0.0898805f \
 //x=12.705 //y=5.56 //x2=12.13 //y2=5.2
cc_1932 ( N_noxref_6_c_2366_n N_VDD_M34_noxref_d ) capacitor c=0.0474638f \
 //x=12.705 //y=5.42 //x2=13 //y2=5.2
cc_1933 ( N_noxref_6_c_2371_n N_VDD_M34_noxref_d ) capacitor c=0.0219185f \
 //x=12.985 //y=5.14 //x2=13 //y2=5.2
cc_1934 ( N_noxref_6_c_2404_n N_VDD_M34_noxref_d ) capacitor c=0.00160423f \
 //x=13.07 //y=2.93 //x2=13 //y2=5.2
cc_1935 ( N_noxref_6_c_2449_n N_VDD_M34_noxref_d ) capacitor c=0.090455f \
 //x=12.705 //y=5.56 //x2=13 //y2=5.2
cc_1936 ( N_noxref_6_c_2366_n N_noxref_18_c_5961_n ) capacitor c=0.00182388f \
 //x=12.705 //y=5.42 //x2=14.607 //y2=5.385
cc_1937 ( N_noxref_6_M41_noxref_g N_noxref_19_c_6042_n ) capacitor \
 c=0.00729709f //x=19.03 //y=6.2 //x2=19.57 //y2=7.085
cc_1938 ( N_noxref_6_M42_noxref_g N_noxref_19_c_6042_n ) capacitor \
 c=0.00932051f //x=19.47 //y=6.2 //x2=19.57 //y2=7.085
cc_1939 ( N_noxref_6_M41_noxref_g N_noxref_19_c_6045_n ) capacitor \
 c=0.00175157f //x=19.03 //y=6.2 //x2=18.81 //y2=5.385
cc_1940 ( N_noxref_6_M41_noxref_g N_noxref_19_c_6051_n ) capacitor \
 c=0.00178586f //x=19.03 //y=6.2 //x2=18.81 //y2=6.915
cc_1941 ( N_noxref_6_M42_noxref_g N_noxref_19_c_6052_n ) capacitor \
 c=0.00406674f //x=19.47 //y=6.2 //x2=19.69 //y2=6.915
cc_1942 ( N_noxref_6_M41_noxref_g N_noxref_19_c_6053_n ) capacitor \
 c=0.0170175f //x=19.03 //y=6.2 //x2=18.81 //y2=5.555
cc_1943 ( N_noxref_6_M42_noxref_g N_noxref_19_M42_noxref_d ) capacitor \
 c=0.0365939f //x=19.47 //y=6.2 //x2=19.545 //y2=5.2
cc_1944 ( N_noxref_6_c_2360_n N_GND_c_6139_n ) capacitor c=0.0014542f \
 //x=12.785 //y=2.02 //x2=14.905 //y2=0.175
cc_1945 ( N_noxref_6_c_2404_n N_GND_c_6139_n ) capacitor c=4.56525e-19 \
 //x=13.07 //y=2.93 //x2=14.905 //y2=0.175
cc_1946 ( N_noxref_6_c_2363_n N_GND_c_6139_n ) capacitor c=0.00957658f \
 //x=12.7 //y=1.185 //x2=14.905 //y2=0.175
cc_1947 ( N_noxref_6_c_2437_n N_GND_c_6139_n ) capacitor c=4.46679e-19 \
 //x=13.07 //y=2.77 //x2=14.905 //y2=0.175
cc_1948 ( N_noxref_6_M6_noxref_d N_GND_c_6139_n ) capacitor c=0.00119455f \
 //x=12.515 //y=1.09 //x2=14.905 //y2=0.175
cc_1949 ( N_noxref_6_c_2363_n N_GND_c_6140_n ) capacitor c=0.00528311f \
 //x=12.7 //y=1.185 //x2=14.99 //y2=1.025
cc_1950 ( N_noxref_6_c_2363_n N_GND_c_6157_n ) capacitor c=0.00130539f \
 //x=12.7 //y=1.185 //x2=12.615 //y2=0.715
cc_1951 ( N_noxref_6_c_2359_n N_GND_c_6359_n ) capacitor c=0.00250206f \
 //x=12.985 //y=2.02 //x2=13.105 //y2=0.715
cc_1952 ( N_noxref_6_c_2363_n N_GND_c_6359_n ) capacitor c=0.00130539f \
 //x=12.7 //y=1.185 //x2=13.105 //y2=0.715
cc_1953 ( N_noxref_6_c_2437_n N_GND_c_6359_n ) capacitor c=4.28655e-19 \
 //x=13.07 //y=2.77 //x2=13.105 //y2=0.715
cc_1954 ( N_noxref_6_c_2365_n N_GND_c_6176_n ) capacitor c=0.00168596f \
 //x=12.7 //y=1.935 //x2=11.59 //y2=0.175
cc_1955 ( N_noxref_6_c_2437_n N_GND_c_6176_n ) capacitor c=0.00313158f \
 //x=13.07 //y=2.77 //x2=11.59 //y2=0.175
cc_1956 ( N_noxref_6_c_2359_n N_GND_c_6177_n ) capacitor c=0.0134996f \
 //x=12.985 //y=2.02 //x2=13.81 //y2=0.175
cc_1957 ( N_noxref_6_c_2360_n N_GND_c_6177_n ) capacitor c=3.23363e-19 \
 //x=12.785 //y=2.02 //x2=13.81 //y2=0.175
cc_1958 ( N_noxref_6_c_2404_n N_GND_c_6177_n ) capacitor c=0.00439621f \
 //x=13.07 //y=2.93 //x2=13.81 //y2=0.175
cc_1959 ( N_noxref_6_c_2437_n N_GND_c_6177_n ) capacitor c=0.0101813f \
 //x=13.07 //y=2.77 //x2=13.81 //y2=0.175
cc_1960 ( N_noxref_6_c_2364_n N_GND_c_6177_n ) capacitor c=0.01325f //x=19.185 \
 //y=2.755 //x2=13.81 //y2=0.175
cc_1961 ( N_noxref_6_c_2469_p N_GND_c_6178_n ) capacitor c=0.00118906f \
 //x=19.36 //y=2.77 //x2=17.14 //y2=0.175
cc_1962 ( N_noxref_6_c_2364_n N_GND_c_6178_n ) capacitor c=0.0128065f \
 //x=19.185 //y=2.755 //x2=17.14 //y2=0.175
cc_1963 ( N_noxref_6_c_2469_p N_GND_c_6179_n ) capacitor c=0.00499198f \
 //x=19.36 //y=2.77 //x2=20.47 //y2=0.175
cc_1964 ( N_noxref_6_c_2471_p N_GND_c_6179_n ) capacitor c=0.00344622f \
 //x=19.36 //y=2.265 //x2=20.47 //y2=0.175
cc_1965 ( N_noxref_6_c_2472_p N_GND_c_6179_n ) capacitor c=0.00564463f \
 //x=19.025 //y=2.1 //x2=20.47 //y2=0.175
cc_1966 ( N_noxref_6_c_2484_p N_GND_c_6179_n ) capacitor c=0.00230557f \
 //x=19.555 //y=1.435 //x2=20.47 //y2=0.175
cc_1967 ( N_noxref_6_c_2365_n N_GND_M6_noxref_s ) capacitor c=0.0300565f \
 //x=12.7 //y=1.935 //x2=12.085 //y2=0.55
cc_1968 ( N_noxref_6_c_2359_n N_GND_M6_noxref_s ) capacitor c=0.00268302f \
 //x=12.985 //y=2.02 //x2=12.085 //y2=0.55
cc_1969 ( N_noxref_6_c_2404_n N_GND_M6_noxref_s ) capacitor c=0.00297082f \
 //x=13.07 //y=2.93 //x2=12.085 //y2=0.55
cc_1970 ( N_noxref_6_c_2363_n N_GND_M6_noxref_s ) capacitor c=0.0139867f \
 //x=12.7 //y=1.185 //x2=12.085 //y2=0.55
cc_1971 ( N_noxref_6_c_2437_n N_GND_M6_noxref_s ) capacitor c=0.00227215f \
 //x=13.07 //y=2.77 //x2=12.085 //y2=0.55
cc_1972 ( N_noxref_6_M6_noxref_d N_GND_M6_noxref_s ) capacitor c=0.0373268f \
 //x=12.515 //y=1.09 //x2=12.085 //y2=0.55
cc_1973 ( N_noxref_6_c_2486_p N_noxref_26_c_7303_n ) capacitor c=0.00888238f \
 //x=19.025 //y=1.745 //x2=18.805 //y2=1.68
cc_1974 ( N_noxref_6_c_2425_n N_noxref_26_c_7304_n ) capacitor c=5.34835e-19 \
 //x=19.24 //y=2.915 //x2=19.69 //y2=0.715
cc_1975 ( N_noxref_6_c_2471_p N_noxref_26_c_7304_n ) capacitor c=4.1952e-19 \
 //x=19.36 //y=2.265 //x2=19.69 //y2=0.715
cc_1976 ( N_noxref_6_c_2479_p N_noxref_26_c_7304_n ) capacitor c=0.0204604f \
 //x=19.025 //y=1.09 //x2=19.69 //y2=0.715
cc_1977 ( N_noxref_6_c_2472_p N_noxref_26_c_7304_n ) capacitor c=2.1838e-19 \
 //x=19.025 //y=2.1 //x2=19.69 //y2=0.715
cc_1978 ( N_noxref_6_c_2483_p N_noxref_26_c_7304_n ) capacitor c=0.00825432f \
 //x=19.555 //y=1.09 //x2=19.69 //y2=0.715
cc_1979 ( N_noxref_6_c_2479_p N_noxref_26_M9_noxref_s ) capacitor \
 c=0.00888238f //x=19.025 //y=1.09 //x2=17.7 //y2=0.55
cc_1980 ( N_noxref_6_c_2483_p N_noxref_26_M9_noxref_s ) capacitor c=0.015333f \
 //x=19.555 //y=1.09 //x2=17.7 //y2=0.55
cc_1981 ( N_noxref_6_c_2484_p N_noxref_26_M9_noxref_s ) capacitor \
 c=0.00248746f //x=19.555 //y=1.435 //x2=17.7 //y2=0.55
cc_1982 ( SUM N_noxref_8_c_2966_n ) capacitor c=0.0458811f //x=16.52 //y=4.62 \
 //x2=16.03 //y2=4.575
cc_1983 ( N_SUM_c_2670_n N_noxref_8_c_2966_n ) capacitor c=0.00263491f \
 //x=16.435 //y=5.385 //x2=16.03 //y2=4.575
cc_1984 ( N_SUM_c_2766_p N_noxref_8_c_2966_n ) capacitor c=2.47143e-19 \
 //x=16.435 //y=1.835 //x2=16.03 //y2=4.575
cc_1985 ( N_SUM_c_2675_n N_noxref_8_c_2966_n ) capacitor c=6.31823e-19 \
 //x=15.92 //y=5.385 //x2=16.03 //y2=4.575
cc_1986 ( SUM N_noxref_8_c_2967_n ) capacitor c=0.0342548f //x=16.52 //y=4.62 \
 //x2=16.03 //y2=4.765
cc_1987 ( N_SUM_c_2670_n N_noxref_8_c_2967_n ) capacitor c=0.00228985f \
 //x=16.435 //y=5.385 //x2=16.03 //y2=4.765
cc_1988 ( N_SUM_c_2675_n N_noxref_8_c_2967_n ) capacitor c=0.0172795f \
 //x=15.92 //y=5.385 //x2=16.03 //y2=4.765
cc_1989 ( N_SUM_c_2771_p N_noxref_8_c_2967_n ) capacitor c=0.00137304f \
 //x=15.92 //y=5.555 //x2=16.03 //y2=4.765
cc_1990 ( SUM N_noxref_8_c_2961_n ) capacitor c=0.00363839f //x=16.52 //y=3.51 \
 //x2=18.25 //y2=2.385
cc_1991 ( SUM N_noxref_8_c_2989_n ) capacitor c=0.0117707f //x=16.52 //y=3.51 \
 //x2=18.25 //y2=3.385
cc_1992 ( SUM N_noxref_8_c_2989_n ) capacitor c=0.00318238f //x=19.73 //y=2.77 \
 //x2=18.25 //y2=3.385
cc_1993 ( SUM N_noxref_8_c_3054_n ) capacitor c=0.00398704f //x=19.73 //y=2.77 \
 //x2=21.21 //y2=3.655
cc_1994 ( SUM N_noxref_8_c_3018_n ) capacitor c=0.0016325f //x=19.73 //y=2.77 \
 //x2=21.21 //y2=4.135
cc_1995 ( SUM N_noxref_8_c_3018_n ) capacitor c=3.17649e-19 //x=19.73 //y=3.88 \
 //x2=21.21 //y2=4.135
cc_1996 ( N_SUM_c_2732_n N_noxref_8_c_3018_n ) capacitor c=0.00493311f \
 //x=19.73 //y=4.055 //x2=21.21 //y2=4.135
cc_1997 ( N_SUM_c_2671_n N_noxref_8_c_3018_n ) capacitor c=0.00139895f \
 //x=19.73 //y=5.3 //x2=21.21 //y2=4.135
cc_1998 ( N_SUM_c_2747_n N_noxref_8_c_3018_n ) capacitor c=0.005854f \
 //x=19.745 //y=3.895 //x2=21.21 //y2=4.135
cc_1999 ( N_SUM_c_2671_n N_noxref_8_c_3060_n ) capacitor c=0.00436509f \
 //x=19.73 //y=5.3 //x2=21.21 //y2=4.43
cc_2000 ( N_SUM_c_2671_n N_noxref_8_c_2968_n ) capacitor c=0.0114788f \
 //x=19.73 //y=5.3 //x2=21.21 //y2=5.055
cc_2001 ( SUM N_noxref_8_c_2963_n ) capacitor c=2.22254e-19 //x=19.73 //y=2.77 \
 //x2=21.495 //y2=2.02
cc_2002 ( SUM N_noxref_8_c_2964_n ) capacitor c=0.0210272f //x=19.73 //y=2.77 \
 //x2=21.295 //y2=2.02
cc_2003 ( N_SUM_c_2671_n N_noxref_8_c_2975_n ) capacitor c=0.00149213f \
 //x=19.73 //y=5.3 //x2=21.575 //y2=5.42
cc_2004 ( N_SUM_c_2676_n N_noxref_8_c_2975_n ) capacitor c=4.99083e-19 \
 //x=19.25 //y=5.385 //x2=21.575 //y2=5.42
cc_2005 ( N_SUM_c_2715_n N_noxref_8_c_3066_n ) capacitor c=0.00464508f \
 //x=19.29 //y=1.75 //x2=21.58 //y2=1.935
cc_2006 ( N_SUM_c_2723_n N_noxref_8_c_3066_n ) capacitor c=0.00337741f \
 //x=19.645 //y=1.835 //x2=21.58 //y2=1.935
cc_2007 ( SUM N_noxref_8_c_2991_n ) capacitor c=0.00654928f //x=16.52 //y=4.62 \
 //x2=16.075 //y2=4.415
cc_2008 ( SUM N_noxref_8_c_3020_n ) capacitor c=0.00403661f //x=16.52 //y=3.51 \
 //x2=18.25 //y2=3.51
cc_2009 ( N_SUM_c_2677_n N_noxref_8_c_3020_n ) capacitor c=0.00760299f \
 //x=19.585 //y=3.895 //x2=18.25 //y2=3.51
cc_2010 ( SUM N_noxref_8_c_3071_n ) capacitor c=2.17715e-19 //x=19.73 //y=2.77 \
 //x2=21.21 //y2=3.51
cc_2011 ( N_SUM_c_2671_n N_noxref_8_c_3072_n ) capacitor c=5.93415e-19 \
 //x=19.73 //y=5.3 //x2=21.21 //y2=4.25
cc_2012 ( N_SUM_c_2665_n N_noxref_8_c_2965_n ) capacitor c=0.00581407f \
 //x=19.29 //y=1.3 //x2=21.58 //y2=1.185
cc_2013 ( N_SUM_c_2715_n N_noxref_8_c_2965_n ) capacitor c=6.23317e-19 \
 //x=19.29 //y=1.75 //x2=21.58 //y2=1.185
cc_2014 ( SUM N_noxref_8_c_2977_n ) capacitor c=0.00664189f //x=16.52 //y=4.62 \
 //x2=16.075 //y2=4.28
cc_2015 ( SUM N_noxref_8_c_3021_n ) capacitor c=0.00354109f //x=16.52 //y=3.51 \
 //x2=18.41 //y2=3.525
cc_2016 ( N_SUM_c_2677_n N_noxref_8_c_3021_n ) capacitor c=0.0349865f \
 //x=19.585 //y=3.895 //x2=18.41 //y2=3.525
cc_2017 ( N_SUM_c_2671_n N_noxref_8_c_3078_n ) capacitor c=0.0016766f \
 //x=19.73 //y=5.3 //x2=21.215 //y2=4.27
cc_2018 ( SUM N_noxref_8_c_2978_n ) capacitor c=0.0224741f //x=16.52 //y=4.62 \
 //x2=21.055 //y2=4.27
cc_2019 ( N_SUM_c_2686_n N_noxref_8_c_2978_n ) capacitor c=0.00564019f \
 //x=16.52 //y=4.055 //x2=21.055 //y2=4.27
cc_2020 ( N_SUM_c_2732_n N_noxref_8_c_2978_n ) capacitor c=0.00540116f \
 //x=19.73 //y=4.055 //x2=21.055 //y2=4.27
cc_2021 ( N_SUM_c_2671_n N_noxref_8_c_2978_n ) capacitor c=0.0201136f \
 //x=19.73 //y=5.3 //x2=21.055 //y2=4.27
cc_2022 ( N_SUM_c_2687_n N_noxref_8_c_2978_n ) capacitor c=0.0358686f \
 //x=16.725 //y=3.895 //x2=21.055 //y2=4.27
cc_2023 ( N_SUM_c_2747_n N_noxref_8_c_2978_n ) capacitor c=0.0360345f \
 //x=19.745 //y=3.895 //x2=21.055 //y2=4.27
cc_2024 ( N_SUM_c_2677_n N_noxref_8_c_2978_n ) capacitor c=0.24711f //x=19.585 \
 //y=3.895 //x2=21.055 //y2=4.27
cc_2025 ( SUM N_noxref_8_c_3086_n ) capacitor c=0.00191229f //x=19.73 //y=2.77 \
 //x2=21.245 //y2=3.495
cc_2026 ( SUM N_noxref_8_c_2996_n ) capacitor c=0.0203568f //x=19.73 //y=2.77 \
 //x2=21.085 //y2=3.495
cc_2027 ( N_SUM_c_2732_n N_noxref_8_c_2996_n ) capacitor c=0.0076014f \
 //x=19.73 //y=4.055 //x2=21.085 //y2=3.495
cc_2028 ( N_SUM_c_2747_n N_noxref_8_c_2996_n ) capacitor c=0.0360345f \
 //x=19.745 //y=3.895 //x2=21.085 //y2=3.495
cc_2029 ( N_SUM_c_2677_n N_noxref_8_c_2996_n ) capacitor c=0.0922798f \
 //x=19.585 //y=3.895 //x2=21.085 //y2=3.495
cc_2030 ( SUM N_noxref_8_c_2997_n ) capacitor c=0.00451646f //x=16.52 //y=4.62 \
 //x2=16.03 //y2=4.88
cc_2031 ( N_SUM_c_2670_n N_noxref_8_c_2997_n ) capacitor c=0.00104675f \
 //x=16.435 //y=5.385 //x2=16.03 //y2=4.88
cc_2032 ( N_SUM_c_2675_n N_noxref_8_c_2997_n ) capacitor c=0.00390413f \
 //x=15.92 //y=5.385 //x2=16.03 //y2=4.88
cc_2033 ( N_SUM_c_2771_p N_noxref_8_c_2997_n ) capacitor c=0.00414188f \
 //x=15.92 //y=5.555 //x2=16.03 //y2=4.88
cc_2034 ( N_SUM_c_2675_n N_noxref_8_M37_noxref_g ) capacitor c=0.00179689f \
 //x=15.92 //y=5.385 //x2=15.7 //y2=6.2
cc_2035 ( N_SUM_c_2771_p N_noxref_8_M37_noxref_g ) capacitor c=0.0120591f \
 //x=15.92 //y=5.555 //x2=15.7 //y2=6.2
cc_2036 ( N_SUM_c_2670_n N_noxref_8_M38_noxref_g ) capacitor c=0.0097775f \
 //x=16.435 //y=5.385 //x2=16.14 //y2=6.2
cc_2037 ( N_SUM_c_2675_n N_noxref_8_M38_noxref_g ) capacitor c=0.00277466f \
 //x=15.92 //y=5.385 //x2=16.14 //y2=6.2
cc_2038 ( N_SUM_c_2771_p N_noxref_8_M38_noxref_g ) capacitor c=0.0140704f \
 //x=15.92 //y=5.555 //x2=16.14 //y2=6.2
cc_2039 ( SUM N_noxref_8_c_3004_n ) capacitor c=0.0100106f //x=16.52 //y=4.62 \
 //x2=16.03 //y2=4.88
cc_2040 ( N_SUM_c_2675_n N_noxref_8_c_3004_n ) capacitor c=0.00203067f \
 //x=15.92 //y=5.385 //x2=16.03 //y2=4.88
cc_2041 ( N_SUM_c_2771_p N_noxref_8_c_3004_n ) capacitor c=0.00435839f \
 //x=15.92 //y=5.555 //x2=16.03 //y2=4.88
cc_2042 ( SUM CIN ) capacitor c=0.00167005f //x=19.73 //y=2.77 //x2=21.95 \
 //y2=2.77
cc_2043 ( SUM CIN ) capacitor c=0.00118611f //x=19.73 //y=2.77 //x2=21.95 \
 //y2=3.51
cc_2044 ( N_SUM_c_2671_n CIN ) capacitor c=0.00142372f //x=19.73 //y=5.3 \
 //x2=21.95 //y2=3.51
cc_2045 ( SUM CIN ) capacitor c=0.0348988f //x=16.52 //y=3.51 //x2=16.03 \
 //y2=3.14
cc_2046 ( N_SUM_c_2766_p CIN ) capacitor c=0.00220819f //x=16.435 //y=1.835 \
 //x2=16.03 //y2=3.14
cc_2047 ( N_SUM_c_2664_n CIN ) capacitor c=6.73583e-19 //x=16.045 //y=1.835 \
 //x2=16.03 //y2=3.14
cc_2048 ( N_SUM_c_2675_n CIN ) capacitor c=5.19658e-19 //x=15.92 //y=5.385 \
 //x2=16.03 //y2=3.14
cc_2049 ( SUM CIN ) capacitor c=0.00459954f //x=16.52 //y=4.62 //x2=18.25 \
 //y2=4.62
cc_2050 ( SUM N_CIN_c_3283_n ) capacitor c=0.0243787f //x=16.52 //y=3.51 \
 //x2=16.03 //y2=2.415
cc_2051 ( N_SUM_c_2766_p N_CIN_c_3283_n ) capacitor c=0.00221754f //x=16.435 \
 //y=1.835 //x2=16.03 //y2=2.415
cc_2052 ( N_SUM_c_2664_n N_CIN_c_3283_n ) capacitor c=0.0193088f //x=16.045 \
 //y=1.835 //x2=16.03 //y2=2.415
cc_2053 ( N_SUM_M8_noxref_d N_CIN_c_3283_n ) capacitor c=4.61207e-19 //x=15.77 \
 //y=1.09 //x2=16.03 //y2=2.415
cc_2054 ( SUM N_CIN_c_3328_n ) capacitor c=0.0365387f //x=16.52 //y=3.51 \
 //x2=16.03 //y2=2.995
cc_2055 ( SUM N_CIN_c_3286_n ) capacitor c=0.0222476f //x=16.52 //y=3.51 \
 //x2=20.86 //y2=3.14
cc_2056 ( SUM N_CIN_c_3286_n ) capacitor c=0.0245459f //x=19.73 //y=2.77 \
 //x2=20.86 //y2=3.14
cc_2057 ( N_SUM_c_2686_n N_CIN_c_3286_n ) capacitor c=0.00652184f //x=16.52 \
 //y=4.055 //x2=20.86 //y2=3.14
cc_2058 ( N_SUM_c_2687_n N_CIN_c_3286_n ) capacitor c=0.0157015f //x=16.725 \
 //y=3.895 //x2=20.86 //y2=3.14
cc_2059 ( N_SUM_c_2747_n N_CIN_c_3286_n ) capacitor c=7.21807e-19 //x=19.745 \
 //y=3.895 //x2=20.86 //y2=3.14
cc_2060 ( N_SUM_c_2677_n N_CIN_c_3286_n ) capacitor c=0.0680498f //x=19.585 \
 //y=3.895 //x2=20.86 //y2=3.14
cc_2061 ( SUM N_CIN_c_3297_n ) capacitor c=0.00345047f //x=16.52 //y=4.62 \
 //x2=21.085 //y2=4.655
cc_2062 ( N_SUM_c_2671_n N_CIN_c_3297_n ) capacitor c=0.0217376f //x=19.73 \
 //y=5.3 //x2=21.085 //y2=4.655
cc_2063 ( N_SUM_c_2747_n N_CIN_c_3297_n ) capacitor c=7.60969e-19 //x=19.745 \
 //y=3.895 //x2=21.085 //y2=4.655
cc_2064 ( N_SUM_c_2677_n N_CIN_c_3297_n ) capacitor c=0.00744882f //x=19.585 \
 //y=3.895 //x2=21.085 //y2=4.655
cc_2065 ( SUM N_CIN_c_3304_n ) capacitor c=0.00470736f //x=16.52 //y=3.51 \
 //x2=16.19 //y2=3.155
cc_2066 ( SUM N_CIN_c_3343_n ) capacitor c=0.00167894f //x=16.52 //y=3.51 \
 //x2=16.03 //y2=2.265
cc_2067 ( N_SUM_c_2766_p N_CIN_c_3343_n ) capacitor c=0.00147657f //x=16.435 \
 //y=1.835 //x2=16.03 //y2=2.265
cc_2068 ( N_SUM_c_2664_n N_CIN_c_3343_n ) capacitor c=0.00408056f //x=16.045 \
 //y=1.835 //x2=16.03 //y2=2.265
cc_2069 ( N_SUM_M8_noxref_d N_CIN_c_3343_n ) capacitor c=0.00150031f //x=15.77 \
 //y=1.09 //x2=16.03 //y2=2.265
cc_2070 ( N_SUM_c_2671_n N_CIN_c_3309_n ) capacitor c=2.74213e-19 //x=19.73 \
 //y=5.3 //x2=18.25 //y2=4.62
cc_2071 ( N_SUM_c_2663_n N_CIN_c_3356_n ) capacitor c=5.45132e-19 //x=15.96 \
 //y=1.305 //x2=15.695 //y2=1.09
cc_2072 ( N_SUM_M8_noxref_d N_CIN_c_3356_n ) capacitor c=0.00137165f //x=15.77 \
 //y=1.09 //x2=15.695 //y2=1.09
cc_2073 ( N_SUM_c_2663_n N_CIN_c_3359_n ) capacitor c=0.00220865f //x=15.96 \
 //y=1.305 //x2=15.695 //y2=1.435
cc_2074 ( N_SUM_c_2705_n N_CIN_c_3359_n ) capacitor c=0.00118531f //x=15.96 \
 //y=1.75 //x2=15.695 //y2=1.435
cc_2075 ( N_SUM_M8_noxref_d N_CIN_c_3359_n ) capacitor c=0.00237422f //x=15.77 \
 //y=1.09 //x2=15.695 //y2=1.435
cc_2076 ( N_SUM_c_2705_n N_CIN_c_3361_n ) capacitor c=0.00409175f //x=15.96 \
 //y=1.75 //x2=15.695 //y2=1.745
cc_2077 ( SUM N_CIN_c_3364_n ) capacitor c=0.0074539f //x=16.52 //y=3.51 \
 //x2=15.695 //y2=2.1
cc_2078 ( N_SUM_c_2705_n N_CIN_c_3364_n ) capacitor c=0.00341876f //x=15.96 \
 //y=1.75 //x2=15.695 //y2=2.1
cc_2079 ( N_SUM_c_2664_n N_CIN_c_3364_n ) capacitor c=0.00203544f //x=16.045 \
 //y=1.835 //x2=15.695 //y2=2.1
cc_2080 ( N_SUM_M8_noxref_d N_CIN_c_3364_n ) capacitor c=4.64071e-19 //x=15.77 \
 //y=1.09 //x2=15.695 //y2=2.1
cc_2081 ( N_SUM_c_2663_n N_CIN_c_3446_n ) capacitor c=5.33629e-19 //x=15.96 \
 //y=1.305 //x2=16.07 //y2=0.935
cc_2082 ( N_SUM_M8_noxref_d N_CIN_c_3446_n ) capacitor c=0.0020782f //x=15.77 \
 //y=1.09 //x2=16.07 //y2=0.935
cc_2083 ( N_SUM_c_2663_n N_CIN_c_3448_n ) capacitor c=5.44173e-19 //x=15.96 \
 //y=1.305 //x2=16.07 //y2=1.59
cc_2084 ( N_SUM_c_2705_n N_CIN_c_3448_n ) capacitor c=0.00758256f //x=15.96 \
 //y=1.75 //x2=16.07 //y2=1.59
cc_2085 ( N_SUM_c_2766_p N_CIN_c_3448_n ) capacitor c=0.00122055f //x=16.435 \
 //y=1.835 //x2=16.07 //y2=1.59
cc_2086 ( N_SUM_M8_noxref_d N_CIN_c_3448_n ) capacitor c=0.00344131f //x=15.77 \
 //y=1.09 //x2=16.07 //y2=1.59
cc_2087 ( N_SUM_c_2663_n N_CIN_c_3367_n ) capacitor c=6.34991e-19 //x=15.96 \
 //y=1.305 //x2=16.225 //y2=1.09
cc_2088 ( N_SUM_M8_noxref_d N_CIN_c_3367_n ) capacitor c=8.50094e-19 //x=15.77 \
 //y=1.09 //x2=16.225 //y2=1.09
cc_2089 ( N_SUM_c_2663_n N_CIN_c_3368_n ) capacitor c=0.00320504f //x=15.96 \
 //y=1.305 //x2=16.225 //y2=1.435
cc_2090 ( N_SUM_c_2705_n N_CIN_c_3368_n ) capacitor c=0.003249f //x=15.96 \
 //y=1.75 //x2=16.225 //y2=1.435
cc_2091 ( N_SUM_c_2766_p N_CIN_c_3368_n ) capacitor c=0.00300547f //x=16.435 \
 //y=1.835 //x2=16.225 //y2=1.435
cc_2092 ( N_SUM_M8_noxref_d N_CIN_c_3368_n ) capacitor c=0.00237422f //x=15.77 \
 //y=1.09 //x2=16.225 //y2=1.435
cc_2093 ( N_SUM_c_2670_n N_VDD_c_5101_n ) capacitor c=0.00189842f //x=16.435 \
 //y=5.385 //x2=18.285 //y2=7.585
cc_2094 ( N_SUM_c_2686_n N_VDD_c_5101_n ) capacitor c=6.60328e-19 //x=16.52 \
 //y=4.055 //x2=18.285 //y2=7.585
cc_2095 ( N_SUM_c_2720_n N_VDD_c_5104_n ) capacitor c=2.88396e-19 //x=19.645 \
 //y=5.385 //x2=34.935 //y2=7.585
cc_2096 ( N_SUM_c_2732_n N_VDD_c_5104_n ) capacitor c=2.35309e-19 //x=19.73 \
 //y=4.055 //x2=34.935 //y2=7.585
cc_2097 ( N_SUM_c_2670_n N_VDD_c_5187_n ) capacitor c=9.37362e-19 //x=16.435 \
 //y=5.385 //x2=16.97 //y2=7.585
cc_2098 ( N_SUM_c_2771_p N_VDD_c_5187_n ) capacitor c=0.00472214f //x=15.92 \
 //y=5.555 //x2=16.97 //y2=7.585
cc_2099 ( N_SUM_c_2750_n N_VDD_c_5245_n ) capacitor c=0.00485234f //x=19.25 \
 //y=5.555 //x2=20.3 //y2=7.585
cc_2100 ( SUM N_VDD_c_5131_n ) capacitor c=0.00107899f //x=16.52 //y=4.62 \
 //x2=13.81 //y2=7.585
cc_2101 ( SUM N_VDD_c_5132_n ) capacitor c=0.0325233f //x=16.52 //y=4.62 \
 //x2=17.14 //y2=7.585
cc_2102 ( N_SUM_c_2671_n N_VDD_c_5132_n ) capacitor c=0.00111226f //x=19.73 \
 //y=5.3 //x2=17.14 //y2=7.585
cc_2103 ( N_SUM_c_2675_n N_VDD_c_5132_n ) capacitor c=0.00269155f //x=15.92 \
 //y=5.385 //x2=17.14 //y2=7.585
cc_2104 ( N_SUM_c_2771_p N_VDD_c_5132_n ) capacitor c=0.0091804f //x=15.92 \
 //y=5.555 //x2=17.14 //y2=7.585
cc_2105 ( N_SUM_c_2671_n N_VDD_c_5135_n ) capacitor c=0.0239644f //x=19.73 \
 //y=5.3 //x2=20.47 //y2=7.585
cc_2106 ( N_SUM_c_2676_n N_VDD_c_5135_n ) capacitor c=0.00261447f //x=19.25 \
 //y=5.385 //x2=20.47 //y2=7.585
cc_2107 ( N_SUM_c_2750_n N_VDD_c_5135_n ) capacitor c=0.00920443f //x=19.25 \
 //y=5.555 //x2=20.47 //y2=7.585
cc_2108 ( N_SUM_c_2675_n N_VDD_M34_noxref_d ) capacitor c=2.46246e-19 \
 //x=15.92 //y=5.385 //x2=13 //y2=5.2
cc_2109 ( N_SUM_c_2771_p N_VDD_M35_noxref_d ) capacitor c=0.00464138f \
 //x=15.92 //y=5.555 //x2=14.895 //y2=5.2
cc_2110 ( N_SUM_c_2750_n N_VDD_M39_noxref_d ) capacitor c=0.00464146f \
 //x=19.25 //y=5.555 //x2=18.225 //y2=5.2
cc_2111 ( N_SUM_c_2720_n N_VDD_M43_noxref_s ) capacitor c=0.00325155f \
 //x=19.645 //y=5.385 //x2=21.01 //y2=5.2
cc_2112 ( N_SUM_c_2676_n N_VDD_M43_noxref_s ) capacitor c=0.0057075f //x=19.25 \
 //y=5.385 //x2=21.01 //y2=5.2
cc_2113 ( N_SUM_c_2670_n N_noxref_18_c_5960_n ) capacitor c=0.00287591f \
 //x=16.435 //y=5.385 //x2=16.245 //y2=7.085
cc_2114 ( N_SUM_c_2675_n N_noxref_18_c_5960_n ) capacitor c=0.00474359f \
 //x=15.92 //y=5.385 //x2=16.245 //y2=7.085
cc_2115 ( N_SUM_c_2771_p N_noxref_18_c_5960_n ) capacitor c=0.00407104f \
 //x=15.92 //y=5.555 //x2=16.245 //y2=7.085
cc_2116 ( N_SUM_c_2675_n N_noxref_18_c_5961_n ) capacitor c=6.22227e-19 \
 //x=15.92 //y=5.385 //x2=14.607 //y2=5.385
cc_2117 ( N_SUM_c_2675_n N_noxref_18_c_5962_n ) capacitor c=0.0507834f \
 //x=15.92 //y=5.385 //x2=15.48 //y2=5.385
cc_2118 ( N_SUM_c_2771_p N_noxref_18_c_5962_n ) capacitor c=0.00270385f \
 //x=15.92 //y=5.555 //x2=15.48 //y2=5.385
cc_2119 ( N_SUM_c_2670_n N_noxref_18_c_5984_n ) capacitor c=0.00438539f \
 //x=16.435 //y=5.385 //x2=16.36 //y2=6.915
cc_2120 ( N_SUM_c_2675_n N_noxref_18_c_5975_n ) capacitor c=0.00261471f \
 //x=15.92 //y=5.385 //x2=15.48 //y2=5.555
cc_2121 ( N_SUM_c_2771_p N_noxref_18_c_5975_n ) capacitor c=0.0673924f \
 //x=15.92 //y=5.555 //x2=15.48 //y2=5.555
cc_2122 ( N_SUM_c_2670_n N_noxref_18_M38_noxref_d ) capacitor c=0.00704645f \
 //x=16.435 //y=5.385 //x2=16.215 //y2=5.2
cc_2123 ( N_SUM_c_2771_p N_noxref_18_M38_noxref_d ) capacitor c=0.0472015f \
 //x=15.92 //y=5.555 //x2=16.215 //y2=5.2
cc_2124 ( N_SUM_c_2720_n N_noxref_19_c_6042_n ) capacitor c=0.00278476f \
 //x=19.645 //y=5.385 //x2=19.57 //y2=7.085
cc_2125 ( N_SUM_c_2676_n N_noxref_19_c_6042_n ) capacitor c=0.00470906f \
 //x=19.25 //y=5.385 //x2=19.57 //y2=7.085
cc_2126 ( N_SUM_c_2750_n N_noxref_19_c_6042_n ) capacitor c=0.00407104f \
 //x=19.25 //y=5.555 //x2=19.57 //y2=7.085
cc_2127 ( N_SUM_c_2670_n N_noxref_19_c_6043_n ) capacitor c=0.0039433f \
 //x=16.435 //y=5.385 //x2=17.93 //y2=5.385
cc_2128 ( N_SUM_c_2675_n N_noxref_19_c_6043_n ) capacitor c=0.00509041f \
 //x=15.92 //y=5.385 //x2=17.93 //y2=5.385
cc_2129 ( N_SUM_c_2676_n N_noxref_19_c_6043_n ) capacitor c=6.06937e-19 \
 //x=19.25 //y=5.385 //x2=17.93 //y2=5.385
cc_2130 ( N_SUM_c_2676_n N_noxref_19_c_6045_n ) capacitor c=0.0499377f \
 //x=19.25 //y=5.385 //x2=18.81 //y2=5.385
cc_2131 ( N_SUM_c_2750_n N_noxref_19_c_6045_n ) capacitor c=0.0026584f \
 //x=19.25 //y=5.555 //x2=18.81 //y2=5.385
cc_2132 ( N_SUM_c_2720_n N_noxref_19_c_6052_n ) capacitor c=0.00477888f \
 //x=19.645 //y=5.385 //x2=19.69 //y2=6.915
cc_2133 ( N_SUM_c_2676_n N_noxref_19_c_6053_n ) capacitor c=0.00266093f \
 //x=19.25 //y=5.385 //x2=18.81 //y2=5.555
cc_2134 ( N_SUM_c_2750_n N_noxref_19_c_6053_n ) capacitor c=0.0674619f \
 //x=19.25 //y=5.555 //x2=18.81 //y2=5.555
cc_2135 ( SUM N_noxref_19_M42_noxref_d ) capacitor c=0.0012136f //x=19.73 \
 //y=3.88 //x2=19.545 //y2=5.2
cc_2136 ( N_SUM_c_2720_n N_noxref_19_M42_noxref_d ) capacitor c=0.00776833f \
 //x=19.645 //y=5.385 //x2=19.545 //y2=5.2
cc_2137 ( N_SUM_c_2750_n N_noxref_19_M42_noxref_d ) capacitor c=0.0473277f \
 //x=19.25 //y=5.555 //x2=19.545 //y2=5.2
cc_2138 ( N_SUM_c_2663_n N_GND_c_6140_n ) capacitor c=0.0136681f //x=15.96 \
 //y=1.305 //x2=14.99 //y2=1.025
cc_2139 ( N_SUM_M8_noxref_d N_GND_c_6140_n ) capacitor c=5.48773e-19 //x=15.77 \
 //y=1.09 //x2=14.99 //y2=1.025
cc_2140 ( N_SUM_c_2663_n N_GND_c_6141_n ) capacitor c=0.00890018f //x=15.96 \
 //y=1.305 //x2=18.235 //y2=0.175
cc_2141 ( N_SUM_c_2766_p N_GND_c_6141_n ) capacitor c=0.00870172f //x=16.435 \
 //y=1.835 //x2=18.235 //y2=0.175
cc_2142 ( N_SUM_c_2686_n N_GND_c_6141_n ) capacitor c=7.35675e-19 //x=16.52 \
 //y=4.055 //x2=18.235 //y2=0.175
cc_2143 ( N_SUM_M8_noxref_d N_GND_c_6141_n ) capacitor c=2.98166e-19 //x=15.77 \
 //y=1.09 //x2=18.235 //y2=0.175
cc_2144 ( N_SUM_c_2663_n N_GND_c_6142_n ) capacitor c=0.00519351f //x=15.96 \
 //y=1.305 //x2=18.32 //y2=1.025
cc_2145 ( N_SUM_c_2665_n N_GND_c_6142_n ) capacitor c=0.0136059f //x=19.29 \
 //y=1.3 //x2=18.32 //y2=1.025
cc_2146 ( N_SUM_M10_noxref_d N_GND_c_6142_n ) capacitor c=5.45329e-19 //x=19.1 \
 //y=1.09 //x2=18.32 //y2=1.025
cc_2147 ( N_SUM_c_2665_n N_GND_c_6143_n ) capacitor c=0.00877894f //x=19.29 \
 //y=1.3 //x2=23.785 //y2=0.175
cc_2148 ( N_SUM_c_2723_n N_GND_c_6143_n ) capacitor c=0.00686142f //x=19.645 \
 //y=1.835 //x2=23.785 //y2=0.175
cc_2149 ( N_SUM_M10_noxref_d N_GND_c_6143_n ) capacitor c=2.98166e-19 //x=19.1 \
 //y=1.09 //x2=23.785 //y2=0.175
cc_2150 ( N_SUM_c_2766_p N_GND_c_6360_n ) capacitor c=0.001371f //x=16.435 \
 //y=1.835 //x2=16.97 //y2=0.175
cc_2151 ( N_SUM_c_2723_n N_GND_c_6450_n ) capacitor c=7.79681e-19 //x=19.645 \
 //y=1.835 //x2=20.3 //y2=0.175
cc_2152 ( SUM N_GND_c_6177_n ) capacitor c=2.00002e-19 //x=16.52 //y=3.51 \
 //x2=13.81 //y2=0.175
cc_2153 ( SUM N_GND_c_6178_n ) capacitor c=2.24186e-19 //x=19.73 //y=2.77 \
 //x2=17.14 //y2=0.175
cc_2154 ( N_SUM_c_2705_n N_GND_c_6178_n ) capacitor c=0.00289817f //x=15.96 \
 //y=1.75 //x2=17.14 //y2=0.175
cc_2155 ( N_SUM_c_2766_p N_GND_c_6178_n ) capacitor c=0.0299265f //x=16.435 \
 //y=1.835 //x2=17.14 //y2=0.175
cc_2156 ( N_SUM_c_2715_n N_GND_c_6179_n ) capacitor c=0.00262965f //x=19.29 \
 //y=1.75 //x2=20.47 //y2=0.175
cc_2157 ( N_SUM_c_2723_n N_GND_c_6179_n ) capacitor c=0.021471f //x=19.645 \
 //y=1.835 //x2=20.47 //y2=0.175
cc_2158 ( N_SUM_c_2663_n N_GND_M7_noxref_d ) capacitor c=5.45409e-19 //x=15.96 \
 //y=1.305 //x2=14.8 //y2=1.05
cc_2159 ( N_SUM_c_2665_n N_GND_M9_noxref_d ) capacitor c=5.45329e-19 //x=19.29 \
 //y=1.3 //x2=18.13 //y2=1.05
cc_2160 ( N_SUM_c_2664_n N_noxref_25_c_7242_n ) capacitor c=0.00898362f \
 //x=16.045 //y=1.835 //x2=15.475 //y2=1.68
cc_2161 ( N_SUM_c_2663_n N_noxref_25_c_7243_n ) capacitor c=0.00352617f \
 //x=15.96 //y=1.305 //x2=16.36 //y2=0.715
cc_2162 ( N_SUM_c_2766_p N_noxref_25_c_7243_n ) capacitor c=0.00362992f \
 //x=16.435 //y=1.835 //x2=16.36 //y2=0.715
cc_2163 ( N_SUM_M8_noxref_d N_noxref_25_c_7243_n ) capacitor c=0.00910163f \
 //x=15.77 //y=1.09 //x2=16.36 //y2=0.715
cc_2164 ( SUM N_noxref_25_M7_noxref_s ) capacitor c=4.48997e-19 //x=16.57 \
 //y=3.88 //x2=14.37 //y2=0.55
cc_2165 ( N_SUM_c_2663_n N_noxref_25_M7_noxref_s ) capacitor c=0.00888619f \
 //x=15.96 //y=1.305 //x2=14.37 //y2=0.55
cc_2166 ( N_SUM_c_2705_n N_noxref_25_M7_noxref_s ) capacitor c=0.0161119f \
 //x=15.96 //y=1.75 //x2=14.37 //y2=0.55
cc_2167 ( N_SUM_c_2766_p N_noxref_25_M7_noxref_s ) capacitor c=0.00879038f \
 //x=16.435 //y=1.835 //x2=14.37 //y2=0.55
cc_2168 ( N_SUM_M8_noxref_d N_noxref_25_M7_noxref_s ) capacitor c=0.0275562f \
 //x=15.77 //y=1.09 //x2=14.37 //y2=0.55
cc_2169 ( N_SUM_c_2666_n N_noxref_26_c_7303_n ) capacitor c=0.00902033f \
 //x=19.375 //y=1.835 //x2=18.805 //y2=1.68
cc_2170 ( N_SUM_c_2665_n N_noxref_26_c_7304_n ) capacitor c=0.00340242f \
 //x=19.29 //y=1.3 //x2=19.69 //y2=0.715
cc_2171 ( N_SUM_c_2723_n N_noxref_26_c_7304_n ) capacitor c=0.00367965f \
 //x=19.645 //y=1.835 //x2=19.69 //y2=0.715
cc_2172 ( N_SUM_M10_noxref_d N_noxref_26_c_7304_n ) capacitor c=0.00910163f \
 //x=19.1 //y=1.09 //x2=19.69 //y2=0.715
cc_2173 ( SUM N_noxref_26_M9_noxref_s ) capacitor c=8.43954e-19 //x=19.73 \
 //y=3.88 //x2=17.7 //y2=0.55
cc_2174 ( N_SUM_c_2665_n N_noxref_26_M9_noxref_s ) capacitor c=0.00845391f \
 //x=19.29 //y=1.3 //x2=17.7 //y2=0.55
cc_2175 ( N_SUM_c_2715_n N_noxref_26_M9_noxref_s ) capacitor c=0.0157899f \
 //x=19.29 //y=1.75 //x2=17.7 //y2=0.55
cc_2176 ( N_SUM_c_2723_n N_noxref_26_M9_noxref_s ) capacitor c=0.00674704f \
 //x=19.645 //y=1.835 //x2=17.7 //y2=0.55
cc_2177 ( N_SUM_c_2732_n N_noxref_26_M9_noxref_s ) capacitor c=3.19116e-19 \
 //x=19.73 //y=4.055 //x2=17.7 //y2=0.55
cc_2178 ( N_SUM_M10_noxref_d N_noxref_26_M9_noxref_s ) capacitor c=0.0275615f \
 //x=19.1 //y=1.09 //x2=17.7 //y2=0.55
cc_2179 ( N_noxref_8_c_2962_n CIN ) capacitor c=0.0225594f //x=21.21 //y=3.335 \
 //x2=21.95 //y2=2.77
cc_2180 ( N_noxref_8_c_2962_n CIN ) capacitor c=0.00158373f //x=21.21 \
 //y=3.335 //x2=21.95 //y2=3.51
cc_2181 ( N_noxref_8_c_3054_n CIN ) capacitor c=0.0163214f //x=21.21 //y=3.655 \
 //x2=21.95 //y2=3.51
cc_2182 ( N_noxref_8_c_3018_n CIN ) capacitor c=0.0208771f //x=21.21 //y=4.135 \
 //x2=21.95 //y2=3.51
cc_2183 ( N_noxref_8_c_3060_n CIN ) capacitor c=0.014272f //x=21.21 //y=4.43 \
 //x2=21.95 //y2=3.51
cc_2184 ( N_noxref_8_c_2968_n CIN ) capacitor c=0.0101948f //x=21.21 //y=5.055 \
 //x2=21.95 //y2=3.51
cc_2185 ( N_noxref_8_c_3071_n CIN ) capacitor c=9.19401e-19 //x=21.21 //y=3.51 \
 //x2=21.95 //y2=3.51
cc_2186 ( N_noxref_8_c_3072_n CIN ) capacitor c=0.0014208f //x=21.21 //y=4.25 \
 //x2=21.95 //y2=3.51
cc_2187 ( N_noxref_8_c_3078_n CIN ) capacitor c=0.00688969f //x=21.215 \
 //y=4.27 //x2=21.95 //y2=3.51
cc_2188 ( N_noxref_8_c_3086_n CIN ) capacitor c=0.00722096f //x=21.245 \
 //y=3.495 //x2=21.95 //y2=3.51
cc_2189 ( N_noxref_8_c_2962_n CIN ) capacitor c=0.00227038f //x=21.21 \
 //y=3.335 //x2=23.8 //y2=2.77
cc_2190 ( N_noxref_8_c_3018_n CIN ) capacitor c=4.90612e-19 //x=21.21 \
 //y=4.135 //x2=23.8 //y2=2.77
cc_2191 ( N_noxref_8_c_2966_n CIN ) capacitor c=0.0132081f //x=16.03 //y=4.575 \
 //x2=16.03 //y2=3.14
cc_2192 ( N_noxref_8_c_2991_n CIN ) capacitor c=0.0075172f //x=16.075 \
 //y=4.415 //x2=16.03 //y2=3.14
cc_2193 ( N_noxref_8_c_3020_n CIN ) capacitor c=0.0092811f //x=18.25 //y=3.51 \
 //x2=18.25 //y2=4.62
cc_2194 ( N_noxref_8_c_2978_n CIN ) capacitor c=0.00931051f //x=21.055 \
 //y=4.27 //x2=18.25 //y2=4.62
cc_2195 ( N_noxref_8_c_2962_n CIN ) capacitor c=6.78671e-19 //x=21.21 \
 //y=3.335 //x2=21.95 //y2=3.14
cc_2196 ( N_noxref_8_c_2989_n N_CIN_c_3328_n ) capacitor c=0.0014474f \
 //x=18.25 //y=3.385 //x2=16.03 //y2=2.995
cc_2197 ( N_noxref_8_c_2962_n N_CIN_c_3330_n ) capacitor c=0.017255f //x=21.21 \
 //y=3.335 //x2=21.95 //y2=3.3
cc_2198 ( N_noxref_8_c_2968_n N_CIN_c_3291_n ) capacitor c=0.0135463f \
 //x=21.21 //y=5.055 //x2=21.95 //y2=4.88
cc_2199 ( N_noxref_8_c_2962_n N_CIN_c_3284_n ) capacitor c=0.015237f //x=21.21 \
 //y=3.335 //x2=21.95 //y2=2.265
cc_2200 ( N_noxref_8_c_2962_n N_CIN_c_3285_n ) capacitor c=5.64962e-19 \
 //x=21.21 //y=3.335 //x2=23.8 //y2=2.26
cc_2201 ( N_noxref_8_c_2966_n N_CIN_c_3286_n ) capacitor c=8.94562e-19 \
 //x=16.03 //y=4.575 //x2=20.86 //y2=3.14
cc_2202 ( N_noxref_8_c_2989_n N_CIN_c_3286_n ) capacitor c=0.0236671f \
 //x=18.25 //y=3.385 //x2=20.86 //y2=3.14
cc_2203 ( N_noxref_8_c_2962_n N_CIN_c_3286_n ) capacitor c=9.10138e-19 \
 //x=21.21 //y=3.335 //x2=20.86 //y2=3.14
cc_2204 ( N_noxref_8_c_3054_n N_CIN_c_3286_n ) capacitor c=0.00252824f \
 //x=21.21 //y=3.655 //x2=20.86 //y2=3.14
cc_2205 ( N_noxref_8_c_3020_n N_CIN_c_3286_n ) capacitor c=0.00442261f \
 //x=18.25 //y=3.51 //x2=20.86 //y2=3.14
cc_2206 ( N_noxref_8_c_2977_n N_CIN_c_3286_n ) capacitor c=0.0176563f \
 //x=16.075 //y=4.28 //x2=20.86 //y2=3.14
cc_2207 ( N_noxref_8_c_3021_n N_CIN_c_3286_n ) capacitor c=0.0368037f \
 //x=18.41 //y=3.525 //x2=20.86 //y2=3.14
cc_2208 ( N_noxref_8_c_2996_n N_CIN_c_3286_n ) capacitor c=0.229568f \
 //x=21.085 //y=3.495 //x2=20.86 //y2=3.14
cc_2209 ( N_noxref_8_c_2962_n N_CIN_c_3287_n ) capacitor c=0.02623f //x=21.21 \
 //y=3.335 //x2=21.46 //y2=3.11
cc_2210 ( N_noxref_8_c_3054_n N_CIN_c_3287_n ) capacitor c=0.00405043f \
 //x=21.21 //y=3.655 //x2=21.46 //y2=3.11
cc_2211 ( N_noxref_8_c_3078_n N_CIN_c_3287_n ) capacitor c=9.16478e-19 \
 //x=21.215 //y=4.27 //x2=21.46 //y2=3.11
cc_2212 ( N_noxref_8_c_3086_n N_CIN_c_3287_n ) capacitor c=0.0358686f \
 //x=21.245 //y=3.495 //x2=21.46 //y2=3.11
cc_2213 ( N_noxref_8_c_3054_n N_CIN_c_3492_n ) capacitor c=2.76741e-19 \
 //x=21.21 //y=3.655 //x2=21.43 //y2=4.655
cc_2214 ( N_noxref_8_c_3060_n N_CIN_c_3492_n ) capacitor c=0.00242768f \
 //x=21.21 //y=4.43 //x2=21.43 //y2=4.655
cc_2215 ( N_noxref_8_c_2968_n N_CIN_c_3492_n ) capacitor c=0.0207448f \
 //x=21.21 //y=5.055 //x2=21.43 //y2=4.655
cc_2216 ( N_noxref_8_c_3086_n N_CIN_c_3492_n ) capacitor c=0.00164053f \
 //x=21.245 //y=3.495 //x2=21.43 //y2=4.655
cc_2217 ( N_noxref_8_c_3060_n N_CIN_c_3297_n ) capacitor c=0.00110686f \
 //x=21.21 //y=4.43 //x2=21.085 //y2=4.655
cc_2218 ( N_noxref_8_c_2968_n N_CIN_c_3297_n ) capacitor c=0.00100708f \
 //x=21.21 //y=5.055 //x2=21.085 //y2=4.655
cc_2219 ( N_noxref_8_c_2977_n N_CIN_c_3297_n ) capacitor c=2.52353e-19 \
 //x=16.075 //y=4.28 //x2=21.085 //y2=4.655
cc_2220 ( N_noxref_8_c_3078_n N_CIN_c_3297_n ) capacitor c=0.0358254f \
 //x=21.215 //y=4.27 //x2=21.085 //y2=4.655
cc_2221 ( N_noxref_8_c_2978_n N_CIN_c_3297_n ) capacitor c=0.275182f \
 //x=21.055 //y=4.27 //x2=21.085 //y2=4.655
cc_2222 ( N_noxref_8_c_2996_n N_CIN_c_3297_n ) capacitor c=0.00392621f \
 //x=21.085 //y=3.495 //x2=21.085 //y2=4.655
cc_2223 ( N_noxref_8_c_2968_n N_CIN_c_3300_n ) capacitor c=0.00360945f \
 //x=21.21 //y=5.055 //x2=21.96 //y2=4.885
cc_2224 ( N_noxref_8_c_2968_n N_CIN_c_3303_n ) capacitor c=7.18854e-19 \
 //x=21.21 //y=5.055 //x2=22.12 //y2=4.62
cc_2225 ( N_noxref_8_c_2969_n N_CIN_c_3303_n ) capacitor c=0.00468121f \
 //x=21.49 //y=5.14 //x2=22.12 //y2=4.62
cc_2226 ( N_noxref_8_c_2966_n N_CIN_c_3304_n ) capacitor c=0.00386915f \
 //x=16.03 //y=4.575 //x2=16.19 //y2=3.155
cc_2227 ( N_noxref_8_c_2977_n N_CIN_c_3304_n ) capacitor c=0.00735888f \
 //x=16.075 //y=4.28 //x2=16.19 //y2=3.155
cc_2228 ( N_noxref_8_c_3020_n N_CIN_c_3309_n ) capacitor c=0.00778656f \
 //x=18.25 //y=3.51 //x2=18.25 //y2=4.62
cc_2229 ( N_noxref_8_c_2978_n N_CIN_c_3309_n ) capacitor c=0.00158244f \
 //x=21.055 //y=4.27 //x2=18.25 //y2=4.62
cc_2230 ( N_noxref_8_c_2962_n N_CIN_c_3509_n ) capacitor c=4.71798e-19 \
 //x=21.21 //y=3.335 //x2=21.95 //y2=2.265
cc_2231 ( N_noxref_8_c_2968_n N_CIN_c_3510_n ) capacitor c=5.88334e-19 \
 //x=21.21 //y=5.055 //x2=21.95 //y2=4.88
cc_2232 ( N_noxref_8_c_2969_n N_CIN_M43_noxref_g ) capacitor c=0.00552962f \
 //x=21.49 //y=5.14 //x2=21.355 //y2=6.2
cc_2233 ( N_noxref_8_c_2974_n N_CIN_M43_noxref_g ) capacitor c=0.00222545f \
 //x=21.295 //y=5.14 //x2=21.355 //y2=6.2
cc_2234 ( N_noxref_8_c_2975_n N_CIN_M43_noxref_g ) capacitor c=0.00295423f \
 //x=21.575 //y=5.42 //x2=21.355 //y2=6.2
cc_2235 ( N_noxref_8_c_3159_p N_CIN_M43_noxref_g ) capacitor c=0.0162066f \
 //x=21.575 //y=5.56 //x2=21.355 //y2=6.2
cc_2236 ( N_noxref_8_c_2969_n N_CIN_M44_noxref_g ) capacitor c=0.00450573f \
 //x=21.49 //y=5.14 //x2=21.795 //y2=6.2
cc_2237 ( N_noxref_8_c_2975_n N_CIN_M44_noxref_g ) capacitor c=0.00141266f \
 //x=21.575 //y=5.42 //x2=21.795 //y2=6.2
cc_2238 ( N_noxref_8_c_3159_p N_CIN_M44_noxref_g ) capacitor c=0.0162066f \
 //x=21.575 //y=5.56 //x2=21.795 //y2=6.2
cc_2239 ( N_noxref_8_c_2965_n N_CIN_c_3518_n ) capacitor c=0.00147264f \
 //x=21.58 //y=1.185 //x2=21.31 //y2=1.09
cc_2240 ( N_noxref_8_M11_noxref_d N_CIN_c_3518_n ) capacitor c=0.00136418f \
 //x=21.385 //y=1.09 //x2=21.31 //y2=1.09
cc_2241 ( N_noxref_8_c_2963_n N_CIN_c_3520_n ) capacitor c=0.00153269f \
 //x=21.495 //y=2.02 //x2=21.31 //y2=1.435
cc_2242 ( N_noxref_8_c_3066_n N_CIN_c_3520_n ) capacitor c=0.00322824f \
 //x=21.58 //y=1.935 //x2=21.31 //y2=1.435
cc_2243 ( N_noxref_8_c_2965_n N_CIN_c_3520_n ) capacitor c=0.00350441f \
 //x=21.58 //y=1.185 //x2=21.31 //y2=1.435
cc_2244 ( N_noxref_8_M11_noxref_d N_CIN_c_3520_n ) capacitor c=0.00235934f \
 //x=21.385 //y=1.09 //x2=21.31 //y2=1.435
cc_2245 ( N_noxref_8_c_2969_n N_CIN_c_3524_n ) capacitor c=0.00262283f \
 //x=21.49 //y=5.14 //x2=21.72 //y2=4.97
cc_2246 ( N_noxref_8_c_3159_p N_CIN_c_3524_n ) capacitor c=0.00290963f \
 //x=21.575 //y=5.56 //x2=21.72 //y2=4.97
cc_2247 ( N_noxref_8_c_3060_n N_CIN_c_3526_n ) capacitor c=0.00105397f \
 //x=21.21 //y=4.43 //x2=21.43 //y2=4.97
cc_2248 ( N_noxref_8_c_2968_n N_CIN_c_3526_n ) capacitor c=0.00205067f \
 //x=21.21 //y=5.055 //x2=21.43 //y2=4.97
cc_2249 ( N_noxref_8_c_3072_n N_CIN_c_3526_n ) capacitor c=2.84121e-19 \
 //x=21.21 //y=4.25 //x2=21.43 //y2=4.97
cc_2250 ( N_noxref_8_c_2965_n N_CIN_c_3529_n ) capacitor c=5.57924e-19 \
 //x=21.58 //y=1.185 //x2=21.685 //y2=0.935
cc_2251 ( N_noxref_8_M11_noxref_d N_CIN_c_3529_n ) capacitor c=0.0020782f \
 //x=21.385 //y=1.09 //x2=21.685 //y2=0.935
cc_2252 ( N_noxref_8_c_2963_n N_CIN_c_3531_n ) capacitor c=2.8493e-19 \
 //x=21.495 //y=2.02 //x2=21.685 //y2=1.59
cc_2253 ( N_noxref_8_c_3066_n N_CIN_c_3531_n ) capacitor c=0.00919641f \
 //x=21.58 //y=1.935 //x2=21.685 //y2=1.59
cc_2254 ( N_noxref_8_c_2965_n N_CIN_c_3531_n ) capacitor c=5.77693e-19 \
 //x=21.58 //y=1.185 //x2=21.685 //y2=1.59
cc_2255 ( N_noxref_8_M11_noxref_d N_CIN_c_3531_n ) capacitor c=0.00356097f \
 //x=21.385 //y=1.09 //x2=21.685 //y2=1.59
cc_2256 ( N_noxref_8_c_2965_n N_CIN_c_3535_n ) capacitor c=0.00176376f \
 //x=21.58 //y=1.185 //x2=21.84 //y2=1.09
cc_2257 ( N_noxref_8_M11_noxref_d N_CIN_c_3535_n ) capacitor c=0.00139961f \
 //x=21.385 //y=1.09 //x2=21.84 //y2=1.09
cc_2258 ( N_noxref_8_c_3066_n N_CIN_c_3537_n ) capacitor c=0.00119114f \
 //x=21.58 //y=1.935 //x2=21.84 //y2=1.435
cc_2259 ( N_noxref_8_c_2965_n N_CIN_c_3537_n ) capacitor c=0.00360482f \
 //x=21.58 //y=1.185 //x2=21.84 //y2=1.435
cc_2260 ( N_noxref_8_M11_noxref_d N_CIN_c_3537_n ) capacitor c=0.0023891f \
 //x=21.385 //y=1.09 //x2=21.84 //y2=1.435
cc_2261 ( N_noxref_8_c_3066_n N_CIN_c_3540_n ) capacitor c=0.00546825f \
 //x=21.58 //y=1.935 //x2=21.84 //y2=1.745
cc_2262 ( N_noxref_8_c_3066_n N_CIN_c_3541_n ) capacitor c=0.00392748f \
 //x=21.58 //y=1.935 //x2=21.84 //y2=2.1
cc_2263 ( N_noxref_8_c_2962_n N_CIN_c_3542_n ) capacitor c=0.00256727f \
 //x=21.21 //y=3.335 //x2=21.84 //y2=2.265
cc_2264 ( N_noxref_8_c_2963_n N_CIN_c_3542_n ) capacitor c=0.00392748f \
 //x=21.495 //y=2.02 //x2=21.84 //y2=2.265
cc_2265 ( N_noxref_8_c_3066_n N_noxref_10_c_3718_n ) capacitor c=0.00497605f \
 //x=21.58 //y=1.935 //x2=24.84 //y2=1.75
cc_2266 ( N_noxref_8_c_2965_n N_noxref_10_c_3718_n ) capacitor c=4.16137e-19 \
 //x=21.58 //y=1.185 //x2=24.84 //y2=1.75
cc_2267 ( N_noxref_8_c_3066_n N_noxref_10_c_3692_n ) capacitor c=4.18662e-19 \
 //x=21.58 //y=1.935 //x2=25.28 //y2=3.35
cc_2268 ( N_noxref_8_c_2969_n N_noxref_10_c_3702_n ) capacitor c=0.00184347f \
 //x=21.49 //y=5.14 //x2=25.28 //y2=5.295
cc_2269 ( N_noxref_8_c_2975_n N_noxref_10_c_3707_n ) capacitor c=4.10509e-19 \
 //x=21.575 //y=5.42 //x2=23.92 //y2=5.56
cc_2270 ( N_noxref_8_c_2965_n N_noxref_10_c_3695_n ) capacitor c=6.80839e-19 \
 //x=21.58 //y=1.185 //x2=24.84 //y2=1.18
cc_2271 ( N_noxref_8_c_2974_n N_VDD_c_5104_n ) capacitor c=0.00142941f \
 //x=21.295 //y=5.14 //x2=34.935 //y2=7.585
cc_2272 ( N_noxref_8_c_2975_n N_VDD_c_5104_n ) capacitor c=0.00235763f \
 //x=21.575 //y=5.42 //x2=34.935 //y2=7.585
cc_2273 ( N_noxref_8_c_3159_p N_VDD_c_5104_n ) capacitor c=0.00241566f \
 //x=21.575 //y=5.56 //x2=34.935 //y2=7.585
cc_2274 ( N_noxref_8_M37_noxref_g N_VDD_c_5187_n ) capacitor c=0.00777954f \
 //x=15.7 //y=6.2 //x2=16.97 //y2=7.585
cc_2275 ( N_noxref_8_M38_noxref_g N_VDD_c_5187_n ) capacitor c=0.00758899f \
 //x=16.14 //y=6.2 //x2=16.97 //y2=7.585
cc_2276 ( N_noxref_8_c_2974_n N_VDD_c_5287_n ) capacitor c=0.00113355f \
 //x=21.295 //y=5.14 //x2=21.93 //y2=7.585
cc_2277 ( N_noxref_8_c_2975_n N_VDD_c_5287_n ) capacitor c=8.96756e-19 \
 //x=21.575 //y=5.42 //x2=21.93 //y2=7.585
cc_2278 ( N_noxref_8_c_3159_p N_VDD_c_5287_n ) capacitor c=0.0138017f \
 //x=21.575 //y=5.56 //x2=21.93 //y2=7.585
cc_2279 ( N_noxref_8_c_2991_n N_VDD_c_5132_n ) capacitor c=0.00225757f \
 //x=16.075 //y=4.415 //x2=17.14 //y2=7.585
cc_2280 ( N_noxref_8_c_2978_n N_VDD_c_5132_n ) capacitor c=0.0114993f \
 //x=21.055 //y=4.27 //x2=17.14 //y2=7.585
cc_2281 ( N_noxref_8_c_2997_n N_VDD_c_5132_n ) capacitor c=0.00340357f \
 //x=16.03 //y=4.88 //x2=17.14 //y2=7.585
cc_2282 ( N_noxref_8_c_3004_n N_VDD_c_5132_n ) capacitor c=0.0197064f \
 //x=16.03 //y=4.88 //x2=17.14 //y2=7.585
cc_2283 ( N_noxref_8_c_3060_n N_VDD_c_5135_n ) capacitor c=0.00193791f \
 //x=21.21 //y=4.43 //x2=20.47 //y2=7.585
cc_2284 ( N_noxref_8_c_2968_n N_VDD_c_5135_n ) capacitor c=0.0151037f \
 //x=21.21 //y=5.055 //x2=20.47 //y2=7.585
cc_2285 ( N_noxref_8_c_2975_n N_VDD_c_5135_n ) capacitor c=0.00156f //x=21.575 \
 //y=5.42 //x2=20.47 //y2=7.585
cc_2286 ( N_noxref_8_c_3072_n N_VDD_c_5135_n ) capacitor c=0.00491566f \
 //x=21.21 //y=4.25 //x2=20.47 //y2=7.585
cc_2287 ( N_noxref_8_c_2978_n N_VDD_c_5135_n ) capacitor c=0.00929033f \
 //x=21.055 //y=4.27 //x2=20.47 //y2=7.585
cc_2288 ( N_noxref_8_c_3159_p N_VDD_c_5135_n ) capacitor c=0.00821201f \
 //x=21.575 //y=5.56 //x2=20.47 //y2=7.585
cc_2289 ( N_noxref_8_c_2969_n N_VDD_c_5137_n ) capacitor c=0.00505775f \
 //x=21.49 //y=5.14 //x2=22.69 //y2=7.585
cc_2290 ( N_noxref_8_c_3072_n N_VDD_c_5137_n ) capacitor c=0.00143727f \
 //x=21.21 //y=4.25 //x2=22.69 //y2=7.585
cc_2291 ( N_noxref_8_c_3159_p N_VDD_c_5137_n ) capacitor c=0.00820823f \
 //x=21.575 //y=5.56 //x2=22.69 //y2=7.585
cc_2292 ( N_noxref_8_c_3060_n N_VDD_M43_noxref_s ) capacitor c=0.00400465f \
 //x=21.21 //y=4.43 //x2=21.01 //y2=5.2
cc_2293 ( N_noxref_8_c_2974_n N_VDD_M43_noxref_s ) capacitor c=0.0207447f \
 //x=21.295 //y=5.14 //x2=21.01 //y2=5.2
cc_2294 ( N_noxref_8_c_2975_n N_VDD_M43_noxref_s ) capacitor c=0.0472889f \
 //x=21.575 //y=5.42 //x2=21.01 //y2=5.2
cc_2295 ( N_noxref_8_c_3072_n N_VDD_M43_noxref_s ) capacitor c=0.00133028f \
 //x=21.21 //y=4.25 //x2=21.01 //y2=5.2
cc_2296 ( N_noxref_8_c_3159_p N_VDD_M43_noxref_s ) capacitor c=0.0904293f \
 //x=21.575 //y=5.56 //x2=21.01 //y2=5.2
cc_2297 ( N_noxref_8_c_2975_n N_VDD_M44_noxref_d ) capacitor c=0.0464721f \
 //x=21.575 //y=5.42 //x2=21.87 //y2=5.2
cc_2298 ( N_noxref_8_c_3159_p N_VDD_M44_noxref_d ) capacitor c=0.0897886f \
 //x=21.575 //y=5.56 //x2=21.87 //y2=5.2
cc_2299 ( N_noxref_8_c_2975_n N_VDD_M45_noxref_s ) capacitor c=0.00107615f \
 //x=21.575 //y=5.42 //x2=23.345 //y2=5.2
cc_2300 ( N_noxref_8_M37_noxref_g N_noxref_18_c_5960_n ) capacitor \
 c=0.00726833f //x=15.7 //y=6.2 //x2=16.245 //y2=7.085
cc_2301 ( N_noxref_8_M38_noxref_g N_noxref_18_c_5960_n ) capacitor \
 c=0.00931492f //x=16.14 //y=6.2 //x2=16.245 //y2=7.085
cc_2302 ( N_noxref_8_M37_noxref_g N_noxref_18_c_5962_n ) capacitor \
 c=0.00179653f //x=15.7 //y=6.2 //x2=15.48 //y2=5.385
cc_2303 ( N_noxref_8_M37_noxref_g N_noxref_18_c_5972_n ) capacitor \
 c=0.00179267f //x=15.7 //y=6.2 //x2=15.48 //y2=6.915
cc_2304 ( N_noxref_8_M38_noxref_g N_noxref_18_c_5984_n ) capacitor \
 c=0.00394587f //x=16.14 //y=6.2 //x2=16.36 //y2=6.915
cc_2305 ( N_noxref_8_M37_noxref_g N_noxref_18_c_5975_n ) capacitor \
 c=0.0170175f //x=15.7 //y=6.2 //x2=15.48 //y2=5.555
cc_2306 ( N_noxref_8_M38_noxref_g N_noxref_18_M38_noxref_d ) capacitor \
 c=0.0365939f //x=16.14 //y=6.2 //x2=16.215 //y2=5.2
cc_2307 ( N_noxref_8_c_2961_n N_GND_c_6142_n ) capacitor c=0.00270311f \
 //x=18.25 //y=2.385 //x2=18.32 //y2=1.025
cc_2308 ( N_noxref_8_c_3020_n N_GND_c_6142_n ) capacitor c=2.93809e-19 \
 //x=18.25 //y=3.51 //x2=18.32 //y2=1.025
cc_2309 ( N_noxref_8_c_3000_n N_GND_c_6142_n ) capacitor c=4.17987e-19 \
 //x=18.25 //y=2.265 //x2=18.32 //y2=1.025
cc_2310 ( N_noxref_8_c_3030_n N_GND_c_6142_n ) capacitor c=0.00144305f \
 //x=18.055 //y=1.05 //x2=18.32 //y2=1.025
cc_2311 ( N_noxref_8_c_3031_n N_GND_c_6142_n ) capacitor c=0.00300481f \
 //x=18.055 //y=1.395 //x2=18.32 //y2=1.025
cc_2312 ( N_noxref_8_c_3236_p N_GND_c_6142_n ) capacitor c=0.00942865f \
 //x=18.43 //y=0.895 //x2=18.32 //y2=1.025
cc_2313 ( N_noxref_8_c_3237_p N_GND_c_6142_n ) capacitor c=5.58852e-19 \
 //x=18.43 //y=1.55 //x2=18.32 //y2=1.025
cc_2314 ( N_noxref_8_c_3038_n N_GND_c_6142_n ) capacitor c=0.00170944f \
 //x=18.585 //y=1.05 //x2=18.32 //y2=1.025
cc_2315 ( N_noxref_8_c_3040_n N_GND_c_6142_n ) capacitor c=0.00212338f \
 //x=18.585 //y=1.395 //x2=18.32 //y2=1.025
cc_2316 ( N_noxref_8_c_3054_n N_GND_c_6143_n ) capacitor c=2.90073e-19 \
 //x=21.21 //y=3.655 //x2=23.785 //y2=0.175
cc_2317 ( N_noxref_8_c_2964_n N_GND_c_6143_n ) capacitor c=0.00145429f \
 //x=21.295 //y=2.02 //x2=23.785 //y2=0.175
cc_2318 ( N_noxref_8_c_2965_n N_GND_c_6143_n ) capacitor c=0.00973441f \
 //x=21.58 //y=1.185 //x2=23.785 //y2=0.175
cc_2319 ( N_noxref_8_M11_noxref_d N_GND_c_6143_n ) capacitor c=0.00119455f \
 //x=21.385 //y=1.09 //x2=23.785 //y2=0.175
cc_2320 ( N_noxref_8_c_2965_n N_GND_c_6148_n ) capacitor c=0.00522863f \
 //x=21.58 //y=1.185 //x2=23.87 //y2=1.135
cc_2321 ( N_noxref_8_c_3030_n N_GND_c_6450_n ) capacitor c=0.00684115f \
 //x=18.055 //y=1.05 //x2=20.3 //y2=0.175
cc_2322 ( N_noxref_8_c_2964_n N_GND_c_6474_n ) capacitor c=0.00258806f \
 //x=21.295 //y=2.02 //x2=21.495 //y2=0.715
cc_2323 ( N_noxref_8_c_3071_n N_GND_c_6474_n ) capacitor c=2.56972e-19 \
 //x=21.21 //y=3.51 //x2=21.495 //y2=0.715
cc_2324 ( N_noxref_8_c_2965_n N_GND_c_6474_n ) capacitor c=0.00130539f \
 //x=21.58 //y=1.185 //x2=21.495 //y2=0.715
cc_2325 ( N_noxref_8_c_2965_n N_GND_c_6158_n ) capacitor c=0.00130539f \
 //x=21.58 //y=1.185 //x2=21.975 //y2=0.715
cc_2326 ( N_noxref_8_c_2961_n N_GND_c_6178_n ) capacitor c=0.00325789f \
 //x=18.25 //y=2.385 //x2=17.14 //y2=0.175
cc_2327 ( N_noxref_8_c_2989_n N_GND_c_6178_n ) capacitor c=0.00619643f \
 //x=18.25 //y=3.385 //x2=17.14 //y2=0.175
cc_2328 ( N_noxref_8_c_3000_n N_GND_c_6178_n ) capacitor c=0.00353806f \
 //x=18.25 //y=2.265 //x2=17.14 //y2=0.175
cc_2329 ( N_noxref_8_c_3032_n N_GND_c_6178_n ) capacitor c=0.0015404f \
 //x=18.055 //y=1.705 //x2=17.14 //y2=0.175
cc_2330 ( N_noxref_8_c_3034_n N_GND_c_6178_n ) capacitor c=0.0089051f \
 //x=18.055 //y=2.1 //x2=17.14 //y2=0.175
cc_2331 ( N_noxref_8_c_2963_n N_GND_c_6179_n ) capacitor c=2.4805e-19 \
 //x=21.495 //y=2.02 //x2=20.47 //y2=0.175
cc_2332 ( N_noxref_8_c_2964_n N_GND_c_6179_n ) capacitor c=0.0189738f \
 //x=21.295 //y=2.02 //x2=20.47 //y2=0.175
cc_2333 ( N_noxref_8_c_3066_n N_GND_c_6180_n ) capacitor c=0.00198764f \
 //x=21.58 //y=1.935 //x2=22.69 //y2=0.175
cc_2334 ( N_noxref_8_c_2961_n N_GND_M9_noxref_d ) capacitor c=4.23034e-19 \
 //x=18.25 //y=2.385 //x2=18.13 //y2=1.05
cc_2335 ( N_noxref_8_c_3030_n N_GND_M9_noxref_d ) capacitor c=0.00192399f \
 //x=18.055 //y=1.05 //x2=18.13 //y2=1.05
cc_2336 ( N_noxref_8_c_3031_n N_GND_M9_noxref_d ) capacitor c=0.00210798f \
 //x=18.055 //y=1.395 //x2=18.13 //y2=1.05
cc_2337 ( N_noxref_8_c_3236_p N_GND_M9_noxref_d ) capacitor c=0.00473146f \
 //x=18.43 //y=0.895 //x2=18.13 //y2=1.05
cc_2338 ( N_noxref_8_c_3237_p N_GND_M9_noxref_d ) capacitor c=0.00166857f \
 //x=18.43 //y=1.55 //x2=18.13 //y2=1.05
cc_2339 ( N_noxref_8_c_3038_n N_GND_M9_noxref_d ) capacitor c=0.00230174f \
 //x=18.585 //y=1.05 //x2=18.13 //y2=1.05
cc_2340 ( N_noxref_8_c_3040_n N_GND_M9_noxref_d ) capacitor c=0.00210798f \
 //x=18.585 //y=1.395 //x2=18.13 //y2=1.05
cc_2341 ( N_noxref_8_c_3054_n N_GND_M11_noxref_s ) capacitor c=0.00134951f \
 //x=21.21 //y=3.655 //x2=20.965 //y2=0.55
cc_2342 ( N_noxref_8_c_2964_n N_GND_M11_noxref_s ) capacitor c=0.0033702f \
 //x=21.295 //y=2.02 //x2=20.965 //y2=0.55
cc_2343 ( N_noxref_8_c_3066_n N_GND_M11_noxref_s ) capacitor c=0.0298574f \
 //x=21.58 //y=1.935 //x2=20.965 //y2=0.55
cc_2344 ( N_noxref_8_c_3071_n N_GND_M11_noxref_s ) capacitor c=7.24953e-19 \
 //x=21.21 //y=3.51 //x2=20.965 //y2=0.55
cc_2345 ( N_noxref_8_c_2965_n N_GND_M11_noxref_s ) capacitor c=0.0140714f \
 //x=21.58 //y=1.185 //x2=20.965 //y2=0.55
cc_2346 ( N_noxref_8_M11_noxref_d N_GND_M11_noxref_s ) capacitor c=0.0376931f \
 //x=21.385 //y=1.09 //x2=20.965 //y2=0.55
cc_2347 ( N_noxref_8_c_3034_n N_noxref_26_c_7301_n ) capacitor c=0.00262672f \
 //x=18.055 //y=2.1 //x2=17.835 //y2=1.68
cc_2348 ( N_noxref_8_c_2961_n N_noxref_26_c_7302_n ) capacitor c=0.00528521f \
 //x=18.25 //y=2.385 //x2=18.72 //y2=1.765
cc_2349 ( N_noxref_8_c_3020_n N_noxref_26_c_7302_n ) capacitor c=0.00242244f \
 //x=18.25 //y=3.51 //x2=18.72 //y2=1.765
cc_2350 ( N_noxref_8_c_3000_n N_noxref_26_c_7302_n ) capacitor c=0.00763108f \
 //x=18.25 //y=2.265 //x2=18.72 //y2=1.765
cc_2351 ( N_noxref_8_c_3032_n N_noxref_26_c_7302_n ) capacitor c=0.00697569f \
 //x=18.055 //y=1.705 //x2=18.72 //y2=1.765
cc_2352 ( N_noxref_8_c_3034_n N_noxref_26_c_7302_n ) capacitor c=0.0167993f \
 //x=18.055 //y=2.1 //x2=18.72 //y2=1.765
cc_2353 ( N_noxref_8_c_3237_p N_noxref_26_c_7302_n ) capacitor c=0.00725634f \
 //x=18.43 //y=1.55 //x2=18.72 //y2=1.765
cc_2354 ( N_noxref_8_c_3040_n N_noxref_26_c_7302_n ) capacitor c=0.0034036f \
 //x=18.585 //y=1.395 //x2=18.72 //y2=1.765
cc_2355 ( N_noxref_8_c_3034_n N_noxref_26_c_7303_n ) capacitor c=6.71402e-19 \
 //x=18.055 //y=2.1 //x2=18.805 //y2=1.68
cc_2356 ( N_noxref_8_c_3030_n N_noxref_26_M9_noxref_s ) capacitor c=0.0294925f \
 //x=18.055 //y=1.05 //x2=17.7 //y2=0.55
cc_2357 ( N_noxref_8_c_3032_n N_noxref_26_M9_noxref_s ) capacitor \
 c=3.48408e-19 //x=18.055 //y=1.705 //x2=17.7 //y2=0.55
cc_2358 ( N_noxref_8_c_3038_n N_noxref_26_M9_noxref_s ) capacitor c=0.0125442f \
 //x=18.585 //y=1.05 //x2=17.7 //y2=0.55
cc_2359 ( N_CIN_M46_noxref_g N_noxref_10_c_3700_n ) capacitor c=0.00806083f \
 //x=24.14 //y=6.2 //x2=24.685 //y2=5.38
cc_2360 ( CIN N_noxref_10_c_3692_n ) capacitor c=0.00367958f //x=23.8 //y=2.77 \
 //x2=25.28 //y2=3.35
cc_2361 ( CIN N_noxref_10_c_3702_n ) capacitor c=0.0019133f //x=23.8 //y=2.77 \
 //x2=25.28 //y2=5.295
cc_2362 ( CIN N_noxref_10_c_3707_n ) capacitor c=0.0116219f //x=23.8 //y=4.62 \
 //x2=23.92 //y2=5.56
cc_2363 ( N_CIN_c_3312_n N_noxref_10_c_3707_n ) capacitor c=0.00279623f \
 //x=23.8 //y=4.62 //x2=23.92 //y2=5.56
cc_2364 ( N_CIN_M45_noxref_g N_noxref_10_c_3707_n ) capacitor c=0.0020367f \
 //x=23.7 //y=6.2 //x2=23.92 //y2=5.56
cc_2365 ( N_CIN_M46_noxref_g N_noxref_10_c_3707_n ) capacitor c=0.00192712f \
 //x=24.14 //y=6.2 //x2=23.92 //y2=5.56
cc_2366 ( N_CIN_c_3382_n N_noxref_10_c_3707_n ) capacitor c=0.00194843f \
 //x=23.8 //y=4.88 //x2=23.92 //y2=5.56
cc_2367 ( CIN N_noxref_10_c_3773_n ) capacitor c=0.00234507f //x=23.8 //y=4.62 \
 //x2=23.92 //y2=5.56
cc_2368 ( N_CIN_c_3312_n N_noxref_10_c_3773_n ) capacitor c=0.00377297f \
 //x=23.8 //y=4.62 //x2=23.92 //y2=5.56
cc_2369 ( N_CIN_M45_noxref_g N_noxref_10_c_3773_n ) capacitor c=0.0158358f \
 //x=23.7 //y=6.2 //x2=23.92 //y2=5.56
cc_2370 ( N_CIN_M46_noxref_g N_noxref_10_c_3773_n ) capacitor c=0.0178987f \
 //x=24.14 //y=6.2 //x2=23.92 //y2=5.56
cc_2371 ( N_CIN_c_3382_n N_noxref_10_c_3773_n ) capacitor c=0.00438961f \
 //x=23.8 //y=4.88 //x2=23.92 //y2=5.56
cc_2372 ( N_CIN_M39_noxref_g N_VDD_c_5103_n ) capacitor c=0.00365752f \
 //x=18.15 //y=6.2 //x2=18.37 //y2=6.69
cc_2373 ( N_CIN_M40_noxref_g N_VDD_c_5103_n ) capacitor c=0.00387858f \
 //x=18.59 //y=6.2 //x2=18.37 //y2=6.69
cc_2374 ( N_CIN_M39_noxref_g N_VDD_c_5313_n ) capacitor c=0.00522062f \
 //x=18.15 //y=6.2 //x2=18.37 //y2=7.41
cc_2375 ( N_CIN_M40_noxref_g N_VDD_c_5313_n ) capacitor c=0.00588679f \
 //x=18.59 //y=6.2 //x2=18.37 //y2=7.41
cc_2376 ( CIN N_VDD_c_5104_n ) capacitor c=5.94528e-19 //x=23.8 //y=4.62 \
 //x2=34.935 //y2=7.585
cc_2377 ( N_CIN_c_3510_n N_VDD_c_5104_n ) capacitor c=3.40755e-19 //x=21.95 \
 //y=4.88 //x2=34.935 //y2=7.585
cc_2378 ( N_CIN_c_3312_n N_VDD_c_5104_n ) capacitor c=6.18284e-19 //x=23.8 \
 //y=4.62 //x2=34.935 //y2=7.585
cc_2379 ( N_CIN_M39_noxref_g N_VDD_c_5245_n ) capacitor c=0.00750251f \
 //x=18.15 //y=6.2 //x2=20.3 //y2=7.585
cc_2380 ( N_CIN_M40_noxref_g N_VDD_c_5245_n ) capacitor c=0.00773472f \
 //x=18.59 //y=6.2 //x2=20.3 //y2=7.585
cc_2381 ( N_CIN_c_3291_n N_VDD_c_5287_n ) capacitor c=2.31683e-19 //x=21.95 \
 //y=4.88 //x2=21.93 //y2=7.585
cc_2382 ( N_CIN_M43_noxref_g N_VDD_c_5287_n ) capacitor c=0.00751326f \
 //x=21.355 //y=6.2 //x2=21.93 //y2=7.585
cc_2383 ( N_CIN_M44_noxref_g N_VDD_c_5287_n ) capacitor c=0.00753931f \
 //x=21.795 //y=6.2 //x2=21.93 //y2=7.585
cc_2384 ( CIN N_VDD_c_5323_n ) capacitor c=5.07929e-19 //x=23.8 //y=4.62 \
 //x2=24.275 //y2=7.585
cc_2385 ( N_CIN_M45_noxref_g N_VDD_c_5323_n ) capacitor c=0.00732618f //x=23.7 \
 //y=6.2 //x2=24.275 //y2=7.585
cc_2386 ( N_CIN_M46_noxref_g N_VDD_c_5323_n ) capacitor c=0.00755544f \
 //x=24.14 //y=6.2 //x2=24.275 //y2=7.585
cc_2387 ( CIN N_VDD_c_5132_n ) capacitor c=0.00343839f //x=18.25 //y=4.62 \
 //x2=17.14 //y2=7.585
cc_2388 ( N_CIN_c_3309_n N_VDD_c_5132_n ) capacitor c=0.00965911f //x=18.25 \
 //y=4.62 //x2=17.14 //y2=7.585
cc_2389 ( N_CIN_c_3404_n N_VDD_c_5132_n ) capacitor c=0.0157652f //x=18.25 \
 //y=4.88 //x2=17.14 //y2=7.585
cc_2390 ( N_CIN_c_3297_n N_VDD_c_5135_n ) capacitor c=0.0152271f //x=21.085 \
 //y=4.655 //x2=20.47 //y2=7.585
cc_2391 ( N_CIN_c_3309_n N_VDD_c_5135_n ) capacitor c=0.00149513f //x=18.25 \
 //y=4.62 //x2=20.47 //y2=7.585
cc_2392 ( N_CIN_c_3510_n N_VDD_c_5135_n ) capacitor c=0.00209414f //x=21.95 \
 //y=4.88 //x2=20.47 //y2=7.585
cc_2393 ( N_CIN_c_3526_n N_VDD_c_5135_n ) capacitor c=0.00882729f //x=21.43 \
 //y=4.97 //x2=20.47 //y2=7.585
cc_2394 ( N_CIN_c_3579_p N_VDD_c_5135_n ) capacitor c=2.63786e-19 //x=21.795 \
 //y=5.045 //x2=20.47 //y2=7.585
cc_2395 ( CIN N_VDD_c_5137_n ) capacitor c=0.00880779f //x=21.95 //y=3.51 \
 //x2=22.69 //y2=7.585
cc_2396 ( CIN N_VDD_c_5137_n ) capacitor c=0.00284886f //x=23.8 //y=2.77 \
 //x2=22.69 //y2=7.585
cc_2397 ( CIN N_VDD_c_5137_n ) capacitor c=0.00631027f //x=23.8 //y=4.62 \
 //x2=22.69 //y2=7.585
cc_2398 ( N_CIN_c_3291_n N_VDD_c_5137_n ) capacitor c=0.00446111f //x=21.95 \
 //y=4.88 //x2=22.69 //y2=7.585
cc_2399 ( N_CIN_c_3300_n N_VDD_c_5137_n ) capacitor c=2.95282e-19 //x=21.96 \
 //y=4.885 //x2=22.69 //y2=7.585
cc_2400 ( N_CIN_c_3306_n N_VDD_c_5137_n ) capacitor c=0.0152533f //x=23.635 \
 //y=4.625 //x2=22.69 //y2=7.585
cc_2401 ( N_CIN_c_3510_n N_VDD_c_5137_n ) capacitor c=0.00820274f //x=21.95 \
 //y=4.88 //x2=22.69 //y2=7.585
cc_2402 ( N_CIN_c_3312_n N_VDD_c_5137_n ) capacitor c=0.00806138f //x=23.8 \
 //y=4.62 //x2=22.69 //y2=7.585
cc_2403 ( N_CIN_M44_noxref_g N_VDD_c_5137_n ) capacitor c=0.00628055f \
 //x=21.795 //y=6.2 //x2=22.69 //y2=7.585
cc_2404 ( N_CIN_c_3579_p N_VDD_c_5137_n ) capacitor c=0.00606577f //x=21.795 \
 //y=5.045 //x2=22.69 //y2=7.585
cc_2405 ( N_CIN_c_3382_n N_VDD_c_5137_n ) capacitor c=0.0111004f //x=23.8 \
 //y=4.88 //x2=22.69 //y2=7.585
cc_2406 ( N_CIN_c_3312_n N_VDD_c_5139_n ) capacitor c=0.00156448f //x=23.8 \
 //y=4.62 //x2=26.02 //y2=7.585
cc_2407 ( N_CIN_c_3309_n N_VDD_M39_noxref_d ) capacitor c=0.00176891f \
 //x=18.25 //y=4.62 //x2=18.225 //y2=5.2
cc_2408 ( N_CIN_M39_noxref_g N_VDD_M39_noxref_d ) capacitor c=0.00896756f \
 //x=18.15 //y=6.2 //x2=18.225 //y2=5.2
cc_2409 ( N_CIN_M40_noxref_g N_VDD_M39_noxref_d ) capacitor c=0.00896756f \
 //x=18.59 //y=6.2 //x2=18.225 //y2=5.2
cc_2410 ( N_CIN_c_3404_n N_VDD_M39_noxref_d ) capacitor c=0.00318882f \
 //x=18.25 //y=4.88 //x2=18.225 //y2=5.2
cc_2411 ( N_CIN_M43_noxref_g N_VDD_M43_noxref_s ) capacitor c=0.0572684f \
 //x=21.355 //y=6.2 //x2=21.01 //y2=5.2
cc_2412 ( N_CIN_c_3291_n N_VDD_M44_noxref_d ) capacitor c=0.0192846f //x=21.95 \
 //y=4.88 //x2=21.87 //y2=5.2
cc_2413 ( N_CIN_c_3510_n N_VDD_M44_noxref_d ) capacitor c=0.00971644f \
 //x=21.95 //y=4.88 //x2=21.87 //y2=5.2
cc_2414 ( N_CIN_M44_noxref_g N_VDD_M44_noxref_d ) capacitor c=0.0573304f \
 //x=21.795 //y=6.2 //x2=21.87 //y2=5.2
cc_2415 ( N_CIN_c_3579_p N_VDD_M44_noxref_d ) capacitor c=0.00459286f \
 //x=21.795 //y=5.045 //x2=21.87 //y2=5.2
cc_2416 ( CIN N_VDD_M45_noxref_s ) capacitor c=0.00357457f //x=23.8 //y=4.62 \
 //x2=23.345 //y2=5.2
cc_2417 ( N_CIN_M45_noxref_g N_VDD_M45_noxref_s ) capacitor c=0.0567929f \
 //x=23.7 //y=6.2 //x2=23.345 //y2=5.2
cc_2418 ( N_CIN_M46_noxref_g N_VDD_M46_noxref_d ) capacitor c=0.015318f \
 //x=24.14 //y=6.2 //x2=24.215 //y2=5.2
cc_2419 ( CIN N_noxref_19_c_6041_n ) capacitor c=0.0189989f //x=18.25 //y=4.62 \
 //x2=18.695 //y2=5.385
cc_2420 ( N_CIN_c_3309_n N_noxref_19_c_6041_n ) capacitor c=0.00477626f \
 //x=18.25 //y=4.62 //x2=18.695 //y2=5.385
cc_2421 ( N_CIN_M39_noxref_g N_noxref_19_c_6041_n ) capacitor c=0.0109603f \
 //x=18.15 //y=6.2 //x2=18.695 //y2=5.385
cc_2422 ( N_CIN_M40_noxref_g N_noxref_19_c_6041_n ) capacitor c=0.00954785f \
 //x=18.59 //y=6.2 //x2=18.695 //y2=5.385
cc_2423 ( N_CIN_c_3404_n N_noxref_19_c_6041_n ) capacitor c=0.00131275f \
 //x=18.25 //y=4.88 //x2=18.695 //y2=5.385
cc_2424 ( N_CIN_M39_noxref_g N_noxref_19_c_6043_n ) capacitor c=0.00394587f \
 //x=18.15 //y=6.2 //x2=17.93 //y2=5.385
cc_2425 ( N_CIN_M40_noxref_g N_noxref_19_c_6045_n ) capacitor c=0.00179267f \
 //x=18.59 //y=6.2 //x2=18.81 //y2=5.385
cc_2426 ( N_CIN_M40_noxref_g N_noxref_19_c_6051_n ) capacitor c=0.00182026f \
 //x=18.59 //y=6.2 //x2=18.81 //y2=6.915
cc_2427 ( N_CIN_M39_noxref_g N_noxref_19_c_6077_n ) capacitor c=0.046753f \
 //x=18.15 //y=6.2 //x2=17.93 //y2=5.555
cc_2428 ( N_CIN_M40_noxref_g N_noxref_19_c_6053_n ) capacitor c=0.0184757f \
 //x=18.59 //y=6.2 //x2=18.81 //y2=5.555
cc_2429 ( N_CIN_M39_noxref_g N_noxref_19_M39_noxref_s ) capacitor \
 c=0.00526487f //x=18.15 //y=6.2 //x2=17.795 //y2=5.2
cc_2430 ( N_CIN_c_3330_n N_GND_c_6143_n ) capacitor c=2.28791e-19 //x=21.95 \
 //y=3.3 //x2=23.785 //y2=0.175
cc_2431 ( N_CIN_c_3284_n N_GND_c_6143_n ) capacitor c=7.37182e-19 //x=21.95 \
 //y=2.265 //x2=23.785 //y2=0.175
cc_2432 ( N_CIN_c_3509_n N_GND_c_6143_n ) capacitor c=7.5371e-19 //x=21.95 \
 //y=2.265 //x2=23.785 //y2=0.175
cc_2433 ( N_CIN_c_3285_n N_GND_c_6148_n ) capacitor c=0.00387972f //x=23.8 \
 //y=2.26 //x2=23.87 //y2=1.135
cc_2434 ( N_CIN_c_3346_n N_GND_c_6148_n ) capacitor c=2.13705e-19 //x=23.8 \
 //y=2.26 //x2=23.87 //y2=1.135
cc_2435 ( N_CIN_c_3369_n N_GND_c_6148_n ) capacitor c=0.00175272f //x=23.605 \
 //y=1.045 //x2=23.87 //y2=1.135
cc_2436 ( N_CIN_c_3370_n N_GND_c_6148_n ) capacitor c=0.00354198f //x=23.605 \
 //y=1.39 //x2=23.87 //y2=1.135
cc_2437 ( N_CIN_c_3371_n N_GND_c_6148_n ) capacitor c=4.2764e-19 //x=23.605 \
 //y=1.7 //x2=23.87 //y2=1.135
cc_2438 ( N_CIN_c_3623_p N_GND_c_6148_n ) capacitor c=9.36995e-19 //x=23.98 \
 //y=0.89 //x2=23.87 //y2=1.135
cc_2439 ( N_CIN_c_3624_p N_GND_c_6148_n ) capacitor c=6.38426e-19 //x=23.98 \
 //y=1.545 //x2=23.87 //y2=1.135
cc_2440 ( N_CIN_c_3377_n N_GND_c_6148_n ) capacitor c=0.00174905f //x=24.135 \
 //y=1.045 //x2=23.87 //y2=1.135
cc_2441 ( N_CIN_c_3379_n N_GND_c_6148_n ) capacitor c=0.00296337f //x=24.135 \
 //y=1.39 //x2=23.87 //y2=1.135
cc_2442 ( N_CIN_c_3369_n N_GND_c_6511_n ) capacitor c=3.51399e-19 //x=23.605 \
 //y=1.045 //x2=23.867 //y2=1.005
cc_2443 ( N_CIN_c_3623_p N_GND_c_6511_n ) capacitor c=0.00864609f //x=23.98 \
 //y=0.89 //x2=23.867 //y2=1.005
cc_2444 ( N_CIN_c_3377_n N_GND_c_6511_n ) capacitor c=4.45447e-19 //x=24.135 \
 //y=1.045 //x2=23.867 //y2=1.005
cc_2445 ( N_CIN_c_3518_n N_GND_c_6474_n ) capacitor c=0.0132669f //x=21.31 \
 //y=1.09 //x2=21.495 //y2=0.715
cc_2446 ( N_CIN_c_3330_n N_GND_c_6158_n ) capacitor c=6.82669e-19 //x=21.95 \
 //y=3.3 //x2=21.975 //y2=0.715
cc_2447 ( N_CIN_c_3284_n N_GND_c_6158_n ) capacitor c=0.00114179f //x=21.95 \
 //y=2.265 //x2=21.975 //y2=0.715
cc_2448 ( N_CIN_c_3509_n N_GND_c_6158_n ) capacitor c=3.95714e-19 //x=21.95 \
 //y=2.265 //x2=21.975 //y2=0.715
cc_2449 ( N_CIN_c_3535_n N_GND_c_6158_n ) capacitor c=0.0126466f //x=21.84 \
 //y=1.09 //x2=21.975 //y2=0.715
cc_2450 ( N_CIN_c_3542_n N_GND_c_6158_n ) capacitor c=2.1838e-19 //x=21.84 \
 //y=2.265 //x2=21.975 //y2=0.715
cc_2451 ( N_CIN_c_3369_n N_GND_c_6361_n ) capacitor c=0.00688027f //x=23.605 \
 //y=1.045 //x2=25.85 //y2=0.175
cc_2452 ( N_CIN_c_3286_n N_GND_c_6178_n ) capacitor c=0.00411812f //x=20.86 \
 //y=3.14 //x2=17.14 //y2=0.175
cc_2453 ( N_CIN_c_3343_n N_GND_c_6178_n ) capacitor c=0.00340847f //x=16.03 \
 //y=2.265 //x2=17.14 //y2=0.175
cc_2454 ( N_CIN_c_3364_n N_GND_c_6178_n ) capacitor c=0.00564554f //x=15.695 \
 //y=2.1 //x2=17.14 //y2=0.175
cc_2455 ( N_CIN_c_3368_n N_GND_c_6178_n ) capacitor c=0.00230557f //x=16.225 \
 //y=1.435 //x2=17.14 //y2=0.175
cc_2456 ( N_CIN_c_3286_n N_GND_c_6179_n ) capacitor c=0.00504399f //x=20.86 \
 //y=3.14 //x2=20.47 //y2=0.175
cc_2457 ( N_CIN_c_3509_n N_GND_c_6179_n ) capacitor c=0.00199543f //x=21.95 \
 //y=2.265 //x2=20.47 //y2=0.175
cc_2458 ( N_CIN_c_3542_n N_GND_c_6179_n ) capacitor c=2.63786e-19 //x=21.84 \
 //y=2.265 //x2=20.47 //y2=0.175
cc_2459 ( CIN N_GND_c_6180_n ) capacitor c=0.0108451f //x=21.95 //y=2.77 \
 //x2=22.69 //y2=0.175
cc_2460 ( CIN N_GND_c_6180_n ) capacitor c=0.00780945f //x=23.8 //y=2.77 \
 //x2=22.69 //y2=0.175
cc_2461 ( N_CIN_c_3284_n N_GND_c_6180_n ) capacitor c=0.00558413f //x=21.95 \
 //y=2.265 //x2=22.69 //y2=0.175
cc_2462 ( N_CIN_c_3285_n N_GND_c_6180_n ) capacitor c=0.00361577f //x=23.8 \
 //y=2.26 //x2=22.69 //y2=0.175
cc_2463 ( N_CIN_c_3306_n N_GND_c_6180_n ) capacitor c=0.00178286f //x=23.635 \
 //y=4.625 //x2=22.69 //y2=0.175
cc_2464 ( N_CIN_c_3509_n N_GND_c_6180_n ) capacitor c=0.00756244f //x=21.95 \
 //y=2.265 //x2=22.69 //y2=0.175
cc_2465 ( N_CIN_c_3346_n N_GND_c_6180_n ) capacitor c=0.00354414f //x=23.8 \
 //y=2.26 //x2=22.69 //y2=0.175
cc_2466 ( N_CIN_c_3541_n N_GND_c_6180_n ) capacitor c=0.00311736f //x=21.84 \
 //y=2.1 //x2=22.69 //y2=0.175
cc_2467 ( N_CIN_c_3373_n N_GND_c_6180_n ) capacitor c=0.00873019f //x=23.605 \
 //y=2.095 //x2=22.69 //y2=0.175
cc_2468 ( N_CIN_c_3542_n N_GND_c_6180_n ) capacitor c=0.00770411f //x=21.84 \
 //y=2.265 //x2=22.69 //y2=0.175
cc_2469 ( N_CIN_c_3330_n N_GND_M11_noxref_s ) capacitor c=5.465e-19 //x=21.95 \
 //y=3.3 //x2=20.965 //y2=0.55
cc_2470 ( N_CIN_c_3284_n N_GND_M11_noxref_s ) capacitor c=0.00297876f \
 //x=21.95 //y=2.265 //x2=20.965 //y2=0.55
cc_2471 ( N_CIN_c_3509_n N_GND_M11_noxref_s ) capacitor c=0.00651326f \
 //x=21.95 //y=2.265 //x2=20.965 //y2=0.55
cc_2472 ( N_CIN_c_3518_n N_GND_M11_noxref_s ) capacitor c=0.0153553f //x=21.31 \
 //y=1.09 //x2=20.965 //y2=0.55
cc_2473 ( N_CIN_c_3520_n N_GND_M11_noxref_s ) capacitor c=0.00629878f \
 //x=21.31 //y=1.435 //x2=20.965 //y2=0.55
cc_2474 ( N_CIN_c_3529_n N_GND_M11_noxref_s ) capacitor c=0.00521375f \
 //x=21.685 //y=0.935 //x2=20.965 //y2=0.55
cc_2475 ( N_CIN_c_3535_n N_GND_M11_noxref_s ) capacitor c=0.0300873f //x=21.84 \
 //y=1.09 //x2=20.965 //y2=0.55
cc_2476 ( N_CIN_c_3540_n N_GND_M11_noxref_s ) capacitor c=0.002132f //x=21.84 \
 //y=1.745 //x2=20.965 //y2=0.55
cc_2477 ( N_CIN_c_3541_n N_GND_M11_noxref_s ) capacitor c=0.00304786f \
 //x=21.84 //y=2.1 //x2=20.965 //y2=0.55
cc_2478 ( N_CIN_c_3542_n N_GND_M11_noxref_s ) capacitor c=0.00404577f \
 //x=21.84 //y=2.265 //x2=20.965 //y2=0.55
cc_2479 ( N_CIN_c_3285_n N_GND_M12_noxref_d ) capacitor c=2.20438e-19 //x=23.8 \
 //y=2.26 //x2=23.68 //y2=1.045
cc_2480 ( N_CIN_c_3369_n N_GND_M12_noxref_d ) capacitor c=0.00192399f \
 //x=23.605 //y=1.045 //x2=23.68 //y2=1.045
cc_2481 ( N_CIN_c_3370_n N_GND_M12_noxref_d ) capacitor c=0.00210798f \
 //x=23.605 //y=1.39 //x2=23.68 //y2=1.045
cc_2482 ( N_CIN_c_3623_p N_GND_M12_noxref_d ) capacitor c=0.00472259f \
 //x=23.98 //y=0.89 //x2=23.68 //y2=1.045
cc_2483 ( N_CIN_c_3624_p N_GND_M12_noxref_d ) capacitor c=0.00166857f \
 //x=23.98 //y=1.545 //x2=23.68 //y2=1.045
cc_2484 ( N_CIN_c_3377_n N_GND_M12_noxref_d ) capacitor c=0.00230174f \
 //x=24.135 //y=1.045 //x2=23.68 //y2=1.045
cc_2485 ( N_CIN_c_3379_n N_GND_M12_noxref_d ) capacitor c=0.00210798f \
 //x=24.135 //y=1.39 //x2=23.68 //y2=1.045
cc_2486 ( N_CIN_c_3361_n N_noxref_25_c_7242_n ) capacitor c=0.00888238f \
 //x=15.695 //y=1.745 //x2=15.475 //y2=1.68
cc_2487 ( N_CIN_c_3343_n N_noxref_25_c_7243_n ) capacitor c=4.16328e-19 \
 //x=16.03 //y=2.265 //x2=16.36 //y2=0.715
cc_2488 ( N_CIN_c_3356_n N_noxref_25_c_7243_n ) capacitor c=0.0204604f \
 //x=15.695 //y=1.09 //x2=16.36 //y2=0.715
cc_2489 ( N_CIN_c_3364_n N_noxref_25_c_7243_n ) capacitor c=2.1838e-19 \
 //x=15.695 //y=2.1 //x2=16.36 //y2=0.715
cc_2490 ( N_CIN_c_3367_n N_noxref_25_c_7243_n ) capacitor c=0.00825432f \
 //x=16.225 //y=1.09 //x2=16.36 //y2=0.715
cc_2491 ( N_CIN_c_3356_n N_noxref_25_M7_noxref_s ) capacitor c=0.00888238f \
 //x=15.695 //y=1.09 //x2=14.37 //y2=0.55
cc_2492 ( N_CIN_c_3367_n N_noxref_25_M7_noxref_s ) capacitor c=0.015333f \
 //x=16.225 //y=1.09 //x2=14.37 //y2=0.55
cc_2493 ( N_CIN_c_3368_n N_noxref_25_M7_noxref_s ) capacitor c=0.00248746f \
 //x=16.225 //y=1.435 //x2=14.37 //y2=0.55
cc_2494 ( N_CIN_c_3373_n N_noxref_27_c_7365_n ) capacitor c=0.00262672f \
 //x=23.605 //y=2.095 //x2=23.385 //y2=1.675
cc_2495 ( CIN N_noxref_27_c_7366_n ) capacitor c=0.00305537f //x=23.8 //y=4.62 \
 //x2=24.27 //y2=1.76
cc_2496 ( N_CIN_c_3285_n N_noxref_27_c_7366_n ) capacitor c=0.00454254f \
 //x=23.8 //y=2.26 //x2=24.27 //y2=1.76
cc_2497 ( N_CIN_c_3346_n N_noxref_27_c_7366_n ) capacitor c=0.00763108f \
 //x=23.8 //y=2.26 //x2=24.27 //y2=1.76
cc_2498 ( N_CIN_c_3371_n N_noxref_27_c_7366_n ) capacitor c=0.00697076f \
 //x=23.605 //y=1.7 //x2=24.27 //y2=1.76
cc_2499 ( N_CIN_c_3373_n N_noxref_27_c_7366_n ) capacitor c=0.0168006f \
 //x=23.605 //y=2.095 //x2=24.27 //y2=1.76
cc_2500 ( N_CIN_c_3624_p N_noxref_27_c_7366_n ) capacitor c=0.00723574f \
 //x=23.98 //y=1.545 //x2=24.27 //y2=1.76
cc_2501 ( N_CIN_c_3379_n N_noxref_27_c_7366_n ) capacitor c=0.00339872f \
 //x=24.135 //y=1.39 //x2=24.27 //y2=1.76
cc_2502 ( N_CIN_c_3373_n N_noxref_27_c_7367_n ) capacitor c=6.71402e-19 \
 //x=23.605 //y=2.095 //x2=24.355 //y2=1.675
cc_2503 ( N_CIN_c_3369_n N_noxref_27_M12_noxref_s ) capacitor c=0.0294925f \
 //x=23.605 //y=1.045 //x2=23.25 //y2=0.545
cc_2504 ( N_CIN_c_3371_n N_noxref_27_M12_noxref_s ) capacitor c=3.48408e-19 \
 //x=23.605 //y=1.7 //x2=23.25 //y2=0.545
cc_2505 ( N_CIN_c_3377_n N_noxref_27_M12_noxref_s ) capacitor c=0.0125442f \
 //x=24.135 //y=1.045 //x2=23.25 //y2=0.545
cc_2506 ( N_noxref_10_c_3718_n N_noxref_12_c_4216_n ) capacitor c=0.00466656f \
 //x=24.84 //y=1.75 //x2=27.13 //y2=1.935
cc_2507 ( N_noxref_10_c_3724_n N_noxref_12_c_4216_n ) capacitor c=0.00203846f \
 //x=25.195 //y=1.835 //x2=27.13 //y2=1.935
cc_2508 ( N_noxref_10_c_3780_p N_noxref_12_c_4216_n ) capacitor c=0.00108934f \
 //x=26.87 //y=1.435 //x2=27.13 //y2=1.935
cc_2509 ( N_noxref_10_c_3781_p N_noxref_12_c_4216_n ) capacitor c=0.00524682f \
 //x=26.87 //y=1.745 //x2=27.13 //y2=1.935
cc_2510 ( N_noxref_10_c_3782_p N_noxref_12_c_4216_n ) capacitor c=0.00352777f \
 //x=26.87 //y=2.1 //x2=27.13 //y2=1.935
cc_2511 ( N_noxref_10_c_3783_p N_noxref_12_c_4216_n ) capacitor c=0.00918832f \
 //x=27.245 //y=1.59 //x2=27.13 //y2=1.935
cc_2512 ( N_noxref_10_c_3784_p N_noxref_12_c_4216_n ) capacitor c=0.00344663f \
 //x=27.4 //y=1.435 //x2=27.13 //y2=1.935
cc_2513 ( N_noxref_10_c_3723_n N_noxref_12_c_4200_n ) capacitor c=0.00290594f \
 //x=25.195 //y=5.38 //x2=27.135 //y2=5.42
cc_2514 ( N_noxref_10_c_3739_n N_noxref_12_c_4200_n ) capacitor c=5.44332e-19 \
 //x=24.8 //y=5.38 //x2=27.135 //y2=5.42
cc_2515 ( N_noxref_10_M49_noxref_g N_noxref_12_c_4200_n ) capacitor \
 c=0.00141266f //x=26.915 //y=6.2 //x2=27.135 //y2=5.42
cc_2516 ( N_noxref_10_M50_noxref_g N_noxref_12_c_4200_n ) capacitor \
 c=0.0035262f //x=27.355 //y=6.2 //x2=27.135 //y2=5.42
cc_2517 ( N_noxref_10_c_3783_p N_noxref_12_c_4187_n ) capacitor c=0.00153269f \
 //x=27.245 //y=1.59 //x2=27.415 //y2=2.02
cc_2518 ( N_noxref_10_c_3692_n N_noxref_12_c_4188_n ) capacitor c=0.00203846f \
 //x=25.28 //y=3.35 //x2=27.215 //y2=2.02
cc_2519 ( N_noxref_10_c_3783_p N_noxref_12_c_4188_n ) capacitor c=2.8493e-19 \
 //x=27.245 //y=1.59 //x2=27.215 //y2=2.02
cc_2520 ( N_noxref_10_c_3792_p N_noxref_12_c_4188_n ) capacitor c=0.00352777f \
 //x=26.76 //y=2.265 //x2=27.215 //y2=2.02
cc_2521 ( N_noxref_10_M50_noxref_g N_noxref_12_c_4201_n ) capacitor \
 c=0.00915175f //x=27.355 //y=6.2 //x2=27.415 //y2=5.14
cc_2522 ( N_noxref_10_c_3702_n N_noxref_12_c_4202_n ) capacitor c=0.00272999f \
 //x=25.28 //y=5.295 //x2=27.22 //y2=5.14
cc_2523 ( N_noxref_10_M49_noxref_g N_noxref_12_c_4202_n ) capacitor \
 c=0.00421745f //x=26.915 //y=6.2 //x2=27.22 //y2=5.14
cc_2524 ( N_noxref_10_c_3796_p N_noxref_12_c_4202_n ) capacitor c=0.00224237f \
 //x=27.28 //y=4.97 //x2=27.22 //y2=5.14
cc_2525 ( N_noxref_10_c_3692_n N_noxref_12_c_4189_n ) capacitor c=0.00286576f \
 //x=25.28 //y=3.35 //x2=27.5 //y2=2.99
cc_2526 ( N_noxref_10_c_3703_n N_noxref_12_c_4189_n ) capacitor c=0.0236114f \
 //x=26.76 //y=3.35 //x2=27.5 //y2=2.99
cc_2527 ( N_noxref_10_c_3696_n N_noxref_12_c_4189_n ) capacitor c=0.017436f \
 //x=26.76 //y=2.265 //x2=27.5 //y2=2.99
cc_2528 ( N_noxref_10_c_3800_p N_noxref_12_c_4189_n ) capacitor c=4.71798e-19 \
 //x=26.76 //y=2.265 //x2=27.5 //y2=2.99
cc_2529 ( N_noxref_10_c_3792_p N_noxref_12_c_4189_n ) capacitor c=0.00267825f \
 //x=26.76 //y=2.265 //x2=27.5 //y2=2.99
cc_2530 ( N_noxref_10_c_3703_n N_noxref_12_c_4191_n ) capacitor c=0.0148575f \
 //x=26.76 //y=3.35 //x2=27.5 //y2=3.31
cc_2531 ( N_noxref_10_c_3702_n N_noxref_12_c_4192_n ) capacitor c=0.002817f \
 //x=25.28 //y=5.295 //x2=27.5 //y2=5.055
cc_2532 ( N_noxref_10_c_3703_n N_noxref_12_c_4192_n ) capacitor c=0.0018228f \
 //x=26.76 //y=3.35 //x2=27.5 //y2=5.055
cc_2533 ( N_noxref_10_c_3694_n N_noxref_12_c_4192_n ) capacitor c=0.0146933f \
 //x=26.76 //y=3.67 //x2=27.5 //y2=5.055
cc_2534 ( N_noxref_10_c_3705_n N_noxref_12_c_4192_n ) capacitor c=0.0622558f \
 //x=26.76 //y=4.76 //x2=27.5 //y2=5.055
cc_2535 ( N_noxref_10_c_3807_p N_noxref_12_c_4192_n ) capacitor c=6.03895e-19 \
 //x=26.755 //y=3.51 //x2=27.5 //y2=5.055
cc_2536 ( N_noxref_10_c_3699_n N_noxref_12_c_4192_n ) capacitor c=0.00684338f \
 //x=26.755 //y=3.51 //x2=27.5 //y2=5.055
cc_2537 ( N_noxref_10_c_3712_n N_noxref_12_c_4192_n ) capacitor c=0.00142468f \
 //x=26.76 //y=4.88 //x2=27.5 //y2=5.055
cc_2538 ( N_noxref_10_c_3796_p N_noxref_12_c_4192_n ) capacitor c=0.0021132f \
 //x=27.28 //y=4.97 //x2=27.5 //y2=5.055
cc_2539 ( N_noxref_10_c_3811_p N_noxref_12_c_4192_n ) capacitor c=0.00140024f \
 //x=26.99 //y=4.97 //x2=27.5 //y2=5.055
cc_2540 ( N_noxref_10_c_3718_n N_noxref_12_c_4193_n ) capacitor c=6.23317e-19 \
 //x=24.84 //y=1.75 //x2=27.13 //y2=1.185
cc_2541 ( N_noxref_10_c_3695_n N_noxref_12_c_4193_n ) capacitor c=0.00597106f \
 //x=24.84 //y=1.18 //x2=27.13 //y2=1.185
cc_2542 ( N_noxref_10_c_3814_p N_noxref_12_c_4193_n ) capacitor c=0.00175305f \
 //x=26.87 //y=1.09 //x2=27.13 //y2=1.185
cc_2543 ( N_noxref_10_c_3780_p N_noxref_12_c_4193_n ) capacitor c=0.00354487f \
 //x=26.87 //y=1.435 //x2=27.13 //y2=1.185
cc_2544 ( N_noxref_10_c_3816_p N_noxref_12_c_4193_n ) capacitor c=5.57924e-19 \
 //x=27.245 //y=0.935 //x2=27.13 //y2=1.185
cc_2545 ( N_noxref_10_c_3783_p N_noxref_12_c_4193_n ) capacitor c=5.77693e-19 \
 //x=27.245 //y=1.59 //x2=27.13 //y2=1.185
cc_2546 ( N_noxref_10_c_3818_p N_noxref_12_c_4193_n ) capacitor c=0.00148146f \
 //x=27.4 //y=1.09 //x2=27.13 //y2=1.185
cc_2547 ( N_noxref_10_c_3784_p N_noxref_12_c_4193_n ) capacitor c=0.00356478f \
 //x=27.4 //y=1.435 //x2=27.13 //y2=1.185
cc_2548 ( N_noxref_10_c_3703_n N_noxref_12_c_4258_n ) capacitor c=8.04679e-19 \
 //x=26.76 //y=3.35 //x2=27.5 //y2=3.14
cc_2549 ( N_noxref_10_c_3703_n N_noxref_12_c_4199_n ) capacitor c=0.00691556f \
 //x=26.76 //y=3.35 //x2=27.66 //y2=3.15
cc_2550 ( N_noxref_10_M49_noxref_g N_noxref_12_c_4260_n ) capacitor \
 c=0.0162066f //x=26.915 //y=6.2 //x2=27.135 //y2=5.56
cc_2551 ( N_noxref_10_M50_noxref_g N_noxref_12_c_4260_n ) capacitor \
 c=0.0162066f //x=27.355 //y=6.2 //x2=27.135 //y2=5.56
cc_2552 ( N_noxref_10_c_3796_p N_noxref_12_c_4260_n ) capacitor c=0.00290963f \
 //x=27.28 //y=4.97 //x2=27.135 //y2=5.56
cc_2553 ( N_noxref_10_c_3814_p N_noxref_12_M14_noxref_d ) capacitor \
 c=0.00137914f //x=26.87 //y=1.09 //x2=26.945 //y2=1.09
cc_2554 ( N_noxref_10_c_3780_p N_noxref_12_M14_noxref_d ) capacitor \
 c=0.0023891f //x=26.87 //y=1.435 //x2=26.945 //y2=1.09
cc_2555 ( N_noxref_10_c_3816_p N_noxref_12_M14_noxref_d ) capacitor \
 c=0.0020782f //x=27.245 //y=0.935 //x2=26.945 //y2=1.09
cc_2556 ( N_noxref_10_c_3783_p N_noxref_12_M14_noxref_d ) capacitor \
 c=0.00356097f //x=27.245 //y=1.59 //x2=26.945 //y2=1.09
cc_2557 ( N_noxref_10_c_3818_p N_noxref_12_M14_noxref_d ) capacitor \
 c=0.00138452f //x=27.4 //y=1.09 //x2=26.945 //y2=1.09
cc_2558 ( N_noxref_10_c_3784_p N_noxref_12_M14_noxref_d ) capacitor \
 c=0.00235934f //x=27.4 //y=1.435 //x2=26.945 //y2=1.09
cc_2559 ( N_noxref_10_c_3700_n N_VDD_c_5104_n ) capacitor c=0.00648307f \
 //x=24.685 //y=5.38 //x2=34.935 //y2=7.585
cc_2560 ( N_noxref_10_c_3723_n N_VDD_c_5104_n ) capacitor c=0.00492584f \
 //x=25.195 //y=5.38 //x2=34.935 //y2=7.585
cc_2561 ( N_noxref_10_c_3693_n N_VDD_c_5104_n ) capacitor c=4.72703e-19 \
 //x=25.28 //y=3.67 //x2=34.935 //y2=7.585
cc_2562 ( N_noxref_10_c_3694_n N_VDD_c_5104_n ) capacitor c=2.74716e-19 \
 //x=26.76 //y=3.67 //x2=34.935 //y2=7.585
cc_2563 ( N_noxref_10_c_3705_n N_VDD_c_5104_n ) capacitor c=2.02649e-19 \
 //x=26.76 //y=4.76 //x2=34.935 //y2=7.585
cc_2564 ( N_noxref_10_c_3707_n N_VDD_c_5104_n ) capacitor c=0.00368834f \
 //x=23.92 //y=5.56 //x2=34.935 //y2=7.585
cc_2565 ( N_noxref_10_c_3739_n N_VDD_c_5104_n ) capacitor c=8.42709e-19 \
 //x=24.8 //y=5.38 //x2=34.935 //y2=7.585
cc_2566 ( N_noxref_10_c_3838_p N_VDD_c_5104_n ) capacitor c=0.00285853f \
 //x=24.8 //y=5.56 //x2=34.935 //y2=7.585
cc_2567 ( N_noxref_10_c_3773_n N_VDD_c_5104_n ) capacitor c=0.00224881f \
 //x=23.92 //y=5.56 //x2=34.935 //y2=7.585
cc_2568 ( N_noxref_10_c_3750_n N_VDD_c_5104_n ) capacitor c=0.00224881f \
 //x=24.8 //y=5.56 //x2=34.935 //y2=7.585
cc_2569 ( N_noxref_10_c_3712_n N_VDD_c_5104_n ) capacitor c=3.40755e-19 \
 //x=26.76 //y=4.88 //x2=34.935 //y2=7.585
cc_2570 ( N_noxref_10_c_3700_n N_VDD_c_5323_n ) capacitor c=0.00208087f \
 //x=24.685 //y=5.38 //x2=24.275 //y2=7.585
cc_2571 ( N_noxref_10_c_3707_n N_VDD_c_5323_n ) capacitor c=9.41185e-19 \
 //x=23.92 //y=5.56 //x2=24.275 //y2=7.585
cc_2572 ( N_noxref_10_c_3773_n N_VDD_c_5323_n ) capacitor c=0.0136705f \
 //x=23.92 //y=5.56 //x2=24.275 //y2=7.585
cc_2573 ( N_noxref_10_c_3700_n N_VDD_c_5189_n ) capacitor c=0.00180737f \
 //x=24.685 //y=5.38 //x2=25.155 //y2=7.585
cc_2574 ( N_noxref_10_c_3723_n N_VDD_c_5189_n ) capacitor c=0.00208087f \
 //x=25.195 //y=5.38 //x2=25.155 //y2=7.585
cc_2575 ( N_noxref_10_c_3739_n N_VDD_c_5189_n ) capacitor c=4.23719e-19 \
 //x=24.8 //y=5.38 //x2=25.155 //y2=7.585
cc_2576 ( N_noxref_10_c_3838_p N_VDD_c_5189_n ) capacitor c=5.77976e-19 \
 //x=24.8 //y=5.56 //x2=25.155 //y2=7.585
cc_2577 ( N_noxref_10_c_3750_n N_VDD_c_5189_n ) capacitor c=0.0136705f \
 //x=24.8 //y=5.56 //x2=25.155 //y2=7.585
cc_2578 ( N_noxref_10_M49_noxref_g N_VDD_c_5377_n ) capacitor c=0.00753931f \
 //x=26.915 //y=6.2 //x2=27.49 //y2=7.585
cc_2579 ( N_noxref_10_M50_noxref_g N_VDD_c_5377_n ) capacitor c=0.00755544f \
 //x=27.355 //y=6.2 //x2=27.49 //y2=7.585
cc_2580 ( N_noxref_10_c_3702_n N_VDD_c_5137_n ) capacitor c=0.00115911f \
 //x=25.28 //y=5.295 //x2=22.69 //y2=7.585
cc_2581 ( N_noxref_10_c_3707_n N_VDD_c_5137_n ) capacitor c=5.11957e-19 \
 //x=23.92 //y=5.56 //x2=22.69 //y2=7.585
cc_2582 ( N_noxref_10_c_3773_n N_VDD_c_5137_n ) capacitor c=0.0064135f \
 //x=23.92 //y=5.56 //x2=22.69 //y2=7.585
cc_2583 ( N_noxref_10_c_3702_n N_VDD_c_5139_n ) capacitor c=0.0262709f \
 //x=25.28 //y=5.295 //x2=26.02 //y2=7.585
cc_2584 ( N_noxref_10_c_3705_n N_VDD_c_5139_n ) capacitor c=0.0141366f \
 //x=26.76 //y=4.76 //x2=26.02 //y2=7.585
cc_2585 ( N_noxref_10_c_3739_n N_VDD_c_5139_n ) capacitor c=0.002343f //x=24.8 \
 //y=5.38 //x2=26.02 //y2=7.585
cc_2586 ( N_noxref_10_c_3838_p N_VDD_c_5139_n ) capacitor c=4.0348e-19 \
 //x=24.8 //y=5.56 //x2=26.02 //y2=7.585
cc_2587 ( N_noxref_10_c_3697_n N_VDD_c_5139_n ) capacitor c=0.00369229f \
 //x=26.595 //y=3.51 //x2=26.02 //y2=7.585
cc_2588 ( N_noxref_10_c_3750_n N_VDD_c_5139_n ) capacitor c=0.0101861f \
 //x=24.8 //y=5.56 //x2=26.02 //y2=7.585
cc_2589 ( N_noxref_10_c_3712_n N_VDD_c_5139_n ) capacitor c=0.00822821f \
 //x=26.76 //y=4.88 //x2=26.02 //y2=7.585
cc_2590 ( N_noxref_10_M49_noxref_g N_VDD_c_5139_n ) capacitor c=0.00706759f \
 //x=26.915 //y=6.2 //x2=26.02 //y2=7.585
cc_2591 ( N_noxref_10_c_3811_p N_VDD_c_5139_n ) capacitor c=0.00786559f \
 //x=26.99 //y=4.97 //x2=26.02 //y2=7.585
cc_2592 ( N_noxref_10_c_3712_n N_VDD_c_5140_n ) capacitor c=0.00209414f \
 //x=26.76 //y=4.88 //x2=28.24 //y2=7.585
cc_2593 ( N_noxref_10_c_3796_p N_VDD_c_5140_n ) capacitor c=0.00747969f \
 //x=27.28 //y=4.97 //x2=28.24 //y2=7.585
cc_2594 ( N_noxref_10_c_3811_p N_VDD_c_5140_n ) capacitor c=2.63786e-19 \
 //x=26.99 //y=4.97 //x2=28.24 //y2=7.585
cc_2595 ( N_noxref_10_c_3707_n N_VDD_M44_noxref_d ) capacitor c=7.33546e-19 \
 //x=23.92 //y=5.56 //x2=21.87 //y2=5.2
cc_2596 ( N_noxref_10_c_3707_n N_VDD_M45_noxref_s ) capacitor c=0.0604289f \
 //x=23.92 //y=5.56 //x2=23.345 //y2=5.2
cc_2597 ( N_noxref_10_c_3739_n N_VDD_M45_noxref_s ) capacitor c=6.52457e-19 \
 //x=24.8 //y=5.38 //x2=23.345 //y2=5.2
cc_2598 ( N_noxref_10_c_3773_n N_VDD_M45_noxref_s ) capacitor c=0.0887533f \
 //x=23.92 //y=5.56 //x2=23.345 //y2=5.2
cc_2599 ( N_noxref_10_c_3700_n N_VDD_M46_noxref_d ) capacitor c=0.00734094f \
 //x=24.685 //y=5.38 //x2=24.215 //y2=5.2
cc_2600 ( N_noxref_10_c_3707_n N_VDD_M46_noxref_d ) capacitor c=0.0043528f \
 //x=23.92 //y=5.56 //x2=24.215 //y2=5.2
cc_2601 ( N_noxref_10_c_3838_p N_VDD_M46_noxref_d ) capacitor c=0.0043528f \
 //x=24.8 //y=5.56 //x2=24.215 //y2=5.2
cc_2602 ( N_noxref_10_c_3773_n N_VDD_M46_noxref_d ) capacitor c=0.065554f \
 //x=23.92 //y=5.56 //x2=24.215 //y2=5.2
cc_2603 ( N_noxref_10_c_3750_n N_VDD_M46_noxref_d ) capacitor c=0.065554f \
 //x=24.8 //y=5.56 //x2=24.215 //y2=5.2
cc_2604 ( N_noxref_10_c_3723_n N_VDD_M48_noxref_d ) capacitor c=0.00934027f \
 //x=25.195 //y=5.38 //x2=25.095 //y2=5.2
cc_2605 ( N_noxref_10_c_3838_p N_VDD_M48_noxref_d ) capacitor c=0.00921458f \
 //x=24.8 //y=5.56 //x2=25.095 //y2=5.2
cc_2606 ( N_noxref_10_c_3748_n N_VDD_M48_noxref_d ) capacitor c=9.65951e-19 \
 //x=25.28 //y=3.51 //x2=25.095 //y2=5.2
cc_2607 ( N_noxref_10_c_3750_n N_VDD_M48_noxref_d ) capacitor c=0.065554f \
 //x=24.8 //y=5.56 //x2=25.095 //y2=5.2
cc_2608 ( N_noxref_10_c_3723_n N_VDD_M49_noxref_s ) capacitor c=0.00316782f \
 //x=25.195 //y=5.38 //x2=26.56 //y2=5.2
cc_2609 ( N_noxref_10_c_3694_n N_VDD_M49_noxref_s ) capacitor c=0.00124178f \
 //x=26.76 //y=3.67 //x2=26.56 //y2=5.2
cc_2610 ( N_noxref_10_c_3705_n N_VDD_M49_noxref_s ) capacitor c=0.018352f \
 //x=26.76 //y=4.76 //x2=26.56 //y2=5.2
cc_2611 ( N_noxref_10_c_3739_n N_VDD_M49_noxref_s ) capacitor c=0.00460957f \
 //x=24.8 //y=5.38 //x2=26.56 //y2=5.2
cc_2612 ( N_noxref_10_c_3838_p N_VDD_M49_noxref_s ) capacitor c=0.00135645f \
 //x=24.8 //y=5.56 //x2=26.56 //y2=5.2
cc_2613 ( N_noxref_10_c_3712_n N_VDD_M49_noxref_s ) capacitor c=0.00914073f \
 //x=26.76 //y=4.88 //x2=26.56 //y2=5.2
cc_2614 ( N_noxref_10_M49_noxref_g N_VDD_M49_noxref_s ) capacitor c=0.0573441f \
 //x=26.915 //y=6.2 //x2=26.56 //y2=5.2
cc_2615 ( N_noxref_10_c_3811_p N_VDD_M49_noxref_s ) capacitor c=0.00524567f \
 //x=26.99 //y=4.97 //x2=26.56 //y2=5.2
cc_2616 ( N_noxref_10_M50_noxref_g N_VDD_M50_noxref_d ) capacitor c=0.0572684f \
 //x=27.355 //y=6.2 //x2=27.43 //y2=5.2
cc_2617 ( N_noxref_10_c_3724_n N_GND_c_6144_n ) capacitor c=0.00685812f \
 //x=25.195 //y=1.835 //x2=29.335 //y2=0.175
cc_2618 ( N_noxref_10_c_3693_n N_GND_c_6144_n ) capacitor c=2.50177e-19 \
 //x=25.28 //y=3.67 //x2=29.335 //y2=0.175
cc_2619 ( N_noxref_10_c_3694_n N_GND_c_6144_n ) capacitor c=2.72315e-19 \
 //x=26.76 //y=3.67 //x2=29.335 //y2=0.175
cc_2620 ( N_noxref_10_c_3695_n N_GND_c_6144_n ) capacitor c=0.00913824f \
 //x=24.84 //y=1.18 //x2=29.335 //y2=0.175
cc_2621 ( N_noxref_10_c_3696_n N_GND_c_6144_n ) capacitor c=7.37182e-19 \
 //x=26.76 //y=2.265 //x2=29.335 //y2=0.175
cc_2622 ( N_noxref_10_c_3800_p N_GND_c_6144_n ) capacitor c=7.5371e-19 \
 //x=26.76 //y=2.265 //x2=29.335 //y2=0.175
cc_2623 ( N_noxref_10_M13_noxref_d N_GND_c_6144_n ) capacitor c=3.01769e-19 \
 //x=24.65 //y=1.085 //x2=29.335 //y2=0.175
cc_2624 ( N_noxref_10_c_3707_n N_GND_c_6148_n ) capacitor c=7.60873e-19 \
 //x=23.92 //y=5.56 //x2=23.87 //y2=1.135
cc_2625 ( N_noxref_10_c_3695_n N_GND_c_6148_n ) capacitor c=0.0140211f \
 //x=24.84 //y=1.18 //x2=23.87 //y2=1.135
cc_2626 ( N_noxref_10_M13_noxref_d N_GND_c_6148_n ) capacitor c=2.93544e-19 \
 //x=24.65 //y=1.085 //x2=23.87 //y2=1.135
cc_2627 ( N_noxref_10_c_3724_n N_GND_c_6361_n ) capacitor c=7.75992e-19 \
 //x=25.195 //y=1.835 //x2=25.85 //y2=0.175
cc_2628 ( N_noxref_10_c_3693_n N_GND_c_6361_n ) capacitor c=3.21306e-19 \
 //x=25.28 //y=3.67 //x2=25.85 //y2=0.175
cc_2629 ( N_noxref_10_c_3696_n N_GND_c_6159_n ) capacitor c=0.00114179f \
 //x=26.76 //y=2.265 //x2=27.045 //y2=0.715
cc_2630 ( N_noxref_10_c_3800_p N_GND_c_6159_n ) capacitor c=3.95714e-19 \
 //x=26.76 //y=2.265 //x2=27.045 //y2=0.715
cc_2631 ( N_noxref_10_c_3814_p N_GND_c_6159_n ) capacitor c=0.0126466f \
 //x=26.87 //y=1.09 //x2=27.045 //y2=0.715
cc_2632 ( N_noxref_10_c_3792_p N_GND_c_6159_n ) capacitor c=2.1838e-19 \
 //x=26.76 //y=2.265 //x2=27.045 //y2=0.715
cc_2633 ( N_noxref_10_c_3818_p N_GND_c_6571_n ) capacitor c=0.0132013f \
 //x=27.4 //y=1.09 //x2=27.535 //y2=0.715
cc_2634 ( N_noxref_10_c_3692_n N_GND_c_6180_n ) capacitor c=2.36438e-19 \
 //x=25.28 //y=3.35 //x2=22.69 //y2=0.175
cc_2635 ( N_noxref_10_c_3718_n N_GND_c_6181_n ) capacitor c=0.00269515f \
 //x=24.84 //y=1.75 //x2=26.02 //y2=0.175
cc_2636 ( N_noxref_10_c_3724_n N_GND_c_6181_n ) capacitor c=0.0254618f \
 //x=25.195 //y=1.835 //x2=26.02 //y2=0.175
cc_2637 ( N_noxref_10_c_3703_n N_GND_c_6181_n ) capacitor c=0.0103129f \
 //x=26.76 //y=3.35 //x2=26.02 //y2=0.175
cc_2638 ( N_noxref_10_c_3696_n N_GND_c_6181_n ) capacitor c=0.00632755f \
 //x=26.76 //y=2.265 //x2=26.02 //y2=0.175
cc_2639 ( N_noxref_10_c_3697_n N_GND_c_6181_n ) capacitor c=0.00432636f \
 //x=26.595 //y=3.51 //x2=26.02 //y2=0.175
cc_2640 ( N_noxref_10_c_3800_p N_GND_c_6181_n ) capacitor c=0.00733236f \
 //x=26.76 //y=2.265 //x2=26.02 //y2=0.175
cc_2641 ( N_noxref_10_c_3782_p N_GND_c_6181_n ) capacitor c=0.00393964f \
 //x=26.87 //y=2.1 //x2=26.02 //y2=0.175
cc_2642 ( N_noxref_10_c_3792_p N_GND_c_6181_n ) capacitor c=0.00781545f \
 //x=26.76 //y=2.265 //x2=26.02 //y2=0.175
cc_2643 ( N_noxref_10_c_3800_p N_GND_c_6182_n ) capacitor c=0.0022444f \
 //x=26.76 //y=2.265 //x2=28.24 //y2=0.175
cc_2644 ( N_noxref_10_c_3792_p N_GND_c_6182_n ) capacitor c=2.63786e-19 \
 //x=26.76 //y=2.265 //x2=28.24 //y2=0.175
cc_2645 ( N_noxref_10_c_3695_n N_GND_M12_noxref_d ) capacitor c=2.82748e-19 \
 //x=24.84 //y=1.18 //x2=23.68 //y2=1.045
cc_2646 ( N_noxref_10_c_3694_n N_GND_M14_noxref_s ) capacitor c=8.20337e-19 \
 //x=26.76 //y=3.67 //x2=26.515 //y2=0.55
cc_2647 ( N_noxref_10_c_3696_n N_GND_M14_noxref_s ) capacitor c=0.00297876f \
 //x=26.76 //y=2.265 //x2=26.515 //y2=0.55
cc_2648 ( N_noxref_10_c_3800_p N_GND_M14_noxref_s ) capacitor c=0.00651326f \
 //x=26.76 //y=2.265 //x2=26.515 //y2=0.55
cc_2649 ( N_noxref_10_c_3814_p N_GND_M14_noxref_s ) capacitor c=0.0300814f \
 //x=26.87 //y=1.09 //x2=26.515 //y2=0.55
cc_2650 ( N_noxref_10_c_3781_p N_GND_M14_noxref_s ) capacitor c=0.002132f \
 //x=26.87 //y=1.745 //x2=26.515 //y2=0.55
cc_2651 ( N_noxref_10_c_3782_p N_GND_M14_noxref_s ) capacitor c=0.00304786f \
 //x=26.87 //y=2.1 //x2=26.515 //y2=0.55
cc_2652 ( N_noxref_10_c_3816_p N_GND_M14_noxref_s ) capacitor c=0.00521375f \
 //x=27.245 //y=0.935 //x2=26.515 //y2=0.55
cc_2653 ( N_noxref_10_c_3818_p N_GND_M14_noxref_s ) capacitor c=0.0153553f \
 //x=27.4 //y=1.09 //x2=26.515 //y2=0.55
cc_2654 ( N_noxref_10_c_3784_p N_GND_M14_noxref_s ) capacitor c=0.00629878f \
 //x=27.4 //y=1.435 //x2=26.515 //y2=0.55
cc_2655 ( N_noxref_10_c_3792_p N_GND_M14_noxref_s ) capacitor c=0.00405173f \
 //x=26.76 //y=2.265 //x2=26.515 //y2=0.55
cc_2656 ( N_noxref_10_c_3691_n N_noxref_27_c_7367_n ) capacitor c=0.00900974f \
 //x=24.925 //y=1.835 //x2=24.355 //y2=1.675
cc_2657 ( N_noxref_10_c_3724_n N_noxref_27_c_7368_n ) capacitor c=0.00399245f \
 //x=25.195 //y=1.835 //x2=25.24 //y2=0.71
cc_2658 ( N_noxref_10_c_3695_n N_noxref_27_c_7368_n ) capacitor c=0.003751f \
 //x=24.84 //y=1.18 //x2=25.24 //y2=0.71
cc_2659 ( N_noxref_10_M13_noxref_d N_noxref_27_c_7368_n ) capacitor \
 c=0.00910163f //x=24.65 //y=1.085 //x2=25.24 //y2=0.71
cc_2660 ( N_noxref_10_c_3718_n N_noxref_27_M12_noxref_s ) capacitor \
 c=0.0156395f //x=24.84 //y=1.75 //x2=23.25 //y2=0.545
cc_2661 ( N_noxref_10_c_3724_n N_noxref_27_M12_noxref_s ) capacitor \
 c=0.00640979f //x=25.195 //y=1.835 //x2=23.25 //y2=0.545
cc_2662 ( N_noxref_10_c_3693_n N_noxref_27_M12_noxref_s ) capacitor \
 c=4.17069e-19 //x=25.28 //y=3.67 //x2=23.25 //y2=0.545
cc_2663 ( N_noxref_10_c_3695_n N_noxref_27_M12_noxref_s ) capacitor \
 c=0.00896428f //x=24.84 //y=1.18 //x2=23.25 //y2=0.545
cc_2664 ( N_noxref_10_c_3748_n N_noxref_27_M12_noxref_s ) capacitor \
 c=0.0010514f //x=25.28 //y=3.51 //x2=23.25 //y2=0.545
cc_2665 ( N_noxref_10_M13_noxref_d N_noxref_27_M12_noxref_s ) capacitor \
 c=0.0275552f //x=24.65 //y=1.085 //x2=23.25 //y2=0.545
cc_2666 ( N_noxref_11_c_3943_n N_noxref_12_c_4216_n ) capacitor c=0.00498121f \
 //x=30.39 //y=1.75 //x2=27.13 //y2=1.935
cc_2667 ( N_noxref_11_c_3958_n N_noxref_12_c_4200_n ) capacitor c=6.68558e-19 \
 //x=30.83 //y=5.295 //x2=27.135 //y2=5.42
cc_2668 ( N_noxref_11_c_3990_n N_noxref_12_c_4200_n ) capacitor c=6.16426e-19 \
 //x=29.47 //y=5.56 //x2=27.135 //y2=5.42
cc_2669 ( N_noxref_11_c_3951_n N_noxref_12_c_4187_n ) capacitor c=9.55435e-19 \
 //x=30.83 //y=3.35 //x2=27.415 //y2=2.02
cc_2670 ( N_noxref_11_c_3958_n N_noxref_12_c_4201_n ) capacitor c=0.00145135f \
 //x=30.83 //y=5.295 //x2=27.415 //y2=5.14
cc_2671 ( N_noxref_11_c_3963_n N_noxref_12_c_4274_n ) capacitor c=0.00169359f \
 //x=32.31 //y=3.35 //x2=34.9 //y2=2.965
cc_2672 ( N_noxref_11_c_3964_n N_noxref_12_c_4275_n ) capacitor c=0.00211225f \
 //x=32.31 //y=4.76 //x2=34.9 //y2=4.765
cc_2673 ( N_noxref_11_c_3943_n N_noxref_12_c_4193_n ) capacitor c=4.16137e-19 \
 //x=30.39 //y=1.75 //x2=27.13 //y2=1.185
cc_2674 ( N_noxref_11_c_3968_n N_noxref_12_c_4193_n ) capacitor c=6.80839e-19 \
 //x=30.39 //y=1.18 //x2=27.13 //y2=1.185
cc_2675 ( N_noxref_11_c_3949_n N_noxref_12_c_4194_n ) capacitor c=0.0043574f \
 //x=30.745 //y=1.835 //x2=30.445 //y2=3.14
cc_2676 ( N_noxref_11_c_4011_p N_noxref_12_c_4194_n ) capacitor c=0.00482943f \
 //x=30.475 //y=1.835 //x2=30.445 //y2=3.14
cc_2677 ( N_noxref_11_c_3951_n N_noxref_12_c_4194_n ) capacitor c=3.11404e-19 \
 //x=30.83 //y=3.35 //x2=30.445 //y2=3.14
cc_2678 ( N_noxref_11_c_3968_n N_noxref_12_c_4194_n ) capacitor c=4.69652e-19 \
 //x=30.39 //y=1.18 //x2=30.445 //y2=3.14
cc_2679 ( N_noxref_11_c_3951_n N_noxref_12_c_4282_n ) capacitor c=0.0281922f \
 //x=30.83 //y=3.35 //x2=31.045 //y2=3.125
cc_2680 ( N_noxref_11_c_3957_n N_noxref_12_c_4282_n ) capacitor c=0.00808101f \
 //x=30.83 //y=3.67 //x2=31.045 //y2=3.125
cc_2681 ( N_noxref_11_c_4016_p N_noxref_12_c_4282_n ) capacitor c=0.101789f \
 //x=32.145 //y=3.51 //x2=31.045 //y2=3.125
cc_2682 ( N_noxref_11_c_3975_n N_noxref_12_c_4282_n ) capacitor c=0.0374977f \
 //x=30.99 //y=3.51 //x2=31.045 //y2=3.125
cc_2683 ( N_noxref_11_c_3963_n N_noxref_12_c_4286_n ) capacitor c=4.49947e-19 \
 //x=32.31 //y=3.35 //x2=31.92 //y2=3.14
cc_2684 ( N_noxref_11_c_4019_p N_noxref_12_c_4286_n ) capacitor c=0.00276844f \
 //x=32.31 //y=3.67 //x2=31.92 //y2=3.14
cc_2685 ( N_noxref_11_c_4016_p N_noxref_12_c_4286_n ) capacitor c=0.0117238f \
 //x=32.145 //y=3.51 //x2=31.92 //y2=3.14
cc_2686 ( N_noxref_11_c_3963_n N_noxref_12_c_4289_n ) capacitor c=0.0264728f \
 //x=32.31 //y=3.35 //x2=32.52 //y2=3.125
cc_2687 ( N_noxref_11_c_4019_p N_noxref_12_c_4289_n ) capacitor c=0.00448915f \
 //x=32.31 //y=3.67 //x2=32.52 //y2=3.125
cc_2688 ( N_noxref_11_c_4023_p N_noxref_12_c_4289_n ) capacitor c=0.0027091f \
 //x=32.31 //y=2.265 //x2=32.52 //y2=3.125
cc_2689 ( N_noxref_11_c_4024_p N_noxref_12_c_4289_n ) capacitor c=0.0374977f \
 //x=32.305 //y=3.51 //x2=32.52 //y2=3.125
cc_2690 ( N_noxref_11_c_3943_n N_noxref_13_c_4489_n ) capacitor c=0.0044864f \
 //x=30.39 //y=1.75 //x2=32.68 //y2=1.935
cc_2691 ( N_noxref_11_c_3949_n N_noxref_13_c_4489_n ) capacitor c=0.00320685f \
 //x=30.745 //y=1.835 //x2=32.68 //y2=1.935
cc_2692 ( N_noxref_11_c_4027_p N_noxref_13_c_4489_n ) capacitor c=0.00108934f \
 //x=32.42 //y=1.435 //x2=32.68 //y2=1.935
cc_2693 ( N_noxref_11_c_4028_p N_noxref_13_c_4489_n ) capacitor c=0.00524682f \
 //x=32.42 //y=1.745 //x2=32.68 //y2=1.935
cc_2694 ( N_noxref_11_c_4029_p N_noxref_13_c_4489_n ) capacitor c=0.00376309f \
 //x=32.42 //y=2.1 //x2=32.68 //y2=1.935
cc_2695 ( N_noxref_11_c_4030_p N_noxref_13_c_4489_n ) capacitor c=0.0090274f \
 //x=32.795 //y=1.59 //x2=32.68 //y2=1.935
cc_2696 ( N_noxref_11_c_4031_p N_noxref_13_c_4489_n ) capacitor c=0.00324043f \
 //x=32.95 //y=1.435 //x2=32.68 //y2=1.935
cc_2697 ( N_noxref_11_c_3948_n N_noxref_13_c_4496_n ) capacitor c=0.00308101f \
 //x=30.745 //y=5.38 //x2=32.685 //y2=5.42
cc_2698 ( N_noxref_11_c_3965_n N_noxref_13_c_4496_n ) capacitor c=5.44332e-19 \
 //x=30.35 //y=5.38 //x2=32.685 //y2=5.42
cc_2699 ( N_noxref_11_M55_noxref_g N_noxref_13_c_4496_n ) capacitor \
 c=0.00141266f //x=32.465 //y=6.2 //x2=32.685 //y2=5.42
cc_2700 ( N_noxref_11_M56_noxref_g N_noxref_13_c_4496_n ) capacitor \
 c=0.0035313f //x=32.905 //y=6.2 //x2=32.685 //y2=5.42
cc_2701 ( N_noxref_11_c_4030_p N_noxref_13_c_4500_n ) capacitor c=0.00180253f \
 //x=32.795 //y=1.59 //x2=32.965 //y2=2.02
cc_2702 ( N_noxref_11_c_3951_n N_noxref_13_c_4501_n ) capacitor c=0.00320685f \
 //x=30.83 //y=3.35 //x2=32.765 //y2=2.02
cc_2703 ( N_noxref_11_c_4038_p N_noxref_13_c_4501_n ) capacitor c=0.00376309f \
 //x=32.31 //y=2.265 //x2=32.765 //y2=2.02
cc_2704 ( N_noxref_11_M56_noxref_g N_noxref_13_c_4503_n ) capacitor \
 c=0.00942823f //x=32.905 //y=6.2 //x2=32.965 //y2=5.14
cc_2705 ( N_noxref_11_c_3958_n N_noxref_13_c_4504_n ) capacitor c=0.00290506f \
 //x=30.83 //y=5.295 //x2=32.77 //y2=5.14
cc_2706 ( N_noxref_11_M55_noxref_g N_noxref_13_c_4504_n ) capacitor \
 c=0.00427521f //x=32.465 //y=6.2 //x2=32.77 //y2=5.14
cc_2707 ( N_noxref_11_c_4042_p N_noxref_13_c_4504_n ) capacitor c=0.00262283f \
 //x=32.83 //y=4.97 //x2=32.77 //y2=5.14
cc_2708 ( N_noxref_11_c_3951_n N_noxref_13_c_4507_n ) capacitor c=0.00322583f \
 //x=30.83 //y=3.35 //x2=33.05 //y2=3.35
cc_2709 ( N_noxref_11_c_3963_n N_noxref_13_c_4507_n ) capacitor c=0.0374516f \
 //x=32.31 //y=3.35 //x2=33.05 //y2=3.35
cc_2710 ( N_noxref_11_c_4023_p N_noxref_13_c_4507_n ) capacitor c=0.017436f \
 //x=32.31 //y=2.265 //x2=33.05 //y2=3.35
cc_2711 ( N_noxref_11_c_4046_p N_noxref_13_c_4507_n ) capacitor c=4.71798e-19 \
 //x=32.31 //y=2.265 //x2=33.05 //y2=3.35
cc_2712 ( N_noxref_11_c_4038_p N_noxref_13_c_4507_n ) capacitor c=0.00270592f \
 //x=32.31 //y=2.265 //x2=33.05 //y2=3.35
cc_2713 ( N_noxref_11_c_4019_p N_noxref_13_c_4512_n ) capacitor c=0.0208752f \
 //x=32.31 //y=3.67 //x2=33.05 //y2=3.67
cc_2714 ( N_noxref_11_c_4049_p N_noxref_13_c_4512_n ) capacitor c=6.06825e-19 \
 //x=32.305 //y=3.51 //x2=33.05 //y2=3.67
cc_2715 ( N_noxref_11_c_4024_p N_noxref_13_c_4512_n ) capacitor c=0.00324265f \
 //x=32.305 //y=3.51 //x2=33.05 //y2=3.67
cc_2716 ( N_noxref_11_c_3958_n N_noxref_13_c_4515_n ) capacitor c=0.00299446f \
 //x=30.83 //y=5.295 //x2=33.05 //y2=5.055
cc_2717 ( N_noxref_11_c_3964_n N_noxref_13_c_4515_n ) capacitor c=0.0655082f \
 //x=32.31 //y=4.76 //x2=33.05 //y2=5.055
cc_2718 ( N_noxref_11_c_4053_p N_noxref_13_c_4515_n ) capacitor c=0.00383777f \
 //x=32.31 //y=4.88 //x2=33.05 //y2=5.055
cc_2719 ( N_noxref_11_c_4042_p N_noxref_13_c_4515_n ) capacitor c=0.00208891f \
 //x=32.83 //y=4.97 //x2=33.05 //y2=5.055
cc_2720 ( N_noxref_11_c_4055_p N_noxref_13_c_4515_n ) capacitor c=0.00140024f \
 //x=32.54 //y=4.97 //x2=33.05 //y2=5.055
cc_2721 ( N_noxref_11_c_3943_n N_noxref_13_c_4520_n ) capacitor c=6.23317e-19 \
 //x=30.39 //y=1.75 //x2=32.68 //y2=1.185
cc_2722 ( N_noxref_11_c_3968_n N_noxref_13_c_4520_n ) capacitor c=0.00596895f \
 //x=30.39 //y=1.18 //x2=32.68 //y2=1.185
cc_2723 ( N_noxref_11_c_4058_p N_noxref_13_c_4520_n ) capacitor c=0.00175305f \
 //x=32.42 //y=1.09 //x2=32.68 //y2=1.185
cc_2724 ( N_noxref_11_c_4027_p N_noxref_13_c_4520_n ) capacitor c=0.00354487f \
 //x=32.42 //y=1.435 //x2=32.68 //y2=1.185
cc_2725 ( N_noxref_11_c_4060_p N_noxref_13_c_4520_n ) capacitor c=5.57924e-19 \
 //x=32.795 //y=0.935 //x2=32.68 //y2=1.185
cc_2726 ( N_noxref_11_c_4030_p N_noxref_13_c_4520_n ) capacitor c=5.75878e-19 \
 //x=32.795 //y=1.59 //x2=32.68 //y2=1.185
cc_2727 ( N_noxref_11_c_4062_p N_noxref_13_c_4520_n ) capacitor c=0.00148463f \
 //x=32.95 //y=1.09 //x2=32.68 //y2=1.185
cc_2728 ( N_noxref_11_c_4031_p N_noxref_13_c_4520_n ) capacitor c=0.00349964f \
 //x=32.95 //y=1.435 //x2=32.68 //y2=1.185
cc_2729 ( N_noxref_11_c_4019_p N_noxref_13_c_4528_n ) capacitor c=5.87928e-19 \
 //x=32.31 //y=3.67 //x2=33.045 //y2=3.51
cc_2730 ( N_noxref_11_c_4049_p N_noxref_13_c_4528_n ) capacitor c=0.0101761f \
 //x=32.305 //y=3.51 //x2=33.045 //y2=3.51
cc_2731 ( N_noxref_11_c_4019_p N_noxref_13_c_4530_n ) capacitor c=0.00324335f \
 //x=32.31 //y=3.67 //x2=33.205 //y2=3.51
cc_2732 ( N_noxref_11_c_4024_p N_noxref_13_c_4530_n ) capacitor c=0.0234361f \
 //x=32.305 //y=3.51 //x2=33.205 //y2=3.51
cc_2733 ( N_noxref_11_M55_noxref_g N_noxref_13_c_4532_n ) capacitor \
 c=0.0162066f //x=32.465 //y=6.2 //x2=32.685 //y2=5.56
cc_2734 ( N_noxref_11_M56_noxref_g N_noxref_13_c_4532_n ) capacitor \
 c=0.0162066f //x=32.905 //y=6.2 //x2=32.685 //y2=5.56
cc_2735 ( N_noxref_11_c_4042_p N_noxref_13_c_4532_n ) capacitor c=0.00290963f \
 //x=32.83 //y=4.97 //x2=32.685 //y2=5.56
cc_2736 ( N_noxref_11_c_4058_p N_noxref_13_M17_noxref_d ) capacitor \
 c=0.00137914f //x=32.42 //y=1.09 //x2=32.495 //y2=1.09
cc_2737 ( N_noxref_11_c_4027_p N_noxref_13_M17_noxref_d ) capacitor \
 c=0.0023891f //x=32.42 //y=1.435 //x2=32.495 //y2=1.09
cc_2738 ( N_noxref_11_c_4060_p N_noxref_13_M17_noxref_d ) capacitor \
 c=0.0020782f //x=32.795 //y=0.935 //x2=32.495 //y2=1.09
cc_2739 ( N_noxref_11_c_4030_p N_noxref_13_M17_noxref_d ) capacitor \
 c=0.00356097f //x=32.795 //y=1.59 //x2=32.495 //y2=1.09
cc_2740 ( N_noxref_11_c_4062_p N_noxref_13_M17_noxref_d ) capacitor \
 c=0.00138452f //x=32.95 //y=1.09 //x2=32.495 //y2=1.09
cc_2741 ( N_noxref_11_c_4031_p N_noxref_13_M17_noxref_d ) capacitor \
 c=0.00235934f //x=32.95 //y=1.435 //x2=32.495 //y2=1.09
cc_2742 ( N_noxref_11_c_3943_n N_noxref_14_c_4743_n ) capacitor c=3.56665e-19 \
 //x=30.39 //y=1.75 //x2=34.97 //y2=1.75
cc_2743 ( N_noxref_11_c_3949_n N_noxref_14_c_4744_n ) capacitor c=3.3474e-19 \
 //x=30.745 //y=1.835 //x2=35.055 //y2=1.835
cc_2744 ( N_noxref_11_c_3938_n N_VDD_c_5104_n ) capacitor c=0.00648307f \
 //x=30.235 //y=5.38 //x2=34.935 //y2=7.585
cc_2745 ( N_noxref_11_c_3948_n N_VDD_c_5104_n ) capacitor c=0.00492584f \
 //x=30.745 //y=5.38 //x2=34.935 //y2=7.585
cc_2746 ( N_noxref_11_c_3957_n N_VDD_c_5104_n ) capacitor c=4.28274e-19 \
 //x=30.83 //y=3.67 //x2=34.935 //y2=7.585
cc_2747 ( N_noxref_11_c_4019_p N_VDD_c_5104_n ) capacitor c=2.47416e-19 \
 //x=32.31 //y=3.67 //x2=34.935 //y2=7.585
cc_2748 ( N_noxref_11_c_3964_n N_VDD_c_5104_n ) capacitor c=5.73169e-19 \
 //x=32.31 //y=4.76 //x2=34.935 //y2=7.585
cc_2749 ( N_noxref_11_c_3990_n N_VDD_c_5104_n ) capacitor c=0.00368834f \
 //x=29.47 //y=5.56 //x2=34.935 //y2=7.585
cc_2750 ( N_noxref_11_c_3965_n N_VDD_c_5104_n ) capacitor c=8.42709e-19 \
 //x=30.35 //y=5.38 //x2=34.935 //y2=7.585
cc_2751 ( N_noxref_11_c_4086_p N_VDD_c_5104_n ) capacitor c=0.00285853f \
 //x=30.35 //y=5.56 //x2=34.935 //y2=7.585
cc_2752 ( N_noxref_11_c_3996_n N_VDD_c_5104_n ) capacitor c=0.00224881f \
 //x=29.47 //y=5.56 //x2=34.935 //y2=7.585
cc_2753 ( N_noxref_11_c_3976_n N_VDD_c_5104_n ) capacitor c=0.00224881f \
 //x=30.35 //y=5.56 //x2=34.935 //y2=7.585
cc_2754 ( N_noxref_11_c_4053_p N_VDD_c_5104_n ) capacitor c=3.40755e-19 \
 //x=32.31 //y=4.88 //x2=34.935 //y2=7.585
cc_2755 ( N_noxref_11_c_3938_n N_VDD_c_5114_n ) capacitor c=0.00213203f \
 //x=30.235 //y=5.38 //x2=29.825 //y2=7.585
cc_2756 ( N_noxref_11_c_3990_n N_VDD_c_5114_n ) capacitor c=9.9885e-19 \
 //x=29.47 //y=5.56 //x2=29.825 //y2=7.585
cc_2757 ( N_noxref_11_c_3996_n N_VDD_c_5114_n ) capacitor c=0.0136705f \
 //x=29.47 //y=5.56 //x2=29.825 //y2=7.585
cc_2758 ( N_noxref_11_c_3938_n N_VDD_c_5003_n ) capacitor c=0.00184541f \
 //x=30.235 //y=5.38 //x2=30.705 //y2=7.585
cc_2759 ( N_noxref_11_c_3948_n N_VDD_c_5003_n ) capacitor c=0.00213203f \
 //x=30.745 //y=5.38 //x2=30.705 //y2=7.585
cc_2760 ( N_noxref_11_c_3965_n N_VDD_c_5003_n ) capacitor c=5.39459e-19 \
 //x=30.35 //y=5.38 //x2=30.705 //y2=7.585
cc_2761 ( N_noxref_11_c_4086_p N_VDD_c_5003_n ) capacitor c=5.77976e-19 \
 //x=30.35 //y=5.56 //x2=30.705 //y2=7.585
cc_2762 ( N_noxref_11_c_3976_n N_VDD_c_5003_n ) capacitor c=0.0136705f \
 //x=30.35 //y=5.56 //x2=30.705 //y2=7.585
cc_2763 ( N_noxref_11_c_3964_n N_VDD_c_5435_n ) capacitor c=5.48929e-19 \
 //x=32.31 //y=4.76 //x2=33.04 //y2=7.585
cc_2764 ( N_noxref_11_M55_noxref_g N_VDD_c_5435_n ) capacitor c=0.00753931f \
 //x=32.465 //y=6.2 //x2=33.04 //y2=7.585
cc_2765 ( N_noxref_11_M56_noxref_g N_VDD_c_5435_n ) capacitor c=0.00755544f \
 //x=32.905 //y=6.2 //x2=33.04 //y2=7.585
cc_2766 ( N_noxref_11_c_3958_n N_VDD_c_5140_n ) capacitor c=9.43238e-19 \
 //x=30.83 //y=5.295 //x2=28.24 //y2=7.585
cc_2767 ( N_noxref_11_c_3990_n N_VDD_c_5140_n ) capacitor c=5.11447e-19 \
 //x=29.47 //y=5.56 //x2=28.24 //y2=7.585
cc_2768 ( N_noxref_11_c_3996_n N_VDD_c_5140_n ) capacitor c=0.0064135f \
 //x=29.47 //y=5.56 //x2=28.24 //y2=7.585
cc_2769 ( N_noxref_11_c_3958_n N_VDD_c_5023_n ) capacitor c=0.0282518f \
 //x=30.83 //y=5.295 //x2=31.57 //y2=7.585
cc_2770 ( N_noxref_11_c_3964_n N_VDD_c_5023_n ) capacitor c=0.0155837f \
 //x=32.31 //y=4.76 //x2=31.57 //y2=7.585
cc_2771 ( N_noxref_11_c_3965_n N_VDD_c_5023_n ) capacitor c=0.002343f \
 //x=30.35 //y=5.38 //x2=31.57 //y2=7.585
cc_2772 ( N_noxref_11_c_4086_p N_VDD_c_5023_n ) capacitor c=4.0348e-19 \
 //x=30.35 //y=5.56 //x2=31.57 //y2=7.585
cc_2773 ( N_noxref_11_c_4016_p N_VDD_c_5023_n ) capacitor c=0.00501359f \
 //x=32.145 //y=3.51 //x2=31.57 //y2=7.585
cc_2774 ( N_noxref_11_c_3976_n N_VDD_c_5023_n ) capacitor c=0.0101861f \
 //x=30.35 //y=5.56 //x2=31.57 //y2=7.585
cc_2775 ( N_noxref_11_c_4053_p N_VDD_c_5023_n ) capacitor c=0.00795272f \
 //x=32.31 //y=4.88 //x2=31.57 //y2=7.585
cc_2776 ( N_noxref_11_M55_noxref_g N_VDD_c_5023_n ) capacitor c=0.00713158f \
 //x=32.465 //y=6.2 //x2=31.57 //y2=7.585
cc_2777 ( N_noxref_11_c_4055_p N_VDD_c_5023_n ) capacitor c=0.00799922f \
 //x=32.54 //y=4.97 //x2=31.57 //y2=7.585
cc_2778 ( N_noxref_11_c_4053_p N_VDD_c_5450_n ) capacitor c=0.00235165f \
 //x=32.31 //y=4.88 //x2=33.79 //y2=7.585
cc_2779 ( N_noxref_11_c_4042_p N_VDD_c_5450_n ) capacitor c=0.00809791f \
 //x=32.83 //y=4.97 //x2=33.79 //y2=7.585
cc_2780 ( N_noxref_11_c_4055_p N_VDD_c_5450_n ) capacitor c=2.63786e-19 \
 //x=32.54 //y=4.97 //x2=33.79 //y2=7.585
cc_2781 ( N_noxref_11_c_3990_n N_VDD_M50_noxref_d ) capacitor c=0.00114029f \
 //x=29.47 //y=5.56 //x2=27.43 //y2=5.2
cc_2782 ( N_noxref_11_c_3990_n N_VDD_M51_noxref_s ) capacitor c=0.0604727f \
 //x=29.47 //y=5.56 //x2=28.895 //y2=5.2
cc_2783 ( N_noxref_11_c_3965_n N_VDD_M51_noxref_s ) capacitor c=6.52457e-19 \
 //x=30.35 //y=5.38 //x2=28.895 //y2=5.2
cc_2784 ( N_noxref_11_c_3996_n N_VDD_M51_noxref_s ) capacitor c=0.0887533f \
 //x=29.47 //y=5.56 //x2=28.895 //y2=5.2
cc_2785 ( N_noxref_11_c_3938_n N_VDD_M52_noxref_d ) capacitor c=0.00814528f \
 //x=30.235 //y=5.38 //x2=29.765 //y2=5.2
cc_2786 ( N_noxref_11_c_3990_n N_VDD_M52_noxref_d ) capacitor c=0.0043528f \
 //x=29.47 //y=5.56 //x2=29.765 //y2=5.2
cc_2787 ( N_noxref_11_c_4086_p N_VDD_M52_noxref_d ) capacitor c=0.0043528f \
 //x=30.35 //y=5.56 //x2=29.765 //y2=5.2
cc_2788 ( N_noxref_11_c_3996_n N_VDD_M52_noxref_d ) capacitor c=0.065554f \
 //x=29.47 //y=5.56 //x2=29.765 //y2=5.2
cc_2789 ( N_noxref_11_c_3976_n N_VDD_M52_noxref_d ) capacitor c=0.065554f \
 //x=30.35 //y=5.56 //x2=29.765 //y2=5.2
cc_2790 ( N_noxref_11_c_3948_n N_VDD_M54_noxref_d ) capacitor c=0.00934027f \
 //x=30.745 //y=5.38 //x2=30.645 //y2=5.2
cc_2791 ( N_noxref_11_c_4086_p N_VDD_M54_noxref_d ) capacitor c=0.00921458f \
 //x=30.35 //y=5.56 //x2=30.645 //y2=5.2
cc_2792 ( N_noxref_11_c_3974_n N_VDD_M54_noxref_d ) capacitor c=9.65951e-19 \
 //x=30.83 //y=3.51 //x2=30.645 //y2=5.2
cc_2793 ( N_noxref_11_c_3976_n N_VDD_M54_noxref_d ) capacitor c=0.065554f \
 //x=30.35 //y=5.56 //x2=30.645 //y2=5.2
cc_2794 ( N_noxref_11_c_3948_n N_VDD_M55_noxref_s ) capacitor c=0.00316782f \
 //x=30.745 //y=5.38 //x2=32.11 //y2=5.2
cc_2795 ( N_noxref_11_c_4019_p N_VDD_M55_noxref_s ) capacitor c=0.00120123f \
 //x=32.31 //y=3.67 //x2=32.11 //y2=5.2
cc_2796 ( N_noxref_11_c_3964_n N_VDD_M55_noxref_s ) capacitor c=0.0211605f \
 //x=32.31 //y=4.76 //x2=32.11 //y2=5.2
cc_2797 ( N_noxref_11_c_3965_n N_VDD_M55_noxref_s ) capacitor c=0.00460957f \
 //x=30.35 //y=5.38 //x2=32.11 //y2=5.2
cc_2798 ( N_noxref_11_c_4086_p N_VDD_M55_noxref_s ) capacitor c=0.00135645f \
 //x=30.35 //y=5.56 //x2=32.11 //y2=5.2
cc_2799 ( N_noxref_11_c_4024_p N_VDD_M55_noxref_s ) capacitor c=4.8313e-19 \
 //x=32.305 //y=3.51 //x2=32.11 //y2=5.2
cc_2800 ( N_noxref_11_c_4053_p N_VDD_M55_noxref_s ) capacitor c=0.00986169f \
 //x=32.31 //y=4.88 //x2=32.11 //y2=5.2
cc_2801 ( N_noxref_11_M55_noxref_g N_VDD_M55_noxref_s ) capacitor c=0.0573441f \
 //x=32.465 //y=6.2 //x2=32.11 //y2=5.2
cc_2802 ( N_noxref_11_c_4055_p N_VDD_M55_noxref_s ) capacitor c=0.00524567f \
 //x=32.54 //y=4.97 //x2=32.11 //y2=5.2
cc_2803 ( N_noxref_11_M56_noxref_g N_VDD_M56_noxref_d ) capacitor c=0.0572684f \
 //x=32.905 //y=6.2 //x2=32.98 //y2=5.2
cc_2804 ( N_noxref_11_c_3949_n N_GND_c_6145_n ) capacitor c=0.00654514f \
 //x=30.745 //y=1.835 //x2=38.97 //y2=0.18
cc_2805 ( N_noxref_11_c_3957_n N_GND_c_6145_n ) capacitor c=4.52555e-19 \
 //x=30.83 //y=3.67 //x2=38.97 //y2=0.18
cc_2806 ( N_noxref_11_c_4019_p N_GND_c_6145_n ) capacitor c=4.65445e-19 \
 //x=32.31 //y=3.67 //x2=38.97 //y2=0.18
cc_2807 ( N_noxref_11_c_3968_n N_GND_c_6145_n ) capacitor c=0.00951288f \
 //x=30.39 //y=1.18 //x2=38.97 //y2=0.18
cc_2808 ( N_noxref_11_c_4023_p N_GND_c_6145_n ) capacitor c=0.00249122f \
 //x=32.31 //y=2.265 //x2=38.97 //y2=0.18
cc_2809 ( N_noxref_11_c_4046_p N_GND_c_6145_n ) capacitor c=7.5371e-19 \
 //x=32.31 //y=2.265 //x2=38.97 //y2=0.18
cc_2810 ( N_noxref_11_M16_noxref_d N_GND_c_6145_n ) capacitor c=3.01769e-19 \
 //x=30.2 //y=1.085 //x2=38.97 //y2=0.18
cc_2811 ( N_noxref_11_c_3990_n N_GND_c_6149_n ) capacitor c=6.60111e-19 \
 //x=29.47 //y=5.56 //x2=29.42 //y2=1.135
cc_2812 ( N_noxref_11_c_3968_n N_GND_c_6149_n ) capacitor c=0.0140211f \
 //x=30.39 //y=1.18 //x2=29.42 //y2=1.135
cc_2813 ( N_noxref_11_M16_noxref_d N_GND_c_6149_n ) capacitor c=2.93544e-19 \
 //x=30.2 //y=1.085 //x2=29.42 //y2=1.135
cc_2814 ( N_noxref_11_c_3949_n N_GND_c_6160_n ) capacitor c=7.75992e-19 \
 //x=30.745 //y=1.835 //x2=31.4 //y2=0.175
cc_2815 ( N_noxref_11_c_3957_n N_GND_c_6160_n ) capacitor c=3.21306e-19 \
 //x=30.83 //y=3.67 //x2=31.4 //y2=0.175
cc_2816 ( N_noxref_11_c_4023_p N_GND_c_6606_n ) capacitor c=0.00114179f \
 //x=32.31 //y=2.265 //x2=32.595 //y2=0.715
cc_2817 ( N_noxref_11_c_4046_p N_GND_c_6606_n ) capacitor c=3.95714e-19 \
 //x=32.31 //y=2.265 //x2=32.595 //y2=0.715
cc_2818 ( N_noxref_11_c_4058_p N_GND_c_6606_n ) capacitor c=0.0125444f \
 //x=32.42 //y=1.09 //x2=32.595 //y2=0.715
cc_2819 ( N_noxref_11_c_4038_p N_GND_c_6606_n ) capacitor c=2.1838e-19 \
 //x=32.31 //y=2.265 //x2=32.595 //y2=0.715
cc_2820 ( N_noxref_11_c_4062_p N_GND_c_6610_n ) capacitor c=0.0132277f \
 //x=32.95 //y=1.09 //x2=33.085 //y2=0.715
cc_2821 ( N_noxref_11_c_3951_n N_GND_c_6182_n ) capacitor c=5.90582e-19 \
 //x=30.83 //y=3.35 //x2=28.24 //y2=0.175
cc_2822 ( N_noxref_11_c_3943_n N_GND_c_6183_n ) capacitor c=0.00269515f \
 //x=30.39 //y=1.75 //x2=31.57 //y2=0.175
cc_2823 ( N_noxref_11_c_3949_n N_GND_c_6183_n ) capacitor c=0.027102f \
 //x=30.745 //y=1.835 //x2=31.57 //y2=0.175
cc_2824 ( N_noxref_11_c_3963_n N_GND_c_6183_n ) capacitor c=0.0103129f \
 //x=32.31 //y=3.35 //x2=31.57 //y2=0.175
cc_2825 ( N_noxref_11_c_4023_p N_GND_c_6183_n ) capacitor c=0.00594409f \
 //x=32.31 //y=2.265 //x2=31.57 //y2=0.175
cc_2826 ( N_noxref_11_c_4046_p N_GND_c_6183_n ) capacitor c=0.00788922f \
 //x=32.31 //y=2.265 //x2=31.57 //y2=0.175
cc_2827 ( N_noxref_11_c_4029_p N_GND_c_6183_n ) capacitor c=0.00427677f \
 //x=32.42 //y=2.1 //x2=31.57 //y2=0.175
cc_2828 ( N_noxref_11_c_4038_p N_GND_c_6183_n ) capacitor c=0.00687518f \
 //x=32.31 //y=2.265 //x2=31.57 //y2=0.175
cc_2829 ( N_noxref_11_c_4046_p N_GND_c_6619_n ) capacitor c=0.0022444f \
 //x=32.31 //y=2.265 //x2=33.79 //y2=0.175
cc_2830 ( N_noxref_11_c_4038_p N_GND_c_6619_n ) capacitor c=2.63786e-19 \
 //x=32.31 //y=2.265 //x2=33.79 //y2=0.175
cc_2831 ( N_noxref_11_c_3968_n N_GND_M15_noxref_d ) capacitor c=2.82748e-19 \
 //x=30.39 //y=1.18 //x2=29.23 //y2=1.045
cc_2832 ( N_noxref_11_c_4019_p N_GND_M17_noxref_s ) capacitor c=8.20337e-19 \
 //x=32.31 //y=3.67 //x2=32.065 //y2=0.55
cc_2833 ( N_noxref_11_c_4023_p N_GND_M17_noxref_s ) capacitor c=0.00297876f \
 //x=32.31 //y=2.265 //x2=32.065 //y2=0.55
cc_2834 ( N_noxref_11_c_4046_p N_GND_M17_noxref_s ) capacitor c=0.00651326f \
 //x=32.31 //y=2.265 //x2=32.065 //y2=0.55
cc_2835 ( N_noxref_11_c_4058_p N_GND_M17_noxref_s ) capacitor c=0.0300873f \
 //x=32.42 //y=1.09 //x2=32.065 //y2=0.55
cc_2836 ( N_noxref_11_c_4028_p N_GND_M17_noxref_s ) capacitor c=0.002132f \
 //x=32.42 //y=1.745 //x2=32.065 //y2=0.55
cc_2837 ( N_noxref_11_c_4029_p N_GND_M17_noxref_s ) capacitor c=0.00304786f \
 //x=32.42 //y=2.1 //x2=32.065 //y2=0.55
cc_2838 ( N_noxref_11_c_4060_p N_GND_M17_noxref_s ) capacitor c=0.00517463f \
 //x=32.795 //y=0.935 //x2=32.065 //y2=0.55
cc_2839 ( N_noxref_11_c_4062_p N_GND_M17_noxref_s ) capacitor c=0.0153553f \
 //x=32.95 //y=1.09 //x2=32.065 //y2=0.55
cc_2840 ( N_noxref_11_c_4031_p N_GND_M17_noxref_s ) capacitor c=0.00629878f \
 //x=32.95 //y=1.435 //x2=32.065 //y2=0.55
cc_2841 ( N_noxref_11_c_4038_p N_GND_M17_noxref_s ) capacitor c=0.00405173f \
 //x=32.31 //y=2.265 //x2=32.065 //y2=0.55
cc_2842 ( N_noxref_11_c_4011_p N_noxref_28_c_7433_n ) capacitor c=0.00900974f \
 //x=30.475 //y=1.835 //x2=29.905 //y2=1.675
cc_2843 ( N_noxref_11_c_3949_n N_noxref_28_c_7437_n ) capacitor c=0.00373013f \
 //x=30.745 //y=1.835 //x2=30.79 //y2=0.71
cc_2844 ( N_noxref_11_c_3968_n N_noxref_28_c_7437_n ) capacitor c=0.00367971f \
 //x=30.39 //y=1.18 //x2=30.79 //y2=0.71
cc_2845 ( N_noxref_11_M16_noxref_d N_noxref_28_c_7437_n ) capacitor \
 c=0.00910163f //x=30.2 //y=1.085 //x2=30.79 //y2=0.71
cc_2846 ( N_noxref_11_c_3943_n N_noxref_28_M15_noxref_s ) capacitor \
 c=0.0156395f //x=30.39 //y=1.75 //x2=28.8 //y2=0.545
cc_2847 ( N_noxref_11_c_3949_n N_noxref_28_M15_noxref_s ) capacitor \
 c=0.00640979f //x=30.745 //y=1.835 //x2=28.8 //y2=0.545
cc_2848 ( N_noxref_11_c_3957_n N_noxref_28_M15_noxref_s ) capacitor \
 c=4.17069e-19 //x=30.83 //y=3.67 //x2=28.8 //y2=0.545
cc_2849 ( N_noxref_11_c_3968_n N_noxref_28_M15_noxref_s ) capacitor \
 c=0.00896448f //x=30.39 //y=1.18 //x2=28.8 //y2=0.545
cc_2850 ( N_noxref_11_c_3974_n N_noxref_28_M15_noxref_s ) capacitor \
 c=0.0010514f //x=30.83 //y=3.51 //x2=28.8 //y2=0.545
cc_2851 ( N_noxref_11_M16_noxref_d N_noxref_28_M15_noxref_s ) capacitor \
 c=0.0275552f //x=30.2 //y=1.085 //x2=28.8 //y2=0.545
cc_2852 ( N_noxref_12_c_4293_p N_noxref_13_c_4500_n ) capacitor c=0.00259711f \
 //x=33.26 //y=3.125 //x2=32.965 //y2=2.02
cc_2853 ( N_noxref_12_c_4289_n N_noxref_13_c_4501_n ) capacitor c=0.0068747f \
 //x=32.52 //y=3.125 //x2=32.765 //y2=2.02
cc_2854 ( N_noxref_12_c_4293_p N_noxref_13_c_4503_n ) capacitor c=0.00130181f \
 //x=33.26 //y=3.125 //x2=32.965 //y2=5.14
cc_2855 ( N_noxref_12_c_4289_n N_noxref_13_c_4504_n ) capacitor c=0.00332687f \
 //x=32.52 //y=3.125 //x2=32.77 //y2=5.14
cc_2856 ( N_noxref_12_c_4274_n N_noxref_13_c_4507_n ) capacitor c=0.00928534f \
 //x=34.9 //y=2.965 //x2=33.05 //y2=3.35
cc_2857 ( N_noxref_12_c_4298_p N_noxref_13_c_4507_n ) capacitor c=0.00258416f \
 //x=34.9 //y=3.285 //x2=33.05 //y2=3.35
cc_2858 ( N_noxref_12_c_4275_n N_noxref_13_c_4507_n ) capacitor c=0.00110732f \
 //x=34.9 //y=4.765 //x2=33.05 //y2=3.35
cc_2859 ( N_noxref_12_c_4300_p N_noxref_13_c_4507_n ) capacitor c=0.00473642f \
 //x=34.9 //y=2.26 //x2=33.05 //y2=3.35
cc_2860 ( N_noxref_12_c_4289_n N_noxref_13_c_4507_n ) capacitor c=2.81238e-19 \
 //x=32.52 //y=3.125 //x2=33.05 //y2=3.35
cc_2861 ( N_noxref_12_c_4293_p N_noxref_13_c_4507_n ) capacitor c=0.0303099f \
 //x=33.26 //y=3.125 //x2=33.05 //y2=3.35
cc_2862 ( N_noxref_12_c_4275_n N_noxref_13_c_4512_n ) capacitor c=0.00254087f \
 //x=34.9 //y=4.765 //x2=33.05 //y2=3.67
cc_2863 ( N_noxref_12_c_4293_p N_noxref_13_c_4512_n ) capacitor c=0.00702644f \
 //x=33.26 //y=3.125 //x2=33.05 //y2=3.67
cc_2864 ( N_noxref_12_c_4275_n N_noxref_13_c_4515_n ) capacitor c=0.0199075f \
 //x=34.9 //y=4.765 //x2=33.05 //y2=5.055
cc_2865 ( N_noxref_12_c_4306_p N_noxref_13_c_4515_n ) capacitor c=0.00642329f \
 //x=34.745 //y=4.885 //x2=33.05 //y2=5.055
cc_2866 ( N_noxref_12_c_4274_n N_noxref_13_c_4555_n ) capacitor c=0.0241588f \
 //x=34.9 //y=2.965 //x2=35.64 //y2=3.35
cc_2867 ( N_noxref_12_c_4298_p N_noxref_13_c_4555_n ) capacitor c=0.014957f \
 //x=34.9 //y=3.285 //x2=35.64 //y2=3.35
cc_2868 ( N_noxref_12_c_4275_n N_noxref_13_c_4555_n ) capacitor c=0.0028341f \
 //x=34.9 //y=4.765 //x2=35.64 //y2=3.35
cc_2869 ( N_noxref_12_c_4310_p N_noxref_13_c_4555_n ) capacitor c=9.19401e-19 \
 //x=34.9 //y=3.14 //x2=35.64 //y2=3.35
cc_2870 ( N_noxref_12_c_4293_p N_noxref_13_c_4555_n ) capacitor c=0.00692851f \
 //x=33.26 //y=3.125 //x2=35.64 //y2=3.35
cc_2871 ( N_noxref_12_c_4312_p N_noxref_13_c_4555_n ) capacitor c=2.61947e-19 \
 //x=34.9 //y=2.26 //x2=35.64 //y2=3.35
cc_2872 ( N_noxref_12_c_4275_n N_noxref_13_c_4561_n ) capacitor c=0.0173986f \
 //x=34.9 //y=4.765 //x2=35.64 //y2=3.67
cc_2873 ( N_noxref_12_c_4289_n N_noxref_13_c_4520_n ) capacitor c=6.00397e-19 \
 //x=32.52 //y=3.125 //x2=32.68 //y2=1.185
cc_2874 ( N_noxref_12_c_4275_n N_noxref_13_c_4563_n ) capacitor c=5.62253e-19 \
 //x=34.9 //y=4.765 //x2=35.635 //y2=3.51
cc_2875 ( N_noxref_12_c_4300_p N_noxref_13_c_4564_n ) capacitor c=0.0217252f \
 //x=34.9 //y=2.26 //x2=35.64 //y2=2.26
cc_2876 ( N_noxref_12_c_4312_p N_noxref_13_c_4564_n ) capacitor c=5.41079e-19 \
 //x=34.9 //y=2.26 //x2=35.64 //y2=2.26
cc_2877 ( N_noxref_12_c_4318_p N_noxref_13_c_4564_n ) capacitor c=0.00178181f \
 //x=34.705 //y=2.095 //x2=35.64 //y2=2.26
cc_2878 ( N_noxref_12_c_4306_p N_noxref_13_c_4567_n ) capacitor c=0.0308117f \
 //x=34.745 //y=4.885 //x2=35.675 //y2=4.885
cc_2879 ( N_noxref_12_c_4320_p N_noxref_13_c_4567_n ) capacitor c=0.00105182f \
 //x=34.745 //y=4.885 //x2=35.675 //y2=4.885
cc_2880 ( N_noxref_12_c_4321_p N_noxref_13_c_4567_n ) capacitor c=0.00107587f \
 //x=35.165 //y=4.975 //x2=35.675 //y2=4.885
cc_2881 ( N_noxref_12_c_4275_n N_noxref_13_c_4570_n ) capacitor c=0.029593f \
 //x=34.9 //y=4.765 //x2=35.675 //y2=4.74
cc_2882 ( N_noxref_12_c_4298_p N_noxref_13_c_4571_n ) capacitor c=0.0057024f \
 //x=34.9 //y=3.285 //x2=35.475 //y2=3.51
cc_2883 ( N_noxref_12_c_4275_n N_noxref_13_c_4571_n ) capacitor c=0.0269174f \
 //x=34.9 //y=4.765 //x2=35.475 //y2=3.51
cc_2884 ( N_noxref_12_c_4306_p N_noxref_13_c_4571_n ) capacitor c=0.00643715f \
 //x=34.745 //y=4.885 //x2=35.475 //y2=3.51
cc_2885 ( N_noxref_12_c_4293_p N_noxref_13_c_4571_n ) capacitor c=0.182388f \
 //x=33.26 //y=3.125 //x2=35.475 //y2=3.51
cc_2886 ( N_noxref_12_c_4320_p N_noxref_13_c_4571_n ) capacitor c=0.00380803f \
 //x=34.745 //y=4.885 //x2=35.475 //y2=3.51
cc_2887 ( N_noxref_12_c_4275_n N_noxref_13_c_4530_n ) capacitor c=0.00157696f \
 //x=34.9 //y=4.765 //x2=33.205 //y2=3.51
cc_2888 ( N_noxref_12_c_4293_p N_noxref_13_c_4530_n ) capacitor c=0.0374977f \
 //x=33.26 //y=3.125 //x2=33.205 //y2=3.51
cc_2889 ( N_noxref_12_c_4275_n N_noxref_13_c_4578_n ) capacitor c=0.00328982f \
 //x=34.9 //y=4.765 //x2=35.635 //y2=3.51
cc_2890 ( N_noxref_12_c_4274_n N_noxref_13_c_4579_n ) capacitor c=2.61947e-19 \
 //x=34.9 //y=2.965 //x2=35.64 //y2=2.26
cc_2891 ( N_noxref_12_c_4300_p N_noxref_13_c_4579_n ) capacitor c=5.24865e-19 \
 //x=34.9 //y=2.26 //x2=35.64 //y2=2.26
cc_2892 ( N_noxref_12_c_4312_p N_noxref_13_c_4579_n ) capacitor c=0.00445529f \
 //x=34.9 //y=2.26 //x2=35.64 //y2=2.26
cc_2893 ( N_noxref_12_c_4318_p N_noxref_13_c_4579_n ) capacitor c=0.00267961f \
 //x=34.705 //y=2.095 //x2=35.64 //y2=2.26
cc_2894 ( N_noxref_12_c_4306_p N_noxref_13_c_4583_n ) capacitor c=4.32488e-19 \
 //x=34.745 //y=4.885 //x2=35.675 //y2=4.885
cc_2895 ( N_noxref_12_c_4320_p N_noxref_13_c_4583_n ) capacitor c=0.00242589f \
 //x=34.745 //y=4.885 //x2=35.675 //y2=4.885
cc_2896 ( N_noxref_12_c_4321_p N_noxref_13_c_4583_n ) capacitor c=0.00116837f \
 //x=35.165 //y=4.975 //x2=35.675 //y2=4.885
cc_2897 ( N_noxref_12_c_4338_p N_noxref_13_c_4583_n ) capacitor c=0.00121814f \
 //x=34.745 //y=4.885 //x2=35.675 //y2=4.885
cc_2898 ( N_noxref_12_M57_noxref_g N_noxref_13_M59_noxref_g ) capacitor \
 c=0.0101077f //x=34.8 //y=6.205 //x2=35.68 //y2=6.205
cc_2899 ( N_noxref_12_M58_noxref_g N_noxref_13_M59_noxref_g ) capacitor \
 c=0.109254f //x=35.24 //y=6.205 //x2=35.68 //y2=6.205
cc_2900 ( N_noxref_12_M58_noxref_g N_noxref_13_M60_noxref_g ) capacitor \
 c=0.00945018f //x=35.24 //y=6.205 //x2=36.12 //y2=6.205
cc_2901 ( N_noxref_12_c_4342_p N_noxref_13_c_4590_n ) capacitor c=0.00125788f \
 //x=34.705 //y=1.085 //x2=35.675 //y2=1.085
cc_2902 ( N_noxref_12_c_4343_p N_noxref_13_c_4590_n ) capacitor c=0.0126654f \
 //x=35.235 //y=1.085 //x2=35.675 //y2=1.085
cc_2903 ( N_noxref_12_c_4344_p N_noxref_13_c_4592_n ) capacitor c=0.00149727f \
 //x=34.705 //y=1.43 //x2=35.675 //y2=1.435
cc_2904 ( N_noxref_12_c_4345_p N_noxref_13_c_4592_n ) capacitor c=0.00111802f \
 //x=34.705 //y=1.74 //x2=35.675 //y2=1.435
cc_2905 ( N_noxref_12_c_4346_p N_noxref_13_c_4592_n ) capacitor c=0.0126654f \
 //x=35.235 //y=1.43 //x2=35.675 //y2=1.435
cc_2906 ( N_noxref_12_c_4345_p N_noxref_13_c_4595_n ) capacitor c=0.00116305f \
 //x=34.705 //y=1.74 //x2=35.675 //y2=1.74
cc_2907 ( N_noxref_12_c_4346_p N_noxref_13_c_4595_n ) capacitor c=0.00938322f \
 //x=35.235 //y=1.43 //x2=35.675 //y2=1.74
cc_2908 ( N_noxref_12_c_4346_p N_noxref_13_c_4597_n ) capacitor c=0.00131492f \
 //x=35.235 //y=1.43 //x2=36.05 //y2=1.585
cc_2909 ( N_noxref_12_c_4343_p N_noxref_13_c_4598_n ) capacitor c=0.00132934f \
 //x=35.235 //y=1.085 //x2=36.205 //y2=1.085
cc_2910 ( N_noxref_12_c_4346_p N_noxref_13_c_4599_n ) capacitor c=0.00151998f \
 //x=35.235 //y=1.43 //x2=36.205 //y2=1.435
cc_2911 ( N_noxref_12_c_4300_p N_noxref_13_c_4600_n ) capacitor c=0.00173144f \
 //x=34.9 //y=2.26 //x2=35.64 //y2=2.26
cc_2912 ( N_noxref_12_c_4312_p N_noxref_13_c_4600_n ) capacitor c=0.00266443f \
 //x=34.9 //y=2.26 //x2=35.64 //y2=2.26
cc_2913 ( N_noxref_12_c_4318_p N_noxref_13_c_4600_n ) capacitor c=0.0181449f \
 //x=34.705 //y=2.095 //x2=35.64 //y2=2.26
cc_2914 ( N_noxref_12_c_4318_p N_noxref_13_c_4603_n ) capacitor c=0.00636965f \
 //x=34.705 //y=2.095 //x2=35.64 //y2=2.095
cc_2915 ( N_noxref_12_c_4275_n N_noxref_13_c_4604_n ) capacitor c=0.00117265f \
 //x=34.9 //y=4.765 //x2=35.675 //y2=4.885
cc_2916 ( N_noxref_12_c_4306_p N_noxref_13_c_4604_n ) capacitor c=4.8456e-19 \
 //x=34.745 //y=4.885 //x2=35.675 //y2=4.885
cc_2917 ( N_noxref_12_c_4320_p N_noxref_13_c_4604_n ) capacitor c=0.00211373f \
 //x=34.745 //y=4.885 //x2=35.675 //y2=4.885
cc_2918 ( N_noxref_12_c_4321_p N_noxref_13_c_4604_n ) capacitor c=0.0203928f \
 //x=35.165 //y=4.975 //x2=35.675 //y2=4.885
cc_2919 ( N_noxref_12_c_4338_p N_noxref_13_c_4604_n ) capacitor c=0.00590438f \
 //x=34.745 //y=4.885 //x2=35.675 //y2=4.885
cc_2920 ( N_noxref_12_c_4300_p N_noxref_14_c_4745_n ) capacitor c=0.00117774f \
 //x=34.9 //y=2.26 //x2=34.97 //y2=1.305
cc_2921 ( N_noxref_12_c_4312_p N_noxref_14_c_4745_n ) capacitor c=7.02188e-19 \
 //x=34.9 //y=2.26 //x2=34.97 //y2=1.305
cc_2922 ( N_noxref_12_c_4342_p N_noxref_14_c_4745_n ) capacitor c=6.03241e-19 \
 //x=34.705 //y=1.085 //x2=34.97 //y2=1.305
cc_2923 ( N_noxref_12_c_4344_p N_noxref_14_c_4745_n ) capacitor c=0.00325126f \
 //x=34.705 //y=1.43 //x2=34.97 //y2=1.305
cc_2924 ( N_noxref_12_c_4365_p N_noxref_14_c_4745_n ) capacitor c=5.29726e-19 \
 //x=35.08 //y=0.93 //x2=34.97 //y2=1.305
cc_2925 ( N_noxref_12_c_4366_p N_noxref_14_c_4745_n ) capacitor c=6.14781e-19 \
 //x=35.08 //y=1.585 //x2=34.97 //y2=1.305
cc_2926 ( N_noxref_12_c_4343_p N_noxref_14_c_4745_n ) capacitor c=5.57259e-19 \
 //x=35.235 //y=1.085 //x2=34.97 //y2=1.305
cc_2927 ( N_noxref_12_c_4346_p N_noxref_14_c_4745_n ) capacitor c=0.00212774f \
 //x=35.235 //y=1.43 //x2=34.97 //y2=1.305
cc_2928 ( N_noxref_12_c_4344_p N_noxref_14_c_4743_n ) capacitor c=0.00108322f \
 //x=34.705 //y=1.43 //x2=34.97 //y2=1.75
cc_2929 ( N_noxref_12_c_4345_p N_noxref_14_c_4743_n ) capacitor c=0.00312733f \
 //x=34.705 //y=1.74 //x2=34.97 //y2=1.75
cc_2930 ( N_noxref_12_c_4318_p N_noxref_14_c_4743_n ) capacitor c=0.00326244f \
 //x=34.705 //y=2.095 //x2=34.97 //y2=1.75
cc_2931 ( N_noxref_12_c_4366_p N_noxref_14_c_4743_n ) capacitor c=0.00672368f \
 //x=35.08 //y=1.585 //x2=34.97 //y2=1.75
cc_2932 ( N_noxref_12_c_4346_p N_noxref_14_c_4743_n ) capacitor c=0.00253555f \
 //x=35.235 //y=1.43 //x2=34.97 //y2=1.75
cc_2933 ( N_noxref_12_c_4346_p N_noxref_14_c_4758_n ) capacitor c=7.25274e-19 \
 //x=35.235 //y=1.43 //x2=35.855 //y2=1.835
cc_2934 ( N_noxref_12_c_4298_p N_noxref_14_c_4744_n ) capacitor c=8.53783e-19 \
 //x=34.9 //y=3.285 //x2=35.055 //y2=1.835
cc_2935 ( N_noxref_12_c_4300_p N_noxref_14_c_4744_n ) capacitor c=0.0163579f \
 //x=34.9 //y=2.26 //x2=35.055 //y2=1.835
cc_2936 ( N_noxref_12_c_4293_p N_noxref_14_c_4744_n ) capacitor c=5.17513e-19 \
 //x=33.26 //y=3.125 //x2=35.055 //y2=1.835
cc_2937 ( N_noxref_12_c_4312_p N_noxref_14_c_4744_n ) capacitor c=0.00293572f \
 //x=34.9 //y=2.26 //x2=35.055 //y2=1.835
cc_2938 ( N_noxref_12_c_4318_p N_noxref_14_c_4744_n ) capacitor c=0.00110769f \
 //x=34.705 //y=2.095 //x2=35.055 //y2=1.835
cc_2939 ( N_noxref_12_c_4346_p N_noxref_14_c_4764_n ) capacitor c=6.29838e-19 \
 //x=35.235 //y=1.43 //x2=35.94 //y2=1.75
cc_2940 ( N_noxref_12_c_4274_n N_noxref_14_c_4765_n ) capacitor c=0.0025995f \
 //x=34.9 //y=2.965 //x2=36.38 //y2=3.355
cc_2941 ( N_noxref_12_c_4275_n N_noxref_14_c_4766_n ) capacitor c=0.00434294f \
 //x=34.9 //y=4.765 //x2=36.38 //y2=5.305
cc_2942 ( N_noxref_12_c_4320_p N_noxref_14_c_4766_n ) capacitor c=2.44646e-19 \
 //x=34.745 //y=4.885 //x2=36.38 //y2=5.305
cc_2943 ( N_noxref_12_c_4300_p N_noxref_14_M18_noxref_d ) capacitor \
 c=7.18966e-19 //x=34.9 //y=2.26 //x2=34.78 //y2=1.085
cc_2944 ( N_noxref_12_c_4312_p N_noxref_14_M18_noxref_d ) capacitor \
 c=0.00150225f //x=34.9 //y=2.26 //x2=34.78 //y2=1.085
cc_2945 ( N_noxref_12_c_4342_p N_noxref_14_M18_noxref_d ) capacitor \
 c=0.00124139f //x=34.705 //y=1.085 //x2=34.78 //y2=1.085
cc_2946 ( N_noxref_12_c_4344_p N_noxref_14_M18_noxref_d ) capacitor \
 c=0.00237422f //x=34.705 //y=1.43 //x2=34.78 //y2=1.085
cc_2947 ( N_noxref_12_c_4318_p N_noxref_14_M18_noxref_d ) capacitor \
 c=4.64713e-19 //x=34.705 //y=2.095 //x2=34.78 //y2=1.085
cc_2948 ( N_noxref_12_c_4365_p N_noxref_14_M18_noxref_d ) capacitor \
 c=0.00213893f //x=35.08 //y=0.93 //x2=34.78 //y2=1.085
cc_2949 ( N_noxref_12_c_4366_p N_noxref_14_M18_noxref_d ) capacitor \
 c=0.00345753f //x=35.08 //y=1.585 //x2=34.78 //y2=1.085
cc_2950 ( N_noxref_12_c_4343_p N_noxref_14_M18_noxref_d ) capacitor \
 c=0.00211919f //x=35.235 //y=1.085 //x2=34.78 //y2=1.085
cc_2951 ( N_noxref_12_c_4346_p N_noxref_14_M18_noxref_d ) capacitor \
 c=0.00237422f //x=35.235 //y=1.43 //x2=34.78 //y2=1.085
cc_2952 ( N_noxref_12_c_4200_n N_VDD_c_5104_n ) capacitor c=0.00259721f \
 //x=27.135 //y=5.42 //x2=34.935 //y2=7.585
cc_2953 ( N_noxref_12_c_4201_n N_VDD_c_5104_n ) capacitor c=0.00221242f \
 //x=27.415 //y=5.14 //x2=34.935 //y2=7.585
cc_2954 ( N_noxref_12_c_4260_n N_VDD_c_5104_n ) capacitor c=0.00241566f \
 //x=27.135 //y=5.56 //x2=34.935 //y2=7.585
cc_2955 ( N_noxref_12_M57_noxref_g N_VDD_c_5479_n ) capacitor c=0.00122608f \
 //x=34.8 //y=6.205 //x2=35.02 //y2=7.035
cc_2956 ( N_noxref_12_M58_noxref_g N_VDD_c_5479_n ) capacitor c=0.00122608f \
 //x=35.24 //y=6.205 //x2=35.02 //y2=7.035
cc_2957 ( N_noxref_12_M57_noxref_g N_VDD_c_5481_n ) capacitor c=0.00205385f \
 //x=34.8 //y=6.205 //x2=35.02 //y2=7.41
cc_2958 ( N_noxref_12_M58_noxref_g N_VDD_c_5481_n ) capacitor c=0.00294739f \
 //x=35.24 //y=6.205 //x2=35.02 //y2=7.41
cc_2959 ( N_noxref_12_c_4200_n N_VDD_c_5377_n ) capacitor c=8.96756e-19 \
 //x=27.135 //y=5.42 //x2=27.49 //y2=7.585
cc_2960 ( N_noxref_12_c_4201_n N_VDD_c_5377_n ) capacitor c=0.00197507f \
 //x=27.415 //y=5.14 //x2=27.49 //y2=7.585
cc_2961 ( N_noxref_12_c_4260_n N_VDD_c_5377_n ) capacitor c=0.0138017f \
 //x=27.135 //y=5.56 //x2=27.49 //y2=7.585
cc_2962 ( N_noxref_12_M57_noxref_g N_VDD_c_5486_n ) capacitor c=0.00737762f \
 //x=34.8 //y=6.205 //x2=36.95 //y2=7.585
cc_2963 ( N_noxref_12_M58_noxref_g N_VDD_c_5486_n ) capacitor c=0.00760847f \
 //x=35.24 //y=6.205 //x2=36.95 //y2=7.585
cc_2964 ( N_noxref_12_c_4202_n N_VDD_c_5139_n ) capacitor c=0.00453802f \
 //x=27.22 //y=5.14 //x2=26.02 //y2=7.585
cc_2965 ( N_noxref_12_c_4260_n N_VDD_c_5139_n ) capacitor c=0.00821397f \
 //x=27.135 //y=5.56 //x2=26.02 //y2=7.585
cc_2966 ( N_noxref_12_c_4200_n N_VDD_c_5140_n ) capacitor c=0.00231872f \
 //x=27.135 //y=5.42 //x2=28.24 //y2=7.585
cc_2967 ( N_noxref_12_c_4192_n N_VDD_c_5140_n ) capacitor c=0.0209204f \
 //x=27.5 //y=5.055 //x2=28.24 //y2=7.585
cc_2968 ( N_noxref_12_c_4194_n N_VDD_c_5140_n ) capacitor c=0.00289606f \
 //x=30.445 //y=3.14 //x2=28.24 //y2=7.585
cc_2969 ( N_noxref_12_c_4260_n N_VDD_c_5140_n ) capacitor c=0.00824308f \
 //x=27.135 //y=5.56 //x2=28.24 //y2=7.585
cc_2970 ( N_noxref_12_c_4275_n N_VDD_c_5450_n ) capacitor c=0.00722719f \
 //x=34.9 //y=4.765 //x2=33.79 //y2=7.585
cc_2971 ( N_noxref_12_c_4306_p N_VDD_c_5450_n ) capacitor c=0.00344941f \
 //x=34.745 //y=4.885 //x2=33.79 //y2=7.585
cc_2972 ( N_noxref_12_c_4320_p N_VDD_c_5450_n ) capacitor c=0.00616738f \
 //x=34.745 //y=4.885 //x2=33.79 //y2=7.585
cc_2973 ( N_noxref_12_M57_noxref_g N_VDD_c_5450_n ) capacitor c=0.00817584f \
 //x=34.8 //y=6.205 //x2=33.79 //y2=7.585
cc_2974 ( N_noxref_12_c_4338_p N_VDD_c_5450_n ) capacitor c=0.004975f \
 //x=34.745 //y=4.885 //x2=33.79 //y2=7.585
cc_2975 ( N_noxref_12_c_4320_p N_VDD_c_5499_n ) capacitor c=3.49022e-19 \
 //x=34.745 //y=4.885 //x2=37.12 //y2=7.585
cc_2976 ( N_noxref_12_c_4200_n N_VDD_M45_noxref_s ) capacitor c=2.62188e-19 \
 //x=27.135 //y=5.42 //x2=23.345 //y2=5.2
cc_2977 ( N_noxref_12_c_4200_n N_VDD_M49_noxref_s ) capacitor c=0.0465774f \
 //x=27.135 //y=5.42 //x2=26.56 //y2=5.2
cc_2978 ( N_noxref_12_c_4260_n N_VDD_M49_noxref_s ) capacitor c=0.0899011f \
 //x=27.135 //y=5.56 //x2=26.56 //y2=5.2
cc_2979 ( N_noxref_12_c_4200_n N_VDD_M50_noxref_d ) capacitor c=0.0474638f \
 //x=27.135 //y=5.42 //x2=27.43 //y2=5.2
cc_2980 ( N_noxref_12_c_4201_n N_VDD_M50_noxref_d ) capacitor c=0.0218469f \
 //x=27.415 //y=5.14 //x2=27.43 //y2=5.2
cc_2981 ( N_noxref_12_c_4191_n N_VDD_M50_noxref_d ) capacitor c=0.00188373f \
 //x=27.5 //y=3.31 //x2=27.43 //y2=5.2
cc_2982 ( N_noxref_12_c_4260_n N_VDD_M50_noxref_d ) capacitor c=0.0907f \
 //x=27.135 //y=5.56 //x2=27.43 //y2=5.2
cc_2983 ( N_noxref_12_c_4200_n N_VDD_M51_noxref_s ) capacitor c=0.00151378f \
 //x=27.135 //y=5.42 //x2=28.895 //y2=5.2
cc_2984 ( N_noxref_12_c_4310_p N_VDD_M57_noxref_d ) capacitor c=4.14695e-19 \
 //x=34.9 //y=3.14 //x2=34.875 //y2=5.205
cc_2985 ( N_noxref_12_M57_noxref_g N_VDD_M57_noxref_d ) capacitor c=0.0130453f \
 //x=34.8 //y=6.205 //x2=34.875 //y2=5.205
cc_2986 ( N_noxref_12_M58_noxref_g N_VDD_M57_noxref_d ) capacitor c=0.0142727f \
 //x=35.24 //y=6.205 //x2=34.875 //y2=5.205
cc_2987 ( N_noxref_12_c_4321_p N_VDD_M57_noxref_d ) capacitor c=0.00240567f \
 //x=35.165 //y=4.975 //x2=34.875 //y2=5.205
cc_2988 ( N_noxref_12_c_4188_n N_GND_c_6144_n ) capacitor c=0.00145427f \
 //x=27.215 //y=2.02 //x2=29.335 //y2=0.175
cc_2989 ( N_noxref_12_c_4191_n N_GND_c_6144_n ) capacitor c=3.61716e-19 \
 //x=27.5 //y=3.31 //x2=29.335 //y2=0.175
cc_2990 ( N_noxref_12_c_4193_n N_GND_c_6144_n ) capacitor c=0.00957658f \
 //x=27.13 //y=1.185 //x2=29.335 //y2=0.175
cc_2991 ( N_noxref_12_c_4258_n N_GND_c_6144_n ) capacitor c=3.85911e-19 \
 //x=27.5 //y=3.14 //x2=29.335 //y2=0.175
cc_2992 ( N_noxref_12_M14_noxref_d N_GND_c_6144_n ) capacitor c=0.00119455f \
 //x=26.945 //y=1.09 //x2=29.335 //y2=0.175
cc_2993 ( N_noxref_12_c_4298_p N_GND_c_6145_n ) capacitor c=3.00566e-19 \
 //x=34.9 //y=3.285 //x2=38.97 //y2=0.18
cc_2994 ( N_noxref_12_c_4300_p N_GND_c_6145_n ) capacitor c=8.84449e-19 \
 //x=34.9 //y=2.26 //x2=38.97 //y2=0.18
cc_2995 ( N_noxref_12_c_4193_n N_GND_c_6149_n ) capacitor c=0.00522864f \
 //x=27.13 //y=1.185 //x2=29.42 //y2=1.135
cc_2996 ( N_noxref_12_c_4193_n N_GND_c_6159_n ) capacitor c=0.00130539f \
 //x=27.13 //y=1.185 //x2=27.045 //y2=0.715
cc_2997 ( N_noxref_12_c_4187_n N_GND_c_6571_n ) capacitor c=0.00254795f \
 //x=27.415 //y=2.02 //x2=27.535 //y2=0.715
cc_2998 ( N_noxref_12_c_4193_n N_GND_c_6571_n ) capacitor c=0.00130539f \
 //x=27.13 //y=1.185 //x2=27.535 //y2=0.715
cc_2999 ( N_noxref_12_c_4258_n N_GND_c_6571_n ) capacitor c=3.38701e-19 \
 //x=27.5 //y=3.14 //x2=27.535 //y2=0.715
cc_3000 ( N_noxref_12_c_4298_p N_GND_c_6644_n ) capacitor c=5.50931e-19 \
 //x=34.9 //y=3.285 //x2=35.37 //y2=0.71
cc_3001 ( N_noxref_12_c_4300_p N_GND_c_6644_n ) capacitor c=0.0010437f \
 //x=34.9 //y=2.26 //x2=35.37 //y2=0.71
cc_3002 ( N_noxref_12_c_4312_p N_GND_c_6644_n ) capacitor c=4.19728e-19 \
 //x=34.9 //y=2.26 //x2=35.37 //y2=0.71
cc_3003 ( N_noxref_12_c_4342_p N_GND_c_6644_n ) capacitor c=0.0211652f \
 //x=34.705 //y=1.085 //x2=35.37 //y2=0.71
cc_3004 ( N_noxref_12_c_4318_p N_GND_c_6644_n ) capacitor c=2.1838e-19 \
 //x=34.705 //y=2.095 //x2=35.37 //y2=0.71
cc_3005 ( N_noxref_12_c_4343_p N_GND_c_6644_n ) capacitor c=0.00805599f \
 //x=35.235 //y=1.085 //x2=35.37 //y2=0.71
cc_3006 ( N_noxref_12_c_4216_n N_GND_c_6181_n ) capacitor c=0.00158939f \
 //x=27.13 //y=1.935 //x2=26.02 //y2=0.175
cc_3007 ( N_noxref_12_c_4187_n N_GND_c_6182_n ) capacitor c=0.0208673f \
 //x=27.415 //y=2.02 //x2=28.24 //y2=0.175
cc_3008 ( N_noxref_12_c_4188_n N_GND_c_6182_n ) capacitor c=3.23363e-19 \
 //x=27.215 //y=2.02 //x2=28.24 //y2=0.175
cc_3009 ( N_noxref_12_c_4194_n N_GND_c_6182_n ) capacitor c=0.00574654f \
 //x=30.445 //y=3.14 //x2=28.24 //y2=0.175
cc_3010 ( N_noxref_12_c_4286_n N_GND_c_6183_n ) capacitor c=0.00725442f \
 //x=31.92 //y=3.14 //x2=31.57 //y2=0.175
cc_3011 ( N_noxref_12_c_4274_n N_GND_c_6619_n ) capacitor c=0.00821798f \
 //x=34.9 //y=2.965 //x2=33.79 //y2=0.175
cc_3012 ( N_noxref_12_c_4300_p N_GND_c_6619_n ) capacitor c=0.00446799f \
 //x=34.9 //y=2.26 //x2=33.79 //y2=0.175
cc_3013 ( N_noxref_12_c_4293_p N_GND_c_6619_n ) capacitor c=0.00725442f \
 //x=33.26 //y=3.125 //x2=33.79 //y2=0.175
cc_3014 ( N_noxref_12_c_4312_p N_GND_c_6619_n ) capacitor c=0.00369203f \
 //x=34.9 //y=2.26 //x2=33.79 //y2=0.175
cc_3015 ( N_noxref_12_c_4318_p N_GND_c_6619_n ) capacitor c=0.00932032f \
 //x=34.705 //y=2.095 //x2=33.79 //y2=0.175
cc_3016 ( N_noxref_12_c_4216_n N_GND_M14_noxref_s ) capacitor c=0.0298527f \
 //x=27.13 //y=1.935 //x2=26.515 //y2=0.55
cc_3017 ( N_noxref_12_c_4187_n N_GND_M14_noxref_s ) capacitor c=0.0030818f \
 //x=27.415 //y=2.02 //x2=26.515 //y2=0.55
cc_3018 ( N_noxref_12_c_4191_n N_GND_M14_noxref_s ) capacitor c=0.00201987f \
 //x=27.5 //y=3.31 //x2=26.515 //y2=0.55
cc_3019 ( N_noxref_12_c_4193_n N_GND_M14_noxref_s ) capacitor c=0.0140677f \
 //x=27.13 //y=1.185 //x2=26.515 //y2=0.55
cc_3020 ( N_noxref_12_c_4258_n N_GND_M14_noxref_s ) capacitor c=0.00117226f \
 //x=27.5 //y=3.14 //x2=26.515 //y2=0.55
cc_3021 ( N_noxref_12_M14_noxref_d N_GND_M14_noxref_s ) capacitor c=0.0373268f \
 //x=26.945 //y=1.09 //x2=26.515 //y2=0.55
cc_3022 ( N_noxref_12_c_4289_n N_GND_M17_noxref_s ) capacitor c=0.00108752f \
 //x=32.52 //y=3.125 //x2=32.065 //y2=0.55
cc_3023 ( N_noxref_12_c_4293_p N_GND_M17_noxref_s ) capacitor c=0.0018638f \
 //x=33.26 //y=3.125 //x2=32.065 //y2=0.55
cc_3024 ( N_noxref_12_c_4293_p N_GND_M18_noxref_s ) capacitor c=0.00319293f \
 //x=33.26 //y=3.125 //x2=34.35 //y2=0.545
cc_3025 ( N_noxref_12_c_4342_p N_GND_M18_noxref_s ) capacitor c=0.0329097f \
 //x=34.705 //y=1.085 //x2=34.35 //y2=0.545
cc_3026 ( N_noxref_12_c_4343_p N_GND_M18_noxref_s ) capacitor c=0.00605785f \
 //x=35.235 //y=1.085 //x2=34.35 //y2=0.545
cc_3027 ( N_noxref_12_c_4346_p N_GND_M18_noxref_s ) capacitor c=0.00120103f \
 //x=35.235 //y=1.43 //x2=34.35 //y2=0.545
cc_3028 ( N_noxref_12_c_4298_p N_noxref_21_c_6940_n ) capacitor c=5.65836e-19 \
 //x=34.9 //y=3.285 //x2=35.34 //y2=5.39
cc_3029 ( N_noxref_12_c_4310_p N_noxref_21_c_6940_n ) capacitor c=5.46338e-19 \
 //x=34.9 //y=3.14 //x2=35.34 //y2=5.39
cc_3030 ( N_noxref_12_c_4306_p N_noxref_21_c_6940_n ) capacitor c=0.00774202f \
 //x=34.745 //y=4.885 //x2=35.34 //y2=5.39
cc_3031 ( N_noxref_12_c_4320_p N_noxref_21_c_6940_n ) capacitor c=0.00104675f \
 //x=34.745 //y=4.885 //x2=35.34 //y2=5.39
cc_3032 ( N_noxref_12_M57_noxref_g N_noxref_21_c_6940_n ) capacitor \
 c=0.0106664f //x=34.8 //y=6.205 //x2=35.34 //y2=5.39
cc_3033 ( N_noxref_12_M58_noxref_g N_noxref_21_c_6940_n ) capacitor \
 c=0.00949421f //x=35.24 //y=6.205 //x2=35.34 //y2=5.39
cc_3034 ( N_noxref_12_c_4321_p N_noxref_21_c_6940_n ) capacitor c=0.00185445f \
 //x=35.165 //y=4.975 //x2=35.34 //y2=5.39
cc_3035 ( N_noxref_12_c_4306_p N_noxref_21_c_6947_n ) capacitor c=0.0244349f \
 //x=34.745 //y=4.885 //x2=34.58 //y2=5.39
cc_3036 ( N_noxref_12_c_4320_p N_noxref_21_c_6947_n ) capacitor c=0.00565356f \
 //x=34.745 //y=4.885 //x2=34.58 //y2=5.39
cc_3037 ( N_noxref_12_M57_noxref_g N_noxref_21_c_6947_n ) capacitor \
 c=0.00403872f //x=34.8 //y=6.205 //x2=34.58 //y2=5.39
cc_3038 ( N_noxref_12_c_4338_p N_noxref_21_c_6947_n ) capacitor c=9.12041e-19 \
 //x=34.745 //y=4.885 //x2=34.58 //y2=5.39
cc_3039 ( N_noxref_12_M58_noxref_g N_noxref_21_c_6951_n ) capacitor \
 c=0.0018094f //x=35.24 //y=6.205 //x2=35.46 //y2=5.39
cc_3040 ( N_noxref_12_M58_noxref_g N_noxref_21_c_6952_n ) capacitor \
 c=0.00180782f //x=35.24 //y=6.205 //x2=35.46 //y2=6.92
cc_3041 ( N_noxref_12_c_4306_p N_noxref_21_c_6953_n ) capacitor c=0.00154424f \
 //x=34.745 //y=4.885 //x2=34.58 //y2=5.56
cc_3042 ( N_noxref_12_c_4320_p N_noxref_21_c_6953_n ) capacitor c=0.00126654f \
 //x=34.745 //y=4.885 //x2=34.58 //y2=5.56
cc_3043 ( N_noxref_12_M57_noxref_g N_noxref_21_c_6953_n ) capacitor \
 c=0.0483843f //x=34.8 //y=6.205 //x2=34.58 //y2=5.56
cc_3044 ( N_noxref_12_c_4338_p N_noxref_21_c_6953_n ) capacitor c=0.00297041f \
 //x=34.745 //y=4.885 //x2=34.58 //y2=5.56
cc_3045 ( N_noxref_12_M58_noxref_g N_noxref_21_c_6957_n ) capacitor \
 c=0.0170175f //x=35.24 //y=6.205 //x2=35.46 //y2=5.56
cc_3046 ( N_noxref_12_M57_noxref_g N_noxref_21_M57_noxref_s ) capacitor \
 c=0.00378422f //x=34.8 //y=6.205 //x2=34.445 //y2=5.205
cc_3047 ( N_noxref_12_c_4282_n N_noxref_28_M15_noxref_s ) capacitor \
 c=5.85337e-19 //x=31.045 //y=3.125 //x2=28.8 //y2=0.545
cc_3048 ( N_noxref_13_c_4520_n N_noxref_14_c_4745_n ) capacitor c=0.00602995f \
 //x=32.68 //y=1.185 //x2=34.97 //y2=1.305
cc_3049 ( N_noxref_13_c_4489_n N_noxref_14_c_4743_n ) capacitor c=0.00665212f \
 //x=32.68 //y=1.935 //x2=34.97 //y2=1.75
cc_3050 ( N_noxref_13_c_4520_n N_noxref_14_c_4743_n ) capacitor c=5.1658e-19 \
 //x=32.68 //y=1.185 //x2=34.97 //y2=1.75
cc_3051 ( N_noxref_13_c_4595_n N_noxref_14_c_4743_n ) capacitor c=0.00120307f \
 //x=35.675 //y=1.74 //x2=34.97 //y2=1.75
cc_3052 ( N_noxref_13_c_4561_n N_noxref_14_c_4758_n ) capacitor c=0.00224615f \
 //x=35.64 //y=3.67 //x2=35.855 //y2=1.835
cc_3053 ( N_noxref_13_c_4564_n N_noxref_14_c_4758_n ) capacitor c=0.0304502f \
 //x=35.64 //y=2.26 //x2=35.855 //y2=1.835
cc_3054 ( N_noxref_13_c_4571_n N_noxref_14_c_4758_n ) capacitor c=0.00682403f \
 //x=35.475 //y=3.51 //x2=35.855 //y2=1.835
cc_3055 ( N_noxref_13_c_4578_n N_noxref_14_c_4758_n ) capacitor c=7.72845e-19 \
 //x=35.635 //y=3.51 //x2=35.855 //y2=1.835
cc_3056 ( N_noxref_13_c_4579_n N_noxref_14_c_4758_n ) capacitor c=0.00491852f \
 //x=35.64 //y=2.26 //x2=35.855 //y2=1.835
cc_3057 ( N_noxref_13_c_4600_n N_noxref_14_c_4758_n ) capacitor c=0.0014397f \
 //x=35.64 //y=2.26 //x2=35.855 //y2=1.835
cc_3058 ( N_noxref_13_c_4603_n N_noxref_14_c_4758_n ) capacitor c=0.00817459f \
 //x=35.64 //y=2.095 //x2=35.855 //y2=1.835
cc_3059 ( N_noxref_13_c_4590_n N_noxref_14_c_4788_n ) capacitor c=0.00112851f \
 //x=35.675 //y=1.085 //x2=35.94 //y2=1.3
cc_3060 ( N_noxref_13_c_4592_n N_noxref_14_c_4788_n ) capacitor c=0.0021447f \
 //x=35.675 //y=1.435 //x2=35.94 //y2=1.3
cc_3061 ( N_noxref_13_c_4622_p N_noxref_14_c_4788_n ) capacitor c=5.32053e-19 \
 //x=36.05 //y=0.93 //x2=35.94 //y2=1.3
cc_3062 ( N_noxref_13_c_4597_n N_noxref_14_c_4788_n ) capacitor c=5.60411e-19 \
 //x=36.05 //y=1.585 //x2=35.94 //y2=1.3
cc_3063 ( N_noxref_13_c_4598_n N_noxref_14_c_4788_n ) capacitor c=8.03404e-19 \
 //x=36.205 //y=1.085 //x2=35.94 //y2=1.3
cc_3064 ( N_noxref_13_c_4599_n N_noxref_14_c_4788_n ) capacitor c=0.00322382f \
 //x=36.205 //y=1.435 //x2=35.94 //y2=1.3
cc_3065 ( N_noxref_13_c_4489_n N_noxref_14_c_4764_n ) capacitor c=6.25488e-19 \
 //x=32.68 //y=1.935 //x2=35.94 //y2=1.75
cc_3066 ( N_noxref_13_c_4592_n N_noxref_14_c_4764_n ) capacitor c=7.7986e-19 \
 //x=35.675 //y=1.435 //x2=35.94 //y2=1.75
cc_3067 ( N_noxref_13_c_4595_n N_noxref_14_c_4764_n ) capacitor c=0.00364979f \
 //x=35.675 //y=1.74 //x2=35.94 //y2=1.75
cc_3068 ( N_noxref_13_c_4597_n N_noxref_14_c_4764_n ) capacitor c=0.00954408f \
 //x=36.05 //y=1.585 //x2=35.94 //y2=1.75
cc_3069 ( N_noxref_13_c_4599_n N_noxref_14_c_4764_n ) capacitor c=0.00115112f \
 //x=36.205 //y=1.435 //x2=35.94 //y2=1.75
cc_3070 ( N_noxref_13_M60_noxref_g N_noxref_14_c_4799_n ) capacitor \
 c=0.0110031f //x=36.12 //y=6.205 //x2=36.295 //y2=5.39
cc_3071 ( N_noxref_13_c_4597_n N_noxref_14_c_4800_n ) capacitor c=0.00500113f \
 //x=36.05 //y=1.585 //x2=36.295 //y2=1.835
cc_3072 ( N_noxref_13_c_4500_n N_noxref_14_c_4765_n ) capacitor c=0.00198687f \
 //x=32.965 //y=2.02 //x2=36.38 //y2=3.355
cc_3073 ( N_noxref_13_c_4555_n N_noxref_14_c_4765_n ) capacitor c=0.0410904f \
 //x=35.64 //y=3.35 //x2=36.38 //y2=3.355
cc_3074 ( N_noxref_13_c_4561_n N_noxref_14_c_4765_n ) capacitor c=2.75004e-19 \
 //x=35.64 //y=3.67 //x2=36.38 //y2=3.355
cc_3075 ( N_noxref_13_c_4564_n N_noxref_14_c_4765_n ) capacitor c=0.0160491f \
 //x=35.64 //y=2.26 //x2=36.38 //y2=3.355
cc_3076 ( N_noxref_13_c_4579_n N_noxref_14_c_4765_n ) capacitor c=0.00331564f \
 //x=35.64 //y=2.26 //x2=36.38 //y2=3.355
cc_3077 ( N_noxref_13_c_4600_n N_noxref_14_c_4765_n ) capacitor c=0.0028062f \
 //x=35.64 //y=2.26 //x2=36.38 //y2=3.355
cc_3078 ( N_noxref_13_c_4603_n N_noxref_14_c_4765_n ) capacitor c=0.00312016f \
 //x=35.64 //y=2.095 //x2=36.38 //y2=3.355
cc_3079 ( N_noxref_13_c_4561_n N_noxref_14_c_4808_n ) capacitor c=0.0200677f \
 //x=35.64 //y=3.67 //x2=36.38 //y2=3.675
cc_3080 ( N_noxref_13_c_4563_n N_noxref_14_c_4808_n ) capacitor c=6.26985e-19 \
 //x=35.635 //y=3.51 //x2=36.38 //y2=3.675
cc_3081 ( N_noxref_13_c_4570_n N_noxref_14_c_4808_n ) capacitor c=2.78459e-19 \
 //x=35.675 //y=4.74 //x2=36.38 //y2=3.675
cc_3082 ( N_noxref_13_c_4578_n N_noxref_14_c_4808_n ) capacitor c=0.00317828f \
 //x=35.635 //y=3.51 //x2=36.38 //y2=3.675
cc_3083 ( N_noxref_13_c_4496_n N_noxref_14_c_4766_n ) capacitor c=7.65451e-19 \
 //x=32.685 //y=5.42 //x2=36.38 //y2=5.305
cc_3084 ( N_noxref_13_c_4515_n N_noxref_14_c_4766_n ) capacitor c=0.00219125f \
 //x=33.05 //y=5.055 //x2=36.38 //y2=5.305
cc_3085 ( N_noxref_13_c_4567_n N_noxref_14_c_4766_n ) capacitor c=0.0175188f \
 //x=35.675 //y=4.885 //x2=36.38 //y2=5.305
cc_3086 ( N_noxref_13_c_4570_n N_noxref_14_c_4766_n ) capacitor c=0.0481621f \
 //x=35.675 //y=4.74 //x2=36.38 //y2=5.305
cc_3087 ( N_noxref_13_c_4583_n N_noxref_14_c_4766_n ) capacitor c=7.83796e-19 \
 //x=35.675 //y=4.885 //x2=36.38 //y2=5.305
cc_3088 ( N_noxref_13_c_4649_p N_noxref_14_c_4766_n ) capacitor c=0.00854359f \
 //x=36.045 //y=4.975 //x2=36.38 //y2=5.305
cc_3089 ( N_noxref_13_c_4604_n N_noxref_14_c_4766_n ) capacitor c=0.00141757f \
 //x=35.675 //y=4.885 //x2=36.38 //y2=5.305
cc_3090 ( N_noxref_13_c_4555_n N_noxref_14_c_4819_n ) capacitor c=0.00254374f \
 //x=35.64 //y=3.35 //x2=37.86 //y2=3.355
cc_3091 ( N_noxref_13_c_4570_n N_noxref_14_c_4820_n ) capacitor c=0.00225563f \
 //x=35.675 //y=4.74 //x2=37.86 //y2=4.76
cc_3092 ( N_noxref_13_c_4496_n N_noxref_14_c_4821_n ) capacitor c=3.52602e-19 \
 //x=32.685 //y=5.42 //x2=35.895 //y2=5.39
cc_3093 ( N_noxref_13_c_4567_n N_noxref_14_c_4821_n ) capacitor c=0.00201061f \
 //x=35.675 //y=4.885 //x2=35.895 //y2=5.39
cc_3094 ( N_noxref_13_M59_noxref_g N_noxref_14_c_4821_n ) capacitor \
 c=0.00184899f //x=35.68 //y=6.205 //x2=35.895 //y2=5.39
cc_3095 ( N_noxref_13_M60_noxref_g N_noxref_14_c_4821_n ) capacitor \
 c=0.00272721f //x=36.12 //y=6.205 //x2=35.895 //y2=5.39
cc_3096 ( N_noxref_13_c_4649_p N_noxref_14_c_4821_n ) capacitor c=0.00213157f \
 //x=36.045 //y=4.975 //x2=35.895 //y2=5.39
cc_3097 ( N_noxref_13_c_4561_n N_noxref_14_c_4826_n ) capacitor c=6.17496e-19 \
 //x=35.64 //y=3.67 //x2=36.38 //y2=3.51
cc_3098 ( N_noxref_13_c_4563_n N_noxref_14_c_4826_n ) capacitor c=0.0102019f \
 //x=35.635 //y=3.51 //x2=36.38 //y2=3.51
cc_3099 ( N_noxref_13_c_4561_n N_noxref_14_c_4828_n ) capacitor c=0.0031805f \
 //x=35.64 //y=3.67 //x2=36.54 //y2=3.515
cc_3100 ( N_noxref_13_c_4578_n N_noxref_14_c_4828_n ) capacitor c=0.0226015f \
 //x=35.635 //y=3.51 //x2=36.54 //y2=3.515
cc_3101 ( N_noxref_13_M59_noxref_g N_noxref_14_c_4830_n ) capacitor \
 c=0.0120591f //x=35.68 //y=6.205 //x2=35.9 //y2=5.56
cc_3102 ( N_noxref_13_M60_noxref_g N_noxref_14_c_4830_n ) capacitor \
 c=0.0140704f //x=36.12 //y=6.205 //x2=35.9 //y2=5.56
cc_3103 ( N_noxref_13_c_4649_p N_noxref_14_c_4830_n ) capacitor c=0.00293135f \
 //x=36.045 //y=4.975 //x2=35.9 //y2=5.56
cc_3104 ( N_noxref_13_c_4590_n N_noxref_14_M19_noxref_d ) capacitor \
 c=0.00218694f //x=35.675 //y=1.085 //x2=35.75 //y2=1.085
cc_3105 ( N_noxref_13_c_4592_n N_noxref_14_M19_noxref_d ) capacitor \
 c=0.00237422f //x=35.675 //y=1.435 //x2=35.75 //y2=1.085
cc_3106 ( N_noxref_13_c_4622_p N_noxref_14_M19_noxref_d ) capacitor \
 c=0.00213893f //x=36.05 //y=0.93 //x2=35.75 //y2=1.085
cc_3107 ( N_noxref_13_c_4597_n N_noxref_14_M19_noxref_d ) capacitor \
 c=0.00357974f //x=36.05 //y=1.585 //x2=35.75 //y2=1.085
cc_3108 ( N_noxref_13_c_4598_n N_noxref_14_M19_noxref_d ) capacitor \
 c=0.0012513f //x=36.205 //y=1.085 //x2=35.75 //y2=1.085
cc_3109 ( N_noxref_13_c_4599_n N_noxref_14_M19_noxref_d ) capacitor \
 c=0.00237422f //x=36.205 //y=1.435 //x2=35.75 //y2=1.085
cc_3110 ( N_noxref_13_c_4496_n N_VDD_c_5104_n ) capacitor c=0.00259721f \
 //x=32.685 //y=5.42 //x2=34.935 //y2=7.585
cc_3111 ( N_noxref_13_c_4503_n N_VDD_c_5104_n ) capacitor c=0.00266633f \
 //x=32.965 //y=5.14 //x2=34.935 //y2=7.585
cc_3112 ( N_noxref_13_c_4532_n N_VDD_c_5104_n ) capacitor c=0.00241566f \
 //x=32.685 //y=5.56 //x2=34.935 //y2=7.585
cc_3113 ( N_noxref_13_c_4496_n N_VDD_c_5435_n ) capacitor c=0.00100699f \
 //x=32.685 //y=5.42 //x2=33.04 //y2=7.585
cc_3114 ( N_noxref_13_c_4503_n N_VDD_c_5435_n ) capacitor c=0.00197507f \
 //x=32.965 //y=5.14 //x2=33.04 //y2=7.585
cc_3115 ( N_noxref_13_c_4532_n N_VDD_c_5435_n ) capacitor c=0.0138017f \
 //x=32.685 //y=5.56 //x2=33.04 //y2=7.585
cc_3116 ( N_noxref_13_M59_noxref_g N_VDD_c_5486_n ) capacitor c=0.00724816f \
 //x=35.68 //y=6.205 //x2=36.95 //y2=7.585
cc_3117 ( N_noxref_13_M60_noxref_g N_VDD_c_5486_n ) capacitor c=0.00782837f \
 //x=36.12 //y=6.205 //x2=36.95 //y2=7.585
cc_3118 ( N_noxref_13_c_4504_n N_VDD_c_5023_n ) capacitor c=0.00470334f \
 //x=32.77 //y=5.14 //x2=31.57 //y2=7.585
cc_3119 ( N_noxref_13_c_4532_n N_VDD_c_5023_n ) capacitor c=0.00820745f \
 //x=32.685 //y=5.56 //x2=31.57 //y2=7.585
cc_3120 ( N_noxref_13_c_4496_n N_VDD_c_5450_n ) capacitor c=0.00233135f \
 //x=32.685 //y=5.42 //x2=33.79 //y2=7.585
cc_3121 ( N_noxref_13_c_4515_n N_VDD_c_5450_n ) capacitor c=0.0222088f \
 //x=33.05 //y=5.055 //x2=33.79 //y2=7.585
cc_3122 ( N_noxref_13_c_4571_n N_VDD_c_5450_n ) capacitor c=0.00501359f \
 //x=35.475 //y=3.51 //x2=33.79 //y2=7.585
cc_3123 ( N_noxref_13_c_4532_n N_VDD_c_5450_n ) capacitor c=0.00821732f \
 //x=32.685 //y=5.56 //x2=33.79 //y2=7.585
cc_3124 ( N_noxref_13_c_4583_n N_VDD_c_5499_n ) capacitor c=0.00231379f \
 //x=35.675 //y=4.885 //x2=37.12 //y2=7.585
cc_3125 ( N_noxref_13_c_4649_p N_VDD_c_5499_n ) capacitor c=0.016784f \
 //x=36.045 //y=4.975 //x2=37.12 //y2=7.585
cc_3126 ( N_noxref_13_c_4604_n N_VDD_c_5499_n ) capacitor c=2.75092e-19 \
 //x=35.675 //y=4.885 //x2=37.12 //y2=7.585
cc_3127 ( N_noxref_13_c_4496_n N_VDD_M51_noxref_s ) capacitor c=2.62188e-19 \
 //x=32.685 //y=5.42 //x2=28.895 //y2=5.2
cc_3128 ( N_noxref_13_c_4496_n N_VDD_M55_noxref_s ) capacitor c=0.0465774f \
 //x=32.685 //y=5.42 //x2=32.11 //y2=5.2
cc_3129 ( N_noxref_13_c_4532_n N_VDD_M55_noxref_s ) capacitor c=0.0897769f \
 //x=32.685 //y=5.56 //x2=32.11 //y2=5.2
cc_3130 ( N_noxref_13_c_4496_n N_VDD_M56_noxref_d ) capacitor c=0.0474638f \
 //x=32.685 //y=5.42 //x2=32.98 //y2=5.2
cc_3131 ( N_noxref_13_c_4503_n N_VDD_M56_noxref_d ) capacitor c=0.0212594f \
 //x=32.965 //y=5.14 //x2=32.98 //y2=5.2
cc_3132 ( N_noxref_13_c_4512_n N_VDD_M56_noxref_d ) capacitor c=0.00231426f \
 //x=33.05 //y=3.67 //x2=32.98 //y2=5.2
cc_3133 ( N_noxref_13_c_4528_n N_VDD_M56_noxref_d ) capacitor c=3.07461e-19 \
 //x=33.045 //y=3.51 //x2=32.98 //y2=5.2
cc_3134 ( N_noxref_13_c_4571_n N_VDD_M56_noxref_d ) capacitor c=4.25529e-19 \
 //x=35.475 //y=3.51 //x2=32.98 //y2=5.2
cc_3135 ( N_noxref_13_c_4530_n N_VDD_M56_noxref_d ) capacitor c=7.26829e-19 \
 //x=33.205 //y=3.51 //x2=32.98 //y2=5.2
cc_3136 ( N_noxref_13_c_4532_n N_VDD_M56_noxref_d ) capacitor c=0.0904512f \
 //x=32.685 //y=5.56 //x2=32.98 //y2=5.2
cc_3137 ( N_noxref_13_c_4500_n N_GND_c_6145_n ) capacitor c=0.00499608f \
 //x=32.965 //y=2.02 //x2=38.97 //y2=0.18
cc_3138 ( N_noxref_13_c_4512_n N_GND_c_6145_n ) capacitor c=5.21171e-19 \
 //x=33.05 //y=3.67 //x2=38.97 //y2=0.18
cc_3139 ( N_noxref_13_c_4520_n N_GND_c_6145_n ) capacitor c=0.00998676f \
 //x=32.68 //y=1.185 //x2=38.97 //y2=0.18
cc_3140 ( N_noxref_13_c_4528_n N_GND_c_6145_n ) capacitor c=2.38608e-19 \
 //x=33.045 //y=3.51 //x2=38.97 //y2=0.18
cc_3141 ( N_noxref_13_M17_noxref_d N_GND_c_6145_n ) capacitor c=0.00119455f \
 //x=32.495 //y=1.09 //x2=38.97 //y2=0.18
cc_3142 ( N_noxref_13_c_4520_n N_GND_c_6606_n ) capacitor c=0.00124813f \
 //x=32.68 //y=1.185 //x2=32.595 //y2=0.715
cc_3143 ( N_noxref_13_c_4500_n N_GND_c_6610_n ) capacitor c=0.0031667f \
 //x=32.965 //y=2.02 //x2=33.085 //y2=0.715
cc_3144 ( N_noxref_13_c_4520_n N_GND_c_6610_n ) capacitor c=0.00130539f \
 //x=32.68 //y=1.185 //x2=33.085 //y2=0.715
cc_3145 ( N_noxref_13_c_4528_n N_GND_c_6610_n ) capacitor c=2.81376e-19 \
 //x=33.045 //y=3.51 //x2=33.085 //y2=0.715
cc_3146 ( N_noxref_13_c_4564_n N_GND_c_6681_n ) capacitor c=3.09398e-19 \
 //x=35.64 //y=2.26 //x2=36.34 //y2=0.71
cc_3147 ( N_noxref_13_c_4579_n N_GND_c_6681_n ) capacitor c=8.64363e-19 \
 //x=35.64 //y=2.26 //x2=36.34 //y2=0.71
cc_3148 ( N_noxref_13_c_4590_n N_GND_c_6681_n ) capacitor c=0.0210887f \
 //x=35.675 //y=1.085 //x2=36.34 //y2=0.71
cc_3149 ( N_noxref_13_c_4598_n N_GND_c_6681_n ) capacitor c=0.00825432f \
 //x=36.205 //y=1.085 //x2=36.34 //y2=0.71
cc_3150 ( N_noxref_13_c_4600_n N_GND_c_6681_n ) capacitor c=2.1838e-19 \
 //x=35.64 //y=2.26 //x2=36.34 //y2=0.71
cc_3151 ( N_noxref_13_c_4489_n N_GND_c_6183_n ) capacitor c=0.00290844f \
 //x=32.68 //y=1.935 //x2=31.57 //y2=0.175
cc_3152 ( N_noxref_13_c_4500_n N_GND_c_6619_n ) capacitor c=0.023022f \
 //x=32.965 //y=2.02 //x2=33.79 //y2=0.175
cc_3153 ( N_noxref_13_c_4579_n N_GND_c_6688_n ) capacitor c=0.00231028f \
 //x=35.64 //y=2.26 //x2=37.12 //y2=0.175
cc_3154 ( N_noxref_13_c_4597_n N_GND_c_6688_n ) capacitor c=0.0028635f \
 //x=36.05 //y=1.585 //x2=37.12 //y2=0.175
cc_3155 ( N_noxref_13_c_4489_n N_GND_M17_noxref_s ) capacitor c=0.0287657f \
 //x=32.68 //y=1.935 //x2=32.065 //y2=0.55
cc_3156 ( N_noxref_13_c_4500_n N_GND_M17_noxref_s ) capacitor c=0.00386445f \
 //x=32.965 //y=2.02 //x2=32.065 //y2=0.55
cc_3157 ( N_noxref_13_c_4512_n N_GND_M17_noxref_s ) capacitor c=0.00141061f \
 //x=33.05 //y=3.67 //x2=32.065 //y2=0.55
cc_3158 ( N_noxref_13_c_4520_n N_GND_M17_noxref_s ) capacitor c=0.0139466f \
 //x=32.68 //y=1.185 //x2=32.065 //y2=0.55
cc_3159 ( N_noxref_13_c_4528_n N_GND_M17_noxref_s ) capacitor c=7.90336e-19 \
 //x=33.045 //y=3.51 //x2=32.065 //y2=0.55
cc_3160 ( N_noxref_13_M17_noxref_d N_GND_M17_noxref_s ) capacitor c=0.0377642f \
 //x=32.495 //y=1.09 //x2=32.065 //y2=0.55
cc_3161 ( N_noxref_13_c_4590_n N_GND_M18_noxref_s ) capacitor c=0.00720961f \
 //x=35.675 //y=1.085 //x2=34.35 //y2=0.545
cc_3162 ( N_noxref_13_c_4597_n N_GND_M18_noxref_s ) capacitor c=0.00271091f \
 //x=36.05 //y=1.585 //x2=34.35 //y2=0.545
cc_3163 ( N_noxref_13_c_4598_n N_GND_M18_noxref_s ) capacitor c=0.0151996f \
 //x=36.205 //y=1.085 //x2=34.35 //y2=0.545
cc_3164 ( N_noxref_13_c_4600_n N_GND_M18_noxref_s ) capacitor c=0.00119136f \
 //x=35.64 //y=2.26 //x2=34.35 //y2=0.545
cc_3165 ( N_noxref_13_c_4571_n N_noxref_21_c_6940_n ) capacitor c=0.00911888f \
 //x=35.475 //y=3.51 //x2=35.34 //y2=5.39
cc_3166 ( N_noxref_13_c_4567_n N_noxref_21_c_6960_n ) capacitor c=0.00213487f \
 //x=35.675 //y=4.885 //x2=36.21 //y2=7.09
cc_3167 ( N_noxref_13_c_4583_n N_noxref_21_c_6960_n ) capacitor c=0.00233585f \
 //x=35.675 //y=4.885 //x2=36.21 //y2=7.09
cc_3168 ( N_noxref_13_M59_noxref_g N_noxref_21_c_6960_n ) capacitor \
 c=0.00777443f //x=35.68 //y=6.205 //x2=36.21 //y2=7.09
cc_3169 ( N_noxref_13_M60_noxref_g N_noxref_21_c_6960_n ) capacitor \
 c=0.0093887f //x=36.12 //y=6.205 //x2=36.21 //y2=7.09
cc_3170 ( N_noxref_13_c_4496_n N_noxref_21_c_6947_n ) capacitor c=0.00174649f \
 //x=32.685 //y=5.42 //x2=34.58 //y2=5.39
cc_3171 ( N_noxref_13_c_4571_n N_noxref_21_c_6947_n ) capacitor c=0.00240125f \
 //x=35.475 //y=3.51 //x2=34.58 //y2=5.39
cc_3172 ( N_noxref_13_c_4561_n N_noxref_21_c_6951_n ) capacitor c=0.00293398f \
 //x=35.64 //y=3.67 //x2=35.46 //y2=5.39
cc_3173 ( N_noxref_13_c_4567_n N_noxref_21_c_6951_n ) capacitor c=0.00260151f \
 //x=35.675 //y=4.885 //x2=35.46 //y2=5.39
cc_3174 ( N_noxref_13_c_4571_n N_noxref_21_c_6951_n ) capacitor c=0.00101351f \
 //x=35.475 //y=3.51 //x2=35.46 //y2=5.39
cc_3175 ( N_noxref_13_c_4578_n N_noxref_21_c_6951_n ) capacitor c=8.44205e-19 \
 //x=35.635 //y=3.51 //x2=35.46 //y2=5.39
cc_3176 ( N_noxref_13_M59_noxref_g N_noxref_21_c_6951_n ) capacitor \
 c=0.00176767f //x=35.68 //y=6.205 //x2=35.46 //y2=5.39
cc_3177 ( N_noxref_13_c_4604_n N_noxref_21_c_6951_n ) capacitor c=6.07239e-19 \
 //x=35.675 //y=4.885 //x2=35.46 //y2=5.39
cc_3178 ( N_noxref_13_M59_noxref_g N_noxref_21_c_6952_n ) capacitor \
 c=0.00186228f //x=35.68 //y=6.205 //x2=35.46 //y2=6.92
cc_3179 ( N_noxref_13_M60_noxref_g N_noxref_21_c_6973_n ) capacitor \
 c=0.00410728f //x=36.12 //y=6.205 //x2=36.34 //y2=6.92
cc_3180 ( N_noxref_13_M59_noxref_g N_noxref_21_c_6957_n ) capacitor \
 c=0.0170175f //x=35.68 //y=6.205 //x2=35.46 //y2=5.56
cc_3181 ( N_noxref_13_M60_noxref_g N_noxref_21_M60_noxref_d ) capacitor \
 c=0.0365939f //x=36.12 //y=6.205 //x2=36.195 //y2=5.205
cc_3182 ( N_noxref_14_c_4799_n N_VDD_c_5539_n ) capacitor c=2.90144e-19 \
 //x=36.295 //y=5.39 //x2=38.97 //y2=7.58
cc_3183 ( N_noxref_14_c_4808_n N_VDD_c_5539_n ) capacitor c=4.28439e-19 \
 //x=36.38 //y=3.675 //x2=38.97 //y2=7.58
cc_3184 ( N_noxref_14_c_4841_p N_VDD_c_5539_n ) capacitor c=2.57268e-19 \
 //x=37.86 //y=3.675 //x2=38.97 //y2=7.58
cc_3185 ( N_noxref_14_c_4820_n N_VDD_c_5539_n ) capacitor c=5.73169e-19 \
 //x=37.86 //y=4.76 //x2=38.97 //y2=7.58
cc_3186 ( N_noxref_14_c_4843_p N_VDD_c_5539_n ) capacitor c=3.40755e-19 \
 //x=37.86 //y=4.88 //x2=38.97 //y2=7.58
cc_3187 ( N_noxref_14_c_4799_n N_VDD_c_5486_n ) capacitor c=0.00140363f \
 //x=36.295 //y=5.39 //x2=36.95 //y2=7.585
cc_3188 ( N_noxref_14_c_4830_n N_VDD_c_5486_n ) capacitor c=0.00513429f \
 //x=35.9 //y=5.56 //x2=36.95 //y2=7.585
cc_3189 ( N_noxref_14_c_4820_n N_VDD_c_5546_n ) capacitor c=5.48929e-19 \
 //x=37.86 //y=4.76 //x2=38.59 //y2=7.585
cc_3190 ( N_noxref_14_M61_noxref_g N_VDD_c_5546_n ) capacitor c=0.00753931f \
 //x=38.015 //y=6.2 //x2=38.59 //y2=7.585
cc_3191 ( N_noxref_14_M62_noxref_g N_VDD_c_5546_n ) capacitor c=0.00755544f \
 //x=38.455 //y=6.2 //x2=38.59 //y2=7.585
cc_3192 ( N_noxref_14_c_4843_p N_VDD_c_5549_n ) capacitor c=0.00241457f \
 //x=37.86 //y=4.88 //x2=38.97 //y2=7.58
cc_3193 ( N_noxref_14_c_4850_p N_VDD_c_5549_n ) capacitor c=0.0196838f \
 //x=38.38 //y=4.97 //x2=38.97 //y2=7.58
cc_3194 ( N_noxref_14_c_4766_n N_VDD_c_5450_n ) capacitor c=0.00126419f \
 //x=36.38 //y=5.305 //x2=33.79 //y2=7.585
cc_3195 ( N_noxref_14_c_4766_n N_VDD_c_5499_n ) capacitor c=0.0282523f \
 //x=36.38 //y=5.305 //x2=37.12 //y2=7.585
cc_3196 ( N_noxref_14_c_4820_n N_VDD_c_5499_n ) capacitor c=0.0155837f \
 //x=37.86 //y=4.76 //x2=37.12 //y2=7.585
cc_3197 ( N_noxref_14_c_4821_n N_VDD_c_5499_n ) capacitor c=0.00263628f \
 //x=35.895 //y=5.39 //x2=37.12 //y2=7.585
cc_3198 ( N_noxref_14_c_4855_p N_VDD_c_5499_n ) capacitor c=0.00501359f \
 //x=37.7 //y=3.515 //x2=37.12 //y2=7.585
cc_3199 ( N_noxref_14_c_4830_n N_VDD_c_5499_n ) capacitor c=0.00923008f \
 //x=35.9 //y=5.56 //x2=37.12 //y2=7.585
cc_3200 ( N_noxref_14_c_4843_p N_VDD_c_5499_n ) capacitor c=0.0079528f \
 //x=37.86 //y=4.88 //x2=37.12 //y2=7.585
cc_3201 ( N_noxref_14_M61_noxref_g N_VDD_c_5499_n ) capacitor c=0.00770587f \
 //x=38.015 //y=6.2 //x2=37.12 //y2=7.585
cc_3202 ( N_noxref_14_c_4859_p N_VDD_c_5499_n ) capacitor c=0.00799922f \
 //x=38.09 //y=4.97 //x2=37.12 //y2=7.585
cc_3203 ( N_noxref_14_c_4821_n N_VDD_M56_noxref_d ) capacitor c=2.8473e-19 \
 //x=35.895 //y=5.39 //x2=32.98 //y2=5.2
cc_3204 ( N_noxref_14_c_4830_n N_VDD_M57_noxref_d ) capacitor c=0.00560906f \
 //x=35.9 //y=5.56 //x2=34.875 //y2=5.205
cc_3205 ( N_noxref_14_c_4799_n N_VDD_M61_noxref_s ) capacitor c=0.00336564f \
 //x=36.295 //y=5.39 //x2=37.66 //y2=5.2
cc_3206 ( N_noxref_14_c_4841_p N_VDD_M61_noxref_s ) capacitor c=0.00120003f \
 //x=37.86 //y=3.675 //x2=37.66 //y2=5.2
cc_3207 ( N_noxref_14_c_4820_n N_VDD_M61_noxref_s ) capacitor c=0.0211603f \
 //x=37.86 //y=4.76 //x2=37.66 //y2=5.2
cc_3208 ( N_noxref_14_c_4821_n N_VDD_M61_noxref_s ) capacitor c=0.00573134f \
 //x=35.895 //y=5.39 //x2=37.66 //y2=5.2
cc_3209 ( N_noxref_14_c_4866_p N_VDD_M61_noxref_s ) capacitor c=4.26343e-19 \
 //x=37.86 //y=3.515 //x2=37.66 //y2=5.2
cc_3210 ( N_noxref_14_c_4855_p N_VDD_M61_noxref_s ) capacitor c=2.12313e-19 \
 //x=37.7 //y=3.515 //x2=37.66 //y2=5.2
cc_3211 ( N_noxref_14_c_4843_p N_VDD_M61_noxref_s ) capacitor c=0.00986169f \
 //x=37.86 //y=4.88 //x2=37.66 //y2=5.2
cc_3212 ( N_noxref_14_M61_noxref_g N_VDD_M61_noxref_s ) capacitor c=0.0573441f \
 //x=38.015 //y=6.2 //x2=37.66 //y2=5.2
cc_3213 ( N_noxref_14_c_4859_p N_VDD_M61_noxref_s ) capacitor c=0.00524544f \
 //x=38.09 //y=4.97 //x2=37.66 //y2=5.2
cc_3214 ( N_noxref_14_M62_noxref_g N_VDD_M62_noxref_d ) capacitor c=0.0572684f \
 //x=38.455 //y=6.2 //x2=38.53 //y2=5.2
cc_3215 ( N_noxref_14_c_4745_n N_GND_c_6145_n ) capacitor c=0.00996669f \
 //x=34.97 //y=1.305 //x2=38.97 //y2=0.18
cc_3216 ( N_noxref_14_c_4758_n N_GND_c_6145_n ) capacitor c=0.00677787f \
 //x=35.855 //y=1.835 //x2=38.97 //y2=0.18
cc_3217 ( N_noxref_14_c_4788_n N_GND_c_6145_n ) capacitor c=0.0106318f \
 //x=35.94 //y=1.3 //x2=38.97 //y2=0.18
cc_3218 ( N_noxref_14_c_4800_n N_GND_c_6145_n ) capacitor c=0.00667116f \
 //x=36.295 //y=1.835 //x2=38.97 //y2=0.18
cc_3219 ( N_noxref_14_c_4808_n N_GND_c_6145_n ) capacitor c=4.97045e-19 \
 //x=36.38 //y=3.675 //x2=38.97 //y2=0.18
cc_3220 ( N_noxref_14_c_4841_p N_GND_c_6145_n ) capacitor c=4.49547e-19 \
 //x=37.86 //y=3.675 //x2=38.97 //y2=0.18
cc_3221 ( N_noxref_14_c_4826_n N_GND_c_6145_n ) capacitor c=3.83892e-19 \
 //x=36.38 //y=3.51 //x2=38.97 //y2=0.18
cc_3222 ( N_noxref_14_c_4879_p N_GND_c_6145_n ) capacitor c=0.00249122f \
 //x=37.86 //y=2.265 //x2=38.97 //y2=0.18
cc_3223 ( N_noxref_14_c_4880_p N_GND_c_6145_n ) capacitor c=7.5371e-19 \
 //x=37.86 //y=2.265 //x2=38.97 //y2=0.18
cc_3224 ( N_noxref_14_M18_noxref_d N_GND_c_6145_n ) capacitor c=3.01769e-19 \
 //x=34.78 //y=1.085 //x2=38.97 //y2=0.18
cc_3225 ( N_noxref_14_M19_noxref_d N_GND_c_6145_n ) capacitor c=3.01769e-19 \
 //x=35.75 //y=1.085 //x2=38.97 //y2=0.18
cc_3226 ( N_noxref_14_c_4745_n N_GND_c_6644_n ) capacitor c=0.00372564f \
 //x=34.97 //y=1.305 //x2=35.37 //y2=0.71
cc_3227 ( N_noxref_14_c_4758_n N_GND_c_6644_n ) capacitor c=0.00128856f \
 //x=35.855 //y=1.835 //x2=35.37 //y2=0.71
cc_3228 ( N_noxref_14_M18_noxref_d N_GND_c_6644_n ) capacitor c=0.0122548f \
 //x=34.78 //y=1.085 //x2=35.37 //y2=0.71
cc_3229 ( N_noxref_14_c_4758_n N_GND_c_6681_n ) capacitor c=0.00128298f \
 //x=35.855 //y=1.835 //x2=36.34 //y2=0.71
cc_3230 ( N_noxref_14_c_4788_n N_GND_c_6681_n ) capacitor c=0.00469733f \
 //x=35.94 //y=1.3 //x2=36.34 //y2=0.71
cc_3231 ( N_noxref_14_c_4800_n N_GND_c_6681_n ) capacitor c=0.00353189f \
 //x=36.295 //y=1.835 //x2=36.34 //y2=0.71
cc_3232 ( N_noxref_14_M19_noxref_d N_GND_c_6681_n ) capacitor c=0.0122548f \
 //x=35.75 //y=1.085 //x2=36.34 //y2=0.71
cc_3233 ( N_noxref_14_c_4879_p N_GND_c_6718_n ) capacitor c=0.00114179f \
 //x=37.86 //y=2.265 //x2=38.145 //y2=0.715
cc_3234 ( N_noxref_14_c_4880_p N_GND_c_6718_n ) capacitor c=3.95714e-19 \
 //x=37.86 //y=2.265 //x2=38.145 //y2=0.715
cc_3235 ( N_noxref_14_c_4892_p N_GND_c_6718_n ) capacitor c=0.0125549f \
 //x=37.97 //y=1.09 //x2=38.145 //y2=0.715
cc_3236 ( N_noxref_14_c_4893_p N_GND_c_6718_n ) capacitor c=2.1838e-19 \
 //x=37.86 //y=2.265 //x2=38.145 //y2=0.715
cc_3237 ( N_noxref_14_c_4894_p N_GND_c_6722_n ) capacitor c=0.0134289f \
 //x=38.5 //y=1.09 //x2=38.635 //y2=0.715
cc_3238 ( N_noxref_14_c_4880_p N_GND_c_6723_n ) capacitor c=0.0022444f \
 //x=37.86 //y=2.265 //x2=38.97 //y2=0.18
cc_3239 ( N_noxref_14_c_4893_p N_GND_c_6723_n ) capacitor c=2.63786e-19 \
 //x=37.86 //y=2.265 //x2=38.97 //y2=0.18
cc_3240 ( N_noxref_14_c_4765_n N_GND_c_6619_n ) capacitor c=9.34543e-19 \
 //x=36.38 //y=3.355 //x2=33.79 //y2=0.175
cc_3241 ( N_noxref_14_c_4764_n N_GND_c_6688_n ) capacitor c=0.00304019f \
 //x=35.94 //y=1.75 //x2=37.12 //y2=0.175
cc_3242 ( N_noxref_14_c_4800_n N_GND_c_6688_n ) capacitor c=0.0277976f \
 //x=36.295 //y=1.835 //x2=37.12 //y2=0.175
cc_3243 ( N_noxref_14_c_4819_n N_GND_c_6688_n ) capacitor c=0.0103129f \
 //x=37.86 //y=3.355 //x2=37.12 //y2=0.175
cc_3244 ( N_noxref_14_c_4879_p N_GND_c_6688_n ) capacitor c=0.00682461f \
 //x=37.86 //y=2.265 //x2=37.12 //y2=0.175
cc_3245 ( N_noxref_14_c_4855_p N_GND_c_6688_n ) capacitor c=0.00560367f \
 //x=37.7 //y=3.515 //x2=37.12 //y2=0.175
cc_3246 ( N_noxref_14_c_4880_p N_GND_c_6688_n ) capacitor c=0.00733236f \
 //x=37.86 //y=2.265 //x2=37.12 //y2=0.175
cc_3247 ( N_noxref_14_c_4904_p N_GND_c_6688_n ) capacitor c=0.00425509f \
 //x=37.97 //y=2.1 //x2=37.12 //y2=0.175
cc_3248 ( N_noxref_14_c_4893_p N_GND_c_6688_n ) capacitor c=0.00786308f \
 //x=37.86 //y=2.265 //x2=37.12 //y2=0.175
cc_3249 ( N_noxref_14_c_4745_n N_GND_M18_noxref_s ) capacitor c=0.00934626f \
 //x=34.97 //y=1.305 //x2=34.35 //y2=0.545
cc_3250 ( N_noxref_14_c_4743_n N_GND_M18_noxref_s ) capacitor c=0.0227687f \
 //x=34.97 //y=1.75 //x2=34.35 //y2=0.545
cc_3251 ( N_noxref_14_c_4758_n N_GND_M18_noxref_s ) capacitor c=0.00757265f \
 //x=35.855 //y=1.835 //x2=34.35 //y2=0.545
cc_3252 ( N_noxref_14_c_4788_n N_GND_M18_noxref_s ) capacitor c=0.00943435f \
 //x=35.94 //y=1.3 //x2=34.35 //y2=0.545
cc_3253 ( N_noxref_14_c_4764_n N_GND_M18_noxref_s ) capacitor c=0.0106843f \
 //x=35.94 //y=1.75 //x2=34.35 //y2=0.545
cc_3254 ( N_noxref_14_c_4800_n N_GND_M18_noxref_s ) capacitor c=0.0070507f \
 //x=36.295 //y=1.835 //x2=34.35 //y2=0.545
cc_3255 ( N_noxref_14_c_4808_n N_GND_M18_noxref_s ) capacitor c=4.20303e-19 \
 //x=36.38 //y=3.675 //x2=34.35 //y2=0.545
cc_3256 ( N_noxref_14_c_4826_n N_GND_M18_noxref_s ) capacitor c=0.00106787f \
 //x=36.38 //y=3.51 //x2=34.35 //y2=0.545
cc_3257 ( N_noxref_14_M18_noxref_d N_GND_M18_noxref_s ) capacitor c=0.0297221f \
 //x=34.78 //y=1.085 //x2=34.35 //y2=0.545
cc_3258 ( N_noxref_14_M19_noxref_d N_GND_M18_noxref_s ) capacitor c=0.029747f \
 //x=35.75 //y=1.085 //x2=34.35 //y2=0.545
cc_3259 ( N_noxref_14_c_4841_p N_GND_M20_noxref_s ) capacitor c=8.07162e-19 \
 //x=37.86 //y=3.675 //x2=37.615 //y2=0.55
cc_3260 ( N_noxref_14_c_4879_p N_GND_M20_noxref_s ) capacitor c=0.00297876f \
 //x=37.86 //y=2.265 //x2=37.615 //y2=0.55
cc_3261 ( N_noxref_14_c_4880_p N_GND_M20_noxref_s ) capacitor c=0.00651326f \
 //x=37.86 //y=2.265 //x2=37.615 //y2=0.55
cc_3262 ( N_noxref_14_c_4892_p N_GND_M20_noxref_s ) capacitor c=0.030052f \
 //x=37.97 //y=1.09 //x2=37.615 //y2=0.55
cc_3263 ( N_noxref_14_c_4920_p N_GND_M20_noxref_s ) capacitor c=0.002132f \
 //x=37.97 //y=1.745 //x2=37.615 //y2=0.55
cc_3264 ( N_noxref_14_c_4904_p N_GND_M20_noxref_s ) capacitor c=0.00304786f \
 //x=37.97 //y=2.1 //x2=37.615 //y2=0.55
cc_3265 ( N_noxref_14_c_4922_p N_GND_M20_noxref_s ) capacitor c=0.00517463f \
 //x=38.345 //y=0.935 //x2=37.615 //y2=0.55
cc_3266 ( N_noxref_14_c_4894_p N_GND_M20_noxref_s ) capacitor c=0.0153553f \
 //x=38.5 //y=1.09 //x2=37.615 //y2=0.55
cc_3267 ( N_noxref_14_c_4924_p N_GND_M20_noxref_s ) capacitor c=0.00629878f \
 //x=38.5 //y=1.435 //x2=37.615 //y2=0.55
cc_3268 ( N_noxref_14_c_4893_p N_GND_M20_noxref_s ) capacitor c=0.00660555f \
 //x=37.86 //y=2.265 //x2=37.615 //y2=0.55
cc_3269 ( N_noxref_14_c_4745_n N_noxref_21_c_6940_n ) capacitor c=2.9936e-19 \
 //x=34.97 //y=1.305 //x2=35.34 //y2=5.39
cc_3270 ( N_noxref_14_c_4744_n N_noxref_21_c_6940_n ) capacitor c=0.00168745f \
 //x=35.055 //y=1.835 //x2=35.34 //y2=5.39
cc_3271 ( N_noxref_14_c_4799_n N_noxref_21_c_6960_n ) capacitor c=0.00301289f \
 //x=36.295 //y=5.39 //x2=36.21 //y2=7.09
cc_3272 ( N_noxref_14_c_4821_n N_noxref_21_c_6960_n ) capacitor c=0.00513934f \
 //x=35.895 //y=5.39 //x2=36.21 //y2=7.09
cc_3273 ( N_noxref_14_c_4830_n N_noxref_21_c_6960_n ) capacitor c=0.00406191f \
 //x=35.9 //y=5.56 //x2=36.21 //y2=7.09
cc_3274 ( N_noxref_14_c_4821_n N_noxref_21_c_6947_n ) capacitor c=6.34305e-19 \
 //x=35.895 //y=5.39 //x2=34.58 //y2=5.39
cc_3275 ( N_noxref_14_c_4758_n N_noxref_21_c_6951_n ) capacitor c=0.00188056f \
 //x=35.855 //y=1.835 //x2=35.46 //y2=5.39
cc_3276 ( N_noxref_14_c_4821_n N_noxref_21_c_6951_n ) capacitor c=0.0514662f \
 //x=35.895 //y=5.39 //x2=35.46 //y2=5.39
cc_3277 ( N_noxref_14_c_4830_n N_noxref_21_c_6951_n ) capacitor c=0.00266f \
 //x=35.9 //y=5.56 //x2=35.46 //y2=5.39
cc_3278 ( N_noxref_14_c_4799_n N_noxref_21_c_6973_n ) capacitor c=0.00564659f \
 //x=36.295 //y=5.39 //x2=36.34 //y2=6.92
cc_3279 ( N_noxref_14_c_4821_n N_noxref_21_c_6957_n ) capacitor c=0.00275395f \
 //x=35.895 //y=5.39 //x2=35.46 //y2=5.56
cc_3280 ( N_noxref_14_c_4830_n N_noxref_21_c_6957_n ) capacitor c=0.0684611f \
 //x=35.9 //y=5.56 //x2=35.46 //y2=5.56
cc_3281 ( N_noxref_14_c_4799_n N_noxref_21_M60_noxref_d ) capacitor \
 c=0.00810041f //x=36.295 //y=5.39 //x2=36.195 //y2=5.205
cc_3282 ( N_noxref_14_c_4826_n N_noxref_21_M60_noxref_d ) capacitor \
 c=9.55403e-19 //x=36.38 //y=3.51 //x2=36.195 //y2=5.205
cc_3283 ( N_noxref_14_c_4830_n N_noxref_21_M60_noxref_d ) capacitor \
 c=0.0478724f //x=35.9 //y=5.56 //x2=36.195 //y2=5.205
cc_3284 ( N_noxref_14_c_4765_n COUT ) capacitor c=0.00270588f //x=36.38 \
 //y=3.355 //x2=38.6 //y2=2.4
cc_3285 ( N_noxref_14_c_4766_n COUT ) capacitor c=0.00273877f //x=36.38 \
 //y=5.305 //x2=38.6 //y2=2.4
cc_3286 ( N_noxref_14_c_4819_n COUT ) capacitor c=0.0425276f //x=37.86 \
 //y=3.355 //x2=38.6 //y2=2.4
cc_3287 ( N_noxref_14_c_4841_p COUT ) capacitor c=0.0149195f //x=37.86 \
 //y=3.675 //x2=38.6 //y2=2.4
cc_3288 ( N_noxref_14_c_4820_n COUT ) capacitor c=0.0570666f //x=37.86 \
 //y=4.76 //x2=38.6 //y2=2.4
cc_3289 ( N_noxref_14_c_4946_p COUT ) capacitor c=0.00541027f //x=37.86 \
 //y=3.51 //x2=38.6 //y2=2.4
cc_3290 ( N_noxref_14_c_4879_p COUT ) capacitor c=0.00825076f //x=37.86 \
 //y=2.265 //x2=38.6 //y2=2.4
cc_3291 ( N_noxref_14_c_4866_p COUT ) capacitor c=0.00687738f //x=37.86 \
 //y=3.515 //x2=38.6 //y2=2.4
cc_3292 ( N_noxref_14_c_4880_p COUT ) capacitor c=0.0023016f //x=37.86 \
 //y=2.265 //x2=38.6 //y2=2.4
cc_3293 ( N_noxref_14_c_4843_p COUT ) capacitor c=0.00250262f //x=37.86 \
 //y=4.88 //x2=38.6 //y2=2.4
cc_3294 ( N_noxref_14_c_4850_p COUT ) capacitor c=4.08297e-19 //x=38.38 \
 //y=4.97 //x2=38.6 //y2=2.4
cc_3295 ( N_noxref_14_c_4859_p COUT ) capacitor c=0.00124564f //x=38.09 \
 //y=4.97 //x2=38.6 //y2=2.4
cc_3296 ( N_noxref_14_c_4893_p COUT ) capacitor c=0.00112403f //x=37.86 \
 //y=2.265 //x2=38.6 //y2=2.4
cc_3297 ( N_noxref_14_c_4743_n N_COUT_c_7048_n ) capacitor c=6.27081e-19 \
 //x=34.97 //y=1.75 //x2=38.23 //y2=1.935
cc_3298 ( N_noxref_14_c_4764_n N_COUT_c_7048_n ) capacitor c=0.00448773f \
 //x=35.94 //y=1.75 //x2=38.23 //y2=1.935
cc_3299 ( N_noxref_14_c_4800_n N_COUT_c_7048_n ) capacitor c=0.00325795f \
 //x=36.295 //y=1.835 //x2=38.23 //y2=1.935
cc_3300 ( N_noxref_14_c_4957_p N_COUT_c_7048_n ) capacitor c=0.00108934f \
 //x=37.97 //y=1.435 //x2=38.23 //y2=1.935
cc_3301 ( N_noxref_14_c_4920_p N_COUT_c_7048_n ) capacitor c=0.00524682f \
 //x=37.97 //y=1.745 //x2=38.23 //y2=1.935
cc_3302 ( N_noxref_14_c_4904_p N_COUT_c_7048_n ) capacitor c=0.00376309f \
 //x=37.97 //y=2.1 //x2=38.23 //y2=1.935
cc_3303 ( N_noxref_14_c_4960_p N_COUT_c_7048_n ) capacitor c=0.00934265f \
 //x=38.345 //y=1.59 //x2=38.23 //y2=1.935
cc_3304 ( N_noxref_14_c_4924_p N_COUT_c_7048_n ) capacitor c=0.00362207f \
 //x=38.5 //y=1.435 //x2=38.23 //y2=1.935
cc_3305 ( N_noxref_14_c_4799_n N_COUT_c_7056_n ) capacitor c=0.0031459f \
 //x=36.295 //y=5.39 //x2=38.235 //y2=5.42
cc_3306 ( N_noxref_14_c_4821_n N_COUT_c_7056_n ) capacitor c=5.06627e-19 \
 //x=35.895 //y=5.39 //x2=38.235 //y2=5.42
cc_3307 ( N_noxref_14_M61_noxref_g N_COUT_c_7056_n ) capacitor c=0.00141266f \
 //x=38.015 //y=6.2 //x2=38.235 //y2=5.42
cc_3308 ( N_noxref_14_M62_noxref_g N_COUT_c_7056_n ) capacitor c=0.00377331f \
 //x=38.455 //y=6.2 //x2=38.235 //y2=5.42
cc_3309 ( N_noxref_14_c_4960_p N_COUT_c_7060_n ) capacitor c=0.00180253f \
 //x=38.345 //y=1.59 //x2=38.515 //y2=2.02
cc_3310 ( N_noxref_14_c_4765_n N_COUT_c_7061_n ) capacitor c=0.00325795f \
 //x=36.38 //y=3.355 //x2=38.315 //y2=2.02
cc_3311 ( N_noxref_14_c_4893_p N_COUT_c_7061_n ) capacitor c=0.00376309f \
 //x=37.86 //y=2.265 //x2=38.315 //y2=2.02
cc_3312 ( N_noxref_14_M62_noxref_g N_COUT_c_7063_n ) capacitor c=0.00966342f \
 //x=38.455 //y=6.2 //x2=38.515 //y2=5.14
cc_3313 ( N_noxref_14_c_4766_n N_COUT_c_7064_n ) capacitor c=0.00293713f \
 //x=36.38 //y=5.305 //x2=38.32 //y2=5.14
cc_3314 ( N_noxref_14_M61_noxref_g N_COUT_c_7064_n ) capacitor c=0.00427521f \
 //x=38.015 //y=6.2 //x2=38.32 //y2=5.14
cc_3315 ( N_noxref_14_c_4850_p N_COUT_c_7064_n ) capacitor c=0.00262283f \
 //x=38.38 //y=4.97 //x2=38.32 //y2=5.14
cc_3316 ( N_noxref_14_c_4788_n N_COUT_c_7067_n ) capacitor c=0.0059861f \
 //x=35.94 //y=1.3 //x2=38.23 //y2=1.185
cc_3317 ( N_noxref_14_c_4764_n N_COUT_c_7067_n ) capacitor c=6.20316e-19 \
 //x=35.94 //y=1.75 //x2=38.23 //y2=1.185
cc_3318 ( N_noxref_14_c_4892_p N_COUT_c_7067_n ) capacitor c=0.00175335f \
 //x=37.97 //y=1.09 //x2=38.23 //y2=1.185
cc_3319 ( N_noxref_14_c_4957_p N_COUT_c_7067_n ) capacitor c=0.00353833f \
 //x=37.97 //y=1.435 //x2=38.23 //y2=1.185
cc_3320 ( N_noxref_14_c_4922_p N_COUT_c_7067_n ) capacitor c=5.57924e-19 \
 //x=38.345 //y=0.935 //x2=38.23 //y2=1.185
cc_3321 ( N_noxref_14_c_4960_p N_COUT_c_7067_n ) capacitor c=5.75878e-19 \
 //x=38.345 //y=1.59 //x2=38.23 //y2=1.185
cc_3322 ( N_noxref_14_c_4894_p N_COUT_c_7067_n ) capacitor c=0.00160969f \
 //x=38.5 //y=1.09 //x2=38.23 //y2=1.185
cc_3323 ( N_noxref_14_c_4924_p N_COUT_c_7067_n ) capacitor c=0.00411132f \
 //x=38.5 //y=1.435 //x2=38.23 //y2=1.185
cc_3324 ( N_noxref_14_M61_noxref_g N_COUT_c_7075_n ) capacitor c=0.0162066f \
 //x=38.015 //y=6.2 //x2=38.235 //y2=5.56
cc_3325 ( N_noxref_14_M62_noxref_g N_COUT_c_7075_n ) capacitor c=0.0162066f \
 //x=38.455 //y=6.2 //x2=38.235 //y2=5.56
cc_3326 ( N_noxref_14_c_4850_p N_COUT_c_7075_n ) capacitor c=0.00290963f \
 //x=38.38 //y=4.97 //x2=38.235 //y2=5.56
cc_3327 ( N_noxref_14_c_4892_p N_COUT_M20_noxref_d ) capacitor c=0.00137914f \
 //x=37.97 //y=1.09 //x2=38.045 //y2=1.09
cc_3328 ( N_noxref_14_c_4957_p N_COUT_M20_noxref_d ) capacitor c=0.0023891f \
 //x=37.97 //y=1.435 //x2=38.045 //y2=1.09
cc_3329 ( N_noxref_14_c_4922_p N_COUT_M20_noxref_d ) capacitor c=0.0020782f \
 //x=38.345 //y=0.935 //x2=38.045 //y2=1.09
cc_3330 ( N_noxref_14_c_4960_p N_COUT_M20_noxref_d ) capacitor c=0.00356097f \
 //x=38.345 //y=1.59 //x2=38.045 //y2=1.09
cc_3331 ( N_noxref_14_c_4894_p N_COUT_M20_noxref_d ) capacitor c=0.00138452f \
 //x=38.5 //y=1.09 //x2=38.045 //y2=1.09
cc_3332 ( N_noxref_14_c_4924_p N_COUT_M20_noxref_d ) capacitor c=0.00235934f \
 //x=38.5 //y=1.435 //x2=38.045 //y2=1.09
cc_3333 ( N_VDD_c_4990_n N_noxref_16_c_5802_n ) capacitor c=0.00175386f \
 //x=3.855 //y=7.585 //x2=4.26 //y2=5.385
cc_3334 ( N_VDD_c_4993_n N_noxref_16_c_5802_n ) capacitor c=0.00657437f \
 //x=3.94 //y=6.7 //x2=4.26 //y2=5.385
cc_3335 ( N_VDD_c_5169_n N_noxref_16_c_5802_n ) capacitor c=5.36854e-19 \
 //x=7.185 //y=7.585 //x2=4.26 //y2=5.385
cc_3336 ( N_VDD_c_5001_n N_noxref_16_c_5802_n ) capacitor c=0.00593793f \
 //x=5.87 //y=7.585 //x2=4.26 //y2=5.385
cc_3337 ( N_VDD_M23_noxref_d N_noxref_16_c_5802_n ) capacitor c=0.00553895f \
 //x=3.795 //y=5.2 //x2=4.26 //y2=5.385
cc_3338 ( N_VDD_c_5549_n N_noxref_16_c_5819_n ) capacitor c=0.00219447f \
 //x=38.97 //y=7.58 //x2=5.145 //y2=7.085
cc_3339 ( N_VDD_c_4990_n N_noxref_16_c_5809_n ) capacitor c=4.41493e-19 \
 //x=3.855 //y=7.585 //x2=3.507 //y2=5.385
cc_3340 ( N_VDD_c_5001_n N_noxref_16_c_5809_n ) capacitor c=2.31756e-19 \
 //x=5.87 //y=7.585 //x2=3.507 //y2=5.385
cc_3341 ( N_VDD_c_5012_n N_noxref_16_c_5809_n ) capacitor c=0.00721415f \
 //x=2.71 //y=7.585 //x2=3.507 //y2=5.385
cc_3342 ( N_VDD_M22_noxref_d N_noxref_16_c_5809_n ) capacitor c=0.0122414f \
 //x=1.9 //y=5.2 //x2=3.507 //y2=5.385
cc_3343 ( N_VDD_c_4995_n N_noxref_16_c_5813_n ) capacitor c=0.0389154f \
 //x=3.94 //y=7.41 //x2=4.38 //y2=6.915
cc_3344 ( N_VDD_c_5169_n N_noxref_16_c_5813_n ) capacitor c=0.0963663f \
 //x=7.185 //y=7.585 //x2=4.38 //y2=6.915
cc_3345 ( N_VDD_c_5001_n N_noxref_16_c_5813_n ) capacitor c=0.020417f //x=5.87 \
 //y=7.585 //x2=4.38 //y2=6.915
cc_3346 ( N_VDD_c_4995_n N_noxref_16_c_5823_n ) capacitor c=0.00102965f \
 //x=3.94 //y=7.41 //x2=5.26 //y2=6.915
cc_3347 ( N_VDD_c_5169_n N_noxref_16_c_5823_n ) capacitor c=0.00184284f \
 //x=7.185 //y=7.585 //x2=5.26 //y2=6.915
cc_3348 ( N_VDD_c_5096_n N_noxref_16_c_5823_n ) capacitor c=0.002629f //x=7.27 \
 //y=7.41 //x2=5.26 //y2=6.915
cc_3349 ( N_VDD_c_5001_n N_noxref_16_c_5823_n ) capacitor c=9.09182e-19 \
 //x=5.87 //y=7.585 //x2=5.26 //y2=6.915
cc_3350 ( N_VDD_c_5056_n N_noxref_16_c_5823_n ) capacitor c=0.00746969f \
 //x=6.04 //y=7.585 //x2=5.26 //y2=6.915
cc_3351 ( N_VDD_c_4990_n N_noxref_16_c_5814_n ) capacitor c=0.00209062f \
 //x=3.855 //y=7.585 //x2=3.5 //y2=5.555
cc_3352 ( N_VDD_c_4993_n N_noxref_16_c_5814_n ) capacitor c=0.00716177f \
 //x=3.94 //y=6.7 //x2=3.5 //y2=5.555
cc_3353 ( N_VDD_c_4995_n N_noxref_16_c_5814_n ) capacitor c=0.00218649f \
 //x=3.94 //y=7.41 //x2=3.5 //y2=5.555
cc_3354 ( N_VDD_c_5001_n N_noxref_16_c_5814_n ) capacitor c=0.00844587f \
 //x=5.87 //y=7.585 //x2=3.5 //y2=5.555
cc_3355 ( N_VDD_c_5549_n N_noxref_16_c_5814_n ) capacitor c=2.22395e-19 \
 //x=38.97 //y=7.58 //x2=3.5 //y2=5.555
cc_3356 ( N_VDD_c_5012_n N_noxref_16_c_5814_n ) capacitor c=0.0523125f \
 //x=2.71 //y=7.585 //x2=3.5 //y2=5.555
cc_3357 ( N_VDD_M22_noxref_d N_noxref_16_c_5814_n ) capacitor c=0.00276503f \
 //x=1.9 //y=5.2 //x2=3.5 //y2=5.555
cc_3358 ( N_VDD_M23_noxref_d N_noxref_16_c_5814_n ) capacitor c=0.0478566f \
 //x=3.795 //y=5.2 //x2=3.5 //y2=5.555
cc_3359 ( N_VDD_c_4993_n N_noxref_16_c_5816_n ) capacitor c=0.00626175f \
 //x=3.94 //y=6.7 //x2=4.38 //y2=5.555
cc_3360 ( N_VDD_c_4995_n N_noxref_16_c_5816_n ) capacitor c=0.00311588f \
 //x=3.94 //y=7.41 //x2=4.38 //y2=5.555
cc_3361 ( N_VDD_c_5169_n N_noxref_16_c_5816_n ) capacitor c=0.00203449f \
 //x=7.185 //y=7.585 //x2=4.38 //y2=5.555
cc_3362 ( N_VDD_c_5001_n N_noxref_16_c_5816_n ) capacitor c=0.0084192f \
 //x=5.87 //y=7.585 //x2=4.38 //y2=5.555
cc_3363 ( N_VDD_c_5549_n N_noxref_16_c_5816_n ) capacitor c=2.22395e-19 \
 //x=38.97 //y=7.58 //x2=4.38 //y2=5.555
cc_3364 ( N_VDD_M23_noxref_d N_noxref_16_c_5816_n ) capacitor c=0.047843f \
 //x=3.795 //y=5.2 //x2=4.38 //y2=5.555
cc_3365 ( N_VDD_c_4990_n N_noxref_16_M23_noxref_s ) capacitor c=0.0218384f \
 //x=3.855 //y=7.585 //x2=3.365 //y2=5.2
cc_3366 ( N_VDD_c_4995_n N_noxref_16_M23_noxref_s ) capacitor c=0.0369805f \
 //x=3.94 //y=7.41 //x2=3.365 //y2=5.2
cc_3367 ( N_VDD_c_5001_n N_noxref_16_M23_noxref_s ) capacitor c=0.00343047f \
 //x=5.87 //y=7.585 //x2=3.365 //y2=5.2
cc_3368 ( N_VDD_c_5012_n N_noxref_16_M23_noxref_s ) capacitor c=0.00927581f \
 //x=2.71 //y=7.585 //x2=3.365 //y2=5.2
cc_3369 ( N_VDD_c_5169_n N_noxref_16_M26_noxref_d ) capacitor c=0.00204601f \
 //x=7.185 //y=7.585 //x2=5.115 //y2=5.2
cc_3370 ( N_VDD_c_5001_n N_noxref_16_M26_noxref_d ) capacitor c=0.00844271f \
 //x=5.87 //y=7.585 //x2=5.115 //y2=5.2
cc_3371 ( N_VDD_c_5549_n N_noxref_16_M26_noxref_d ) capacitor c=2.22395e-19 \
 //x=38.97 //y=7.58 //x2=5.115 //y2=5.2
cc_3372 ( N_VDD_c_5056_n N_noxref_16_M26_noxref_d ) capacitor c=0.0449172f \
 //x=6.04 //y=7.585 //x2=5.115 //y2=5.2
cc_3373 ( N_VDD_c_5169_n N_noxref_17_c_5891_n ) capacitor c=5.9643e-19 \
 //x=7.185 //y=7.585 //x2=7.595 //y2=5.385
cc_3374 ( N_VDD_c_5094_n N_noxref_17_c_5891_n ) capacitor c=0.00619799f \
 //x=7.27 //y=6.69 //x2=7.595 //y2=5.385
cc_3375 ( N_VDD_c_5065_n N_noxref_17_c_5891_n ) capacitor c=5.9643e-19 \
 //x=14.955 //y=7.585 //x2=7.595 //y2=5.385
cc_3376 ( N_VDD_c_5047_n N_noxref_17_c_5891_n ) capacitor c=0.0075955f //x=9.2 \
 //y=7.585 //x2=7.595 //y2=5.385
cc_3377 ( N_VDD_M27_noxref_d N_noxref_17_c_5891_n ) capacitor c=0.00560574f \
 //x=7.125 //y=5.2 //x2=7.595 //y2=5.385
cc_3378 ( N_VDD_c_5549_n N_noxref_17_c_5882_n ) capacitor c=0.00219447f \
 //x=38.97 //y=7.58 //x2=8.47 //y2=7.085
cc_3379 ( N_VDD_c_5056_n N_noxref_17_c_5889_n ) capacitor c=0.00751288f \
 //x=6.04 //y=7.585 //x2=6.83 //y2=5.385
cc_3380 ( N_VDD_M31_noxref_s N_noxref_17_c_5884_n ) capacitor c=7.50235e-19 \
 //x=9.91 //y=5.2 //x2=7.71 //y2=5.385
cc_3381 ( N_VDD_c_5096_n N_noxref_17_c_5885_n ) capacitor c=0.0393574f \
 //x=7.27 //y=7.41 //x2=7.71 //y2=6.915
cc_3382 ( N_VDD_c_5065_n N_noxref_17_c_5885_n ) capacitor c=0.09647f \
 //x=14.955 //y=7.585 //x2=7.71 //y2=6.915
cc_3383 ( N_VDD_c_5047_n N_noxref_17_c_5885_n ) capacitor c=0.0204087f //x=9.2 \
 //y=7.585 //x2=7.71 //y2=6.915
cc_3384 ( N_VDD_c_5096_n N_noxref_17_c_5886_n ) capacitor c=0.00105525f \
 //x=7.27 //y=7.41 //x2=8.59 //y2=6.915
cc_3385 ( N_VDD_c_5065_n N_noxref_17_c_5886_n ) capacitor c=0.00191156f \
 //x=14.955 //y=7.585 //x2=8.59 //y2=6.915
cc_3386 ( N_VDD_c_5047_n N_noxref_17_c_5886_n ) capacitor c=5.93287e-19 \
 //x=9.2 //y=7.585 //x2=8.59 //y2=6.915
cc_3387 ( N_VDD_c_5057_n N_noxref_17_c_5886_n ) capacitor c=0.0114198f \
 //x=9.37 //y=7.585 //x2=8.59 //y2=6.915
cc_3388 ( N_VDD_c_5169_n N_noxref_17_c_5901_n ) capacitor c=0.00210247f \
 //x=7.185 //y=7.585 //x2=6.83 //y2=5.555
cc_3389 ( N_VDD_c_5094_n N_noxref_17_c_5901_n ) capacitor c=0.00601924f \
 //x=7.27 //y=6.69 //x2=6.83 //y2=5.555
cc_3390 ( N_VDD_c_5096_n N_noxref_17_c_5901_n ) capacitor c=0.00237006f \
 //x=7.27 //y=7.41 //x2=6.83 //y2=5.555
cc_3391 ( N_VDD_c_5047_n N_noxref_17_c_5901_n ) capacitor c=0.00845221f \
 //x=9.2 //y=7.585 //x2=6.83 //y2=5.555
cc_3392 ( N_VDD_c_5549_n N_noxref_17_c_5901_n ) capacitor c=2.22395e-19 \
 //x=38.97 //y=7.58 //x2=6.83 //y2=5.555
cc_3393 ( N_VDD_c_5056_n N_noxref_17_c_5901_n ) capacitor c=0.0532223f \
 //x=6.04 //y=7.585 //x2=6.83 //y2=5.555
cc_3394 ( N_VDD_M27_noxref_d N_noxref_17_c_5901_n ) capacitor c=0.0479465f \
 //x=7.125 //y=5.2 //x2=6.83 //y2=5.555
cc_3395 ( N_VDD_c_5094_n N_noxref_17_c_5887_n ) capacitor c=0.00689217f \
 //x=7.27 //y=6.69 //x2=7.71 //y2=5.555
cc_3396 ( N_VDD_c_5096_n N_noxref_17_c_5887_n ) capacitor c=0.00366379f \
 //x=7.27 //y=7.41 //x2=7.71 //y2=5.555
cc_3397 ( N_VDD_c_5065_n N_noxref_17_c_5887_n ) capacitor c=0.00203449f \
 //x=14.955 //y=7.585 //x2=7.71 //y2=5.555
cc_3398 ( N_VDD_c_5047_n N_noxref_17_c_5887_n ) capacitor c=0.0084192f //x=9.2 \
 //y=7.585 //x2=7.71 //y2=5.555
cc_3399 ( N_VDD_c_5549_n N_noxref_17_c_5887_n ) capacitor c=2.22395e-19 \
 //x=38.97 //y=7.58 //x2=7.71 //y2=5.555
cc_3400 ( N_VDD_M27_noxref_d N_noxref_17_c_5887_n ) capacitor c=0.0478672f \
 //x=7.125 //y=5.2 //x2=7.71 //y2=5.555
cc_3401 ( N_VDD_c_4995_n N_noxref_17_M27_noxref_s ) capacitor c=4.52323e-19 \
 //x=3.94 //y=7.41 //x2=6.695 //y2=5.2
cc_3402 ( N_VDD_c_5169_n N_noxref_17_M27_noxref_s ) capacitor c=0.0216531f \
 //x=7.185 //y=7.585 //x2=6.695 //y2=5.2
cc_3403 ( N_VDD_c_5096_n N_noxref_17_M27_noxref_s ) capacitor c=0.0339466f \
 //x=7.27 //y=7.41 //x2=6.695 //y2=5.2
cc_3404 ( N_VDD_c_5047_n N_noxref_17_M27_noxref_s ) capacitor c=0.00371538f \
 //x=9.2 //y=7.585 //x2=6.695 //y2=5.2
cc_3405 ( N_VDD_c_5056_n N_noxref_17_M27_noxref_s ) capacitor c=0.00541973f \
 //x=6.04 //y=7.585 //x2=6.695 //y2=5.2
cc_3406 ( N_VDD_c_5065_n N_noxref_17_M30_noxref_d ) capacitor c=0.00204601f \
 //x=14.955 //y=7.585 //x2=8.445 //y2=5.2
cc_3407 ( N_VDD_c_5047_n N_noxref_17_M30_noxref_d ) capacitor c=0.00844271f \
 //x=9.2 //y=7.585 //x2=8.445 //y2=5.2
cc_3408 ( N_VDD_c_5549_n N_noxref_17_M30_noxref_d ) capacitor c=2.22395e-19 \
 //x=38.97 //y=7.58 //x2=8.445 //y2=5.2
cc_3409 ( N_VDD_c_5057_n N_noxref_17_M30_noxref_d ) capacitor c=0.0442402f \
 //x=9.37 //y=7.585 //x2=8.445 //y2=5.2
cc_3410 ( N_VDD_M31_noxref_s N_noxref_17_M30_noxref_d ) capacitor \
 c=0.00279822f //x=9.91 //y=5.2 //x2=8.445 //y2=5.2
cc_3411 ( N_VDD_c_5065_n N_noxref_18_c_5963_n ) capacitor c=3.58101e-19 \
 //x=14.955 //y=7.585 //x2=15.36 //y2=5.385
cc_3412 ( N_VDD_c_5177_n N_noxref_18_c_5963_n ) capacitor c=0.0060757f \
 //x=15.04 //y=6.7 //x2=15.36 //y2=5.385
cc_3413 ( N_VDD_c_5101_n N_noxref_18_c_5963_n ) capacitor c=5.36854e-19 \
 //x=18.285 //y=7.585 //x2=15.36 //y2=5.385
cc_3414 ( N_VDD_c_5187_n N_noxref_18_c_5963_n ) capacitor c=0.00748005f \
 //x=16.97 //y=7.585 //x2=15.36 //y2=5.385
cc_3415 ( N_VDD_M35_noxref_d N_noxref_18_c_5963_n ) capacitor c=0.0056162f \
 //x=14.895 //y=5.2 //x2=15.36 //y2=5.385
cc_3416 ( N_VDD_c_5549_n N_noxref_18_c_5960_n ) capacitor c=0.00219447f \
 //x=38.97 //y=7.58 //x2=16.245 //y2=7.085
cc_3417 ( N_VDD_c_5065_n N_noxref_18_c_5961_n ) capacitor c=4.41493e-19 \
 //x=14.955 //y=7.585 //x2=14.607 //y2=5.385
cc_3418 ( N_VDD_c_5187_n N_noxref_18_c_5961_n ) capacitor c=2.31756e-19 \
 //x=16.97 //y=7.585 //x2=14.607 //y2=5.385
cc_3419 ( N_VDD_c_5131_n N_noxref_18_c_5961_n ) capacitor c=0.00721415f \
 //x=13.81 //y=7.585 //x2=14.607 //y2=5.385
cc_3420 ( N_VDD_M34_noxref_d N_noxref_18_c_5961_n ) capacitor c=0.0122414f \
 //x=13 //y=5.2 //x2=14.607 //y2=5.385
cc_3421 ( N_VDD_c_5179_n N_noxref_18_c_5972_n ) capacitor c=0.0389154f \
 //x=15.04 //y=7.41 //x2=15.48 //y2=6.915
cc_3422 ( N_VDD_c_5101_n N_noxref_18_c_5972_n ) capacitor c=0.0963663f \
 //x=18.285 //y=7.585 //x2=15.48 //y2=6.915
cc_3423 ( N_VDD_c_5187_n N_noxref_18_c_5972_n ) capacitor c=0.0200922f \
 //x=16.97 //y=7.585 //x2=15.48 //y2=6.915
cc_3424 ( N_VDD_c_5179_n N_noxref_18_c_5984_n ) capacitor c=0.00102965f \
 //x=15.04 //y=7.41 //x2=16.36 //y2=6.915
cc_3425 ( N_VDD_c_5101_n N_noxref_18_c_5984_n ) capacitor c=0.00184284f \
 //x=18.285 //y=7.585 //x2=16.36 //y2=6.915
cc_3426 ( N_VDD_c_5313_n N_noxref_18_c_5984_n ) capacitor c=0.002629f \
 //x=18.37 //y=7.41 //x2=16.36 //y2=6.915
cc_3427 ( N_VDD_c_5187_n N_noxref_18_c_5984_n ) capacitor c=5.81313e-19 \
 //x=16.97 //y=7.585 //x2=16.36 //y2=6.915
cc_3428 ( N_VDD_c_5132_n N_noxref_18_c_5984_n ) capacitor c=0.00746969f \
 //x=17.14 //y=7.585 //x2=16.36 //y2=6.915
cc_3429 ( N_VDD_c_5065_n N_noxref_18_c_5973_n ) capacitor c=0.00209062f \
 //x=14.955 //y=7.585 //x2=14.6 //y2=5.555
cc_3430 ( N_VDD_c_5177_n N_noxref_18_c_5973_n ) capacitor c=0.00716177f \
 //x=15.04 //y=6.7 //x2=14.6 //y2=5.555
cc_3431 ( N_VDD_c_5179_n N_noxref_18_c_5973_n ) capacitor c=0.00218649f \
 //x=15.04 //y=7.41 //x2=14.6 //y2=5.555
cc_3432 ( N_VDD_c_5187_n N_noxref_18_c_5973_n ) capacitor c=0.00844587f \
 //x=16.97 //y=7.585 //x2=14.6 //y2=5.555
cc_3433 ( N_VDD_c_5549_n N_noxref_18_c_5973_n ) capacitor c=2.22395e-19 \
 //x=38.97 //y=7.58 //x2=14.6 //y2=5.555
cc_3434 ( N_VDD_c_5131_n N_noxref_18_c_5973_n ) capacitor c=0.0523125f \
 //x=13.81 //y=7.585 //x2=14.6 //y2=5.555
cc_3435 ( N_VDD_M34_noxref_d N_noxref_18_c_5973_n ) capacitor c=0.00276503f \
 //x=13 //y=5.2 //x2=14.6 //y2=5.555
cc_3436 ( N_VDD_M35_noxref_d N_noxref_18_c_5973_n ) capacitor c=0.0478566f \
 //x=14.895 //y=5.2 //x2=14.6 //y2=5.555
cc_3437 ( N_VDD_c_5177_n N_noxref_18_c_5975_n ) capacitor c=0.00626175f \
 //x=15.04 //y=6.7 //x2=15.48 //y2=5.555
cc_3438 ( N_VDD_c_5179_n N_noxref_18_c_5975_n ) capacitor c=0.00311588f \
 //x=15.04 //y=7.41 //x2=15.48 //y2=5.555
cc_3439 ( N_VDD_c_5101_n N_noxref_18_c_5975_n ) capacitor c=0.00203449f \
 //x=18.285 //y=7.585 //x2=15.48 //y2=5.555
cc_3440 ( N_VDD_c_5187_n N_noxref_18_c_5975_n ) capacitor c=0.0084192f \
 //x=16.97 //y=7.585 //x2=15.48 //y2=5.555
cc_3441 ( N_VDD_c_5549_n N_noxref_18_c_5975_n ) capacitor c=2.22395e-19 \
 //x=38.97 //y=7.58 //x2=15.48 //y2=5.555
cc_3442 ( N_VDD_M35_noxref_d N_noxref_18_c_5975_n ) capacitor c=0.047843f \
 //x=14.895 //y=5.2 //x2=15.48 //y2=5.555
cc_3443 ( N_VDD_c_5065_n N_noxref_18_M35_noxref_s ) capacitor c=0.022205f \
 //x=14.955 //y=7.585 //x2=14.465 //y2=5.2
cc_3444 ( N_VDD_c_5179_n N_noxref_18_M35_noxref_s ) capacitor c=0.0369805f \
 //x=15.04 //y=7.41 //x2=14.465 //y2=5.2
cc_3445 ( N_VDD_c_5187_n N_noxref_18_M35_noxref_s ) capacitor c=0.00271761f \
 //x=16.97 //y=7.585 //x2=14.465 //y2=5.2
cc_3446 ( N_VDD_c_5131_n N_noxref_18_M35_noxref_s ) capacitor c=0.00927581f \
 //x=13.81 //y=7.585 //x2=14.465 //y2=5.2
cc_3447 ( N_VDD_c_5101_n N_noxref_18_M38_noxref_d ) capacitor c=0.00204601f \
 //x=18.285 //y=7.585 //x2=16.215 //y2=5.2
cc_3448 ( N_VDD_c_5187_n N_noxref_18_M38_noxref_d ) capacitor c=0.00844271f \
 //x=16.97 //y=7.585 //x2=16.215 //y2=5.2
cc_3449 ( N_VDD_c_5549_n N_noxref_18_M38_noxref_d ) capacitor c=2.22395e-19 \
 //x=38.97 //y=7.58 //x2=16.215 //y2=5.2
cc_3450 ( N_VDD_c_5132_n N_noxref_18_M38_noxref_d ) capacitor c=0.0449172f \
 //x=17.14 //y=7.585 //x2=16.215 //y2=5.2
cc_3451 ( N_VDD_c_5101_n N_noxref_19_c_6041_n ) capacitor c=5.32403e-19 \
 //x=18.285 //y=7.585 //x2=18.695 //y2=5.385
cc_3452 ( N_VDD_c_5103_n N_noxref_19_c_6041_n ) capacitor c=0.00661415f \
 //x=18.37 //y=6.69 //x2=18.695 //y2=5.385
cc_3453 ( N_VDD_c_5104_n N_noxref_19_c_6041_n ) capacitor c=5.32403e-19 \
 //x=34.935 //y=7.585 //x2=18.695 //y2=5.385
cc_3454 ( N_VDD_c_5245_n N_noxref_19_c_6041_n ) capacitor c=0.007587f //x=20.3 \
 //y=7.585 //x2=18.695 //y2=5.385
cc_3455 ( N_VDD_M39_noxref_d N_noxref_19_c_6041_n ) capacitor c=0.00560574f \
 //x=18.225 //y=5.2 //x2=18.695 //y2=5.385
cc_3456 ( N_VDD_c_5549_n N_noxref_19_c_6042_n ) capacitor c=0.00219447f \
 //x=38.97 //y=7.58 //x2=19.57 //y2=7.085
cc_3457 ( N_VDD_c_5132_n N_noxref_19_c_6043_n ) capacitor c=0.00716372f \
 //x=17.14 //y=7.585 //x2=17.93 //y2=5.385
cc_3458 ( N_VDD_M43_noxref_s N_noxref_19_c_6045_n ) capacitor c=6.85763e-19 \
 //x=21.01 //y=5.2 //x2=18.81 //y2=5.385
cc_3459 ( N_VDD_c_5313_n N_noxref_19_c_6051_n ) capacitor c=0.0393574f \
 //x=18.37 //y=7.41 //x2=18.81 //y2=6.915
cc_3460 ( N_VDD_c_5104_n N_noxref_19_c_6051_n ) capacitor c=0.0964794f \
 //x=34.935 //y=7.585 //x2=18.81 //y2=6.915
cc_3461 ( N_VDD_c_5245_n N_noxref_19_c_6051_n ) capacitor c=0.020084f //x=20.3 \
 //y=7.585 //x2=18.81 //y2=6.915
cc_3462 ( N_VDD_c_5313_n N_noxref_19_c_6052_n ) capacitor c=0.00105525f \
 //x=18.37 //y=7.41 //x2=19.69 //y2=6.915
cc_3463 ( N_VDD_c_5104_n N_noxref_19_c_6052_n ) capacitor c=0.00191156f \
 //x=34.935 //y=7.585 //x2=19.69 //y2=6.915
cc_3464 ( N_VDD_c_5245_n N_noxref_19_c_6052_n ) capacitor c=5.93287e-19 \
 //x=20.3 //y=7.585 //x2=19.69 //y2=6.915
cc_3465 ( N_VDD_c_5135_n N_noxref_19_c_6052_n ) capacitor c=0.0114198f \
 //x=20.47 //y=7.585 //x2=19.69 //y2=6.915
cc_3466 ( N_VDD_c_5101_n N_noxref_19_c_6077_n ) capacitor c=0.00210247f \
 //x=18.285 //y=7.585 //x2=17.93 //y2=5.555
cc_3467 ( N_VDD_c_5103_n N_noxref_19_c_6077_n ) capacitor c=0.00601924f \
 //x=18.37 //y=6.69 //x2=17.93 //y2=5.555
cc_3468 ( N_VDD_c_5313_n N_noxref_19_c_6077_n ) capacitor c=0.00237006f \
 //x=18.37 //y=7.41 //x2=17.93 //y2=5.555
cc_3469 ( N_VDD_c_5245_n N_noxref_19_c_6077_n ) capacitor c=0.00845221f \
 //x=20.3 //y=7.585 //x2=17.93 //y2=5.555
cc_3470 ( N_VDD_c_5549_n N_noxref_19_c_6077_n ) capacitor c=2.22395e-19 \
 //x=38.97 //y=7.58 //x2=17.93 //y2=5.555
cc_3471 ( N_VDD_c_5132_n N_noxref_19_c_6077_n ) capacitor c=0.0532223f \
 //x=17.14 //y=7.585 //x2=17.93 //y2=5.555
cc_3472 ( N_VDD_M39_noxref_d N_noxref_19_c_6077_n ) capacitor c=0.0479465f \
 //x=18.225 //y=5.2 //x2=17.93 //y2=5.555
cc_3473 ( N_VDD_c_5103_n N_noxref_19_c_6053_n ) capacitor c=0.00689217f \
 //x=18.37 //y=6.69 //x2=18.81 //y2=5.555
cc_3474 ( N_VDD_c_5313_n N_noxref_19_c_6053_n ) capacitor c=0.00366379f \
 //x=18.37 //y=7.41 //x2=18.81 //y2=5.555
cc_3475 ( N_VDD_c_5104_n N_noxref_19_c_6053_n ) capacitor c=0.00203449f \
 //x=34.935 //y=7.585 //x2=18.81 //y2=5.555
cc_3476 ( N_VDD_c_5245_n N_noxref_19_c_6053_n ) capacitor c=0.0084192f \
 //x=20.3 //y=7.585 //x2=18.81 //y2=5.555
cc_3477 ( N_VDD_c_5549_n N_noxref_19_c_6053_n ) capacitor c=2.22395e-19 \
 //x=38.97 //y=7.58 //x2=18.81 //y2=5.555
cc_3478 ( N_VDD_M39_noxref_d N_noxref_19_c_6053_n ) capacitor c=0.0478672f \
 //x=18.225 //y=5.2 //x2=18.81 //y2=5.555
cc_3479 ( N_VDD_c_5179_n N_noxref_19_M39_noxref_s ) capacitor c=4.52323e-19 \
 //x=15.04 //y=7.41 //x2=17.795 //y2=5.2
cc_3480 ( N_VDD_c_5101_n N_noxref_19_M39_noxref_s ) capacitor c=0.0220122f \
 //x=18.285 //y=7.585 //x2=17.795 //y2=5.2
cc_3481 ( N_VDD_c_5313_n N_noxref_19_M39_noxref_s ) capacitor c=0.0339466f \
 //x=18.37 //y=7.41 //x2=17.795 //y2=5.2
cc_3482 ( N_VDD_c_5245_n N_noxref_19_M39_noxref_s ) capacitor c=0.00289402f \
 //x=20.3 //y=7.585 //x2=17.795 //y2=5.2
cc_3483 ( N_VDD_c_5132_n N_noxref_19_M39_noxref_s ) capacitor c=0.00541973f \
 //x=17.14 //y=7.585 //x2=17.795 //y2=5.2
cc_3484 ( N_VDD_c_5104_n N_noxref_19_M42_noxref_d ) capacitor c=0.00204601f \
 //x=34.935 //y=7.585 //x2=19.545 //y2=5.2
cc_3485 ( N_VDD_c_5245_n N_noxref_19_M42_noxref_d ) capacitor c=0.00844271f \
 //x=20.3 //y=7.585 //x2=19.545 //y2=5.2
cc_3486 ( N_VDD_c_5549_n N_noxref_19_M42_noxref_d ) capacitor c=2.22395e-19 \
 //x=38.97 //y=7.58 //x2=19.545 //y2=5.2
cc_3487 ( N_VDD_c_5135_n N_noxref_19_M42_noxref_d ) capacitor c=0.0442402f \
 //x=20.47 //y=7.585 //x2=19.545 //y2=5.2
cc_3488 ( N_VDD_M43_noxref_s N_noxref_19_M42_noxref_d ) capacitor \
 c=0.00279822f //x=21.01 //y=5.2 //x2=19.545 //y2=5.2
cc_3489 ( N_VDD_c_5549_n N_GND_c_6723_n ) capacitor c=0.00989514f //x=38.97 \
 //y=7.58 //x2=38.97 //y2=0.18
cc_3490 ( N_VDD_c_5005_n N_GND_c_6161_n ) capacitor c=0.00989514f //x=1.23 \
 //y=7.58 //x2=1.12 //y2=0.175
cc_3491 ( N_VDD_c_5012_n N_GND_c_6166_n ) capacitor c=0.00680738f //x=2.71 \
 //y=7.585 //x2=2.71 //y2=0.175
cc_3492 ( N_VDD_c_5056_n N_GND_c_6173_n ) capacitor c=0.00647951f //x=6.04 \
 //y=7.585 //x2=6.04 //y2=0.175
cc_3493 ( N_VDD_c_5057_n N_GND_c_6175_n ) capacitor c=0.00648088f //x=9.37 \
 //y=7.585 //x2=9.37 //y2=0.175
cc_3494 ( N_VDD_c_5083_n N_GND_c_6176_n ) capacitor c=0.00913368f //x=11.59 \
 //y=7.585 //x2=11.59 //y2=0.175
cc_3495 ( N_VDD_c_5131_n N_GND_c_6177_n ) capacitor c=0.00680738f //x=13.81 \
 //y=7.585 //x2=13.81 //y2=0.175
cc_3496 ( N_VDD_c_5132_n N_GND_c_6178_n ) capacitor c=0.00647951f //x=17.14 \
 //y=7.585 //x2=17.14 //y2=0.175
cc_3497 ( N_VDD_c_5135_n N_GND_c_6179_n ) capacitor c=0.00650455f //x=20.47 \
 //y=7.585 //x2=20.47 //y2=0.175
cc_3498 ( N_VDD_c_5137_n N_GND_c_6180_n ) capacitor c=0.00961451f //x=22.69 \
 //y=7.585 //x2=22.69 //y2=0.175
cc_3499 ( N_VDD_c_5139_n N_GND_c_6181_n ) capacitor c=0.00912573f //x=26.02 \
 //y=7.585 //x2=26.02 //y2=0.175
cc_3500 ( N_VDD_c_5140_n N_GND_c_6182_n ) capacitor c=0.00915826f //x=28.24 \
 //y=7.585 //x2=28.24 //y2=0.175
cc_3501 ( N_VDD_c_5023_n N_GND_c_6183_n ) capacitor c=0.00906209f //x=31.57 \
 //y=7.585 //x2=31.57 //y2=0.175
cc_3502 ( N_VDD_c_5450_n N_GND_c_6619_n ) capacitor c=0.00906209f //x=33.79 \
 //y=7.585 //x2=33.79 //y2=0.175
cc_3503 ( N_VDD_c_5499_n N_GND_c_6688_n ) capacitor c=0.00912573f //x=37.12 \
 //y=7.585 //x2=37.12 //y2=0.175
cc_3504 ( N_VDD_c_5104_n N_noxref_21_c_6940_n ) capacitor c=5.98028e-19 \
 //x=34.935 //y=7.585 //x2=35.34 //y2=5.39
cc_3505 ( N_VDD_c_5479_n N_noxref_21_c_6940_n ) capacitor c=0.004989f \
 //x=35.02 //y=7.035 //x2=35.34 //y2=5.39
cc_3506 ( N_VDD_c_5539_n N_noxref_21_c_6940_n ) capacitor c=0.00192799f \
 //x=38.97 //y=7.58 //x2=35.34 //y2=5.39
cc_3507 ( N_VDD_c_5486_n N_noxref_21_c_6940_n ) capacitor c=0.00590635f \
 //x=36.95 //y=7.585 //x2=35.34 //y2=5.39
cc_3508 ( N_VDD_M57_noxref_d N_noxref_21_c_6940_n ) capacitor c=0.00650094f \
 //x=34.875 //y=5.205 //x2=35.34 //y2=5.39
cc_3509 ( N_VDD_c_5549_n N_noxref_21_c_6960_n ) capacitor c=0.00224226f \
 //x=38.97 //y=7.58 //x2=36.21 //y2=7.09
cc_3510 ( N_VDD_c_5450_n N_noxref_21_c_6947_n ) capacitor c=0.00713363f \
 //x=33.79 //y=7.585 //x2=34.58 //y2=5.39
cc_3511 ( N_VDD_M56_noxref_d N_noxref_21_c_6947_n ) capacitor c=0.0123722f \
 //x=32.98 //y=5.2 //x2=34.58 //y2=5.39
cc_3512 ( N_VDD_M61_noxref_s N_noxref_21_c_6951_n ) capacitor c=8.05316e-19 \
 //x=37.66 //y=5.2 //x2=35.46 //y2=5.39
cc_3513 ( N_VDD_c_5479_n N_noxref_21_c_6952_n ) capacitor c=0.0377581f \
 //x=35.02 //y=7.035 //x2=35.46 //y2=6.92
cc_3514 ( N_VDD_c_5481_n N_noxref_21_c_6952_n ) capacitor c=0.0104317f \
 //x=35.02 //y=7.41 //x2=35.46 //y2=6.92
cc_3515 ( N_VDD_c_5539_n N_noxref_21_c_6952_n ) capacitor c=0.098052f \
 //x=38.97 //y=7.58 //x2=35.46 //y2=6.92
cc_3516 ( N_VDD_c_5486_n N_noxref_21_c_6952_n ) capacitor c=0.0204966f \
 //x=36.95 //y=7.585 //x2=35.46 //y2=6.92
cc_3517 ( N_VDD_M57_noxref_d N_noxref_21_c_6952_n ) capacitor c=0.00510287f \
 //x=34.875 //y=5.205 //x2=35.46 //y2=6.92
cc_3518 ( N_VDD_c_5479_n N_noxref_21_c_6973_n ) capacitor c=6.1128e-19 \
 //x=35.02 //y=7.035 //x2=36.34 //y2=6.92
cc_3519 ( N_VDD_c_5539_n N_noxref_21_c_6973_n ) capacitor c=0.00193184f \
 //x=38.97 //y=7.58 //x2=36.34 //y2=6.92
cc_3520 ( N_VDD_c_5486_n N_noxref_21_c_6973_n ) capacitor c=9.3761e-19 \
 //x=36.95 //y=7.585 //x2=36.34 //y2=6.92
cc_3521 ( N_VDD_c_5499_n N_noxref_21_c_6973_n ) capacitor c=0.0111101f \
 //x=37.12 //y=7.585 //x2=36.34 //y2=6.92
cc_3522 ( N_VDD_c_5104_n N_noxref_21_c_6953_n ) capacitor c=0.00240365f \
 //x=34.935 //y=7.585 //x2=34.58 //y2=5.56
cc_3523 ( N_VDD_c_5479_n N_noxref_21_c_6953_n ) capacitor c=0.00220777f \
 //x=35.02 //y=7.035 //x2=34.58 //y2=5.56
cc_3524 ( N_VDD_c_5481_n N_noxref_21_c_6953_n ) capacitor c=0.00154298f \
 //x=35.02 //y=7.41 //x2=34.58 //y2=5.56
cc_3525 ( N_VDD_c_5486_n N_noxref_21_c_6953_n ) capacitor c=0.0126473f \
 //x=36.95 //y=7.585 //x2=34.58 //y2=5.56
cc_3526 ( N_VDD_c_5549_n N_noxref_21_c_6953_n ) capacitor c=2.28864e-19 \
 //x=38.97 //y=7.58 //x2=34.58 //y2=5.56
cc_3527 ( N_VDD_c_5450_n N_noxref_21_c_6953_n ) capacitor c=0.0558076f \
 //x=33.79 //y=7.585 //x2=34.58 //y2=5.56
cc_3528 ( N_VDD_M56_noxref_d N_noxref_21_c_6953_n ) capacitor c=0.00262214f \
 //x=32.98 //y=5.2 //x2=34.58 //y2=5.56
cc_3529 ( N_VDD_M57_noxref_d N_noxref_21_c_6953_n ) capacitor c=0.0737268f \
 //x=34.875 //y=5.205 //x2=34.58 //y2=5.56
cc_3530 ( N_VDD_c_5479_n N_noxref_21_c_6957_n ) capacitor c=0.00211426f \
 //x=35.02 //y=7.035 //x2=35.46 //y2=5.56
cc_3531 ( N_VDD_c_5481_n N_noxref_21_c_6957_n ) capacitor c=4.62894e-19 \
 //x=35.02 //y=7.41 //x2=35.46 //y2=5.56
cc_3532 ( N_VDD_c_5539_n N_noxref_21_c_6957_n ) capacitor c=0.00205411f \
 //x=38.97 //y=7.58 //x2=35.46 //y2=5.56
cc_3533 ( N_VDD_c_5486_n N_noxref_21_c_6957_n ) capacitor c=0.0085453f \
 //x=36.95 //y=7.585 //x2=35.46 //y2=5.56
cc_3534 ( N_VDD_c_5549_n N_noxref_21_c_6957_n ) capacitor c=2.28864e-19 \
 //x=38.97 //y=7.58 //x2=35.46 //y2=5.56
cc_3535 ( N_VDD_M57_noxref_d N_noxref_21_c_6957_n ) capacitor c=0.0674082f \
 //x=34.875 //y=5.205 //x2=35.46 //y2=5.56
cc_3536 ( N_VDD_c_5104_n N_noxref_21_M57_noxref_s ) capacitor c=0.0245962f \
 //x=34.935 //y=7.585 //x2=34.445 //y2=5.205
cc_3537 ( N_VDD_c_5479_n N_noxref_21_M57_noxref_s ) capacitor c=0.0378001f \
 //x=35.02 //y=7.035 //x2=34.445 //y2=5.205
cc_3538 ( N_VDD_c_5481_n N_noxref_21_M57_noxref_s ) capacitor c=0.0124823f \
 //x=35.02 //y=7.41 //x2=34.445 //y2=5.205
cc_3539 ( N_VDD_c_5486_n N_noxref_21_M57_noxref_s ) capacitor c=0.00293047f \
 //x=36.95 //y=7.585 //x2=34.445 //y2=5.205
cc_3540 ( N_VDD_c_5450_n N_noxref_21_M57_noxref_s ) capacitor c=0.00933367f \
 //x=33.79 //y=7.585 //x2=34.445 //y2=5.205
cc_3541 ( N_VDD_M57_noxref_d N_noxref_21_M57_noxref_s ) capacitor \
 c=0.00566597f //x=34.875 //y=5.205 //x2=34.445 //y2=5.205
cc_3542 ( N_VDD_c_5539_n N_noxref_21_M60_noxref_d ) capacitor c=0.00206569f \
 //x=38.97 //y=7.58 //x2=36.195 //y2=5.205
cc_3543 ( N_VDD_c_5486_n N_noxref_21_M60_noxref_d ) capacitor c=0.00856914f \
 //x=36.95 //y=7.585 //x2=36.195 //y2=5.205
cc_3544 ( N_VDD_c_5549_n N_noxref_21_M60_noxref_d ) capacitor c=2.28864e-19 \
 //x=38.97 //y=7.58 //x2=36.195 //y2=5.205
cc_3545 ( N_VDD_c_5499_n N_noxref_21_M60_noxref_d ) capacitor c=0.0444839f \
 //x=37.12 //y=7.585 //x2=36.195 //y2=5.205
cc_3546 ( N_VDD_M61_noxref_s N_noxref_21_M60_noxref_d ) capacitor \
 c=0.00238698f //x=37.66 //y=5.2 //x2=36.195 //y2=5.205
cc_3547 ( N_VDD_c_5549_n COUT ) capacitor c=0.0297606f //x=38.97 //y=7.58 \
 //x2=38.6 //y2=2.4
cc_3548 ( N_VDD_c_5539_n N_COUT_c_7056_n ) capacitor c=0.00259721f //x=38.97 \
 //y=7.58 //x2=38.235 //y2=5.42
cc_3549 ( N_VDD_c_5546_n N_COUT_c_7056_n ) capacitor c=0.00100699f //x=38.59 \
 //y=7.585 //x2=38.235 //y2=5.42
cc_3550 ( N_VDD_c_5549_n N_COUT_c_7056_n ) capacitor c=0.00295945f //x=38.97 \
 //y=7.58 //x2=38.235 //y2=5.42
cc_3551 ( N_VDD_M61_noxref_s N_COUT_c_7056_n ) capacitor c=0.0467655f \
 //x=37.66 //y=5.2 //x2=38.235 //y2=5.42
cc_3552 ( N_VDD_M62_noxref_d N_COUT_c_7056_n ) capacitor c=0.0486749f \
 //x=38.53 //y=5.2 //x2=38.235 //y2=5.42
cc_3553 ( N_VDD_c_5539_n N_COUT_c_7063_n ) capacitor c=0.00199795f //x=38.97 \
 //y=7.58 //x2=38.515 //y2=5.14
cc_3554 ( N_VDD_c_5546_n N_COUT_c_7063_n ) capacitor c=0.00207379f //x=38.59 \
 //y=7.585 //x2=38.515 //y2=5.14
cc_3555 ( N_VDD_M62_noxref_d N_COUT_c_7063_n ) capacitor c=0.0235609f \
 //x=38.53 //y=5.2 //x2=38.515 //y2=5.14
cc_3556 ( N_VDD_c_5499_n N_COUT_c_7064_n ) capacitor c=0.00464635f //x=37.12 \
 //y=7.585 //x2=38.32 //y2=5.14
cc_3557 ( N_VDD_c_5539_n N_COUT_c_7075_n ) capacitor c=0.00241566f //x=38.97 \
 //y=7.58 //x2=38.235 //y2=5.56
cc_3558 ( N_VDD_c_5546_n N_COUT_c_7075_n ) capacitor c=0.0138017f //x=38.59 \
 //y=7.585 //x2=38.235 //y2=5.56
cc_3559 ( N_VDD_c_5549_n N_COUT_c_7075_n ) capacitor c=0.00825872f //x=38.97 \
 //y=7.58 //x2=38.235 //y2=5.56
cc_3560 ( N_VDD_c_5499_n N_COUT_c_7075_n ) capacitor c=0.00819834f //x=37.12 \
 //y=7.585 //x2=38.235 //y2=5.56
cc_3561 ( N_VDD_M61_noxref_s N_COUT_c_7075_n ) capacitor c=0.0898116f \
 //x=37.66 //y=5.2 //x2=38.235 //y2=5.56
cc_3562 ( N_VDD_M62_noxref_d N_COUT_c_7075_n ) capacitor c=0.0933215f \
 //x=38.53 //y=5.2 //x2=38.235 //y2=5.56
cc_3563 ( N_noxref_16_c_5812_n N_noxref_17_c_5889_n ) capacitor c=0.00119247f \
 //x=4.38 //y=5.385 //x2=6.83 //y2=5.385
cc_3564 ( N_noxref_16_c_5823_n N_noxref_17_c_5885_n ) capacitor c=5.03119e-19 \
 //x=5.26 //y=6.915 //x2=7.71 //y2=6.915
cc_3565 ( N_noxref_16_M26_noxref_d N_noxref_17_c_5901_n ) capacitor \
 c=0.00208849f //x=5.115 //y=5.2 //x2=6.83 //y2=5.555
cc_3566 ( N_noxref_16_c_5823_n N_noxref_17_M27_noxref_s ) capacitor \
 c=0.0112164f //x=5.26 //y=6.915 //x2=6.695 //y2=5.2
cc_3567 ( N_noxref_16_c_5802_n N_GND_c_6127_n ) capacitor c=2.79503e-19 \
 //x=4.26 //y=5.385 //x2=3.89 //y2=1.025
cc_3568 ( N_noxref_18_c_5962_n N_noxref_19_c_6043_n ) capacitor c=0.00106604f \
 //x=15.48 //y=5.385 //x2=17.93 //y2=5.385
cc_3569 ( N_noxref_18_c_5984_n N_noxref_19_c_6051_n ) capacitor c=5.03119e-19 \
 //x=16.36 //y=6.915 //x2=18.81 //y2=6.915
cc_3570 ( N_noxref_18_M38_noxref_d N_noxref_19_c_6077_n ) capacitor \
 c=0.00208849f //x=16.215 //y=5.2 //x2=17.93 //y2=5.555
cc_3571 ( N_noxref_18_c_5984_n N_noxref_19_M39_noxref_s ) capacitor \
 c=0.0112164f //x=16.36 //y=6.915 //x2=17.795 //y2=5.2
cc_3572 ( N_noxref_18_c_5963_n N_GND_c_6140_n ) capacitor c=2.66241e-19 \
 //x=15.36 //y=5.385 //x2=14.99 //y2=1.025
cc_3573 ( N_GND_c_6723_n N_COUT_c_7048_n ) capacitor c=0.00122336f //x=38.97 \
 //y=0.18 //x2=38.23 //y2=1.935
cc_3574 ( N_GND_c_6688_n N_COUT_c_7048_n ) capacitor c=0.00344631f //x=37.12 \
 //y=0.175 //x2=38.23 //y2=1.935
cc_3575 ( N_GND_M20_noxref_s N_COUT_c_7048_n ) capacitor c=0.0325324f \
 //x=37.615 //y=0.55 //x2=38.23 //y2=1.935
cc_3576 ( N_GND_c_6145_n N_COUT_c_7060_n ) capacitor c=0.00497604f //x=38.97 \
 //y=0.18 //x2=38.515 //y2=2.02
cc_3577 ( N_GND_c_6722_n N_COUT_c_7060_n ) capacitor c=0.00321695f //x=38.635 \
 //y=0.715 //x2=38.515 //y2=2.02
cc_3578 ( N_GND_c_6723_n N_COUT_c_7060_n ) capacitor c=0.030726f //x=38.97 \
 //y=0.18 //x2=38.515 //y2=2.02
cc_3579 ( N_GND_M20_noxref_s N_COUT_c_7060_n ) capacitor c=0.00565821f \
 //x=37.615 //y=0.55 //x2=38.515 //y2=2.02
cc_3580 ( N_GND_c_6145_n N_COUT_c_7067_n ) capacitor c=0.00998676f //x=38.97 \
 //y=0.18 //x2=38.23 //y2=1.185
cc_3581 ( N_GND_c_6718_n N_COUT_c_7067_n ) capacitor c=0.00124813f //x=38.145 \
 //y=0.715 //x2=38.23 //y2=1.185
cc_3582 ( N_GND_c_6722_n N_COUT_c_7067_n ) capacitor c=0.00130539f //x=38.635 \
 //y=0.715 //x2=38.23 //y2=1.185
cc_3583 ( N_GND_M20_noxref_s N_COUT_c_7067_n ) capacitor c=0.0156099f \
 //x=37.615 //y=0.55 //x2=38.23 //y2=1.185
cc_3584 ( N_GND_c_6145_n N_COUT_M20_noxref_d ) capacitor c=0.00119455f \
 //x=38.97 //y=0.18 //x2=38.045 //y2=1.09
cc_3585 ( N_GND_M20_noxref_s N_COUT_M20_noxref_d ) capacitor c=0.0377642f \
 //x=37.615 //y=0.55 //x2=38.045 //y2=1.09
cc_3586 ( N_GND_M0_noxref_s N_noxref_23_c_7114_n ) capacitor c=0.00297957f \
 //x=0.985 //y=0.55 //x2=3.405 //y2=1.68
cc_3587 ( N_GND_c_6122_n N_noxref_23_c_7115_n ) capacitor c=0.00248646f \
 //x=3.805 //y=0.175 //x2=4.29 //y2=1.765
cc_3588 ( N_GND_c_6127_n N_noxref_23_c_7115_n ) capacitor c=0.00319061f \
 //x=3.89 //y=1.025 //x2=4.29 //y2=1.765
cc_3589 ( N_GND_c_6137_n N_noxref_23_c_7115_n ) capacitor c=7.43272e-19 \
 //x=7.135 //y=0.175 //x2=4.29 //y2=1.765
cc_3590 ( N_GND_c_6155_n N_noxref_23_c_7115_n ) capacitor c=0.00377804f \
 //x=5.87 //y=0.175 //x2=4.29 //y2=1.765
cc_3591 ( N_GND_M1_noxref_d N_noxref_23_c_7115_n ) capacitor c=0.00578453f \
 //x=3.7 //y=1.05 //x2=4.29 //y2=1.765
cc_3592 ( N_GND_c_6127_n N_noxref_23_c_7154_n ) capacitor c=0.0120153f \
 //x=3.89 //y=1.025 //x2=4.375 //y2=0.8
cc_3593 ( N_GND_c_6137_n N_noxref_23_c_7154_n ) capacitor c=0.00445163f \
 //x=7.135 //y=0.175 //x2=4.375 //y2=0.8
cc_3594 ( N_GND_c_6155_n N_noxref_23_c_7154_n ) capacitor c=0.0143697f \
 //x=5.87 //y=0.175 //x2=4.375 //y2=0.8
cc_3595 ( N_GND_c_6166_n N_noxref_23_c_7154_n ) capacitor c=0.00282499f \
 //x=2.71 //y=0.175 //x2=4.375 //y2=0.8
cc_3596 ( N_GND_c_6173_n N_noxref_23_c_7154_n ) capacitor c=2.99356e-19 \
 //x=6.04 //y=0.175 //x2=4.375 //y2=0.8
cc_3597 ( N_GND_c_6166_n N_noxref_23_c_7123_n ) capacitor c=2.8481e-19 \
 //x=2.71 //y=0.175 //x2=4.375 //y2=1.68
cc_3598 ( N_GND_c_6137_n N_noxref_23_c_7125_n ) capacitor c=0.0122876f \
 //x=7.135 //y=0.175 //x2=5.26 //y2=0.715
cc_3599 ( N_GND_c_6155_n N_noxref_23_c_7125_n ) capacitor c=0.0370695f \
 //x=5.87 //y=0.175 //x2=5.26 //y2=0.715
cc_3600 ( N_GND_c_6723_n N_noxref_23_c_7125_n ) capacitor c=0.00195382f \
 //x=38.97 //y=0.18 //x2=5.26 //y2=0.715
cc_3601 ( N_GND_c_6137_n N_noxref_23_c_7163_n ) capacitor c=0.00234408f \
 //x=7.135 //y=0.175 //x2=5.345 //y2=0.8
cc_3602 ( N_GND_c_6155_n N_noxref_23_c_7163_n ) capacitor c=0.0141679f \
 //x=5.87 //y=0.175 //x2=5.345 //y2=0.8
cc_3603 ( N_GND_c_6173_n N_noxref_23_c_7163_n ) capacitor c=0.0392084f \
 //x=6.04 //y=0.175 //x2=5.345 //y2=0.8
cc_3604 ( N_GND_c_6122_n N_noxref_23_M1_noxref_s ) capacitor c=0.00717833f \
 //x=3.805 //y=0.175 //x2=3.27 //y2=0.55
cc_3605 ( N_GND_c_6127_n N_noxref_23_M1_noxref_s ) capacitor c=0.0262211f \
 //x=3.89 //y=1.025 //x2=3.27 //y2=0.55
cc_3606 ( N_GND_c_6804_p N_noxref_23_M1_noxref_s ) capacitor c=0.00297957f \
 //x=2.09 //y=0.63 //x2=3.27 //y2=0.55
cc_3607 ( N_GND_c_6155_n N_noxref_23_M1_noxref_s ) capacitor c=0.0143523f \
 //x=5.87 //y=0.175 //x2=3.27 //y2=0.55
cc_3608 ( N_GND_c_6166_n N_noxref_23_M1_noxref_s ) capacitor c=0.0528189f \
 //x=2.71 //y=0.175 //x2=3.27 //y2=0.55
cc_3609 ( N_GND_c_6173_n N_noxref_23_M1_noxref_s ) capacitor c=0.00645748f \
 //x=6.04 //y=0.175 //x2=3.27 //y2=0.55
cc_3610 ( N_GND_M1_noxref_d N_noxref_23_M1_noxref_s ) capacitor c=0.0271984f \
 //x=3.7 //y=1.05 //x2=3.27 //y2=0.55
cc_3611 ( N_GND_c_6137_n N_noxref_24_c_7177_n ) capacitor c=0.0011344f \
 //x=7.135 //y=0.175 //x2=7.62 //y2=1.765
cc_3612 ( N_GND_c_6138_n N_noxref_24_c_7177_n ) capacitor c=0.00300742f \
 //x=7.22 //y=1.025 //x2=7.62 //y2=1.765
cc_3613 ( N_GND_c_6139_n N_noxref_24_c_7177_n ) capacitor c=7.43272e-19 \
 //x=14.905 //y=0.175 //x2=7.62 //y2=1.765
cc_3614 ( N_GND_c_6248_n N_noxref_24_c_7177_n ) capacitor c=0.00398129f \
 //x=9.2 //y=0.175 //x2=7.62 //y2=1.765
cc_3615 ( N_GND_M3_noxref_d N_noxref_24_c_7177_n ) capacitor c=0.00578453f \
 //x=7.03 //y=1.05 //x2=7.62 //y2=1.765
cc_3616 ( N_GND_c_6138_n N_noxref_24_c_7217_n ) capacitor c=0.0167642f \
 //x=7.22 //y=1.025 //x2=7.705 //y2=0.8
cc_3617 ( N_GND_c_6139_n N_noxref_24_c_7217_n ) capacitor c=0.00445163f \
 //x=14.905 //y=0.175 //x2=7.705 //y2=0.8
cc_3618 ( N_GND_c_6248_n N_noxref_24_c_7217_n ) capacitor c=0.0143697f //x=9.2 \
 //y=0.175 //x2=7.705 //y2=0.8
cc_3619 ( N_GND_c_6173_n N_noxref_24_c_7217_n ) capacitor c=0.00282553f \
 //x=6.04 //y=0.175 //x2=7.705 //y2=0.8
cc_3620 ( N_GND_c_6175_n N_noxref_24_c_7217_n ) capacitor c=2.21767e-19 \
 //x=9.37 //y=0.175 //x2=7.705 //y2=0.8
cc_3621 ( N_GND_c_6173_n N_noxref_24_c_7178_n ) capacitor c=2.83682e-19 \
 //x=6.04 //y=0.175 //x2=7.705 //y2=1.68
cc_3622 ( N_GND_c_6139_n N_noxref_24_c_7179_n ) capacitor c=0.0115899f \
 //x=14.905 //y=0.175 //x2=8.59 //y2=0.715
cc_3623 ( N_GND_c_6248_n N_noxref_24_c_7179_n ) capacitor c=0.0370695f //x=9.2 \
 //y=0.175 //x2=8.59 //y2=0.715
cc_3624 ( N_GND_c_6723_n N_noxref_24_c_7179_n ) capacitor c=0.00195382f \
 //x=38.97 //y=0.18 //x2=8.59 //y2=0.715
cc_3625 ( N_GND_c_6139_n N_noxref_24_c_7226_n ) capacitor c=0.00251347f \
 //x=14.905 //y=0.175 //x2=8.675 //y2=0.8
cc_3626 ( N_GND_c_6248_n N_noxref_24_c_7226_n ) capacitor c=0.014204f //x=9.2 \
 //y=0.175 //x2=8.675 //y2=0.8
cc_3627 ( N_GND_c_6825_p N_noxref_24_c_7226_n ) capacitor c=0.00212205f \
 //x=9.99 //y=0.63 //x2=8.675 //y2=0.8
cc_3628 ( N_GND_c_6175_n N_noxref_24_c_7226_n ) capacitor c=0.0402f //x=9.37 \
 //y=0.175 //x2=8.675 //y2=0.8
cc_3629 ( N_GND_c_6137_n N_noxref_24_M3_noxref_s ) capacitor c=0.00445163f \
 //x=7.135 //y=0.175 //x2=6.6 //y2=0.55
cc_3630 ( N_GND_c_6138_n N_noxref_24_M3_noxref_s ) capacitor c=0.02175f \
 //x=7.22 //y=1.025 //x2=6.6 //y2=0.55
cc_3631 ( N_GND_c_6248_n N_noxref_24_M3_noxref_s ) capacitor c=0.0143697f \
 //x=9.2 //y=0.175 //x2=6.6 //y2=0.55
cc_3632 ( N_GND_c_6173_n N_noxref_24_M3_noxref_s ) capacitor c=0.0518398f \
 //x=6.04 //y=0.175 //x2=6.6 //y2=0.55
cc_3633 ( N_GND_c_6175_n N_noxref_24_M3_noxref_s ) capacitor c=0.00642631f \
 //x=9.37 //y=0.175 //x2=6.6 //y2=0.55
cc_3634 ( N_GND_M3_noxref_d N_noxref_24_M3_noxref_s ) capacitor c=0.0272028f \
 //x=7.03 //y=1.05 //x2=6.6 //y2=0.55
cc_3635 ( N_GND_M5_noxref_s N_noxref_24_M3_noxref_s ) capacitor c=0.0032083f \
 //x=9.865 //y=0.55 //x2=6.6 //y2=0.55
cc_3636 ( N_GND_M6_noxref_s N_noxref_25_c_7240_n ) capacitor c=0.00297957f \
 //x=12.085 //y=0.55 //x2=14.505 //y2=1.68
cc_3637 ( N_GND_c_6139_n N_noxref_25_c_7241_n ) capacitor c=9.97081e-19 \
 //x=14.905 //y=0.175 //x2=15.39 //y2=1.765
cc_3638 ( N_GND_c_6140_n N_noxref_25_c_7241_n ) capacitor c=0.00329826f \
 //x=14.99 //y=1.025 //x2=15.39 //y2=1.765
cc_3639 ( N_GND_c_6141_n N_noxref_25_c_7241_n ) capacitor c=7.43272e-19 \
 //x=18.235 //y=0.175 //x2=15.39 //y2=1.765
cc_3640 ( N_GND_c_6360_n N_noxref_25_c_7241_n ) capacitor c=0.0039751f \
 //x=16.97 //y=0.175 //x2=15.39 //y2=1.765
cc_3641 ( N_GND_M7_noxref_d N_noxref_25_c_7241_n ) capacitor c=0.00578453f \
 //x=14.8 //y=1.05 //x2=15.39 //y2=1.765
cc_3642 ( N_GND_c_6140_n N_noxref_25_c_7279_n ) capacitor c=0.0120153f \
 //x=14.99 //y=1.025 //x2=15.475 //y2=0.8
cc_3643 ( N_GND_c_6141_n N_noxref_25_c_7279_n ) capacitor c=0.00445163f \
 //x=18.235 //y=0.175 //x2=15.475 //y2=0.8
cc_3644 ( N_GND_c_6360_n N_noxref_25_c_7279_n ) capacitor c=0.0143697f \
 //x=16.97 //y=0.175 //x2=15.475 //y2=0.8
cc_3645 ( N_GND_c_6177_n N_noxref_25_c_7279_n ) capacitor c=0.00282499f \
 //x=13.81 //y=0.175 //x2=15.475 //y2=0.8
cc_3646 ( N_GND_c_6178_n N_noxref_25_c_7279_n ) capacitor c=2.99356e-19 \
 //x=17.14 //y=0.175 //x2=15.475 //y2=0.8
cc_3647 ( N_GND_c_6177_n N_noxref_25_c_7242_n ) capacitor c=2.8481e-19 \
 //x=13.81 //y=0.175 //x2=15.475 //y2=1.68
cc_3648 ( N_GND_c_6141_n N_noxref_25_c_7243_n ) capacitor c=0.0122876f \
 //x=18.235 //y=0.175 //x2=16.36 //y2=0.715
cc_3649 ( N_GND_c_6360_n N_noxref_25_c_7243_n ) capacitor c=0.0370695f \
 //x=16.97 //y=0.175 //x2=16.36 //y2=0.715
cc_3650 ( N_GND_c_6723_n N_noxref_25_c_7243_n ) capacitor c=0.00195382f \
 //x=38.97 //y=0.18 //x2=16.36 //y2=0.715
cc_3651 ( N_GND_c_6141_n N_noxref_25_c_7288_n ) capacitor c=0.00234408f \
 //x=18.235 //y=0.175 //x2=16.445 //y2=0.8
cc_3652 ( N_GND_c_6360_n N_noxref_25_c_7288_n ) capacitor c=0.0141679f \
 //x=16.97 //y=0.175 //x2=16.445 //y2=0.8
cc_3653 ( N_GND_c_6178_n N_noxref_25_c_7288_n ) capacitor c=0.0392084f \
 //x=17.14 //y=0.175 //x2=16.445 //y2=0.8
cc_3654 ( N_GND_c_6139_n N_noxref_25_M7_noxref_s ) capacitor c=0.00445163f \
 //x=14.905 //y=0.175 //x2=14.37 //y2=0.55
cc_3655 ( N_GND_c_6140_n N_noxref_25_M7_noxref_s ) capacitor c=0.0262211f \
 //x=14.99 //y=1.025 //x2=14.37 //y2=0.55
cc_3656 ( N_GND_c_6854_p N_noxref_25_M7_noxref_s ) capacitor c=0.00297957f \
 //x=13.19 //y=0.63 //x2=14.37 //y2=0.55
cc_3657 ( N_GND_c_6360_n N_noxref_25_M7_noxref_s ) capacitor c=0.0143697f \
 //x=16.97 //y=0.175 //x2=14.37 //y2=0.55
cc_3658 ( N_GND_c_6177_n N_noxref_25_M7_noxref_s ) capacitor c=0.0528189f \
 //x=13.81 //y=0.175 //x2=14.37 //y2=0.55
cc_3659 ( N_GND_c_6178_n N_noxref_25_M7_noxref_s ) capacitor c=0.00645748f \
 //x=17.14 //y=0.175 //x2=14.37 //y2=0.55
cc_3660 ( N_GND_M7_noxref_d N_noxref_25_M7_noxref_s ) capacitor c=0.0271984f \
 //x=14.8 //y=1.05 //x2=14.37 //y2=0.55
cc_3661 ( N_GND_c_6141_n N_noxref_26_c_7302_n ) capacitor c=0.0011344f \
 //x=18.235 //y=0.175 //x2=18.72 //y2=1.765
cc_3662 ( N_GND_c_6142_n N_noxref_26_c_7302_n ) capacitor c=0.00300742f \
 //x=18.32 //y=1.025 //x2=18.72 //y2=1.765
cc_3663 ( N_GND_c_6143_n N_noxref_26_c_7302_n ) capacitor c=7.43272e-19 \
 //x=23.785 //y=0.175 //x2=18.72 //y2=1.765
cc_3664 ( N_GND_c_6450_n N_noxref_26_c_7302_n ) capacitor c=0.00398129f \
 //x=20.3 //y=0.175 //x2=18.72 //y2=1.765
cc_3665 ( N_GND_M9_noxref_d N_noxref_26_c_7302_n ) capacitor c=0.00578453f \
 //x=18.13 //y=1.05 //x2=18.72 //y2=1.765
cc_3666 ( N_GND_c_6142_n N_noxref_26_c_7342_n ) capacitor c=0.0167642f \
 //x=18.32 //y=1.025 //x2=18.805 //y2=0.8
cc_3667 ( N_GND_c_6143_n N_noxref_26_c_7342_n ) capacitor c=0.00445163f \
 //x=23.785 //y=0.175 //x2=18.805 //y2=0.8
cc_3668 ( N_GND_c_6450_n N_noxref_26_c_7342_n ) capacitor c=0.0143697f \
 //x=20.3 //y=0.175 //x2=18.805 //y2=0.8
cc_3669 ( N_GND_c_6178_n N_noxref_26_c_7342_n ) capacitor c=0.00282553f \
 //x=17.14 //y=0.175 //x2=18.805 //y2=0.8
cc_3670 ( N_GND_c_6179_n N_noxref_26_c_7342_n ) capacitor c=2.21767e-19 \
 //x=20.47 //y=0.175 //x2=18.805 //y2=0.8
cc_3671 ( N_GND_c_6178_n N_noxref_26_c_7303_n ) capacitor c=2.83682e-19 \
 //x=17.14 //y=0.175 //x2=18.805 //y2=1.68
cc_3672 ( N_GND_c_6143_n N_noxref_26_c_7304_n ) capacitor c=0.0115899f \
 //x=23.785 //y=0.175 //x2=19.69 //y2=0.715
cc_3673 ( N_GND_c_6450_n N_noxref_26_c_7304_n ) capacitor c=0.0369908f \
 //x=20.3 //y=0.175 //x2=19.69 //y2=0.715
cc_3674 ( N_GND_c_6723_n N_noxref_26_c_7304_n ) capacitor c=0.00195382f \
 //x=38.97 //y=0.18 //x2=19.69 //y2=0.715
cc_3675 ( N_GND_c_6143_n N_noxref_26_c_7351_n ) capacitor c=0.00251347f \
 //x=23.785 //y=0.175 //x2=19.775 //y2=0.8
cc_3676 ( N_GND_c_6450_n N_noxref_26_c_7351_n ) capacitor c=0.014204f //x=20.3 \
 //y=0.175 //x2=19.775 //y2=0.8
cc_3677 ( N_GND_c_6875_p N_noxref_26_c_7351_n ) capacitor c=0.00212205f \
 //x=21.09 //y=0.63 //x2=19.775 //y2=0.8
cc_3678 ( N_GND_c_6179_n N_noxref_26_c_7351_n ) capacitor c=0.0402f //x=20.47 \
 //y=0.175 //x2=19.775 //y2=0.8
cc_3679 ( N_GND_c_6141_n N_noxref_26_M9_noxref_s ) capacitor c=0.00445163f \
 //x=18.235 //y=0.175 //x2=17.7 //y2=0.55
cc_3680 ( N_GND_c_6142_n N_noxref_26_M9_noxref_s ) capacitor c=0.02175f \
 //x=18.32 //y=1.025 //x2=17.7 //y2=0.55
cc_3681 ( N_GND_c_6450_n N_noxref_26_M9_noxref_s ) capacitor c=0.0143697f \
 //x=20.3 //y=0.175 //x2=17.7 //y2=0.55
cc_3682 ( N_GND_c_6178_n N_noxref_26_M9_noxref_s ) capacitor c=0.0518398f \
 //x=17.14 //y=0.175 //x2=17.7 //y2=0.55
cc_3683 ( N_GND_c_6179_n N_noxref_26_M9_noxref_s ) capacitor c=0.00642631f \
 //x=20.47 //y=0.175 //x2=17.7 //y2=0.55
cc_3684 ( N_GND_M9_noxref_d N_noxref_26_M9_noxref_s ) capacitor c=0.0272028f \
 //x=18.13 //y=1.05 //x2=17.7 //y2=0.55
cc_3685 ( N_GND_M11_noxref_s N_noxref_26_M9_noxref_s ) capacitor c=0.0032083f \
 //x=20.965 //y=0.55 //x2=17.7 //y2=0.55
cc_3686 ( N_GND_M11_noxref_s N_noxref_27_c_7365_n ) capacitor c=0.00294525f \
 //x=20.965 //y=0.55 //x2=23.385 //y2=1.675
cc_3687 ( N_GND_c_6143_n N_noxref_27_c_7366_n ) capacitor c=0.0010065f \
 //x=23.785 //y=0.175 //x2=24.27 //y2=1.76
cc_3688 ( N_GND_c_6144_n N_noxref_27_c_7366_n ) capacitor c=7.45647e-19 \
 //x=29.335 //y=0.175 //x2=24.27 //y2=1.76
cc_3689 ( N_GND_c_6148_n N_noxref_27_c_7366_n ) capacitor c=0.00405057f \
 //x=23.87 //y=1.135 //x2=24.27 //y2=1.76
cc_3690 ( N_GND_c_6361_n N_noxref_27_c_7366_n ) capacitor c=0.00395681f \
 //x=25.85 //y=0.175 //x2=24.27 //y2=1.76
cc_3691 ( N_GND_M12_noxref_d N_noxref_27_c_7366_n ) capacitor c=0.00578453f \
 //x=23.68 //y=1.045 //x2=24.27 //y2=1.76
cc_3692 ( N_GND_c_6144_n N_noxref_27_c_7409_n ) capacitor c=0.00376192f \
 //x=29.335 //y=0.175 //x2=24.355 //y2=0.795
cc_3693 ( N_GND_c_6511_n N_noxref_27_c_7409_n ) capacitor c=0.0167642f \
 //x=23.867 //y=1.005 //x2=24.355 //y2=0.795
cc_3694 ( N_GND_c_6361_n N_noxref_27_c_7409_n ) capacitor c=0.0144005f \
 //x=25.85 //y=0.175 //x2=24.355 //y2=0.795
cc_3695 ( N_GND_c_6180_n N_noxref_27_c_7409_n ) capacitor c=0.00282499f \
 //x=22.69 //y=0.175 //x2=24.355 //y2=0.795
cc_3696 ( N_GND_c_6181_n N_noxref_27_c_7409_n ) capacitor c=2.21767e-19 \
 //x=26.02 //y=0.175 //x2=24.355 //y2=0.795
cc_3697 ( N_GND_c_6180_n N_noxref_27_c_7367_n ) capacitor c=2.84609e-19 \
 //x=22.69 //y=0.175 //x2=24.355 //y2=1.675
cc_3698 ( N_GND_c_6144_n N_noxref_27_c_7368_n ) capacitor c=0.00987346f \
 //x=29.335 //y=0.175 //x2=25.24 //y2=0.71
cc_3699 ( N_GND_c_6361_n N_noxref_27_c_7368_n ) capacitor c=0.0374802f \
 //x=25.85 //y=0.175 //x2=25.24 //y2=0.71
cc_3700 ( N_GND_c_6723_n N_noxref_27_c_7368_n ) capacitor c=0.00199999f \
 //x=38.97 //y=0.18 //x2=25.24 //y2=0.71
cc_3701 ( N_GND_c_6144_n N_noxref_27_c_7418_n ) capacitor c=0.00250904f \
 //x=29.335 //y=0.175 //x2=25.325 //y2=0.795
cc_3702 ( N_GND_c_6361_n N_noxref_27_c_7418_n ) capacitor c=0.0145073f \
 //x=25.85 //y=0.175 //x2=25.325 //y2=0.795
cc_3703 ( N_GND_c_6901_p N_noxref_27_c_7418_n ) capacitor c=0.00209572f \
 //x=26.65 //y=0.63 //x2=25.325 //y2=0.795
cc_3704 ( N_GND_c_6181_n N_noxref_27_c_7418_n ) capacitor c=0.0402083f \
 //x=26.02 //y=0.175 //x2=25.325 //y2=0.795
cc_3705 ( N_GND_c_6143_n N_noxref_27_M12_noxref_s ) capacitor c=0.0045077f \
 //x=23.785 //y=0.175 //x2=23.25 //y2=0.545
cc_3706 ( N_GND_c_6148_n N_noxref_27_M12_noxref_s ) capacitor c=0.0100498f \
 //x=23.87 //y=1.135 //x2=23.25 //y2=0.545
cc_3707 ( N_GND_c_6511_n N_noxref_27_M12_noxref_s ) capacitor c=0.0173062f \
 //x=23.867 //y=1.005 //x2=23.25 //y2=0.545
cc_3708 ( N_GND_c_6906_p N_noxref_27_M12_noxref_s ) capacitor c=0.00294525f \
 //x=22.06 //y=0.63 //x2=23.25 //y2=0.545
cc_3709 ( N_GND_c_6361_n N_noxref_27_M12_noxref_s ) capacitor c=0.0146766f \
 //x=25.85 //y=0.175 //x2=23.25 //y2=0.545
cc_3710 ( N_GND_c_6180_n N_noxref_27_M12_noxref_s ) capacitor c=0.0528146f \
 //x=22.69 //y=0.175 //x2=23.25 //y2=0.545
cc_3711 ( N_GND_c_6181_n N_noxref_27_M12_noxref_s ) capacitor c=0.00642652f \
 //x=26.02 //y=0.175 //x2=23.25 //y2=0.545
cc_3712 ( N_GND_M12_noxref_d N_noxref_27_M12_noxref_s ) capacitor c=0.0271276f \
 //x=23.68 //y=1.045 //x2=23.25 //y2=0.545
cc_3713 ( N_GND_M14_noxref_s N_noxref_27_M12_noxref_s ) capacitor c=0.0031675f \
 //x=26.515 //y=0.55 //x2=23.25 //y2=0.545
cc_3714 ( N_GND_M14_noxref_s N_noxref_28_c_7431_n ) capacitor c=0.0029758f \
 //x=26.515 //y=0.55 //x2=28.935 //y2=1.675
cc_3715 ( N_GND_c_6144_n N_noxref_28_c_7432_n ) capacitor c=0.0011359f \
 //x=29.335 //y=0.175 //x2=29.82 //y2=1.76
cc_3716 ( N_GND_c_6145_n N_noxref_28_c_7432_n ) capacitor c=0.00200937f \
 //x=38.97 //y=0.18 //x2=29.82 //y2=1.76
cc_3717 ( N_GND_c_6149_n N_noxref_28_c_7432_n ) capacitor c=0.00405799f \
 //x=29.42 //y=1.135 //x2=29.82 //y2=1.76
cc_3718 ( N_GND_c_6160_n N_noxref_28_c_7432_n ) capacitor c=0.00389895f \
 //x=31.4 //y=0.175 //x2=29.82 //y2=1.76
cc_3719 ( N_GND_M15_noxref_d N_noxref_28_c_7432_n ) capacitor c=0.00578453f \
 //x=29.23 //y=1.045 //x2=29.82 //y2=1.76
cc_3720 ( N_GND_c_6145_n N_noxref_28_c_7475_n ) capacitor c=0.00380507f \
 //x=38.97 //y=0.18 //x2=29.905 //y2=0.795
cc_3721 ( N_GND_c_6286_n N_noxref_28_c_7475_n ) capacitor c=0.0167642f \
 //x=29.417 //y=1.005 //x2=29.905 //y2=0.795
cc_3722 ( N_GND_c_6160_n N_noxref_28_c_7475_n ) capacitor c=0.0146693f \
 //x=31.4 //y=0.175 //x2=29.905 //y2=0.795
cc_3723 ( N_GND_c_6182_n N_noxref_28_c_7475_n ) capacitor c=0.00282499f \
 //x=28.24 //y=0.175 //x2=29.905 //y2=0.795
cc_3724 ( N_GND_c_6183_n N_noxref_28_c_7475_n ) capacitor c=2.21767e-19 \
 //x=31.57 //y=0.175 //x2=29.905 //y2=0.795
cc_3725 ( N_GND_c_6182_n N_noxref_28_c_7433_n ) capacitor c=2.84609e-19 \
 //x=28.24 //y=0.175 //x2=29.905 //y2=1.675
cc_3726 ( N_GND_c_6145_n N_noxref_28_c_7437_n ) capacitor c=0.00981538f \
 //x=38.97 //y=0.18 //x2=30.79 //y2=0.71
cc_3727 ( N_GND_c_6160_n N_noxref_28_c_7437_n ) capacitor c=0.0374802f \
 //x=31.4 //y=0.175 //x2=30.79 //y2=0.71
cc_3728 ( N_GND_c_6723_n N_noxref_28_c_7437_n ) capacitor c=0.00199999f \
 //x=38.97 //y=0.18 //x2=30.79 //y2=0.71
cc_3729 ( N_GND_c_6145_n N_noxref_28_c_7484_n ) capacitor c=0.00250904f \
 //x=38.97 //y=0.18 //x2=30.875 //y2=0.795
cc_3730 ( N_GND_c_6160_n N_noxref_28_c_7484_n ) capacitor c=0.0145784f \
 //x=31.4 //y=0.175 //x2=30.875 //y2=0.795
cc_3731 ( N_GND_c_6929_p N_noxref_28_c_7484_n ) capacitor c=0.00209572f \
 //x=32.2 //y=0.63 //x2=30.875 //y2=0.795
cc_3732 ( N_GND_c_6183_n N_noxref_28_c_7484_n ) capacitor c=0.0402083f \
 //x=31.57 //y=0.175 //x2=30.875 //y2=0.795
cc_3733 ( N_GND_c_6144_n N_noxref_28_M15_noxref_s ) capacitor c=0.0045077f \
 //x=29.335 //y=0.175 //x2=28.8 //y2=0.545
cc_3734 ( N_GND_c_6149_n N_noxref_28_M15_noxref_s ) capacitor c=0.0100435f \
 //x=29.42 //y=1.135 //x2=28.8 //y2=0.545
cc_3735 ( N_GND_c_6286_n N_noxref_28_M15_noxref_s ) capacitor c=0.0173062f \
 //x=29.417 //y=1.005 //x2=28.8 //y2=0.545
cc_3736 ( N_GND_c_6934_p N_noxref_28_M15_noxref_s ) capacitor c=0.0029758f \
 //x=27.62 //y=0.63 //x2=28.8 //y2=0.545
cc_3737 ( N_GND_c_6160_n N_noxref_28_M15_noxref_s ) capacitor c=0.0146766f \
 //x=31.4 //y=0.175 //x2=28.8 //y2=0.545
cc_3738 ( N_GND_c_6182_n N_noxref_28_M15_noxref_s ) capacitor c=0.0528146f \
 //x=28.24 //y=0.175 //x2=28.8 //y2=0.545
cc_3739 ( N_GND_c_6183_n N_noxref_28_M15_noxref_s ) capacitor c=0.00642652f \
 //x=31.57 //y=0.175 //x2=28.8 //y2=0.545
cc_3740 ( N_GND_M15_noxref_d N_noxref_28_M15_noxref_s ) capacitor c=0.0271276f \
 //x=29.23 //y=1.045 //x2=28.8 //y2=0.545
cc_3741 ( N_GND_M17_noxref_s N_noxref_28_M15_noxref_s ) capacitor c=0.0031675f \
 //x=32.065 //y=0.55 //x2=28.8 //y2=0.545
cc_3742 ( N_noxref_21_c_6951_n N_COUT_c_7056_n ) capacitor c=3.69557e-19 \
 //x=35.46 //y=5.39 //x2=38.235 //y2=5.42
cc_3743 ( N_noxref_23_c_7123_n N_noxref_24_c_7176_n ) capacitor c=5.32163e-19 \
 //x=4.375 //y=1.68 //x2=6.735 //y2=1.68
cc_3744 ( N_noxref_23_c_7163_n N_noxref_24_M3_noxref_s ) capacitor \
 c=0.00453341f //x=5.345 //y=0.8 //x2=6.6 //y2=0.55
cc_3745 ( N_noxref_23_M1_noxref_s N_noxref_24_M3_noxref_s ) capacitor \
 c=5.32163e-19 //x=3.27 //y=0.55 //x2=6.6 //y2=0.55
cc_3746 ( N_noxref_25_c_7242_n N_noxref_26_c_7301_n ) capacitor c=5.32163e-19 \
 //x=15.475 //y=1.68 //x2=17.835 //y2=1.68
cc_3747 ( N_noxref_25_c_7288_n N_noxref_26_M9_noxref_s ) capacitor \
 c=0.00453341f //x=16.445 //y=0.8 //x2=17.7 //y2=0.55
cc_3748 ( N_noxref_25_M7_noxref_s N_noxref_26_M9_noxref_s ) capacitor \
 c=5.32163e-19 //x=14.37 //y=0.55 //x2=17.7 //y2=0.55
