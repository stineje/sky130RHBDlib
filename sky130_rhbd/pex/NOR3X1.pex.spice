// File: NOR3X1.spi.pex
// Created: Fri Feb 20 10:14:10 2026
// Program "Calibre xRC"
// Version "v2023.2_27.15"
// Nominal Temperature: 30C
// Circuit Temperature: 30C
//
simulator lang=spectre
subckt PM_NOR3X1\%GND ( 1 11 25 39 53 66 70 82 )
c72 ( 82 0 ) capacitor c=0.102521f //x=1.05 //y=0.545
c73 ( 79 0 ) capacitor c=0.00597439f //x=4.095 //y=0.175
c74 ( 76 0 ) capacitor c=0.00597439f //x=3.125 //y=0.175
c75 ( 73 0 ) capacitor c=0.00597439f //x=2.155 //y=0.175
c76 ( 70 0 ) capacitor c=0.229132f //x=1.23 //y=0.18
c77 ( 66 0 ) capacitor c=0.272476f //x=4.56 //y=0.18
c78 ( 58 0 ) capacitor c=0.00932713f //x=4.095 //y=0.625
c79 ( 53 0 ) capacitor c=0.0149942f //x=4.01 //y=0.71
c80 ( 49 0 ) capacitor c=0.0258125f //x=4.01 //y=0.175
c81 ( 44 0 ) capacitor c=0.00726869f //x=3.125 //y=0.625
c82 ( 39 0 ) capacitor c=0.016156f //x=3.04 //y=0.71
c83 ( 35 0 ) capacitor c=0.0258125f //x=3.04 //y=0.175
c84 ( 30 0 ) capacitor c=0.00726869f //x=2.155 //y=0.625
c85 ( 25 0 ) capacitor c=0.0170849f //x=2.07 //y=0.71
c86 ( 23 0 ) capacitor c=0.0257966f //x=2.07 //y=0.175
c87 ( 18 0 ) capacitor c=0.00739123f //x=1.185 //y=0.625
c88 ( 11 0 ) capacitor c=0.23355f //x=4.56 //y=0.18
r89 (  64 79 ) resistor r=2.87058 //w=0.35 //l=0.085 //layer=li \
 //thickness=0.1 //x=4.18 //y=0.175 //x2=4.095 //y2=0.175
r90 (  64 66 ) resistor r=13.2534 //w=0.367 //l=0.38 //layer=li \
 //thickness=0.1 //x=4.18 //y=0.175 //x2=4.56 //y2=0.175
r91 (  59 82 ) resistor r=5.4201 //w=0.17 //l=0.085 //layer=li //thickness=0.1 \
 //x=4.095 //y=0.795 //x2=4.095 //y2=0.71
r92 (  59 82 ) resistor r=18.139 //w=0.187 //l=0.265 //layer=li \
 //thickness=0.1 //x=4.095 //y=0.795 //x2=4.095 //y2=1.06
r93 (  58 82 ) resistor r=5.4201 //w=0.17 //l=0.085 //layer=li //thickness=0.1 \
 //x=4.095 //y=0.625 //x2=4.095 //y2=0.71
r94 (  57 79 ) resistor r=4.23183 //w=0.7 //l=0.175 //layer=li //thickness=0.1 \
 //x=4.095 //y=0.35 //x2=4.095 //y2=0.175
r95 (  57 58 ) resistor r=18.8235 //w=0.187 //l=0.275 //layer=li \
 //thickness=0.1 //x=4.095 //y=0.35 //x2=4.095 //y2=0.625
r96 (  54 82 ) resistor r=6.4 //w=0.17 //l=0.085 //layer=li //thickness=0.1 \
 //x=3.21 //y=0.71 //x2=3.125 //y2=0.71
r97 (  54 82 ) resistor r=27.3797 //w=0.187 //l=0.4 //layer=li //thickness=0.1 \
 //x=3.21 //y=0.71 //x2=3.61 //y2=0.71
r98 (  53 82 ) resistor r=1.40859 //w=0.34 //l=0.085 //layer=li \
 //thickness=0.1 //x=4.01 //y=0.71 //x2=4.095 //y2=0.71
r99 (  53 82 ) resistor r=27.3797 //w=0.187 //l=0.4 //layer=li //thickness=0.1 \
 //x=4.01 //y=0.71 //x2=3.61 //y2=0.71
r100 (  50 76 ) resistor r=2.87058 //w=0.35 //l=0.085 //layer=li \
 //thickness=0.1 //x=3.21 //y=0.175 //x2=3.125 //y2=0.175
r101 (  50 52 ) resistor r=8.37057 //w=0.367 //l=0.24 //layer=li \
 //thickness=0.1 //x=3.21 //y=0.175 //x2=3.45 //y2=0.175
r102 (  49 79 ) resistor r=2.87058 //w=0.35 //l=0.085 //layer=li \
 //thickness=0.1 //x=4.01 //y=0.175 //x2=4.095 //y2=0.175
r103 (  49 52 ) resistor r=19.5313 //w=0.367 //l=0.56 //layer=li \
 //thickness=0.1 //x=4.01 //y=0.175 //x2=3.45 //y2=0.175
r104 (  45 82 ) resistor r=6.4 //w=0.17 //l=0.085 //layer=li //thickness=0.1 \
 //x=3.125 //y=0.795 //x2=3.125 //y2=0.71
r105 (  45 82 ) resistor r=18.139 //w=0.187 //l=0.265 //layer=li \
 //thickness=0.1 //x=3.125 //y=0.795 //x2=3.125 //y2=1.06
r106 (  44 82 ) resistor r=6.4 //w=0.17 //l=0.085 //layer=li //thickness=0.1 \
 //x=3.125 //y=0.625 //x2=3.125 //y2=0.71
r107 (  43 76 ) resistor r=4.23183 //w=0.7 //l=0.175 //layer=li \
 //thickness=0.1 //x=3.125 //y=0.35 //x2=3.125 //y2=0.175
r108 (  43 44 ) resistor r=18.8235 //w=0.187 //l=0.275 //layer=li \
 //thickness=0.1 //x=3.125 //y=0.35 //x2=3.125 //y2=0.625
r109 (  40 82 ) resistor r=6.4 //w=0.17 //l=0.085 //layer=li //thickness=0.1 \
 //x=2.24 //y=0.71 //x2=2.155 //y2=0.71
r110 (  40 82 ) resistor r=27.3797 //w=0.187 //l=0.4 //layer=li \
 //thickness=0.1 //x=2.24 //y=0.71 //x2=2.64 //y2=0.71
r111 (  39 82 ) resistor r=6.4 //w=0.17 //l=0.085 //layer=li //thickness=0.1 \
 //x=3.04 //y=0.71 //x2=3.125 //y2=0.71
r112 (  39 82 ) resistor r=27.3797 //w=0.187 //l=0.4 //layer=li \
 //thickness=0.1 //x=3.04 //y=0.71 //x2=2.64 //y2=0.71
r113 (  36 73 ) resistor r=2.87058 //w=0.35 //l=0.085 //layer=li \
 //thickness=0.1 //x=2.24 //y=0.175 //x2=2.155 //y2=0.175
r114 (  36 38 ) resistor r=3.48774 //w=0.367 //l=0.1 //layer=li \
 //thickness=0.1 //x=2.24 //y=0.175 //x2=2.34 //y2=0.175
r115 (  35 76 ) resistor r=2.87058 //w=0.35 //l=0.085 //layer=li \
 //thickness=0.1 //x=3.04 //y=0.175 //x2=3.125 //y2=0.175
r116 (  35 38 ) resistor r=24.4142 //w=0.367 //l=0.7 //layer=li \
 //thickness=0.1 //x=3.04 //y=0.175 //x2=2.34 //y2=0.175
r117 (  31 82 ) resistor r=6.4 //w=0.17 //l=0.085 //layer=li //thickness=0.1 \
 //x=2.155 //y=0.795 //x2=2.155 //y2=0.71
r118 (  31 82 ) resistor r=18.139 //w=0.187 //l=0.265 //layer=li \
 //thickness=0.1 //x=2.155 //y=0.795 //x2=2.155 //y2=1.06
r119 (  30 82 ) resistor r=6.4 //w=0.17 //l=0.085 //layer=li //thickness=0.1 \
 //x=2.155 //y=0.625 //x2=2.155 //y2=0.71
r120 (  29 73 ) resistor r=4.23183 //w=0.7 //l=0.175 //layer=li \
 //thickness=0.1 //x=2.155 //y=0.35 //x2=2.155 //y2=0.175
r121 (  29 30 ) resistor r=18.8235 //w=0.187 //l=0.275 //layer=li \
 //thickness=0.1 //x=2.155 //y=0.35 //x2=2.155 //y2=0.625
r122 (  26 82 ) resistor r=1.40859 //w=0.34 //l=0.085 //layer=li \
 //thickness=0.1 //x=1.27 //y=0.71 //x2=1.185 //y2=0.71
r123 (  26 82 ) resistor r=27.3797 //w=0.187 //l=0.4 //layer=li \
 //thickness=0.1 //x=1.27 //y=0.71 //x2=1.67 //y2=0.71
r124 (  25 82 ) resistor r=6.4 //w=0.17 //l=0.085 //layer=li //thickness=0.1 \
 //x=2.07 //y=0.71 //x2=2.155 //y2=0.71
r125 (  25 82 ) resistor r=27.3797 //w=0.187 //l=0.4 //layer=li \
 //thickness=0.1 //x=2.07 //y=0.71 //x2=1.67 //y2=0.71
r126 (  24 70 ) resistor r=2.87058 //w=0.35 //l=0.085 //layer=li \
 //thickness=0.1 //x=1.27 //y=0.175 //x2=1.185 //y2=0.175
r127 (  23 73 ) resistor r=2.87058 //w=0.35 //l=0.085 //layer=li \
 //thickness=0.1 //x=2.07 //y=0.175 //x2=2.155 //y2=0.175
r128 (  23 24 ) resistor r=27.9019 //w=0.367 //l=0.8 //layer=li \
 //thickness=0.1 //x=2.07 //y=0.175 //x2=1.27 //y2=0.175
r129 (  19 82 ) resistor r=5.4201 //w=0.17 //l=0.085 //layer=li \
 //thickness=0.1 //x=1.185 //y=0.795 //x2=1.185 //y2=0.71
r130 (  19 82 ) resistor r=41.4118 //w=0.187 //l=0.605 //layer=li \
 //thickness=0.1 //x=1.185 //y=0.795 //x2=1.185 //y2=1.4
r131 (  18 82 ) resistor r=5.4201 //w=0.17 //l=0.085 //layer=li \
 //thickness=0.1 //x=1.185 //y=0.625 //x2=1.185 //y2=0.71
r132 (  17 70 ) resistor r=4.23183 //w=0.7 //l=0.175 //layer=li \
 //thickness=0.1 //x=1.185 //y=0.35 //x2=1.185 //y2=0.175
r133 (  17 18 ) resistor r=18.8235 //w=0.187 //l=0.275 //layer=li \
 //thickness=0.1 //x=1.185 //y=0.35 //x2=1.185 //y2=0.625
r134 (  11 66 ) resistor r=3.1 //w=0.17 //l=0.51 //layer=mcon //count=3 \
 //x=4.56 //y=0.18 //x2=4.56 //y2=0.18
r135 (  9 52 ) resistor r=3.1 //w=0.17 //l=0.51 //layer=mcon //count=3 \
 //x=3.45 //y=0.18 //x2=3.45 //y2=0.18
r136 (  9 11 ) resistor r=0.446141 //w=0.311 //l=1.11 //layer=m1 \
 //thickness=0.36 //x=3.45 //y=0.175 //x2=4.56 //y2=0.175
r137 (  6 38 ) resistor r=3.1 //w=0.17 //l=0.51 //layer=mcon //count=3 \
 //x=2.34 //y=0.18 //x2=2.34 //y2=0.18
r138 (  3 70 ) resistor r=3.1 //w=0.17 //l=0.51 //layer=mcon //count=3 \
 //x=1.23 //y=0.18 //x2=1.23 //y2=0.18
r139 (  3 6 ) resistor r=0.446141 //w=0.311 //l=1.11 //layer=m1 \
 //thickness=0.36 //x=1.23 //y=0.175 //x2=2.34 //y2=0.175
r140 (  1 9 ) resistor r=0.223071 //w=0.311 //l=0.555 //layer=m1 \
 //thickness=0.36 //x=2.895 //y=0.175 //x2=3.45 //y2=0.175
r141 (  1 6 ) resistor r=0.223071 //w=0.311 //l=0.555 //layer=m1 \
 //thickness=0.36 //x=2.895 //y=0.175 //x2=2.34 //y2=0.175
ends PM_NOR3X1\%GND

subckt PM_NOR3X1\%noxref_2 ( 1 3 5 10 14 17 20 30 46 47 48 )
c90 ( 48 0 ) capacitor c=0.0253852f //x=2.895 //y=5.205
c91 ( 46 0 ) capacitor c=0.0115693f //x=1.145 //y=5.205
c92 ( 30 0 ) capacitor c=0.0302586f //x=2.16 //y=5.56
c93 ( 20 0 ) capacitor c=0.0435973f //x=1.28 //y=5.56
c94 ( 17 0 ) capacitor c=0.00775965f //x=3.04 //y=6.92
c95 ( 14 0 ) capacitor c=0.00599877f //x=2.16 //y=6.92
c96 ( 10 0 ) capacitor c=0.0105983f //x=2.162 //y=5.39
c97 ( 5 0 ) capacitor c=0.0183603f //x=1.282 //y=5.39
c98 ( 3 0 ) capacitor c=0.00728543f //x=2.925 //y=7.09
c99 ( 1 0 ) capacitor c=0.0133332f //x=2.045 //y=5.39
r100 (  37 47 ) resistor r=23.2727 //w=0.187 //l=0.34 //layer=li \
 //thickness=0.1 //x=2.16 //y=6.92 //x2=2.16 //y2=6.58
r101 (  30 47 ) resistor r=23.2727 //w=0.187 //l=0.34 //layer=li \
 //thickness=0.1 //x=2.16 //y=5.56 //x2=2.16 //y2=5.9
r102 (  20 46 ) resistor r=23.2727 //w=0.187 //l=0.34 //layer=li \
 //thickness=0.1 //x=1.28 //y=5.56 //x2=1.28 //y2=5.9
r103 (  17 48 ) resistor r=9.3 //w=0.17 //l=0.17 //layer=mcon //count=1 \
 //x=3.04 //y=6.92 //x2=3.04 //y2=6.92
r104 (  17 18 ) resistor r=0.0983796 //w=0.216 //l=0.17 //layer=m1 \
 //thickness=0.36 //x=3.042 //y=6.92 //x2=3.042 //y2=7.09
r105 (  14 37 ) resistor r=9.3 //w=0.17 //l=0.17 //layer=mcon //count=1 \
 //x=2.16 //y=6.92 //x2=2.16 //y2=6.92
r106 (  14 15 ) resistor r=0.0979263 //w=0.217 //l=0.17 //layer=m1 \
 //thickness=0.36 //x=2.162 //y=6.92 //x2=2.162 //y2=7.09
r107 (  12 30 ) resistor r=9.3 //w=0.17 //l=0.17 //layer=mcon //count=1 \
 //x=2.16 //y=5.56 //x2=2.16 //y2=5.56
r108 (  10 12 ) resistor r=0.0983796 //w=0.216 //l=0.17 //layer=m1 \
 //thickness=0.36 //x=2.162 //y=5.39 //x2=2.162 //y2=5.56
r109 (  7 20 ) resistor r=9.3 //w=0.17 //l=0.17 //layer=mcon //count=1 \
 //x=1.28 //y=5.56 //x2=1.28 //y2=5.56
r110 (  5 7 ) resistor r=0.0940266 //w=0.226 //l=0.17 //layer=m1 \
 //thickness=0.36 //x=1.282 //y=5.39 //x2=1.282 //y2=5.56
r111 (  4 15 ) resistor r=0.0222262 //w=0.217 //l=0.118 //layer=m1 \
 //thickness=0.36 //x=2.28 //y=7.09 //x2=2.162 //y2=7.09
r112 (  3 18 ) resistor r=0.0219491 //w=0.216 //l=0.117 //layer=m1 \
 //thickness=0.36 //x=2.925 //y=7.09 //x2=3.042 //y2=7.09
r113 (  3 4 ) resistor r=0.615458 //w=0.131 //l=0.645 //layer=m1 \
 //thickness=0.36 //x=2.925 //y=7.09 //x2=2.28 //y2=7.09
r114 (  2 5 ) resistor r=0.0246599 //w=0.226 //l=0.123 //layer=m1 \
 //thickness=0.36 //x=1.405 //y=5.39 //x2=1.282 //y2=5.39
r115 (  1 10 ) resistor r=0.0219491 //w=0.216 //l=0.117 //layer=m1 \
 //thickness=0.36 //x=2.045 //y=5.39 //x2=2.162 //y2=5.39
r116 (  1 2 ) resistor r=0.610687 //w=0.131 //l=0.64 //layer=m1 \
 //thickness=0.36 //x=2.045 //y=5.39 //x2=1.405 //y2=5.39
ends PM_NOR3X1\%noxref_2

subckt PM_NOR3X1\%A ( 1 2 3 4 5 6 7 8 17 23 28 32 33 34 35 36 37 38 42 44 47 \
 49 50 55 )
c112 ( 55 0 ) capacitor c=0.0426712f //x=1.445 //y=4.885
c113 ( 50 0 ) capacitor c=0.0337825f //x=1.935 //y=1.43
c114 ( 49 0 ) capacitor c=0.0185904f //x=1.935 //y=1.085
c115 ( 47 0 ) capacitor c=0.0351114f //x=1.865 //y=4.975
c116 ( 44 0 ) capacitor c=0.013578f //x=1.78 //y=1.585
c117 ( 42 0 ) capacitor c=0.0157807f //x=1.78 //y=0.93
c118 ( 38 0 ) capacitor c=0.0843978f //x=1.405 //y=2.095
c119 ( 37 0 ) capacitor c=0.0230165f //x=1.405 //y=1.74
c120 ( 36 0 ) capacitor c=0.0234348f //x=1.405 //y=1.43
c121 ( 35 0 ) capacitor c=0.0192379f //x=1.405 //y=1.085
c122 ( 34 0 ) capacitor c=0.110994f //x=1.94 //y=6.205
c123 ( 33 0 ) capacitor c=0.154777f //x=1.5 //y=6.205
c124 ( 28 0 ) capacitor c=0.00174733f //x=1.6 //y=2.26
c125 ( 23 0 ) capacitor c=0.00712211f //x=1.445 //y=4.885
c126 ( 17 0 ) capacitor c=0.0160301f //x=1.445 //y=4.885
c127 ( 8 0 ) capacitor c=0.0130531f //x=1.6 //y=2.425
c128 ( 1 0 ) capacitor c=0.110591f //x=1.6 //y=2.77
r129 (  57 58 ) resistor r=32.4568 //w=0.214 //l=0.075 //layer=ply \
 //thickness=0.18 //x=1.445 //y=4.975 //x2=1.445 //y2=5.05
r130 (  55 57 ) resistor r=20.271 //w=0.214 //l=0.09 //layer=ply \
 //thickness=0.18 //x=1.445 //y=4.885 //x2=1.445 //y2=4.975
r131 (  50 64 ) resistor r=45.1352 //w=0.168 //l=0.173853 //layer=ply \
 //thickness=0.18 //x=1.935 //y=1.43 //x2=1.895 //y2=1.585
r132 (  49 63 ) resistor r=45.1352 //w=0.168 //l=0.173853 //layer=ply \
 //thickness=0.18 //x=1.935 //y=1.085 //x2=1.895 //y2=0.93
r133 (  49 50 ) resistor r=176.904 //w=0.094 //l=0.345 //layer=ply \
 //thickness=0.18 //x=1.935 //y=1.085 //x2=1.935 //y2=1.43
r134 (  48 57 ) resistor r=16.5046 //w=0.27 //l=0.135 //layer=ply \
 //thickness=0.18 //x=1.58 //y=4.975 //x2=1.445 //y2=4.975
r135 (  47 51 ) resistor r=26.9307 //w=0.15 //l=0.106066 //layer=ply \
 //thickness=0.18 //x=1.865 //y=4.975 //x2=1.94 //y2=5.05
r136 (  47 48 ) resistor r=146.138 //w=0.094 //l=0.285 //layer=ply \
 //thickness=0.18 //x=1.865 //y=4.975 //x2=1.58 //y2=4.975
r137 (  45 62 ) resistor r=10.701 //w=0.21 //l=0.115 //layer=ply \
 //thickness=0.18 //x=1.56 //y=1.585 //x2=1.445 //y2=1.585
r138 (  44 64 ) resistor r=5.52526 //w=0.168 //l=0.115 //layer=ply \
 //thickness=0.18 //x=1.78 //y=1.585 //x2=1.895 //y2=1.585
r139 (  43 61 ) resistor r=5.52526 //w=0.168 //l=0.115 //layer=ply \
 //thickness=0.18 //x=1.56 //y=0.93 //x2=1.445 //y2=0.93
r140 (  42 63 ) resistor r=5.52526 //w=0.168 //l=0.115 //layer=ply \
 //thickness=0.18 //x=1.78 //y=0.93 //x2=1.895 //y2=0.93
r141 (  42 43 ) resistor r=112.809 //w=0.094 //l=0.22 //layer=ply \
 //thickness=0.18 //x=1.78 //y=0.93 //x2=1.56 //y2=0.93
r142 (  38 60 ) resistor r=34.8111 //w=0.27 //l=0.264953 //layer=ply \
 //thickness=0.18 //x=1.405 //y=2.095 //x2=1.6 //y2=2.26
r143 (  37 62 ) resistor r=39.5823 //w=0.21 //l=0.173853 //layer=ply \
 //thickness=0.18 //x=1.405 //y=1.74 //x2=1.445 //y2=1.585
r144 (  37 38 ) resistor r=182.032 //w=0.094 //l=0.355 //layer=ply \
 //thickness=0.18 //x=1.405 //y=1.74 //x2=1.405 //y2=2.095
r145 (  36 62 ) resistor r=39.5823 //w=0.21 //l=0.173853 //layer=ply \
 //thickness=0.18 //x=1.405 //y=1.43 //x2=1.445 //y2=1.585
r146 (  35 61 ) resistor r=45.1352 //w=0.168 //l=0.173853 //layer=ply \
 //thickness=0.18 //x=1.405 //y=1.085 //x2=1.445 //y2=0.93
r147 (  35 36 ) resistor r=176.904 //w=0.094 //l=0.345 //layer=ply \
 //thickness=0.18 //x=1.405 //y=1.085 //x2=1.405 //y2=1.43
r148 (  34 51 ) resistor r=592.245 //w=0.094 //l=1.155 //layer=ply \
 //thickness=0.18 //x=1.94 //y=6.205 //x2=1.94 //y2=5.05
r149 (  33 58 ) resistor r=592.245 //w=0.094 //l=1.155 //layer=ply \
 //thickness=0.18 //x=1.5 //y=6.205 //x2=1.5 //y2=5.05
r150 (  32 44 ) resistor r=56.4043 //w=0.094 //l=0.11 //layer=ply \
 //thickness=0.18 //x=1.67 //y=1.585 //x2=1.78 //y2=1.585
r151 (  32 45 ) resistor r=56.4043 //w=0.094 //l=0.11 //layer=ply \
 //thickness=0.18 //x=1.67 //y=1.585 //x2=1.56 //y2=1.585
r152 (  28 60 ) resistor r=152 //w=0.17 //l=0.17 //layer=licon //count=1 \
 //x=1.6 //y=2.26 //x2=1.6 //y2=2.26
r153 (  23 55 ) resistor r=152 //w=0.17 //l=0.17 //layer=licon //count=1 \
 //x=1.445 //y=4.885 //x2=1.445 //y2=4.885
r154 (  20 28 ) resistor r=9.3 //w=0.17 //l=0.17 //layer=mcon //count=1 \
 //x=1.6 //y=2.26 //x2=1.6 //y2=2.26
r155 (  17 23 ) resistor r=9.3 //w=0.17 //l=0.17 //layer=mcon //count=1 \
 //x=1.445 //y=4.885 //x2=1.445 //y2=4.885
r156 (  17 18 ) resistor r=0.0905374 //w=0.214 //l=0.155 //layer=m1 \
 //thickness=0.36 //x=1.445 //y=4.882 //x2=1.6 //y2=4.882
r157 (  9 18 ) resistor r=0.0213909 //w=0.214 //l=0.117 //layer=m1 \
 //thickness=0.36 //x=1.6 //y=4.765 //x2=1.6 //y2=4.882
r158 (  7 8 ) resistor r=0.0249032 //w=0.247 //l=0.025 //layer=m1 \
 //thickness=0.36 //x=1.6 //y=2.4 //x2=1.6 //y2=2.425
r159 (  7 20 ) resistor r=0.0708502 //w=0.247 //l=0.14 //layer=m1 \
 //thickness=0.36 //x=1.6 //y=2.4 //x2=1.6 //y2=2.26
r160 (  6 9 ) resistor r=0.138359 //w=0.131 //l=0.145 //layer=m1 \
 //thickness=0.36 //x=1.6 //y=4.62 //x2=1.6 //y2=4.765
r161 (  5 6 ) resistor r=0.353053 //w=0.131 //l=0.37 //layer=m1 \
 //thickness=0.36 //x=1.6 //y=4.25 //x2=1.6 //y2=4.62
r162 (  4 5 ) resistor r=0.353053 //w=0.131 //l=0.37 //layer=m1 \
 //thickness=0.36 //x=1.6 //y=3.88 //x2=1.6 //y2=4.25
r163 (  3 4 ) resistor r=0.353053 //w=0.131 //l=0.37 //layer=m1 \
 //thickness=0.36 //x=1.6 //y=3.51 //x2=1.6 //y2=3.88
r164 (  2 3 ) resistor r=0.353053 //w=0.131 //l=0.37 //layer=m1 \
 //thickness=0.36 //x=1.6 //y=3.14 //x2=1.6 //y2=3.51
r165 (  1 2 ) resistor r=0.353053 //w=0.131 //l=0.37 //layer=m1 \
 //thickness=0.36 //x=1.6 //y=2.77 //x2=1.6 //y2=3.14
r166 (  1 8 ) resistor r=0.329198 //w=0.131 //l=0.345 //layer=m1 \
 //thickness=0.36 //x=1.6 //y=2.77 //x2=1.6 //y2=2.425
ends PM_NOR3X1\%A

subckt PM_NOR3X1\%VDD ( 1 2 6 7 15 25 31 41 )
c74 ( 41 0 ) capacitor c=0.0229259f //x=1.575 //y=5.205
c75 ( 31 0 ) capacitor c=0.441071f //x=4.56 //y=7.58
c76 ( 25 0 ) capacitor c=0.229815f //x=1.23 //y=7.58
c77 ( 17 0 ) capacitor c=0.00499323f //x=1.72 //y=7.585
c78 ( 15 0 ) capacitor c=0.148684f //x=4.56 //y=7.58
c79 ( 7 0 ) capacitor c=0.00987753f //x=1.72 //y=7.41
c80 ( 6 0 ) capacitor c=0.00592383f //x=1.72 //y=7.035
c81 ( 2 0 ) capacitor c=0.0788951f //x=1.635 //y=7.585
r82 (  29 31 ) resistor r=38.7139 //w=0.367 //l=1.11 //layer=li \
 //thickness=0.1 //x=3.45 //y=7.585 //x2=4.56 //y2=7.585
r83 (  27 29 ) resistor r=38.7139 //w=0.367 //l=1.11 //layer=li \
 //thickness=0.1 //x=2.34 //y=7.585 //x2=3.45 //y2=7.585
r84 (  25 27 ) resistor r=38.7139 //w=0.367 //l=1.11 //layer=li \
 //thickness=0.1 //x=1.23 //y=7.585 //x2=2.34 //y2=7.585
r85 (  19 41 ) resistor r=9.3 //w=0.17 //l=0.17 //layer=mcon //count=1 \
 //x=1.72 //y=6.92 //x2=1.72 //y2=6.92
r86 (  15 31 ) resistor r=3.1 //w=0.17 //l=0.51 //layer=mcon //count=3 \
 //x=4.56 //y=7.58 //x2=4.56 //y2=7.58
r87 (  13 29 ) resistor r=3.1 //w=0.17 //l=0.51 //layer=mcon //count=3 \
 //x=3.45 //y=7.58 //x2=3.45 //y2=7.58
r88 (  13 15 ) resistor r=0.446141 //w=0.311 //l=1.11 //layer=m1 \
 //thickness=0.36 //x=3.45 //y=7.585 //x2=4.56 //y2=7.585
r89 (  10 27 ) resistor r=3.1 //w=0.17 //l=0.51 //layer=mcon //count=3 \
 //x=2.34 //y=7.58 //x2=2.34 //y2=7.58
r90 (  8 17 ) resistor r=0.028033 //w=0.35 //l=0.085 //layer=m1 \
 //thickness=0.36 //x=1.805 //y=7.585 //x2=1.72 //y2=7.585
r91 (  8 10 ) resistor r=0.215032 //w=0.311 //l=0.535 //layer=m1 \
 //thickness=0.36 //x=1.805 //y=7.585 //x2=2.34 //y2=7.585
r92 (  7 17 ) resistor r=0.0413265 //w=0.7 //l=0.175 //layer=m1 \
 //thickness=0.36 //x=1.72 //y=7.41 //x2=1.72 //y2=7.585
r93 (  6 19 ) resistor r=0.0722282 //w=0.219 //l=0.115 //layer=m1 \
 //thickness=0.36 //x=1.72 //y=7.035 //x2=1.72 //y2=6.92
r94 (  6 7 ) resistor r=0.357824 //w=0.131 //l=0.375 //layer=m1 \
 //thickness=0.36 //x=1.72 //y=7.035 //x2=1.72 //y2=7.41
r95 (  4 25 ) resistor r=3.1 //w=0.17 //l=0.51 //layer=mcon //count=3 //x=1.23 \
 //y=7.58 //x2=1.23 //y2=7.58
r96 (  2 17 ) resistor r=0.028033 //w=0.35 //l=0.085 //layer=m1 \
 //thickness=0.36 //x=1.635 //y=7.585 //x2=1.72 //y2=7.585
r97 (  2 4 ) resistor r=0.162781 //w=0.311 //l=0.405 //layer=m1 \
 //thickness=0.36 //x=1.635 //y=7.585 //x2=1.23 //y2=7.585
r98 (  1 13 ) resistor r=0.223071 //w=0.311 //l=0.555 //layer=m1 \
 //thickness=0.36 //x=2.895 //y=7.585 //x2=3.45 //y2=7.585
r99 (  1 10 ) resistor r=0.223071 //w=0.311 //l=0.555 //layer=m1 \
 //thickness=0.36 //x=2.895 //y=7.585 //x2=2.34 //y2=7.585
ends PM_NOR3X1\%VDD

subckt PM_NOR3X1\%B ( 1 2 3 4 5 6 7 8 9 22 27 31 32 33 34 35 36 41 43 45 51 52 \
 54 55 58 )
c131 ( 58 0 ) capacitor c=0.0385046f //x=2.375 //y=4.885
c132 ( 55 0 ) capacitor c=0.0266377f //x=2.34 //y=2.095
c133 ( 54 0 ) capacitor c=0.0431872f //x=2.34 //y=2.26
c134 ( 52 0 ) capacitor c=0.0170969f //x=2.905 //y=1.435
c135 ( 51 0 ) capacitor c=0.0176979f //x=2.905 //y=1.085
c136 ( 45 0 ) capacitor c=0.0323332f //x=2.75 //y=1.585
c137 ( 43 0 ) capacitor c=0.0157807f //x=2.75 //y=0.93
c138 ( 41 0 ) capacitor c=0.0338349f //x=2.745 //y=4.975
c139 ( 36 0 ) capacitor c=0.0194854f //x=2.375 //y=1.74
c140 ( 35 0 ) capacitor c=0.0169638f //x=2.375 //y=1.435
c141 ( 34 0 ) capacitor c=0.0177156f //x=2.375 //y=1.085
c142 ( 33 0 ) capacitor c=0.140843f //x=2.82 //y=6.205
c143 ( 32 0 ) capacitor c=0.110534f //x=2.38 //y=6.205
c144 ( 27 0 ) capacitor c=0.00161643f //x=2.375 //y=4.885
c145 ( 22 0 ) capacitor c=0.00179873f //x=2.34 //y=2.26
c146 ( 9 0 ) capacitor c=0.00618211f //x=2.34 //y=4.74
c147 ( 8 0 ) capacitor c=0.00671238f //x=2.34 //y=2.39
c148 ( 1 0 ) capacitor c=0.0715742f //x=2.34 //y=2.4
r149 (  60 61 ) resistor r=32.4568 //w=0.214 //l=0.075 //layer=ply \
 //thickness=0.18 //x=2.375 //y=4.975 //x2=2.375 //y2=5.05
r150 (  58 60 ) resistor r=20.271 //w=0.214 //l=0.09 //layer=ply \
 //thickness=0.18 //x=2.375 //y=4.885 //x2=2.375 //y2=4.975
r151 (  54 55 ) resistor r=52.7279 //w=0.214 //l=0.165 //layer=ply \
 //thickness=0.18 //x=2.34 //y=2.26 //x2=2.34 //y2=2.095
r152 (  52 65 ) resistor r=4.95774 //w=0.164 //l=0.112 //layer=ply \
 //thickness=0.18 //x=2.905 //y=1.435 //x2=2.905 //y2=1.547
r153 (  51 64 ) resistor r=45.1352 //w=0.168 //l=0.173853 //layer=ply \
 //thickness=0.18 //x=2.905 //y=1.085 //x2=2.865 //y2=0.93
r154 (  51 52 ) resistor r=179.468 //w=0.094 //l=0.35 //layer=ply \
 //thickness=0.18 //x=2.905 //y=1.085 //x2=2.905 //y2=1.435
r155 (  46 63 ) resistor r=10.8103 //w=0.211 //l=0.115 //layer=ply \
 //thickness=0.18 //x=2.53 //y=1.585 //x2=2.415 //y2=1.585
r156 (  45 65 ) resistor r=45.9962 //w=0.164 //l=0.17296 //layer=ply \
 //thickness=0.18 //x=2.75 //y=1.585 //x2=2.905 //y2=1.547
r157 (  44 62 ) resistor r=5.52526 //w=0.168 //l=0.115 //layer=ply \
 //thickness=0.18 //x=2.53 //y=0.93 //x2=2.415 //y2=0.93
r158 (  43 64 ) resistor r=5.52526 //w=0.168 //l=0.115 //layer=ply \
 //thickness=0.18 //x=2.75 //y=0.93 //x2=2.865 //y2=0.93
r159 (  43 44 ) resistor r=112.809 //w=0.094 //l=0.22 //layer=ply \
 //thickness=0.18 //x=2.75 //y=0.93 //x2=2.53 //y2=0.93
r160 (  42 60 ) resistor r=16.5046 //w=0.27 //l=0.135 //layer=ply \
 //thickness=0.18 //x=2.51 //y=4.975 //x2=2.375 //y2=4.975
r161 (  41 48 ) resistor r=26.9307 //w=0.15 //l=0.106066 //layer=ply \
 //thickness=0.18 //x=2.745 //y=4.975 //x2=2.82 //y2=5.05
r162 (  41 42 ) resistor r=120.5 //w=0.094 //l=0.235 //layer=ply \
 //thickness=0.18 //x=2.745 //y=4.975 //x2=2.51 //y2=4.975
r163 (  36 63 ) resistor r=39.5036 //w=0.211 //l=0.173853 //layer=ply \
 //thickness=0.18 //x=2.375 //y=1.74 //x2=2.415 //y2=1.585
r164 (  36 55 ) resistor r=182.032 //w=0.094 //l=0.355 //layer=ply \
 //thickness=0.18 //x=2.375 //y=1.74 //x2=2.375 //y2=2.095
r165 (  35 63 ) resistor r=38.3614 //w=0.211 //l=0.168819 //layer=ply \
 //thickness=0.18 //x=2.375 //y=1.435 //x2=2.415 //y2=1.585
r166 (  34 62 ) resistor r=45.1352 //w=0.168 //l=0.173853 //layer=ply \
 //thickness=0.18 //x=2.375 //y=1.085 //x2=2.415 //y2=0.93
r167 (  34 35 ) resistor r=179.468 //w=0.094 //l=0.35 //layer=ply \
 //thickness=0.18 //x=2.375 //y=1.085 //x2=2.375 //y2=1.435
r168 (  33 48 ) resistor r=592.245 //w=0.094 //l=1.155 //layer=ply \
 //thickness=0.18 //x=2.82 //y=6.205 //x2=2.82 //y2=5.05
r169 (  32 61 ) resistor r=592.245 //w=0.094 //l=1.155 //layer=ply \
 //thickness=0.18 //x=2.38 //y=6.205 //x2=2.38 //y2=5.05
r170 (  31 45 ) resistor r=56.4043 //w=0.094 //l=0.11 //layer=ply \
 //thickness=0.18 //x=2.64 //y=1.585 //x2=2.75 //y2=1.585
r171 (  31 46 ) resistor r=56.4043 //w=0.094 //l=0.11 //layer=ply \
 //thickness=0.18 //x=2.64 //y=1.585 //x2=2.53 //y2=1.585
r172 (  27 58 ) resistor r=152 //w=0.17 //l=0.17 //layer=licon //count=1 \
 //x=2.375 //y=4.885 //x2=2.375 //y2=4.885
r173 (  22 54 ) resistor r=152 //w=0.17 //l=0.17 //layer=licon //count=1 \
 //x=2.34 //y=2.26 //x2=2.34 //y2=2.26
r174 (  20 27 ) resistor r=9.3 //w=0.17 //l=0.17 //layer=mcon //count=1 \
 //x=2.375 //y=4.885 //x2=2.375 //y2=4.885
r175 (  18 22 ) resistor r=9.3 //w=0.17 //l=0.17 //layer=mcon //count=1 \
 //x=2.34 //y=2.26 //x2=2.34 //y2=2.26
r176 (  9 20 ) resistor r=0.0875652 //w=0.23 //l=0.161555 //layer=m1 \
 //thickness=0.36 //x=2.34 //y=4.74 //x2=2.375 //y2=4.885
r177 (  8 18 ) resistor r=0.078924 //w=0.235 //l=0.131491 //layer=m1 \
 //thickness=0.36 //x=2.34 //y=2.39 //x2=2.337 //y2=2.26
r178 (  7 9 ) resistor r=0.114504 //w=0.131 //l=0.12 //layer=m1 \
 //thickness=0.36 //x=2.34 //y=4.62 //x2=2.34 //y2=4.74
r179 (  6 7 ) resistor r=0.353053 //w=0.131 //l=0.37 //layer=m1 \
 //thickness=0.36 //x=2.34 //y=4.25 //x2=2.34 //y2=4.62
r180 (  5 6 ) resistor r=0.353053 //w=0.131 //l=0.37 //layer=m1 \
 //thickness=0.36 //x=2.34 //y=3.88 //x2=2.34 //y2=4.25
r181 (  4 5 ) resistor r=0.353053 //w=0.131 //l=0.37 //layer=m1 \
 //thickness=0.36 //x=2.34 //y=3.51 //x2=2.34 //y2=3.88
r182 (  3 4 ) resistor r=0.353053 //w=0.131 //l=0.37 //layer=m1 \
 //thickness=0.36 //x=2.34 //y=3.14 //x2=2.34 //y2=3.51
r183 (  2 3 ) resistor r=0.353053 //w=0.131 //l=0.37 //layer=m1 \
 //thickness=0.36 //x=2.34 //y=2.77 //x2=2.34 //y2=3.14
r184 (  1 2 ) resistor r=0.353053 //w=0.131 //l=0.37 //layer=m1 \
 //thickness=0.36 //x=2.34 //y=2.4 //x2=2.34 //y2=2.77
r185 (  1 8 ) resistor r=0.00954198 //w=0.131 //l=0.01 //layer=m1 \
 //thickness=0.36 //x=2.34 //y=2.4 //x2=2.34 //y2=2.39
ends PM_NOR3X1\%B

subckt PM_NOR3X1\%C ( 1 2 3 4 5 6 7 8 9 22 27 31 32 33 34 35 36 37 38 40 43 48 \
 49 50 55 59 )
c108 ( 65 0 ) capacitor c=0.011077f //x=3.86 //y=4.975
c109 ( 59 0 ) capacitor c=0.0475417f //x=3.45 //y=4.885
c110 ( 55 0 ) capacitor c=0.053123f //x=3.345 //y=2.26
c111 ( 50 0 ) capacitor c=0.0378324f //x=4.225 //y=4.975
c112 ( 49 0 ) capacitor c=0.0237765f //x=3.875 //y=1.435
c113 ( 48 0 ) capacitor c=0.0192157f //x=3.875 //y=1.085
c114 ( 43 0 ) capacitor c=0.0202474f //x=3.785 //y=4.975
c115 ( 40 0 ) capacitor c=0.0344387f //x=3.72 //y=1.585
c116 ( 38 0 ) capacitor c=0.0157807f //x=3.72 //y=0.93
c117 ( 37 0 ) capacitor c=0.0293304f //x=3.345 //y=2.095
c118 ( 36 0 ) capacitor c=0.0194031f //x=3.345 //y=1.74
c119 ( 35 0 ) capacitor c=0.0170969f //x=3.345 //y=1.435
c120 ( 34 0 ) capacitor c=0.0185784f //x=3.345 //y=1.085
c121 ( 33 0 ) capacitor c=0.155498f //x=4.3 //y=6.205
c122 ( 32 0 ) capacitor c=0.140775f //x=3.86 //y=6.205
c123 ( 27 0 ) capacitor c=0.00110779f //x=3.45 //y=4.885
c124 ( 22 0 ) capacitor c=9.1262e-19 //x=3.45 //y=2.26
c125 ( 9 0 ) capacitor c=0.00581787f //x=3.45 //y=4.765
c126 ( 8 0 ) capacitor c=0.00606585f //x=3.45 //y=2.405
c127 ( 1 0 ) capacitor c=0.0717538f //x=3.45 //y=2.77
r128 (  59 61 ) resistor r=20.271 //w=0.214 //l=0.09 //layer=ply \
 //thickness=0.18 //x=3.45 //y=4.885 //x2=3.45 //y2=4.975
r129 (  55 57 ) resistor r=16.5934 //w=0.305 //l=0.105 //layer=ply \
 //thickness=0.18 //x=3.345 //y=2.26 //x2=3.45 //y2=2.26
r130 (  51 65 ) resistor r=20.4101 //w=0.15 //l=0.075 //layer=ply \
 //thickness=0.18 //x=3.935 //y=4.975 //x2=3.86 //y2=4.975
r131 (  50 52 ) resistor r=26.9307 //w=0.15 //l=0.106066 //layer=ply \
 //thickness=0.18 //x=4.225 //y=4.975 //x2=4.3 //y2=5.05
r132 (  50 51 ) resistor r=148.702 //w=0.094 //l=0.29 //layer=ply \
 //thickness=0.18 //x=4.225 //y=4.975 //x2=3.935 //y2=4.975
r133 (  49 67 ) resistor r=4.95774 //w=0.164 //l=0.112 //layer=ply \
 //thickness=0.18 //x=3.875 //y=1.435 //x2=3.875 //y2=1.547
r134 (  48 66 ) resistor r=45.1352 //w=0.168 //l=0.173853 //layer=ply \
 //thickness=0.18 //x=3.875 //y=1.085 //x2=3.835 //y2=0.93
r135 (  48 49 ) resistor r=179.468 //w=0.094 //l=0.35 //layer=ply \
 //thickness=0.18 //x=3.875 //y=1.085 //x2=3.875 //y2=1.435
r136 (  45 65 ) resistor r=5.30422 //w=0.3 //l=0.075 //layer=ply \
 //thickness=0.18 //x=3.86 //y=5.05 //x2=3.86 //y2=4.975
r137 (  44 61 ) resistor r=16.5046 //w=0.27 //l=0.135 //layer=ply \
 //thickness=0.18 //x=3.585 //y=4.975 //x2=3.45 //y2=4.975
r138 (  43 65 ) resistor r=20.4101 //w=0.15 //l=0.075 //layer=ply \
 //thickness=0.18 //x=3.785 //y=4.975 //x2=3.86 //y2=4.975
r139 (  43 44 ) resistor r=102.553 //w=0.094 //l=0.2 //layer=ply \
 //thickness=0.18 //x=3.785 //y=4.975 //x2=3.585 //y2=4.975
r140 (  41 64 ) resistor r=10.8103 //w=0.211 //l=0.115 //layer=ply \
 //thickness=0.18 //x=3.5 //y=1.585 //x2=3.385 //y2=1.585
r141 (  40 67 ) resistor r=45.9962 //w=0.164 //l=0.17296 //layer=ply \
 //thickness=0.18 //x=3.72 //y=1.585 //x2=3.875 //y2=1.547
r142 (  39 63 ) resistor r=5.52526 //w=0.168 //l=0.115 //layer=ply \
 //thickness=0.18 //x=3.5 //y=0.93 //x2=3.385 //y2=0.93
r143 (  38 66 ) resistor r=5.52526 //w=0.168 //l=0.115 //layer=ply \
 //thickness=0.18 //x=3.72 //y=0.93 //x2=3.835 //y2=0.93
r144 (  38 39 ) resistor r=112.809 //w=0.094 //l=0.22 //layer=ply \
 //thickness=0.18 //x=3.72 //y=0.93 //x2=3.5 //y2=0.93
r145 (  37 55 ) resistor r=19.3576 //w=0.305 //l=0.165 //layer=ply \
 //thickness=0.18 //x=3.345 //y=2.095 //x2=3.345 //y2=2.26
r146 (  36 64 ) resistor r=39.5036 //w=0.211 //l=0.173853 //layer=ply \
 //thickness=0.18 //x=3.345 //y=1.74 //x2=3.385 //y2=1.585
r147 (  36 37 ) resistor r=182.032 //w=0.094 //l=0.355 //layer=ply \
 //thickness=0.18 //x=3.345 //y=1.74 //x2=3.345 //y2=2.095
r148 (  35 64 ) resistor r=38.3614 //w=0.211 //l=0.168819 //layer=ply \
 //thickness=0.18 //x=3.345 //y=1.435 //x2=3.385 //y2=1.585
r149 (  34 63 ) resistor r=45.1352 //w=0.168 //l=0.173853 //layer=ply \
 //thickness=0.18 //x=3.345 //y=1.085 //x2=3.385 //y2=0.93
r150 (  34 35 ) resistor r=179.468 //w=0.094 //l=0.35 //layer=ply \
 //thickness=0.18 //x=3.345 //y=1.085 //x2=3.345 //y2=1.435
r151 (  33 52 ) resistor r=592.245 //w=0.094 //l=1.155 //layer=ply \
 //thickness=0.18 //x=4.3 //y=6.205 //x2=4.3 //y2=5.05
r152 (  32 45 ) resistor r=592.245 //w=0.094 //l=1.155 //layer=ply \
 //thickness=0.18 //x=3.86 //y=6.205 //x2=3.86 //y2=5.05
r153 (  31 40 ) resistor r=56.4043 //w=0.094 //l=0.11 //layer=ply \
 //thickness=0.18 //x=3.61 //y=1.585 //x2=3.72 //y2=1.585
r154 (  31 41 ) resistor r=56.4043 //w=0.094 //l=0.11 //layer=ply \
 //thickness=0.18 //x=3.61 //y=1.585 //x2=3.5 //y2=1.585
r155 (  27 59 ) resistor r=152 //w=0.17 //l=0.17 //layer=licon //count=1 \
 //x=3.45 //y=4.885 //x2=3.45 //y2=4.885
r156 (  22 57 ) resistor r=152 //w=0.17 //l=0.17 //layer=licon //count=1 \
 //x=3.45 //y=2.26 //x2=3.45 //y2=2.26
r157 (  20 27 ) resistor r=9.3 //w=0.17 //l=0.17 //layer=mcon //count=1 \
 //x=3.45 //y=4.885 //x2=3.45 //y2=4.885
r158 (  17 22 ) resistor r=9.3 //w=0.17 //l=0.17 //layer=mcon //count=1 \
 //x=3.45 //y=2.26 //x2=3.45 //y2=2.26
r159 (  9 20 ) resistor r=0.0744285 //w=0.225 //l=0.12 //layer=m1 \
 //thickness=0.36 //x=3.45 //y=4.765 //x2=3.45 //y2=4.885
r160 (  7 8 ) resistor r=0.0132101 //w=0.239 //l=0.00632456 //layer=m1 \
 //thickness=0.36 //x=3.447 //y=2.4 //x2=3.45 //y2=2.405
r161 (  7 17 ) resistor r=0.0732218 //w=0.239 //l=0.14 //layer=m1 \
 //thickness=0.36 //x=3.447 //y=2.4 //x2=3.447 //y2=2.26
r162 (  6 9 ) resistor r=0.138359 //w=0.131 //l=0.145 //layer=m1 \
 //thickness=0.36 //x=3.45 //y=4.62 //x2=3.45 //y2=4.765
r163 (  5 6 ) resistor r=0.353053 //w=0.131 //l=0.37 //layer=m1 \
 //thickness=0.36 //x=3.45 //y=4.25 //x2=3.45 //y2=4.62
r164 (  4 5 ) resistor r=0.353053 //w=0.131 //l=0.37 //layer=m1 \
 //thickness=0.36 //x=3.45 //y=3.88 //x2=3.45 //y2=4.25
r165 (  3 4 ) resistor r=0.353053 //w=0.131 //l=0.37 //layer=m1 \
 //thickness=0.36 //x=3.45 //y=3.51 //x2=3.45 //y2=3.88
r166 (  2 3 ) resistor r=0.353053 //w=0.131 //l=0.37 //layer=m1 \
 //thickness=0.36 //x=3.45 //y=3.14 //x2=3.45 //y2=3.51
r167 (  1 2 ) resistor r=0.353053 //w=0.131 //l=0.37 //layer=m1 \
 //thickness=0.36 //x=3.45 //y=2.77 //x2=3.45 //y2=3.14
r168 (  1 8 ) resistor r=0.348282 //w=0.131 //l=0.365 //layer=m1 \
 //thickness=0.36 //x=3.45 //y=2.77 //x2=3.45 //y2=2.405
ends PM_NOR3X1\%C

subckt PM_NOR3X1\%noxref_7 ( 1 4 5 7 13 16 19 27 42 43 44 )
c76 ( 44 0 ) capacitor c=0.0383139f //x=4.375 //y=5.205
c77 ( 27 0 ) capacitor c=0.0270496f //x=3.64 //y=5.9
c78 ( 19 0 ) capacitor c=0.0250744f //x=2.6 //y=5.56
c79 ( 16 0 ) capacitor c=0.0178258f //x=4.52 //y=6.92
c80 ( 13 0 ) capacitor c=0.00671901f //x=3.64 //y=6.92
c81 ( 7 0 ) capacitor c=0.0124325f //x=2.6 //y=5.39
c82 ( 5 0 ) capacitor c=0.00970854f //x=4.405 //y=7.09
c83 ( 4 0 ) capacitor c=0.0176668f //x=3.64 //y=5.77
c84 ( 1 0 ) capacitor c=0.03242f //x=3.555 //y=5.39
r85 (  27 43 ) resistor r=23.2727 //w=0.187 //l=0.34 //layer=li \
 //thickness=0.1 //x=3.64 //y=5.9 //x2=3.64 //y2=6.24
r86 (  19 42 ) resistor r=23.2727 //w=0.187 //l=0.34 //layer=li \
 //thickness=0.1 //x=2.6 //y=5.56 //x2=2.6 //y2=5.9
r87 (  16 44 ) resistor r=9.3 //w=0.17 //l=0.17 //layer=mcon //count=1 \
 //x=4.52 //y=6.92 //x2=4.52 //y2=6.92
r88 (  16 17 ) resistor r=0.103155 //w=0.206 //l=0.17 //layer=m1 \
 //thickness=0.36 //x=4.52 //y=6.92 //x2=4.52 //y2=7.09
r89 (  13 43 ) resistor r=9.3 //w=0.17 //l=0.17 //layer=mcon //count=1 \
 //x=3.64 //y=6.92 //x2=3.64 //y2=6.92
r90 (  13 14 ) resistor r=0.103155 //w=0.206 //l=0.17 //layer=m1 \
 //thickness=0.36 //x=3.64 //y=6.92 //x2=3.64 //y2=7.09
r91 (  11 27 ) resistor r=9.3 //w=0.17 //l=0.17 //layer=mcon //count=1 \
 //x=3.64 //y=5.9 //x2=3.64 //y2=5.9
r92 (  9 19 ) resistor r=9.3 //w=0.17 //l=0.17 //layer=mcon //count=1 //x=2.6 \
 //y=5.56 //x2=2.6 //y2=5.56
r93 (  7 9 ) resistor r=0.0961538 //w=0.221 //l=0.17 //layer=m1 \
 //thickness=0.36 //x=2.6 //y=5.39 //x2=2.6 //y2=5.56
r94 (  6 14 ) resistor r=0.0190994 //w=0.206 //l=0.115 //layer=m1 \
 //thickness=0.36 //x=3.755 //y=7.09 //x2=3.64 //y2=7.09
r95 (  5 17 ) resistor r=0.0190994 //w=0.206 //l=0.115 //layer=m1 \
 //thickness=0.36 //x=4.405 //y=7.09 //x2=4.52 //y2=7.09
r96 (  5 6 ) resistor r=0.620229 //w=0.131 //l=0.65 //layer=m1 \
 //thickness=0.36 //x=4.405 //y=7.09 //x2=3.755 //y2=7.09
r97 (  4 11 ) resistor r=0.0784347 //w=0.241 //l=0.130996 //layer=m1 \
 //thickness=0.36 //x=3.64 //y=5.77 //x2=3.642 //y2=5.9
r98 (  3 4 ) resistor r=0.281489 //w=0.131 //l=0.295 //layer=m1 \
 //thickness=0.36 //x=3.64 //y=5.475 //x2=3.64 //y2=5.77
r99 (  2 7 ) resistor r=0.0233208 //w=0.221 //l=0.12 //layer=m1 \
 //thickness=0.36 //x=2.72 //y=5.39 //x2=2.6 //y2=5.39
r100 (  1 3 ) resistor r=0.0698411 //w=0.17 //l=0.120208 //layer=m1 \
 //thickness=0.36 //x=3.555 //y=5.39 //x2=3.64 //y2=5.475
r101 (  1 2 ) resistor r=0.796756 //w=0.131 //l=0.835 //layer=m1 \
 //thickness=0.36 //x=3.555 //y=5.39 //x2=2.72 //y2=5.39
ends PM_NOR3X1\%noxref_7

subckt PM_NOR3X1\%Y ( 1 2 3 4 5 6 7 8 9 10 11 12 13 14 16 17 18 21 36 41 61 66 \
 67 68 72 )
c163 ( 68 0 ) capacitor c=0.00873058f //x=3.42 //y=1.085
c164 ( 67 0 ) capacitor c=0.00875954f //x=2.45 //y=1.085
c165 ( 66 0 ) capacitor c=0.00846995f //x=1.48 //y=1.085
c166 ( 61 0 ) capacitor c=0.0175291f //x=4.08 //y=5.9
c167 ( 41 0 ) capacitor c=0.00871708f //x=4.19 //y=5.39
c168 ( 36 0 ) capacitor c=0.00396315f //x=3.61 //y=1.835
c169 ( 33 0 ) capacitor c=0.0053239f //x=2.64 //y=1.835
c170 ( 21 0 ) capacitor c=0.0215729f //x=4.08 //y=5.77
c171 ( 18 0 ) capacitor c=0.025414f //x=4.105 //y=1.835
c172 ( 17 0 ) capacitor c=0.0114203f //x=3.61 //y=1.75
c173 ( 16 0 ) capacitor c=0.0124805f //x=3.61 //y=1.325
c174 ( 14 0 ) capacitor c=0.0226795f //x=3.525 //y=1.835
c175 ( 13 0 ) capacitor c=0.00495158f //x=2.64 //y=1.75
c176 ( 12 0 ) capacitor c=0.00403165f //x=2.64 //y=1.31
c177 ( 11 0 ) capacitor c=0.00466756f //x=1.755 //y=1.835
c178 ( 10 0 ) capacitor c=0.0219101f //x=2.555 //y=1.835
c179 ( 9 0 ) capacitor c=0.0106027f //x=1.67 //y=1.75
c180 ( 8 0 ) capacitor c=0.0119131f //x=1.67 //y=1.31
c181 ( 1 0 ) capacitor c=0.150495f //x=4.19 //y=2.4
r182 (  61 72 ) resistor r=23.2727 //w=0.187 //l=0.34 //layer=li \
 //thickness=0.1 //x=4.08 //y=5.9 //x2=4.08 //y2=6.24
r183 (  44 61 ) resistor r=9.3 //w=0.17 //l=0.17 //layer=mcon //count=1 \
 //x=4.08 //y=5.9 //x2=4.08 //y2=5.9
r184 (  39 41 ) resistor r=0.104962 //w=0.131 //l=0.11 //layer=m1 \
 //thickness=0.36 //x=4.08 //y=5.39 //x2=4.19 //y2=5.39
r185 (  38 68 ) resistor r=9.3 //w=0.17 //l=0.17 //layer=mcon //count=1 \
 //x=3.61 //y=1.18 //x2=3.61 //y2=1.18
r186 (  35 67 ) resistor r=9.3 //w=0.17 //l=0.17 //layer=mcon //count=1 \
 //x=2.64 //y=1.18 //x2=2.64 //y2=1.18
r187 (  32 66 ) resistor r=9.3 //w=0.17 //l=0.17 //layer=mcon //count=1 \
 //x=1.67 //y=1.18 //x2=1.67 //y2=1.18
r188 (  23 41 ) resistor r=0.0073411 //w=0.17 //l=0.085 //layer=m1 \
 //thickness=0.36 //x=4.19 //y=5.305 //x2=4.19 //y2=5.39
r189 (  21 44 ) resistor r=0.0784347 //w=0.241 //l=0.130996 //layer=m1 \
 //thickness=0.36 //x=4.08 //y=5.77 //x2=4.082 //y2=5.9
r190 (  20 39 ) resistor r=0.0073411 //w=0.17 //l=0.085 //layer=m1 \
 //thickness=0.36 //x=4.08 //y=5.475 //x2=4.08 //y2=5.39
r191 (  20 21 ) resistor r=0.281489 //w=0.131 //l=0.295 //layer=m1 \
 //thickness=0.36 //x=4.08 //y=5.475 //x2=4.08 //y2=5.77
r192 (  19 36 ) resistor r=0.0529306 //w=0.17 //l=0.085 //layer=m1 \
 //thickness=0.36 //x=3.695 //y=1.835 //x2=3.61 //y2=1.835
r193 (  18 22 ) resistor r=0.0698411 //w=0.17 //l=0.120208 //layer=m1 \
 //thickness=0.36 //x=4.105 //y=1.835 //x2=4.19 //y2=1.92
r194 (  18 19 ) resistor r=0.391221 //w=0.131 //l=0.41 //layer=m1 \
 //thickness=0.36 //x=4.105 //y=1.835 //x2=3.695 //y2=1.835
r195 (  17 36 ) resistor r=0.0137558 //w=0.34 //l=0.085 //layer=m1 \
 //thickness=0.36 //x=3.61 //y=1.75 //x2=3.61 //y2=1.835
r196 (  16 38 ) resistor r=0.0857222 //w=0.246 //l=0.145 //layer=m1 \
 //thickness=0.36 //x=3.61 //y=1.325 //x2=3.61 //y2=1.18
r197 (  16 17 ) resistor r=0.405534 //w=0.131 //l=0.425 //layer=m1 \
 //thickness=0.36 //x=3.61 //y=1.325 //x2=3.61 //y2=1.75
r198 (  15 33 ) resistor r=0.0529306 //w=0.17 //l=0.085 //layer=m1 \
 //thickness=0.36 //x=2.725 //y=1.835 //x2=2.64 //y2=1.835
r199 (  14 36 ) resistor r=0.0529306 //w=0.17 //l=0.085 //layer=m1 \
 //thickness=0.36 //x=3.525 //y=1.835 //x2=3.61 //y2=1.835
r200 (  14 15 ) resistor r=0.763359 //w=0.131 //l=0.8 //layer=m1 \
 //thickness=0.36 //x=3.525 //y=1.835 //x2=2.725 //y2=1.835
r201 (  13 33 ) resistor r=0.0137558 //w=0.34 //l=0.085 //layer=m1 \
 //thickness=0.36 //x=2.64 //y=1.75 //x2=2.64 //y2=1.835
r202 (  12 35 ) resistor r=0.0778262 //w=0.251 //l=0.131491 //layer=m1 \
 //thickness=0.36 //x=2.64 //y=1.31 //x2=2.637 //y2=1.18
r203 (  12 13 ) resistor r=0.419847 //w=0.131 //l=0.44 //layer=m1 \
 //thickness=0.36 //x=2.64 //y=1.31 //x2=2.64 //y2=1.75
r204 (  10 33 ) resistor r=0.0529306 //w=0.17 //l=0.085 //layer=m1 \
 //thickness=0.36 //x=2.555 //y=1.835 //x2=2.64 //y2=1.835
r205 (  10 11 ) resistor r=0.763359 //w=0.131 //l=0.8 //layer=m1 \
 //thickness=0.36 //x=2.555 //y=1.835 //x2=1.755 //y2=1.835
r206 (  9 11 ) resistor r=0.0698411 //w=0.17 //l=0.120208 //layer=m1 \
 //thickness=0.36 //x=1.67 //y=1.75 //x2=1.755 //y2=1.835
r207 (  8 32 ) resistor r=0.0779837 //w=0.248 //l=0.130996 //layer=m1 \
 //thickness=0.36 //x=1.67 //y=1.31 //x2=1.672 //y2=1.18
r208 (  8 9 ) resistor r=0.419847 //w=0.131 //l=0.44 //layer=m1 \
 //thickness=0.36 //x=1.67 //y=1.31 //x2=1.67 //y2=1.75
r209 (  7 23 ) resistor r=0.653626 //w=0.131 //l=0.685 //layer=m1 \
 //thickness=0.36 //x=4.19 //y=4.62 //x2=4.19 //y2=5.305
r210 (  6 7 ) resistor r=0.353053 //w=0.131 //l=0.37 //layer=m1 \
 //thickness=0.36 //x=4.19 //y=4.25 //x2=4.19 //y2=4.62
r211 (  5 6 ) resistor r=0.353053 //w=0.131 //l=0.37 //layer=m1 \
 //thickness=0.36 //x=4.19 //y=3.88 //x2=4.19 //y2=4.25
r212 (  4 5 ) resistor r=0.353053 //w=0.131 //l=0.37 //layer=m1 \
 //thickness=0.36 //x=4.19 //y=3.51 //x2=4.19 //y2=3.88
r213 (  3 4 ) resistor r=0.353053 //w=0.131 //l=0.37 //layer=m1 \
 //thickness=0.36 //x=4.19 //y=3.14 //x2=4.19 //y2=3.51
r214 (  2 3 ) resistor r=0.353053 //w=0.131 //l=0.37 //layer=m1 \
 //thickness=0.36 //x=4.19 //y=2.77 //x2=4.19 //y2=3.14
r215 (  1 2 ) resistor r=0.353053 //w=0.131 //l=0.37 //layer=m1 \
 //thickness=0.36 //x=4.19 //y=2.4 //x2=4.19 //y2=2.77
r216 (  1 22 ) resistor r=0.458015 //w=0.131 //l=0.48 //layer=m1 \
 //thickness=0.36 //x=4.19 //y=2.4 //x2=4.19 //y2=1.92
ends PM_NOR3X1\%Y
