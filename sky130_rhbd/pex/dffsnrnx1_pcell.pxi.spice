// File: dffsnrnx1_pcell.spi.DFFSNRNX1_PCELL.pxi
// Created: Sun Apr 12 08:40:08 2026
//
simulator lang=spectre
x_PM_DFFSNRNX1_PCELL\%noxref_1 ( N_noxref_1_c_144_p N_noxref_1_c_114_p \
 N_noxref_1_c_83_p N_noxref_1_c_61_p N_noxref_1_c_62_p N_noxref_1_c_123_p \
 N_noxref_1_c_72_p N_noxref_1_c_63_p N_noxref_1_c_12_p N_noxref_1_c_55_p \
 N_noxref_1_c_13_p N_noxref_1_c_9_p N_noxref_1_c_14_p N_noxref_1_c_15_p \
 N_noxref_1_c_16_p N_noxref_1_c_73_p N_noxref_1_c_74_p N_noxref_1_c_75_p \
 N_noxref_1_c_25_p N_noxref_1_c_236_p N_noxref_1_c_145_p N_noxref_1_c_65_p \
 N_noxref_1_c_59_p N_noxref_1_c_17_p N_noxref_1_c_5_p N_noxref_1_c_60_p \
 N_noxref_1_c_101_p N_noxref_1_c_18_p N_noxref_1_c_77_p N_noxref_1_c_19_p \
 N_noxref_1_c_238_p N_noxref_1_c_149_p N_noxref_1_c_70_p N_noxref_1_c_10_p \
 N_noxref_1_c_22_p N_noxref_1_c_166_p N_noxref_1_c_189_p \
 N_noxref_1_M3_noxref_g N_noxref_1_M6_noxref_g N_noxref_1_M24_noxref_g \
 N_noxref_1_M25_noxref_g N_noxref_1_M30_noxref_g N_noxref_1_M31_noxref_g \
 N_noxref_1_c_39_p N_noxref_1_c_40_p N_noxref_1_c_42_p N_noxref_1_c_11_p \
 N_noxref_1_c_318_p N_noxref_1_c_331_p N_noxref_1_c_41_p N_noxref_1_c_43_p \
 N_noxref_1_c_23_p N_noxref_1_c_24_p N_noxref_1_c_205_p N_noxref_1_c_206_p \
 N_noxref_1_c_208_p N_noxref_1_c_180_p N_noxref_1_c_321_p N_noxref_1_c_341_p \
 N_noxref_1_c_207_p N_noxref_1_c_209_p N_noxref_1_c_4_p N_noxref_1_c_191_p \
 N_noxref_1_M2_noxref_d N_noxref_1_M18_noxref_d N_noxref_1_M20_noxref_d \
 N_noxref_1_M22_noxref_d )  PM_DFFSNRNX1_PCELL\%noxref_1
x_PM_DFFSNRNX1_PCELL\%noxref_2 ( N_noxref_2_c_407_n N_noxref_2_c_510_p \
 N_noxref_2_c_535_p N_noxref_2_c_430_p N_noxref_2_c_468_p N_noxref_2_c_560_p \
 N_noxref_2_c_469_p N_noxref_2_c_463_p N_noxref_2_c_418_p N_noxref_2_c_473_p \
 N_noxref_2_c_419_p N_noxref_2_c_415_p N_noxref_2_c_420_p N_noxref_2_c_421_p \
 N_noxref_2_c_422_p N_noxref_2_c_408_n N_noxref_2_c_434_p N_noxref_2_c_530_p \
 N_noxref_2_c_411_n N_noxref_2_c_423_p N_noxref_2_c_466_p N_noxref_2_c_475_p \
 N_noxref_2_c_424_p N_noxref_2_c_412_n N_noxref_2_c_488_p N_noxref_2_c_531_p \
 N_noxref_2_c_416_p N_noxref_2_c_427_p N_noxref_2_M9_noxref_g \
 N_noxref_2_M36_noxref_g N_noxref_2_M37_noxref_g N_noxref_2_c_447_p \
 N_noxref_2_c_448_p N_noxref_2_c_450_p N_noxref_2_c_417_p N_noxref_2_c_649_p \
 N_noxref_2_c_659_p N_noxref_2_c_449_p N_noxref_2_c_451_p N_noxref_2_c_428_p \
 N_noxref_2_c_429_p N_noxref_2_M8_noxref_d N_noxref_2_M30_noxref_d \
 N_noxref_2_M32_noxref_d N_noxref_2_M34_noxref_d )  PM_DFFSNRNX1_PCELL\%noxref_2
x_PM_DFFSNRNX1_PCELL\%noxref_3 ( N_noxref_3_c_696_n N_noxref_3_c_699_n \
 N_noxref_3_c_740_n N_noxref_3_c_743_n N_noxref_3_c_708_n N_noxref_3_c_751_n \
 N_noxref_3_c_712_n N_noxref_3_c_713_n N_noxref_3_c_760_n N_noxref_3_c_715_n \
 N_noxref_3_c_719_n N_noxref_3_c_761_n N_noxref_3_c_765_n \
 N_noxref_3_M4_noxref_g N_noxref_3_M10_noxref_g N_noxref_3_M26_noxref_g \
 N_noxref_3_M27_noxref_g N_noxref_3_M38_noxref_g N_noxref_3_M39_noxref_g \
 N_noxref_3_c_726_n N_noxref_3_c_729_n N_noxref_3_c_931_p N_noxref_3_c_932_p \
 N_noxref_3_c_731_n N_noxref_3_c_732_n N_noxref_3_c_733_n N_noxref_3_c_734_n \
 N_noxref_3_c_802_p N_noxref_3_c_772_n N_noxref_3_c_775_n N_noxref_3_c_946_p \
 N_noxref_3_c_947_p N_noxref_3_c_777_n N_noxref_3_c_778_n N_noxref_3_c_779_n \
 N_noxref_3_c_780_n N_noxref_3_c_844_p N_noxref_3_c_737_n N_noxref_3_c_783_n ) \
 PM_DFFSNRNX1_PCELL\%noxref_3
x_PM_DFFSNRNX1_PCELL\%noxref_4 ( N_noxref_4_c_976_n N_noxref_4_c_977_n \
 N_noxref_4_c_984_n N_noxref_4_c_989_n N_noxref_4_c_994_n N_noxref_4_c_1078_n \
 N_noxref_4_c_1067_n N_noxref_4_c_1068_n N_noxref_4_c_1128_p \
 N_noxref_4_c_1261_p N_noxref_4_c_1069_n N_noxref_4_c_995_n N_noxref_4_c_996_n \
 N_noxref_4_c_1002_n N_noxref_4_c_1004_n N_noxref_4_c_1113_p \
 N_noxref_4_c_1110_p N_noxref_4_c_1118_p N_noxref_4_c_1111_p \
 N_noxref_4_c_1005_n N_noxref_4_c_1006_n N_noxref_4_c_1083_n \
 N_noxref_4_c_1218_p N_noxref_4_c_1208_p N_noxref_4_c_1120_p \
 N_noxref_4_c_1011_n N_noxref_4_c_1015_n N_noxref_4_c_1018_n \
 N_noxref_4_c_1027_n N_noxref_4_c_1121_p N_noxref_4_c_1029_n \
 N_noxref_4_c_1030_n N_noxref_4_c_1034_n N_noxref_4_c_1095_n \
 N_noxref_4_c_1219_p N_noxref_4_c_1115_p N_noxref_4_c_1122_p \
 N_noxref_4_M2_noxref_g N_noxref_4_M12_noxref_g N_noxref_4_M22_noxref_g \
 N_noxref_4_M23_noxref_g N_noxref_4_M42_noxref_g N_noxref_4_M43_noxref_g \
 N_noxref_4_c_1043_n N_noxref_4_c_1045_n N_noxref_4_c_1048_n \
 N_noxref_4_c_1049_n N_noxref_4_c_1051_n N_noxref_4_c_1055_n \
 N_noxref_4_c_1057_n N_noxref_4_c_1171_p N_noxref_4_c_1172_p \
 N_noxref_4_c_1174_p N_noxref_4_c_1116_p N_noxref_4_c_1382_p \
 N_noxref_4_c_1392_p N_noxref_4_c_1173_p N_noxref_4_c_1175_p \
 N_noxref_4_c_1123_p N_noxref_4_c_1124_p N_noxref_4_c_1061_n \
 N_noxref_4_c_1062_n N_noxref_4_c_1064_n N_noxref_4_M5_noxref_d \
 N_noxref_4_M24_noxref_d N_noxref_4_M26_noxref_d N_noxref_4_M28_noxref_d )  \
 PM_DFFSNRNX1_PCELL\%noxref_4
x_PM_DFFSNRNX1_PCELL\%noxref_5 ( N_noxref_5_c_1430_n N_noxref_5_c_1432_n \
 N_noxref_5_c_1482_n N_noxref_5_c_1464_n N_noxref_5_c_1530_n \
 N_noxref_5_c_1534_n N_noxref_5_c_1436_n N_noxref_5_c_1551_n \
 N_noxref_5_c_1469_n N_noxref_5_c_1473_n N_noxref_5_c_1476_n \
 N_noxref_5_c_1481_n N_noxref_5_c_1555_n N_noxref_5_c_1557_n \
 N_noxref_5_c_1561_n N_noxref_5_c_1453_n N_noxref_5_c_1496_n \
 N_noxref_5_c_1499_n N_noxref_5_c_1567_n N_noxref_5_c_1570_n \
 N_noxref_5_M1_noxref_g N_noxref_5_M11_noxref_g N_noxref_5_M13_noxref_g \
 N_noxref_5_M20_noxref_g N_noxref_5_M21_noxref_g N_noxref_5_M40_noxref_g \
 N_noxref_5_M41_noxref_g N_noxref_5_M44_noxref_g N_noxref_5_M45_noxref_g \
 N_noxref_5_c_1720_p N_noxref_5_c_1722_p N_noxref_5_c_1747_p \
 N_noxref_5_c_1748_p N_noxref_5_c_1580_n N_noxref_5_c_1581_n \
 N_noxref_5_c_1582_n N_noxref_5_c_1583_n N_noxref_5_c_1461_n \
 N_noxref_5_c_1505_n N_noxref_5_c_1506_n N_noxref_5_c_1507_n \
 N_noxref_5_c_1639_p N_noxref_5_c_1640_p N_noxref_5_c_1641_p \
 N_noxref_5_c_1642_p N_noxref_5_c_1588_n N_noxref_5_c_1591_n \
 N_noxref_5_c_1787_p N_noxref_5_c_1788_p N_noxref_5_c_1593_n \
 N_noxref_5_c_1594_n N_noxref_5_c_1595_n N_noxref_5_c_1596_n \
 N_noxref_5_c_1822_p N_noxref_5_c_1463_n N_noxref_5_c_1508_n \
 N_noxref_5_c_1511_n N_noxref_5_c_1512_n N_noxref_5_c_1602_n )  \
 PM_DFFSNRNX1_PCELL\%noxref_5
x_PM_DFFSNRNX1_PCELL\%noxref_6 ( N_noxref_6_c_1904_n N_noxref_6_c_1907_n \
 N_noxref_6_c_1913_n N_noxref_6_c_1914_n N_noxref_6_c_2028_p \
 N_noxref_6_c_2031_p N_noxref_6_c_2032_p N_noxref_6_c_2033_p \
 N_noxref_6_c_1918_n N_noxref_6_c_2034_p N_noxref_6_c_1954_n \
 N_noxref_6_c_1957_n N_noxref_6_c_1960_n N_noxref_6_c_1964_n \
 N_noxref_6_c_1979_n N_noxref_6_c_1991_n N_noxref_6_c_1919_n \
 N_noxref_6_c_1920_n N_noxref_6_c_1924_n N_noxref_6_c_2029_p \
 N_noxref_6_c_2039_p N_noxref_6_M7_noxref_g N_noxref_6_M16_noxref_g \
 N_noxref_6_M32_noxref_g N_noxref_6_M33_noxref_g N_noxref_6_M50_noxref_g \
 N_noxref_6_M51_noxref_g N_noxref_6_c_1931_n N_noxref_6_c_1934_n \
 N_noxref_6_c_2111_p N_noxref_6_c_2112_p N_noxref_6_c_1936_n \
 N_noxref_6_c_1937_n N_noxref_6_c_1938_n N_noxref_6_c_1939_n \
 N_noxref_6_c_1974_n N_noxref_6_c_2157_p N_noxref_6_c_2159_p \
 N_noxref_6_c_2183_p N_noxref_6_c_2184_p N_noxref_6_c_2077_p \
 N_noxref_6_c_2078_p N_noxref_6_c_2079_p N_noxref_6_c_2030_p \
 N_noxref_6_c_2094_p N_noxref_6_c_1942_n N_noxref_6_c_2040_p )  \
 PM_DFFSNRNX1_PCELL\%noxref_6
x_PM_DFFSNRNX1_PCELL\%noxref_7 ( N_noxref_7_c_2313_n N_noxref_7_c_2236_n \
 N_noxref_7_c_2318_n N_noxref_7_c_2241_n N_noxref_7_c_2248_n \
 N_noxref_7_c_2243_n N_noxref_7_c_2256_n N_noxref_7_c_2245_n \
 N_noxref_7_c_2264_n N_noxref_7_c_2332_n N_noxref_7_c_2459_n \
 N_noxref_7_c_2461_n N_noxref_7_c_2465_n N_noxref_7_c_2473_n \
 N_noxref_7_c_2478_n N_noxref_7_c_2265_n N_noxref_7_c_2333_n \
 N_noxref_7_c_2400_n N_noxref_7_c_2334_n N_noxref_7_c_2532_n \
 N_noxref_7_c_2535_n N_noxref_7_c_2541_n N_noxref_7_c_2542_n \
 N_noxref_7_c_2335_n N_noxref_7_c_2266_n N_noxref_7_c_2267_n \
 N_noxref_7_c_2337_n N_noxref_7_c_2494_n N_noxref_7_c_2498_n \
 N_noxref_7_c_2546_n N_noxref_7_c_2272_n N_noxref_7_c_2405_n \
 N_noxref_7_c_2407_n N_noxref_7_c_2347_n N_noxref_7_c_2246_n \
 N_noxref_7_c_2274_n N_noxref_7_c_2351_n N_noxref_7_c_2355_n \
 N_noxref_7_c_2275_n N_noxref_7_c_2276_n N_noxref_7_c_2280_n \
 N_noxref_7_c_2358_n N_noxref_7_c_2506_n N_noxref_7_c_2565_n \
 N_noxref_7_c_2569_n N_noxref_7_M5_noxref_g N_noxref_7_M8_noxref_g \
 N_noxref_7_M17_noxref_g N_noxref_7_M28_noxref_g N_noxref_7_M29_noxref_g \
 N_noxref_7_M34_noxref_g N_noxref_7_M35_noxref_g N_noxref_7_M52_noxref_g \
 N_noxref_7_M53_noxref_g N_noxref_7_c_2365_n N_noxref_7_c_2366_n \
 N_noxref_7_c_2367_n N_noxref_7_c_2436_n N_noxref_7_c_2438_n \
 N_noxref_7_c_2442_n N_noxref_7_c_2444_n N_noxref_7_c_2289_n \
 N_noxref_7_c_2291_n N_noxref_7_c_2294_n N_noxref_7_c_2295_n \
 N_noxref_7_c_2297_n N_noxref_7_c_2301_n N_noxref_7_c_2303_n \
 N_noxref_7_c_2581_n N_noxref_7_c_2582_n N_noxref_7_c_2583_n \
 N_noxref_7_c_2755_p N_noxref_7_c_2756_p N_noxref_7_c_2734_p \
 N_noxref_7_c_2720_p N_noxref_7_c_2368_n N_noxref_7_c_2371_n \
 N_noxref_7_c_2372_n N_noxref_7_c_2307_n N_noxref_7_c_2308_n \
 N_noxref_7_c_2310_n N_noxref_7_c_2592_n N_noxref_7_c_2595_n \
 N_noxref_7_c_2596_n N_noxref_7_M11_noxref_d N_noxref_7_M36_noxref_d \
 N_noxref_7_M38_noxref_d N_noxref_7_M40_noxref_d )  PM_DFFSNRNX1_PCELL\%noxref_7
x_PM_DFFSNRNX1_PCELL\%noxref_8 ( N_noxref_8_c_2794_n N_noxref_8_c_2803_n \
 N_noxref_8_c_2805_n N_noxref_8_c_2808_n N_noxref_8_c_2812_n \
 N_noxref_8_c_2816_n N_noxref_8_c_2817_n N_noxref_8_c_2907_n \
 N_noxref_8_c_2939_n N_noxref_8_c_2943_n N_noxref_8_c_2819_n \
 N_noxref_8_c_2868_n N_noxref_8_c_2872_n N_noxref_8_c_2876_n \
 N_noxref_8_c_2877_n N_noxref_8_c_2909_n N_noxref_8_c_2982_n \
 N_noxref_8_c_3027_n N_noxref_8_c_2944_n N_noxref_8_c_2984_n \
 N_noxref_8_c_3078_p N_noxref_8_c_3097_p N_noxref_8_c_3136_p \
 N_noxref_8_c_2996_n N_noxref_8_c_3028_n N_noxref_8_c_3030_n \
 N_noxref_8_c_2821_n N_noxref_8_c_2827_n N_noxref_8_c_2881_n \
 N_noxref_8_c_2954_n N_noxref_8_c_3044_n N_noxref_8_M18_noxref_s \
 N_noxref_8_M19_noxref_d N_noxref_8_M21_noxref_d N_noxref_8_M23_noxref_d \
 N_noxref_8_M24_noxref_s N_noxref_8_M25_noxref_d N_noxref_8_M27_noxref_d \
 N_noxref_8_M29_noxref_d N_noxref_8_M30_noxref_s N_noxref_8_M31_noxref_d \
 N_noxref_8_M33_noxref_d N_noxref_8_M35_noxref_d N_noxref_8_M36_noxref_s \
 N_noxref_8_M37_noxref_d N_noxref_8_M39_noxref_d N_noxref_8_M41_noxref_d \
 N_noxref_8_M42_noxref_s N_noxref_8_M43_noxref_d N_noxref_8_M45_noxref_d \
 N_noxref_8_M47_noxref_d N_noxref_8_M48_noxref_s N_noxref_8_M49_noxref_d \
 N_noxref_8_M51_noxref_d N_noxref_8_M53_noxref_d )  PM_DFFSNRNX1_PCELL\%noxref_8
x_PM_DFFSNRNX1_PCELL\%noxref_9 ( N_noxref_9_c_3188_n N_noxref_9_c_3186_n \
 N_noxref_9_c_3198_n N_noxref_9_c_3201_n N_noxref_9_M0_noxref_g \
 N_noxref_9_M18_noxref_g N_noxref_9_M19_noxref_g N_noxref_9_c_3207_n \
 N_noxref_9_c_3208_n N_noxref_9_c_3209_n N_noxref_9_c_3210_n \
 N_noxref_9_c_3235_p N_noxref_9_c_3243_p N_noxref_9_c_3213_n \
 N_noxref_9_c_3215_n N_noxref_9_c_3184_n N_noxref_9_c_3221_n )  \
 PM_DFFSNRNX1_PCELL\%noxref_9
x_PM_DFFSNRNX1_PCELL\%noxref_10 ( N_noxref_10_c_3292_n N_noxref_10_c_3312_p \
 N_noxref_10_c_3271_n N_noxref_10_c_3314_p N_noxref_10_c_3274_n \
 N_noxref_10_M1_noxref_d N_noxref_10_M2_noxref_s )  \
 PM_DFFSNRNX1_PCELL\%noxref_10
x_PM_DFFSNRNX1_PCELL\%noxref_11 ( N_noxref_11_c_3341_n N_noxref_11_c_3382_p \
 N_noxref_11_c_3356_n N_noxref_11_c_3384_p N_noxref_11_c_3359_n \
 N_noxref_11_M4_noxref_d N_noxref_11_M5_noxref_s )  \
 PM_DFFSNRNX1_PCELL\%noxref_11
x_PM_DFFSNRNX1_PCELL\%noxref_12 ( N_noxref_12_c_3422_n N_noxref_12_c_3453_p \
 N_noxref_12_c_3410_n N_noxref_12_c_3455_p N_noxref_12_c_3413_n \
 N_noxref_12_M7_noxref_d N_noxref_12_M8_noxref_s )  \
 PM_DFFSNRNX1_PCELL\%noxref_12
x_PM_DFFSNRNX1_PCELL\%noxref_13 ( N_noxref_13_c_3482_n N_noxref_13_c_3523_p \
 N_noxref_13_c_3498_n N_noxref_13_c_3525_p N_noxref_13_c_3503_n \
 N_noxref_13_M10_noxref_d N_noxref_13_M11_noxref_s )  \
 PM_DFFSNRNX1_PCELL\%noxref_13
x_PM_DFFSNRNX1_PCELL\%noxref_14 ( N_noxref_14_c_3551_n N_noxref_14_c_3592_p \
 N_noxref_14_c_3571_p N_noxref_14_c_3594_p N_noxref_14_c_3575_p \
 N_noxref_14_M13_noxref_d N_noxref_14_M14_noxref_s )  \
 PM_DFFSNRNX1_PCELL\%noxref_14
x_PM_DFFSNRNX1_PCELL\%noxref_15 ( N_noxref_15_c_3622_n N_noxref_15_c_3620_n \
 N_noxref_15_c_3631_n N_noxref_15_c_3634_n N_noxref_15_M14_noxref_g \
 N_noxref_15_M46_noxref_g N_noxref_15_M47_noxref_g N_noxref_15_c_3640_n \
 N_noxref_15_c_3641_n N_noxref_15_c_3642_n N_noxref_15_c_3678_p \
 N_noxref_15_c_3679_p N_noxref_15_c_3666_n N_noxref_15_c_3668_n \
 N_noxref_15_c_3643_n N_noxref_15_c_3646_n N_noxref_15_c_3647_n )  \
 PM_DFFSNRNX1_PCELL\%noxref_15
x_PM_DFFSNRNX1_PCELL\%noxref_16 ( N_noxref_16_c_3714_n N_noxref_16_c_3726_n \
 N_noxref_16_c_3758_n N_noxref_16_c_3743_n N_noxref_16_c_3738_n \
 N_noxref_16_c_3794_n N_noxref_16_c_3795_n N_noxref_16_c_3739_n \
 N_noxref_16_c_3727_n N_noxref_16_c_3715_n N_noxref_16_c_3728_n \
 N_noxref_16_c_3825_n N_noxref_16_c_3718_n N_noxref_16_c_3734_n \
 N_noxref_16_c_3785_n N_noxref_16_M14_noxref_d N_noxref_16_M42_noxref_d \
 N_noxref_16_M44_noxref_d N_noxref_16_M46_noxref_d )  \
 PM_DFFSNRNX1_PCELL\%noxref_16
x_PM_DFFSNRNX1_PCELL\%noxref_17 ( N_noxref_17_c_4234_p N_noxref_17_c_4069_n \
 N_noxref_17_c_3852_n N_noxref_17_c_3856_n N_noxref_17_c_3962_n \
 N_noxref_17_c_3859_n N_noxref_17_c_3922_n N_noxref_17_c_3926_n \
 N_noxref_17_c_3963_n N_noxref_17_c_3969_n N_noxref_17_c_4015_n \
 N_noxref_17_c_4196_p N_noxref_17_c_4033_n N_noxref_17_c_4060_n \
 N_noxref_17_c_3862_n N_noxref_17_c_3873_n N_noxref_17_c_3929_n \
 N_noxref_17_c_3973_n N_noxref_17_c_4034_n N_noxref_17_c_3883_n \
 N_noxref_17_c_4062_n N_noxref_17_c_3885_n N_noxref_17_c_3886_n \
 N_noxref_17_c_3942_n N_noxref_17_c_3986_n N_noxref_17_c_4050_n \
 N_noxref_17_c_3887_n N_noxref_17_c_3900_n N_noxref_17_c_3943_n \
 N_noxref_17_c_3994_n N_noxref_17_c_4037_n N_noxref_17_M0_noxref_d \
 N_noxref_17_M3_noxref_d N_noxref_17_M6_noxref_d N_noxref_17_M9_noxref_d \
 N_noxref_17_M12_noxref_d N_noxref_17_M15_noxref_d )  \
 PM_DFFSNRNX1_PCELL\%noxref_17
x_PM_DFFSNRNX1_PCELL\%noxref_18 ( N_noxref_18_c_4352_n N_noxref_18_c_4356_n \
 N_noxref_18_c_4364_n N_noxref_18_c_4368_n N_noxref_18_M15_noxref_g \
 N_noxref_18_M48_noxref_g N_noxref_18_M49_noxref_g N_noxref_18_c_4374_n \
 N_noxref_18_c_4375_n N_noxref_18_c_4376_n N_noxref_18_c_4377_n \
 N_noxref_18_c_4422_n N_noxref_18_c_4425_n N_noxref_18_c_4380_n \
 N_noxref_18_c_4382_n N_noxref_18_c_4385_n N_noxref_18_c_4388_n )  \
 PM_DFFSNRNX1_PCELL\%noxref_18
x_PM_DFFSNRNX1_PCELL\%noxref_19 ( N_noxref_19_c_4451_n N_noxref_19_c_4483_n \
 N_noxref_19_c_4468_n N_noxref_19_c_4487_n N_noxref_19_c_4473_n \
 N_noxref_19_M16_noxref_d N_noxref_19_M17_noxref_s )  \
 PM_DFFSNRNX1_PCELL\%noxref_19
x_PM_DFFSNRNX1_PCELL\%noxref_20 ( N_noxref_20_c_4514_n N_noxref_20_c_4519_n \
 N_noxref_20_c_4535_n N_noxref_20_c_4537_n N_noxref_20_c_4542_n \
 N_noxref_20_c_4548_n N_noxref_20_c_4553_n N_noxref_20_c_4618_n \
 N_noxref_20_c_4520_n N_noxref_20_c_4565_n N_noxref_20_c_4522_n \
 N_noxref_20_c_4567_n N_noxref_20_c_4604_n N_noxref_20_c_4528_n \
 N_noxref_20_c_4570_n N_noxref_20_M17_noxref_d N_noxref_20_M48_noxref_d \
 N_noxref_20_M50_noxref_d N_noxref_20_M52_noxref_d )  \
 PM_DFFSNRNX1_PCELL\%noxref_20
x_PM_DFFSNRNX1_PCELL\%noxref_21 ( N_noxref_21_c_4654_n N_noxref_21_c_4655_n \
 N_noxref_21_c_4666_n N_noxref_21_c_4643_n N_noxref_21_c_4645_n \
 N_noxref_21_M0_noxref_s )  PM_DFFSNRNX1_PCELL\%noxref_21
x_PM_DFFSNRNX1_PCELL\%noxref_22 ( N_noxref_22_c_4696_n N_noxref_22_c_4697_n \
 N_noxref_22_c_4724_n N_noxref_22_c_4708_n N_noxref_22_c_4710_n \
 N_noxref_22_M3_noxref_s )  PM_DFFSNRNX1_PCELL\%noxref_22
x_PM_DFFSNRNX1_PCELL\%noxref_23 ( N_noxref_23_c_4754_n N_noxref_23_c_4755_n \
 N_noxref_23_c_4783_n N_noxref_23_c_4770_n N_noxref_23_c_4768_n \
 N_noxref_23_M6_noxref_s )  PM_DFFSNRNX1_PCELL\%noxref_23
x_PM_DFFSNRNX1_PCELL\%noxref_24 ( N_noxref_24_c_4813_n N_noxref_24_c_4814_n \
 N_noxref_24_c_4843_n N_noxref_24_c_4825_n N_noxref_24_c_4827_n \
 N_noxref_24_M9_noxref_s )  PM_DFFSNRNX1_PCELL\%noxref_24
x_PM_DFFSNRNX1_PCELL\%noxref_25 ( N_noxref_25_c_4873_n N_noxref_25_c_4874_n \
 N_noxref_25_c_4902_n N_noxref_25_c_4887_n N_noxref_25_c_4889_n \
 N_noxref_25_M12_noxref_s )  PM_DFFSNRNX1_PCELL\%noxref_25
x_PM_DFFSNRNX1_PCELL\%noxref_26 ( N_noxref_26_c_4932_n N_noxref_26_c_4933_n \
 N_noxref_26_c_4955_n N_noxref_26_c_4934_n N_noxref_26_c_4936_n \
 N_noxref_26_M15_noxref_s )  PM_DFFSNRNX1_PCELL\%noxref_26
cc_1 ( N_noxref_1_M31_noxref_g N_noxref_2_c_407_n ) capacitor c=0.00893512f \
 //x=11.37 //y=6.02 //x2=11.91 //y2=5.155
cc_2 ( N_noxref_1_M30_noxref_g N_noxref_2_c_408_n ) capacitor c=0.00461408f \
 //x=10.93 //y=6.02 //x2=11.152 //y2=5.155
cc_3 ( N_noxref_1_M31_noxref_g N_noxref_2_c_408_n ) capacitor c=0.00229208f \
 //x=11.37 //y=6.02 //x2=11.152 //y2=5.155
cc_4 ( N_noxref_1_c_4_p N_noxref_2_c_408_n ) capacitor c=0.00171885f \
 //x=11.295 //y=4.79 //x2=11.152 //y2=5.155
cc_5 ( N_noxref_1_c_5_p N_noxref_2_c_411_n ) capacitor c=4.2553e-19 //x=10.73 \
 //y=2.59 //x2=13.69 //y2=2.59
cc_6 ( N_noxref_1_M30_noxref_g N_noxref_2_c_412_n ) capacitor c=0.0162284f \
 //x=10.93 //y=6.02 //x2=11.15 //y2=5.38
cc_7 ( N_noxref_1_M31_noxref_g N_noxref_2_c_412_n ) capacitor c=0.0179041f \
 //x=11.37 //y=6.02 //x2=11.15 //y2=5.38
cc_8 ( N_noxref_1_c_4_p N_noxref_2_c_412_n ) capacitor c=0.00291477f \
 //x=11.295 //y=4.79 //x2=11.15 //y2=5.38
cc_9 ( N_noxref_1_c_9_p N_noxref_3_c_696_n ) capacitor c=0.00932261f //x=5.92 \
 //y=2.195 //x2=7.03 //y2=2.195
cc_10 ( N_noxref_1_c_10_p N_noxref_3_c_696_n ) capacitor c=5.40058e-19 \
 //x=5.92 //y=2.08 //x2=7.03 //y2=2.195
cc_11 ( N_noxref_1_c_11_p N_noxref_3_c_696_n ) capacitor c=0.00142893f \
 //x=5.62 //y=1.915 //x2=7.03 //y2=2.195
cc_12 ( N_noxref_1_c_12_p N_noxref_3_c_699_n ) capacitor c=3.44709e-19 \
 //x=4.07 //y=2.445 //x2=7.03 //y2=4.495
cc_13 ( N_noxref_1_c_13_p N_noxref_3_c_699_n ) capacitor c=0.00151589f \
 //x=4.07 //y=5.07 //x2=7.03 //y2=4.495
cc_14 ( N_noxref_1_c_14_p N_noxref_3_c_699_n ) capacitor c=0.00510083f \
 //x=5.92 //y=2.445 //x2=7.03 //y2=4.495
cc_15 ( N_noxref_1_c_15_p N_noxref_3_c_699_n ) capacitor c=0.00782284f \
 //x=5.92 //y=2.765 //x2=7.03 //y2=4.495
cc_16 ( N_noxref_1_c_16_p N_noxref_3_c_699_n ) capacitor c=0.0499082f //x=5.92 \
 //y=4.575 //x2=7.03 //y2=4.495
cc_17 ( N_noxref_1_c_17_p N_noxref_3_c_699_n ) capacitor c=4.11345e-19 \
 //x=5.92 //y=2.59 //x2=7.03 //y2=4.495
cc_18 ( N_noxref_1_c_18_p N_noxref_3_c_699_n ) capacitor c=0.00248676f \
 //x=6.085 //y=2.605 //x2=7.03 //y2=4.495
cc_19 ( N_noxref_1_c_19_p N_noxref_3_c_699_n ) capacitor c=0.0255817f \
 //x=10.57 //y=2.605 //x2=7.03 //y2=4.495
cc_20 ( N_noxref_1_c_10_p N_noxref_3_c_699_n ) capacitor c=3.9149e-19 //x=5.92 \
 //y=2.08 //x2=7.03 //y2=4.495
cc_21 ( N_noxref_1_c_16_p N_noxref_3_c_708_n ) capacitor c=0.0091087f //x=5.92 \
 //y=4.575 //x2=7.025 //y2=4.655
cc_22 ( N_noxref_1_c_22_p N_noxref_3_c_708_n ) capacitor c=6.32742e-19 \
 //x=5.92 //y=4.7 //x2=7.025 //y2=4.655
cc_23 ( N_noxref_1_c_23_p N_noxref_3_c_708_n ) capacitor c=7.15803e-19 \
 //x=6.485 //y=4.79 //x2=7.025 //y2=4.655
cc_24 ( N_noxref_1_c_24_p N_noxref_3_c_708_n ) capacitor c=8.67242e-19 \
 //x=6.195 //y=4.79 //x2=7.025 //y2=4.655
cc_25 ( N_noxref_1_c_25_p N_noxref_3_c_712_n ) capacitor c=0.0356055f \
 //x=10.73 //y=4.575 //x2=16.495 //y2=4.44
cc_26 ( N_noxref_1_c_16_p N_noxref_3_c_713_n ) capacitor c=0.0102588f //x=5.92 \
 //y=4.575 //x2=7.025 //y2=4.44
cc_27 ( N_noxref_1_c_19_p N_noxref_3_c_713_n ) capacitor c=0.001423f //x=10.57 \
 //y=2.605 //x2=7.025 //y2=4.44
cc_28 ( N_noxref_1_c_9_p N_noxref_3_c_715_n ) capacitor c=5.39999e-19 //x=5.92 \
 //y=2.195 //x2=7.03 //y2=2.08
cc_29 ( N_noxref_1_c_14_p N_noxref_3_c_715_n ) capacitor c=3.9149e-19 //x=5.92 \
 //y=2.445 //x2=7.03 //y2=2.08
cc_30 ( N_noxref_1_c_10_p N_noxref_3_c_715_n ) capacitor c=0.00125213f \
 //x=5.92 //y=2.08 //x2=7.03 //y2=2.08
cc_31 ( N_noxref_1_c_11_p N_noxref_3_c_715_n ) capacitor c=0.00214573f \
 //x=5.62 //y=1.915 //x2=7.03 //y2=2.08
cc_32 ( N_noxref_1_c_16_p N_noxref_3_c_719_n ) capacitor c=5.64453e-19 \
 //x=5.92 //y=4.575 //x2=7.03 //y2=4.7
cc_33 ( N_noxref_1_c_22_p N_noxref_3_c_719_n ) capacitor c=0.00113666f \
 //x=5.92 //y=4.7 //x2=7.03 //y2=4.7
cc_34 ( N_noxref_1_c_23_p N_noxref_3_c_719_n ) capacitor c=0.00116563f \
 //x=6.485 //y=4.79 //x2=7.03 //y2=4.7
cc_35 ( N_noxref_1_c_24_p N_noxref_3_c_719_n ) capacitor c=0.0012974f \
 //x=6.195 //y=4.79 //x2=7.03 //y2=4.7
cc_36 ( N_noxref_1_M24_noxref_g N_noxref_3_M26_noxref_g ) capacitor \
 c=0.0106276f //x=6.12 //y=6.02 //x2=7 //y2=6.02
cc_37 ( N_noxref_1_M25_noxref_g N_noxref_3_M26_noxref_g ) capacitor \
 c=0.107144f //x=6.56 //y=6.02 //x2=7 //y2=6.02
cc_38 ( N_noxref_1_M25_noxref_g N_noxref_3_M27_noxref_g ) capacitor \
 c=0.0101598f //x=6.56 //y=6.02 //x2=7.44 //y2=6.02
cc_39 ( N_noxref_1_c_39_p N_noxref_3_c_726_n ) capacitor c=5.72528e-19 \
 //x=5.62 //y=0.875 //x2=6.595 //y2=0.91
cc_40 ( N_noxref_1_c_40_p N_noxref_3_c_726_n ) capacitor c=0.00150277f \
 //x=5.62 //y=1.22 //x2=6.595 //y2=0.91
cc_41 ( N_noxref_1_c_41_p N_noxref_3_c_726_n ) capacitor c=0.0160123f //x=6.15 \
 //y=0.875 //x2=6.595 //y2=0.91
cc_42 ( N_noxref_1_c_42_p N_noxref_3_c_729_n ) capacitor c=0.00111227f \
 //x=5.62 //y=1.53 //x2=6.595 //y2=1.22
cc_43 ( N_noxref_1_c_43_p N_noxref_3_c_729_n ) capacitor c=0.0124075f //x=6.15 \
 //y=1.22 //x2=6.595 //y2=1.22
cc_44 ( N_noxref_1_c_41_p N_noxref_3_c_731_n ) capacitor c=9.19165e-19 \
 //x=6.15 //y=0.875 //x2=7.12 //y2=0.91
cc_45 ( N_noxref_1_c_43_p N_noxref_3_c_732_n ) capacitor c=0.0010154f //x=6.15 \
 //y=1.22 //x2=7.12 //y2=1.22
cc_46 ( N_noxref_1_c_43_p N_noxref_3_c_733_n ) capacitor c=9.23422e-19 \
 //x=6.15 //y=1.22 //x2=7.12 //y2=1.45
cc_47 ( N_noxref_1_c_9_p N_noxref_3_c_734_n ) capacitor c=0.00136403f //x=5.92 \
 //y=2.195 //x2=7.12 //y2=1.915
cc_48 ( N_noxref_1_c_10_p N_noxref_3_c_734_n ) capacitor c=0.0020754f //x=5.92 \
 //y=2.08 //x2=7.12 //y2=1.915
cc_49 ( N_noxref_1_c_11_p N_noxref_3_c_734_n ) capacitor c=0.00964411f \
 //x=5.62 //y=1.915 //x2=7.12 //y2=1.915
cc_50 ( N_noxref_1_c_22_p N_noxref_3_c_737_n ) capacitor c=0.00123917f \
 //x=5.92 //y=4.7 //x2=7.03 //y2=4.7
cc_51 ( N_noxref_1_c_23_p N_noxref_3_c_737_n ) capacitor c=0.0169508f \
 //x=6.485 //y=4.79 //x2=7.03 //y2=4.7
cc_52 ( N_noxref_1_c_24_p N_noxref_3_c_737_n ) capacitor c=0.00406071f \
 //x=6.195 //y=4.79 //x2=7.03 //y2=4.7
cc_53 ( N_noxref_1_c_12_p N_noxref_4_c_976_n ) capacitor c=0.0139504f //x=4.07 \
 //y=2.445 //x2=3.33 //y2=2.195
cc_54 ( N_noxref_1_c_12_p N_noxref_4_c_977_n ) capacitor c=0.00894987f \
 //x=4.07 //y=2.445 //x2=3.33 //y2=3.175
cc_55 ( N_noxref_1_c_55_p N_noxref_4_c_977_n ) capacitor c=0.014957f //x=4.07 \
 //y=2.765 //x2=3.33 //y2=3.175
cc_56 ( N_noxref_1_c_13_p N_noxref_4_c_977_n ) capacitor c=0.0194668f //x=4.07 \
 //y=5.07 //x2=3.33 //y2=3.175
cc_57 ( N_noxref_1_c_14_p N_noxref_4_c_977_n ) capacitor c=4.63723e-19 \
 //x=5.92 //y=2.445 //x2=3.33 //y2=3.175
cc_58 ( N_noxref_1_c_16_p N_noxref_4_c_977_n ) capacitor c=4.18822e-19 \
 //x=5.92 //y=4.575 //x2=3.33 //y2=3.175
cc_59 ( N_noxref_1_c_59_p N_noxref_4_c_977_n ) capacitor c=7.6985e-19 //x=4.07 \
 //y=2.59 //x2=3.33 //y2=3.175
cc_60 ( N_noxref_1_c_60_p N_noxref_4_c_977_n ) capacitor c=0.00692765f \
 //x=4.235 //y=2.605 //x2=3.33 //y2=3.175
cc_61 ( N_noxref_1_c_61_p N_noxref_4_c_984_n ) capacitor c=0.00100392f \
 //x=3.985 //y=5.155 //x2=3.33 //y2=3.495
cc_62 ( N_noxref_1_c_62_p N_noxref_4_c_984_n ) capacitor c=2.35691e-19 \
 //x=3.585 //y=1.125 //x2=3.33 //y2=3.495
cc_63 ( N_noxref_1_c_63_p N_noxref_4_c_984_n ) capacitor c=0.00102808f \
 //x=3.67 //y=1.665 //x2=3.33 //y2=3.495
cc_64 ( N_noxref_1_c_13_p N_noxref_4_c_984_n ) capacitor c=0.0174568f //x=4.07 \
 //y=5.07 //x2=3.33 //y2=3.495
cc_65 ( N_noxref_1_c_65_p N_noxref_4_c_984_n ) capacitor c=5.92579e-19 \
 //x=3.29 //y=5.155 //x2=3.33 //y2=3.495
cc_66 ( N_noxref_1_c_61_p N_noxref_4_c_989_n ) capacitor c=0.00239349f \
 //x=3.985 //y=5.155 //x2=3.33 //y2=4.57
cc_67 ( N_noxref_1_c_13_p N_noxref_4_c_989_n ) capacitor c=0.0649554f //x=4.07 \
 //y=5.07 //x2=3.33 //y2=4.57
cc_68 ( N_noxref_1_c_16_p N_noxref_4_c_989_n ) capacitor c=0.00210144f \
 //x=5.92 //y=4.575 //x2=3.33 //y2=4.57
cc_69 ( N_noxref_1_c_65_p N_noxref_4_c_989_n ) capacitor c=0.0228871f //x=3.29 \
 //y=5.155 //x2=3.33 //y2=4.57
cc_70 ( N_noxref_1_c_70_p N_noxref_4_c_989_n ) capacitor c=0.00217653f \
 //x=3.29 //y=5.38 //x2=3.33 //y2=4.57
cc_71 ( N_noxref_1_M25_noxref_g N_noxref_4_c_994_n ) capacitor c=0.0109353f \
 //x=6.56 //y=6.02 //x2=7.1 //y2=5.155
cc_72 ( N_noxref_1_c_72_p N_noxref_4_c_995_n ) capacitor c=0.00163399f \
 //x=3.985 //y=1.665 //x2=8.48 //y2=1.665
cc_73 ( N_noxref_1_c_73_p N_noxref_4_c_996_n ) capacitor c=0.00357748f \
 //x=10.73 //y=2.195 //x2=8.88 //y2=3.155
cc_74 ( N_noxref_1_c_74_p N_noxref_4_c_996_n ) capacitor c=0.00243104f \
 //x=10.73 //y=2.445 //x2=8.88 //y2=3.155
cc_75 ( N_noxref_1_c_75_p N_noxref_4_c_996_n ) capacitor c=0.00248785f \
 //x=10.73 //y=2.765 //x2=8.88 //y2=3.155
cc_76 ( N_noxref_1_c_25_p N_noxref_4_c_996_n ) capacitor c=0.00734525f \
 //x=10.73 //y=4.575 //x2=8.88 //y2=3.155
cc_77 ( N_noxref_1_c_77_p N_noxref_4_c_996_n ) capacitor c=0.00159838f \
 //x=10.73 //y=2.605 //x2=8.88 //y2=3.155
cc_78 ( N_noxref_1_c_19_p N_noxref_4_c_996_n ) capacitor c=0.0252332f \
 //x=10.57 //y=2.605 //x2=8.88 //y2=3.155
cc_79 ( N_noxref_1_c_25_p N_noxref_4_c_1002_n ) capacitor c=0.00254697f \
 //x=10.73 //y=4.575 //x2=8.88 //y2=3.475
cc_80 ( N_noxref_1_c_19_p N_noxref_4_c_1002_n ) capacitor c=0.00511475f \
 //x=10.57 //y=2.605 //x2=8.88 //y2=3.475
cc_81 ( N_noxref_1_c_25_p N_noxref_4_c_1004_n ) capacitor c=0.019152f \
 //x=10.73 //y=4.575 //x2=8.88 //y2=5.07
cc_82 ( N_noxref_1_c_13_p N_noxref_4_c_1005_n ) capacitor c=6.89957e-19 \
 //x=4.07 //y=5.07 //x2=3.33 //y2=3.33
cc_83 ( N_noxref_1_c_83_p N_noxref_4_c_1006_n ) capacitor c=6.09703e-19 \
 //x=3.29 //y=5.38 //x2=6.342 //y2=5.155
cc_84 ( N_noxref_1_c_61_p N_noxref_4_c_1006_n ) capacitor c=0.00306432f \
 //x=3.985 //y=5.155 //x2=6.342 //y2=5.155
cc_85 ( N_noxref_1_M24_noxref_g N_noxref_4_c_1006_n ) capacitor c=0.00461408f \
 //x=6.12 //y=6.02 //x2=6.342 //y2=5.155
cc_86 ( N_noxref_1_M25_noxref_g N_noxref_4_c_1006_n ) capacitor c=0.00229208f \
 //x=6.56 //y=6.02 //x2=6.342 //y2=5.155
cc_87 ( N_noxref_1_c_23_p N_noxref_4_c_1006_n ) capacitor c=0.00171885f \
 //x=6.485 //y=4.79 //x2=6.342 //y2=5.155
cc_88 ( N_noxref_1_c_75_p N_noxref_4_c_1011_n ) capacitor c=0.00481573f \
 //x=10.73 //y=2.765 //x2=20.185 //y2=3.33
cc_89 ( N_noxref_1_c_25_p N_noxref_4_c_1011_n ) capacitor c=0.0266779f \
 //x=10.73 //y=4.575 //x2=20.185 //y2=3.33
cc_90 ( N_noxref_1_c_77_p N_noxref_4_c_1011_n ) capacitor c=0.01611f //x=10.73 \
 //y=2.605 //x2=20.185 //y2=3.33
cc_91 ( N_noxref_1_c_19_p N_noxref_4_c_1011_n ) capacitor c=0.0688583f \
 //x=10.57 //y=2.605 //x2=20.185 //y2=3.33
cc_92 ( N_noxref_1_c_61_p N_noxref_4_c_1015_n ) capacitor c=0.00108711f \
 //x=3.985 //y=5.155 //x2=3.5 //y2=3.335
cc_93 ( N_noxref_1_c_13_p N_noxref_4_c_1015_n ) capacitor c=0.00330634f \
 //x=4.07 //y=5.07 //x2=3.5 //y2=3.335
cc_94 ( N_noxref_1_c_65_p N_noxref_4_c_1015_n ) capacitor c=3.8367e-19 \
 //x=3.29 //y=5.155 //x2=3.5 //y2=3.335
cc_95 ( N_noxref_1_c_61_p N_noxref_4_c_1018_n ) capacitor c=0.00767625f \
 //x=3.985 //y=5.155 //x2=8.72 //y2=3.315
cc_96 ( N_noxref_1_c_55_p N_noxref_4_c_1018_n ) capacitor c=0.00653648f \
 //x=4.07 //y=2.765 //x2=8.72 //y2=3.315
cc_97 ( N_noxref_1_c_13_p N_noxref_4_c_1018_n ) capacitor c=0.0310758f \
 //x=4.07 //y=5.07 //x2=8.72 //y2=3.315
cc_98 ( N_noxref_1_c_15_p N_noxref_4_c_1018_n ) capacitor c=0.00471438f \
 //x=5.92 //y=2.765 //x2=8.72 //y2=3.315
cc_99 ( N_noxref_1_c_16_p N_noxref_4_c_1018_n ) capacitor c=0.0342389f \
 //x=5.92 //y=4.575 //x2=8.72 //y2=3.315
cc_100 ( N_noxref_1_c_60_p N_noxref_4_c_1018_n ) capacitor c=0.0162295f \
 //x=4.235 //y=2.605 //x2=8.72 //y2=3.315
cc_101 ( N_noxref_1_c_101_p N_noxref_4_c_1018_n ) capacitor c=0.0708269f \
 //x=5.765 //y=2.605 //x2=8.72 //y2=3.315
cc_102 ( N_noxref_1_c_18_p N_noxref_4_c_1018_n ) capacitor c=0.0162295f \
 //x=6.085 //y=2.605 //x2=8.72 //y2=3.315
cc_103 ( N_noxref_1_c_19_p N_noxref_4_c_1018_n ) capacitor c=0.115136f \
 //x=10.57 //y=2.605 //x2=8.72 //y2=3.315
cc_104 ( N_noxref_1_c_25_p N_noxref_4_c_1027_n ) capacitor c=0.00159838f \
 //x=10.73 //y=4.575 //x2=9.04 //y2=3.315
cc_105 ( N_noxref_1_c_19_p N_noxref_4_c_1027_n ) capacitor c=0.0161465f \
 //x=10.57 //y=2.605 //x2=9.04 //y2=3.315
cc_106 ( N_noxref_1_c_12_p N_noxref_4_c_1029_n ) capacitor c=0.0015536f \
 //x=4.07 //y=2.445 //x2=3.33 //y2=2.08
cc_107 ( N_noxref_1_c_61_p N_noxref_4_c_1030_n ) capacitor c=0.00130631f \
 //x=3.985 //y=5.155 //x2=3.33 //y2=4.7
cc_108 ( N_noxref_1_c_13_p N_noxref_4_c_1030_n ) capacitor c=0.00131258f \
 //x=4.07 //y=5.07 //x2=3.33 //y2=4.7
cc_109 ( N_noxref_1_c_65_p N_noxref_4_c_1030_n ) capacitor c=0.00346456f \
 //x=3.29 //y=5.155 //x2=3.33 //y2=4.7
cc_110 ( N_noxref_1_c_70_p N_noxref_4_c_1030_n ) capacitor c=0.00624059f \
 //x=3.29 //y=5.38 //x2=3.33 //y2=4.7
cc_111 ( N_noxref_1_M24_noxref_g N_noxref_4_c_1034_n ) capacitor c=0.0162284f \
 //x=6.12 //y=6.02 //x2=6.34 //y2=5.38
cc_112 ( N_noxref_1_M25_noxref_g N_noxref_4_c_1034_n ) capacitor c=0.0179041f \
 //x=6.56 //y=6.02 //x2=6.34 //y2=5.38
cc_113 ( N_noxref_1_c_23_p N_noxref_4_c_1034_n ) capacitor c=0.00291477f \
 //x=6.485 //y=4.79 //x2=6.34 //y2=5.38
cc_114 ( N_noxref_1_c_114_p N_noxref_4_M22_noxref_g ) capacitor c=0.0136936f \
 //x=3.175 //y=5.155 //x2=3.07 //y2=6.02
cc_115 ( N_noxref_1_c_83_p N_noxref_4_M22_noxref_g ) capacitor c=0.00226521f \
 //x=3.29 //y=5.38 //x2=3.07 //y2=6.02
cc_116 ( N_noxref_1_c_70_p N_noxref_4_M22_noxref_g ) capacitor c=0.0178885f \
 //x=3.29 //y=5.38 //x2=3.07 //y2=6.02
cc_117 ( N_noxref_1_c_83_p N_noxref_4_M23_noxref_g ) capacitor c=0.00381703f \
 //x=3.29 //y=5.38 //x2=3.51 //y2=6.02
cc_118 ( N_noxref_1_c_61_p N_noxref_4_M23_noxref_g ) capacitor c=0.011323f \
 //x=3.985 //y=5.155 //x2=3.51 //y2=6.02
cc_119 ( N_noxref_1_c_70_p N_noxref_4_M23_noxref_g ) capacitor c=0.0188608f \
 //x=3.29 //y=5.38 //x2=3.51 //y2=6.02
cc_120 ( N_noxref_1_c_62_p N_noxref_4_c_1043_n ) capacitor c=4.64015e-19 \
 //x=3.585 //y=1.125 //x2=3.32 //y2=0.915
cc_121 ( N_noxref_1_M2_noxref_d N_noxref_4_c_1043_n ) capacitor c=0.00137165f \
 //x=3.395 //y=0.915 //x2=3.32 //y2=0.915
cc_122 ( N_noxref_1_c_62_p N_noxref_4_c_1045_n ) capacitor c=0.0026012f \
 //x=3.585 //y=1.125 //x2=3.32 //y2=1.26
cc_123 ( N_noxref_1_c_123_p N_noxref_4_c_1045_n ) capacitor c=0.00127432f \
 //x=3.585 //y=1.58 //x2=3.32 //y2=1.26
cc_124 ( N_noxref_1_M2_noxref_d N_noxref_4_c_1045_n ) capacitor c=0.00237422f \
 //x=3.395 //y=0.915 //x2=3.32 //y2=1.26
cc_125 ( N_noxref_1_c_123_p N_noxref_4_c_1048_n ) capacitor c=0.00429966f \
 //x=3.585 //y=1.58 //x2=3.32 //y2=1.57
cc_126 ( N_noxref_1_c_62_p N_noxref_4_c_1049_n ) capacitor c=5.29969e-19 \
 //x=3.585 //y=1.125 //x2=3.695 //y2=0.76
cc_127 ( N_noxref_1_M2_noxref_d N_noxref_4_c_1049_n ) capacitor c=0.0020782f \
 //x=3.395 //y=0.915 //x2=3.695 //y2=0.76
cc_128 ( N_noxref_1_c_62_p N_noxref_4_c_1051_n ) capacitor c=5.00148e-19 \
 //x=3.585 //y=1.125 //x2=3.695 //y2=1.415
cc_129 ( N_noxref_1_c_123_p N_noxref_4_c_1051_n ) capacitor c=0.00942306f \
 //x=3.585 //y=1.58 //x2=3.695 //y2=1.415
cc_130 ( N_noxref_1_c_72_p N_noxref_4_c_1051_n ) capacitor c=0.00194716f \
 //x=3.985 //y=1.665 //x2=3.695 //y2=1.415
cc_131 ( N_noxref_1_M2_noxref_d N_noxref_4_c_1051_n ) capacitor c=0.00356097f \
 //x=3.395 //y=0.915 //x2=3.695 //y2=1.415
cc_132 ( N_noxref_1_c_62_p N_noxref_4_c_1055_n ) capacitor c=5.24634e-19 \
 //x=3.585 //y=1.125 //x2=3.85 //y2=0.915
cc_133 ( N_noxref_1_M2_noxref_d N_noxref_4_c_1055_n ) capacitor c=0.00139206f \
 //x=3.395 //y=0.915 //x2=3.85 //y2=0.915
cc_134 ( N_noxref_1_c_62_p N_noxref_4_c_1057_n ) capacitor c=0.00307978f \
 //x=3.585 //y=1.125 //x2=3.85 //y2=1.26
cc_135 ( N_noxref_1_c_123_p N_noxref_4_c_1057_n ) capacitor c=0.00363411f \
 //x=3.585 //y=1.58 //x2=3.85 //y2=1.26
cc_136 ( N_noxref_1_c_72_p N_noxref_4_c_1057_n ) capacitor c=0.00323576f \
 //x=3.985 //y=1.665 //x2=3.85 //y2=1.26
cc_137 ( N_noxref_1_M2_noxref_d N_noxref_4_c_1057_n ) capacitor c=0.00237422f \
 //x=3.395 //y=0.915 //x2=3.85 //y2=1.26
cc_138 ( N_noxref_1_c_12_p N_noxref_4_c_1061_n ) capacitor c=0.0024584f \
 //x=4.07 //y=2.445 //x2=3.33 //y2=2.08
cc_139 ( N_noxref_1_c_123_p N_noxref_4_c_1062_n ) capacitor c=0.00372124f \
 //x=3.585 //y=1.58 //x2=3.33 //y2=1.915
cc_140 ( N_noxref_1_c_12_p N_noxref_4_c_1062_n ) capacitor c=0.00282067f \
 //x=4.07 //y=2.445 //x2=3.33 //y2=1.915
cc_141 ( N_noxref_1_c_13_p N_noxref_4_c_1064_n ) capacitor c=0.00739875f \
 //x=4.07 //y=5.07 //x2=3.33 //y2=4.7
cc_142 ( N_noxref_1_c_65_p N_noxref_4_c_1064_n ) capacitor c=0.00203307f \
 //x=3.29 //y=5.155 //x2=3.33 //y2=4.7
cc_143 ( N_noxref_1_c_70_p N_noxref_4_c_1064_n ) capacitor c=0.00255197f \
 //x=3.29 //y=5.38 //x2=3.33 //y2=4.7
cc_144 ( N_noxref_1_c_144_p N_noxref_5_c_1430_n ) capacitor c=3.55609e-19 \
 //x=2.29 //y=5.155 //x2=2.22 //y2=2.38
cc_145 ( N_noxref_1_c_145_p N_noxref_5_c_1430_n ) capacitor c=4.1155e-19 \
 //x=2.41 //y=5.155 //x2=2.22 //y2=2.38
cc_146 ( N_noxref_1_c_144_p N_noxref_5_c_1432_n ) capacitor c=0.0220212f \
 //x=2.29 //y=5.155 //x2=2.22 //y2=4.585
cc_147 ( N_noxref_1_c_13_p N_noxref_5_c_1432_n ) capacitor c=0.00340479f \
 //x=4.07 //y=5.07 //x2=2.22 //y2=4.585
cc_148 ( N_noxref_1_c_145_p N_noxref_5_c_1432_n ) capacitor c=0.00259321f \
 //x=2.41 //y=5.155 //x2=2.22 //y2=4.585
cc_149 ( N_noxref_1_c_149_p N_noxref_5_c_1432_n ) capacitor c=7.85344e-19 \
 //x=2.41 //y=5.38 //x2=2.22 //y2=4.585
cc_150 ( N_noxref_1_c_62_p N_noxref_5_c_1436_n ) capacitor c=6.87062e-19 \
 //x=3.585 //y=1.125 //x2=13.305 //y2=2.22
cc_151 ( N_noxref_1_c_63_p N_noxref_5_c_1436_n ) capacitor c=0.0206216f \
 //x=3.67 //y=1.665 //x2=13.305 //y2=2.22
cc_152 ( N_noxref_1_c_12_p N_noxref_5_c_1436_n ) capacitor c=0.027263f \
 //x=4.07 //y=2.445 //x2=13.305 //y2=2.22
cc_153 ( N_noxref_1_c_55_p N_noxref_5_c_1436_n ) capacitor c=0.0083331f \
 //x=4.07 //y=2.765 //x2=13.305 //y2=2.22
cc_154 ( N_noxref_1_c_9_p N_noxref_5_c_1436_n ) capacitor c=0.0155883f \
 //x=5.92 //y=2.195 //x2=13.305 //y2=2.22
cc_155 ( N_noxref_1_c_14_p N_noxref_5_c_1436_n ) capacitor c=0.0138002f \
 //x=5.92 //y=2.445 //x2=13.305 //y2=2.22
cc_156 ( N_noxref_1_c_15_p N_noxref_5_c_1436_n ) capacitor c=0.00747608f \
 //x=5.92 //y=2.765 //x2=13.305 //y2=2.22
cc_157 ( N_noxref_1_c_73_p N_noxref_5_c_1436_n ) capacitor c=0.0155623f \
 //x=10.73 //y=2.195 //x2=13.305 //y2=2.22
cc_158 ( N_noxref_1_c_74_p N_noxref_5_c_1436_n ) capacitor c=0.0137567f \
 //x=10.73 //y=2.445 //x2=13.305 //y2=2.22
cc_159 ( N_noxref_1_c_75_p N_noxref_5_c_1436_n ) capacitor c=0.00802015f \
 //x=10.73 //y=2.765 //x2=13.305 //y2=2.22
cc_160 ( N_noxref_1_c_60_p N_noxref_5_c_1436_n ) capacitor c=0.0365231f \
 //x=4.235 //y=2.605 //x2=13.305 //y2=2.22
cc_161 ( N_noxref_1_c_101_p N_noxref_5_c_1436_n ) capacitor c=0.141202f \
 //x=5.765 //y=2.605 //x2=13.305 //y2=2.22
cc_162 ( N_noxref_1_c_18_p N_noxref_5_c_1436_n ) capacitor c=0.0370413f \
 //x=6.085 //y=2.605 //x2=13.305 //y2=2.22
cc_163 ( N_noxref_1_c_77_p N_noxref_5_c_1436_n ) capacitor c=0.0370413f \
 //x=10.73 //y=2.605 //x2=13.305 //y2=2.22
cc_164 ( N_noxref_1_c_19_p N_noxref_5_c_1436_n ) capacitor c=0.405445f \
 //x=10.57 //y=2.605 //x2=13.305 //y2=2.22
cc_165 ( N_noxref_1_c_10_p N_noxref_5_c_1436_n ) capacitor c=5.18204e-19 \
 //x=5.92 //y=2.08 //x2=13.305 //y2=2.22
cc_166 ( N_noxref_1_c_166_p N_noxref_5_c_1436_n ) capacitor c=5.18204e-19 \
 //x=10.73 //y=2.08 //x2=13.305 //y2=2.22
cc_167 ( N_noxref_1_c_144_p N_noxref_5_c_1453_n ) capacitor c=0.00492634f \
 //x=2.29 //y=5.155 //x2=2.22 //y2=4.7
cc_168 ( N_noxref_1_c_145_p N_noxref_5_c_1453_n ) capacitor c=0.00132214f \
 //x=2.41 //y=5.155 //x2=2.22 //y2=4.7
cc_169 ( N_noxref_1_c_144_p N_noxref_5_M20_noxref_g ) capacitor c=0.00858241f \
 //x=2.29 //y=5.155 //x2=2.19 //y2=6.02
cc_170 ( N_noxref_1_c_145_p N_noxref_5_M20_noxref_g ) capacitor c=0.00229818f \
 //x=2.41 //y=5.155 //x2=2.19 //y2=6.02
cc_171 ( N_noxref_1_c_149_p N_noxref_5_M20_noxref_g ) capacitor c=0.0179041f \
 //x=2.41 //y=5.38 //x2=2.19 //y2=6.02
cc_172 ( N_noxref_1_c_114_p N_noxref_5_M21_noxref_g ) capacitor c=0.0136936f \
 //x=3.175 //y=5.155 //x2=2.63 //y2=6.02
cc_173 ( N_noxref_1_c_145_p N_noxref_5_M21_noxref_g ) capacitor c=0.00230699f \
 //x=2.41 //y=5.155 //x2=2.63 //y2=6.02
cc_174 ( N_noxref_1_c_149_p N_noxref_5_M21_noxref_g ) capacitor c=0.0179041f \
 //x=2.41 //y=5.38 //x2=2.63 //y2=6.02
cc_175 ( N_noxref_1_c_145_p N_noxref_5_c_1461_n ) capacitor c=0.00180979f \
 //x=2.41 //y=5.155 //x2=2.555 //y2=4.79
cc_176 ( N_noxref_1_c_149_p N_noxref_5_c_1461_n ) capacitor c=0.00290085f \
 //x=2.41 //y=5.38 //x2=2.555 //y2=4.79
cc_177 ( N_noxref_1_c_144_p N_noxref_5_c_1463_n ) capacitor c=6.57727e-19 \
 //x=2.29 //y=5.155 //x2=2.22 //y2=4.7
cc_178 ( N_noxref_1_c_73_p N_noxref_6_c_1904_n ) capacitor c=0.00932261f \
 //x=10.73 //y=2.195 //x2=11.84 //y2=2.195
cc_179 ( N_noxref_1_c_166_p N_noxref_6_c_1904_n ) capacitor c=5.40058e-19 \
 //x=10.73 //y=2.08 //x2=11.84 //y2=2.195
cc_180 ( N_noxref_1_c_180_p N_noxref_6_c_1904_n ) capacitor c=0.00142893f \
 //x=10.43 //y=1.915 //x2=11.84 //y2=2.195
cc_181 ( N_noxref_1_c_74_p N_noxref_6_c_1907_n ) capacitor c=0.00510184f \
 //x=10.73 //y=2.445 //x2=11.84 //y2=2.785
cc_182 ( N_noxref_1_c_75_p N_noxref_6_c_1907_n ) capacitor c=0.00782712f \
 //x=10.73 //y=2.765 //x2=11.84 //y2=2.785
cc_183 ( N_noxref_1_c_25_p N_noxref_6_c_1907_n ) capacitor c=6.32157e-19 \
 //x=10.73 //y=4.575 //x2=11.84 //y2=2.785
cc_184 ( N_noxref_1_c_5_p N_noxref_6_c_1907_n ) capacitor c=3.49492e-19 \
 //x=10.73 //y=2.59 //x2=11.84 //y2=2.785
cc_185 ( N_noxref_1_c_77_p N_noxref_6_c_1907_n ) capacitor c=0.00513442f \
 //x=10.73 //y=2.605 //x2=11.84 //y2=2.785
cc_186 ( N_noxref_1_c_166_p N_noxref_6_c_1907_n ) capacitor c=3.9149e-19 \
 //x=10.73 //y=2.08 //x2=11.84 //y2=2.785
cc_187 ( N_noxref_1_c_25_p N_noxref_6_c_1913_n ) capacitor c=0.00782712f \
 //x=10.73 //y=4.575 //x2=11.84 //y2=3.105
cc_188 ( N_noxref_1_c_25_p N_noxref_6_c_1914_n ) capacitor c=0.047392f \
 //x=10.73 //y=4.575 //x2=11.84 //y2=4.585
cc_189 ( N_noxref_1_c_189_p N_noxref_6_c_1914_n ) capacitor c=6.26008e-19 \
 //x=10.73 //y=4.7 //x2=11.84 //y2=4.585
cc_190 ( N_noxref_1_c_4_p N_noxref_6_c_1914_n ) capacitor c=7.66769e-19 \
 //x=11.295 //y=4.79 //x2=11.84 //y2=4.585
cc_191 ( N_noxref_1_c_191_p N_noxref_6_c_1914_n ) capacitor c=7.54501e-19 \
 //x=11.005 //y=4.79 //x2=11.84 //y2=4.585
cc_192 ( N_noxref_1_c_25_p N_noxref_6_c_1918_n ) capacitor c=5.01652e-19 \
 //x=10.73 //y=4.575 //x2=11.84 //y2=2.96
cc_193 ( N_noxref_1_c_25_p N_noxref_6_c_1919_n ) capacitor c=0.00513501f \
 //x=10.73 //y=4.575 //x2=12 //y2=2.945
cc_194 ( N_noxref_1_c_73_p N_noxref_6_c_1920_n ) capacitor c=5.39999e-19 \
 //x=10.73 //y=2.195 //x2=11.84 //y2=2.08
cc_195 ( N_noxref_1_c_74_p N_noxref_6_c_1920_n ) capacitor c=3.9149e-19 \
 //x=10.73 //y=2.445 //x2=11.84 //y2=2.08
cc_196 ( N_noxref_1_c_166_p N_noxref_6_c_1920_n ) capacitor c=0.00125213f \
 //x=10.73 //y=2.08 //x2=11.84 //y2=2.08
cc_197 ( N_noxref_1_c_180_p N_noxref_6_c_1920_n ) capacitor c=0.00214573f \
 //x=10.43 //y=1.915 //x2=11.84 //y2=2.08
cc_198 ( N_noxref_1_c_25_p N_noxref_6_c_1924_n ) capacitor c=0.00103399f \
 //x=10.73 //y=4.575 //x2=11.84 //y2=4.7
cc_199 ( N_noxref_1_c_189_p N_noxref_6_c_1924_n ) capacitor c=0.00113984f \
 //x=10.73 //y=4.7 //x2=11.84 //y2=4.7
cc_200 ( N_noxref_1_c_4_p N_noxref_6_c_1924_n ) capacitor c=0.00116563f \
 //x=11.295 //y=4.79 //x2=11.84 //y2=4.7
cc_201 ( N_noxref_1_c_191_p N_noxref_6_c_1924_n ) capacitor c=0.00129812f \
 //x=11.005 //y=4.79 //x2=11.84 //y2=4.7
cc_202 ( N_noxref_1_M30_noxref_g N_noxref_6_M32_noxref_g ) capacitor \
 c=0.0106276f //x=10.93 //y=6.02 //x2=11.81 //y2=6.02
cc_203 ( N_noxref_1_M31_noxref_g N_noxref_6_M32_noxref_g ) capacitor \
 c=0.107144f //x=11.37 //y=6.02 //x2=11.81 //y2=6.02
cc_204 ( N_noxref_1_M31_noxref_g N_noxref_6_M33_noxref_g ) capacitor \
 c=0.0101598f //x=11.37 //y=6.02 //x2=12.25 //y2=6.02
cc_205 ( N_noxref_1_c_205_p N_noxref_6_c_1931_n ) capacitor c=5.72528e-19 \
 //x=10.43 //y=0.875 //x2=11.405 //y2=0.91
cc_206 ( N_noxref_1_c_206_p N_noxref_6_c_1931_n ) capacitor c=0.00150277f \
 //x=10.43 //y=1.22 //x2=11.405 //y2=0.91
cc_207 ( N_noxref_1_c_207_p N_noxref_6_c_1931_n ) capacitor c=0.0160123f \
 //x=10.96 //y=0.875 //x2=11.405 //y2=0.91
cc_208 ( N_noxref_1_c_208_p N_noxref_6_c_1934_n ) capacitor c=0.00111227f \
 //x=10.43 //y=1.53 //x2=11.405 //y2=1.22
cc_209 ( N_noxref_1_c_209_p N_noxref_6_c_1934_n ) capacitor c=0.0124075f \
 //x=10.96 //y=1.22 //x2=11.405 //y2=1.22
cc_210 ( N_noxref_1_c_207_p N_noxref_6_c_1936_n ) capacitor c=9.19165e-19 \
 //x=10.96 //y=0.875 //x2=11.93 //y2=0.91
cc_211 ( N_noxref_1_c_209_p N_noxref_6_c_1937_n ) capacitor c=0.0010154f \
 //x=10.96 //y=1.22 //x2=11.93 //y2=1.22
cc_212 ( N_noxref_1_c_209_p N_noxref_6_c_1938_n ) capacitor c=9.23422e-19 \
 //x=10.96 //y=1.22 //x2=11.93 //y2=1.45
cc_213 ( N_noxref_1_c_73_p N_noxref_6_c_1939_n ) capacitor c=0.00136403f \
 //x=10.73 //y=2.195 //x2=11.93 //y2=1.915
cc_214 ( N_noxref_1_c_166_p N_noxref_6_c_1939_n ) capacitor c=0.0020754f \
 //x=10.73 //y=2.08 //x2=11.93 //y2=1.915
cc_215 ( N_noxref_1_c_180_p N_noxref_6_c_1939_n ) capacitor c=0.00964411f \
 //x=10.43 //y=1.915 //x2=11.93 //y2=1.915
cc_216 ( N_noxref_1_c_25_p N_noxref_6_c_1942_n ) capacitor c=0.00116212f \
 //x=10.73 //y=4.575 //x2=11.84 //y2=4.7
cc_217 ( N_noxref_1_c_189_p N_noxref_6_c_1942_n ) capacitor c=0.00155973f \
 //x=10.73 //y=4.7 //x2=11.84 //y2=4.7
cc_218 ( N_noxref_1_c_4_p N_noxref_6_c_1942_n ) capacitor c=0.0171374f \
 //x=11.295 //y=4.79 //x2=11.84 //y2=4.7
cc_219 ( N_noxref_1_c_191_p N_noxref_6_c_1942_n ) capacitor c=0.00484466f \
 //x=11.005 //y=4.79 //x2=11.84 //y2=4.7
cc_220 ( N_noxref_1_c_14_p N_noxref_7_c_2236_n ) capacitor c=2.88859e-19 \
 //x=5.92 //y=2.445 //x2=8.14 //y2=3.555
cc_221 ( N_noxref_1_c_16_p N_noxref_7_c_2236_n ) capacitor c=7.72134e-19 \
 //x=5.92 //y=4.575 //x2=8.14 //y2=3.555
cc_222 ( N_noxref_1_c_74_p N_noxref_7_c_2236_n ) capacitor c=4.65873e-19 \
 //x=10.73 //y=2.445 //x2=8.14 //y2=3.555
cc_223 ( N_noxref_1_c_25_p N_noxref_7_c_2236_n ) capacitor c=0.00103409f \
 //x=10.73 //y=4.575 //x2=8.14 //y2=3.555
cc_224 ( N_noxref_1_c_19_p N_noxref_7_c_2236_n ) capacitor c=0.0247205f \
 //x=10.57 //y=2.605 //x2=8.14 //y2=3.555
cc_225 ( N_noxref_1_c_16_p N_noxref_7_c_2241_n ) capacitor c=0.00103363f \
 //x=5.92 //y=4.575 //x2=8.14 //y2=4.57
cc_226 ( N_noxref_1_c_25_p N_noxref_7_c_2241_n ) capacitor c=0.00112359f \
 //x=10.73 //y=4.575 //x2=8.14 //y2=4.57
cc_227 ( N_noxref_1_c_74_p N_noxref_7_c_2243_n ) capacitor c=2.88859e-19 \
 //x=10.73 //y=2.445 //x2=12.95 //y2=3.555
cc_228 ( N_noxref_1_c_25_p N_noxref_7_c_2243_n ) capacitor c=0.00107979f \
 //x=10.73 //y=4.575 //x2=12.95 //y2=3.555
cc_229 ( N_noxref_1_c_25_p N_noxref_7_c_2245_n ) capacitor c=7.55532e-19 \
 //x=10.73 //y=4.575 //x2=12.95 //y2=4.57
cc_230 ( N_noxref_1_c_25_p N_noxref_7_c_2246_n ) capacitor c=0.0273936f \
 //x=10.73 //y=4.575 //x2=12.79 //y2=3.715
cc_231 ( N_noxref_1_c_19_p N_noxref_7_c_2246_n ) capacitor c=0.0105236f \
 //x=10.57 //y=2.605 //x2=12.79 //y2=3.715
cc_232 ( N_noxref_1_c_144_p N_noxref_8_c_2794_n ) capacitor c=0.00620651f \
 //x=2.29 //y=5.155 //x2=28.12 //y2=7.4
cc_233 ( N_noxref_1_c_114_p N_noxref_8_c_2794_n ) capacitor c=0.00626474f \
 //x=3.175 //y=5.155 //x2=28.12 //y2=7.4
cc_234 ( N_noxref_1_c_83_p N_noxref_8_c_2794_n ) capacitor c=0.0025559f \
 //x=3.29 //y=5.38 //x2=28.12 //y2=7.4
cc_235 ( N_noxref_1_c_61_p N_noxref_8_c_2794_n ) capacitor c=0.00822762f \
 //x=3.985 //y=5.155 //x2=28.12 //y2=7.4
cc_236 ( N_noxref_1_c_236_p N_noxref_8_c_2794_n ) capacitor c=0.00261379f \
 //x=1.532 //y=5.155 //x2=28.12 //y2=7.4
cc_237 ( N_noxref_1_c_145_p N_noxref_8_c_2794_n ) capacitor c=0.0026965f \
 //x=2.41 //y=5.155 //x2=28.12 //y2=7.4
cc_238 ( N_noxref_1_c_238_p N_noxref_8_c_2794_n ) capacitor c=0.00242194f \
 //x=1.53 //y=5.38 //x2=28.12 //y2=7.4
cc_239 ( N_noxref_1_c_149_p N_noxref_8_c_2794_n ) capacitor c=0.00242194f \
 //x=2.41 //y=5.38 //x2=28.12 //y2=7.4
cc_240 ( N_noxref_1_c_70_p N_noxref_8_c_2794_n ) capacitor c=0.00242194f \
 //x=3.29 //y=5.38 //x2=28.12 //y2=7.4
cc_241 ( N_noxref_1_c_236_p N_noxref_8_c_2803_n ) capacitor c=0.00331944f \
 //x=1.532 //y=5.155 //x2=0.74 //y2=7.4
cc_242 ( N_noxref_1_c_238_p N_noxref_8_c_2803_n ) capacitor c=0.00509469f \
 //x=1.53 //y=5.38 //x2=0.74 //y2=7.4
cc_243 ( N_noxref_1_c_144_p N_noxref_8_c_2805_n ) capacitor c=0.0020718f \
 //x=2.29 //y=5.155 //x2=1.885 //y2=7.4
cc_244 ( N_noxref_1_c_236_p N_noxref_8_c_2805_n ) capacitor c=0.00105895f \
 //x=1.532 //y=5.155 //x2=1.885 //y2=7.4
cc_245 ( N_noxref_1_c_238_p N_noxref_8_c_2805_n ) capacitor c=0.0137846f \
 //x=1.53 //y=5.38 //x2=1.885 //y2=7.4
cc_246 ( N_noxref_1_c_144_p N_noxref_8_c_2808_n ) capacitor c=0.00177088f \
 //x=2.29 //y=5.155 //x2=2.765 //y2=7.4
cc_247 ( N_noxref_1_c_114_p N_noxref_8_c_2808_n ) capacitor c=0.0020718f \
 //x=3.175 //y=5.155 //x2=2.765 //y2=7.4
cc_248 ( N_noxref_1_c_145_p N_noxref_8_c_2808_n ) capacitor c=0.00105421f \
 //x=2.41 //y=5.155 //x2=2.765 //y2=7.4
cc_249 ( N_noxref_1_c_149_p N_noxref_8_c_2808_n ) capacitor c=0.0137846f \
 //x=2.41 //y=5.38 //x2=2.765 //y2=7.4
cc_250 ( N_noxref_1_c_114_p N_noxref_8_c_2812_n ) capacitor c=0.00210784f \
 //x=3.175 //y=5.155 //x2=3.645 //y2=7.4
cc_251 ( N_noxref_1_c_83_p N_noxref_8_c_2812_n ) capacitor c=8.59017e-19 \
 //x=3.29 //y=5.38 //x2=3.645 //y2=7.4
cc_252 ( N_noxref_1_c_61_p N_noxref_8_c_2812_n ) capacitor c=0.00204261f \
 //x=3.985 //y=5.155 //x2=3.645 //y2=7.4
cc_253 ( N_noxref_1_c_70_p N_noxref_8_c_2812_n ) capacitor c=0.0137846f \
 //x=3.29 //y=5.38 //x2=3.645 //y2=7.4
cc_254 ( N_noxref_1_c_61_p N_noxref_8_c_2816_n ) capacitor c=0.00183429f \
 //x=3.985 //y=5.155 //x2=4.64 //y2=7.4
cc_255 ( N_noxref_1_M24_noxref_g N_noxref_8_c_2817_n ) capacitor c=0.00749687f \
 //x=6.12 //y=6.02 //x2=6.695 //y2=7.4
cc_256 ( N_noxref_1_M25_noxref_g N_noxref_8_c_2817_n ) capacitor c=0.00749619f \
 //x=6.56 //y=6.02 //x2=6.695 //y2=7.4
cc_257 ( N_noxref_1_M30_noxref_g N_noxref_8_c_2819_n ) capacitor c=0.00749687f \
 //x=10.93 //y=6.02 //x2=11.505 //y2=7.4
cc_258 ( N_noxref_1_M31_noxref_g N_noxref_8_c_2819_n ) capacitor c=0.00749619f \
 //x=11.37 //y=6.02 //x2=11.505 //y2=7.4
cc_259 ( N_noxref_1_c_83_p N_noxref_8_c_2821_n ) capacitor c=0.00282782f \
 //x=3.29 //y=5.38 //x2=4.81 //y2=7.4
cc_260 ( N_noxref_1_c_13_p N_noxref_8_c_2821_n ) capacitor c=0.0363128f \
 //x=4.07 //y=5.07 //x2=4.81 //y2=7.4
cc_261 ( N_noxref_1_c_16_p N_noxref_8_c_2821_n ) capacitor c=0.0146125f \
 //x=5.92 //y=4.575 //x2=4.81 //y2=7.4
cc_262 ( N_noxref_1_c_70_p N_noxref_8_c_2821_n ) capacitor c=0.00777981f \
 //x=3.29 //y=5.38 //x2=4.81 //y2=7.4
cc_263 ( N_noxref_1_c_22_p N_noxref_8_c_2821_n ) capacitor c=0.00370784f \
 //x=5.92 //y=4.7 //x2=4.81 //y2=7.4
cc_264 ( N_noxref_1_c_24_p N_noxref_8_c_2821_n ) capacitor c=0.00590568f \
 //x=6.195 //y=4.79 //x2=4.81 //y2=7.4
cc_265 ( N_noxref_1_c_25_p N_noxref_8_c_2827_n ) capacitor c=0.0125893f \
 //x=10.73 //y=4.575 //x2=9.62 //y2=7.4
cc_266 ( N_noxref_1_c_189_p N_noxref_8_c_2827_n ) capacitor c=0.00370784f \
 //x=10.73 //y=4.7 //x2=9.62 //y2=7.4
cc_267 ( N_noxref_1_c_191_p N_noxref_8_c_2827_n ) capacitor c=0.00590568f \
 //x=11.005 //y=4.79 //x2=9.62 //y2=7.4
cc_268 ( N_noxref_1_c_236_p N_noxref_8_M18_noxref_s ) capacitor c=0.0453361f \
 //x=1.532 //y=5.155 //x2=0.955 //y2=5.02
cc_269 ( N_noxref_1_c_145_p N_noxref_8_M18_noxref_s ) capacitor c=7.80122e-19 \
 //x=2.41 //y=5.155 //x2=0.955 //y2=5.02
cc_270 ( N_noxref_1_c_238_p N_noxref_8_M18_noxref_s ) capacitor c=0.09305f \
 //x=1.53 //y=5.38 //x2=0.955 //y2=5.02
cc_271 ( N_noxref_1_c_144_p N_noxref_8_M19_noxref_d ) capacitor c=0.00775668f \
 //x=2.29 //y=5.155 //x2=1.825 //y2=5.02
cc_272 ( N_noxref_1_c_238_p N_noxref_8_M19_noxref_d ) capacitor c=0.0674491f \
 //x=1.53 //y=5.38 //x2=1.825 //y2=5.02
cc_273 ( N_noxref_1_c_149_p N_noxref_8_M19_noxref_d ) capacitor c=0.0674762f \
 //x=2.41 //y=5.38 //x2=1.825 //y2=5.02
cc_274 ( N_noxref_1_c_114_p N_noxref_8_M21_noxref_d ) capacitor c=0.00775668f \
 //x=3.175 //y=5.155 //x2=2.705 //y2=5.02
cc_275 ( N_noxref_1_c_149_p N_noxref_8_M21_noxref_d ) capacitor c=0.067493f \
 //x=2.41 //y=5.38 //x2=2.705 //y2=5.02
cc_276 ( N_noxref_1_c_70_p N_noxref_8_M21_noxref_d ) capacitor c=0.0674979f \
 //x=3.29 //y=5.38 //x2=2.705 //y2=5.02
cc_277 ( N_noxref_1_c_61_p N_noxref_8_M23_noxref_d ) capacitor c=0.0068945f \
 //x=3.985 //y=5.155 //x2=3.585 //y2=5.02
cc_278 ( N_noxref_1_c_70_p N_noxref_8_M23_noxref_d ) capacitor c=0.0675002f \
 //x=3.29 //y=5.38 //x2=3.585 //y2=5.02
cc_279 ( N_noxref_1_c_83_p N_noxref_8_M24_noxref_s ) capacitor c=0.00492616f \
 //x=3.29 //y=5.38 //x2=5.765 //y2=5.02
cc_280 ( N_noxref_1_c_61_p N_noxref_8_M24_noxref_s ) capacitor c=9.42705e-19 \
 //x=3.985 //y=5.155 //x2=5.765 //y2=5.02
cc_281 ( N_noxref_1_c_15_p N_noxref_8_M24_noxref_s ) capacitor c=4.68392e-19 \
 //x=5.92 //y=2.765 //x2=5.765 //y2=5.02
cc_282 ( N_noxref_1_c_16_p N_noxref_8_M24_noxref_s ) capacitor c=0.0228936f \
 //x=5.92 //y=4.575 //x2=5.765 //y2=5.02
cc_283 ( N_noxref_1_c_145_p N_noxref_8_M24_noxref_s ) capacitor c=2.11884e-19 \
 //x=2.41 //y=5.155 //x2=5.765 //y2=5.02
cc_284 ( N_noxref_1_c_22_p N_noxref_8_M24_noxref_s ) capacitor c=0.00911304f \
 //x=5.92 //y=4.7 //x2=5.765 //y2=5.02
cc_285 ( N_noxref_1_M24_noxref_g N_noxref_8_M24_noxref_s ) capacitor \
 c=0.053419f //x=6.12 //y=6.02 //x2=5.765 //y2=5.02
cc_286 ( N_noxref_1_c_24_p N_noxref_8_M24_noxref_s ) capacitor c=0.00608852f \
 //x=6.195 //y=4.79 //x2=5.765 //y2=5.02
cc_287 ( N_noxref_1_M25_noxref_g N_noxref_8_M25_noxref_d ) capacitor \
 c=0.015318f //x=6.56 //y=6.02 //x2=6.635 //y2=5.02
cc_288 ( N_noxref_1_c_75_p N_noxref_8_M30_noxref_s ) capacitor c=4.37211e-19 \
 //x=10.73 //y=2.765 //x2=10.575 //y2=5.02
cc_289 ( N_noxref_1_c_25_p N_noxref_8_M30_noxref_s ) capacitor c=0.0217983f \
 //x=10.73 //y=4.575 //x2=10.575 //y2=5.02
cc_290 ( N_noxref_1_c_189_p N_noxref_8_M30_noxref_s ) capacitor c=0.00983393f \
 //x=10.73 //y=4.7 //x2=10.575 //y2=5.02
cc_291 ( N_noxref_1_M30_noxref_g N_noxref_8_M30_noxref_s ) capacitor \
 c=0.053419f //x=10.93 //y=6.02 //x2=10.575 //y2=5.02
cc_292 ( N_noxref_1_c_191_p N_noxref_8_M30_noxref_s ) capacitor c=0.00608852f \
 //x=11.005 //y=4.79 //x2=10.575 //y2=5.02
cc_293 ( N_noxref_1_M31_noxref_g N_noxref_8_M31_noxref_d ) capacitor \
 c=0.015318f //x=11.37 //y=6.02 //x2=11.445 //y2=5.02
cc_294 ( N_noxref_1_c_236_p N_noxref_9_M18_noxref_g ) capacitor c=0.00501342f \
 //x=1.532 //y=5.155 //x2=1.31 //y2=6.02
cc_295 ( N_noxref_1_c_238_p N_noxref_9_M18_noxref_g ) capacitor c=0.0162284f \
 //x=1.53 //y=5.38 //x2=1.31 //y2=6.02
cc_296 ( N_noxref_1_c_144_p N_noxref_9_M19_noxref_g ) capacitor c=0.0130704f \
 //x=2.29 //y=5.155 //x2=1.75 //y2=6.02
cc_297 ( N_noxref_1_c_236_p N_noxref_9_M19_noxref_g ) capacitor c=0.00229208f \
 //x=1.532 //y=5.155 //x2=1.75 //y2=6.02
cc_298 ( N_noxref_1_c_238_p N_noxref_9_M19_noxref_g ) capacitor c=0.0179041f \
 //x=1.53 //y=5.38 //x2=1.75 //y2=6.02
cc_299 ( N_noxref_1_c_236_p N_noxref_9_c_3184_n ) capacitor c=0.00171885f \
 //x=1.532 //y=5.155 //x2=1.675 //y2=4.79
cc_300 ( N_noxref_1_c_238_p N_noxref_9_c_3184_n ) capacitor c=0.00291477f \
 //x=1.53 //y=5.38 //x2=1.675 //y2=4.79
cc_301 ( N_noxref_1_c_62_p N_noxref_10_c_3271_n ) capacitor c=0.0036878f \
 //x=3.585 //y=1.125 //x2=3.985 //y2=0.54
cc_302 ( N_noxref_1_c_72_p N_noxref_10_c_3271_n ) capacitor c=0.00399931f \
 //x=3.985 //y=1.665 //x2=3.985 //y2=0.54
cc_303 ( N_noxref_1_M2_noxref_d N_noxref_10_c_3271_n ) capacitor c=0.00910163f \
 //x=3.395 //y=0.915 //x2=3.985 //y2=0.54
cc_304 ( N_noxref_1_M2_noxref_d N_noxref_10_c_3274_n ) capacitor c=0.00120711f \
 //x=3.395 //y=0.915 //x2=3.1 //y2=0.995
cc_305 ( N_noxref_1_c_144_p N_noxref_10_M1_noxref_d ) capacitor c=0.00135532f \
 //x=2.29 //y=5.155 //x2=1.86 //y2=0.91
cc_306 ( N_noxref_1_c_62_p N_noxref_10_M1_noxref_d ) capacitor c=0.00802417f \
 //x=3.585 //y=1.125 //x2=1.86 //y2=0.91
cc_307 ( N_noxref_1_c_62_p N_noxref_10_M2_noxref_s ) capacitor c=0.0098487f \
 //x=3.585 //y=1.125 //x2=2.965 //y2=0.375
cc_308 ( N_noxref_1_c_123_p N_noxref_10_M2_noxref_s ) capacitor c=0.028602f \
 //x=3.585 //y=1.58 //x2=2.965 //y2=0.375
cc_309 ( N_noxref_1_c_72_p N_noxref_10_M2_noxref_s ) capacitor c=0.00752108f \
 //x=3.985 //y=1.665 //x2=2.965 //y2=0.375
cc_310 ( N_noxref_1_c_59_p N_noxref_10_M2_noxref_s ) capacitor c=0.00309975f \
 //x=4.07 //y=2.59 //x2=2.965 //y2=0.375
cc_311 ( N_noxref_1_M2_noxref_d N_noxref_10_M2_noxref_s ) capacitor \
 c=0.0279003f //x=3.395 //y=0.915 //x2=2.965 //y2=0.375
cc_312 ( N_noxref_1_c_62_p N_noxref_11_M4_noxref_d ) capacitor c=3.20746e-19 \
 //x=3.585 //y=1.125 //x2=6.67 //y2=0.91
cc_313 ( N_noxref_1_c_62_p N_noxref_17_c_3852_n ) capacitor c=0.00882633f \
 //x=3.585 //y=1.125 //x2=5.8 //y2=0
cc_314 ( N_noxref_1_c_72_p N_noxref_17_c_3852_n ) capacitor c=0.00661744f \
 //x=3.985 //y=1.665 //x2=5.8 //y2=0
cc_315 ( N_noxref_1_c_55_p N_noxref_17_c_3852_n ) capacitor c=4.30958e-19 \
 //x=4.07 //y=2.765 //x2=5.8 //y2=0
cc_316 ( N_noxref_1_M2_noxref_d N_noxref_17_c_3852_n ) capacitor c=2.94508e-19 \
 //x=3.395 //y=0.915 //x2=5.8 //y2=0
cc_317 ( N_noxref_1_c_39_p N_noxref_17_c_3856_n ) capacitor c=3.97665e-19 \
 //x=5.62 //y=0.875 //x2=5.885 //y2=0.835
cc_318 ( N_noxref_1_c_318_p N_noxref_17_c_3856_n ) capacitor c=0.00864609f \
 //x=5.995 //y=0.72 //x2=5.885 //y2=0.835
cc_319 ( N_noxref_1_c_41_p N_noxref_17_c_3856_n ) capacitor c=4.45447e-19 \
 //x=6.15 //y=0.875 //x2=5.885 //y2=0.835
cc_320 ( N_noxref_1_c_205_p N_noxref_17_c_3859_n ) capacitor c=3.97665e-19 \
 //x=10.43 //y=0.875 //x2=10.695 //y2=0.835
cc_321 ( N_noxref_1_c_321_p N_noxref_17_c_3859_n ) capacitor c=0.00864609f \
 //x=10.805 //y=0.72 //x2=10.695 //y2=0.835
cc_322 ( N_noxref_1_c_207_p N_noxref_17_c_3859_n ) capacitor c=4.45447e-19 \
 //x=10.96 //y=0.875 //x2=10.695 //y2=0.835
cc_323 ( N_noxref_1_c_62_p N_noxref_17_c_3862_n ) capacitor c=0.00543195f \
 //x=3.585 //y=1.125 //x2=5.885 //y2=0.965
cc_324 ( N_noxref_1_c_9_p N_noxref_17_c_3862_n ) capacitor c=0.00772254f \
 //x=5.92 //y=2.195 //x2=5.885 //y2=0.965
cc_325 ( N_noxref_1_c_15_p N_noxref_17_c_3862_n ) capacitor c=9.18424e-19 \
 //x=5.92 //y=2.765 //x2=5.885 //y2=0.965
cc_326 ( N_noxref_1_c_10_p N_noxref_17_c_3862_n ) capacitor c=2.22861e-19 \
 //x=5.92 //y=2.08 //x2=5.885 //y2=0.965
cc_327 ( N_noxref_1_c_39_p N_noxref_17_c_3862_n ) capacitor c=0.00156339f \
 //x=5.62 //y=0.875 //x2=5.885 //y2=0.965
cc_328 ( N_noxref_1_c_40_p N_noxref_17_c_3862_n ) capacitor c=0.00352472f \
 //x=5.62 //y=1.22 //x2=5.885 //y2=0.965
cc_329 ( N_noxref_1_c_42_p N_noxref_17_c_3862_n ) capacitor c=4.35713e-19 \
 //x=5.62 //y=1.53 //x2=5.885 //y2=0.965
cc_330 ( N_noxref_1_c_318_p N_noxref_17_c_3862_n ) capacitor c=9.36995e-19 \
 //x=5.995 //y=0.72 //x2=5.885 //y2=0.965
cc_331 ( N_noxref_1_c_331_p N_noxref_17_c_3862_n ) capacitor c=5.29132e-19 \
 //x=5.995 //y=1.375 //x2=5.885 //y2=0.965
cc_332 ( N_noxref_1_c_41_p N_noxref_17_c_3862_n ) capacitor c=0.0017438f \
 //x=6.15 //y=0.875 //x2=5.885 //y2=0.965
cc_333 ( N_noxref_1_c_43_p N_noxref_17_c_3862_n ) capacitor c=0.00276804f \
 //x=6.15 //y=1.22 //x2=5.885 //y2=0.965
cc_334 ( N_noxref_1_c_73_p N_noxref_17_c_3873_n ) capacitor c=0.00772254f \
 //x=10.73 //y=2.195 //x2=10.695 //y2=0.965
cc_335 ( N_noxref_1_c_75_p N_noxref_17_c_3873_n ) capacitor c=0.00117625f \
 //x=10.73 //y=2.765 //x2=10.695 //y2=0.965
cc_336 ( N_noxref_1_c_166_p N_noxref_17_c_3873_n ) capacitor c=2.22861e-19 \
 //x=10.73 //y=2.08 //x2=10.695 //y2=0.965
cc_337 ( N_noxref_1_c_205_p N_noxref_17_c_3873_n ) capacitor c=0.00156339f \
 //x=10.43 //y=0.875 //x2=10.695 //y2=0.965
cc_338 ( N_noxref_1_c_206_p N_noxref_17_c_3873_n ) capacitor c=0.00352472f \
 //x=10.43 //y=1.22 //x2=10.695 //y2=0.965
cc_339 ( N_noxref_1_c_208_p N_noxref_17_c_3873_n ) capacitor c=3.86356e-19 \
 //x=10.43 //y=1.53 //x2=10.695 //y2=0.965
cc_340 ( N_noxref_1_c_321_p N_noxref_17_c_3873_n ) capacitor c=9.36995e-19 \
 //x=10.805 //y=0.72 //x2=10.695 //y2=0.965
cc_341 ( N_noxref_1_c_341_p N_noxref_17_c_3873_n ) capacitor c=5.29132e-19 \
 //x=10.805 //y=1.375 //x2=10.695 //y2=0.965
cc_342 ( N_noxref_1_c_207_p N_noxref_17_c_3873_n ) capacitor c=0.0017438f \
 //x=10.96 //y=0.875 //x2=10.695 //y2=0.965
cc_343 ( N_noxref_1_c_209_p N_noxref_17_c_3873_n ) capacitor c=0.00276804f \
 //x=10.96 //y=1.22 //x2=10.695 //y2=0.965
cc_344 ( N_noxref_1_c_72_p N_noxref_17_c_3883_n ) capacitor c=6.86937e-19 \
 //x=3.985 //y=1.665 //x2=4.64 //y2=0
cc_345 ( N_noxref_1_c_55_p N_noxref_17_c_3883_n ) capacitor c=6.00968e-19 \
 //x=4.07 //y=2.765 //x2=4.64 //y2=0
cc_346 ( N_noxref_1_c_39_p N_noxref_17_c_3885_n ) capacitor c=0.00675103f \
 //x=5.62 //y=0.875 //x2=9.45 //y2=0
cc_347 ( N_noxref_1_c_205_p N_noxref_17_c_3886_n ) capacitor c=0.00675021f \
 //x=10.43 //y=0.875 //x2=14.26 //y2=0
cc_348 ( N_noxref_1_c_123_p N_noxref_17_c_3887_n ) capacitor c=0.0045138f \
 //x=3.585 //y=1.58 //x2=4.81 //y2=0
cc_349 ( N_noxref_1_c_72_p N_noxref_17_c_3887_n ) capacitor c=0.0229887f \
 //x=3.985 //y=1.665 //x2=4.81 //y2=0
cc_350 ( N_noxref_1_c_12_p N_noxref_17_c_3887_n ) capacitor c=2.00878e-19 \
 //x=4.07 //y=2.445 //x2=4.81 //y2=0
cc_351 ( N_noxref_1_c_55_p N_noxref_17_c_3887_n ) capacitor c=0.00411109f \
 //x=4.07 //y=2.765 //x2=4.81 //y2=0
cc_352 ( N_noxref_1_c_9_p N_noxref_17_c_3887_n ) capacitor c=0.00343139f \
 //x=5.92 //y=2.195 //x2=4.81 //y2=0
cc_353 ( N_noxref_1_c_14_p N_noxref_17_c_3887_n ) capacitor c=0.00401621f \
 //x=5.92 //y=2.445 //x2=4.81 //y2=0
cc_354 ( N_noxref_1_c_15_p N_noxref_17_c_3887_n ) capacitor c=0.00256181f \
 //x=5.92 //y=2.765 //x2=4.81 //y2=0
cc_355 ( N_noxref_1_c_59_p N_noxref_17_c_3887_n ) capacitor c=0.0104119f \
 //x=4.07 //y=2.59 //x2=4.81 //y2=0
cc_356 ( N_noxref_1_c_17_p N_noxref_17_c_3887_n ) capacitor c=0.00527261f \
 //x=5.92 //y=2.59 //x2=4.81 //y2=0
cc_357 ( N_noxref_1_c_101_p N_noxref_17_c_3887_n ) capacitor c=0.00964798f \
 //x=5.765 //y=2.605 //x2=4.81 //y2=0
cc_358 ( N_noxref_1_c_10_p N_noxref_17_c_3887_n ) capacitor c=0.00379567f \
 //x=5.92 //y=2.08 //x2=4.81 //y2=0
cc_359 ( N_noxref_1_c_42_p N_noxref_17_c_3887_n ) capacitor c=0.00170145f \
 //x=5.62 //y=1.53 //x2=4.81 //y2=0
cc_360 ( N_noxref_1_c_11_p N_noxref_17_c_3887_n ) capacitor c=0.0102191f \
 //x=5.62 //y=1.915 //x2=4.81 //y2=0
cc_361 ( N_noxref_1_c_73_p N_noxref_17_c_3900_n ) capacitor c=0.00343139f \
 //x=10.73 //y=2.195 //x2=9.62 //y2=0
cc_362 ( N_noxref_1_c_74_p N_noxref_17_c_3900_n ) capacitor c=0.00401621f \
 //x=10.73 //y=2.445 //x2=9.62 //y2=0
cc_363 ( N_noxref_1_c_75_p N_noxref_17_c_3900_n ) capacitor c=0.0030172f \
 //x=10.73 //y=2.765 //x2=9.62 //y2=0
cc_364 ( N_noxref_1_c_5_p N_noxref_17_c_3900_n ) capacitor c=0.00528783f \
 //x=10.73 //y=2.59 //x2=9.62 //y2=0
cc_365 ( N_noxref_1_c_19_p N_noxref_17_c_3900_n ) capacitor c=0.0120029f \
 //x=10.57 //y=2.605 //x2=9.62 //y2=0
cc_366 ( N_noxref_1_c_166_p N_noxref_17_c_3900_n ) capacitor c=0.0039621f \
 //x=10.73 //y=2.08 //x2=9.62 //y2=0
cc_367 ( N_noxref_1_c_208_p N_noxref_17_c_3900_n ) capacitor c=0.00170145f \
 //x=10.43 //y=1.53 //x2=9.62 //y2=0
cc_368 ( N_noxref_1_c_180_p N_noxref_17_c_3900_n ) capacitor c=0.0102191f \
 //x=10.43 //y=1.915 //x2=9.62 //y2=0
cc_369 ( N_noxref_1_c_9_p N_noxref_17_M3_noxref_d ) capacitor c=4.4417e-19 \
 //x=5.92 //y=2.195 //x2=5.695 //y2=0.875
cc_370 ( N_noxref_1_c_39_p N_noxref_17_M3_noxref_d ) capacitor c=0.00184354f \
 //x=5.62 //y=0.875 //x2=5.695 //y2=0.875
cc_371 ( N_noxref_1_c_40_p N_noxref_17_M3_noxref_d ) capacitor c=0.00210798f \
 //x=5.62 //y=1.22 //x2=5.695 //y2=0.875
cc_372 ( N_noxref_1_c_318_p N_noxref_17_M3_noxref_d ) capacitor c=0.00474029f \
 //x=5.995 //y=0.72 //x2=5.695 //y2=0.875
cc_373 ( N_noxref_1_c_331_p N_noxref_17_M3_noxref_d ) capacitor c=0.00166857f \
 //x=5.995 //y=1.375 //x2=5.695 //y2=0.875
cc_374 ( N_noxref_1_c_41_p N_noxref_17_M3_noxref_d ) capacitor c=0.00230174f \
 //x=6.15 //y=0.875 //x2=5.695 //y2=0.875
cc_375 ( N_noxref_1_c_43_p N_noxref_17_M3_noxref_d ) capacitor c=0.00210798f \
 //x=6.15 //y=1.22 //x2=5.695 //y2=0.875
cc_376 ( N_noxref_1_c_73_p N_noxref_17_M6_noxref_d ) capacitor c=4.4417e-19 \
 //x=10.73 //y=2.195 //x2=10.505 //y2=0.875
cc_377 ( N_noxref_1_c_205_p N_noxref_17_M6_noxref_d ) capacitor c=0.00184354f \
 //x=10.43 //y=0.875 //x2=10.505 //y2=0.875
cc_378 ( N_noxref_1_c_206_p N_noxref_17_M6_noxref_d ) capacitor c=0.00210798f \
 //x=10.43 //y=1.22 //x2=10.505 //y2=0.875
cc_379 ( N_noxref_1_c_321_p N_noxref_17_M6_noxref_d ) capacitor c=0.00474029f \
 //x=10.805 //y=0.72 //x2=10.505 //y2=0.875
cc_380 ( N_noxref_1_c_341_p N_noxref_17_M6_noxref_d ) capacitor c=0.00166857f \
 //x=10.805 //y=1.375 //x2=10.505 //y2=0.875
cc_381 ( N_noxref_1_c_207_p N_noxref_17_M6_noxref_d ) capacitor c=0.00230174f \
 //x=10.96 //y=0.875 //x2=10.505 //y2=0.875
cc_382 ( N_noxref_1_c_209_p N_noxref_17_M6_noxref_d ) capacitor c=0.00210798f \
 //x=10.96 //y=1.22 //x2=10.505 //y2=0.875
cc_383 ( N_noxref_1_c_11_p N_noxref_22_c_4696_n ) capacitor c=0.00262672f \
 //x=5.62 //y=1.915 //x2=5.4 //y2=1.505
cc_384 ( N_noxref_1_c_9_p N_noxref_22_c_4697_n ) capacitor c=0.00428451f \
 //x=5.92 //y=2.195 //x2=6.285 //y2=1.59
cc_385 ( N_noxref_1_c_15_p N_noxref_22_c_4697_n ) capacitor c=0.00361907f \
 //x=5.92 //y=2.765 //x2=6.285 //y2=1.59
cc_386 ( N_noxref_1_c_10_p N_noxref_22_c_4697_n ) capacitor c=0.0104666f \
 //x=5.92 //y=2.08 //x2=6.285 //y2=1.59
cc_387 ( N_noxref_1_c_42_p N_noxref_22_c_4697_n ) capacitor c=0.00705077f \
 //x=5.62 //y=1.53 //x2=6.285 //y2=1.59
cc_388 ( N_noxref_1_c_11_p N_noxref_22_c_4697_n ) capacitor c=0.0204935f \
 //x=5.62 //y=1.915 //x2=6.285 //y2=1.59
cc_389 ( N_noxref_1_c_331_p N_noxref_22_c_4697_n ) capacitor c=0.00588627f \
 //x=5.995 //y=1.375 //x2=6.285 //y2=1.59
cc_390 ( N_noxref_1_c_43_p N_noxref_22_c_4697_n ) capacitor c=0.00698822f \
 //x=6.15 //y=1.22 //x2=6.285 //y2=1.59
cc_391 ( N_noxref_1_c_39_p N_noxref_22_M3_noxref_s ) capacitor c=0.0295256f \
 //x=5.62 //y=0.875 //x2=5.265 //y2=0.375
cc_392 ( N_noxref_1_c_42_p N_noxref_22_M3_noxref_s ) capacitor c=7.99997e-19 \
 //x=5.62 //y=1.53 //x2=5.265 //y2=0.375
cc_393 ( N_noxref_1_c_11_p N_noxref_22_M3_noxref_s ) capacitor c=0.00122123f \
 //x=5.62 //y=1.915 //x2=5.265 //y2=0.375
cc_394 ( N_noxref_1_c_41_p N_noxref_22_M3_noxref_s ) capacitor c=0.0125924f \
 //x=6.15 //y=0.875 //x2=5.265 //y2=0.375
cc_395 ( N_noxref_1_c_180_p N_noxref_23_c_4754_n ) capacitor c=0.00262672f \
 //x=10.43 //y=1.915 //x2=10.21 //y2=1.505
cc_396 ( N_noxref_1_c_73_p N_noxref_23_c_4755_n ) capacitor c=0.00428451f \
 //x=10.73 //y=2.195 //x2=11.095 //y2=1.59
cc_397 ( N_noxref_1_c_75_p N_noxref_23_c_4755_n ) capacitor c=0.00447635f \
 //x=10.73 //y=2.765 //x2=11.095 //y2=1.59
cc_398 ( N_noxref_1_c_166_p N_noxref_23_c_4755_n ) capacitor c=0.0104666f \
 //x=10.73 //y=2.08 //x2=11.095 //y2=1.59
cc_399 ( N_noxref_1_c_208_p N_noxref_23_c_4755_n ) capacitor c=0.00705077f \
 //x=10.43 //y=1.53 //x2=11.095 //y2=1.59
cc_400 ( N_noxref_1_c_180_p N_noxref_23_c_4755_n ) capacitor c=0.0197834f \
 //x=10.43 //y=1.915 //x2=11.095 //y2=1.59
cc_401 ( N_noxref_1_c_341_p N_noxref_23_c_4755_n ) capacitor c=0.00588627f \
 //x=10.805 //y=1.375 //x2=11.095 //y2=1.59
cc_402 ( N_noxref_1_c_209_p N_noxref_23_c_4755_n ) capacitor c=0.00698822f \
 //x=10.96 //y=1.22 //x2=11.095 //y2=1.59
cc_403 ( N_noxref_1_c_205_p N_noxref_23_M6_noxref_s ) capacitor c=0.0295256f \
 //x=10.43 //y=0.875 //x2=10.075 //y2=0.375
cc_404 ( N_noxref_1_c_208_p N_noxref_23_M6_noxref_s ) capacitor c=7.99997e-19 \
 //x=10.43 //y=1.53 //x2=10.075 //y2=0.375
cc_405 ( N_noxref_1_c_180_p N_noxref_23_M6_noxref_s ) capacitor c=0.00122123f \
 //x=10.43 //y=1.915 //x2=10.075 //y2=0.375
cc_406 ( N_noxref_1_c_207_p N_noxref_23_M6_noxref_s ) capacitor c=0.0125924f \
 //x=10.96 //y=0.875 //x2=10.075 //y2=0.375
cc_407 ( N_noxref_2_c_415_p N_noxref_3_c_740_n ) capacitor c=0.00898333f \
 //x=15.54 //y=2.195 //x2=16.65 //y2=2.195
cc_408 ( N_noxref_2_c_416_p N_noxref_3_c_740_n ) capacitor c=5.40058e-19 \
 //x=15.54 //y=2.08 //x2=16.65 //y2=2.195
cc_409 ( N_noxref_2_c_417_p N_noxref_3_c_740_n ) capacitor c=0.00142893f \
 //x=15.24 //y=1.915 //x2=16.65 //y2=2.195
cc_410 ( N_noxref_2_c_418_p N_noxref_3_c_743_n ) capacitor c=3.32566e-19 \
 //x=13.69 //y=2.43 //x2=16.65 //y2=4.495
cc_411 ( N_noxref_2_c_419_p N_noxref_3_c_743_n ) capacitor c=0.0012083f \
 //x=13.69 //y=5.07 //x2=16.65 //y2=4.495
cc_412 ( N_noxref_2_c_420_p N_noxref_3_c_743_n ) capacitor c=0.00460058f \
 //x=15.54 //y=2.43 //x2=16.65 //y2=4.495
cc_413 ( N_noxref_2_c_421_p N_noxref_3_c_743_n ) capacitor c=0.00787446f \
 //x=15.54 //y=2.75 //x2=16.65 //y2=4.495
cc_414 ( N_noxref_2_c_422_p N_noxref_3_c_743_n ) capacitor c=0.0433339f \
 //x=15.54 //y=4.575 //x2=16.65 //y2=4.495
cc_415 ( N_noxref_2_c_423_p N_noxref_3_c_743_n ) capacitor c=2.90818e-19 \
 //x=15.54 //y=2.59 //x2=16.65 //y2=4.495
cc_416 ( N_noxref_2_c_424_p N_noxref_3_c_743_n ) capacitor c=0.00512134f \
 //x=15.55 //y=2.59 //x2=16.65 //y2=4.495
cc_417 ( N_noxref_2_c_416_p N_noxref_3_c_743_n ) capacitor c=3.9149e-19 \
 //x=15.54 //y=2.08 //x2=16.65 //y2=4.495
cc_418 ( N_noxref_2_c_422_p N_noxref_3_c_751_n ) capacitor c=0.00876228f \
 //x=15.54 //y=4.575 //x2=16.655 //y2=4.655
cc_419 ( N_noxref_2_c_427_p N_noxref_3_c_751_n ) capacitor c=6.25125e-19 \
 //x=15.54 //y=4.7 //x2=16.655 //y2=4.655
cc_420 ( N_noxref_2_c_428_p N_noxref_3_c_751_n ) capacitor c=7.07965e-19 \
 //x=16.105 //y=4.79 //x2=16.655 //y2=4.655
cc_421 ( N_noxref_2_c_429_p N_noxref_3_c_751_n ) capacitor c=8.59438e-19 \
 //x=15.815 //y=4.79 //x2=16.655 //y2=4.655
cc_422 ( N_noxref_2_c_430_p N_noxref_3_c_712_n ) capacitor c=0.0218009f \
 //x=13.605 //y=5.155 //x2=16.495 //y2=4.44
cc_423 ( N_noxref_2_c_419_p N_noxref_3_c_712_n ) capacitor c=0.03272f \
 //x=13.69 //y=5.07 //x2=16.495 //y2=4.44
cc_424 ( N_noxref_2_c_422_p N_noxref_3_c_712_n ) capacitor c=0.0356388f \
 //x=15.54 //y=4.575 //x2=16.495 //y2=4.44
cc_425 ( N_noxref_2_c_408_n N_noxref_3_c_712_n ) capacitor c=0.0297814f \
 //x=11.152 //y=5.155 //x2=16.495 //y2=4.44
cc_426 ( N_noxref_2_c_434_p N_noxref_3_c_712_n ) capacitor c=0.0375778f \
 //x=12.03 //y=5.155 //x2=16.495 //y2=4.44
cc_427 ( N_noxref_2_c_422_p N_noxref_3_c_760_n ) capacitor c=0.00655873f \
 //x=15.54 //y=4.575 //x2=16.655 //y2=4.44
cc_428 ( N_noxref_2_c_415_p N_noxref_3_c_761_n ) capacitor c=5.39999e-19 \
 //x=15.54 //y=2.195 //x2=16.65 //y2=2.08
cc_429 ( N_noxref_2_c_420_p N_noxref_3_c_761_n ) capacitor c=3.9149e-19 \
 //x=15.54 //y=2.43 //x2=16.65 //y2=2.08
cc_430 ( N_noxref_2_c_416_p N_noxref_3_c_761_n ) capacitor c=0.00125213f \
 //x=15.54 //y=2.08 //x2=16.65 //y2=2.08
cc_431 ( N_noxref_2_c_417_p N_noxref_3_c_761_n ) capacitor c=0.00214573f \
 //x=15.24 //y=1.915 //x2=16.65 //y2=2.08
cc_432 ( N_noxref_2_c_422_p N_noxref_3_c_765_n ) capacitor c=5.64453e-19 \
 //x=15.54 //y=4.575 //x2=16.65 //y2=4.7
cc_433 ( N_noxref_2_c_427_p N_noxref_3_c_765_n ) capacitor c=0.00113671f \
 //x=15.54 //y=4.7 //x2=16.65 //y2=4.7
cc_434 ( N_noxref_2_c_428_p N_noxref_3_c_765_n ) capacitor c=0.00116563f \
 //x=16.105 //y=4.79 //x2=16.65 //y2=4.7
cc_435 ( N_noxref_2_c_429_p N_noxref_3_c_765_n ) capacitor c=0.0012974f \
 //x=15.815 //y=4.79 //x2=16.65 //y2=4.7
cc_436 ( N_noxref_2_M36_noxref_g N_noxref_3_M38_noxref_g ) capacitor \
 c=0.0106276f //x=15.74 //y=6.02 //x2=16.62 //y2=6.02
cc_437 ( N_noxref_2_M37_noxref_g N_noxref_3_M38_noxref_g ) capacitor \
 c=0.107144f //x=16.18 //y=6.02 //x2=16.62 //y2=6.02
cc_438 ( N_noxref_2_M37_noxref_g N_noxref_3_M39_noxref_g ) capacitor \
 c=0.0101598f //x=16.18 //y=6.02 //x2=17.06 //y2=6.02
cc_439 ( N_noxref_2_c_447_p N_noxref_3_c_772_n ) capacitor c=5.72528e-19 \
 //x=15.24 //y=0.875 //x2=16.215 //y2=0.91
cc_440 ( N_noxref_2_c_448_p N_noxref_3_c_772_n ) capacitor c=0.00150277f \
 //x=15.24 //y=1.22 //x2=16.215 //y2=0.91
cc_441 ( N_noxref_2_c_449_p N_noxref_3_c_772_n ) capacitor c=0.0160123f \
 //x=15.77 //y=0.875 //x2=16.215 //y2=0.91
cc_442 ( N_noxref_2_c_450_p N_noxref_3_c_775_n ) capacitor c=0.00111227f \
 //x=15.24 //y=1.53 //x2=16.215 //y2=1.22
cc_443 ( N_noxref_2_c_451_p N_noxref_3_c_775_n ) capacitor c=0.0124075f \
 //x=15.77 //y=1.22 //x2=16.215 //y2=1.22
cc_444 ( N_noxref_2_c_449_p N_noxref_3_c_777_n ) capacitor c=9.19165e-19 \
 //x=15.77 //y=0.875 //x2=16.74 //y2=0.91
cc_445 ( N_noxref_2_c_451_p N_noxref_3_c_778_n ) capacitor c=0.0010154f \
 //x=15.77 //y=1.22 //x2=16.74 //y2=1.22
cc_446 ( N_noxref_2_c_451_p N_noxref_3_c_779_n ) capacitor c=9.23422e-19 \
 //x=15.77 //y=1.22 //x2=16.74 //y2=1.45
cc_447 ( N_noxref_2_c_415_p N_noxref_3_c_780_n ) capacitor c=0.0013537f \
 //x=15.54 //y=2.195 //x2=16.74 //y2=1.915
cc_448 ( N_noxref_2_c_416_p N_noxref_3_c_780_n ) capacitor c=0.0020754f \
 //x=15.54 //y=2.08 //x2=16.74 //y2=1.915
cc_449 ( N_noxref_2_c_417_p N_noxref_3_c_780_n ) capacitor c=0.00964411f \
 //x=15.24 //y=1.915 //x2=16.74 //y2=1.915
cc_450 ( N_noxref_2_c_427_p N_noxref_3_c_783_n ) capacitor c=0.00123917f \
 //x=15.54 //y=4.7 //x2=16.65 //y2=4.7
cc_451 ( N_noxref_2_c_428_p N_noxref_3_c_783_n ) capacitor c=0.0169508f \
 //x=16.105 //y=4.79 //x2=16.65 //y2=4.7
cc_452 ( N_noxref_2_c_429_p N_noxref_3_c_783_n ) capacitor c=0.00406071f \
 //x=15.815 //y=4.79 //x2=16.65 //y2=4.7
cc_453 ( N_noxref_2_c_408_n N_noxref_4_c_1067_n ) capacitor c=6.09703e-19 \
 //x=11.152 //y=5.155 //x2=8.1 //y2=5.38
cc_454 ( N_noxref_2_c_408_n N_noxref_4_c_1068_n ) capacitor c=0.00306432f \
 //x=11.152 //y=5.155 //x2=8.795 //y2=5.155
cc_455 ( N_noxref_2_c_463_p N_noxref_4_c_1069_n ) capacitor c=0.00163399f \
 //x=13.29 //y=1.665 //x2=8.795 //y2=1.665
cc_456 ( N_noxref_2_c_419_p N_noxref_4_c_1011_n ) capacitor c=0.0232184f \
 //x=13.69 //y=5.07 //x2=20.185 //y2=3.33
cc_457 ( N_noxref_2_c_422_p N_noxref_4_c_1011_n ) capacitor c=0.0246617f \
 //x=15.54 //y=4.575 //x2=20.185 //y2=3.33
cc_458 ( N_noxref_2_c_466_p N_noxref_4_c_1011_n ) capacitor c=0.00854113f \
 //x=15.39 //y=2.59 //x2=20.185 //y2=3.33
cc_459 ( N_noxref_2_c_422_p N_noxref_5_c_1464_n ) capacitor c=0.00181974f \
 //x=15.54 //y=4.575 //x2=17.76 //y2=4.57
cc_460 ( N_noxref_2_c_468_p N_noxref_5_c_1436_n ) capacitor c=7.09906e-19 \
 //x=13.205 //y=1.125 //x2=13.305 //y2=2.22
cc_461 ( N_noxref_2_c_469_p N_noxref_5_c_1436_n ) capacitor c=0.00861999f \
 //x=13.605 //y=1.665 //x2=13.305 //y2=2.22
cc_462 ( N_noxref_2_c_463_p N_noxref_5_c_1436_n ) capacitor c=0.0125707f \
 //x=13.29 //y=1.665 //x2=13.305 //y2=2.22
cc_463 ( N_noxref_2_c_418_p N_noxref_5_c_1436_n ) capacitor c=3.12067e-19 \
 //x=13.69 //y=2.43 //x2=13.305 //y2=2.22
cc_464 ( N_noxref_2_c_418_p N_noxref_5_c_1469_n ) capacitor c=0.0272405f \
 //x=13.69 //y=2.43 //x2=13.905 //y2=2.205
cc_465 ( N_noxref_2_c_473_p N_noxref_5_c_1469_n ) capacitor c=0.0082766f \
 //x=13.69 //y=2.75 //x2=13.905 //y2=2.205
cc_466 ( N_noxref_2_c_466_p N_noxref_5_c_1469_n ) capacitor c=0.13396f \
 //x=15.39 //y=2.59 //x2=13.905 //y2=2.205
cc_467 ( N_noxref_2_c_475_p N_noxref_5_c_1469_n ) capacitor c=0.0365231f \
 //x=13.85 //y=2.59 //x2=13.905 //y2=2.205
cc_468 ( N_noxref_2_c_420_p N_noxref_5_c_1473_n ) capacitor c=5.11045e-19 \
 //x=15.54 //y=2.43 //x2=15.165 //y2=2.22
cc_469 ( N_noxref_2_c_421_p N_noxref_5_c_1473_n ) capacitor c=0.00348052f \
 //x=15.54 //y=2.75 //x2=15.165 //y2=2.22
cc_470 ( N_noxref_2_c_466_p N_noxref_5_c_1473_n ) capacitor c=0.0109101f \
 //x=15.39 //y=2.59 //x2=15.165 //y2=2.22
cc_471 ( N_noxref_2_c_415_p N_noxref_5_c_1476_n ) capacitor c=0.0168589f \
 //x=15.54 //y=2.195 //x2=15.765 //y2=2.205
cc_472 ( N_noxref_2_c_420_p N_noxref_5_c_1476_n ) capacitor c=0.012163f \
 //x=15.54 //y=2.43 //x2=15.765 //y2=2.205
cc_473 ( N_noxref_2_c_421_p N_noxref_5_c_1476_n ) capacitor c=0.00478203f \
 //x=15.54 //y=2.75 //x2=15.765 //y2=2.205
cc_474 ( N_noxref_2_c_424_p N_noxref_5_c_1476_n ) capacitor c=0.0370412f \
 //x=15.55 //y=2.59 //x2=15.765 //y2=2.205
cc_475 ( N_noxref_2_c_416_p N_noxref_5_c_1476_n ) capacitor c=5.18204e-19 \
 //x=15.54 //y=2.08 //x2=15.765 //y2=2.205
cc_476 ( N_noxref_2_c_420_p N_noxref_5_c_1481_n ) capacitor c=3.71593e-19 \
 //x=15.54 //y=2.43 //x2=17.925 //y2=2.22
cc_477 ( N_noxref_2_c_418_p N_noxref_6_c_1907_n ) capacitor c=3.42202e-19 \
 //x=13.69 //y=2.43 //x2=11.84 //y2=2.785
cc_478 ( N_noxref_2_c_407_n N_noxref_6_c_1913_n ) capacitor c=4.73573e-19 \
 //x=11.91 //y=5.155 //x2=11.84 //y2=3.105
cc_479 ( N_noxref_2_c_434_p N_noxref_6_c_1913_n ) capacitor c=0.00141981f \
 //x=12.03 //y=5.155 //x2=11.84 //y2=3.105
cc_480 ( N_noxref_2_c_488_p N_noxref_6_c_1913_n ) capacitor c=4.8301e-19 \
 //x=12.03 //y=5.38 //x2=11.84 //y2=3.105
cc_481 ( N_noxref_2_c_407_n N_noxref_6_c_1914_n ) capacitor c=0.0213631f \
 //x=11.91 //y=5.155 //x2=11.84 //y2=4.585
cc_482 ( N_noxref_2_c_419_p N_noxref_6_c_1914_n ) capacitor c=0.00209314f \
 //x=13.69 //y=5.07 //x2=11.84 //y2=4.585
cc_483 ( N_noxref_2_c_434_p N_noxref_6_c_1914_n ) capacitor c=0.00239361f \
 //x=12.03 //y=5.155 //x2=11.84 //y2=4.585
cc_484 ( N_noxref_2_c_488_p N_noxref_6_c_1914_n ) capacitor c=6.21282e-19 \
 //x=12.03 //y=5.38 //x2=11.84 //y2=4.585
cc_485 ( N_noxref_2_c_473_p N_noxref_6_c_1954_n ) capacitor c=0.00153128f \
 //x=13.69 //y=2.75 //x2=13.305 //y2=2.96
cc_486 ( N_noxref_2_c_419_p N_noxref_6_c_1954_n ) capacitor c=3.29006e-19 \
 //x=13.69 //y=5.07 //x2=13.305 //y2=2.96
cc_487 ( N_noxref_2_c_475_p N_noxref_6_c_1954_n ) capacitor c=0.0358254f \
 //x=13.85 //y=2.59 //x2=13.305 //y2=2.96
cc_488 ( N_noxref_2_c_473_p N_noxref_6_c_1957_n ) capacitor c=0.0102778f \
 //x=13.69 //y=2.75 //x2=13.905 //y2=2.975
cc_489 ( N_noxref_2_c_419_p N_noxref_6_c_1957_n ) capacitor c=0.0226563f \
 //x=13.69 //y=5.07 //x2=13.905 //y2=2.975
cc_490 ( N_noxref_2_c_466_p N_noxref_6_c_1957_n ) capacitor c=0.128848f \
 //x=15.39 //y=2.59 //x2=13.905 //y2=2.975
cc_491 ( N_noxref_2_c_421_p N_noxref_6_c_1960_n ) capacitor c=0.00511674f \
 //x=15.54 //y=2.75 //x2=15.165 //y2=2.96
cc_492 ( N_noxref_2_c_422_p N_noxref_6_c_1960_n ) capacitor c=5.11045e-19 \
 //x=15.54 //y=4.575 //x2=15.165 //y2=2.96
cc_493 ( N_noxref_2_c_466_p N_noxref_6_c_1960_n ) capacitor c=0.0107306f \
 //x=15.39 //y=2.59 //x2=15.165 //y2=2.96
cc_494 ( N_noxref_2_c_424_p N_noxref_6_c_1960_n ) capacitor c=0.0358254f \
 //x=15.55 //y=2.59 //x2=15.165 //y2=2.96
cc_495 ( N_noxref_2_c_421_p N_noxref_6_c_1964_n ) capacitor c=0.00397194f \
 //x=15.54 //y=2.75 //x2=15.765 //y2=2.975
cc_496 ( N_noxref_2_c_422_p N_noxref_6_c_1964_n ) capacitor c=0.023934f \
 //x=15.54 //y=4.575 //x2=15.765 //y2=2.975
cc_497 ( N_noxref_2_c_407_n N_noxref_6_c_1924_n ) capacitor c=0.00492634f \
 //x=11.91 //y=5.155 //x2=11.84 //y2=4.7
cc_498 ( N_noxref_2_c_434_p N_noxref_6_c_1924_n ) capacitor c=0.00132214f \
 //x=12.03 //y=5.155 //x2=11.84 //y2=4.7
cc_499 ( N_noxref_2_c_407_n N_noxref_6_M32_noxref_g ) capacitor c=0.00858241f \
 //x=11.91 //y=5.155 //x2=11.81 //y2=6.02
cc_500 ( N_noxref_2_c_434_p N_noxref_6_M32_noxref_g ) capacitor c=0.00229818f \
 //x=12.03 //y=5.155 //x2=11.81 //y2=6.02
cc_501 ( N_noxref_2_c_488_p N_noxref_6_M32_noxref_g ) capacitor c=0.0179041f \
 //x=12.03 //y=5.38 //x2=11.81 //y2=6.02
cc_502 ( N_noxref_2_c_510_p N_noxref_6_M33_noxref_g ) capacitor c=0.00955829f \
 //x=12.795 //y=5.155 //x2=12.25 //y2=6.02
cc_503 ( N_noxref_2_c_434_p N_noxref_6_M33_noxref_g ) capacitor c=0.00230699f \
 //x=12.03 //y=5.155 //x2=12.25 //y2=6.02
cc_504 ( N_noxref_2_c_488_p N_noxref_6_M33_noxref_g ) capacitor c=0.0179041f \
 //x=12.03 //y=5.38 //x2=12.25 //y2=6.02
cc_505 ( N_noxref_2_c_434_p N_noxref_6_c_1974_n ) capacitor c=0.00201022f \
 //x=12.03 //y=5.155 //x2=12.175 //y2=4.79
cc_506 ( N_noxref_2_c_488_p N_noxref_6_c_1974_n ) capacitor c=0.00290085f \
 //x=12.03 //y=5.38 //x2=12.175 //y2=4.79
cc_507 ( N_noxref_2_c_407_n N_noxref_6_c_1942_n ) capacitor c=5.877e-19 \
 //x=11.91 //y=5.155 //x2=11.84 //y2=4.7
cc_508 ( N_noxref_2_c_418_p N_noxref_7_c_2248_n ) capacitor c=0.013767f \
 //x=13.69 //y=2.43 //x2=12.95 //y2=2.195
cc_509 ( N_noxref_2_c_418_p N_noxref_7_c_2243_n ) capacitor c=0.0086632f \
 //x=13.69 //y=2.43 //x2=12.95 //y2=3.555
cc_510 ( N_noxref_2_c_473_p N_noxref_7_c_2243_n ) capacitor c=0.0148501f \
 //x=13.69 //y=2.75 //x2=12.95 //y2=3.555
cc_511 ( N_noxref_2_c_419_p N_noxref_7_c_2243_n ) capacitor c=0.0317529f \
 //x=13.69 //y=5.07 //x2=12.95 //y2=3.555
cc_512 ( N_noxref_2_c_420_p N_noxref_7_c_2243_n ) capacitor c=4.40369e-19 \
 //x=15.54 //y=2.43 //x2=12.95 //y2=3.555
cc_513 ( N_noxref_2_c_422_p N_noxref_7_c_2243_n ) capacitor c=5.12503e-19 \
 //x=15.54 //y=4.575 //x2=12.95 //y2=3.555
cc_514 ( N_noxref_2_c_411_n N_noxref_7_c_2243_n ) capacitor c=5.64873e-19 \
 //x=13.69 //y=2.59 //x2=12.95 //y2=3.555
cc_515 ( N_noxref_2_c_475_p N_noxref_7_c_2243_n ) capacitor c=0.00687494f \
 //x=13.85 //y=2.59 //x2=12.95 //y2=3.555
cc_516 ( N_noxref_2_c_510_p N_noxref_7_c_2256_n ) capacitor c=0.00169109f \
 //x=12.795 //y=5.155 //x2=12.95 //y2=3.875
cc_517 ( N_noxref_2_c_430_p N_noxref_7_c_2256_n ) capacitor c=4.27841e-19 \
 //x=13.605 //y=5.155 //x2=12.95 //y2=3.875
cc_518 ( N_noxref_2_c_419_p N_noxref_7_c_2256_n ) capacitor c=0.0148932f \
 //x=13.69 //y=5.07 //x2=12.95 //y2=3.875
cc_519 ( N_noxref_2_c_430_p N_noxref_7_c_2245_n ) capacitor c=0.00228791f \
 //x=13.605 //y=5.155 //x2=12.95 //y2=4.57
cc_520 ( N_noxref_2_c_419_p N_noxref_7_c_2245_n ) capacitor c=0.0444551f \
 //x=13.69 //y=5.07 //x2=12.95 //y2=4.57
cc_521 ( N_noxref_2_c_422_p N_noxref_7_c_2245_n ) capacitor c=0.00112359f \
 //x=15.54 //y=4.575 //x2=12.95 //y2=4.57
cc_522 ( N_noxref_2_c_530_p N_noxref_7_c_2245_n ) capacitor c=0.0221235f \
 //x=12.91 //y=5.155 //x2=12.95 //y2=4.57
cc_523 ( N_noxref_2_c_531_p N_noxref_7_c_2245_n ) capacitor c=0.00217653f \
 //x=12.91 //y=5.38 //x2=12.95 //y2=4.57
cc_524 ( N_noxref_2_M37_noxref_g N_noxref_7_c_2264_n ) capacitor c=0.00893512f \
 //x=16.18 //y=6.02 //x2=16.72 //y2=5.155
cc_525 ( N_noxref_2_c_469_p N_noxref_7_c_2265_n ) capacitor c=0.00163399f \
 //x=13.605 //y=1.665 //x2=18.1 //y2=1.665
cc_526 ( N_noxref_2_c_419_p N_noxref_7_c_2266_n ) capacitor c=9.19401e-19 \
 //x=13.69 //y=5.07 //x2=12.95 //y2=3.7
cc_527 ( N_noxref_2_c_535_p N_noxref_7_c_2267_n ) capacitor c=6.09703e-19 \
 //x=12.91 //y=5.38 //x2=15.962 //y2=5.155
cc_528 ( N_noxref_2_c_430_p N_noxref_7_c_2267_n ) capacitor c=0.00306432f \
 //x=13.605 //y=5.155 //x2=15.962 //y2=5.155
cc_529 ( N_noxref_2_M36_noxref_g N_noxref_7_c_2267_n ) capacitor c=0.00461408f \
 //x=15.74 //y=6.02 //x2=15.962 //y2=5.155
cc_530 ( N_noxref_2_M37_noxref_g N_noxref_7_c_2267_n ) capacitor c=0.00229208f \
 //x=16.18 //y=6.02 //x2=15.962 //y2=5.155
cc_531 ( N_noxref_2_c_428_p N_noxref_7_c_2267_n ) capacitor c=0.00171885f \
 //x=16.105 //y=4.79 //x2=15.962 //y2=5.155
cc_532 ( N_noxref_2_c_419_p N_noxref_7_c_2272_n ) capacitor c=0.0256123f \
 //x=13.69 //y=5.07 //x2=18.33 //y2=3.7
cc_533 ( N_noxref_2_c_422_p N_noxref_7_c_2272_n ) capacitor c=0.0274554f \
 //x=15.54 //y=4.575 //x2=18.33 //y2=3.7
cc_534 ( N_noxref_2_c_419_p N_noxref_7_c_2274_n ) capacitor c=0.00336755f \
 //x=13.69 //y=5.07 //x2=13.11 //y2=3.715
cc_535 ( N_noxref_2_c_418_p N_noxref_7_c_2275_n ) capacitor c=0.0015536f \
 //x=13.69 //y=2.43 //x2=12.95 //y2=2.08
cc_536 ( N_noxref_2_c_430_p N_noxref_7_c_2276_n ) capacitor c=0.00130631f \
 //x=13.605 //y=5.155 //x2=12.95 //y2=4.7
cc_537 ( N_noxref_2_c_419_p N_noxref_7_c_2276_n ) capacitor c=0.00131258f \
 //x=13.69 //y=5.07 //x2=12.95 //y2=4.7
cc_538 ( N_noxref_2_c_530_p N_noxref_7_c_2276_n ) capacitor c=0.00346456f \
 //x=12.91 //y=5.155 //x2=12.95 //y2=4.7
cc_539 ( N_noxref_2_c_531_p N_noxref_7_c_2276_n ) capacitor c=0.00624059f \
 //x=12.91 //y=5.38 //x2=12.95 //y2=4.7
cc_540 ( N_noxref_2_M36_noxref_g N_noxref_7_c_2280_n ) capacitor c=0.0162284f \
 //x=15.74 //y=6.02 //x2=15.96 //y2=5.38
cc_541 ( N_noxref_2_M37_noxref_g N_noxref_7_c_2280_n ) capacitor c=0.0179041f \
 //x=16.18 //y=6.02 //x2=15.96 //y2=5.38
cc_542 ( N_noxref_2_c_428_p N_noxref_7_c_2280_n ) capacitor c=0.00291477f \
 //x=16.105 //y=4.79 //x2=15.96 //y2=5.38
cc_543 ( N_noxref_2_c_510_p N_noxref_7_M34_noxref_g ) capacitor c=0.00952006f \
 //x=12.795 //y=5.155 //x2=12.69 //y2=6.02
cc_544 ( N_noxref_2_c_535_p N_noxref_7_M34_noxref_g ) capacitor c=0.00226521f \
 //x=12.91 //y=5.38 //x2=12.69 //y2=6.02
cc_545 ( N_noxref_2_c_531_p N_noxref_7_M34_noxref_g ) capacitor c=0.0178885f \
 //x=12.91 //y=5.38 //x2=12.69 //y2=6.02
cc_546 ( N_noxref_2_c_535_p N_noxref_7_M35_noxref_g ) capacitor c=0.00381703f \
 //x=12.91 //y=5.38 //x2=13.13 //y2=6.02
cc_547 ( N_noxref_2_c_430_p N_noxref_7_M35_noxref_g ) capacitor c=0.0108571f \
 //x=13.605 //y=5.155 //x2=13.13 //y2=6.02
cc_548 ( N_noxref_2_c_531_p N_noxref_7_M35_noxref_g ) capacitor c=0.0188608f \
 //x=12.91 //y=5.38 //x2=13.13 //y2=6.02
cc_549 ( N_noxref_2_c_468_p N_noxref_7_c_2289_n ) capacitor c=4.64015e-19 \
 //x=13.205 //y=1.125 //x2=12.94 //y2=0.915
cc_550 ( N_noxref_2_M8_noxref_d N_noxref_7_c_2289_n ) capacitor c=0.00137165f \
 //x=13.015 //y=0.915 //x2=12.94 //y2=0.915
cc_551 ( N_noxref_2_c_468_p N_noxref_7_c_2291_n ) capacitor c=0.0026012f \
 //x=13.205 //y=1.125 //x2=12.94 //y2=1.26
cc_552 ( N_noxref_2_c_560_p N_noxref_7_c_2291_n ) capacitor c=0.00127432f \
 //x=13.205 //y=1.58 //x2=12.94 //y2=1.26
cc_553 ( N_noxref_2_M8_noxref_d N_noxref_7_c_2291_n ) capacitor c=0.00237422f \
 //x=13.015 //y=0.915 //x2=12.94 //y2=1.26
cc_554 ( N_noxref_2_c_560_p N_noxref_7_c_2294_n ) capacitor c=0.00429966f \
 //x=13.205 //y=1.58 //x2=12.94 //y2=1.57
cc_555 ( N_noxref_2_c_468_p N_noxref_7_c_2295_n ) capacitor c=5.29969e-19 \
 //x=13.205 //y=1.125 //x2=13.315 //y2=0.76
cc_556 ( N_noxref_2_M8_noxref_d N_noxref_7_c_2295_n ) capacitor c=0.0020782f \
 //x=13.015 //y=0.915 //x2=13.315 //y2=0.76
cc_557 ( N_noxref_2_c_468_p N_noxref_7_c_2297_n ) capacitor c=5.32228e-19 \
 //x=13.205 //y=1.125 //x2=13.315 //y2=1.415
cc_558 ( N_noxref_2_c_560_p N_noxref_7_c_2297_n ) capacitor c=0.00942306f \
 //x=13.205 //y=1.58 //x2=13.315 //y2=1.415
cc_559 ( N_noxref_2_c_469_p N_noxref_7_c_2297_n ) capacitor c=0.00194716f \
 //x=13.605 //y=1.665 //x2=13.315 //y2=1.415
cc_560 ( N_noxref_2_M8_noxref_d N_noxref_7_c_2297_n ) capacitor c=0.00356097f \
 //x=13.015 //y=0.915 //x2=13.315 //y2=1.415
cc_561 ( N_noxref_2_c_468_p N_noxref_7_c_2301_n ) capacitor c=5.24634e-19 \
 //x=13.205 //y=1.125 //x2=13.47 //y2=0.915
cc_562 ( N_noxref_2_M8_noxref_d N_noxref_7_c_2301_n ) capacitor c=0.00139206f \
 //x=13.015 //y=0.915 //x2=13.47 //y2=0.915
cc_563 ( N_noxref_2_c_468_p N_noxref_7_c_2303_n ) capacitor c=0.00307978f \
 //x=13.205 //y=1.125 //x2=13.47 //y2=1.26
cc_564 ( N_noxref_2_c_560_p N_noxref_7_c_2303_n ) capacitor c=0.00363411f \
 //x=13.205 //y=1.58 //x2=13.47 //y2=1.26
cc_565 ( N_noxref_2_c_469_p N_noxref_7_c_2303_n ) capacitor c=0.00323576f \
 //x=13.605 //y=1.665 //x2=13.47 //y2=1.26
cc_566 ( N_noxref_2_M8_noxref_d N_noxref_7_c_2303_n ) capacitor c=0.00237422f \
 //x=13.015 //y=0.915 //x2=13.47 //y2=1.26
cc_567 ( N_noxref_2_c_418_p N_noxref_7_c_2307_n ) capacitor c=0.00244157f \
 //x=13.69 //y=2.43 //x2=12.95 //y2=2.08
cc_568 ( N_noxref_2_c_560_p N_noxref_7_c_2308_n ) capacitor c=0.0036273f \
 //x=13.205 //y=1.58 //x2=12.95 //y2=1.915
cc_569 ( N_noxref_2_c_418_p N_noxref_7_c_2308_n ) capacitor c=0.00282067f \
 //x=13.69 //y=2.43 //x2=12.95 //y2=1.915
cc_570 ( N_noxref_2_c_419_p N_noxref_7_c_2310_n ) capacitor c=0.00739875f \
 //x=13.69 //y=5.07 //x2=12.95 //y2=4.7
cc_571 ( N_noxref_2_c_530_p N_noxref_7_c_2310_n ) capacitor c=0.00203307f \
 //x=12.91 //y=5.155 //x2=12.95 //y2=4.7
cc_572 ( N_noxref_2_c_531_p N_noxref_7_c_2310_n ) capacitor c=0.00375636f \
 //x=12.91 //y=5.38 //x2=12.95 //y2=4.7
cc_573 ( N_noxref_2_c_407_n N_noxref_8_c_2794_n ) capacitor c=0.00620641f \
 //x=11.91 //y=5.155 //x2=28.12 //y2=7.4
cc_574 ( N_noxref_2_c_510_p N_noxref_8_c_2794_n ) capacitor c=0.00626467f \
 //x=12.795 //y=5.155 //x2=28.12 //y2=7.4
cc_575 ( N_noxref_2_c_535_p N_noxref_8_c_2794_n ) capacitor c=0.00255587f \
 //x=12.91 //y=5.38 //x2=28.12 //y2=7.4
cc_576 ( N_noxref_2_c_430_p N_noxref_8_c_2794_n ) capacitor c=0.00822764f \
 //x=13.605 //y=5.155 //x2=28.12 //y2=7.4
cc_577 ( N_noxref_2_c_408_n N_noxref_8_c_2794_n ) capacitor c=0.00261379f \
 //x=11.152 //y=5.155 //x2=28.12 //y2=7.4
cc_578 ( N_noxref_2_c_434_p N_noxref_8_c_2794_n ) capacitor c=0.0026965f \
 //x=12.03 //y=5.155 //x2=28.12 //y2=7.4
cc_579 ( N_noxref_2_c_412_n N_noxref_8_c_2794_n ) capacitor c=0.00242194f \
 //x=11.15 //y=5.38 //x2=28.12 //y2=7.4
cc_580 ( N_noxref_2_c_488_p N_noxref_8_c_2794_n ) capacitor c=0.00242194f \
 //x=12.03 //y=5.38 //x2=28.12 //y2=7.4
cc_581 ( N_noxref_2_c_531_p N_noxref_8_c_2794_n ) capacitor c=0.00242194f \
 //x=12.91 //y=5.38 //x2=28.12 //y2=7.4
cc_582 ( N_noxref_2_c_407_n N_noxref_8_c_2819_n ) capacitor c=0.00202948f \
 //x=11.91 //y=5.155 //x2=11.505 //y2=7.4
cc_583 ( N_noxref_2_c_408_n N_noxref_8_c_2819_n ) capacitor c=9.37357e-19 \
 //x=11.152 //y=5.155 //x2=11.505 //y2=7.4
cc_584 ( N_noxref_2_c_412_n N_noxref_8_c_2819_n ) capacitor c=0.0137846f \
 //x=11.15 //y=5.38 //x2=11.505 //y2=7.4
cc_585 ( N_noxref_2_c_407_n N_noxref_8_c_2868_n ) capacitor c=0.00177088f \
 //x=11.91 //y=5.155 //x2=12.385 //y2=7.4
cc_586 ( N_noxref_2_c_510_p N_noxref_8_c_2868_n ) capacitor c=0.00202948f \
 //x=12.795 //y=5.155 //x2=12.385 //y2=7.4
cc_587 ( N_noxref_2_c_434_p N_noxref_8_c_2868_n ) capacitor c=9.47876e-19 \
 //x=12.03 //y=5.155 //x2=12.385 //y2=7.4
cc_588 ( N_noxref_2_c_488_p N_noxref_8_c_2868_n ) capacitor c=0.0137846f \
 //x=12.03 //y=5.38 //x2=12.385 //y2=7.4
cc_589 ( N_noxref_2_c_510_p N_noxref_8_c_2872_n ) capacitor c=0.00205929f \
 //x=12.795 //y=5.155 //x2=13.265 //y2=7.4
cc_590 ( N_noxref_2_c_535_p N_noxref_8_c_2872_n ) capacitor c=8.49349e-19 \
 //x=12.91 //y=5.38 //x2=13.265 //y2=7.4
cc_591 ( N_noxref_2_c_430_p N_noxref_8_c_2872_n ) capacitor c=0.00204261f \
 //x=13.605 //y=5.155 //x2=13.265 //y2=7.4
cc_592 ( N_noxref_2_c_531_p N_noxref_8_c_2872_n ) capacitor c=0.0134886f \
 //x=12.91 //y=5.38 //x2=13.265 //y2=7.4
cc_593 ( N_noxref_2_c_430_p N_noxref_8_c_2876_n ) capacitor c=0.00183429f \
 //x=13.605 //y=5.155 //x2=14.26 //y2=7.4
cc_594 ( N_noxref_2_M36_noxref_g N_noxref_8_c_2877_n ) capacitor c=0.00749687f \
 //x=15.74 //y=6.02 //x2=16.315 //y2=7.4
cc_595 ( N_noxref_2_M37_noxref_g N_noxref_8_c_2877_n ) capacitor c=0.00749619f \
 //x=16.18 //y=6.02 //x2=16.315 //y2=7.4
cc_596 ( N_noxref_2_c_408_n N_noxref_8_c_2827_n ) capacitor c=0.0022955f \
 //x=11.152 //y=5.155 //x2=9.62 //y2=7.4
cc_597 ( N_noxref_2_c_412_n N_noxref_8_c_2827_n ) capacitor c=0.00509469f \
 //x=11.15 //y=5.38 //x2=9.62 //y2=7.4
cc_598 ( N_noxref_2_c_535_p N_noxref_8_c_2881_n ) capacitor c=0.00282782f \
 //x=12.91 //y=5.38 //x2=14.43 //y2=7.4
cc_599 ( N_noxref_2_c_419_p N_noxref_8_c_2881_n ) capacitor c=0.0337603f \
 //x=13.69 //y=5.07 //x2=14.43 //y2=7.4
cc_600 ( N_noxref_2_c_422_p N_noxref_8_c_2881_n ) capacitor c=0.0130517f \
 //x=15.54 //y=4.575 //x2=14.43 //y2=7.4
cc_601 ( N_noxref_2_c_531_p N_noxref_8_c_2881_n ) capacitor c=0.00777981f \
 //x=12.91 //y=5.38 //x2=14.43 //y2=7.4
cc_602 ( N_noxref_2_c_427_p N_noxref_8_c_2881_n ) capacitor c=0.00370784f \
 //x=15.54 //y=4.7 //x2=14.43 //y2=7.4
cc_603 ( N_noxref_2_c_429_p N_noxref_8_c_2881_n ) capacitor c=0.00590568f \
 //x=15.815 //y=4.79 //x2=14.43 //y2=7.4
cc_604 ( N_noxref_2_c_408_n N_noxref_8_M30_noxref_s ) capacitor c=0.0442713f \
 //x=11.152 //y=5.155 //x2=10.575 //y2=5.02
cc_605 ( N_noxref_2_c_434_p N_noxref_8_M30_noxref_s ) capacitor c=7.80122e-19 \
 //x=12.03 //y=5.155 //x2=10.575 //y2=5.02
cc_606 ( N_noxref_2_c_412_n N_noxref_8_M30_noxref_s ) capacitor c=0.09305f \
 //x=11.15 //y=5.38 //x2=10.575 //y2=5.02
cc_607 ( N_noxref_2_c_407_n N_noxref_8_M31_noxref_d ) capacitor c=0.00700078f \
 //x=11.91 //y=5.155 //x2=11.445 //y2=5.02
cc_608 ( N_noxref_2_c_412_n N_noxref_8_M31_noxref_d ) capacitor c=0.0674491f \
 //x=11.15 //y=5.38 //x2=11.445 //y2=5.02
cc_609 ( N_noxref_2_c_488_p N_noxref_8_M31_noxref_d ) capacitor c=0.0674762f \
 //x=12.03 //y=5.38 //x2=11.445 //y2=5.02
cc_610 ( N_noxref_2_c_510_p N_noxref_8_M33_noxref_d ) capacitor c=0.00700078f \
 //x=12.795 //y=5.155 //x2=12.325 //y2=5.02
cc_611 ( N_noxref_2_c_488_p N_noxref_8_M33_noxref_d ) capacitor c=0.067493f \
 //x=12.03 //y=5.38 //x2=12.325 //y2=5.02
cc_612 ( N_noxref_2_c_531_p N_noxref_8_M33_noxref_d ) capacitor c=0.0674979f \
 //x=12.91 //y=5.38 //x2=12.325 //y2=5.02
cc_613 ( N_noxref_2_c_430_p N_noxref_8_M35_noxref_d ) capacitor c=0.00700078f \
 //x=13.605 //y=5.155 //x2=13.205 //y2=5.02
cc_614 ( N_noxref_2_c_531_p N_noxref_8_M35_noxref_d ) capacitor c=0.0675002f \
 //x=12.91 //y=5.38 //x2=13.205 //y2=5.02
cc_615 ( N_noxref_2_c_535_p N_noxref_8_M36_noxref_s ) capacitor c=0.00492616f \
 //x=12.91 //y=5.38 //x2=15.385 //y2=5.02
cc_616 ( N_noxref_2_c_430_p N_noxref_8_M36_noxref_s ) capacitor c=9.42705e-19 \
 //x=13.605 //y=5.155 //x2=15.385 //y2=5.02
cc_617 ( N_noxref_2_c_421_p N_noxref_8_M36_noxref_s ) capacitor c=4.32734e-19 \
 //x=15.54 //y=2.75 //x2=15.385 //y2=5.02
cc_618 ( N_noxref_2_c_422_p N_noxref_8_M36_noxref_s ) capacitor c=0.0217983f \
 //x=15.54 //y=4.575 //x2=15.385 //y2=5.02
cc_619 ( N_noxref_2_c_434_p N_noxref_8_M36_noxref_s ) capacitor c=2.11884e-19 \
 //x=12.03 //y=5.155 //x2=15.385 //y2=5.02
cc_620 ( N_noxref_2_c_427_p N_noxref_8_M36_noxref_s ) capacitor c=0.00983827f \
 //x=15.54 //y=4.7 //x2=15.385 //y2=5.02
cc_621 ( N_noxref_2_M36_noxref_g N_noxref_8_M36_noxref_s ) capacitor \
 c=0.053419f //x=15.74 //y=6.02 //x2=15.385 //y2=5.02
cc_622 ( N_noxref_2_c_429_p N_noxref_8_M36_noxref_s ) capacitor c=0.00608894f \
 //x=15.815 //y=4.79 //x2=15.385 //y2=5.02
cc_623 ( N_noxref_2_M37_noxref_g N_noxref_8_M37_noxref_d ) capacitor \
 c=0.015318f //x=16.18 //y=6.02 //x2=16.255 //y2=5.02
cc_624 ( N_noxref_2_c_468_p N_noxref_12_c_3410_n ) capacitor c=0.0036878f \
 //x=13.205 //y=1.125 //x2=13.605 //y2=0.54
cc_625 ( N_noxref_2_c_469_p N_noxref_12_c_3410_n ) capacitor c=0.00399931f \
 //x=13.605 //y=1.665 //x2=13.605 //y2=0.54
cc_626 ( N_noxref_2_M8_noxref_d N_noxref_12_c_3410_n ) capacitor c=0.00910163f \
 //x=13.015 //y=0.915 //x2=13.605 //y2=0.54
cc_627 ( N_noxref_2_M8_noxref_d N_noxref_12_c_3413_n ) capacitor c=0.00120711f \
 //x=13.015 //y=0.915 //x2=12.72 //y2=0.995
cc_628 ( N_noxref_2_c_407_n N_noxref_12_M7_noxref_d ) capacitor c=0.00132605f \
 //x=11.91 //y=5.155 //x2=11.48 //y2=0.91
cc_629 ( N_noxref_2_c_468_p N_noxref_12_M7_noxref_d ) capacitor c=0.00802417f \
 //x=13.205 //y=1.125 //x2=11.48 //y2=0.91
cc_630 ( N_noxref_2_c_468_p N_noxref_12_M8_noxref_s ) capacitor c=0.0098487f \
 //x=13.205 //y=1.125 //x2=12.585 //y2=0.375
cc_631 ( N_noxref_2_c_560_p N_noxref_12_M8_noxref_s ) capacitor c=0.0283243f \
 //x=13.205 //y=1.58 //x2=12.585 //y2=0.375
cc_632 ( N_noxref_2_c_469_p N_noxref_12_M8_noxref_s ) capacitor c=0.00752108f \
 //x=13.605 //y=1.665 //x2=12.585 //y2=0.375
cc_633 ( N_noxref_2_c_411_n N_noxref_12_M8_noxref_s ) capacitor c=0.00309975f \
 //x=13.69 //y=2.59 //x2=12.585 //y2=0.375
cc_634 ( N_noxref_2_M8_noxref_d N_noxref_12_M8_noxref_s ) capacitor \
 c=0.0279003f //x=13.015 //y=0.915 //x2=12.585 //y2=0.375
cc_635 ( N_noxref_2_c_468_p N_noxref_13_M10_noxref_d ) capacitor c=3.20746e-19 \
 //x=13.205 //y=1.125 //x2=16.29 //y2=0.91
cc_636 ( N_noxref_2_c_468_p N_noxref_17_c_3922_n ) capacitor c=0.00877081f \
 //x=13.205 //y=1.125 //x2=15.42 //y2=0
cc_637 ( N_noxref_2_c_469_p N_noxref_17_c_3922_n ) capacitor c=0.00661306f \
 //x=13.605 //y=1.665 //x2=15.42 //y2=0
cc_638 ( N_noxref_2_c_473_p N_noxref_17_c_3922_n ) capacitor c=4.30761e-19 \
 //x=13.69 //y=2.75 //x2=15.42 //y2=0
cc_639 ( N_noxref_2_M8_noxref_d N_noxref_17_c_3922_n ) capacitor c=2.94508e-19 \
 //x=13.015 //y=0.915 //x2=15.42 //y2=0
cc_640 ( N_noxref_2_c_447_p N_noxref_17_c_3926_n ) capacitor c=3.97665e-19 \
 //x=15.24 //y=0.875 //x2=15.505 //y2=0.835
cc_641 ( N_noxref_2_c_649_p N_noxref_17_c_3926_n ) capacitor c=0.00864609f \
 //x=15.615 //y=0.72 //x2=15.505 //y2=0.835
cc_642 ( N_noxref_2_c_449_p N_noxref_17_c_3926_n ) capacitor c=4.45447e-19 \
 //x=15.77 //y=0.875 //x2=15.505 //y2=0.835
cc_643 ( N_noxref_2_c_468_p N_noxref_17_c_3929_n ) capacitor c=0.00543195f \
 //x=13.205 //y=1.125 //x2=15.505 //y2=0.965
cc_644 ( N_noxref_2_c_415_p N_noxref_17_c_3929_n ) capacitor c=0.00770915f \
 //x=15.54 //y=2.195 //x2=15.505 //y2=0.965
cc_645 ( N_noxref_2_c_421_p N_noxref_17_c_3929_n ) capacitor c=0.0011623f \
 //x=15.54 //y=2.75 //x2=15.505 //y2=0.965
cc_646 ( N_noxref_2_c_416_p N_noxref_17_c_3929_n ) capacitor c=2.22861e-19 \
 //x=15.54 //y=2.08 //x2=15.505 //y2=0.965
cc_647 ( N_noxref_2_c_447_p N_noxref_17_c_3929_n ) capacitor c=0.00156339f \
 //x=15.24 //y=0.875 //x2=15.505 //y2=0.965
cc_648 ( N_noxref_2_c_448_p N_noxref_17_c_3929_n ) capacitor c=0.00352472f \
 //x=15.24 //y=1.22 //x2=15.505 //y2=0.965
cc_649 ( N_noxref_2_c_450_p N_noxref_17_c_3929_n ) capacitor c=3.88232e-19 \
 //x=15.24 //y=1.53 //x2=15.505 //y2=0.965
cc_650 ( N_noxref_2_c_649_p N_noxref_17_c_3929_n ) capacitor c=9.36995e-19 \
 //x=15.615 //y=0.72 //x2=15.505 //y2=0.965
cc_651 ( N_noxref_2_c_659_p N_noxref_17_c_3929_n ) capacitor c=5.27793e-19 \
 //x=15.615 //y=1.375 //x2=15.505 //y2=0.965
cc_652 ( N_noxref_2_c_449_p N_noxref_17_c_3929_n ) capacitor c=0.0017438f \
 //x=15.77 //y=0.875 //x2=15.505 //y2=0.965
cc_653 ( N_noxref_2_c_451_p N_noxref_17_c_3929_n ) capacitor c=0.00276804f \
 //x=15.77 //y=1.22 //x2=15.505 //y2=0.965
cc_654 ( N_noxref_2_c_469_p N_noxref_17_c_3886_n ) capacitor c=6.86937e-19 \
 //x=13.605 //y=1.665 //x2=14.26 //y2=0
cc_655 ( N_noxref_2_c_473_p N_noxref_17_c_3886_n ) capacitor c=6.02944e-19 \
 //x=13.69 //y=2.75 //x2=14.26 //y2=0
cc_656 ( N_noxref_2_c_447_p N_noxref_17_c_3942_n ) capacitor c=0.00675185f \
 //x=15.24 //y=0.875 //x2=19.07 //y2=0
cc_657 ( N_noxref_2_c_560_p N_noxref_17_c_3943_n ) capacitor c=0.0045138f \
 //x=13.205 //y=1.58 //x2=14.43 //y2=0
cc_658 ( N_noxref_2_c_469_p N_noxref_17_c_3943_n ) capacitor c=0.0233604f \
 //x=13.605 //y=1.665 //x2=14.43 //y2=0
cc_659 ( N_noxref_2_c_473_p N_noxref_17_c_3943_n ) capacitor c=0.00422913f \
 //x=13.69 //y=2.75 //x2=14.43 //y2=0
cc_660 ( N_noxref_2_c_415_p N_noxref_17_c_3943_n ) capacitor c=0.00330334f \
 //x=15.54 //y=2.195 //x2=14.43 //y2=0
cc_661 ( N_noxref_2_c_420_p N_noxref_17_c_3943_n ) capacitor c=0.00394827f \
 //x=15.54 //y=2.43 //x2=14.43 //y2=0
cc_662 ( N_noxref_2_c_421_p N_noxref_17_c_3943_n ) capacitor c=0.00305356f \
 //x=15.54 //y=2.75 //x2=14.43 //y2=0
cc_663 ( N_noxref_2_c_411_n N_noxref_17_c_3943_n ) capacitor c=0.0103933f \
 //x=13.69 //y=2.59 //x2=14.43 //y2=0
cc_664 ( N_noxref_2_c_423_p N_noxref_17_c_3943_n ) capacitor c=0.00527139f \
 //x=15.54 //y=2.59 //x2=14.43 //y2=0
cc_665 ( N_noxref_2_c_466_p N_noxref_17_c_3943_n ) capacitor c=0.00911627f \
 //x=15.39 //y=2.59 //x2=14.43 //y2=0
cc_666 ( N_noxref_2_c_416_p N_noxref_17_c_3943_n ) capacitor c=0.0039621f \
 //x=15.54 //y=2.08 //x2=14.43 //y2=0
cc_667 ( N_noxref_2_c_450_p N_noxref_17_c_3943_n ) capacitor c=0.00170145f \
 //x=15.24 //y=1.53 //x2=14.43 //y2=0
cc_668 ( N_noxref_2_c_417_p N_noxref_17_c_3943_n ) capacitor c=0.0102191f \
 //x=15.24 //y=1.915 //x2=14.43 //y2=0
cc_669 ( N_noxref_2_c_415_p N_noxref_17_M9_noxref_d ) capacitor c=4.4417e-19 \
 //x=15.54 //y=2.195 //x2=15.315 //y2=0.875
cc_670 ( N_noxref_2_c_447_p N_noxref_17_M9_noxref_d ) capacitor c=0.00184354f \
 //x=15.24 //y=0.875 //x2=15.315 //y2=0.875
cc_671 ( N_noxref_2_c_448_p N_noxref_17_M9_noxref_d ) capacitor c=0.00210798f \
 //x=15.24 //y=1.22 //x2=15.315 //y2=0.875
cc_672 ( N_noxref_2_c_649_p N_noxref_17_M9_noxref_d ) capacitor c=0.00474029f \
 //x=15.615 //y=0.72 //x2=15.315 //y2=0.875
cc_673 ( N_noxref_2_c_659_p N_noxref_17_M9_noxref_d ) capacitor c=0.00166857f \
 //x=15.615 //y=1.375 //x2=15.315 //y2=0.875
cc_674 ( N_noxref_2_c_449_p N_noxref_17_M9_noxref_d ) capacitor c=0.00230174f \
 //x=15.77 //y=0.875 //x2=15.315 //y2=0.875
cc_675 ( N_noxref_2_c_451_p N_noxref_17_M9_noxref_d ) capacitor c=0.00210798f \
 //x=15.77 //y=1.22 //x2=15.315 //y2=0.875
cc_676 ( N_noxref_2_c_417_p N_noxref_24_c_4813_n ) capacitor c=0.00262672f \
 //x=15.24 //y=1.915 //x2=15.02 //y2=1.505
cc_677 ( N_noxref_2_c_415_p N_noxref_24_c_4814_n ) capacitor c=0.00428451f \
 //x=15.54 //y=2.195 //x2=15.905 //y2=1.59
cc_678 ( N_noxref_2_c_421_p N_noxref_24_c_4814_n ) capacitor c=0.0046919f \
 //x=15.54 //y=2.75 //x2=15.905 //y2=1.59
cc_679 ( N_noxref_2_c_416_p N_noxref_24_c_4814_n ) capacitor c=0.0104666f \
 //x=15.54 //y=2.08 //x2=15.905 //y2=1.59
cc_680 ( N_noxref_2_c_450_p N_noxref_24_c_4814_n ) capacitor c=0.00705077f \
 //x=15.24 //y=1.53 //x2=15.905 //y2=1.59
cc_681 ( N_noxref_2_c_417_p N_noxref_24_c_4814_n ) capacitor c=0.0197809f \
 //x=15.24 //y=1.915 //x2=15.905 //y2=1.59
cc_682 ( N_noxref_2_c_659_p N_noxref_24_c_4814_n ) capacitor c=0.00588627f \
 //x=15.615 //y=1.375 //x2=15.905 //y2=1.59
cc_683 ( N_noxref_2_c_451_p N_noxref_24_c_4814_n ) capacitor c=0.00698822f \
 //x=15.77 //y=1.22 //x2=15.905 //y2=1.59
cc_684 ( N_noxref_2_c_447_p N_noxref_24_M9_noxref_s ) capacitor c=0.0295256f \
 //x=15.24 //y=0.875 //x2=14.885 //y2=0.375
cc_685 ( N_noxref_2_c_450_p N_noxref_24_M9_noxref_s ) capacitor c=7.99997e-19 \
 //x=15.24 //y=1.53 //x2=14.885 //y2=0.375
cc_686 ( N_noxref_2_c_417_p N_noxref_24_M9_noxref_s ) capacitor c=0.00122123f \
 //x=15.24 //y=1.915 //x2=14.885 //y2=0.375
cc_687 ( N_noxref_2_c_449_p N_noxref_24_M9_noxref_s ) capacitor c=0.0125924f \
 //x=15.77 //y=0.875 //x2=14.885 //y2=0.375
cc_688 ( N_noxref_3_c_708_n N_noxref_4_c_994_n ) capacitor c=0.0235444f \
 //x=7.025 //y=4.655 //x2=7.1 //y2=5.155
cc_689 ( N_noxref_3_c_713_n N_noxref_4_c_994_n ) capacitor c=0.00243099f \
 //x=7.025 //y=4.44 //x2=7.1 //y2=5.155
cc_690 ( N_noxref_3_c_719_n N_noxref_4_c_994_n ) capacitor c=0.00492634f \
 //x=7.03 //y=4.7 //x2=7.1 //y2=5.155
cc_691 ( N_noxref_3_M26_noxref_g N_noxref_4_c_994_n ) capacitor c=0.00858222f \
 //x=7 //y=6.02 //x2=7.1 //y2=5.155
cc_692 ( N_noxref_3_c_737_n N_noxref_4_c_994_n ) capacitor c=3.54644e-19 \
 //x=7.03 //y=4.7 //x2=7.1 //y2=5.155
cc_693 ( N_noxref_3_M27_noxref_g N_noxref_4_c_1078_n ) capacitor c=0.00955829f \
 //x=7.44 //y=6.02 //x2=7.985 //y2=5.155
cc_694 ( N_noxref_3_c_712_n N_noxref_4_c_1068_n ) capacitor c=0.0201076f \
 //x=16.495 //y=4.44 //x2=8.795 //y2=5.155
cc_695 ( N_noxref_3_c_699_n N_noxref_4_c_996_n ) capacitor c=0.00145246f \
 //x=7.03 //y=4.495 //x2=8.88 //y2=3.155
cc_696 ( N_noxref_3_c_699_n N_noxref_4_c_1004_n ) capacitor c=0.00193685f \
 //x=7.03 //y=4.495 //x2=8.88 //y2=5.07
cc_697 ( N_noxref_3_c_712_n N_noxref_4_c_1004_n ) capacitor c=0.0326471f \
 //x=16.495 //y=4.44 //x2=8.88 //y2=5.07
cc_698 ( N_noxref_3_c_708_n N_noxref_4_c_1083_n ) capacitor c=0.00512107f \
 //x=7.025 //y=4.655 //x2=7.22 //y2=5.155
cc_699 ( N_noxref_3_c_712_n N_noxref_4_c_1083_n ) capacitor c=0.0384754f \
 //x=16.495 //y=4.44 //x2=7.22 //y2=5.155
cc_700 ( N_noxref_3_c_713_n N_noxref_4_c_1083_n ) capacitor c=0.00207204f \
 //x=7.025 //y=4.44 //x2=7.22 //y2=5.155
cc_701 ( N_noxref_3_c_719_n N_noxref_4_c_1083_n ) capacitor c=0.00132214f \
 //x=7.03 //y=4.7 //x2=7.22 //y2=5.155
cc_702 ( N_noxref_3_M26_noxref_g N_noxref_4_c_1083_n ) capacitor c=0.00229818f \
 //x=7 //y=6.02 //x2=7.22 //y2=5.155
cc_703 ( N_noxref_3_M27_noxref_g N_noxref_4_c_1083_n ) capacitor c=0.00230699f \
 //x=7.44 //y=6.02 //x2=7.22 //y2=5.155
cc_704 ( N_noxref_3_c_802_p N_noxref_4_c_1083_n ) capacitor c=0.00170733f \
 //x=7.365 //y=4.79 //x2=7.22 //y2=5.155
cc_705 ( N_noxref_3_c_743_n N_noxref_4_c_1011_n ) capacitor c=0.0235243f \
 //x=16.65 //y=4.495 //x2=20.185 //y2=3.33
cc_706 ( N_noxref_3_c_712_n N_noxref_4_c_1011_n ) capacitor c=0.0339218f \
 //x=16.495 //y=4.44 //x2=20.185 //y2=3.33
cc_707 ( N_noxref_3_c_699_n N_noxref_4_c_1018_n ) capacitor c=0.030452f \
 //x=7.03 //y=4.495 //x2=8.72 //y2=3.315
cc_708 ( N_noxref_3_c_708_n N_noxref_4_c_1018_n ) capacitor c=4.35971e-19 \
 //x=7.025 //y=4.655 //x2=8.72 //y2=3.315
cc_709 ( N_noxref_3_c_713_n N_noxref_4_c_1018_n ) capacitor c=0.0385487f \
 //x=7.025 //y=4.44 //x2=8.72 //y2=3.315
cc_710 ( N_noxref_3_c_708_n N_noxref_4_c_1095_n ) capacitor c=0.00134045f \
 //x=7.025 //y=4.655 //x2=7.22 //y2=5.38
cc_711 ( N_noxref_3_M26_noxref_g N_noxref_4_c_1095_n ) capacitor c=0.0179041f \
 //x=7 //y=6.02 //x2=7.22 //y2=5.38
cc_712 ( N_noxref_3_M27_noxref_g N_noxref_4_c_1095_n ) capacitor c=0.0179041f \
 //x=7.44 //y=6.02 //x2=7.22 //y2=5.38
cc_713 ( N_noxref_3_c_802_p N_noxref_4_c_1095_n ) capacitor c=0.00293647f \
 //x=7.365 //y=4.79 //x2=7.22 //y2=5.38
cc_714 ( N_noxref_3_c_740_n N_noxref_5_c_1482_n ) capacitor c=0.00814679f \
 //x=16.65 //y=2.195 //x2=17.76 //y2=2.385
cc_715 ( N_noxref_3_c_743_n N_noxref_5_c_1482_n ) capacitor c=0.00368508f \
 //x=16.65 //y=4.495 //x2=17.76 //y2=2.385
cc_716 ( N_noxref_3_c_761_n N_noxref_5_c_1482_n ) capacitor c=0.00115994f \
 //x=16.65 //y=2.08 //x2=17.76 //y2=2.385
cc_717 ( N_noxref_3_c_780_n N_noxref_5_c_1482_n ) capacitor c=0.00151788f \
 //x=16.74 //y=1.915 //x2=17.76 //y2=2.385
cc_718 ( N_noxref_3_c_743_n N_noxref_5_c_1464_n ) capacitor c=0.0536498f \
 //x=16.65 //y=4.495 //x2=17.76 //y2=4.57
cc_719 ( N_noxref_3_c_751_n N_noxref_5_c_1464_n ) capacitor c=0.00855488f \
 //x=16.655 //y=4.655 //x2=17.76 //y2=4.57
cc_720 ( N_noxref_3_c_760_n N_noxref_5_c_1464_n ) capacitor c=0.00909697f \
 //x=16.655 //y=4.44 //x2=17.76 //y2=4.57
cc_721 ( N_noxref_3_c_765_n N_noxref_5_c_1464_n ) capacitor c=4.56604e-19 \
 //x=16.65 //y=4.7 //x2=17.76 //y2=4.57
cc_722 ( N_noxref_3_c_696_n N_noxref_5_c_1436_n ) capacitor c=0.0168576f \
 //x=7.03 //y=2.195 //x2=13.305 //y2=2.22
cc_723 ( N_noxref_3_c_699_n N_noxref_5_c_1436_n ) capacitor c=0.0137582f \
 //x=7.03 //y=4.495 //x2=13.305 //y2=2.22
cc_724 ( N_noxref_3_c_715_n N_noxref_5_c_1436_n ) capacitor c=5.2767e-19 \
 //x=7.03 //y=2.08 //x2=13.305 //y2=2.22
cc_725 ( N_noxref_3_c_740_n N_noxref_5_c_1481_n ) capacitor c=0.0187206f \
 //x=16.65 //y=2.195 //x2=17.925 //y2=2.22
cc_726 ( N_noxref_3_c_743_n N_noxref_5_c_1481_n ) capacitor c=0.0176132f \
 //x=16.65 //y=4.495 //x2=17.925 //y2=2.22
cc_727 ( N_noxref_3_c_761_n N_noxref_5_c_1481_n ) capacitor c=2.63835e-19 \
 //x=16.65 //y=2.08 //x2=17.925 //y2=2.22
cc_728 ( N_noxref_3_c_740_n N_noxref_5_c_1496_n ) capacitor c=5.42289e-19 \
 //x=16.65 //y=2.195 //x2=17.76 //y2=2.08
cc_729 ( N_noxref_3_c_761_n N_noxref_5_c_1496_n ) capacitor c=0.00124908f \
 //x=16.65 //y=2.08 //x2=17.76 //y2=2.08
cc_730 ( N_noxref_3_c_780_n N_noxref_5_c_1496_n ) capacitor c=0.00209592f \
 //x=16.74 //y=1.915 //x2=17.76 //y2=2.08
cc_731 ( N_noxref_3_c_751_n N_noxref_5_c_1499_n ) capacitor c=7.60106e-19 \
 //x=16.655 //y=4.655 //x2=17.76 //y2=4.7
cc_732 ( N_noxref_3_c_765_n N_noxref_5_c_1499_n ) capacitor c=0.00113666f \
 //x=16.65 //y=4.7 //x2=17.76 //y2=4.7
cc_733 ( N_noxref_3_c_783_n N_noxref_5_c_1499_n ) capacitor c=9.77556e-19 \
 //x=16.65 //y=4.7 //x2=17.76 //y2=4.7
cc_734 ( N_noxref_3_M38_noxref_g N_noxref_5_M40_noxref_g ) capacitor \
 c=0.0101598f //x=16.62 //y=6.02 //x2=17.5 //y2=6.02
cc_735 ( N_noxref_3_M39_noxref_g N_noxref_5_M40_noxref_g ) capacitor \
 c=0.0607518f //x=17.06 //y=6.02 //x2=17.5 //y2=6.02
cc_736 ( N_noxref_3_M39_noxref_g N_noxref_5_M41_noxref_g ) capacitor \
 c=0.0101598f //x=17.06 //y=6.02 //x2=17.94 //y2=6.02
cc_737 ( N_noxref_3_c_777_n N_noxref_5_c_1505_n ) capacitor c=0.00456962f \
 //x=16.74 //y=0.91 //x2=17.75 //y2=0.915
cc_738 ( N_noxref_3_c_778_n N_noxref_5_c_1506_n ) capacitor c=0.00438372f \
 //x=16.74 //y=1.22 //x2=17.75 //y2=1.26
cc_739 ( N_noxref_3_c_779_n N_noxref_5_c_1507_n ) capacitor c=0.00438372f \
 //x=16.74 //y=1.45 //x2=17.75 //y2=1.57
cc_740 ( N_noxref_3_c_740_n N_noxref_5_c_1508_n ) capacitor c=6.32114e-19 \
 //x=16.65 //y=2.195 //x2=17.76 //y2=2.08
cc_741 ( N_noxref_3_c_761_n N_noxref_5_c_1508_n ) capacitor c=0.00172812f \
 //x=16.65 //y=2.08 //x2=17.76 //y2=2.08
cc_742 ( N_noxref_3_c_780_n N_noxref_5_c_1508_n ) capacitor c=0.00865408f \
 //x=16.74 //y=1.915 //x2=17.76 //y2=2.08
cc_743 ( N_noxref_3_c_780_n N_noxref_5_c_1511_n ) capacitor c=0.00438372f \
 //x=16.74 //y=1.915 //x2=17.76 //y2=1.915
cc_744 ( N_noxref_3_c_751_n N_noxref_5_c_1512_n ) capacitor c=0.00133906f \
 //x=16.655 //y=4.655 //x2=17.76 //y2=4.7
cc_745 ( N_noxref_3_c_765_n N_noxref_5_c_1512_n ) capacitor c=0.00186974f \
 //x=16.65 //y=4.7 //x2=17.76 //y2=4.7
cc_746 ( N_noxref_3_c_844_p N_noxref_5_c_1512_n ) capacitor c=0.0616777f \
 //x=16.985 //y=4.79 //x2=17.76 //y2=4.7
cc_747 ( N_noxref_3_c_783_n N_noxref_5_c_1512_n ) capacitor c=0.0042693f \
 //x=16.65 //y=4.7 //x2=17.76 //y2=4.7
cc_748 ( N_noxref_3_c_712_n N_noxref_6_c_1914_n ) capacitor c=0.0334453f \
 //x=16.495 //y=4.44 //x2=11.84 //y2=4.585
cc_749 ( N_noxref_3_c_743_n N_noxref_6_c_1964_n ) capacitor c=5.00011e-19 \
 //x=16.65 //y=4.495 //x2=15.765 //y2=2.975
cc_750 ( N_noxref_3_c_743_n N_noxref_6_c_1979_n ) capacitor c=0.0261813f \
 //x=16.65 //y=4.495 //x2=19.96 //y2=2.96
cc_751 ( N_noxref_3_c_696_n N_noxref_7_c_2313_n ) capacitor c=0.00939109f \
 //x=7.03 //y=2.195 //x2=8.14 //y2=2.195
cc_752 ( N_noxref_3_c_715_n N_noxref_7_c_2313_n ) capacitor c=5.39999e-19 \
 //x=7.03 //y=2.08 //x2=8.14 //y2=2.195
cc_753 ( N_noxref_3_c_734_n N_noxref_7_c_2313_n ) capacitor c=0.00137098f \
 //x=7.12 //y=1.915 //x2=8.14 //y2=2.195
cc_754 ( N_noxref_3_c_699_n N_noxref_7_c_2236_n ) capacitor c=0.0332928f \
 //x=7.03 //y=4.495 //x2=8.14 //y2=3.555
cc_755 ( N_noxref_3_c_715_n N_noxref_7_c_2236_n ) capacitor c=3.9149e-19 \
 //x=7.03 //y=2.08 //x2=8.14 //y2=3.555
cc_756 ( N_noxref_3_c_699_n N_noxref_7_c_2318_n ) capacitor c=0.00782712f \
 //x=7.03 //y=4.495 //x2=8.14 //y2=3.875
cc_757 ( N_noxref_3_c_712_n N_noxref_7_c_2318_n ) capacitor c=0.00309756f \
 //x=16.495 //y=4.44 //x2=8.14 //y2=3.875
cc_758 ( N_noxref_3_c_699_n N_noxref_7_c_2241_n ) capacitor c=0.0163921f \
 //x=7.03 //y=4.495 //x2=8.14 //y2=4.57
cc_759 ( N_noxref_3_c_708_n N_noxref_7_c_2241_n ) capacitor c=0.0082089f \
 //x=7.025 //y=4.655 //x2=8.14 //y2=4.57
cc_760 ( N_noxref_3_c_712_n N_noxref_7_c_2241_n ) capacitor c=0.0307559f \
 //x=16.495 //y=4.44 //x2=8.14 //y2=4.57
cc_761 ( N_noxref_3_c_713_n N_noxref_7_c_2241_n ) capacitor c=0.00655852f \
 //x=7.025 //y=4.44 //x2=8.14 //y2=4.57
cc_762 ( N_noxref_3_c_719_n N_noxref_7_c_2241_n ) capacitor c=4.56604e-19 \
 //x=7.03 //y=4.7 //x2=8.14 //y2=4.57
cc_763 ( N_noxref_3_c_712_n N_noxref_7_c_2256_n ) capacitor c=0.00309756f \
 //x=16.495 //y=4.44 //x2=12.95 //y2=3.875
cc_764 ( N_noxref_3_c_712_n N_noxref_7_c_2245_n ) capacitor c=0.0307931f \
 //x=16.495 //y=4.44 //x2=12.95 //y2=4.57
cc_765 ( N_noxref_3_c_751_n N_noxref_7_c_2264_n ) capacitor c=0.0227484f \
 //x=16.655 //y=4.655 //x2=16.72 //y2=5.155
cc_766 ( N_noxref_3_c_760_n N_noxref_7_c_2264_n ) capacitor c=0.00213056f \
 //x=16.655 //y=4.44 //x2=16.72 //y2=5.155
cc_767 ( N_noxref_3_c_765_n N_noxref_7_c_2264_n ) capacitor c=0.00492634f \
 //x=16.65 //y=4.7 //x2=16.72 //y2=5.155
cc_768 ( N_noxref_3_M38_noxref_g N_noxref_7_c_2264_n ) capacitor c=0.00858222f \
 //x=16.62 //y=6.02 //x2=16.72 //y2=5.155
cc_769 ( N_noxref_3_c_783_n N_noxref_7_c_2264_n ) capacitor c=3.54644e-19 \
 //x=16.65 //y=4.7 //x2=16.72 //y2=5.155
cc_770 ( N_noxref_3_M39_noxref_g N_noxref_7_c_2332_n ) capacitor c=0.0110196f \
 //x=17.06 //y=6.02 //x2=17.605 //y2=5.155
cc_771 ( N_noxref_3_c_743_n N_noxref_7_c_2333_n ) capacitor c=0.00239078f \
 //x=16.65 //y=4.495 //x2=18.5 //y2=3.555
cc_772 ( N_noxref_3_c_743_n N_noxref_7_c_2334_n ) capacitor c=9.19219e-19 \
 //x=16.65 //y=4.495 //x2=18.5 //y2=5.07
cc_773 ( N_noxref_3_c_699_n N_noxref_7_c_2335_n ) capacitor c=5.01652e-19 \
 //x=7.03 //y=4.495 //x2=8.14 //y2=3.7
cc_774 ( N_noxref_3_c_712_n N_noxref_7_c_2267_n ) capacitor c=0.0283605f \
 //x=16.495 //y=4.44 //x2=15.962 //y2=5.155
cc_775 ( N_noxref_3_c_751_n N_noxref_7_c_2337_n ) capacitor c=0.00585991f \
 //x=16.655 //y=4.655 //x2=16.84 //y2=5.155
cc_776 ( N_noxref_3_c_760_n N_noxref_7_c_2337_n ) capacitor c=0.00237316f \
 //x=16.655 //y=4.44 //x2=16.84 //y2=5.155
cc_777 ( N_noxref_3_c_765_n N_noxref_7_c_2337_n ) capacitor c=0.00132214f \
 //x=16.65 //y=4.7 //x2=16.84 //y2=5.155
cc_778 ( N_noxref_3_M38_noxref_g N_noxref_7_c_2337_n ) capacitor c=0.00229818f \
 //x=16.62 //y=6.02 //x2=16.84 //y2=5.155
cc_779 ( N_noxref_3_M39_noxref_g N_noxref_7_c_2337_n ) capacitor c=0.00230699f \
 //x=17.06 //y=6.02 //x2=16.84 //y2=5.155
cc_780 ( N_noxref_3_c_844_p N_noxref_7_c_2337_n ) capacitor c=0.00170831f \
 //x=16.985 //y=4.79 //x2=16.84 //y2=5.155
cc_781 ( N_noxref_3_c_743_n N_noxref_7_c_2272_n ) capacitor c=0.0260463f \
 //x=16.65 //y=4.495 //x2=18.33 //y2=3.7
cc_782 ( N_noxref_3_c_751_n N_noxref_7_c_2272_n ) capacitor c=0.00108398f \
 //x=16.655 //y=4.655 //x2=18.33 //y2=3.7
cc_783 ( N_noxref_3_c_712_n N_noxref_7_c_2272_n ) capacitor c=0.165733f \
 //x=16.495 //y=4.44 //x2=18.33 //y2=3.7
cc_784 ( N_noxref_3_c_760_n N_noxref_7_c_2272_n ) capacitor c=0.00306887f \
 //x=16.655 //y=4.44 //x2=18.33 //y2=3.7
cc_785 ( N_noxref_3_c_699_n N_noxref_7_c_2347_n ) capacitor c=0.00513442f \
 //x=7.03 //y=4.495 //x2=8.3 //y2=3.715
cc_786 ( N_noxref_3_c_712_n N_noxref_7_c_2347_n ) capacitor c=0.016229f \
 //x=16.495 //y=4.44 //x2=8.3 //y2=3.715
cc_787 ( N_noxref_3_c_712_n N_noxref_7_c_2246_n ) capacitor c=0.202787f \
 //x=16.495 //y=4.44 //x2=12.79 //y2=3.715
cc_788 ( N_noxref_3_c_712_n N_noxref_7_c_2274_n ) capacitor c=0.016229f \
 //x=16.495 //y=4.44 //x2=13.11 //y2=3.715
cc_789 ( N_noxref_3_c_696_n N_noxref_7_c_2351_n ) capacitor c=5.42289e-19 \
 //x=7.03 //y=2.195 //x2=8.14 //y2=2.08
cc_790 ( N_noxref_3_c_699_n N_noxref_7_c_2351_n ) capacitor c=3.9149e-19 \
 //x=7.03 //y=4.495 //x2=8.14 //y2=2.08
cc_791 ( N_noxref_3_c_715_n N_noxref_7_c_2351_n ) capacitor c=0.00125213f \
 //x=7.03 //y=2.08 //x2=8.14 //y2=2.08
cc_792 ( N_noxref_3_c_734_n N_noxref_7_c_2351_n ) capacitor c=0.00209664f \
 //x=7.12 //y=1.915 //x2=8.14 //y2=2.08
cc_793 ( N_noxref_3_c_708_n N_noxref_7_c_2355_n ) capacitor c=7.52809e-19 \
 //x=7.025 //y=4.655 //x2=8.14 //y2=4.7
cc_794 ( N_noxref_3_c_719_n N_noxref_7_c_2355_n ) capacitor c=0.00113671f \
 //x=7.03 //y=4.7 //x2=8.14 //y2=4.7
cc_795 ( N_noxref_3_c_737_n N_noxref_7_c_2355_n ) capacitor c=9.77556e-19 \
 //x=7.03 //y=4.7 //x2=8.14 //y2=4.7
cc_796 ( N_noxref_3_c_751_n N_noxref_7_c_2358_n ) capacitor c=0.00148364f \
 //x=16.655 //y=4.655 //x2=16.84 //y2=5.38
cc_797 ( N_noxref_3_M38_noxref_g N_noxref_7_c_2358_n ) capacitor c=0.0179041f \
 //x=16.62 //y=6.02 //x2=16.84 //y2=5.38
cc_798 ( N_noxref_3_M39_noxref_g N_noxref_7_c_2358_n ) capacitor c=0.0179041f \
 //x=17.06 //y=6.02 //x2=16.84 //y2=5.38
cc_799 ( N_noxref_3_c_844_p N_noxref_7_c_2358_n ) capacitor c=0.00295522f \
 //x=16.985 //y=4.79 //x2=16.84 //y2=5.38
cc_800 ( N_noxref_3_M26_noxref_g N_noxref_7_M28_noxref_g ) capacitor \
 c=0.0101598f //x=7 //y=6.02 //x2=7.88 //y2=6.02
cc_801 ( N_noxref_3_M27_noxref_g N_noxref_7_M28_noxref_g ) capacitor \
 c=0.0607518f //x=7.44 //y=6.02 //x2=7.88 //y2=6.02
cc_802 ( N_noxref_3_M27_noxref_g N_noxref_7_M29_noxref_g ) capacitor \
 c=0.0101598f //x=7.44 //y=6.02 //x2=8.32 //y2=6.02
cc_803 ( N_noxref_3_c_731_n N_noxref_7_c_2365_n ) capacitor c=0.00456962f \
 //x=7.12 //y=0.91 //x2=8.13 //y2=0.915
cc_804 ( N_noxref_3_c_732_n N_noxref_7_c_2366_n ) capacitor c=0.00438372f \
 //x=7.12 //y=1.22 //x2=8.13 //y2=1.26
cc_805 ( N_noxref_3_c_733_n N_noxref_7_c_2367_n ) capacitor c=0.00438372f \
 //x=7.12 //y=1.45 //x2=8.13 //y2=1.57
cc_806 ( N_noxref_3_c_696_n N_noxref_7_c_2368_n ) capacitor c=0.00134951f \
 //x=7.03 //y=2.195 //x2=8.14 //y2=2.08
cc_807 ( N_noxref_3_c_715_n N_noxref_7_c_2368_n ) capacitor c=0.00204868f \
 //x=7.03 //y=2.08 //x2=8.14 //y2=2.08
cc_808 ( N_noxref_3_c_734_n N_noxref_7_c_2368_n ) capacitor c=0.00933826f \
 //x=7.12 //y=1.915 //x2=8.14 //y2=2.08
cc_809 ( N_noxref_3_c_734_n N_noxref_7_c_2371_n ) capacitor c=0.00438372f \
 //x=7.12 //y=1.915 //x2=8.14 //y2=1.915
cc_810 ( N_noxref_3_c_708_n N_noxref_7_c_2372_n ) capacitor c=0.0013272f \
 //x=7.025 //y=4.655 //x2=8.14 //y2=4.7
cc_811 ( N_noxref_3_c_719_n N_noxref_7_c_2372_n ) capacitor c=0.00186974f \
 //x=7.03 //y=4.7 //x2=8.14 //y2=4.7
cc_812 ( N_noxref_3_c_802_p N_noxref_7_c_2372_n ) capacitor c=0.0616777f \
 //x=7.365 //y=4.79 //x2=8.14 //y2=4.7
cc_813 ( N_noxref_3_c_737_n N_noxref_7_c_2372_n ) capacitor c=0.0042693f \
 //x=7.03 //y=4.7 //x2=8.14 //y2=4.7
cc_814 ( N_noxref_3_M26_noxref_g N_noxref_8_c_2907_n ) capacitor c=0.00700336f \
 //x=7 //y=6.02 //x2=7.575 //y2=7.4
cc_815 ( N_noxref_3_M27_noxref_g N_noxref_8_c_2907_n ) capacitor c=0.00749619f \
 //x=7.44 //y=6.02 //x2=7.575 //y2=7.4
cc_816 ( N_noxref_3_M38_noxref_g N_noxref_8_c_2909_n ) capacitor c=0.00700336f \
 //x=16.62 //y=6.02 //x2=17.195 //y2=7.4
cc_817 ( N_noxref_3_M39_noxref_g N_noxref_8_c_2909_n ) capacitor c=0.00749619f \
 //x=17.06 //y=6.02 //x2=17.195 //y2=7.4
cc_818 ( N_noxref_3_c_712_n N_noxref_8_c_2827_n ) capacitor c=0.0253781f \
 //x=16.495 //y=4.44 //x2=9.62 //y2=7.4
cc_819 ( N_noxref_3_c_712_n N_noxref_8_c_2881_n ) capacitor c=0.0253781f \
 //x=16.495 //y=4.44 //x2=14.43 //y2=7.4
cc_820 ( N_noxref_3_M26_noxref_g N_noxref_8_M25_noxref_d ) capacitor \
 c=0.015318f //x=7 //y=6.02 //x2=6.635 //y2=5.02
cc_821 ( N_noxref_3_M27_noxref_g N_noxref_8_M27_noxref_d ) capacitor \
 c=0.015318f //x=7.44 //y=6.02 //x2=7.515 //y2=5.02
cc_822 ( N_noxref_3_c_712_n N_noxref_8_M30_noxref_s ) capacitor c=8.56765e-19 \
 //x=16.495 //y=4.44 //x2=10.575 //y2=5.02
cc_823 ( N_noxref_3_c_712_n N_noxref_8_M36_noxref_s ) capacitor c=8.57911e-19 \
 //x=16.495 //y=4.44 //x2=15.385 //y2=5.02
cc_824 ( N_noxref_3_M38_noxref_g N_noxref_8_M37_noxref_d ) capacitor \
 c=0.015318f //x=16.62 //y=6.02 //x2=16.255 //y2=5.02
cc_825 ( N_noxref_3_M39_noxref_g N_noxref_8_M39_noxref_d ) capacitor \
 c=0.015318f //x=17.06 //y=6.02 //x2=17.135 //y2=5.02
cc_826 ( N_noxref_3_c_731_n N_noxref_11_c_3341_n ) capacitor c=0.00123426f \
 //x=7.12 //y=0.91 //x2=7.825 //y2=0.995
cc_827 ( N_noxref_3_c_732_n N_noxref_11_c_3341_n ) capacitor c=0.0129288f \
 //x=7.12 //y=1.22 //x2=7.825 //y2=0.995
cc_828 ( N_noxref_3_c_733_n N_noxref_11_c_3341_n ) capacitor c=0.00132209f \
 //x=7.12 //y=1.45 //x2=7.825 //y2=0.995
cc_829 ( N_noxref_3_c_696_n N_noxref_11_M4_noxref_d ) capacitor c=0.00600656f \
 //x=7.03 //y=2.195 //x2=6.67 //y2=0.91
cc_830 ( N_noxref_3_c_715_n N_noxref_11_M4_noxref_d ) capacitor c=2.2052e-19 \
 //x=7.03 //y=2.08 //x2=6.67 //y2=0.91
cc_831 ( N_noxref_3_c_726_n N_noxref_11_M4_noxref_d ) capacitor c=0.00253592f \
 //x=6.595 //y=0.91 //x2=6.67 //y2=0.91
cc_832 ( N_noxref_3_c_729_n N_noxref_11_M4_noxref_d ) capacitor c=0.00604087f \
 //x=6.595 //y=1.22 //x2=6.67 //y2=0.91
cc_833 ( N_noxref_3_c_931_p N_noxref_11_M4_noxref_d ) capacitor c=0.002686f \
 //x=6.965 //y=0.755 //x2=6.67 //y2=0.91
cc_834 ( N_noxref_3_c_932_p N_noxref_11_M4_noxref_d ) capacitor c=0.00251995f \
 //x=6.965 //y=1.375 //x2=6.67 //y2=0.91
cc_835 ( N_noxref_3_c_731_n N_noxref_11_M4_noxref_d ) capacitor c=0.00314523f \
 //x=7.12 //y=0.91 //x2=6.67 //y2=0.91
cc_836 ( N_noxref_3_c_732_n N_noxref_11_M4_noxref_d ) capacitor c=0.00168289f \
 //x=7.12 //y=1.22 //x2=6.67 //y2=0.91
cc_837 ( N_noxref_3_c_733_n N_noxref_11_M4_noxref_d ) capacitor c=0.00111165f \
 //x=7.12 //y=1.45 //x2=6.67 //y2=0.91
cc_838 ( N_noxref_3_c_731_n N_noxref_11_M5_noxref_s ) capacitor c=7.21316e-19 \
 //x=7.12 //y=0.91 //x2=7.775 //y2=0.375
cc_839 ( N_noxref_3_c_732_n N_noxref_11_M5_noxref_s ) capacitor c=0.00365271f \
 //x=7.12 //y=1.22 //x2=7.775 //y2=0.375
cc_840 ( N_noxref_3_c_734_n N_noxref_11_M5_noxref_s ) capacitor c=9.86711e-19 \
 //x=7.12 //y=1.915 //x2=7.775 //y2=0.375
cc_841 ( N_noxref_3_c_777_n N_noxref_13_c_3482_n ) capacitor c=0.00123426f \
 //x=16.74 //y=0.91 //x2=17.445 //y2=0.995
cc_842 ( N_noxref_3_c_778_n N_noxref_13_c_3482_n ) capacitor c=0.0129288f \
 //x=16.74 //y=1.22 //x2=17.445 //y2=0.995
cc_843 ( N_noxref_3_c_779_n N_noxref_13_c_3482_n ) capacitor c=0.00132209f \
 //x=16.74 //y=1.45 //x2=17.445 //y2=0.995
cc_844 ( N_noxref_3_c_740_n N_noxref_13_M10_noxref_d ) capacitor c=0.00600656f \
 //x=16.65 //y=2.195 //x2=16.29 //y2=0.91
cc_845 ( N_noxref_3_c_761_n N_noxref_13_M10_noxref_d ) capacitor c=2.2052e-19 \
 //x=16.65 //y=2.08 //x2=16.29 //y2=0.91
cc_846 ( N_noxref_3_c_772_n N_noxref_13_M10_noxref_d ) capacitor c=0.00253592f \
 //x=16.215 //y=0.91 //x2=16.29 //y2=0.91
cc_847 ( N_noxref_3_c_775_n N_noxref_13_M10_noxref_d ) capacitor c=0.00604087f \
 //x=16.215 //y=1.22 //x2=16.29 //y2=0.91
cc_848 ( N_noxref_3_c_946_p N_noxref_13_M10_noxref_d ) capacitor c=0.002686f \
 //x=16.585 //y=0.755 //x2=16.29 //y2=0.91
cc_849 ( N_noxref_3_c_947_p N_noxref_13_M10_noxref_d ) capacitor c=0.00251995f \
 //x=16.585 //y=1.375 //x2=16.29 //y2=0.91
cc_850 ( N_noxref_3_c_777_n N_noxref_13_M10_noxref_d ) capacitor c=0.00314523f \
 //x=16.74 //y=0.91 //x2=16.29 //y2=0.91
cc_851 ( N_noxref_3_c_778_n N_noxref_13_M10_noxref_d ) capacitor c=0.00168289f \
 //x=16.74 //y=1.22 //x2=16.29 //y2=0.91
cc_852 ( N_noxref_3_c_779_n N_noxref_13_M10_noxref_d ) capacitor c=0.00111165f \
 //x=16.74 //y=1.45 //x2=16.29 //y2=0.91
cc_853 ( N_noxref_3_c_777_n N_noxref_13_M11_noxref_s ) capacitor c=7.21316e-19 \
 //x=16.74 //y=0.91 //x2=17.395 //y2=0.375
cc_854 ( N_noxref_3_c_778_n N_noxref_13_M11_noxref_s ) capacitor c=0.00365271f \
 //x=16.74 //y=1.22 //x2=17.395 //y2=0.375
cc_855 ( N_noxref_3_c_780_n N_noxref_13_M11_noxref_s ) capacitor c=9.86711e-19 \
 //x=16.74 //y=1.915 //x2=17.395 //y2=0.375
cc_856 ( N_noxref_3_c_696_n N_noxref_17_c_3962_n ) capacitor c=7.98245e-19 \
 //x=7.03 //y=2.195 //x2=10.61 //y2=0
cc_857 ( N_noxref_3_c_740_n N_noxref_17_c_3963_n ) capacitor c=7.97935e-19 \
 //x=16.65 //y=2.195 //x2=20.23 //y2=0
cc_858 ( N_noxref_3_c_726_n N_noxref_22_c_4708_n ) capacitor c=0.0167228f \
 //x=6.595 //y=0.91 //x2=7.255 //y2=0.54
cc_859 ( N_noxref_3_c_731_n N_noxref_22_c_4708_n ) capacitor c=0.00534519f \
 //x=7.12 //y=0.91 //x2=7.255 //y2=0.54
cc_860 ( N_noxref_3_c_696_n N_noxref_22_c_4710_n ) capacitor c=0.0048147f \
 //x=7.03 //y=2.195 //x2=7.255 //y2=1.59
cc_861 ( N_noxref_3_c_708_n N_noxref_22_c_4710_n ) capacitor c=8.72493e-19 \
 //x=7.025 //y=4.655 //x2=7.255 //y2=1.59
cc_862 ( N_noxref_3_c_715_n N_noxref_22_c_4710_n ) capacitor c=0.0105652f \
 //x=7.03 //y=2.08 //x2=7.255 //y2=1.59
cc_863 ( N_noxref_3_c_729_n N_noxref_22_c_4710_n ) capacitor c=0.0153476f \
 //x=6.595 //y=1.22 //x2=7.255 //y2=1.59
cc_864 ( N_noxref_3_c_734_n N_noxref_22_c_4710_n ) capacitor c=0.0216832f \
 //x=7.12 //y=1.915 //x2=7.255 //y2=1.59
cc_865 ( N_noxref_3_c_726_n N_noxref_22_M3_noxref_s ) capacitor c=0.00798959f \
 //x=6.595 //y=0.91 //x2=5.265 //y2=0.375
cc_866 ( N_noxref_3_c_733_n N_noxref_22_M3_noxref_s ) capacitor c=0.00212176f \
 //x=7.12 //y=1.45 //x2=5.265 //y2=0.375
cc_867 ( N_noxref_3_c_734_n N_noxref_22_M3_noxref_s ) capacitor c=0.00298115f \
 //x=7.12 //y=1.915 //x2=5.265 //y2=0.375
cc_868 ( N_noxref_3_c_772_n N_noxref_24_c_4825_n ) capacitor c=0.0167228f \
 //x=16.215 //y=0.91 //x2=16.875 //y2=0.54
cc_869 ( N_noxref_3_c_777_n N_noxref_24_c_4825_n ) capacitor c=0.00534519f \
 //x=16.74 //y=0.91 //x2=16.875 //y2=0.54
cc_870 ( N_noxref_3_c_740_n N_noxref_24_c_4827_n ) capacitor c=0.00481485f \
 //x=16.65 //y=2.195 //x2=16.875 //y2=1.59
cc_871 ( N_noxref_3_c_751_n N_noxref_24_c_4827_n ) capacitor c=0.00102459f \
 //x=16.655 //y=4.655 //x2=16.875 //y2=1.59
cc_872 ( N_noxref_3_c_761_n N_noxref_24_c_4827_n ) capacitor c=0.0105652f \
 //x=16.65 //y=2.08 //x2=16.875 //y2=1.59
cc_873 ( N_noxref_3_c_775_n N_noxref_24_c_4827_n ) capacitor c=0.0153476f \
 //x=16.215 //y=1.22 //x2=16.875 //y2=1.59
cc_874 ( N_noxref_3_c_780_n N_noxref_24_c_4827_n ) capacitor c=0.0216832f \
 //x=16.74 //y=1.915 //x2=16.875 //y2=1.59
cc_875 ( N_noxref_3_c_772_n N_noxref_24_M9_noxref_s ) capacitor c=0.00798959f \
 //x=16.215 //y=0.91 //x2=14.885 //y2=0.375
cc_876 ( N_noxref_3_c_779_n N_noxref_24_M9_noxref_s ) capacitor c=0.00212176f \
 //x=16.74 //y=1.45 //x2=14.885 //y2=0.375
cc_877 ( N_noxref_3_c_780_n N_noxref_24_M9_noxref_s ) capacitor c=0.00298115f \
 //x=16.74 //y=1.915 //x2=14.885 //y2=0.375
cc_878 ( N_noxref_4_c_976_n N_noxref_5_c_1430_n ) capacitor c=0.00806473f \
 //x=3.33 //y=2.195 //x2=2.22 //y2=2.38
cc_879 ( N_noxref_4_c_977_n N_noxref_5_c_1430_n ) capacitor c=0.00361597f \
 //x=3.33 //y=3.175 //x2=2.22 //y2=2.38
cc_880 ( N_noxref_4_c_1029_n N_noxref_5_c_1430_n ) capacitor c=0.00116634f \
 //x=3.33 //y=2.08 //x2=2.22 //y2=2.38
cc_881 ( N_noxref_4_c_1061_n N_noxref_5_c_1430_n ) capacitor c=0.00149512f \
 //x=3.33 //y=2.08 //x2=2.22 //y2=2.38
cc_882 ( N_noxref_4_c_977_n N_noxref_5_c_1432_n ) capacitor c=0.0241688f \
 //x=3.33 //y=3.175 //x2=2.22 //y2=4.585
cc_883 ( N_noxref_4_c_984_n N_noxref_5_c_1432_n ) capacitor c=0.00763467f \
 //x=3.33 //y=3.495 //x2=2.22 //y2=4.585
cc_884 ( N_noxref_4_c_989_n N_noxref_5_c_1432_n ) capacitor c=0.0443291f \
 //x=3.33 //y=4.57 //x2=2.22 //y2=4.585
cc_885 ( N_noxref_4_c_1005_n N_noxref_5_c_1432_n ) capacitor c=3.43503e-19 \
 //x=3.33 //y=3.33 //x2=2.22 //y2=4.585
cc_886 ( N_noxref_4_c_1015_n N_noxref_5_c_1432_n ) capacitor c=0.00504602f \
 //x=3.5 //y=3.335 //x2=2.22 //y2=4.585
cc_887 ( N_noxref_4_c_1030_n N_noxref_5_c_1432_n ) capacitor c=7.51101e-19 \
 //x=3.33 //y=4.7 //x2=2.22 //y2=4.585
cc_888 ( N_noxref_4_c_1064_n N_noxref_5_c_1432_n ) capacitor c=0.00124604f \
 //x=3.33 //y=4.7 //x2=2.22 //y2=4.585
cc_889 ( N_noxref_4_c_1110_p N_noxref_5_c_1464_n ) capacitor c=0.00146315f \
 //x=20.35 //y=3.17 //x2=17.76 //y2=4.57
cc_890 ( N_noxref_4_c_1111_p N_noxref_5_c_1464_n ) capacitor c=0.00234559f \
 //x=20.35 //y=4.575 //x2=17.76 //y2=4.57
cc_891 ( N_noxref_4_c_1011_n N_noxref_5_c_1464_n ) capacitor c=0.0220806f \
 //x=20.185 //y=3.33 //x2=17.76 //y2=4.57
cc_892 ( N_noxref_4_c_1113_p N_noxref_5_c_1530_n ) capacitor c=0.00820823f \
 //x=20.35 //y=2.195 //x2=21.46 //y2=2.39
cc_893 ( N_noxref_4_c_1110_p N_noxref_5_c_1530_n ) capacitor c=0.00387426f \
 //x=20.35 //y=3.17 //x2=21.46 //y2=2.39
cc_894 ( N_noxref_4_c_1115_p N_noxref_5_c_1530_n ) capacitor c=0.00116826f \
 //x=20.35 //y=2.08 //x2=21.46 //y2=2.39
cc_895 ( N_noxref_4_c_1116_p N_noxref_5_c_1530_n ) capacitor c=0.00158832f \
 //x=20.05 //y=1.915 //x2=21.46 //y2=2.39
cc_896 ( N_noxref_4_c_1110_p N_noxref_5_c_1534_n ) capacitor c=0.0213198f \
 //x=20.35 //y=3.17 //x2=21.46 //y2=4.585
cc_897 ( N_noxref_4_c_1118_p N_noxref_5_c_1534_n ) capacitor c=0.00769355f \
 //x=20.35 //y=3.49 //x2=21.46 //y2=4.585
cc_898 ( N_noxref_4_c_1111_p N_noxref_5_c_1534_n ) capacitor c=0.0416993f \
 //x=20.35 //y=4.575 //x2=21.46 //y2=4.585
cc_899 ( N_noxref_4_c_1120_p N_noxref_5_c_1534_n ) capacitor c=3.35971e-19 \
 //x=20.345 //y=3.33 //x2=21.46 //y2=4.585
cc_900 ( N_noxref_4_c_1121_p N_noxref_5_c_1534_n ) capacitor c=0.00506355f \
 //x=20.345 //y=3.33 //x2=21.46 //y2=4.585
cc_901 ( N_noxref_4_c_1122_p N_noxref_5_c_1534_n ) capacitor c=6.26008e-19 \
 //x=20.35 //y=4.7 //x2=21.46 //y2=4.585
cc_902 ( N_noxref_4_c_1123_p N_noxref_5_c_1534_n ) capacitor c=7.66769e-19 \
 //x=20.915 //y=4.79 //x2=21.46 //y2=4.585
cc_903 ( N_noxref_4_c_1124_p N_noxref_5_c_1534_n ) capacitor c=7.54501e-19 \
 //x=20.625 //y=4.79 //x2=21.46 //y2=4.585
cc_904 ( N_noxref_4_c_976_n N_noxref_5_c_1436_n ) capacitor c=0.0157182f \
 //x=3.33 //y=2.195 //x2=13.305 //y2=2.22
cc_905 ( N_noxref_4_c_977_n N_noxref_5_c_1436_n ) capacitor c=0.0168553f \
 //x=3.33 //y=3.175 //x2=13.305 //y2=2.22
cc_906 ( N_noxref_4_c_984_n N_noxref_5_c_1436_n ) capacitor c=0.00255835f \
 //x=3.33 //y=3.495 //x2=13.305 //y2=2.22
cc_907 ( N_noxref_4_c_1128_p N_noxref_5_c_1436_n ) capacitor c=7.15814e-19 \
 //x=8.395 //y=1.125 //x2=13.305 //y2=2.22
cc_908 ( N_noxref_4_c_995_n N_noxref_5_c_1436_n ) capacitor c=0.0211903f \
 //x=8.48 //y=1.665 //x2=13.305 //y2=2.22
cc_909 ( N_noxref_4_c_996_n N_noxref_5_c_1436_n ) capacitor c=0.0277836f \
 //x=8.88 //y=3.155 //x2=13.305 //y2=2.22
cc_910 ( N_noxref_4_c_1011_n N_noxref_5_c_1436_n ) capacitor c=0.0415968f \
 //x=20.185 //y=3.33 //x2=13.305 //y2=2.22
cc_911 ( N_noxref_4_c_1015_n N_noxref_5_c_1436_n ) capacitor c=0.00848395f \
 //x=3.5 //y=3.335 //x2=13.305 //y2=2.22
cc_912 ( N_noxref_4_c_1018_n N_noxref_5_c_1436_n ) capacitor c=0.0324095f \
 //x=8.72 //y=3.315 //x2=13.305 //y2=2.22
cc_913 ( N_noxref_4_c_976_n N_noxref_5_c_1551_n ) capacitor c=0.00172487f \
 //x=3.33 //y=2.195 //x2=2.38 //y2=2.22
cc_914 ( N_noxref_4_c_977_n N_noxref_5_c_1551_n ) capacitor c=0.00121233f \
 //x=3.33 //y=3.175 //x2=2.38 //y2=2.22
cc_915 ( N_noxref_4_c_1011_n N_noxref_5_c_1476_n ) capacitor c=8.6307e-19 \
 //x=20.185 //y=3.33 //x2=15.765 //y2=2.205
cc_916 ( N_noxref_4_c_1011_n N_noxref_5_c_1481_n ) capacitor c=0.00853994f \
 //x=20.185 //y=3.33 //x2=17.925 //y2=2.22
cc_917 ( N_noxref_4_c_1113_p N_noxref_5_c_1555_n ) capacitor c=0.00149687f \
 //x=20.35 //y=2.195 //x2=21.455 //y2=2.23
cc_918 ( N_noxref_4_c_1110_p N_noxref_5_c_1555_n ) capacitor c=0.00137876f \
 //x=20.35 //y=3.17 //x2=21.455 //y2=2.23
cc_919 ( N_noxref_4_c_1113_p N_noxref_5_c_1557_n ) capacitor c=0.0165384f \
 //x=20.35 //y=2.195 //x2=21.295 //y2=2.23
cc_920 ( N_noxref_4_c_1110_p N_noxref_5_c_1557_n ) capacitor c=0.0167844f \
 //x=20.35 //y=3.17 //x2=21.295 //y2=2.23
cc_921 ( N_noxref_4_c_1011_n N_noxref_5_c_1557_n ) capacitor c=0.01013f \
 //x=20.185 //y=3.33 //x2=21.295 //y2=2.23
cc_922 ( N_noxref_4_c_1115_p N_noxref_5_c_1557_n ) capacitor c=2.54369e-19 \
 //x=20.35 //y=2.08 //x2=21.295 //y2=2.23
cc_923 ( N_noxref_4_c_976_n N_noxref_5_c_1561_n ) capacitor c=5.39999e-19 \
 //x=3.33 //y=2.195 //x2=2.22 //y2=2.08
cc_924 ( N_noxref_4_c_1029_n N_noxref_5_c_1561_n ) capacitor c=0.00124907f \
 //x=3.33 //y=2.08 //x2=2.22 //y2=2.08
cc_925 ( N_noxref_4_c_1061_n N_noxref_5_c_1561_n ) capacitor c=0.00204796f \
 //x=3.33 //y=2.08 //x2=2.22 //y2=2.08
cc_926 ( N_noxref_4_c_989_n N_noxref_5_c_1453_n ) capacitor c=9.52396e-19 \
 //x=3.33 //y=4.57 //x2=2.22 //y2=4.7
cc_927 ( N_noxref_4_c_1030_n N_noxref_5_c_1453_n ) capacitor c=0.00113985f \
 //x=3.33 //y=4.7 //x2=2.22 //y2=4.7
cc_928 ( N_noxref_4_c_1064_n N_noxref_5_c_1453_n ) capacitor c=0.00187046f \
 //x=3.33 //y=4.7 //x2=2.22 //y2=4.7
cc_929 ( N_noxref_4_c_1113_p N_noxref_5_c_1567_n ) capacitor c=5.39999e-19 \
 //x=20.35 //y=2.195 //x2=21.46 //y2=2.08
cc_930 ( N_noxref_4_c_1115_p N_noxref_5_c_1567_n ) capacitor c=0.00124906f \
 //x=20.35 //y=2.08 //x2=21.46 //y2=2.08
cc_931 ( N_noxref_4_c_1116_p N_noxref_5_c_1567_n ) capacitor c=0.00214501f \
 //x=20.05 //y=1.915 //x2=21.46 //y2=2.08
cc_932 ( N_noxref_4_c_1111_p N_noxref_5_c_1570_n ) capacitor c=0.00103399f \
 //x=20.35 //y=4.575 //x2=21.46 //y2=4.7
cc_933 ( N_noxref_4_c_1122_p N_noxref_5_c_1570_n ) capacitor c=0.00113984f \
 //x=20.35 //y=4.7 //x2=21.46 //y2=4.7
cc_934 ( N_noxref_4_c_1123_p N_noxref_5_c_1570_n ) capacitor c=0.00116563f \
 //x=20.915 //y=4.79 //x2=21.46 //y2=4.7
cc_935 ( N_noxref_4_c_1124_p N_noxref_5_c_1570_n ) capacitor c=0.00129812f \
 //x=20.625 //y=4.79 //x2=21.46 //y2=4.7
cc_936 ( N_noxref_4_M22_noxref_g N_noxref_5_M20_noxref_g ) capacitor \
 c=0.0101598f //x=3.07 //y=6.02 //x2=2.19 //y2=6.02
cc_937 ( N_noxref_4_M22_noxref_g N_noxref_5_M21_noxref_g ) capacitor \
 c=0.0607518f //x=3.07 //y=6.02 //x2=2.63 //y2=6.02
cc_938 ( N_noxref_4_M23_noxref_g N_noxref_5_M21_noxref_g ) capacitor \
 c=0.0101598f //x=3.51 //y=6.02 //x2=2.63 //y2=6.02
cc_939 ( N_noxref_4_M42_noxref_g N_noxref_5_M44_noxref_g ) capacitor \
 c=0.0106276f //x=20.55 //y=6.02 //x2=21.43 //y2=6.02
cc_940 ( N_noxref_4_M43_noxref_g N_noxref_5_M44_noxref_g ) capacitor \
 c=0.107144f //x=20.99 //y=6.02 //x2=21.43 //y2=6.02
cc_941 ( N_noxref_4_M43_noxref_g N_noxref_5_M45_noxref_g ) capacitor \
 c=0.0101598f //x=20.99 //y=6.02 //x2=21.87 //y2=6.02
cc_942 ( N_noxref_4_c_1043_n N_noxref_5_c_1580_n ) capacitor c=0.00456962f \
 //x=3.32 //y=0.915 //x2=2.31 //y2=0.91
cc_943 ( N_noxref_4_c_1045_n N_noxref_5_c_1581_n ) capacitor c=0.00438372f \
 //x=3.32 //y=1.26 //x2=2.31 //y2=1.22
cc_944 ( N_noxref_4_c_1048_n N_noxref_5_c_1582_n ) capacitor c=0.00438372f \
 //x=3.32 //y=1.57 //x2=2.31 //y2=1.45
cc_945 ( N_noxref_4_c_976_n N_noxref_5_c_1583_n ) capacitor c=6.57681e-19 \
 //x=3.33 //y=2.195 //x2=2.31 //y2=1.915
cc_946 ( N_noxref_4_c_1029_n N_noxref_5_c_1583_n ) capacitor c=0.00177608f \
 //x=3.33 //y=2.08 //x2=2.31 //y2=1.915
cc_947 ( N_noxref_4_c_1061_n N_noxref_5_c_1583_n ) capacitor c=0.00873247f \
 //x=3.33 //y=2.08 //x2=2.31 //y2=1.915
cc_948 ( N_noxref_4_c_1062_n N_noxref_5_c_1583_n ) capacitor c=0.00438372f \
 //x=3.33 //y=1.915 //x2=2.31 //y2=1.915
cc_949 ( N_noxref_4_c_1064_n N_noxref_5_c_1461_n ) capacitor c=0.0616777f \
 //x=3.33 //y=4.7 //x2=2.555 //y2=4.79
cc_950 ( N_noxref_4_c_1171_p N_noxref_5_c_1588_n ) capacitor c=5.72528e-19 \
 //x=20.05 //y=0.875 //x2=21.025 //y2=0.91
cc_951 ( N_noxref_4_c_1172_p N_noxref_5_c_1588_n ) capacitor c=0.00150277f \
 //x=20.05 //y=1.22 //x2=21.025 //y2=0.91
cc_952 ( N_noxref_4_c_1173_p N_noxref_5_c_1588_n ) capacitor c=0.0160123f \
 //x=20.58 //y=0.875 //x2=21.025 //y2=0.91
cc_953 ( N_noxref_4_c_1174_p N_noxref_5_c_1591_n ) capacitor c=0.00111227f \
 //x=20.05 //y=1.53 //x2=21.025 //y2=1.22
cc_954 ( N_noxref_4_c_1175_p N_noxref_5_c_1591_n ) capacitor c=0.0124075f \
 //x=20.58 //y=1.22 //x2=21.025 //y2=1.22
cc_955 ( N_noxref_4_c_1173_p N_noxref_5_c_1593_n ) capacitor c=9.19165e-19 \
 //x=20.58 //y=0.875 //x2=21.55 //y2=0.91
cc_956 ( N_noxref_4_c_1175_p N_noxref_5_c_1594_n ) capacitor c=0.0010154f \
 //x=20.58 //y=1.22 //x2=21.55 //y2=1.22
cc_957 ( N_noxref_4_c_1175_p N_noxref_5_c_1595_n ) capacitor c=9.23422e-19 \
 //x=20.58 //y=1.22 //x2=21.55 //y2=1.45
cc_958 ( N_noxref_4_c_1113_p N_noxref_5_c_1596_n ) capacitor c=6.79315e-19 \
 //x=20.35 //y=2.195 //x2=21.55 //y2=1.915
cc_959 ( N_noxref_4_c_1115_p N_noxref_5_c_1596_n ) capacitor c=0.00176374f \
 //x=20.35 //y=2.08 //x2=21.55 //y2=1.915
cc_960 ( N_noxref_4_c_1116_p N_noxref_5_c_1596_n ) capacitor c=0.00887699f \
 //x=20.05 //y=1.915 //x2=21.55 //y2=1.915
cc_961 ( N_noxref_4_c_989_n N_noxref_5_c_1463_n ) capacitor c=8.42568e-19 \
 //x=3.33 //y=4.57 //x2=2.22 //y2=4.7
cc_962 ( N_noxref_4_c_1030_n N_noxref_5_c_1463_n ) capacitor c=0.00129812f \
 //x=3.33 //y=4.7 //x2=2.22 //y2=4.7
cc_963 ( N_noxref_4_c_1064_n N_noxref_5_c_1463_n ) capacitor c=0.00487508f \
 //x=3.33 //y=4.7 //x2=2.22 //y2=4.7
cc_964 ( N_noxref_4_c_1111_p N_noxref_5_c_1602_n ) capacitor c=0.00116212f \
 //x=20.35 //y=4.575 //x2=21.46 //y2=4.7
cc_965 ( N_noxref_4_c_1122_p N_noxref_5_c_1602_n ) capacitor c=0.00155973f \
 //x=20.35 //y=4.7 //x2=21.46 //y2=4.7
cc_966 ( N_noxref_4_c_1123_p N_noxref_5_c_1602_n ) capacitor c=0.0171374f \
 //x=20.915 //y=4.79 //x2=21.46 //y2=4.7
cc_967 ( N_noxref_4_c_1124_p N_noxref_5_c_1602_n ) capacitor c=0.00484466f \
 //x=20.625 //y=4.79 //x2=21.46 //y2=4.7
cc_968 ( N_noxref_4_c_996_n N_noxref_6_c_1907_n ) capacitor c=0.00102767f \
 //x=8.88 //y=3.155 //x2=11.84 //y2=2.785
cc_969 ( N_noxref_4_c_1011_n N_noxref_6_c_1913_n ) capacitor c=0.00591344f \
 //x=20.185 //y=3.33 //x2=11.84 //y2=3.105
cc_970 ( N_noxref_4_c_1004_n N_noxref_6_c_1914_n ) capacitor c=0.00102743f \
 //x=8.88 //y=5.07 //x2=11.84 //y2=4.585
cc_971 ( N_noxref_4_c_1011_n N_noxref_6_c_1914_n ) capacitor c=0.0229415f \
 //x=20.185 //y=3.33 //x2=11.84 //y2=4.585
cc_972 ( N_noxref_4_c_1011_n N_noxref_6_c_1954_n ) capacitor c=0.175659f \
 //x=20.185 //y=3.33 //x2=13.305 //y2=2.96
cc_973 ( N_noxref_4_c_1011_n N_noxref_6_c_1957_n ) capacitor c=0.112359f \
 //x=20.185 //y=3.33 //x2=13.905 //y2=2.975
cc_974 ( N_noxref_4_c_1011_n N_noxref_6_c_1960_n ) capacitor c=0.0579165f \
 //x=20.185 //y=3.33 //x2=15.165 //y2=2.96
cc_975 ( N_noxref_4_c_1011_n N_noxref_6_c_1964_n ) capacitor c=0.36266f \
 //x=20.185 //y=3.33 //x2=15.765 //y2=2.975
cc_976 ( N_noxref_4_c_1110_p N_noxref_6_c_1979_n ) capacitor c=4.64545e-19 \
 //x=20.35 //y=3.17 //x2=19.96 //y2=2.96
cc_977 ( N_noxref_4_c_1118_p N_noxref_6_c_1979_n ) capacitor c=0.00323523f \
 //x=20.35 //y=3.49 //x2=19.96 //y2=2.96
cc_978 ( N_noxref_4_c_1011_n N_noxref_6_c_1979_n ) capacitor c=0.010873f \
 //x=20.185 //y=3.33 //x2=19.96 //y2=2.96
cc_979 ( N_noxref_4_c_1110_p N_noxref_6_c_1991_n ) capacitor c=0.0269272f \
 //x=20.35 //y=3.17 //x2=20.56 //y2=2.945
cc_980 ( N_noxref_4_c_1118_p N_noxref_6_c_1991_n ) capacitor c=0.00485165f \
 //x=20.35 //y=3.49 //x2=20.56 //y2=2.945
cc_981 ( N_noxref_4_c_1121_p N_noxref_6_c_1991_n ) capacitor c=0.0358686f \
 //x=20.345 //y=3.33 //x2=20.56 //y2=2.945
cc_982 ( N_noxref_4_c_1011_n N_noxref_6_c_1919_n ) capacitor c=0.0358686f \
 //x=20.185 //y=3.33 //x2=12 //y2=2.945
cc_983 ( N_noxref_4_c_996_n N_noxref_7_c_2313_n ) capacitor c=0.0140058f \
 //x=8.88 //y=3.155 //x2=8.14 //y2=2.195
cc_984 ( N_noxref_4_c_996_n N_noxref_7_c_2236_n ) capacitor c=0.0395462f \
 //x=8.88 //y=3.155 //x2=8.14 //y2=3.555
cc_985 ( N_noxref_4_c_1002_n N_noxref_7_c_2236_n ) capacitor c=0.0148932f \
 //x=8.88 //y=3.475 //x2=8.14 //y2=3.555
cc_986 ( N_noxref_4_c_1004_n N_noxref_7_c_2236_n ) capacitor c=0.00340923f \
 //x=8.88 //y=5.07 //x2=8.14 //y2=3.555
cc_987 ( N_noxref_4_c_1208_p N_noxref_7_c_2236_n ) capacitor c=9.19401e-19 \
 //x=8.88 //y=3.33 //x2=8.14 //y2=3.555
cc_988 ( N_noxref_4_c_1018_n N_noxref_7_c_2236_n ) capacitor c=0.0237398f \
 //x=8.72 //y=3.315 //x2=8.14 //y2=3.555
cc_989 ( N_noxref_4_c_1027_n N_noxref_7_c_2236_n ) capacitor c=0.00336755f \
 //x=9.04 //y=3.315 //x2=8.14 //y2=3.555
cc_990 ( N_noxref_4_c_1078_n N_noxref_7_c_2318_n ) capacitor c=8.49432e-19 \
 //x=7.985 //y=5.155 //x2=8.14 //y2=3.875
cc_991 ( N_noxref_4_c_1068_n N_noxref_7_c_2318_n ) capacitor c=0.00118639f \
 //x=8.795 //y=5.155 //x2=8.14 //y2=3.875
cc_992 ( N_noxref_4_c_995_n N_noxref_7_c_2318_n ) capacitor c=8.07658e-19 \
 //x=8.48 //y=1.665 //x2=8.14 //y2=3.875
cc_993 ( N_noxref_4_c_1004_n N_noxref_7_c_2318_n ) capacitor c=0.01761f \
 //x=8.88 //y=5.07 //x2=8.14 //y2=3.875
cc_994 ( N_noxref_4_c_1018_n N_noxref_7_c_2318_n ) capacitor c=0.00611939f \
 //x=8.72 //y=3.315 //x2=8.14 //y2=3.875
cc_995 ( N_noxref_4_c_1068_n N_noxref_7_c_2241_n ) capacitor c=0.00228791f \
 //x=8.795 //y=5.155 //x2=8.14 //y2=4.57
cc_996 ( N_noxref_4_c_1004_n N_noxref_7_c_2241_n ) capacitor c=0.0442174f \
 //x=8.88 //y=5.07 //x2=8.14 //y2=4.57
cc_997 ( N_noxref_4_c_1218_p N_noxref_7_c_2241_n ) capacitor c=0.0221235f \
 //x=8.1 //y=5.155 //x2=8.14 //y2=4.57
cc_998 ( N_noxref_4_c_1219_p N_noxref_7_c_2241_n ) capacitor c=0.00217653f \
 //x=8.1 //y=5.38 //x2=8.14 //y2=4.57
cc_999 ( N_noxref_4_c_1011_n N_noxref_7_c_2243_n ) capacitor c=0.0214961f \
 //x=20.185 //y=3.33 //x2=12.95 //y2=3.555
cc_1000 ( N_noxref_4_c_1011_n N_noxref_7_c_2256_n ) capacitor c=0.00642248f \
 //x=20.185 //y=3.33 //x2=12.95 //y2=3.875
cc_1001 ( N_noxref_4_c_1113_p N_noxref_7_c_2333_n ) capacitor c=0.00357748f \
 //x=20.35 //y=2.195 //x2=18.5 //y2=3.555
cc_1002 ( N_noxref_4_c_1110_p N_noxref_7_c_2333_n ) capacitor c=0.0130224f \
 //x=20.35 //y=3.17 //x2=18.5 //y2=3.555
cc_1003 ( N_noxref_4_c_1118_p N_noxref_7_c_2333_n ) capacitor c=0.00255079f \
 //x=20.35 //y=3.49 //x2=18.5 //y2=3.555
cc_1004 ( N_noxref_4_c_1111_p N_noxref_7_c_2333_n ) capacitor c=0.0011073f \
 //x=20.35 //y=4.575 //x2=18.5 //y2=3.555
cc_1005 ( N_noxref_4_c_1011_n N_noxref_7_c_2333_n ) capacitor c=0.0225414f \
 //x=20.185 //y=3.33 //x2=18.5 //y2=3.555
cc_1006 ( N_noxref_4_c_1121_p N_noxref_7_c_2333_n ) capacitor c=0.00158465f \
 //x=20.345 //y=3.33 //x2=18.5 //y2=3.555
cc_1007 ( N_noxref_4_c_1111_p N_noxref_7_c_2400_n ) capacitor c=0.0025694f \
 //x=20.35 //y=4.575 //x2=18.5 //y2=3.875
cc_1008 ( N_noxref_4_c_1011_n N_noxref_7_c_2400_n ) capacitor c=0.00926238f \
 //x=20.185 //y=3.33 //x2=18.5 //y2=3.875
cc_1009 ( N_noxref_4_c_1111_p N_noxref_7_c_2334_n ) capacitor c=0.0165778f \
 //x=20.35 //y=4.575 //x2=18.5 //y2=5.07
cc_1010 ( N_noxref_4_c_1004_n N_noxref_7_c_2335_n ) capacitor c=9.19401e-19 \
 //x=8.88 //y=5.07 //x2=8.14 //y2=3.7
cc_1011 ( N_noxref_4_c_1011_n N_noxref_7_c_2272_n ) capacitor c=0.457195f \
 //x=20.185 //y=3.33 //x2=18.33 //y2=3.7
cc_1012 ( N_noxref_4_c_1118_p N_noxref_7_c_2405_n ) capacitor c=0.00269024f \
 //x=20.35 //y=3.49 //x2=20.56 //y2=3.715
cc_1013 ( N_noxref_4_c_1111_p N_noxref_7_c_2405_n ) capacitor c=0.0306353f \
 //x=20.35 //y=4.575 //x2=20.56 //y2=3.715
cc_1014 ( N_noxref_4_c_1118_p N_noxref_7_c_2407_n ) capacitor c=0.00347895f \
 //x=20.35 //y=3.49 //x2=20.215 //y2=3.715
cc_1015 ( N_noxref_4_c_1111_p N_noxref_7_c_2407_n ) capacitor c=0.00196004f \
 //x=20.35 //y=4.575 //x2=20.215 //y2=3.715
cc_1016 ( N_noxref_4_c_1011_n N_noxref_7_c_2407_n ) capacitor c=0.176374f \
 //x=20.185 //y=3.33 //x2=20.215 //y2=3.715
cc_1017 ( N_noxref_4_c_1121_p N_noxref_7_c_2407_n ) capacitor c=0.0364799f \
 //x=20.345 //y=3.33 //x2=20.215 //y2=3.715
cc_1018 ( N_noxref_4_c_1004_n N_noxref_7_c_2347_n ) capacitor c=0.00336755f \
 //x=8.88 //y=5.07 //x2=8.3 //y2=3.715
cc_1019 ( N_noxref_4_c_1018_n N_noxref_7_c_2347_n ) capacitor c=0.0358686f \
 //x=8.72 //y=3.315 //x2=8.3 //y2=3.715
cc_1020 ( N_noxref_4_c_1002_n N_noxref_7_c_2246_n ) capacitor c=0.00917068f \
 //x=8.88 //y=3.475 //x2=12.79 //y2=3.715
cc_1021 ( N_noxref_4_c_1004_n N_noxref_7_c_2246_n ) capacitor c=0.0242948f \
 //x=8.88 //y=5.07 //x2=12.79 //y2=3.715
cc_1022 ( N_noxref_4_c_1011_n N_noxref_7_c_2246_n ) capacitor c=0.323902f \
 //x=20.185 //y=3.33 //x2=12.79 //y2=3.715
cc_1023 ( N_noxref_4_c_1018_n N_noxref_7_c_2246_n ) capacitor c=0.035195f \
 //x=8.72 //y=3.315 //x2=12.79 //y2=3.715
cc_1024 ( N_noxref_4_c_1027_n N_noxref_7_c_2246_n ) capacitor c=0.0358686f \
 //x=9.04 //y=3.315 //x2=12.79 //y2=3.715
cc_1025 ( N_noxref_4_c_1011_n N_noxref_7_c_2274_n ) capacitor c=0.0358686f \
 //x=20.185 //y=3.33 //x2=13.11 //y2=3.715
cc_1026 ( N_noxref_4_c_996_n N_noxref_7_c_2351_n ) capacitor c=0.0015536f \
 //x=8.88 //y=3.155 //x2=8.14 //y2=2.08
cc_1027 ( N_noxref_4_c_1068_n N_noxref_7_c_2355_n ) capacitor c=0.00130631f \
 //x=8.795 //y=5.155 //x2=8.14 //y2=4.7
cc_1028 ( N_noxref_4_c_1004_n N_noxref_7_c_2355_n ) capacitor c=0.00131258f \
 //x=8.88 //y=5.07 //x2=8.14 //y2=4.7
cc_1029 ( N_noxref_4_c_1218_p N_noxref_7_c_2355_n ) capacitor c=0.00346456f \
 //x=8.1 //y=5.155 //x2=8.14 //y2=4.7
cc_1030 ( N_noxref_4_c_1219_p N_noxref_7_c_2355_n ) capacitor c=0.00624059f \
 //x=8.1 //y=5.38 //x2=8.14 //y2=4.7
cc_1031 ( N_noxref_4_c_1078_n N_noxref_7_M28_noxref_g ) capacitor \
 c=0.00955829f //x=7.985 //y=5.155 //x2=7.88 //y2=6.02
cc_1032 ( N_noxref_4_c_1067_n N_noxref_7_M28_noxref_g ) capacitor \
 c=0.00226521f //x=8.1 //y=5.38 //x2=7.88 //y2=6.02
cc_1033 ( N_noxref_4_c_1219_p N_noxref_7_M28_noxref_g ) capacitor c=0.0178885f \
 //x=8.1 //y=5.38 //x2=7.88 //y2=6.02
cc_1034 ( N_noxref_4_c_1067_n N_noxref_7_M29_noxref_g ) capacitor \
 c=0.00381703f //x=8.1 //y=5.38 //x2=8.32 //y2=6.02
cc_1035 ( N_noxref_4_c_1068_n N_noxref_7_M29_noxref_g ) capacitor c=0.0109636f \
 //x=8.795 //y=5.155 //x2=8.32 //y2=6.02
cc_1036 ( N_noxref_4_c_1219_p N_noxref_7_M29_noxref_g ) capacitor c=0.0188608f \
 //x=8.1 //y=5.38 //x2=8.32 //y2=6.02
cc_1037 ( N_noxref_4_c_1128_p N_noxref_7_c_2365_n ) capacitor c=4.64015e-19 \
 //x=8.395 //y=1.125 //x2=8.13 //y2=0.915
cc_1038 ( N_noxref_4_M5_noxref_d N_noxref_7_c_2365_n ) capacitor c=0.00137165f \
 //x=8.205 //y=0.915 //x2=8.13 //y2=0.915
cc_1039 ( N_noxref_4_c_1128_p N_noxref_7_c_2366_n ) capacitor c=0.0026012f \
 //x=8.395 //y=1.125 //x2=8.13 //y2=1.26
cc_1040 ( N_noxref_4_c_1261_p N_noxref_7_c_2366_n ) capacitor c=0.00127432f \
 //x=8.395 //y=1.58 //x2=8.13 //y2=1.26
cc_1041 ( N_noxref_4_M5_noxref_d N_noxref_7_c_2366_n ) capacitor c=0.00237422f \
 //x=8.205 //y=0.915 //x2=8.13 //y2=1.26
cc_1042 ( N_noxref_4_c_1261_p N_noxref_7_c_2367_n ) capacitor c=0.00429966f \
 //x=8.395 //y=1.58 //x2=8.13 //y2=1.57
cc_1043 ( N_noxref_4_c_1128_p N_noxref_7_c_2436_n ) capacitor c=5.29969e-19 \
 //x=8.395 //y=1.125 //x2=8.505 //y2=0.76
cc_1044 ( N_noxref_4_M5_noxref_d N_noxref_7_c_2436_n ) capacitor c=0.0020782f \
 //x=8.205 //y=0.915 //x2=8.505 //y2=0.76
cc_1045 ( N_noxref_4_c_1128_p N_noxref_7_c_2438_n ) capacitor c=5.18355e-19 \
 //x=8.395 //y=1.125 //x2=8.505 //y2=1.415
cc_1046 ( N_noxref_4_c_1261_p N_noxref_7_c_2438_n ) capacitor c=0.00942306f \
 //x=8.395 //y=1.58 //x2=8.505 //y2=1.415
cc_1047 ( N_noxref_4_c_1069_n N_noxref_7_c_2438_n ) capacitor c=0.00194716f \
 //x=8.795 //y=1.665 //x2=8.505 //y2=1.415
cc_1048 ( N_noxref_4_M5_noxref_d N_noxref_7_c_2438_n ) capacitor c=0.00356097f \
 //x=8.205 //y=0.915 //x2=8.505 //y2=1.415
cc_1049 ( N_noxref_4_c_1128_p N_noxref_7_c_2442_n ) capacitor c=5.24634e-19 \
 //x=8.395 //y=1.125 //x2=8.66 //y2=0.915
cc_1050 ( N_noxref_4_M5_noxref_d N_noxref_7_c_2442_n ) capacitor c=0.00139206f \
 //x=8.205 //y=0.915 //x2=8.66 //y2=0.915
cc_1051 ( N_noxref_4_c_1128_p N_noxref_7_c_2444_n ) capacitor c=0.00307978f \
 //x=8.395 //y=1.125 //x2=8.66 //y2=1.26
cc_1052 ( N_noxref_4_c_1261_p N_noxref_7_c_2444_n ) capacitor c=0.00363411f \
 //x=8.395 //y=1.58 //x2=8.66 //y2=1.26
cc_1053 ( N_noxref_4_c_1069_n N_noxref_7_c_2444_n ) capacitor c=0.00323576f \
 //x=8.795 //y=1.665 //x2=8.66 //y2=1.26
cc_1054 ( N_noxref_4_M5_noxref_d N_noxref_7_c_2444_n ) capacitor c=0.00237422f \
 //x=8.205 //y=0.915 //x2=8.66 //y2=1.26
cc_1055 ( N_noxref_4_c_996_n N_noxref_7_c_2368_n ) capacitor c=0.0024584f \
 //x=8.88 //y=3.155 //x2=8.14 //y2=2.08
cc_1056 ( N_noxref_4_c_1261_p N_noxref_7_c_2371_n ) capacitor c=0.0036273f \
 //x=8.395 //y=1.58 //x2=8.14 //y2=1.915
cc_1057 ( N_noxref_4_c_996_n N_noxref_7_c_2371_n ) capacitor c=0.00282067f \
 //x=8.88 //y=3.155 //x2=8.14 //y2=1.915
cc_1058 ( N_noxref_4_c_1004_n N_noxref_7_c_2372_n ) capacitor c=0.00739875f \
 //x=8.88 //y=5.07 //x2=8.14 //y2=4.7
cc_1059 ( N_noxref_4_c_1218_p N_noxref_7_c_2372_n ) capacitor c=0.00203307f \
 //x=8.1 //y=5.155 //x2=8.14 //y2=4.7
cc_1060 ( N_noxref_4_c_1219_p N_noxref_7_c_2372_n ) capacitor c=0.00375636f \
 //x=8.1 //y=5.38 //x2=8.14 //y2=4.7
cc_1061 ( N_noxref_4_c_994_n N_noxref_8_c_2794_n ) capacitor c=0.0062064f \
 //x=7.1 //y=5.155 //x2=28.12 //y2=7.4
cc_1062 ( N_noxref_4_c_1078_n N_noxref_8_c_2794_n ) capacitor c=0.00626473f \
 //x=7.985 //y=5.155 //x2=28.12 //y2=7.4
cc_1063 ( N_noxref_4_c_1067_n N_noxref_8_c_2794_n ) capacitor c=0.00255587f \
 //x=8.1 //y=5.38 //x2=28.12 //y2=7.4
cc_1064 ( N_noxref_4_c_1068_n N_noxref_8_c_2794_n ) capacitor c=0.00827852f \
 //x=8.795 //y=5.155 //x2=28.12 //y2=7.4
cc_1065 ( N_noxref_4_c_1002_n N_noxref_8_c_2794_n ) capacitor c=4.57096e-19 \
 //x=8.88 //y=3.475 //x2=28.12 //y2=7.4
cc_1066 ( N_noxref_4_c_1118_p N_noxref_8_c_2794_n ) capacitor c=3.7858e-19 \
 //x=20.35 //y=3.49 //x2=28.12 //y2=7.4
cc_1067 ( N_noxref_4_c_1006_n N_noxref_8_c_2794_n ) capacitor c=0.00261379f \
 //x=6.342 //y=5.155 //x2=28.12 //y2=7.4
cc_1068 ( N_noxref_4_c_1083_n N_noxref_8_c_2794_n ) capacitor c=0.0026965f \
 //x=7.22 //y=5.155 //x2=28.12 //y2=7.4
cc_1069 ( N_noxref_4_c_1034_n N_noxref_8_c_2794_n ) capacitor c=0.00242194f \
 //x=6.34 //y=5.38 //x2=28.12 //y2=7.4
cc_1070 ( N_noxref_4_c_1095_n N_noxref_8_c_2794_n ) capacitor c=0.00242194f \
 //x=7.22 //y=5.38 //x2=28.12 //y2=7.4
cc_1071 ( N_noxref_4_c_1219_p N_noxref_8_c_2794_n ) capacitor c=0.00242194f \
 //x=8.1 //y=5.38 //x2=28.12 //y2=7.4
cc_1072 ( N_noxref_4_M22_noxref_g N_noxref_8_c_2812_n ) capacitor \
 c=0.00749619f //x=3.07 //y=6.02 //x2=3.645 //y2=7.4
cc_1073 ( N_noxref_4_M23_noxref_g N_noxref_8_c_2812_n ) capacitor \
 c=0.00749823f //x=3.51 //y=6.02 //x2=3.645 //y2=7.4
cc_1074 ( N_noxref_4_c_994_n N_noxref_8_c_2817_n ) capacitor c=0.00202948f \
 //x=7.1 //y=5.155 //x2=6.695 //y2=7.4
cc_1075 ( N_noxref_4_c_1006_n N_noxref_8_c_2817_n ) capacitor c=0.00105895f \
 //x=6.342 //y=5.155 //x2=6.695 //y2=7.4
cc_1076 ( N_noxref_4_c_1034_n N_noxref_8_c_2817_n ) capacitor c=0.0137846f \
 //x=6.34 //y=5.38 //x2=6.695 //y2=7.4
cc_1077 ( N_noxref_4_c_994_n N_noxref_8_c_2907_n ) capacitor c=0.00177088f \
 //x=7.1 //y=5.155 //x2=7.575 //y2=7.4
cc_1078 ( N_noxref_4_c_1078_n N_noxref_8_c_2907_n ) capacitor c=0.00202948f \
 //x=7.985 //y=5.155 //x2=7.575 //y2=7.4
cc_1079 ( N_noxref_4_c_1083_n N_noxref_8_c_2907_n ) capacitor c=9.47876e-19 \
 //x=7.22 //y=5.155 //x2=7.575 //y2=7.4
cc_1080 ( N_noxref_4_c_1095_n N_noxref_8_c_2907_n ) capacitor c=0.0137846f \
 //x=7.22 //y=5.38 //x2=7.575 //y2=7.4
cc_1081 ( N_noxref_4_c_1078_n N_noxref_8_c_2939_n ) capacitor c=0.00205929f \
 //x=7.985 //y=5.155 //x2=8.455 //y2=7.4
cc_1082 ( N_noxref_4_c_1067_n N_noxref_8_c_2939_n ) capacitor c=8.49349e-19 \
 //x=8.1 //y=5.38 //x2=8.455 //y2=7.4
cc_1083 ( N_noxref_4_c_1068_n N_noxref_8_c_2939_n ) capacitor c=0.00204261f \
 //x=8.795 //y=5.155 //x2=8.455 //y2=7.4
cc_1084 ( N_noxref_4_c_1219_p N_noxref_8_c_2939_n ) capacitor c=0.0134886f \
 //x=8.1 //y=5.38 //x2=8.455 //y2=7.4
cc_1085 ( N_noxref_4_c_1068_n N_noxref_8_c_2943_n ) capacitor c=0.00183429f \
 //x=8.795 //y=5.155 //x2=9.45 //y2=7.4
cc_1086 ( N_noxref_4_M42_noxref_g N_noxref_8_c_2944_n ) capacitor \
 c=0.00749687f //x=20.55 //y=6.02 //x2=21.125 //y2=7.4
cc_1087 ( N_noxref_4_M43_noxref_g N_noxref_8_c_2944_n ) capacitor \
 c=0.00749619f //x=20.99 //y=6.02 //x2=21.125 //y2=7.4
cc_1088 ( N_noxref_4_c_1006_n N_noxref_8_c_2821_n ) capacitor c=0.0022955f \
 //x=6.342 //y=5.155 //x2=4.81 //y2=7.4
cc_1089 ( N_noxref_4_c_1018_n N_noxref_8_c_2821_n ) capacitor c=0.00501351f \
 //x=8.72 //y=3.315 //x2=4.81 //y2=7.4
cc_1090 ( N_noxref_4_c_1030_n N_noxref_8_c_2821_n ) capacitor c=0.00224736f \
 //x=3.33 //y=4.7 //x2=4.81 //y2=7.4
cc_1091 ( N_noxref_4_c_1034_n N_noxref_8_c_2821_n ) capacitor c=0.00509469f \
 //x=6.34 //y=5.38 //x2=4.81 //y2=7.4
cc_1092 ( N_noxref_4_c_1064_n N_noxref_8_c_2821_n ) capacitor c=2.63786e-19 \
 //x=3.33 //y=4.7 //x2=4.81 //y2=7.4
cc_1093 ( N_noxref_4_c_1067_n N_noxref_8_c_2827_n ) capacitor c=0.00282782f \
 //x=8.1 //y=5.38 //x2=9.62 //y2=7.4
cc_1094 ( N_noxref_4_c_1004_n N_noxref_8_c_2827_n ) capacitor c=0.0337108f \
 //x=8.88 //y=5.07 //x2=9.62 //y2=7.4
cc_1095 ( N_noxref_4_c_1219_p N_noxref_8_c_2827_n ) capacitor c=0.00777981f \
 //x=8.1 //y=5.38 //x2=9.62 //y2=7.4
cc_1096 ( N_noxref_4_c_1111_p N_noxref_8_c_2954_n ) capacitor c=0.0147448f \
 //x=20.35 //y=4.575 //x2=19.24 //y2=7.4
cc_1097 ( N_noxref_4_c_1122_p N_noxref_8_c_2954_n ) capacitor c=0.00370784f \
 //x=20.35 //y=4.7 //x2=19.24 //y2=7.4
cc_1098 ( N_noxref_4_c_1124_p N_noxref_8_c_2954_n ) capacitor c=0.00590568f \
 //x=20.625 //y=4.79 //x2=19.24 //y2=7.4
cc_1099 ( N_noxref_4_M22_noxref_g N_noxref_8_M21_noxref_d ) capacitor \
 c=0.015318f //x=3.07 //y=6.02 //x2=2.705 //y2=5.02
cc_1100 ( N_noxref_4_M23_noxref_g N_noxref_8_M23_noxref_d ) capacitor \
 c=0.0394719f //x=3.51 //y=6.02 //x2=3.585 //y2=5.02
cc_1101 ( N_noxref_4_c_1006_n N_noxref_8_M24_noxref_s ) capacitor c=0.0442713f \
 //x=6.342 //y=5.155 //x2=5.765 //y2=5.02
cc_1102 ( N_noxref_4_c_1083_n N_noxref_8_M24_noxref_s ) capacitor \
 c=7.80122e-19 //x=7.22 //y=5.155 //x2=5.765 //y2=5.02
cc_1103 ( N_noxref_4_c_1018_n N_noxref_8_M24_noxref_s ) capacitor \
 c=3.24204e-19 //x=8.72 //y=3.315 //x2=5.765 //y2=5.02
cc_1104 ( N_noxref_4_c_1034_n N_noxref_8_M24_noxref_s ) capacitor c=0.09305f \
 //x=6.34 //y=5.38 //x2=5.765 //y2=5.02
cc_1105 ( N_noxref_4_c_994_n N_noxref_8_M25_noxref_d ) capacitor c=0.0068945f \
 //x=7.1 //y=5.155 //x2=6.635 //y2=5.02
cc_1106 ( N_noxref_4_c_1034_n N_noxref_8_M25_noxref_d ) capacitor c=0.0674491f \
 //x=6.34 //y=5.38 //x2=6.635 //y2=5.02
cc_1107 ( N_noxref_4_c_1095_n N_noxref_8_M25_noxref_d ) capacitor c=0.0674762f \
 //x=7.22 //y=5.38 //x2=6.635 //y2=5.02
cc_1108 ( N_noxref_4_c_1078_n N_noxref_8_M27_noxref_d ) capacitor \
 c=0.00700078f //x=7.985 //y=5.155 //x2=7.515 //y2=5.02
cc_1109 ( N_noxref_4_c_1095_n N_noxref_8_M27_noxref_d ) capacitor c=0.067493f \
 //x=7.22 //y=5.38 //x2=7.515 //y2=5.02
cc_1110 ( N_noxref_4_c_1219_p N_noxref_8_M27_noxref_d ) capacitor c=0.0674979f \
 //x=8.1 //y=5.38 //x2=7.515 //y2=5.02
cc_1111 ( N_noxref_4_c_1068_n N_noxref_8_M29_noxref_d ) capacitor \
 c=0.00700078f //x=8.795 //y=5.155 //x2=8.395 //y2=5.02
cc_1112 ( N_noxref_4_c_1219_p N_noxref_8_M29_noxref_d ) capacitor c=0.0675002f \
 //x=8.1 //y=5.38 //x2=8.395 //y2=5.02
cc_1113 ( N_noxref_4_c_1067_n N_noxref_8_M30_noxref_s ) capacitor \
 c=0.00492616f //x=8.1 //y=5.38 //x2=10.575 //y2=5.02
cc_1114 ( N_noxref_4_c_1068_n N_noxref_8_M30_noxref_s ) capacitor \
 c=9.42705e-19 //x=8.795 //y=5.155 //x2=10.575 //y2=5.02
cc_1115 ( N_noxref_4_c_1083_n N_noxref_8_M30_noxref_s ) capacitor \
 c=2.11884e-19 //x=7.22 //y=5.155 //x2=10.575 //y2=5.02
cc_1116 ( N_noxref_4_c_1118_p N_noxref_8_M42_noxref_s ) capacitor \
 c=6.32159e-19 //x=20.35 //y=3.49 //x2=20.195 //y2=5.02
cc_1117 ( N_noxref_4_c_1111_p N_noxref_8_M42_noxref_s ) capacitor c=0.0227486f \
 //x=20.35 //y=4.575 //x2=20.195 //y2=5.02
cc_1118 ( N_noxref_4_c_1122_p N_noxref_8_M42_noxref_s ) capacitor \
 c=0.00983393f //x=20.35 //y=4.7 //x2=20.195 //y2=5.02
cc_1119 ( N_noxref_4_M42_noxref_g N_noxref_8_M42_noxref_s ) capacitor \
 c=0.053419f //x=20.55 //y=6.02 //x2=20.195 //y2=5.02
cc_1120 ( N_noxref_4_c_1124_p N_noxref_8_M42_noxref_s ) capacitor \
 c=0.00606254f //x=20.625 //y=4.79 //x2=20.195 //y2=5.02
cc_1121 ( N_noxref_4_M43_noxref_g N_noxref_8_M43_noxref_d ) capacitor \
 c=0.015318f //x=20.99 //y=6.02 //x2=21.065 //y2=5.02
cc_1122 ( N_noxref_4_c_977_n N_noxref_9_c_3186_n ) capacitor c=0.00189402f \
 //x=3.33 //y=3.175 //x2=1.11 //y2=4.575
cc_1123 ( N_noxref_4_c_989_n N_noxref_9_c_3186_n ) capacitor c=0.00146193f \
 //x=3.33 //y=4.57 //x2=1.11 //y2=4.575
cc_1124 ( N_noxref_4_c_976_n N_noxref_10_c_3271_n ) capacitor c=0.00177186f \
 //x=3.33 //y=2.195 //x2=3.985 //y2=0.54
cc_1125 ( N_noxref_4_c_1029_n N_noxref_10_c_3271_n ) capacitor c=0.00117306f \
 //x=3.33 //y=2.08 //x2=3.985 //y2=0.54
cc_1126 ( N_noxref_4_c_1043_n N_noxref_10_c_3271_n ) capacitor c=0.0206349f \
 //x=3.32 //y=0.915 //x2=3.985 //y2=0.54
cc_1127 ( N_noxref_4_c_1055_n N_noxref_10_c_3271_n ) capacitor c=0.00825432f \
 //x=3.85 //y=0.915 //x2=3.985 //y2=0.54
cc_1128 ( N_noxref_4_c_1061_n N_noxref_10_c_3271_n ) capacitor c=2.20712e-19 \
 //x=3.33 //y=2.08 //x2=3.985 //y2=0.54
cc_1129 ( N_noxref_4_c_1045_n N_noxref_10_c_3274_n ) capacitor c=0.0071177f \
 //x=3.32 //y=1.26 //x2=3.1 //y2=0.995
cc_1130 ( N_noxref_4_c_1043_n N_noxref_10_M2_noxref_s ) capacitor c=0.0071177f \
 //x=3.32 //y=0.915 //x2=2.965 //y2=0.375
cc_1131 ( N_noxref_4_c_1048_n N_noxref_10_M2_noxref_s ) capacitor c=0.0071177f \
 //x=3.32 //y=1.57 //x2=2.965 //y2=0.375
cc_1132 ( N_noxref_4_c_1055_n N_noxref_10_M2_noxref_s ) capacitor c=0.015333f \
 //x=3.85 //y=0.915 //x2=2.965 //y2=0.375
cc_1133 ( N_noxref_4_c_1057_n N_noxref_10_M2_noxref_s ) capacitor \
 c=0.00248746f //x=3.85 //y=1.26 //x2=2.965 //y2=0.375
cc_1134 ( N_noxref_4_c_1128_p N_noxref_11_c_3356_n ) capacitor c=0.0036878f \
 //x=8.395 //y=1.125 //x2=8.795 //y2=0.54
cc_1135 ( N_noxref_4_c_1069_n N_noxref_11_c_3356_n ) capacitor c=0.00399931f \
 //x=8.795 //y=1.665 //x2=8.795 //y2=0.54
cc_1136 ( N_noxref_4_M5_noxref_d N_noxref_11_c_3356_n ) capacitor \
 c=0.00910163f //x=8.205 //y=0.915 //x2=8.795 //y2=0.54
cc_1137 ( N_noxref_4_M5_noxref_d N_noxref_11_c_3359_n ) capacitor \
 c=0.00120711f //x=8.205 //y=0.915 //x2=7.91 //y2=0.995
cc_1138 ( N_noxref_4_c_994_n N_noxref_11_M4_noxref_d ) capacitor c=0.00155082f \
 //x=7.1 //y=5.155 //x2=6.67 //y2=0.91
cc_1139 ( N_noxref_4_c_1128_p N_noxref_11_M4_noxref_d ) capacitor \
 c=0.00802417f //x=8.395 //y=1.125 //x2=6.67 //y2=0.91
cc_1140 ( N_noxref_4_c_1128_p N_noxref_11_M5_noxref_s ) capacitor c=0.0098487f \
 //x=8.395 //y=1.125 //x2=7.775 //y2=0.375
cc_1141 ( N_noxref_4_c_1261_p N_noxref_11_M5_noxref_s ) capacitor c=0.0283243f \
 //x=8.395 //y=1.58 //x2=7.775 //y2=0.375
cc_1142 ( N_noxref_4_c_1069_n N_noxref_11_M5_noxref_s ) capacitor \
 c=0.00871957f //x=8.795 //y=1.665 //x2=7.775 //y2=0.375
cc_1143 ( N_noxref_4_c_1208_p N_noxref_11_M5_noxref_s ) capacitor c=0.0016218f \
 //x=8.88 //y=3.33 //x2=7.775 //y2=0.375
cc_1144 ( N_noxref_4_M5_noxref_d N_noxref_11_M5_noxref_s ) capacitor \
 c=0.0279003f //x=8.205 //y=0.915 //x2=7.775 //y2=0.375
cc_1145 ( N_noxref_4_c_1128_p N_noxref_12_M7_noxref_d ) capacitor \
 c=3.20746e-19 //x=8.395 //y=1.125 //x2=11.48 //y2=0.91
cc_1146 ( N_noxref_4_c_1110_p N_noxref_15_c_3620_n ) capacitor c=0.00137168f \
 //x=20.35 //y=3.17 //x2=22.57 //y2=4.57
cc_1147 ( N_noxref_4_c_1111_p N_noxref_15_c_3620_n ) capacitor c=0.00134871f \
 //x=20.35 //y=4.575 //x2=22.57 //y2=4.57
cc_1148 ( N_noxref_4_M43_noxref_g N_noxref_16_c_3714_n ) capacitor \
 c=0.0103964f //x=20.99 //y=6.02 //x2=21.53 //y2=5.155
cc_1149 ( N_noxref_4_M42_noxref_g N_noxref_16_c_3715_n ) capacitor \
 c=0.00461408f //x=20.55 //y=6.02 //x2=20.772 //y2=5.155
cc_1150 ( N_noxref_4_M43_noxref_g N_noxref_16_c_3715_n ) capacitor \
 c=0.00229208f //x=20.99 //y=6.02 //x2=20.772 //y2=5.155
cc_1151 ( N_noxref_4_c_1123_p N_noxref_16_c_3715_n ) capacitor c=0.00171885f \
 //x=20.915 //y=4.79 //x2=20.772 //y2=5.155
cc_1152 ( N_noxref_4_M42_noxref_g N_noxref_16_c_3718_n ) capacitor \
 c=0.0162284f //x=20.55 //y=6.02 //x2=20.77 //y2=5.38
cc_1153 ( N_noxref_4_M43_noxref_g N_noxref_16_c_3718_n ) capacitor \
 c=0.0179041f //x=20.99 //y=6.02 //x2=20.77 //y2=5.38
cc_1154 ( N_noxref_4_c_1123_p N_noxref_16_c_3718_n ) capacitor c=0.00291477f \
 //x=20.915 //y=4.79 //x2=20.77 //y2=5.38
cc_1155 ( N_noxref_4_c_976_n N_noxref_17_c_3852_n ) capacitor c=0.00196073f \
 //x=3.33 //y=2.195 //x2=5.8 //y2=0
cc_1156 ( N_noxref_4_c_1128_p N_noxref_17_c_3962_n ) capacitor c=0.00877081f \
 //x=8.395 //y=1.125 //x2=10.61 //y2=0
cc_1157 ( N_noxref_4_c_1069_n N_noxref_17_c_3962_n ) capacitor c=0.00661744f \
 //x=8.795 //y=1.665 //x2=10.61 //y2=0
cc_1158 ( N_noxref_4_c_1002_n N_noxref_17_c_3962_n ) capacitor c=2.94822e-19 \
 //x=8.88 //y=3.475 //x2=10.61 //y2=0
cc_1159 ( N_noxref_4_M5_noxref_d N_noxref_17_c_3962_n ) capacitor \
 c=2.94508e-19 //x=8.205 //y=0.915 //x2=10.61 //y2=0
cc_1160 ( N_noxref_4_c_1171_p N_noxref_17_c_3969_n ) capacitor c=3.97665e-19 \
 //x=20.05 //y=0.875 //x2=20.315 //y2=0.835
cc_1161 ( N_noxref_4_c_1382_p N_noxref_17_c_3969_n ) capacitor c=0.00864609f \
 //x=20.425 //y=0.72 //x2=20.315 //y2=0.835
cc_1162 ( N_noxref_4_c_1173_p N_noxref_17_c_3969_n ) capacitor c=4.45447e-19 \
 //x=20.58 //y=0.875 //x2=20.315 //y2=0.835
cc_1163 ( N_noxref_4_c_1128_p N_noxref_17_c_3873_n ) capacitor c=0.00543195f \
 //x=8.395 //y=1.125 //x2=10.695 //y2=0.965
cc_1164 ( N_noxref_4_c_1113_p N_noxref_17_c_3973_n ) capacitor c=0.00772254f \
 //x=20.35 //y=2.195 //x2=20.315 //y2=0.965
cc_1165 ( N_noxref_4_c_1118_p N_noxref_17_c_3973_n ) capacitor c=7.73975e-19 \
 //x=20.35 //y=3.49 //x2=20.315 //y2=0.965
cc_1166 ( N_noxref_4_c_1115_p N_noxref_17_c_3973_n ) capacitor c=2.22861e-19 \
 //x=20.35 //y=2.08 //x2=20.315 //y2=0.965
cc_1167 ( N_noxref_4_c_1171_p N_noxref_17_c_3973_n ) capacitor c=0.00156339f \
 //x=20.05 //y=0.875 //x2=20.315 //y2=0.965
cc_1168 ( N_noxref_4_c_1172_p N_noxref_17_c_3973_n ) capacitor c=0.00352472f \
 //x=20.05 //y=1.22 //x2=20.315 //y2=0.965
cc_1169 ( N_noxref_4_c_1174_p N_noxref_17_c_3973_n ) capacitor c=4.26589e-19 \
 //x=20.05 //y=1.53 //x2=20.315 //y2=0.965
cc_1170 ( N_noxref_4_c_1382_p N_noxref_17_c_3973_n ) capacitor c=9.36995e-19 \
 //x=20.425 //y=0.72 //x2=20.315 //y2=0.965
cc_1171 ( N_noxref_4_c_1392_p N_noxref_17_c_3973_n ) capacitor c=5.79272e-19 \
 //x=20.425 //y=1.375 //x2=20.315 //y2=0.965
cc_1172 ( N_noxref_4_c_1173_p N_noxref_17_c_3973_n ) capacitor c=0.0017438f \
 //x=20.58 //y=0.875 //x2=20.315 //y2=0.965
cc_1173 ( N_noxref_4_c_1175_p N_noxref_17_c_3973_n ) capacitor c=0.00276804f \
 //x=20.58 //y=1.22 //x2=20.315 //y2=0.965
cc_1174 ( N_noxref_4_c_976_n N_noxref_17_c_3883_n ) capacitor c=2.01623e-19 \
 //x=3.33 //y=2.195 //x2=4.64 //y2=0
cc_1175 ( N_noxref_4_c_1069_n N_noxref_17_c_3885_n ) capacitor c=6.86937e-19 \
 //x=8.795 //y=1.665 //x2=9.45 //y2=0
cc_1176 ( N_noxref_4_c_1002_n N_noxref_17_c_3885_n ) capacitor c=4.04267e-19 \
 //x=8.88 //y=3.475 //x2=9.45 //y2=0
cc_1177 ( N_noxref_4_c_1171_p N_noxref_17_c_3986_n ) capacitor c=0.00674939f \
 //x=20.05 //y=0.875 //x2=23.88 //y2=0
cc_1178 ( N_noxref_4_c_1018_n N_noxref_17_c_3887_n ) capacitor c=0.00341373f \
 //x=8.72 //y=3.315 //x2=4.81 //y2=0
cc_1179 ( N_noxref_4_c_1029_n N_noxref_17_c_3887_n ) capacitor c=0.00222376f \
 //x=3.33 //y=2.08 //x2=4.81 //y2=0
cc_1180 ( N_noxref_4_c_1057_n N_noxref_17_c_3887_n ) capacitor c=0.00262688f \
 //x=3.85 //y=1.26 //x2=4.81 //y2=0
cc_1181 ( N_noxref_4_c_1061_n N_noxref_17_c_3887_n ) capacitor c=2.63786e-19 \
 //x=3.33 //y=2.08 //x2=4.81 //y2=0
cc_1182 ( N_noxref_4_c_1261_p N_noxref_17_c_3900_n ) capacitor c=0.0045138f \
 //x=8.395 //y=1.58 //x2=9.62 //y2=0
cc_1183 ( N_noxref_4_c_1069_n N_noxref_17_c_3900_n ) capacitor c=0.0304827f \
 //x=8.795 //y=1.665 //x2=9.62 //y2=0
cc_1184 ( N_noxref_4_c_1011_n N_noxref_17_c_3900_n ) capacitor c=0.00341373f \
 //x=20.185 //y=3.33 //x2=9.62 //y2=0
cc_1185 ( N_noxref_4_c_1113_p N_noxref_17_c_3994_n ) capacitor c=0.0035728f \
 //x=20.35 //y=2.195 //x2=19.24 //y2=0
cc_1186 ( N_noxref_4_c_1110_p N_noxref_17_c_3994_n ) capacitor c=0.0106692f \
 //x=20.35 //y=3.17 //x2=19.24 //y2=0
cc_1187 ( N_noxref_4_c_1115_p N_noxref_17_c_3994_n ) capacitor c=0.0039621f \
 //x=20.35 //y=2.08 //x2=19.24 //y2=0
cc_1188 ( N_noxref_4_c_1174_p N_noxref_17_c_3994_n ) capacitor c=0.00170145f \
 //x=20.05 //y=1.53 //x2=19.24 //y2=0
cc_1189 ( N_noxref_4_c_1116_p N_noxref_17_c_3994_n ) capacitor c=0.0102191f \
 //x=20.05 //y=1.915 //x2=19.24 //y2=0
cc_1190 ( N_noxref_4_c_1113_p N_noxref_17_M12_noxref_d ) capacitor \
 c=4.4417e-19 //x=20.35 //y=2.195 //x2=20.125 //y2=0.875
cc_1191 ( N_noxref_4_c_1171_p N_noxref_17_M12_noxref_d ) capacitor \
 c=0.00184354f //x=20.05 //y=0.875 //x2=20.125 //y2=0.875
cc_1192 ( N_noxref_4_c_1172_p N_noxref_17_M12_noxref_d ) capacitor \
 c=0.00210798f //x=20.05 //y=1.22 //x2=20.125 //y2=0.875
cc_1193 ( N_noxref_4_c_1382_p N_noxref_17_M12_noxref_d ) capacitor \
 c=0.00474029f //x=20.425 //y=0.72 //x2=20.125 //y2=0.875
cc_1194 ( N_noxref_4_c_1392_p N_noxref_17_M12_noxref_d ) capacitor \
 c=0.00166857f //x=20.425 //y=1.375 //x2=20.125 //y2=0.875
cc_1195 ( N_noxref_4_c_1173_p N_noxref_17_M12_noxref_d ) capacitor \
 c=0.00230174f //x=20.58 //y=0.875 //x2=20.125 //y2=0.875
cc_1196 ( N_noxref_4_c_1175_p N_noxref_17_M12_noxref_d ) capacitor \
 c=0.00210798f //x=20.58 //y=1.22 //x2=20.125 //y2=0.875
cc_1197 ( N_noxref_4_c_1116_p N_noxref_25_c_4873_n ) capacitor c=0.00262672f \
 //x=20.05 //y=1.915 //x2=19.83 //y2=1.505
cc_1198 ( N_noxref_4_c_1113_p N_noxref_25_c_4874_n ) capacitor c=0.00428451f \
 //x=20.35 //y=2.195 //x2=20.715 //y2=1.59
cc_1199 ( N_noxref_4_c_1118_p N_noxref_25_c_4874_n ) capacitor c=0.00260186f \
 //x=20.35 //y=3.49 //x2=20.715 //y2=1.59
cc_1200 ( N_noxref_4_c_1115_p N_noxref_25_c_4874_n ) capacitor c=0.0104666f \
 //x=20.35 //y=2.08 //x2=20.715 //y2=1.59
cc_1201 ( N_noxref_4_c_1174_p N_noxref_25_c_4874_n ) capacitor c=0.00705077f \
 //x=20.05 //y=1.53 //x2=20.715 //y2=1.59
cc_1202 ( N_noxref_4_c_1116_p N_noxref_25_c_4874_n ) capacitor c=0.020708f \
 //x=20.05 //y=1.915 //x2=20.715 //y2=1.59
cc_1203 ( N_noxref_4_c_1392_p N_noxref_25_c_4874_n ) capacitor c=0.00588627f \
 //x=20.425 //y=1.375 //x2=20.715 //y2=1.59
cc_1204 ( N_noxref_4_c_1175_p N_noxref_25_c_4874_n ) capacitor c=0.00698822f \
 //x=20.58 //y=1.22 //x2=20.715 //y2=1.59
cc_1205 ( N_noxref_4_c_1171_p N_noxref_25_M12_noxref_s ) capacitor \
 c=0.0295256f //x=20.05 //y=0.875 //x2=19.695 //y2=0.375
cc_1206 ( N_noxref_4_c_1174_p N_noxref_25_M12_noxref_s ) capacitor \
 c=7.99997e-19 //x=20.05 //y=1.53 //x2=19.695 //y2=0.375
cc_1207 ( N_noxref_4_c_1116_p N_noxref_25_M12_noxref_s ) capacitor \
 c=0.00122123f //x=20.05 //y=1.915 //x2=19.695 //y2=0.375
cc_1208 ( N_noxref_4_c_1173_p N_noxref_25_M12_noxref_s ) capacitor \
 c=0.0125924f //x=20.58 //y=0.875 //x2=19.695 //y2=0.375
cc_1209 ( N_noxref_5_c_1436_n N_noxref_6_c_1904_n ) capacitor c=0.0160575f \
 //x=13.305 //y=2.22 //x2=11.84 //y2=2.195
cc_1210 ( N_noxref_5_c_1436_n N_noxref_6_c_1907_n ) capacitor c=0.0158656f \
 //x=13.305 //y=2.22 //x2=11.84 //y2=2.785
cc_1211 ( N_noxref_5_c_1436_n N_noxref_6_c_1913_n ) capacitor c=0.00335599f \
 //x=13.305 //y=2.22 //x2=11.84 //y2=3.105
cc_1212 ( N_noxref_5_c_1436_n N_noxref_6_c_1954_n ) capacitor c=0.0663482f \
 //x=13.305 //y=2.22 //x2=13.305 //y2=2.96
cc_1213 ( N_noxref_5_c_1469_n N_noxref_6_c_1957_n ) capacitor c=0.00795676f \
 //x=13.905 //y=2.205 //x2=13.905 //y2=2.975
cc_1214 ( N_noxref_5_c_1473_n N_noxref_6_c_1960_n ) capacitor c=0.00796799f \
 //x=15.165 //y=2.22 //x2=15.165 //y2=2.96
cc_1215 ( N_noxref_5_c_1476_n N_noxref_6_c_1964_n ) capacitor c=0.004445f \
 //x=15.765 //y=2.205 //x2=15.765 //y2=2.975
cc_1216 ( N_noxref_5_c_1481_n N_noxref_6_c_1964_n ) capacitor c=0.0810897f \
 //x=17.925 //y=2.22 //x2=15.765 //y2=2.975
cc_1217 ( N_noxref_5_c_1482_n N_noxref_6_c_1979_n ) capacitor c=0.00277911f \
 //x=17.76 //y=2.385 //x2=19.96 //y2=2.96
cc_1218 ( N_noxref_5_c_1464_n N_noxref_6_c_1979_n ) capacitor c=0.0242602f \
 //x=17.76 //y=4.57 //x2=19.96 //y2=2.96
cc_1219 ( N_noxref_5_c_1481_n N_noxref_6_c_1979_n ) capacitor c=0.0161618f \
 //x=17.925 //y=2.22 //x2=19.96 //y2=2.96
cc_1220 ( N_noxref_5_c_1557_n N_noxref_6_c_1979_n ) capacitor c=0.126859f \
 //x=21.295 //y=2.23 //x2=19.96 //y2=2.96
cc_1221 ( N_noxref_5_c_1530_n N_noxref_6_c_1991_n ) capacitor c=0.00227051f \
 //x=21.46 //y=2.39 //x2=20.56 //y2=2.945
cc_1222 ( N_noxref_5_c_1534_n N_noxref_6_c_1991_n ) capacitor c=0.0288444f \
 //x=21.46 //y=4.585 //x2=20.56 //y2=2.945
cc_1223 ( N_noxref_5_c_1555_n N_noxref_6_c_1991_n ) capacitor c=0.0163271f \
 //x=21.455 //y=2.23 //x2=20.56 //y2=2.945
cc_1224 ( N_noxref_5_c_1557_n N_noxref_6_c_1991_n ) capacitor c=0.0308846f \
 //x=21.295 //y=2.23 //x2=20.56 //y2=2.945
cc_1225 ( N_noxref_5_c_1436_n N_noxref_6_c_1919_n ) capacitor c=0.016591f \
 //x=13.305 //y=2.22 //x2=12 //y2=2.945
cc_1226 ( N_noxref_5_c_1436_n N_noxref_6_c_1920_n ) capacitor c=5.2767e-19 \
 //x=13.305 //y=2.22 //x2=11.84 //y2=2.08
cc_1227 ( N_noxref_5_c_1436_n N_noxref_7_c_2313_n ) capacitor c=0.0160806f \
 //x=13.305 //y=2.22 //x2=8.14 //y2=2.195
cc_1228 ( N_noxref_5_c_1436_n N_noxref_7_c_2236_n ) capacitor c=0.0129637f \
 //x=13.305 //y=2.22 //x2=8.14 //y2=3.555
cc_1229 ( N_noxref_5_c_1436_n N_noxref_7_c_2248_n ) capacitor c=0.0167111f \
 //x=13.305 //y=2.22 //x2=12.95 //y2=2.195
cc_1230 ( N_noxref_5_c_1436_n N_noxref_7_c_2243_n ) capacitor c=0.0154065f \
 //x=13.305 //y=2.22 //x2=12.95 //y2=3.555
cc_1231 ( N_noxref_5_M40_noxref_g N_noxref_7_c_2332_n ) capacitor c=0.0110196f \
 //x=17.5 //y=6.02 //x2=17.605 //y2=5.155
cc_1232 ( N_noxref_5_M40_noxref_g N_noxref_7_c_2459_n ) capacitor \
 c=0.00226521f //x=17.5 //y=6.02 //x2=17.72 //y2=5.38
cc_1233 ( N_noxref_5_M41_noxref_g N_noxref_7_c_2459_n ) capacitor \
 c=0.00381703f //x=17.94 //y=6.02 //x2=17.72 //y2=5.38
cc_1234 ( N_noxref_5_c_1482_n N_noxref_7_c_2461_n ) capacitor c=2.36524e-19 \
 //x=17.76 //y=2.385 //x2=18.415 //y2=5.155
cc_1235 ( N_noxref_5_c_1464_n N_noxref_7_c_2461_n ) capacitor c=0.0023799f \
 //x=17.76 //y=4.57 //x2=18.415 //y2=5.155
cc_1236 ( N_noxref_5_c_1499_n N_noxref_7_c_2461_n ) capacitor c=0.00130631f \
 //x=17.76 //y=4.7 //x2=18.415 //y2=5.155
cc_1237 ( N_noxref_5_M41_noxref_g N_noxref_7_c_2461_n ) capacitor c=0.0114801f \
 //x=17.94 //y=6.02 //x2=18.415 //y2=5.155
cc_1238 ( N_noxref_5_c_1482_n N_noxref_7_c_2465_n ) capacitor c=4.88647e-19 \
 //x=17.76 //y=2.385 //x2=18.015 //y2=1.125
cc_1239 ( N_noxref_5_c_1481_n N_noxref_7_c_2465_n ) capacitor c=3.86337e-19 \
 //x=17.925 //y=2.22 //x2=18.015 //y2=1.125
cc_1240 ( N_noxref_5_c_1505_n N_noxref_7_c_2465_n ) capacitor c=4.64015e-19 \
 //x=17.75 //y=0.915 //x2=18.015 //y2=1.125
cc_1241 ( N_noxref_5_c_1506_n N_noxref_7_c_2465_n ) capacitor c=0.0026012f \
 //x=17.75 //y=1.26 //x2=18.015 //y2=1.125
cc_1242 ( N_noxref_5_c_1639_p N_noxref_7_c_2465_n ) capacitor c=5.29969e-19 \
 //x=18.125 //y=0.76 //x2=18.015 //y2=1.125
cc_1243 ( N_noxref_5_c_1640_p N_noxref_7_c_2465_n ) capacitor c=4.41409e-19 \
 //x=18.125 //y=1.415 //x2=18.015 //y2=1.125
cc_1244 ( N_noxref_5_c_1641_p N_noxref_7_c_2465_n ) capacitor c=5.24634e-19 \
 //x=18.28 //y=0.915 //x2=18.015 //y2=1.125
cc_1245 ( N_noxref_5_c_1642_p N_noxref_7_c_2465_n ) capacitor c=0.00307978f \
 //x=18.28 //y=1.26 //x2=18.015 //y2=1.125
cc_1246 ( N_noxref_5_c_1506_n N_noxref_7_c_2473_n ) capacitor c=0.00127432f \
 //x=17.75 //y=1.26 //x2=18.015 //y2=1.58
cc_1247 ( N_noxref_5_c_1507_n N_noxref_7_c_2473_n ) capacitor c=0.00441386f \
 //x=17.75 //y=1.57 //x2=18.015 //y2=1.58
cc_1248 ( N_noxref_5_c_1640_p N_noxref_7_c_2473_n ) capacitor c=0.00942306f \
 //x=18.125 //y=1.415 //x2=18.015 //y2=1.58
cc_1249 ( N_noxref_5_c_1642_p N_noxref_7_c_2473_n ) capacitor c=0.00363411f \
 //x=18.28 //y=1.26 //x2=18.015 //y2=1.58
cc_1250 ( N_noxref_5_c_1511_n N_noxref_7_c_2473_n ) capacitor c=0.0036273f \
 //x=17.76 //y=1.915 //x2=18.015 //y2=1.58
cc_1251 ( N_noxref_5_c_1640_p N_noxref_7_c_2478_n ) capacitor c=0.00194716f \
 //x=18.125 //y=1.415 //x2=18.415 //y2=1.665
cc_1252 ( N_noxref_5_c_1642_p N_noxref_7_c_2478_n ) capacitor c=0.00323576f \
 //x=18.28 //y=1.26 //x2=18.415 //y2=1.665
cc_1253 ( N_noxref_5_c_1557_n N_noxref_7_c_2265_n ) capacitor c=0.021648f \
 //x=21.295 //y=2.23 //x2=18.1 //y2=1.665
cc_1254 ( N_noxref_5_c_1482_n N_noxref_7_c_2333_n ) capacitor c=0.0217159f \
 //x=17.76 //y=2.385 //x2=18.5 //y2=3.555
cc_1255 ( N_noxref_5_c_1464_n N_noxref_7_c_2333_n ) capacitor c=0.0475984f \
 //x=17.76 //y=4.57 //x2=18.5 //y2=3.555
cc_1256 ( N_noxref_5_c_1534_n N_noxref_7_c_2333_n ) capacitor c=0.00180128f \
 //x=21.46 //y=4.585 //x2=18.5 //y2=3.555
cc_1257 ( N_noxref_5_c_1481_n N_noxref_7_c_2333_n ) capacitor c=0.00328982f \
 //x=17.925 //y=2.22 //x2=18.5 //y2=3.555
cc_1258 ( N_noxref_5_c_1557_n N_noxref_7_c_2333_n ) capacitor c=0.0300597f \
 //x=21.295 //y=2.23 //x2=18.5 //y2=3.555
cc_1259 ( N_noxref_5_c_1496_n N_noxref_7_c_2333_n ) capacitor c=9.86766e-19 \
 //x=17.76 //y=2.08 //x2=18.5 //y2=3.555
cc_1260 ( N_noxref_5_c_1508_n N_noxref_7_c_2333_n ) capacitor c=0.00117465f \
 //x=17.76 //y=2.08 //x2=18.5 //y2=3.555
cc_1261 ( N_noxref_5_c_1511_n N_noxref_7_c_2333_n ) capacitor c=0.00282067f \
 //x=17.76 //y=1.915 //x2=18.5 //y2=3.555
cc_1262 ( N_noxref_5_c_1464_n N_noxref_7_c_2400_n ) capacitor c=0.0152522f \
 //x=17.76 //y=4.57 //x2=18.5 //y2=3.875
cc_1263 ( N_noxref_5_c_1464_n N_noxref_7_c_2334_n ) capacitor c=0.0459852f \
 //x=17.76 //y=4.57 //x2=18.5 //y2=5.07
cc_1264 ( N_noxref_5_c_1534_n N_noxref_7_c_2334_n ) capacitor c=0.00130353f \
 //x=21.46 //y=4.585 //x2=18.5 //y2=5.07
cc_1265 ( N_noxref_5_c_1499_n N_noxref_7_c_2334_n ) capacitor c=0.00131258f \
 //x=17.76 //y=4.7 //x2=18.5 //y2=5.07
cc_1266 ( N_noxref_5_c_1512_n N_noxref_7_c_2334_n ) capacitor c=0.00739875f \
 //x=17.76 //y=4.7 //x2=18.5 //y2=5.07
cc_1267 ( N_noxref_5_c_1482_n N_noxref_7_c_2494_n ) capacitor c=4.69912e-19 \
 //x=17.76 //y=2.385 //x2=17.72 //y2=5.155
cc_1268 ( N_noxref_5_c_1464_n N_noxref_7_c_2494_n ) capacitor c=0.0235312f \
 //x=17.76 //y=4.57 //x2=17.72 //y2=5.155
cc_1269 ( N_noxref_5_c_1499_n N_noxref_7_c_2494_n ) capacitor c=0.00346456f \
 //x=17.76 //y=4.7 //x2=17.72 //y2=5.155
cc_1270 ( N_noxref_5_c_1512_n N_noxref_7_c_2494_n ) capacitor c=0.00203307f \
 //x=17.76 //y=4.7 //x2=17.72 //y2=5.155
cc_1271 ( N_noxref_5_c_1464_n N_noxref_7_c_2498_n ) capacitor c=9.19401e-19 \
 //x=17.76 //y=4.57 //x2=18.5 //y2=3.7
cc_1272 ( N_noxref_5_c_1464_n N_noxref_7_c_2272_n ) capacitor c=0.0287131f \
 //x=17.76 //y=4.57 //x2=18.33 //y2=3.7
cc_1273 ( N_noxref_5_c_1534_n N_noxref_7_c_2405_n ) capacitor c=0.0336817f \
 //x=21.46 //y=4.585 //x2=20.56 //y2=3.715
cc_1274 ( N_noxref_5_c_1557_n N_noxref_7_c_2405_n ) capacitor c=0.00271898f \
 //x=21.295 //y=2.23 //x2=20.56 //y2=3.715
cc_1275 ( N_noxref_5_c_1464_n N_noxref_7_c_2407_n ) capacitor c=0.00340182f \
 //x=17.76 //y=4.57 //x2=20.215 //y2=3.715
cc_1276 ( N_noxref_5_c_1436_n N_noxref_7_c_2246_n ) capacitor c=0.00447591f \
 //x=13.305 //y=2.22 //x2=12.79 //y2=3.715
cc_1277 ( N_noxref_5_c_1436_n N_noxref_7_c_2351_n ) capacitor c=2.63835e-19 \
 //x=13.305 //y=2.22 //x2=8.14 //y2=2.08
cc_1278 ( N_noxref_5_c_1436_n N_noxref_7_c_2275_n ) capacitor c=2.63835e-19 \
 //x=13.305 //y=2.22 //x2=12.95 //y2=2.08
cc_1279 ( N_noxref_5_c_1464_n N_noxref_7_c_2506_n ) capacitor c=0.00266871f \
 //x=17.76 //y=4.57 //x2=17.72 //y2=5.38
cc_1280 ( N_noxref_5_c_1499_n N_noxref_7_c_2506_n ) capacitor c=0.00624059f \
 //x=17.76 //y=4.7 //x2=17.72 //y2=5.38
cc_1281 ( N_noxref_5_M40_noxref_g N_noxref_7_c_2506_n ) capacitor c=0.0178885f \
 //x=17.5 //y=6.02 //x2=17.72 //y2=5.38
cc_1282 ( N_noxref_5_M41_noxref_g N_noxref_7_c_2506_n ) capacitor c=0.0188608f \
 //x=17.94 //y=6.02 //x2=17.72 //y2=5.38
cc_1283 ( N_noxref_5_c_1512_n N_noxref_7_c_2506_n ) capacitor c=0.00375636f \
 //x=17.76 //y=4.7 //x2=17.72 //y2=5.38
cc_1284 ( N_noxref_5_c_1505_n N_noxref_7_M11_noxref_d ) capacitor \
 c=0.00137165f //x=17.75 //y=0.915 //x2=17.825 //y2=0.915
cc_1285 ( N_noxref_5_c_1506_n N_noxref_7_M11_noxref_d ) capacitor \
 c=0.00237422f //x=17.75 //y=1.26 //x2=17.825 //y2=0.915
cc_1286 ( N_noxref_5_c_1639_p N_noxref_7_M11_noxref_d ) capacitor c=0.0020782f \
 //x=18.125 //y=0.76 //x2=17.825 //y2=0.915
cc_1287 ( N_noxref_5_c_1640_p N_noxref_7_M11_noxref_d ) capacitor \
 c=0.00356097f //x=18.125 //y=1.415 //x2=17.825 //y2=0.915
cc_1288 ( N_noxref_5_c_1641_p N_noxref_7_M11_noxref_d ) capacitor \
 c=0.00139206f //x=18.28 //y=0.915 //x2=17.825 //y2=0.915
cc_1289 ( N_noxref_5_c_1642_p N_noxref_7_M11_noxref_d ) capacitor \
 c=0.00237422f //x=18.28 //y=1.26 //x2=17.825 //y2=0.915
cc_1290 ( N_noxref_5_M20_noxref_g N_noxref_8_c_2808_n ) capacitor \
 c=0.00700336f //x=2.19 //y=6.02 //x2=2.765 //y2=7.4
cc_1291 ( N_noxref_5_M21_noxref_g N_noxref_8_c_2808_n ) capacitor \
 c=0.00749619f //x=2.63 //y=6.02 //x2=2.765 //y2=7.4
cc_1292 ( N_noxref_5_M40_noxref_g N_noxref_8_c_2982_n ) capacitor \
 c=0.00749619f //x=17.5 //y=6.02 //x2=18.075 //y2=7.4
cc_1293 ( N_noxref_5_M41_noxref_g N_noxref_8_c_2982_n ) capacitor \
 c=0.00749823f //x=17.94 //y=6.02 //x2=18.075 //y2=7.4
cc_1294 ( N_noxref_5_M44_noxref_g N_noxref_8_c_2984_n ) capacitor \
 c=0.00700336f //x=21.43 //y=6.02 //x2=22.005 //y2=7.4
cc_1295 ( N_noxref_5_M45_noxref_g N_noxref_8_c_2984_n ) capacitor \
 c=0.00749619f //x=21.87 //y=6.02 //x2=22.005 //y2=7.4
cc_1296 ( N_noxref_5_c_1499_n N_noxref_8_c_2954_n ) capacitor c=0.00224736f \
 //x=17.76 //y=4.7 //x2=19.24 //y2=7.4
cc_1297 ( N_noxref_5_c_1512_n N_noxref_8_c_2954_n ) capacitor c=2.63786e-19 \
 //x=17.76 //y=4.7 //x2=19.24 //y2=7.4
cc_1298 ( N_noxref_5_M20_noxref_g N_noxref_8_M19_noxref_d ) capacitor \
 c=0.015318f //x=2.19 //y=6.02 //x2=1.825 //y2=5.02
cc_1299 ( N_noxref_5_M21_noxref_g N_noxref_8_M21_noxref_d ) capacitor \
 c=0.015318f //x=2.63 //y=6.02 //x2=2.705 //y2=5.02
cc_1300 ( N_noxref_5_M40_noxref_g N_noxref_8_M39_noxref_d ) capacitor \
 c=0.015318f //x=17.5 //y=6.02 //x2=17.135 //y2=5.02
cc_1301 ( N_noxref_5_M41_noxref_g N_noxref_8_M41_noxref_d ) capacitor \
 c=0.0394719f //x=17.94 //y=6.02 //x2=18.015 //y2=5.02
cc_1302 ( N_noxref_5_M44_noxref_g N_noxref_8_M43_noxref_d ) capacitor \
 c=0.015318f //x=21.43 //y=6.02 //x2=21.065 //y2=5.02
cc_1303 ( N_noxref_5_M45_noxref_g N_noxref_8_M45_noxref_d ) capacitor \
 c=0.015318f //x=21.87 //y=6.02 //x2=21.945 //y2=5.02
cc_1304 ( N_noxref_5_c_1430_n N_noxref_9_c_3188_n ) capacitor c=0.00852402f \
 //x=2.22 //y=2.38 //x2=1.11 //y2=2.195
cc_1305 ( N_noxref_5_c_1551_n N_noxref_9_c_3188_n ) capacitor c=0.00308547f \
 //x=2.38 //y=2.22 //x2=1.11 //y2=2.195
cc_1306 ( N_noxref_5_c_1561_n N_noxref_9_c_3188_n ) capacitor c=0.00371135f \
 //x=2.22 //y=2.08 //x2=1.11 //y2=2.195
cc_1307 ( N_noxref_5_c_1583_n N_noxref_9_c_3188_n ) capacitor c=0.00138458f \
 //x=2.31 //y=1.915 //x2=1.11 //y2=2.195
cc_1308 ( N_noxref_5_c_1430_n N_noxref_9_c_3186_n ) capacitor c=0.004205f \
 //x=2.22 //y=2.38 //x2=1.11 //y2=4.575
cc_1309 ( N_noxref_5_c_1432_n N_noxref_9_c_3186_n ) capacitor c=0.0814787f \
 //x=2.22 //y=4.585 //x2=1.11 //y2=4.575
cc_1310 ( N_noxref_5_c_1551_n N_noxref_9_c_3186_n ) capacitor c=0.00324704f \
 //x=2.38 //y=2.22 //x2=1.11 //y2=4.575
cc_1311 ( N_noxref_5_c_1561_n N_noxref_9_c_3186_n ) capacitor c=4.09877e-19 \
 //x=2.22 //y=2.08 //x2=1.11 //y2=4.575
cc_1312 ( N_noxref_5_c_1453_n N_noxref_9_c_3186_n ) capacitor c=0.00411832f \
 //x=2.22 //y=4.7 //x2=1.11 //y2=4.575
cc_1313 ( N_noxref_5_c_1463_n N_noxref_9_c_3186_n ) capacitor c=0.00116212f \
 //x=2.22 //y=4.7 //x2=1.11 //y2=4.575
cc_1314 ( N_noxref_5_c_1430_n N_noxref_9_c_3198_n ) capacitor c=0.00116411f \
 //x=2.22 //y=2.38 //x2=1.11 //y2=2.08
cc_1315 ( N_noxref_5_c_1561_n N_noxref_9_c_3198_n ) capacitor c=0.00124907f \
 //x=2.22 //y=2.08 //x2=1.11 //y2=2.08
cc_1316 ( N_noxref_5_c_1583_n N_noxref_9_c_3198_n ) capacitor c=0.00174566f \
 //x=2.31 //y=1.915 //x2=1.11 //y2=2.08
cc_1317 ( N_noxref_5_c_1432_n N_noxref_9_c_3201_n ) capacitor c=6.26008e-19 \
 //x=2.22 //y=4.585 //x2=1.11 //y2=4.7
cc_1318 ( N_noxref_5_c_1453_n N_noxref_9_c_3201_n ) capacitor c=0.00113984f \
 //x=2.22 //y=4.7 //x2=1.11 //y2=4.7
cc_1319 ( N_noxref_5_c_1463_n N_noxref_9_c_3201_n ) capacitor c=0.00155973f \
 //x=2.22 //y=4.7 //x2=1.11 //y2=4.7
cc_1320 ( N_noxref_5_M20_noxref_g N_noxref_9_M18_noxref_g ) capacitor \
 c=0.0106276f //x=2.19 //y=6.02 //x2=1.31 //y2=6.02
cc_1321 ( N_noxref_5_M20_noxref_g N_noxref_9_M19_noxref_g ) capacitor \
 c=0.107144f //x=2.19 //y=6.02 //x2=1.75 //y2=6.02
cc_1322 ( N_noxref_5_M21_noxref_g N_noxref_9_M19_noxref_g ) capacitor \
 c=0.0101598f //x=2.63 //y=6.02 //x2=1.75 //y2=6.02
cc_1323 ( N_noxref_5_c_1720_p N_noxref_9_c_3207_n ) capacitor c=5.72528e-19 \
 //x=1.785 //y=0.91 //x2=0.81 //y2=0.875
cc_1324 ( N_noxref_5_c_1720_p N_noxref_9_c_3208_n ) capacitor c=0.00150277f \
 //x=1.785 //y=0.91 //x2=0.81 //y2=1.22
cc_1325 ( N_noxref_5_c_1722_p N_noxref_9_c_3209_n ) capacitor c=0.00111227f \
 //x=1.785 //y=1.22 //x2=0.81 //y2=1.53
cc_1326 ( N_noxref_5_c_1430_n N_noxref_9_c_3210_n ) capacitor c=0.00157447f \
 //x=2.22 //y=2.38 //x2=0.81 //y2=1.915
cc_1327 ( N_noxref_5_c_1561_n N_noxref_9_c_3210_n ) capacitor c=0.00214501f \
 //x=2.22 //y=2.08 //x2=0.81 //y2=1.915
cc_1328 ( N_noxref_5_c_1583_n N_noxref_9_c_3210_n ) capacitor c=0.0088427f \
 //x=2.31 //y=1.915 //x2=0.81 //y2=1.915
cc_1329 ( N_noxref_5_c_1720_p N_noxref_9_c_3213_n ) capacitor c=0.0160123f \
 //x=1.785 //y=0.91 //x2=1.34 //y2=0.875
cc_1330 ( N_noxref_5_c_1580_n N_noxref_9_c_3213_n ) capacitor c=9.19165e-19 \
 //x=2.31 //y=0.91 //x2=1.34 //y2=0.875
cc_1331 ( N_noxref_5_c_1722_p N_noxref_9_c_3215_n ) capacitor c=0.0124075f \
 //x=1.785 //y=1.22 //x2=1.34 //y2=1.22
cc_1332 ( N_noxref_5_c_1581_n N_noxref_9_c_3215_n ) capacitor c=0.0010154f \
 //x=2.31 //y=1.22 //x2=1.34 //y2=1.22
cc_1333 ( N_noxref_5_c_1582_n N_noxref_9_c_3215_n ) capacitor c=9.23422e-19 \
 //x=2.31 //y=1.45 //x2=1.34 //y2=1.22
cc_1334 ( N_noxref_5_c_1432_n N_noxref_9_c_3184_n ) capacitor c=7.66769e-19 \
 //x=2.22 //y=4.585 //x2=1.675 //y2=4.79
cc_1335 ( N_noxref_5_c_1453_n N_noxref_9_c_3184_n ) capacitor c=0.00116563f \
 //x=2.22 //y=4.7 //x2=1.675 //y2=4.79
cc_1336 ( N_noxref_5_c_1463_n N_noxref_9_c_3184_n ) capacitor c=0.0171374f \
 //x=2.22 //y=4.7 //x2=1.675 //y2=4.79
cc_1337 ( N_noxref_5_c_1432_n N_noxref_9_c_3221_n ) capacitor c=7.54501e-19 \
 //x=2.22 //y=4.585 //x2=1.385 //y2=4.79
cc_1338 ( N_noxref_5_c_1453_n N_noxref_9_c_3221_n ) capacitor c=0.00129812f \
 //x=2.22 //y=4.7 //x2=1.385 //y2=4.79
cc_1339 ( N_noxref_5_c_1463_n N_noxref_9_c_3221_n ) capacitor c=0.00484466f \
 //x=2.22 //y=4.7 //x2=1.385 //y2=4.79
cc_1340 ( N_noxref_5_c_1436_n N_noxref_10_c_3292_n ) capacitor c=0.00519491f \
 //x=13.305 //y=2.22 //x2=3.015 //y2=0.995
cc_1341 ( N_noxref_5_c_1580_n N_noxref_10_c_3292_n ) capacitor c=0.00123426f \
 //x=2.31 //y=0.91 //x2=3.015 //y2=0.995
cc_1342 ( N_noxref_5_c_1581_n N_noxref_10_c_3292_n ) capacitor c=0.0129287f \
 //x=2.31 //y=1.22 //x2=3.015 //y2=0.995
cc_1343 ( N_noxref_5_c_1582_n N_noxref_10_c_3292_n ) capacitor c=0.00132209f \
 //x=2.31 //y=1.45 //x2=3.015 //y2=0.995
cc_1344 ( N_noxref_5_c_1436_n N_noxref_10_c_3271_n ) capacitor c=3.59668e-19 \
 //x=13.305 //y=2.22 //x2=3.985 //y2=0.54
cc_1345 ( N_noxref_5_c_1430_n N_noxref_10_M1_noxref_d ) capacitor \
 c=0.00672102f //x=2.22 //y=2.38 //x2=1.86 //y2=0.91
cc_1346 ( N_noxref_5_c_1551_n N_noxref_10_M1_noxref_d ) capacitor \
 c=9.79219e-19 //x=2.38 //y=2.22 //x2=1.86 //y2=0.91
cc_1347 ( N_noxref_5_c_1561_n N_noxref_10_M1_noxref_d ) capacitor c=2.2052e-19 \
 //x=2.22 //y=2.08 //x2=1.86 //y2=0.91
cc_1348 ( N_noxref_5_c_1720_p N_noxref_10_M1_noxref_d ) capacitor \
 c=0.00253592f //x=1.785 //y=0.91 //x2=1.86 //y2=0.91
cc_1349 ( N_noxref_5_c_1722_p N_noxref_10_M1_noxref_d ) capacitor \
 c=0.00604634f //x=1.785 //y=1.22 //x2=1.86 //y2=0.91
cc_1350 ( N_noxref_5_c_1747_p N_noxref_10_M1_noxref_d ) capacitor c=0.002686f \
 //x=2.155 //y=0.755 //x2=1.86 //y2=0.91
cc_1351 ( N_noxref_5_c_1748_p N_noxref_10_M1_noxref_d ) capacitor \
 c=0.00251995f //x=2.155 //y=1.375 //x2=1.86 //y2=0.91
cc_1352 ( N_noxref_5_c_1580_n N_noxref_10_M1_noxref_d ) capacitor \
 c=0.00314523f //x=2.31 //y=0.91 //x2=1.86 //y2=0.91
cc_1353 ( N_noxref_5_c_1581_n N_noxref_10_M1_noxref_d ) capacitor \
 c=0.00168289f //x=2.31 //y=1.22 //x2=1.86 //y2=0.91
cc_1354 ( N_noxref_5_c_1582_n N_noxref_10_M1_noxref_d ) capacitor \
 c=0.00111165f //x=2.31 //y=1.45 //x2=1.86 //y2=0.91
cc_1355 ( N_noxref_5_c_1436_n N_noxref_10_M2_noxref_s ) capacitor \
 c=0.00421809f //x=13.305 //y=2.22 //x2=2.965 //y2=0.375
cc_1356 ( N_noxref_5_c_1580_n N_noxref_10_M2_noxref_s ) capacitor \
 c=7.21316e-19 //x=2.31 //y=0.91 //x2=2.965 //y2=0.375
cc_1357 ( N_noxref_5_c_1581_n N_noxref_10_M2_noxref_s ) capacitor \
 c=0.00365271f //x=2.31 //y=1.22 //x2=2.965 //y2=0.375
cc_1358 ( N_noxref_5_c_1583_n N_noxref_10_M2_noxref_s ) capacitor \
 c=9.86711e-19 //x=2.31 //y=1.915 //x2=2.965 //y2=0.375
cc_1359 ( N_noxref_5_c_1436_n N_noxref_11_c_3341_n ) capacitor c=0.00601428f \
 //x=13.305 //y=2.22 //x2=7.825 //y2=0.995
cc_1360 ( N_noxref_5_c_1436_n N_noxref_11_c_3356_n ) capacitor c=3.59668e-19 \
 //x=13.305 //y=2.22 //x2=8.795 //y2=0.54
cc_1361 ( N_noxref_5_c_1436_n N_noxref_11_M4_noxref_d ) capacitor c=0.0071888f \
 //x=13.305 //y=2.22 //x2=6.67 //y2=0.91
cc_1362 ( N_noxref_5_c_1436_n N_noxref_11_M5_noxref_s ) capacitor \
 c=0.00448124f //x=13.305 //y=2.22 //x2=7.775 //y2=0.375
cc_1363 ( N_noxref_5_c_1436_n N_noxref_12_c_3422_n ) capacitor c=0.00601428f \
 //x=13.305 //y=2.22 //x2=12.635 //y2=0.995
cc_1364 ( N_noxref_5_c_1436_n N_noxref_12_c_3410_n ) capacitor c=3.59668e-19 \
 //x=13.305 //y=2.22 //x2=13.605 //y2=0.54
cc_1365 ( N_noxref_5_c_1436_n N_noxref_12_M7_noxref_d ) capacitor \
 c=0.00693903f //x=13.305 //y=2.22 //x2=11.48 //y2=0.91
cc_1366 ( N_noxref_5_c_1436_n N_noxref_12_M8_noxref_s ) capacitor \
 c=0.00471087f //x=13.305 //y=2.22 //x2=12.585 //y2=0.375
cc_1367 ( N_noxref_5_c_1481_n N_noxref_13_c_3482_n ) capacitor c=0.00601428f \
 //x=17.925 //y=2.22 //x2=17.445 //y2=0.995
cc_1368 ( N_noxref_5_c_1482_n N_noxref_13_c_3498_n ) capacitor c=0.00205753f \
 //x=17.76 //y=2.385 //x2=18.415 //y2=0.54
cc_1369 ( N_noxref_5_c_1496_n N_noxref_13_c_3498_n ) capacitor c=0.00117306f \
 //x=17.76 //y=2.08 //x2=18.415 //y2=0.54
cc_1370 ( N_noxref_5_c_1505_n N_noxref_13_c_3498_n ) capacitor c=0.0206349f \
 //x=17.75 //y=0.915 //x2=18.415 //y2=0.54
cc_1371 ( N_noxref_5_c_1641_p N_noxref_13_c_3498_n ) capacitor c=0.00825432f \
 //x=18.28 //y=0.915 //x2=18.415 //y2=0.54
cc_1372 ( N_noxref_5_c_1508_n N_noxref_13_c_3498_n ) capacitor c=2.20712e-19 \
 //x=17.76 //y=2.08 //x2=18.415 //y2=0.54
cc_1373 ( N_noxref_5_c_1506_n N_noxref_13_c_3503_n ) capacitor c=0.0071177f \
 //x=17.75 //y=1.26 //x2=17.53 //y2=0.995
cc_1374 ( N_noxref_5_c_1481_n N_noxref_13_M10_noxref_d ) capacitor \
 c=0.00720826f //x=17.925 //y=2.22 //x2=16.29 //y2=0.91
cc_1375 ( N_noxref_5_c_1482_n N_noxref_13_M11_noxref_s ) capacitor \
 c=4.02723e-19 //x=17.76 //y=2.385 //x2=17.395 //y2=0.375
cc_1376 ( N_noxref_5_c_1481_n N_noxref_13_M11_noxref_s ) capacitor \
 c=0.00418676f //x=17.925 //y=2.22 //x2=17.395 //y2=0.375
cc_1377 ( N_noxref_5_c_1505_n N_noxref_13_M11_noxref_s ) capacitor \
 c=0.0071177f //x=17.75 //y=0.915 //x2=17.395 //y2=0.375
cc_1378 ( N_noxref_5_c_1507_n N_noxref_13_M11_noxref_s ) capacitor \
 c=0.0071177f //x=17.75 //y=1.57 //x2=17.395 //y2=0.375
cc_1379 ( N_noxref_5_c_1641_p N_noxref_13_M11_noxref_s ) capacitor c=0.015333f \
 //x=18.28 //y=0.915 //x2=17.395 //y2=0.375
cc_1380 ( N_noxref_5_c_1642_p N_noxref_13_M11_noxref_s ) capacitor \
 c=0.00248746f //x=18.28 //y=1.26 //x2=17.395 //y2=0.375
cc_1381 ( N_noxref_5_c_1593_n N_noxref_14_c_3551_n ) capacitor c=0.00123426f \
 //x=21.55 //y=0.91 //x2=22.255 //y2=0.995
cc_1382 ( N_noxref_5_c_1594_n N_noxref_14_c_3551_n ) capacitor c=0.0129287f \
 //x=21.55 //y=1.22 //x2=22.255 //y2=0.995
cc_1383 ( N_noxref_5_c_1595_n N_noxref_14_c_3551_n ) capacitor c=0.00132209f \
 //x=21.55 //y=1.45 //x2=22.255 //y2=0.995
cc_1384 ( N_noxref_5_c_1530_n N_noxref_14_M13_noxref_d ) capacitor \
 c=0.00676893f //x=21.46 //y=2.39 //x2=21.1 //y2=0.91
cc_1385 ( N_noxref_5_c_1555_n N_noxref_14_M13_noxref_d ) capacitor \
 c=0.00108533f //x=21.455 //y=2.23 //x2=21.1 //y2=0.91
cc_1386 ( N_noxref_5_c_1557_n N_noxref_14_M13_noxref_d ) capacitor \
 c=0.00528699f //x=21.295 //y=2.23 //x2=21.1 //y2=0.91
cc_1387 ( N_noxref_5_c_1567_n N_noxref_14_M13_noxref_d ) capacitor \
 c=2.2052e-19 //x=21.46 //y=2.08 //x2=21.1 //y2=0.91
cc_1388 ( N_noxref_5_c_1588_n N_noxref_14_M13_noxref_d ) capacitor \
 c=0.00253592f //x=21.025 //y=0.91 //x2=21.1 //y2=0.91
cc_1389 ( N_noxref_5_c_1591_n N_noxref_14_M13_noxref_d ) capacitor \
 c=0.00604087f //x=21.025 //y=1.22 //x2=21.1 //y2=0.91
cc_1390 ( N_noxref_5_c_1787_p N_noxref_14_M13_noxref_d ) capacitor c=0.002686f \
 //x=21.395 //y=0.755 //x2=21.1 //y2=0.91
cc_1391 ( N_noxref_5_c_1788_p N_noxref_14_M13_noxref_d ) capacitor \
 c=0.00251995f //x=21.395 //y=1.375 //x2=21.1 //y2=0.91
cc_1392 ( N_noxref_5_c_1593_n N_noxref_14_M13_noxref_d ) capacitor \
 c=0.00314523f //x=21.55 //y=0.91 //x2=21.1 //y2=0.91
cc_1393 ( N_noxref_5_c_1594_n N_noxref_14_M13_noxref_d ) capacitor \
 c=0.00168289f //x=21.55 //y=1.22 //x2=21.1 //y2=0.91
cc_1394 ( N_noxref_5_c_1595_n N_noxref_14_M13_noxref_d ) capacitor \
 c=0.00111165f //x=21.55 //y=1.45 //x2=21.1 //y2=0.91
cc_1395 ( N_noxref_5_c_1593_n N_noxref_14_M14_noxref_s ) capacitor \
 c=7.21316e-19 //x=21.55 //y=0.91 //x2=22.205 //y2=0.375
cc_1396 ( N_noxref_5_c_1594_n N_noxref_14_M14_noxref_s ) capacitor \
 c=0.00365271f //x=21.55 //y=1.22 //x2=22.205 //y2=0.375
cc_1397 ( N_noxref_5_c_1596_n N_noxref_14_M14_noxref_s ) capacitor \
 c=9.86711e-19 //x=21.55 //y=1.915 //x2=22.205 //y2=0.375
cc_1398 ( N_noxref_5_c_1530_n N_noxref_15_c_3622_n ) capacitor c=0.0086307f \
 //x=21.46 //y=2.39 //x2=22.57 //y2=2.195
cc_1399 ( N_noxref_5_c_1555_n N_noxref_15_c_3622_n ) capacitor c=0.0028518f \
 //x=21.455 //y=2.23 //x2=22.57 //y2=2.195
cc_1400 ( N_noxref_5_c_1567_n N_noxref_15_c_3622_n ) capacitor c=5.39999e-19 \
 //x=21.46 //y=2.08 //x2=22.57 //y2=2.195
cc_1401 ( N_noxref_5_c_1596_n N_noxref_15_c_3622_n ) capacitor c=6.8688e-19 \
 //x=21.55 //y=1.915 //x2=22.57 //y2=2.195
cc_1402 ( N_noxref_5_c_1530_n N_noxref_15_c_3620_n ) capacitor c=0.00437966f \
 //x=21.46 //y=2.39 //x2=22.57 //y2=4.57
cc_1403 ( N_noxref_5_c_1534_n N_noxref_15_c_3620_n ) capacitor c=0.0711951f \
 //x=21.46 //y=4.585 //x2=22.57 //y2=4.57
cc_1404 ( N_noxref_5_c_1555_n N_noxref_15_c_3620_n ) capacitor c=0.00339632f \
 //x=21.455 //y=2.23 //x2=22.57 //y2=4.57
cc_1405 ( N_noxref_5_c_1570_n N_noxref_15_c_3620_n ) capacitor c=9.52396e-19 \
 //x=21.46 //y=4.7 //x2=22.57 //y2=4.57
cc_1406 ( N_noxref_5_c_1602_n N_noxref_15_c_3620_n ) capacitor c=8.42568e-19 \
 //x=21.46 //y=4.7 //x2=22.57 //y2=4.57
cc_1407 ( N_noxref_5_c_1530_n N_noxref_15_c_3631_n ) capacitor c=0.00116223f \
 //x=21.46 //y=2.39 //x2=22.57 //y2=2.08
cc_1408 ( N_noxref_5_c_1567_n N_noxref_15_c_3631_n ) capacitor c=0.00124908f \
 //x=21.46 //y=2.08 //x2=22.57 //y2=2.08
cc_1409 ( N_noxref_5_c_1596_n N_noxref_15_c_3631_n ) capacitor c=0.00178498f \
 //x=21.55 //y=1.915 //x2=22.57 //y2=2.08
cc_1410 ( N_noxref_5_c_1534_n N_noxref_15_c_3634_n ) capacitor c=7.51101e-19 \
 //x=21.46 //y=4.585 //x2=22.57 //y2=4.7
cc_1411 ( N_noxref_5_c_1570_n N_noxref_15_c_3634_n ) capacitor c=0.00113985f \
 //x=21.46 //y=4.7 //x2=22.57 //y2=4.7
cc_1412 ( N_noxref_5_c_1602_n N_noxref_15_c_3634_n ) capacitor c=0.00129812f \
 //x=21.46 //y=4.7 //x2=22.57 //y2=4.7
cc_1413 ( N_noxref_5_M44_noxref_g N_noxref_15_M46_noxref_g ) capacitor \
 c=0.0101598f //x=21.43 //y=6.02 //x2=22.31 //y2=6.02
cc_1414 ( N_noxref_5_M45_noxref_g N_noxref_15_M46_noxref_g ) capacitor \
 c=0.0607518f //x=21.87 //y=6.02 //x2=22.31 //y2=6.02
cc_1415 ( N_noxref_5_M45_noxref_g N_noxref_15_M47_noxref_g ) capacitor \
 c=0.0101598f //x=21.87 //y=6.02 //x2=22.75 //y2=6.02
cc_1416 ( N_noxref_5_c_1593_n N_noxref_15_c_3640_n ) capacitor c=0.00456962f \
 //x=21.55 //y=0.91 //x2=22.56 //y2=0.915
cc_1417 ( N_noxref_5_c_1594_n N_noxref_15_c_3641_n ) capacitor c=0.00438372f \
 //x=21.55 //y=1.22 //x2=22.56 //y2=1.26
cc_1418 ( N_noxref_5_c_1595_n N_noxref_15_c_3642_n ) capacitor c=0.00438372f \
 //x=21.55 //y=1.45 //x2=22.56 //y2=1.57
cc_1419 ( N_noxref_5_c_1530_n N_noxref_15_c_3643_n ) capacitor c=0.00149853f \
 //x=21.46 //y=2.39 //x2=22.57 //y2=2.08
cc_1420 ( N_noxref_5_c_1567_n N_noxref_15_c_3643_n ) capacitor c=0.00204796f \
 //x=21.46 //y=2.08 //x2=22.57 //y2=2.08
cc_1421 ( N_noxref_5_c_1596_n N_noxref_15_c_3643_n ) capacitor c=0.0087493f \
 //x=21.55 //y=1.915 //x2=22.57 //y2=2.08
cc_1422 ( N_noxref_5_c_1596_n N_noxref_15_c_3646_n ) capacitor c=0.00438372f \
 //x=21.55 //y=1.915 //x2=22.57 //y2=1.915
cc_1423 ( N_noxref_5_c_1534_n N_noxref_15_c_3647_n ) capacitor c=0.00124604f \
 //x=21.46 //y=4.585 //x2=22.57 //y2=4.7
cc_1424 ( N_noxref_5_c_1570_n N_noxref_15_c_3647_n ) capacitor c=0.00187046f \
 //x=21.46 //y=4.7 //x2=22.57 //y2=4.7
cc_1425 ( N_noxref_5_c_1822_p N_noxref_15_c_3647_n ) capacitor c=0.0616777f \
 //x=21.795 //y=4.79 //x2=22.57 //y2=4.7
cc_1426 ( N_noxref_5_c_1602_n N_noxref_15_c_3647_n ) capacitor c=0.00487508f \
 //x=21.46 //y=4.7 //x2=22.57 //y2=4.7
cc_1427 ( N_noxref_5_c_1530_n N_noxref_16_c_3714_n ) capacitor c=3.99678e-19 \
 //x=21.46 //y=2.39 //x2=21.53 //y2=5.155
cc_1428 ( N_noxref_5_c_1534_n N_noxref_16_c_3714_n ) capacitor c=0.0219105f \
 //x=21.46 //y=4.585 //x2=21.53 //y2=5.155
cc_1429 ( N_noxref_5_c_1570_n N_noxref_16_c_3714_n ) capacitor c=0.00492634f \
 //x=21.46 //y=4.7 //x2=21.53 //y2=5.155
cc_1430 ( N_noxref_5_M44_noxref_g N_noxref_16_c_3714_n ) capacitor \
 c=0.00858241f //x=21.43 //y=6.02 //x2=21.53 //y2=5.155
cc_1431 ( N_noxref_5_c_1602_n N_noxref_16_c_3714_n ) capacitor c=6.1418e-19 \
 //x=21.46 //y=4.7 //x2=21.53 //y2=5.155
cc_1432 ( N_noxref_5_M45_noxref_g N_noxref_16_c_3726_n ) capacitor \
 c=0.0110196f //x=21.87 //y=6.02 //x2=22.415 //y2=5.155
cc_1433 ( N_noxref_5_c_1534_n N_noxref_16_c_3727_n ) capacitor c=0.00394217f \
 //x=21.46 //y=4.585 //x2=23.31 //y2=5.07
cc_1434 ( N_noxref_5_c_1530_n N_noxref_16_c_3728_n ) capacitor c=4.42078e-19 \
 //x=21.46 //y=2.39 //x2=21.65 //y2=5.155
cc_1435 ( N_noxref_5_c_1534_n N_noxref_16_c_3728_n ) capacitor c=0.0024774f \
 //x=21.46 //y=4.585 //x2=21.65 //y2=5.155
cc_1436 ( N_noxref_5_c_1570_n N_noxref_16_c_3728_n ) capacitor c=0.00132214f \
 //x=21.46 //y=4.7 //x2=21.65 //y2=5.155
cc_1437 ( N_noxref_5_M44_noxref_g N_noxref_16_c_3728_n ) capacitor \
 c=0.00229818f //x=21.43 //y=6.02 //x2=21.65 //y2=5.155
cc_1438 ( N_noxref_5_M45_noxref_g N_noxref_16_c_3728_n ) capacitor \
 c=0.00230699f //x=21.87 //y=6.02 //x2=21.65 //y2=5.155
cc_1439 ( N_noxref_5_c_1822_p N_noxref_16_c_3728_n ) capacitor c=0.0017897f \
 //x=21.795 //y=4.79 //x2=21.65 //y2=5.155
cc_1440 ( N_noxref_5_c_1534_n N_noxref_16_c_3734_n ) capacitor c=7.85344e-19 \
 //x=21.46 //y=4.585 //x2=21.65 //y2=5.38
cc_1441 ( N_noxref_5_M44_noxref_g N_noxref_16_c_3734_n ) capacitor \
 c=0.0179041f //x=21.43 //y=6.02 //x2=21.65 //y2=5.38
cc_1442 ( N_noxref_5_M45_noxref_g N_noxref_16_c_3734_n ) capacitor \
 c=0.0179041f //x=21.87 //y=6.02 //x2=21.65 //y2=5.38
cc_1443 ( N_noxref_5_c_1822_p N_noxref_16_c_3734_n ) capacitor c=0.00290085f \
 //x=21.795 //y=4.79 //x2=21.65 //y2=5.38
cc_1444 ( N_noxref_5_c_1430_n N_noxref_17_c_3852_n ) capacitor c=8.86429e-19 \
 //x=2.22 //y=2.38 //x2=5.8 //y2=0
cc_1445 ( N_noxref_5_c_1436_n N_noxref_17_c_3852_n ) capacitor c=0.0989488f \
 //x=13.305 //y=2.22 //x2=5.8 //y2=0
cc_1446 ( N_noxref_5_c_1551_n N_noxref_17_c_3852_n ) capacitor c=0.00332968f \
 //x=2.38 //y=2.22 //x2=5.8 //y2=0
cc_1447 ( N_noxref_5_c_1436_n N_noxref_17_c_3962_n ) capacitor c=0.123131f \
 //x=13.305 //y=2.22 //x2=10.61 //y2=0
cc_1448 ( N_noxref_5_c_1436_n N_noxref_17_c_3922_n ) capacitor c=0.0573255f \
 //x=13.305 //y=2.22 //x2=15.42 //y2=0
cc_1449 ( N_noxref_5_c_1469_n N_noxref_17_c_3922_n ) capacitor c=0.0614498f \
 //x=13.905 //y=2.205 //x2=15.42 //y2=0
cc_1450 ( N_noxref_5_c_1482_n N_noxref_17_c_3963_n ) capacitor c=0.00212207f \
 //x=17.76 //y=2.385 //x2=20.23 //y2=0
cc_1451 ( N_noxref_5_c_1481_n N_noxref_17_c_3963_n ) capacitor c=0.0574323f \
 //x=17.925 //y=2.22 //x2=20.23 //y2=0
cc_1452 ( N_noxref_5_c_1557_n N_noxref_17_c_3963_n ) capacitor c=0.0621895f \
 //x=21.295 //y=2.23 //x2=20.23 //y2=0
cc_1453 ( N_noxref_5_c_1530_n N_noxref_17_c_4015_n ) capacitor c=8.89344e-19 \
 //x=21.46 //y=2.39 //x2=25.04 //y2=0
cc_1454 ( N_noxref_5_c_1555_n N_noxref_17_c_4015_n ) capacitor c=0.00322656f \
 //x=21.455 //y=2.23 //x2=25.04 //y2=0
cc_1455 ( N_noxref_5_c_1557_n N_noxref_17_c_4015_n ) capacitor c=0.0202748f \
 //x=21.295 //y=2.23 //x2=25.04 //y2=0
cc_1456 ( N_noxref_5_c_1436_n N_noxref_17_c_3862_n ) capacitor c=0.00497906f \
 //x=13.305 //y=2.22 //x2=5.885 //y2=0.965
cc_1457 ( N_noxref_5_c_1436_n N_noxref_17_c_3873_n ) capacitor c=0.00492593f \
 //x=13.305 //y=2.22 //x2=10.695 //y2=0.965
cc_1458 ( N_noxref_5_c_1476_n N_noxref_17_c_3929_n ) capacitor c=0.00498173f \
 //x=15.765 //y=2.205 //x2=15.505 //y2=0.965
cc_1459 ( N_noxref_5_c_1557_n N_noxref_17_c_3973_n ) capacitor c=0.00504873f \
 //x=21.295 //y=2.23 //x2=20.315 //y2=0.965
cc_1460 ( N_noxref_5_c_1482_n N_noxref_17_c_3942_n ) capacitor c=2.47898e-19 \
 //x=17.76 //y=2.385 //x2=19.07 //y2=0
cc_1461 ( N_noxref_5_c_1436_n N_noxref_17_c_3887_n ) capacitor c=0.0219476f \
 //x=13.305 //y=2.22 //x2=4.81 //y2=0
cc_1462 ( N_noxref_5_c_1436_n N_noxref_17_c_3900_n ) capacitor c=0.0223841f \
 //x=13.305 //y=2.22 //x2=9.62 //y2=0
cc_1463 ( N_noxref_5_c_1469_n N_noxref_17_c_3943_n ) capacitor c=2.80619e-19 \
 //x=13.905 //y=2.205 //x2=14.43 //y2=0
cc_1464 ( N_noxref_5_c_1473_n N_noxref_17_c_3943_n ) capacitor c=0.0221136f \
 //x=15.165 //y=2.22 //x2=14.43 //y2=0
cc_1465 ( N_noxref_5_c_1557_n N_noxref_17_c_3994_n ) capacitor c=0.0215345f \
 //x=21.295 //y=2.23 //x2=19.24 //y2=0
cc_1466 ( N_noxref_5_c_1496_n N_noxref_17_c_3994_n ) capacitor c=0.0022223f \
 //x=17.76 //y=2.08 //x2=19.24 //y2=0
cc_1467 ( N_noxref_5_c_1642_p N_noxref_17_c_3994_n ) capacitor c=0.00262688f \
 //x=18.28 //y=1.26 //x2=19.24 //y2=0
cc_1468 ( N_noxref_5_c_1508_n N_noxref_17_c_3994_n ) capacitor c=2.63786e-19 \
 //x=17.76 //y=2.08 //x2=19.24 //y2=0
cc_1469 ( N_noxref_5_c_1720_p N_noxref_21_c_4643_n ) capacitor c=0.0167228f \
 //x=1.785 //y=0.91 //x2=2.445 //y2=0.54
cc_1470 ( N_noxref_5_c_1580_n N_noxref_21_c_4643_n ) capacitor c=0.00534519f \
 //x=2.31 //y=0.91 //x2=2.445 //y2=0.54
cc_1471 ( N_noxref_5_c_1430_n N_noxref_21_c_4645_n ) capacitor c=0.00749908f \
 //x=2.22 //y=2.38 //x2=2.445 //y2=1.59
cc_1472 ( N_noxref_5_c_1436_n N_noxref_21_c_4645_n ) capacitor c=0.00122327f \
 //x=13.305 //y=2.22 //x2=2.445 //y2=1.59
cc_1473 ( N_noxref_5_c_1561_n N_noxref_21_c_4645_n ) capacitor c=0.0105652f \
 //x=2.22 //y=2.08 //x2=2.445 //y2=1.59
cc_1474 ( N_noxref_5_c_1722_p N_noxref_21_c_4645_n ) capacitor c=0.0154024f \
 //x=1.785 //y=1.22 //x2=2.445 //y2=1.59
cc_1475 ( N_noxref_5_c_1583_n N_noxref_21_c_4645_n ) capacitor c=0.021204f \
 //x=2.31 //y=1.915 //x2=2.445 //y2=1.59
cc_1476 ( N_noxref_5_c_1436_n N_noxref_21_M0_noxref_s ) capacitor \
 c=0.00361774f //x=13.305 //y=2.22 //x2=0.455 //y2=0.375
cc_1477 ( N_noxref_5_c_1720_p N_noxref_21_M0_noxref_s ) capacitor \
 c=0.00798959f //x=1.785 //y=0.91 //x2=0.455 //y2=0.375
cc_1478 ( N_noxref_5_c_1582_n N_noxref_21_M0_noxref_s ) capacitor \
 c=0.00212176f //x=2.31 //y=1.45 //x2=0.455 //y2=0.375
cc_1479 ( N_noxref_5_c_1583_n N_noxref_21_M0_noxref_s ) capacitor \
 c=0.00298115f //x=2.31 //y=1.915 //x2=0.455 //y2=0.375
cc_1480 ( N_noxref_5_c_1436_n N_noxref_22_c_4696_n ) capacitor c=0.00444844f \
 //x=13.305 //y=2.22 //x2=5.4 //y2=1.505
cc_1481 ( N_noxref_5_c_1436_n N_noxref_22_c_4697_n ) capacitor c=0.0129686f \
 //x=13.305 //y=2.22 //x2=6.285 //y2=1.59
cc_1482 ( N_noxref_5_c_1436_n N_noxref_22_c_4710_n ) capacitor c=0.0113756f \
 //x=13.305 //y=2.22 //x2=7.255 //y2=1.59
cc_1483 ( N_noxref_5_c_1436_n N_noxref_22_M3_noxref_s ) capacitor \
 c=0.00828583f //x=13.305 //y=2.22 //x2=5.265 //y2=0.375
cc_1484 ( N_noxref_5_c_1436_n N_noxref_23_c_4754_n ) capacitor c=0.00444844f \
 //x=13.305 //y=2.22 //x2=10.21 //y2=1.505
cc_1485 ( N_noxref_5_c_1436_n N_noxref_23_c_4755_n ) capacitor c=0.0131394f \
 //x=13.305 //y=2.22 //x2=11.095 //y2=1.59
cc_1486 ( N_noxref_5_c_1436_n N_noxref_23_c_4768_n ) capacitor c=0.0118857f \
 //x=13.305 //y=2.22 //x2=12.065 //y2=1.59
cc_1487 ( N_noxref_5_c_1436_n N_noxref_23_M6_noxref_s ) capacitor \
 c=0.00841698f //x=13.305 //y=2.22 //x2=10.075 //y2=0.375
cc_1488 ( N_noxref_5_c_1473_n N_noxref_24_c_4813_n ) capacitor c=0.00444844f \
 //x=15.165 //y=2.22 //x2=15.02 //y2=1.505
cc_1489 ( N_noxref_5_c_1473_n N_noxref_24_c_4814_n ) capacitor c=0.00790942f \
 //x=15.165 //y=2.22 //x2=15.905 //y2=1.59
cc_1490 ( N_noxref_5_c_1476_n N_noxref_24_c_4814_n ) capacitor c=0.00395202f \
 //x=15.765 //y=2.205 //x2=15.905 //y2=1.59
cc_1491 ( N_noxref_5_c_1481_n N_noxref_24_c_4814_n ) capacitor c=0.00126965f \
 //x=17.925 //y=2.22 //x2=15.905 //y2=1.59
cc_1492 ( N_noxref_5_c_1481_n N_noxref_24_c_4827_n ) capacitor c=0.0113756f \
 //x=17.925 //y=2.22 //x2=16.875 //y2=1.59
cc_1493 ( N_noxref_5_c_1481_n N_noxref_24_M9_noxref_s ) capacitor \
 c=0.00828583f //x=17.925 //y=2.22 //x2=14.885 //y2=0.375
cc_1494 ( N_noxref_5_c_1557_n N_noxref_25_c_4873_n ) capacitor c=0.00444844f \
 //x=21.295 //y=2.23 //x2=19.83 //y2=1.505
cc_1495 ( N_noxref_5_c_1557_n N_noxref_25_c_4874_n ) capacitor c=0.0131507f \
 //x=21.295 //y=2.23 //x2=20.715 //y2=1.59
cc_1496 ( N_noxref_5_c_1588_n N_noxref_25_c_4887_n ) capacitor c=0.0167228f \
 //x=21.025 //y=0.91 //x2=21.685 //y2=0.54
cc_1497 ( N_noxref_5_c_1593_n N_noxref_25_c_4887_n ) capacitor c=0.00534519f \
 //x=21.55 //y=0.91 //x2=21.685 //y2=0.54
cc_1498 ( N_noxref_5_c_1530_n N_noxref_25_c_4889_n ) capacitor c=0.00747132f \
 //x=21.46 //y=2.39 //x2=21.685 //y2=1.59
cc_1499 ( N_noxref_5_c_1557_n N_noxref_25_c_4889_n ) capacitor c=0.00812797f \
 //x=21.295 //y=2.23 //x2=21.685 //y2=1.59
cc_1500 ( N_noxref_5_c_1567_n N_noxref_25_c_4889_n ) capacitor c=0.0105652f \
 //x=21.46 //y=2.08 //x2=21.685 //y2=1.59
cc_1501 ( N_noxref_5_c_1591_n N_noxref_25_c_4889_n ) capacitor c=0.0154134f \
 //x=21.025 //y=1.22 //x2=21.685 //y2=1.59
cc_1502 ( N_noxref_5_c_1596_n N_noxref_25_c_4889_n ) capacitor c=0.0196098f \
 //x=21.55 //y=1.915 //x2=21.685 //y2=1.59
cc_1503 ( N_noxref_5_c_1557_n N_noxref_25_M12_noxref_s ) capacitor \
 c=0.00444844f //x=21.295 //y=2.23 //x2=19.695 //y2=0.375
cc_1504 ( N_noxref_5_c_1588_n N_noxref_25_M12_noxref_s ) capacitor \
 c=0.00798959f //x=21.025 //y=0.91 //x2=19.695 //y2=0.375
cc_1505 ( N_noxref_5_c_1595_n N_noxref_25_M12_noxref_s ) capacitor \
 c=0.00212176f //x=21.55 //y=1.45 //x2=19.695 //y2=0.375
cc_1506 ( N_noxref_5_c_1596_n N_noxref_25_M12_noxref_s ) capacitor \
 c=0.00298115f //x=21.55 //y=1.915 //x2=19.695 //y2=0.375
cc_1507 ( N_noxref_6_c_1904_n N_noxref_7_c_2248_n ) capacitor c=0.00934497f \
 //x=11.84 //y=2.195 //x2=12.95 //y2=2.195
cc_1508 ( N_noxref_6_c_1920_n N_noxref_7_c_2248_n ) capacitor c=5.39999e-19 \
 //x=11.84 //y=2.08 //x2=12.95 //y2=2.195
cc_1509 ( N_noxref_6_c_1939_n N_noxref_7_c_2248_n ) capacitor c=0.00137098f \
 //x=11.93 //y=1.915 //x2=12.95 //y2=2.195
cc_1510 ( N_noxref_6_c_1907_n N_noxref_7_c_2243_n ) capacitor c=0.0141637f \
 //x=11.84 //y=2.785 //x2=12.95 //y2=3.555
cc_1511 ( N_noxref_6_c_1913_n N_noxref_7_c_2243_n ) capacitor c=0.00786461f \
 //x=11.84 //y=3.105 //x2=12.95 //y2=3.555
cc_1512 ( N_noxref_6_c_1914_n N_noxref_7_c_2243_n ) capacitor c=0.0110327f \
 //x=11.84 //y=4.585 //x2=12.95 //y2=3.555
cc_1513 ( N_noxref_6_c_1918_n N_noxref_7_c_2243_n ) capacitor c=5.01652e-19 \
 //x=11.84 //y=2.96 //x2=12.95 //y2=3.555
cc_1514 ( N_noxref_6_c_1954_n N_noxref_7_c_2243_n ) capacitor c=0.0242609f \
 //x=13.305 //y=2.96 //x2=12.95 //y2=3.555
cc_1515 ( N_noxref_6_c_1919_n N_noxref_7_c_2243_n ) capacitor c=0.00237766f \
 //x=12 //y=2.945 //x2=12.95 //y2=3.555
cc_1516 ( N_noxref_6_c_1920_n N_noxref_7_c_2243_n ) capacitor c=3.9149e-19 \
 //x=11.84 //y=2.08 //x2=12.95 //y2=3.555
cc_1517 ( N_noxref_6_c_1914_n N_noxref_7_c_2256_n ) capacitor c=0.0078001f \
 //x=11.84 //y=4.585 //x2=12.95 //y2=3.875
cc_1518 ( N_noxref_6_c_1914_n N_noxref_7_c_2245_n ) capacitor c=0.0291007f \
 //x=11.84 //y=4.585 //x2=12.95 //y2=4.57
cc_1519 ( N_noxref_6_c_1924_n N_noxref_7_c_2245_n ) capacitor c=9.52396e-19 \
 //x=11.84 //y=4.7 //x2=12.95 //y2=4.57
cc_1520 ( N_noxref_6_c_1942_n N_noxref_7_c_2245_n ) capacitor c=8.42568e-19 \
 //x=11.84 //y=4.7 //x2=12.95 //y2=4.57
cc_1521 ( N_noxref_6_c_1979_n N_noxref_7_c_2333_n ) capacitor c=0.0261576f \
 //x=19.96 //y=2.96 //x2=18.5 //y2=3.555
cc_1522 ( N_noxref_6_c_2028_p N_noxref_7_c_2532_n ) capacitor c=0.0116288f \
 //x=26.27 //y=2.195 //x2=27.38 //y2=2.195
cc_1523 ( N_noxref_6_c_2029_p N_noxref_7_c_2532_n ) capacitor c=5.39999e-19 \
 //x=26.27 //y=2.08 //x2=27.38 //y2=2.195
cc_1524 ( N_noxref_6_c_2030_p N_noxref_7_c_2532_n ) capacitor c=0.00141236f \
 //x=26.36 //y=1.915 //x2=27.38 //y2=2.195
cc_1525 ( N_noxref_6_c_2031_p N_noxref_7_c_2535_n ) capacitor c=0.016879f \
 //x=26.27 //y=2.805 //x2=27.38 //y2=3.545
cc_1526 ( N_noxref_6_c_2032_p N_noxref_7_c_2535_n ) capacitor c=0.00775314f \
 //x=26.27 //y=3.125 //x2=27.38 //y2=3.545
cc_1527 ( N_noxref_6_c_2033_p N_noxref_7_c_2535_n ) capacitor c=0.0138441f \
 //x=26.27 //y=4.585 //x2=27.38 //y2=3.545
cc_1528 ( N_noxref_6_c_2034_p N_noxref_7_c_2535_n ) capacitor c=3.43503e-19 \
 //x=26.27 //y=2.96 //x2=27.38 //y2=3.545
cc_1529 ( N_noxref_6_c_1991_n N_noxref_7_c_2535_n ) capacitor c=0.00508119f \
 //x=20.56 //y=2.945 //x2=27.38 //y2=3.545
cc_1530 ( N_noxref_6_c_2029_p N_noxref_7_c_2535_n ) capacitor c=4.16726e-19 \
 //x=26.27 //y=2.08 //x2=27.38 //y2=3.545
cc_1531 ( N_noxref_6_c_2033_p N_noxref_7_c_2541_n ) capacitor c=0.00772613f \
 //x=26.27 //y=4.585 //x2=27.38 //y2=3.865
cc_1532 ( N_noxref_6_c_2033_p N_noxref_7_c_2542_n ) capacitor c=0.0320186f \
 //x=26.27 //y=4.585 //x2=27.38 //y2=4.57
cc_1533 ( N_noxref_6_c_2039_p N_noxref_7_c_2542_n ) capacitor c=9.52396e-19 \
 //x=26.27 //y=4.7 //x2=27.38 //y2=4.57
cc_1534 ( N_noxref_6_c_2040_p N_noxref_7_c_2542_n ) capacitor c=8.42568e-19 \
 //x=26.27 //y=4.7 //x2=27.38 //y2=4.57
cc_1535 ( N_noxref_6_c_1914_n N_noxref_7_c_2266_n ) capacitor c=5.01652e-19 \
 //x=11.84 //y=4.585 //x2=12.95 //y2=3.7
cc_1536 ( N_noxref_6_c_2033_p N_noxref_7_c_2546_n ) capacitor c=3.43503e-19 \
 //x=26.27 //y=4.585 //x2=27.38 //y2=3.7
cc_1537 ( N_noxref_6_c_1954_n N_noxref_7_c_2272_n ) capacitor c=0.00665426f \
 //x=13.305 //y=2.96 //x2=18.33 //y2=3.7
cc_1538 ( N_noxref_6_c_1957_n N_noxref_7_c_2272_n ) capacitor c=0.00885794f \
 //x=13.905 //y=2.975 //x2=18.33 //y2=3.7
cc_1539 ( N_noxref_6_c_1960_n N_noxref_7_c_2272_n ) capacitor c=0.00346831f \
 //x=15.165 //y=2.96 //x2=18.33 //y2=3.7
cc_1540 ( N_noxref_6_c_1964_n N_noxref_7_c_2272_n ) capacitor c=0.0210577f \
 //x=15.765 //y=2.975 //x2=18.33 //y2=3.7
cc_1541 ( N_noxref_6_c_2032_p N_noxref_7_c_2405_n ) capacitor c=0.00337062f \
 //x=26.27 //y=3.125 //x2=20.56 //y2=3.715
cc_1542 ( N_noxref_6_c_2033_p N_noxref_7_c_2405_n ) capacitor c=0.0342606f \
 //x=26.27 //y=4.585 //x2=20.56 //y2=3.715
cc_1543 ( N_noxref_6_c_1991_n N_noxref_7_c_2405_n ) capacitor c=0.271438f \
 //x=20.56 //y=2.945 //x2=20.56 //y2=3.715
cc_1544 ( N_noxref_6_c_1979_n N_noxref_7_c_2407_n ) capacitor c=0.0138894f \
 //x=19.96 //y=2.96 //x2=20.215 //y2=3.715
cc_1545 ( N_noxref_6_c_1914_n N_noxref_7_c_2246_n ) capacitor c=0.025571f \
 //x=11.84 //y=4.585 //x2=12.79 //y2=3.715
cc_1546 ( N_noxref_6_c_1954_n N_noxref_7_c_2246_n ) capacitor c=0.00595018f \
 //x=13.305 //y=2.96 //x2=12.79 //y2=3.715
cc_1547 ( N_noxref_6_c_1914_n N_noxref_7_c_2274_n ) capacitor c=0.0024779f \
 //x=11.84 //y=4.585 //x2=13.11 //y2=3.715
cc_1548 ( N_noxref_6_c_1904_n N_noxref_7_c_2275_n ) capacitor c=5.42289e-19 \
 //x=11.84 //y=2.195 //x2=12.95 //y2=2.08
cc_1549 ( N_noxref_6_c_1907_n N_noxref_7_c_2275_n ) capacitor c=3.9149e-19 \
 //x=11.84 //y=2.785 //x2=12.95 //y2=2.08
cc_1550 ( N_noxref_6_c_1920_n N_noxref_7_c_2275_n ) capacitor c=0.00125213f \
 //x=11.84 //y=2.08 //x2=12.95 //y2=2.08
cc_1551 ( N_noxref_6_c_1939_n N_noxref_7_c_2275_n ) capacitor c=0.00209664f \
 //x=11.93 //y=1.915 //x2=12.95 //y2=2.08
cc_1552 ( N_noxref_6_c_1914_n N_noxref_7_c_2276_n ) capacitor c=7.51101e-19 \
 //x=11.84 //y=4.585 //x2=12.95 //y2=4.7
cc_1553 ( N_noxref_6_c_1924_n N_noxref_7_c_2276_n ) capacitor c=0.00113985f \
 //x=11.84 //y=4.7 //x2=12.95 //y2=4.7
cc_1554 ( N_noxref_6_c_1942_n N_noxref_7_c_2276_n ) capacitor c=0.00129812f \
 //x=11.84 //y=4.7 //x2=12.95 //y2=4.7
cc_1555 ( N_noxref_6_c_2028_p N_noxref_7_c_2565_n ) capacitor c=5.42289e-19 \
 //x=26.27 //y=2.195 //x2=27.38 //y2=2.08
cc_1556 ( N_noxref_6_c_2031_p N_noxref_7_c_2565_n ) capacitor c=4.16726e-19 \
 //x=26.27 //y=2.805 //x2=27.38 //y2=2.08
cc_1557 ( N_noxref_6_c_2029_p N_noxref_7_c_2565_n ) capacitor c=0.00125213f \
 //x=26.27 //y=2.08 //x2=27.38 //y2=2.08
cc_1558 ( N_noxref_6_c_2030_p N_noxref_7_c_2565_n ) capacitor c=0.00209664f \
 //x=26.36 //y=1.915 //x2=27.38 //y2=2.08
cc_1559 ( N_noxref_6_c_2033_p N_noxref_7_c_2569_n ) capacitor c=7.51101e-19 \
 //x=26.27 //y=4.585 //x2=27.38 //y2=4.7
cc_1560 ( N_noxref_6_c_2039_p N_noxref_7_c_2569_n ) capacitor c=0.00113985f \
 //x=26.27 //y=4.7 //x2=27.38 //y2=4.7
cc_1561 ( N_noxref_6_c_2040_p N_noxref_7_c_2569_n ) capacitor c=0.00129812f \
 //x=26.27 //y=4.7 //x2=27.38 //y2=4.7
cc_1562 ( N_noxref_6_M32_noxref_g N_noxref_7_M34_noxref_g ) capacitor \
 c=0.0101598f //x=11.81 //y=6.02 //x2=12.69 //y2=6.02
cc_1563 ( N_noxref_6_M33_noxref_g N_noxref_7_M34_noxref_g ) capacitor \
 c=0.0607518f //x=12.25 //y=6.02 //x2=12.69 //y2=6.02
cc_1564 ( N_noxref_6_M33_noxref_g N_noxref_7_M35_noxref_g ) capacitor \
 c=0.0101598f //x=12.25 //y=6.02 //x2=13.13 //y2=6.02
cc_1565 ( N_noxref_6_M50_noxref_g N_noxref_7_M52_noxref_g ) capacitor \
 c=0.0101598f //x=26.24 //y=6.02 //x2=27.12 //y2=6.02
cc_1566 ( N_noxref_6_M51_noxref_g N_noxref_7_M52_noxref_g ) capacitor \
 c=0.0607518f //x=26.68 //y=6.02 //x2=27.12 //y2=6.02
cc_1567 ( N_noxref_6_M51_noxref_g N_noxref_7_M53_noxref_g ) capacitor \
 c=0.0101598f //x=26.68 //y=6.02 //x2=27.56 //y2=6.02
cc_1568 ( N_noxref_6_c_1936_n N_noxref_7_c_2289_n ) capacitor c=0.00456962f \
 //x=11.93 //y=0.91 //x2=12.94 //y2=0.915
cc_1569 ( N_noxref_6_c_1937_n N_noxref_7_c_2291_n ) capacitor c=0.00438372f \
 //x=11.93 //y=1.22 //x2=12.94 //y2=1.26
cc_1570 ( N_noxref_6_c_1938_n N_noxref_7_c_2294_n ) capacitor c=0.00438372f \
 //x=11.93 //y=1.45 //x2=12.94 //y2=1.57
cc_1571 ( N_noxref_6_c_2077_p N_noxref_7_c_2581_n ) capacitor c=0.00456962f \
 //x=26.36 //y=0.91 //x2=27.37 //y2=0.915
cc_1572 ( N_noxref_6_c_2078_p N_noxref_7_c_2582_n ) capacitor c=0.00438372f \
 //x=26.36 //y=1.22 //x2=27.37 //y2=1.26
cc_1573 ( N_noxref_6_c_2079_p N_noxref_7_c_2583_n ) capacitor c=0.00438372f \
 //x=26.36 //y=1.45 //x2=27.37 //y2=1.57
cc_1574 ( N_noxref_6_c_1904_n N_noxref_7_c_2307_n ) capacitor c=0.00134951f \
 //x=11.84 //y=2.195 //x2=12.95 //y2=2.08
cc_1575 ( N_noxref_6_c_1920_n N_noxref_7_c_2307_n ) capacitor c=0.00204868f \
 //x=11.84 //y=2.08 //x2=12.95 //y2=2.08
cc_1576 ( N_noxref_6_c_1939_n N_noxref_7_c_2307_n ) capacitor c=0.00933826f \
 //x=11.93 //y=1.915 //x2=12.95 //y2=2.08
cc_1577 ( N_noxref_6_c_1939_n N_noxref_7_c_2308_n ) capacitor c=0.00438372f \
 //x=11.93 //y=1.915 //x2=12.95 //y2=1.915
cc_1578 ( N_noxref_6_c_1914_n N_noxref_7_c_2310_n ) capacitor c=0.00124604f \
 //x=11.84 //y=4.585 //x2=12.95 //y2=4.7
cc_1579 ( N_noxref_6_c_1924_n N_noxref_7_c_2310_n ) capacitor c=0.00187046f \
 //x=11.84 //y=4.7 //x2=12.95 //y2=4.7
cc_1580 ( N_noxref_6_c_1974_n N_noxref_7_c_2310_n ) capacitor c=0.0616777f \
 //x=12.175 //y=4.79 //x2=12.95 //y2=4.7
cc_1581 ( N_noxref_6_c_1942_n N_noxref_7_c_2310_n ) capacitor c=0.00487508f \
 //x=11.84 //y=4.7 //x2=12.95 //y2=4.7
cc_1582 ( N_noxref_6_c_2028_p N_noxref_7_c_2592_n ) capacitor c=0.00139071f \
 //x=26.27 //y=2.195 //x2=27.38 //y2=2.08
cc_1583 ( N_noxref_6_c_2029_p N_noxref_7_c_2592_n ) capacitor c=0.00204868f \
 //x=26.27 //y=2.08 //x2=27.38 //y2=2.08
cc_1584 ( N_noxref_6_c_2030_p N_noxref_7_c_2592_n ) capacitor c=0.00933826f \
 //x=26.36 //y=1.915 //x2=27.38 //y2=2.08
cc_1585 ( N_noxref_6_c_2030_p N_noxref_7_c_2595_n ) capacitor c=0.00438372f \
 //x=26.36 //y=1.915 //x2=27.38 //y2=1.915
cc_1586 ( N_noxref_6_c_2033_p N_noxref_7_c_2596_n ) capacitor c=0.00124604f \
 //x=26.27 //y=4.585 //x2=27.38 //y2=4.7
cc_1587 ( N_noxref_6_c_2039_p N_noxref_7_c_2596_n ) capacitor c=0.00187046f \
 //x=26.27 //y=4.7 //x2=27.38 //y2=4.7
cc_1588 ( N_noxref_6_c_2094_p N_noxref_7_c_2596_n ) capacitor c=0.0616777f \
 //x=26.605 //y=4.79 //x2=27.38 //y2=4.7
cc_1589 ( N_noxref_6_c_2040_p N_noxref_7_c_2596_n ) capacitor c=0.00487508f \
 //x=26.27 //y=4.7 //x2=27.38 //y2=4.7
cc_1590 ( N_noxref_6_M32_noxref_g N_noxref_8_c_2868_n ) capacitor \
 c=0.00700336f //x=11.81 //y=6.02 //x2=12.385 //y2=7.4
cc_1591 ( N_noxref_6_M33_noxref_g N_noxref_8_c_2868_n ) capacitor \
 c=0.00749619f //x=12.25 //y=6.02 //x2=12.385 //y2=7.4
cc_1592 ( N_noxref_6_M50_noxref_g N_noxref_8_c_2996_n ) capacitor \
 c=0.00700336f //x=26.24 //y=6.02 //x2=26.815 //y2=7.4
cc_1593 ( N_noxref_6_M51_noxref_g N_noxref_8_c_2996_n ) capacitor \
 c=0.00749619f //x=26.68 //y=6.02 //x2=26.815 //y2=7.4
cc_1594 ( N_noxref_6_M32_noxref_g N_noxref_8_M31_noxref_d ) capacitor \
 c=0.015318f //x=11.81 //y=6.02 //x2=11.445 //y2=5.02
cc_1595 ( N_noxref_6_M33_noxref_g N_noxref_8_M33_noxref_d ) capacitor \
 c=0.015318f //x=12.25 //y=6.02 //x2=12.325 //y2=5.02
cc_1596 ( N_noxref_6_M50_noxref_g N_noxref_8_M49_noxref_d ) capacitor \
 c=0.015318f //x=26.24 //y=6.02 //x2=25.875 //y2=5.02
cc_1597 ( N_noxref_6_M51_noxref_g N_noxref_8_M51_noxref_d ) capacitor \
 c=0.015318f //x=26.68 //y=6.02 //x2=26.755 //y2=5.02
cc_1598 ( N_noxref_6_c_1936_n N_noxref_12_c_3422_n ) capacitor c=0.00123426f \
 //x=11.93 //y=0.91 //x2=12.635 //y2=0.995
cc_1599 ( N_noxref_6_c_1937_n N_noxref_12_c_3422_n ) capacitor c=0.0129288f \
 //x=11.93 //y=1.22 //x2=12.635 //y2=0.995
cc_1600 ( N_noxref_6_c_1938_n N_noxref_12_c_3422_n ) capacitor c=0.00132209f \
 //x=11.93 //y=1.45 //x2=12.635 //y2=0.995
cc_1601 ( N_noxref_6_c_1904_n N_noxref_12_M7_noxref_d ) capacitor \
 c=0.00600656f //x=11.84 //y=2.195 //x2=11.48 //y2=0.91
cc_1602 ( N_noxref_6_c_1920_n N_noxref_12_M7_noxref_d ) capacitor c=2.2052e-19 \
 //x=11.84 //y=2.08 //x2=11.48 //y2=0.91
cc_1603 ( N_noxref_6_c_1931_n N_noxref_12_M7_noxref_d ) capacitor \
 c=0.00253592f //x=11.405 //y=0.91 //x2=11.48 //y2=0.91
cc_1604 ( N_noxref_6_c_1934_n N_noxref_12_M7_noxref_d ) capacitor \
 c=0.00604087f //x=11.405 //y=1.22 //x2=11.48 //y2=0.91
cc_1605 ( N_noxref_6_c_2111_p N_noxref_12_M7_noxref_d ) capacitor c=0.002686f \
 //x=11.775 //y=0.755 //x2=11.48 //y2=0.91
cc_1606 ( N_noxref_6_c_2112_p N_noxref_12_M7_noxref_d ) capacitor \
 c=0.00251995f //x=11.775 //y=1.375 //x2=11.48 //y2=0.91
cc_1607 ( N_noxref_6_c_1936_n N_noxref_12_M7_noxref_d ) capacitor \
 c=0.00314523f //x=11.93 //y=0.91 //x2=11.48 //y2=0.91
cc_1608 ( N_noxref_6_c_1937_n N_noxref_12_M7_noxref_d ) capacitor \
 c=0.00168289f //x=11.93 //y=1.22 //x2=11.48 //y2=0.91
cc_1609 ( N_noxref_6_c_1938_n N_noxref_12_M7_noxref_d ) capacitor \
 c=0.00111165f //x=11.93 //y=1.45 //x2=11.48 //y2=0.91
cc_1610 ( N_noxref_6_c_1936_n N_noxref_12_M8_noxref_s ) capacitor \
 c=7.21316e-19 //x=11.93 //y=0.91 //x2=12.585 //y2=0.375
cc_1611 ( N_noxref_6_c_1937_n N_noxref_12_M8_noxref_s ) capacitor \
 c=0.00365271f //x=11.93 //y=1.22 //x2=12.585 //y2=0.375
cc_1612 ( N_noxref_6_c_1939_n N_noxref_12_M8_noxref_s ) capacitor \
 c=9.86711e-19 //x=11.93 //y=1.915 //x2=12.585 //y2=0.375
cc_1613 ( N_noxref_6_c_1991_n N_noxref_14_c_3551_n ) capacitor c=0.00449472f \
 //x=20.56 //y=2.945 //x2=22.255 //y2=0.995
cc_1614 ( N_noxref_6_c_1991_n N_noxref_14_M14_noxref_s ) capacitor \
 c=0.00319011f //x=20.56 //y=2.945 //x2=22.205 //y2=0.375
cc_1615 ( N_noxref_6_c_1991_n N_noxref_15_c_3622_n ) capacitor c=0.00286342f \
 //x=20.56 //y=2.945 //x2=22.57 //y2=2.195
cc_1616 ( N_noxref_6_c_1991_n N_noxref_15_c_3620_n ) capacitor c=0.0291182f \
 //x=20.56 //y=2.945 //x2=22.57 //y2=4.57
cc_1617 ( N_noxref_6_c_1991_n N_noxref_16_c_3738_n ) capacitor c=4.64045e-19 \
 //x=20.56 //y=2.945 //x2=22.825 //y2=1.125
cc_1618 ( N_noxref_6_c_1991_n N_noxref_16_c_3739_n ) capacitor c=0.0107016f \
 //x=20.56 //y=2.945 //x2=22.91 //y2=1.665
cc_1619 ( N_noxref_6_c_2031_p N_noxref_16_c_3727_n ) capacitor c=0.00134254f \
 //x=26.27 //y=2.805 //x2=23.31 //y2=5.07
cc_1620 ( N_noxref_6_c_2033_p N_noxref_16_c_3727_n ) capacitor c=0.00167116f \
 //x=26.27 //y=4.585 //x2=23.31 //y2=5.07
cc_1621 ( N_noxref_6_c_1991_n N_noxref_16_c_3727_n ) capacitor c=0.0315797f \
 //x=20.56 //y=2.945 //x2=23.31 //y2=5.07
cc_1622 ( N_noxref_6_c_1904_n N_noxref_17_c_3922_n ) capacitor c=7.98245e-19 \
 //x=11.84 //y=2.195 //x2=15.42 //y2=0
cc_1623 ( N_noxref_6_c_1913_n N_noxref_17_c_3922_n ) capacitor c=2.08133e-19 \
 //x=11.84 //y=3.105 //x2=15.42 //y2=0
cc_1624 ( N_noxref_6_c_2028_p N_noxref_17_c_4033_n ) capacitor c=9.14667e-19 \
 //x=26.27 //y=2.195 //x2=28.12 //y2=0
cc_1625 ( N_noxref_6_c_1991_n N_noxref_17_c_4034_n ) capacitor c=0.00286195f \
 //x=20.56 //y=2.945 //x2=25.125 //y2=0.965
cc_1626 ( N_noxref_6_c_1960_n N_noxref_17_c_3943_n ) capacitor c=0.00411791f \
 //x=15.165 //y=2.96 //x2=14.43 //y2=0
cc_1627 ( N_noxref_6_c_1979_n N_noxref_17_c_3994_n ) capacitor c=0.00504378f \
 //x=19.96 //y=2.96 //x2=19.24 //y2=0
cc_1628 ( N_noxref_6_c_1991_n N_noxref_17_c_4037_n ) capacitor c=0.00725422f \
 //x=20.56 //y=2.945 //x2=24.05 //y2=0
cc_1629 ( N_noxref_6_c_2028_p N_noxref_18_c_4352_n ) capacitor c=0.0115546f \
 //x=26.27 //y=2.195 //x2=25.16 //y2=2.195
cc_1630 ( N_noxref_6_c_1991_n N_noxref_18_c_4352_n ) capacitor c=0.00279788f \
 //x=20.56 //y=2.945 //x2=25.16 //y2=2.195
cc_1631 ( N_noxref_6_c_2029_p N_noxref_18_c_4352_n ) capacitor c=5.39999e-19 \
 //x=26.27 //y=2.08 //x2=25.16 //y2=2.195
cc_1632 ( N_noxref_6_c_2030_p N_noxref_18_c_4352_n ) capacitor c=0.00140534f \
 //x=26.36 //y=1.915 //x2=25.16 //y2=2.195
cc_1633 ( N_noxref_6_c_2031_p N_noxref_18_c_4356_n ) capacitor c=0.0181296f \
 //x=26.27 //y=2.805 //x2=25.16 //y2=4.575
cc_1634 ( N_noxref_6_c_2032_p N_noxref_18_c_4356_n ) capacitor c=0.00772613f \
 //x=26.27 //y=3.125 //x2=25.16 //y2=4.575
cc_1635 ( N_noxref_6_c_2033_p N_noxref_18_c_4356_n ) capacitor c=0.0539231f \
 //x=26.27 //y=4.585 //x2=25.16 //y2=4.575
cc_1636 ( N_noxref_6_c_2034_p N_noxref_18_c_4356_n ) capacitor c=3.43503e-19 \
 //x=26.27 //y=2.96 //x2=25.16 //y2=4.575
cc_1637 ( N_noxref_6_c_1991_n N_noxref_18_c_4356_n ) capacitor c=0.0336134f \
 //x=20.56 //y=2.945 //x2=25.16 //y2=4.575
cc_1638 ( N_noxref_6_c_2029_p N_noxref_18_c_4356_n ) capacitor c=4.16726e-19 \
 //x=26.27 //y=2.08 //x2=25.16 //y2=4.575
cc_1639 ( N_noxref_6_c_2039_p N_noxref_18_c_4356_n ) capacitor c=0.00103399f \
 //x=26.27 //y=4.7 //x2=25.16 //y2=4.575
cc_1640 ( N_noxref_6_c_2040_p N_noxref_18_c_4356_n ) capacitor c=0.00116212f \
 //x=26.27 //y=4.7 //x2=25.16 //y2=4.575
cc_1641 ( N_noxref_6_c_2028_p N_noxref_18_c_4364_n ) capacitor c=5.40058e-19 \
 //x=26.27 //y=2.195 //x2=25.16 //y2=2.08
cc_1642 ( N_noxref_6_c_2031_p N_noxref_18_c_4364_n ) capacitor c=4.16726e-19 \
 //x=26.27 //y=2.805 //x2=25.16 //y2=2.08
cc_1643 ( N_noxref_6_c_2029_p N_noxref_18_c_4364_n ) capacitor c=0.00125213f \
 //x=26.27 //y=2.08 //x2=25.16 //y2=2.08
cc_1644 ( N_noxref_6_c_2030_p N_noxref_18_c_4364_n ) capacitor c=0.0020754f \
 //x=26.36 //y=1.915 //x2=25.16 //y2=2.08
cc_1645 ( N_noxref_6_c_2033_p N_noxref_18_c_4368_n ) capacitor c=6.26008e-19 \
 //x=26.27 //y=4.585 //x2=25.16 //y2=4.7
cc_1646 ( N_noxref_6_c_2039_p N_noxref_18_c_4368_n ) capacitor c=0.00113984f \
 //x=26.27 //y=4.7 //x2=25.16 //y2=4.7
cc_1647 ( N_noxref_6_c_2040_p N_noxref_18_c_4368_n ) capacitor c=0.00155973f \
 //x=26.27 //y=4.7 //x2=25.16 //y2=4.7
cc_1648 ( N_noxref_6_M50_noxref_g N_noxref_18_M48_noxref_g ) capacitor \
 c=0.0106276f //x=26.24 //y=6.02 //x2=25.36 //y2=6.02
cc_1649 ( N_noxref_6_M50_noxref_g N_noxref_18_M49_noxref_g ) capacitor \
 c=0.107144f //x=26.24 //y=6.02 //x2=25.8 //y2=6.02
cc_1650 ( N_noxref_6_M51_noxref_g N_noxref_18_M49_noxref_g ) capacitor \
 c=0.0101598f //x=26.68 //y=6.02 //x2=25.8 //y2=6.02
cc_1651 ( N_noxref_6_c_2157_p N_noxref_18_c_4374_n ) capacitor c=5.72528e-19 \
 //x=25.835 //y=0.91 //x2=24.86 //y2=0.875
cc_1652 ( N_noxref_6_c_2157_p N_noxref_18_c_4375_n ) capacitor c=0.00150277f \
 //x=25.835 //y=0.91 //x2=24.86 //y2=1.22
cc_1653 ( N_noxref_6_c_2159_p N_noxref_18_c_4376_n ) capacitor c=0.00111227f \
 //x=25.835 //y=1.22 //x2=24.86 //y2=1.53
cc_1654 ( N_noxref_6_c_2028_p N_noxref_18_c_4377_n ) capacitor c=0.00147006f \
 //x=26.27 //y=2.195 //x2=24.86 //y2=1.915
cc_1655 ( N_noxref_6_c_2029_p N_noxref_18_c_4377_n ) capacitor c=0.00214573f \
 //x=26.27 //y=2.08 //x2=24.86 //y2=1.915
cc_1656 ( N_noxref_6_c_2030_p N_noxref_18_c_4377_n ) capacitor c=0.00964411f \
 //x=26.36 //y=1.915 //x2=24.86 //y2=1.915
cc_1657 ( N_noxref_6_c_2157_p N_noxref_18_c_4380_n ) capacitor c=0.0160123f \
 //x=25.835 //y=0.91 //x2=25.39 //y2=0.875
cc_1658 ( N_noxref_6_c_2077_p N_noxref_18_c_4380_n ) capacitor c=9.19165e-19 \
 //x=26.36 //y=0.91 //x2=25.39 //y2=0.875
cc_1659 ( N_noxref_6_c_2159_p N_noxref_18_c_4382_n ) capacitor c=0.0124075f \
 //x=25.835 //y=1.22 //x2=25.39 //y2=1.22
cc_1660 ( N_noxref_6_c_2078_p N_noxref_18_c_4382_n ) capacitor c=0.0010154f \
 //x=26.36 //y=1.22 //x2=25.39 //y2=1.22
cc_1661 ( N_noxref_6_c_2079_p N_noxref_18_c_4382_n ) capacitor c=9.23422e-19 \
 //x=26.36 //y=1.45 //x2=25.39 //y2=1.22
cc_1662 ( N_noxref_6_c_2033_p N_noxref_18_c_4385_n ) capacitor c=7.66769e-19 \
 //x=26.27 //y=4.585 //x2=25.725 //y2=4.79
cc_1663 ( N_noxref_6_c_2039_p N_noxref_18_c_4385_n ) capacitor c=0.00116563f \
 //x=26.27 //y=4.7 //x2=25.725 //y2=4.79
cc_1664 ( N_noxref_6_c_2040_p N_noxref_18_c_4385_n ) capacitor c=0.0171374f \
 //x=26.27 //y=4.7 //x2=25.725 //y2=4.79
cc_1665 ( N_noxref_6_c_2033_p N_noxref_18_c_4388_n ) capacitor c=7.54501e-19 \
 //x=26.27 //y=4.585 //x2=25.435 //y2=4.79
cc_1666 ( N_noxref_6_c_2039_p N_noxref_18_c_4388_n ) capacitor c=0.00129812f \
 //x=26.27 //y=4.7 //x2=25.435 //y2=4.79
cc_1667 ( N_noxref_6_c_2040_p N_noxref_18_c_4388_n ) capacitor c=0.00484466f \
 //x=26.27 //y=4.7 //x2=25.435 //y2=4.79
cc_1668 ( N_noxref_6_c_2077_p N_noxref_19_c_4451_n ) capacitor c=0.00123426f \
 //x=26.36 //y=0.91 //x2=27.065 //y2=0.995
cc_1669 ( N_noxref_6_c_2078_p N_noxref_19_c_4451_n ) capacitor c=0.0129288f \
 //x=26.36 //y=1.22 //x2=27.065 //y2=0.995
cc_1670 ( N_noxref_6_c_2079_p N_noxref_19_c_4451_n ) capacitor c=0.00132209f \
 //x=26.36 //y=1.45 //x2=27.065 //y2=0.995
cc_1671 ( N_noxref_6_c_2028_p N_noxref_19_M16_noxref_d ) capacitor \
 c=0.0060598f //x=26.27 //y=2.195 //x2=25.91 //y2=0.91
cc_1672 ( N_noxref_6_c_2032_p N_noxref_19_M16_noxref_d ) capacitor \
 c=5.60946e-19 //x=26.27 //y=3.125 //x2=25.91 //y2=0.91
cc_1673 ( N_noxref_6_c_1991_n N_noxref_19_M16_noxref_d ) capacitor \
 c=0.00346347f //x=20.56 //y=2.945 //x2=25.91 //y2=0.91
cc_1674 ( N_noxref_6_c_2029_p N_noxref_19_M16_noxref_d ) capacitor \
 c=2.2052e-19 //x=26.27 //y=2.08 //x2=25.91 //y2=0.91
cc_1675 ( N_noxref_6_c_2157_p N_noxref_19_M16_noxref_d ) capacitor \
 c=0.00253592f //x=25.835 //y=0.91 //x2=25.91 //y2=0.91
cc_1676 ( N_noxref_6_c_2159_p N_noxref_19_M16_noxref_d ) capacitor \
 c=0.00604087f //x=25.835 //y=1.22 //x2=25.91 //y2=0.91
cc_1677 ( N_noxref_6_c_2183_p N_noxref_19_M16_noxref_d ) capacitor c=0.002686f \
 //x=26.205 //y=0.755 //x2=25.91 //y2=0.91
cc_1678 ( N_noxref_6_c_2184_p N_noxref_19_M16_noxref_d ) capacitor \
 c=0.00249146f //x=26.205 //y=1.375 //x2=25.91 //y2=0.91
cc_1679 ( N_noxref_6_c_2077_p N_noxref_19_M16_noxref_d ) capacitor \
 c=0.00314523f //x=26.36 //y=0.91 //x2=25.91 //y2=0.91
cc_1680 ( N_noxref_6_c_2078_p N_noxref_19_M16_noxref_d ) capacitor \
 c=0.00168289f //x=26.36 //y=1.22 //x2=25.91 //y2=0.91
cc_1681 ( N_noxref_6_c_2079_p N_noxref_19_M16_noxref_d ) capacitor \
 c=0.00111165f //x=26.36 //y=1.45 //x2=25.91 //y2=0.91
cc_1682 ( N_noxref_6_c_2077_p N_noxref_19_M17_noxref_s ) capacitor \
 c=7.21316e-19 //x=26.36 //y=0.91 //x2=27.015 //y2=0.375
cc_1683 ( N_noxref_6_c_2078_p N_noxref_19_M17_noxref_s ) capacitor \
 c=0.00365271f //x=26.36 //y=1.22 //x2=27.015 //y2=0.375
cc_1684 ( N_noxref_6_c_2030_p N_noxref_19_M17_noxref_s ) capacitor \
 c=9.86711e-19 //x=26.36 //y=1.915 //x2=27.015 //y2=0.375
cc_1685 ( N_noxref_6_c_2032_p N_noxref_20_c_4514_n ) capacitor c=0.00136055f \
 //x=26.27 //y=3.125 //x2=26.34 //y2=5.155
cc_1686 ( N_noxref_6_c_2033_p N_noxref_20_c_4514_n ) capacitor c=0.0219105f \
 //x=26.27 //y=4.585 //x2=26.34 //y2=5.155
cc_1687 ( N_noxref_6_c_2039_p N_noxref_20_c_4514_n ) capacitor c=0.00492634f \
 //x=26.27 //y=4.7 //x2=26.34 //y2=5.155
cc_1688 ( N_noxref_6_M50_noxref_g N_noxref_20_c_4514_n ) capacitor \
 c=0.00858241f //x=26.24 //y=6.02 //x2=26.34 //y2=5.155
cc_1689 ( N_noxref_6_c_2040_p N_noxref_20_c_4514_n ) capacitor c=5.8675e-19 \
 //x=26.27 //y=4.7 //x2=26.34 //y2=5.155
cc_1690 ( N_noxref_6_M51_noxref_g N_noxref_20_c_4519_n ) capacitor \
 c=0.0110196f //x=26.68 //y=6.02 //x2=27.225 //y2=5.155
cc_1691 ( N_noxref_6_c_2031_p N_noxref_20_c_4520_n ) capacitor c=0.00143561f \
 //x=26.27 //y=2.805 //x2=28.12 //y2=5.07
cc_1692 ( N_noxref_6_c_2033_p N_noxref_20_c_4520_n ) capacitor c=0.00306817f \
 //x=26.27 //y=4.585 //x2=28.12 //y2=5.07
cc_1693 ( N_noxref_6_c_2032_p N_noxref_20_c_4522_n ) capacitor c=5.87118e-19 \
 //x=26.27 //y=3.125 //x2=26.46 //y2=5.155
cc_1694 ( N_noxref_6_c_2033_p N_noxref_20_c_4522_n ) capacitor c=0.0024774f \
 //x=26.27 //y=4.585 //x2=26.46 //y2=5.155
cc_1695 ( N_noxref_6_c_2039_p N_noxref_20_c_4522_n ) capacitor c=0.00132214f \
 //x=26.27 //y=4.7 //x2=26.46 //y2=5.155
cc_1696 ( N_noxref_6_M50_noxref_g N_noxref_20_c_4522_n ) capacitor \
 c=0.00229818f //x=26.24 //y=6.02 //x2=26.46 //y2=5.155
cc_1697 ( N_noxref_6_M51_noxref_g N_noxref_20_c_4522_n ) capacitor \
 c=0.00230699f //x=26.68 //y=6.02 //x2=26.46 //y2=5.155
cc_1698 ( N_noxref_6_c_2094_p N_noxref_20_c_4522_n ) capacitor c=0.00177491f \
 //x=26.605 //y=4.79 //x2=26.46 //y2=5.155
cc_1699 ( N_noxref_6_c_2033_p N_noxref_20_c_4528_n ) capacitor c=6.21282e-19 \
 //x=26.27 //y=4.585 //x2=26.46 //y2=5.38
cc_1700 ( N_noxref_6_M50_noxref_g N_noxref_20_c_4528_n ) capacitor \
 c=0.0179041f //x=26.24 //y=6.02 //x2=26.46 //y2=5.38
cc_1701 ( N_noxref_6_M51_noxref_g N_noxref_20_c_4528_n ) capacitor \
 c=0.0179041f //x=26.68 //y=6.02 //x2=26.46 //y2=5.38
cc_1702 ( N_noxref_6_c_2094_p N_noxref_20_c_4528_n ) capacitor c=0.00290085f \
 //x=26.605 //y=4.79 //x2=26.46 //y2=5.38
cc_1703 ( N_noxref_6_c_1931_n N_noxref_23_c_4770_n ) capacitor c=0.0167228f \
 //x=11.405 //y=0.91 //x2=12.065 //y2=0.54
cc_1704 ( N_noxref_6_c_1936_n N_noxref_23_c_4770_n ) capacitor c=0.00534519f \
 //x=11.93 //y=0.91 //x2=12.065 //y2=0.54
cc_1705 ( N_noxref_6_c_1904_n N_noxref_23_c_4768_n ) capacitor c=0.0048147f \
 //x=11.84 //y=2.195 //x2=12.065 //y2=1.59
cc_1706 ( N_noxref_6_c_1913_n N_noxref_23_c_4768_n ) capacitor c=0.00254411f \
 //x=11.84 //y=3.105 //x2=12.065 //y2=1.59
cc_1707 ( N_noxref_6_c_1920_n N_noxref_23_c_4768_n ) capacitor c=0.0105652f \
 //x=11.84 //y=2.08 //x2=12.065 //y2=1.59
cc_1708 ( N_noxref_6_c_1934_n N_noxref_23_c_4768_n ) capacitor c=0.0153476f \
 //x=11.405 //y=1.22 //x2=12.065 //y2=1.59
cc_1709 ( N_noxref_6_c_1939_n N_noxref_23_c_4768_n ) capacitor c=0.019963f \
 //x=11.93 //y=1.915 //x2=12.065 //y2=1.59
cc_1710 ( N_noxref_6_c_1913_n N_noxref_23_M6_noxref_s ) capacitor \
 c=5.54826e-19 //x=11.84 //y=3.105 //x2=10.075 //y2=0.375
cc_1711 ( N_noxref_6_c_1931_n N_noxref_23_M6_noxref_s ) capacitor \
 c=0.00798959f //x=11.405 //y=0.91 //x2=10.075 //y2=0.375
cc_1712 ( N_noxref_6_c_1938_n N_noxref_23_M6_noxref_s ) capacitor \
 c=0.00212176f //x=11.93 //y=1.45 //x2=10.075 //y2=0.375
cc_1713 ( N_noxref_6_c_1939_n N_noxref_23_M6_noxref_s ) capacitor \
 c=0.00298115f //x=11.93 //y=1.915 //x2=10.075 //y2=0.375
cc_1714 ( N_noxref_6_c_1991_n N_noxref_25_c_4889_n ) capacitor c=0.00103808f \
 //x=20.56 //y=2.945 //x2=21.685 //y2=1.59
cc_1715 ( N_noxref_6_c_1991_n N_noxref_25_M12_noxref_s ) capacitor \
 c=0.00269856f //x=20.56 //y=2.945 //x2=19.695 //y2=0.375
cc_1716 ( N_noxref_6_c_1991_n N_noxref_26_c_4932_n ) capacitor c=0.00319011f \
 //x=20.56 //y=2.945 //x2=24.64 //y2=1.505
cc_1717 ( N_noxref_6_c_1991_n N_noxref_26_c_4933_n ) capacitor c=0.0104745f \
 //x=20.56 //y=2.945 //x2=25.525 //y2=1.59
cc_1718 ( N_noxref_6_c_2157_p N_noxref_26_c_4934_n ) capacitor c=0.0167228f \
 //x=25.835 //y=0.91 //x2=26.495 //y2=0.54
cc_1719 ( N_noxref_6_c_2077_p N_noxref_26_c_4934_n ) capacitor c=0.00534519f \
 //x=26.36 //y=0.91 //x2=26.495 //y2=0.54
cc_1720 ( N_noxref_6_c_2028_p N_noxref_26_c_4936_n ) capacitor c=0.0048147f \
 //x=26.27 //y=2.195 //x2=26.495 //y2=1.59
cc_1721 ( N_noxref_6_c_2032_p N_noxref_26_c_4936_n ) capacitor c=0.00288317f \
 //x=26.27 //y=3.125 //x2=26.495 //y2=1.59
cc_1722 ( N_noxref_6_c_1991_n N_noxref_26_c_4936_n ) capacitor c=0.00492503f \
 //x=20.56 //y=2.945 //x2=26.495 //y2=1.59
cc_1723 ( N_noxref_6_c_2029_p N_noxref_26_c_4936_n ) capacitor c=0.0105652f \
 //x=26.27 //y=2.08 //x2=26.495 //y2=1.59
cc_1724 ( N_noxref_6_c_2159_p N_noxref_26_c_4936_n ) capacitor c=0.0153476f \
 //x=25.835 //y=1.22 //x2=26.495 //y2=1.59
cc_1725 ( N_noxref_6_c_2030_p N_noxref_26_c_4936_n ) capacitor c=0.0200784f \
 //x=26.36 //y=1.915 //x2=26.495 //y2=1.59
cc_1726 ( N_noxref_6_c_1991_n N_noxref_26_M15_noxref_s ) capacitor \
 c=0.00319011f //x=20.56 //y=2.945 //x2=24.505 //y2=0.375
cc_1727 ( N_noxref_6_c_2157_p N_noxref_26_M15_noxref_s ) capacitor \
 c=0.00798959f //x=25.835 //y=0.91 //x2=24.505 //y2=0.375
cc_1728 ( N_noxref_6_c_2079_p N_noxref_26_M15_noxref_s ) capacitor \
 c=0.00212176f //x=26.36 //y=1.45 //x2=24.505 //y2=0.375
cc_1729 ( N_noxref_6_c_2030_p N_noxref_26_M15_noxref_s ) capacitor \
 c=0.00298115f //x=26.36 //y=1.915 //x2=24.505 //y2=0.375
cc_1730 ( N_noxref_7_c_2264_n N_noxref_8_c_2794_n ) capacitor c=0.00620642f \
 //x=16.72 //y=5.155 //x2=28.12 //y2=7.4
cc_1731 ( N_noxref_7_c_2332_n N_noxref_8_c_2794_n ) capacitor c=0.00626474f \
 //x=17.605 //y=5.155 //x2=28.12 //y2=7.4
cc_1732 ( N_noxref_7_c_2459_n N_noxref_8_c_2794_n ) capacitor c=0.00255604f \
 //x=17.72 //y=5.38 //x2=28.12 //y2=7.4
cc_1733 ( N_noxref_7_c_2461_n N_noxref_8_c_2794_n ) capacitor c=0.00827852f \
 //x=18.415 //y=5.155 //x2=28.12 //y2=7.4
cc_1734 ( N_noxref_7_c_2400_n N_noxref_8_c_2794_n ) capacitor c=4.58772e-19 \
 //x=18.5 //y=3.875 //x2=28.12 //y2=7.4
cc_1735 ( N_noxref_7_c_2267_n N_noxref_8_c_2794_n ) capacitor c=0.00261379f \
 //x=15.962 //y=5.155 //x2=28.12 //y2=7.4
cc_1736 ( N_noxref_7_c_2337_n N_noxref_8_c_2794_n ) capacitor c=0.0026965f \
 //x=16.84 //y=5.155 //x2=28.12 //y2=7.4
cc_1737 ( N_noxref_7_c_2280_n N_noxref_8_c_2794_n ) capacitor c=0.00242194f \
 //x=15.96 //y=5.38 //x2=28.12 //y2=7.4
cc_1738 ( N_noxref_7_c_2358_n N_noxref_8_c_2794_n ) capacitor c=0.00242194f \
 //x=16.84 //y=5.38 //x2=28.12 //y2=7.4
cc_1739 ( N_noxref_7_c_2506_n N_noxref_8_c_2794_n ) capacitor c=0.00242194f \
 //x=17.72 //y=5.38 //x2=28.12 //y2=7.4
cc_1740 ( N_noxref_7_M28_noxref_g N_noxref_8_c_2939_n ) capacitor \
 c=0.00749619f //x=7.88 //y=6.02 //x2=8.455 //y2=7.4
cc_1741 ( N_noxref_7_M29_noxref_g N_noxref_8_c_2939_n ) capacitor \
 c=0.00749823f //x=8.32 //y=6.02 //x2=8.455 //y2=7.4
cc_1742 ( N_noxref_7_M34_noxref_g N_noxref_8_c_2872_n ) capacitor \
 c=0.00749619f //x=12.69 //y=6.02 //x2=13.265 //y2=7.4
cc_1743 ( N_noxref_7_M35_noxref_g N_noxref_8_c_2872_n ) capacitor \
 c=0.00749823f //x=13.13 //y=6.02 //x2=13.265 //y2=7.4
cc_1744 ( N_noxref_7_c_2264_n N_noxref_8_c_2877_n ) capacitor c=0.00202948f \
 //x=16.72 //y=5.155 //x2=16.315 //y2=7.4
cc_1745 ( N_noxref_7_c_2267_n N_noxref_8_c_2877_n ) capacitor c=9.37357e-19 \
 //x=15.962 //y=5.155 //x2=16.315 //y2=7.4
cc_1746 ( N_noxref_7_c_2280_n N_noxref_8_c_2877_n ) capacitor c=0.0137846f \
 //x=15.96 //y=5.38 //x2=16.315 //y2=7.4
cc_1747 ( N_noxref_7_c_2264_n N_noxref_8_c_2909_n ) capacitor c=0.00177088f \
 //x=16.72 //y=5.155 //x2=17.195 //y2=7.4
cc_1748 ( N_noxref_7_c_2332_n N_noxref_8_c_2909_n ) capacitor c=0.00202948f \
 //x=17.605 //y=5.155 //x2=17.195 //y2=7.4
cc_1749 ( N_noxref_7_c_2337_n N_noxref_8_c_2909_n ) capacitor c=9.47876e-19 \
 //x=16.84 //y=5.155 //x2=17.195 //y2=7.4
cc_1750 ( N_noxref_7_c_2358_n N_noxref_8_c_2909_n ) capacitor c=0.0137846f \
 //x=16.84 //y=5.38 //x2=17.195 //y2=7.4
cc_1751 ( N_noxref_7_c_2332_n N_noxref_8_c_2982_n ) capacitor c=0.00205929f \
 //x=17.605 //y=5.155 //x2=18.075 //y2=7.4
cc_1752 ( N_noxref_7_c_2459_n N_noxref_8_c_2982_n ) capacitor c=8.49349e-19 \
 //x=17.72 //y=5.38 //x2=18.075 //y2=7.4
cc_1753 ( N_noxref_7_c_2461_n N_noxref_8_c_2982_n ) capacitor c=0.00204261f \
 //x=18.415 //y=5.155 //x2=18.075 //y2=7.4
cc_1754 ( N_noxref_7_c_2506_n N_noxref_8_c_2982_n ) capacitor c=0.0137846f \
 //x=17.72 //y=5.38 //x2=18.075 //y2=7.4
cc_1755 ( N_noxref_7_c_2461_n N_noxref_8_c_3027_n ) capacitor c=0.00183429f \
 //x=18.415 //y=5.155 //x2=19.07 //y2=7.4
cc_1756 ( N_noxref_7_M52_noxref_g N_noxref_8_c_3028_n ) capacitor \
 c=0.00749619f //x=27.12 //y=6.02 //x2=27.695 //y2=7.4
cc_1757 ( N_noxref_7_M53_noxref_g N_noxref_8_c_3028_n ) capacitor \
 c=0.00749823f //x=27.56 //y=6.02 //x2=27.695 //y2=7.4
cc_1758 ( N_noxref_7_c_2569_n N_noxref_8_c_3030_n ) capacitor c=0.00224736f \
 //x=27.38 //y=4.7 //x2=28.12 //y2=7.4
cc_1759 ( N_noxref_7_c_2596_n N_noxref_8_c_3030_n ) capacitor c=2.63786e-19 \
 //x=27.38 //y=4.7 //x2=28.12 //y2=7.4
cc_1760 ( N_noxref_7_c_2246_n N_noxref_8_c_2827_n ) capacitor c=0.00419961f \
 //x=12.79 //y=3.715 //x2=9.62 //y2=7.4
cc_1761 ( N_noxref_7_c_2355_n N_noxref_8_c_2827_n ) capacitor c=0.00224736f \
 //x=8.14 //y=4.7 //x2=9.62 //y2=7.4
cc_1762 ( N_noxref_7_c_2372_n N_noxref_8_c_2827_n ) capacitor c=2.63786e-19 \
 //x=8.14 //y=4.7 //x2=9.62 //y2=7.4
cc_1763 ( N_noxref_7_c_2267_n N_noxref_8_c_2881_n ) capacitor c=0.0022955f \
 //x=15.962 //y=5.155 //x2=14.43 //y2=7.4
cc_1764 ( N_noxref_7_c_2272_n N_noxref_8_c_2881_n ) capacitor c=0.00419961f \
 //x=18.33 //y=3.7 //x2=14.43 //y2=7.4
cc_1765 ( N_noxref_7_c_2276_n N_noxref_8_c_2881_n ) capacitor c=0.00224736f \
 //x=12.95 //y=4.7 //x2=14.43 //y2=7.4
cc_1766 ( N_noxref_7_c_2280_n N_noxref_8_c_2881_n ) capacitor c=0.00509469f \
 //x=15.96 //y=5.38 //x2=14.43 //y2=7.4
cc_1767 ( N_noxref_7_c_2310_n N_noxref_8_c_2881_n ) capacitor c=2.63786e-19 \
 //x=12.95 //y=4.7 //x2=14.43 //y2=7.4
cc_1768 ( N_noxref_7_c_2459_n N_noxref_8_c_2954_n ) capacitor c=0.00282782f \
 //x=17.72 //y=5.38 //x2=19.24 //y2=7.4
cc_1769 ( N_noxref_7_c_2334_n N_noxref_8_c_2954_n ) capacitor c=0.0354222f \
 //x=18.5 //y=5.07 //x2=19.24 //y2=7.4
cc_1770 ( N_noxref_7_c_2407_n N_noxref_8_c_2954_n ) capacitor c=0.00643435f \
 //x=20.215 //y=3.715 //x2=19.24 //y2=7.4
cc_1771 ( N_noxref_7_c_2506_n N_noxref_8_c_2954_n ) capacitor c=0.00777981f \
 //x=17.72 //y=5.38 //x2=19.24 //y2=7.4
cc_1772 ( N_noxref_7_c_2405_n N_noxref_8_c_3044_n ) capacitor c=0.00643435f \
 //x=20.56 //y=3.715 //x2=24.05 //y2=7.4
cc_1773 ( N_noxref_7_M28_noxref_g N_noxref_8_M27_noxref_d ) capacitor \
 c=0.015318f //x=7.88 //y=6.02 //x2=7.515 //y2=5.02
cc_1774 ( N_noxref_7_M29_noxref_g N_noxref_8_M29_noxref_d ) capacitor \
 c=0.0394719f //x=8.32 //y=6.02 //x2=8.395 //y2=5.02
cc_1775 ( N_noxref_7_M34_noxref_g N_noxref_8_M33_noxref_d ) capacitor \
 c=0.015318f //x=12.69 //y=6.02 //x2=12.325 //y2=5.02
cc_1776 ( N_noxref_7_M35_noxref_g N_noxref_8_M35_noxref_d ) capacitor \
 c=0.0394719f //x=13.13 //y=6.02 //x2=13.205 //y2=5.02
cc_1777 ( N_noxref_7_c_2267_n N_noxref_8_M36_noxref_s ) capacitor c=0.0442713f \
 //x=15.962 //y=5.155 //x2=15.385 //y2=5.02
cc_1778 ( N_noxref_7_c_2337_n N_noxref_8_M36_noxref_s ) capacitor \
 c=7.80122e-19 //x=16.84 //y=5.155 //x2=15.385 //y2=5.02
cc_1779 ( N_noxref_7_c_2280_n N_noxref_8_M36_noxref_s ) capacitor c=0.09305f \
 //x=15.96 //y=5.38 //x2=15.385 //y2=5.02
cc_1780 ( N_noxref_7_c_2264_n N_noxref_8_M37_noxref_d ) capacitor \
 c=0.00700078f //x=16.72 //y=5.155 //x2=16.255 //y2=5.02
cc_1781 ( N_noxref_7_c_2280_n N_noxref_8_M37_noxref_d ) capacitor c=0.0674491f \
 //x=15.96 //y=5.38 //x2=16.255 //y2=5.02
cc_1782 ( N_noxref_7_c_2358_n N_noxref_8_M37_noxref_d ) capacitor c=0.0674762f \
 //x=16.84 //y=5.38 //x2=16.255 //y2=5.02
cc_1783 ( N_noxref_7_c_2332_n N_noxref_8_M39_noxref_d ) capacitor \
 c=0.00700078f //x=17.605 //y=5.155 //x2=17.135 //y2=5.02
cc_1784 ( N_noxref_7_c_2358_n N_noxref_8_M39_noxref_d ) capacitor c=0.067493f \
 //x=16.84 //y=5.38 //x2=17.135 //y2=5.02
cc_1785 ( N_noxref_7_c_2506_n N_noxref_8_M39_noxref_d ) capacitor c=0.0674979f \
 //x=17.72 //y=5.38 //x2=17.135 //y2=5.02
cc_1786 ( N_noxref_7_c_2461_n N_noxref_8_M41_noxref_d ) capacitor \
 c=0.00700078f //x=18.415 //y=5.155 //x2=18.015 //y2=5.02
cc_1787 ( N_noxref_7_c_2506_n N_noxref_8_M41_noxref_d ) capacitor c=0.0675002f \
 //x=17.72 //y=5.38 //x2=18.015 //y2=5.02
cc_1788 ( N_noxref_7_c_2459_n N_noxref_8_M42_noxref_s ) capacitor \
 c=0.00492616f //x=17.72 //y=5.38 //x2=20.195 //y2=5.02
cc_1789 ( N_noxref_7_c_2461_n N_noxref_8_M42_noxref_s ) capacitor \
 c=9.42705e-19 //x=18.415 //y=5.155 //x2=20.195 //y2=5.02
cc_1790 ( N_noxref_7_c_2337_n N_noxref_8_M42_noxref_s ) capacitor \
 c=2.11884e-19 //x=16.84 //y=5.155 //x2=20.195 //y2=5.02
cc_1791 ( N_noxref_7_c_2407_n N_noxref_8_M42_noxref_s ) capacitor \
 c=3.43041e-19 //x=20.215 //y=3.715 //x2=20.195 //y2=5.02
cc_1792 ( N_noxref_7_c_2405_n N_noxref_8_M48_noxref_s ) capacitor \
 c=4.77143e-19 //x=20.56 //y=3.715 //x2=25.005 //y2=5.02
cc_1793 ( N_noxref_7_M52_noxref_g N_noxref_8_M51_noxref_d ) capacitor \
 c=0.015318f //x=27.12 //y=6.02 //x2=26.755 //y2=5.02
cc_1794 ( N_noxref_7_M53_noxref_g N_noxref_8_M53_noxref_d ) capacitor \
 c=0.0394719f //x=27.56 //y=6.02 //x2=27.635 //y2=5.02
cc_1795 ( N_noxref_7_c_2313_n N_noxref_11_c_3356_n ) capacitor c=0.00177186f \
 //x=8.14 //y=2.195 //x2=8.795 //y2=0.54
cc_1796 ( N_noxref_7_c_2351_n N_noxref_11_c_3356_n ) capacitor c=0.00117306f \
 //x=8.14 //y=2.08 //x2=8.795 //y2=0.54
cc_1797 ( N_noxref_7_c_2365_n N_noxref_11_c_3356_n ) capacitor c=0.0206349f \
 //x=8.13 //y=0.915 //x2=8.795 //y2=0.54
cc_1798 ( N_noxref_7_c_2442_n N_noxref_11_c_3356_n ) capacitor c=0.00825432f \
 //x=8.66 //y=0.915 //x2=8.795 //y2=0.54
cc_1799 ( N_noxref_7_c_2368_n N_noxref_11_c_3356_n ) capacitor c=2.20712e-19 \
 //x=8.14 //y=2.08 //x2=8.795 //y2=0.54
cc_1800 ( N_noxref_7_c_2366_n N_noxref_11_c_3359_n ) capacitor c=0.0071177f \
 //x=8.13 //y=1.26 //x2=7.91 //y2=0.995
cc_1801 ( N_noxref_7_c_2365_n N_noxref_11_M5_noxref_s ) capacitor c=0.0071177f \
 //x=8.13 //y=0.915 //x2=7.775 //y2=0.375
cc_1802 ( N_noxref_7_c_2367_n N_noxref_11_M5_noxref_s ) capacitor c=0.0071177f \
 //x=8.13 //y=1.57 //x2=7.775 //y2=0.375
cc_1803 ( N_noxref_7_c_2442_n N_noxref_11_M5_noxref_s ) capacitor c=0.015333f \
 //x=8.66 //y=0.915 //x2=7.775 //y2=0.375
cc_1804 ( N_noxref_7_c_2444_n N_noxref_11_M5_noxref_s ) capacitor \
 c=0.00248746f //x=8.66 //y=1.26 //x2=7.775 //y2=0.375
cc_1805 ( N_noxref_7_c_2248_n N_noxref_12_c_3410_n ) capacitor c=0.00177186f \
 //x=12.95 //y=2.195 //x2=13.605 //y2=0.54
cc_1806 ( N_noxref_7_c_2275_n N_noxref_12_c_3410_n ) capacitor c=0.00117306f \
 //x=12.95 //y=2.08 //x2=13.605 //y2=0.54
cc_1807 ( N_noxref_7_c_2289_n N_noxref_12_c_3410_n ) capacitor c=0.0206349f \
 //x=12.94 //y=0.915 //x2=13.605 //y2=0.54
cc_1808 ( N_noxref_7_c_2301_n N_noxref_12_c_3410_n ) capacitor c=0.00825432f \
 //x=13.47 //y=0.915 //x2=13.605 //y2=0.54
cc_1809 ( N_noxref_7_c_2307_n N_noxref_12_c_3410_n ) capacitor c=2.20712e-19 \
 //x=12.95 //y=2.08 //x2=13.605 //y2=0.54
cc_1810 ( N_noxref_7_c_2291_n N_noxref_12_c_3413_n ) capacitor c=0.0071177f \
 //x=12.94 //y=1.26 //x2=12.72 //y2=0.995
cc_1811 ( N_noxref_7_c_2256_n N_noxref_12_M8_noxref_s ) capacitor \
 c=9.71372e-19 //x=12.95 //y=3.875 //x2=12.585 //y2=0.375
cc_1812 ( N_noxref_7_c_2289_n N_noxref_12_M8_noxref_s ) capacitor c=0.0071177f \
 //x=12.94 //y=0.915 //x2=12.585 //y2=0.375
cc_1813 ( N_noxref_7_c_2294_n N_noxref_12_M8_noxref_s ) capacitor c=0.0071177f \
 //x=12.94 //y=1.57 //x2=12.585 //y2=0.375
cc_1814 ( N_noxref_7_c_2301_n N_noxref_12_M8_noxref_s ) capacitor c=0.015333f \
 //x=13.47 //y=0.915 //x2=12.585 //y2=0.375
cc_1815 ( N_noxref_7_c_2303_n N_noxref_12_M8_noxref_s ) capacitor \
 c=0.00248746f //x=13.47 //y=1.26 //x2=12.585 //y2=0.375
cc_1816 ( N_noxref_7_c_2465_n N_noxref_13_c_3498_n ) capacitor c=0.0036878f \
 //x=18.015 //y=1.125 //x2=18.415 //y2=0.54
cc_1817 ( N_noxref_7_c_2478_n N_noxref_13_c_3498_n ) capacitor c=0.00399931f \
 //x=18.415 //y=1.665 //x2=18.415 //y2=0.54
cc_1818 ( N_noxref_7_M11_noxref_d N_noxref_13_c_3498_n ) capacitor \
 c=0.00949319f //x=17.825 //y=0.915 //x2=18.415 //y2=0.54
cc_1819 ( N_noxref_7_M11_noxref_d N_noxref_13_c_3503_n ) capacitor \
 c=0.00120711f //x=17.825 //y=0.915 //x2=17.53 //y2=0.995
cc_1820 ( N_noxref_7_c_2264_n N_noxref_13_M10_noxref_d ) capacitor \
 c=0.00149054f //x=16.72 //y=5.155 //x2=16.29 //y2=0.91
cc_1821 ( N_noxref_7_c_2465_n N_noxref_13_M10_noxref_d ) capacitor \
 c=0.00802417f //x=18.015 //y=1.125 //x2=16.29 //y2=0.91
cc_1822 ( N_noxref_7_c_2465_n N_noxref_13_M11_noxref_s ) capacitor \
 c=0.0098487f //x=18.015 //y=1.125 //x2=17.395 //y2=0.375
cc_1823 ( N_noxref_7_c_2473_n N_noxref_13_M11_noxref_s ) capacitor \
 c=0.0283243f //x=18.015 //y=1.58 //x2=17.395 //y2=0.375
cc_1824 ( N_noxref_7_c_2478_n N_noxref_13_M11_noxref_s ) capacitor \
 c=0.00911719f //x=18.415 //y=1.665 //x2=17.395 //y2=0.375
cc_1825 ( N_noxref_7_c_2498_n N_noxref_13_M11_noxref_s ) capacitor \
 c=0.00129723f //x=18.5 //y=3.7 //x2=17.395 //y2=0.375
cc_1826 ( N_noxref_7_M11_noxref_d N_noxref_13_M11_noxref_s ) capacitor \
 c=0.0279003f //x=17.825 //y=0.915 //x2=17.395 //y2=0.375
cc_1827 ( N_noxref_7_c_2465_n N_noxref_14_M13_noxref_d ) capacitor \
 c=3.20746e-19 //x=18.015 //y=1.125 //x2=21.1 //y2=0.91
cc_1828 ( N_noxref_7_c_2405_n N_noxref_15_c_3620_n ) capacitor c=0.0319226f \
 //x=20.56 //y=3.715 //x2=22.57 //y2=4.57
cc_1829 ( N_noxref_7_c_2405_n N_noxref_16_c_3743_n ) capacitor c=0.0136188f \
 //x=20.56 //y=3.715 //x2=23.225 //y2=5.155
cc_1830 ( N_noxref_7_c_2478_n N_noxref_16_c_3739_n ) capacitor c=0.00163399f \
 //x=18.415 //y=1.665 //x2=22.91 //y2=1.665
cc_1831 ( N_noxref_7_c_2405_n N_noxref_16_c_3727_n ) capacitor c=0.0326588f \
 //x=20.56 //y=3.715 //x2=23.31 //y2=5.07
cc_1832 ( N_noxref_7_c_2459_n N_noxref_16_c_3715_n ) capacitor c=6.09703e-19 \
 //x=17.72 //y=5.38 //x2=20.772 //y2=5.155
cc_1833 ( N_noxref_7_c_2461_n N_noxref_16_c_3715_n ) capacitor c=0.00306432f \
 //x=18.415 //y=5.155 //x2=20.772 //y2=5.155
cc_1834 ( N_noxref_7_c_2405_n N_noxref_16_c_3715_n ) capacitor c=0.018597f \
 //x=20.56 //y=3.715 //x2=20.772 //y2=5.155
cc_1835 ( N_noxref_7_c_2405_n N_noxref_16_c_3728_n ) capacitor c=0.0268868f \
 //x=20.56 //y=3.715 //x2=21.65 //y2=5.155
cc_1836 ( N_noxref_7_c_2313_n N_noxref_17_c_3962_n ) capacitor c=0.00196073f \
 //x=8.14 //y=2.195 //x2=10.61 //y2=0
cc_1837 ( N_noxref_7_c_2248_n N_noxref_17_c_3922_n ) capacitor c=0.00196073f \
 //x=12.95 //y=2.195 //x2=15.42 //y2=0
cc_1838 ( N_noxref_7_c_2465_n N_noxref_17_c_3963_n ) capacitor c=0.0087684f \
 //x=18.015 //y=1.125 //x2=20.23 //y2=0
cc_1839 ( N_noxref_7_c_2478_n N_noxref_17_c_3963_n ) capacitor c=0.00661744f \
 //x=18.415 //y=1.665 //x2=20.23 //y2=0
cc_1840 ( N_noxref_7_c_2400_n N_noxref_17_c_3963_n ) capacitor c=3.09126e-19 \
 //x=18.5 //y=3.875 //x2=20.23 //y2=0
cc_1841 ( N_noxref_7_M11_noxref_d N_noxref_17_c_3963_n ) capacitor \
 c=2.94508e-19 //x=17.825 //y=0.915 //x2=20.23 //y2=0
cc_1842 ( N_noxref_7_c_2532_n N_noxref_17_c_4033_n ) capacitor c=0.00219445f \
 //x=27.38 //y=2.195 //x2=28.12 //y2=0
cc_1843 ( N_noxref_7_c_2541_n N_noxref_17_c_4033_n ) capacitor c=2.74256e-19 \
 //x=27.38 //y=3.865 //x2=28.12 //y2=0
cc_1844 ( N_noxref_7_c_2465_n N_noxref_17_c_3973_n ) capacitor c=0.00543195f \
 //x=18.015 //y=1.125 //x2=20.315 //y2=0.965
cc_1845 ( N_noxref_7_c_2313_n N_noxref_17_c_3885_n ) capacitor c=2.01623e-19 \
 //x=8.14 //y=2.195 //x2=9.45 //y2=0
cc_1846 ( N_noxref_7_c_2248_n N_noxref_17_c_3886_n ) capacitor c=2.01623e-19 \
 //x=12.95 //y=2.195 //x2=14.26 //y2=0
cc_1847 ( N_noxref_7_c_2478_n N_noxref_17_c_3942_n ) capacitor c=6.86937e-19 \
 //x=18.415 //y=1.665 //x2=19.07 //y2=0
cc_1848 ( N_noxref_7_c_2532_n N_noxref_17_c_4050_n ) capacitor c=2.01623e-19 \
 //x=27.38 //y=2.195 //x2=28.12 //y2=0
cc_1849 ( N_noxref_7_c_2565_n N_noxref_17_c_4050_n ) capacitor c=0.00239899f \
 //x=27.38 //y=2.08 //x2=28.12 //y2=0
cc_1850 ( N_noxref_7_c_2720_p N_noxref_17_c_4050_n ) capacitor c=0.00275764f \
 //x=27.9 //y=1.26 //x2=28.12 //y2=0
cc_1851 ( N_noxref_7_c_2592_n N_noxref_17_c_4050_n ) capacitor c=2.63786e-19 \
 //x=27.38 //y=2.08 //x2=28.12 //y2=0
cc_1852 ( N_noxref_7_c_2351_n N_noxref_17_c_3900_n ) capacitor c=0.00222376f \
 //x=8.14 //y=2.08 //x2=9.62 //y2=0
cc_1853 ( N_noxref_7_c_2444_n N_noxref_17_c_3900_n ) capacitor c=0.00262688f \
 //x=8.66 //y=1.26 //x2=9.62 //y2=0
cc_1854 ( N_noxref_7_c_2275_n N_noxref_17_c_3943_n ) capacitor c=0.00222376f \
 //x=12.95 //y=2.08 //x2=14.43 //y2=0
cc_1855 ( N_noxref_7_c_2303_n N_noxref_17_c_3943_n ) capacitor c=0.00262688f \
 //x=13.47 //y=1.26 //x2=14.43 //y2=0
cc_1856 ( N_noxref_7_c_2473_n N_noxref_17_c_3994_n ) capacitor c=0.0045138f \
 //x=18.015 //y=1.58 //x2=19.24 //y2=0
cc_1857 ( N_noxref_7_c_2478_n N_noxref_17_c_3994_n ) capacitor c=0.0319165f \
 //x=18.415 //y=1.665 //x2=19.24 //y2=0
cc_1858 ( N_noxref_7_c_2535_n N_noxref_18_c_4356_n ) capacitor c=0.00224542f \
 //x=27.38 //y=3.545 //x2=25.16 //y2=4.575
cc_1859 ( N_noxref_7_c_2542_n N_noxref_18_c_4356_n ) capacitor c=0.0011266f \
 //x=27.38 //y=4.57 //x2=25.16 //y2=4.575
cc_1860 ( N_noxref_7_c_2405_n N_noxref_18_c_4356_n ) capacitor c=0.0350971f \
 //x=20.56 //y=3.715 //x2=25.16 //y2=4.575
cc_1861 ( N_noxref_7_c_2532_n N_noxref_19_c_4468_n ) capacitor c=0.00177186f \
 //x=27.38 //y=2.195 //x2=28.035 //y2=0.54
cc_1862 ( N_noxref_7_c_2565_n N_noxref_19_c_4468_n ) capacitor c=0.00117306f \
 //x=27.38 //y=2.08 //x2=28.035 //y2=0.54
cc_1863 ( N_noxref_7_c_2581_n N_noxref_19_c_4468_n ) capacitor c=0.0206349f \
 //x=27.37 //y=0.915 //x2=28.035 //y2=0.54
cc_1864 ( N_noxref_7_c_2734_p N_noxref_19_c_4468_n ) capacitor c=0.00825432f \
 //x=27.9 //y=0.915 //x2=28.035 //y2=0.54
cc_1865 ( N_noxref_7_c_2592_n N_noxref_19_c_4468_n ) capacitor c=2.20712e-19 \
 //x=27.38 //y=2.08 //x2=28.035 //y2=0.54
cc_1866 ( N_noxref_7_c_2582_n N_noxref_19_c_4473_n ) capacitor c=0.0071177f \
 //x=27.37 //y=1.26 //x2=27.15 //y2=0.995
cc_1867 ( N_noxref_7_c_2541_n N_noxref_19_M17_noxref_s ) capacitor \
 c=9.73433e-19 //x=27.38 //y=3.865 //x2=27.015 //y2=0.375
cc_1868 ( N_noxref_7_c_2405_n N_noxref_19_M17_noxref_s ) capacitor \
 c=6.25077e-19 //x=20.56 //y=3.715 //x2=27.015 //y2=0.375
cc_1869 ( N_noxref_7_c_2581_n N_noxref_19_M17_noxref_s ) capacitor \
 c=0.0071177f //x=27.37 //y=0.915 //x2=27.015 //y2=0.375
cc_1870 ( N_noxref_7_c_2583_n N_noxref_19_M17_noxref_s ) capacitor \
 c=0.0071177f //x=27.37 //y=1.57 //x2=27.015 //y2=0.375
cc_1871 ( N_noxref_7_c_2734_p N_noxref_19_M17_noxref_s ) capacitor c=0.015333f \
 //x=27.9 //y=0.915 //x2=27.015 //y2=0.375
cc_1872 ( N_noxref_7_c_2720_p N_noxref_19_M17_noxref_s ) capacitor \
 c=0.00248746f //x=27.9 //y=1.26 //x2=27.015 //y2=0.375
cc_1873 ( N_noxref_7_c_2541_n N_noxref_20_c_4519_n ) capacitor c=0.0019404f \
 //x=27.38 //y=3.865 //x2=27.225 //y2=5.155
cc_1874 ( N_noxref_7_c_2405_n N_noxref_20_c_4519_n ) capacitor c=0.00259056f \
 //x=20.56 //y=3.715 //x2=27.225 //y2=5.155
cc_1875 ( N_noxref_7_M52_noxref_g N_noxref_20_c_4519_n ) capacitor \
 c=0.0102805f //x=27.12 //y=6.02 //x2=27.225 //y2=5.155
cc_1876 ( N_noxref_7_M52_noxref_g N_noxref_20_c_4535_n ) capacitor \
 c=0.00226521f //x=27.12 //y=6.02 //x2=27.34 //y2=5.38
cc_1877 ( N_noxref_7_M53_noxref_g N_noxref_20_c_4535_n ) capacitor \
 c=0.00427254f //x=27.56 //y=6.02 //x2=27.34 //y2=5.38
cc_1878 ( N_noxref_7_c_2541_n N_noxref_20_c_4537_n ) capacitor c=5.37284e-19 \
 //x=27.38 //y=3.865 //x2=28.035 //y2=5.155
cc_1879 ( N_noxref_7_c_2542_n N_noxref_20_c_4537_n ) capacitor c=0.00237494f \
 //x=27.38 //y=4.57 //x2=28.035 //y2=5.155
cc_1880 ( N_noxref_7_c_2405_n N_noxref_20_c_4537_n ) capacitor c=9.55715e-19 \
 //x=20.56 //y=3.715 //x2=28.035 //y2=5.155
cc_1881 ( N_noxref_7_c_2569_n N_noxref_20_c_4537_n ) capacitor c=0.00130631f \
 //x=27.38 //y=4.7 //x2=28.035 //y2=5.155
cc_1882 ( N_noxref_7_M53_noxref_g N_noxref_20_c_4537_n ) capacitor c=0.011539f \
 //x=27.56 //y=6.02 //x2=28.035 //y2=5.155
cc_1883 ( N_noxref_7_c_2581_n N_noxref_20_c_4542_n ) capacitor c=4.64015e-19 \
 //x=27.37 //y=0.915 //x2=27.635 //y2=1.125
cc_1884 ( N_noxref_7_c_2582_n N_noxref_20_c_4542_n ) capacitor c=0.0026012f \
 //x=27.37 //y=1.26 //x2=27.635 //y2=1.125
cc_1885 ( N_noxref_7_c_2755_p N_noxref_20_c_4542_n ) capacitor c=5.29969e-19 \
 //x=27.745 //y=0.76 //x2=27.635 //y2=1.125
cc_1886 ( N_noxref_7_c_2756_p N_noxref_20_c_4542_n ) capacitor c=5.31989e-19 \
 //x=27.745 //y=1.415 //x2=27.635 //y2=1.125
cc_1887 ( N_noxref_7_c_2734_p N_noxref_20_c_4542_n ) capacitor c=5.7502e-19 \
 //x=27.9 //y=0.915 //x2=27.635 //y2=1.125
cc_1888 ( N_noxref_7_c_2720_p N_noxref_20_c_4542_n ) capacitor c=0.00357756f \
 //x=27.9 //y=1.26 //x2=27.635 //y2=1.125
cc_1889 ( N_noxref_7_c_2582_n N_noxref_20_c_4548_n ) capacitor c=0.00127432f \
 //x=27.37 //y=1.26 //x2=27.635 //y2=1.58
cc_1890 ( N_noxref_7_c_2583_n N_noxref_20_c_4548_n ) capacitor c=0.00429966f \
 //x=27.37 //y=1.57 //x2=27.635 //y2=1.58
cc_1891 ( N_noxref_7_c_2756_p N_noxref_20_c_4548_n ) capacitor c=0.00942306f \
 //x=27.745 //y=1.415 //x2=27.635 //y2=1.58
cc_1892 ( N_noxref_7_c_2720_p N_noxref_20_c_4548_n ) capacitor c=0.00363411f \
 //x=27.9 //y=1.26 //x2=27.635 //y2=1.58
cc_1893 ( N_noxref_7_c_2595_n N_noxref_20_c_4548_n ) capacitor c=0.0036273f \
 //x=27.38 //y=1.915 //x2=27.635 //y2=1.58
cc_1894 ( N_noxref_7_c_2756_p N_noxref_20_c_4553_n ) capacitor c=0.00194716f \
 //x=27.745 //y=1.415 //x2=28.035 //y2=1.665
cc_1895 ( N_noxref_7_c_2720_p N_noxref_20_c_4553_n ) capacitor c=0.00323576f \
 //x=27.9 //y=1.26 //x2=28.035 //y2=1.665
cc_1896 ( N_noxref_7_c_2532_n N_noxref_20_c_4520_n ) capacitor c=0.0148484f \
 //x=27.38 //y=2.195 //x2=28.12 //y2=5.07
cc_1897 ( N_noxref_7_c_2535_n N_noxref_20_c_4520_n ) capacitor c=0.0629655f \
 //x=27.38 //y=3.545 //x2=28.12 //y2=5.07
cc_1898 ( N_noxref_7_c_2541_n N_noxref_20_c_4520_n ) capacitor c=0.0149195f \
 //x=27.38 //y=3.865 //x2=28.12 //y2=5.07
cc_1899 ( N_noxref_7_c_2542_n N_noxref_20_c_4520_n ) capacitor c=0.0484264f \
 //x=27.38 //y=4.57 //x2=28.12 //y2=5.07
cc_1900 ( N_noxref_7_c_2546_n N_noxref_20_c_4520_n ) capacitor c=0.00548505f \
 //x=27.38 //y=3.7 //x2=28.12 //y2=5.07
cc_1901 ( N_noxref_7_c_2405_n N_noxref_20_c_4520_n ) capacitor c=0.00686827f \
 //x=20.56 //y=3.715 //x2=28.12 //y2=5.07
cc_1902 ( N_noxref_7_c_2565_n N_noxref_20_c_4520_n ) capacitor c=0.00448538f \
 //x=27.38 //y=2.08 //x2=28.12 //y2=5.07
cc_1903 ( N_noxref_7_c_2569_n N_noxref_20_c_4520_n ) capacitor c=0.00442006f \
 //x=27.38 //y=4.7 //x2=28.12 //y2=5.07
cc_1904 ( N_noxref_7_c_2592_n N_noxref_20_c_4520_n ) capacitor c=0.00246559f \
 //x=27.38 //y=2.08 //x2=28.12 //y2=5.07
cc_1905 ( N_noxref_7_c_2596_n N_noxref_20_c_4520_n ) capacitor c=0.0035458f \
 //x=27.38 //y=4.7 //x2=28.12 //y2=5.07
cc_1906 ( N_noxref_7_c_2405_n N_noxref_20_c_4565_n ) capacitor c=0.0185222f \
 //x=20.56 //y=3.715 //x2=25.582 //y2=5.155
cc_1907 ( N_noxref_7_c_2405_n N_noxref_20_c_4522_n ) capacitor c=0.0217318f \
 //x=20.56 //y=3.715 //x2=26.46 //y2=5.155
cc_1908 ( N_noxref_7_c_2542_n N_noxref_20_c_4567_n ) capacitor c=0.022673f \
 //x=27.38 //y=4.57 //x2=27.34 //y2=5.155
cc_1909 ( N_noxref_7_c_2569_n N_noxref_20_c_4567_n ) capacitor c=0.00346456f \
 //x=27.38 //y=4.7 //x2=27.34 //y2=5.155
cc_1910 ( N_noxref_7_c_2596_n N_noxref_20_c_4567_n ) capacitor c=0.00203307f \
 //x=27.38 //y=4.7 //x2=27.34 //y2=5.155
cc_1911 ( N_noxref_7_c_2542_n N_noxref_20_c_4570_n ) capacitor c=0.00217653f \
 //x=27.38 //y=4.57 //x2=27.34 //y2=5.38
cc_1912 ( N_noxref_7_c_2569_n N_noxref_20_c_4570_n ) capacitor c=0.00624059f \
 //x=27.38 //y=4.7 //x2=27.34 //y2=5.38
cc_1913 ( N_noxref_7_M52_noxref_g N_noxref_20_c_4570_n ) capacitor \
 c=0.0178885f //x=27.12 //y=6.02 //x2=27.34 //y2=5.38
cc_1914 ( N_noxref_7_M53_noxref_g N_noxref_20_c_4570_n ) capacitor \
 c=0.0188608f //x=27.56 //y=6.02 //x2=27.34 //y2=5.38
cc_1915 ( N_noxref_7_c_2596_n N_noxref_20_c_4570_n ) capacitor c=0.00255197f \
 //x=27.38 //y=4.7 //x2=27.34 //y2=5.38
cc_1916 ( N_noxref_7_c_2581_n N_noxref_20_M17_noxref_d ) capacitor \
 c=0.00137165f //x=27.37 //y=0.915 //x2=27.445 //y2=0.915
cc_1917 ( N_noxref_7_c_2582_n N_noxref_20_M17_noxref_d ) capacitor \
 c=0.00237422f //x=27.37 //y=1.26 //x2=27.445 //y2=0.915
cc_1918 ( N_noxref_7_c_2755_p N_noxref_20_M17_noxref_d ) capacitor \
 c=0.0020782f //x=27.745 //y=0.76 //x2=27.445 //y2=0.915
cc_1919 ( N_noxref_7_c_2756_p N_noxref_20_M17_noxref_d ) capacitor \
 c=0.00356097f //x=27.745 //y=1.415 //x2=27.445 //y2=0.915
cc_1920 ( N_noxref_7_c_2734_p N_noxref_20_M17_noxref_d ) capacitor \
 c=0.00139206f //x=27.9 //y=0.915 //x2=27.445 //y2=0.915
cc_1921 ( N_noxref_7_c_2720_p N_noxref_20_M17_noxref_d ) capacitor \
 c=0.00237422f //x=27.9 //y=1.26 //x2=27.445 //y2=0.915
cc_1922 ( N_noxref_7_c_2405_n N_noxref_26_c_4936_n ) capacitor c=0.00100521f \
 //x=20.56 //y=3.715 //x2=26.495 //y2=1.59
cc_1923 ( N_noxref_7_c_2405_n N_noxref_26_M15_noxref_s ) capacitor \
 c=0.0020282f //x=20.56 //y=3.715 //x2=24.505 //y2=0.375
cc_1924 ( N_noxref_8_c_2803_n N_noxref_9_c_3186_n ) capacitor c=0.019298f \
 //x=0.74 //y=7.4 //x2=1.11 //y2=4.575
cc_1925 ( N_noxref_8_M18_noxref_s N_noxref_9_c_3186_n ) capacitor c=0.0230398f \
 //x=0.955 //y=5.02 //x2=1.11 //y2=4.575
cc_1926 ( N_noxref_8_c_2803_n N_noxref_9_c_3201_n ) capacitor c=0.00371026f \
 //x=0.74 //y=7.4 //x2=1.11 //y2=4.7
cc_1927 ( N_noxref_8_M18_noxref_s N_noxref_9_c_3201_n ) capacitor \
 c=0.00983393f //x=0.955 //y=5.02 //x2=1.11 //y2=4.7
cc_1928 ( N_noxref_8_c_2805_n N_noxref_9_M18_noxref_g ) capacitor \
 c=0.00749687f //x=1.885 //y=7.4 //x2=1.31 //y2=6.02
cc_1929 ( N_noxref_8_M18_noxref_s N_noxref_9_M18_noxref_g ) capacitor \
 c=0.053419f //x=0.955 //y=5.02 //x2=1.31 //y2=6.02
cc_1930 ( N_noxref_8_c_2805_n N_noxref_9_M19_noxref_g ) capacitor \
 c=0.00749619f //x=1.885 //y=7.4 //x2=1.75 //y2=6.02
cc_1931 ( N_noxref_8_M19_noxref_d N_noxref_9_M19_noxref_g ) capacitor \
 c=0.015318f //x=1.825 //y=5.02 //x2=1.75 //y2=6.02
cc_1932 ( N_noxref_8_c_2803_n N_noxref_9_c_3221_n ) capacitor c=0.00594885f \
 //x=0.74 //y=7.4 //x2=1.385 //y2=4.79
cc_1933 ( N_noxref_8_M18_noxref_s N_noxref_9_c_3221_n ) capacitor \
 c=0.00633107f //x=0.955 //y=5.02 //x2=1.385 //y2=4.79
cc_1934 ( N_noxref_8_c_3044_n N_noxref_15_c_3634_n ) capacitor c=0.00224736f \
 //x=24.05 //y=7.4 //x2=22.57 //y2=4.7
cc_1935 ( N_noxref_8_c_3078_p N_noxref_15_M46_noxref_g ) capacitor \
 c=0.00749619f //x=22.885 //y=7.4 //x2=22.31 //y2=6.02
cc_1936 ( N_noxref_8_M45_noxref_d N_noxref_15_M46_noxref_g ) capacitor \
 c=0.015318f //x=21.945 //y=5.02 //x2=22.31 //y2=6.02
cc_1937 ( N_noxref_8_c_3078_p N_noxref_15_M47_noxref_g ) capacitor \
 c=0.00749823f //x=22.885 //y=7.4 //x2=22.75 //y2=6.02
cc_1938 ( N_noxref_8_M47_noxref_d N_noxref_15_M47_noxref_g ) capacitor \
 c=0.0394719f //x=22.825 //y=5.02 //x2=22.75 //y2=6.02
cc_1939 ( N_noxref_8_c_3044_n N_noxref_15_c_3647_n ) capacitor c=2.63786e-19 \
 //x=24.05 //y=7.4 //x2=22.57 //y2=4.7
cc_1940 ( N_noxref_8_c_2794_n N_noxref_16_c_3714_n ) capacitor c=0.00620651f \
 //x=28.12 //y=7.4 //x2=21.53 //y2=5.155
cc_1941 ( N_noxref_8_c_2944_n N_noxref_16_c_3714_n ) capacitor c=0.00202948f \
 //x=21.125 //y=7.4 //x2=21.53 //y2=5.155
cc_1942 ( N_noxref_8_c_2984_n N_noxref_16_c_3714_n ) capacitor c=0.00177088f \
 //x=22.005 //y=7.4 //x2=21.53 //y2=5.155
cc_1943 ( N_noxref_8_M43_noxref_d N_noxref_16_c_3714_n ) capacitor \
 c=0.00700078f //x=21.065 //y=5.02 //x2=21.53 //y2=5.155
cc_1944 ( N_noxref_8_c_2794_n N_noxref_16_c_3726_n ) capacitor c=0.00626474f \
 //x=28.12 //y=7.4 //x2=22.415 //y2=5.155
cc_1945 ( N_noxref_8_c_2984_n N_noxref_16_c_3726_n ) capacitor c=0.00202948f \
 //x=22.005 //y=7.4 //x2=22.415 //y2=5.155
cc_1946 ( N_noxref_8_c_3078_p N_noxref_16_c_3726_n ) capacitor c=0.00205929f \
 //x=22.885 //y=7.4 //x2=22.415 //y2=5.155
cc_1947 ( N_noxref_8_M45_noxref_d N_noxref_16_c_3726_n ) capacitor \
 c=0.00700078f //x=21.945 //y=5.02 //x2=22.415 //y2=5.155
cc_1948 ( N_noxref_8_c_2794_n N_noxref_16_c_3758_n ) capacitor c=0.00255604f \
 //x=28.12 //y=7.4 //x2=22.53 //y2=5.38
cc_1949 ( N_noxref_8_c_3078_p N_noxref_16_c_3758_n ) capacitor c=8.49349e-19 \
 //x=22.885 //y=7.4 //x2=22.53 //y2=5.38
cc_1950 ( N_noxref_8_c_3044_n N_noxref_16_c_3758_n ) capacitor c=0.00282782f \
 //x=24.05 //y=7.4 //x2=22.53 //y2=5.38
cc_1951 ( N_noxref_8_M48_noxref_s N_noxref_16_c_3758_n ) capacitor \
 c=0.00492616f //x=25.005 //y=5.02 //x2=22.53 //y2=5.38
cc_1952 ( N_noxref_8_c_2794_n N_noxref_16_c_3743_n ) capacitor c=0.00822764f \
 //x=28.12 //y=7.4 //x2=23.225 //y2=5.155
cc_1953 ( N_noxref_8_c_3078_p N_noxref_16_c_3743_n ) capacitor c=0.00204261f \
 //x=22.885 //y=7.4 //x2=23.225 //y2=5.155
cc_1954 ( N_noxref_8_c_3097_p N_noxref_16_c_3743_n ) capacitor c=0.00183429f \
 //x=23.88 //y=7.4 //x2=23.225 //y2=5.155
cc_1955 ( N_noxref_8_M47_noxref_d N_noxref_16_c_3743_n ) capacitor \
 c=0.00700078f //x=22.825 //y=5.02 //x2=23.225 //y2=5.155
cc_1956 ( N_noxref_8_M48_noxref_s N_noxref_16_c_3743_n ) capacitor \
 c=0.00124195f //x=25.005 //y=5.02 //x2=23.225 //y2=5.155
cc_1957 ( N_noxref_8_c_3044_n N_noxref_16_c_3727_n ) capacitor c=0.0372869f \
 //x=24.05 //y=7.4 //x2=23.31 //y2=5.07
cc_1958 ( N_noxref_8_c_2794_n N_noxref_16_c_3715_n ) capacitor c=0.00261379f \
 //x=28.12 //y=7.4 //x2=20.772 //y2=5.155
cc_1959 ( N_noxref_8_c_2944_n N_noxref_16_c_3715_n ) capacitor c=9.37357e-19 \
 //x=21.125 //y=7.4 //x2=20.772 //y2=5.155
cc_1960 ( N_noxref_8_c_2954_n N_noxref_16_c_3715_n ) capacitor c=0.0022955f \
 //x=19.24 //y=7.4 //x2=20.772 //y2=5.155
cc_1961 ( N_noxref_8_M42_noxref_s N_noxref_16_c_3715_n ) capacitor \
 c=0.0442713f //x=20.195 //y=5.02 //x2=20.772 //y2=5.155
cc_1962 ( N_noxref_8_c_2794_n N_noxref_16_c_3728_n ) capacitor c=0.0026965f \
 //x=28.12 //y=7.4 //x2=21.65 //y2=5.155
cc_1963 ( N_noxref_8_c_2984_n N_noxref_16_c_3728_n ) capacitor c=9.47876e-19 \
 //x=22.005 //y=7.4 //x2=21.65 //y2=5.155
cc_1964 ( N_noxref_8_M42_noxref_s N_noxref_16_c_3728_n ) capacitor \
 c=7.80122e-19 //x=20.195 //y=5.02 //x2=21.65 //y2=5.155
cc_1965 ( N_noxref_8_M48_noxref_s N_noxref_16_c_3728_n ) capacitor \
 c=2.11884e-19 //x=25.005 //y=5.02 //x2=21.65 //y2=5.155
cc_1966 ( N_noxref_8_c_2794_n N_noxref_16_c_3718_n ) capacitor c=0.00242194f \
 //x=28.12 //y=7.4 //x2=20.77 //y2=5.38
cc_1967 ( N_noxref_8_c_2944_n N_noxref_16_c_3718_n ) capacitor c=0.0137846f \
 //x=21.125 //y=7.4 //x2=20.77 //y2=5.38
cc_1968 ( N_noxref_8_c_2954_n N_noxref_16_c_3718_n ) capacitor c=0.00509469f \
 //x=19.24 //y=7.4 //x2=20.77 //y2=5.38
cc_1969 ( N_noxref_8_M42_noxref_s N_noxref_16_c_3718_n ) capacitor c=0.09305f \
 //x=20.195 //y=5.02 //x2=20.77 //y2=5.38
cc_1970 ( N_noxref_8_M43_noxref_d N_noxref_16_c_3718_n ) capacitor \
 c=0.0674491f //x=21.065 //y=5.02 //x2=20.77 //y2=5.38
cc_1971 ( N_noxref_8_c_2794_n N_noxref_16_c_3734_n ) capacitor c=0.00242194f \
 //x=28.12 //y=7.4 //x2=21.65 //y2=5.38
cc_1972 ( N_noxref_8_c_2984_n N_noxref_16_c_3734_n ) capacitor c=0.0137846f \
 //x=22.005 //y=7.4 //x2=21.65 //y2=5.38
cc_1973 ( N_noxref_8_M43_noxref_d N_noxref_16_c_3734_n ) capacitor \
 c=0.0674762f //x=21.065 //y=5.02 //x2=21.65 //y2=5.38
cc_1974 ( N_noxref_8_M45_noxref_d N_noxref_16_c_3734_n ) capacitor c=0.067493f \
 //x=21.945 //y=5.02 //x2=21.65 //y2=5.38
cc_1975 ( N_noxref_8_c_2794_n N_noxref_16_c_3785_n ) capacitor c=0.00242194f \
 //x=28.12 //y=7.4 //x2=22.53 //y2=5.38
cc_1976 ( N_noxref_8_c_3078_p N_noxref_16_c_3785_n ) capacitor c=0.0137846f \
 //x=22.885 //y=7.4 //x2=22.53 //y2=5.38
cc_1977 ( N_noxref_8_c_3044_n N_noxref_16_c_3785_n ) capacitor c=0.00777981f \
 //x=24.05 //y=7.4 //x2=22.53 //y2=5.38
cc_1978 ( N_noxref_8_M45_noxref_d N_noxref_16_c_3785_n ) capacitor \
 c=0.0674979f //x=21.945 //y=5.02 //x2=22.53 //y2=5.38
cc_1979 ( N_noxref_8_M47_noxref_d N_noxref_16_c_3785_n ) capacitor \
 c=0.0675002f //x=22.825 //y=5.02 //x2=22.53 //y2=5.38
cc_1980 ( N_noxref_8_M18_noxref_s N_noxref_17_c_4060_n ) capacitor \
 c=5.21561e-19 //x=0.955 //y=5.02 //x2=1.075 //y2=0.965
cc_1981 ( N_noxref_8_M48_noxref_s N_noxref_17_c_4034_n ) capacitor \
 c=6.41086e-19 //x=25.005 //y=5.02 //x2=25.125 //y2=0.965
cc_1982 ( N_noxref_8_c_2803_n N_noxref_17_c_4062_n ) capacitor c=0.00989031f \
 //x=0.74 //y=7.4 //x2=0.74 //y2=0
cc_1983 ( N_noxref_8_c_3030_n N_noxref_17_c_4050_n ) capacitor c=0.00989031f \
 //x=28.12 //y=7.4 //x2=28.12 //y2=0
cc_1984 ( N_noxref_8_c_2821_n N_noxref_17_c_3887_n ) capacitor c=0.00912128f \
 //x=4.81 //y=7.4 //x2=4.81 //y2=0
cc_1985 ( N_noxref_8_c_2827_n N_noxref_17_c_3900_n ) capacitor c=0.009036f \
 //x=9.62 //y=7.4 //x2=9.62 //y2=0
cc_1986 ( N_noxref_8_c_2881_n N_noxref_17_c_3943_n ) capacitor c=0.00897238f \
 //x=14.43 //y=7.4 //x2=14.43 //y2=0
cc_1987 ( N_noxref_8_c_2954_n N_noxref_17_c_3994_n ) capacitor c=0.00897238f \
 //x=19.24 //y=7.4 //x2=19.24 //y2=0
cc_1988 ( N_noxref_8_c_3044_n N_noxref_17_c_4037_n ) capacitor c=0.00897238f \
 //x=24.05 //y=7.4 //x2=24.05 //y2=0
cc_1989 ( N_noxref_8_c_3044_n N_noxref_18_c_4356_n ) capacitor c=0.0147448f \
 //x=24.05 //y=7.4 //x2=25.16 //y2=4.575
cc_1990 ( N_noxref_8_M48_noxref_s N_noxref_18_c_4356_n ) capacitor \
 c=0.0227567f //x=25.005 //y=5.02 //x2=25.16 //y2=4.575
cc_1991 ( N_noxref_8_c_3044_n N_noxref_18_c_4368_n ) capacitor c=0.00370784f \
 //x=24.05 //y=7.4 //x2=25.16 //y2=4.7
cc_1992 ( N_noxref_8_M48_noxref_s N_noxref_18_c_4368_n ) capacitor \
 c=0.00911304f //x=25.005 //y=5.02 //x2=25.16 //y2=4.7
cc_1993 ( N_noxref_8_c_3136_p N_noxref_18_M48_noxref_g ) capacitor \
 c=0.00749687f //x=25.935 //y=7.4 //x2=25.36 //y2=6.02
cc_1994 ( N_noxref_8_M48_noxref_s N_noxref_18_M48_noxref_g ) capacitor \
 c=0.053419f //x=25.005 //y=5.02 //x2=25.36 //y2=6.02
cc_1995 ( N_noxref_8_c_3136_p N_noxref_18_M49_noxref_g ) capacitor \
 c=0.00749619f //x=25.935 //y=7.4 //x2=25.8 //y2=6.02
cc_1996 ( N_noxref_8_M49_noxref_d N_noxref_18_M49_noxref_g ) capacitor \
 c=0.015318f //x=25.875 //y=5.02 //x2=25.8 //y2=6.02
cc_1997 ( N_noxref_8_c_3044_n N_noxref_18_c_4388_n ) capacitor c=0.00590568f \
 //x=24.05 //y=7.4 //x2=25.435 //y2=4.79
cc_1998 ( N_noxref_8_M48_noxref_s N_noxref_18_c_4388_n ) capacitor \
 c=0.00611794f //x=25.005 //y=5.02 //x2=25.435 //y2=4.79
cc_1999 ( N_noxref_8_c_2794_n N_noxref_20_c_4514_n ) capacitor c=0.00620617f \
 //x=28.12 //y=7.4 //x2=26.34 //y2=5.155
cc_2000 ( N_noxref_8_c_3136_p N_noxref_20_c_4514_n ) capacitor c=0.00202948f \
 //x=25.935 //y=7.4 //x2=26.34 //y2=5.155
cc_2001 ( N_noxref_8_c_2996_n N_noxref_20_c_4514_n ) capacitor c=0.00177088f \
 //x=26.815 //y=7.4 //x2=26.34 //y2=5.155
cc_2002 ( N_noxref_8_M49_noxref_d N_noxref_20_c_4514_n ) capacitor \
 c=0.00700078f //x=25.875 //y=5.02 //x2=26.34 //y2=5.155
cc_2003 ( N_noxref_8_c_2794_n N_noxref_20_c_4519_n ) capacitor c=0.00626467f \
 //x=28.12 //y=7.4 //x2=27.225 //y2=5.155
cc_2004 ( N_noxref_8_c_2996_n N_noxref_20_c_4519_n ) capacitor c=0.00202948f \
 //x=26.815 //y=7.4 //x2=27.225 //y2=5.155
cc_2005 ( N_noxref_8_c_3028_n N_noxref_20_c_4519_n ) capacitor c=0.00205929f \
 //x=27.695 //y=7.4 //x2=27.225 //y2=5.155
cc_2006 ( N_noxref_8_M51_noxref_d N_noxref_20_c_4519_n ) capacitor \
 c=0.00700078f //x=26.755 //y=5.02 //x2=27.225 //y2=5.155
cc_2007 ( N_noxref_8_c_2794_n N_noxref_20_c_4535_n ) capacitor c=0.00255587f \
 //x=28.12 //y=7.4 //x2=27.34 //y2=5.38
cc_2008 ( N_noxref_8_c_3028_n N_noxref_20_c_4535_n ) capacitor c=8.49349e-19 \
 //x=27.695 //y=7.4 //x2=27.34 //y2=5.38
cc_2009 ( N_noxref_8_c_3030_n N_noxref_20_c_4535_n ) capacitor c=0.00414616f \
 //x=28.12 //y=7.4 //x2=27.34 //y2=5.38
cc_2010 ( N_noxref_8_c_2794_n N_noxref_20_c_4537_n ) capacitor c=0.00822764f \
 //x=28.12 //y=7.4 //x2=28.035 //y2=5.155
cc_2011 ( N_noxref_8_c_3028_n N_noxref_20_c_4537_n ) capacitor c=0.00205506f \
 //x=27.695 //y=7.4 //x2=28.035 //y2=5.155
cc_2012 ( N_noxref_8_c_3030_n N_noxref_20_c_4537_n ) capacitor c=0.00226495f \
 //x=28.12 //y=7.4 //x2=28.035 //y2=5.155
cc_2013 ( N_noxref_8_M53_noxref_d N_noxref_20_c_4537_n ) capacitor \
 c=0.00775668f //x=27.635 //y=5.02 //x2=28.035 //y2=5.155
cc_2014 ( N_noxref_8_c_3030_n N_noxref_20_c_4520_n ) capacitor c=0.0398466f \
 //x=28.12 //y=7.4 //x2=28.12 //y2=5.07
cc_2015 ( N_noxref_8_c_2794_n N_noxref_20_c_4565_n ) capacitor c=0.00261379f \
 //x=28.12 //y=7.4 //x2=25.582 //y2=5.155
cc_2016 ( N_noxref_8_c_3136_p N_noxref_20_c_4565_n ) capacitor c=9.37357e-19 \
 //x=25.935 //y=7.4 //x2=25.582 //y2=5.155
cc_2017 ( N_noxref_8_c_3044_n N_noxref_20_c_4565_n ) capacitor c=0.0022955f \
 //x=24.05 //y=7.4 //x2=25.582 //y2=5.155
cc_2018 ( N_noxref_8_M48_noxref_s N_noxref_20_c_4565_n ) capacitor \
 c=0.0442713f //x=25.005 //y=5.02 //x2=25.582 //y2=5.155
cc_2019 ( N_noxref_8_c_2794_n N_noxref_20_c_4522_n ) capacitor c=0.0026965f \
 //x=28.12 //y=7.4 //x2=26.46 //y2=5.155
cc_2020 ( N_noxref_8_c_2996_n N_noxref_20_c_4522_n ) capacitor c=9.47876e-19 \
 //x=26.815 //y=7.4 //x2=26.46 //y2=5.155
cc_2021 ( N_noxref_8_M48_noxref_s N_noxref_20_c_4522_n ) capacitor \
 c=7.80122e-19 //x=25.005 //y=5.02 //x2=26.46 //y2=5.155
cc_2022 ( N_noxref_8_c_2794_n N_noxref_20_c_4604_n ) capacitor c=0.00242194f \
 //x=28.12 //y=7.4 //x2=25.58 //y2=5.38
cc_2023 ( N_noxref_8_c_3136_p N_noxref_20_c_4604_n ) capacitor c=0.0137846f \
 //x=25.935 //y=7.4 //x2=25.58 //y2=5.38
cc_2024 ( N_noxref_8_c_3044_n N_noxref_20_c_4604_n ) capacitor c=0.00509469f \
 //x=24.05 //y=7.4 //x2=25.58 //y2=5.38
cc_2025 ( N_noxref_8_M48_noxref_s N_noxref_20_c_4604_n ) capacitor c=0.09305f \
 //x=25.005 //y=5.02 //x2=25.58 //y2=5.38
cc_2026 ( N_noxref_8_M49_noxref_d N_noxref_20_c_4604_n ) capacitor \
 c=0.0674491f //x=25.875 //y=5.02 //x2=25.58 //y2=5.38
cc_2027 ( N_noxref_8_c_2794_n N_noxref_20_c_4528_n ) capacitor c=0.00242194f \
 //x=28.12 //y=7.4 //x2=26.46 //y2=5.38
cc_2028 ( N_noxref_8_c_2996_n N_noxref_20_c_4528_n ) capacitor c=0.0137846f \
 //x=26.815 //y=7.4 //x2=26.46 //y2=5.38
cc_2029 ( N_noxref_8_M49_noxref_d N_noxref_20_c_4528_n ) capacitor \
 c=0.0674762f //x=25.875 //y=5.02 //x2=26.46 //y2=5.38
cc_2030 ( N_noxref_8_M51_noxref_d N_noxref_20_c_4528_n ) capacitor c=0.067493f \
 //x=26.755 //y=5.02 //x2=26.46 //y2=5.38
cc_2031 ( N_noxref_8_c_2794_n N_noxref_20_c_4570_n ) capacitor c=0.00242194f \
 //x=28.12 //y=7.4 //x2=27.34 //y2=5.38
cc_2032 ( N_noxref_8_c_3028_n N_noxref_20_c_4570_n ) capacitor c=0.0134886f \
 //x=27.695 //y=7.4 //x2=27.34 //y2=5.38
cc_2033 ( N_noxref_8_c_3030_n N_noxref_20_c_4570_n ) capacitor c=0.00778106f \
 //x=28.12 //y=7.4 //x2=27.34 //y2=5.38
cc_2034 ( N_noxref_8_M51_noxref_d N_noxref_20_c_4570_n ) capacitor \
 c=0.0675031f //x=26.755 //y=5.02 //x2=27.34 //y2=5.38
cc_2035 ( N_noxref_8_M53_noxref_d N_noxref_20_c_4570_n ) capacitor \
 c=0.0675091f //x=27.635 //y=5.02 //x2=27.34 //y2=5.38
cc_2036 ( N_noxref_9_c_3207_n N_noxref_17_c_4069_n ) capacitor c=3.97665e-19 \
 //x=0.81 //y=0.875 //x2=1.075 //y2=0.835
cc_2037 ( N_noxref_9_c_3235_p N_noxref_17_c_4069_n ) capacitor c=0.00864609f \
 //x=1.185 //y=0.72 //x2=1.075 //y2=0.835
cc_2038 ( N_noxref_9_c_3213_n N_noxref_17_c_4069_n ) capacitor c=4.45447e-19 \
 //x=1.34 //y=0.875 //x2=1.075 //y2=0.835
cc_2039 ( N_noxref_9_c_3188_n N_noxref_17_c_4060_n ) capacitor c=0.00849484f \
 //x=1.11 //y=2.195 //x2=1.075 //y2=0.965
cc_2040 ( N_noxref_9_c_3198_n N_noxref_17_c_4060_n ) capacitor c=2.22861e-19 \
 //x=1.11 //y=2.08 //x2=1.075 //y2=0.965
cc_2041 ( N_noxref_9_c_3207_n N_noxref_17_c_4060_n ) capacitor c=0.00142616f \
 //x=0.81 //y=0.875 //x2=1.075 //y2=0.965
cc_2042 ( N_noxref_9_c_3208_n N_noxref_17_c_4060_n ) capacitor c=0.00411286f \
 //x=0.81 //y=1.22 //x2=1.075 //y2=0.965
cc_2043 ( N_noxref_9_c_3209_n N_noxref_17_c_4060_n ) capacitor c=4.86145e-19 \
 //x=0.81 //y=1.53 //x2=1.075 //y2=0.965
cc_2044 ( N_noxref_9_c_3235_p N_noxref_17_c_4060_n ) capacitor c=7.3749e-19 \
 //x=1.185 //y=0.72 //x2=1.075 //y2=0.965
cc_2045 ( N_noxref_9_c_3243_p N_noxref_17_c_4060_n ) capacitor c=6.35695e-19 \
 //x=1.185 //y=1.375 //x2=1.075 //y2=0.965
cc_2046 ( N_noxref_9_c_3213_n N_noxref_17_c_4060_n ) capacitor c=0.0017438f \
 //x=1.34 //y=0.875 //x2=1.075 //y2=0.965
cc_2047 ( N_noxref_9_c_3215_n N_noxref_17_c_4060_n ) capacitor c=0.00276804f \
 //x=1.34 //y=1.22 //x2=1.075 //y2=0.965
cc_2048 ( N_noxref_9_c_3207_n N_noxref_17_c_3883_n ) capacitor c=0.00678001f \
 //x=0.81 //y=0.875 //x2=4.64 //y2=0
cc_2049 ( N_noxref_9_c_3188_n N_noxref_17_c_4062_n ) capacitor c=0.00779049f \
 //x=1.11 //y=2.195 //x2=0.74 //y2=0
cc_2050 ( N_noxref_9_c_3186_n N_noxref_17_c_4062_n ) capacitor c=0.0125306f \
 //x=1.11 //y=4.575 //x2=0.74 //y2=0
cc_2051 ( N_noxref_9_c_3198_n N_noxref_17_c_4062_n ) capacitor c=0.00394776f \
 //x=1.11 //y=2.08 //x2=0.74 //y2=0
cc_2052 ( N_noxref_9_c_3209_n N_noxref_17_c_4062_n ) capacitor c=0.00295461f \
 //x=0.81 //y=1.53 //x2=0.74 //y2=0
cc_2053 ( N_noxref_9_c_3210_n N_noxref_17_c_4062_n ) capacitor c=0.0112432f \
 //x=0.81 //y=1.915 //x2=0.74 //y2=0
cc_2054 ( N_noxref_9_c_3188_n N_noxref_17_M0_noxref_d ) capacitor c=4.4417e-19 \
 //x=1.11 //y=2.195 //x2=0.885 //y2=0.875
cc_2055 ( N_noxref_9_c_3207_n N_noxref_17_M0_noxref_d ) capacitor \
 c=0.00184354f //x=0.81 //y=0.875 //x2=0.885 //y2=0.875
cc_2056 ( N_noxref_9_c_3208_n N_noxref_17_M0_noxref_d ) capacitor \
 c=0.00210798f //x=0.81 //y=1.22 //x2=0.885 //y2=0.875
cc_2057 ( N_noxref_9_c_3235_p N_noxref_17_M0_noxref_d ) capacitor \
 c=0.00474029f //x=1.185 //y=0.72 //x2=0.885 //y2=0.875
cc_2058 ( N_noxref_9_c_3243_p N_noxref_17_M0_noxref_d ) capacitor \
 c=0.00166857f //x=1.185 //y=1.375 //x2=0.885 //y2=0.875
cc_2059 ( N_noxref_9_c_3213_n N_noxref_17_M0_noxref_d ) capacitor \
 c=0.00230174f //x=1.34 //y=0.875 //x2=0.885 //y2=0.875
cc_2060 ( N_noxref_9_c_3215_n N_noxref_17_M0_noxref_d ) capacitor \
 c=0.00210798f //x=1.34 //y=1.22 //x2=0.885 //y2=0.875
cc_2061 ( N_noxref_9_c_3210_n N_noxref_21_c_4654_n ) capacitor c=0.00267608f \
 //x=0.81 //y=1.915 //x2=0.59 //y2=1.505
cc_2062 ( N_noxref_9_c_3188_n N_noxref_21_c_4655_n ) capacitor c=0.00428451f \
 //x=1.11 //y=2.195 //x2=1.475 //y2=1.59
cc_2063 ( N_noxref_9_c_3186_n N_noxref_21_c_4655_n ) capacitor c=3.1252e-19 \
 //x=1.11 //y=4.575 //x2=1.475 //y2=1.59
cc_2064 ( N_noxref_9_c_3198_n N_noxref_21_c_4655_n ) capacitor c=0.0104666f \
 //x=1.11 //y=2.08 //x2=1.475 //y2=1.59
cc_2065 ( N_noxref_9_c_3209_n N_noxref_21_c_4655_n ) capacitor c=0.00703864f \
 //x=0.81 //y=1.53 //x2=1.475 //y2=1.59
cc_2066 ( N_noxref_9_c_3210_n N_noxref_21_c_4655_n ) capacitor c=0.0232409f \
 //x=0.81 //y=1.915 //x2=1.475 //y2=1.59
cc_2067 ( N_noxref_9_c_3243_p N_noxref_21_c_4655_n ) capacitor c=0.00588627f \
 //x=1.185 //y=1.375 //x2=1.475 //y2=1.59
cc_2068 ( N_noxref_9_c_3215_n N_noxref_21_c_4655_n ) capacitor c=0.00758305f \
 //x=1.34 //y=1.22 //x2=1.475 //y2=1.59
cc_2069 ( N_noxref_9_c_3207_n N_noxref_21_M0_noxref_s ) capacitor c=0.0295256f \
 //x=0.81 //y=0.875 //x2=0.455 //y2=0.375
cc_2070 ( N_noxref_9_c_3209_n N_noxref_21_M0_noxref_s ) capacitor \
 c=7.99997e-19 //x=0.81 //y=1.53 //x2=0.455 //y2=0.375
cc_2071 ( N_noxref_9_c_3210_n N_noxref_21_M0_noxref_s ) capacitor \
 c=0.00122123f //x=0.81 //y=1.915 //x2=0.455 //y2=0.375
cc_2072 ( N_noxref_9_c_3213_n N_noxref_21_M0_noxref_s ) capacitor c=0.0125924f \
 //x=1.34 //y=0.875 //x2=0.455 //y2=0.375
cc_2073 ( N_noxref_10_c_3292_n N_noxref_17_c_3852_n ) capacitor c=0.00533525f \
 //x=3.015 //y=0.995 //x2=5.8 //y2=0
cc_2074 ( N_noxref_10_c_3312_p N_noxref_17_c_3852_n ) capacitor c=0.00435457f \
 //x=3.1 //y=0.625 //x2=5.8 //y2=0
cc_2075 ( N_noxref_10_c_3271_n N_noxref_17_c_3852_n ) capacitor c=0.00957847f \
 //x=3.985 //y=0.54 //x2=5.8 //y2=0
cc_2076 ( N_noxref_10_c_3314_p N_noxref_17_c_3852_n ) capacitor c=0.00232857f \
 //x=4.07 //y=0.625 //x2=5.8 //y2=0
cc_2077 ( N_noxref_10_M1_noxref_d N_noxref_17_c_3852_n ) capacitor c=0.013236f \
 //x=1.86 //y=0.91 //x2=5.8 //y2=0
cc_2078 ( N_noxref_10_M1_noxref_d N_noxref_17_c_4060_n ) capacitor \
 c=0.0156367f //x=1.86 //y=0.91 //x2=1.075 //y2=0.965
cc_2079 ( N_noxref_10_c_3292_n N_noxref_17_c_3883_n ) capacitor c=0.00914678f \
 //x=3.015 //y=0.995 //x2=4.64 //y2=0
cc_2080 ( N_noxref_10_c_3312_p N_noxref_17_c_3883_n ) capacitor c=0.0141422f \
 //x=3.1 //y=0.625 //x2=4.64 //y2=0
cc_2081 ( N_noxref_10_c_3271_n N_noxref_17_c_3883_n ) capacitor c=0.036437f \
 //x=3.985 //y=0.54 //x2=4.64 //y2=0
cc_2082 ( N_noxref_10_c_3314_p N_noxref_17_c_3883_n ) capacitor c=0.0138658f \
 //x=4.07 //y=0.625 //x2=4.64 //y2=0
cc_2083 ( N_noxref_10_M2_noxref_s N_noxref_17_c_4062_n ) capacitor \
 c=8.16352e-19 //x=2.965 //y=0.375 //x2=0.74 //y2=0
cc_2084 ( N_noxref_10_c_3292_n N_noxref_17_c_4050_n ) capacitor c=3.54249e-19 \
 //x=3.015 //y=0.995 //x2=28.12 //y2=0
cc_2085 ( N_noxref_10_c_3271_n N_noxref_17_c_4050_n ) capacitor c=0.00283214f \
 //x=3.985 //y=0.54 //x2=28.12 //y2=0
cc_2086 ( N_noxref_10_M1_noxref_d N_noxref_17_c_4050_n ) capacitor \
 c=2.7648e-19 //x=1.86 //y=0.91 //x2=28.12 //y2=0
cc_2087 ( N_noxref_10_c_3314_p N_noxref_17_c_3887_n ) capacitor c=0.037873f \
 //x=4.07 //y=0.625 //x2=4.81 //y2=0
cc_2088 ( N_noxref_10_M2_noxref_s N_noxref_17_c_3887_n ) capacitor \
 c=0.0051897f //x=2.965 //y=0.375 //x2=4.81 //y2=0
cc_2089 ( N_noxref_10_M1_noxref_d N_noxref_17_M0_noxref_d ) capacitor \
 c=3.12752e-19 //x=1.86 //y=0.91 //x2=0.885 //y2=0.875
cc_2090 ( N_noxref_10_c_3312_p N_noxref_21_c_4666_n ) capacitor c=2.15937e-19 \
 //x=3.1 //y=0.625 //x2=1.56 //y2=0.625
cc_2091 ( N_noxref_10_c_3292_n N_noxref_21_c_4643_n ) capacitor c=0.0130708f \
 //x=3.015 //y=0.995 //x2=2.445 //y2=0.54
cc_2092 ( N_noxref_10_M1_noxref_d N_noxref_21_c_4643_n ) capacitor \
 c=0.0162022f //x=1.86 //y=0.91 //x2=2.445 //y2=0.54
cc_2093 ( N_noxref_10_c_3292_n N_noxref_21_c_4645_n ) capacitor c=0.00940919f \
 //x=3.015 //y=0.995 //x2=2.445 //y2=1.59
cc_2094 ( N_noxref_10_M1_noxref_d N_noxref_21_c_4645_n ) capacitor \
 c=0.0151199f //x=1.86 //y=0.91 //x2=2.445 //y2=1.59
cc_2095 ( N_noxref_10_c_3292_n N_noxref_21_M0_noxref_s ) capacitor \
 c=0.0223986f //x=3.015 //y=0.995 //x2=0.455 //y2=0.375
cc_2096 ( N_noxref_10_c_3312_p N_noxref_21_M0_noxref_s ) capacitor \
 c=0.0175461f //x=3.1 //y=0.625 //x2=0.455 //y2=0.375
cc_2097 ( N_noxref_10_c_3314_p N_noxref_21_M0_noxref_s ) capacitor \
 c=2.98576e-19 //x=4.07 //y=0.625 //x2=0.455 //y2=0.375
cc_2098 ( N_noxref_10_M1_noxref_d N_noxref_21_M0_noxref_s ) capacitor \
 c=0.0187969f //x=1.86 //y=0.91 //x2=0.455 //y2=0.375
cc_2099 ( N_noxref_10_M2_noxref_s N_noxref_21_M0_noxref_s ) capacitor \
 c=0.0210819f //x=2.965 //y=0.375 //x2=0.455 //y2=0.375
cc_2100 ( N_noxref_10_c_3314_p N_noxref_22_M3_noxref_s ) capacitor \
 c=0.00368328f //x=4.07 //y=0.625 //x2=5.265 //y2=0.375
cc_2101 ( N_noxref_10_M2_noxref_s N_noxref_22_M3_noxref_s ) capacitor \
 c=0.00125282f //x=2.965 //y=0.375 //x2=5.265 //y2=0.375
cc_2102 ( N_noxref_11_c_3341_n N_noxref_17_c_3962_n ) capacitor c=0.00533525f \
 //x=7.825 //y=0.995 //x2=10.61 //y2=0
cc_2103 ( N_noxref_11_c_3382_p N_noxref_17_c_3962_n ) capacitor c=0.00427243f \
 //x=7.91 //y=0.625 //x2=10.61 //y2=0
cc_2104 ( N_noxref_11_c_3356_n N_noxref_17_c_3962_n ) capacitor c=0.00960457f \
 //x=8.795 //y=0.54 //x2=10.61 //y2=0
cc_2105 ( N_noxref_11_c_3384_p N_noxref_17_c_3962_n ) capacitor c=0.00232857f \
 //x=8.88 //y=0.625 //x2=10.61 //y2=0
cc_2106 ( N_noxref_11_M4_noxref_d N_noxref_17_c_3962_n ) capacitor \
 c=0.0130904f //x=6.67 //y=0.91 //x2=10.61 //y2=0
cc_2107 ( N_noxref_11_M4_noxref_d N_noxref_17_c_3862_n ) capacitor \
 c=0.0154456f //x=6.67 //y=0.91 //x2=5.885 //y2=0.965
cc_2108 ( N_noxref_11_c_3341_n N_noxref_17_c_3885_n ) capacitor c=0.00914678f \
 //x=7.825 //y=0.995 //x2=9.45 //y2=0
cc_2109 ( N_noxref_11_c_3382_p N_noxref_17_c_3885_n ) capacitor c=0.0141422f \
 //x=7.91 //y=0.625 //x2=9.45 //y2=0
cc_2110 ( N_noxref_11_c_3356_n N_noxref_17_c_3885_n ) capacitor c=0.036437f \
 //x=8.795 //y=0.54 //x2=9.45 //y2=0
cc_2111 ( N_noxref_11_c_3384_p N_noxref_17_c_3885_n ) capacitor c=0.0138658f \
 //x=8.88 //y=0.625 //x2=9.45 //y2=0
cc_2112 ( N_noxref_11_c_3341_n N_noxref_17_c_4050_n ) capacitor c=3.54249e-19 \
 //x=7.825 //y=0.995 //x2=28.12 //y2=0
cc_2113 ( N_noxref_11_c_3356_n N_noxref_17_c_4050_n ) capacitor c=0.00283214f \
 //x=8.795 //y=0.54 //x2=28.12 //y2=0
cc_2114 ( N_noxref_11_M4_noxref_d N_noxref_17_c_4050_n ) capacitor \
 c=2.7648e-19 //x=6.67 //y=0.91 //x2=28.12 //y2=0
cc_2115 ( N_noxref_11_M5_noxref_s N_noxref_17_c_3887_n ) capacitor \
 c=8.16352e-19 //x=7.775 //y=0.375 //x2=4.81 //y2=0
cc_2116 ( N_noxref_11_c_3384_p N_noxref_17_c_3900_n ) capacitor c=0.037873f \
 //x=8.88 //y=0.625 //x2=9.62 //y2=0
cc_2117 ( N_noxref_11_M5_noxref_s N_noxref_17_c_3900_n ) capacitor \
 c=0.0051897f //x=7.775 //y=0.375 //x2=9.62 //y2=0
cc_2118 ( N_noxref_11_M4_noxref_d N_noxref_17_M3_noxref_d ) capacitor \
 c=3.12752e-19 //x=6.67 //y=0.91 //x2=5.695 //y2=0.875
cc_2119 ( N_noxref_11_c_3382_p N_noxref_22_c_4724_n ) capacitor c=2.15937e-19 \
 //x=7.91 //y=0.625 //x2=6.37 //y2=0.625
cc_2120 ( N_noxref_11_c_3341_n N_noxref_22_c_4708_n ) capacitor c=0.0130857f \
 //x=7.825 //y=0.995 //x2=7.255 //y2=0.54
cc_2121 ( N_noxref_11_M4_noxref_d N_noxref_22_c_4708_n ) capacitor \
 c=0.0160925f //x=6.67 //y=0.91 //x2=7.255 //y2=0.54
cc_2122 ( N_noxref_11_c_3341_n N_noxref_22_c_4710_n ) capacitor c=0.00944538f \
 //x=7.825 //y=0.995 //x2=7.255 //y2=1.59
cc_2123 ( N_noxref_11_M4_noxref_d N_noxref_22_c_4710_n ) capacitor \
 c=0.0152674f //x=6.67 //y=0.91 //x2=7.255 //y2=1.59
cc_2124 ( N_noxref_11_c_3341_n N_noxref_22_M3_noxref_s ) capacitor \
 c=0.0223986f //x=7.825 //y=0.995 //x2=5.265 //y2=0.375
cc_2125 ( N_noxref_11_c_3382_p N_noxref_22_M3_noxref_s ) capacitor \
 c=0.0175461f //x=7.91 //y=0.625 //x2=5.265 //y2=0.375
cc_2126 ( N_noxref_11_c_3384_p N_noxref_22_M3_noxref_s ) capacitor \
 c=2.98576e-19 //x=8.88 //y=0.625 //x2=5.265 //y2=0.375
cc_2127 ( N_noxref_11_M4_noxref_d N_noxref_22_M3_noxref_s ) capacitor \
 c=0.0187685f //x=6.67 //y=0.91 //x2=5.265 //y2=0.375
cc_2128 ( N_noxref_11_M5_noxref_s N_noxref_22_M3_noxref_s ) capacitor \
 c=0.0210819f //x=7.775 //y=0.375 //x2=5.265 //y2=0.375
cc_2129 ( N_noxref_11_c_3384_p N_noxref_23_M6_noxref_s ) capacitor \
 c=0.00368328f //x=8.88 //y=0.625 //x2=10.075 //y2=0.375
cc_2130 ( N_noxref_11_M5_noxref_s N_noxref_23_M6_noxref_s ) capacitor \
 c=0.00125282f //x=7.775 //y=0.375 //x2=10.075 //y2=0.375
cc_2131 ( N_noxref_12_c_3422_n N_noxref_17_c_3922_n ) capacitor c=0.00533525f \
 //x=12.635 //y=0.995 //x2=15.42 //y2=0
cc_2132 ( N_noxref_12_c_3453_p N_noxref_17_c_3922_n ) capacitor c=0.003389f \
 //x=12.72 //y=0.625 //x2=15.42 //y2=0
cc_2133 ( N_noxref_12_c_3410_n N_noxref_17_c_3922_n ) capacitor c=0.00960457f \
 //x=13.605 //y=0.54 //x2=15.42 //y2=0
cc_2134 ( N_noxref_12_c_3455_p N_noxref_17_c_3922_n ) capacitor c=0.00232857f \
 //x=13.69 //y=0.625 //x2=15.42 //y2=0
cc_2135 ( N_noxref_12_M7_noxref_d N_noxref_17_c_3922_n ) capacitor \
 c=0.0130904f //x=11.48 //y=0.91 //x2=15.42 //y2=0
cc_2136 ( N_noxref_12_M7_noxref_d N_noxref_17_c_3873_n ) capacitor \
 c=0.0154456f //x=11.48 //y=0.91 //x2=10.695 //y2=0.965
cc_2137 ( N_noxref_12_c_3422_n N_noxref_17_c_3886_n ) capacitor c=0.00914678f \
 //x=12.635 //y=0.995 //x2=14.26 //y2=0
cc_2138 ( N_noxref_12_c_3453_p N_noxref_17_c_3886_n ) capacitor c=0.0141422f \
 //x=12.72 //y=0.625 //x2=14.26 //y2=0
cc_2139 ( N_noxref_12_c_3410_n N_noxref_17_c_3886_n ) capacitor c=0.036437f \
 //x=13.605 //y=0.54 //x2=14.26 //y2=0
cc_2140 ( N_noxref_12_c_3455_p N_noxref_17_c_3886_n ) capacitor c=0.0138658f \
 //x=13.69 //y=0.625 //x2=14.26 //y2=0
cc_2141 ( N_noxref_12_c_3422_n N_noxref_17_c_4050_n ) capacitor c=3.54249e-19 \
 //x=12.635 //y=0.995 //x2=28.12 //y2=0
cc_2142 ( N_noxref_12_c_3410_n N_noxref_17_c_4050_n ) capacitor c=0.00283214f \
 //x=13.605 //y=0.54 //x2=28.12 //y2=0
cc_2143 ( N_noxref_12_M7_noxref_d N_noxref_17_c_4050_n ) capacitor \
 c=2.7648e-19 //x=11.48 //y=0.91 //x2=28.12 //y2=0
cc_2144 ( N_noxref_12_M8_noxref_s N_noxref_17_c_3900_n ) capacitor \
 c=8.16352e-19 //x=12.585 //y=0.375 //x2=9.62 //y2=0
cc_2145 ( N_noxref_12_c_3455_p N_noxref_17_c_3943_n ) capacitor c=0.037873f \
 //x=13.69 //y=0.625 //x2=14.43 //y2=0
cc_2146 ( N_noxref_12_M8_noxref_s N_noxref_17_c_3943_n ) capacitor \
 c=0.0051897f //x=12.585 //y=0.375 //x2=14.43 //y2=0
cc_2147 ( N_noxref_12_M7_noxref_d N_noxref_17_M6_noxref_d ) capacitor \
 c=3.12752e-19 //x=11.48 //y=0.91 //x2=10.505 //y2=0.875
cc_2148 ( N_noxref_12_c_3453_p N_noxref_23_c_4783_n ) capacitor c=2.15937e-19 \
 //x=12.72 //y=0.625 //x2=11.18 //y2=0.625
cc_2149 ( N_noxref_12_c_3422_n N_noxref_23_c_4770_n ) capacitor c=0.0130857f \
 //x=12.635 //y=0.995 //x2=12.065 //y2=0.54
cc_2150 ( N_noxref_12_M7_noxref_d N_noxref_23_c_4770_n ) capacitor \
 c=0.0160925f //x=11.48 //y=0.91 //x2=12.065 //y2=0.54
cc_2151 ( N_noxref_12_c_3422_n N_noxref_23_c_4768_n ) capacitor c=0.00944538f \
 //x=12.635 //y=0.995 //x2=12.065 //y2=1.59
cc_2152 ( N_noxref_12_M7_noxref_d N_noxref_23_c_4768_n ) capacitor \
 c=0.0151784f //x=11.48 //y=0.91 //x2=12.065 //y2=1.59
cc_2153 ( N_noxref_12_c_3422_n N_noxref_23_M6_noxref_s ) capacitor \
 c=0.0223986f //x=12.635 //y=0.995 //x2=10.075 //y2=0.375
cc_2154 ( N_noxref_12_c_3453_p N_noxref_23_M6_noxref_s ) capacitor \
 c=0.0175461f //x=12.72 //y=0.625 //x2=10.075 //y2=0.375
cc_2155 ( N_noxref_12_c_3455_p N_noxref_23_M6_noxref_s ) capacitor \
 c=2.98576e-19 //x=13.69 //y=0.625 //x2=10.075 //y2=0.375
cc_2156 ( N_noxref_12_M7_noxref_d N_noxref_23_M6_noxref_s ) capacitor \
 c=0.0187685f //x=11.48 //y=0.91 //x2=10.075 //y2=0.375
cc_2157 ( N_noxref_12_M8_noxref_s N_noxref_23_M6_noxref_s ) capacitor \
 c=0.0210819f //x=12.585 //y=0.375 //x2=10.075 //y2=0.375
cc_2158 ( N_noxref_12_c_3455_p N_noxref_24_M9_noxref_s ) capacitor \
 c=0.00368328f //x=13.69 //y=0.625 //x2=14.885 //y2=0.375
cc_2159 ( N_noxref_12_M8_noxref_s N_noxref_24_M9_noxref_s ) capacitor \
 c=0.00125282f //x=12.585 //y=0.375 //x2=14.885 //y2=0.375
cc_2160 ( N_noxref_13_c_3482_n N_noxref_17_c_3963_n ) capacitor c=0.00533525f \
 //x=17.445 //y=0.995 //x2=20.23 //y2=0
cc_2161 ( N_noxref_13_c_3523_p N_noxref_17_c_3963_n ) capacitor c=0.00428935f \
 //x=17.53 //y=0.625 //x2=20.23 //y2=0
cc_2162 ( N_noxref_13_c_3498_n N_noxref_17_c_3963_n ) capacitor c=0.00948755f \
 //x=18.415 //y=0.54 //x2=20.23 //y2=0
cc_2163 ( N_noxref_13_c_3525_p N_noxref_17_c_3963_n ) capacitor c=0.00232857f \
 //x=18.5 //y=0.625 //x2=20.23 //y2=0
cc_2164 ( N_noxref_13_M10_noxref_d N_noxref_17_c_3963_n ) capacitor \
 c=0.0130904f //x=16.29 //y=0.91 //x2=20.23 //y2=0
cc_2165 ( N_noxref_13_M10_noxref_d N_noxref_17_c_3929_n ) capacitor \
 c=0.0154456f //x=16.29 //y=0.91 //x2=15.505 //y2=0.965
cc_2166 ( N_noxref_13_c_3482_n N_noxref_17_c_3942_n ) capacitor c=0.00914678f \
 //x=17.445 //y=0.995 //x2=19.07 //y2=0
cc_2167 ( N_noxref_13_c_3523_p N_noxref_17_c_3942_n ) capacitor c=0.0141383f \
 //x=17.53 //y=0.625 //x2=19.07 //y2=0
cc_2168 ( N_noxref_13_c_3498_n N_noxref_17_c_3942_n ) capacitor c=0.0364283f \
 //x=18.415 //y=0.54 //x2=19.07 //y2=0
cc_2169 ( N_noxref_13_c_3525_p N_noxref_17_c_3942_n ) capacitor c=0.0138658f \
 //x=18.5 //y=0.625 //x2=19.07 //y2=0
cc_2170 ( N_noxref_13_c_3482_n N_noxref_17_c_4050_n ) capacitor c=3.54249e-19 \
 //x=17.445 //y=0.995 //x2=28.12 //y2=0
cc_2171 ( N_noxref_13_c_3498_n N_noxref_17_c_4050_n ) capacitor c=0.00283214f \
 //x=18.415 //y=0.54 //x2=28.12 //y2=0
cc_2172 ( N_noxref_13_M10_noxref_d N_noxref_17_c_4050_n ) capacitor \
 c=2.7648e-19 //x=16.29 //y=0.91 //x2=28.12 //y2=0
cc_2173 ( N_noxref_13_M11_noxref_s N_noxref_17_c_3943_n ) capacitor \
 c=8.16352e-19 //x=17.395 //y=0.375 //x2=14.43 //y2=0
cc_2174 ( N_noxref_13_c_3525_p N_noxref_17_c_3994_n ) capacitor c=0.037873f \
 //x=18.5 //y=0.625 //x2=19.24 //y2=0
cc_2175 ( N_noxref_13_M11_noxref_s N_noxref_17_c_3994_n ) capacitor \
 c=0.0051897f //x=17.395 //y=0.375 //x2=19.24 //y2=0
cc_2176 ( N_noxref_13_M10_noxref_d N_noxref_17_M9_noxref_d ) capacitor \
 c=3.12752e-19 //x=16.29 //y=0.91 //x2=15.315 //y2=0.875
cc_2177 ( N_noxref_13_c_3523_p N_noxref_24_c_4843_n ) capacitor c=2.15937e-19 \
 //x=17.53 //y=0.625 //x2=15.99 //y2=0.625
cc_2178 ( N_noxref_13_c_3482_n N_noxref_24_c_4825_n ) capacitor c=0.0130857f \
 //x=17.445 //y=0.995 //x2=16.875 //y2=0.54
cc_2179 ( N_noxref_13_M10_noxref_d N_noxref_24_c_4825_n ) capacitor \
 c=0.0160925f //x=16.29 //y=0.91 //x2=16.875 //y2=0.54
cc_2180 ( N_noxref_13_c_3482_n N_noxref_24_c_4827_n ) capacitor c=0.00944538f \
 //x=17.445 //y=0.995 //x2=16.875 //y2=1.59
cc_2181 ( N_noxref_13_M10_noxref_d N_noxref_24_c_4827_n ) capacitor \
 c=0.0152727f //x=16.29 //y=0.91 //x2=16.875 //y2=1.59
cc_2182 ( N_noxref_13_c_3482_n N_noxref_24_M9_noxref_s ) capacitor \
 c=0.0223986f //x=17.445 //y=0.995 //x2=14.885 //y2=0.375
cc_2183 ( N_noxref_13_c_3523_p N_noxref_24_M9_noxref_s ) capacitor \
 c=0.0175461f //x=17.53 //y=0.625 //x2=14.885 //y2=0.375
cc_2184 ( N_noxref_13_c_3525_p N_noxref_24_M9_noxref_s ) capacitor \
 c=2.98576e-19 //x=18.5 //y=0.625 //x2=14.885 //y2=0.375
cc_2185 ( N_noxref_13_M10_noxref_d N_noxref_24_M9_noxref_s ) capacitor \
 c=0.0187685f //x=16.29 //y=0.91 //x2=14.885 //y2=0.375
cc_2186 ( N_noxref_13_M11_noxref_s N_noxref_24_M9_noxref_s ) capacitor \
 c=0.0210819f //x=17.395 //y=0.375 //x2=14.885 //y2=0.375
cc_2187 ( N_noxref_13_c_3525_p N_noxref_25_M12_noxref_s ) capacitor \
 c=0.00368328f //x=18.5 //y=0.625 //x2=19.695 //y2=0.375
cc_2188 ( N_noxref_13_M11_noxref_s N_noxref_25_M12_noxref_s ) capacitor \
 c=0.00125282f //x=17.395 //y=0.375 //x2=19.695 //y2=0.375
cc_2189 ( N_noxref_14_c_3571_p N_noxref_15_c_3622_n ) capacitor c=0.00171317f \
 //x=23.225 //y=0.54 //x2=22.57 //y2=2.195
cc_2190 ( N_noxref_14_c_3571_p N_noxref_15_c_3631_n ) capacitor c=0.00117306f \
 //x=23.225 //y=0.54 //x2=22.57 //y2=2.08
cc_2191 ( N_noxref_14_c_3571_p N_noxref_15_c_3640_n ) capacitor c=0.0205874f \
 //x=23.225 //y=0.54 //x2=22.56 //y2=0.915
cc_2192 ( N_noxref_14_M14_noxref_s N_noxref_15_c_3640_n ) capacitor \
 c=0.0071177f //x=22.205 //y=0.375 //x2=22.56 //y2=0.915
cc_2193 ( N_noxref_14_c_3575_p N_noxref_15_c_3641_n ) capacitor c=0.0071177f \
 //x=22.34 //y=0.995 //x2=22.56 //y2=1.26
cc_2194 ( N_noxref_14_M14_noxref_s N_noxref_15_c_3642_n ) capacitor \
 c=0.0071177f //x=22.205 //y=0.375 //x2=22.56 //y2=1.57
cc_2195 ( N_noxref_14_c_3571_p N_noxref_15_c_3666_n ) capacitor c=0.00825432f \
 //x=23.225 //y=0.54 //x2=23.09 //y2=0.915
cc_2196 ( N_noxref_14_M14_noxref_s N_noxref_15_c_3666_n ) capacitor \
 c=0.015333f //x=22.205 //y=0.375 //x2=23.09 //y2=0.915
cc_2197 ( N_noxref_14_M14_noxref_s N_noxref_15_c_3668_n ) capacitor \
 c=0.00248746f //x=22.205 //y=0.375 //x2=23.09 //y2=1.26
cc_2198 ( N_noxref_14_c_3571_p N_noxref_15_c_3643_n ) capacitor c=2.20712e-19 \
 //x=23.225 //y=0.54 //x2=22.57 //y2=2.08
cc_2199 ( N_noxref_14_M13_noxref_d N_noxref_16_c_3714_n ) capacitor \
 c=0.0013303f //x=21.1 //y=0.91 //x2=21.53 //y2=5.155
cc_2200 ( N_noxref_14_c_3571_p N_noxref_16_c_3738_n ) capacitor c=0.00361816f \
 //x=23.225 //y=0.54 //x2=22.825 //y2=1.125
cc_2201 ( N_noxref_14_M13_noxref_d N_noxref_16_c_3738_n ) capacitor \
 c=0.00802417f //x=21.1 //y=0.91 //x2=22.825 //y2=1.125
cc_2202 ( N_noxref_14_M14_noxref_s N_noxref_16_c_3738_n ) capacitor \
 c=0.0098487f //x=22.205 //y=0.375 //x2=22.825 //y2=1.125
cc_2203 ( N_noxref_14_M14_noxref_s N_noxref_16_c_3794_n ) capacitor \
 c=0.0283243f //x=22.205 //y=0.375 //x2=22.825 //y2=1.58
cc_2204 ( N_noxref_14_c_3571_p N_noxref_16_c_3795_n ) capacitor c=0.00362807f \
 //x=23.225 //y=0.54 //x2=23.225 //y2=1.665
cc_2205 ( N_noxref_14_M14_noxref_s N_noxref_16_c_3795_n ) capacitor \
 c=0.0104136f //x=22.205 //y=0.375 //x2=23.225 //y2=1.665
cc_2206 ( N_noxref_14_c_3571_p N_noxref_16_M14_noxref_d ) capacitor \
 c=0.00910163f //x=23.225 //y=0.54 //x2=22.635 //y2=0.915
cc_2207 ( N_noxref_14_c_3575_p N_noxref_16_M14_noxref_d ) capacitor \
 c=0.00120711f //x=22.34 //y=0.995 //x2=22.635 //y2=0.915
cc_2208 ( N_noxref_14_M14_noxref_s N_noxref_16_M14_noxref_d ) capacitor \
 c=0.0279003f //x=22.205 //y=0.375 //x2=22.635 //y2=0.915
cc_2209 ( N_noxref_14_c_3551_n N_noxref_17_c_4015_n ) capacitor c=0.00533525f \
 //x=22.255 //y=0.995 //x2=25.04 //y2=0
cc_2210 ( N_noxref_14_c_3592_p N_noxref_17_c_4015_n ) capacitor c=0.00709506f \
 //x=22.34 //y=0.625 //x2=25.04 //y2=0
cc_2211 ( N_noxref_14_c_3571_p N_noxref_17_c_4015_n ) capacitor c=0.0104298f \
 //x=23.225 //y=0.54 //x2=25.04 //y2=0
cc_2212 ( N_noxref_14_c_3594_p N_noxref_17_c_4015_n ) capacitor c=0.00232857f \
 //x=23.31 //y=0.625 //x2=25.04 //y2=0
cc_2213 ( N_noxref_14_M13_noxref_d N_noxref_17_c_4015_n ) capacitor \
 c=0.0130753f //x=21.1 //y=0.91 //x2=25.04 //y2=0
cc_2214 ( N_noxref_14_M13_noxref_d N_noxref_17_c_3973_n ) capacitor \
 c=0.0154456f //x=21.1 //y=0.91 //x2=20.315 //y2=0.965
cc_2215 ( N_noxref_14_c_3551_n N_noxref_17_c_3986_n ) capacitor c=0.00807048f \
 //x=22.255 //y=0.995 //x2=23.88 //y2=0
cc_2216 ( N_noxref_14_c_3592_p N_noxref_17_c_3986_n ) capacitor c=0.0140218f \
 //x=22.34 //y=0.625 //x2=23.88 //y2=0
cc_2217 ( N_noxref_14_c_3571_p N_noxref_17_c_3986_n ) capacitor c=0.0364204f \
 //x=23.225 //y=0.54 //x2=23.88 //y2=0
cc_2218 ( N_noxref_14_c_3594_p N_noxref_17_c_3986_n ) capacitor c=0.0138658f \
 //x=23.31 //y=0.625 //x2=23.88 //y2=0
cc_2219 ( N_noxref_14_c_3551_n N_noxref_17_c_4050_n ) capacitor c=3.54249e-19 \
 //x=22.255 //y=0.995 //x2=28.12 //y2=0
cc_2220 ( N_noxref_14_c_3571_p N_noxref_17_c_4050_n ) capacitor c=0.00283214f \
 //x=23.225 //y=0.54 //x2=28.12 //y2=0
cc_2221 ( N_noxref_14_M13_noxref_d N_noxref_17_c_4050_n ) capacitor \
 c=2.7648e-19 //x=21.1 //y=0.91 //x2=28.12 //y2=0
cc_2222 ( N_noxref_14_M14_noxref_s N_noxref_17_c_3994_n ) capacitor \
 c=8.16352e-19 //x=22.205 //y=0.375 //x2=19.24 //y2=0
cc_2223 ( N_noxref_14_c_3594_p N_noxref_17_c_4037_n ) capacitor c=0.037873f \
 //x=23.31 //y=0.625 //x2=24.05 //y2=0
cc_2224 ( N_noxref_14_M14_noxref_s N_noxref_17_c_4037_n ) capacitor \
 c=0.00519292f //x=22.205 //y=0.375 //x2=24.05 //y2=0
cc_2225 ( N_noxref_14_M13_noxref_d N_noxref_17_M12_noxref_d ) capacitor \
 c=3.12752e-19 //x=21.1 //y=0.91 //x2=20.125 //y2=0.875
cc_2226 ( N_noxref_14_c_3592_p N_noxref_25_c_4902_n ) capacitor c=2.15937e-19 \
 //x=22.34 //y=0.625 //x2=20.8 //y2=0.625
cc_2227 ( N_noxref_14_c_3551_n N_noxref_25_c_4887_n ) capacitor c=0.0132186f \
 //x=22.255 //y=0.995 //x2=21.685 //y2=0.54
cc_2228 ( N_noxref_14_M13_noxref_d N_noxref_25_c_4887_n ) capacitor \
 c=0.0160925f //x=21.1 //y=0.91 //x2=21.685 //y2=0.54
cc_2229 ( N_noxref_14_c_3551_n N_noxref_25_c_4889_n ) capacitor c=0.00945545f \
 //x=22.255 //y=0.995 //x2=21.685 //y2=1.59
cc_2230 ( N_noxref_14_M13_noxref_d N_noxref_25_c_4889_n ) capacitor \
 c=0.0151017f //x=21.1 //y=0.91 //x2=21.685 //y2=1.59
cc_2231 ( N_noxref_14_c_3551_n N_noxref_25_M12_noxref_s ) capacitor \
 c=0.0232572f //x=22.255 //y=0.995 //x2=19.695 //y2=0.375
cc_2232 ( N_noxref_14_c_3592_p N_noxref_25_M12_noxref_s ) capacitor \
 c=0.0175461f //x=22.34 //y=0.625 //x2=19.695 //y2=0.375
cc_2233 ( N_noxref_14_c_3594_p N_noxref_25_M12_noxref_s ) capacitor \
 c=2.98576e-19 //x=23.31 //y=0.625 //x2=19.695 //y2=0.375
cc_2234 ( N_noxref_14_M13_noxref_d N_noxref_25_M12_noxref_s ) capacitor \
 c=0.0187685f //x=21.1 //y=0.91 //x2=19.695 //y2=0.375
cc_2235 ( N_noxref_14_M14_noxref_s N_noxref_25_M12_noxref_s ) capacitor \
 c=0.0210926f //x=22.205 //y=0.375 //x2=19.695 //y2=0.375
cc_2236 ( N_noxref_14_c_3594_p N_noxref_26_M15_noxref_s ) capacitor \
 c=0.00368328f //x=23.31 //y=0.625 //x2=24.505 //y2=0.375
cc_2237 ( N_noxref_14_M14_noxref_s N_noxref_26_M15_noxref_s ) capacitor \
 c=0.00125319f //x=22.205 //y=0.375 //x2=24.505 //y2=0.375
cc_2238 ( N_noxref_15_M46_noxref_g N_noxref_16_c_3726_n ) capacitor \
 c=0.0110196f //x=22.31 //y=6.02 //x2=22.415 //y2=5.155
cc_2239 ( N_noxref_15_M46_noxref_g N_noxref_16_c_3758_n ) capacitor \
 c=0.00226521f //x=22.31 //y=6.02 //x2=22.53 //y2=5.38
cc_2240 ( N_noxref_15_M47_noxref_g N_noxref_16_c_3758_n ) capacitor \
 c=0.00381703f //x=22.75 //y=6.02 //x2=22.53 //y2=5.38
cc_2241 ( N_noxref_15_c_3620_n N_noxref_16_c_3743_n ) capacitor c=0.0023799f \
 //x=22.57 //y=4.57 //x2=23.225 //y2=5.155
cc_2242 ( N_noxref_15_c_3634_n N_noxref_16_c_3743_n ) capacitor c=0.00130631f \
 //x=22.57 //y=4.7 //x2=23.225 //y2=5.155
cc_2243 ( N_noxref_15_M47_noxref_g N_noxref_16_c_3743_n ) capacitor \
 c=0.0115648f //x=22.75 //y=6.02 //x2=23.225 //y2=5.155
cc_2244 ( N_noxref_15_c_3640_n N_noxref_16_c_3738_n ) capacitor c=4.64015e-19 \
 //x=22.56 //y=0.915 //x2=22.825 //y2=1.125
cc_2245 ( N_noxref_15_c_3641_n N_noxref_16_c_3738_n ) capacitor c=0.0026012f \
 //x=22.56 //y=1.26 //x2=22.825 //y2=1.125
cc_2246 ( N_noxref_15_c_3678_p N_noxref_16_c_3738_n ) capacitor c=5.29969e-19 \
 //x=22.935 //y=0.76 //x2=22.825 //y2=1.125
cc_2247 ( N_noxref_15_c_3679_p N_noxref_16_c_3738_n ) capacitor c=5.54437e-19 \
 //x=22.935 //y=1.415 //x2=22.825 //y2=1.125
cc_2248 ( N_noxref_15_c_3666_n N_noxref_16_c_3738_n ) capacitor c=5.24634e-19 \
 //x=23.09 //y=0.915 //x2=22.825 //y2=1.125
cc_2249 ( N_noxref_15_c_3668_n N_noxref_16_c_3738_n ) capacitor c=0.00307978f \
 //x=23.09 //y=1.26 //x2=22.825 //y2=1.125
cc_2250 ( N_noxref_15_c_3641_n N_noxref_16_c_3794_n ) capacitor c=0.00127432f \
 //x=22.56 //y=1.26 //x2=22.825 //y2=1.58
cc_2251 ( N_noxref_15_c_3642_n N_noxref_16_c_3794_n ) capacitor c=0.00429966f \
 //x=22.56 //y=1.57 //x2=22.825 //y2=1.58
cc_2252 ( N_noxref_15_c_3679_p N_noxref_16_c_3794_n ) capacitor c=0.00942306f \
 //x=22.935 //y=1.415 //x2=22.825 //y2=1.58
cc_2253 ( N_noxref_15_c_3668_n N_noxref_16_c_3794_n ) capacitor c=0.00363411f \
 //x=23.09 //y=1.26 //x2=22.825 //y2=1.58
cc_2254 ( N_noxref_15_c_3646_n N_noxref_16_c_3794_n ) capacitor c=0.0036273f \
 //x=22.57 //y=1.915 //x2=22.825 //y2=1.58
cc_2255 ( N_noxref_15_c_3679_p N_noxref_16_c_3795_n ) capacitor c=0.00194716f \
 //x=22.935 //y=1.415 //x2=23.225 //y2=1.665
cc_2256 ( N_noxref_15_c_3668_n N_noxref_16_c_3795_n ) capacitor c=0.00323576f \
 //x=23.09 //y=1.26 //x2=23.225 //y2=1.665
cc_2257 ( N_noxref_15_c_3622_n N_noxref_16_c_3727_n ) capacitor c=0.0147566f \
 //x=22.57 //y=2.195 //x2=23.31 //y2=5.07
cc_2258 ( N_noxref_15_c_3620_n N_noxref_16_c_3727_n ) capacitor c=0.118008f \
 //x=22.57 //y=4.57 //x2=23.31 //y2=5.07
cc_2259 ( N_noxref_15_c_3631_n N_noxref_16_c_3727_n ) capacitor c=0.00144133f \
 //x=22.57 //y=2.08 //x2=23.31 //y2=5.07
cc_2260 ( N_noxref_15_c_3634_n N_noxref_16_c_3727_n ) capacitor c=0.00131258f \
 //x=22.57 //y=4.7 //x2=23.31 //y2=5.07
cc_2261 ( N_noxref_15_c_3643_n N_noxref_16_c_3727_n ) capacitor c=0.00246559f \
 //x=22.57 //y=2.08 //x2=23.31 //y2=5.07
cc_2262 ( N_noxref_15_c_3647_n N_noxref_16_c_3727_n ) capacitor c=0.0035458f \
 //x=22.57 //y=4.7 //x2=23.31 //y2=5.07
cc_2263 ( N_noxref_15_c_3620_n N_noxref_16_c_3825_n ) capacitor c=0.022756f \
 //x=22.57 //y=4.57 //x2=22.53 //y2=5.155
cc_2264 ( N_noxref_15_c_3634_n N_noxref_16_c_3825_n ) capacitor c=0.00346456f \
 //x=22.57 //y=4.7 //x2=22.53 //y2=5.155
cc_2265 ( N_noxref_15_c_3647_n N_noxref_16_c_3825_n ) capacitor c=0.00203307f \
 //x=22.57 //y=4.7 //x2=22.53 //y2=5.155
cc_2266 ( N_noxref_15_c_3620_n N_noxref_16_c_3785_n ) capacitor c=0.00266871f \
 //x=22.57 //y=4.57 //x2=22.53 //y2=5.38
cc_2267 ( N_noxref_15_c_3634_n N_noxref_16_c_3785_n ) capacitor c=0.00552343f \
 //x=22.57 //y=4.7 //x2=22.53 //y2=5.38
cc_2268 ( N_noxref_15_M46_noxref_g N_noxref_16_c_3785_n ) capacitor \
 c=0.0178885f //x=22.31 //y=6.02 //x2=22.53 //y2=5.38
cc_2269 ( N_noxref_15_M47_noxref_g N_noxref_16_c_3785_n ) capacitor \
 c=0.0188608f //x=22.75 //y=6.02 //x2=22.53 //y2=5.38
cc_2270 ( N_noxref_15_c_3647_n N_noxref_16_c_3785_n ) capacitor c=0.00375636f \
 //x=22.57 //y=4.7 //x2=22.53 //y2=5.38
cc_2271 ( N_noxref_15_c_3640_n N_noxref_16_M14_noxref_d ) capacitor \
 c=0.00137165f //x=22.56 //y=0.915 //x2=22.635 //y2=0.915
cc_2272 ( N_noxref_15_c_3641_n N_noxref_16_M14_noxref_d ) capacitor \
 c=0.00237422f //x=22.56 //y=1.26 //x2=22.635 //y2=0.915
cc_2273 ( N_noxref_15_c_3678_p N_noxref_16_M14_noxref_d ) capacitor \
 c=0.0020782f //x=22.935 //y=0.76 //x2=22.635 //y2=0.915
cc_2274 ( N_noxref_15_c_3679_p N_noxref_16_M14_noxref_d ) capacitor \
 c=0.00356097f //x=22.935 //y=1.415 //x2=22.635 //y2=0.915
cc_2275 ( N_noxref_15_c_3666_n N_noxref_16_M14_noxref_d ) capacitor \
 c=0.00139206f //x=23.09 //y=0.915 //x2=22.635 //y2=0.915
cc_2276 ( N_noxref_15_c_3668_n N_noxref_16_M14_noxref_d ) capacitor \
 c=0.00237422f //x=23.09 //y=1.26 //x2=22.635 //y2=0.915
cc_2277 ( N_noxref_15_c_3622_n N_noxref_17_c_4015_n ) capacitor c=0.00219445f \
 //x=22.57 //y=2.195 //x2=25.04 //y2=0
cc_2278 ( N_noxref_15_c_3622_n N_noxref_17_c_3986_n ) capacitor c=2.01623e-19 \
 //x=22.57 //y=2.195 //x2=23.88 //y2=0
cc_2279 ( N_noxref_15_c_3631_n N_noxref_17_c_4037_n ) capacitor c=0.00246191f \
 //x=22.57 //y=2.08 //x2=24.05 //y2=0
cc_2280 ( N_noxref_15_c_3668_n N_noxref_17_c_4037_n ) capacitor c=0.00262688f \
 //x=23.09 //y=1.26 //x2=24.05 //y2=0
cc_2281 ( N_noxref_15_c_3620_n N_noxref_18_c_4356_n ) capacitor c=0.00419399f \
 //x=22.57 //y=4.57 //x2=25.16 //y2=4.575
cc_2282 ( N_noxref_16_c_3738_n N_noxref_17_c_4015_n ) capacitor c=0.00905765f \
 //x=22.825 //y=1.125 //x2=25.04 //y2=0
cc_2283 ( N_noxref_16_c_3795_n N_noxref_17_c_4015_n ) capacitor c=0.00712383f \
 //x=23.225 //y=1.665 //x2=25.04 //y2=0
cc_2284 ( N_noxref_16_M14_noxref_d N_noxref_17_c_4015_n ) capacitor \
 c=2.94508e-19 //x=22.635 //y=0.915 //x2=25.04 //y2=0
cc_2285 ( N_noxref_16_c_3738_n N_noxref_17_c_4034_n ) capacitor c=0.00543195f \
 //x=22.825 //y=1.125 //x2=25.125 //y2=0.965
cc_2286 ( N_noxref_16_c_3795_n N_noxref_17_c_3986_n ) capacitor c=6.86937e-19 \
 //x=23.225 //y=1.665 //x2=23.88 //y2=0
cc_2287 ( N_noxref_16_c_3794_n N_noxref_17_c_4037_n ) capacitor c=0.0045138f \
 //x=22.825 //y=1.58 //x2=24.05 //y2=0
cc_2288 ( N_noxref_16_c_3795_n N_noxref_17_c_4037_n ) capacitor c=0.0356739f \
 //x=23.225 //y=1.665 //x2=24.05 //y2=0
cc_2289 ( N_noxref_16_c_3727_n N_noxref_18_c_4352_n ) capacitor c=0.00459838f \
 //x=23.31 //y=5.07 //x2=25.16 //y2=2.195
cc_2290 ( N_noxref_16_c_3727_n N_noxref_18_c_4356_n ) capacitor c=0.0420835f \
 //x=23.31 //y=5.07 //x2=25.16 //y2=4.575
cc_2291 ( N_noxref_16_c_3738_n N_noxref_19_M16_noxref_d ) capacitor \
 c=3.20746e-19 //x=22.825 //y=1.125 //x2=25.91 //y2=0.91
cc_2292 ( N_noxref_16_c_3795_n N_noxref_20_c_4618_n ) capacitor c=0.00191828f \
 //x=23.225 //y=1.665 //x2=27.72 //y2=1.665
cc_2293 ( N_noxref_16_c_3758_n N_noxref_20_c_4565_n ) capacitor c=6.09703e-19 \
 //x=22.53 //y=5.38 //x2=25.582 //y2=5.155
cc_2294 ( N_noxref_16_c_3743_n N_noxref_20_c_4565_n ) capacitor c=0.0033327f \
 //x=23.225 //y=5.155 //x2=25.582 //y2=5.155
cc_2295 ( N_noxref_17_c_4034_n N_noxref_18_c_4352_n ) capacitor c=0.0081679f \
 //x=25.125 //y=0.965 //x2=25.16 //y2=2.195
cc_2296 ( N_noxref_17_c_4037_n N_noxref_18_c_4352_n ) capacitor c=0.00407472f \
 //x=24.05 //y=0 //x2=25.16 //y2=2.195
cc_2297 ( N_noxref_17_M15_noxref_d N_noxref_18_c_4352_n ) capacitor \
 c=4.4417e-19 //x=24.935 //y=0.875 //x2=25.16 //y2=2.195
cc_2298 ( N_noxref_17_c_4037_n N_noxref_18_c_4356_n ) capacitor c=0.0118341f \
 //x=24.05 //y=0 //x2=25.16 //y2=4.575
cc_2299 ( N_noxref_17_c_4034_n N_noxref_18_c_4364_n ) capacitor c=2.22861e-19 \
 //x=25.125 //y=0.965 //x2=25.16 //y2=2.08
cc_2300 ( N_noxref_17_c_4037_n N_noxref_18_c_4364_n ) capacitor c=0.00394651f \
 //x=24.05 //y=0 //x2=25.16 //y2=2.08
cc_2301 ( N_noxref_17_c_4196_p N_noxref_18_c_4374_n ) capacitor c=3.97665e-19 \
 //x=25.125 //y=0.835 //x2=24.86 //y2=0.875
cc_2302 ( N_noxref_17_c_4034_n N_noxref_18_c_4374_n ) capacitor c=0.00156339f \
 //x=25.125 //y=0.965 //x2=24.86 //y2=0.875
cc_2303 ( N_noxref_17_c_4050_n N_noxref_18_c_4374_n ) capacitor c=0.00679028f \
 //x=28.12 //y=0 //x2=24.86 //y2=0.875
cc_2304 ( N_noxref_17_M15_noxref_d N_noxref_18_c_4374_n ) capacitor \
 c=0.00184354f //x=24.935 //y=0.875 //x2=24.86 //y2=0.875
cc_2305 ( N_noxref_17_c_4034_n N_noxref_18_c_4375_n ) capacitor c=0.00352472f \
 //x=25.125 //y=0.965 //x2=24.86 //y2=1.22
cc_2306 ( N_noxref_17_M15_noxref_d N_noxref_18_c_4375_n ) capacitor \
 c=0.00210798f //x=24.935 //y=0.875 //x2=24.86 //y2=1.22
cc_2307 ( N_noxref_17_c_4034_n N_noxref_18_c_4376_n ) capacitor c=4.86145e-19 \
 //x=25.125 //y=0.965 //x2=24.86 //y2=1.53
cc_2308 ( N_noxref_17_c_4037_n N_noxref_18_c_4376_n ) capacitor c=0.00170145f \
 //x=24.05 //y=0 //x2=24.86 //y2=1.53
cc_2309 ( N_noxref_17_c_4037_n N_noxref_18_c_4377_n ) capacitor c=0.0103608f \
 //x=24.05 //y=0 //x2=24.86 //y2=1.915
cc_2310 ( N_noxref_17_c_4196_p N_noxref_18_c_4422_n ) capacitor c=0.00864609f \
 //x=25.125 //y=0.835 //x2=25.235 //y2=0.72
cc_2311 ( N_noxref_17_c_4034_n N_noxref_18_c_4422_n ) capacitor c=7.3749e-19 \
 //x=25.125 //y=0.965 //x2=25.235 //y2=0.72
cc_2312 ( N_noxref_17_M15_noxref_d N_noxref_18_c_4422_n ) capacitor \
 c=0.00474029f //x=24.935 //y=0.875 //x2=25.235 //y2=0.72
cc_2313 ( N_noxref_17_c_4034_n N_noxref_18_c_4425_n ) capacitor c=6.35695e-19 \
 //x=25.125 //y=0.965 //x2=25.235 //y2=1.375
cc_2314 ( N_noxref_17_M15_noxref_d N_noxref_18_c_4425_n ) capacitor \
 c=0.00166857f //x=24.935 //y=0.875 //x2=25.235 //y2=1.375
cc_2315 ( N_noxref_17_c_4196_p N_noxref_18_c_4380_n ) capacitor c=4.45447e-19 \
 //x=25.125 //y=0.835 //x2=25.39 //y2=0.875
cc_2316 ( N_noxref_17_c_4034_n N_noxref_18_c_4380_n ) capacitor c=0.00158223f \
 //x=25.125 //y=0.965 //x2=25.39 //y2=0.875
cc_2317 ( N_noxref_17_M15_noxref_d N_noxref_18_c_4380_n ) capacitor \
 c=0.00230174f //x=24.935 //y=0.875 //x2=25.39 //y2=0.875
cc_2318 ( N_noxref_17_c_4034_n N_noxref_18_c_4382_n ) capacitor c=0.00276804f \
 //x=25.125 //y=0.965 //x2=25.39 //y2=1.22
cc_2319 ( N_noxref_17_M15_noxref_d N_noxref_18_c_4382_n ) capacitor \
 c=0.00210798f //x=24.935 //y=0.875 //x2=25.39 //y2=1.22
cc_2320 ( N_noxref_17_c_4033_n N_noxref_19_c_4451_n ) capacitor c=0.00789826f \
 //x=28.12 //y=0 //x2=27.065 //y2=0.995
cc_2321 ( N_noxref_17_c_4050_n N_noxref_19_c_4451_n ) capacitor c=0.00842473f \
 //x=28.12 //y=0 //x2=27.065 //y2=0.995
cc_2322 ( N_noxref_17_c_4033_n N_noxref_19_c_4483_n ) capacitor c=0.00418147f \
 //x=28.12 //y=0 //x2=27.15 //y2=0.625
cc_2323 ( N_noxref_17_c_4050_n N_noxref_19_c_4483_n ) capacitor c=0.0140218f \
 //x=28.12 //y=0 //x2=27.15 //y2=0.625
cc_2324 ( N_noxref_17_c_4033_n N_noxref_19_c_4468_n ) capacitor c=0.00960391f \
 //x=28.12 //y=0 //x2=28.035 //y2=0.54
cc_2325 ( N_noxref_17_c_4050_n N_noxref_19_c_4468_n ) capacitor c=0.0392526f \
 //x=28.12 //y=0 //x2=28.035 //y2=0.54
cc_2326 ( N_noxref_17_c_4033_n N_noxref_19_c_4487_n ) capacitor c=0.00232857f \
 //x=28.12 //y=0 //x2=28.12 //y2=0.625
cc_2327 ( N_noxref_17_c_4050_n N_noxref_19_c_4487_n ) capacitor c=0.0541348f \
 //x=28.12 //y=0 //x2=28.12 //y2=0.625
cc_2328 ( N_noxref_17_c_4033_n N_noxref_19_M16_noxref_d ) capacitor \
 c=0.013411f //x=28.12 //y=0 //x2=25.91 //y2=0.91
cc_2329 ( N_noxref_17_c_4034_n N_noxref_19_M16_noxref_d ) capacitor \
 c=0.0154456f //x=25.125 //y=0.965 //x2=25.91 //y2=0.91
cc_2330 ( N_noxref_17_c_4050_n N_noxref_19_M16_noxref_d ) capacitor \
 c=2.7648e-19 //x=28.12 //y=0 //x2=25.91 //y2=0.91
cc_2331 ( N_noxref_17_M15_noxref_d N_noxref_19_M16_noxref_d ) capacitor \
 c=3.12752e-19 //x=24.935 //y=0.875 //x2=25.91 //y2=0.91
cc_2332 ( N_noxref_17_c_4050_n N_noxref_19_M17_noxref_s ) capacitor \
 c=0.00533266f //x=28.12 //y=0 //x2=27.015 //y2=0.375
cc_2333 ( N_noxref_17_c_4037_n N_noxref_19_M17_noxref_s ) capacitor \
 c=8.16352e-19 //x=24.05 //y=0 //x2=27.015 //y2=0.375
cc_2334 ( N_noxref_17_c_4033_n N_noxref_20_c_4542_n ) capacitor c=0.00900212f \
 //x=28.12 //y=0 //x2=27.635 //y2=1.125
cc_2335 ( N_noxref_17_c_4050_n N_noxref_20_c_4548_n ) capacitor c=0.00518727f \
 //x=28.12 //y=0 //x2=27.635 //y2=1.58
cc_2336 ( N_noxref_17_c_4033_n N_noxref_20_c_4553_n ) capacitor c=0.00712383f \
 //x=28.12 //y=0 //x2=28.035 //y2=1.665
cc_2337 ( N_noxref_17_c_4050_n N_noxref_20_c_4553_n ) capacitor c=0.0407595f \
 //x=28.12 //y=0 //x2=28.035 //y2=1.665
cc_2338 ( N_noxref_17_c_4033_n N_noxref_20_M17_noxref_d ) capacitor \
 c=2.94508e-19 //x=28.12 //y=0 //x2=27.445 //y2=0.915
cc_2339 ( N_noxref_17_c_4234_p N_noxref_21_c_4655_n ) capacitor c=0.00294033f \
 //x=0.99 //y=0 //x2=1.475 //y2=1.59
cc_2340 ( N_noxref_17_c_3852_n N_noxref_21_c_4655_n ) capacitor c=7.68788e-19 \
 //x=5.8 //y=0 //x2=1.475 //y2=1.59
cc_2341 ( N_noxref_17_c_4060_n N_noxref_21_c_4655_n ) capacitor c=0.00388641f \
 //x=1.075 //y=0.965 //x2=1.475 //y2=1.59
cc_2342 ( N_noxref_17_c_3883_n N_noxref_21_c_4655_n ) capacitor c=0.00401983f \
 //x=4.64 //y=0 //x2=1.475 //y2=1.59
cc_2343 ( N_noxref_17_M0_noxref_d N_noxref_21_c_4655_n ) capacitor \
 c=0.00578031f //x=0.885 //y=0.875 //x2=1.475 //y2=1.59
cc_2344 ( N_noxref_17_c_4069_n N_noxref_21_c_4666_n ) capacitor c=0.0169052f \
 //x=1.075 //y=0.835 //x2=1.56 //y2=0.625
cc_2345 ( N_noxref_17_c_3852_n N_noxref_21_c_4666_n ) capacitor c=0.00709506f \
 //x=5.8 //y=0 //x2=1.56 //y2=0.625
cc_2346 ( N_noxref_17_c_3883_n N_noxref_21_c_4666_n ) capacitor c=0.0140218f \
 //x=4.64 //y=0 //x2=1.56 //y2=0.625
cc_2347 ( N_noxref_17_c_4062_n N_noxref_21_c_4666_n ) capacitor c=0.00323118f \
 //x=0.74 //y=0 //x2=1.56 //y2=0.625
cc_2348 ( N_noxref_17_c_3852_n N_noxref_21_c_4643_n ) capacitor c=0.0130182f \
 //x=5.8 //y=0 //x2=2.445 //y2=0.54
cc_2349 ( N_noxref_17_c_3883_n N_noxref_21_c_4643_n ) capacitor c=0.0358446f \
 //x=4.64 //y=0 //x2=2.445 //y2=0.54
cc_2350 ( N_noxref_17_c_4050_n N_noxref_21_c_4643_n ) capacitor c=0.00265129f \
 //x=28.12 //y=0 //x2=2.445 //y2=0.54
cc_2351 ( N_noxref_17_c_4234_p N_noxref_21_M0_noxref_s ) capacitor \
 c=0.00709506f //x=0.99 //y=0 //x2=0.455 //y2=0.375
cc_2352 ( N_noxref_17_c_4069_n N_noxref_21_M0_noxref_s ) capacitor \
 c=0.0173062f //x=1.075 //y=0.835 //x2=0.455 //y2=0.375
cc_2353 ( N_noxref_17_c_3852_n N_noxref_21_M0_noxref_s ) capacitor \
 c=0.00444952f //x=5.8 //y=0 //x2=0.455 //y2=0.375
cc_2354 ( N_noxref_17_c_4060_n N_noxref_21_M0_noxref_s ) capacitor \
 c=0.0113024f //x=1.075 //y=0.965 //x2=0.455 //y2=0.375
cc_2355 ( N_noxref_17_c_3883_n N_noxref_21_M0_noxref_s ) capacitor \
 c=0.0272168f //x=4.64 //y=0 //x2=0.455 //y2=0.375
cc_2356 ( N_noxref_17_c_4062_n N_noxref_21_M0_noxref_s ) capacitor \
 c=0.0675506f //x=0.74 //y=0 //x2=0.455 //y2=0.375
cc_2357 ( N_noxref_17_c_3887_n N_noxref_21_M0_noxref_s ) capacitor \
 c=0.00166413f //x=4.81 //y=0 //x2=0.455 //y2=0.375
cc_2358 ( N_noxref_17_M0_noxref_d N_noxref_21_M0_noxref_s ) capacitor \
 c=0.0271316f //x=0.885 //y=0.875 //x2=0.455 //y2=0.375
cc_2359 ( N_noxref_17_c_3852_n N_noxref_22_c_4697_n ) capacitor c=0.00113313f \
 //x=5.8 //y=0 //x2=6.285 //y2=1.59
cc_2360 ( N_noxref_17_c_3962_n N_noxref_22_c_4697_n ) capacitor c=6.52202e-19 \
 //x=10.61 //y=0 //x2=6.285 //y2=1.59
cc_2361 ( N_noxref_17_c_3862_n N_noxref_22_c_4697_n ) capacitor c=0.00359758f \
 //x=5.885 //y=0.965 //x2=6.285 //y2=1.59
cc_2362 ( N_noxref_17_c_3885_n N_noxref_22_c_4697_n ) capacitor c=0.00391745f \
 //x=9.45 //y=0 //x2=6.285 //y2=1.59
cc_2363 ( N_noxref_17_M3_noxref_d N_noxref_22_c_4697_n ) capacitor \
 c=0.00578031f //x=5.695 //y=0.875 //x2=6.285 //y2=1.59
cc_2364 ( N_noxref_17_c_3856_n N_noxref_22_c_4724_n ) capacitor c=0.0169052f \
 //x=5.885 //y=0.835 //x2=6.37 //y2=0.625
cc_2365 ( N_noxref_17_c_3962_n N_noxref_22_c_4724_n ) capacitor c=0.00439992f \
 //x=10.61 //y=0 //x2=6.37 //y2=0.625
cc_2366 ( N_noxref_17_c_3885_n N_noxref_22_c_4724_n ) capacitor c=0.0141422f \
 //x=9.45 //y=0 //x2=6.37 //y2=0.625
cc_2367 ( N_noxref_17_c_3887_n N_noxref_22_c_4724_n ) capacitor c=0.00322478f \
 //x=4.81 //y=0 //x2=6.37 //y2=0.625
cc_2368 ( N_noxref_17_c_3962_n N_noxref_22_c_4708_n ) capacitor c=0.0124407f \
 //x=10.61 //y=0 //x2=7.255 //y2=0.54
cc_2369 ( N_noxref_17_c_3885_n N_noxref_22_c_4708_n ) capacitor c=0.036101f \
 //x=9.45 //y=0 //x2=7.255 //y2=0.54
cc_2370 ( N_noxref_17_c_4050_n N_noxref_22_c_4708_n ) capacitor c=0.00265129f \
 //x=28.12 //y=0 //x2=7.255 //y2=0.54
cc_2371 ( N_noxref_17_c_3852_n N_noxref_22_M3_noxref_s ) capacitor \
 c=0.00439992f //x=5.8 //y=0 //x2=5.265 //y2=0.375
cc_2372 ( N_noxref_17_c_3856_n N_noxref_22_M3_noxref_s ) capacitor \
 c=0.0173062f //x=5.885 //y=0.835 //x2=5.265 //y2=0.375
cc_2373 ( N_noxref_17_c_3962_n N_noxref_22_M3_noxref_s ) capacitor \
 c=0.00444952f //x=10.61 //y=0 //x2=5.265 //y2=0.375
cc_2374 ( N_noxref_17_c_3862_n N_noxref_22_M3_noxref_s ) capacitor \
 c=0.00988958f //x=5.885 //y=0.965 //x2=5.265 //y2=0.375
cc_2375 ( N_noxref_17_c_3885_n N_noxref_22_M3_noxref_s ) capacitor \
 c=0.0273372f //x=9.45 //y=0 //x2=5.265 //y2=0.375
cc_2376 ( N_noxref_17_c_3887_n N_noxref_22_M3_noxref_s ) capacitor \
 c=0.0634633f //x=4.81 //y=0 //x2=5.265 //y2=0.375
cc_2377 ( N_noxref_17_c_3900_n N_noxref_22_M3_noxref_s ) capacitor \
 c=0.00166413f //x=9.62 //y=0 //x2=5.265 //y2=0.375
cc_2378 ( N_noxref_17_M3_noxref_d N_noxref_22_M3_noxref_s ) capacitor \
 c=0.0271316f //x=5.695 //y=0.875 //x2=5.265 //y2=0.375
cc_2379 ( N_noxref_17_c_3962_n N_noxref_23_c_4755_n ) capacitor c=0.00113313f \
 //x=10.61 //y=0 //x2=11.095 //y2=1.59
cc_2380 ( N_noxref_17_c_3922_n N_noxref_23_c_4755_n ) capacitor c=7.40573e-19 \
 //x=15.42 //y=0 //x2=11.095 //y2=1.59
cc_2381 ( N_noxref_17_c_3873_n N_noxref_23_c_4755_n ) capacitor c=0.00350782f \
 //x=10.695 //y=0.965 //x2=11.095 //y2=1.59
cc_2382 ( N_noxref_17_c_3886_n N_noxref_23_c_4755_n ) capacitor c=0.00391745f \
 //x=14.26 //y=0 //x2=11.095 //y2=1.59
cc_2383 ( N_noxref_17_M6_noxref_d N_noxref_23_c_4755_n ) capacitor \
 c=0.00578031f //x=10.505 //y=0.875 //x2=11.095 //y2=1.59
cc_2384 ( N_noxref_17_c_3859_n N_noxref_23_c_4783_n ) capacitor c=0.0169052f \
 //x=10.695 //y=0.835 //x2=11.18 //y2=0.625
cc_2385 ( N_noxref_17_c_3922_n N_noxref_23_c_4783_n ) capacitor c=0.00439992f \
 //x=15.42 //y=0 //x2=11.18 //y2=0.625
cc_2386 ( N_noxref_17_c_3886_n N_noxref_23_c_4783_n ) capacitor c=0.0141422f \
 //x=14.26 //y=0 //x2=11.18 //y2=0.625
cc_2387 ( N_noxref_17_c_3900_n N_noxref_23_c_4783_n ) capacitor c=0.00322478f \
 //x=9.62 //y=0 //x2=11.18 //y2=0.625
cc_2388 ( N_noxref_17_c_3922_n N_noxref_23_c_4770_n ) capacitor c=0.0118026f \
 //x=15.42 //y=0 //x2=12.065 //y2=0.54
cc_2389 ( N_noxref_17_c_3886_n N_noxref_23_c_4770_n ) capacitor c=0.036101f \
 //x=14.26 //y=0 //x2=12.065 //y2=0.54
cc_2390 ( N_noxref_17_c_4050_n N_noxref_23_c_4770_n ) capacitor c=0.00265129f \
 //x=28.12 //y=0 //x2=12.065 //y2=0.54
cc_2391 ( N_noxref_17_c_3962_n N_noxref_23_M6_noxref_s ) capacitor \
 c=0.00439992f //x=10.61 //y=0 //x2=10.075 //y2=0.375
cc_2392 ( N_noxref_17_c_3859_n N_noxref_23_M6_noxref_s ) capacitor \
 c=0.0173062f //x=10.695 //y=0.835 //x2=10.075 //y2=0.375
cc_2393 ( N_noxref_17_c_3922_n N_noxref_23_M6_noxref_s ) capacitor \
 c=0.00405449f //x=15.42 //y=0 //x2=10.075 //y2=0.375
cc_2394 ( N_noxref_17_c_3873_n N_noxref_23_M6_noxref_s ) capacitor \
 c=0.00988958f //x=10.695 //y=0.965 //x2=10.075 //y2=0.375
cc_2395 ( N_noxref_17_c_3886_n N_noxref_23_M6_noxref_s ) capacitor \
 c=0.0273372f //x=14.26 //y=0 //x2=10.075 //y2=0.375
cc_2396 ( N_noxref_17_c_3900_n N_noxref_23_M6_noxref_s ) capacitor \
 c=0.0634633f //x=9.62 //y=0 //x2=10.075 //y2=0.375
cc_2397 ( N_noxref_17_c_3943_n N_noxref_23_M6_noxref_s ) capacitor \
 c=0.00166413f //x=14.43 //y=0 //x2=10.075 //y2=0.375
cc_2398 ( N_noxref_17_M6_noxref_d N_noxref_23_M6_noxref_s ) capacitor \
 c=0.0271316f //x=10.505 //y=0.875 //x2=10.075 //y2=0.375
cc_2399 ( N_noxref_17_c_3922_n N_noxref_24_c_4814_n ) capacitor c=0.00113313f \
 //x=15.42 //y=0 //x2=15.905 //y2=1.59
cc_2400 ( N_noxref_17_c_3963_n N_noxref_24_c_4814_n ) capacitor c=7.40573e-19 \
 //x=20.23 //y=0 //x2=15.905 //y2=1.59
cc_2401 ( N_noxref_17_c_3929_n N_noxref_24_c_4814_n ) capacitor c=0.00350844f \
 //x=15.505 //y=0.965 //x2=15.905 //y2=1.59
cc_2402 ( N_noxref_17_c_3942_n N_noxref_24_c_4814_n ) capacitor c=0.00391744f \
 //x=19.07 //y=0 //x2=15.905 //y2=1.59
cc_2403 ( N_noxref_17_M9_noxref_d N_noxref_24_c_4814_n ) capacitor \
 c=0.00578031f //x=15.315 //y=0.875 //x2=15.905 //y2=1.59
cc_2404 ( N_noxref_17_c_3926_n N_noxref_24_c_4843_n ) capacitor c=0.0169052f \
 //x=15.505 //y=0.835 //x2=15.99 //y2=0.625
cc_2405 ( N_noxref_17_c_3963_n N_noxref_24_c_4843_n ) capacitor c=0.00439992f \
 //x=20.23 //y=0 //x2=15.99 //y2=0.625
cc_2406 ( N_noxref_17_c_3942_n N_noxref_24_c_4843_n ) capacitor c=0.0141422f \
 //x=19.07 //y=0 //x2=15.99 //y2=0.625
cc_2407 ( N_noxref_17_c_3943_n N_noxref_24_c_4843_n ) capacitor c=0.00322478f \
 //x=14.43 //y=0 //x2=15.99 //y2=0.625
cc_2408 ( N_noxref_17_c_3963_n N_noxref_24_c_4825_n ) capacitor c=0.0123795f \
 //x=20.23 //y=0 //x2=16.875 //y2=0.54
cc_2409 ( N_noxref_17_c_3942_n N_noxref_24_c_4825_n ) capacitor c=0.036101f \
 //x=19.07 //y=0 //x2=16.875 //y2=0.54
cc_2410 ( N_noxref_17_c_4050_n N_noxref_24_c_4825_n ) capacitor c=0.00265129f \
 //x=28.12 //y=0 //x2=16.875 //y2=0.54
cc_2411 ( N_noxref_17_c_3922_n N_noxref_24_M9_noxref_s ) capacitor \
 c=0.00439992f //x=15.42 //y=0 //x2=14.885 //y2=0.375
cc_2412 ( N_noxref_17_c_3926_n N_noxref_24_M9_noxref_s ) capacitor \
 c=0.0173062f //x=15.505 //y=0.835 //x2=14.885 //y2=0.375
cc_2413 ( N_noxref_17_c_3963_n N_noxref_24_M9_noxref_s ) capacitor \
 c=0.00444952f //x=20.23 //y=0 //x2=14.885 //y2=0.375
cc_2414 ( N_noxref_17_c_3929_n N_noxref_24_M9_noxref_s ) capacitor \
 c=0.00988958f //x=15.505 //y=0.965 //x2=14.885 //y2=0.375
cc_2415 ( N_noxref_17_c_3942_n N_noxref_24_M9_noxref_s ) capacitor \
 c=0.0273372f //x=19.07 //y=0 //x2=14.885 //y2=0.375
cc_2416 ( N_noxref_17_c_3943_n N_noxref_24_M9_noxref_s ) capacitor \
 c=0.0634633f //x=14.43 //y=0 //x2=14.885 //y2=0.375
cc_2417 ( N_noxref_17_c_3994_n N_noxref_24_M9_noxref_s ) capacitor \
 c=0.00166413f //x=19.24 //y=0 //x2=14.885 //y2=0.375
cc_2418 ( N_noxref_17_M9_noxref_d N_noxref_24_M9_noxref_s ) capacitor \
 c=0.0271316f //x=15.315 //y=0.875 //x2=14.885 //y2=0.375
cc_2419 ( N_noxref_17_c_3963_n N_noxref_25_c_4874_n ) capacitor c=0.00113313f \
 //x=20.23 //y=0 //x2=20.715 //y2=1.59
cc_2420 ( N_noxref_17_c_4015_n N_noxref_25_c_4874_n ) capacitor c=7.40573e-19 \
 //x=25.04 //y=0 //x2=20.715 //y2=1.59
cc_2421 ( N_noxref_17_c_3973_n N_noxref_25_c_4874_n ) capacitor c=0.00365559f \
 //x=20.315 //y=0.965 //x2=20.715 //y2=1.59
cc_2422 ( N_noxref_17_c_3986_n N_noxref_25_c_4874_n ) capacitor c=0.00391745f \
 //x=23.88 //y=0 //x2=20.715 //y2=1.59
cc_2423 ( N_noxref_17_M12_noxref_d N_noxref_25_c_4874_n ) capacitor \
 c=0.00578031f //x=20.125 //y=0.875 //x2=20.715 //y2=1.59
cc_2424 ( N_noxref_17_c_3969_n N_noxref_25_c_4902_n ) capacitor c=0.0169052f \
 //x=20.315 //y=0.835 //x2=20.8 //y2=0.625
cc_2425 ( N_noxref_17_c_4015_n N_noxref_25_c_4902_n ) capacitor c=0.00439992f \
 //x=25.04 //y=0 //x2=20.8 //y2=0.625
cc_2426 ( N_noxref_17_c_3986_n N_noxref_25_c_4902_n ) capacitor c=0.0141422f \
 //x=23.88 //y=0 //x2=20.8 //y2=0.625
cc_2427 ( N_noxref_17_c_3994_n N_noxref_25_c_4902_n ) capacitor c=0.00322478f \
 //x=19.24 //y=0 //x2=20.8 //y2=0.625
cc_2428 ( N_noxref_17_c_4015_n N_noxref_25_c_4887_n ) capacitor c=0.013008f \
 //x=25.04 //y=0 //x2=21.685 //y2=0.54
cc_2429 ( N_noxref_17_c_3986_n N_noxref_25_c_4887_n ) capacitor c=0.0358643f \
 //x=23.88 //y=0 //x2=21.685 //y2=0.54
cc_2430 ( N_noxref_17_c_4050_n N_noxref_25_c_4887_n ) capacitor c=0.00265129f \
 //x=28.12 //y=0 //x2=21.685 //y2=0.54
cc_2431 ( N_noxref_17_c_3963_n N_noxref_25_M12_noxref_s ) capacitor \
 c=0.00439992f //x=20.23 //y=0 //x2=19.695 //y2=0.375
cc_2432 ( N_noxref_17_c_3969_n N_noxref_25_M12_noxref_s ) capacitor \
 c=0.0173062f //x=20.315 //y=0.835 //x2=19.695 //y2=0.375
cc_2433 ( N_noxref_17_c_4015_n N_noxref_25_M12_noxref_s ) capacitor \
 c=0.00682701f //x=25.04 //y=0 //x2=19.695 //y2=0.375
cc_2434 ( N_noxref_17_c_3973_n N_noxref_25_M12_noxref_s ) capacitor \
 c=0.00988958f //x=20.315 //y=0.965 //x2=19.695 //y2=0.375
cc_2435 ( N_noxref_17_c_3986_n N_noxref_25_M12_noxref_s ) capacitor \
 c=0.0272844f //x=23.88 //y=0 //x2=19.695 //y2=0.375
cc_2436 ( N_noxref_17_c_3994_n N_noxref_25_M12_noxref_s ) capacitor \
 c=0.0634633f //x=19.24 //y=0 //x2=19.695 //y2=0.375
cc_2437 ( N_noxref_17_c_4037_n N_noxref_25_M12_noxref_s ) capacitor \
 c=0.00166476f //x=24.05 //y=0 //x2=19.695 //y2=0.375
cc_2438 ( N_noxref_17_M12_noxref_d N_noxref_25_M12_noxref_s ) capacitor \
 c=0.0271316f //x=20.125 //y=0.875 //x2=19.695 //y2=0.375
cc_2439 ( N_noxref_17_c_4015_n N_noxref_26_c_4933_n ) capacitor c=0.00113313f \
 //x=25.04 //y=0 //x2=25.525 //y2=1.59
cc_2440 ( N_noxref_17_c_4033_n N_noxref_26_c_4933_n ) capacitor c=0.00193141f \
 //x=28.12 //y=0 //x2=25.525 //y2=1.59
cc_2441 ( N_noxref_17_c_4034_n N_noxref_26_c_4933_n ) capacitor c=0.00388641f \
 //x=25.125 //y=0.965 //x2=25.525 //y2=1.59
cc_2442 ( N_noxref_17_c_4050_n N_noxref_26_c_4933_n ) capacitor c=0.00413809f \
 //x=28.12 //y=0 //x2=25.525 //y2=1.59
cc_2443 ( N_noxref_17_M15_noxref_d N_noxref_26_c_4933_n ) capacitor \
 c=0.00578031f //x=24.935 //y=0.875 //x2=25.525 //y2=1.59
cc_2444 ( N_noxref_17_c_4196_p N_noxref_26_c_4955_n ) capacitor c=0.0169052f \
 //x=25.125 //y=0.835 //x2=25.61 //y2=0.625
cc_2445 ( N_noxref_17_c_4033_n N_noxref_26_c_4955_n ) capacitor c=0.00709506f \
 //x=28.12 //y=0 //x2=25.61 //y2=0.625
cc_2446 ( N_noxref_17_c_4050_n N_noxref_26_c_4955_n ) capacitor c=0.0140218f \
 //x=28.12 //y=0 //x2=25.61 //y2=0.625
cc_2447 ( N_noxref_17_c_4037_n N_noxref_26_c_4955_n ) capacitor c=0.00322478f \
 //x=24.05 //y=0 //x2=25.61 //y2=0.625
cc_2448 ( N_noxref_17_c_4033_n N_noxref_26_c_4934_n ) capacitor c=0.0137451f \
 //x=28.12 //y=0 //x2=26.495 //y2=0.54
cc_2449 ( N_noxref_17_c_4050_n N_noxref_26_c_4934_n ) capacitor c=0.0382591f \
 //x=28.12 //y=0 //x2=26.495 //y2=0.54
cc_2450 ( N_noxref_17_c_4015_n N_noxref_26_M15_noxref_s ) capacitor \
 c=0.00709506f //x=25.04 //y=0 //x2=24.505 //y2=0.375
cc_2451 ( N_noxref_17_c_4196_p N_noxref_26_M15_noxref_s ) capacitor \
 c=0.0173062f //x=25.125 //y=0.835 //x2=24.505 //y2=0.375
cc_2452 ( N_noxref_17_c_4033_n N_noxref_26_M15_noxref_s ) capacitor \
 c=0.00682701f //x=28.12 //y=0 //x2=24.505 //y2=0.375
cc_2453 ( N_noxref_17_c_4034_n N_noxref_26_M15_noxref_s ) capacitor \
 c=0.00988958f //x=25.125 //y=0.965 //x2=24.505 //y2=0.375
cc_2454 ( N_noxref_17_c_4050_n N_noxref_26_M15_noxref_s ) capacitor \
 c=0.028526f //x=28.12 //y=0 //x2=24.505 //y2=0.375
cc_2455 ( N_noxref_17_c_4037_n N_noxref_26_M15_noxref_s ) capacitor \
 c=0.0634633f //x=24.05 //y=0 //x2=24.505 //y2=0.375
cc_2456 ( N_noxref_17_M15_noxref_d N_noxref_26_M15_noxref_s ) capacitor \
 c=0.0271316f //x=24.935 //y=0.875 //x2=24.505 //y2=0.375
cc_2457 ( N_noxref_18_M49_noxref_g N_noxref_20_c_4514_n ) capacitor \
 c=0.0103964f //x=25.8 //y=6.02 //x2=26.34 //y2=5.155
cc_2458 ( N_noxref_18_M48_noxref_g N_noxref_20_c_4565_n ) capacitor \
 c=0.00461408f //x=25.36 //y=6.02 //x2=25.582 //y2=5.155
cc_2459 ( N_noxref_18_M49_noxref_g N_noxref_20_c_4565_n ) capacitor \
 c=0.00229208f //x=25.8 //y=6.02 //x2=25.582 //y2=5.155
cc_2460 ( N_noxref_18_c_4385_n N_noxref_20_c_4565_n ) capacitor c=0.00171885f \
 //x=25.725 //y=4.79 //x2=25.582 //y2=5.155
cc_2461 ( N_noxref_18_M48_noxref_g N_noxref_20_c_4604_n ) capacitor \
 c=0.0162284f //x=25.36 //y=6.02 //x2=25.58 //y2=5.38
cc_2462 ( N_noxref_18_M49_noxref_g N_noxref_20_c_4604_n ) capacitor \
 c=0.0179041f //x=25.8 //y=6.02 //x2=25.58 //y2=5.38
cc_2463 ( N_noxref_18_c_4385_n N_noxref_20_c_4604_n ) capacitor c=0.00291477f \
 //x=25.725 //y=4.79 //x2=25.58 //y2=5.38
cc_2464 ( N_noxref_18_c_4377_n N_noxref_26_c_4932_n ) capacitor c=0.00262672f \
 //x=24.86 //y=1.915 //x2=24.64 //y2=1.505
cc_2465 ( N_noxref_18_c_4352_n N_noxref_26_c_4933_n ) capacitor c=0.00411069f \
 //x=25.16 //y=2.195 //x2=25.525 //y2=1.59
cc_2466 ( N_noxref_18_c_4356_n N_noxref_26_c_4933_n ) capacitor c=2.72044e-19 \
 //x=25.16 //y=4.575 //x2=25.525 //y2=1.59
cc_2467 ( N_noxref_18_c_4364_n N_noxref_26_c_4933_n ) capacitor c=0.00933431f \
 //x=25.16 //y=2.08 //x2=25.525 //y2=1.59
cc_2468 ( N_noxref_18_c_4376_n N_noxref_26_c_4933_n ) capacitor c=0.00705077f \
 //x=24.86 //y=1.53 //x2=25.525 //y2=1.59
cc_2469 ( N_noxref_18_c_4377_n N_noxref_26_c_4933_n ) capacitor c=0.0234761f \
 //x=24.86 //y=1.915 //x2=25.525 //y2=1.59
cc_2470 ( N_noxref_18_c_4425_n N_noxref_26_c_4933_n ) capacitor c=0.00588627f \
 //x=25.235 //y=1.375 //x2=25.525 //y2=1.59
cc_2471 ( N_noxref_18_c_4382_n N_noxref_26_c_4933_n ) capacitor c=0.00698822f \
 //x=25.39 //y=1.22 //x2=25.525 //y2=1.59
cc_2472 ( N_noxref_18_c_4374_n N_noxref_26_M15_noxref_s ) capacitor \
 c=0.0295256f //x=24.86 //y=0.875 //x2=24.505 //y2=0.375
cc_2473 ( N_noxref_18_c_4376_n N_noxref_26_M15_noxref_s ) capacitor \
 c=7.99997e-19 //x=24.86 //y=1.53 //x2=24.505 //y2=0.375
cc_2474 ( N_noxref_18_c_4377_n N_noxref_26_M15_noxref_s ) capacitor \
 c=0.00122123f //x=24.86 //y=1.915 //x2=24.505 //y2=0.375
cc_2475 ( N_noxref_18_c_4380_n N_noxref_26_M15_noxref_s ) capacitor \
 c=0.0125924f //x=25.39 //y=0.875 //x2=24.505 //y2=0.375
cc_2476 ( N_noxref_19_M16_noxref_d N_noxref_20_c_4514_n ) capacitor \
 c=9.66038e-19 //x=25.91 //y=0.91 //x2=26.34 //y2=5.155
cc_2477 ( N_noxref_19_c_4468_n N_noxref_20_c_4542_n ) capacitor c=0.00366459f \
 //x=28.035 //y=0.54 //x2=27.635 //y2=1.125
cc_2478 ( N_noxref_19_M16_noxref_d N_noxref_20_c_4542_n ) capacitor \
 c=0.00803465f //x=25.91 //y=0.91 //x2=27.635 //y2=1.125
cc_2479 ( N_noxref_19_M17_noxref_s N_noxref_20_c_4542_n ) capacitor \
 c=0.011355f //x=27.015 //y=0.375 //x2=27.635 //y2=1.125
cc_2480 ( N_noxref_19_M17_noxref_s N_noxref_20_c_4548_n ) capacitor \
 c=0.0283243f //x=27.015 //y=0.375 //x2=27.635 //y2=1.58
cc_2481 ( N_noxref_19_c_4468_n N_noxref_20_c_4553_n ) capacitor c=0.00362807f \
 //x=28.035 //y=0.54 //x2=28.035 //y2=1.665
cc_2482 ( N_noxref_19_M17_noxref_s N_noxref_20_c_4553_n ) capacitor \
 c=0.0106347f //x=27.015 //y=0.375 //x2=28.035 //y2=1.665
cc_2483 ( N_noxref_19_c_4468_n N_noxref_20_M17_noxref_d ) capacitor \
 c=0.00949319f //x=28.035 //y=0.54 //x2=27.445 //y2=0.915
cc_2484 ( N_noxref_19_c_4473_n N_noxref_20_M17_noxref_d ) capacitor \
 c=0.00120711f //x=27.15 //y=0.995 //x2=27.445 //y2=0.915
cc_2485 ( N_noxref_19_M17_noxref_s N_noxref_20_M17_noxref_d ) capacitor \
 c=0.0279003f //x=27.015 //y=0.375 //x2=27.445 //y2=0.915
cc_2486 ( N_noxref_19_c_4483_n N_noxref_26_c_4955_n ) capacitor c=2.15937e-19 \
 //x=27.15 //y=0.625 //x2=25.61 //y2=0.625
cc_2487 ( N_noxref_19_c_4451_n N_noxref_26_c_4934_n ) capacitor c=0.0132395f \
 //x=27.065 //y=0.995 //x2=26.495 //y2=0.54
cc_2488 ( N_noxref_19_M16_noxref_d N_noxref_26_c_4934_n ) capacitor \
 c=0.0160925f //x=25.91 //y=0.91 //x2=26.495 //y2=0.54
cc_2489 ( N_noxref_19_c_4451_n N_noxref_26_c_4936_n ) capacitor c=0.00953011f \
 //x=27.065 //y=0.995 //x2=26.495 //y2=1.59
cc_2490 ( N_noxref_19_M16_noxref_d N_noxref_26_c_4936_n ) capacitor \
 c=0.0148972f //x=25.91 //y=0.91 //x2=26.495 //y2=1.59
cc_2491 ( N_noxref_19_c_4451_n N_noxref_26_M15_noxref_s ) capacitor \
 c=0.023368f //x=27.065 //y=0.995 //x2=24.505 //y2=0.375
cc_2492 ( N_noxref_19_c_4483_n N_noxref_26_M15_noxref_s ) capacitor \
 c=0.0182125f //x=27.15 //y=0.625 //x2=24.505 //y2=0.375
cc_2493 ( N_noxref_19_M16_noxref_d N_noxref_26_M15_noxref_s ) capacitor \
 c=0.0187685f //x=25.91 //y=0.91 //x2=24.505 //y2=0.375
cc_2494 ( N_noxref_19_M17_noxref_s N_noxref_26_M15_noxref_s ) capacitor \
 c=0.0210061f //x=27.015 //y=0.375 //x2=24.505 //y2=0.375
