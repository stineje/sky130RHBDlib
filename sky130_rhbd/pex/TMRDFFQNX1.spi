// File: TMRDFFQNX1.spi
// Created: Thu Jan 22 07:08:37 2026
// Program "Calibre xRC"
// Version "v2023.2_27.15"
//
simulator lang=spectre
include "/import/yukari1/lrburle/sky130RHBDlib/calibre/sky130_rhbd_output/spice/TMRDFFQNX1.pex.spice"
subckt TMRDFFQNX1 (  D CLK QN VDD GND )
//
// GND	GND
// VDD	VDD
// QN	QN
// CLK	CLK
// D	D
M0_noxref ( N_GND_M0_noxref_d N_noxref_5_M0_noxref_g N_noxref_30_M0_noxref_s \
 noxref_723 ) NMOS l=0.163119 w=2.35104 m=1
M1_noxref ( N_noxref_23_M1_noxref_d N_CLK_M1_noxref_g N_noxref_30_M0_noxref_s \
 noxref_723 ) NMOS l=0.160516 w=2.29447 m=1
M2_noxref ( N_noxref_3_M2_noxref_d N_noxref_1_M2_noxref_g \
 N_noxref_23_M2_noxref_s noxref_723 ) NMOS l=0.163346 w=2.31104 m=1
M3_noxref ( N_GND_M3_noxref_d N_noxref_3_M3_noxref_g N_noxref_31_M3_noxref_s \
 noxref_723 ) NMOS l=0.163119 w=2.35104 m=1
M4_noxref ( N_noxref_1_M4_noxref_d N_D_M4_noxref_g N_noxref_31_M3_noxref_s \
 noxref_723 ) NMOS l=0.163346 w=2.31104 m=1
M5_noxref ( N_GND_M5_noxref_d N_noxref_1_M5_noxref_g N_noxref_32_M5_noxref_s \
 noxref_723 ) NMOS l=0.163119 w=2.35104 m=1
M6_noxref ( N_noxref_2_M6_noxref_d N_noxref_5_M6_noxref_g \
 N_noxref_32_M5_noxref_s noxref_723 ) NMOS l=0.163346 w=2.31104 m=1
M7_noxref ( N_GND_M7_noxref_d N_noxref_2_M7_noxref_g N_noxref_33_M7_noxref_s \
 noxref_723 ) NMOS l=0.163119 w=2.35104 m=1
M8_noxref ( N_noxref_5_M8_noxref_d N_CLK_M8_noxref_g N_noxref_33_M7_noxref_s \
 noxref_723 ) NMOS l=0.163346 w=2.31104 m=1
M9_noxref ( N_GND_M9_noxref_d N_noxref_3_M9_noxref_g N_noxref_34_M9_noxref_s \
 noxref_723 ) NMOS l=0.163119 w=2.35104 m=1
M10_noxref ( N_noxref_4_M10_noxref_d N_noxref_20_M10_noxref_g \
 N_noxref_34_M9_noxref_s noxref_723 ) NMOS l=0.163346 w=2.31104 m=1
M11_noxref ( N_GND_M11_noxref_d N_noxref_4_M11_noxref_g \
 N_noxref_35_M11_noxref_s noxref_723 ) NMOS l=0.163119 w=2.35104 m=1
M12_noxref ( N_noxref_20_M12_noxref_d N_noxref_5_M12_noxref_g \
 N_noxref_35_M11_noxref_s noxref_723 ) NMOS l=0.163346 w=2.31104 m=1
M13_noxref ( N_GND_M13_noxref_d N_noxref_11_M13_noxref_g \
 N_noxref_36_M13_noxref_s noxref_723 ) NMOS l=0.163119 w=2.35104 m=1
M14_noxref ( N_noxref_24_M14_noxref_d N_CLK_M14_noxref_g \
 N_noxref_36_M13_noxref_s noxref_723 ) NMOS l=0.160516 w=2.29447 m=1
M15_noxref ( N_noxref_9_M15_noxref_d N_noxref_7_M15_noxref_g \
 N_noxref_24_M15_noxref_s noxref_723 ) NMOS l=0.163346 w=2.31104 m=1
M16_noxref ( N_GND_M16_noxref_d N_noxref_9_M16_noxref_g \
 N_noxref_37_M16_noxref_s noxref_723 ) NMOS l=0.163119 w=2.35104 m=1
M17_noxref ( N_noxref_7_M17_noxref_d N_D_M17_noxref_g N_noxref_37_M16_noxref_s \
 noxref_723 ) NMOS l=0.163346 w=2.31104 m=1
M18_noxref ( N_GND_M18_noxref_d N_noxref_7_M18_noxref_g \
 N_noxref_38_M18_noxref_s noxref_723 ) NMOS l=0.163119 w=2.35104 m=1
M19_noxref ( N_noxref_8_M19_noxref_d N_noxref_11_M19_noxref_g \
 N_noxref_38_M18_noxref_s noxref_723 ) NMOS l=0.163346 w=2.31104 m=1
M20_noxref ( N_GND_M20_noxref_d N_noxref_8_M20_noxref_g \
 N_noxref_39_M20_noxref_s noxref_723 ) NMOS l=0.163119 w=2.35104 m=1
M21_noxref ( N_noxref_11_M21_noxref_d N_CLK_M21_noxref_g \
 N_noxref_39_M20_noxref_s noxref_723 ) NMOS l=0.163346 w=2.31104 m=1
M22_noxref ( N_GND_M22_noxref_d N_noxref_9_M22_noxref_g \
 N_noxref_40_M22_noxref_s noxref_723 ) NMOS l=0.163119 w=2.35104 m=1
M23_noxref ( N_noxref_10_M23_noxref_d N_noxref_19_M23_noxref_g \
 N_noxref_40_M22_noxref_s noxref_723 ) NMOS l=0.163346 w=2.31104 m=1
M24_noxref ( N_GND_M24_noxref_d N_noxref_10_M24_noxref_g \
 N_noxref_41_M24_noxref_s noxref_723 ) NMOS l=0.163119 w=2.35104 m=1
M25_noxref ( N_noxref_25_M25_noxref_d N_noxref_11_M25_noxref_g \
 N_noxref_41_M24_noxref_s noxref_723 ) NMOS l=0.163346 w=2.31104 m=1
M26_noxref ( N_GND_M26_noxref_d N_noxref_17_M26_noxref_g \
 N_noxref_42_M26_noxref_s noxref_723 ) NMOS l=0.163119 w=2.35104 m=1
M27_noxref ( N_noxref_26_M27_noxref_d N_CLK_M27_noxref_g \
 N_noxref_42_M26_noxref_s noxref_723 ) NMOS l=0.160516 w=2.29447 m=1
M28_noxref ( N_noxref_15_M28_noxref_d N_noxref_12_M28_noxref_g \
 N_noxref_26_M28_noxref_s noxref_723 ) NMOS l=0.163346 w=2.31104 m=1
M29_noxref ( N_GND_M29_noxref_d N_noxref_15_M29_noxref_g \
 N_noxref_43_M29_noxref_s noxref_723 ) NMOS l=0.163119 w=2.35104 m=1
M30_noxref ( N_noxref_12_M30_noxref_d N_D_M30_noxref_g \
 N_noxref_43_M29_noxref_s noxref_723 ) NMOS l=0.163346 w=2.31104 m=1
M31_noxref ( N_GND_M31_noxref_d N_noxref_12_M31_noxref_g \
 N_noxref_44_M31_noxref_s noxref_723 ) NMOS l=0.163119 w=2.35104 m=1
M32_noxref ( N_noxref_13_M32_noxref_d N_noxref_17_M32_noxref_g \
 N_noxref_44_M31_noxref_s noxref_723 ) NMOS l=0.163346 w=2.31104 m=1
M33_noxref ( N_GND_M33_noxref_d N_noxref_13_M33_noxref_g \
 N_noxref_45_M33_noxref_s noxref_723 ) NMOS l=0.163119 w=2.35104 m=1
M34_noxref ( N_noxref_17_M34_noxref_d N_CLK_M34_noxref_g \
 N_noxref_45_M33_noxref_s noxref_723 ) NMOS l=0.163346 w=2.31104 m=1
M35_noxref ( N_GND_M35_noxref_d N_noxref_15_M35_noxref_g \
 N_noxref_46_M35_noxref_s noxref_723 ) NMOS l=0.163119 w=2.35104 m=1
M36_noxref ( N_noxref_16_M36_noxref_d N_noxref_18_M36_noxref_g \
 N_noxref_46_M35_noxref_s noxref_723 ) NMOS l=0.163346 w=2.31104 m=1
M37_noxref ( N_GND_M37_noxref_d N_noxref_16_M37_noxref_g \
 N_noxref_47_M37_noxref_s noxref_723 ) NMOS l=0.163119 w=2.35104 m=1
M38_noxref ( N_noxref_18_M38_noxref_d N_noxref_17_M38_noxref_g \
 N_noxref_47_M37_noxref_s noxref_723 ) NMOS l=0.163346 w=2.31104 m=1
M39_noxref ( N_GND_M39_noxref_d N_noxref_18_M39_noxref_g \
 N_noxref_48_M39_noxref_s noxref_723 ) NMOS l=0.163119 w=2.35104 m=1
M40_noxref ( N_QN_M40_noxref_d N_noxref_19_M40_noxref_g \
 N_noxref_48_M39_noxref_s noxref_723 ) NMOS l=0.163346 w=2.31104 m=1
M41_noxref ( noxref_49 N_noxref_18_M41_noxref_g N_noxref_51_M41_noxref_s \
 noxref_723 ) NMOS l=0.163119 w=2.35104 m=1
M42_noxref ( N_QN_M42_noxref_d N_noxref_20_M42_noxref_g \
 N_noxref_51_M41_noxref_s noxref_723 ) NMOS l=0.163346 w=2.31104 m=1
M43_noxref ( N_GND_M43_noxref_d N_noxref_20_M43_noxref_g \
 N_noxref_52_M43_noxref_s noxref_723 ) NMOS l=0.163119 w=2.35104 m=1
M44_noxref ( N_QN_M44_noxref_d N_noxref_19_M44_noxref_g \
 N_noxref_52_M43_noxref_s noxref_723 ) NMOS l=0.163129 w=2.31397 m=1
M45_noxref ( N_noxref_3_M45_noxref_d N_noxref_5_M45_noxref_g \
 N_VDD_M45_noxref_s noxref_721 ) PMOS l=0.15 w=2 ad=0.57 as=0.57 pd=2.57 \
 ps=2.57 nrd=0 nrs=0 m=1
M46_noxref ( N_VDD_M46_noxref_d N_noxref_5_M46_noxref_g \
 N_noxref_3_M45_noxref_d noxref_721 ) PMOS l=0.15 w=2 ad=0.58 as=0.58 pd=2.58 \
 ps=2.58 nrd=0 nrs=0 m=1
M47_noxref ( N_noxref_3_M47_noxref_d N_CLK_M47_noxref_g N_VDD_M46_noxref_d \
 noxref_721 ) PMOS l=0.15 w=2 ad=0.58 as=0.58 pd=2.58 ps=2.58 nrd=0 nrs=0 m=1
M48_noxref ( N_VDD_M48_noxref_d N_CLK_M48_noxref_g N_noxref_3_M47_noxref_d \
 noxref_721 ) PMOS l=0.15 w=2 ad=0.58 as=0.58 pd=2.58 ps=2.58 nrd=0 nrs=0 m=1
M49_noxref ( N_noxref_3_M49_noxref_d N_noxref_1_M49_noxref_g \
 N_VDD_M48_noxref_d noxref_721 ) PMOS l=0.15 w=2 ad=0.58 as=0.58 pd=2.58 \
 ps=2.58 nrd=0 nrs=0 m=1
M50_noxref ( N_VDD_M50_noxref_d N_noxref_1_M50_noxref_g \
 N_noxref_3_M49_noxref_d noxref_721 ) PMOS l=0.15 w=2 ad=0.56 as=0.56 pd=2.56 \
 ps=2.56 nrd=0 nrs=0 m=1
M51_noxref ( N_noxref_1_M51_noxref_d N_noxref_3_M51_noxref_g \
 N_VDD_M51_noxref_s noxref_721 ) PMOS l=0.15 w=2 ad=0.57 as=0.57 pd=2.57 \
 ps=2.57 nrd=0 nrs=0 m=1
M52_noxref ( N_VDD_M52_noxref_d N_noxref_3_M52_noxref_g \
 N_noxref_1_M51_noxref_d noxref_721 ) PMOS l=0.15 w=2 ad=0.58 as=0.58 pd=2.58 \
 ps=2.58 nrd=0 nrs=0 m=1
M53_noxref ( N_noxref_1_M53_noxref_d N_D_M53_noxref_g N_VDD_M52_noxref_d \
 noxref_721 ) PMOS l=0.15 w=2 ad=0.58 as=0.58 pd=2.58 ps=2.58 nrd=0 nrs=0 m=1
M54_noxref ( N_VDD_M54_noxref_d N_D_M54_noxref_g N_noxref_1_M53_noxref_d \
 noxref_721 ) PMOS l=0.15 w=2 ad=0.56 as=0.56 pd=2.56 ps=2.56 nrd=0 nrs=0 m=1
M55_noxref ( N_noxref_2_M55_noxref_d N_noxref_1_M55_noxref_g \
 N_VDD_M55_noxref_s noxref_721 ) PMOS l=0.15 w=2 ad=0.57 as=0.57 pd=2.57 \
 ps=2.57 nrd=0 nrs=0 m=1
M56_noxref ( N_VDD_M56_noxref_d N_noxref_1_M56_noxref_g \
 N_noxref_2_M55_noxref_d noxref_721 ) PMOS l=0.15 w=2 ad=0.58 as=0.58 pd=2.58 \
 ps=2.58 nrd=0 nrs=0 m=1
M57_noxref ( N_noxref_2_M57_noxref_d N_noxref_5_M57_noxref_g \
 N_VDD_M56_noxref_d noxref_721 ) PMOS l=0.15 w=2 ad=0.58 as=0.58 pd=2.58 \
 ps=2.58 nrd=0 nrs=0 m=1
M58_noxref ( N_VDD_M58_noxref_d N_noxref_5_M58_noxref_g \
 N_noxref_2_M57_noxref_d noxref_721 ) PMOS l=0.15 w=2 ad=0.56 as=0.56 pd=2.56 \
 ps=2.56 nrd=0 nrs=0 m=1
M59_noxref ( N_noxref_5_M59_noxref_d N_noxref_2_M59_noxref_g \
 N_VDD_M59_noxref_s noxref_721 ) PMOS l=0.15 w=2 ad=0.57 as=0.57 pd=2.57 \
 ps=2.57 nrd=0 nrs=0 m=1
M60_noxref ( N_VDD_M60_noxref_d N_noxref_2_M60_noxref_g \
 N_noxref_5_M59_noxref_d noxref_721 ) PMOS l=0.15 w=2 ad=0.58 as=0.58 pd=2.58 \
 ps=2.58 nrd=0 nrs=0 m=1
M61_noxref ( N_noxref_5_M61_noxref_d N_CLK_M61_noxref_g N_VDD_M60_noxref_d \
 noxref_721 ) PMOS l=0.15 w=2 ad=0.58 as=0.58 pd=2.58 ps=2.58 nrd=0 nrs=0 m=1
M62_noxref ( N_VDD_M62_noxref_d N_CLK_M62_noxref_g N_noxref_5_M61_noxref_d \
 noxref_721 ) PMOS l=0.15 w=2 ad=0.56 as=0.56 pd=2.56 ps=2.56 nrd=0 nrs=0 m=1
M63_noxref ( N_noxref_4_M63_noxref_d N_noxref_3_M63_noxref_g \
 N_VDD_M63_noxref_s noxref_721 ) PMOS l=0.15 w=2 ad=0.57 as=0.57 pd=2.57 \
 ps=2.57 nrd=0 nrs=0 m=1
M64_noxref ( N_VDD_M64_noxref_d N_noxref_3_M64_noxref_g \
 N_noxref_4_M63_noxref_d noxref_721 ) PMOS l=0.15 w=2 ad=0.58 as=0.58 pd=2.58 \
 ps=2.58 nrd=0 nrs=0 m=1
M65_noxref ( N_noxref_4_M65_noxref_d N_noxref_20_M65_noxref_g \
 N_VDD_M64_noxref_d noxref_721 ) PMOS l=0.15 w=2 ad=0.58 as=0.58 pd=2.58 \
 ps=2.58 nrd=0 nrs=0 m=1
M66_noxref ( N_VDD_M66_noxref_d N_noxref_20_M66_noxref_g \
 N_noxref_4_M65_noxref_d noxref_721 ) PMOS l=0.15 w=2 ad=0.56 as=0.56 pd=2.56 \
 ps=2.56 nrd=0 nrs=0 m=1
M67_noxref ( N_noxref_20_M67_noxref_d N_noxref_4_M67_noxref_g \
 N_VDD_M67_noxref_s noxref_721 ) PMOS l=0.15 w=2 ad=0.57 as=0.57 pd=2.57 \
 ps=2.57 nrd=0 nrs=0 m=1
M68_noxref ( N_VDD_M68_noxref_d N_noxref_4_M68_noxref_g \
 N_noxref_20_M67_noxref_d noxref_721 ) PMOS l=0.15 w=2 ad=0.58 as=0.58 pd=2.58 \
 ps=2.58 nrd=0 nrs=0 m=1
M69_noxref ( N_noxref_20_M69_noxref_d N_noxref_5_M69_noxref_g \
 N_VDD_M68_noxref_d noxref_721 ) PMOS l=0.15 w=2 ad=0.58 as=0.58 pd=2.58 \
 ps=2.58 nrd=0 nrs=0 m=1
M70_noxref ( N_VDD_M70_noxref_d N_noxref_5_M70_noxref_g \
 N_noxref_20_M69_noxref_d noxref_721 ) PMOS l=0.15 w=2 ad=0.56 as=0.56 pd=2.56 \
 ps=2.56 nrd=0 nrs=0 m=1
M71_noxref ( N_noxref_9_M71_noxref_d N_noxref_11_M71_noxref_g \
 N_VDD_M71_noxref_s noxref_721 ) PMOS l=0.15 w=2 ad=0.57 as=0.57 pd=2.57 \
 ps=2.57 nrd=0 nrs=0 m=1
M72_noxref ( N_VDD_M72_noxref_d N_noxref_11_M72_noxref_g \
 N_noxref_9_M71_noxref_d noxref_721 ) PMOS l=0.15 w=2 ad=0.58 as=0.58 pd=2.58 \
 ps=2.58 nrd=0 nrs=0 m=1
M73_noxref ( N_noxref_9_M73_noxref_d N_CLK_M73_noxref_g N_VDD_M72_noxref_d \
 noxref_721 ) PMOS l=0.15 w=2 ad=0.58 as=0.58 pd=2.58 ps=2.58 nrd=0 nrs=0 m=1
M74_noxref ( N_VDD_M74_noxref_d N_CLK_M74_noxref_g N_noxref_9_M73_noxref_d \
 noxref_721 ) PMOS l=0.15 w=2 ad=0.58 as=0.58 pd=2.58 ps=2.58 nrd=0 nrs=0 m=1
M75_noxref ( N_noxref_9_M75_noxref_d N_noxref_7_M75_noxref_g \
 N_VDD_M74_noxref_d noxref_721 ) PMOS l=0.15 w=2 ad=0.58 as=0.58 pd=2.58 \
 ps=2.58 nrd=0 nrs=0 m=1
M76_noxref ( N_VDD_M76_noxref_d N_noxref_7_M76_noxref_g \
 N_noxref_9_M75_noxref_d noxref_721 ) PMOS l=0.15 w=2 ad=0.56 as=0.56 pd=2.56 \
 ps=2.56 nrd=0 nrs=0 m=1
M77_noxref ( N_noxref_7_M77_noxref_d N_noxref_9_M77_noxref_g \
 N_VDD_M77_noxref_s noxref_721 ) PMOS l=0.15 w=2 ad=0.57 as=0.57 pd=2.57 \
 ps=2.57 nrd=0 nrs=0 m=1
M78_noxref ( N_VDD_M78_noxref_d N_noxref_9_M78_noxref_g \
 N_noxref_7_M77_noxref_d noxref_721 ) PMOS l=0.15 w=2 ad=0.58 as=0.58 pd=2.58 \
 ps=2.58 nrd=0 nrs=0 m=1
M79_noxref ( N_noxref_7_M79_noxref_d N_D_M79_noxref_g N_VDD_M78_noxref_d \
 noxref_721 ) PMOS l=0.15 w=2 ad=0.58 as=0.58 pd=2.58 ps=2.58 nrd=0 nrs=0 m=1
M80_noxref ( N_VDD_M80_noxref_d N_D_M80_noxref_g N_noxref_7_M79_noxref_d \
 noxref_721 ) PMOS l=0.15 w=2 ad=0.56 as=0.56 pd=2.56 ps=2.56 nrd=0 nrs=0 m=1
M81_noxref ( N_noxref_8_M81_noxref_d N_noxref_7_M81_noxref_g \
 N_VDD_M81_noxref_s noxref_721 ) PMOS l=0.15 w=2 ad=0.57 as=0.57 pd=2.57 \
 ps=2.57 nrd=0 nrs=0 m=1
M82_noxref ( N_VDD_M82_noxref_d N_noxref_7_M82_noxref_g \
 N_noxref_8_M81_noxref_d noxref_721 ) PMOS l=0.15 w=2 ad=0.58 as=0.58 pd=2.58 \
 ps=2.58 nrd=0 nrs=0 m=1
M83_noxref ( N_noxref_8_M83_noxref_d N_noxref_11_M83_noxref_g \
 N_VDD_M82_noxref_d noxref_721 ) PMOS l=0.15 w=2 ad=0.58 as=0.58 pd=2.58 \
 ps=2.58 nrd=0 nrs=0 m=1
M84_noxref ( N_VDD_M84_noxref_d N_noxref_11_M84_noxref_g \
 N_noxref_8_M83_noxref_d noxref_721 ) PMOS l=0.15 w=2 ad=0.56 as=0.56 pd=2.56 \
 ps=2.56 nrd=0 nrs=0 m=1
M85_noxref ( N_noxref_11_M85_noxref_d N_noxref_8_M85_noxref_g \
 N_VDD_M85_noxref_s noxref_721 ) PMOS l=0.15 w=2 ad=0.57 as=0.57 pd=2.57 \
 ps=2.57 nrd=0 nrs=0 m=1
M86_noxref ( N_VDD_M86_noxref_d N_noxref_8_M86_noxref_g \
 N_noxref_11_M85_noxref_d noxref_721 ) PMOS l=0.15 w=2 ad=0.58 as=0.58 pd=2.58 \
 ps=2.58 nrd=0 nrs=0 m=1
M87_noxref ( N_noxref_11_M87_noxref_d N_CLK_M87_noxref_g N_VDD_M86_noxref_d \
 noxref_721 ) PMOS l=0.15 w=2 ad=0.58 as=0.58 pd=2.58 ps=2.58 nrd=0 nrs=0 m=1
M88_noxref ( N_VDD_M88_noxref_d N_CLK_M88_noxref_g N_noxref_11_M87_noxref_d \
 noxref_721 ) PMOS l=0.15 w=2 ad=0.56 as=0.56 pd=2.56 ps=2.56 nrd=0 nrs=0 m=1
M89_noxref ( N_noxref_10_M89_noxref_d N_noxref_9_M89_noxref_g \
 N_VDD_M89_noxref_s noxref_721 ) PMOS l=0.15 w=2 ad=0.57 as=0.57 pd=2.57 \
 ps=2.57 nrd=0 nrs=0 m=1
M90_noxref ( N_VDD_M90_noxref_d N_noxref_9_M90_noxref_g \
 N_noxref_10_M89_noxref_d noxref_721 ) PMOS l=0.15 w=2 ad=0.58 as=0.58 pd=2.58 \
 ps=2.58 nrd=0 nrs=0 m=1
M91_noxref ( N_noxref_10_M91_noxref_d N_noxref_19_M91_noxref_g \
 N_VDD_M90_noxref_d noxref_721 ) PMOS l=0.15 w=2 ad=0.58 as=0.58 pd=2.58 \
 ps=2.58 nrd=0 nrs=0 m=1
M92_noxref ( N_VDD_M92_noxref_d N_noxref_19_M92_noxref_g \
 N_noxref_10_M91_noxref_d noxref_721 ) PMOS l=0.15 w=2 ad=0.56 as=0.56 pd=2.56 \
 ps=2.56 nrd=0 nrs=0 m=1
M93_noxref ( N_noxref_25_M93_noxref_d N_noxref_10_M93_noxref_g \
 N_VDD_M93_noxref_s noxref_721 ) PMOS l=0.15 w=2 ad=0.57 as=0.57 pd=2.57 \
 ps=2.57 nrd=0 nrs=0 m=1
M94_noxref ( N_VDD_M94_noxref_d N_noxref_10_M94_noxref_g \
 N_noxref_25_M93_noxref_d noxref_721 ) PMOS l=0.15 w=2 ad=0.58 as=0.58 pd=2.58 \
 ps=2.58 nrd=0 nrs=0 m=1
M95_noxref ( N_noxref_25_M95_noxref_d N_noxref_11_M95_noxref_g \
 N_VDD_M94_noxref_d noxref_721 ) PMOS l=0.15 w=2 ad=0.58 as=0.58 pd=2.58 \
 ps=2.58 nrd=0 nrs=0 m=1
M96_noxref ( N_VDD_M96_noxref_d N_noxref_11_M96_noxref_g \
 N_noxref_25_M95_noxref_d noxref_721 ) PMOS l=0.15 w=2 ad=0.56 as=0.56 pd=2.56 \
 ps=2.56 nrd=0 nrs=0 m=1
M97_noxref ( N_noxref_15_M97_noxref_d N_noxref_17_M97_noxref_g \
 N_VDD_M97_noxref_s noxref_721 ) PMOS l=0.15 w=2 ad=0.57 as=0.57 pd=2.57 \
 ps=2.57 nrd=0 nrs=0 m=1
M98_noxref ( N_VDD_M98_noxref_d N_noxref_17_M98_noxref_g \
 N_noxref_15_M97_noxref_d noxref_721 ) PMOS l=0.15 w=2 ad=0.58 as=0.58 pd=2.58 \
 ps=2.58 nrd=0 nrs=0 m=1
M99_noxref ( N_noxref_15_M99_noxref_d N_CLK_M99_noxref_g N_VDD_M98_noxref_d \
 noxref_721 ) PMOS l=0.15 w=2 ad=0.58 as=0.58 pd=2.58 ps=2.58 nrd=0 nrs=0 m=1
M100_noxref ( N_VDD_M100_noxref_d N_CLK_M100_noxref_g N_noxref_15_M99_noxref_d \
 noxref_721 ) PMOS l=0.15 w=2 ad=0.58 as=0.58 pd=2.58 ps=2.58 nrd=0 nrs=0 m=1
M101_noxref ( N_noxref_15_M101_noxref_d N_noxref_12_M101_noxref_g \
 N_VDD_M100_noxref_d noxref_721 ) PMOS l=0.15 w=2 ad=0.58 as=0.58 pd=2.58 \
 ps=2.58 nrd=0 nrs=0 m=1
M102_noxref ( N_VDD_M102_noxref_d N_noxref_12_M102_noxref_g \
 N_noxref_15_M101_noxref_d noxref_721 ) PMOS l=0.15 w=2 ad=0.56 as=0.56 \
 pd=2.56 ps=2.56 nrd=0 nrs=0 m=1
M103_noxref ( N_noxref_12_M103_noxref_d N_noxref_15_M103_noxref_g \
 N_VDD_M103_noxref_s noxref_721 ) PMOS l=0.15 w=2 ad=0.57 as=0.57 pd=2.57 \
 ps=2.57 nrd=0 nrs=0 m=1
M104_noxref ( N_VDD_M104_noxref_d N_noxref_15_M104_noxref_g \
 N_noxref_12_M103_noxref_d noxref_721 ) PMOS l=0.15 w=2 ad=0.58 as=0.58 \
 pd=2.58 ps=2.58 nrd=0 nrs=0 m=1
M105_noxref ( N_noxref_12_M105_noxref_d N_D_M105_noxref_g N_VDD_M104_noxref_d \
 noxref_721 ) PMOS l=0.15 w=2 ad=0.58 as=0.58 pd=2.58 ps=2.58 nrd=0 nrs=0 m=1
M106_noxref ( N_VDD_M106_noxref_d N_D_M106_noxref_g N_noxref_12_M105_noxref_d \
 noxref_721 ) PMOS l=0.15 w=2 ad=0.56 as=0.56 pd=2.56 ps=2.56 nrd=0 nrs=0 m=1
M107_noxref ( N_noxref_13_M107_noxref_d N_noxref_12_M107_noxref_g \
 N_VDD_M107_noxref_s noxref_721 ) PMOS l=0.15 w=2 ad=0.57 as=0.57 pd=2.57 \
 ps=2.57 nrd=0 nrs=0 m=1
M108_noxref ( N_VDD_M108_noxref_d N_noxref_12_M108_noxref_g \
 N_noxref_13_M107_noxref_d noxref_721 ) PMOS l=0.15 w=2 ad=0.58 as=0.58 \
 pd=2.58 ps=2.58 nrd=0 nrs=0 m=1
M109_noxref ( N_noxref_13_M109_noxref_d N_noxref_17_M109_noxref_g \
 N_VDD_M108_noxref_d noxref_721 ) PMOS l=0.15 w=2 ad=0.58 as=0.58 pd=2.58 \
 ps=2.58 nrd=0 nrs=0 m=1
M110_noxref ( N_VDD_M110_noxref_d N_noxref_17_M110_noxref_g \
 N_noxref_13_M109_noxref_d noxref_721 ) PMOS l=0.15 w=2 ad=0.56 as=0.56 \
 pd=2.56 ps=2.56 nrd=0 nrs=0 m=1
M111_noxref ( N_noxref_17_M111_noxref_d N_noxref_13_M111_noxref_g \
 N_VDD_M111_noxref_s noxref_721 ) PMOS l=0.15 w=2 ad=0.57 as=0.57 pd=2.57 \
 ps=2.57 nrd=0 nrs=0 m=1
M112_noxref ( N_VDD_M112_noxref_d N_noxref_13_M112_noxref_g \
 N_noxref_17_M111_noxref_d noxref_721 ) PMOS l=0.15 w=2 ad=0.58 as=0.58 \
 pd=2.58 ps=2.58 nrd=0 nrs=0 m=1
M113_noxref ( N_noxref_17_M113_noxref_d N_CLK_M113_noxref_g \
 N_VDD_M112_noxref_d noxref_721 ) PMOS l=0.15 w=2 ad=0.58 as=0.58 pd=2.58 \
 ps=2.58 nrd=0 nrs=0 m=1
M114_noxref ( N_VDD_M114_noxref_d N_CLK_M114_noxref_g \
 N_noxref_17_M113_noxref_d noxref_721 ) PMOS l=0.15 w=2 ad=0.56 as=0.56 \
 pd=2.56 ps=2.56 nrd=0 nrs=0 m=1
M115_noxref ( N_noxref_16_M115_noxref_d N_noxref_15_M115_noxref_g \
 N_VDD_M115_noxref_s noxref_721 ) PMOS l=0.15 w=2 ad=0.57 as=0.57 pd=2.57 \
 ps=2.57 nrd=0 nrs=0 m=1
M116_noxref ( N_VDD_M116_noxref_d N_noxref_15_M116_noxref_g \
 N_noxref_16_M115_noxref_d noxref_721 ) PMOS l=0.15 w=2 ad=0.58 as=0.58 \
 pd=2.58 ps=2.58 nrd=0 nrs=0 m=1
M117_noxref ( N_noxref_16_M117_noxref_d N_noxref_18_M117_noxref_g \
 N_VDD_M116_noxref_d noxref_721 ) PMOS l=0.15 w=2 ad=0.58 as=0.58 pd=2.58 \
 ps=2.58 nrd=0 nrs=0 m=1
M118_noxref ( N_VDD_M118_noxref_d N_noxref_18_M118_noxref_g \
 N_noxref_16_M117_noxref_d noxref_721 ) PMOS l=0.15 w=2 ad=0.56 as=0.56 \
 pd=2.56 ps=2.56 nrd=0 nrs=0 m=1
M119_noxref ( N_noxref_18_M119_noxref_d N_noxref_16_M119_noxref_g \
 N_VDD_M119_noxref_s noxref_721 ) PMOS l=0.15 w=2 ad=0.57 as=0.57 pd=2.57 \
 ps=2.57 nrd=0 nrs=0 m=1
M120_noxref ( N_VDD_M120_noxref_d N_noxref_16_M120_noxref_g \
 N_noxref_18_M119_noxref_d noxref_721 ) PMOS l=0.15 w=2 ad=0.58 as=0.58 \
 pd=2.58 ps=2.58 nrd=0 nrs=0 m=1
M121_noxref ( N_noxref_18_M121_noxref_d N_noxref_17_M121_noxref_g \
 N_VDD_M120_noxref_d noxref_721 ) PMOS l=0.15 w=2 ad=0.58 as=0.58 pd=2.58 \
 ps=2.58 nrd=0 nrs=0 m=1
M122_noxref ( N_VDD_M122_noxref_d N_noxref_17_M122_noxref_g \
 N_noxref_18_M121_noxref_d noxref_721 ) PMOS l=0.15 w=2 ad=0.56 as=0.56 \
 pd=2.56 ps=2.56 nrd=0 nrs=0 m=1
M123_noxref ( N_noxref_27_M123_noxref_d N_noxref_18_M123_noxref_g \
 N_VDD_M123_noxref_s noxref_721 ) PMOS l=0.15 w=2 ad=0.57 as=0.57 pd=2.57 \
 ps=2.57 nrd=0 nrs=0 m=1
M124_noxref ( N_VDD_M124_noxref_d N_noxref_18_M124_noxref_g \
 N_noxref_27_M123_noxref_d noxref_721 ) PMOS l=0.15 w=2 ad=0.58 as=0.58 \
 pd=2.58 ps=2.58 nrd=0 nrs=0 m=1
M125_noxref ( N_noxref_27_M125_noxref_d N_noxref_19_M125_noxref_g \
 N_VDD_M124_noxref_d noxref_721 ) PMOS l=0.15 w=2 ad=0.58 as=0.58 pd=2.58 \
 ps=2.58 nrd=0 nrs=0 m=1
M126_noxref ( N_VDD_M126_noxref_d N_noxref_19_M126_noxref_g \
 N_noxref_27_M125_noxref_d noxref_721 ) PMOS l=0.15 w=2 ad=0.56 as=0.56 \
 pd=2.56 ps=2.56 nrd=0 nrs=0 m=1
M127_noxref ( N_noxref_28_M127_noxref_d N_noxref_18_M127_noxref_g \
 N_noxref_27_M127_noxref_s noxref_721 ) PMOS l=0.15 w=2 ad=0.56 as=0.56 \
 pd=2.56 ps=2.56 nrd=0 nrs=0 m=1
M128_noxref ( N_noxref_27_M128_noxref_d N_noxref_18_M128_noxref_g \
 N_noxref_28_M127_noxref_d noxref_721 ) PMOS l=0.15 w=2 ad=0.58 as=0.58 \
 pd=2.58 ps=2.58 nrd=0 nrs=0 m=1
M129_noxref ( noxref_50 N_noxref_20_M129_noxref_g N_noxref_27_M128_noxref_d \
 noxref_721 ) PMOS l=0.15 w=2 ad=0.58 as=0.58 pd=2.58 ps=2.58 nrd=0 nrs=0 m=1
M130_noxref ( N_noxref_27_M130_noxref_d N_noxref_20_M130_noxref_g noxref_50 \
 noxref_721 ) PMOS l=0.15 w=2 ad=0.57 as=0.57 pd=2.57 ps=2.57 nrd=0 nrs=0 m=1
M131_noxref ( N_QN_M131_noxref_d N_noxref_20_M131_noxref_g \
 N_noxref_28_M131_noxref_s noxref_721 ) PMOS l=0.15 w=2 ad=0.57 as=0.57 \
 pd=2.57 ps=2.57 nrd=0 nrs=0 m=1
M132_noxref ( N_noxref_28_M132_noxref_d N_noxref_20_M132_noxref_g \
 N_QN_M131_noxref_d noxref_721 ) PMOS l=0.15 w=2 ad=0.58 as=0.58 pd=2.58 \
 ps=2.58 nrd=0 nrs=0 m=1
M133_noxref ( N_QN_M133_noxref_d N_noxref_19_M133_noxref_g \
 N_noxref_28_M132_noxref_d noxref_721 ) PMOS l=0.15 w=2 ad=0.58 as=0.58 \
 pd=2.58 ps=2.58 nrd=0 nrs=0 m=1
M134_noxref ( N_noxref_28_M134_noxref_d N_noxref_19_M134_noxref_g \
 N_QN_M133_noxref_d noxref_721 ) PMOS l=0.15 w=2 ad=0.56 as=0.56 pd=2.56 \
 ps=2.56 nrd=0 nrs=0 m=1
c_14862 ( noxref_49 0 ) capacitor c=0.0069842f //x=69.19 //y=1.045
c_14872 ( noxref_50 0 ) capacitor c=0.0143171f //x=70.155 //y=5.205
//
include "/import/yukari1/lrburle/sky130RHBDlib/calibre/sky130_rhbd_output/spice/TMRDFFQNX1.pxi.spice"
//
ends TMRDFFQNX1
//
//
