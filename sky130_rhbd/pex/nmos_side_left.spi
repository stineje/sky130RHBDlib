// File: nmos_side_left.spi
// Created: Thu Jan 22 07:14:42 2026
// Program "Calibre xRC"
// Version "v2023.2_27.15"
//
simulator lang=spectre
include "/import/yukari1/lrburle/sky130RHBDlib/sky130_rhbd/pex/nmos_side_left.pex.spice"
subckt nmos_side_left (  )
//
M0_noxref ( noxref_1 noxref_3 noxref_2 noxref_5 ) NMOS l=0.160516 w=2.29447 m=1
c_3 ( noxref_1 0 ) capacitor c=0.00901116f //x=0.435 //y=0.535
c_6 ( noxref_2 0 ) capacitor c=0.205234f //x=0 //y=0
c_9 ( noxref_3 0 ) capacitor c=0.211421f //x=0.622 //y=0.925
//
include "/import/yukari1/lrburle/sky130RHBDlib/sky130_rhbd/pex/nmos_side_left.pxi.spice"
//
ends NMOS_SIDE_LEFT
//
//
