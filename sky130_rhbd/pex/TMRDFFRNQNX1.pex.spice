// File: TMRDFFRNQNX1.spi.pex
// Created: Thu Jan 22 07:09:05 2026
// Program "Calibre xRC"
// Version "v2023.2_27.15"
// Nominal Temperature: 30C
// Circuit Temperature: 30C
//
simulator lang=spectre
subckt PM_TMRDFFRNQNX1\%noxref_1 ( 1 2 3 4 5 7 10 11 13 14 15 16 18 19 20 22 \
 23 30 32 35 38 44 47 50 53 54 56 57 58 60 62 64 65 72 75 84 89 97 105 122 131 \
 135 136 137 138 139 140 144 145 146 151 153 156 157 158 159 160 161 165 167 \
 170 171 176 177 182 191 194 196 197 198 )
c440 ( 194 0 ) capacitor c=0.00885916f //x=8.695 //y=1.095
c441 ( 191 0 ) capacitor c=0.0682508f //x=11.22 //y=4.88
c442 ( 182 0 ) capacitor c=0.0710579f //x=3.82 //y=4.88
c443 ( 177 0 ) capacitor c=0.0278202f //x=3.82 //y=2.095
c444 ( 176 0 ) capacitor c=0.0479324f //x=3.82 //y=2.26
c445 ( 171 0 ) capacitor c=0.0318956f //x=11.555 //y=1.39
c446 ( 170 0 ) capacitor c=0.0186809f //x=11.555 //y=1.045
c447 ( 167 0 ) capacitor c=0.0141821f //x=11.4 //y=1.545
c448 ( 165 0 ) capacitor c=0.0158553f //x=11.4 //y=0.89
c449 ( 161 0 ) capacitor c=0.0854195f //x=11.025 //y=2.095
c450 ( 160 0 ) capacitor c=0.0229235f //x=11.025 //y=1.7
c451 ( 159 0 ) capacitor c=0.0234359f //x=11.025 //y=1.39
c452 ( 158 0 ) capacitor c=0.0198759f //x=11.025 //y=1.045
c453 ( 157 0 ) capacitor c=0.0443175f //x=4.34 //y=1.44
c454 ( 156 0 ) capacitor c=0.0199703f //x=4.34 //y=1.095
c455 ( 153 0 ) capacitor c=0.0162526f //x=4.185 //y=1.595
c456 ( 151 0 ) capacitor c=0.0157807f //x=4.185 //y=0.94
c457 ( 146 0 ) capacitor c=0.0220935f //x=3.81 //y=1.75
c458 ( 145 0 ) capacitor c=0.0207489f //x=3.81 //y=1.44
c459 ( 144 0 ) capacitor c=0.0194091f //x=3.81 //y=1.095
c460 ( 140 0 ) capacitor c=0.110369f //x=11.56 //y=6.2
c461 ( 139 0 ) capacitor c=0.154619f //x=11.12 //y=6.2
c462 ( 138 0 ) capacitor c=0.159671f //x=4 //y=6.2
c463 ( 137 0 ) capacitor c=0.110208f //x=3.56 //y=6.2
c464 ( 131 0 ) capacitor c=8.13425e-19 //x=11.22 //y=4.88
c465 ( 122 0 ) capacitor c=7.85889e-19 //x=11.22 //y=2.26
c466 ( 105 0 ) capacitor c=0.0292634f //x=8.59 //y=5.56
c467 ( 97 0 ) capacitor c=0.029137f //x=7.71 //y=5.56
c468 ( 89 0 ) capacitor c=0.0278099f //x=6.83 //y=5.56
c469 ( 84 0 ) capacitor c=7.7417e-19 //x=3.82 //y=4.88
c470 ( 75 0 ) capacitor c=0.00101179f //x=3.82 //y=2.26
c471 ( 72 0 ) capacitor c=5.33433e-19 //x=11.22 //y=3.51
c472 ( 65 0 ) capacitor c=0.0374236f //x=9.535 //y=3.51
c473 ( 64 0 ) capacitor c=0.0228332f //x=11.06 //y=3.51
c474 ( 62 0 ) capacitor c=0.00710937f //x=6.63 //y=3.495
c475 ( 60 0 ) capacitor c=0.0381161f //x=6.03 //y=3.51
c476 ( 58 0 ) capacitor c=0.0188644f //x=4.78 //y=3.5
c477 ( 57 0 ) capacitor c=0.00332161f //x=3.98 //y=3.51
c478 ( 56 0 ) capacitor c=0.00726184f //x=4.18 //y=3.51
c479 ( 54 0 ) capacitor c=0.0268056f //x=11.222 //y=4.74
c480 ( 53 0 ) capacitor c=0.00611114f //x=11.22 //y=4.88
c481 ( 50 0 ) capacitor c=0.00463527f //x=11.22 //y=2.26
c482 ( 47 0 ) capacitor c=0.0161834f //x=11.22 //y=3.51
c483 ( 44 0 ) capacitor c=0.0170515f //x=9.37 //y=3.51
c484 ( 38 0 ) capacitor c=0.00112339f //x=8.59 //y=5.335
c485 ( 35 0 ) capacitor c=0.007583f //x=7.71 //y=5.335
c486 ( 32 0 ) capacitor c=0.0111234f //x=6.832 //y=5.335
c487 ( 30 0 ) capacitor c=0.0148558f //x=3.82 //y=3.51
c488 ( 23 0 ) capacitor c=0.013335f //x=11.22 //y=3.67
c489 ( 22 0 ) capacitor c=0.0276006f //x=11.22 //y=3.35
c490 ( 20 0 ) capacitor c=0.0423864f //x=9.37 //y=5.25
c491 ( 19 0 ) capacitor c=0.013011f //x=9.37 //y=3.67
c492 ( 18 0 ) capacitor c=0.039502f //x=9.37 //y=3.35
c493 ( 16 0 ) capacitor c=0.00493487f //x=8.97 //y=1.845
c494 ( 15 0 ) capacitor c=0.012936f //x=9.285 //y=1.845
c495 ( 14 0 ) capacitor c=0.0136149f //x=8.885 //y=1.76
c496 ( 13 0 ) capacitor c=0.0112307f //x=8.885 //y=1.305
c497 ( 11 0 ) capacitor c=0.0238781f //x=9.285 //y=5.335
c498 ( 10 0 ) capacitor c=0.00906713f //x=8.59 //y=5.56
c499 ( 7 0 ) capacitor c=0.019596f //x=8.475 //y=5.335
c500 ( 5 0 ) capacitor c=0.0151559f //x=7.59 //y=5.335
c501 ( 4 0 ) capacitor c=0.0286235f //x=3.82 //y=4.75
c502 ( 3 0 ) capacitor c=0.0129216f //x=3.82 //y=3.67
c503 ( 2 0 ) capacitor c=0.0274817f //x=3.82 //y=3.35
c504 ( 1 0 ) capacitor c=0.00685053f //x=3.82 //y=2.375
r505 (  189 191 ) resistor r=20.6867 //w=0.233 //l=0.1 //layer=ply \
 //thickness=0.18 //x=11.12 //y=4.88 //x2=11.22 //y2=4.88
r506 (  176 177 ) resistor r=52.7279 //w=0.214 //l=0.165 //layer=ply \
 //thickness=0.18 //x=3.82 //y=2.26 //x2=3.82 //y2=2.095
r507 (  172 191 ) resistor r=70.3348 //w=0.233 //l=0.414367 //layer=ply \
 //thickness=0.18 //x=11.56 //y=5.045 //x2=11.22 //y2=4.88
r508 (  171 193 ) resistor r=45.1352 //w=0.168 //l=0.173853 //layer=ply \
 //thickness=0.18 //x=11.555 //y=1.39 //x2=11.515 //y2=1.545
r509 (  170 192 ) resistor r=45.1352 //w=0.168 //l=0.173853 //layer=ply \
 //thickness=0.18 //x=11.555 //y=1.045 //x2=11.515 //y2=0.89
r510 (  170 171 ) resistor r=176.904 //w=0.094 //l=0.345 //layer=ply \
 //thickness=0.18 //x=11.555 //y=1.045 //x2=11.555 //y2=1.39
r511 (  168 188 ) resistor r=10.701 //w=0.21 //l=0.115 //layer=ply \
 //thickness=0.18 //x=11.18 //y=1.545 //x2=11.065 //y2=1.545
r512 (  167 193 ) resistor r=5.52526 //w=0.168 //l=0.115 //layer=ply \
 //thickness=0.18 //x=11.4 //y=1.545 //x2=11.515 //y2=1.545
r513 (  166 187 ) resistor r=5.52526 //w=0.168 //l=0.115 //layer=ply \
 //thickness=0.18 //x=11.18 //y=0.89 //x2=11.065 //y2=0.89
r514 (  165 192 ) resistor r=5.52526 //w=0.168 //l=0.115 //layer=ply \
 //thickness=0.18 //x=11.4 //y=0.89 //x2=11.515 //y2=0.89
r515 (  165 166 ) resistor r=112.809 //w=0.094 //l=0.22 //layer=ply \
 //thickness=0.18 //x=11.4 //y=0.89 //x2=11.18 //y2=0.89
r516 (  162 189 ) resistor r=13.0941 //w=0.233 //l=0.165 //layer=ply \
 //thickness=0.18 //x=11.12 //y=5.045 //x2=11.12 //y2=4.88
r517 (  161 186 ) resistor r=34.8111 //w=0.27 //l=0.264953 //layer=ply \
 //thickness=0.18 //x=11.025 //y=2.095 //x2=11.22 //y2=2.26
r518 (  160 188 ) resistor r=39.5823 //w=0.21 //l=0.173853 //layer=ply \
 //thickness=0.18 //x=11.025 //y=1.7 //x2=11.065 //y2=1.545
r519 (  160 161 ) resistor r=202.543 //w=0.094 //l=0.395 //layer=ply \
 //thickness=0.18 //x=11.025 //y=1.7 //x2=11.025 //y2=2.095
r520 (  159 188 ) resistor r=39.5823 //w=0.21 //l=0.173853 //layer=ply \
 //thickness=0.18 //x=11.025 //y=1.39 //x2=11.065 //y2=1.545
r521 (  158 187 ) resistor r=45.1352 //w=0.168 //l=0.173853 //layer=ply \
 //thickness=0.18 //x=11.025 //y=1.045 //x2=11.065 //y2=0.89
r522 (  158 159 ) resistor r=176.904 //w=0.094 //l=0.345 //layer=ply \
 //thickness=0.18 //x=11.025 //y=1.045 //x2=11.025 //y2=1.39
r523 (  157 184 ) resistor r=45.1352 //w=0.168 //l=0.173853 //layer=ply \
 //thickness=0.18 //x=4.34 //y=1.44 //x2=4.3 //y2=1.595
r524 (  156 183 ) resistor r=45.1352 //w=0.168 //l=0.173853 //layer=ply \
 //thickness=0.18 //x=4.34 //y=1.095 //x2=4.3 //y2=0.94
r525 (  156 157 ) resistor r=176.904 //w=0.094 //l=0.345 //layer=ply \
 //thickness=0.18 //x=4.34 //y=1.095 //x2=4.34 //y2=1.44
r526 (  154 180 ) resistor r=10.701 //w=0.21 //l=0.115 //layer=ply \
 //thickness=0.18 //x=3.965 //y=1.595 //x2=3.85 //y2=1.595
r527 (  153 184 ) resistor r=5.52526 //w=0.168 //l=0.115 //layer=ply \
 //thickness=0.18 //x=4.185 //y=1.595 //x2=4.3 //y2=1.595
r528 (  152 179 ) resistor r=5.52526 //w=0.168 //l=0.115 //layer=ply \
 //thickness=0.18 //x=3.965 //y=0.94 //x2=3.85 //y2=0.94
r529 (  151 183 ) resistor r=5.52526 //w=0.168 //l=0.115 //layer=ply \
 //thickness=0.18 //x=4.185 //y=0.94 //x2=4.3 //y2=0.94
r530 (  151 152 ) resistor r=112.809 //w=0.094 //l=0.22 //layer=ply \
 //thickness=0.18 //x=4.185 //y=0.94 //x2=3.965 //y2=0.94
r531 (  148 182 ) resistor r=37.236 //w=0.233 //l=0.249199 //layer=ply \
 //thickness=0.18 //x=4 //y=5.045 //x2=3.82 //y2=4.88
r532 (  146 180 ) resistor r=39.5823 //w=0.21 //l=0.173853 //layer=ply \
 //thickness=0.18 //x=3.81 //y=1.75 //x2=3.85 //y2=1.595
r533 (  146 177 ) resistor r=176.904 //w=0.094 //l=0.345 //layer=ply \
 //thickness=0.18 //x=3.81 //y=1.75 //x2=3.81 //y2=2.095
r534 (  145 180 ) resistor r=39.5823 //w=0.21 //l=0.173853 //layer=ply \
 //thickness=0.18 //x=3.81 //y=1.44 //x2=3.85 //y2=1.595
r535 (  144 179 ) resistor r=45.1352 //w=0.168 //l=0.173853 //layer=ply \
 //thickness=0.18 //x=3.81 //y=1.095 //x2=3.85 //y2=0.94
r536 (  144 145 ) resistor r=176.904 //w=0.094 //l=0.345 //layer=ply \
 //thickness=0.18 //x=3.81 //y=1.095 //x2=3.81 //y2=1.44
r537 (  141 182 ) resistor r=53.7854 //w=0.233 //l=0.332415 //layer=ply \
 //thickness=0.18 //x=3.56 //y=5.045 //x2=3.82 //y2=4.88
r538 (  140 172 ) resistor r=592.245 //w=0.094 //l=1.155 //layer=ply \
 //thickness=0.18 //x=11.56 //y=6.2 //x2=11.56 //y2=5.045
r539 (  139 162 ) resistor r=592.245 //w=0.094 //l=1.155 //layer=ply \
 //thickness=0.18 //x=11.12 //y=6.2 //x2=11.12 //y2=5.045
r540 (  138 148 ) resistor r=592.245 //w=0.094 //l=1.155 //layer=ply \
 //thickness=0.18 //x=4 //y=6.2 //x2=4 //y2=5.045
r541 (  137 141 ) resistor r=592.245 //w=0.094 //l=1.155 //layer=ply \
 //thickness=0.18 //x=3.56 //y=6.2 //x2=3.56 //y2=5.045
r542 (  136 167 ) resistor r=56.4043 //w=0.094 //l=0.11 //layer=ply \
 //thickness=0.18 //x=11.29 //y=1.545 //x2=11.4 //y2=1.545
r543 (  136 168 ) resistor r=56.4043 //w=0.094 //l=0.11 //layer=ply \
 //thickness=0.18 //x=11.29 //y=1.545 //x2=11.18 //y2=1.545
r544 (  135 153 ) resistor r=56.4043 //w=0.094 //l=0.11 //layer=ply \
 //thickness=0.18 //x=4.075 //y=1.595 //x2=4.185 //y2=1.595
r545 (  135 154 ) resistor r=56.4043 //w=0.094 //l=0.11 //layer=ply \
 //thickness=0.18 //x=4.075 //y=1.595 //x2=3.965 //y2=1.595
r546 (  131 191 ) resistor r=152 //w=0.17 //l=0.17 //layer=licon //count=1 \
 //x=11.22 //y=4.88 //x2=11.22 //y2=4.88
r547 (  122 186 ) resistor r=152 //w=0.17 //l=0.17 //layer=licon //count=1 \
 //x=11.22 //y=2.26 //x2=11.22 //y2=2.26
r548 (  105 198 ) resistor r=23.615 //w=0.187 //l=0.345 //layer=li \
 //thickness=0.1 //x=8.59 //y=5.56 //x2=8.59 //y2=5.905
r549 (  97 197 ) resistor r=23.615 //w=0.187 //l=0.345 //layer=li \
 //thickness=0.1 //x=7.71 //y=5.56 //x2=7.71 //y2=5.905
r550 (  89 196 ) resistor r=23.615 //w=0.187 //l=0.345 //layer=li \
 //thickness=0.1 //x=6.83 //y=5.56 //x2=6.83 //y2=5.905
r551 (  84 182 ) resistor r=152 //w=0.17 //l=0.17 //layer=licon //count=1 \
 //x=3.82 //y=4.88 //x2=3.82 //y2=4.88
r552 (  75 176 ) resistor r=152 //w=0.17 //l=0.17 //layer=licon //count=1 \
 //x=3.82 //y=2.26 //x2=3.82 //y2=2.26
r553 (  65 70 ) resistor r=0.108234 //w=0.187 //l=0.16 //layer=m2 \
 //thickness=0.36 //x=9.535 //y=3.51 //x2=9.375 //y2=3.51
r554 (  64 72 ) resistor r=0.10734 //w=0.281 //l=0.16 //layer=m2 \
 //thickness=0.36 //x=11.06 //y=3.51 //x2=11.22 //y2=3.51
r555 (  64 65 ) resistor r=1.45515 //w=0.131 //l=1.525 //layer=m2 \
 //thickness=0.36 //x=11.06 //y=3.51 //x2=9.535 //y2=3.51
r556 (  62 70 ) resistor r=1.83617 //w=0.187 //l=2.75249 //layer=m2 \
 //thickness=0.36 //x=6.63 //y=3.495 //x2=9.375 //y2=3.51
r557 (  62 63 ) resistor r=0.410305 //w=0.131 //l=0.43 //layer=m2 \
 //thickness=0.36 //x=6.63 //y=3.495 //x2=6.2 //y2=3.495
r558 (  60 63 ) resistor r=0.125 //w=0.17 //l=0.177341 //layer=m2 \
 //thickness=0.36 //x=6.03 //y=3.51 //x2=6.2 //y2=3.495
r559 (  60 61 ) resistor r=0.949427 //w=0.131 //l=0.995 //layer=m2 \
 //thickness=0.36 //x=6.03 //y=3.51 //x2=5.035 //y2=3.51
r560 (  58 61 ) resistor r=0.1875 //w=0.17 //l=0.259952 //layer=m2 \
 //thickness=0.36 //x=4.78 //y=3.5 //x2=5.035 //y2=3.51
r561 (  58 59 ) resistor r=0.410305 //w=0.131 //l=0.43 //layer=m2 \
 //thickness=0.36 //x=4.78 //y=3.5 //x2=4.35 //y2=3.5
r562 (  57 67 ) resistor r=0.10734 //w=0.281 //l=0.16 //layer=m2 \
 //thickness=0.36 //x=3.98 //y=3.51 //x2=3.82 //y2=3.51
r563 (  56 59 ) resistor r=0.125 //w=0.17 //l=0.174929 //layer=m2 \
 //thickness=0.36 //x=4.18 //y=3.51 //x2=4.35 //y2=3.5
r564 (  56 57 ) resistor r=0.19084 //w=0.131 //l=0.2 //layer=m2 \
 //thickness=0.36 //x=4.18 //y=3.51 //x2=3.98 //y2=3.51
r565 (  53 131 ) resistor r=9.3 //w=0.17 //l=0.17 //layer=mcon //count=1 \
 //x=11.22 //y=4.88 //x2=11.22 //y2=4.88
r566 (  53 54 ) resistor r=0.103207 //w=0.196 //l=0.14 //layer=m1 \
 //thickness=0.36 //x=11.222 //y=4.88 //x2=11.222 //y2=4.74
r567 (  50 122 ) resistor r=9.3 //w=0.17 //l=0.17 //layer=mcon //count=1 \
 //x=11.22 //y=2.26 //x2=11.22 //y2=2.26
r568 (  47 72 ) resistor r=4.5 //w=0.15 //l=0.15 //layer=via1 //count=1 \
 //x=11.22 //y=3.51 //x2=11.22 //y2=3.51
r569 (  44 70 ) resistor r=4.5 //w=0.15 //l=0.15 //layer=via1 //count=1 \
 //x=9.375 //y=3.51 //x2=9.375 //y2=3.51
r570 (  42 194 ) resistor r=9.3 //w=0.17 //l=0.17 //layer=mcon //count=1 \
 //x=8.885 //y=1.19 //x2=8.885 //y2=1.19
r571 (  40 105 ) resistor r=9.3 //w=0.17 //l=0.17 //layer=mcon //count=1 \
 //x=8.59 //y=5.56 //x2=8.59 //y2=5.56
r572 (  37 97 ) resistor r=9.3 //w=0.17 //l=0.17 //layer=mcon //count=1 \
 //x=7.71 //y=5.56 //x2=7.71 //y2=5.56
r573 (  35 37 ) resistor r=0.121228 //w=0.232 //l=0.225 //layer=m1 \
 //thickness=0.36 //x=7.71 //y=5.335 //x2=7.71 //y2=5.56
r574 (  34 89 ) resistor r=9.3 //w=0.17 //l=0.17 //layer=mcon //count=1 \
 //x=6.83 //y=5.56 //x2=6.83 //y2=5.56
r575 (  32 34 ) resistor r=0.129608 //w=0.217 //l=0.225 //layer=m1 \
 //thickness=0.36 //x=6.832 //y=5.335 //x2=6.832 //y2=5.56
r576 (  30 67 ) resistor r=4.5 //w=0.15 //l=0.15 //layer=via1 //count=1 \
 //x=3.82 //y=3.51 //x2=3.82 //y2=3.51
r577 (  28 84 ) resistor r=9.3 //w=0.17 //l=0.17 //layer=mcon //count=1 \
 //x=3.82 //y=4.88 //x2=3.82 //y2=4.88
r578 (  26 75 ) resistor r=9.3 //w=0.17 //l=0.17 //layer=mcon //count=1 \
 //x=3.82 //y=2.26 //x2=3.82 //y2=2.26
r579 (  23 47 ) resistor r=0.0911593 //w=0.376 //l=0.184608 //layer=m1 \
 //thickness=0.36 //x=11.22 //y=3.67 //x2=11.167 //y2=3.51
r580 (  23 54 ) resistor r=1.02099 //w=0.131 //l=1.07 //layer=m1 \
 //thickness=0.36 //x=11.22 //y=3.67 //x2=11.22 //y2=4.74
r581 (  22 47 ) resistor r=0.0911593 //w=0.376 //l=0.184608 //layer=m1 \
 //thickness=0.36 //x=11.22 //y=3.35 //x2=11.167 //y2=3.51
r582 (  21 50 ) resistor r=0.0933015 //w=0.201 //l=0.125 //layer=m1 \
 //thickness=0.36 //x=11.22 //y=2.385 //x2=11.22 //y2=2.26
r583 (  21 22 ) resistor r=0.920802 //w=0.131 //l=0.965 //layer=m1 \
 //thickness=0.36 //x=11.22 //y=2.385 //x2=11.22 //y2=3.35
r584 (  19 44 ) resistor r=0.0910802 //w=0.374 //l=0.185472 //layer=m1 \
 //thickness=0.36 //x=9.37 //y=3.67 //x2=9.425 //y2=3.51
r585 (  19 20 ) resistor r=1.50763 //w=0.131 //l=1.58 //layer=m1 \
 //thickness=0.36 //x=9.37 //y=3.67 //x2=9.37 //y2=5.25
r586 (  18 44 ) resistor r=0.0910802 //w=0.374 //l=0.185472 //layer=m1 \
 //thickness=0.36 //x=9.37 //y=3.35 //x2=9.425 //y2=3.51
r587 (  17 18 ) resistor r=1.35496 //w=0.131 //l=1.42 //layer=m1 \
 //thickness=0.36 //x=9.37 //y=1.93 //x2=9.37 //y2=3.35
r588 (  15 17 ) resistor r=0.0698411 //w=0.17 //l=0.120208 //layer=m1 \
 //thickness=0.36 //x=9.285 //y=1.845 //x2=9.37 //y2=1.93
r589 (  15 16 ) resistor r=0.300573 //w=0.131 //l=0.315 //layer=m1 \
 //thickness=0.36 //x=9.285 //y=1.845 //x2=8.97 //y2=1.845
r590 (  14 16 ) resistor r=0.0698411 //w=0.17 //l=0.120208 //layer=m1 \
 //thickness=0.36 //x=8.885 //y=1.76 //x2=8.97 //y2=1.845
r591 (  13 42 ) resistor r=0.0717383 //w=0.224 //l=0.115 //layer=m1 \
 //thickness=0.36 //x=8.885 //y=1.305 //x2=8.885 //y2=1.19
r592 (  13 14 ) resistor r=0.43416 //w=0.131 //l=0.455 //layer=m1 \
 //thickness=0.36 //x=8.885 //y=1.305 //x2=8.885 //y2=1.76
r593 (  12 38 ) resistor r=0.0675342 //w=0.23 //l=0.115 //layer=m1 \
 //thickness=0.36 //x=8.705 //y=5.335 //x2=8.59 //y2=5.335
r594 (  11 20 ) resistor r=0.0698411 //w=0.17 //l=0.120208 //layer=m1 \
 //thickness=0.36 //x=9.285 //y=5.335 //x2=9.37 //y2=5.25
r595 (  11 12 ) resistor r=0.553435 //w=0.131 //l=0.58 //layer=m1 \
 //thickness=0.36 //x=9.285 //y=5.335 //x2=8.705 //y2=5.335
r596 (  10 40 ) resistor r=0.00118313 //w=0.23 //layer=m1 //thickness=0.36 \
 //x=8.59 //y=5.56 //x2=8.59 //y2=5.56
r597 (  9 38 ) resistor r=0.002872 //w=0.34 //l=0.085 //layer=m1 \
 //thickness=0.36 //x=8.59 //y=5.42 //x2=8.59 //y2=5.335
r598 (  9 10 ) resistor r=0.091623 //w=0.191 //l=0.14 //layer=m1 \
 //thickness=0.36 //x=8.59 //y=5.42 //x2=8.59 //y2=5.56
r599 (  8 35 ) resistor r=0.0262263 //w=0.232 //l=0.12 //layer=m1 \
 //thickness=0.36 //x=7.83 //y=5.335 //x2=7.71 //y2=5.335
r600 (  7 38 ) resistor r=0.0675342 //w=0.23 //l=0.115 //layer=m1 \
 //thickness=0.36 //x=8.475 //y=5.335 //x2=8.59 //y2=5.335
r601 (  7 8 ) resistor r=0.615458 //w=0.131 //l=0.645 //layer=m1 \
 //thickness=0.36 //x=8.475 //y=5.335 //x2=7.83 //y2=5.335
r602 (  6 32 ) resistor r=0.0222262 //w=0.217 //l=0.118 //layer=m1 \
 //thickness=0.36 //x=6.95 //y=5.335 //x2=6.832 //y2=5.335
r603 (  5 35 ) resistor r=0.0262263 //w=0.232 //l=0.12 //layer=m1 \
 //thickness=0.36 //x=7.59 //y=5.335 //x2=7.71 //y2=5.335
r604 (  5 6 ) resistor r=0.610687 //w=0.131 //l=0.64 //layer=m1 \
 //thickness=0.36 //x=7.59 //y=5.335 //x2=6.95 //y2=5.335
r605 (  4 28 ) resistor r=0.0801089 //w=0.224 //l=0.13 //layer=m1 \
 //thickness=0.36 //x=3.82 //y=4.75 //x2=3.82 //y2=4.88
r606 (  3 30 ) resistor r=0.0911593 //w=0.376 //l=0.184174 //layer=m1 \
 //thickness=0.36 //x=3.82 //y=3.67 //x2=3.872 //y2=3.51
r607 (  3 4 ) resistor r=1.03053 //w=0.131 //l=1.08 //layer=m1 \
 //thickness=0.36 //x=3.82 //y=3.67 //x2=3.82 //y2=4.75
r608 (  2 30 ) resistor r=0.0911593 //w=0.376 //l=0.184174 //layer=m1 \
 //thickness=0.36 //x=3.82 //y=3.35 //x2=3.872 //y2=3.51
r609 (  1 26 ) resistor r=0.0719237 //w=0.222 //l=0.115 //layer=m1 \
 //thickness=0.36 //x=3.82 //y=2.375 //x2=3.82 //y2=2.26
r610 (  1 2 ) resistor r=0.930344 //w=0.131 //l=0.975 //layer=m1 \
 //thickness=0.36 //x=3.82 //y=2.375 //x2=3.82 //y2=3.35
ends PM_TMRDFFRNQNX1\%noxref_1

subckt PM_TMRDFFRNQNX1\%noxref_2 ( 3 8 9 11 12 14 15 16 17 18 19 20 23 24 27 \
 29 32 36 48 50 51 54 62 79 88 92 93 94 95 96 97 98 99 101 107 108 109 110 122 \
 124 125 )
c277 ( 122 0 ) capacitor c=0.00878249f //x=12.07 //y=1.085
c278 ( 110 0 ) capacitor c=0.0612936f //x=14.825 //y=4.97
c279 ( 109 0 ) capacitor c=0.0376642f //x=15.115 //y=4.97
c280 ( 108 0 ) capacitor c=0.0346489f //x=14.78 //y=1.4
c281 ( 107 0 ) capacitor c=0.018692f //x=14.78 //y=1.055
c282 ( 101 0 ) capacitor c=0.0137077f //x=14.625 //y=1.555
c283 ( 99 0 ) capacitor c=0.0158585f //x=14.625 //y=0.9
c284 ( 98 0 ) capacitor c=0.101012f //x=14.25 //y=2.095
c285 ( 97 0 ) capacitor c=0.0229444f //x=14.25 //y=1.71
c286 ( 96 0 ) capacitor c=0.0234359f //x=14.25 //y=1.4
c287 ( 95 0 ) capacitor c=0.019815f //x=14.25 //y=1.055
c288 ( 94 0 ) capacitor c=0.110208f //x=15.19 //y=6.2
c289 ( 93 0 ) capacitor c=0.158957f //x=14.75 //y=6.2
c290 ( 88 0 ) capacitor c=0.0014751f //x=14.55 //y=4.88
c291 ( 79 0 ) capacitor c=0.0012618f //x=14.55 //y=2.26
c292 ( 62 0 ) capacitor c=0.0322017f //x=12.22 //y=5.56
c293 ( 54 0 ) capacitor c=0.0291938f //x=11.34 //y=5.56
c294 ( 51 0 ) capacitor c=0.0230934f //x=14.395 //y=3.515
c295 ( 50 0 ) capacitor c=5.6075e-19 //x=14.555 //y=3.515
c296 ( 48 0 ) capacitor c=8.37988e-19 //x=12.86 //y=3.515
c297 ( 36 0 ) capacitor c=0.0170693f //x=14.55 //y=3.51
c298 ( 32 0 ) capacitor c=0.016938f //x=12.7 //y=3.51
c299 ( 29 0 ) capacitor c=0.0112415f //x=12.26 //y=1.18
c300 ( 27 0 ) capacitor c=5.78613e-19 //x=12.22 //y=5.56
c301 ( 24 0 ) capacitor c=0.010659f //x=12.22 //y=5.38
c302 ( 23 0 ) capacitor c=0.00926978f //x=11.34 //y=5.56
c303 ( 20 0 ) capacitor c=0.0382053f //x=14.55 //y=4.755
c304 ( 19 0 ) capacitor c=0.0145929f //x=14.55 //y=3.675
c305 ( 18 0 ) capacitor c=0.0314186f //x=14.55 //y=3.355
c306 ( 17 0 ) capacitor c=0.00495287f //x=14.55 //y=2.375
c307 ( 16 0 ) capacitor c=0.0418029f //x=12.7 //y=5.295
c308 ( 15 0 ) capacitor c=0.0134337f //x=12.7 //y=3.675
c309 ( 14 0 ) capacitor c=0.0411601f //x=12.7 //y=3.355
c310 ( 12 0 ) capacitor c=0.00466468f //x=12.345 //y=1.835
c311 ( 11 0 ) capacitor c=0.0120653f //x=12.615 //y=1.835
c312 ( 9 0 ) capacitor c=0.0116495f //x=12.615 //y=5.38
c313 ( 8 0 ) capacitor c=0.0134844f //x=12.26 //y=1.75
c314 ( 3 0 ) capacitor c=0.013452f //x=12.105 //y=5.38
r315 (  109 111 ) resistor r=26.9307 //w=0.15 //l=0.106066 //layer=ply \
 //thickness=0.18 //x=15.115 //y=4.97 //x2=15.19 //y2=5.045
r316 (  109 110 ) resistor r=148.702 //w=0.094 //l=0.29 //layer=ply \
 //thickness=0.18 //x=15.115 //y=4.97 //x2=14.825 //y2=4.97
r317 (  108 121 ) resistor r=45.1352 //w=0.168 //l=0.173853 //layer=ply \
 //thickness=0.18 //x=14.78 //y=1.4 //x2=14.74 //y2=1.555
r318 (  107 120 ) resistor r=45.1352 //w=0.168 //l=0.173853 //layer=ply \
 //thickness=0.18 //x=14.78 //y=1.055 //x2=14.74 //y2=0.9
r319 (  107 108 ) resistor r=176.904 //w=0.094 //l=0.345 //layer=ply \
 //thickness=0.18 //x=14.78 //y=1.055 //x2=14.78 //y2=1.4
r320 (  104 110 ) resistor r=22.7971 //w=0.269 //l=0.106066 //layer=ply \
 //thickness=0.18 //x=14.75 //y=5.045 //x2=14.825 //y2=4.97
r321 (  104 119 ) resistor r=35.8364 //w=0.269 //l=0.270185 //layer=ply \
 //thickness=0.18 //x=14.75 //y=5.045 //x2=14.55 //y2=4.88
r322 (  102 115 ) resistor r=10.701 //w=0.21 //l=0.115 //layer=ply \
 //thickness=0.18 //x=14.405 //y=1.555 //x2=14.29 //y2=1.555
r323 (  101 121 ) resistor r=5.52526 //w=0.168 //l=0.115 //layer=ply \
 //thickness=0.18 //x=14.625 //y=1.555 //x2=14.74 //y2=1.555
r324 (  100 114 ) resistor r=5.52526 //w=0.168 //l=0.115 //layer=ply \
 //thickness=0.18 //x=14.405 //y=0.9 //x2=14.29 //y2=0.9
r325 (  99 120 ) resistor r=5.52526 //w=0.168 //l=0.115 //layer=ply \
 //thickness=0.18 //x=14.625 //y=0.9 //x2=14.74 //y2=0.9
r326 (  99 100 ) resistor r=112.809 //w=0.094 //l=0.22 //layer=ply \
 //thickness=0.18 //x=14.625 //y=0.9 //x2=14.405 //y2=0.9
r327 (  98 117 ) resistor r=58.7805 //w=0.246 //l=0.373497 //layer=ply \
 //thickness=0.18 //x=14.25 //y=2.095 //x2=14.55 //y2=2.26
r328 (  97 115 ) resistor r=39.5823 //w=0.21 //l=0.173853 //layer=ply \
 //thickness=0.18 //x=14.25 //y=1.71 //x2=14.29 //y2=1.555
r329 (  97 98 ) resistor r=197.415 //w=0.094 //l=0.385 //layer=ply \
 //thickness=0.18 //x=14.25 //y=1.71 //x2=14.25 //y2=2.095
r330 (  96 115 ) resistor r=39.5823 //w=0.21 //l=0.173853 //layer=ply \
 //thickness=0.18 //x=14.25 //y=1.4 //x2=14.29 //y2=1.555
r331 (  95 114 ) resistor r=45.1352 //w=0.168 //l=0.173853 //layer=ply \
 //thickness=0.18 //x=14.25 //y=1.055 //x2=14.29 //y2=0.9
r332 (  95 96 ) resistor r=176.904 //w=0.094 //l=0.345 //layer=ply \
 //thickness=0.18 //x=14.25 //y=1.055 //x2=14.25 //y2=1.4
r333 (  94 111 ) resistor r=592.245 //w=0.094 //l=1.155 //layer=ply \
 //thickness=0.18 //x=15.19 //y=6.2 //x2=15.19 //y2=5.045
r334 (  93 104 ) resistor r=592.245 //w=0.094 //l=1.155 //layer=ply \
 //thickness=0.18 //x=14.75 //y=6.2 //x2=14.75 //y2=5.045
r335 (  92 101 ) resistor r=56.4043 //w=0.094 //l=0.11 //layer=ply \
 //thickness=0.18 //x=14.515 //y=1.555 //x2=14.625 //y2=1.555
r336 (  92 102 ) resistor r=56.4043 //w=0.094 //l=0.11 //layer=ply \
 //thickness=0.18 //x=14.515 //y=1.555 //x2=14.405 //y2=1.555
r337 (  88 119 ) resistor r=152 //w=0.17 //l=0.17 //layer=licon //count=1 \
 //x=14.55 //y=4.88 //x2=14.55 //y2=4.88
r338 (  79 117 ) resistor r=152 //w=0.17 //l=0.17 //layer=licon //count=1 \
 //x=14.55 //y=2.26 //x2=14.55 //y2=2.26
r339 (  62 125 ) resistor r=23.615 //w=0.187 //l=0.345 //layer=li \
 //thickness=0.1 //x=12.22 //y=5.56 //x2=12.22 //y2=5.905
r340 (  54 124 ) resistor r=23.615 //w=0.187 //l=0.345 //layer=li \
 //thickness=0.1 //x=11.34 //y=5.56 //x2=11.34 //y2=5.905
r341 (  50 51 ) resistor r=0.10734 //w=0.281 //l=0.16 //layer=m2 \
 //thickness=0.36 //x=14.555 //y=3.515 //x2=14.395 //y2=3.515
r342 (  48 51 ) resistor r=1.46469 //w=0.131 //l=1.535 //layer=m2 \
 //thickness=0.36 //x=12.86 //y=3.51 //x2=14.395 //y2=3.51
r343 (  46 48 ) resistor r=0.10734 //w=0.281 //l=0.16 //layer=m2 \
 //thickness=0.36 //x=12.7 //y=3.515 //x2=12.86 //y2=3.515
r344 (  42 88 ) resistor r=9.3 //w=0.17 //l=0.17 //layer=mcon //count=1 \
 //x=14.55 //y=4.88 //x2=14.55 //y2=4.88
r345 (  40 79 ) resistor r=9.3 //w=0.17 //l=0.17 //layer=mcon //count=1 \
 //x=14.55 //y=2.26 //x2=14.55 //y2=2.26
r346 (  38 50 ) resistor r=4.5 //w=0.15 //l=0.15 //layer=via1 //count=1 \
 //x=14.555 //y=3.515 //x2=14.555 //y2=3.515
r347 (  36 38 ) resistor r=0.00164908 //w=0.379 //l=0.005 //layer=m1 \
 //thickness=0.36 //x=14.5 //y=3.51 //x2=14.5 //y2=3.515
r348 (  34 46 ) resistor r=4.5 //w=0.15 //l=0.15 //layer=via1 //count=1 \
 //x=12.7 //y=3.515 //x2=12.7 //y2=3.515
r349 (  32 34 ) resistor r=0.00166223 //w=0.376 //l=0.005 //layer=m1 \
 //thickness=0.36 //x=12.752 //y=3.51 //x2=12.752 //y2=3.515
r350 (  29 122 ) resistor r=9.3 //w=0.17 //l=0.17 //layer=mcon //count=1 \
 //x=12.26 //y=1.18 //x2=12.26 //y2=1.18
r351 (  27 62 ) resistor r=9.3 //w=0.17 //l=0.17 //layer=mcon //count=1 \
 //x=12.22 //y=5.56 //x2=12.22 //y2=5.56
r352 (  24 27 ) resistor r=0.117801 //w=0.191 //l=0.18 //layer=m1 \
 //thickness=0.36 //x=12.22 //y=5.38 //x2=12.22 //y2=5.56
r353 (  23 54 ) resistor r=9.3 //w=0.17 //l=0.17 //layer=mcon //count=1 \
 //x=11.34 //y=5.56 //x2=11.34 //y2=5.56
r354 (  21 23 ) resistor r=0.10274 //w=0.219 //l=0.18 //layer=m1 \
 //thickness=0.36 //x=11.34 //y=5.38 //x2=11.34 //y2=5.56
r355 (  20 42 ) resistor r=0.0760407 //w=0.238 //l=0.125 //layer=m1 \
 //thickness=0.36 //x=14.55 //y=4.755 //x2=14.55 //y2=4.88
r356 (  19 38 ) resistor r=0.0912814 //w=0.379 //l=0.183303 //layer=m1 \
 //thickness=0.36 //x=14.55 //y=3.675 //x2=14.5 //y2=3.515
r357 (  19 20 ) resistor r=1.03053 //w=0.131 //l=1.08 //layer=m1 \
 //thickness=0.36 //x=14.55 //y=3.675 //x2=14.55 //y2=4.755
r358 (  18 36 ) resistor r=0.0896323 //w=0.379 //l=0.178255 //layer=m1 \
 //thickness=0.36 //x=14.55 //y=3.355 //x2=14.5 //y2=3.51
r359 (  17 40 ) resistor r=0.0719237 //w=0.222 //l=0.115 //layer=m1 \
 //thickness=0.36 //x=14.55 //y=2.375 //x2=14.55 //y2=2.26
r360 (  17 18 ) resistor r=0.935115 //w=0.131 //l=0.98 //layer=m1 \
 //thickness=0.36 //x=14.55 //y=2.375 //x2=14.55 //y2=3.355
r361 (  15 34 ) resistor r=0.0911593 //w=0.376 //l=0.184174 //layer=m1 \
 //thickness=0.36 //x=12.7 //y=3.675 //x2=12.752 //y2=3.515
r362 (  15 16 ) resistor r=1.5458 //w=0.131 //l=1.62 //layer=m1 \
 //thickness=0.36 //x=12.7 //y=3.675 //x2=12.7 //y2=5.295
r363 (  14 32 ) resistor r=0.0894971 //w=0.376 //l=0.179123 //layer=m1 \
 //thickness=0.36 //x=12.7 //y=3.355 //x2=12.752 //y2=3.51
r364 (  13 14 ) resistor r=1.36927 //w=0.131 //l=1.435 //layer=m1 \
 //thickness=0.36 //x=12.7 //y=1.92 //x2=12.7 //y2=3.355
r365 (  11 13 ) resistor r=0.0698411 //w=0.17 //l=0.120208 //layer=m1 \
 //thickness=0.36 //x=12.615 //y=1.835 //x2=12.7 //y2=1.92
r366 (  11 12 ) resistor r=0.257634 //w=0.131 //l=0.27 //layer=m1 \
 //thickness=0.36 //x=12.615 //y=1.835 //x2=12.345 //y2=1.835
r367 (  10 24 ) resistor r=0.0257089 //w=0.23 //l=0.115 //layer=m1 \
 //thickness=0.36 //x=12.335 //y=5.38 //x2=12.22 //y2=5.38
r368 (  9 16 ) resistor r=0.0698411 //w=0.17 //l=0.120208 //layer=m1 \
 //thickness=0.36 //x=12.615 //y=5.38 //x2=12.7 //y2=5.295
r369 (  9 10 ) resistor r=0.267176 //w=0.131 //l=0.28 //layer=m1 \
 //thickness=0.36 //x=12.615 //y=5.38 //x2=12.335 //y2=5.38
r370 (  8 12 ) resistor r=0.0698411 //w=0.17 //l=0.120208 //layer=m1 \
 //thickness=0.36 //x=12.26 //y=1.75 //x2=12.345 //y2=1.835
r371 (  7 29 ) resistor r=0.0913624 //w=0.191 //l=0.12 //layer=m1 \
 //thickness=0.36 //x=12.26 //y=1.3 //x2=12.26 //y2=1.18
r372 (  7 8 ) resistor r=0.429389 //w=0.131 //l=0.45 //layer=m1 \
 //thickness=0.36 //x=12.26 //y=1.3 //x2=12.26 //y2=1.75
r373 (  4 21 ) resistor r=0.0227762 //w=0.219 //l=0.115 //layer=m1 \
 //thickness=0.36 //x=11.455 //y=5.38 //x2=11.34 //y2=5.38
r374 (  3 24 ) resistor r=0.0257089 //w=0.23 //l=0.115 //layer=m1 \
 //thickness=0.36 //x=12.105 //y=5.38 //x2=12.22 //y2=5.38
r375 (  3 4 ) resistor r=0.620229 //w=0.131 //l=0.65 //layer=m1 \
 //thickness=0.36 //x=12.105 //y=5.38 //x2=11.455 //y2=5.38
ends PM_TMRDFFRNQNX1\%noxref_2

subckt PM_TMRDFFRNQNX1\%noxref_3 ( 1 3 6 7 9 10 11 12 14 15 16 17 18 19 20 21 \
 22 23 24 25 28 31 37 45 48 54 56 57 58 60 62 64 66 68 70 72 77 83 91 99 116 \
 125 130 139 143 144 145 146 147 148 149 150 151 152 153 155 161 162 163 164 \
 168 169 170 171 172 174 180 181 182 183 203 205 206 207 )
c479 ( 203 0 ) capacitor c=0.00885916f //x=3.885 //y=1.095
c480 ( 183 0 ) capacitor c=0.0583399f //x=19.635 //y=4.97
c481 ( 182 0 ) capacitor c=0.0376642f //x=19.925 //y=4.97
c482 ( 181 0 ) capacitor c=0.0346489f //x=19.59 //y=1.4
c483 ( 180 0 ) capacitor c=0.018692f //x=19.59 //y=1.055
c484 ( 174 0 ) capacitor c=0.0137077f //x=19.435 //y=1.555
c485 ( 172 0 ) capacitor c=0.0158585f //x=19.435 //y=0.9
c486 ( 171 0 ) capacitor c=0.103534f //x=19.06 //y=2.095
c487 ( 170 0 ) capacitor c=0.0229444f //x=19.06 //y=1.71
c488 ( 169 0 ) capacitor c=0.0234359f //x=19.06 //y=1.4
c489 ( 168 0 ) capacitor c=0.019815f //x=19.06 //y=1.055
c490 ( 164 0 ) capacitor c=0.0564069f //x=6.685 //y=4.97
c491 ( 163 0 ) capacitor c=0.0376642f //x=6.975 //y=4.97
c492 ( 162 0 ) capacitor c=0.0346489f //x=6.64 //y=1.4
c493 ( 161 0 ) capacitor c=0.018692f //x=6.64 //y=1.055
c494 ( 155 0 ) capacitor c=0.0137077f //x=6.485 //y=1.555
c495 ( 153 0 ) capacitor c=0.0158585f //x=6.485 //y=0.9
c496 ( 152 0 ) capacitor c=0.103534f //x=6.11 //y=2.095
c497 ( 151 0 ) capacitor c=0.0229444f //x=6.11 //y=1.71
c498 ( 150 0 ) capacitor c=0.0234359f //x=6.11 //y=1.4
c499 ( 149 0 ) capacitor c=0.019815f //x=6.11 //y=1.055
c500 ( 148 0 ) capacitor c=0.110208f //x=20 //y=6.2
c501 ( 147 0 ) capacitor c=0.158957f //x=19.56 //y=6.2
c502 ( 146 0 ) capacitor c=0.110208f //x=7.05 //y=6.2
c503 ( 145 0 ) capacitor c=0.158957f //x=6.61 //y=6.2
c504 ( 139 0 ) capacitor c=0.0014751f //x=19.36 //y=4.88
c505 ( 130 0 ) capacitor c=0.0012618f //x=19.36 //y=2.26
c506 ( 125 0 ) capacitor c=0.0014751f //x=6.41 //y=4.88
c507 ( 116 0 ) capacitor c=0.0012618f //x=6.41 //y=2.26
c508 ( 99 0 ) capacitor c=0.0293561f //x=3.78 //y=5.56
c509 ( 91 0 ) capacitor c=0.029137f //x=2.9 //y=5.56
c510 ( 83 0 ) capacitor c=0.0278099f //x=2.02 //y=5.56
c511 ( 77 0 ) capacitor c=7.36606e-19 //x=4.725 //y=3.885
c512 ( 72 0 ) capacitor c=0.0323769f //x=17.73 //y=3.87
c513 ( 70 0 ) capacitor c=0.0302787f //x=17.13 //y=3.88
c514 ( 68 0 ) capacitor c=0.00490196f //x=14.77 //y=3.9
c515 ( 66 0 ) capacitor c=0.018225f //x=14.17 //y=3.88
c516 ( 64 0 ) capacitor c=0.00418082f //x=12.915 //y=3.9
c517 ( 62 0 ) capacitor c=0.00894521f //x=12.18 //y=3.865
c518 ( 60 0 ) capacitor c=0.00622316f //x=11.435 //y=3.895
c519 ( 58 0 ) capacitor c=0.0174986f //x=10.835 //y=3.88
c520 ( 57 0 ) capacitor c=0.0244069f //x=9.245 //y=3.895
c521 ( 56 0 ) capacitor c=0.00423161f //x=9.59 //y=3.895
c522 ( 54 0 ) capacitor c=0.0209003f //x=6.255 //y=3.88
c523 ( 48 0 ) capacitor c=0.0152841f //x=19.35 //y=3.88
c524 ( 45 0 ) capacitor c=0.0167936f //x=6.41 //y=3.88
c525 ( 37 0 ) capacitor c=0.0172565f //x=4.56 //y=3.88
c526 ( 31 0 ) capacitor c=9.55882e-19 //x=3.78 //y=5.335
c527 ( 28 0 ) capacitor c=0.00740623f //x=2.9 //y=5.335
c528 ( 25 0 ) capacitor c=0.0123281f //x=2.022 //y=5.335
c529 ( 24 0 ) capacitor c=0.024997f //x=19.36 //y=4.755
c530 ( 23 0 ) capacitor c=0.0136306f //x=19.36 //y=4.04
c531 ( 22 0 ) capacitor c=0.0448512f //x=19.36 //y=3.72
c532 ( 21 0 ) capacitor c=0.00489532f //x=19.36 //y=2.375
c533 ( 20 0 ) capacitor c=0.0266349f //x=6.41 //y=4.755
c534 ( 19 0 ) capacitor c=0.0127337f //x=6.41 //y=4.04
c535 ( 18 0 ) capacitor c=0.0420226f //x=6.41 //y=3.72
c536 ( 17 0 ) capacitor c=0.00670383f //x=6.41 //y=2.375
c537 ( 16 0 ) capacitor c=0.0325919f //x=4.56 //y=5.25
c538 ( 15 0 ) capacitor c=0.0131885f //x=4.56 //y=4.045
c539 ( 14 0 ) capacitor c=0.0524199f //x=4.56 //y=3.725
c540 ( 12 0 ) capacitor c=0.00686157f //x=4.16 //y=1.845
c541 ( 11 0 ) capacitor c=0.0163455f //x=4.475 //y=1.845
c542 ( 10 0 ) capacitor c=0.0167992f //x=4.075 //y=1.76
c543 ( 9 0 ) capacitor c=0.0113813f //x=4.075 //y=1.305
c544 ( 7 0 ) capacitor c=0.0229543f //x=4.475 //y=5.335
c545 ( 6 0 ) capacitor c=0.00933983f //x=3.78 //y=5.56
c546 ( 3 0 ) capacitor c=0.019444f //x=3.665 //y=5.335
c547 ( 1 0 ) capacitor c=0.0149475f //x=2.78 //y=5.335
r548 (  182 184 ) resistor r=26.9307 //w=0.15 //l=0.106066 //layer=ply \
 //thickness=0.18 //x=19.925 //y=4.97 //x2=20 //y2=5.045
r549 (  182 183 ) resistor r=148.702 //w=0.094 //l=0.29 //layer=ply \
 //thickness=0.18 //x=19.925 //y=4.97 //x2=19.635 //y2=4.97
r550 (  181 202 ) resistor r=45.1352 //w=0.168 //l=0.173853 //layer=ply \
 //thickness=0.18 //x=19.59 //y=1.4 //x2=19.55 //y2=1.555
r551 (  180 201 ) resistor r=45.1352 //w=0.168 //l=0.173853 //layer=ply \
 //thickness=0.18 //x=19.59 //y=1.055 //x2=19.55 //y2=0.9
r552 (  180 181 ) resistor r=176.904 //w=0.094 //l=0.345 //layer=ply \
 //thickness=0.18 //x=19.59 //y=1.055 //x2=19.59 //y2=1.4
r553 (  177 183 ) resistor r=22.7971 //w=0.269 //l=0.106066 //layer=ply \
 //thickness=0.18 //x=19.56 //y=5.045 //x2=19.635 //y2=4.97
r554 (  177 200 ) resistor r=35.8364 //w=0.269 //l=0.270185 //layer=ply \
 //thickness=0.18 //x=19.56 //y=5.045 //x2=19.36 //y2=4.88
r555 (  175 196 ) resistor r=10.701 //w=0.21 //l=0.115 //layer=ply \
 //thickness=0.18 //x=19.215 //y=1.555 //x2=19.1 //y2=1.555
r556 (  174 202 ) resistor r=5.52526 //w=0.168 //l=0.115 //layer=ply \
 //thickness=0.18 //x=19.435 //y=1.555 //x2=19.55 //y2=1.555
r557 (  173 195 ) resistor r=5.52526 //w=0.168 //l=0.115 //layer=ply \
 //thickness=0.18 //x=19.215 //y=0.9 //x2=19.1 //y2=0.9
r558 (  172 201 ) resistor r=5.52526 //w=0.168 //l=0.115 //layer=ply \
 //thickness=0.18 //x=19.435 //y=0.9 //x2=19.55 //y2=0.9
r559 (  172 173 ) resistor r=112.809 //w=0.094 //l=0.22 //layer=ply \
 //thickness=0.18 //x=19.435 //y=0.9 //x2=19.215 //y2=0.9
r560 (  171 198 ) resistor r=58.7805 //w=0.246 //l=0.373497 //layer=ply \
 //thickness=0.18 //x=19.06 //y=2.095 //x2=19.36 //y2=2.26
r561 (  170 196 ) resistor r=39.5823 //w=0.21 //l=0.173853 //layer=ply \
 //thickness=0.18 //x=19.06 //y=1.71 //x2=19.1 //y2=1.555
r562 (  170 171 ) resistor r=197.415 //w=0.094 //l=0.385 //layer=ply \
 //thickness=0.18 //x=19.06 //y=1.71 //x2=19.06 //y2=2.095
r563 (  169 196 ) resistor r=39.5823 //w=0.21 //l=0.173853 //layer=ply \
 //thickness=0.18 //x=19.06 //y=1.4 //x2=19.1 //y2=1.555
r564 (  168 195 ) resistor r=45.1352 //w=0.168 //l=0.173853 //layer=ply \
 //thickness=0.18 //x=19.06 //y=1.055 //x2=19.1 //y2=0.9
r565 (  168 169 ) resistor r=176.904 //w=0.094 //l=0.345 //layer=ply \
 //thickness=0.18 //x=19.06 //y=1.055 //x2=19.06 //y2=1.4
r566 (  163 165 ) resistor r=26.9307 //w=0.15 //l=0.106066 //layer=ply \
 //thickness=0.18 //x=6.975 //y=4.97 //x2=7.05 //y2=5.045
r567 (  163 164 ) resistor r=148.702 //w=0.094 //l=0.29 //layer=ply \
 //thickness=0.18 //x=6.975 //y=4.97 //x2=6.685 //y2=4.97
r568 (  162 194 ) resistor r=45.1352 //w=0.168 //l=0.173853 //layer=ply \
 //thickness=0.18 //x=6.64 //y=1.4 //x2=6.6 //y2=1.555
r569 (  161 193 ) resistor r=45.1352 //w=0.168 //l=0.173853 //layer=ply \
 //thickness=0.18 //x=6.64 //y=1.055 //x2=6.6 //y2=0.9
r570 (  161 162 ) resistor r=176.904 //w=0.094 //l=0.345 //layer=ply \
 //thickness=0.18 //x=6.64 //y=1.055 //x2=6.64 //y2=1.4
r571 (  158 164 ) resistor r=22.7971 //w=0.269 //l=0.106066 //layer=ply \
 //thickness=0.18 //x=6.61 //y=5.045 //x2=6.685 //y2=4.97
r572 (  158 192 ) resistor r=35.8364 //w=0.269 //l=0.270185 //layer=ply \
 //thickness=0.18 //x=6.61 //y=5.045 //x2=6.41 //y2=4.88
r573 (  156 188 ) resistor r=10.701 //w=0.21 //l=0.115 //layer=ply \
 //thickness=0.18 //x=6.265 //y=1.555 //x2=6.15 //y2=1.555
r574 (  155 194 ) resistor r=5.52526 //w=0.168 //l=0.115 //layer=ply \
 //thickness=0.18 //x=6.485 //y=1.555 //x2=6.6 //y2=1.555
r575 (  154 187 ) resistor r=5.52526 //w=0.168 //l=0.115 //layer=ply \
 //thickness=0.18 //x=6.265 //y=0.9 //x2=6.15 //y2=0.9
r576 (  153 193 ) resistor r=5.52526 //w=0.168 //l=0.115 //layer=ply \
 //thickness=0.18 //x=6.485 //y=0.9 //x2=6.6 //y2=0.9
r577 (  153 154 ) resistor r=112.809 //w=0.094 //l=0.22 //layer=ply \
 //thickness=0.18 //x=6.485 //y=0.9 //x2=6.265 //y2=0.9
r578 (  152 190 ) resistor r=58.7805 //w=0.246 //l=0.373497 //layer=ply \
 //thickness=0.18 //x=6.11 //y=2.095 //x2=6.41 //y2=2.26
r579 (  151 188 ) resistor r=39.5823 //w=0.21 //l=0.173853 //layer=ply \
 //thickness=0.18 //x=6.11 //y=1.71 //x2=6.15 //y2=1.555
r580 (  151 152 ) resistor r=197.415 //w=0.094 //l=0.385 //layer=ply \
 //thickness=0.18 //x=6.11 //y=1.71 //x2=6.11 //y2=2.095
r581 (  150 188 ) resistor r=39.5823 //w=0.21 //l=0.173853 //layer=ply \
 //thickness=0.18 //x=6.11 //y=1.4 //x2=6.15 //y2=1.555
r582 (  149 187 ) resistor r=45.1352 //w=0.168 //l=0.173853 //layer=ply \
 //thickness=0.18 //x=6.11 //y=1.055 //x2=6.15 //y2=0.9
r583 (  149 150 ) resistor r=176.904 //w=0.094 //l=0.345 //layer=ply \
 //thickness=0.18 //x=6.11 //y=1.055 //x2=6.11 //y2=1.4
r584 (  148 184 ) resistor r=592.245 //w=0.094 //l=1.155 //layer=ply \
 //thickness=0.18 //x=20 //y=6.2 //x2=20 //y2=5.045
r585 (  147 177 ) resistor r=592.245 //w=0.094 //l=1.155 //layer=ply \
 //thickness=0.18 //x=19.56 //y=6.2 //x2=19.56 //y2=5.045
r586 (  146 165 ) resistor r=592.245 //w=0.094 //l=1.155 //layer=ply \
 //thickness=0.18 //x=7.05 //y=6.2 //x2=7.05 //y2=5.045
r587 (  145 158 ) resistor r=592.245 //w=0.094 //l=1.155 //layer=ply \
 //thickness=0.18 //x=6.61 //y=6.2 //x2=6.61 //y2=5.045
r588 (  144 174 ) resistor r=56.4043 //w=0.094 //l=0.11 //layer=ply \
 //thickness=0.18 //x=19.325 //y=1.555 //x2=19.435 //y2=1.555
r589 (  144 175 ) resistor r=56.4043 //w=0.094 //l=0.11 //layer=ply \
 //thickness=0.18 //x=19.325 //y=1.555 //x2=19.215 //y2=1.555
r590 (  143 155 ) resistor r=56.4043 //w=0.094 //l=0.11 //layer=ply \
 //thickness=0.18 //x=6.375 //y=1.555 //x2=6.485 //y2=1.555
r591 (  143 156 ) resistor r=56.4043 //w=0.094 //l=0.11 //layer=ply \
 //thickness=0.18 //x=6.375 //y=1.555 //x2=6.265 //y2=1.555
r592 (  139 200 ) resistor r=152 //w=0.17 //l=0.17 //layer=licon //count=1 \
 //x=19.36 //y=4.88 //x2=19.36 //y2=4.88
r593 (  130 198 ) resistor r=152 //w=0.17 //l=0.17 //layer=licon //count=1 \
 //x=19.36 //y=2.26 //x2=19.36 //y2=2.26
r594 (  125 192 ) resistor r=152 //w=0.17 //l=0.17 //layer=licon //count=1 \
 //x=6.41 //y=4.88 //x2=6.41 //y2=4.88
r595 (  116 190 ) resistor r=152 //w=0.17 //l=0.17 //layer=licon //count=1 \
 //x=6.41 //y=2.26 //x2=6.41 //y2=2.26
r596 (  99 207 ) resistor r=23.615 //w=0.187 //l=0.345 //layer=li \
 //thickness=0.1 //x=3.78 //y=5.56 //x2=3.78 //y2=5.905
r597 (  91 206 ) resistor r=23.615 //w=0.187 //l=0.345 //layer=li \
 //thickness=0.1 //x=2.9 //y=5.56 //x2=2.9 //y2=5.905
r598 (  83 205 ) resistor r=23.615 //w=0.187 //l=0.345 //layer=li \
 //thickness=0.1 //x=2.02 //y=5.56 //x2=2.02 //y2=5.905
r599 (  75 77 ) resistor r=0.10734 //w=0.281 //l=0.16 //layer=m2 \
 //thickness=0.36 //x=4.565 //y=3.885 //x2=4.725 //y2=3.885
r600 (  72 81 ) resistor r=1.03061 //w=0.197 //l=1.62499 //layer=m2 \
 //thickness=0.36 //x=17.73 //y=3.87 //x2=19.35 //y2=3.88
r601 (  72 73 ) resistor r=0.410305 //w=0.131 //l=0.43 //layer=m2 \
 //thickness=0.36 //x=17.73 //y=3.87 //x2=17.3 //y2=3.87
r602 (  70 73 ) resistor r=0.125 //w=0.17 //l=0.174929 //layer=m2 \
 //thickness=0.36 //x=17.13 //y=3.88 //x2=17.3 //y2=3.87
r603 (  70 71 ) resistor r=2.08969 //w=0.131 //l=2.19 //layer=m2 \
 //thickness=0.36 //x=17.13 //y=3.88 //x2=14.94 //y2=3.88
r604 (  68 71 ) resistor r=0.125 //w=0.17 //l=0.179722 //layer=m2 \
 //thickness=0.36 //x=14.77 //y=3.9 //x2=14.94 //y2=3.88
r605 (  68 69 ) resistor r=0.329198 //w=0.131 //l=0.345 //layer=m2 \
 //thickness=0.36 //x=14.77 //y=3.9 //x2=14.425 //y2=3.9
r606 (  66 69 ) resistor r=0.1875 //w=0.17 //l=0.264811 //layer=m2 \
 //thickness=0.36 //x=14.17 //y=3.88 //x2=14.425 //y2=3.9
r607 (  66 67 ) resistor r=1.03531 //w=0.131 //l=1.085 //layer=m2 \
 //thickness=0.36 //x=14.17 //y=3.88 //x2=13.085 //y2=3.88
r608 (  64 67 ) resistor r=0.125 //w=0.17 //l=0.179722 //layer=m2 \
 //thickness=0.36 //x=12.915 //y=3.9 //x2=13.085 //y2=3.88
r609 (  64 65 ) resistor r=0.329198 //w=0.131 //l=0.345 //layer=m2 \
 //thickness=0.36 //x=12.915 //y=3.9 //x2=12.57 //y2=3.9
r610 (  62 65 ) resistor r=0.286765 //w=0.17 //l=0.407124 //layer=m2 \
 //thickness=0.36 //x=12.18 //y=3.865 //x2=12.57 //y2=3.9
r611 (  62 63 ) resistor r=0.410305 //w=0.131 //l=0.43 //layer=m2 \
 //thickness=0.36 //x=12.18 //y=3.865 //x2=11.75 //y2=3.865
r612 (  60 63 ) resistor r=0.231618 //w=0.17 //l=0.329659 //layer=m2 \
 //thickness=0.36 //x=11.435 //y=3.895 //x2=11.75 //y2=3.865
r613 (  60 61 ) resistor r=0.329198 //w=0.131 //l=0.345 //layer=m2 \
 //thickness=0.36 //x=11.435 //y=3.895 //x2=11.09 //y2=3.895
r614 (  58 61 ) resistor r=0.1875 //w=0.17 //l=0.262393 //layer=m2 \
 //thickness=0.36 //x=10.835 //y=3.88 //x2=11.09 //y2=3.895
r615 (  58 59 ) resistor r=1.02576 //w=0.131 //l=1.075 //layer=m2 \
 //thickness=0.36 //x=10.835 //y=3.88 //x2=9.76 //y2=3.88
r616 (  57 79 ) resistor r=1.89299 //w=0.187 //l=2.83749 //layer=m2 \
 //thickness=0.36 //x=9.245 //y=3.895 //x2=6.415 //y2=3.88
r617 (  56 59 ) resistor r=0.125 //w=0.17 //l=0.177341 //layer=m2 \
 //thickness=0.36 //x=9.59 //y=3.895 //x2=9.76 //y2=3.88
r618 (  56 57 ) resistor r=0.329198 //w=0.131 //l=0.345 //layer=m2 \
 //thickness=0.36 //x=9.59 //y=3.895 //x2=9.245 //y2=3.895
r619 (  54 79 ) resistor r=0.108234 //w=0.187 //l=0.16 //layer=m2 \
 //thickness=0.36 //x=6.255 //y=3.88 //x2=6.415 //y2=3.88
r620 (  54 77 ) resistor r=1.45992 //w=0.131 //l=1.53 //layer=m2 \
 //thickness=0.36 //x=6.255 //y=3.88 //x2=4.725 //y2=3.88
r621 (  53 139 ) resistor r=9.3 //w=0.17 //l=0.17 //layer=mcon //count=1 \
 //x=19.36 //y=4.88 //x2=19.36 //y2=4.88
r622 (  51 130 ) resistor r=9.3 //w=0.17 //l=0.17 //layer=mcon //count=1 \
 //x=19.36 //y=2.26 //x2=19.36 //y2=2.26
r623 (  48 81 ) resistor r=4.5 //w=0.15 //l=0.15 //layer=via1 //count=1 \
 //x=19.35 //y=3.88 //x2=19.35 //y2=3.88
r624 (  45 79 ) resistor r=4.5 //w=0.15 //l=0.15 //layer=via1 //count=1 \
 //x=6.415 //y=3.88 //x2=6.415 //y2=3.88
r625 (  43 125 ) resistor r=9.3 //w=0.17 //l=0.17 //layer=mcon //count=1 \
 //x=6.41 //y=4.88 //x2=6.41 //y2=4.88
r626 (  41 116 ) resistor r=9.3 //w=0.17 //l=0.17 //layer=mcon //count=1 \
 //x=6.41 //y=2.26 //x2=6.41 //y2=2.26
r627 (  39 75 ) resistor r=4.5 //w=0.15 //l=0.15 //layer=via1 //count=1 \
 //x=4.565 //y=3.885 //x2=4.565 //y2=3.885
r628 (  37 39 ) resistor r=0.00167112 //w=0.374 //l=0.005 //layer=m1 \
 //thickness=0.36 //x=4.615 //y=3.88 //x2=4.615 //y2=3.885
r629 (  35 203 ) resistor r=9.3 //w=0.17 //l=0.17 //layer=mcon //count=1 \
 //x=4.075 //y=1.19 //x2=4.075 //y2=1.19
r630 (  33 99 ) resistor r=9.3 //w=0.17 //l=0.17 //layer=mcon //count=1 \
 //x=3.78 //y=5.56 //x2=3.78 //y2=5.56
r631 (  30 91 ) resistor r=9.3 //w=0.17 //l=0.17 //layer=mcon //count=1 \
 //x=2.9 //y=5.56 //x2=2.9 //y2=5.56
r632 (  28 30 ) resistor r=0.121228 //w=0.232 //l=0.225 //layer=m1 \
 //thickness=0.36 //x=2.9 //y=5.335 //x2=2.9 //y2=5.56
r633 (  27 83 ) resistor r=9.3 //w=0.17 //l=0.17 //layer=mcon //count=1 \
 //x=2.02 //y=5.56 //x2=2.02 //y2=5.56
r634 (  25 27 ) resistor r=0.129608 //w=0.217 //l=0.225 //layer=m1 \
 //thickness=0.36 //x=2.022 //y=5.335 //x2=2.022 //y2=5.56
r635 (  24 53 ) resistor r=0.0760407 //w=0.238 //l=0.125 //layer=m1 \
 //thickness=0.36 //x=19.36 //y=4.755 //x2=19.36 //y2=4.88
r636 (  23 48 ) resistor r=0.0909648 //w=0.371 //l=0.186762 //layer=m1 \
 //thickness=0.36 //x=19.36 //y=4.04 //x2=19.302 //y2=3.88
r637 (  23 24 ) resistor r=0.682252 //w=0.131 //l=0.715 //layer=m1 \
 //thickness=0.36 //x=19.36 //y=4.04 //x2=19.36 //y2=4.755
r638 (  22 48 ) resistor r=0.0909648 //w=0.371 //l=0.186762 //layer=m1 \
 //thickness=0.36 //x=19.36 //y=3.72 //x2=19.302 //y2=3.88
r639 (  21 51 ) resistor r=0.0719237 //w=0.222 //l=0.115 //layer=m1 \
 //thickness=0.36 //x=19.36 //y=2.375 //x2=19.36 //y2=2.26
r640 (  21 22 ) resistor r=1.2834 //w=0.131 //l=1.345 //layer=m1 \
 //thickness=0.36 //x=19.36 //y=2.375 //x2=19.36 //y2=3.72
r641 (  20 43 ) resistor r=0.0760407 //w=0.238 //l=0.125 //layer=m1 \
 //thickness=0.36 //x=6.41 //y=4.755 //x2=6.41 //y2=4.88
r642 (  19 45 ) resistor r=0.0910802 //w=0.374 //l=0.185472 //layer=m1 \
 //thickness=0.36 //x=6.41 //y=4.04 //x2=6.465 //y2=3.88
r643 (  19 20 ) resistor r=0.682252 //w=0.131 //l=0.715 //layer=m1 \
 //thickness=0.36 //x=6.41 //y=4.04 //x2=6.41 //y2=4.755
r644 (  18 45 ) resistor r=0.0910802 //w=0.374 //l=0.185472 //layer=m1 \
 //thickness=0.36 //x=6.41 //y=3.72 //x2=6.465 //y2=3.88
r645 (  17 41 ) resistor r=0.0719237 //w=0.222 //l=0.115 //layer=m1 \
 //thickness=0.36 //x=6.41 //y=2.375 //x2=6.41 //y2=2.26
r646 (  17 18 ) resistor r=1.2834 //w=0.131 //l=1.345 //layer=m1 \
 //thickness=0.36 //x=6.41 //y=2.375 //x2=6.41 //y2=3.72
r647 (  15 39 ) resistor r=0.0910802 //w=0.374 //l=0.185472 //layer=m1 \
 //thickness=0.36 //x=4.56 //y=4.045 //x2=4.615 //y2=3.885
r648 (  15 16 ) resistor r=1.14981 //w=0.131 //l=1.205 //layer=m1 \
 //thickness=0.36 //x=4.56 //y=4.045 //x2=4.56 //y2=5.25
r649 (  14 37 ) resistor r=0.089409 //w=0.374 //l=0.180416 //layer=m1 \
 //thickness=0.36 //x=4.56 //y=3.725 //x2=4.615 //y2=3.88
r650 (  13 14 ) resistor r=1.71279 //w=0.131 //l=1.795 //layer=m1 \
 //thickness=0.36 //x=4.56 //y=1.93 //x2=4.56 //y2=3.725
r651 (  11 13 ) resistor r=0.0698411 //w=0.17 //l=0.120208 //layer=m1 \
 //thickness=0.36 //x=4.475 //y=1.845 //x2=4.56 //y2=1.93
r652 (  11 12 ) resistor r=0.300573 //w=0.131 //l=0.315 //layer=m1 \
 //thickness=0.36 //x=4.475 //y=1.845 //x2=4.16 //y2=1.845
r653 (  10 12 ) resistor r=0.0698411 //w=0.17 //l=0.120208 //layer=m1 \
 //thickness=0.36 //x=4.075 //y=1.76 //x2=4.16 //y2=1.845
r654 (  9 35 ) resistor r=0.0717383 //w=0.224 //l=0.115 //layer=m1 \
 //thickness=0.36 //x=4.075 //y=1.305 //x2=4.075 //y2=1.19
r655 (  9 10 ) resistor r=0.43416 //w=0.131 //l=0.455 //layer=m1 \
 //thickness=0.36 //x=4.075 //y=1.305 //x2=4.075 //y2=1.76
r656 (  8 31 ) resistor r=0.0675342 //w=0.23 //l=0.115 //layer=m1 \
 //thickness=0.36 //x=3.895 //y=5.335 //x2=3.78 //y2=5.335
r657 (  7 16 ) resistor r=0.0698411 //w=0.17 //l=0.120208 //layer=m1 \
 //thickness=0.36 //x=4.475 //y=5.335 //x2=4.56 //y2=5.25
r658 (  7 8 ) resistor r=0.553435 //w=0.131 //l=0.58 //layer=m1 \
 //thickness=0.36 //x=4.475 //y=5.335 //x2=3.895 //y2=5.335
r659 (  6 33 ) resistor r=0.00118313 //w=0.23 //layer=m1 //thickness=0.36 \
 //x=3.78 //y=5.56 //x2=3.78 //y2=5.56
r660 (  5 31 ) resistor r=0.002872 //w=0.34 //l=0.085 //layer=m1 \
 //thickness=0.36 //x=3.78 //y=5.42 //x2=3.78 //y2=5.335
r661 (  5 6 ) resistor r=0.091623 //w=0.191 //l=0.14 //layer=m1 \
 //thickness=0.36 //x=3.78 //y=5.42 //x2=3.78 //y2=5.56
r662 (  4 28 ) resistor r=0.0262263 //w=0.232 //l=0.12 //layer=m1 \
 //thickness=0.36 //x=3.02 //y=5.335 //x2=2.9 //y2=5.335
r663 (  3 31 ) resistor r=0.0675342 //w=0.23 //l=0.115 //layer=m1 \
 //thickness=0.36 //x=3.665 //y=5.335 //x2=3.78 //y2=5.335
r664 (  3 4 ) resistor r=0.615458 //w=0.131 //l=0.645 //layer=m1 \
 //thickness=0.36 //x=3.665 //y=5.335 //x2=3.02 //y2=5.335
r665 (  2 25 ) resistor r=0.0222262 //w=0.217 //l=0.118 //layer=m1 \
 //thickness=0.36 //x=2.14 //y=5.335 //x2=2.022 //y2=5.335
r666 (  1 28 ) resistor r=0.0262263 //w=0.232 //l=0.12 //layer=m1 \
 //thickness=0.36 //x=2.78 //y=5.335 //x2=2.9 //y2=5.335
r667 (  1 2 ) resistor r=0.610687 //w=0.131 //l=0.64 //layer=m1 \
 //thickness=0.36 //x=2.78 //y=5.335 //x2=2.14 //y2=5.335
ends PM_TMRDFFRNQNX1\%noxref_3

subckt PM_TMRDFFRNQNX1\%noxref_4 ( 1 2 3 4 6 7 8 9 11 14 15 17 18 19 20 22 23 \
 24 25 27 30 31 33 34 35 36 38 39 40 42 43 46 47 48 54 58 61 66 69 72 78 81 84 \
 87 95 99 101 104 105 108 112 117 119 121 123 125 126 127 128 130 136 145 146 \
 148 149 152 161 166 175 180 188 196 213 221 229 246 255 260 269 273 274 275 \
 276 277 278 279 280 281 282 283 284 285 286 287 288 289 291 297 298 299 300 \
 304 305 306 311 313 315 321 322 323 324 325 326 330 332 335 336 340 341 342 \
 347 349 351 357 358 368 369 372 386 390 391 394 402 403 406 407 408 409 410 \
 411 )
c824 ( 403 0 ) capacitor c=0.00885916f //x=21.645 //y=1.095
c825 ( 402 0 ) capacitor c=0.00885916f //x=16.835 //y=1.095
c826 ( 394 0 ) capacitor c=0.0366137f //x=24.94 //y=4.88
c827 ( 391 0 ) capacitor c=0.0297213f //x=24.91 //y=2.095
c828 ( 390 0 ) capacitor c=0.0488821f //x=24.91 //y=2.26
c829 ( 386 0 ) capacitor c=0.0641856f //x=24.17 //y=4.88
c830 ( 372 0 ) capacitor c=0.0354929f //x=11.99 //y=4.88
c831 ( 369 0 ) capacitor c=0.0284095f //x=11.96 //y=2.095
c832 ( 368 0 ) capacitor c=0.0476356f //x=11.96 //y=2.26
c833 ( 358 0 ) capacitor c=0.0441827f //x=25.475 //y=1.43
c834 ( 357 0 ) capacitor c=0.019833f //x=25.475 //y=1.085
c835 ( 351 0 ) capacitor c=0.0162526f //x=25.32 //y=1.585
c836 ( 349 0 ) capacitor c=0.0157807f //x=25.32 //y=0.93
c837 ( 347 0 ) capacitor c=0.0372668f //x=25.315 //y=4.97
c838 ( 342 0 ) capacitor c=0.0216374f //x=24.945 //y=1.74
c839 ( 341 0 ) capacitor c=0.0179909f //x=24.945 //y=1.43
c840 ( 340 0 ) capacitor c=0.0178631f //x=24.945 //y=1.085
c841 ( 336 0 ) capacitor c=0.0338883f //x=24.505 //y=1.39
c842 ( 335 0 ) capacitor c=0.0188688f //x=24.505 //y=1.045
c843 ( 332 0 ) capacitor c=0.0141821f //x=24.35 //y=1.545
c844 ( 330 0 ) capacitor c=0.0158553f //x=24.35 //y=0.89
c845 ( 326 0 ) capacitor c=0.0899055f //x=23.975 //y=2.095
c846 ( 325 0 ) capacitor c=0.0230625f //x=23.975 //y=1.7
c847 ( 324 0 ) capacitor c=0.0234359f //x=23.975 //y=1.39
c848 ( 323 0 ) capacitor c=0.0200755f //x=23.975 //y=1.045
c849 ( 322 0 ) capacitor c=0.0439708f //x=12.525 //y=1.43
c850 ( 321 0 ) capacitor c=0.0192582f //x=12.525 //y=1.085
c851 ( 315 0 ) capacitor c=0.0162526f //x=12.37 //y=1.585
c852 ( 313 0 ) capacitor c=0.0157807f //x=12.37 //y=0.93
c853 ( 311 0 ) capacitor c=0.0372668f //x=12.365 //y=4.97
c854 ( 306 0 ) capacitor c=0.0210762f //x=11.995 //y=1.74
c855 ( 305 0 ) capacitor c=0.0168511f //x=11.995 //y=1.43
c856 ( 304 0 ) capacitor c=0.0175485f //x=11.995 //y=1.085
c857 ( 300 0 ) capacitor c=0.0551642f //x=1.875 //y=4.97
c858 ( 299 0 ) capacitor c=0.0376642f //x=2.165 //y=4.97
c859 ( 298 0 ) capacitor c=0.0346489f //x=1.83 //y=1.4
c860 ( 297 0 ) capacitor c=0.018692f //x=1.83 //y=1.055
c861 ( 291 0 ) capacitor c=0.0137077f //x=1.675 //y=1.555
c862 ( 289 0 ) capacitor c=0.0158585f //x=1.675 //y=0.9
c863 ( 288 0 ) capacitor c=0.103534f //x=1.3 //y=2.095
c864 ( 287 0 ) capacitor c=0.0229444f //x=1.3 //y=1.71
c865 ( 286 0 ) capacitor c=0.0234359f //x=1.3 //y=1.4
c866 ( 285 0 ) capacitor c=0.019815f //x=1.3 //y=1.055
c867 ( 284 0 ) capacitor c=0.155269f //x=25.39 //y=6.2
c868 ( 283 0 ) capacitor c=0.116174f //x=24.95 //y=6.2
c869 ( 282 0 ) capacitor c=0.116167f //x=24.51 //y=6.2
c870 ( 281 0 ) capacitor c=0.154619f //x=24.07 //y=6.2
c871 ( 280 0 ) capacitor c=0.155269f //x=12.44 //y=6.2
c872 ( 279 0 ) capacitor c=0.110375f //x=12 //y=6.2
c873 ( 278 0 ) capacitor c=0.110208f //x=2.24 //y=6.2
c874 ( 277 0 ) capacitor c=0.158957f //x=1.8 //y=6.2
c875 ( 269 0 ) capacitor c=5.80994e-19 //x=24.94 //y=4.88
c876 ( 260 0 ) capacitor c=5.78095e-19 //x=24.91 //y=2.26
c877 ( 255 0 ) capacitor c=5.44848e-19 //x=24.17 //y=4.88
c878 ( 246 0 ) capacitor c=7.85889e-19 //x=24.17 //y=2.26
c879 ( 229 0 ) capacitor c=0.0292977f //x=21.54 //y=5.56
c880 ( 221 0 ) capacitor c=0.029137f //x=20.66 //y=5.56
c881 ( 213 0 ) capacitor c=0.0278099f //x=19.78 //y=5.56
c882 ( 196 0 ) capacitor c=0.0293124f //x=16.73 //y=5.56
c883 ( 188 0 ) capacitor c=0.029137f //x=15.85 //y=5.56
c884 ( 180 0 ) capacitor c=0.0277605f //x=14.97 //y=5.56
c885 ( 175 0 ) capacitor c=5.80994e-19 //x=11.99 //y=4.88
c886 ( 166 0 ) capacitor c=5.78095e-19 //x=11.96 //y=2.26
c887 ( 161 0 ) capacitor c=0.00120653f //x=1.6 //y=4.88
c888 ( 152 0 ) capacitor c=0.0012618f //x=1.6 //y=2.26
c889 ( 149 0 ) capacitor c=0.0046692f //x=24.74 //y=4.255
c890 ( 148 0 ) capacitor c=9.28285e-19 //x=24.9 //y=4.255
c891 ( 146 0 ) capacitor c=0.00100054f //x=24.34 //y=4.235
c892 ( 145 0 ) capacitor c=0.0247901f //x=24.02 //y=4.235
c893 ( 136 0 ) capacitor c=0.0109595f //x=1.76 //y=4.26
c894 ( 130 0 ) capacitor c=0.0374818f //x=22.475 //y=4.25
c895 ( 128 0 ) capacitor c=0.0202931f //x=19.22 //y=4.265
c896 ( 127 0 ) capacitor c=0.00207952f //x=19.565 //y=4.265
c897 ( 126 0 ) capacitor c=0.0479906f //x=12.125 //y=4.25
c898 ( 125 0 ) capacitor c=0.0489806f //x=17.355 //y=4.25
c899 ( 123 0 ) capacitor c=0.00158466f //x=6.63 //y=4.265
c900 ( 121 0 ) capacitor c=0.0162158f //x=6.03 //y=4.25
c901 ( 119 0 ) capacitor c=0.00487421f //x=4.815 //y=4.27
c902 ( 117 0 ) capacitor c=0.0681494f //x=4.175 //y=4.25
c903 ( 112 0 ) capacitor c=0.00504273f //x=24.91 //y=2.26
c904 ( 108 0 ) capacitor c=0.0134983f //x=24.91 //y=4.25
c905 ( 105 0 ) capacitor c=0.00653918f //x=24.172 //y=4.74
c906 ( 104 0 ) capacitor c=0.0058774f //x=24.17 //y=4.88
c907 ( 101 0 ) capacitor c=0.00462953f //x=24.17 //y=2.26
c908 ( 99 0 ) capacitor c=0.0134864f //x=24.17 //y=4.25
c909 ( 95 0 ) capacitor c=0.0161335f //x=22.32 //y=4.25
c910 ( 87 0 ) capacitor c=0.00101407f //x=21.54 //y=5.335
c911 ( 84 0 ) capacitor c=0.00809525f //x=20.66 //y=5.335
c912 ( 81 0 ) capacitor c=0.0109594f //x=19.782 //y=5.335
c913 ( 78 0 ) capacitor c=0.0151867f //x=17.51 //y=4.25
c914 ( 72 0 ) capacitor c=0.00112339f //x=16.73 //y=5.335
c915 ( 69 0 ) capacitor c=0.00744415f //x=15.85 //y=5.335
c916 ( 66 0 ) capacitor c=0.0112819f //x=14.972 //y=5.335
c917 ( 61 0 ) capacitor c=0.00504845f //x=11.96 //y=2.26
c918 ( 58 0 ) capacitor c=0.0141348f //x=11.96 //y=4.25
c919 ( 54 0 ) capacitor c=0.0160313f //x=1.6 //y=4.25
c920 ( 48 0 ) capacitor c=0.00890193f //x=24.91 //y=4.735
c921 ( 47 0 ) capacitor c=0.00921967f //x=24.91 //y=4.415
c922 ( 46 0 ) capacitor c=0.0371208f //x=24.91 //y=4.095
c923 ( 43 0 ) capacitor c=0.0116842f //x=24.17 //y=4.395
c924 ( 42 0 ) capacitor c=0.048579f //x=24.17 //y=4.075
c925 ( 40 0 ) capacitor c=0.0212366f //x=22.32 //y=5.25
c926 ( 39 0 ) capacitor c=0.0132754f //x=22.32 //y=4.395
c927 ( 38 0 ) capacitor c=0.0629528f //x=22.32 //y=4.075
c928 ( 36 0 ) capacitor c=0.0043645f //x=21.92 //y=1.845
c929 ( 35 0 ) capacitor c=0.0130102f //x=22.235 //y=1.845
c930 ( 34 0 ) capacitor c=0.0136149f //x=21.835 //y=1.76
c931 ( 33 0 ) capacitor c=0.0111655f //x=21.835 //y=1.305
c932 ( 31 0 ) capacitor c=0.0228099f //x=22.235 //y=5.335
c933 ( 30 0 ) capacitor c=0.00906713f //x=21.54 //y=5.56
c934 ( 27 0 ) capacitor c=0.0195495f //x=21.425 //y=5.335
c935 ( 25 0 ) capacitor c=0.0151049f //x=20.54 //y=5.335
c936 ( 24 0 ) capacitor c=0.0222888f //x=17.51 //y=5.25
c937 ( 23 0 ) capacitor c=0.012762f //x=17.51 //y=4.415
c938 ( 22 0 ) capacitor c=0.0657923f //x=17.51 //y=4.095
c939 ( 20 0 ) capacitor c=0.00493487f //x=17.11 //y=1.845
c940 ( 19 0 ) capacitor c=0.0132593f //x=17.425 //y=1.845
c941 ( 18 0 ) capacitor c=0.0167333f //x=17.025 //y=1.76
c942 ( 17 0 ) capacitor c=0.0111392f //x=17.025 //y=1.305
c943 ( 15 0 ) capacitor c=0.0230009f //x=17.425 //y=5.335
c944 ( 14 0 ) capacitor c=0.00933983f //x=16.73 //y=5.56
c945 ( 11 0 ) capacitor c=0.019596f //x=16.615 //y=5.335
c946 ( 9 0 ) capacitor c=0.0147103f //x=15.73 //y=5.335
c947 ( 8 0 ) capacitor c=0.00917813f //x=11.96 //y=4.735
c948 ( 7 0 ) capacitor c=0.00994911f //x=11.96 //y=4.41
c949 ( 6 0 ) capacitor c=0.0355443f //x=11.96 //y=4.09
c950 ( 4 0 ) capacitor c=0.0226005f //x=1.6 //y=4.755
c951 ( 3 0 ) capacitor c=0.0130233f //x=1.6 //y=4.42
c952 ( 2 0 ) capacitor c=0.0864232f //x=1.6 //y=4.1
c953 ( 1 0 ) capacitor c=0.011342f //x=1.6 //y=2.375
r954 (  396 397 ) resistor r=32.4568 //w=0.214 //l=0.075 //layer=ply \
 //thickness=0.18 //x=24.94 //y=4.97 //x2=24.94 //y2=5.045
r955 (  394 396 ) resistor r=20.271 //w=0.214 //l=0.09 //layer=ply \
 //thickness=0.18 //x=24.94 //y=4.88 //x2=24.94 //y2=4.97
r956 (  390 391 ) resistor r=52.7279 //w=0.214 //l=0.165 //layer=ply \
 //thickness=0.18 //x=24.91 //y=2.26 //x2=24.91 //y2=2.095
r957 (  384 386 ) resistor r=20.6867 //w=0.233 //l=0.1 //layer=ply \
 //thickness=0.18 //x=24.07 //y=4.88 //x2=24.17 //y2=4.88
r958 (  374 375 ) resistor r=32.4568 //w=0.214 //l=0.075 //layer=ply \
 //thickness=0.18 //x=11.99 //y=4.97 //x2=11.99 //y2=5.045
r959 (  372 374 ) resistor r=20.271 //w=0.214 //l=0.09 //layer=ply \
 //thickness=0.18 //x=11.99 //y=4.88 //x2=11.99 //y2=4.97
r960 (  368 369 ) resistor r=52.7279 //w=0.214 //l=0.165 //layer=ply \
 //thickness=0.18 //x=11.96 //y=2.26 //x2=11.96 //y2=2.095
r961 (  358 401 ) resistor r=45.1352 //w=0.168 //l=0.173853 //layer=ply \
 //thickness=0.18 //x=25.475 //y=1.43 //x2=25.435 //y2=1.585
r962 (  357 400 ) resistor r=45.1352 //w=0.168 //l=0.173853 //layer=ply \
 //thickness=0.18 //x=25.475 //y=1.085 //x2=25.435 //y2=0.93
r963 (  357 358 ) resistor r=176.904 //w=0.094 //l=0.345 //layer=ply \
 //thickness=0.18 //x=25.475 //y=1.085 //x2=25.475 //y2=1.43
r964 (  352 399 ) resistor r=10.701 //w=0.21 //l=0.115 //layer=ply \
 //thickness=0.18 //x=25.1 //y=1.585 //x2=24.985 //y2=1.585
r965 (  351 401 ) resistor r=5.52526 //w=0.168 //l=0.115 //layer=ply \
 //thickness=0.18 //x=25.32 //y=1.585 //x2=25.435 //y2=1.585
r966 (  350 398 ) resistor r=5.52526 //w=0.168 //l=0.115 //layer=ply \
 //thickness=0.18 //x=25.1 //y=0.93 //x2=24.985 //y2=0.93
r967 (  349 400 ) resistor r=5.52526 //w=0.168 //l=0.115 //layer=ply \
 //thickness=0.18 //x=25.32 //y=0.93 //x2=25.435 //y2=0.93
r968 (  349 350 ) resistor r=112.809 //w=0.094 //l=0.22 //layer=ply \
 //thickness=0.18 //x=25.32 //y=0.93 //x2=25.1 //y2=0.93
r969 (  348 396 ) resistor r=16.5046 //w=0.27 //l=0.135 //layer=ply \
 //thickness=0.18 //x=25.075 //y=4.97 //x2=24.94 //y2=4.97
r970 (  347 354 ) resistor r=26.9307 //w=0.15 //l=0.106066 //layer=ply \
 //thickness=0.18 //x=25.315 //y=4.97 //x2=25.39 //y2=5.045
r971 (  347 348 ) resistor r=123.064 //w=0.094 //l=0.24 //layer=ply \
 //thickness=0.18 //x=25.315 //y=4.97 //x2=25.075 //y2=4.97
r972 (  342 399 ) resistor r=39.5823 //w=0.21 //l=0.173853 //layer=ply \
 //thickness=0.18 //x=24.945 //y=1.74 //x2=24.985 //y2=1.585
r973 (  342 391 ) resistor r=182.032 //w=0.094 //l=0.355 //layer=ply \
 //thickness=0.18 //x=24.945 //y=1.74 //x2=24.945 //y2=2.095
r974 (  341 399 ) resistor r=39.5823 //w=0.21 //l=0.173853 //layer=ply \
 //thickness=0.18 //x=24.945 //y=1.43 //x2=24.985 //y2=1.585
r975 (  340 398 ) resistor r=45.1352 //w=0.168 //l=0.173853 //layer=ply \
 //thickness=0.18 //x=24.945 //y=1.085 //x2=24.985 //y2=0.93
r976 (  340 341 ) resistor r=176.904 //w=0.094 //l=0.345 //layer=ply \
 //thickness=0.18 //x=24.945 //y=1.085 //x2=24.945 //y2=1.43
r977 (  337 386 ) resistor r=70.3348 //w=0.233 //l=0.414367 //layer=ply \
 //thickness=0.18 //x=24.51 //y=5.045 //x2=24.17 //y2=4.88
r978 (  336 388 ) resistor r=45.1352 //w=0.168 //l=0.173853 //layer=ply \
 //thickness=0.18 //x=24.505 //y=1.39 //x2=24.465 //y2=1.545
r979 (  335 387 ) resistor r=45.1352 //w=0.168 //l=0.173853 //layer=ply \
 //thickness=0.18 //x=24.505 //y=1.045 //x2=24.465 //y2=0.89
r980 (  335 336 ) resistor r=176.904 //w=0.094 //l=0.345 //layer=ply \
 //thickness=0.18 //x=24.505 //y=1.045 //x2=24.505 //y2=1.39
r981 (  333 383 ) resistor r=10.701 //w=0.21 //l=0.115 //layer=ply \
 //thickness=0.18 //x=24.13 //y=1.545 //x2=24.015 //y2=1.545
r982 (  332 388 ) resistor r=5.52526 //w=0.168 //l=0.115 //layer=ply \
 //thickness=0.18 //x=24.35 //y=1.545 //x2=24.465 //y2=1.545
r983 (  331 382 ) resistor r=5.52526 //w=0.168 //l=0.115 //layer=ply \
 //thickness=0.18 //x=24.13 //y=0.89 //x2=24.015 //y2=0.89
r984 (  330 387 ) resistor r=5.52526 //w=0.168 //l=0.115 //layer=ply \
 //thickness=0.18 //x=24.35 //y=0.89 //x2=24.465 //y2=0.89
r985 (  330 331 ) resistor r=112.809 //w=0.094 //l=0.22 //layer=ply \
 //thickness=0.18 //x=24.35 //y=0.89 //x2=24.13 //y2=0.89
r986 (  327 384 ) resistor r=13.0941 //w=0.233 //l=0.165 //layer=ply \
 //thickness=0.18 //x=24.07 //y=5.045 //x2=24.07 //y2=4.88
r987 (  326 381 ) resistor r=34.8111 //w=0.27 //l=0.264953 //layer=ply \
 //thickness=0.18 //x=23.975 //y=2.095 //x2=24.17 //y2=2.26
r988 (  325 383 ) resistor r=39.5823 //w=0.21 //l=0.173853 //layer=ply \
 //thickness=0.18 //x=23.975 //y=1.7 //x2=24.015 //y2=1.545
r989 (  325 326 ) resistor r=202.543 //w=0.094 //l=0.395 //layer=ply \
 //thickness=0.18 //x=23.975 //y=1.7 //x2=23.975 //y2=2.095
r990 (  324 383 ) resistor r=39.5823 //w=0.21 //l=0.173853 //layer=ply \
 //thickness=0.18 //x=23.975 //y=1.39 //x2=24.015 //y2=1.545
r991 (  323 382 ) resistor r=45.1352 //w=0.168 //l=0.173853 //layer=ply \
 //thickness=0.18 //x=23.975 //y=1.045 //x2=24.015 //y2=0.89
r992 (  323 324 ) resistor r=176.904 //w=0.094 //l=0.345 //layer=ply \
 //thickness=0.18 //x=23.975 //y=1.045 //x2=23.975 //y2=1.39
r993 (  322 379 ) resistor r=45.1352 //w=0.168 //l=0.173853 //layer=ply \
 //thickness=0.18 //x=12.525 //y=1.43 //x2=12.485 //y2=1.585
r994 (  321 378 ) resistor r=45.1352 //w=0.168 //l=0.173853 //layer=ply \
 //thickness=0.18 //x=12.525 //y=1.085 //x2=12.485 //y2=0.93
r995 (  321 322 ) resistor r=176.904 //w=0.094 //l=0.345 //layer=ply \
 //thickness=0.18 //x=12.525 //y=1.085 //x2=12.525 //y2=1.43
r996 (  316 377 ) resistor r=10.701 //w=0.21 //l=0.115 //layer=ply \
 //thickness=0.18 //x=12.15 //y=1.585 //x2=12.035 //y2=1.585
r997 (  315 379 ) resistor r=5.52526 //w=0.168 //l=0.115 //layer=ply \
 //thickness=0.18 //x=12.37 //y=1.585 //x2=12.485 //y2=1.585
r998 (  314 376 ) resistor r=5.52526 //w=0.168 //l=0.115 //layer=ply \
 //thickness=0.18 //x=12.15 //y=0.93 //x2=12.035 //y2=0.93
r999 (  313 378 ) resistor r=5.52526 //w=0.168 //l=0.115 //layer=ply \
 //thickness=0.18 //x=12.37 //y=0.93 //x2=12.485 //y2=0.93
r1000 (  313 314 ) resistor r=112.809 //w=0.094 //l=0.22 //layer=ply \
 //thickness=0.18 //x=12.37 //y=0.93 //x2=12.15 //y2=0.93
r1001 (  312 374 ) resistor r=16.5046 //w=0.27 //l=0.135 //layer=ply \
 //thickness=0.18 //x=12.125 //y=4.97 //x2=11.99 //y2=4.97
r1002 (  311 318 ) resistor r=26.9307 //w=0.15 //l=0.106066 //layer=ply \
 //thickness=0.18 //x=12.365 //y=4.97 //x2=12.44 //y2=5.045
r1003 (  311 312 ) resistor r=123.064 //w=0.094 //l=0.24 //layer=ply \
 //thickness=0.18 //x=12.365 //y=4.97 //x2=12.125 //y2=4.97
r1004 (  306 377 ) resistor r=39.5823 //w=0.21 //l=0.173853 //layer=ply \
 //thickness=0.18 //x=11.995 //y=1.74 //x2=12.035 //y2=1.585
r1005 (  306 369 ) resistor r=182.032 //w=0.094 //l=0.355 //layer=ply \
 //thickness=0.18 //x=11.995 //y=1.74 //x2=11.995 //y2=2.095
r1006 (  305 377 ) resistor r=39.5823 //w=0.21 //l=0.173853 //layer=ply \
 //thickness=0.18 //x=11.995 //y=1.43 //x2=12.035 //y2=1.585
r1007 (  304 376 ) resistor r=45.1352 //w=0.168 //l=0.173853 //layer=ply \
 //thickness=0.18 //x=11.995 //y=1.085 //x2=12.035 //y2=0.93
r1008 (  304 305 ) resistor r=176.904 //w=0.094 //l=0.345 //layer=ply \
 //thickness=0.18 //x=11.995 //y=1.085 //x2=11.995 //y2=1.43
r1009 (  299 301 ) resistor r=26.9307 //w=0.15 //l=0.106066 //layer=ply \
 //thickness=0.18 //x=2.165 //y=4.97 //x2=2.24 //y2=5.045
r1010 (  299 300 ) resistor r=148.702 //w=0.094 //l=0.29 //layer=ply \
 //thickness=0.18 //x=2.165 //y=4.97 //x2=1.875 //y2=4.97
r1011 (  298 366 ) resistor r=45.1352 //w=0.168 //l=0.173853 //layer=ply \
 //thickness=0.18 //x=1.83 //y=1.4 //x2=1.79 //y2=1.555
r1012 (  297 365 ) resistor r=45.1352 //w=0.168 //l=0.173853 //layer=ply \
 //thickness=0.18 //x=1.83 //y=1.055 //x2=1.79 //y2=0.9
r1013 (  297 298 ) resistor r=176.904 //w=0.094 //l=0.345 //layer=ply \
 //thickness=0.18 //x=1.83 //y=1.055 //x2=1.83 //y2=1.4
r1014 (  294 300 ) resistor r=22.7971 //w=0.269 //l=0.106066 //layer=ply \
 //thickness=0.18 //x=1.8 //y=5.045 //x2=1.875 //y2=4.97
r1015 (  294 364 ) resistor r=35.8364 //w=0.269 //l=0.270185 //layer=ply \
 //thickness=0.18 //x=1.8 //y=5.045 //x2=1.6 //y2=4.88
r1016 (  292 360 ) resistor r=10.701 //w=0.21 //l=0.115 //layer=ply \
 //thickness=0.18 //x=1.455 //y=1.555 //x2=1.34 //y2=1.555
r1017 (  291 366 ) resistor r=5.52526 //w=0.168 //l=0.115 //layer=ply \
 //thickness=0.18 //x=1.675 //y=1.555 //x2=1.79 //y2=1.555
r1018 (  290 359 ) resistor r=5.52526 //w=0.168 //l=0.115 //layer=ply \
 //thickness=0.18 //x=1.455 //y=0.9 //x2=1.34 //y2=0.9
r1019 (  289 365 ) resistor r=5.52526 //w=0.168 //l=0.115 //layer=ply \
 //thickness=0.18 //x=1.675 //y=0.9 //x2=1.79 //y2=0.9
r1020 (  289 290 ) resistor r=112.809 //w=0.094 //l=0.22 //layer=ply \
 //thickness=0.18 //x=1.675 //y=0.9 //x2=1.455 //y2=0.9
r1021 (  288 362 ) resistor r=58.7805 //w=0.246 //l=0.373497 //layer=ply \
 //thickness=0.18 //x=1.3 //y=2.095 //x2=1.6 //y2=2.26
r1022 (  287 360 ) resistor r=39.5823 //w=0.21 //l=0.173853 //layer=ply \
 //thickness=0.18 //x=1.3 //y=1.71 //x2=1.34 //y2=1.555
r1023 (  287 288 ) resistor r=197.415 //w=0.094 //l=0.385 //layer=ply \
 //thickness=0.18 //x=1.3 //y=1.71 //x2=1.3 //y2=2.095
r1024 (  286 360 ) resistor r=39.5823 //w=0.21 //l=0.173853 //layer=ply \
 //thickness=0.18 //x=1.3 //y=1.4 //x2=1.34 //y2=1.555
r1025 (  285 359 ) resistor r=45.1352 //w=0.168 //l=0.173853 //layer=ply \
 //thickness=0.18 //x=1.3 //y=1.055 //x2=1.34 //y2=0.9
r1026 (  285 286 ) resistor r=176.904 //w=0.094 //l=0.345 //layer=ply \
 //thickness=0.18 //x=1.3 //y=1.055 //x2=1.3 //y2=1.4
r1027 (  284 354 ) resistor r=592.245 //w=0.094 //l=1.155 //layer=ply \
 //thickness=0.18 //x=25.39 //y=6.2 //x2=25.39 //y2=5.045
r1028 (  283 397 ) resistor r=592.245 //w=0.094 //l=1.155 //layer=ply \
 //thickness=0.18 //x=24.95 //y=6.2 //x2=24.95 //y2=5.045
r1029 (  282 337 ) resistor r=592.245 //w=0.094 //l=1.155 //layer=ply \
 //thickness=0.18 //x=24.51 //y=6.2 //x2=24.51 //y2=5.045
r1030 (  281 327 ) resistor r=592.245 //w=0.094 //l=1.155 //layer=ply \
 //thickness=0.18 //x=24.07 //y=6.2 //x2=24.07 //y2=5.045
r1031 (  280 318 ) resistor r=592.245 //w=0.094 //l=1.155 //layer=ply \
 //thickness=0.18 //x=12.44 //y=6.2 //x2=12.44 //y2=5.045
r1032 (  279 375 ) resistor r=592.245 //w=0.094 //l=1.155 //layer=ply \
 //thickness=0.18 //x=12 //y=6.2 //x2=12 //y2=5.045
r1033 (  278 301 ) resistor r=592.245 //w=0.094 //l=1.155 //layer=ply \
 //thickness=0.18 //x=2.24 //y=6.2 //x2=2.24 //y2=5.045
r1034 (  277 294 ) resistor r=592.245 //w=0.094 //l=1.155 //layer=ply \
 //thickness=0.18 //x=1.8 //y=6.2 //x2=1.8 //y2=5.045
r1035 (  276 351 ) resistor r=56.4043 //w=0.094 //l=0.11 //layer=ply \
 //thickness=0.18 //x=25.21 //y=1.585 //x2=25.32 //y2=1.585
r1036 (  276 352 ) resistor r=56.4043 //w=0.094 //l=0.11 //layer=ply \
 //thickness=0.18 //x=25.21 //y=1.585 //x2=25.1 //y2=1.585
r1037 (  275 332 ) resistor r=56.4043 //w=0.094 //l=0.11 //layer=ply \
 //thickness=0.18 //x=24.24 //y=1.545 //x2=24.35 //y2=1.545
r1038 (  275 333 ) resistor r=56.4043 //w=0.094 //l=0.11 //layer=ply \
 //thickness=0.18 //x=24.24 //y=1.545 //x2=24.13 //y2=1.545
r1039 (  274 315 ) resistor r=56.4043 //w=0.094 //l=0.11 //layer=ply \
 //thickness=0.18 //x=12.26 //y=1.585 //x2=12.37 //y2=1.585
r1040 (  274 316 ) resistor r=56.4043 //w=0.094 //l=0.11 //layer=ply \
 //thickness=0.18 //x=12.26 //y=1.585 //x2=12.15 //y2=1.585
r1041 (  273 291 ) resistor r=56.4043 //w=0.094 //l=0.11 //layer=ply \
 //thickness=0.18 //x=1.565 //y=1.555 //x2=1.675 //y2=1.555
r1042 (  273 292 ) resistor r=56.4043 //w=0.094 //l=0.11 //layer=ply \
 //thickness=0.18 //x=1.565 //y=1.555 //x2=1.455 //y2=1.555
r1043 (  269 394 ) resistor r=152 //w=0.17 //l=0.17 //layer=licon //count=1 \
 //x=24.94 //y=4.88 //x2=24.94 //y2=4.88
r1044 (  260 390 ) resistor r=152 //w=0.17 //l=0.17 //layer=licon //count=1 \
 //x=24.91 //y=2.26 //x2=24.91 //y2=2.26
r1045 (  255 386 ) resistor r=152 //w=0.17 //l=0.17 //layer=licon //count=1 \
 //x=24.17 //y=4.88 //x2=24.17 //y2=4.88
r1046 (  246 381 ) resistor r=152 //w=0.17 //l=0.17 //layer=licon //count=1 \
 //x=24.17 //y=2.26 //x2=24.17 //y2=2.26
r1047 (  229 411 ) resistor r=23.615 //w=0.187 //l=0.345 //layer=li \
 //thickness=0.1 //x=21.54 //y=5.56 //x2=21.54 //y2=5.905
r1048 (  221 410 ) resistor r=23.615 //w=0.187 //l=0.345 //layer=li \
 //thickness=0.1 //x=20.66 //y=5.56 //x2=20.66 //y2=5.905
r1049 (  213 409 ) resistor r=23.615 //w=0.187 //l=0.345 //layer=li \
 //thickness=0.1 //x=19.78 //y=5.56 //x2=19.78 //y2=5.905
r1050 (  196 408 ) resistor r=23.615 //w=0.187 //l=0.345 //layer=li \
 //thickness=0.1 //x=16.73 //y=5.56 //x2=16.73 //y2=5.905
r1051 (  188 407 ) resistor r=23.615 //w=0.187 //l=0.345 //layer=li \
 //thickness=0.1 //x=15.85 //y=5.56 //x2=15.85 //y2=5.905
r1052 (  180 406 ) resistor r=23.615 //w=0.187 //l=0.345 //layer=li \
 //thickness=0.1 //x=14.97 //y=5.56 //x2=14.97 //y2=5.905
r1053 (  175 372 ) resistor r=152 //w=0.17 //l=0.17 //layer=licon //count=1 \
 //x=11.99 //y=4.88 //x2=11.99 //y2=4.88
r1054 (  166 368 ) resistor r=152 //w=0.17 //l=0.17 //layer=licon //count=1 \
 //x=11.96 //y=2.26 //x2=11.96 //y2=2.26
r1055 (  161 364 ) resistor r=152 //w=0.17 //l=0.17 //layer=licon //count=1 \
 //x=1.6 //y=4.88 //x2=1.6 //y2=4.88
r1056 (  152 362 ) resistor r=152 //w=0.17 //l=0.17 //layer=licon //count=1 \
 //x=1.6 //y=2.26 //x2=1.6 //y2=2.26
r1057 (  148 149 ) resistor r=0.10734 //w=0.281 //l=0.16 //layer=m2 \
 //thickness=0.36 //x=24.9 //y=4.255 //x2=24.74 //y2=4.255
r1058 (  146 149 ) resistor r=0.381679 //w=0.131 //l=0.4 //layer=m2 \
 //thickness=0.36 //x=24.34 //y=4.25 //x2=24.74 //y2=4.25
r1059 (  144 146 ) resistor r=0.10734 //w=0.281 //l=0.16 //layer=m2 \
 //thickness=0.36 //x=24.18 //y=4.235 //x2=24.34 //y2=4.235
r1060 (  144 145 ) resistor r=0.10734 //w=0.281 //l=0.16 //layer=m2 \
 //thickness=0.36 //x=24.18 //y=4.235 //x2=24.02 //y2=4.235
r1061 (  134 136 ) resistor r=0.10734 //w=0.281 //l=0.16 //layer=m2 \
 //thickness=0.36 //x=1.6 //y=4.26 //x2=1.76 //y2=4.26
r1062 (  130 142 ) resistor r=0.108234 //w=0.187 //l=0.167332 //layer=m2 \
 //thickness=0.36 //x=22.475 //y=4.25 //x2=22.315 //y2=4.235
r1063 (  130 145 ) resistor r=1.47424 //w=0.131 //l=1.545 //layer=m2 \
 //thickness=0.36 //x=22.475 //y=4.25 //x2=24.02 //y2=4.25
r1064 (  128 140 ) resistor r=1.08991 //w=0.196 //l=1.70999 //layer=m2 \
 //thickness=0.36 //x=19.22 //y=4.265 //x2=17.515 //y2=4.255
r1065 (  127 142 ) resistor r=1.83952 //w=0.187 //l=2.76496 //layer=m2 \
 //thickness=0.36 //x=19.565 //y=4.265 //x2=22.315 //y2=4.235
r1066 (  127 128 ) resistor r=0.329198 //w=0.131 //l=0.345 //layer=m2 \
 //thickness=0.36 //x=19.565 //y=4.265 //x2=19.22 //y2=4.265
r1067 (  126 138 ) resistor r=0.112172 //w=0.179 //l=0.16 //layer=m2 \
 //thickness=0.36 //x=12.125 //y=4.25 //x2=11.965 //y2=4.25
r1068 (  125 140 ) resistor r=0.104578 //w=0.196 //l=0.162481 //layer=m2 \
 //thickness=0.36 //x=17.355 //y=4.25 //x2=17.515 //y2=4.255
r1069 (  125 126 ) resistor r=4.99046 //w=0.131 //l=5.23 //layer=m2 \
 //thickness=0.36 //x=17.355 //y=4.25 //x2=12.125 //y2=4.25
r1070 (  123 138 ) resistor r=3.726 //w=0.179 //l=5.34249 //layer=m2 \
 //thickness=0.36 //x=6.63 //y=4.265 //x2=11.965 //y2=4.25
r1071 (  123 124 ) resistor r=0.329198 //w=0.131 //l=0.345 //layer=m2 \
 //thickness=0.36 //x=6.63 //y=4.265 //x2=6.285 //y2=4.265
r1072 (  121 124 ) resistor r=0.1875 //w=0.17 //l=0.262393 //layer=m2 \
 //thickness=0.36 //x=6.03 //y=4.25 //x2=6.285 //y2=4.265
r1073 (  121 122 ) resistor r=0.997137 //w=0.131 //l=1.045 //layer=m2 \
 //thickness=0.36 //x=6.03 //y=4.25 //x2=4.985 //y2=4.25
r1074 (  119 122 ) resistor r=0.125 //w=0.17 //l=0.179722 //layer=m2 \
 //thickness=0.36 //x=4.815 //y=4.27 //x2=4.985 //y2=4.25
r1075 (  119 120 ) resistor r=0.367366 //w=0.131 //l=0.385 //layer=m2 \
 //thickness=0.36 //x=4.815 //y=4.27 //x2=4.43 //y2=4.27
r1076 (  117 120 ) resistor r=0.1875 //w=0.17 //l=0.264811 //layer=m2 \
 //thickness=0.36 //x=4.175 //y=4.25 //x2=4.43 //y2=4.27
r1077 (  117 136 ) resistor r=2.30439 //w=0.131 //l=2.415 //layer=m2 \
 //thickness=0.36 //x=4.175 //y=4.25 //x2=1.76 //y2=4.25
r1078 (  116 269 ) resistor r=9.3 //w=0.17 //l=0.17 //layer=mcon //count=1 \
 //x=24.94 //y=4.88 //x2=24.94 //y2=4.88
r1079 (  112 260 ) resistor r=9.3 //w=0.17 //l=0.17 //layer=mcon //count=1 \
 //x=24.91 //y=2.26 //x2=24.91 //y2=2.26
r1080 (  112 114 ) resistor r=0.0936408 //w=0.196 //l=0.125 //layer=m1 \
 //thickness=0.36 //x=24.912 //y=2.26 //x2=24.912 //y2=2.385
r1081 (  110 148 ) resistor r=4.5 //w=0.15 //l=0.15 //layer=via1 //count=1 \
 //x=24.9 //y=4.255 //x2=24.9 //y2=4.255
r1082 (  108 110 ) resistor r=0.00168464 //w=0.371 //l=0.005 //layer=m1 \
 //thickness=0.36 //x=24.852 //y=4.25 //x2=24.852 //y2=4.255
r1083 (  104 255 ) resistor r=9.3 //w=0.17 //l=0.17 //layer=mcon //count=1 \
 //x=24.17 //y=4.88 //x2=24.17 //y2=4.88
r1084 (  104 105 ) resistor r=0.103207 //w=0.196 //l=0.14 //layer=m1 \
 //thickness=0.36 //x=24.172 //y=4.88 //x2=24.172 //y2=4.74
r1085 (  101 246 ) resistor r=9.3 //w=0.17 //l=0.17 //layer=mcon //count=1 \
 //x=24.17 //y=2.26 //x2=24.17 //y2=2.26
r1086 (  97 144 ) resistor r=4.5 //w=0.15 //l=0.15 //layer=via1 //count=1 \
 //x=24.18 //y=4.235 //x2=24.18 //y2=4.235
r1087 (  97 99 ) resistor r=0.00490838 //w=0.382 //l=0.015 //layer=m1 \
 //thickness=0.36 //x=24.122 //y=4.235 //x2=24.122 //y2=4.25
r1088 (  93 142 ) resistor r=4.5 //w=0.15 //l=0.15 //layer=via1 //count=1 \
 //x=22.315 //y=4.235 //x2=22.315 //y2=4.235
r1089 (  93 95 ) resistor r=0.00494723 //w=0.379 //l=0.015 //layer=m1 \
 //thickness=0.36 //x=22.37 //y=4.235 //x2=22.37 //y2=4.25
r1090 (  91 403 ) resistor r=9.3 //w=0.17 //l=0.17 //layer=mcon //count=1 \
 //x=21.835 //y=1.19 //x2=21.835 //y2=1.19
r1091 (  89 229 ) resistor r=9.3 //w=0.17 //l=0.17 //layer=mcon //count=1 \
 //x=21.54 //y=5.56 //x2=21.54 //y2=5.56
r1092 (  86 221 ) resistor r=9.3 //w=0.17 //l=0.17 //layer=mcon //count=1 \
 //x=20.66 //y=5.56 //x2=20.66 //y2=5.56
r1093 (  84 86 ) resistor r=0.121228 //w=0.232 //l=0.225 //layer=m1 \
 //thickness=0.36 //x=20.66 //y=5.335 //x2=20.66 //y2=5.56
r1094 (  83 213 ) resistor r=9.3 //w=0.17 //l=0.17 //layer=mcon //count=1 \
 //x=19.78 //y=5.56 //x2=19.78 //y2=5.56
r1095 (  81 83 ) resistor r=0.129608 //w=0.217 //l=0.225 //layer=m1 \
 //thickness=0.36 //x=19.782 //y=5.335 //x2=19.782 //y2=5.56
r1096 (  80 140 ) resistor r=4.5 //w=0.15 //l=0.15 //layer=via1 //count=1 \
 //x=17.515 //y=4.255 //x2=17.515 //y2=4.255
r1097 (  78 80 ) resistor r=0.00164908 //w=0.379 //l=0.005 //layer=m1 \
 //thickness=0.36 //x=17.46 //y=4.25 //x2=17.46 //y2=4.255
r1098 (  76 402 ) resistor r=9.3 //w=0.17 //l=0.17 //layer=mcon //count=1 \
 //x=17.025 //y=1.19 //x2=17.025 //y2=1.19
r1099 (  74 196 ) resistor r=9.3 //w=0.17 //l=0.17 //layer=mcon //count=1 \
 //x=16.73 //y=5.56 //x2=16.73 //y2=5.56
r1100 (  71 188 ) resistor r=9.3 //w=0.17 //l=0.17 //layer=mcon //count=1 \
 //x=15.85 //y=5.56 //x2=15.85 //y2=5.56
r1101 (  69 71 ) resistor r=0.121228 //w=0.232 //l=0.225 //layer=m1 \
 //thickness=0.36 //x=15.85 //y=5.335 //x2=15.85 //y2=5.56
r1102 (  68 180 ) resistor r=9.3 //w=0.17 //l=0.17 //layer=mcon //count=1 \
 //x=14.97 //y=5.56 //x2=14.97 //y2=5.56
r1103 (  66 68 ) resistor r=0.129608 //w=0.217 //l=0.225 //layer=m1 \
 //thickness=0.36 //x=14.972 //y=5.335 //x2=14.972 //y2=5.56
r1104 (  65 175 ) resistor r=9.3 //w=0.17 //l=0.17 //layer=mcon //count=1 \
 //x=11.99 //y=4.88 //x2=11.99 //y2=4.88
r1105 (  61 166 ) resistor r=9.3 //w=0.17 //l=0.17 //layer=mcon //count=1 \
 //x=11.96 //y=2.26 //x2=11.96 //y2=2.26
r1106 (  61 63 ) resistor r=0.0936408 //w=0.196 //l=0.125 //layer=m1 \
 //thickness=0.36 //x=11.962 //y=2.26 //x2=11.962 //y2=2.385
r1107 (  58 138 ) resistor r=4.5 //w=0.15 //l=0.15 //layer=via1 //count=1 \
 //x=11.965 //y=4.25 //x2=11.965 //y2=4.25
r1108 (  56 134 ) resistor r=4.5 //w=0.15 //l=0.15 //layer=via1 //count=1 \
 //x=1.6 //y=4.26 //x2=1.6 //y2=4.26
r1109 (  54 56 ) resistor r=0.00332447 //w=0.376 //l=0.01 //layer=m1 \
 //thickness=0.36 //x=1.652 //y=4.25 //x2=1.652 //y2=4.26
r1110 (  52 161 ) resistor r=9.3 //w=0.17 //l=0.17 //layer=mcon //count=1 \
 //x=1.6 //y=4.88 //x2=1.6 //y2=4.88
r1111 (  50 152 ) resistor r=9.3 //w=0.17 //l=0.17 //layer=mcon //count=1 \
 //x=1.6 //y=2.26 //x2=1.6 //y2=2.26
r1112 (  48 116 ) resistor r=0.0878548 //w=0.228 //l=0.159295 //layer=m1 \
 //thickness=0.36 //x=24.91 //y=4.735 //x2=24.94 //y2=4.88
r1113 (  47 110 ) resistor r=0.0909648 //w=0.371 //l=0.186762 //layer=m1 \
 //thickness=0.36 //x=24.91 //y=4.415 //x2=24.852 //y2=4.255
r1114 (  47 48 ) resistor r=0.305344 //w=0.131 //l=0.32 //layer=m1 \
 //thickness=0.36 //x=24.91 //y=4.415 //x2=24.91 //y2=4.735
r1115 (  46 108 ) resistor r=0.0892801 //w=0.371 //l=0.1817 //layer=m1 \
 //thickness=0.36 //x=24.91 //y=4.095 //x2=24.852 //y2=4.25
r1116 (  46 114 ) resistor r=1.63168 //w=0.131 //l=1.71 //layer=m1 \
 //thickness=0.36 //x=24.91 //y=4.095 //x2=24.91 //y2=2.385
r1117 (  43 99 ) resistor r=0.0864989 //w=0.382 //l=0.167287 //layer=m1 \
 //thickness=0.36 //x=24.17 //y=4.395 //x2=24.122 //y2=4.25
r1118 (  43 105 ) resistor r=0.329198 //w=0.131 //l=0.345 //layer=m1 \
 //thickness=0.36 //x=24.17 //y=4.395 //x2=24.17 //y2=4.74
r1119 (  42 97 ) resistor r=0.0914072 //w=0.382 //l=0.182428 //layer=m1 \
 //thickness=0.36 //x=24.17 //y=4.075 //x2=24.122 //y2=4.235
r1120 (  41 101 ) resistor r=0.0933015 //w=0.201 //l=0.125 //layer=m1 \
 //thickness=0.36 //x=24.17 //y=2.385 //x2=24.17 //y2=2.26
r1121 (  41 42 ) resistor r=1.6126 //w=0.131 //l=1.69 //layer=m1 \
 //thickness=0.36 //x=24.17 //y=2.385 //x2=24.17 //y2=4.075
r1122 (  39 95 ) resistor r=0.0863342 //w=0.379 //l=0.168152 //layer=m1 \
 //thickness=0.36 //x=22.32 //y=4.395 //x2=22.37 //y2=4.25
r1123 (  39 40 ) resistor r=0.81584 //w=0.131 //l=0.855 //layer=m1 \
 //thickness=0.36 //x=22.32 //y=4.395 //x2=22.32 //y2=5.25
r1124 (  38 93 ) resistor r=0.0912814 //w=0.379 //l=0.183303 //layer=m1 \
 //thickness=0.36 //x=22.32 //y=4.075 //x2=22.37 //y2=4.235
r1125 (  37 38 ) resistor r=2.04676 //w=0.131 //l=2.145 //layer=m1 \
 //thickness=0.36 //x=22.32 //y=1.93 //x2=22.32 //y2=4.075
r1126 (  35 37 ) resistor r=0.0698411 //w=0.17 //l=0.120208 //layer=m1 \
 //thickness=0.36 //x=22.235 //y=1.845 //x2=22.32 //y2=1.93
r1127 (  35 36 ) resistor r=0.300573 //w=0.131 //l=0.315 //layer=m1 \
 //thickness=0.36 //x=22.235 //y=1.845 //x2=21.92 //y2=1.845
r1128 (  34 36 ) resistor r=0.0698411 //w=0.17 //l=0.120208 //layer=m1 \
 //thickness=0.36 //x=21.835 //y=1.76 //x2=21.92 //y2=1.845
r1129 (  33 91 ) resistor r=0.0717383 //w=0.224 //l=0.115 //layer=m1 \
 //thickness=0.36 //x=21.835 //y=1.305 //x2=21.835 //y2=1.19
r1130 (  33 34 ) resistor r=0.43416 //w=0.131 //l=0.455 //layer=m1 \
 //thickness=0.36 //x=21.835 //y=1.305 //x2=21.835 //y2=1.76
r1131 (  32 87 ) resistor r=0.0675342 //w=0.23 //l=0.115 //layer=m1 \
 //thickness=0.36 //x=21.655 //y=5.335 //x2=21.54 //y2=5.335
r1132 (  31 40 ) resistor r=0.0698411 //w=0.17 //l=0.120208 //layer=m1 \
 //thickness=0.36 //x=22.235 //y=5.335 //x2=22.32 //y2=5.25
r1133 (  31 32 ) resistor r=0.553435 //w=0.131 //l=0.58 //layer=m1 \
 //thickness=0.36 //x=22.235 //y=5.335 //x2=21.655 //y2=5.335
r1134 (  30 89 ) resistor r=0.00118313 //w=0.23 //layer=m1 //thickness=0.36 \
 //x=21.54 //y=5.56 //x2=21.54 //y2=5.56
r1135 (  29 87 ) resistor r=0.002872 //w=0.34 //l=0.085 //layer=m1 \
 //thickness=0.36 //x=21.54 //y=5.42 //x2=21.54 //y2=5.335
r1136 (  29 30 ) resistor r=0.091623 //w=0.191 //l=0.14 //layer=m1 \
 //thickness=0.36 //x=21.54 //y=5.42 //x2=21.54 //y2=5.56
r1137 (  28 84 ) resistor r=0.0262263 //w=0.232 //l=0.12 //layer=m1 \
 //thickness=0.36 //x=20.78 //y=5.335 //x2=20.66 //y2=5.335
r1138 (  27 87 ) resistor r=0.0675342 //w=0.23 //l=0.115 //layer=m1 \
 //thickness=0.36 //x=21.425 //y=5.335 //x2=21.54 //y2=5.335
r1139 (  27 28 ) resistor r=0.615458 //w=0.131 //l=0.645 //layer=m1 \
 //thickness=0.36 //x=21.425 //y=5.335 //x2=20.78 //y2=5.335
r1140 (  26 81 ) resistor r=0.0222262 //w=0.217 //l=0.118 //layer=m1 \
 //thickness=0.36 //x=19.9 //y=5.335 //x2=19.782 //y2=5.335
r1141 (  25 84 ) resistor r=0.0262263 //w=0.232 //l=0.12 //layer=m1 \
 //thickness=0.36 //x=20.54 //y=5.335 //x2=20.66 //y2=5.335
r1142 (  25 26 ) resistor r=0.610687 //w=0.131 //l=0.64 //layer=m1 \
 //thickness=0.36 //x=20.54 //y=5.335 //x2=19.9 //y2=5.335
r1143 (  23 80 ) resistor r=0.0912814 //w=0.379 //l=0.183303 //layer=m1 \
 //thickness=0.36 //x=17.51 //y=4.415 //x2=17.46 //y2=4.255
r1144 (  23 24 ) resistor r=0.796756 //w=0.131 //l=0.835 //layer=m1 \
 //thickness=0.36 //x=17.51 //y=4.415 //x2=17.51 //y2=5.25
r1145 (  22 78 ) resistor r=0.0896323 //w=0.379 //l=0.178255 //layer=m1 \
 //thickness=0.36 //x=17.51 //y=4.095 //x2=17.46 //y2=4.25
r1146 (  21 22 ) resistor r=2.06584 //w=0.131 //l=2.165 //layer=m1 \
 //thickness=0.36 //x=17.51 //y=1.93 //x2=17.51 //y2=4.095
r1147 (  19 21 ) resistor r=0.0698411 //w=0.17 //l=0.120208 //layer=m1 \
 //thickness=0.36 //x=17.425 //y=1.845 //x2=17.51 //y2=1.93
r1148 (  19 20 ) resistor r=0.300573 //w=0.131 //l=0.315 //layer=m1 \
 //thickness=0.36 //x=17.425 //y=1.845 //x2=17.11 //y2=1.845
r1149 (  18 20 ) resistor r=0.0698411 //w=0.17 //l=0.120208 //layer=m1 \
 //thickness=0.36 //x=17.025 //y=1.76 //x2=17.11 //y2=1.845
r1150 (  17 76 ) resistor r=0.0717383 //w=0.224 //l=0.115 //layer=m1 \
 //thickness=0.36 //x=17.025 //y=1.305 //x2=17.025 //y2=1.19
r1151 (  17 18 ) resistor r=0.43416 //w=0.131 //l=0.455 //layer=m1 \
 //thickness=0.36 //x=17.025 //y=1.305 //x2=17.025 //y2=1.76
r1152 (  16 72 ) resistor r=0.0675342 //w=0.23 //l=0.115 //layer=m1 \
 //thickness=0.36 //x=16.845 //y=5.335 //x2=16.73 //y2=5.335
r1153 (  15 24 ) resistor r=0.0698411 //w=0.17 //l=0.120208 //layer=m1 \
 //thickness=0.36 //x=17.425 //y=5.335 //x2=17.51 //y2=5.25
r1154 (  15 16 ) resistor r=0.553435 //w=0.131 //l=0.58 //layer=m1 \
 //thickness=0.36 //x=17.425 //y=5.335 //x2=16.845 //y2=5.335
r1155 (  14 74 ) resistor r=0.00118313 //w=0.23 //layer=m1 //thickness=0.36 \
 //x=16.73 //y=5.56 //x2=16.73 //y2=5.56
r1156 (  13 72 ) resistor r=0.002872 //w=0.34 //l=0.085 //layer=m1 \
 //thickness=0.36 //x=16.73 //y=5.42 //x2=16.73 //y2=5.335
r1157 (  13 14 ) resistor r=0.091623 //w=0.191 //l=0.14 //layer=m1 \
 //thickness=0.36 //x=16.73 //y=5.42 //x2=16.73 //y2=5.56
r1158 (  12 69 ) resistor r=0.0262263 //w=0.232 //l=0.12 //layer=m1 \
 //thickness=0.36 //x=15.97 //y=5.335 //x2=15.85 //y2=5.335
r1159 (  11 72 ) resistor r=0.0675342 //w=0.23 //l=0.115 //layer=m1 \
 //thickness=0.36 //x=16.615 //y=5.335 //x2=16.73 //y2=5.335
r1160 (  11 12 ) resistor r=0.615458 //w=0.131 //l=0.645 //layer=m1 \
 //thickness=0.36 //x=16.615 //y=5.335 //x2=15.97 //y2=5.335
r1161 (  10 66 ) resistor r=0.0222262 //w=0.217 //l=0.118 //layer=m1 \
 //thickness=0.36 //x=15.09 //y=5.335 //x2=14.972 //y2=5.335
r1162 (  9 69 ) resistor r=0.0262263 //w=0.232 //l=0.12 //layer=m1 \
 //thickness=0.36 //x=15.73 //y=5.335 //x2=15.85 //y2=5.335
r1163 (  9 10 ) resistor r=0.610687 //w=0.131 //l=0.64 //layer=m1 \
 //thickness=0.36 //x=15.73 //y=5.335 //x2=15.09 //y2=5.335
r1164 (  8 65 ) resistor r=0.0878548 //w=0.228 //l=0.159295 //layer=m1 \
 //thickness=0.36 //x=11.96 //y=4.735 //x2=11.99 //y2=4.88
r1165 (  7 58 ) resistor r=0.0912814 //w=0.379 //l=0.183303 //layer=m1 \
 //thickness=0.36 //x=11.96 //y=4.41 //x2=11.91 //y2=4.25
r1166 (  7 8 ) resistor r=0.310115 //w=0.131 //l=0.325 //layer=m1 \
 //thickness=0.36 //x=11.96 //y=4.41 //x2=11.96 //y2=4.735
r1167 (  6 58 ) resistor r=0.0912814 //w=0.379 //l=0.183303 //layer=m1 \
 //thickness=0.36 //x=11.96 //y=4.09 //x2=11.91 //y2=4.25
r1168 (  6 63 ) resistor r=1.62691 //w=0.131 //l=1.705 //layer=m1 \
 //thickness=0.36 //x=11.96 //y=4.09 //x2=11.96 //y2=2.385
r1169 (  4 52 ) resistor r=0.0760407 //w=0.238 //l=0.125 //layer=m1 \
 //thickness=0.36 //x=1.6 //y=4.755 //x2=1.6 //y2=4.88
r1170 (  3 56 ) resistor r=0.0911593 //w=0.376 //l=0.184174 //layer=m1 \
 //thickness=0.36 //x=1.6 //y=4.42 //x2=1.652 //y2=4.26
r1171 (  3 4 ) resistor r=0.319656 //w=0.131 //l=0.335 //layer=m1 \
 //thickness=0.36 //x=1.6 //y=4.42 //x2=1.6 //y2=4.755
r1172 (  2 54 ) resistor r=0.0878349 //w=0.376 //l=0.174069 //layer=m1 \
 //thickness=0.36 //x=1.6 //y=4.1 //x2=1.652 //y2=4.25
r1173 (  1 50 ) resistor r=0.0719237 //w=0.222 //l=0.115 //layer=m1 \
 //thickness=0.36 //x=1.6 //y=2.375 //x2=1.6 //y2=2.26
r1174 (  1 2 ) resistor r=1.64599 //w=0.131 //l=1.725 //layer=m1 \
 //thickness=0.36 //x=1.6 //y=2.375 //x2=1.6 //y2=4.1
ends PM_TMRDFFRNQNX1\%noxref_4

subckt PM_TMRDFFRNQNX1\%D ( 1 2 3 4 5 6 8 9 10 11 27 35 37 38 41 50 55 64 68 \
 69 70 71 72 73 74 75 76 78 84 85 86 87 88 93 94 95 97 103 104 105 106 107 115 \
 126 )
c428 ( 126 0 ) capacitor c=0.0369044f //x=33.42 //y=4.88
c429 ( 115 0 ) capacitor c=0.0369044f //x=7.52 //y=4.88
c430 ( 107 0 ) capacitor c=0.0309248f //x=33.755 //y=4.97
c431 ( 106 0 ) capacitor c=0.0817345f //x=33.51 //y=2.095
c432 ( 105 0 ) capacitor c=0.0170266f //x=33.51 //y=1.63
c433 ( 104 0 ) capacitor c=0.018609f //x=33.51 //y=1.4
c434 ( 103 0 ) capacitor c=0.0186599f //x=33.51 //y=1.09
c435 ( 97 0 ) capacitor c=0.0146988f //x=33.355 //y=1.555
c436 ( 95 0 ) capacitor c=0.0148531f //x=33.355 //y=0.935
c437 ( 94 0 ) capacitor c=0.0334406f //x=32.985 //y=1.4
c438 ( 93 0 ) capacitor c=0.0173191f //x=32.985 //y=1.09
c439 ( 88 0 ) capacitor c=0.0309248f //x=7.855 //y=4.97
c440 ( 87 0 ) capacitor c=0.0817418f //x=7.61 //y=2.095
c441 ( 86 0 ) capacitor c=0.0170266f //x=7.61 //y=1.63
c442 ( 85 0 ) capacitor c=0.018609f //x=7.61 //y=1.4
c443 ( 84 0 ) capacitor c=0.0186599f //x=7.61 //y=1.09
c444 ( 78 0 ) capacitor c=0.0146988f //x=7.455 //y=1.555
c445 ( 76 0 ) capacitor c=0.0148531f //x=7.455 //y=0.935
c446 ( 75 0 ) capacitor c=0.0334406f //x=7.085 //y=1.4
c447 ( 74 0 ) capacitor c=0.0173191f //x=7.085 //y=1.09
c448 ( 73 0 ) capacitor c=0.110208f //x=33.83 //y=6.2
c449 ( 72 0 ) capacitor c=0.110214f //x=33.39 //y=6.2
c450 ( 71 0 ) capacitor c=0.110208f //x=7.93 //y=6.2
c451 ( 70 0 ) capacitor c=0.110214f //x=7.49 //y=6.2
c452 ( 64 0 ) capacitor c=0.00129935f //x=33.42 //y=4.88
c453 ( 55 0 ) capacitor c=9.49278e-19 //x=33.42 //y=2.26
c454 ( 50 0 ) capacitor c=0.00129935f //x=7.52 //y=4.88
c455 ( 41 0 ) capacitor c=9.49278e-19 //x=7.52 //y=2.26
c456 ( 38 0 ) capacitor c=0.287113f //x=33.26 //y=2.755
c457 ( 37 0 ) capacitor c=0.234409f //x=33.42 //y=2.755
c458 ( 35 0 ) capacitor c=0.00266524f //x=7.675 //y=2.78
c459 ( 27 0 ) capacitor c=0.0162528f //x=33.42 //y=2.77
c460 ( 11 0 ) capacitor c=0.0542391f //x=33.42 //y=4.765
c461 ( 10 0 ) capacitor c=0.0122917f //x=33.42 //y=2.915
c462 ( 9 0 ) capacitor c=0.0038202f //x=33.42 //y=2.595
c463 ( 8 0 ) capacitor c=0.00337384f //x=33.42 //y=2.375
c464 ( 6 0 ) capacitor c=0.00494922f //x=7.52 //y=4.765
c465 ( 5 0 ) capacitor c=0.012521f //x=7.52 //y=2.94
c466 ( 4 0 ) capacitor c=0.0053563f //x=7.52 //y=2.62
c467 ( 3 0 ) capacitor c=0.00503429f //x=7.52 //y=2.375
c468 ( 2 0 ) capacitor c=0.0162461f //x=7.52 //y=2.77
c469 ( 1 0 ) capacitor c=0.0513512f //x=7.52 //y=3.14
r470 (  128 129 ) resistor r=32.4568 //w=0.214 //l=0.075 //layer=ply \
 //thickness=0.18 //x=33.42 //y=4.97 //x2=33.42 //y2=5.045
r471 (  126 128 ) resistor r=20.271 //w=0.214 //l=0.09 //layer=ply \
 //thickness=0.18 //x=33.42 //y=4.88 //x2=33.42 //y2=4.97
r472 (  117 118 ) resistor r=32.4568 //w=0.214 //l=0.075 //layer=ply \
 //thickness=0.18 //x=7.52 //y=4.97 //x2=7.52 //y2=5.045
r473 (  115 117 ) resistor r=20.271 //w=0.214 //l=0.09 //layer=ply \
 //thickness=0.18 //x=7.52 //y=4.88 //x2=7.52 //y2=4.97
r474 (  108 128 ) resistor r=16.5046 //w=0.27 //l=0.135 //layer=ply \
 //thickness=0.18 //x=33.555 //y=4.97 //x2=33.42 //y2=4.97
r475 (  107 109 ) resistor r=26.9307 //w=0.15 //l=0.106066 //layer=ply \
 //thickness=0.18 //x=33.755 //y=4.97 //x2=33.83 //y2=5.045
r476 (  107 108 ) resistor r=102.553 //w=0.094 //l=0.2 //layer=ply \
 //thickness=0.18 //x=33.755 //y=4.97 //x2=33.555 //y2=4.97
r477 (  106 133 ) resistor r=38.6777 //w=0.284 //l=0.198997 //layer=ply \
 //thickness=0.18 //x=33.51 //y=2.095 //x2=33.435 //y2=2.26
r478 (  105 131 ) resistor r=21.2976 //w=0.217 //l=0.0928709 //layer=ply \
 //thickness=0.18 //x=33.51 //y=1.63 //x2=33.47 //y2=1.555
r479 (  105 106 ) resistor r=238.436 //w=0.094 //l=0.465 //layer=ply \
 //thickness=0.18 //x=33.51 //y=1.63 //x2=33.51 //y2=2.095
r480 (  104 131 ) resistor r=39.0671 //w=0.217 //l=0.173853 //layer=ply \
 //thickness=0.18 //x=33.51 //y=1.4 //x2=33.47 //y2=1.555
r481 (  103 130 ) resistor r=45.1352 //w=0.168 //l=0.173853 //layer=ply \
 //thickness=0.18 //x=33.51 //y=1.09 //x2=33.47 //y2=0.935
r482 (  103 104 ) resistor r=158.957 //w=0.094 //l=0.31 //layer=ply \
 //thickness=0.18 //x=33.51 //y=1.09 //x2=33.51 //y2=1.4
r483 (  98 124 ) resistor r=5.52526 //w=0.168 //l=0.115 //layer=ply \
 //thickness=0.18 //x=33.14 //y=1.555 //x2=33.025 //y2=1.555
r484 (  97 131 ) resistor r=11.4558 //w=0.217 //l=0.115 //layer=ply \
 //thickness=0.18 //x=33.355 //y=1.555 //x2=33.47 //y2=1.555
r485 (  96 123 ) resistor r=5.52526 //w=0.168 //l=0.115 //layer=ply \
 //thickness=0.18 //x=33.14 //y=0.935 //x2=33.025 //y2=0.935
r486 (  95 130 ) resistor r=5.52526 //w=0.168 //l=0.115 //layer=ply \
 //thickness=0.18 //x=33.355 //y=0.935 //x2=33.47 //y2=0.935
r487 (  95 96 ) resistor r=110.245 //w=0.094 //l=0.215 //layer=ply \
 //thickness=0.18 //x=33.355 //y=0.935 //x2=33.14 //y2=0.935
r488 (  94 124 ) resistor r=45.1352 //w=0.168 //l=0.173853 //layer=ply \
 //thickness=0.18 //x=32.985 //y=1.4 //x2=33.025 //y2=1.555
r489 (  93 123 ) resistor r=45.1352 //w=0.168 //l=0.173853 //layer=ply \
 //thickness=0.18 //x=32.985 //y=1.09 //x2=33.025 //y2=0.935
r490 (  93 94 ) resistor r=158.957 //w=0.094 //l=0.31 //layer=ply \
 //thickness=0.18 //x=32.985 //y=1.09 //x2=32.985 //y2=1.4
r491 (  89 117 ) resistor r=16.5046 //w=0.27 //l=0.135 //layer=ply \
 //thickness=0.18 //x=7.655 //y=4.97 //x2=7.52 //y2=4.97
r492 (  88 90 ) resistor r=26.9307 //w=0.15 //l=0.106066 //layer=ply \
 //thickness=0.18 //x=7.855 //y=4.97 //x2=7.93 //y2=5.045
r493 (  88 89 ) resistor r=102.553 //w=0.094 //l=0.2 //layer=ply \
 //thickness=0.18 //x=7.855 //y=4.97 //x2=7.655 //y2=4.97
r494 (  87 122 ) resistor r=38.6777 //w=0.284 //l=0.198997 //layer=ply \
 //thickness=0.18 //x=7.61 //y=2.095 //x2=7.535 //y2=2.26
r495 (  86 120 ) resistor r=21.2976 //w=0.217 //l=0.0928709 //layer=ply \
 //thickness=0.18 //x=7.61 //y=1.63 //x2=7.57 //y2=1.555
r496 (  86 87 ) resistor r=238.436 //w=0.094 //l=0.465 //layer=ply \
 //thickness=0.18 //x=7.61 //y=1.63 //x2=7.61 //y2=2.095
r497 (  85 120 ) resistor r=39.0671 //w=0.217 //l=0.173853 //layer=ply \
 //thickness=0.18 //x=7.61 //y=1.4 //x2=7.57 //y2=1.555
r498 (  84 119 ) resistor r=45.1352 //w=0.168 //l=0.173853 //layer=ply \
 //thickness=0.18 //x=7.61 //y=1.09 //x2=7.57 //y2=0.935
r499 (  84 85 ) resistor r=158.957 //w=0.094 //l=0.31 //layer=ply \
 //thickness=0.18 //x=7.61 //y=1.09 //x2=7.61 //y2=1.4
r500 (  79 113 ) resistor r=5.52526 //w=0.168 //l=0.115 //layer=ply \
 //thickness=0.18 //x=7.24 //y=1.555 //x2=7.125 //y2=1.555
r501 (  78 120 ) resistor r=11.4558 //w=0.217 //l=0.115 //layer=ply \
 //thickness=0.18 //x=7.455 //y=1.555 //x2=7.57 //y2=1.555
r502 (  77 112 ) resistor r=5.52526 //w=0.168 //l=0.115 //layer=ply \
 //thickness=0.18 //x=7.24 //y=0.935 //x2=7.125 //y2=0.935
r503 (  76 119 ) resistor r=5.52526 //w=0.168 //l=0.115 //layer=ply \
 //thickness=0.18 //x=7.455 //y=0.935 //x2=7.57 //y2=0.935
r504 (  76 77 ) resistor r=110.245 //w=0.094 //l=0.215 //layer=ply \
 //thickness=0.18 //x=7.455 //y=0.935 //x2=7.24 //y2=0.935
r505 (  75 113 ) resistor r=45.1352 //w=0.168 //l=0.173853 //layer=ply \
 //thickness=0.18 //x=7.085 //y=1.4 //x2=7.125 //y2=1.555
r506 (  74 112 ) resistor r=45.1352 //w=0.168 //l=0.173853 //layer=ply \
 //thickness=0.18 //x=7.085 //y=1.09 //x2=7.125 //y2=0.935
r507 (  74 75 ) resistor r=158.957 //w=0.094 //l=0.31 //layer=ply \
 //thickness=0.18 //x=7.085 //y=1.09 //x2=7.085 //y2=1.4
r508 (  73 109 ) resistor r=592.245 //w=0.094 //l=1.155 //layer=ply \
 //thickness=0.18 //x=33.83 //y=6.2 //x2=33.83 //y2=5.045
r509 (  72 129 ) resistor r=592.245 //w=0.094 //l=1.155 //layer=ply \
 //thickness=0.18 //x=33.39 //y=6.2 //x2=33.39 //y2=5.045
r510 (  71 90 ) resistor r=592.245 //w=0.094 //l=1.155 //layer=ply \
 //thickness=0.18 //x=7.93 //y=6.2 //x2=7.93 //y2=5.045
r511 (  70 118 ) resistor r=592.245 //w=0.094 //l=1.155 //layer=ply \
 //thickness=0.18 //x=7.49 //y=6.2 //x2=7.49 //y2=5.045
r512 (  69 97 ) resistor r=55.3787 //w=0.094 //l=0.108 //layer=ply \
 //thickness=0.18 //x=33.247 //y=1.555 //x2=33.355 //y2=1.555
r513 (  69 98 ) resistor r=54.866 //w=0.094 //l=0.107 //layer=ply \
 //thickness=0.18 //x=33.247 //y=1.555 //x2=33.14 //y2=1.555
r514 (  68 78 ) resistor r=55.3787 //w=0.094 //l=0.108 //layer=ply \
 //thickness=0.18 //x=7.347 //y=1.555 //x2=7.455 //y2=1.555
r515 (  68 79 ) resistor r=54.866 //w=0.094 //l=0.107 //layer=ply \
 //thickness=0.18 //x=7.347 //y=1.555 //x2=7.24 //y2=1.555
r516 (  64 126 ) resistor r=152 //w=0.17 //l=0.17 //layer=licon //count=1 \
 //x=33.42 //y=4.88 //x2=33.42 //y2=4.88
r517 (  55 133 ) resistor r=152 //w=0.17 //l=0.17 //layer=licon //count=1 \
 //x=33.42 //y=2.26 //x2=33.42 //y2=2.26
r518 (  50 115 ) resistor r=152 //w=0.17 //l=0.17 //layer=licon //count=1 \
 //x=7.52 //y=4.88 //x2=7.52 //y2=4.88
r519 (  41 122 ) resistor r=152 //w=0.17 //l=0.17 //layer=licon //count=1 \
 //x=7.52 //y=2.26 //x2=7.52 //y2=2.26
r520 (  37 38 ) resistor r=0.10734 //w=0.281 //l=0.16 //layer=m2 \
 //thickness=0.36 //x=33.42 //y=2.755 //x2=33.26 //y2=2.755
r521 (  35 38 ) resistor r=24.4132 //w=0.131 //l=25.585 //layer=m2 \
 //thickness=0.36 //x=7.675 //y=2.77 //x2=33.26 //y2=2.77
r522 (  33 35 ) resistor r=0.10734 //w=0.281 //l=0.16 //layer=m2 \
 //thickness=0.36 //x=7.515 //y=2.78 //x2=7.675 //y2=2.78
r523 (  25 37 ) resistor r=4.5 //w=0.15 //l=0.15 //layer=via1 //count=1 \
 //x=33.42 //y=2.755 //x2=33.42 //y2=2.755
r524 (  25 27 ) resistor r=0.0049867 //w=0.376 //l=0.015 //layer=m1 \
 //thickness=0.36 //x=33.472 //y=2.755 //x2=33.472 //y2=2.77
r525 (  23 64 ) resistor r=9.3 //w=0.17 //l=0.17 //layer=mcon //count=1 \
 //x=33.42 //y=4.88 //x2=33.42 //y2=4.88
r526 (  21 55 ) resistor r=9.3 //w=0.17 //l=0.17 //layer=mcon //count=1 \
 //x=33.42 //y=2.26 //x2=33.42 //y2=2.26
r527 (  19 33 ) resistor r=4.5 //w=0.15 //l=0.15 //layer=via1 //count=1 \
 //x=7.515 //y=2.78 //x2=7.515 //y2=2.78
r528 (  15 50 ) resistor r=9.3 //w=0.17 //l=0.17 //layer=mcon //count=1 \
 //x=7.52 //y=4.88 //x2=7.52 //y2=4.88
r529 (  13 41 ) resistor r=9.3 //w=0.17 //l=0.17 //layer=mcon //count=1 \
 //x=7.52 //y=2.26 //x2=7.52 //y2=2.26
r530 (  11 23 ) resistor r=0.0717383 //w=0.224 //l=0.115 //layer=m1 \
 //thickness=0.36 //x=33.42 //y=4.765 //x2=33.42 //y2=4.88
r531 (  10 27 ) resistor r=0.0861726 //w=0.376 //l=0.169012 //layer=m1 \
 //thickness=0.36 //x=33.42 //y=2.915 //x2=33.472 //y2=2.77
r532 (  10 11 ) resistor r=1.76527 //w=0.131 //l=1.85 //layer=m1 \
 //thickness=0.36 //x=33.42 //y=2.915 //x2=33.42 //y2=4.765
r533 (  9 25 ) resistor r=0.0911593 //w=0.376 //l=0.184174 //layer=m1 \
 //thickness=0.36 //x=33.42 //y=2.595 //x2=33.472 //y2=2.755
r534 (  8 21 ) resistor r=0.0715665 //w=0.226 //l=0.115996 //layer=m1 \
 //thickness=0.36 //x=33.42 //y=2.375 //x2=33.422 //y2=2.26
r535 (  8 9 ) resistor r=0.209924 //w=0.131 //l=0.22 //layer=m1 \
 //thickness=0.36 //x=33.42 //y=2.375 //x2=33.42 //y2=2.595
r536 (  6 15 ) resistor r=0.0717383 //w=0.224 //l=0.115 //layer=m1 \
 //thickness=0.36 //x=7.52 //y=4.765 //x2=7.52 //y2=4.88
r537 (  5 19 ) resistor r=0.0912814 //w=0.379 //l=0.183303 //layer=m1 \
 //thickness=0.36 //x=7.52 //y=2.94 //x2=7.57 //y2=2.78
r538 (  3 13 ) resistor r=0.0715665 //w=0.226 //l=0.115996 //layer=m1 \
 //thickness=0.36 //x=7.52 //y=2.375 //x2=7.522 //y2=2.26
r539 (  3 4 ) resistor r=0.233779 //w=0.131 //l=0.245 //layer=m1 \
 //thickness=0.36 //x=7.52 //y=2.375 //x2=7.52 //y2=2.62
r540 (  2 19 ) resistor r=0.00329815 //w=0.379 //l=0.01 //layer=m1 \
 //thickness=0.36 //x=7.57 //y=2.77 //x2=7.57 //y2=2.78
r541 (  2 4 ) resistor r=0.0879833 //w=0.379 //l=0.173205 //layer=m1 \
 //thickness=0.36 //x=7.57 //y=2.77 //x2=7.52 //y2=2.62
r542 (  1 6 ) resistor r=1.55057 //w=0.131 //l=1.625 //layer=m1 \
 //thickness=0.36 //x=7.52 //y=3.14 //x2=7.52 //y2=4.765
r543 (  1 5 ) resistor r=0.19084 //w=0.131 //l=0.2 //layer=m1 //thickness=0.36 \
 //x=7.52 //y=3.14 //x2=7.52 //y2=2.94
ends PM_TMRDFFRNQNX1\%D

subckt PM_TMRDFFRNQNX1\%noxref_6 ( 1 2 3 4 5 7 10 11 13 14 15 16 18 19 20 22 \
 23 30 32 35 38 44 47 50 53 54 56 57 58 60 62 64 65 72 75 84 89 97 105 122 131 \
 135 136 137 138 139 140 144 145 146 151 153 156 157 158 159 160 161 165 167 \
 170 171 176 177 182 191 194 196 197 198 )
c447 ( 194 0 ) capacitor c=0.00885916f //x=34.595 //y=1.095
c448 ( 191 0 ) capacitor c=0.0682508f //x=37.12 //y=4.88
c449 ( 182 0 ) capacitor c=0.0710579f //x=29.72 //y=4.88
c450 ( 177 0 ) capacitor c=0.0278202f //x=29.72 //y=2.095
c451 ( 176 0 ) capacitor c=0.0479324f //x=29.72 //y=2.26
c452 ( 171 0 ) capacitor c=0.0318956f //x=37.455 //y=1.39
c453 ( 170 0 ) capacitor c=0.0186809f //x=37.455 //y=1.045
c454 ( 167 0 ) capacitor c=0.0141821f //x=37.3 //y=1.545
c455 ( 165 0 ) capacitor c=0.0158553f //x=37.3 //y=0.89
c456 ( 161 0 ) capacitor c=0.0854195f //x=36.925 //y=2.095
c457 ( 160 0 ) capacitor c=0.0229235f //x=36.925 //y=1.7
c458 ( 159 0 ) capacitor c=0.0234359f //x=36.925 //y=1.39
c459 ( 158 0 ) capacitor c=0.0198759f //x=36.925 //y=1.045
c460 ( 157 0 ) capacitor c=0.0443175f //x=30.24 //y=1.44
c461 ( 156 0 ) capacitor c=0.0199703f //x=30.24 //y=1.095
c462 ( 153 0 ) capacitor c=0.0162526f //x=30.085 //y=1.595
c463 ( 151 0 ) capacitor c=0.0157807f //x=30.085 //y=0.94
c464 ( 146 0 ) capacitor c=0.0220935f //x=29.71 //y=1.75
c465 ( 145 0 ) capacitor c=0.0207489f //x=29.71 //y=1.44
c466 ( 144 0 ) capacitor c=0.0194091f //x=29.71 //y=1.095
c467 ( 140 0 ) capacitor c=0.110369f //x=37.46 //y=6.2
c468 ( 139 0 ) capacitor c=0.154619f //x=37.02 //y=6.2
c469 ( 138 0 ) capacitor c=0.159671f //x=29.9 //y=6.2
c470 ( 137 0 ) capacitor c=0.110208f //x=29.46 //y=6.2
c471 ( 131 0 ) capacitor c=8.13425e-19 //x=37.12 //y=4.88
c472 ( 122 0 ) capacitor c=7.85889e-19 //x=37.12 //y=2.26
c473 ( 105 0 ) capacitor c=0.0292634f //x=34.49 //y=5.56
c474 ( 97 0 ) capacitor c=0.029137f //x=33.61 //y=5.56
c475 ( 89 0 ) capacitor c=0.0278099f //x=32.73 //y=5.56
c476 ( 84 0 ) capacitor c=7.7417e-19 //x=29.72 //y=4.88
c477 ( 75 0 ) capacitor c=0.00101179f //x=29.72 //y=2.26
c478 ( 72 0 ) capacitor c=4.64216e-19 //x=37.12 //y=3.51
c479 ( 65 0 ) capacitor c=0.0234238f //x=35.435 //y=3.51
c480 ( 64 0 ) capacitor c=0.0189392f //x=36.96 //y=3.51
c481 ( 62 0 ) capacitor c=0.00228713f //x=32.53 //y=3.495
c482 ( 60 0 ) capacitor c=0.0164618f //x=31.93 //y=3.51
c483 ( 58 0 ) capacitor c=0.00615936f //x=30.68 //y=3.5
c484 ( 57 0 ) capacitor c=6.16648e-19 //x=29.88 //y=3.51
c485 ( 56 0 ) capacitor c=0.00320294f //x=30.08 //y=3.51
c486 ( 54 0 ) capacitor c=0.0268056f //x=37.122 //y=4.74
c487 ( 53 0 ) capacitor c=0.00611114f //x=37.12 //y=4.88
c488 ( 50 0 ) capacitor c=0.00463527f //x=37.12 //y=2.26
c489 ( 47 0 ) capacitor c=0.0161834f //x=37.12 //y=3.51
c490 ( 44 0 ) capacitor c=0.0170515f //x=35.27 //y=3.51
c491 ( 38 0 ) capacitor c=0.00112339f //x=34.49 //y=5.335
c492 ( 35 0 ) capacitor c=0.007585f //x=33.61 //y=5.335
c493 ( 32 0 ) capacitor c=0.0111234f //x=32.732 //y=5.335
c494 ( 30 0 ) capacitor c=0.0148558f //x=29.72 //y=3.51
c495 ( 23 0 ) capacitor c=0.013335f //x=37.12 //y=3.67
c496 ( 22 0 ) capacitor c=0.0249558f //x=37.12 //y=3.35
c497 ( 20 0 ) capacitor c=0.0423864f //x=35.27 //y=5.25
c498 ( 19 0 ) capacitor c=0.013011f //x=35.27 //y=3.67
c499 ( 18 0 ) capacitor c=0.0368112f //x=35.27 //y=3.35
c500 ( 16 0 ) capacitor c=0.00493487f //x=34.87 //y=1.845
c501 ( 15 0 ) capacitor c=0.012936f //x=35.185 //y=1.845
c502 ( 14 0 ) capacitor c=0.0136149f //x=34.785 //y=1.76
c503 ( 13 0 ) capacitor c=0.0112307f //x=34.785 //y=1.305
c504 ( 11 0 ) capacitor c=0.0238781f //x=35.185 //y=5.335
c505 ( 10 0 ) capacitor c=0.00906713f //x=34.49 //y=5.56
c506 ( 7 0 ) capacitor c=0.019596f //x=34.375 //y=5.335
c507 ( 5 0 ) capacitor c=0.0151774f //x=33.49 //y=5.335
c508 ( 4 0 ) capacitor c=0.0286235f //x=29.72 //y=4.75
c509 ( 3 0 ) capacitor c=0.0129098f //x=29.72 //y=3.67
c510 ( 2 0 ) capacitor c=0.0229166f //x=29.72 //y=3.35
c511 ( 1 0 ) capacitor c=0.00556102f //x=29.72 //y=2.375
r512 (  189 191 ) resistor r=20.6867 //w=0.233 //l=0.1 //layer=ply \
 //thickness=0.18 //x=37.02 //y=4.88 //x2=37.12 //y2=4.88
r513 (  176 177 ) resistor r=52.7279 //w=0.214 //l=0.165 //layer=ply \
 //thickness=0.18 //x=29.72 //y=2.26 //x2=29.72 //y2=2.095
r514 (  172 191 ) resistor r=70.3348 //w=0.233 //l=0.414367 //layer=ply \
 //thickness=0.18 //x=37.46 //y=5.045 //x2=37.12 //y2=4.88
r515 (  171 193 ) resistor r=45.1352 //w=0.168 //l=0.173853 //layer=ply \
 //thickness=0.18 //x=37.455 //y=1.39 //x2=37.415 //y2=1.545
r516 (  170 192 ) resistor r=45.1352 //w=0.168 //l=0.173853 //layer=ply \
 //thickness=0.18 //x=37.455 //y=1.045 //x2=37.415 //y2=0.89
r517 (  170 171 ) resistor r=176.904 //w=0.094 //l=0.345 //layer=ply \
 //thickness=0.18 //x=37.455 //y=1.045 //x2=37.455 //y2=1.39
r518 (  168 188 ) resistor r=10.701 //w=0.21 //l=0.115 //layer=ply \
 //thickness=0.18 //x=37.08 //y=1.545 //x2=36.965 //y2=1.545
r519 (  167 193 ) resistor r=5.52526 //w=0.168 //l=0.115 //layer=ply \
 //thickness=0.18 //x=37.3 //y=1.545 //x2=37.415 //y2=1.545
r520 (  166 187 ) resistor r=5.52526 //w=0.168 //l=0.115 //layer=ply \
 //thickness=0.18 //x=37.08 //y=0.89 //x2=36.965 //y2=0.89
r521 (  165 192 ) resistor r=5.52526 //w=0.168 //l=0.115 //layer=ply \
 //thickness=0.18 //x=37.3 //y=0.89 //x2=37.415 //y2=0.89
r522 (  165 166 ) resistor r=112.809 //w=0.094 //l=0.22 //layer=ply \
 //thickness=0.18 //x=37.3 //y=0.89 //x2=37.08 //y2=0.89
r523 (  162 189 ) resistor r=13.0941 //w=0.233 //l=0.165 //layer=ply \
 //thickness=0.18 //x=37.02 //y=5.045 //x2=37.02 //y2=4.88
r524 (  161 186 ) resistor r=34.8111 //w=0.27 //l=0.264953 //layer=ply \
 //thickness=0.18 //x=36.925 //y=2.095 //x2=37.12 //y2=2.26
r525 (  160 188 ) resistor r=39.5823 //w=0.21 //l=0.173853 //layer=ply \
 //thickness=0.18 //x=36.925 //y=1.7 //x2=36.965 //y2=1.545
r526 (  160 161 ) resistor r=202.543 //w=0.094 //l=0.395 //layer=ply \
 //thickness=0.18 //x=36.925 //y=1.7 //x2=36.925 //y2=2.095
r527 (  159 188 ) resistor r=39.5823 //w=0.21 //l=0.173853 //layer=ply \
 //thickness=0.18 //x=36.925 //y=1.39 //x2=36.965 //y2=1.545
r528 (  158 187 ) resistor r=45.1352 //w=0.168 //l=0.173853 //layer=ply \
 //thickness=0.18 //x=36.925 //y=1.045 //x2=36.965 //y2=0.89
r529 (  158 159 ) resistor r=176.904 //w=0.094 //l=0.345 //layer=ply \
 //thickness=0.18 //x=36.925 //y=1.045 //x2=36.925 //y2=1.39
r530 (  157 184 ) resistor r=45.1352 //w=0.168 //l=0.173853 //layer=ply \
 //thickness=0.18 //x=30.24 //y=1.44 //x2=30.2 //y2=1.595
r531 (  156 183 ) resistor r=45.1352 //w=0.168 //l=0.173853 //layer=ply \
 //thickness=0.18 //x=30.24 //y=1.095 //x2=30.2 //y2=0.94
r532 (  156 157 ) resistor r=176.904 //w=0.094 //l=0.345 //layer=ply \
 //thickness=0.18 //x=30.24 //y=1.095 //x2=30.24 //y2=1.44
r533 (  154 180 ) resistor r=10.701 //w=0.21 //l=0.115 //layer=ply \
 //thickness=0.18 //x=29.865 //y=1.595 //x2=29.75 //y2=1.595
r534 (  153 184 ) resistor r=5.52526 //w=0.168 //l=0.115 //layer=ply \
 //thickness=0.18 //x=30.085 //y=1.595 //x2=30.2 //y2=1.595
r535 (  152 179 ) resistor r=5.52526 //w=0.168 //l=0.115 //layer=ply \
 //thickness=0.18 //x=29.865 //y=0.94 //x2=29.75 //y2=0.94
r536 (  151 183 ) resistor r=5.52526 //w=0.168 //l=0.115 //layer=ply \
 //thickness=0.18 //x=30.085 //y=0.94 //x2=30.2 //y2=0.94
r537 (  151 152 ) resistor r=112.809 //w=0.094 //l=0.22 //layer=ply \
 //thickness=0.18 //x=30.085 //y=0.94 //x2=29.865 //y2=0.94
r538 (  148 182 ) resistor r=37.236 //w=0.233 //l=0.249199 //layer=ply \
 //thickness=0.18 //x=29.9 //y=5.045 //x2=29.72 //y2=4.88
r539 (  146 180 ) resistor r=39.5823 //w=0.21 //l=0.173853 //layer=ply \
 //thickness=0.18 //x=29.71 //y=1.75 //x2=29.75 //y2=1.595
r540 (  146 177 ) resistor r=176.904 //w=0.094 //l=0.345 //layer=ply \
 //thickness=0.18 //x=29.71 //y=1.75 //x2=29.71 //y2=2.095
r541 (  145 180 ) resistor r=39.5823 //w=0.21 //l=0.173853 //layer=ply \
 //thickness=0.18 //x=29.71 //y=1.44 //x2=29.75 //y2=1.595
r542 (  144 179 ) resistor r=45.1352 //w=0.168 //l=0.173853 //layer=ply \
 //thickness=0.18 //x=29.71 //y=1.095 //x2=29.75 //y2=0.94
r543 (  144 145 ) resistor r=176.904 //w=0.094 //l=0.345 //layer=ply \
 //thickness=0.18 //x=29.71 //y=1.095 //x2=29.71 //y2=1.44
r544 (  141 182 ) resistor r=53.7854 //w=0.233 //l=0.332415 //layer=ply \
 //thickness=0.18 //x=29.46 //y=5.045 //x2=29.72 //y2=4.88
r545 (  140 172 ) resistor r=592.245 //w=0.094 //l=1.155 //layer=ply \
 //thickness=0.18 //x=37.46 //y=6.2 //x2=37.46 //y2=5.045
r546 (  139 162 ) resistor r=592.245 //w=0.094 //l=1.155 //layer=ply \
 //thickness=0.18 //x=37.02 //y=6.2 //x2=37.02 //y2=5.045
r547 (  138 148 ) resistor r=592.245 //w=0.094 //l=1.155 //layer=ply \
 //thickness=0.18 //x=29.9 //y=6.2 //x2=29.9 //y2=5.045
r548 (  137 141 ) resistor r=592.245 //w=0.094 //l=1.155 //layer=ply \
 //thickness=0.18 //x=29.46 //y=6.2 //x2=29.46 //y2=5.045
r549 (  136 167 ) resistor r=56.4043 //w=0.094 //l=0.11 //layer=ply \
 //thickness=0.18 //x=37.19 //y=1.545 //x2=37.3 //y2=1.545
r550 (  136 168 ) resistor r=56.4043 //w=0.094 //l=0.11 //layer=ply \
 //thickness=0.18 //x=37.19 //y=1.545 //x2=37.08 //y2=1.545
r551 (  135 153 ) resistor r=56.4043 //w=0.094 //l=0.11 //layer=ply \
 //thickness=0.18 //x=29.975 //y=1.595 //x2=30.085 //y2=1.595
r552 (  135 154 ) resistor r=56.4043 //w=0.094 //l=0.11 //layer=ply \
 //thickness=0.18 //x=29.975 //y=1.595 //x2=29.865 //y2=1.595
r553 (  131 191 ) resistor r=152 //w=0.17 //l=0.17 //layer=licon //count=1 \
 //x=37.12 //y=4.88 //x2=37.12 //y2=4.88
r554 (  122 186 ) resistor r=152 //w=0.17 //l=0.17 //layer=licon //count=1 \
 //x=37.12 //y=2.26 //x2=37.12 //y2=2.26
r555 (  105 198 ) resistor r=23.615 //w=0.187 //l=0.345 //layer=li \
 //thickness=0.1 //x=34.49 //y=5.56 //x2=34.49 //y2=5.905
r556 (  97 197 ) resistor r=23.615 //w=0.187 //l=0.345 //layer=li \
 //thickness=0.1 //x=33.61 //y=5.56 //x2=33.61 //y2=5.905
r557 (  89 196 ) resistor r=23.615 //w=0.187 //l=0.345 //layer=li \
 //thickness=0.1 //x=32.73 //y=5.56 //x2=32.73 //y2=5.905
r558 (  84 182 ) resistor r=152 //w=0.17 //l=0.17 //layer=licon //count=1 \
 //x=29.72 //y=4.88 //x2=29.72 //y2=4.88
r559 (  75 176 ) resistor r=152 //w=0.17 //l=0.17 //layer=licon //count=1 \
 //x=29.72 //y=2.26 //x2=29.72 //y2=2.26
r560 (  65 70 ) resistor r=0.108234 //w=0.187 //l=0.16 //layer=m2 \
 //thickness=0.36 //x=35.435 //y=3.51 //x2=35.275 //y2=3.51
r561 (  64 72 ) resistor r=0.10734 //w=0.281 //l=0.16 //layer=m2 \
 //thickness=0.36 //x=36.96 //y=3.51 //x2=37.12 //y2=3.51
r562 (  64 65 ) resistor r=1.45515 //w=0.131 //l=1.525 //layer=m2 \
 //thickness=0.36 //x=36.96 //y=3.51 //x2=35.435 //y2=3.51
r563 (  62 70 ) resistor r=1.83617 //w=0.187 //l=2.75249 //layer=m2 \
 //thickness=0.36 //x=32.53 //y=3.495 //x2=35.275 //y2=3.51
r564 (  62 63 ) resistor r=0.410305 //w=0.131 //l=0.43 //layer=m2 \
 //thickness=0.36 //x=32.53 //y=3.495 //x2=32.1 //y2=3.495
r565 (  60 63 ) resistor r=0.125 //w=0.17 //l=0.177341 //layer=m2 \
 //thickness=0.36 //x=31.93 //y=3.51 //x2=32.1 //y2=3.495
r566 (  60 61 ) resistor r=0.949427 //w=0.131 //l=0.995 //layer=m2 \
 //thickness=0.36 //x=31.93 //y=3.51 //x2=30.935 //y2=3.51
r567 (  58 61 ) resistor r=0.1875 //w=0.17 //l=0.259952 //layer=m2 \
 //thickness=0.36 //x=30.68 //y=3.5 //x2=30.935 //y2=3.51
r568 (  58 59 ) resistor r=0.410305 //w=0.131 //l=0.43 //layer=m2 \
 //thickness=0.36 //x=30.68 //y=3.5 //x2=30.25 //y2=3.5
r569 (  57 67 ) resistor r=0.10734 //w=0.281 //l=0.16 //layer=m2 \
 //thickness=0.36 //x=29.88 //y=3.51 //x2=29.72 //y2=3.51
r570 (  56 59 ) resistor r=0.125 //w=0.17 //l=0.174929 //layer=m2 \
 //thickness=0.36 //x=30.08 //y=3.51 //x2=30.25 //y2=3.5
r571 (  56 57 ) resistor r=0.19084 //w=0.131 //l=0.2 //layer=m2 \
 //thickness=0.36 //x=30.08 //y=3.51 //x2=29.88 //y2=3.51
r572 (  53 131 ) resistor r=9.3 //w=0.17 //l=0.17 //layer=mcon //count=1 \
 //x=37.12 //y=4.88 //x2=37.12 //y2=4.88
r573 (  53 54 ) resistor r=0.103207 //w=0.196 //l=0.14 //layer=m1 \
 //thickness=0.36 //x=37.122 //y=4.88 //x2=37.122 //y2=4.74
r574 (  50 122 ) resistor r=9.3 //w=0.17 //l=0.17 //layer=mcon //count=1 \
 //x=37.12 //y=2.26 //x2=37.12 //y2=2.26
r575 (  47 72 ) resistor r=4.5 //w=0.15 //l=0.15 //layer=via1 //count=1 \
 //x=37.12 //y=3.51 //x2=37.12 //y2=3.51
r576 (  44 70 ) resistor r=4.5 //w=0.15 //l=0.15 //layer=via1 //count=1 \
 //x=35.275 //y=3.51 //x2=35.275 //y2=3.51
r577 (  42 194 ) resistor r=9.3 //w=0.17 //l=0.17 //layer=mcon //count=1 \
 //x=34.785 //y=1.19 //x2=34.785 //y2=1.19
r578 (  40 105 ) resistor r=9.3 //w=0.17 //l=0.17 //layer=mcon //count=1 \
 //x=34.49 //y=5.56 //x2=34.49 //y2=5.56
r579 (  37 97 ) resistor r=9.3 //w=0.17 //l=0.17 //layer=mcon //count=1 \
 //x=33.61 //y=5.56 //x2=33.61 //y2=5.56
r580 (  35 37 ) resistor r=0.121228 //w=0.232 //l=0.225 //layer=m1 \
 //thickness=0.36 //x=33.61 //y=5.335 //x2=33.61 //y2=5.56
r581 (  34 89 ) resistor r=9.3 //w=0.17 //l=0.17 //layer=mcon //count=1 \
 //x=32.73 //y=5.56 //x2=32.73 //y2=5.56
r582 (  32 34 ) resistor r=0.129608 //w=0.217 //l=0.225 //layer=m1 \
 //thickness=0.36 //x=32.732 //y=5.335 //x2=32.732 //y2=5.56
r583 (  30 67 ) resistor r=4.5 //w=0.15 //l=0.15 //layer=via1 //count=1 \
 //x=29.72 //y=3.51 //x2=29.72 //y2=3.51
r584 (  28 84 ) resistor r=9.3 //w=0.17 //l=0.17 //layer=mcon //count=1 \
 //x=29.72 //y=4.88 //x2=29.72 //y2=4.88
r585 (  26 75 ) resistor r=9.3 //w=0.17 //l=0.17 //layer=mcon //count=1 \
 //x=29.72 //y=2.26 //x2=29.72 //y2=2.26
r586 (  23 47 ) resistor r=0.0911593 //w=0.376 //l=0.184608 //layer=m1 \
 //thickness=0.36 //x=37.12 //y=3.67 //x2=37.067 //y2=3.51
r587 (  23 54 ) resistor r=1.02099 //w=0.131 //l=1.07 //layer=m1 \
 //thickness=0.36 //x=37.12 //y=3.67 //x2=37.12 //y2=4.74
r588 (  22 47 ) resistor r=0.0911593 //w=0.376 //l=0.184608 //layer=m1 \
 //thickness=0.36 //x=37.12 //y=3.35 //x2=37.067 //y2=3.51
r589 (  21 50 ) resistor r=0.0933015 //w=0.201 //l=0.125 //layer=m1 \
 //thickness=0.36 //x=37.12 //y=2.385 //x2=37.12 //y2=2.26
r590 (  21 22 ) resistor r=0.920802 //w=0.131 //l=0.965 //layer=m1 \
 //thickness=0.36 //x=37.12 //y=2.385 //x2=37.12 //y2=3.35
r591 (  19 44 ) resistor r=0.0910802 //w=0.374 //l=0.185472 //layer=m1 \
 //thickness=0.36 //x=35.27 //y=3.67 //x2=35.325 //y2=3.51
r592 (  19 20 ) resistor r=1.50763 //w=0.131 //l=1.58 //layer=m1 \
 //thickness=0.36 //x=35.27 //y=3.67 //x2=35.27 //y2=5.25
r593 (  18 44 ) resistor r=0.0910802 //w=0.374 //l=0.185472 //layer=m1 \
 //thickness=0.36 //x=35.27 //y=3.35 //x2=35.325 //y2=3.51
r594 (  17 18 ) resistor r=1.35496 //w=0.131 //l=1.42 //layer=m1 \
 //thickness=0.36 //x=35.27 //y=1.93 //x2=35.27 //y2=3.35
r595 (  15 17 ) resistor r=0.0698411 //w=0.17 //l=0.120208 //layer=m1 \
 //thickness=0.36 //x=35.185 //y=1.845 //x2=35.27 //y2=1.93
r596 (  15 16 ) resistor r=0.300573 //w=0.131 //l=0.315 //layer=m1 \
 //thickness=0.36 //x=35.185 //y=1.845 //x2=34.87 //y2=1.845
r597 (  14 16 ) resistor r=0.0698411 //w=0.17 //l=0.120208 //layer=m1 \
 //thickness=0.36 //x=34.785 //y=1.76 //x2=34.87 //y2=1.845
r598 (  13 42 ) resistor r=0.0717383 //w=0.224 //l=0.115 //layer=m1 \
 //thickness=0.36 //x=34.785 //y=1.305 //x2=34.785 //y2=1.19
r599 (  13 14 ) resistor r=0.43416 //w=0.131 //l=0.455 //layer=m1 \
 //thickness=0.36 //x=34.785 //y=1.305 //x2=34.785 //y2=1.76
r600 (  12 38 ) resistor r=0.0675342 //w=0.23 //l=0.115 //layer=m1 \
 //thickness=0.36 //x=34.605 //y=5.335 //x2=34.49 //y2=5.335
r601 (  11 20 ) resistor r=0.0698411 //w=0.17 //l=0.120208 //layer=m1 \
 //thickness=0.36 //x=35.185 //y=5.335 //x2=35.27 //y2=5.25
r602 (  11 12 ) resistor r=0.553435 //w=0.131 //l=0.58 //layer=m1 \
 //thickness=0.36 //x=35.185 //y=5.335 //x2=34.605 //y2=5.335
r603 (  10 40 ) resistor r=0.00118313 //w=0.23 //layer=m1 //thickness=0.36 \
 //x=34.49 //y=5.56 //x2=34.49 //y2=5.56
r604 (  9 38 ) resistor r=0.002872 //w=0.34 //l=0.085 //layer=m1 \
 //thickness=0.36 //x=34.49 //y=5.42 //x2=34.49 //y2=5.335
r605 (  9 10 ) resistor r=0.091623 //w=0.191 //l=0.14 //layer=m1 \
 //thickness=0.36 //x=34.49 //y=5.42 //x2=34.49 //y2=5.56
r606 (  8 35 ) resistor r=0.0262263 //w=0.232 //l=0.12 //layer=m1 \
 //thickness=0.36 //x=33.73 //y=5.335 //x2=33.61 //y2=5.335
r607 (  7 38 ) resistor r=0.0675342 //w=0.23 //l=0.115 //layer=m1 \
 //thickness=0.36 //x=34.375 //y=5.335 //x2=34.49 //y2=5.335
r608 (  7 8 ) resistor r=0.615458 //w=0.131 //l=0.645 //layer=m1 \
 //thickness=0.36 //x=34.375 //y=5.335 //x2=33.73 //y2=5.335
r609 (  6 32 ) resistor r=0.0222262 //w=0.217 //l=0.118 //layer=m1 \
 //thickness=0.36 //x=32.85 //y=5.335 //x2=32.732 //y2=5.335
r610 (  5 35 ) resistor r=0.0262263 //w=0.232 //l=0.12 //layer=m1 \
 //thickness=0.36 //x=33.49 //y=5.335 //x2=33.61 //y2=5.335
r611 (  5 6 ) resistor r=0.610687 //w=0.131 //l=0.64 //layer=m1 \
 //thickness=0.36 //x=33.49 //y=5.335 //x2=32.85 //y2=5.335
r612 (  4 28 ) resistor r=0.0801089 //w=0.224 //l=0.13 //layer=m1 \
 //thickness=0.36 //x=29.72 //y=4.75 //x2=29.72 //y2=4.88
r613 (  3 30 ) resistor r=0.0911593 //w=0.376 //l=0.184174 //layer=m1 \
 //thickness=0.36 //x=29.72 //y=3.67 //x2=29.772 //y2=3.51
r614 (  3 4 ) resistor r=1.03053 //w=0.131 //l=1.08 //layer=m1 \
 //thickness=0.36 //x=29.72 //y=3.67 //x2=29.72 //y2=4.75
r615 (  2 30 ) resistor r=0.0911593 //w=0.376 //l=0.184174 //layer=m1 \
 //thickness=0.36 //x=29.72 //y=3.35 //x2=29.772 //y2=3.51
r616 (  1 26 ) resistor r=0.0719237 //w=0.222 //l=0.115 //layer=m1 \
 //thickness=0.36 //x=29.72 //y=2.375 //x2=29.72 //y2=2.26
r617 (  1 2 ) resistor r=0.930344 //w=0.131 //l=0.975 //layer=m1 \
 //thickness=0.36 //x=29.72 //y=2.375 //x2=29.72 //y2=3.35
ends PM_TMRDFFRNQNX1\%noxref_6

subckt PM_TMRDFFRNQNX1\%noxref_7 ( 3 8 9 11 12 14 15 16 17 18 19 20 23 24 27 \
 29 32 36 48 50 51 54 62 79 88 92 93 94 95 96 97 98 99 101 107 108 109 110 122 \
 124 125 )
c282 ( 122 0 ) capacitor c=0.00878249f //x=37.97 //y=1.085
c283 ( 110 0 ) capacitor c=0.0612936f //x=40.725 //y=4.97
c284 ( 109 0 ) capacitor c=0.0376642f //x=41.015 //y=4.97
c285 ( 108 0 ) capacitor c=0.0346489f //x=40.68 //y=1.4
c286 ( 107 0 ) capacitor c=0.018692f //x=40.68 //y=1.055
c287 ( 101 0 ) capacitor c=0.0137077f //x=40.525 //y=1.555
c288 ( 99 0 ) capacitor c=0.0158585f //x=40.525 //y=0.9
c289 ( 98 0 ) capacitor c=0.101012f //x=40.15 //y=2.095
c290 ( 97 0 ) capacitor c=0.0229444f //x=40.15 //y=1.71
c291 ( 96 0 ) capacitor c=0.0234359f //x=40.15 //y=1.4
c292 ( 95 0 ) capacitor c=0.019815f //x=40.15 //y=1.055
c293 ( 94 0 ) capacitor c=0.110208f //x=41.09 //y=6.2
c294 ( 93 0 ) capacitor c=0.158957f //x=40.65 //y=6.2
c295 ( 88 0 ) capacitor c=0.0014751f //x=40.45 //y=4.88
c296 ( 79 0 ) capacitor c=0.0012618f //x=40.45 //y=2.26
c297 ( 62 0 ) capacitor c=0.0322017f //x=38.12 //y=5.56
c298 ( 54 0 ) capacitor c=0.0291938f //x=37.24 //y=5.56
c299 ( 51 0 ) capacitor c=0.0193747f //x=40.295 //y=3.515
c300 ( 50 0 ) capacitor c=4.92224e-19 //x=40.455 //y=3.515
c301 ( 48 0 ) capacitor c=6.92089e-19 //x=38.76 //y=3.515
c302 ( 36 0 ) capacitor c=0.0170693f //x=40.45 //y=3.51
c303 ( 32 0 ) capacitor c=0.016938f //x=38.6 //y=3.51
c304 ( 29 0 ) capacitor c=0.0112415f //x=38.16 //y=1.18
c305 ( 27 0 ) capacitor c=5.78613e-19 //x=38.12 //y=5.56
c306 ( 24 0 ) capacitor c=0.010659f //x=38.12 //y=5.38
c307 ( 23 0 ) capacitor c=0.00926978f //x=37.24 //y=5.56
c308 ( 20 0 ) capacitor c=0.0382053f //x=40.45 //y=4.755
c309 ( 19 0 ) capacitor c=0.0145929f //x=40.45 //y=3.675
c310 ( 18 0 ) capacitor c=0.0285052f //x=40.45 //y=3.355
c311 ( 17 0 ) capacitor c=0.00495287f //x=40.45 //y=2.375
c312 ( 16 0 ) capacitor c=0.0418029f //x=38.6 //y=5.295
c313 ( 15 0 ) capacitor c=0.0134337f //x=38.6 //y=3.675
c314 ( 14 0 ) capacitor c=0.038519f //x=38.6 //y=3.355
c315 ( 12 0 ) capacitor c=0.00466468f //x=38.245 //y=1.835
c316 ( 11 0 ) capacitor c=0.0120653f //x=38.515 //y=1.835
c317 ( 9 0 ) capacitor c=0.0116495f //x=38.515 //y=5.38
c318 ( 8 0 ) capacitor c=0.0134844f //x=38.16 //y=1.75
c319 ( 3 0 ) capacitor c=0.013452f //x=38.005 //y=5.38
r320 (  109 111 ) resistor r=26.9307 //w=0.15 //l=0.106066 //layer=ply \
 //thickness=0.18 //x=41.015 //y=4.97 //x2=41.09 //y2=5.045
r321 (  109 110 ) resistor r=148.702 //w=0.094 //l=0.29 //layer=ply \
 //thickness=0.18 //x=41.015 //y=4.97 //x2=40.725 //y2=4.97
r322 (  108 121 ) resistor r=45.1352 //w=0.168 //l=0.173853 //layer=ply \
 //thickness=0.18 //x=40.68 //y=1.4 //x2=40.64 //y2=1.555
r323 (  107 120 ) resistor r=45.1352 //w=0.168 //l=0.173853 //layer=ply \
 //thickness=0.18 //x=40.68 //y=1.055 //x2=40.64 //y2=0.9
r324 (  107 108 ) resistor r=176.904 //w=0.094 //l=0.345 //layer=ply \
 //thickness=0.18 //x=40.68 //y=1.055 //x2=40.68 //y2=1.4
r325 (  104 110 ) resistor r=22.7971 //w=0.269 //l=0.106066 //layer=ply \
 //thickness=0.18 //x=40.65 //y=5.045 //x2=40.725 //y2=4.97
r326 (  104 119 ) resistor r=35.8364 //w=0.269 //l=0.270185 //layer=ply \
 //thickness=0.18 //x=40.65 //y=5.045 //x2=40.45 //y2=4.88
r327 (  102 115 ) resistor r=10.701 //w=0.21 //l=0.115 //layer=ply \
 //thickness=0.18 //x=40.305 //y=1.555 //x2=40.19 //y2=1.555
r328 (  101 121 ) resistor r=5.52526 //w=0.168 //l=0.115 //layer=ply \
 //thickness=0.18 //x=40.525 //y=1.555 //x2=40.64 //y2=1.555
r329 (  100 114 ) resistor r=5.52526 //w=0.168 //l=0.115 //layer=ply \
 //thickness=0.18 //x=40.305 //y=0.9 //x2=40.19 //y2=0.9
r330 (  99 120 ) resistor r=5.52526 //w=0.168 //l=0.115 //layer=ply \
 //thickness=0.18 //x=40.525 //y=0.9 //x2=40.64 //y2=0.9
r331 (  99 100 ) resistor r=112.809 //w=0.094 //l=0.22 //layer=ply \
 //thickness=0.18 //x=40.525 //y=0.9 //x2=40.305 //y2=0.9
r332 (  98 117 ) resistor r=58.7805 //w=0.246 //l=0.373497 //layer=ply \
 //thickness=0.18 //x=40.15 //y=2.095 //x2=40.45 //y2=2.26
r333 (  97 115 ) resistor r=39.5823 //w=0.21 //l=0.173853 //layer=ply \
 //thickness=0.18 //x=40.15 //y=1.71 //x2=40.19 //y2=1.555
r334 (  97 98 ) resistor r=197.415 //w=0.094 //l=0.385 //layer=ply \
 //thickness=0.18 //x=40.15 //y=1.71 //x2=40.15 //y2=2.095
r335 (  96 115 ) resistor r=39.5823 //w=0.21 //l=0.173853 //layer=ply \
 //thickness=0.18 //x=40.15 //y=1.4 //x2=40.19 //y2=1.555
r336 (  95 114 ) resistor r=45.1352 //w=0.168 //l=0.173853 //layer=ply \
 //thickness=0.18 //x=40.15 //y=1.055 //x2=40.19 //y2=0.9
r337 (  95 96 ) resistor r=176.904 //w=0.094 //l=0.345 //layer=ply \
 //thickness=0.18 //x=40.15 //y=1.055 //x2=40.15 //y2=1.4
r338 (  94 111 ) resistor r=592.245 //w=0.094 //l=1.155 //layer=ply \
 //thickness=0.18 //x=41.09 //y=6.2 //x2=41.09 //y2=5.045
r339 (  93 104 ) resistor r=592.245 //w=0.094 //l=1.155 //layer=ply \
 //thickness=0.18 //x=40.65 //y=6.2 //x2=40.65 //y2=5.045
r340 (  92 101 ) resistor r=56.4043 //w=0.094 //l=0.11 //layer=ply \
 //thickness=0.18 //x=40.415 //y=1.555 //x2=40.525 //y2=1.555
r341 (  92 102 ) resistor r=56.4043 //w=0.094 //l=0.11 //layer=ply \
 //thickness=0.18 //x=40.415 //y=1.555 //x2=40.305 //y2=1.555
r342 (  88 119 ) resistor r=152 //w=0.17 //l=0.17 //layer=licon //count=1 \
 //x=40.45 //y=4.88 //x2=40.45 //y2=4.88
r343 (  79 117 ) resistor r=152 //w=0.17 //l=0.17 //layer=licon //count=1 \
 //x=40.45 //y=2.26 //x2=40.45 //y2=2.26
r344 (  62 125 ) resistor r=23.615 //w=0.187 //l=0.345 //layer=li \
 //thickness=0.1 //x=38.12 //y=5.56 //x2=38.12 //y2=5.905
r345 (  54 124 ) resistor r=23.615 //w=0.187 //l=0.345 //layer=li \
 //thickness=0.1 //x=37.24 //y=5.56 //x2=37.24 //y2=5.905
r346 (  50 51 ) resistor r=0.10734 //w=0.281 //l=0.16 //layer=m2 \
 //thickness=0.36 //x=40.455 //y=3.515 //x2=40.295 //y2=3.515
r347 (  48 51 ) resistor r=1.46469 //w=0.131 //l=1.535 //layer=m2 \
 //thickness=0.36 //x=38.76 //y=3.51 //x2=40.295 //y2=3.51
r348 (  46 48 ) resistor r=0.10734 //w=0.281 //l=0.16 //layer=m2 \
 //thickness=0.36 //x=38.6 //y=3.515 //x2=38.76 //y2=3.515
r349 (  42 88 ) resistor r=9.3 //w=0.17 //l=0.17 //layer=mcon //count=1 \
 //x=40.45 //y=4.88 //x2=40.45 //y2=4.88
r350 (  40 79 ) resistor r=9.3 //w=0.17 //l=0.17 //layer=mcon //count=1 \
 //x=40.45 //y=2.26 //x2=40.45 //y2=2.26
r351 (  38 50 ) resistor r=4.5 //w=0.15 //l=0.15 //layer=via1 //count=1 \
 //x=40.455 //y=3.515 //x2=40.455 //y2=3.515
r352 (  36 38 ) resistor r=0.00164908 //w=0.379 //l=0.005 //layer=m1 \
 //thickness=0.36 //x=40.4 //y=3.51 //x2=40.4 //y2=3.515
r353 (  34 46 ) resistor r=4.5 //w=0.15 //l=0.15 //layer=via1 //count=1 \
 //x=38.6 //y=3.515 //x2=38.6 //y2=3.515
r354 (  32 34 ) resistor r=0.00166223 //w=0.376 //l=0.005 //layer=m1 \
 //thickness=0.36 //x=38.652 //y=3.51 //x2=38.652 //y2=3.515
r355 (  29 122 ) resistor r=9.3 //w=0.17 //l=0.17 //layer=mcon //count=1 \
 //x=38.16 //y=1.18 //x2=38.16 //y2=1.18
r356 (  27 62 ) resistor r=9.3 //w=0.17 //l=0.17 //layer=mcon //count=1 \
 //x=38.12 //y=5.56 //x2=38.12 //y2=5.56
r357 (  24 27 ) resistor r=0.117801 //w=0.191 //l=0.18 //layer=m1 \
 //thickness=0.36 //x=38.12 //y=5.38 //x2=38.12 //y2=5.56
r358 (  23 54 ) resistor r=9.3 //w=0.17 //l=0.17 //layer=mcon //count=1 \
 //x=37.24 //y=5.56 //x2=37.24 //y2=5.56
r359 (  21 23 ) resistor r=0.10274 //w=0.219 //l=0.18 //layer=m1 \
 //thickness=0.36 //x=37.24 //y=5.38 //x2=37.24 //y2=5.56
r360 (  20 42 ) resistor r=0.0760407 //w=0.238 //l=0.125 //layer=m1 \
 //thickness=0.36 //x=40.45 //y=4.755 //x2=40.45 //y2=4.88
r361 (  19 38 ) resistor r=0.0912814 //w=0.379 //l=0.183303 //layer=m1 \
 //thickness=0.36 //x=40.45 //y=3.675 //x2=40.4 //y2=3.515
r362 (  19 20 ) resistor r=1.03053 //w=0.131 //l=1.08 //layer=m1 \
 //thickness=0.36 //x=40.45 //y=3.675 //x2=40.45 //y2=4.755
r363 (  18 36 ) resistor r=0.0896323 //w=0.379 //l=0.178255 //layer=m1 \
 //thickness=0.36 //x=40.45 //y=3.355 //x2=40.4 //y2=3.51
r364 (  17 40 ) resistor r=0.0719237 //w=0.222 //l=0.115 //layer=m1 \
 //thickness=0.36 //x=40.45 //y=2.375 //x2=40.45 //y2=2.26
r365 (  17 18 ) resistor r=0.935115 //w=0.131 //l=0.98 //layer=m1 \
 //thickness=0.36 //x=40.45 //y=2.375 //x2=40.45 //y2=3.355
r366 (  15 34 ) resistor r=0.0911593 //w=0.376 //l=0.184174 //layer=m1 \
 //thickness=0.36 //x=38.6 //y=3.675 //x2=38.652 //y2=3.515
r367 (  15 16 ) resistor r=1.5458 //w=0.131 //l=1.62 //layer=m1 \
 //thickness=0.36 //x=38.6 //y=3.675 //x2=38.6 //y2=5.295
r368 (  14 32 ) resistor r=0.0894971 //w=0.376 //l=0.179123 //layer=m1 \
 //thickness=0.36 //x=38.6 //y=3.355 //x2=38.652 //y2=3.51
r369 (  13 14 ) resistor r=1.36927 //w=0.131 //l=1.435 //layer=m1 \
 //thickness=0.36 //x=38.6 //y=1.92 //x2=38.6 //y2=3.355
r370 (  11 13 ) resistor r=0.0698411 //w=0.17 //l=0.120208 //layer=m1 \
 //thickness=0.36 //x=38.515 //y=1.835 //x2=38.6 //y2=1.92
r371 (  11 12 ) resistor r=0.257634 //w=0.131 //l=0.27 //layer=m1 \
 //thickness=0.36 //x=38.515 //y=1.835 //x2=38.245 //y2=1.835
r372 (  10 24 ) resistor r=0.0257089 //w=0.23 //l=0.115 //layer=m1 \
 //thickness=0.36 //x=38.235 //y=5.38 //x2=38.12 //y2=5.38
r373 (  9 16 ) resistor r=0.0698411 //w=0.17 //l=0.120208 //layer=m1 \
 //thickness=0.36 //x=38.515 //y=5.38 //x2=38.6 //y2=5.295
r374 (  9 10 ) resistor r=0.267176 //w=0.131 //l=0.28 //layer=m1 \
 //thickness=0.36 //x=38.515 //y=5.38 //x2=38.235 //y2=5.38
r375 (  8 12 ) resistor r=0.0698411 //w=0.17 //l=0.120208 //layer=m1 \
 //thickness=0.36 //x=38.16 //y=1.75 //x2=38.245 //y2=1.835
r376 (  7 29 ) resistor r=0.0913624 //w=0.191 //l=0.12 //layer=m1 \
 //thickness=0.36 //x=38.16 //y=1.3 //x2=38.16 //y2=1.18
r377 (  7 8 ) resistor r=0.429389 //w=0.131 //l=0.45 //layer=m1 \
 //thickness=0.36 //x=38.16 //y=1.3 //x2=38.16 //y2=1.75
r378 (  4 21 ) resistor r=0.0227762 //w=0.219 //l=0.115 //layer=m1 \
 //thickness=0.36 //x=37.355 //y=5.38 //x2=37.24 //y2=5.38
r379 (  3 24 ) resistor r=0.0257089 //w=0.23 //l=0.115 //layer=m1 \
 //thickness=0.36 //x=38.005 //y=5.38 //x2=38.12 //y2=5.38
r380 (  3 4 ) resistor r=0.620229 //w=0.131 //l=0.65 //layer=m1 \
 //thickness=0.36 //x=38.005 //y=5.38 //x2=37.355 //y2=5.38
ends PM_TMRDFFRNQNX1\%noxref_7

subckt PM_TMRDFFRNQNX1\%noxref_8 ( 1 3 6 7 9 10 11 12 14 15 16 17 18 19 20 21 \
 22 23 24 25 28 31 37 45 48 54 56 57 58 60 62 64 66 68 70 72 77 83 91 99 116 \
 125 130 139 143 144 145 146 147 148 149 150 151 152 153 155 161 162 163 164 \
 168 169 170 171 172 174 180 181 182 183 203 205 206 207 )
c489 ( 203 0 ) capacitor c=0.00885916f //x=29.785 //y=1.095
c490 ( 183 0 ) capacitor c=0.0583399f //x=45.535 //y=4.97
c491 ( 182 0 ) capacitor c=0.0376642f //x=45.825 //y=4.97
c492 ( 181 0 ) capacitor c=0.0346489f //x=45.49 //y=1.4
c493 ( 180 0 ) capacitor c=0.018692f //x=45.49 //y=1.055
c494 ( 174 0 ) capacitor c=0.0137077f //x=45.335 //y=1.555
c495 ( 172 0 ) capacitor c=0.0158585f //x=45.335 //y=0.9
c496 ( 171 0 ) capacitor c=0.103534f //x=44.96 //y=2.095
c497 ( 170 0 ) capacitor c=0.0229444f //x=44.96 //y=1.71
c498 ( 169 0 ) capacitor c=0.0234359f //x=44.96 //y=1.4
c499 ( 168 0 ) capacitor c=0.019815f //x=44.96 //y=1.055
c500 ( 164 0 ) capacitor c=0.0564069f //x=32.585 //y=4.97
c501 ( 163 0 ) capacitor c=0.0376642f //x=32.875 //y=4.97
c502 ( 162 0 ) capacitor c=0.0346489f //x=32.54 //y=1.4
c503 ( 161 0 ) capacitor c=0.018692f //x=32.54 //y=1.055
c504 ( 155 0 ) capacitor c=0.0137077f //x=32.385 //y=1.555
c505 ( 153 0 ) capacitor c=0.0158585f //x=32.385 //y=0.9
c506 ( 152 0 ) capacitor c=0.103534f //x=32.01 //y=2.095
c507 ( 151 0 ) capacitor c=0.0229444f //x=32.01 //y=1.71
c508 ( 150 0 ) capacitor c=0.0234359f //x=32.01 //y=1.4
c509 ( 149 0 ) capacitor c=0.019815f //x=32.01 //y=1.055
c510 ( 148 0 ) capacitor c=0.110208f //x=45.9 //y=6.2
c511 ( 147 0 ) capacitor c=0.158957f //x=45.46 //y=6.2
c512 ( 146 0 ) capacitor c=0.110208f //x=32.95 //y=6.2
c513 ( 145 0 ) capacitor c=0.158957f //x=32.51 //y=6.2
c514 ( 139 0 ) capacitor c=0.0014751f //x=45.26 //y=4.88
c515 ( 130 0 ) capacitor c=0.0012618f //x=45.26 //y=2.26
c516 ( 125 0 ) capacitor c=0.0014751f //x=32.31 //y=4.88
c517 ( 116 0 ) capacitor c=0.0012618f //x=32.31 //y=2.26
c518 ( 99 0 ) capacitor c=0.0293561f //x=29.68 //y=5.56
c519 ( 91 0 ) capacitor c=0.029137f //x=28.8 //y=5.56
c520 ( 83 0 ) capacitor c=0.0277605f //x=27.92 //y=5.56
c521 ( 77 0 ) capacitor c=7.36606e-19 //x=30.625 //y=3.885
c522 ( 72 0 ) capacitor c=0.0285101f //x=43.63 //y=3.87
c523 ( 70 0 ) capacitor c=0.0261863f //x=43.03 //y=3.88
c524 ( 68 0 ) capacitor c=0.00448716f //x=40.67 //y=3.9
c525 ( 66 0 ) capacitor c=0.018225f //x=40.07 //y=3.88
c526 ( 64 0 ) capacitor c=0.00418082f //x=38.815 //y=3.9
c527 ( 62 0 ) capacitor c=0.00773363f //x=38.08 //y=3.865
c528 ( 60 0 ) capacitor c=0.00553701f //x=37.335 //y=3.895
c529 ( 58 0 ) capacitor c=0.0174986f //x=36.735 //y=3.88
c530 ( 57 0 ) capacitor c=0.0244234f //x=35.145 //y=3.895
c531 ( 56 0 ) capacitor c=0.00423161f //x=35.49 //y=3.895
c532 ( 54 0 ) capacitor c=0.0209003f //x=32.155 //y=3.88
c533 ( 48 0 ) capacitor c=0.0169558f //x=45.25 //y=3.88
c534 ( 45 0 ) capacitor c=0.0167936f //x=32.31 //y=3.88
c535 ( 37 0 ) capacitor c=0.0172565f //x=30.46 //y=3.88
c536 ( 31 0 ) capacitor c=9.55882e-19 //x=29.68 //y=5.335
c537 ( 28 0 ) capacitor c=0.00740623f //x=28.8 //y=5.335
c538 ( 25 0 ) capacitor c=0.0112819f //x=27.922 //y=5.335
c539 ( 24 0 ) capacitor c=0.0253859f //x=45.26 //y=4.755
c540 ( 23 0 ) capacitor c=0.0136301f //x=45.26 //y=4.04
c541 ( 22 0 ) capacitor c=0.041897f //x=45.26 //y=3.72
c542 ( 21 0 ) capacitor c=0.00489532f //x=45.26 //y=2.375
c543 ( 20 0 ) capacitor c=0.0266349f //x=32.31 //y=4.755
c544 ( 19 0 ) capacitor c=0.0127018f //x=32.31 //y=4.04
c545 ( 18 0 ) capacitor c=0.0384497f //x=32.31 //y=3.72
c546 ( 17 0 ) capacitor c=0.00495287f //x=32.31 //y=2.375
c547 ( 16 0 ) capacitor c=0.0325919f //x=30.46 //y=5.25
c548 ( 15 0 ) capacitor c=0.0131885f //x=30.46 //y=4.045
c549 ( 14 0 ) capacitor c=0.0493256f //x=30.46 //y=3.725
c550 ( 12 0 ) capacitor c=0.0047266f //x=30.06 //y=1.845
c551 ( 11 0 ) capacitor c=0.0133232f //x=30.375 //y=1.845
c552 ( 10 0 ) capacitor c=0.0167333f //x=29.975 //y=1.76
c553 ( 9 0 ) capacitor c=0.0110969f //x=29.975 //y=1.305
c554 ( 7 0 ) capacitor c=0.0229543f //x=30.375 //y=5.335
c555 ( 6 0 ) capacitor c=0.00933983f //x=29.68 //y=5.56
c556 ( 3 0 ) capacitor c=0.019444f //x=29.565 //y=5.335
c557 ( 1 0 ) capacitor c=0.0146659f //x=28.68 //y=5.335
r558 (  182 184 ) resistor r=26.9307 //w=0.15 //l=0.106066 //layer=ply \
 //thickness=0.18 //x=45.825 //y=4.97 //x2=45.9 //y2=5.045
r559 (  182 183 ) resistor r=148.702 //w=0.094 //l=0.29 //layer=ply \
 //thickness=0.18 //x=45.825 //y=4.97 //x2=45.535 //y2=4.97
r560 (  181 202 ) resistor r=45.1352 //w=0.168 //l=0.173853 //layer=ply \
 //thickness=0.18 //x=45.49 //y=1.4 //x2=45.45 //y2=1.555
r561 (  180 201 ) resistor r=45.1352 //w=0.168 //l=0.173853 //layer=ply \
 //thickness=0.18 //x=45.49 //y=1.055 //x2=45.45 //y2=0.9
r562 (  180 181 ) resistor r=176.904 //w=0.094 //l=0.345 //layer=ply \
 //thickness=0.18 //x=45.49 //y=1.055 //x2=45.49 //y2=1.4
r563 (  177 183 ) resistor r=22.7971 //w=0.269 //l=0.106066 //layer=ply \
 //thickness=0.18 //x=45.46 //y=5.045 //x2=45.535 //y2=4.97
r564 (  177 200 ) resistor r=35.8364 //w=0.269 //l=0.270185 //layer=ply \
 //thickness=0.18 //x=45.46 //y=5.045 //x2=45.26 //y2=4.88
r565 (  175 196 ) resistor r=10.701 //w=0.21 //l=0.115 //layer=ply \
 //thickness=0.18 //x=45.115 //y=1.555 //x2=45 //y2=1.555
r566 (  174 202 ) resistor r=5.52526 //w=0.168 //l=0.115 //layer=ply \
 //thickness=0.18 //x=45.335 //y=1.555 //x2=45.45 //y2=1.555
r567 (  173 195 ) resistor r=5.52526 //w=0.168 //l=0.115 //layer=ply \
 //thickness=0.18 //x=45.115 //y=0.9 //x2=45 //y2=0.9
r568 (  172 201 ) resistor r=5.52526 //w=0.168 //l=0.115 //layer=ply \
 //thickness=0.18 //x=45.335 //y=0.9 //x2=45.45 //y2=0.9
r569 (  172 173 ) resistor r=112.809 //w=0.094 //l=0.22 //layer=ply \
 //thickness=0.18 //x=45.335 //y=0.9 //x2=45.115 //y2=0.9
r570 (  171 198 ) resistor r=58.7805 //w=0.246 //l=0.373497 //layer=ply \
 //thickness=0.18 //x=44.96 //y=2.095 //x2=45.26 //y2=2.26
r571 (  170 196 ) resistor r=39.5823 //w=0.21 //l=0.173853 //layer=ply \
 //thickness=0.18 //x=44.96 //y=1.71 //x2=45 //y2=1.555
r572 (  170 171 ) resistor r=197.415 //w=0.094 //l=0.385 //layer=ply \
 //thickness=0.18 //x=44.96 //y=1.71 //x2=44.96 //y2=2.095
r573 (  169 196 ) resistor r=39.5823 //w=0.21 //l=0.173853 //layer=ply \
 //thickness=0.18 //x=44.96 //y=1.4 //x2=45 //y2=1.555
r574 (  168 195 ) resistor r=45.1352 //w=0.168 //l=0.173853 //layer=ply \
 //thickness=0.18 //x=44.96 //y=1.055 //x2=45 //y2=0.9
r575 (  168 169 ) resistor r=176.904 //w=0.094 //l=0.345 //layer=ply \
 //thickness=0.18 //x=44.96 //y=1.055 //x2=44.96 //y2=1.4
r576 (  163 165 ) resistor r=26.9307 //w=0.15 //l=0.106066 //layer=ply \
 //thickness=0.18 //x=32.875 //y=4.97 //x2=32.95 //y2=5.045
r577 (  163 164 ) resistor r=148.702 //w=0.094 //l=0.29 //layer=ply \
 //thickness=0.18 //x=32.875 //y=4.97 //x2=32.585 //y2=4.97
r578 (  162 194 ) resistor r=45.1352 //w=0.168 //l=0.173853 //layer=ply \
 //thickness=0.18 //x=32.54 //y=1.4 //x2=32.5 //y2=1.555
r579 (  161 193 ) resistor r=45.1352 //w=0.168 //l=0.173853 //layer=ply \
 //thickness=0.18 //x=32.54 //y=1.055 //x2=32.5 //y2=0.9
r580 (  161 162 ) resistor r=176.904 //w=0.094 //l=0.345 //layer=ply \
 //thickness=0.18 //x=32.54 //y=1.055 //x2=32.54 //y2=1.4
r581 (  158 164 ) resistor r=22.7971 //w=0.269 //l=0.106066 //layer=ply \
 //thickness=0.18 //x=32.51 //y=5.045 //x2=32.585 //y2=4.97
r582 (  158 192 ) resistor r=35.8364 //w=0.269 //l=0.270185 //layer=ply \
 //thickness=0.18 //x=32.51 //y=5.045 //x2=32.31 //y2=4.88
r583 (  156 188 ) resistor r=10.701 //w=0.21 //l=0.115 //layer=ply \
 //thickness=0.18 //x=32.165 //y=1.555 //x2=32.05 //y2=1.555
r584 (  155 194 ) resistor r=5.52526 //w=0.168 //l=0.115 //layer=ply \
 //thickness=0.18 //x=32.385 //y=1.555 //x2=32.5 //y2=1.555
r585 (  154 187 ) resistor r=5.52526 //w=0.168 //l=0.115 //layer=ply \
 //thickness=0.18 //x=32.165 //y=0.9 //x2=32.05 //y2=0.9
r586 (  153 193 ) resistor r=5.52526 //w=0.168 //l=0.115 //layer=ply \
 //thickness=0.18 //x=32.385 //y=0.9 //x2=32.5 //y2=0.9
r587 (  153 154 ) resistor r=112.809 //w=0.094 //l=0.22 //layer=ply \
 //thickness=0.18 //x=32.385 //y=0.9 //x2=32.165 //y2=0.9
r588 (  152 190 ) resistor r=58.7805 //w=0.246 //l=0.373497 //layer=ply \
 //thickness=0.18 //x=32.01 //y=2.095 //x2=32.31 //y2=2.26
r589 (  151 188 ) resistor r=39.5823 //w=0.21 //l=0.173853 //layer=ply \
 //thickness=0.18 //x=32.01 //y=1.71 //x2=32.05 //y2=1.555
r590 (  151 152 ) resistor r=197.415 //w=0.094 //l=0.385 //layer=ply \
 //thickness=0.18 //x=32.01 //y=1.71 //x2=32.01 //y2=2.095
r591 (  150 188 ) resistor r=39.5823 //w=0.21 //l=0.173853 //layer=ply \
 //thickness=0.18 //x=32.01 //y=1.4 //x2=32.05 //y2=1.555
r592 (  149 187 ) resistor r=45.1352 //w=0.168 //l=0.173853 //layer=ply \
 //thickness=0.18 //x=32.01 //y=1.055 //x2=32.05 //y2=0.9
r593 (  149 150 ) resistor r=176.904 //w=0.094 //l=0.345 //layer=ply \
 //thickness=0.18 //x=32.01 //y=1.055 //x2=32.01 //y2=1.4
r594 (  148 184 ) resistor r=592.245 //w=0.094 //l=1.155 //layer=ply \
 //thickness=0.18 //x=45.9 //y=6.2 //x2=45.9 //y2=5.045
r595 (  147 177 ) resistor r=592.245 //w=0.094 //l=1.155 //layer=ply \
 //thickness=0.18 //x=45.46 //y=6.2 //x2=45.46 //y2=5.045
r596 (  146 165 ) resistor r=592.245 //w=0.094 //l=1.155 //layer=ply \
 //thickness=0.18 //x=32.95 //y=6.2 //x2=32.95 //y2=5.045
r597 (  145 158 ) resistor r=592.245 //w=0.094 //l=1.155 //layer=ply \
 //thickness=0.18 //x=32.51 //y=6.2 //x2=32.51 //y2=5.045
r598 (  144 174 ) resistor r=56.4043 //w=0.094 //l=0.11 //layer=ply \
 //thickness=0.18 //x=45.225 //y=1.555 //x2=45.335 //y2=1.555
r599 (  144 175 ) resistor r=56.4043 //w=0.094 //l=0.11 //layer=ply \
 //thickness=0.18 //x=45.225 //y=1.555 //x2=45.115 //y2=1.555
r600 (  143 155 ) resistor r=56.4043 //w=0.094 //l=0.11 //layer=ply \
 //thickness=0.18 //x=32.275 //y=1.555 //x2=32.385 //y2=1.555
r601 (  143 156 ) resistor r=56.4043 //w=0.094 //l=0.11 //layer=ply \
 //thickness=0.18 //x=32.275 //y=1.555 //x2=32.165 //y2=1.555
r602 (  139 200 ) resistor r=152 //w=0.17 //l=0.17 //layer=licon //count=1 \
 //x=45.26 //y=4.88 //x2=45.26 //y2=4.88
r603 (  130 198 ) resistor r=152 //w=0.17 //l=0.17 //layer=licon //count=1 \
 //x=45.26 //y=2.26 //x2=45.26 //y2=2.26
r604 (  125 192 ) resistor r=152 //w=0.17 //l=0.17 //layer=licon //count=1 \
 //x=32.31 //y=4.88 //x2=32.31 //y2=4.88
r605 (  116 190 ) resistor r=152 //w=0.17 //l=0.17 //layer=licon //count=1 \
 //x=32.31 //y=2.26 //x2=32.31 //y2=2.26
r606 (  99 207 ) resistor r=23.615 //w=0.187 //l=0.345 //layer=li \
 //thickness=0.1 //x=29.68 //y=5.56 //x2=29.68 //y2=5.905
r607 (  91 206 ) resistor r=23.615 //w=0.187 //l=0.345 //layer=li \
 //thickness=0.1 //x=28.8 //y=5.56 //x2=28.8 //y2=5.905
r608 (  83 205 ) resistor r=23.615 //w=0.187 //l=0.345 //layer=li \
 //thickness=0.1 //x=27.92 //y=5.56 //x2=27.92 //y2=5.905
r609 (  75 77 ) resistor r=0.10734 //w=0.281 //l=0.16 //layer=m2 \
 //thickness=0.36 //x=30.465 //y=3.885 //x2=30.625 //y2=3.885
r610 (  72 81 ) resistor r=1.03061 //w=0.197 //l=1.62499 //layer=m2 \
 //thickness=0.36 //x=43.63 //y=3.87 //x2=45.25 //y2=3.88
r611 (  72 73 ) resistor r=0.410305 //w=0.131 //l=0.43 //layer=m2 \
 //thickness=0.36 //x=43.63 //y=3.87 //x2=43.2 //y2=3.87
r612 (  70 73 ) resistor r=0.125 //w=0.17 //l=0.174929 //layer=m2 \
 //thickness=0.36 //x=43.03 //y=3.88 //x2=43.2 //y2=3.87
r613 (  70 71 ) resistor r=2.08969 //w=0.131 //l=2.19 //layer=m2 \
 //thickness=0.36 //x=43.03 //y=3.88 //x2=40.84 //y2=3.88
r614 (  68 71 ) resistor r=0.125 //w=0.17 //l=0.179722 //layer=m2 \
 //thickness=0.36 //x=40.67 //y=3.9 //x2=40.84 //y2=3.88
r615 (  68 69 ) resistor r=0.329198 //w=0.131 //l=0.345 //layer=m2 \
 //thickness=0.36 //x=40.67 //y=3.9 //x2=40.325 //y2=3.9
r616 (  66 69 ) resistor r=0.1875 //w=0.17 //l=0.264811 //layer=m2 \
 //thickness=0.36 //x=40.07 //y=3.88 //x2=40.325 //y2=3.9
r617 (  66 67 ) resistor r=1.03531 //w=0.131 //l=1.085 //layer=m2 \
 //thickness=0.36 //x=40.07 //y=3.88 //x2=38.985 //y2=3.88
r618 (  64 67 ) resistor r=0.125 //w=0.17 //l=0.179722 //layer=m2 \
 //thickness=0.36 //x=38.815 //y=3.9 //x2=38.985 //y2=3.88
r619 (  64 65 ) resistor r=0.329198 //w=0.131 //l=0.345 //layer=m2 \
 //thickness=0.36 //x=38.815 //y=3.9 //x2=38.47 //y2=3.9
r620 (  62 65 ) resistor r=0.286765 //w=0.17 //l=0.407124 //layer=m2 \
 //thickness=0.36 //x=38.08 //y=3.865 //x2=38.47 //y2=3.9
r621 (  62 63 ) resistor r=0.410305 //w=0.131 //l=0.43 //layer=m2 \
 //thickness=0.36 //x=38.08 //y=3.865 //x2=37.65 //y2=3.865
r622 (  60 63 ) resistor r=0.231618 //w=0.17 //l=0.329659 //layer=m2 \
 //thickness=0.36 //x=37.335 //y=3.895 //x2=37.65 //y2=3.865
r623 (  60 61 ) resistor r=0.329198 //w=0.131 //l=0.345 //layer=m2 \
 //thickness=0.36 //x=37.335 //y=3.895 //x2=36.99 //y2=3.895
r624 (  58 61 ) resistor r=0.1875 //w=0.17 //l=0.262393 //layer=m2 \
 //thickness=0.36 //x=36.735 //y=3.88 //x2=36.99 //y2=3.895
r625 (  58 59 ) resistor r=1.02576 //w=0.131 //l=1.075 //layer=m2 \
 //thickness=0.36 //x=36.735 //y=3.88 //x2=35.66 //y2=3.88
r626 (  57 79 ) resistor r=1.89299 //w=0.187 //l=2.83749 //layer=m2 \
 //thickness=0.36 //x=35.145 //y=3.895 //x2=32.315 //y2=3.88
r627 (  56 59 ) resistor r=0.125 //w=0.17 //l=0.177341 //layer=m2 \
 //thickness=0.36 //x=35.49 //y=3.895 //x2=35.66 //y2=3.88
r628 (  56 57 ) resistor r=0.329198 //w=0.131 //l=0.345 //layer=m2 \
 //thickness=0.36 //x=35.49 //y=3.895 //x2=35.145 //y2=3.895
r629 (  54 79 ) resistor r=0.108234 //w=0.187 //l=0.16 //layer=m2 \
 //thickness=0.36 //x=32.155 //y=3.88 //x2=32.315 //y2=3.88
r630 (  54 77 ) resistor r=1.45992 //w=0.131 //l=1.53 //layer=m2 \
 //thickness=0.36 //x=32.155 //y=3.88 //x2=30.625 //y2=3.88
r631 (  53 139 ) resistor r=9.3 //w=0.17 //l=0.17 //layer=mcon //count=1 \
 //x=45.26 //y=4.88 //x2=45.26 //y2=4.88
r632 (  51 130 ) resistor r=9.3 //w=0.17 //l=0.17 //layer=mcon //count=1 \
 //x=45.26 //y=2.26 //x2=45.26 //y2=2.26
r633 (  48 81 ) resistor r=4.5 //w=0.15 //l=0.15 //layer=via1 //count=1 \
 //x=45.25 //y=3.88 //x2=45.25 //y2=3.88
r634 (  45 79 ) resistor r=4.5 //w=0.15 //l=0.15 //layer=via1 //count=1 \
 //x=32.315 //y=3.88 //x2=32.315 //y2=3.88
r635 (  43 125 ) resistor r=9.3 //w=0.17 //l=0.17 //layer=mcon //count=1 \
 //x=32.31 //y=4.88 //x2=32.31 //y2=4.88
r636 (  41 116 ) resistor r=9.3 //w=0.17 //l=0.17 //layer=mcon //count=1 \
 //x=32.31 //y=2.26 //x2=32.31 //y2=2.26
r637 (  39 75 ) resistor r=4.5 //w=0.15 //l=0.15 //layer=via1 //count=1 \
 //x=30.465 //y=3.885 //x2=30.465 //y2=3.885
r638 (  37 39 ) resistor r=0.00167112 //w=0.374 //l=0.005 //layer=m1 \
 //thickness=0.36 //x=30.515 //y=3.88 //x2=30.515 //y2=3.885
r639 (  35 203 ) resistor r=9.3 //w=0.17 //l=0.17 //layer=mcon //count=1 \
 //x=29.975 //y=1.19 //x2=29.975 //y2=1.19
r640 (  33 99 ) resistor r=9.3 //w=0.17 //l=0.17 //layer=mcon //count=1 \
 //x=29.68 //y=5.56 //x2=29.68 //y2=5.56
r641 (  30 91 ) resistor r=9.3 //w=0.17 //l=0.17 //layer=mcon //count=1 \
 //x=28.8 //y=5.56 //x2=28.8 //y2=5.56
r642 (  28 30 ) resistor r=0.121228 //w=0.232 //l=0.225 //layer=m1 \
 //thickness=0.36 //x=28.8 //y=5.335 //x2=28.8 //y2=5.56
r643 (  27 83 ) resistor r=9.3 //w=0.17 //l=0.17 //layer=mcon //count=1 \
 //x=27.92 //y=5.56 //x2=27.92 //y2=5.56
r644 (  25 27 ) resistor r=0.129608 //w=0.217 //l=0.225 //layer=m1 \
 //thickness=0.36 //x=27.922 //y=5.335 //x2=27.922 //y2=5.56
r645 (  24 53 ) resistor r=0.0760407 //w=0.238 //l=0.125 //layer=m1 \
 //thickness=0.36 //x=45.26 //y=4.755 //x2=45.26 //y2=4.88
r646 (  23 48 ) resistor r=0.0909648 //w=0.371 //l=0.186762 //layer=m1 \
 //thickness=0.36 //x=45.26 //y=4.04 //x2=45.202 //y2=3.88
r647 (  23 24 ) resistor r=0.682252 //w=0.131 //l=0.715 //layer=m1 \
 //thickness=0.36 //x=45.26 //y=4.04 //x2=45.26 //y2=4.755
r648 (  22 48 ) resistor r=0.0909648 //w=0.371 //l=0.186762 //layer=m1 \
 //thickness=0.36 //x=45.26 //y=3.72 //x2=45.202 //y2=3.88
r649 (  21 51 ) resistor r=0.0719237 //w=0.222 //l=0.115 //layer=m1 \
 //thickness=0.36 //x=45.26 //y=2.375 //x2=45.26 //y2=2.26
r650 (  21 22 ) resistor r=1.2834 //w=0.131 //l=1.345 //layer=m1 \
 //thickness=0.36 //x=45.26 //y=2.375 //x2=45.26 //y2=3.72
r651 (  20 43 ) resistor r=0.0760407 //w=0.238 //l=0.125 //layer=m1 \
 //thickness=0.36 //x=32.31 //y=4.755 //x2=32.31 //y2=4.88
r652 (  19 45 ) resistor r=0.0910802 //w=0.374 //l=0.185472 //layer=m1 \
 //thickness=0.36 //x=32.31 //y=4.04 //x2=32.365 //y2=3.88
r653 (  19 20 ) resistor r=0.682252 //w=0.131 //l=0.715 //layer=m1 \
 //thickness=0.36 //x=32.31 //y=4.04 //x2=32.31 //y2=4.755
r654 (  18 45 ) resistor r=0.0910802 //w=0.374 //l=0.185472 //layer=m1 \
 //thickness=0.36 //x=32.31 //y=3.72 //x2=32.365 //y2=3.88
r655 (  17 41 ) resistor r=0.0719237 //w=0.222 //l=0.115 //layer=m1 \
 //thickness=0.36 //x=32.31 //y=2.375 //x2=32.31 //y2=2.26
r656 (  17 18 ) resistor r=1.2834 //w=0.131 //l=1.345 //layer=m1 \
 //thickness=0.36 //x=32.31 //y=2.375 //x2=32.31 //y2=3.72
r657 (  15 39 ) resistor r=0.0910802 //w=0.374 //l=0.185472 //layer=m1 \
 //thickness=0.36 //x=30.46 //y=4.045 //x2=30.515 //y2=3.885
r658 (  15 16 ) resistor r=1.14981 //w=0.131 //l=1.205 //layer=m1 \
 //thickness=0.36 //x=30.46 //y=4.045 //x2=30.46 //y2=5.25
r659 (  14 37 ) resistor r=0.089409 //w=0.374 //l=0.180416 //layer=m1 \
 //thickness=0.36 //x=30.46 //y=3.725 //x2=30.515 //y2=3.88
r660 (  13 14 ) resistor r=1.71279 //w=0.131 //l=1.795 //layer=m1 \
 //thickness=0.36 //x=30.46 //y=1.93 //x2=30.46 //y2=3.725
r661 (  11 13 ) resistor r=0.0698411 //w=0.17 //l=0.120208 //layer=m1 \
 //thickness=0.36 //x=30.375 //y=1.845 //x2=30.46 //y2=1.93
r662 (  11 12 ) resistor r=0.300573 //w=0.131 //l=0.315 //layer=m1 \
 //thickness=0.36 //x=30.375 //y=1.845 //x2=30.06 //y2=1.845
r663 (  10 12 ) resistor r=0.0698411 //w=0.17 //l=0.120208 //layer=m1 \
 //thickness=0.36 //x=29.975 //y=1.76 //x2=30.06 //y2=1.845
r664 (  9 35 ) resistor r=0.0717383 //w=0.224 //l=0.115 //layer=m1 \
 //thickness=0.36 //x=29.975 //y=1.305 //x2=29.975 //y2=1.19
r665 (  9 10 ) resistor r=0.43416 //w=0.131 //l=0.455 //layer=m1 \
 //thickness=0.36 //x=29.975 //y=1.305 //x2=29.975 //y2=1.76
r666 (  8 31 ) resistor r=0.0675342 //w=0.23 //l=0.115 //layer=m1 \
 //thickness=0.36 //x=29.795 //y=5.335 //x2=29.68 //y2=5.335
r667 (  7 16 ) resistor r=0.0698411 //w=0.17 //l=0.120208 //layer=m1 \
 //thickness=0.36 //x=30.375 //y=5.335 //x2=30.46 //y2=5.25
r668 (  7 8 ) resistor r=0.553435 //w=0.131 //l=0.58 //layer=m1 \
 //thickness=0.36 //x=30.375 //y=5.335 //x2=29.795 //y2=5.335
r669 (  6 33 ) resistor r=0.00118313 //w=0.23 //layer=m1 //thickness=0.36 \
 //x=29.68 //y=5.56 //x2=29.68 //y2=5.56
r670 (  5 31 ) resistor r=0.002872 //w=0.34 //l=0.085 //layer=m1 \
 //thickness=0.36 //x=29.68 //y=5.42 //x2=29.68 //y2=5.335
r671 (  5 6 ) resistor r=0.091623 //w=0.191 //l=0.14 //layer=m1 \
 //thickness=0.36 //x=29.68 //y=5.42 //x2=29.68 //y2=5.56
r672 (  4 28 ) resistor r=0.0262263 //w=0.232 //l=0.12 //layer=m1 \
 //thickness=0.36 //x=28.92 //y=5.335 //x2=28.8 //y2=5.335
r673 (  3 31 ) resistor r=0.0675342 //w=0.23 //l=0.115 //layer=m1 \
 //thickness=0.36 //x=29.565 //y=5.335 //x2=29.68 //y2=5.335
r674 (  3 4 ) resistor r=0.615458 //w=0.131 //l=0.645 //layer=m1 \
 //thickness=0.36 //x=29.565 //y=5.335 //x2=28.92 //y2=5.335
r675 (  2 25 ) resistor r=0.0222262 //w=0.217 //l=0.118 //layer=m1 \
 //thickness=0.36 //x=28.04 //y=5.335 //x2=27.922 //y2=5.335
r676 (  1 28 ) resistor r=0.0262263 //w=0.232 //l=0.12 //layer=m1 \
 //thickness=0.36 //x=28.68 //y=5.335 //x2=28.8 //y2=5.335
r677 (  1 2 ) resistor r=0.610687 //w=0.131 //l=0.64 //layer=m1 \
 //thickness=0.36 //x=28.68 //y=5.335 //x2=28.04 //y2=5.335
ends PM_TMRDFFRNQNX1\%noxref_8

subckt PM_TMRDFFRNQNX1\%noxref_9 ( 1 3 6 7 9 10 11 12 14 15 16 18 19 21 24 27 \
 35 39 41 44 45 52 54 55 58 66 74 91 100 104 105 106 107 108 109 110 114 116 \
 119 120 130 133 135 136 137 )
c293 ( 133 0 ) capacitor c=0.00885916f //x=47.545 //y=1.095
c294 ( 130 0 ) capacitor c=0.0646983f //x=50.07 //y=4.88
c295 ( 120 0 ) capacitor c=0.0318956f //x=50.405 //y=1.39
c296 ( 119 0 ) capacitor c=0.0186809f //x=50.405 //y=1.045
c297 ( 116 0 ) capacitor c=0.0141821f //x=50.25 //y=1.545
c298 ( 114 0 ) capacitor c=0.0158553f //x=50.25 //y=0.89
c299 ( 110 0 ) capacitor c=0.088055f //x=49.875 //y=2.095
c300 ( 109 0 ) capacitor c=0.0229235f //x=49.875 //y=1.7
c301 ( 108 0 ) capacitor c=0.0234359f //x=49.875 //y=1.39
c302 ( 107 0 ) capacitor c=0.0198759f //x=49.875 //y=1.045
c303 ( 106 0 ) capacitor c=0.110369f //x=50.41 //y=6.2
c304 ( 105 0 ) capacitor c=0.154619f //x=49.97 //y=6.2
c305 ( 100 0 ) capacitor c=8.13425e-19 //x=50.07 //y=4.88
c306 ( 91 0 ) capacitor c=7.85889e-19 //x=50.07 //y=2.26
c307 ( 74 0 ) capacitor c=0.0293075f //x=47.44 //y=5.56
c308 ( 66 0 ) capacitor c=0.029137f //x=46.56 //y=5.56
c309 ( 58 0 ) capacitor c=0.0278099f //x=45.68 //y=5.56
c310 ( 55 0 ) capacitor c=0.019252f //x=49.895 //y=3.865
c311 ( 54 0 ) capacitor c=7.71795e-19 //x=50.055 //y=3.865
c312 ( 52 0 ) capacitor c=7.04319e-19 //x=48.38 //y=3.865
c313 ( 45 0 ) capacitor c=0.0159079f //x=50.072 //y=4.74
c314 ( 44 0 ) capacitor c=0.00598864f //x=50.07 //y=4.88
c315 ( 41 0 ) capacitor c=0.00462953f //x=50.07 //y=2.26
c316 ( 39 0 ) capacitor c=0.0165926f //x=50.07 //y=3.88
c317 ( 35 0 ) capacitor c=0.0178837f //x=48.22 //y=3.88
c318 ( 27 0 ) capacitor c=9.53233e-19 //x=47.44 //y=5.335
c319 ( 24 0 ) capacitor c=0.0080954f //x=46.56 //y=5.335
c320 ( 21 0 ) capacitor c=0.0111234f //x=45.682 //y=5.335
c321 ( 19 0 ) capacitor c=0.0122442f //x=50.07 //y=4.025
c322 ( 18 0 ) capacitor c=0.0344656f //x=50.07 //y=3.705
c323 ( 16 0 ) capacitor c=0.0319031f //x=48.22 //y=5.25
c324 ( 15 0 ) capacitor c=0.0133429f //x=48.22 //y=4.025
c325 ( 14 0 ) capacitor c=0.046944f //x=48.22 //y=3.705
c326 ( 12 0 ) capacitor c=0.0047266f //x=47.82 //y=1.845
c327 ( 11 0 ) capacitor c=0.0129887f //x=48.135 //y=1.845
c328 ( 10 0 ) capacitor c=0.0136149f //x=47.735 //y=1.76
c329 ( 9 0 ) capacitor c=0.0111889f //x=47.735 //y=1.305
c330 ( 7 0 ) capacitor c=0.0228308f //x=48.135 //y=5.335
c331 ( 6 0 ) capacitor c=0.00906713f //x=47.44 //y=5.56
c332 ( 3 0 ) capacitor c=0.019444f //x=47.325 //y=5.335
c333 ( 1 0 ) capacitor c=0.0151049f //x=46.44 //y=5.335
r334 (  128 130 ) resistor r=20.6867 //w=0.233 //l=0.1 //layer=ply \
 //thickness=0.18 //x=49.97 //y=4.88 //x2=50.07 //y2=4.88
r335 (  121 130 ) resistor r=70.3348 //w=0.233 //l=0.414367 //layer=ply \
 //thickness=0.18 //x=50.41 //y=5.045 //x2=50.07 //y2=4.88
r336 (  120 132 ) resistor r=45.1352 //w=0.168 //l=0.173853 //layer=ply \
 //thickness=0.18 //x=50.405 //y=1.39 //x2=50.365 //y2=1.545
r337 (  119 131 ) resistor r=45.1352 //w=0.168 //l=0.173853 //layer=ply \
 //thickness=0.18 //x=50.405 //y=1.045 //x2=50.365 //y2=0.89
r338 (  119 120 ) resistor r=176.904 //w=0.094 //l=0.345 //layer=ply \
 //thickness=0.18 //x=50.405 //y=1.045 //x2=50.405 //y2=1.39
r339 (  117 127 ) resistor r=10.701 //w=0.21 //l=0.115 //layer=ply \
 //thickness=0.18 //x=50.03 //y=1.545 //x2=49.915 //y2=1.545
r340 (  116 132 ) resistor r=5.52526 //w=0.168 //l=0.115 //layer=ply \
 //thickness=0.18 //x=50.25 //y=1.545 //x2=50.365 //y2=1.545
r341 (  115 126 ) resistor r=5.52526 //w=0.168 //l=0.115 //layer=ply \
 //thickness=0.18 //x=50.03 //y=0.89 //x2=49.915 //y2=0.89
r342 (  114 131 ) resistor r=5.52526 //w=0.168 //l=0.115 //layer=ply \
 //thickness=0.18 //x=50.25 //y=0.89 //x2=50.365 //y2=0.89
r343 (  114 115 ) resistor r=112.809 //w=0.094 //l=0.22 //layer=ply \
 //thickness=0.18 //x=50.25 //y=0.89 //x2=50.03 //y2=0.89
r344 (  111 128 ) resistor r=13.0941 //w=0.233 //l=0.165 //layer=ply \
 //thickness=0.18 //x=49.97 //y=5.045 //x2=49.97 //y2=4.88
r345 (  110 125 ) resistor r=34.8111 //w=0.27 //l=0.264953 //layer=ply \
 //thickness=0.18 //x=49.875 //y=2.095 //x2=50.07 //y2=2.26
r346 (  109 127 ) resistor r=39.5823 //w=0.21 //l=0.173853 //layer=ply \
 //thickness=0.18 //x=49.875 //y=1.7 //x2=49.915 //y2=1.545
r347 (  109 110 ) resistor r=202.543 //w=0.094 //l=0.395 //layer=ply \
 //thickness=0.18 //x=49.875 //y=1.7 //x2=49.875 //y2=2.095
r348 (  108 127 ) resistor r=39.5823 //w=0.21 //l=0.173853 //layer=ply \
 //thickness=0.18 //x=49.875 //y=1.39 //x2=49.915 //y2=1.545
r349 (  107 126 ) resistor r=45.1352 //w=0.168 //l=0.173853 //layer=ply \
 //thickness=0.18 //x=49.875 //y=1.045 //x2=49.915 //y2=0.89
r350 (  107 108 ) resistor r=176.904 //w=0.094 //l=0.345 //layer=ply \
 //thickness=0.18 //x=49.875 //y=1.045 //x2=49.875 //y2=1.39
r351 (  106 121 ) resistor r=592.245 //w=0.094 //l=1.155 //layer=ply \
 //thickness=0.18 //x=50.41 //y=6.2 //x2=50.41 //y2=5.045
r352 (  105 111 ) resistor r=592.245 //w=0.094 //l=1.155 //layer=ply \
 //thickness=0.18 //x=49.97 //y=6.2 //x2=49.97 //y2=5.045
r353 (  104 116 ) resistor r=56.4043 //w=0.094 //l=0.11 //layer=ply \
 //thickness=0.18 //x=50.14 //y=1.545 //x2=50.25 //y2=1.545
r354 (  104 117 ) resistor r=56.4043 //w=0.094 //l=0.11 //layer=ply \
 //thickness=0.18 //x=50.14 //y=1.545 //x2=50.03 //y2=1.545
r355 (  100 130 ) resistor r=152 //w=0.17 //l=0.17 //layer=licon //count=1 \
 //x=50.07 //y=4.88 //x2=50.07 //y2=4.88
r356 (  91 125 ) resistor r=152 //w=0.17 //l=0.17 //layer=licon //count=1 \
 //x=50.07 //y=2.26 //x2=50.07 //y2=2.26
r357 (  74 137 ) resistor r=23.615 //w=0.187 //l=0.345 //layer=li \
 //thickness=0.1 //x=47.44 //y=5.56 //x2=47.44 //y2=5.905
r358 (  66 136 ) resistor r=23.615 //w=0.187 //l=0.345 //layer=li \
 //thickness=0.1 //x=46.56 //y=5.56 //x2=46.56 //y2=5.905
r359 (  58 135 ) resistor r=23.615 //w=0.187 //l=0.345 //layer=li \
 //thickness=0.1 //x=45.68 //y=5.56 //x2=45.68 //y2=5.905
r360 (  54 55 ) resistor r=0.10734 //w=0.281 //l=0.16 //layer=m2 \
 //thickness=0.36 //x=50.055 //y=3.865 //x2=49.895 //y2=3.865
r361 (  52 55 ) resistor r=1.44561 //w=0.131 //l=1.515 //layer=m2 \
 //thickness=0.36 //x=48.38 //y=3.88 //x2=49.895 //y2=3.88
r362 (  50 52 ) resistor r=0.10734 //w=0.281 //l=0.16 //layer=m2 \
 //thickness=0.36 //x=48.22 //y=3.865 //x2=48.38 //y2=3.865
r363 (  44 100 ) resistor r=9.3 //w=0.17 //l=0.17 //layer=mcon //count=1 \
 //x=50.07 //y=4.88 //x2=50.07 //y2=4.88
r364 (  44 45 ) resistor r=0.103207 //w=0.196 //l=0.14 //layer=m1 \
 //thickness=0.36 //x=50.072 //y=4.88 //x2=50.072 //y2=4.74
r365 (  41 91 ) resistor r=9.3 //w=0.17 //l=0.17 //layer=mcon //count=1 \
 //x=50.07 //y=2.26 //x2=50.07 //y2=2.26
r366 (  37 54 ) resistor r=4.5 //w=0.15 //l=0.15 //layer=via1 //count=1 \
 //x=50.055 //y=3.865 //x2=50.055 //y2=3.865
r367 (  37 39 ) resistor r=0.00509511 //w=0.368 //l=0.015 //layer=m1 \
 //thickness=0.36 //x=50.01 //y=3.865 //x2=50.01 //y2=3.88
r368 (  33 50 ) resistor r=4.5 //w=0.15 //l=0.15 //layer=via1 //count=1 \
 //x=48.22 //y=3.865 //x2=48.22 //y2=3.865
r369 (  33 35 ) resistor r=0.0049867 //w=0.376 //l=0.015 //layer=m1 \
 //thickness=0.36 //x=48.272 //y=3.865 //x2=48.272 //y2=3.88
r370 (  31 133 ) resistor r=9.3 //w=0.17 //l=0.17 //layer=mcon //count=1 \
 //x=47.735 //y=1.19 //x2=47.735 //y2=1.19
r371 (  29 74 ) resistor r=9.3 //w=0.17 //l=0.17 //layer=mcon //count=1 \
 //x=47.44 //y=5.56 //x2=47.44 //y2=5.56
r372 (  26 66 ) resistor r=9.3 //w=0.17 //l=0.17 //layer=mcon //count=1 \
 //x=46.56 //y=5.56 //x2=46.56 //y2=5.56
r373 (  24 26 ) resistor r=0.121228 //w=0.232 //l=0.225 //layer=m1 \
 //thickness=0.36 //x=46.56 //y=5.335 //x2=46.56 //y2=5.56
r374 (  23 58 ) resistor r=9.3 //w=0.17 //l=0.17 //layer=mcon //count=1 \
 //x=45.68 //y=5.56 //x2=45.68 //y2=5.56
r375 (  21 23 ) resistor r=0.129608 //w=0.217 //l=0.225 //layer=m1 \
 //thickness=0.36 //x=45.682 //y=5.335 //x2=45.682 //y2=5.56
r376 (  19 39 ) resistor r=0.0857585 //w=0.368 //l=0.172409 //layer=m1 \
 //thickness=0.36 //x=50.07 //y=4.025 //x2=50.01 //y2=3.88
r377 (  19 45 ) resistor r=0.682252 //w=0.131 //l=0.715 //layer=m1 \
 //thickness=0.36 //x=50.07 //y=4.025 //x2=50.07 //y2=4.74
r378 (  18 37 ) resistor r=0.0908536 //w=0.368 //l=0.187617 //layer=m1 \
 //thickness=0.36 //x=50.07 //y=3.705 //x2=50.01 //y2=3.865
r379 (  17 41 ) resistor r=0.0933015 //w=0.201 //l=0.125 //layer=m1 \
 //thickness=0.36 //x=50.07 //y=2.385 //x2=50.07 //y2=2.26
r380 (  17 18 ) resistor r=1.25954 //w=0.131 //l=1.32 //layer=m1 \
 //thickness=0.36 //x=50.07 //y=2.385 //x2=50.07 //y2=3.705
r381 (  15 35 ) resistor r=0.0861726 //w=0.376 //l=0.169012 //layer=m1 \
 //thickness=0.36 //x=48.22 //y=4.025 //x2=48.272 //y2=3.88
r382 (  15 16 ) resistor r=1.16889 //w=0.131 //l=1.225 //layer=m1 \
 //thickness=0.36 //x=48.22 //y=4.025 //x2=48.22 //y2=5.25
r383 (  14 33 ) resistor r=0.0911593 //w=0.376 //l=0.184174 //layer=m1 \
 //thickness=0.36 //x=48.22 //y=3.705 //x2=48.272 //y2=3.865
r384 (  13 14 ) resistor r=1.6937 //w=0.131 //l=1.775 //layer=m1 \
 //thickness=0.36 //x=48.22 //y=1.93 //x2=48.22 //y2=3.705
r385 (  11 13 ) resistor r=0.0698411 //w=0.17 //l=0.120208 //layer=m1 \
 //thickness=0.36 //x=48.135 //y=1.845 //x2=48.22 //y2=1.93
r386 (  11 12 ) resistor r=0.300573 //w=0.131 //l=0.315 //layer=m1 \
 //thickness=0.36 //x=48.135 //y=1.845 //x2=47.82 //y2=1.845
r387 (  10 12 ) resistor r=0.0698411 //w=0.17 //l=0.120208 //layer=m1 \
 //thickness=0.36 //x=47.735 //y=1.76 //x2=47.82 //y2=1.845
r388 (  9 31 ) resistor r=0.0717383 //w=0.224 //l=0.115 //layer=m1 \
 //thickness=0.36 //x=47.735 //y=1.305 //x2=47.735 //y2=1.19
r389 (  9 10 ) resistor r=0.43416 //w=0.131 //l=0.455 //layer=m1 \
 //thickness=0.36 //x=47.735 //y=1.305 //x2=47.735 //y2=1.76
r390 (  8 27 ) resistor r=0.0675342 //w=0.23 //l=0.115 //layer=m1 \
 //thickness=0.36 //x=47.555 //y=5.335 //x2=47.44 //y2=5.335
r391 (  7 16 ) resistor r=0.0698411 //w=0.17 //l=0.120208 //layer=m1 \
 //thickness=0.36 //x=48.135 //y=5.335 //x2=48.22 //y2=5.25
r392 (  7 8 ) resistor r=0.553435 //w=0.131 //l=0.58 //layer=m1 \
 //thickness=0.36 //x=48.135 //y=5.335 //x2=47.555 //y2=5.335
r393 (  6 29 ) resistor r=0.00118313 //w=0.23 //layer=m1 //thickness=0.36 \
 //x=47.44 //y=5.56 //x2=47.44 //y2=5.56
r394 (  5 27 ) resistor r=0.002872 //w=0.34 //l=0.085 //layer=m1 \
 //thickness=0.36 //x=47.44 //y=5.42 //x2=47.44 //y2=5.335
r395 (  5 6 ) resistor r=0.091623 //w=0.191 //l=0.14 //layer=m1 \
 //thickness=0.36 //x=47.44 //y=5.42 //x2=47.44 //y2=5.56
r396 (  4 24 ) resistor r=0.0262263 //w=0.232 //l=0.12 //layer=m1 \
 //thickness=0.36 //x=46.68 //y=5.335 //x2=46.56 //y2=5.335
r397 (  3 27 ) resistor r=0.0675342 //w=0.23 //l=0.115 //layer=m1 \
 //thickness=0.36 //x=47.325 //y=5.335 //x2=47.44 //y2=5.335
r398 (  3 4 ) resistor r=0.615458 //w=0.131 //l=0.645 //layer=m1 \
 //thickness=0.36 //x=47.325 //y=5.335 //x2=46.68 //y2=5.335
r399 (  2 21 ) resistor r=0.0222262 //w=0.217 //l=0.118 //layer=m1 \
 //thickness=0.36 //x=45.8 //y=5.335 //x2=45.682 //y2=5.335
r400 (  1 24 ) resistor r=0.0262263 //w=0.232 //l=0.12 //layer=m1 \
 //thickness=0.36 //x=46.44 //y=5.335 //x2=46.56 //y2=5.335
r401 (  1 2 ) resistor r=0.610687 //w=0.131 //l=0.64 //layer=m1 \
 //thickness=0.36 //x=46.44 //y=5.335 //x2=45.8 //y2=5.335
ends PM_TMRDFFRNQNX1\%noxref_9

subckt PM_TMRDFFRNQNX1\%noxref_10 ( 1 2 3 4 6 7 8 9 11 14 15 17 18 19 20 22 23 \
 24 26 27 28 34 38 41 46 49 52 58 62 66 71 73 75 77 79 80 81 82 86 94 103 108 \
 117 122 130 138 155 164 168 169 170 171 172 173 174 175 176 177 178 179 180 \
 181 183 189 190 191 192 196 197 198 203 205 207 213 214 215 216 217 222 224 \
 226 232 233 243 244 247 256 257 260 268 270 271 272 )
c654 ( 268 0 ) capacitor c=0.00885916f //x=42.735 //y=1.095
c655 ( 260 0 ) capacitor c=0.0358148f //x=50.84 //y=4.88
c656 ( 257 0 ) capacitor c=0.0284095f //x=50.81 //y=2.095
c657 ( 256 0 ) capacitor c=0.0476356f //x=50.81 //y=2.26
c658 ( 247 0 ) capacitor c=0.0354929f //x=37.89 //y=4.88
c659 ( 244 0 ) capacitor c=0.0284095f //x=37.86 //y=2.095
c660 ( 243 0 ) capacitor c=0.0476356f //x=37.86 //y=2.26
c661 ( 233 0 ) capacitor c=0.0439708f //x=51.375 //y=1.43
c662 ( 232 0 ) capacitor c=0.0192582f //x=51.375 //y=1.085
c663 ( 226 0 ) capacitor c=0.0162526f //x=51.22 //y=1.585
c664 ( 224 0 ) capacitor c=0.0157807f //x=51.22 //y=0.93
c665 ( 222 0 ) capacitor c=0.0372668f //x=51.215 //y=4.97
c666 ( 217 0 ) capacitor c=0.0210762f //x=50.845 //y=1.74
c667 ( 216 0 ) capacitor c=0.0168511f //x=50.845 //y=1.43
c668 ( 215 0 ) capacitor c=0.0175485f //x=50.845 //y=1.085
c669 ( 214 0 ) capacitor c=0.0439708f //x=38.425 //y=1.43
c670 ( 213 0 ) capacitor c=0.0192582f //x=38.425 //y=1.085
c671 ( 207 0 ) capacitor c=0.0162526f //x=38.27 //y=1.585
c672 ( 205 0 ) capacitor c=0.0157807f //x=38.27 //y=0.93
c673 ( 203 0 ) capacitor c=0.0372668f //x=38.265 //y=4.97
c674 ( 198 0 ) capacitor c=0.0210762f //x=37.895 //y=1.74
c675 ( 197 0 ) capacitor c=0.0168511f //x=37.895 //y=1.43
c676 ( 196 0 ) capacitor c=0.0175485f //x=37.895 //y=1.085
c677 ( 192 0 ) capacitor c=0.0552068f //x=27.775 //y=4.97
c678 ( 191 0 ) capacitor c=0.0376642f //x=28.065 //y=4.97
c679 ( 190 0 ) capacitor c=0.0346489f //x=27.73 //y=1.4
c680 ( 189 0 ) capacitor c=0.018692f //x=27.73 //y=1.055
c681 ( 183 0 ) capacitor c=0.0137077f //x=27.575 //y=1.555
c682 ( 181 0 ) capacitor c=0.0158585f //x=27.575 //y=0.9
c683 ( 180 0 ) capacitor c=0.103534f //x=27.2 //y=2.095
c684 ( 179 0 ) capacitor c=0.0229444f //x=27.2 //y=1.71
c685 ( 178 0 ) capacitor c=0.0234359f //x=27.2 //y=1.4
c686 ( 177 0 ) capacitor c=0.019815f //x=27.2 //y=1.055
c687 ( 176 0 ) capacitor c=0.155269f //x=51.29 //y=6.2
c688 ( 175 0 ) capacitor c=0.110375f //x=50.85 //y=6.2
c689 ( 174 0 ) capacitor c=0.155269f //x=38.34 //y=6.2
c690 ( 173 0 ) capacitor c=0.110375f //x=37.9 //y=6.2
c691 ( 172 0 ) capacitor c=0.110208f //x=28.14 //y=6.2
c692 ( 171 0 ) capacitor c=0.158957f //x=27.7 //y=6.2
c693 ( 164 0 ) capacitor c=5.80994e-19 //x=50.84 //y=4.88
c694 ( 155 0 ) capacitor c=5.78095e-19 //x=50.81 //y=2.26
c695 ( 138 0 ) capacitor c=0.0293124f //x=42.63 //y=5.56
c696 ( 130 0 ) capacitor c=0.029137f //x=41.75 //y=5.56
c697 ( 122 0 ) capacitor c=0.0277605f //x=40.87 //y=5.56
c698 ( 117 0 ) capacitor c=5.80994e-19 //x=37.89 //y=4.88
c699 ( 108 0 ) capacitor c=5.78095e-19 //x=37.86 //y=2.26
c700 ( 103 0 ) capacitor c=0.00125338f //x=27.5 //y=4.88
c701 ( 94 0 ) capacitor c=0.0012618f //x=27.5 //y=2.26
c702 ( 86 0 ) capacitor c=0.00112715f //x=27.66 //y=4.26
c703 ( 82 0 ) capacitor c=0.0202931f //x=45.12 //y=4.265
c704 ( 81 0 ) capacitor c=0.0592498f //x=45.465 //y=4.265
c705 ( 80 0 ) capacitor c=0.0480042f //x=38.025 //y=4.25
c706 ( 79 0 ) capacitor c=0.0489806f //x=43.255 //y=4.25
c707 ( 77 0 ) capacitor c=0.00158466f //x=32.53 //y=4.265
c708 ( 75 0 ) capacitor c=0.0162158f //x=31.93 //y=4.25
c709 ( 73 0 ) capacitor c=0.00487421f //x=30.715 //y=4.27
c710 ( 71 0 ) capacitor c=0.0316949f //x=30.075 //y=4.25
c711 ( 66 0 ) capacitor c=0.00504273f //x=50.81 //y=2.26
c712 ( 62 0 ) capacitor c=0.0152943f //x=50.81 //y=4.25
c713 ( 58 0 ) capacitor c=0.0152032f //x=43.41 //y=4.25
c714 ( 52 0 ) capacitor c=0.00112339f //x=42.63 //y=5.335
c715 ( 49 0 ) capacitor c=0.00744415f //x=41.75 //y=5.335
c716 ( 46 0 ) capacitor c=0.0112819f //x=40.872 //y=5.335
c717 ( 41 0 ) capacitor c=0.00504845f //x=37.86 //y=2.26
c718 ( 38 0 ) capacitor c=0.0141348f //x=37.86 //y=4.25
c719 ( 34 0 ) capacitor c=0.0159682f //x=27.5 //y=4.25
c720 ( 28 0 ) capacitor c=0.00896518f //x=50.81 //y=4.735
c721 ( 27 0 ) capacitor c=0.00958631f //x=50.81 //y=4.415
c722 ( 26 0 ) capacitor c=0.034968f //x=50.81 //y=4.095
c723 ( 24 0 ) capacitor c=0.0222888f //x=43.41 //y=5.25
c724 ( 23 0 ) capacitor c=0.012762f //x=43.41 //y=4.415
c725 ( 22 0 ) capacitor c=0.0630158f //x=43.41 //y=4.095
c726 ( 20 0 ) capacitor c=0.00493487f //x=43.01 //y=1.845
c727 ( 19 0 ) capacitor c=0.0134344f //x=43.325 //y=1.845
c728 ( 18 0 ) capacitor c=0.0167333f //x=42.925 //y=1.76
c729 ( 17 0 ) capacitor c=0.0111392f //x=42.925 //y=1.305
c730 ( 15 0 ) capacitor c=0.0231466f //x=43.325 //y=5.335
c731 ( 14 0 ) capacitor c=0.00933983f //x=42.63 //y=5.56
c732 ( 11 0 ) capacitor c=0.019596f //x=42.515 //y=5.335
c733 ( 9 0 ) capacitor c=0.0147103f //x=41.63 //y=5.335
c734 ( 8 0 ) capacitor c=0.00917813f //x=37.86 //y=4.735
c735 ( 7 0 ) capacitor c=0.00994911f //x=37.86 //y=4.41
c736 ( 6 0 ) capacitor c=0.0333568f //x=37.86 //y=4.09
c737 ( 4 0 ) capacitor c=0.0137415f //x=27.5 //y=4.755
c738 ( 3 0 ) capacitor c=0.0127139f //x=27.5 //y=4.42
c739 ( 2 0 ) capacitor c=0.0556467f //x=27.5 //y=4.1
c740 ( 1 0 ) capacitor c=0.00495287f //x=27.5 //y=2.375
r741 (  262 263 ) resistor r=32.4568 //w=0.214 //l=0.075 //layer=ply \
 //thickness=0.18 //x=50.84 //y=4.97 //x2=50.84 //y2=5.045
r742 (  260 262 ) resistor r=20.271 //w=0.214 //l=0.09 //layer=ply \
 //thickness=0.18 //x=50.84 //y=4.88 //x2=50.84 //y2=4.97
r743 (  256 257 ) resistor r=52.7279 //w=0.214 //l=0.165 //layer=ply \
 //thickness=0.18 //x=50.81 //y=2.26 //x2=50.81 //y2=2.095
r744 (  249 250 ) resistor r=32.4568 //w=0.214 //l=0.075 //layer=ply \
 //thickness=0.18 //x=37.89 //y=4.97 //x2=37.89 //y2=5.045
r745 (  247 249 ) resistor r=20.271 //w=0.214 //l=0.09 //layer=ply \
 //thickness=0.18 //x=37.89 //y=4.88 //x2=37.89 //y2=4.97
r746 (  243 244 ) resistor r=52.7279 //w=0.214 //l=0.165 //layer=ply \
 //thickness=0.18 //x=37.86 //y=2.26 //x2=37.86 //y2=2.095
r747 (  233 267 ) resistor r=45.1352 //w=0.168 //l=0.173853 //layer=ply \
 //thickness=0.18 //x=51.375 //y=1.43 //x2=51.335 //y2=1.585
r748 (  232 266 ) resistor r=45.1352 //w=0.168 //l=0.173853 //layer=ply \
 //thickness=0.18 //x=51.375 //y=1.085 //x2=51.335 //y2=0.93
r749 (  232 233 ) resistor r=176.904 //w=0.094 //l=0.345 //layer=ply \
 //thickness=0.18 //x=51.375 //y=1.085 //x2=51.375 //y2=1.43
r750 (  227 265 ) resistor r=10.701 //w=0.21 //l=0.115 //layer=ply \
 //thickness=0.18 //x=51 //y=1.585 //x2=50.885 //y2=1.585
r751 (  226 267 ) resistor r=5.52526 //w=0.168 //l=0.115 //layer=ply \
 //thickness=0.18 //x=51.22 //y=1.585 //x2=51.335 //y2=1.585
r752 (  225 264 ) resistor r=5.52526 //w=0.168 //l=0.115 //layer=ply \
 //thickness=0.18 //x=51 //y=0.93 //x2=50.885 //y2=0.93
r753 (  224 266 ) resistor r=5.52526 //w=0.168 //l=0.115 //layer=ply \
 //thickness=0.18 //x=51.22 //y=0.93 //x2=51.335 //y2=0.93
r754 (  224 225 ) resistor r=112.809 //w=0.094 //l=0.22 //layer=ply \
 //thickness=0.18 //x=51.22 //y=0.93 //x2=51 //y2=0.93
r755 (  223 262 ) resistor r=16.5046 //w=0.27 //l=0.135 //layer=ply \
 //thickness=0.18 //x=50.975 //y=4.97 //x2=50.84 //y2=4.97
r756 (  222 229 ) resistor r=26.9307 //w=0.15 //l=0.106066 //layer=ply \
 //thickness=0.18 //x=51.215 //y=4.97 //x2=51.29 //y2=5.045
r757 (  222 223 ) resistor r=123.064 //w=0.094 //l=0.24 //layer=ply \
 //thickness=0.18 //x=51.215 //y=4.97 //x2=50.975 //y2=4.97
r758 (  217 265 ) resistor r=39.5823 //w=0.21 //l=0.173853 //layer=ply \
 //thickness=0.18 //x=50.845 //y=1.74 //x2=50.885 //y2=1.585
r759 (  217 257 ) resistor r=182.032 //w=0.094 //l=0.355 //layer=ply \
 //thickness=0.18 //x=50.845 //y=1.74 //x2=50.845 //y2=2.095
r760 (  216 265 ) resistor r=39.5823 //w=0.21 //l=0.173853 //layer=ply \
 //thickness=0.18 //x=50.845 //y=1.43 //x2=50.885 //y2=1.585
r761 (  215 264 ) resistor r=45.1352 //w=0.168 //l=0.173853 //layer=ply \
 //thickness=0.18 //x=50.845 //y=1.085 //x2=50.885 //y2=0.93
r762 (  215 216 ) resistor r=176.904 //w=0.094 //l=0.345 //layer=ply \
 //thickness=0.18 //x=50.845 //y=1.085 //x2=50.845 //y2=1.43
r763 (  214 254 ) resistor r=45.1352 //w=0.168 //l=0.173853 //layer=ply \
 //thickness=0.18 //x=38.425 //y=1.43 //x2=38.385 //y2=1.585
r764 (  213 253 ) resistor r=45.1352 //w=0.168 //l=0.173853 //layer=ply \
 //thickness=0.18 //x=38.425 //y=1.085 //x2=38.385 //y2=0.93
r765 (  213 214 ) resistor r=176.904 //w=0.094 //l=0.345 //layer=ply \
 //thickness=0.18 //x=38.425 //y=1.085 //x2=38.425 //y2=1.43
r766 (  208 252 ) resistor r=10.701 //w=0.21 //l=0.115 //layer=ply \
 //thickness=0.18 //x=38.05 //y=1.585 //x2=37.935 //y2=1.585
r767 (  207 254 ) resistor r=5.52526 //w=0.168 //l=0.115 //layer=ply \
 //thickness=0.18 //x=38.27 //y=1.585 //x2=38.385 //y2=1.585
r768 (  206 251 ) resistor r=5.52526 //w=0.168 //l=0.115 //layer=ply \
 //thickness=0.18 //x=38.05 //y=0.93 //x2=37.935 //y2=0.93
r769 (  205 253 ) resistor r=5.52526 //w=0.168 //l=0.115 //layer=ply \
 //thickness=0.18 //x=38.27 //y=0.93 //x2=38.385 //y2=0.93
r770 (  205 206 ) resistor r=112.809 //w=0.094 //l=0.22 //layer=ply \
 //thickness=0.18 //x=38.27 //y=0.93 //x2=38.05 //y2=0.93
r771 (  204 249 ) resistor r=16.5046 //w=0.27 //l=0.135 //layer=ply \
 //thickness=0.18 //x=38.025 //y=4.97 //x2=37.89 //y2=4.97
r772 (  203 210 ) resistor r=26.9307 //w=0.15 //l=0.106066 //layer=ply \
 //thickness=0.18 //x=38.265 //y=4.97 //x2=38.34 //y2=5.045
r773 (  203 204 ) resistor r=123.064 //w=0.094 //l=0.24 //layer=ply \
 //thickness=0.18 //x=38.265 //y=4.97 //x2=38.025 //y2=4.97
r774 (  198 252 ) resistor r=39.5823 //w=0.21 //l=0.173853 //layer=ply \
 //thickness=0.18 //x=37.895 //y=1.74 //x2=37.935 //y2=1.585
r775 (  198 244 ) resistor r=182.032 //w=0.094 //l=0.355 //layer=ply \
 //thickness=0.18 //x=37.895 //y=1.74 //x2=37.895 //y2=2.095
r776 (  197 252 ) resistor r=39.5823 //w=0.21 //l=0.173853 //layer=ply \
 //thickness=0.18 //x=37.895 //y=1.43 //x2=37.935 //y2=1.585
r777 (  196 251 ) resistor r=45.1352 //w=0.168 //l=0.173853 //layer=ply \
 //thickness=0.18 //x=37.895 //y=1.085 //x2=37.935 //y2=0.93
r778 (  196 197 ) resistor r=176.904 //w=0.094 //l=0.345 //layer=ply \
 //thickness=0.18 //x=37.895 //y=1.085 //x2=37.895 //y2=1.43
r779 (  191 193 ) resistor r=26.9307 //w=0.15 //l=0.106066 //layer=ply \
 //thickness=0.18 //x=28.065 //y=4.97 //x2=28.14 //y2=5.045
r780 (  191 192 ) resistor r=148.702 //w=0.094 //l=0.29 //layer=ply \
 //thickness=0.18 //x=28.065 //y=4.97 //x2=27.775 //y2=4.97
r781 (  190 241 ) resistor r=45.1352 //w=0.168 //l=0.173853 //layer=ply \
 //thickness=0.18 //x=27.73 //y=1.4 //x2=27.69 //y2=1.555
r782 (  189 240 ) resistor r=45.1352 //w=0.168 //l=0.173853 //layer=ply \
 //thickness=0.18 //x=27.73 //y=1.055 //x2=27.69 //y2=0.9
r783 (  189 190 ) resistor r=176.904 //w=0.094 //l=0.345 //layer=ply \
 //thickness=0.18 //x=27.73 //y=1.055 //x2=27.73 //y2=1.4
r784 (  186 192 ) resistor r=22.7971 //w=0.269 //l=0.106066 //layer=ply \
 //thickness=0.18 //x=27.7 //y=5.045 //x2=27.775 //y2=4.97
r785 (  186 239 ) resistor r=35.8364 //w=0.269 //l=0.270185 //layer=ply \
 //thickness=0.18 //x=27.7 //y=5.045 //x2=27.5 //y2=4.88
r786 (  184 235 ) resistor r=10.701 //w=0.21 //l=0.115 //layer=ply \
 //thickness=0.18 //x=27.355 //y=1.555 //x2=27.24 //y2=1.555
r787 (  183 241 ) resistor r=5.52526 //w=0.168 //l=0.115 //layer=ply \
 //thickness=0.18 //x=27.575 //y=1.555 //x2=27.69 //y2=1.555
r788 (  182 234 ) resistor r=5.52526 //w=0.168 //l=0.115 //layer=ply \
 //thickness=0.18 //x=27.355 //y=0.9 //x2=27.24 //y2=0.9
r789 (  181 240 ) resistor r=5.52526 //w=0.168 //l=0.115 //layer=ply \
 //thickness=0.18 //x=27.575 //y=0.9 //x2=27.69 //y2=0.9
r790 (  181 182 ) resistor r=112.809 //w=0.094 //l=0.22 //layer=ply \
 //thickness=0.18 //x=27.575 //y=0.9 //x2=27.355 //y2=0.9
r791 (  180 237 ) resistor r=58.7805 //w=0.246 //l=0.373497 //layer=ply \
 //thickness=0.18 //x=27.2 //y=2.095 //x2=27.5 //y2=2.26
r792 (  179 235 ) resistor r=39.5823 //w=0.21 //l=0.173853 //layer=ply \
 //thickness=0.18 //x=27.2 //y=1.71 //x2=27.24 //y2=1.555
r793 (  179 180 ) resistor r=197.415 //w=0.094 //l=0.385 //layer=ply \
 //thickness=0.18 //x=27.2 //y=1.71 //x2=27.2 //y2=2.095
r794 (  178 235 ) resistor r=39.5823 //w=0.21 //l=0.173853 //layer=ply \
 //thickness=0.18 //x=27.2 //y=1.4 //x2=27.24 //y2=1.555
r795 (  177 234 ) resistor r=45.1352 //w=0.168 //l=0.173853 //layer=ply \
 //thickness=0.18 //x=27.2 //y=1.055 //x2=27.24 //y2=0.9
r796 (  177 178 ) resistor r=176.904 //w=0.094 //l=0.345 //layer=ply \
 //thickness=0.18 //x=27.2 //y=1.055 //x2=27.2 //y2=1.4
r797 (  176 229 ) resistor r=592.245 //w=0.094 //l=1.155 //layer=ply \
 //thickness=0.18 //x=51.29 //y=6.2 //x2=51.29 //y2=5.045
r798 (  175 263 ) resistor r=592.245 //w=0.094 //l=1.155 //layer=ply \
 //thickness=0.18 //x=50.85 //y=6.2 //x2=50.85 //y2=5.045
r799 (  174 210 ) resistor r=592.245 //w=0.094 //l=1.155 //layer=ply \
 //thickness=0.18 //x=38.34 //y=6.2 //x2=38.34 //y2=5.045
r800 (  173 250 ) resistor r=592.245 //w=0.094 //l=1.155 //layer=ply \
 //thickness=0.18 //x=37.9 //y=6.2 //x2=37.9 //y2=5.045
r801 (  172 193 ) resistor r=592.245 //w=0.094 //l=1.155 //layer=ply \
 //thickness=0.18 //x=28.14 //y=6.2 //x2=28.14 //y2=5.045
r802 (  171 186 ) resistor r=592.245 //w=0.094 //l=1.155 //layer=ply \
 //thickness=0.18 //x=27.7 //y=6.2 //x2=27.7 //y2=5.045
r803 (  170 226 ) resistor r=56.4043 //w=0.094 //l=0.11 //layer=ply \
 //thickness=0.18 //x=51.11 //y=1.585 //x2=51.22 //y2=1.585
r804 (  170 227 ) resistor r=56.4043 //w=0.094 //l=0.11 //layer=ply \
 //thickness=0.18 //x=51.11 //y=1.585 //x2=51 //y2=1.585
r805 (  169 207 ) resistor r=56.4043 //w=0.094 //l=0.11 //layer=ply \
 //thickness=0.18 //x=38.16 //y=1.585 //x2=38.27 //y2=1.585
r806 (  169 208 ) resistor r=56.4043 //w=0.094 //l=0.11 //layer=ply \
 //thickness=0.18 //x=38.16 //y=1.585 //x2=38.05 //y2=1.585
r807 (  168 183 ) resistor r=56.4043 //w=0.094 //l=0.11 //layer=ply \
 //thickness=0.18 //x=27.465 //y=1.555 //x2=27.575 //y2=1.555
r808 (  168 184 ) resistor r=56.4043 //w=0.094 //l=0.11 //layer=ply \
 //thickness=0.18 //x=27.465 //y=1.555 //x2=27.355 //y2=1.555
r809 (  164 260 ) resistor r=152 //w=0.17 //l=0.17 //layer=licon //count=1 \
 //x=50.84 //y=4.88 //x2=50.84 //y2=4.88
r810 (  155 256 ) resistor r=152 //w=0.17 //l=0.17 //layer=licon //count=1 \
 //x=50.81 //y=2.26 //x2=50.81 //y2=2.26
r811 (  138 272 ) resistor r=23.615 //w=0.187 //l=0.345 //layer=li \
 //thickness=0.1 //x=42.63 //y=5.56 //x2=42.63 //y2=5.905
r812 (  130 271 ) resistor r=23.615 //w=0.187 //l=0.345 //layer=li \
 //thickness=0.1 //x=41.75 //y=5.56 //x2=41.75 //y2=5.905
r813 (  122 270 ) resistor r=23.615 //w=0.187 //l=0.345 //layer=li \
 //thickness=0.1 //x=40.87 //y=5.56 //x2=40.87 //y2=5.905
r814 (  117 247 ) resistor r=152 //w=0.17 //l=0.17 //layer=licon //count=1 \
 //x=37.89 //y=4.88 //x2=37.89 //y2=4.88
r815 (  108 243 ) resistor r=152 //w=0.17 //l=0.17 //layer=licon //count=1 \
 //x=37.86 //y=2.26 //x2=37.86 //y2=2.26
r816 (  103 239 ) resistor r=152 //w=0.17 //l=0.17 //layer=licon //count=1 \
 //x=27.5 //y=4.88 //x2=27.5 //y2=4.88
r817 (  94 237 ) resistor r=152 //w=0.17 //l=0.17 //layer=licon //count=1 \
 //x=27.5 //y=2.26 //x2=27.5 //y2=2.26
r818 (  84 86 ) resistor r=0.10734 //w=0.281 //l=0.16 //layer=m2 \
 //thickness=0.36 //x=27.5 //y=4.26 //x2=27.66 //y2=4.26
r819 (  82 90 ) resistor r=1.08991 //w=0.196 //l=1.70999 //layer=m2 \
 //thickness=0.36 //x=45.12 //y=4.265 //x2=43.415 //y2=4.255
r820 (  81 92 ) resistor r=3.726 //w=0.179 //l=5.34 //layer=m2 \
 //thickness=0.36 //x=45.465 //y=4.265 //x2=50.8 //y2=4.255
r821 (  81 82 ) resistor r=0.329198 //w=0.131 //l=0.345 //layer=m2 \
 //thickness=0.36 //x=45.465 //y=4.265 //x2=45.12 //y2=4.265
r822 (  80 88 ) resistor r=0.112172 //w=0.179 //l=0.16 //layer=m2 \
 //thickness=0.36 //x=38.025 //y=4.25 //x2=37.865 //y2=4.25
r823 (  79 90 ) resistor r=0.104578 //w=0.196 //l=0.162481 //layer=m2 \
 //thickness=0.36 //x=43.255 //y=4.25 //x2=43.415 //y2=4.255
r824 (  79 80 ) resistor r=4.99046 //w=0.131 //l=5.23 //layer=m2 \
 //thickness=0.36 //x=43.255 //y=4.25 //x2=38.025 //y2=4.25
r825 (  77 88 ) resistor r=3.726 //w=0.179 //l=5.34249 //layer=m2 \
 //thickness=0.36 //x=32.53 //y=4.265 //x2=37.865 //y2=4.25
r826 (  77 78 ) resistor r=0.329198 //w=0.131 //l=0.345 //layer=m2 \
 //thickness=0.36 //x=32.53 //y=4.265 //x2=32.185 //y2=4.265
r827 (  75 78 ) resistor r=0.1875 //w=0.17 //l=0.262393 //layer=m2 \
 //thickness=0.36 //x=31.93 //y=4.25 //x2=32.185 //y2=4.265
r828 (  75 76 ) resistor r=0.997137 //w=0.131 //l=1.045 //layer=m2 \
 //thickness=0.36 //x=31.93 //y=4.25 //x2=30.885 //y2=4.25
r829 (  73 76 ) resistor r=0.125 //w=0.17 //l=0.179722 //layer=m2 \
 //thickness=0.36 //x=30.715 //y=4.27 //x2=30.885 //y2=4.25
r830 (  73 74 ) resistor r=0.367366 //w=0.131 //l=0.385 //layer=m2 \
 //thickness=0.36 //x=30.715 //y=4.27 //x2=30.33 //y2=4.27
r831 (  71 74 ) resistor r=0.1875 //w=0.17 //l=0.264811 //layer=m2 \
 //thickness=0.36 //x=30.075 //y=4.25 //x2=30.33 //y2=4.27
r832 (  71 86 ) resistor r=2.30439 //w=0.131 //l=2.415 //layer=m2 \
 //thickness=0.36 //x=30.075 //y=4.25 //x2=27.66 //y2=4.25
r833 (  70 164 ) resistor r=9.3 //w=0.17 //l=0.17 //layer=mcon //count=1 \
 //x=50.84 //y=4.88 //x2=50.84 //y2=4.88
r834 (  66 155 ) resistor r=9.3 //w=0.17 //l=0.17 //layer=mcon //count=1 \
 //x=50.81 //y=2.26 //x2=50.81 //y2=2.26
r835 (  66 68 ) resistor r=0.0936408 //w=0.196 //l=0.125 //layer=m1 \
 //thickness=0.36 //x=50.812 //y=2.26 //x2=50.812 //y2=2.385
r836 (  64 92 ) resistor r=4.5 //w=0.15 //l=0.15 //layer=via1 //count=1 \
 //x=50.8 //y=4.255 //x2=50.8 //y2=4.255
r837 (  62 64 ) resistor r=0.00168464 //w=0.371 //l=0.005 //layer=m1 \
 //thickness=0.36 //x=50.752 //y=4.25 //x2=50.752 //y2=4.255
r838 (  60 90 ) resistor r=4.5 //w=0.15 //l=0.15 //layer=via1 //count=1 \
 //x=43.415 //y=4.255 //x2=43.415 //y2=4.255
r839 (  58 60 ) resistor r=0.00164908 //w=0.379 //l=0.005 //layer=m1 \
 //thickness=0.36 //x=43.36 //y=4.25 //x2=43.36 //y2=4.255
r840 (  56 268 ) resistor r=9.3 //w=0.17 //l=0.17 //layer=mcon //count=1 \
 //x=42.925 //y=1.19 //x2=42.925 //y2=1.19
r841 (  54 138 ) resistor r=9.3 //w=0.17 //l=0.17 //layer=mcon //count=1 \
 //x=42.63 //y=5.56 //x2=42.63 //y2=5.56
r842 (  51 130 ) resistor r=9.3 //w=0.17 //l=0.17 //layer=mcon //count=1 \
 //x=41.75 //y=5.56 //x2=41.75 //y2=5.56
r843 (  49 51 ) resistor r=0.121228 //w=0.232 //l=0.225 //layer=m1 \
 //thickness=0.36 //x=41.75 //y=5.335 //x2=41.75 //y2=5.56
r844 (  48 122 ) resistor r=9.3 //w=0.17 //l=0.17 //layer=mcon //count=1 \
 //x=40.87 //y=5.56 //x2=40.87 //y2=5.56
r845 (  46 48 ) resistor r=0.129608 //w=0.217 //l=0.225 //layer=m1 \
 //thickness=0.36 //x=40.872 //y=5.335 //x2=40.872 //y2=5.56
r846 (  45 117 ) resistor r=9.3 //w=0.17 //l=0.17 //layer=mcon //count=1 \
 //x=37.89 //y=4.88 //x2=37.89 //y2=4.88
r847 (  41 108 ) resistor r=9.3 //w=0.17 //l=0.17 //layer=mcon //count=1 \
 //x=37.86 //y=2.26 //x2=37.86 //y2=2.26
r848 (  41 43 ) resistor r=0.0936408 //w=0.196 //l=0.125 //layer=m1 \
 //thickness=0.36 //x=37.862 //y=2.26 //x2=37.862 //y2=2.385
r849 (  38 88 ) resistor r=4.5 //w=0.15 //l=0.15 //layer=via1 //count=1 \
 //x=37.865 //y=4.25 //x2=37.865 //y2=4.25
r850 (  36 84 ) resistor r=4.5 //w=0.15 //l=0.15 //layer=via1 //count=1 \
 //x=27.5 //y=4.26 //x2=27.5 //y2=4.26
r851 (  34 36 ) resistor r=0.00332447 //w=0.376 //l=0.01 //layer=m1 \
 //thickness=0.36 //x=27.552 //y=4.25 //x2=27.552 //y2=4.26
r852 (  32 103 ) resistor r=9.3 //w=0.17 //l=0.17 //layer=mcon //count=1 \
 //x=27.5 //y=4.88 //x2=27.5 //y2=4.88
r853 (  30 94 ) resistor r=9.3 //w=0.17 //l=0.17 //layer=mcon //count=1 \
 //x=27.5 //y=2.26 //x2=27.5 //y2=2.26
r854 (  28 70 ) resistor r=0.0878548 //w=0.228 //l=0.159295 //layer=m1 \
 //thickness=0.36 //x=50.81 //y=4.735 //x2=50.84 //y2=4.88
r855 (  27 64 ) resistor r=0.0909648 //w=0.371 //l=0.186762 //layer=m1 \
 //thickness=0.36 //x=50.81 //y=4.415 //x2=50.752 //y2=4.255
r856 (  27 28 ) resistor r=0.305344 //w=0.131 //l=0.32 //layer=m1 \
 //thickness=0.36 //x=50.81 //y=4.415 //x2=50.81 //y2=4.735
r857 (  26 62 ) resistor r=0.0892801 //w=0.371 //l=0.1817 //layer=m1 \
 //thickness=0.36 //x=50.81 //y=4.095 //x2=50.752 //y2=4.25
r858 (  26 68 ) resistor r=1.63168 //w=0.131 //l=1.71 //layer=m1 \
 //thickness=0.36 //x=50.81 //y=4.095 //x2=50.81 //y2=2.385
r859 (  23 60 ) resistor r=0.0912814 //w=0.379 //l=0.183303 //layer=m1 \
 //thickness=0.36 //x=43.41 //y=4.415 //x2=43.36 //y2=4.255
r860 (  23 24 ) resistor r=0.796756 //w=0.131 //l=0.835 //layer=m1 \
 //thickness=0.36 //x=43.41 //y=4.415 //x2=43.41 //y2=5.25
r861 (  22 58 ) resistor r=0.0896323 //w=0.379 //l=0.178255 //layer=m1 \
 //thickness=0.36 //x=43.41 //y=4.095 //x2=43.36 //y2=4.25
r862 (  21 22 ) resistor r=2.06584 //w=0.131 //l=2.165 //layer=m1 \
 //thickness=0.36 //x=43.41 //y=1.93 //x2=43.41 //y2=4.095
r863 (  19 21 ) resistor r=0.0698411 //w=0.17 //l=0.120208 //layer=m1 \
 //thickness=0.36 //x=43.325 //y=1.845 //x2=43.41 //y2=1.93
r864 (  19 20 ) resistor r=0.300573 //w=0.131 //l=0.315 //layer=m1 \
 //thickness=0.36 //x=43.325 //y=1.845 //x2=43.01 //y2=1.845
r865 (  18 20 ) resistor r=0.0698411 //w=0.17 //l=0.120208 //layer=m1 \
 //thickness=0.36 //x=42.925 //y=1.76 //x2=43.01 //y2=1.845
r866 (  17 56 ) resistor r=0.0717383 //w=0.224 //l=0.115 //layer=m1 \
 //thickness=0.36 //x=42.925 //y=1.305 //x2=42.925 //y2=1.19
r867 (  17 18 ) resistor r=0.43416 //w=0.131 //l=0.455 //layer=m1 \
 //thickness=0.36 //x=42.925 //y=1.305 //x2=42.925 //y2=1.76
r868 (  16 52 ) resistor r=0.0675342 //w=0.23 //l=0.115 //layer=m1 \
 //thickness=0.36 //x=42.745 //y=5.335 //x2=42.63 //y2=5.335
r869 (  15 24 ) resistor r=0.0698411 //w=0.17 //l=0.120208 //layer=m1 \
 //thickness=0.36 //x=43.325 //y=5.335 //x2=43.41 //y2=5.25
r870 (  15 16 ) resistor r=0.553435 //w=0.131 //l=0.58 //layer=m1 \
 //thickness=0.36 //x=43.325 //y=5.335 //x2=42.745 //y2=5.335
r871 (  14 54 ) resistor r=0.00118313 //w=0.23 //layer=m1 //thickness=0.36 \
 //x=42.63 //y=5.56 //x2=42.63 //y2=5.56
r872 (  13 52 ) resistor r=0.002872 //w=0.34 //l=0.085 //layer=m1 \
 //thickness=0.36 //x=42.63 //y=5.42 //x2=42.63 //y2=5.335
r873 (  13 14 ) resistor r=0.091623 //w=0.191 //l=0.14 //layer=m1 \
 //thickness=0.36 //x=42.63 //y=5.42 //x2=42.63 //y2=5.56
r874 (  12 49 ) resistor r=0.0262263 //w=0.232 //l=0.12 //layer=m1 \
 //thickness=0.36 //x=41.87 //y=5.335 //x2=41.75 //y2=5.335
r875 (  11 52 ) resistor r=0.0675342 //w=0.23 //l=0.115 //layer=m1 \
 //thickness=0.36 //x=42.515 //y=5.335 //x2=42.63 //y2=5.335
r876 (  11 12 ) resistor r=0.615458 //w=0.131 //l=0.645 //layer=m1 \
 //thickness=0.36 //x=42.515 //y=5.335 //x2=41.87 //y2=5.335
r877 (  10 46 ) resistor r=0.0222262 //w=0.217 //l=0.118 //layer=m1 \
 //thickness=0.36 //x=40.99 //y=5.335 //x2=40.872 //y2=5.335
r878 (  9 49 ) resistor r=0.0262263 //w=0.232 //l=0.12 //layer=m1 \
 //thickness=0.36 //x=41.63 //y=5.335 //x2=41.75 //y2=5.335
r879 (  9 10 ) resistor r=0.610687 //w=0.131 //l=0.64 //layer=m1 \
 //thickness=0.36 //x=41.63 //y=5.335 //x2=40.99 //y2=5.335
r880 (  8 45 ) resistor r=0.0878548 //w=0.228 //l=0.159295 //layer=m1 \
 //thickness=0.36 //x=37.86 //y=4.735 //x2=37.89 //y2=4.88
r881 (  7 38 ) resistor r=0.0912814 //w=0.379 //l=0.183303 //layer=m1 \
 //thickness=0.36 //x=37.86 //y=4.41 //x2=37.81 //y2=4.25
r882 (  7 8 ) resistor r=0.310115 //w=0.131 //l=0.325 //layer=m1 \
 //thickness=0.36 //x=37.86 //y=4.41 //x2=37.86 //y2=4.735
r883 (  6 38 ) resistor r=0.0912814 //w=0.379 //l=0.183303 //layer=m1 \
 //thickness=0.36 //x=37.86 //y=4.09 //x2=37.81 //y2=4.25
r884 (  6 43 ) resistor r=1.62691 //w=0.131 //l=1.705 //layer=m1 \
 //thickness=0.36 //x=37.86 //y=4.09 //x2=37.86 //y2=2.385
r885 (  4 32 ) resistor r=0.0760407 //w=0.238 //l=0.125 //layer=m1 \
 //thickness=0.36 //x=27.5 //y=4.755 //x2=27.5 //y2=4.88
r886 (  3 36 ) resistor r=0.0911593 //w=0.376 //l=0.184174 //layer=m1 \
 //thickness=0.36 //x=27.5 //y=4.42 //x2=27.552 //y2=4.26
r887 (  3 4 ) resistor r=0.319656 //w=0.131 //l=0.335 //layer=m1 \
 //thickness=0.36 //x=27.5 //y=4.42 //x2=27.5 //y2=4.755
r888 (  2 34 ) resistor r=0.0878349 //w=0.376 //l=0.174069 //layer=m1 \
 //thickness=0.36 //x=27.5 //y=4.1 //x2=27.552 //y2=4.25
r889 (  1 30 ) resistor r=0.0719237 //w=0.222 //l=0.115 //layer=m1 \
 //thickness=0.36 //x=27.5 //y=2.375 //x2=27.5 //y2=2.26
r890 (  1 2 ) resistor r=1.64599 //w=0.131 //l=1.725 //layer=m1 \
 //thickness=0.36 //x=27.5 //y=2.375 //x2=27.5 //y2=4.1
ends PM_TMRDFFRNQNX1\%noxref_10

subckt PM_TMRDFFRNQNX1\%CLK ( 1 2 3 4 5 6 7 8 9 10 11 12 13 14 15 16 17 24 28 \
 33 36 40 41 45 52 58 65 71 78 81 83 85 86 87 89 91 93 95 96 97 98 99 101 103 \
 105 107 108 109 123 128 133 138 143 148 153 158 163 168 173 178 182 183 184 \
 185 186 187 188 189 190 191 192 193 194 195 196 197 198 199 200 201 202 204 \
 210 211 212 213 214 219 220 221 223 229 230 231 232 233 238 239 240 242 248 \
 249 250 251 252 257 258 259 261 267 268 269 270 271 276 277 278 280 286 287 \
 288 289 290 295 296 297 299 305 306 307 308 309 317 328 339 350 361 372 )
c1037 ( 372 0 ) capacitor c=0.0356502f //x=67.46 //y=4.88
c1038 ( 361 0 ) capacitor c=0.0357436f //x=54.51 //y=4.88
c1039 ( 350 0 ) capacitor c=0.0356502f //x=41.56 //y=4.88
c1040 ( 339 0 ) capacitor c=0.0357436f //x=28.61 //y=4.88
c1041 ( 328 0 ) capacitor c=0.0356502f //x=15.66 //y=4.88
c1042 ( 317 0 ) capacitor c=0.0356344f //x=2.71 //y=4.88
c1043 ( 309 0 ) capacitor c=0.0306876f //x=67.795 //y=4.97
c1044 ( 308 0 ) capacitor c=0.0863671f //x=67.55 //y=2.095
c1045 ( 307 0 ) capacitor c=0.0170266f //x=67.55 //y=1.63
c1046 ( 306 0 ) capacitor c=0.018609f //x=67.55 //y=1.4
c1047 ( 305 0 ) capacitor c=0.0186599f //x=67.55 //y=1.09
c1048 ( 299 0 ) capacitor c=0.0146988f //x=67.395 //y=1.555
c1049 ( 297 0 ) capacitor c=0.0148531f //x=67.395 //y=0.935
c1050 ( 296 0 ) capacitor c=0.0334406f //x=67.025 //y=1.4
c1051 ( 295 0 ) capacitor c=0.0173191f //x=67.025 //y=1.09
c1052 ( 290 0 ) capacitor c=0.0306608f //x=54.845 //y=4.97
c1053 ( 289 0 ) capacitor c=0.0863671f //x=54.6 //y=2.095
c1054 ( 288 0 ) capacitor c=0.0170266f //x=54.6 //y=1.63
c1055 ( 287 0 ) capacitor c=0.018609f //x=54.6 //y=1.4
c1056 ( 286 0 ) capacitor c=0.0186599f //x=54.6 //y=1.09
c1057 ( 280 0 ) capacitor c=0.0146988f //x=54.445 //y=1.555
c1058 ( 278 0 ) capacitor c=0.0148531f //x=54.445 //y=0.935
c1059 ( 277 0 ) capacitor c=0.0334406f //x=54.075 //y=1.4
c1060 ( 276 0 ) capacitor c=0.0173191f //x=54.075 //y=1.09
c1061 ( 271 0 ) capacitor c=0.0306876f //x=41.895 //y=4.97
c1062 ( 270 0 ) capacitor c=0.0863671f //x=41.65 //y=2.095
c1063 ( 269 0 ) capacitor c=0.0170266f //x=41.65 //y=1.63
c1064 ( 268 0 ) capacitor c=0.018609f //x=41.65 //y=1.4
c1065 ( 267 0 ) capacitor c=0.0186599f //x=41.65 //y=1.09
c1066 ( 261 0 ) capacitor c=0.0146988f //x=41.495 //y=1.555
c1067 ( 259 0 ) capacitor c=0.0148531f //x=41.495 //y=0.935
c1068 ( 258 0 ) capacitor c=0.0334406f //x=41.125 //y=1.4
c1069 ( 257 0 ) capacitor c=0.0173191f //x=41.125 //y=1.09
c1070 ( 252 0 ) capacitor c=0.0306608f //x=28.945 //y=4.97
c1071 ( 251 0 ) capacitor c=0.0863671f //x=28.7 //y=2.095
c1072 ( 250 0 ) capacitor c=0.0170266f //x=28.7 //y=1.63
c1073 ( 249 0 ) capacitor c=0.018609f //x=28.7 //y=1.4
c1074 ( 248 0 ) capacitor c=0.0186599f //x=28.7 //y=1.09
c1075 ( 242 0 ) capacitor c=0.0146988f //x=28.545 //y=1.555
c1076 ( 240 0 ) capacitor c=0.0148531f //x=28.545 //y=0.935
c1077 ( 239 0 ) capacitor c=0.0334406f //x=28.175 //y=1.4
c1078 ( 238 0 ) capacitor c=0.0173191f //x=28.175 //y=1.09
c1079 ( 233 0 ) capacitor c=0.0306876f //x=15.995 //y=4.97
c1080 ( 232 0 ) capacitor c=0.0863671f //x=15.75 //y=2.095
c1081 ( 231 0 ) capacitor c=0.0170266f //x=15.75 //y=1.63
c1082 ( 230 0 ) capacitor c=0.018609f //x=15.75 //y=1.4
c1083 ( 229 0 ) capacitor c=0.0186599f //x=15.75 //y=1.09
c1084 ( 223 0 ) capacitor c=0.0146988f //x=15.595 //y=1.555
c1085 ( 221 0 ) capacitor c=0.0148531f //x=15.595 //y=0.935
c1086 ( 220 0 ) capacitor c=0.0334406f //x=15.225 //y=1.4
c1087 ( 219 0 ) capacitor c=0.0173191f //x=15.225 //y=1.09
c1088 ( 214 0 ) capacitor c=0.0306608f //x=3.045 //y=4.97
c1089 ( 213 0 ) capacitor c=0.0863671f //x=2.8 //y=2.095
c1090 ( 212 0 ) capacitor c=0.0170266f //x=2.8 //y=1.63
c1091 ( 211 0 ) capacitor c=0.018609f //x=2.8 //y=1.4
c1092 ( 210 0 ) capacitor c=0.0186599f //x=2.8 //y=1.09
c1093 ( 204 0 ) capacitor c=0.0146988f //x=2.645 //y=1.555
c1094 ( 202 0 ) capacitor c=0.0148531f //x=2.645 //y=0.935
c1095 ( 201 0 ) capacitor c=0.0334406f //x=2.275 //y=1.4
c1096 ( 200 0 ) capacitor c=0.0173191f //x=2.275 //y=1.09
c1097 ( 199 0 ) capacitor c=0.110208f //x=67.87 //y=6.2
c1098 ( 198 0 ) capacitor c=0.110214f //x=67.43 //y=6.2
c1099 ( 197 0 ) capacitor c=0.110208f //x=54.92 //y=6.2
c1100 ( 196 0 ) capacitor c=0.110214f //x=54.48 //y=6.2
c1101 ( 195 0 ) capacitor c=0.110208f //x=41.97 //y=6.2
c1102 ( 194 0 ) capacitor c=0.110214f //x=41.53 //y=6.2
c1103 ( 193 0 ) capacitor c=0.110208f //x=29.02 //y=6.2
c1104 ( 192 0 ) capacitor c=0.110214f //x=28.58 //y=6.2
c1105 ( 191 0 ) capacitor c=0.110208f //x=16.07 //y=6.2
c1106 ( 190 0 ) capacitor c=0.110214f //x=15.63 //y=6.2
c1107 ( 189 0 ) capacitor c=0.110208f //x=3.12 //y=6.2
c1108 ( 188 0 ) capacitor c=0.110214f //x=2.68 //y=6.2
c1109 ( 178 0 ) capacitor c=0.00129935f //x=67.46 //y=4.88
c1110 ( 173 0 ) capacitor c=0.00121786f //x=67.46 //y=2.26
c1111 ( 168 0 ) capacitor c=0.00129935f //x=54.51 //y=4.88
c1112 ( 163 0 ) capacitor c=0.00121786f //x=54.51 //y=2.26
c1113 ( 158 0 ) capacitor c=0.00129935f //x=41.56 //y=4.88
c1114 ( 153 0 ) capacitor c=0.00121786f //x=41.56 //y=2.26
c1115 ( 148 0 ) capacitor c=0.00129935f //x=28.61 //y=4.88
c1116 ( 143 0 ) capacitor c=0.00121786f //x=28.61 //y=2.26
c1117 ( 138 0 ) capacitor c=0.00129935f //x=15.66 //y=4.88
c1118 ( 133 0 ) capacitor c=0.00121786f //x=15.66 //y=2.26
c1119 ( 128 0 ) capacitor c=0.00129935f //x=2.71 //y=4.88
c1120 ( 123 0 ) capacitor c=0.00121786f //x=2.71 //y=2.26
c1121 ( 109 0 ) capacitor c=0.00444424f //x=2.705 //y=4.62
c1122 ( 108 0 ) capacitor c=0.24025f //x=63.635 //y=4.635
c1123 ( 107 0 ) capacitor c=0.0990677f //x=63.98 //y=4.635
c1124 ( 105 0 ) capacitor c=0.00751925f //x=53.615 //y=4.645
c1125 ( 103 0 ) capacitor c=0.0716828f //x=53.015 //y=4.62
c1126 ( 101 0 ) capacitor c=0.0100813f //x=51.015 //y=4.64
c1127 ( 99 0 ) capacitor c=0.17007f //x=50.415 //y=4.62
c1128 ( 98 0 ) capacitor c=0.12735f //x=43.285 //y=4.64
c1129 ( 97 0 ) capacitor c=0.0147164f //x=43.63 //y=4.64
c1130 ( 96 0 ) capacitor c=0.2402f //x=37.735 //y=4.635
c1131 ( 95 0 ) capacitor c=0.00466941f //x=38.08 //y=4.635
c1132 ( 93 0 ) capacitor c=0.00751925f //x=27.715 //y=4.645
c1133 ( 91 0 ) capacitor c=0.0755386f //x=27.115 //y=4.62
c1134 ( 89 0 ) capacitor c=0.0105682f //x=25.115 //y=4.64
c1135 ( 87 0 ) capacitor c=0.169026f //x=24.515 //y=4.62
c1136 ( 86 0 ) capacitor c=0.12735f //x=17.385 //y=4.64
c1137 ( 85 0 ) capacitor c=0.0147164f //x=17.73 //y=4.64
c1138 ( 83 0 ) capacitor c=0.00466941f //x=12.18 //y=4.635
c1139 ( 81 0 ) capacitor c=0.21766f //x=11.58 //y=4.62
c1140 ( 78 0 ) capacitor c=0.0115855f //x=67.455 //y=4.695
c1141 ( 71 0 ) capacitor c=0.00779217f //x=54.505 //y=4.835
c1142 ( 65 0 ) capacitor c=0.0115855f //x=41.555 //y=4.695
c1143 ( 58 0 ) capacitor c=0.00779217f //x=28.605 //y=4.835
c1144 ( 52 0 ) capacitor c=0.0115855f //x=15.655 //y=4.695
c1145 ( 45 0 ) capacitor c=0.00785249f //x=2.705 //y=4.835
c1146 ( 41 0 ) capacitor c=0.0600974f //x=67.46 //y=4.535
c1147 ( 40 0 ) capacitor c=0.00382585f //x=67.46 //y=2.375
c1148 ( 36 0 ) capacitor c=0.00380207f //x=54.51 //y=2.375
c1149 ( 33 0 ) capacitor c=0.00382585f //x=41.56 //y=2.375
c1150 ( 28 0 ) capacitor c=0.00380207f //x=28.61 //y=2.375
c1151 ( 24 0 ) capacitor c=0.00382585f //x=15.66 //y=2.375
c1152 ( 17 0 ) capacitor c=0.0056477f //x=2.71 //y=2.375
c1153 ( 12 0 ) capacitor c=0.0607593f //x=54.51 //y=3.88
c1154 ( 11 0 ) capacitor c=0.0595144f //x=41.56 //y=3.51
c1155 ( 8 0 ) capacitor c=0.0614609f //x=28.61 //y=3.51
c1156 ( 6 0 ) capacitor c=0.0620551f //x=15.66 //y=3.14
c1157 ( 1 0 ) capacitor c=0.0668824f //x=2.71 //y=2.77
r1158 (  374 375 ) resistor r=32.4568 //w=0.214 //l=0.075 //layer=ply \
 //thickness=0.18 //x=67.46 //y=4.97 //x2=67.46 //y2=5.045
r1159 (  372 374 ) resistor r=20.271 //w=0.214 //l=0.09 //layer=ply \
 //thickness=0.18 //x=67.46 //y=4.88 //x2=67.46 //y2=4.97
r1160 (  363 364 ) resistor r=32.4568 //w=0.214 //l=0.075 //layer=ply \
 //thickness=0.18 //x=54.51 //y=4.97 //x2=54.51 //y2=5.045
r1161 (  361 363 ) resistor r=20.271 //w=0.214 //l=0.09 //layer=ply \
 //thickness=0.18 //x=54.51 //y=4.88 //x2=54.51 //y2=4.97
r1162 (  352 353 ) resistor r=32.4568 //w=0.214 //l=0.075 //layer=ply \
 //thickness=0.18 //x=41.56 //y=4.97 //x2=41.56 //y2=5.045
r1163 (  350 352 ) resistor r=20.271 //w=0.214 //l=0.09 //layer=ply \
 //thickness=0.18 //x=41.56 //y=4.88 //x2=41.56 //y2=4.97
r1164 (  341 342 ) resistor r=32.4568 //w=0.214 //l=0.075 //layer=ply \
 //thickness=0.18 //x=28.61 //y=4.97 //x2=28.61 //y2=5.045
r1165 (  339 341 ) resistor r=20.271 //w=0.214 //l=0.09 //layer=ply \
 //thickness=0.18 //x=28.61 //y=4.88 //x2=28.61 //y2=4.97
r1166 (  330 331 ) resistor r=32.4568 //w=0.214 //l=0.075 //layer=ply \
 //thickness=0.18 //x=15.66 //y=4.97 //x2=15.66 //y2=5.045
r1167 (  328 330 ) resistor r=20.271 //w=0.214 //l=0.09 //layer=ply \
 //thickness=0.18 //x=15.66 //y=4.88 //x2=15.66 //y2=4.97
r1168 (  319 320 ) resistor r=32.4568 //w=0.214 //l=0.075 //layer=ply \
 //thickness=0.18 //x=2.71 //y=4.97 //x2=2.71 //y2=5.045
r1169 (  317 319 ) resistor r=20.271 //w=0.214 //l=0.09 //layer=ply \
 //thickness=0.18 //x=2.71 //y=4.88 //x2=2.71 //y2=4.97
r1170 (  310 374 ) resistor r=16.5046 //w=0.27 //l=0.135 //layer=ply \
 //thickness=0.18 //x=67.595 //y=4.97 //x2=67.46 //y2=4.97
r1171 (  309 311 ) resistor r=26.9307 //w=0.15 //l=0.106066 //layer=ply \
 //thickness=0.18 //x=67.795 //y=4.97 //x2=67.87 //y2=5.045
r1172 (  309 310 ) resistor r=102.553 //w=0.094 //l=0.2 //layer=ply \
 //thickness=0.18 //x=67.795 //y=4.97 //x2=67.595 //y2=4.97
r1173 (  308 379 ) resistor r=38.6777 //w=0.284 //l=0.198997 //layer=ply \
 //thickness=0.18 //x=67.55 //y=2.095 //x2=67.475 //y2=2.26
r1174 (  307 377 ) resistor r=21.2976 //w=0.217 //l=0.0928709 //layer=ply \
 //thickness=0.18 //x=67.55 //y=1.63 //x2=67.51 //y2=1.555
r1175 (  307 308 ) resistor r=238.436 //w=0.094 //l=0.465 //layer=ply \
 //thickness=0.18 //x=67.55 //y=1.63 //x2=67.55 //y2=2.095
r1176 (  306 377 ) resistor r=39.0671 //w=0.217 //l=0.173853 //layer=ply \
 //thickness=0.18 //x=67.55 //y=1.4 //x2=67.51 //y2=1.555
r1177 (  305 376 ) resistor r=45.1352 //w=0.168 //l=0.173853 //layer=ply \
 //thickness=0.18 //x=67.55 //y=1.09 //x2=67.51 //y2=0.935
r1178 (  305 306 ) resistor r=158.957 //w=0.094 //l=0.31 //layer=ply \
 //thickness=0.18 //x=67.55 //y=1.09 //x2=67.55 //y2=1.4
r1179 (  300 370 ) resistor r=5.52526 //w=0.168 //l=0.115 //layer=ply \
 //thickness=0.18 //x=67.18 //y=1.555 //x2=67.065 //y2=1.555
r1180 (  299 377 ) resistor r=11.4558 //w=0.217 //l=0.115 //layer=ply \
 //thickness=0.18 //x=67.395 //y=1.555 //x2=67.51 //y2=1.555
r1181 (  298 369 ) resistor r=5.52526 //w=0.168 //l=0.115 //layer=ply \
 //thickness=0.18 //x=67.18 //y=0.935 //x2=67.065 //y2=0.935
r1182 (  297 376 ) resistor r=5.52526 //w=0.168 //l=0.115 //layer=ply \
 //thickness=0.18 //x=67.395 //y=0.935 //x2=67.51 //y2=0.935
r1183 (  297 298 ) resistor r=110.245 //w=0.094 //l=0.215 //layer=ply \
 //thickness=0.18 //x=67.395 //y=0.935 //x2=67.18 //y2=0.935
r1184 (  296 370 ) resistor r=45.1352 //w=0.168 //l=0.173853 //layer=ply \
 //thickness=0.18 //x=67.025 //y=1.4 //x2=67.065 //y2=1.555
r1185 (  295 369 ) resistor r=45.1352 //w=0.168 //l=0.173853 //layer=ply \
 //thickness=0.18 //x=67.025 //y=1.09 //x2=67.065 //y2=0.935
r1186 (  295 296 ) resistor r=158.957 //w=0.094 //l=0.31 //layer=ply \
 //thickness=0.18 //x=67.025 //y=1.09 //x2=67.025 //y2=1.4
r1187 (  291 363 ) resistor r=16.5046 //w=0.27 //l=0.135 //layer=ply \
 //thickness=0.18 //x=54.645 //y=4.97 //x2=54.51 //y2=4.97
r1188 (  290 292 ) resistor r=26.9307 //w=0.15 //l=0.106066 //layer=ply \
 //thickness=0.18 //x=54.845 //y=4.97 //x2=54.92 //y2=5.045
r1189 (  290 291 ) resistor r=102.553 //w=0.094 //l=0.2 //layer=ply \
 //thickness=0.18 //x=54.845 //y=4.97 //x2=54.645 //y2=4.97
r1190 (  289 368 ) resistor r=38.6777 //w=0.284 //l=0.198997 //layer=ply \
 //thickness=0.18 //x=54.6 //y=2.095 //x2=54.525 //y2=2.26
r1191 (  288 366 ) resistor r=21.2976 //w=0.217 //l=0.0928709 //layer=ply \
 //thickness=0.18 //x=54.6 //y=1.63 //x2=54.56 //y2=1.555
r1192 (  288 289 ) resistor r=238.436 //w=0.094 //l=0.465 //layer=ply \
 //thickness=0.18 //x=54.6 //y=1.63 //x2=54.6 //y2=2.095
r1193 (  287 366 ) resistor r=39.0671 //w=0.217 //l=0.173853 //layer=ply \
 //thickness=0.18 //x=54.6 //y=1.4 //x2=54.56 //y2=1.555
r1194 (  286 365 ) resistor r=45.1352 //w=0.168 //l=0.173853 //layer=ply \
 //thickness=0.18 //x=54.6 //y=1.09 //x2=54.56 //y2=0.935
r1195 (  286 287 ) resistor r=158.957 //w=0.094 //l=0.31 //layer=ply \
 //thickness=0.18 //x=54.6 //y=1.09 //x2=54.6 //y2=1.4
r1196 (  281 359 ) resistor r=5.52526 //w=0.168 //l=0.115 //layer=ply \
 //thickness=0.18 //x=54.23 //y=1.555 //x2=54.115 //y2=1.555
r1197 (  280 366 ) resistor r=11.4558 //w=0.217 //l=0.115 //layer=ply \
 //thickness=0.18 //x=54.445 //y=1.555 //x2=54.56 //y2=1.555
r1198 (  279 358 ) resistor r=5.52526 //w=0.168 //l=0.115 //layer=ply \
 //thickness=0.18 //x=54.23 //y=0.935 //x2=54.115 //y2=0.935
r1199 (  278 365 ) resistor r=5.52526 //w=0.168 //l=0.115 //layer=ply \
 //thickness=0.18 //x=54.445 //y=0.935 //x2=54.56 //y2=0.935
r1200 (  278 279 ) resistor r=110.245 //w=0.094 //l=0.215 //layer=ply \
 //thickness=0.18 //x=54.445 //y=0.935 //x2=54.23 //y2=0.935
r1201 (  277 359 ) resistor r=45.1352 //w=0.168 //l=0.173853 //layer=ply \
 //thickness=0.18 //x=54.075 //y=1.4 //x2=54.115 //y2=1.555
r1202 (  276 358 ) resistor r=45.1352 //w=0.168 //l=0.173853 //layer=ply \
 //thickness=0.18 //x=54.075 //y=1.09 //x2=54.115 //y2=0.935
r1203 (  276 277 ) resistor r=158.957 //w=0.094 //l=0.31 //layer=ply \
 //thickness=0.18 //x=54.075 //y=1.09 //x2=54.075 //y2=1.4
r1204 (  272 352 ) resistor r=16.5046 //w=0.27 //l=0.135 //layer=ply \
 //thickness=0.18 //x=41.695 //y=4.97 //x2=41.56 //y2=4.97
r1205 (  271 273 ) resistor r=26.9307 //w=0.15 //l=0.106066 //layer=ply \
 //thickness=0.18 //x=41.895 //y=4.97 //x2=41.97 //y2=5.045
r1206 (  271 272 ) resistor r=102.553 //w=0.094 //l=0.2 //layer=ply \
 //thickness=0.18 //x=41.895 //y=4.97 //x2=41.695 //y2=4.97
r1207 (  270 357 ) resistor r=38.6777 //w=0.284 //l=0.198997 //layer=ply \
 //thickness=0.18 //x=41.65 //y=2.095 //x2=41.575 //y2=2.26
r1208 (  269 355 ) resistor r=21.2976 //w=0.217 //l=0.0928709 //layer=ply \
 //thickness=0.18 //x=41.65 //y=1.63 //x2=41.61 //y2=1.555
r1209 (  269 270 ) resistor r=238.436 //w=0.094 //l=0.465 //layer=ply \
 //thickness=0.18 //x=41.65 //y=1.63 //x2=41.65 //y2=2.095
r1210 (  268 355 ) resistor r=39.0671 //w=0.217 //l=0.173853 //layer=ply \
 //thickness=0.18 //x=41.65 //y=1.4 //x2=41.61 //y2=1.555
r1211 (  267 354 ) resistor r=45.1352 //w=0.168 //l=0.173853 //layer=ply \
 //thickness=0.18 //x=41.65 //y=1.09 //x2=41.61 //y2=0.935
r1212 (  267 268 ) resistor r=158.957 //w=0.094 //l=0.31 //layer=ply \
 //thickness=0.18 //x=41.65 //y=1.09 //x2=41.65 //y2=1.4
r1213 (  262 348 ) resistor r=5.52526 //w=0.168 //l=0.115 //layer=ply \
 //thickness=0.18 //x=41.28 //y=1.555 //x2=41.165 //y2=1.555
r1214 (  261 355 ) resistor r=11.4558 //w=0.217 //l=0.115 //layer=ply \
 //thickness=0.18 //x=41.495 //y=1.555 //x2=41.61 //y2=1.555
r1215 (  260 347 ) resistor r=5.52526 //w=0.168 //l=0.115 //layer=ply \
 //thickness=0.18 //x=41.28 //y=0.935 //x2=41.165 //y2=0.935
r1216 (  259 354 ) resistor r=5.52526 //w=0.168 //l=0.115 //layer=ply \
 //thickness=0.18 //x=41.495 //y=0.935 //x2=41.61 //y2=0.935
r1217 (  259 260 ) resistor r=110.245 //w=0.094 //l=0.215 //layer=ply \
 //thickness=0.18 //x=41.495 //y=0.935 //x2=41.28 //y2=0.935
r1218 (  258 348 ) resistor r=45.1352 //w=0.168 //l=0.173853 //layer=ply \
 //thickness=0.18 //x=41.125 //y=1.4 //x2=41.165 //y2=1.555
r1219 (  257 347 ) resistor r=45.1352 //w=0.168 //l=0.173853 //layer=ply \
 //thickness=0.18 //x=41.125 //y=1.09 //x2=41.165 //y2=0.935
r1220 (  257 258 ) resistor r=158.957 //w=0.094 //l=0.31 //layer=ply \
 //thickness=0.18 //x=41.125 //y=1.09 //x2=41.125 //y2=1.4
r1221 (  253 341 ) resistor r=16.5046 //w=0.27 //l=0.135 //layer=ply \
 //thickness=0.18 //x=28.745 //y=4.97 //x2=28.61 //y2=4.97
r1222 (  252 254 ) resistor r=26.9307 //w=0.15 //l=0.106066 //layer=ply \
 //thickness=0.18 //x=28.945 //y=4.97 //x2=29.02 //y2=5.045
r1223 (  252 253 ) resistor r=102.553 //w=0.094 //l=0.2 //layer=ply \
 //thickness=0.18 //x=28.945 //y=4.97 //x2=28.745 //y2=4.97
r1224 (  251 346 ) resistor r=38.6777 //w=0.284 //l=0.198997 //layer=ply \
 //thickness=0.18 //x=28.7 //y=2.095 //x2=28.625 //y2=2.26
r1225 (  250 344 ) resistor r=21.2976 //w=0.217 //l=0.0928709 //layer=ply \
 //thickness=0.18 //x=28.7 //y=1.63 //x2=28.66 //y2=1.555
r1226 (  250 251 ) resistor r=238.436 //w=0.094 //l=0.465 //layer=ply \
 //thickness=0.18 //x=28.7 //y=1.63 //x2=28.7 //y2=2.095
r1227 (  249 344 ) resistor r=39.0671 //w=0.217 //l=0.173853 //layer=ply \
 //thickness=0.18 //x=28.7 //y=1.4 //x2=28.66 //y2=1.555
r1228 (  248 343 ) resistor r=45.1352 //w=0.168 //l=0.173853 //layer=ply \
 //thickness=0.18 //x=28.7 //y=1.09 //x2=28.66 //y2=0.935
r1229 (  248 249 ) resistor r=158.957 //w=0.094 //l=0.31 //layer=ply \
 //thickness=0.18 //x=28.7 //y=1.09 //x2=28.7 //y2=1.4
r1230 (  243 337 ) resistor r=5.52526 //w=0.168 //l=0.115 //layer=ply \
 //thickness=0.18 //x=28.33 //y=1.555 //x2=28.215 //y2=1.555
r1231 (  242 344 ) resistor r=11.4558 //w=0.217 //l=0.115 //layer=ply \
 //thickness=0.18 //x=28.545 //y=1.555 //x2=28.66 //y2=1.555
r1232 (  241 336 ) resistor r=5.52526 //w=0.168 //l=0.115 //layer=ply \
 //thickness=0.18 //x=28.33 //y=0.935 //x2=28.215 //y2=0.935
r1233 (  240 343 ) resistor r=5.52526 //w=0.168 //l=0.115 //layer=ply \
 //thickness=0.18 //x=28.545 //y=0.935 //x2=28.66 //y2=0.935
r1234 (  240 241 ) resistor r=110.245 //w=0.094 //l=0.215 //layer=ply \
 //thickness=0.18 //x=28.545 //y=0.935 //x2=28.33 //y2=0.935
r1235 (  239 337 ) resistor r=45.1352 //w=0.168 //l=0.173853 //layer=ply \
 //thickness=0.18 //x=28.175 //y=1.4 //x2=28.215 //y2=1.555
r1236 (  238 336 ) resistor r=45.1352 //w=0.168 //l=0.173853 //layer=ply \
 //thickness=0.18 //x=28.175 //y=1.09 //x2=28.215 //y2=0.935
r1237 (  238 239 ) resistor r=158.957 //w=0.094 //l=0.31 //layer=ply \
 //thickness=0.18 //x=28.175 //y=1.09 //x2=28.175 //y2=1.4
r1238 (  234 330 ) resistor r=16.5046 //w=0.27 //l=0.135 //layer=ply \
 //thickness=0.18 //x=15.795 //y=4.97 //x2=15.66 //y2=4.97
r1239 (  233 235 ) resistor r=26.9307 //w=0.15 //l=0.106066 //layer=ply \
 //thickness=0.18 //x=15.995 //y=4.97 //x2=16.07 //y2=5.045
r1240 (  233 234 ) resistor r=102.553 //w=0.094 //l=0.2 //layer=ply \
 //thickness=0.18 //x=15.995 //y=4.97 //x2=15.795 //y2=4.97
r1241 (  232 335 ) resistor r=38.6777 //w=0.284 //l=0.198997 //layer=ply \
 //thickness=0.18 //x=15.75 //y=2.095 //x2=15.675 //y2=2.26
r1242 (  231 333 ) resistor r=21.2976 //w=0.217 //l=0.0928709 //layer=ply \
 //thickness=0.18 //x=15.75 //y=1.63 //x2=15.71 //y2=1.555
r1243 (  231 232 ) resistor r=238.436 //w=0.094 //l=0.465 //layer=ply \
 //thickness=0.18 //x=15.75 //y=1.63 //x2=15.75 //y2=2.095
r1244 (  230 333 ) resistor r=39.0671 //w=0.217 //l=0.173853 //layer=ply \
 //thickness=0.18 //x=15.75 //y=1.4 //x2=15.71 //y2=1.555
r1245 (  229 332 ) resistor r=45.1352 //w=0.168 //l=0.173853 //layer=ply \
 //thickness=0.18 //x=15.75 //y=1.09 //x2=15.71 //y2=0.935
r1246 (  229 230 ) resistor r=158.957 //w=0.094 //l=0.31 //layer=ply \
 //thickness=0.18 //x=15.75 //y=1.09 //x2=15.75 //y2=1.4
r1247 (  224 326 ) resistor r=5.52526 //w=0.168 //l=0.115 //layer=ply \
 //thickness=0.18 //x=15.38 //y=1.555 //x2=15.265 //y2=1.555
r1248 (  223 333 ) resistor r=11.4558 //w=0.217 //l=0.115 //layer=ply \
 //thickness=0.18 //x=15.595 //y=1.555 //x2=15.71 //y2=1.555
r1249 (  222 325 ) resistor r=5.52526 //w=0.168 //l=0.115 //layer=ply \
 //thickness=0.18 //x=15.38 //y=0.935 //x2=15.265 //y2=0.935
r1250 (  221 332 ) resistor r=5.52526 //w=0.168 //l=0.115 //layer=ply \
 //thickness=0.18 //x=15.595 //y=0.935 //x2=15.71 //y2=0.935
r1251 (  221 222 ) resistor r=110.245 //w=0.094 //l=0.215 //layer=ply \
 //thickness=0.18 //x=15.595 //y=0.935 //x2=15.38 //y2=0.935
r1252 (  220 326 ) resistor r=45.1352 //w=0.168 //l=0.173853 //layer=ply \
 //thickness=0.18 //x=15.225 //y=1.4 //x2=15.265 //y2=1.555
r1253 (  219 325 ) resistor r=45.1352 //w=0.168 //l=0.173853 //layer=ply \
 //thickness=0.18 //x=15.225 //y=1.09 //x2=15.265 //y2=0.935
r1254 (  219 220 ) resistor r=158.957 //w=0.094 //l=0.31 //layer=ply \
 //thickness=0.18 //x=15.225 //y=1.09 //x2=15.225 //y2=1.4
r1255 (  215 319 ) resistor r=16.5046 //w=0.27 //l=0.135 //layer=ply \
 //thickness=0.18 //x=2.845 //y=4.97 //x2=2.71 //y2=4.97
r1256 (  214 216 ) resistor r=26.9307 //w=0.15 //l=0.106066 //layer=ply \
 //thickness=0.18 //x=3.045 //y=4.97 //x2=3.12 //y2=5.045
r1257 (  214 215 ) resistor r=102.553 //w=0.094 //l=0.2 //layer=ply \
 //thickness=0.18 //x=3.045 //y=4.97 //x2=2.845 //y2=4.97
r1258 (  213 324 ) resistor r=38.6777 //w=0.284 //l=0.198997 //layer=ply \
 //thickness=0.18 //x=2.8 //y=2.095 //x2=2.725 //y2=2.26
r1259 (  212 322 ) resistor r=21.2976 //w=0.217 //l=0.0928709 //layer=ply \
 //thickness=0.18 //x=2.8 //y=1.63 //x2=2.76 //y2=1.555
r1260 (  212 213 ) resistor r=238.436 //w=0.094 //l=0.465 //layer=ply \
 //thickness=0.18 //x=2.8 //y=1.63 //x2=2.8 //y2=2.095
r1261 (  211 322 ) resistor r=39.0671 //w=0.217 //l=0.173853 //layer=ply \
 //thickness=0.18 //x=2.8 //y=1.4 //x2=2.76 //y2=1.555
r1262 (  210 321 ) resistor r=45.1352 //w=0.168 //l=0.173853 //layer=ply \
 //thickness=0.18 //x=2.8 //y=1.09 //x2=2.76 //y2=0.935
r1263 (  210 211 ) resistor r=158.957 //w=0.094 //l=0.31 //layer=ply \
 //thickness=0.18 //x=2.8 //y=1.09 //x2=2.8 //y2=1.4
r1264 (  205 315 ) resistor r=5.52526 //w=0.168 //l=0.115 //layer=ply \
 //thickness=0.18 //x=2.43 //y=1.555 //x2=2.315 //y2=1.555
r1265 (  204 322 ) resistor r=11.4558 //w=0.217 //l=0.115 //layer=ply \
 //thickness=0.18 //x=2.645 //y=1.555 //x2=2.76 //y2=1.555
r1266 (  203 314 ) resistor r=5.52526 //w=0.168 //l=0.115 //layer=ply \
 //thickness=0.18 //x=2.43 //y=0.935 //x2=2.315 //y2=0.935
r1267 (  202 321 ) resistor r=5.52526 //w=0.168 //l=0.115 //layer=ply \
 //thickness=0.18 //x=2.645 //y=0.935 //x2=2.76 //y2=0.935
r1268 (  202 203 ) resistor r=110.245 //w=0.094 //l=0.215 //layer=ply \
 //thickness=0.18 //x=2.645 //y=0.935 //x2=2.43 //y2=0.935
r1269 (  201 315 ) resistor r=45.1352 //w=0.168 //l=0.173853 //layer=ply \
 //thickness=0.18 //x=2.275 //y=1.4 //x2=2.315 //y2=1.555
r1270 (  200 314 ) resistor r=45.1352 //w=0.168 //l=0.173853 //layer=ply \
 //thickness=0.18 //x=2.275 //y=1.09 //x2=2.315 //y2=0.935
r1271 (  200 201 ) resistor r=158.957 //w=0.094 //l=0.31 //layer=ply \
 //thickness=0.18 //x=2.275 //y=1.09 //x2=2.275 //y2=1.4
r1272 (  199 311 ) resistor r=592.245 //w=0.094 //l=1.155 //layer=ply \
 //thickness=0.18 //x=67.87 //y=6.2 //x2=67.87 //y2=5.045
r1273 (  198 375 ) resistor r=592.245 //w=0.094 //l=1.155 //layer=ply \
 //thickness=0.18 //x=67.43 //y=6.2 //x2=67.43 //y2=5.045
r1274 (  197 292 ) resistor r=592.245 //w=0.094 //l=1.155 //layer=ply \
 //thickness=0.18 //x=54.92 //y=6.2 //x2=54.92 //y2=5.045
r1275 (  196 364 ) resistor r=592.245 //w=0.094 //l=1.155 //layer=ply \
 //thickness=0.18 //x=54.48 //y=6.2 //x2=54.48 //y2=5.045
r1276 (  195 273 ) resistor r=592.245 //w=0.094 //l=1.155 //layer=ply \
 //thickness=0.18 //x=41.97 //y=6.2 //x2=41.97 //y2=5.045
r1277 (  194 353 ) resistor r=592.245 //w=0.094 //l=1.155 //layer=ply \
 //thickness=0.18 //x=41.53 //y=6.2 //x2=41.53 //y2=5.045
r1278 (  193 254 ) resistor r=592.245 //w=0.094 //l=1.155 //layer=ply \
 //thickness=0.18 //x=29.02 //y=6.2 //x2=29.02 //y2=5.045
r1279 (  192 342 ) resistor r=592.245 //w=0.094 //l=1.155 //layer=ply \
 //thickness=0.18 //x=28.58 //y=6.2 //x2=28.58 //y2=5.045
r1280 (  191 235 ) resistor r=592.245 //w=0.094 //l=1.155 //layer=ply \
 //thickness=0.18 //x=16.07 //y=6.2 //x2=16.07 //y2=5.045
r1281 (  190 331 ) resistor r=592.245 //w=0.094 //l=1.155 //layer=ply \
 //thickness=0.18 //x=15.63 //y=6.2 //x2=15.63 //y2=5.045
r1282 (  189 216 ) resistor r=592.245 //w=0.094 //l=1.155 //layer=ply \
 //thickness=0.18 //x=3.12 //y=6.2 //x2=3.12 //y2=5.045
r1283 (  188 320 ) resistor r=592.245 //w=0.094 //l=1.155 //layer=ply \
 //thickness=0.18 //x=2.68 //y=6.2 //x2=2.68 //y2=5.045
r1284 (  187 299 ) resistor r=55.3787 //w=0.094 //l=0.108 //layer=ply \
 //thickness=0.18 //x=67.287 //y=1.555 //x2=67.395 //y2=1.555
r1285 (  187 300 ) resistor r=54.866 //w=0.094 //l=0.107 //layer=ply \
 //thickness=0.18 //x=67.287 //y=1.555 //x2=67.18 //y2=1.555
r1286 (  186 280 ) resistor r=55.3787 //w=0.094 //l=0.108 //layer=ply \
 //thickness=0.18 //x=54.337 //y=1.555 //x2=54.445 //y2=1.555
r1287 (  186 281 ) resistor r=54.866 //w=0.094 //l=0.107 //layer=ply \
 //thickness=0.18 //x=54.337 //y=1.555 //x2=54.23 //y2=1.555
r1288 (  185 261 ) resistor r=55.3787 //w=0.094 //l=0.108 //layer=ply \
 //thickness=0.18 //x=41.387 //y=1.555 //x2=41.495 //y2=1.555
r1289 (  185 262 ) resistor r=54.866 //w=0.094 //l=0.107 //layer=ply \
 //thickness=0.18 //x=41.387 //y=1.555 //x2=41.28 //y2=1.555
r1290 (  184 242 ) resistor r=55.3787 //w=0.094 //l=0.108 //layer=ply \
 //thickness=0.18 //x=28.437 //y=1.555 //x2=28.545 //y2=1.555
r1291 (  184 243 ) resistor r=54.866 //w=0.094 //l=0.107 //layer=ply \
 //thickness=0.18 //x=28.437 //y=1.555 //x2=28.33 //y2=1.555
r1292 (  183 223 ) resistor r=55.3787 //w=0.094 //l=0.108 //layer=ply \
 //thickness=0.18 //x=15.487 //y=1.555 //x2=15.595 //y2=1.555
r1293 (  183 224 ) resistor r=54.866 //w=0.094 //l=0.107 //layer=ply \
 //thickness=0.18 //x=15.487 //y=1.555 //x2=15.38 //y2=1.555
r1294 (  182 204 ) resistor r=55.3787 //w=0.094 //l=0.108 //layer=ply \
 //thickness=0.18 //x=2.537 //y=1.555 //x2=2.645 //y2=1.555
r1295 (  182 205 ) resistor r=54.866 //w=0.094 //l=0.107 //layer=ply \
 //thickness=0.18 //x=2.537 //y=1.555 //x2=2.43 //y2=1.555
r1296 (  178 372 ) resistor r=152 //w=0.17 //l=0.17 //layer=licon //count=1 \
 //x=67.46 //y=4.88 //x2=67.46 //y2=4.88
r1297 (  173 379 ) resistor r=152 //w=0.17 //l=0.17 //layer=licon //count=1 \
 //x=67.46 //y=2.26 //x2=67.46 //y2=2.26
r1298 (  168 361 ) resistor r=152 //w=0.17 //l=0.17 //layer=licon //count=1 \
 //x=54.51 //y=4.88 //x2=54.51 //y2=4.88
r1299 (  163 368 ) resistor r=152 //w=0.17 //l=0.17 //layer=licon //count=1 \
 //x=54.51 //y=2.26 //x2=54.51 //y2=2.26
r1300 (  158 350 ) resistor r=152 //w=0.17 //l=0.17 //layer=licon //count=1 \
 //x=41.56 //y=4.88 //x2=41.56 //y2=4.88
r1301 (  153 357 ) resistor r=152 //w=0.17 //l=0.17 //layer=licon //count=1 \
 //x=41.56 //y=2.26 //x2=41.56 //y2=2.26
r1302 (  148 339 ) resistor r=152 //w=0.17 //l=0.17 //layer=licon //count=1 \
 //x=28.61 //y=4.88 //x2=28.61 //y2=4.88
r1303 (  143 346 ) resistor r=152 //w=0.17 //l=0.17 //layer=licon //count=1 \
 //x=28.61 //y=2.26 //x2=28.61 //y2=2.26
r1304 (  138 328 ) resistor r=152 //w=0.17 //l=0.17 //layer=licon //count=1 \
 //x=15.66 //y=4.88 //x2=15.66 //y2=4.88
r1305 (  133 335 ) resistor r=152 //w=0.17 //l=0.17 //layer=licon //count=1 \
 //x=15.66 //y=2.26 //x2=15.66 //y2=2.26
r1306 (  128 317 ) resistor r=152 //w=0.17 //l=0.17 //layer=licon //count=1 \
 //x=2.71 //y=4.88 //x2=2.71 //y2=4.88
r1307 (  123 324 ) resistor r=152 //w=0.17 //l=0.17 //layer=licon //count=1 \
 //x=2.71 //y=2.26 //x2=2.71 //y2=2.26
r1308 (  109 111 ) resistor r=0.0904882 //w=0.297 //l=0.215 //layer=m2 \
 //thickness=0.36 //x=2.705 //y=4.62 //x2=2.705 //y2=4.835
r1309 (  108 119 ) resistor r=6.34081 //w=0.18 //l=9.16493 //layer=m2 \
 //thickness=0.36 //x=63.635 //y=4.635 //x2=54.505 //y2=4.705
r1310 (  107 121 ) resistor r=2.36166 //w=0.184 //l=3.50487 //layer=m2 \
 //thickness=0.36 //x=63.98 //y=4.635 //x2=67.455 //y2=4.695
r1311 (  107 108 ) resistor r=0.329198 //w=0.131 //l=0.345 //layer=m2 \
 //thickness=0.36 //x=63.98 //y=4.635 //x2=63.635 //y2=4.635
r1312 (  105 119 ) resistor r=0.618583 //w=0.18 //l=0.919511 //layer=m2 \
 //thickness=0.36 //x=53.615 //y=4.645 //x2=54.505 //y2=4.705
r1313 (  105 106 ) resistor r=0.329198 //w=0.131 //l=0.345 //layer=m2 \
 //thickness=0.36 //x=53.615 //y=4.645 //x2=53.27 //y2=4.645
r1314 (  103 106 ) resistor r=0.1875 //w=0.17 //l=0.267208 //layer=m2 \
 //thickness=0.36 //x=53.015 //y=4.62 //x2=53.27 //y2=4.645
r1315 (  103 104 ) resistor r=1.74618 //w=0.131 //l=1.83 //layer=m2 \
 //thickness=0.36 //x=53.015 //y=4.62 //x2=51.185 //y2=4.62
r1316 (  101 104 ) resistor r=0.125 //w=0.17 //l=0.179722 //layer=m2 \
 //thickness=0.36 //x=51.015 //y=4.64 //x2=51.185 //y2=4.62
r1317 (  101 102 ) resistor r=0.329198 //w=0.131 //l=0.345 //layer=m2 \
 //thickness=0.36 //x=51.015 //y=4.64 //x2=50.67 //y2=4.64
r1318 (  99 102 ) resistor r=0.1875 //w=0.17 //l=0.264811 //layer=m2 \
 //thickness=0.36 //x=50.415 //y=4.62 //x2=50.67 //y2=4.64
r1319 (  99 100 ) resistor r=6.31202 //w=0.131 //l=6.615 //layer=m2 \
 //thickness=0.36 //x=50.415 //y=4.62 //x2=43.8 //y2=4.62
r1320 (  98 117 ) resistor r=1.20192 //w=0.18 //l=1.75728 //layer=m2 \
 //thickness=0.36 //x=43.285 //y=4.64 //x2=41.555 //y2=4.695
r1321 (  97 100 ) resistor r=0.125 //w=0.17 //l=0.179722 //layer=m2 \
 //thickness=0.36 //x=43.63 //y=4.64 //x2=43.8 //y2=4.62
r1322 (  97 98 ) resistor r=0.329198 //w=0.131 //l=0.345 //layer=m2 \
 //thickness=0.36 //x=43.63 //y=4.64 //x2=43.285 //y2=4.64
r1323 (  96 115 ) resistor r=6.34081 //w=0.18 //l=9.16493 //layer=m2 \
 //thickness=0.36 //x=37.735 //y=4.635 //x2=28.605 //y2=4.705
r1324 (  95 117 ) resistor r=2.41372 //w=0.18 //l=3.50487 //layer=m2 \
 //thickness=0.36 //x=38.08 //y=4.635 //x2=41.555 //y2=4.695
r1325 (  95 96 ) resistor r=0.329198 //w=0.131 //l=0.345 //layer=m2 \
 //thickness=0.36 //x=38.08 //y=4.635 //x2=37.735 //y2=4.635
r1326 (  93 115 ) resistor r=0.618583 //w=0.18 //l=0.919511 //layer=m2 \
 //thickness=0.36 //x=27.715 //y=4.645 //x2=28.605 //y2=4.705
r1327 (  93 94 ) resistor r=0.329198 //w=0.131 //l=0.345 //layer=m2 \
 //thickness=0.36 //x=27.715 //y=4.645 //x2=27.37 //y2=4.645
r1328 (  91 94 ) resistor r=0.1875 //w=0.17 //l=0.267208 //layer=m2 \
 //thickness=0.36 //x=27.115 //y=4.62 //x2=27.37 //y2=4.645
r1329 (  91 92 ) resistor r=1.74618 //w=0.131 //l=1.83 //layer=m2 \
 //thickness=0.36 //x=27.115 //y=4.62 //x2=25.285 //y2=4.62
r1330 (  89 92 ) resistor r=0.125 //w=0.17 //l=0.179722 //layer=m2 \
 //thickness=0.36 //x=25.115 //y=4.64 //x2=25.285 //y2=4.62
r1331 (  89 90 ) resistor r=0.329198 //w=0.131 //l=0.345 //layer=m2 \
 //thickness=0.36 //x=25.115 //y=4.64 //x2=24.77 //y2=4.64
r1332 (  87 90 ) resistor r=0.1875 //w=0.17 //l=0.264811 //layer=m2 \
 //thickness=0.36 //x=24.515 //y=4.62 //x2=24.77 //y2=4.64
r1333 (  87 88 ) resistor r=6.31202 //w=0.131 //l=6.615 //layer=m2 \
 //thickness=0.36 //x=24.515 //y=4.62 //x2=17.9 //y2=4.62
r1334 (  86 113 ) resistor r=1.20192 //w=0.18 //l=1.75728 //layer=m2 \
 //thickness=0.36 //x=17.385 //y=4.64 //x2=15.655 //y2=4.695
r1335 (  85 88 ) resistor r=0.125 //w=0.17 //l=0.179722 //layer=m2 \
 //thickness=0.36 //x=17.73 //y=4.64 //x2=17.9 //y2=4.62
r1336 (  85 86 ) resistor r=0.329198 //w=0.131 //l=0.345 //layer=m2 \
 //thickness=0.36 //x=17.73 //y=4.64 //x2=17.385 //y2=4.64
r1337 (  83 113 ) resistor r=2.41372 //w=0.18 //l=3.50487 //layer=m2 \
 //thickness=0.36 //x=12.18 //y=4.635 //x2=15.655 //y2=4.695
r1338 (  83 84 ) resistor r=0.329198 //w=0.131 //l=0.345 //layer=m2 \
 //thickness=0.36 //x=12.18 //y=4.635 //x2=11.835 //y2=4.635
r1339 (  82 109 ) resistor r=0.0410036 //w=0.297 //l=0.16 //layer=m2 \
 //thickness=0.36 //x=2.865 //y=4.62 //x2=2.705 //y2=4.62
r1340 (  81 84 ) resistor r=0.1875 //w=0.17 //l=0.262393 //layer=m2 \
 //thickness=0.36 //x=11.58 //y=4.62 //x2=11.835 //y2=4.635
r1341 (  81 82 ) resistor r=8.31584 //w=0.131 //l=8.715 //layer=m2 \
 //thickness=0.36 //x=11.58 //y=4.62 //x2=2.865 //y2=4.62
r1342 (  80 178 ) resistor r=9.3 //w=0.17 //l=0.17 //layer=mcon //count=1 \
 //x=67.46 //y=4.88 //x2=67.46 //y2=4.88
r1343 (  78 121 ) resistor r=4.5 //w=0.15 //l=0.15 //layer=via1 //count=1 \
 //x=67.455 //y=4.695 //x2=67.455 //y2=4.695
r1344 (  78 80 ) resistor r=0.0808566 //w=0.286 //l=0.185 //layer=m1 \
 //thickness=0.36 //x=67.455 //y=4.695 //x2=67.455 //y2=4.88
r1345 (  75 173 ) resistor r=9.3 //w=0.17 //l=0.17 //layer=mcon //count=1 \
 //x=67.46 //y=2.26 //x2=67.46 //y2=2.26
r1346 (  73 168 ) resistor r=9.3 //w=0.17 //l=0.17 //layer=mcon //count=1 \
 //x=54.51 //y=4.88 //x2=54.51 //y2=4.88
r1347 (  71 119 ) resistor r=4.5 //w=0.15 //l=0.15 //layer=via1 //count=1 \
 //x=54.505 //y=4.835 //x2=54.505 //y2=4.835
r1348 (  71 73 ) resistor r=0.018263 //w=0.308 //l=0.045 //layer=m1 \
 //thickness=0.36 //x=54.505 //y=4.835 //x2=54.505 //y2=4.88
r1349 (  69 163 ) resistor r=9.3 //w=0.17 //l=0.17 //layer=mcon //count=1 \
 //x=54.51 //y=2.26 //x2=54.51 //y2=2.26
r1350 (  67 158 ) resistor r=9.3 //w=0.17 //l=0.17 //layer=mcon //count=1 \
 //x=41.56 //y=4.88 //x2=41.56 //y2=4.88
r1351 (  65 117 ) resistor r=4.5 //w=0.15 //l=0.15 //layer=via1 //count=1 \
 //x=41.555 //y=4.695 //x2=41.555 //y2=4.695
r1352 (  65 67 ) resistor r=0.0808566 //w=0.286 //l=0.185 //layer=m1 \
 //thickness=0.36 //x=41.555 //y=4.695 //x2=41.555 //y2=4.88
r1353 (  62 153 ) resistor r=9.3 //w=0.17 //l=0.17 //layer=mcon //count=1 \
 //x=41.56 //y=2.26 //x2=41.56 //y2=2.26
r1354 (  60 148 ) resistor r=9.3 //w=0.17 //l=0.17 //layer=mcon //count=1 \
 //x=28.61 //y=4.88 //x2=28.61 //y2=4.88
r1355 (  58 115 ) resistor r=4.5 //w=0.15 //l=0.15 //layer=via1 //count=1 \
 //x=28.605 //y=4.835 //x2=28.605 //y2=4.835
r1356 (  58 60 ) resistor r=0.018263 //w=0.308 //l=0.045 //layer=m1 \
 //thickness=0.36 //x=28.605 //y=4.835 //x2=28.605 //y2=4.88
r1357 (  56 143 ) resistor r=9.3 //w=0.17 //l=0.17 //layer=mcon //count=1 \
 //x=28.61 //y=2.26 //x2=28.61 //y2=2.26
r1358 (  54 138 ) resistor r=9.3 //w=0.17 //l=0.17 //layer=mcon //count=1 \
 //x=15.66 //y=4.88 //x2=15.66 //y2=4.88
r1359 (  52 113 ) resistor r=4.5 //w=0.15 //l=0.15 //layer=via1 //count=1 \
 //x=15.655 //y=4.695 //x2=15.655 //y2=4.695
r1360 (  52 54 ) resistor r=0.0808566 //w=0.286 //l=0.185 //layer=m1 \
 //thickness=0.36 //x=15.655 //y=4.695 //x2=15.655 //y2=4.88
r1361 (  49 133 ) resistor r=9.3 //w=0.17 //l=0.17 //layer=mcon //count=1 \
 //x=15.66 //y=2.26 //x2=15.66 //y2=2.26
r1362 (  47 128 ) resistor r=9.3 //w=0.17 //l=0.17 //layer=mcon //count=1 \
 //x=2.71 //y=4.88 //x2=2.71 //y2=4.88
r1363 (  45 111 ) resistor r=4.5 //w=0.15 //l=0.15 //layer=via1 //count=1 \
 //x=2.705 //y=4.835 //x2=2.705 //y2=4.835
r1364 (  45 47 ) resistor r=0.018263 //w=0.308 //l=0.045 //layer=m1 \
 //thickness=0.36 //x=2.705 //y=4.835 //x2=2.705 //y2=4.88
r1365 (  43 123 ) resistor r=9.3 //w=0.17 //l=0.17 //layer=mcon //count=1 \
 //x=2.71 //y=2.26 //x2=2.71 //y2=2.26
r1366 (  40 75 ) resistor r=0.0715665 //w=0.226 //l=0.115996 //layer=m1 \
 //thickness=0.36 //x=67.46 //y=2.375 //x2=67.462 //y2=2.26
r1367 (  40 41 ) resistor r=2.06107 //w=0.131 //l=2.16 //layer=m1 \
 //thickness=0.36 //x=67.46 //y=2.375 //x2=67.46 //y2=4.535
r1368 (  37 71 ) resistor r=0.0898396 //w=0.308 //l=0.162481 //layer=m1 \
 //thickness=0.36 //x=54.51 //y=4.675 //x2=54.505 //y2=4.835
r1369 (  36 69 ) resistor r=0.0715665 //w=0.226 //l=0.115996 //layer=m1 \
 //thickness=0.36 //x=54.51 //y=2.375 //x2=54.512 //y2=2.26
r1370 (  33 62 ) resistor r=0.0715665 //w=0.226 //l=0.115996 //layer=m1 \
 //thickness=0.36 //x=41.56 //y=2.375 //x2=41.562 //y2=2.26
r1371 (  29 58 ) resistor r=0.0898396 //w=0.308 //l=0.162481 //layer=m1 \
 //thickness=0.36 //x=28.61 //y=4.675 //x2=28.605 //y2=4.835
r1372 (  28 56 ) resistor r=0.0715665 //w=0.226 //l=0.115996 //layer=m1 \
 //thickness=0.36 //x=28.61 //y=2.375 //x2=28.612 //y2=2.26
r1373 (  24 49 ) resistor r=0.0715665 //w=0.226 //l=0.115996 //layer=m1 \
 //thickness=0.36 //x=15.66 //y=2.375 //x2=15.662 //y2=2.26
r1374 (  18 45 ) resistor r=0.0898396 //w=0.308 //l=0.162481 //layer=m1 \
 //thickness=0.36 //x=2.71 //y=4.675 //x2=2.705 //y2=4.835
r1375 (  17 43 ) resistor r=0.0715665 //w=0.226 //l=0.115996 //layer=m1 \
 //thickness=0.36 //x=2.71 //y=2.375 //x2=2.712 //y2=2.26
r1376 (  16 78 ) resistor r=0.0327797 //w=0.286 //l=0.075 //layer=m1 \
 //thickness=0.36 //x=67.455 //y=4.62 //x2=67.455 //y2=4.695
r1377 (  16 41 ) resistor r=0.0575483 //w=0.286 //l=0.0874643 //layer=m1 \
 //thickness=0.36 //x=67.455 //y=4.62 //x2=67.46 //y2=4.535
r1378 (  15 65 ) resistor r=0.0327797 //w=0.286 //l=0.075 //layer=m1 \
 //thickness=0.36 //x=41.555 //y=4.62 //x2=41.555 //y2=4.695
r1379 (  15 34 ) resistor r=0.0575483 //w=0.286 //l=0.0874643 //layer=m1 \
 //thickness=0.36 //x=41.555 //y=4.62 //x2=41.56 //y2=4.535
r1380 (  14 52 ) resistor r=0.0327797 //w=0.286 //l=0.075 //layer=m1 \
 //thickness=0.36 //x=15.655 //y=4.62 //x2=15.655 //y2=4.695
r1381 (  14 25 ) resistor r=0.0575483 //w=0.286 //l=0.0874643 //layer=m1 \
 //thickness=0.36 //x=15.655 //y=4.62 //x2=15.66 //y2=4.535
r1382 (  13 37 ) resistor r=0.0524809 //w=0.131 //l=0.055 //layer=m1 \
 //thickness=0.36 //x=54.51 //y=4.62 //x2=54.51 //y2=4.675
r1383 (  12 13 ) resistor r=0.706107 //w=0.131 //l=0.74 //layer=m1 \
 //thickness=0.36 //x=54.51 //y=3.88 //x2=54.51 //y2=4.62
r1384 (  12 36 ) resistor r=1.43607 //w=0.131 //l=1.505 //layer=m1 \
 //thickness=0.36 //x=54.51 //y=3.88 //x2=54.51 //y2=2.375
r1385 (  11 34 ) resistor r=0.978053 //w=0.131 //l=1.025 //layer=m1 \
 //thickness=0.36 //x=41.56 //y=3.51 //x2=41.56 //y2=4.535
r1386 (  11 33 ) resistor r=1.08302 //w=0.131 //l=1.135 //layer=m1 \
 //thickness=0.36 //x=41.56 //y=3.51 //x2=41.56 //y2=2.375
r1387 (  10 29 ) resistor r=0.0524809 //w=0.131 //l=0.055 //layer=m1 \
 //thickness=0.36 //x=28.61 //y=4.62 //x2=28.61 //y2=4.675
r1388 (  9 10 ) resistor r=0.706107 //w=0.131 //l=0.74 //layer=m1 \
 //thickness=0.36 //x=28.61 //y=3.88 //x2=28.61 //y2=4.62
r1389 (  8 9 ) resistor r=0.353053 //w=0.131 //l=0.37 //layer=m1 \
 //thickness=0.36 //x=28.61 //y=3.51 //x2=28.61 //y2=3.88
r1390 (  8 28 ) resistor r=1.08302 //w=0.131 //l=1.135 //layer=m1 \
 //thickness=0.36 //x=28.61 //y=3.51 //x2=28.61 //y2=2.375
r1391 (  7 25 ) resistor r=0.978053 //w=0.131 //l=1.025 //layer=m1 \
 //thickness=0.36 //x=15.66 //y=3.51 //x2=15.66 //y2=4.535
r1392 (  6 7 ) resistor r=0.353053 //w=0.131 //l=0.37 //layer=m1 \
 //thickness=0.36 //x=15.66 //y=3.14 //x2=15.66 //y2=3.51
r1393 (  6 24 ) resistor r=0.729962 //w=0.131 //l=0.765 //layer=m1 \
 //thickness=0.36 //x=15.66 //y=3.14 //x2=15.66 //y2=2.375
r1394 (  5 18 ) resistor r=0.0524809 //w=0.131 //l=0.055 //layer=m1 \
 //thickness=0.36 //x=2.71 //y=4.62 //x2=2.71 //y2=4.675
r1395 (  4 5 ) resistor r=0.706107 //w=0.131 //l=0.74 //layer=m1 \
 //thickness=0.36 //x=2.71 //y=3.88 //x2=2.71 //y2=4.62
r1396 (  3 4 ) resistor r=0.353053 //w=0.131 //l=0.37 //layer=m1 \
 //thickness=0.36 //x=2.71 //y=3.51 //x2=2.71 //y2=3.88
r1397 (  2 3 ) resistor r=0.353053 //w=0.131 //l=0.37 //layer=m1 \
 //thickness=0.36 //x=2.71 //y=3.14 //x2=2.71 //y2=3.51
r1398 (  1 2 ) resistor r=0.353053 //w=0.131 //l=0.37 //layer=m1 \
 //thickness=0.36 //x=2.71 //y=2.77 //x2=2.71 //y2=3.14
r1399 (  1 17 ) resistor r=0.376908 //w=0.131 //l=0.395 //layer=m1 \
 //thickness=0.36 //x=2.71 //y=2.77 //x2=2.71 //y2=2.375
ends PM_TMRDFFRNQNX1\%CLK

subckt PM_TMRDFFRNQNX1\%noxref_12 ( 1 3 6 7 9 10 11 12 14 15 16 17 18 19 20 21 \
 22 23 24 25 28 31 37 45 48 54 56 57 58 60 62 64 66 68 70 72 77 83 91 99 116 \
 125 130 139 143 144 145 146 147 148 149 150 151 152 153 155 161 162 163 164 \
 168 169 170 171 172 174 180 181 182 183 203 205 206 207 )
c488 ( 203 0 ) capacitor c=0.00885916f //x=55.685 //y=1.095
c489 ( 183 0 ) capacitor c=0.0583399f //x=71.435 //y=4.97
c490 ( 182 0 ) capacitor c=0.0376642f //x=71.725 //y=4.97
c491 ( 181 0 ) capacitor c=0.0346489f //x=71.39 //y=1.4
c492 ( 180 0 ) capacitor c=0.018692f //x=71.39 //y=1.055
c493 ( 174 0 ) capacitor c=0.0137077f //x=71.235 //y=1.555
c494 ( 172 0 ) capacitor c=0.0158585f //x=71.235 //y=0.9
c495 ( 171 0 ) capacitor c=0.103534f //x=70.86 //y=2.095
c496 ( 170 0 ) capacitor c=0.0229444f //x=70.86 //y=1.71
c497 ( 169 0 ) capacitor c=0.0234359f //x=70.86 //y=1.4
c498 ( 168 0 ) capacitor c=0.019815f //x=70.86 //y=1.055
c499 ( 164 0 ) capacitor c=0.0564069f //x=58.485 //y=4.97
c500 ( 163 0 ) capacitor c=0.0376642f //x=58.775 //y=4.97
c501 ( 162 0 ) capacitor c=0.0346489f //x=58.44 //y=1.4
c502 ( 161 0 ) capacitor c=0.018692f //x=58.44 //y=1.055
c503 ( 155 0 ) capacitor c=0.0137077f //x=58.285 //y=1.555
c504 ( 153 0 ) capacitor c=0.0158585f //x=58.285 //y=0.9
c505 ( 152 0 ) capacitor c=0.103534f //x=57.91 //y=2.095
c506 ( 151 0 ) capacitor c=0.0229444f //x=57.91 //y=1.71
c507 ( 150 0 ) capacitor c=0.0234359f //x=57.91 //y=1.4
c508 ( 149 0 ) capacitor c=0.019815f //x=57.91 //y=1.055
c509 ( 148 0 ) capacitor c=0.110208f //x=71.8 //y=6.2
c510 ( 147 0 ) capacitor c=0.158957f //x=71.36 //y=6.2
c511 ( 146 0 ) capacitor c=0.110208f //x=58.85 //y=6.2
c512 ( 145 0 ) capacitor c=0.158957f //x=58.41 //y=6.2
c513 ( 139 0 ) capacitor c=0.0014751f //x=71.16 //y=4.88
c514 ( 130 0 ) capacitor c=0.0012618f //x=71.16 //y=2.26
c515 ( 125 0 ) capacitor c=0.0014751f //x=58.21 //y=4.88
c516 ( 116 0 ) capacitor c=0.0012618f //x=58.21 //y=2.26
c517 ( 99 0 ) capacitor c=0.0293561f //x=55.58 //y=5.56
c518 ( 91 0 ) capacitor c=0.029137f //x=54.7 //y=5.56
c519 ( 83 0 ) capacitor c=0.0277605f //x=53.82 //y=5.56
c520 ( 77 0 ) capacitor c=7.36606e-19 //x=56.525 //y=3.885
c521 ( 72 0 ) capacitor c=0.0235722f //x=69.53 //y=3.87
c522 ( 70 0 ) capacitor c=0.0212796f //x=68.93 //y=3.88
c523 ( 68 0 ) capacitor c=0.00400338f //x=66.57 //y=3.9
c524 ( 66 0 ) capacitor c=0.018225f //x=65.97 //y=3.88
c525 ( 64 0 ) capacitor c=0.00418082f //x=64.715 //y=3.9
c526 ( 62 0 ) capacitor c=0.00628181f //x=63.98 //y=3.865
c527 ( 60 0 ) capacitor c=0.00473917f //x=63.235 //y=3.895
c528 ( 58 0 ) capacitor c=0.0174986f //x=62.635 //y=3.88
c529 ( 57 0 ) capacitor c=0.0244643f //x=61.045 //y=3.895
c530 ( 56 0 ) capacitor c=0.00423161f //x=61.39 //y=3.895
c531 ( 54 0 ) capacitor c=0.0209003f //x=58.055 //y=3.88
c532 ( 48 0 ) capacitor c=0.0168323f //x=71.15 //y=3.88
c533 ( 45 0 ) capacitor c=0.0167936f //x=58.21 //y=3.88
c534 ( 37 0 ) capacitor c=0.0172565f //x=56.36 //y=3.88
c535 ( 31 0 ) capacitor c=9.55882e-19 //x=55.58 //y=5.335
c536 ( 28 0 ) capacitor c=0.00740623f //x=54.7 //y=5.335
c537 ( 25 0 ) capacitor c=0.0112819f //x=53.822 //y=5.335
c538 ( 24 0 ) capacitor c=0.0263217f //x=71.16 //y=4.755
c539 ( 23 0 ) capacitor c=0.0136301f //x=71.16 //y=4.04
c540 ( 22 0 ) capacitor c=0.0420706f //x=71.16 //y=3.72
c541 ( 21 0 ) capacitor c=0.00489532f //x=71.16 //y=2.375
c542 ( 20 0 ) capacitor c=0.0266349f //x=58.21 //y=4.755
c543 ( 19 0 ) capacitor c=0.0127018f //x=58.21 //y=4.04
c544 ( 18 0 ) capacitor c=0.0389876f //x=58.21 //y=3.72
c545 ( 17 0 ) capacitor c=0.00495287f //x=58.21 //y=2.375
c546 ( 16 0 ) capacitor c=0.0325919f //x=56.36 //y=5.25
c547 ( 15 0 ) capacitor c=0.0131885f //x=56.36 //y=4.045
c548 ( 14 0 ) capacitor c=0.0492264f //x=56.36 //y=3.725
c549 ( 12 0 ) capacitor c=0.0047266f //x=55.96 //y=1.845
c550 ( 11 0 ) capacitor c=0.0133232f //x=56.275 //y=1.845
c551 ( 10 0 ) capacitor c=0.0167333f //x=55.875 //y=1.76
c552 ( 9 0 ) capacitor c=0.0110969f //x=55.875 //y=1.305
c553 ( 7 0 ) capacitor c=0.0229543f //x=56.275 //y=5.335
c554 ( 6 0 ) capacitor c=0.00933983f //x=55.58 //y=5.56
c555 ( 3 0 ) capacitor c=0.019444f //x=55.465 //y=5.335
c556 ( 1 0 ) capacitor c=0.0146659f //x=54.58 //y=5.335
r557 (  182 184 ) resistor r=26.9307 //w=0.15 //l=0.106066 //layer=ply \
 //thickness=0.18 //x=71.725 //y=4.97 //x2=71.8 //y2=5.045
r558 (  182 183 ) resistor r=148.702 //w=0.094 //l=0.29 //layer=ply \
 //thickness=0.18 //x=71.725 //y=4.97 //x2=71.435 //y2=4.97
r559 (  181 202 ) resistor r=45.1352 //w=0.168 //l=0.173853 //layer=ply \
 //thickness=0.18 //x=71.39 //y=1.4 //x2=71.35 //y2=1.555
r560 (  180 201 ) resistor r=45.1352 //w=0.168 //l=0.173853 //layer=ply \
 //thickness=0.18 //x=71.39 //y=1.055 //x2=71.35 //y2=0.9
r561 (  180 181 ) resistor r=176.904 //w=0.094 //l=0.345 //layer=ply \
 //thickness=0.18 //x=71.39 //y=1.055 //x2=71.39 //y2=1.4
r562 (  177 183 ) resistor r=22.7971 //w=0.269 //l=0.106066 //layer=ply \
 //thickness=0.18 //x=71.36 //y=5.045 //x2=71.435 //y2=4.97
r563 (  177 200 ) resistor r=35.8364 //w=0.269 //l=0.270185 //layer=ply \
 //thickness=0.18 //x=71.36 //y=5.045 //x2=71.16 //y2=4.88
r564 (  175 196 ) resistor r=10.701 //w=0.21 //l=0.115 //layer=ply \
 //thickness=0.18 //x=71.015 //y=1.555 //x2=70.9 //y2=1.555
r565 (  174 202 ) resistor r=5.52526 //w=0.168 //l=0.115 //layer=ply \
 //thickness=0.18 //x=71.235 //y=1.555 //x2=71.35 //y2=1.555
r566 (  173 195 ) resistor r=5.52526 //w=0.168 //l=0.115 //layer=ply \
 //thickness=0.18 //x=71.015 //y=0.9 //x2=70.9 //y2=0.9
r567 (  172 201 ) resistor r=5.52526 //w=0.168 //l=0.115 //layer=ply \
 //thickness=0.18 //x=71.235 //y=0.9 //x2=71.35 //y2=0.9
r568 (  172 173 ) resistor r=112.809 //w=0.094 //l=0.22 //layer=ply \
 //thickness=0.18 //x=71.235 //y=0.9 //x2=71.015 //y2=0.9
r569 (  171 198 ) resistor r=58.7805 //w=0.246 //l=0.373497 //layer=ply \
 //thickness=0.18 //x=70.86 //y=2.095 //x2=71.16 //y2=2.26
r570 (  170 196 ) resistor r=39.5823 //w=0.21 //l=0.173853 //layer=ply \
 //thickness=0.18 //x=70.86 //y=1.71 //x2=70.9 //y2=1.555
r571 (  170 171 ) resistor r=197.415 //w=0.094 //l=0.385 //layer=ply \
 //thickness=0.18 //x=70.86 //y=1.71 //x2=70.86 //y2=2.095
r572 (  169 196 ) resistor r=39.5823 //w=0.21 //l=0.173853 //layer=ply \
 //thickness=0.18 //x=70.86 //y=1.4 //x2=70.9 //y2=1.555
r573 (  168 195 ) resistor r=45.1352 //w=0.168 //l=0.173853 //layer=ply \
 //thickness=0.18 //x=70.86 //y=1.055 //x2=70.9 //y2=0.9
r574 (  168 169 ) resistor r=176.904 //w=0.094 //l=0.345 //layer=ply \
 //thickness=0.18 //x=70.86 //y=1.055 //x2=70.86 //y2=1.4
r575 (  163 165 ) resistor r=26.9307 //w=0.15 //l=0.106066 //layer=ply \
 //thickness=0.18 //x=58.775 //y=4.97 //x2=58.85 //y2=5.045
r576 (  163 164 ) resistor r=148.702 //w=0.094 //l=0.29 //layer=ply \
 //thickness=0.18 //x=58.775 //y=4.97 //x2=58.485 //y2=4.97
r577 (  162 194 ) resistor r=45.1352 //w=0.168 //l=0.173853 //layer=ply \
 //thickness=0.18 //x=58.44 //y=1.4 //x2=58.4 //y2=1.555
r578 (  161 193 ) resistor r=45.1352 //w=0.168 //l=0.173853 //layer=ply \
 //thickness=0.18 //x=58.44 //y=1.055 //x2=58.4 //y2=0.9
r579 (  161 162 ) resistor r=176.904 //w=0.094 //l=0.345 //layer=ply \
 //thickness=0.18 //x=58.44 //y=1.055 //x2=58.44 //y2=1.4
r580 (  158 164 ) resistor r=22.7971 //w=0.269 //l=0.106066 //layer=ply \
 //thickness=0.18 //x=58.41 //y=5.045 //x2=58.485 //y2=4.97
r581 (  158 192 ) resistor r=35.8364 //w=0.269 //l=0.270185 //layer=ply \
 //thickness=0.18 //x=58.41 //y=5.045 //x2=58.21 //y2=4.88
r582 (  156 188 ) resistor r=10.701 //w=0.21 //l=0.115 //layer=ply \
 //thickness=0.18 //x=58.065 //y=1.555 //x2=57.95 //y2=1.555
r583 (  155 194 ) resistor r=5.52526 //w=0.168 //l=0.115 //layer=ply \
 //thickness=0.18 //x=58.285 //y=1.555 //x2=58.4 //y2=1.555
r584 (  154 187 ) resistor r=5.52526 //w=0.168 //l=0.115 //layer=ply \
 //thickness=0.18 //x=58.065 //y=0.9 //x2=57.95 //y2=0.9
r585 (  153 193 ) resistor r=5.52526 //w=0.168 //l=0.115 //layer=ply \
 //thickness=0.18 //x=58.285 //y=0.9 //x2=58.4 //y2=0.9
r586 (  153 154 ) resistor r=112.809 //w=0.094 //l=0.22 //layer=ply \
 //thickness=0.18 //x=58.285 //y=0.9 //x2=58.065 //y2=0.9
r587 (  152 190 ) resistor r=58.7805 //w=0.246 //l=0.373497 //layer=ply \
 //thickness=0.18 //x=57.91 //y=2.095 //x2=58.21 //y2=2.26
r588 (  151 188 ) resistor r=39.5823 //w=0.21 //l=0.173853 //layer=ply \
 //thickness=0.18 //x=57.91 //y=1.71 //x2=57.95 //y2=1.555
r589 (  151 152 ) resistor r=197.415 //w=0.094 //l=0.385 //layer=ply \
 //thickness=0.18 //x=57.91 //y=1.71 //x2=57.91 //y2=2.095
r590 (  150 188 ) resistor r=39.5823 //w=0.21 //l=0.173853 //layer=ply \
 //thickness=0.18 //x=57.91 //y=1.4 //x2=57.95 //y2=1.555
r591 (  149 187 ) resistor r=45.1352 //w=0.168 //l=0.173853 //layer=ply \
 //thickness=0.18 //x=57.91 //y=1.055 //x2=57.95 //y2=0.9
r592 (  149 150 ) resistor r=176.904 //w=0.094 //l=0.345 //layer=ply \
 //thickness=0.18 //x=57.91 //y=1.055 //x2=57.91 //y2=1.4
r593 (  148 184 ) resistor r=592.245 //w=0.094 //l=1.155 //layer=ply \
 //thickness=0.18 //x=71.8 //y=6.2 //x2=71.8 //y2=5.045
r594 (  147 177 ) resistor r=592.245 //w=0.094 //l=1.155 //layer=ply \
 //thickness=0.18 //x=71.36 //y=6.2 //x2=71.36 //y2=5.045
r595 (  146 165 ) resistor r=592.245 //w=0.094 //l=1.155 //layer=ply \
 //thickness=0.18 //x=58.85 //y=6.2 //x2=58.85 //y2=5.045
r596 (  145 158 ) resistor r=592.245 //w=0.094 //l=1.155 //layer=ply \
 //thickness=0.18 //x=58.41 //y=6.2 //x2=58.41 //y2=5.045
r597 (  144 174 ) resistor r=56.4043 //w=0.094 //l=0.11 //layer=ply \
 //thickness=0.18 //x=71.125 //y=1.555 //x2=71.235 //y2=1.555
r598 (  144 175 ) resistor r=56.4043 //w=0.094 //l=0.11 //layer=ply \
 //thickness=0.18 //x=71.125 //y=1.555 //x2=71.015 //y2=1.555
r599 (  143 155 ) resistor r=56.4043 //w=0.094 //l=0.11 //layer=ply \
 //thickness=0.18 //x=58.175 //y=1.555 //x2=58.285 //y2=1.555
r600 (  143 156 ) resistor r=56.4043 //w=0.094 //l=0.11 //layer=ply \
 //thickness=0.18 //x=58.175 //y=1.555 //x2=58.065 //y2=1.555
r601 (  139 200 ) resistor r=152 //w=0.17 //l=0.17 //layer=licon //count=1 \
 //x=71.16 //y=4.88 //x2=71.16 //y2=4.88
r602 (  130 198 ) resistor r=152 //w=0.17 //l=0.17 //layer=licon //count=1 \
 //x=71.16 //y=2.26 //x2=71.16 //y2=2.26
r603 (  125 192 ) resistor r=152 //w=0.17 //l=0.17 //layer=licon //count=1 \
 //x=58.21 //y=4.88 //x2=58.21 //y2=4.88
r604 (  116 190 ) resistor r=152 //w=0.17 //l=0.17 //layer=licon //count=1 \
 //x=58.21 //y=2.26 //x2=58.21 //y2=2.26
r605 (  99 207 ) resistor r=23.615 //w=0.187 //l=0.345 //layer=li \
 //thickness=0.1 //x=55.58 //y=5.56 //x2=55.58 //y2=5.905
r606 (  91 206 ) resistor r=23.615 //w=0.187 //l=0.345 //layer=li \
 //thickness=0.1 //x=54.7 //y=5.56 //x2=54.7 //y2=5.905
r607 (  83 205 ) resistor r=23.615 //w=0.187 //l=0.345 //layer=li \
 //thickness=0.1 //x=53.82 //y=5.56 //x2=53.82 //y2=5.905
r608 (  75 77 ) resistor r=0.10734 //w=0.281 //l=0.16 //layer=m2 \
 //thickness=0.36 //x=56.365 //y=3.885 //x2=56.525 //y2=3.885
r609 (  72 81 ) resistor r=1.03061 //w=0.197 //l=1.62499 //layer=m2 \
 //thickness=0.36 //x=69.53 //y=3.87 //x2=71.15 //y2=3.88
r610 (  72 73 ) resistor r=0.410305 //w=0.131 //l=0.43 //layer=m2 \
 //thickness=0.36 //x=69.53 //y=3.87 //x2=69.1 //y2=3.87
r611 (  70 73 ) resistor r=0.125 //w=0.17 //l=0.174929 //layer=m2 \
 //thickness=0.36 //x=68.93 //y=3.88 //x2=69.1 //y2=3.87
r612 (  70 71 ) resistor r=2.08969 //w=0.131 //l=2.19 //layer=m2 \
 //thickness=0.36 //x=68.93 //y=3.88 //x2=66.74 //y2=3.88
r613 (  68 71 ) resistor r=0.125 //w=0.17 //l=0.179722 //layer=m2 \
 //thickness=0.36 //x=66.57 //y=3.9 //x2=66.74 //y2=3.88
r614 (  68 69 ) resistor r=0.329198 //w=0.131 //l=0.345 //layer=m2 \
 //thickness=0.36 //x=66.57 //y=3.9 //x2=66.225 //y2=3.9
r615 (  66 69 ) resistor r=0.1875 //w=0.17 //l=0.264811 //layer=m2 \
 //thickness=0.36 //x=65.97 //y=3.88 //x2=66.225 //y2=3.9
r616 (  66 67 ) resistor r=1.03531 //w=0.131 //l=1.085 //layer=m2 \
 //thickness=0.36 //x=65.97 //y=3.88 //x2=64.885 //y2=3.88
r617 (  64 67 ) resistor r=0.125 //w=0.17 //l=0.179722 //layer=m2 \
 //thickness=0.36 //x=64.715 //y=3.9 //x2=64.885 //y2=3.88
r618 (  64 65 ) resistor r=0.329198 //w=0.131 //l=0.345 //layer=m2 \
 //thickness=0.36 //x=64.715 //y=3.9 //x2=64.37 //y2=3.9
r619 (  62 65 ) resistor r=0.286765 //w=0.17 //l=0.407124 //layer=m2 \
 //thickness=0.36 //x=63.98 //y=3.865 //x2=64.37 //y2=3.9
r620 (  62 63 ) resistor r=0.410305 //w=0.131 //l=0.43 //layer=m2 \
 //thickness=0.36 //x=63.98 //y=3.865 //x2=63.55 //y2=3.865
r621 (  60 63 ) resistor r=0.231618 //w=0.17 //l=0.329659 //layer=m2 \
 //thickness=0.36 //x=63.235 //y=3.895 //x2=63.55 //y2=3.865
r622 (  60 61 ) resistor r=0.329198 //w=0.131 //l=0.345 //layer=m2 \
 //thickness=0.36 //x=63.235 //y=3.895 //x2=62.89 //y2=3.895
r623 (  58 61 ) resistor r=0.1875 //w=0.17 //l=0.262393 //layer=m2 \
 //thickness=0.36 //x=62.635 //y=3.88 //x2=62.89 //y2=3.895
r624 (  58 59 ) resistor r=1.02576 //w=0.131 //l=1.075 //layer=m2 \
 //thickness=0.36 //x=62.635 //y=3.88 //x2=61.56 //y2=3.88
r625 (  57 79 ) resistor r=1.89299 //w=0.187 //l=2.83749 //layer=m2 \
 //thickness=0.36 //x=61.045 //y=3.895 //x2=58.215 //y2=3.88
r626 (  56 59 ) resistor r=0.125 //w=0.17 //l=0.177341 //layer=m2 \
 //thickness=0.36 //x=61.39 //y=3.895 //x2=61.56 //y2=3.88
r627 (  56 57 ) resistor r=0.329198 //w=0.131 //l=0.345 //layer=m2 \
 //thickness=0.36 //x=61.39 //y=3.895 //x2=61.045 //y2=3.895
r628 (  54 79 ) resistor r=0.108234 //w=0.187 //l=0.16 //layer=m2 \
 //thickness=0.36 //x=58.055 //y=3.88 //x2=58.215 //y2=3.88
r629 (  54 77 ) resistor r=1.45992 //w=0.131 //l=1.53 //layer=m2 \
 //thickness=0.36 //x=58.055 //y=3.88 //x2=56.525 //y2=3.88
r630 (  53 139 ) resistor r=9.3 //w=0.17 //l=0.17 //layer=mcon //count=1 \
 //x=71.16 //y=4.88 //x2=71.16 //y2=4.88
r631 (  51 130 ) resistor r=9.3 //w=0.17 //l=0.17 //layer=mcon //count=1 \
 //x=71.16 //y=2.26 //x2=71.16 //y2=2.26
r632 (  48 81 ) resistor r=4.5 //w=0.15 //l=0.15 //layer=via1 //count=1 \
 //x=71.15 //y=3.88 //x2=71.15 //y2=3.88
r633 (  45 79 ) resistor r=4.5 //w=0.15 //l=0.15 //layer=via1 //count=1 \
 //x=58.215 //y=3.88 //x2=58.215 //y2=3.88
r634 (  43 125 ) resistor r=9.3 //w=0.17 //l=0.17 //layer=mcon //count=1 \
 //x=58.21 //y=4.88 //x2=58.21 //y2=4.88
r635 (  41 116 ) resistor r=9.3 //w=0.17 //l=0.17 //layer=mcon //count=1 \
 //x=58.21 //y=2.26 //x2=58.21 //y2=2.26
r636 (  39 75 ) resistor r=4.5 //w=0.15 //l=0.15 //layer=via1 //count=1 \
 //x=56.365 //y=3.885 //x2=56.365 //y2=3.885
r637 (  37 39 ) resistor r=0.00167112 //w=0.374 //l=0.005 //layer=m1 \
 //thickness=0.36 //x=56.415 //y=3.88 //x2=56.415 //y2=3.885
r638 (  35 203 ) resistor r=9.3 //w=0.17 //l=0.17 //layer=mcon //count=1 \
 //x=55.875 //y=1.19 //x2=55.875 //y2=1.19
r639 (  33 99 ) resistor r=9.3 //w=0.17 //l=0.17 //layer=mcon //count=1 \
 //x=55.58 //y=5.56 //x2=55.58 //y2=5.56
r640 (  30 91 ) resistor r=9.3 //w=0.17 //l=0.17 //layer=mcon //count=1 \
 //x=54.7 //y=5.56 //x2=54.7 //y2=5.56
r641 (  28 30 ) resistor r=0.121228 //w=0.232 //l=0.225 //layer=m1 \
 //thickness=0.36 //x=54.7 //y=5.335 //x2=54.7 //y2=5.56
r642 (  27 83 ) resistor r=9.3 //w=0.17 //l=0.17 //layer=mcon //count=1 \
 //x=53.82 //y=5.56 //x2=53.82 //y2=5.56
r643 (  25 27 ) resistor r=0.129608 //w=0.217 //l=0.225 //layer=m1 \
 //thickness=0.36 //x=53.822 //y=5.335 //x2=53.822 //y2=5.56
r644 (  24 53 ) resistor r=0.0760407 //w=0.238 //l=0.125 //layer=m1 \
 //thickness=0.36 //x=71.16 //y=4.755 //x2=71.16 //y2=4.88
r645 (  23 48 ) resistor r=0.0909648 //w=0.371 //l=0.186762 //layer=m1 \
 //thickness=0.36 //x=71.16 //y=4.04 //x2=71.102 //y2=3.88
r646 (  23 24 ) resistor r=0.682252 //w=0.131 //l=0.715 //layer=m1 \
 //thickness=0.36 //x=71.16 //y=4.04 //x2=71.16 //y2=4.755
r647 (  22 48 ) resistor r=0.0909648 //w=0.371 //l=0.186762 //layer=m1 \
 //thickness=0.36 //x=71.16 //y=3.72 //x2=71.102 //y2=3.88
r648 (  21 51 ) resistor r=0.0719237 //w=0.222 //l=0.115 //layer=m1 \
 //thickness=0.36 //x=71.16 //y=2.375 //x2=71.16 //y2=2.26
r649 (  21 22 ) resistor r=1.2834 //w=0.131 //l=1.345 //layer=m1 \
 //thickness=0.36 //x=71.16 //y=2.375 //x2=71.16 //y2=3.72
r650 (  20 43 ) resistor r=0.0760407 //w=0.238 //l=0.125 //layer=m1 \
 //thickness=0.36 //x=58.21 //y=4.755 //x2=58.21 //y2=4.88
r651 (  19 45 ) resistor r=0.0910802 //w=0.374 //l=0.185472 //layer=m1 \
 //thickness=0.36 //x=58.21 //y=4.04 //x2=58.265 //y2=3.88
r652 (  19 20 ) resistor r=0.682252 //w=0.131 //l=0.715 //layer=m1 \
 //thickness=0.36 //x=58.21 //y=4.04 //x2=58.21 //y2=4.755
r653 (  18 45 ) resistor r=0.0910802 //w=0.374 //l=0.185472 //layer=m1 \
 //thickness=0.36 //x=58.21 //y=3.72 //x2=58.265 //y2=3.88
r654 (  17 41 ) resistor r=0.0719237 //w=0.222 //l=0.115 //layer=m1 \
 //thickness=0.36 //x=58.21 //y=2.375 //x2=58.21 //y2=2.26
r655 (  17 18 ) resistor r=1.2834 //w=0.131 //l=1.345 //layer=m1 \
 //thickness=0.36 //x=58.21 //y=2.375 //x2=58.21 //y2=3.72
r656 (  15 39 ) resistor r=0.0910802 //w=0.374 //l=0.185472 //layer=m1 \
 //thickness=0.36 //x=56.36 //y=4.045 //x2=56.415 //y2=3.885
r657 (  15 16 ) resistor r=1.14981 //w=0.131 //l=1.205 //layer=m1 \
 //thickness=0.36 //x=56.36 //y=4.045 //x2=56.36 //y2=5.25
r658 (  14 37 ) resistor r=0.089409 //w=0.374 //l=0.180416 //layer=m1 \
 //thickness=0.36 //x=56.36 //y=3.725 //x2=56.415 //y2=3.88
r659 (  13 14 ) resistor r=1.71279 //w=0.131 //l=1.795 //layer=m1 \
 //thickness=0.36 //x=56.36 //y=1.93 //x2=56.36 //y2=3.725
r660 (  11 13 ) resistor r=0.0698411 //w=0.17 //l=0.120208 //layer=m1 \
 //thickness=0.36 //x=56.275 //y=1.845 //x2=56.36 //y2=1.93
r661 (  11 12 ) resistor r=0.300573 //w=0.131 //l=0.315 //layer=m1 \
 //thickness=0.36 //x=56.275 //y=1.845 //x2=55.96 //y2=1.845
r662 (  10 12 ) resistor r=0.0698411 //w=0.17 //l=0.120208 //layer=m1 \
 //thickness=0.36 //x=55.875 //y=1.76 //x2=55.96 //y2=1.845
r663 (  9 35 ) resistor r=0.0717383 //w=0.224 //l=0.115 //layer=m1 \
 //thickness=0.36 //x=55.875 //y=1.305 //x2=55.875 //y2=1.19
r664 (  9 10 ) resistor r=0.43416 //w=0.131 //l=0.455 //layer=m1 \
 //thickness=0.36 //x=55.875 //y=1.305 //x2=55.875 //y2=1.76
r665 (  8 31 ) resistor r=0.0675342 //w=0.23 //l=0.115 //layer=m1 \
 //thickness=0.36 //x=55.695 //y=5.335 //x2=55.58 //y2=5.335
r666 (  7 16 ) resistor r=0.0698411 //w=0.17 //l=0.120208 //layer=m1 \
 //thickness=0.36 //x=56.275 //y=5.335 //x2=56.36 //y2=5.25
r667 (  7 8 ) resistor r=0.553435 //w=0.131 //l=0.58 //layer=m1 \
 //thickness=0.36 //x=56.275 //y=5.335 //x2=55.695 //y2=5.335
r668 (  6 33 ) resistor r=0.00118313 //w=0.23 //layer=m1 //thickness=0.36 \
 //x=55.58 //y=5.56 //x2=55.58 //y2=5.56
r669 (  5 31 ) resistor r=0.002872 //w=0.34 //l=0.085 //layer=m1 \
 //thickness=0.36 //x=55.58 //y=5.42 //x2=55.58 //y2=5.335
r670 (  5 6 ) resistor r=0.091623 //w=0.191 //l=0.14 //layer=m1 \
 //thickness=0.36 //x=55.58 //y=5.42 //x2=55.58 //y2=5.56
r671 (  4 28 ) resistor r=0.0262263 //w=0.232 //l=0.12 //layer=m1 \
 //thickness=0.36 //x=54.82 //y=5.335 //x2=54.7 //y2=5.335
r672 (  3 31 ) resistor r=0.0675342 //w=0.23 //l=0.115 //layer=m1 \
 //thickness=0.36 //x=55.465 //y=5.335 //x2=55.58 //y2=5.335
r673 (  3 4 ) resistor r=0.615458 //w=0.131 //l=0.645 //layer=m1 \
 //thickness=0.36 //x=55.465 //y=5.335 //x2=54.82 //y2=5.335
r674 (  2 25 ) resistor r=0.0222262 //w=0.217 //l=0.118 //layer=m1 \
 //thickness=0.36 //x=53.94 //y=5.335 //x2=53.822 //y2=5.335
r675 (  1 28 ) resistor r=0.0262263 //w=0.232 //l=0.12 //layer=m1 \
 //thickness=0.36 //x=54.58 //y=5.335 //x2=54.7 //y2=5.335
r676 (  1 2 ) resistor r=0.610687 //w=0.131 //l=0.64 //layer=m1 \
 //thickness=0.36 //x=54.58 //y=5.335 //x2=53.94 //y2=5.335
ends PM_TMRDFFRNQNX1\%noxref_12

subckt PM_TMRDFFRNQNX1\%RN ( 1 2 3 4 5 6 7 8 9 10 12 14 15 18 19 22 23 24 25 \
 27 28 31 32 33 34 35 36 94 96 97 99 109 113 114 121 122 125 126 129 130 133 \
 134 136 137 140 145 150 155 160 165 170 175 180 185 190 195 200 205 210 215 \
 220 225 229 230 231 232 233 234 235 236 237 238 239 240 241 242 243 244 245 \
 246 247 248 249 250 251 252 253 254 255 259 260 261 266 268 271 272 276 277 \
 278 283 285 288 289 290 291 292 294 300 301 302 303 304 312 313 314 319 321 \
 324 325 329 330 331 336 338 341 342 343 344 345 347 353 354 355 356 357 365 \
 366 367 372 374 377 378 382 383 384 389 391 394 395 396 397 398 400 406 407 \
 408 409 410 416 417 422 426 427 432 438 447 448 453 457 458 463 469 478 479 \
 484 488 489 494 500 )
c1427 ( 500 0 ) capacitor c=0.0369044f //x=72.27 //y=4.88
c1428 ( 494 0 ) capacitor c=0.0710579f //x=68.57 //y=4.88
c1429 ( 489 0 ) capacitor c=0.0278202f //x=68.57 //y=2.095
c1430 ( 488 0 ) capacitor c=0.0490597f //x=68.57 //y=2.26
c1431 ( 484 0 ) capacitor c=0.0710579f //x=60.43 //y=4.88
c1432 ( 479 0 ) capacitor c=0.0278202f //x=60.43 //y=2.095
c1433 ( 478 0 ) capacitor c=0.0490597f //x=60.43 //y=2.26
c1434 ( 469 0 ) capacitor c=0.0369044f //x=46.37 //y=4.88
c1435 ( 463 0 ) capacitor c=0.0710579f //x=42.67 //y=4.88
c1436 ( 458 0 ) capacitor c=0.0278202f //x=42.67 //y=2.095
c1437 ( 457 0 ) capacitor c=0.0490597f //x=42.67 //y=2.26
c1438 ( 453 0 ) capacitor c=0.0710579f //x=34.53 //y=4.88
c1439 ( 448 0 ) capacitor c=0.0278202f //x=34.53 //y=2.095
c1440 ( 447 0 ) capacitor c=0.0490597f //x=34.53 //y=2.26
c1441 ( 438 0 ) capacitor c=0.0369044f //x=20.47 //y=4.88
c1442 ( 432 0 ) capacitor c=0.0710579f //x=16.77 //y=4.88
c1443 ( 427 0 ) capacitor c=0.0278202f //x=16.77 //y=2.095
c1444 ( 426 0 ) capacitor c=0.0490597f //x=16.77 //y=2.26
c1445 ( 422 0 ) capacitor c=0.0710579f //x=8.63 //y=4.88
c1446 ( 417 0 ) capacitor c=0.0278202f //x=8.63 //y=2.095
c1447 ( 416 0 ) capacitor c=0.0490597f //x=8.63 //y=2.26
c1448 ( 410 0 ) capacitor c=0.0309248f //x=72.605 //y=4.97
c1449 ( 409 0 ) capacitor c=0.0852528f //x=72.36 //y=2.095
c1450 ( 408 0 ) capacitor c=0.0170266f //x=72.36 //y=1.63
c1451 ( 407 0 ) capacitor c=0.018609f //x=72.36 //y=1.4
c1452 ( 406 0 ) capacitor c=0.0186599f //x=72.36 //y=1.09
c1453 ( 400 0 ) capacitor c=0.0146988f //x=72.205 //y=1.555
c1454 ( 398 0 ) capacitor c=0.0148531f //x=72.205 //y=0.935
c1455 ( 397 0 ) capacitor c=0.0334406f //x=71.835 //y=1.4
c1456 ( 396 0 ) capacitor c=0.0173191f //x=71.835 //y=1.09
c1457 ( 395 0 ) capacitor c=0.0443175f //x=69.09 //y=1.44
c1458 ( 394 0 ) capacitor c=0.0199703f //x=69.09 //y=1.095
c1459 ( 391 0 ) capacitor c=0.0160331f //x=68.935 //y=1.595
c1460 ( 389 0 ) capacitor c=0.0157807f //x=68.935 //y=0.94
c1461 ( 384 0 ) capacitor c=0.0219045f //x=68.56 //y=1.75
c1462 ( 383 0 ) capacitor c=0.0207489f //x=68.56 //y=1.44
c1463 ( 382 0 ) capacitor c=0.0194091f //x=68.56 //y=1.095
c1464 ( 378 0 ) capacitor c=0.0443175f //x=60.95 //y=1.44
c1465 ( 377 0 ) capacitor c=0.0199703f //x=60.95 //y=1.095
c1466 ( 374 0 ) capacitor c=0.0160331f //x=60.795 //y=1.595
c1467 ( 372 0 ) capacitor c=0.0157807f //x=60.795 //y=0.94
c1468 ( 367 0 ) capacitor c=0.0219045f //x=60.42 //y=1.75
c1469 ( 366 0 ) capacitor c=0.0207489f //x=60.42 //y=1.44
c1470 ( 365 0 ) capacitor c=0.0194091f //x=60.42 //y=1.095
c1471 ( 357 0 ) capacitor c=0.0309248f //x=46.705 //y=4.97
c1472 ( 356 0 ) capacitor c=0.0852528f //x=46.46 //y=2.095
c1473 ( 355 0 ) capacitor c=0.0170266f //x=46.46 //y=1.63
c1474 ( 354 0 ) capacitor c=0.018609f //x=46.46 //y=1.4
c1475 ( 353 0 ) capacitor c=0.0186599f //x=46.46 //y=1.09
c1476 ( 347 0 ) capacitor c=0.0146988f //x=46.305 //y=1.555
c1477 ( 345 0 ) capacitor c=0.0148531f //x=46.305 //y=0.935
c1478 ( 344 0 ) capacitor c=0.0334406f //x=45.935 //y=1.4
c1479 ( 343 0 ) capacitor c=0.0173191f //x=45.935 //y=1.09
c1480 ( 342 0 ) capacitor c=0.0443175f //x=43.19 //y=1.44
c1481 ( 341 0 ) capacitor c=0.0199703f //x=43.19 //y=1.095
c1482 ( 338 0 ) capacitor c=0.0160331f //x=43.035 //y=1.595
c1483 ( 336 0 ) capacitor c=0.0157807f //x=43.035 //y=0.94
c1484 ( 331 0 ) capacitor c=0.0219045f //x=42.66 //y=1.75
c1485 ( 330 0 ) capacitor c=0.0207489f //x=42.66 //y=1.44
c1486 ( 329 0 ) capacitor c=0.0194091f //x=42.66 //y=1.095
c1487 ( 325 0 ) capacitor c=0.0443175f //x=35.05 //y=1.44
c1488 ( 324 0 ) capacitor c=0.0199703f //x=35.05 //y=1.095
c1489 ( 321 0 ) capacitor c=0.0160331f //x=34.895 //y=1.595
c1490 ( 319 0 ) capacitor c=0.0157807f //x=34.895 //y=0.94
c1491 ( 314 0 ) capacitor c=0.0219045f //x=34.52 //y=1.75
c1492 ( 313 0 ) capacitor c=0.0207489f //x=34.52 //y=1.44
c1493 ( 312 0 ) capacitor c=0.0194091f //x=34.52 //y=1.095
c1494 ( 304 0 ) capacitor c=0.0309248f //x=20.805 //y=4.97
c1495 ( 303 0 ) capacitor c=0.0852528f //x=20.56 //y=2.095
c1496 ( 302 0 ) capacitor c=0.0170266f //x=20.56 //y=1.63
c1497 ( 301 0 ) capacitor c=0.018609f //x=20.56 //y=1.4
c1498 ( 300 0 ) capacitor c=0.0186599f //x=20.56 //y=1.09
c1499 ( 294 0 ) capacitor c=0.0146988f //x=20.405 //y=1.555
c1500 ( 292 0 ) capacitor c=0.0148531f //x=20.405 //y=0.935
c1501 ( 291 0 ) capacitor c=0.0334406f //x=20.035 //y=1.4
c1502 ( 290 0 ) capacitor c=0.0173191f //x=20.035 //y=1.09
c1503 ( 289 0 ) capacitor c=0.0443175f //x=17.29 //y=1.44
c1504 ( 288 0 ) capacitor c=0.0199703f //x=17.29 //y=1.095
c1505 ( 285 0 ) capacitor c=0.0160331f //x=17.135 //y=1.595
c1506 ( 283 0 ) capacitor c=0.0157807f //x=17.135 //y=0.94
c1507 ( 278 0 ) capacitor c=0.0219045f //x=16.76 //y=1.75
c1508 ( 277 0 ) capacitor c=0.0207489f //x=16.76 //y=1.44
c1509 ( 276 0 ) capacitor c=0.0194091f //x=16.76 //y=1.095
c1510 ( 272 0 ) capacitor c=0.0443175f //x=9.15 //y=1.44
c1511 ( 271 0 ) capacitor c=0.0199703f //x=9.15 //y=1.095
c1512 ( 268 0 ) capacitor c=0.0160331f //x=8.995 //y=1.595
c1513 ( 266 0 ) capacitor c=0.0157807f //x=8.995 //y=0.94
c1514 ( 261 0 ) capacitor c=0.0219045f //x=8.62 //y=1.75
c1515 ( 260 0 ) capacitor c=0.0207489f //x=8.62 //y=1.44
c1516 ( 259 0 ) capacitor c=0.0194091f //x=8.62 //y=1.095
c1517 ( 255 0 ) capacitor c=0.110208f //x=72.68 //y=6.2
c1518 ( 254 0 ) capacitor c=0.110214f //x=72.24 //y=6.2
c1519 ( 253 0 ) capacitor c=0.159671f //x=68.75 //y=6.2
c1520 ( 252 0 ) capacitor c=0.110208f //x=68.31 //y=6.2
c1521 ( 251 0 ) capacitor c=0.159671f //x=60.61 //y=6.2
c1522 ( 250 0 ) capacitor c=0.110208f //x=60.17 //y=6.2
c1523 ( 249 0 ) capacitor c=0.110208f //x=46.78 //y=6.2
c1524 ( 248 0 ) capacitor c=0.110214f //x=46.34 //y=6.2
c1525 ( 247 0 ) capacitor c=0.159671f //x=42.85 //y=6.2
c1526 ( 246 0 ) capacitor c=0.110208f //x=42.41 //y=6.2
c1527 ( 245 0 ) capacitor c=0.159671f //x=34.71 //y=6.2
c1528 ( 244 0 ) capacitor c=0.110208f //x=34.27 //y=6.2
c1529 ( 243 0 ) capacitor c=0.110208f //x=20.88 //y=6.2
c1530 ( 242 0 ) capacitor c=0.110214f //x=20.44 //y=6.2
c1531 ( 241 0 ) capacitor c=0.159671f //x=16.95 //y=6.2
c1532 ( 240 0 ) capacitor c=0.110208f //x=16.51 //y=6.2
c1533 ( 239 0 ) capacitor c=0.159671f //x=8.81 //y=6.2
c1534 ( 238 0 ) capacitor c=0.110208f //x=8.37 //y=6.2
c1535 ( 225 0 ) capacitor c=0.00129935f //x=72.27 //y=4.88
c1536 ( 220 0 ) capacitor c=0.00121786f //x=72.27 //y=2.26
c1537 ( 215 0 ) capacitor c=7.7417e-19 //x=68.57 //y=4.88
c1538 ( 210 0 ) capacitor c=0.00118671f //x=68.57 //y=2.26
c1539 ( 205 0 ) capacitor c=7.7417e-19 //x=60.43 //y=4.88
c1540 ( 200 0 ) capacitor c=0.00118671f //x=60.43 //y=2.26
c1541 ( 195 0 ) capacitor c=0.00129935f //x=46.37 //y=4.88
c1542 ( 190 0 ) capacitor c=0.00121786f //x=46.37 //y=2.26
c1543 ( 185 0 ) capacitor c=7.7417e-19 //x=42.67 //y=4.88
c1544 ( 180 0 ) capacitor c=0.00118671f //x=42.67 //y=2.26
c1545 ( 175 0 ) capacitor c=7.7417e-19 //x=34.53 //y=4.88
c1546 ( 170 0 ) capacitor c=0.00118671f //x=34.53 //y=2.26
c1547 ( 165 0 ) capacitor c=0.00129935f //x=20.47 //y=4.88
c1548 ( 160 0 ) capacitor c=0.00121786f //x=20.47 //y=2.26
c1549 ( 155 0 ) capacitor c=7.7417e-19 //x=16.77 //y=4.88
c1550 ( 150 0 ) capacitor c=0.00118671f //x=16.77 //y=2.26
c1551 ( 145 0 ) capacitor c=7.7417e-19 //x=8.63 //y=4.88
c1552 ( 140 0 ) capacitor c=0.00118671f //x=8.63 //y=2.26
c1553 ( 137 0 ) capacitor c=0.0848638f //x=72.065 //y=2.355
c1554 ( 136 0 ) capacitor c=0.00518283f //x=72.225 //y=2.355
c1555 ( 134 0 ) capacitor c=0.00830419f //x=68.735 //y=2.315
c1556 ( 133 0 ) capacitor c=0.19753f //x=68.415 //y=2.315
c1557 ( 130 0 ) capacitor c=0.00830419f //x=60.595 //y=2.315
c1558 ( 129 0 ) capacitor c=0.31666f //x=60.275 //y=2.315
c1559 ( 126 0 ) capacitor c=0.00498937f //x=46.485 //y=2.355
c1560 ( 125 0 ) capacitor c=0.075506f //x=46.165 //y=2.355
c1561 ( 122 0 ) capacitor c=0.00776587f //x=42.835 //y=2.315
c1562 ( 121 0 ) capacitor c=0.176703f //x=42.515 //y=2.315
c1563 ( 114 0 ) capacitor c=0.00776587f //x=16.935 //y=2.315
c1564 ( 113 0 ) capacitor c=0.176703f //x=16.615 //y=2.315
c1565 ( 109 0 ) capacitor c=0.00842516f //x=8.635 //y=2.305
c1566 ( 99 0 ) capacitor c=0.0264106f //x=34.695 //y=2.4
c1567 ( 97 0 ) capacitor c=0.291601f //x=33.205 //y=2.37
c1568 ( 96 0 ) capacitor c=0.00844631f //x=33.635 //y=2.37
c1569 ( 94 0 ) capacitor c=0.075506f //x=20.265 //y=2.4
c1570 ( 36 0 ) capacitor c=0.00506049f //x=72.27 //y=4.765
c1571 ( 35 0 ) capacitor c=0.00933959f //x=72.27 //y=2.515
c1572 ( 34 0 ) capacitor c=0.0607928f //x=68.57 //y=4.75
c1573 ( 33 0 ) capacitor c=0.0111478f //x=68.57 //y=2.465
c1574 ( 32 0 ) capacitor c=0.0586286f //x=60.43 //y=4.75
c1575 ( 31 0 ) capacitor c=0.0113376f //x=60.43 //y=2.465
c1576 ( 28 0 ) capacitor c=0.00506049f //x=46.37 //y=4.765
c1577 ( 27 0 ) capacitor c=0.00916792f //x=46.37 //y=2.515
c1578 ( 25 0 ) capacitor c=0.00449964f //x=42.67 //y=4.75
c1579 ( 24 0 ) capacitor c=0.0111214f //x=42.67 //y=2.465
c1580 ( 23 0 ) capacitor c=0.0584036f //x=34.53 //y=4.75
c1581 ( 22 0 ) capacitor c=0.0111214f //x=34.53 //y=2.465
c1582 ( 19 0 ) capacitor c=0.00506049f //x=20.47 //y=4.765
c1583 ( 18 0 ) capacitor c=0.00916777f //x=20.47 //y=2.515
c1584 ( 15 0 ) capacitor c=0.00449964f //x=16.77 //y=4.75
c1585 ( 14 0 ) capacitor c=0.0111214f //x=16.77 //y=2.465
c1586 ( 12 0 ) capacitor c=0.00452448f //x=8.63 //y=4.75
c1587 ( 10 0 ) capacitor c=0.0111214f //x=8.63 //y=2.4
c1588 ( 9 0 ) capacitor c=0.0608717f //x=72.27 //y=3.88
c1589 ( 7 0 ) capacitor c=0.0594606f //x=46.37 //y=3.51
c1590 ( 6 0 ) capacitor c=0.0561443f //x=42.67 //y=3.51
c1591 ( 4 0 ) capacitor c=0.0635313f //x=20.47 //y=3.14
c1592 ( 2 0 ) capacitor c=0.0584568f //x=16.77 //y=3.14
c1593 ( 1 0 ) capacitor c=0.0562304f //x=8.63 //y=3.14
r1594 (  502 503 ) resistor r=32.4568 //w=0.214 //l=0.075 //layer=ply \
 //thickness=0.18 //x=72.27 //y=4.97 //x2=72.27 //y2=5.045
r1595 (  500 502 ) resistor r=20.271 //w=0.214 //l=0.09 //layer=ply \
 //thickness=0.18 //x=72.27 //y=4.88 //x2=72.27 //y2=4.97
r1596 (  488 489 ) resistor r=52.7279 //w=0.214 //l=0.165 //layer=ply \
 //thickness=0.18 //x=68.57 //y=2.26 //x2=68.57 //y2=2.095
r1597 (  478 479 ) resistor r=52.7279 //w=0.214 //l=0.165 //layer=ply \
 //thickness=0.18 //x=60.43 //y=2.26 //x2=60.43 //y2=2.095
r1598 (  471 472 ) resistor r=32.4568 //w=0.214 //l=0.075 //layer=ply \
 //thickness=0.18 //x=46.37 //y=4.97 //x2=46.37 //y2=5.045
r1599 (  469 471 ) resistor r=20.271 //w=0.214 //l=0.09 //layer=ply \
 //thickness=0.18 //x=46.37 //y=4.88 //x2=46.37 //y2=4.97
r1600 (  457 458 ) resistor r=52.7279 //w=0.214 //l=0.165 //layer=ply \
 //thickness=0.18 //x=42.67 //y=2.26 //x2=42.67 //y2=2.095
r1601 (  447 448 ) resistor r=52.7279 //w=0.214 //l=0.165 //layer=ply \
 //thickness=0.18 //x=34.53 //y=2.26 //x2=34.53 //y2=2.095
r1602 (  440 441 ) resistor r=32.4568 //w=0.214 //l=0.075 //layer=ply \
 //thickness=0.18 //x=20.47 //y=4.97 //x2=20.47 //y2=5.045
r1603 (  438 440 ) resistor r=20.271 //w=0.214 //l=0.09 //layer=ply \
 //thickness=0.18 //x=20.47 //y=4.88 //x2=20.47 //y2=4.97
r1604 (  426 427 ) resistor r=52.7279 //w=0.214 //l=0.165 //layer=ply \
 //thickness=0.18 //x=16.77 //y=2.26 //x2=16.77 //y2=2.095
r1605 (  416 417 ) resistor r=52.7279 //w=0.214 //l=0.165 //layer=ply \
 //thickness=0.18 //x=8.63 //y=2.26 //x2=8.63 //y2=2.095
r1606 (  411 502 ) resistor r=16.5046 //w=0.27 //l=0.135 //layer=ply \
 //thickness=0.18 //x=72.405 //y=4.97 //x2=72.27 //y2=4.97
r1607 (  410 412 ) resistor r=26.9307 //w=0.15 //l=0.106066 //layer=ply \
 //thickness=0.18 //x=72.605 //y=4.97 //x2=72.68 //y2=5.045
r1608 (  410 411 ) resistor r=102.553 //w=0.094 //l=0.2 //layer=ply \
 //thickness=0.18 //x=72.605 //y=4.97 //x2=72.405 //y2=4.97
r1609 (  409 507 ) resistor r=38.6777 //w=0.284 //l=0.198997 //layer=ply \
 //thickness=0.18 //x=72.36 //y=2.095 //x2=72.285 //y2=2.26
r1610 (  408 505 ) resistor r=21.2976 //w=0.217 //l=0.0928709 //layer=ply \
 //thickness=0.18 //x=72.36 //y=1.63 //x2=72.32 //y2=1.555
r1611 (  408 409 ) resistor r=238.436 //w=0.094 //l=0.465 //layer=ply \
 //thickness=0.18 //x=72.36 //y=1.63 //x2=72.36 //y2=2.095
r1612 (  407 505 ) resistor r=39.0671 //w=0.217 //l=0.173853 //layer=ply \
 //thickness=0.18 //x=72.36 //y=1.4 //x2=72.32 //y2=1.555
r1613 (  406 504 ) resistor r=45.1352 //w=0.168 //l=0.173853 //layer=ply \
 //thickness=0.18 //x=72.36 //y=1.09 //x2=72.32 //y2=0.935
r1614 (  406 407 ) resistor r=158.957 //w=0.094 //l=0.31 //layer=ply \
 //thickness=0.18 //x=72.36 //y=1.09 //x2=72.36 //y2=1.4
r1615 (  401 498 ) resistor r=5.52526 //w=0.168 //l=0.115 //layer=ply \
 //thickness=0.18 //x=71.99 //y=1.555 //x2=71.875 //y2=1.555
r1616 (  400 505 ) resistor r=11.4558 //w=0.217 //l=0.115 //layer=ply \
 //thickness=0.18 //x=72.205 //y=1.555 //x2=72.32 //y2=1.555
r1617 (  399 497 ) resistor r=5.52526 //w=0.168 //l=0.115 //layer=ply \
 //thickness=0.18 //x=71.99 //y=0.935 //x2=71.875 //y2=0.935
r1618 (  398 504 ) resistor r=5.52526 //w=0.168 //l=0.115 //layer=ply \
 //thickness=0.18 //x=72.205 //y=0.935 //x2=72.32 //y2=0.935
r1619 (  398 399 ) resistor r=110.245 //w=0.094 //l=0.215 //layer=ply \
 //thickness=0.18 //x=72.205 //y=0.935 //x2=71.99 //y2=0.935
r1620 (  397 498 ) resistor r=45.1352 //w=0.168 //l=0.173853 //layer=ply \
 //thickness=0.18 //x=71.835 //y=1.4 //x2=71.875 //y2=1.555
r1621 (  396 497 ) resistor r=45.1352 //w=0.168 //l=0.173853 //layer=ply \
 //thickness=0.18 //x=71.835 //y=1.09 //x2=71.875 //y2=0.935
r1622 (  396 397 ) resistor r=158.957 //w=0.094 //l=0.31 //layer=ply \
 //thickness=0.18 //x=71.835 //y=1.09 //x2=71.835 //y2=1.4
r1623 (  395 496 ) resistor r=45.1352 //w=0.168 //l=0.173853 //layer=ply \
 //thickness=0.18 //x=69.09 //y=1.44 //x2=69.05 //y2=1.595
r1624 (  394 495 ) resistor r=45.1352 //w=0.168 //l=0.173853 //layer=ply \
 //thickness=0.18 //x=69.09 //y=1.095 //x2=69.05 //y2=0.94
r1625 (  394 395 ) resistor r=176.904 //w=0.094 //l=0.345 //layer=ply \
 //thickness=0.18 //x=69.09 //y=1.095 //x2=69.09 //y2=1.44
r1626 (  392 492 ) resistor r=10.701 //w=0.21 //l=0.115 //layer=ply \
 //thickness=0.18 //x=68.715 //y=1.595 //x2=68.6 //y2=1.595
r1627 (  391 496 ) resistor r=5.52526 //w=0.168 //l=0.115 //layer=ply \
 //thickness=0.18 //x=68.935 //y=1.595 //x2=69.05 //y2=1.595
r1628 (  390 491 ) resistor r=5.52526 //w=0.168 //l=0.115 //layer=ply \
 //thickness=0.18 //x=68.715 //y=0.94 //x2=68.6 //y2=0.94
r1629 (  389 495 ) resistor r=5.52526 //w=0.168 //l=0.115 //layer=ply \
 //thickness=0.18 //x=68.935 //y=0.94 //x2=69.05 //y2=0.94
r1630 (  389 390 ) resistor r=112.809 //w=0.094 //l=0.22 //layer=ply \
 //thickness=0.18 //x=68.935 //y=0.94 //x2=68.715 //y2=0.94
r1631 (  386 494 ) resistor r=37.236 //w=0.233 //l=0.249199 //layer=ply \
 //thickness=0.18 //x=68.75 //y=5.045 //x2=68.57 //y2=4.88
r1632 (  384 492 ) resistor r=39.5823 //w=0.21 //l=0.173853 //layer=ply \
 //thickness=0.18 //x=68.56 //y=1.75 //x2=68.6 //y2=1.595
r1633 (  384 489 ) resistor r=176.904 //w=0.094 //l=0.345 //layer=ply \
 //thickness=0.18 //x=68.56 //y=1.75 //x2=68.56 //y2=2.095
r1634 (  383 492 ) resistor r=39.5823 //w=0.21 //l=0.173853 //layer=ply \
 //thickness=0.18 //x=68.56 //y=1.44 //x2=68.6 //y2=1.595
r1635 (  382 491 ) resistor r=45.1352 //w=0.168 //l=0.173853 //layer=ply \
 //thickness=0.18 //x=68.56 //y=1.095 //x2=68.6 //y2=0.94
r1636 (  382 383 ) resistor r=176.904 //w=0.094 //l=0.345 //layer=ply \
 //thickness=0.18 //x=68.56 //y=1.095 //x2=68.56 //y2=1.44
r1637 (  379 494 ) resistor r=53.7854 //w=0.233 //l=0.332415 //layer=ply \
 //thickness=0.18 //x=68.31 //y=5.045 //x2=68.57 //y2=4.88
r1638 (  378 486 ) resistor r=45.1352 //w=0.168 //l=0.173853 //layer=ply \
 //thickness=0.18 //x=60.95 //y=1.44 //x2=60.91 //y2=1.595
r1639 (  377 485 ) resistor r=45.1352 //w=0.168 //l=0.173853 //layer=ply \
 //thickness=0.18 //x=60.95 //y=1.095 //x2=60.91 //y2=0.94
r1640 (  377 378 ) resistor r=176.904 //w=0.094 //l=0.345 //layer=ply \
 //thickness=0.18 //x=60.95 //y=1.095 //x2=60.95 //y2=1.44
r1641 (  375 482 ) resistor r=10.701 //w=0.21 //l=0.115 //layer=ply \
 //thickness=0.18 //x=60.575 //y=1.595 //x2=60.46 //y2=1.595
r1642 (  374 486 ) resistor r=5.52526 //w=0.168 //l=0.115 //layer=ply \
 //thickness=0.18 //x=60.795 //y=1.595 //x2=60.91 //y2=1.595
r1643 (  373 481 ) resistor r=5.52526 //w=0.168 //l=0.115 //layer=ply \
 //thickness=0.18 //x=60.575 //y=0.94 //x2=60.46 //y2=0.94
r1644 (  372 485 ) resistor r=5.52526 //w=0.168 //l=0.115 //layer=ply \
 //thickness=0.18 //x=60.795 //y=0.94 //x2=60.91 //y2=0.94
r1645 (  372 373 ) resistor r=112.809 //w=0.094 //l=0.22 //layer=ply \
 //thickness=0.18 //x=60.795 //y=0.94 //x2=60.575 //y2=0.94
r1646 (  369 484 ) resistor r=37.236 //w=0.233 //l=0.249199 //layer=ply \
 //thickness=0.18 //x=60.61 //y=5.045 //x2=60.43 //y2=4.88
r1647 (  367 482 ) resistor r=39.5823 //w=0.21 //l=0.173853 //layer=ply \
 //thickness=0.18 //x=60.42 //y=1.75 //x2=60.46 //y2=1.595
r1648 (  367 479 ) resistor r=176.904 //w=0.094 //l=0.345 //layer=ply \
 //thickness=0.18 //x=60.42 //y=1.75 //x2=60.42 //y2=2.095
r1649 (  366 482 ) resistor r=39.5823 //w=0.21 //l=0.173853 //layer=ply \
 //thickness=0.18 //x=60.42 //y=1.44 //x2=60.46 //y2=1.595
r1650 (  365 481 ) resistor r=45.1352 //w=0.168 //l=0.173853 //layer=ply \
 //thickness=0.18 //x=60.42 //y=1.095 //x2=60.46 //y2=0.94
r1651 (  365 366 ) resistor r=176.904 //w=0.094 //l=0.345 //layer=ply \
 //thickness=0.18 //x=60.42 //y=1.095 //x2=60.42 //y2=1.44
r1652 (  362 484 ) resistor r=53.7854 //w=0.233 //l=0.332415 //layer=ply \
 //thickness=0.18 //x=60.17 //y=5.045 //x2=60.43 //y2=4.88
r1653 (  358 471 ) resistor r=16.5046 //w=0.27 //l=0.135 //layer=ply \
 //thickness=0.18 //x=46.505 //y=4.97 //x2=46.37 //y2=4.97
r1654 (  357 359 ) resistor r=26.9307 //w=0.15 //l=0.106066 //layer=ply \
 //thickness=0.18 //x=46.705 //y=4.97 //x2=46.78 //y2=5.045
r1655 (  357 358 ) resistor r=102.553 //w=0.094 //l=0.2 //layer=ply \
 //thickness=0.18 //x=46.705 //y=4.97 //x2=46.505 //y2=4.97
r1656 (  356 476 ) resistor r=38.6777 //w=0.284 //l=0.198997 //layer=ply \
 //thickness=0.18 //x=46.46 //y=2.095 //x2=46.385 //y2=2.26
r1657 (  355 474 ) resistor r=21.2976 //w=0.217 //l=0.0928709 //layer=ply \
 //thickness=0.18 //x=46.46 //y=1.63 //x2=46.42 //y2=1.555
r1658 (  355 356 ) resistor r=238.436 //w=0.094 //l=0.465 //layer=ply \
 //thickness=0.18 //x=46.46 //y=1.63 //x2=46.46 //y2=2.095
r1659 (  354 474 ) resistor r=39.0671 //w=0.217 //l=0.173853 //layer=ply \
 //thickness=0.18 //x=46.46 //y=1.4 //x2=46.42 //y2=1.555
r1660 (  353 473 ) resistor r=45.1352 //w=0.168 //l=0.173853 //layer=ply \
 //thickness=0.18 //x=46.46 //y=1.09 //x2=46.42 //y2=0.935
r1661 (  353 354 ) resistor r=158.957 //w=0.094 //l=0.31 //layer=ply \
 //thickness=0.18 //x=46.46 //y=1.09 //x2=46.46 //y2=1.4
r1662 (  348 467 ) resistor r=5.52526 //w=0.168 //l=0.115 //layer=ply \
 //thickness=0.18 //x=46.09 //y=1.555 //x2=45.975 //y2=1.555
r1663 (  347 474 ) resistor r=11.4558 //w=0.217 //l=0.115 //layer=ply \
 //thickness=0.18 //x=46.305 //y=1.555 //x2=46.42 //y2=1.555
r1664 (  346 466 ) resistor r=5.52526 //w=0.168 //l=0.115 //layer=ply \
 //thickness=0.18 //x=46.09 //y=0.935 //x2=45.975 //y2=0.935
r1665 (  345 473 ) resistor r=5.52526 //w=0.168 //l=0.115 //layer=ply \
 //thickness=0.18 //x=46.305 //y=0.935 //x2=46.42 //y2=0.935
r1666 (  345 346 ) resistor r=110.245 //w=0.094 //l=0.215 //layer=ply \
 //thickness=0.18 //x=46.305 //y=0.935 //x2=46.09 //y2=0.935
r1667 (  344 467 ) resistor r=45.1352 //w=0.168 //l=0.173853 //layer=ply \
 //thickness=0.18 //x=45.935 //y=1.4 //x2=45.975 //y2=1.555
r1668 (  343 466 ) resistor r=45.1352 //w=0.168 //l=0.173853 //layer=ply \
 //thickness=0.18 //x=45.935 //y=1.09 //x2=45.975 //y2=0.935
r1669 (  343 344 ) resistor r=158.957 //w=0.094 //l=0.31 //layer=ply \
 //thickness=0.18 //x=45.935 //y=1.09 //x2=45.935 //y2=1.4
r1670 (  342 465 ) resistor r=45.1352 //w=0.168 //l=0.173853 //layer=ply \
 //thickness=0.18 //x=43.19 //y=1.44 //x2=43.15 //y2=1.595
r1671 (  341 464 ) resistor r=45.1352 //w=0.168 //l=0.173853 //layer=ply \
 //thickness=0.18 //x=43.19 //y=1.095 //x2=43.15 //y2=0.94
r1672 (  341 342 ) resistor r=176.904 //w=0.094 //l=0.345 //layer=ply \
 //thickness=0.18 //x=43.19 //y=1.095 //x2=43.19 //y2=1.44
r1673 (  339 461 ) resistor r=10.701 //w=0.21 //l=0.115 //layer=ply \
 //thickness=0.18 //x=42.815 //y=1.595 //x2=42.7 //y2=1.595
r1674 (  338 465 ) resistor r=5.52526 //w=0.168 //l=0.115 //layer=ply \
 //thickness=0.18 //x=43.035 //y=1.595 //x2=43.15 //y2=1.595
r1675 (  337 460 ) resistor r=5.52526 //w=0.168 //l=0.115 //layer=ply \
 //thickness=0.18 //x=42.815 //y=0.94 //x2=42.7 //y2=0.94
r1676 (  336 464 ) resistor r=5.52526 //w=0.168 //l=0.115 //layer=ply \
 //thickness=0.18 //x=43.035 //y=0.94 //x2=43.15 //y2=0.94
r1677 (  336 337 ) resistor r=112.809 //w=0.094 //l=0.22 //layer=ply \
 //thickness=0.18 //x=43.035 //y=0.94 //x2=42.815 //y2=0.94
r1678 (  333 463 ) resistor r=37.236 //w=0.233 //l=0.249199 //layer=ply \
 //thickness=0.18 //x=42.85 //y=5.045 //x2=42.67 //y2=4.88
r1679 (  331 461 ) resistor r=39.5823 //w=0.21 //l=0.173853 //layer=ply \
 //thickness=0.18 //x=42.66 //y=1.75 //x2=42.7 //y2=1.595
r1680 (  331 458 ) resistor r=176.904 //w=0.094 //l=0.345 //layer=ply \
 //thickness=0.18 //x=42.66 //y=1.75 //x2=42.66 //y2=2.095
r1681 (  330 461 ) resistor r=39.5823 //w=0.21 //l=0.173853 //layer=ply \
 //thickness=0.18 //x=42.66 //y=1.44 //x2=42.7 //y2=1.595
r1682 (  329 460 ) resistor r=45.1352 //w=0.168 //l=0.173853 //layer=ply \
 //thickness=0.18 //x=42.66 //y=1.095 //x2=42.7 //y2=0.94
r1683 (  329 330 ) resistor r=176.904 //w=0.094 //l=0.345 //layer=ply \
 //thickness=0.18 //x=42.66 //y=1.095 //x2=42.66 //y2=1.44
r1684 (  326 463 ) resistor r=53.7854 //w=0.233 //l=0.332415 //layer=ply \
 //thickness=0.18 //x=42.41 //y=5.045 //x2=42.67 //y2=4.88
r1685 (  325 455 ) resistor r=45.1352 //w=0.168 //l=0.173853 //layer=ply \
 //thickness=0.18 //x=35.05 //y=1.44 //x2=35.01 //y2=1.595
r1686 (  324 454 ) resistor r=45.1352 //w=0.168 //l=0.173853 //layer=ply \
 //thickness=0.18 //x=35.05 //y=1.095 //x2=35.01 //y2=0.94
r1687 (  324 325 ) resistor r=176.904 //w=0.094 //l=0.345 //layer=ply \
 //thickness=0.18 //x=35.05 //y=1.095 //x2=35.05 //y2=1.44
r1688 (  322 451 ) resistor r=10.701 //w=0.21 //l=0.115 //layer=ply \
 //thickness=0.18 //x=34.675 //y=1.595 //x2=34.56 //y2=1.595
r1689 (  321 455 ) resistor r=5.52526 //w=0.168 //l=0.115 //layer=ply \
 //thickness=0.18 //x=34.895 //y=1.595 //x2=35.01 //y2=1.595
r1690 (  320 450 ) resistor r=5.52526 //w=0.168 //l=0.115 //layer=ply \
 //thickness=0.18 //x=34.675 //y=0.94 //x2=34.56 //y2=0.94
r1691 (  319 454 ) resistor r=5.52526 //w=0.168 //l=0.115 //layer=ply \
 //thickness=0.18 //x=34.895 //y=0.94 //x2=35.01 //y2=0.94
r1692 (  319 320 ) resistor r=112.809 //w=0.094 //l=0.22 //layer=ply \
 //thickness=0.18 //x=34.895 //y=0.94 //x2=34.675 //y2=0.94
r1693 (  316 453 ) resistor r=37.236 //w=0.233 //l=0.249199 //layer=ply \
 //thickness=0.18 //x=34.71 //y=5.045 //x2=34.53 //y2=4.88
r1694 (  314 451 ) resistor r=39.5823 //w=0.21 //l=0.173853 //layer=ply \
 //thickness=0.18 //x=34.52 //y=1.75 //x2=34.56 //y2=1.595
r1695 (  314 448 ) resistor r=176.904 //w=0.094 //l=0.345 //layer=ply \
 //thickness=0.18 //x=34.52 //y=1.75 //x2=34.52 //y2=2.095
r1696 (  313 451 ) resistor r=39.5823 //w=0.21 //l=0.173853 //layer=ply \
 //thickness=0.18 //x=34.52 //y=1.44 //x2=34.56 //y2=1.595
r1697 (  312 450 ) resistor r=45.1352 //w=0.168 //l=0.173853 //layer=ply \
 //thickness=0.18 //x=34.52 //y=1.095 //x2=34.56 //y2=0.94
r1698 (  312 313 ) resistor r=176.904 //w=0.094 //l=0.345 //layer=ply \
 //thickness=0.18 //x=34.52 //y=1.095 //x2=34.52 //y2=1.44
r1699 (  309 453 ) resistor r=53.7854 //w=0.233 //l=0.332415 //layer=ply \
 //thickness=0.18 //x=34.27 //y=5.045 //x2=34.53 //y2=4.88
r1700 (  305 440 ) resistor r=16.5046 //w=0.27 //l=0.135 //layer=ply \
 //thickness=0.18 //x=20.605 //y=4.97 //x2=20.47 //y2=4.97
r1701 (  304 306 ) resistor r=26.9307 //w=0.15 //l=0.106066 //layer=ply \
 //thickness=0.18 //x=20.805 //y=4.97 //x2=20.88 //y2=5.045
r1702 (  304 305 ) resistor r=102.553 //w=0.094 //l=0.2 //layer=ply \
 //thickness=0.18 //x=20.805 //y=4.97 //x2=20.605 //y2=4.97
r1703 (  303 445 ) resistor r=38.6777 //w=0.284 //l=0.198997 //layer=ply \
 //thickness=0.18 //x=20.56 //y=2.095 //x2=20.485 //y2=2.26
r1704 (  302 443 ) resistor r=21.2976 //w=0.217 //l=0.0928709 //layer=ply \
 //thickness=0.18 //x=20.56 //y=1.63 //x2=20.52 //y2=1.555
r1705 (  302 303 ) resistor r=238.436 //w=0.094 //l=0.465 //layer=ply \
 //thickness=0.18 //x=20.56 //y=1.63 //x2=20.56 //y2=2.095
r1706 (  301 443 ) resistor r=39.0671 //w=0.217 //l=0.173853 //layer=ply \
 //thickness=0.18 //x=20.56 //y=1.4 //x2=20.52 //y2=1.555
r1707 (  300 442 ) resistor r=45.1352 //w=0.168 //l=0.173853 //layer=ply \
 //thickness=0.18 //x=20.56 //y=1.09 //x2=20.52 //y2=0.935
r1708 (  300 301 ) resistor r=158.957 //w=0.094 //l=0.31 //layer=ply \
 //thickness=0.18 //x=20.56 //y=1.09 //x2=20.56 //y2=1.4
r1709 (  295 436 ) resistor r=5.52526 //w=0.168 //l=0.115 //layer=ply \
 //thickness=0.18 //x=20.19 //y=1.555 //x2=20.075 //y2=1.555
r1710 (  294 443 ) resistor r=11.4558 //w=0.217 //l=0.115 //layer=ply \
 //thickness=0.18 //x=20.405 //y=1.555 //x2=20.52 //y2=1.555
r1711 (  293 435 ) resistor r=5.52526 //w=0.168 //l=0.115 //layer=ply \
 //thickness=0.18 //x=20.19 //y=0.935 //x2=20.075 //y2=0.935
r1712 (  292 442 ) resistor r=5.52526 //w=0.168 //l=0.115 //layer=ply \
 //thickness=0.18 //x=20.405 //y=0.935 //x2=20.52 //y2=0.935
r1713 (  292 293 ) resistor r=110.245 //w=0.094 //l=0.215 //layer=ply \
 //thickness=0.18 //x=20.405 //y=0.935 //x2=20.19 //y2=0.935
r1714 (  291 436 ) resistor r=45.1352 //w=0.168 //l=0.173853 //layer=ply \
 //thickness=0.18 //x=20.035 //y=1.4 //x2=20.075 //y2=1.555
r1715 (  290 435 ) resistor r=45.1352 //w=0.168 //l=0.173853 //layer=ply \
 //thickness=0.18 //x=20.035 //y=1.09 //x2=20.075 //y2=0.935
r1716 (  290 291 ) resistor r=158.957 //w=0.094 //l=0.31 //layer=ply \
 //thickness=0.18 //x=20.035 //y=1.09 //x2=20.035 //y2=1.4
r1717 (  289 434 ) resistor r=45.1352 //w=0.168 //l=0.173853 //layer=ply \
 //thickness=0.18 //x=17.29 //y=1.44 //x2=17.25 //y2=1.595
r1718 (  288 433 ) resistor r=45.1352 //w=0.168 //l=0.173853 //layer=ply \
 //thickness=0.18 //x=17.29 //y=1.095 //x2=17.25 //y2=0.94
r1719 (  288 289 ) resistor r=176.904 //w=0.094 //l=0.345 //layer=ply \
 //thickness=0.18 //x=17.29 //y=1.095 //x2=17.29 //y2=1.44
r1720 (  286 430 ) resistor r=10.701 //w=0.21 //l=0.115 //layer=ply \
 //thickness=0.18 //x=16.915 //y=1.595 //x2=16.8 //y2=1.595
r1721 (  285 434 ) resistor r=5.52526 //w=0.168 //l=0.115 //layer=ply \
 //thickness=0.18 //x=17.135 //y=1.595 //x2=17.25 //y2=1.595
r1722 (  284 429 ) resistor r=5.52526 //w=0.168 //l=0.115 //layer=ply \
 //thickness=0.18 //x=16.915 //y=0.94 //x2=16.8 //y2=0.94
r1723 (  283 433 ) resistor r=5.52526 //w=0.168 //l=0.115 //layer=ply \
 //thickness=0.18 //x=17.135 //y=0.94 //x2=17.25 //y2=0.94
r1724 (  283 284 ) resistor r=112.809 //w=0.094 //l=0.22 //layer=ply \
 //thickness=0.18 //x=17.135 //y=0.94 //x2=16.915 //y2=0.94
r1725 (  280 432 ) resistor r=37.236 //w=0.233 //l=0.249199 //layer=ply \
 //thickness=0.18 //x=16.95 //y=5.045 //x2=16.77 //y2=4.88
r1726 (  278 430 ) resistor r=39.5823 //w=0.21 //l=0.173853 //layer=ply \
 //thickness=0.18 //x=16.76 //y=1.75 //x2=16.8 //y2=1.595
r1727 (  278 427 ) resistor r=176.904 //w=0.094 //l=0.345 //layer=ply \
 //thickness=0.18 //x=16.76 //y=1.75 //x2=16.76 //y2=2.095
r1728 (  277 430 ) resistor r=39.5823 //w=0.21 //l=0.173853 //layer=ply \
 //thickness=0.18 //x=16.76 //y=1.44 //x2=16.8 //y2=1.595
r1729 (  276 429 ) resistor r=45.1352 //w=0.168 //l=0.173853 //layer=ply \
 //thickness=0.18 //x=16.76 //y=1.095 //x2=16.8 //y2=0.94
r1730 (  276 277 ) resistor r=176.904 //w=0.094 //l=0.345 //layer=ply \
 //thickness=0.18 //x=16.76 //y=1.095 //x2=16.76 //y2=1.44
r1731 (  273 432 ) resistor r=53.7854 //w=0.233 //l=0.332415 //layer=ply \
 //thickness=0.18 //x=16.51 //y=5.045 //x2=16.77 //y2=4.88
r1732 (  272 424 ) resistor r=45.1352 //w=0.168 //l=0.173853 //layer=ply \
 //thickness=0.18 //x=9.15 //y=1.44 //x2=9.11 //y2=1.595
r1733 (  271 423 ) resistor r=45.1352 //w=0.168 //l=0.173853 //layer=ply \
 //thickness=0.18 //x=9.15 //y=1.095 //x2=9.11 //y2=0.94
r1734 (  271 272 ) resistor r=176.904 //w=0.094 //l=0.345 //layer=ply \
 //thickness=0.18 //x=9.15 //y=1.095 //x2=9.15 //y2=1.44
r1735 (  269 420 ) resistor r=10.701 //w=0.21 //l=0.115 //layer=ply \
 //thickness=0.18 //x=8.775 //y=1.595 //x2=8.66 //y2=1.595
r1736 (  268 424 ) resistor r=5.52526 //w=0.168 //l=0.115 //layer=ply \
 //thickness=0.18 //x=8.995 //y=1.595 //x2=9.11 //y2=1.595
r1737 (  267 419 ) resistor r=5.52526 //w=0.168 //l=0.115 //layer=ply \
 //thickness=0.18 //x=8.775 //y=0.94 //x2=8.66 //y2=0.94
r1738 (  266 423 ) resistor r=5.52526 //w=0.168 //l=0.115 //layer=ply \
 //thickness=0.18 //x=8.995 //y=0.94 //x2=9.11 //y2=0.94
r1739 (  266 267 ) resistor r=112.809 //w=0.094 //l=0.22 //layer=ply \
 //thickness=0.18 //x=8.995 //y=0.94 //x2=8.775 //y2=0.94
r1740 (  263 422 ) resistor r=37.236 //w=0.233 //l=0.249199 //layer=ply \
 //thickness=0.18 //x=8.81 //y=5.045 //x2=8.63 //y2=4.88
r1741 (  261 420 ) resistor r=39.5823 //w=0.21 //l=0.173853 //layer=ply \
 //thickness=0.18 //x=8.62 //y=1.75 //x2=8.66 //y2=1.595
r1742 (  261 417 ) resistor r=176.904 //w=0.094 //l=0.345 //layer=ply \
 //thickness=0.18 //x=8.62 //y=1.75 //x2=8.62 //y2=2.095
r1743 (  260 420 ) resistor r=39.5823 //w=0.21 //l=0.173853 //layer=ply \
 //thickness=0.18 //x=8.62 //y=1.44 //x2=8.66 //y2=1.595
r1744 (  259 419 ) resistor r=45.1352 //w=0.168 //l=0.173853 //layer=ply \
 //thickness=0.18 //x=8.62 //y=1.095 //x2=8.66 //y2=0.94
r1745 (  259 260 ) resistor r=176.904 //w=0.094 //l=0.345 //layer=ply \
 //thickness=0.18 //x=8.62 //y=1.095 //x2=8.62 //y2=1.44
r1746 (  256 422 ) resistor r=53.7854 //w=0.233 //l=0.332415 //layer=ply \
 //thickness=0.18 //x=8.37 //y=5.045 //x2=8.63 //y2=4.88
r1747 (  255 412 ) resistor r=592.245 //w=0.094 //l=1.155 //layer=ply \
 //thickness=0.18 //x=72.68 //y=6.2 //x2=72.68 //y2=5.045
r1748 (  254 503 ) resistor r=592.245 //w=0.094 //l=1.155 //layer=ply \
 //thickness=0.18 //x=72.24 //y=6.2 //x2=72.24 //y2=5.045
r1749 (  253 386 ) resistor r=592.245 //w=0.094 //l=1.155 //layer=ply \
 //thickness=0.18 //x=68.75 //y=6.2 //x2=68.75 //y2=5.045
r1750 (  252 379 ) resistor r=592.245 //w=0.094 //l=1.155 //layer=ply \
 //thickness=0.18 //x=68.31 //y=6.2 //x2=68.31 //y2=5.045
r1751 (  251 369 ) resistor r=592.245 //w=0.094 //l=1.155 //layer=ply \
 //thickness=0.18 //x=60.61 //y=6.2 //x2=60.61 //y2=5.045
r1752 (  250 362 ) resistor r=592.245 //w=0.094 //l=1.155 //layer=ply \
 //thickness=0.18 //x=60.17 //y=6.2 //x2=60.17 //y2=5.045
r1753 (  249 359 ) resistor r=592.245 //w=0.094 //l=1.155 //layer=ply \
 //thickness=0.18 //x=46.78 //y=6.2 //x2=46.78 //y2=5.045
r1754 (  248 472 ) resistor r=592.245 //w=0.094 //l=1.155 //layer=ply \
 //thickness=0.18 //x=46.34 //y=6.2 //x2=46.34 //y2=5.045
r1755 (  247 333 ) resistor r=592.245 //w=0.094 //l=1.155 //layer=ply \
 //thickness=0.18 //x=42.85 //y=6.2 //x2=42.85 //y2=5.045
r1756 (  246 326 ) resistor r=592.245 //w=0.094 //l=1.155 //layer=ply \
 //thickness=0.18 //x=42.41 //y=6.2 //x2=42.41 //y2=5.045
r1757 (  245 316 ) resistor r=592.245 //w=0.094 //l=1.155 //layer=ply \
 //thickness=0.18 //x=34.71 //y=6.2 //x2=34.71 //y2=5.045
r1758 (  244 309 ) resistor r=592.245 //w=0.094 //l=1.155 //layer=ply \
 //thickness=0.18 //x=34.27 //y=6.2 //x2=34.27 //y2=5.045
r1759 (  243 306 ) resistor r=592.245 //w=0.094 //l=1.155 //layer=ply \
 //thickness=0.18 //x=20.88 //y=6.2 //x2=20.88 //y2=5.045
r1760 (  242 441 ) resistor r=592.245 //w=0.094 //l=1.155 //layer=ply \
 //thickness=0.18 //x=20.44 //y=6.2 //x2=20.44 //y2=5.045
r1761 (  241 280 ) resistor r=592.245 //w=0.094 //l=1.155 //layer=ply \
 //thickness=0.18 //x=16.95 //y=6.2 //x2=16.95 //y2=5.045
r1762 (  240 273 ) resistor r=592.245 //w=0.094 //l=1.155 //layer=ply \
 //thickness=0.18 //x=16.51 //y=6.2 //x2=16.51 //y2=5.045
r1763 (  239 263 ) resistor r=592.245 //w=0.094 //l=1.155 //layer=ply \
 //thickness=0.18 //x=8.81 //y=6.2 //x2=8.81 //y2=5.045
r1764 (  238 256 ) resistor r=592.245 //w=0.094 //l=1.155 //layer=ply \
 //thickness=0.18 //x=8.37 //y=6.2 //x2=8.37 //y2=5.045
r1765 (  237 400 ) resistor r=55.3787 //w=0.094 //l=0.108 //layer=ply \
 //thickness=0.18 //x=72.097 //y=1.555 //x2=72.205 //y2=1.555
r1766 (  237 401 ) resistor r=54.866 //w=0.094 //l=0.107 //layer=ply \
 //thickness=0.18 //x=72.097 //y=1.555 //x2=71.99 //y2=1.555
r1767 (  236 391 ) resistor r=56.4043 //w=0.094 //l=0.11 //layer=ply \
 //thickness=0.18 //x=68.825 //y=1.595 //x2=68.935 //y2=1.595
r1768 (  236 392 ) resistor r=56.4043 //w=0.094 //l=0.11 //layer=ply \
 //thickness=0.18 //x=68.825 //y=1.595 //x2=68.715 //y2=1.595
r1769 (  235 374 ) resistor r=56.4043 //w=0.094 //l=0.11 //layer=ply \
 //thickness=0.18 //x=60.685 //y=1.595 //x2=60.795 //y2=1.595
r1770 (  235 375 ) resistor r=56.4043 //w=0.094 //l=0.11 //layer=ply \
 //thickness=0.18 //x=60.685 //y=1.595 //x2=60.575 //y2=1.595
r1771 (  234 347 ) resistor r=55.3787 //w=0.094 //l=0.108 //layer=ply \
 //thickness=0.18 //x=46.197 //y=1.555 //x2=46.305 //y2=1.555
r1772 (  234 348 ) resistor r=54.866 //w=0.094 //l=0.107 //layer=ply \
 //thickness=0.18 //x=46.197 //y=1.555 //x2=46.09 //y2=1.555
r1773 (  233 338 ) resistor r=56.4043 //w=0.094 //l=0.11 //layer=ply \
 //thickness=0.18 //x=42.925 //y=1.595 //x2=43.035 //y2=1.595
r1774 (  233 339 ) resistor r=56.4043 //w=0.094 //l=0.11 //layer=ply \
 //thickness=0.18 //x=42.925 //y=1.595 //x2=42.815 //y2=1.595
r1775 (  232 321 ) resistor r=56.4043 //w=0.094 //l=0.11 //layer=ply \
 //thickness=0.18 //x=34.785 //y=1.595 //x2=34.895 //y2=1.595
r1776 (  232 322 ) resistor r=56.4043 //w=0.094 //l=0.11 //layer=ply \
 //thickness=0.18 //x=34.785 //y=1.595 //x2=34.675 //y2=1.595
r1777 (  231 294 ) resistor r=55.3787 //w=0.094 //l=0.108 //layer=ply \
 //thickness=0.18 //x=20.297 //y=1.555 //x2=20.405 //y2=1.555
r1778 (  231 295 ) resistor r=54.866 //w=0.094 //l=0.107 //layer=ply \
 //thickness=0.18 //x=20.297 //y=1.555 //x2=20.19 //y2=1.555
r1779 (  230 285 ) resistor r=56.4043 //w=0.094 //l=0.11 //layer=ply \
 //thickness=0.18 //x=17.025 //y=1.595 //x2=17.135 //y2=1.595
r1780 (  230 286 ) resistor r=56.4043 //w=0.094 //l=0.11 //layer=ply \
 //thickness=0.18 //x=17.025 //y=1.595 //x2=16.915 //y2=1.595
r1781 (  229 268 ) resistor r=56.4043 //w=0.094 //l=0.11 //layer=ply \
 //thickness=0.18 //x=8.885 //y=1.595 //x2=8.995 //y2=1.595
r1782 (  229 269 ) resistor r=56.4043 //w=0.094 //l=0.11 //layer=ply \
 //thickness=0.18 //x=8.885 //y=1.595 //x2=8.775 //y2=1.595
r1783 (  225 500 ) resistor r=152 //w=0.17 //l=0.17 //layer=licon //count=1 \
 //x=72.27 //y=4.88 //x2=72.27 //y2=4.88
r1784 (  220 507 ) resistor r=152 //w=0.17 //l=0.17 //layer=licon //count=1 \
 //x=72.27 //y=2.26 //x2=72.27 //y2=2.26
r1785 (  215 494 ) resistor r=152 //w=0.17 //l=0.17 //layer=licon //count=1 \
 //x=68.57 //y=4.88 //x2=68.57 //y2=4.88
r1786 (  210 488 ) resistor r=152 //w=0.17 //l=0.17 //layer=licon //count=1 \
 //x=68.57 //y=2.26 //x2=68.57 //y2=2.26
r1787 (  205 484 ) resistor r=152 //w=0.17 //l=0.17 //layer=licon //count=1 \
 //x=60.43 //y=4.88 //x2=60.43 //y2=4.88
r1788 (  200 478 ) resistor r=152 //w=0.17 //l=0.17 //layer=licon //count=1 \
 //x=60.43 //y=2.26 //x2=60.43 //y2=2.26
r1789 (  195 469 ) resistor r=152 //w=0.17 //l=0.17 //layer=licon //count=1 \
 //x=46.37 //y=4.88 //x2=46.37 //y2=4.88
r1790 (  190 476 ) resistor r=152 //w=0.17 //l=0.17 //layer=licon //count=1 \
 //x=46.37 //y=2.26 //x2=46.37 //y2=2.26
r1791 (  185 463 ) resistor r=152 //w=0.17 //l=0.17 //layer=licon //count=1 \
 //x=42.67 //y=4.88 //x2=42.67 //y2=4.88
r1792 (  180 457 ) resistor r=152 //w=0.17 //l=0.17 //layer=licon //count=1 \
 //x=42.67 //y=2.26 //x2=42.67 //y2=2.26
r1793 (  175 453 ) resistor r=152 //w=0.17 //l=0.17 //layer=licon //count=1 \
 //x=34.53 //y=4.88 //x2=34.53 //y2=4.88
r1794 (  170 447 ) resistor r=152 //w=0.17 //l=0.17 //layer=licon //count=1 \
 //x=34.53 //y=2.26 //x2=34.53 //y2=2.26
r1795 (  165 438 ) resistor r=152 //w=0.17 //l=0.17 //layer=licon //count=1 \
 //x=20.47 //y=4.88 //x2=20.47 //y2=4.88
r1796 (  160 445 ) resistor r=152 //w=0.17 //l=0.17 //layer=licon //count=1 \
 //x=20.47 //y=2.26 //x2=20.47 //y2=2.26
r1797 (  155 432 ) resistor r=152 //w=0.17 //l=0.17 //layer=licon //count=1 \
 //x=16.77 //y=4.88 //x2=16.77 //y2=4.88
r1798 (  150 426 ) resistor r=152 //w=0.17 //l=0.17 //layer=licon //count=1 \
 //x=16.77 //y=2.26 //x2=16.77 //y2=2.26
r1799 (  145 422 ) resistor r=152 //w=0.17 //l=0.17 //layer=licon //count=1 \
 //x=8.63 //y=4.88 //x2=8.63 //y2=4.88
r1800 (  140 416 ) resistor r=152 //w=0.17 //l=0.17 //layer=licon //count=1 \
 //x=8.63 //y=2.26 //x2=8.63 //y2=2.26
r1801 (  136 137 ) resistor r=0.10734 //w=0.281 //l=0.16 //layer=m2 \
 //thickness=0.36 //x=72.225 //y=2.355 //x2=72.065 //y2=2.355
r1802 (  134 137 ) resistor r=3.17748 //w=0.131 //l=3.33 //layer=m2 \
 //thickness=0.36 //x=68.735 //y=2.4 //x2=72.065 //y2=2.4
r1803 (  132 134 ) resistor r=0.107331 //w=0.301 //l=0.16 //layer=m2 \
 //thickness=0.36 //x=68.575 //y=2.315 //x2=68.735 //y2=2.315
r1804 (  132 133 ) resistor r=0.107331 //w=0.301 //l=0.16 //layer=m2 \
 //thickness=0.36 //x=68.575 //y=2.315 //x2=68.415 //y2=2.315
r1805 (  130 133 ) resistor r=7.46183 //w=0.131 //l=7.82 //layer=m2 \
 //thickness=0.36 //x=60.595 //y=2.4 //x2=68.415 //y2=2.4
r1806 (  128 130 ) resistor r=0.107331 //w=0.301 //l=0.16 //layer=m2 \
 //thickness=0.36 //x=60.435 //y=2.315 //x2=60.595 //y2=2.315
r1807 (  128 129 ) resistor r=0.107331 //w=0.301 //l=0.16 //layer=m2 \
 //thickness=0.36 //x=60.435 //y=2.315 //x2=60.275 //y2=2.315
r1808 (  126 129 ) resistor r=13.1584 //w=0.131 //l=13.79 //layer=m2 \
 //thickness=0.36 //x=46.485 //y=2.4 //x2=60.275 //y2=2.4
r1809 (  124 126 ) resistor r=0.10734 //w=0.281 //l=0.16 //layer=m2 \
 //thickness=0.36 //x=46.325 //y=2.355 //x2=46.485 //y2=2.355
r1810 (  124 125 ) resistor r=0.10734 //w=0.281 //l=0.16 //layer=m2 \
 //thickness=0.36 //x=46.325 //y=2.355 //x2=46.165 //y2=2.355
r1811 (  122 125 ) resistor r=3.17748 //w=0.131 //l=3.33 //layer=m2 \
 //thickness=0.36 //x=42.835 //y=2.4 //x2=46.165 //y2=2.4
r1812 (  120 122 ) resistor r=0.107331 //w=0.301 //l=0.16 //layer=m2 \
 //thickness=0.36 //x=42.675 //y=2.315 //x2=42.835 //y2=2.315
r1813 (  120 121 ) resistor r=0.107331 //w=0.301 //l=0.16 //layer=m2 \
 //thickness=0.36 //x=42.675 //y=2.315 //x2=42.515 //y2=2.315
r1814 (  112 114 ) resistor r=0.107331 //w=0.301 //l=0.16 //layer=m2 \
 //thickness=0.36 //x=16.775 //y=2.315 //x2=16.935 //y2=2.315
r1815 (  112 113 ) resistor r=0.107331 //w=0.301 //l=0.16 //layer=m2 \
 //thickness=0.36 //x=16.775 //y=2.315 //x2=16.615 //y2=2.315
r1816 (  109 110 ) resistor r=0.0373428 //w=0.318 //l=0.095 //layer=m2 \
 //thickness=0.36 //x=8.635 //y=2.305 //x2=8.635 //y2=2.4
r1817 (  99 118 ) resistor r=0.0972615 //w=0.222 //l=0.19799 //layer=m2 \
 //thickness=0.36 //x=34.695 //y=2.4 //x2=34.535 //y2=2.315
r1818 (  99 121 ) resistor r=7.46183 //w=0.131 //l=7.82 //layer=m2 \
 //thickness=0.36 //x=34.695 //y=2.4 //x2=42.515 //y2=2.4
r1819 (  97 116 ) resistor r=9.18103 //w=0.174 //l=12.7875 //layer=m2 \
 //thickness=0.36 //x=33.205 //y=2.37 //x2=20.425 //y2=2.355
r1820 (  96 118 ) resistor r=0.513928 //w=0.222 //l=0.927092 //layer=m2 \
 //thickness=0.36 //x=33.635 //y=2.37 //x2=34.535 //y2=2.315
r1821 (  96 97 ) resistor r=0.410305 //w=0.131 //l=0.43 //layer=m2 \
 //thickness=0.36 //x=33.635 //y=2.37 //x2=33.205 //y2=2.37
r1822 (  94 116 ) resistor r=0.114943 //w=0.174 //l=0.181108 //layer=m2 \
 //thickness=0.36 //x=20.265 //y=2.4 //x2=20.425 //y2=2.355
r1823 (  94 114 ) resistor r=3.17748 //w=0.131 //l=3.33 //layer=m2 \
 //thickness=0.36 //x=20.265 //y=2.4 //x2=16.935 //y2=2.4
r1824 (  93 110 ) resistor r=0.0451273 //w=0.318 //l=0.16 //layer=m2 \
 //thickness=0.36 //x=8.795 //y=2.4 //x2=8.635 //y2=2.4
r1825 (  93 113 ) resistor r=7.46183 //w=0.131 //l=7.82 //layer=m2 \
 //thickness=0.36 //x=8.795 //y=2.4 //x2=16.615 //y2=2.4
r1826 (  91 136 ) resistor r=4.5 //w=0.15 //l=0.15 //layer=via1 //count=1 \
 //x=72.225 //y=2.355 //x2=72.225 //y2=2.355
r1827 (  89 220 ) resistor r=9.3 //w=0.17 //l=0.17 //layer=mcon //count=1 \
 //x=72.27 //y=2.26 //x2=72.27 //y2=2.26
r1828 (  89 91 ) resistor r=0.0401182 //w=0.296 //l=0.095 //layer=m1 \
 //thickness=0.36 //x=72.227 //y=2.26 //x2=72.227 //y2=2.355
r1829 (  87 225 ) resistor r=9.3 //w=0.17 //l=0.17 //layer=mcon //count=1 \
 //x=72.27 //y=4.88 //x2=72.27 //y2=4.88
r1830 (  85 132 ) resistor r=4.5 //w=0.15 //l=0.15 //layer=via1 //count=1 \
 //x=68.575 //y=2.305 //x2=68.575 //y2=2.305
r1831 (  83 210 ) resistor r=9.3 //w=0.17 //l=0.17 //layer=mcon //count=1 \
 //x=68.57 //y=2.26 //x2=68.57 //y2=2.26
r1832 (  83 85 ) resistor r=0.0186258 //w=0.302 //l=0.045 //layer=m1 \
 //thickness=0.36 //x=68.575 //y=2.26 //x2=68.575 //y2=2.305
r1833 (  81 215 ) resistor r=9.3 //w=0.17 //l=0.17 //layer=mcon //count=1 \
 //x=68.57 //y=4.88 //x2=68.57 //y2=4.88
r1834 (  79 128 ) resistor r=4.5 //w=0.15 //l=0.15 //layer=via1 //count=1 \
 //x=60.435 //y=2.305 //x2=60.435 //y2=2.305
r1835 (  77 200 ) resistor r=9.3 //w=0.17 //l=0.17 //layer=mcon //count=1 \
 //x=60.43 //y=2.26 //x2=60.43 //y2=2.26
r1836 (  77 79 ) resistor r=0.0186258 //w=0.302 //l=0.045 //layer=m1 \
 //thickness=0.36 //x=60.435 //y=2.26 //x2=60.435 //y2=2.305
r1837 (  75 205 ) resistor r=9.3 //w=0.17 //l=0.17 //layer=mcon //count=1 \
 //x=60.43 //y=4.88 //x2=60.43 //y2=4.88
r1838 (  73 124 ) resistor r=4.5 //w=0.15 //l=0.15 //layer=via1 //count=1 \
 //x=46.325 //y=2.355 //x2=46.325 //y2=2.355
r1839 (  71 190 ) resistor r=9.3 //w=0.17 //l=0.17 //layer=mcon //count=1 \
 //x=46.37 //y=2.26 //x2=46.37 //y2=2.26
r1840 (  71 73 ) resistor r=0.0401182 //w=0.296 //l=0.095 //layer=m1 \
 //thickness=0.36 //x=46.327 //y=2.26 //x2=46.327 //y2=2.355
r1841 (  69 195 ) resistor r=9.3 //w=0.17 //l=0.17 //layer=mcon //count=1 \
 //x=46.37 //y=4.88 //x2=46.37 //y2=4.88
r1842 (  67 120 ) resistor r=4.5 //w=0.15 //l=0.15 //layer=via1 //count=1 \
 //x=42.675 //y=2.305 //x2=42.675 //y2=2.305
r1843 (  65 180 ) resistor r=9.3 //w=0.17 //l=0.17 //layer=mcon //count=1 \
 //x=42.67 //y=2.26 //x2=42.67 //y2=2.26
r1844 (  65 67 ) resistor r=0.0186258 //w=0.302 //l=0.045 //layer=m1 \
 //thickness=0.36 //x=42.675 //y=2.26 //x2=42.675 //y2=2.305
r1845 (  63 185 ) resistor r=9.3 //w=0.17 //l=0.17 //layer=mcon //count=1 \
 //x=42.67 //y=4.88 //x2=42.67 //y2=4.88
r1846 (  61 118 ) resistor r=4.5 //w=0.15 //l=0.15 //layer=via1 //count=1 \
 //x=34.535 //y=2.305 //x2=34.535 //y2=2.305
r1847 (  59 170 ) resistor r=9.3 //w=0.17 //l=0.17 //layer=mcon //count=1 \
 //x=34.53 //y=2.26 //x2=34.53 //y2=2.26
r1848 (  59 61 ) resistor r=0.0186258 //w=0.302 //l=0.045 //layer=m1 \
 //thickness=0.36 //x=34.535 //y=2.26 //x2=34.535 //y2=2.305
r1849 (  57 175 ) resistor r=9.3 //w=0.17 //l=0.17 //layer=mcon //count=1 \
 //x=34.53 //y=4.88 //x2=34.53 //y2=4.88
r1850 (  55 116 ) resistor r=4.5 //w=0.15 //l=0.15 //layer=via1 //count=1 \
 //x=20.425 //y=2.355 //x2=20.425 //y2=2.355
r1851 (  53 160 ) resistor r=9.3 //w=0.17 //l=0.17 //layer=mcon //count=1 \
 //x=20.47 //y=2.26 //x2=20.47 //y2=2.26
r1852 (  53 55 ) resistor r=0.0401182 //w=0.296 //l=0.095 //layer=m1 \
 //thickness=0.36 //x=20.427 //y=2.26 //x2=20.427 //y2=2.355
r1853 (  51 165 ) resistor r=9.3 //w=0.17 //l=0.17 //layer=mcon //count=1 \
 //x=20.47 //y=4.88 //x2=20.47 //y2=4.88
r1854 (  49 112 ) resistor r=4.5 //w=0.15 //l=0.15 //layer=via1 //count=1 \
 //x=16.775 //y=2.305 //x2=16.775 //y2=2.305
r1855 (  47 150 ) resistor r=9.3 //w=0.17 //l=0.17 //layer=mcon //count=1 \
 //x=16.77 //y=2.26 //x2=16.77 //y2=2.26
r1856 (  47 49 ) resistor r=0.0186258 //w=0.302 //l=0.045 //layer=m1 \
 //thickness=0.36 //x=16.775 //y=2.26 //x2=16.775 //y2=2.305
r1857 (  45 155 ) resistor r=9.3 //w=0.17 //l=0.17 //layer=mcon //count=1 \
 //x=16.77 //y=4.88 //x2=16.77 //y2=4.88
r1858 (  43 109 ) resistor r=4.5 //w=0.15 //l=0.15 //layer=via1 //count=1 \
 //x=8.635 //y=2.305 //x2=8.635 //y2=2.305
r1859 (  39 145 ) resistor r=9.3 //w=0.17 //l=0.17 //layer=mcon //count=1 \
 //x=8.63 //y=4.88 //x2=8.63 //y2=4.88
r1860 (  36 87 ) resistor r=0.0717383 //w=0.224 //l=0.115 //layer=m1 \
 //thickness=0.36 //x=72.27 //y=4.765 //x2=72.27 //y2=4.88
r1861 (  35 91 ) resistor r=0.0900276 //w=0.296 //l=0.180222 //layer=m1 \
 //thickness=0.36 //x=72.27 //y=2.515 //x2=72.227 //y2=2.355
r1862 (  34 81 ) resistor r=0.0801089 //w=0.224 //l=0.13 //layer=m1 \
 //thickness=0.36 //x=68.57 //y=4.75 //x2=68.57 //y2=4.88
r1863 (  33 85 ) resistor r=0.0899119 //w=0.302 //l=0.162481 //layer=m1 \
 //thickness=0.36 //x=68.57 //y=2.465 //x2=68.575 //y2=2.305
r1864 (  33 34 ) resistor r=2.18034 //w=0.131 //l=2.285 //layer=m1 \
 //thickness=0.36 //x=68.57 //y=2.465 //x2=68.57 //y2=4.75
r1865 (  32 75 ) resistor r=0.0801089 //w=0.224 //l=0.13 //layer=m1 \
 //thickness=0.36 //x=60.43 //y=4.75 //x2=60.43 //y2=4.88
r1866 (  31 79 ) resistor r=0.0899119 //w=0.302 //l=0.162481 //layer=m1 \
 //thickness=0.36 //x=60.43 //y=2.465 //x2=60.435 //y2=2.305
r1867 (  31 32 ) resistor r=2.18034 //w=0.131 //l=2.285 //layer=m1 \
 //thickness=0.36 //x=60.43 //y=2.465 //x2=60.43 //y2=4.75
r1868 (  28 69 ) resistor r=0.0717383 //w=0.224 //l=0.115 //layer=m1 \
 //thickness=0.36 //x=46.37 //y=4.765 //x2=46.37 //y2=4.88
r1869 (  27 73 ) resistor r=0.0900276 //w=0.296 //l=0.180222 //layer=m1 \
 //thickness=0.36 //x=46.37 //y=2.515 //x2=46.327 //y2=2.355
r1870 (  25 63 ) resistor r=0.0801089 //w=0.224 //l=0.13 //layer=m1 \
 //thickness=0.36 //x=42.67 //y=4.75 //x2=42.67 //y2=4.88
r1871 (  24 67 ) resistor r=0.0899119 //w=0.302 //l=0.162481 //layer=m1 \
 //thickness=0.36 //x=42.67 //y=2.465 //x2=42.675 //y2=2.305
r1872 (  23 57 ) resistor r=0.0801089 //w=0.224 //l=0.13 //layer=m1 \
 //thickness=0.36 //x=34.53 //y=4.75 //x2=34.53 //y2=4.88
r1873 (  22 61 ) resistor r=0.0899119 //w=0.302 //l=0.162481 //layer=m1 \
 //thickness=0.36 //x=34.53 //y=2.465 //x2=34.535 //y2=2.305
r1874 (  22 23 ) resistor r=2.18034 //w=0.131 //l=2.285 //layer=m1 \
 //thickness=0.36 //x=34.53 //y=2.465 //x2=34.53 //y2=4.75
r1875 (  19 51 ) resistor r=0.0717383 //w=0.224 //l=0.115 //layer=m1 \
 //thickness=0.36 //x=20.47 //y=4.765 //x2=20.47 //y2=4.88
r1876 (  18 55 ) resistor r=0.0900276 //w=0.296 //l=0.180222 //layer=m1 \
 //thickness=0.36 //x=20.47 //y=2.515 //x2=20.427 //y2=2.355
r1877 (  15 45 ) resistor r=0.0801089 //w=0.224 //l=0.13 //layer=m1 \
 //thickness=0.36 //x=16.77 //y=4.75 //x2=16.77 //y2=4.88
r1878 (  14 49 ) resistor r=0.0899119 //w=0.302 //l=0.162481 //layer=m1 \
 //thickness=0.36 //x=16.77 //y=2.465 //x2=16.775 //y2=2.305
r1879 (  12 39 ) resistor r=0.0801089 //w=0.224 //l=0.13 //layer=m1 \
 //thickness=0.36 //x=8.63 //y=4.75 //x2=8.63 //y2=4.88
r1880 (  10 140 ) resistor r=9.3 //w=0.17 //l=0.17 //layer=mcon //count=1 \
 //x=8.63 //y=2.26 //x2=8.63 //y2=2.26
r1881 (  10 43 ) resistor r=0.00179083 //w=0.349 //l=0.005 //layer=m1 \
 //thickness=0.36 //x=8.63 //y=2.28 //x2=8.635 //y2=2.28
r1882 (  10 11 ) resistor r=0.050788 //w=0.349 //l=0.185 //layer=m1 \
 //thickness=0.36 //x=8.63 //y=2.28 //x2=8.63 //y2=2.465
r1883 (  9 36 ) resistor r=0.844466 //w=0.131 //l=0.885 //layer=m1 \
 //thickness=0.36 //x=72.27 //y=3.88 //x2=72.27 //y2=4.765
r1884 (  9 35 ) resistor r=1.30248 //w=0.131 //l=1.365 //layer=m1 \
 //thickness=0.36 //x=72.27 //y=3.88 //x2=72.27 //y2=2.515
r1885 (  8 28 ) resistor r=0.844466 //w=0.131 //l=0.885 //layer=m1 \
 //thickness=0.36 //x=46.37 //y=3.88 //x2=46.37 //y2=4.765
r1886 (  7 8 ) resistor r=0.353053 //w=0.131 //l=0.37 //layer=m1 \
 //thickness=0.36 //x=46.37 //y=3.51 //x2=46.37 //y2=3.88
r1887 (  7 27 ) resistor r=0.949427 //w=0.131 //l=0.995 //layer=m1 \
 //thickness=0.36 //x=46.37 //y=3.51 //x2=46.37 //y2=2.515
r1888 (  6 25 ) resistor r=1.18321 //w=0.131 //l=1.24 //layer=m1 \
 //thickness=0.36 //x=42.67 //y=3.51 //x2=42.67 //y2=4.75
r1889 (  6 24 ) resistor r=0.997137 //w=0.131 //l=1.045 //layer=m1 \
 //thickness=0.36 //x=42.67 //y=3.51 //x2=42.67 //y2=2.465
r1890 (  5 19 ) resistor r=1.19752 //w=0.131 //l=1.255 //layer=m1 \
 //thickness=0.36 //x=20.47 //y=3.51 //x2=20.47 //y2=4.765
r1891 (  4 5 ) resistor r=0.353053 //w=0.131 //l=0.37 //layer=m1 \
 //thickness=0.36 //x=20.47 //y=3.14 //x2=20.47 //y2=3.51
r1892 (  4 18 ) resistor r=0.596374 //w=0.131 //l=0.625 //layer=m1 \
 //thickness=0.36 //x=20.47 //y=3.14 //x2=20.47 //y2=2.515
r1893 (  3 15 ) resistor r=1.18321 //w=0.131 //l=1.24 //layer=m1 \
 //thickness=0.36 //x=16.77 //y=3.51 //x2=16.77 //y2=4.75
r1894 (  2 3 ) resistor r=0.353053 //w=0.131 //l=0.37 //layer=m1 \
 //thickness=0.36 //x=16.77 //y=3.14 //x2=16.77 //y2=3.51
r1895 (  2 14 ) resistor r=0.644084 //w=0.131 //l=0.675 //layer=m1 \
 //thickness=0.36 //x=16.77 //y=3.14 //x2=16.77 //y2=2.465
r1896 (  1 12 ) resistor r=1.53626 //w=0.131 //l=1.61 //layer=m1 \
 //thickness=0.36 //x=8.63 //y=3.14 //x2=8.63 //y2=4.75
r1897 (  1 11 ) resistor r=0.644084 //w=0.131 //l=0.675 //layer=m1 \
 //thickness=0.36 //x=8.63 //y=3.14 //x2=8.63 //y2=2.465
ends PM_TMRDFFRNQNX1\%RN

subckt PM_TMRDFFRNQNX1\%noxref_14 ( 1 2 3 4 6 7 8 9 11 14 15 17 18 19 20 22 23 \
 24 25 27 30 31 33 34 35 36 38 39 40 42 43 46 47 48 54 58 61 66 69 72 78 81 84 \
 87 93 97 101 104 105 108 112 117 119 121 123 125 126 127 128 130 136 145 146 \
 148 149 152 161 166 175 180 188 196 213 221 229 246 255 260 269 273 274 275 \
 276 277 278 279 280 281 282 283 284 285 286 287 288 289 291 297 298 299 300 \
 304 305 306 311 313 315 321 322 323 324 325 326 330 332 335 336 340 341 342 \
 347 349 351 357 358 368 369 372 386 390 391 394 402 403 406 407 408 409 410 \
 411 )
c825 ( 403 0 ) capacitor c=0.00885916f //x=73.445 //y=1.095
c826 ( 402 0 ) capacitor c=0.00885916f //x=68.635 //y=1.095
c827 ( 394 0 ) capacitor c=0.0366137f //x=76.74 //y=4.88
c828 ( 391 0 ) capacitor c=0.0297213f //x=76.71 //y=2.095
c829 ( 390 0 ) capacitor c=0.0488821f //x=76.71 //y=2.26
c830 ( 386 0 ) capacitor c=0.0643877f //x=75.97 //y=4.88
c831 ( 372 0 ) capacitor c=0.0354929f //x=63.79 //y=4.88
c832 ( 369 0 ) capacitor c=0.0284095f //x=63.76 //y=2.095
c833 ( 368 0 ) capacitor c=0.0476356f //x=63.76 //y=2.26
c834 ( 358 0 ) capacitor c=0.0441827f //x=77.275 //y=1.43
c835 ( 357 0 ) capacitor c=0.019833f //x=77.275 //y=1.085
c836 ( 351 0 ) capacitor c=0.0162526f //x=77.12 //y=1.585
c837 ( 349 0 ) capacitor c=0.0157807f //x=77.12 //y=0.93
c838 ( 347 0 ) capacitor c=0.0360083f //x=77.115 //y=4.97
c839 ( 342 0 ) capacitor c=0.0216374f //x=76.745 //y=1.74
c840 ( 341 0 ) capacitor c=0.0179909f //x=76.745 //y=1.43
c841 ( 340 0 ) capacitor c=0.0178631f //x=76.745 //y=1.085
c842 ( 336 0 ) capacitor c=0.0338883f //x=76.305 //y=1.39
c843 ( 335 0 ) capacitor c=0.0188688f //x=76.305 //y=1.045
c844 ( 332 0 ) capacitor c=0.0141821f //x=76.15 //y=1.545
c845 ( 330 0 ) capacitor c=0.0158553f //x=76.15 //y=0.89
c846 ( 326 0 ) capacitor c=0.0899055f //x=75.775 //y=2.095
c847 ( 325 0 ) capacitor c=0.0230625f //x=75.775 //y=1.7
c848 ( 324 0 ) capacitor c=0.0234359f //x=75.775 //y=1.39
c849 ( 323 0 ) capacitor c=0.0200755f //x=75.775 //y=1.045
c850 ( 322 0 ) capacitor c=0.0439708f //x=64.325 //y=1.43
c851 ( 321 0 ) capacitor c=0.0192582f //x=64.325 //y=1.085
c852 ( 315 0 ) capacitor c=0.0162526f //x=64.17 //y=1.585
c853 ( 313 0 ) capacitor c=0.0157807f //x=64.17 //y=0.93
c854 ( 311 0 ) capacitor c=0.0372668f //x=64.165 //y=4.97
c855 ( 306 0 ) capacitor c=0.0210762f //x=63.795 //y=1.74
c856 ( 305 0 ) capacitor c=0.0168511f //x=63.795 //y=1.43
c857 ( 304 0 ) capacitor c=0.0175485f //x=63.795 //y=1.085
c858 ( 300 0 ) capacitor c=0.0552068f //x=53.675 //y=4.97
c859 ( 299 0 ) capacitor c=0.0376642f //x=53.965 //y=4.97
c860 ( 298 0 ) capacitor c=0.0346489f //x=53.63 //y=1.4
c861 ( 297 0 ) capacitor c=0.018692f //x=53.63 //y=1.055
c862 ( 291 0 ) capacitor c=0.0137077f //x=53.475 //y=1.555
c863 ( 289 0 ) capacitor c=0.0158585f //x=53.475 //y=0.9
c864 ( 288 0 ) capacitor c=0.103534f //x=53.1 //y=2.095
c865 ( 287 0 ) capacitor c=0.0229444f //x=53.1 //y=1.71
c866 ( 286 0 ) capacitor c=0.0234359f //x=53.1 //y=1.4
c867 ( 285 0 ) capacitor c=0.019815f //x=53.1 //y=1.055
c868 ( 284 0 ) capacitor c=0.155269f //x=77.19 //y=6.2
c869 ( 283 0 ) capacitor c=0.116174f //x=76.75 //y=6.2
c870 ( 282 0 ) capacitor c=0.116167f //x=76.31 //y=6.2
c871 ( 281 0 ) capacitor c=0.154619f //x=75.87 //y=6.2
c872 ( 280 0 ) capacitor c=0.155269f //x=64.24 //y=6.2
c873 ( 279 0 ) capacitor c=0.110375f //x=63.8 //y=6.2
c874 ( 278 0 ) capacitor c=0.110208f //x=54.04 //y=6.2
c875 ( 277 0 ) capacitor c=0.158957f //x=53.6 //y=6.2
c876 ( 269 0 ) capacitor c=5.80994e-19 //x=76.74 //y=4.88
c877 ( 260 0 ) capacitor c=5.78095e-19 //x=76.71 //y=2.26
c878 ( 255 0 ) capacitor c=5.44848e-19 //x=75.97 //y=4.88
c879 ( 246 0 ) capacitor c=7.85889e-19 //x=75.97 //y=2.26
c880 ( 229 0 ) capacitor c=0.0293219f //x=73.34 //y=5.56
c881 ( 221 0 ) capacitor c=0.029137f //x=72.46 //y=5.56
c882 ( 213 0 ) capacitor c=0.0278099f //x=71.58 //y=5.56
c883 ( 196 0 ) capacitor c=0.0293124f //x=68.53 //y=5.56
c884 ( 188 0 ) capacitor c=0.029137f //x=67.65 //y=5.56
c885 ( 180 0 ) capacitor c=0.0277605f //x=66.77 //y=5.56
c886 ( 175 0 ) capacitor c=5.80994e-19 //x=63.79 //y=4.88
c887 ( 166 0 ) capacitor c=5.78095e-19 //x=63.76 //y=2.26
c888 ( 161 0 ) capacitor c=0.00125338f //x=53.4 //y=4.88
c889 ( 152 0 ) capacitor c=0.0012618f //x=53.4 //y=2.26
c890 ( 149 0 ) capacitor c=0.0075775f //x=76.54 //y=4.255
c891 ( 148 0 ) capacitor c=0.00244809f //x=76.7 //y=4.255
c892 ( 146 0 ) capacitor c=0.00360118f //x=76.12 //y=4.285
c893 ( 145 0 ) capacitor c=0.0426184f //x=75.8 //y=4.285
c894 ( 136 0 ) capacitor c=9.9247e-19 //x=53.56 //y=4.26
c895 ( 130 0 ) capacitor c=0.063933f //x=74.28 //y=4.25
c896 ( 128 0 ) capacitor c=0.0541447f //x=71.02 //y=4.265
c897 ( 127 0 ) capacitor c=0.00660693f //x=71.365 //y=4.265
c898 ( 126 0 ) capacitor c=0.0480379f //x=63.925 //y=4.25
c899 ( 125 0 ) capacitor c=0.0667107f //x=69.155 //y=4.25
c900 ( 123 0 ) capacitor c=0.00158466f //x=58.43 //y=4.265
c901 ( 121 0 ) capacitor c=0.0162158f //x=57.83 //y=4.25
c902 ( 119 0 ) capacitor c=0.00487421f //x=56.615 //y=4.27
c903 ( 117 0 ) capacitor c=0.0280256f //x=55.975 //y=4.25
c904 ( 112 0 ) capacitor c=0.00661943f //x=76.71 //y=2.26
c905 ( 108 0 ) capacitor c=0.013899f //x=76.71 //y=4.25
c906 ( 105 0 ) capacitor c=0.00627601f //x=75.972 //y=4.74
c907 ( 104 0 ) capacitor c=0.00586715f //x=75.97 //y=4.88
c908 ( 101 0 ) capacitor c=0.00668001f //x=75.97 //y=2.26
c909 ( 97 0 ) capacitor c=0.0134842f //x=75.97 //y=4.25
c910 ( 93 0 ) capacitor c=0.0160053f //x=74.12 //y=4.25
c911 ( 87 0 ) capacitor c=9.35422e-19 //x=73.34 //y=5.335
c912 ( 84 0 ) capacitor c=0.00825613f //x=72.46 //y=5.335
c913 ( 81 0 ) capacitor c=0.0111859f //x=71.582 //y=5.335
c914 ( 78 0 ) capacitor c=0.0151867f //x=69.31 //y=4.25
c915 ( 72 0 ) capacitor c=0.00118259f //x=68.53 //y=5.335
c916 ( 69 0 ) capacitor c=0.00758117f //x=67.65 //y=5.335
c917 ( 66 0 ) capacitor c=0.0112819f //x=66.772 //y=5.335
c918 ( 61 0 ) capacitor c=0.00504845f //x=63.76 //y=2.26
c919 ( 58 0 ) capacitor c=0.0141348f //x=63.76 //y=4.25
c920 ( 54 0 ) capacitor c=0.0159682f //x=53.4 //y=4.25
c921 ( 48 0 ) capacitor c=0.0091997f //x=76.71 //y=4.735
c922 ( 47 0 ) capacitor c=0.00912635f //x=76.71 //y=4.415
c923 ( 46 0 ) capacitor c=0.0338927f //x=76.71 //y=4.095
c924 ( 43 0 ) capacitor c=0.0109286f //x=75.97 //y=4.445
c925 ( 42 0 ) capacitor c=0.0465507f //x=75.97 //y=4.125
c926 ( 40 0 ) capacitor c=0.020972f //x=74.12 //y=5.25
c927 ( 39 0 ) capacitor c=0.0137845f //x=74.12 //y=4.45
c928 ( 38 0 ) capacitor c=0.0594284f //x=74.12 //y=4.13
c929 ( 36 0 ) capacitor c=0.00551674f //x=73.72 //y=1.845
c930 ( 35 0 ) capacitor c=0.0156199f //x=74.035 //y=1.845
c931 ( 34 0 ) capacitor c=0.0136149f //x=73.635 //y=1.76
c932 ( 33 0 ) capacitor c=0.0112331f //x=73.635 //y=1.305
c933 ( 31 0 ) capacitor c=0.0238501f //x=74.035 //y=5.335
c934 ( 30 0 ) capacitor c=0.00906713f //x=73.34 //y=5.56
c935 ( 27 0 ) capacitor c=0.0198833f //x=73.225 //y=5.335
c936 ( 25 0 ) capacitor c=0.0154206f //x=72.34 //y=5.335
c937 ( 24 0 ) capacitor c=0.0221841f //x=69.31 //y=5.25
c938 ( 23 0 ) capacitor c=0.0126978f //x=69.31 //y=4.415
c939 ( 22 0 ) capacitor c=0.0610795f //x=69.31 //y=4.095
c940 ( 20 0 ) capacitor c=0.00493487f //x=68.91 //y=1.845
c941 ( 19 0 ) capacitor c=0.0132593f //x=69.225 //y=1.845
c942 ( 18 0 ) capacitor c=0.0167333f //x=68.825 //y=1.76
c943 ( 17 0 ) capacitor c=0.0111392f //x=68.825 //y=1.305
c944 ( 15 0 ) capacitor c=0.0239047f //x=69.225 //y=5.335
c945 ( 14 0 ) capacitor c=0.00933983f //x=68.53 //y=5.56
c946 ( 11 0 ) capacitor c=0.0200404f //x=68.415 //y=5.335
c947 ( 9 0 ) capacitor c=0.0147103f //x=67.53 //y=5.335
c948 ( 8 0 ) capacitor c=0.00917813f //x=63.76 //y=4.735
c949 ( 7 0 ) capacitor c=0.00994911f //x=63.76 //y=4.41
c950 ( 6 0 ) capacitor c=0.0349592f //x=63.76 //y=4.09
c951 ( 4 0 ) capacitor c=0.0137415f //x=53.4 //y=4.755
c952 ( 3 0 ) capacitor c=0.0127134f //x=53.4 //y=4.42
c953 ( 2 0 ) capacitor c=0.0531351f //x=53.4 //y=4.1
c954 ( 1 0 ) capacitor c=0.00495287f //x=53.4 //y=2.375
r955 (  396 397 ) resistor r=32.4568 //w=0.214 //l=0.075 //layer=ply \
 //thickness=0.18 //x=76.74 //y=4.97 //x2=76.74 //y2=5.045
r956 (  394 396 ) resistor r=20.271 //w=0.214 //l=0.09 //layer=ply \
 //thickness=0.18 //x=76.74 //y=4.88 //x2=76.74 //y2=4.97
r957 (  390 391 ) resistor r=52.7279 //w=0.214 //l=0.165 //layer=ply \
 //thickness=0.18 //x=76.71 //y=2.26 //x2=76.71 //y2=2.095
r958 (  384 386 ) resistor r=20.6867 //w=0.233 //l=0.1 //layer=ply \
 //thickness=0.18 //x=75.87 //y=4.88 //x2=75.97 //y2=4.88
r959 (  374 375 ) resistor r=32.4568 //w=0.214 //l=0.075 //layer=ply \
 //thickness=0.18 //x=63.79 //y=4.97 //x2=63.79 //y2=5.045
r960 (  372 374 ) resistor r=20.271 //w=0.214 //l=0.09 //layer=ply \
 //thickness=0.18 //x=63.79 //y=4.88 //x2=63.79 //y2=4.97
r961 (  368 369 ) resistor r=52.7279 //w=0.214 //l=0.165 //layer=ply \
 //thickness=0.18 //x=63.76 //y=2.26 //x2=63.76 //y2=2.095
r962 (  358 401 ) resistor r=45.1352 //w=0.168 //l=0.173853 //layer=ply \
 //thickness=0.18 //x=77.275 //y=1.43 //x2=77.235 //y2=1.585
r963 (  357 400 ) resistor r=45.1352 //w=0.168 //l=0.173853 //layer=ply \
 //thickness=0.18 //x=77.275 //y=1.085 //x2=77.235 //y2=0.93
r964 (  357 358 ) resistor r=176.904 //w=0.094 //l=0.345 //layer=ply \
 //thickness=0.18 //x=77.275 //y=1.085 //x2=77.275 //y2=1.43
r965 (  352 399 ) resistor r=10.701 //w=0.21 //l=0.115 //layer=ply \
 //thickness=0.18 //x=76.9 //y=1.585 //x2=76.785 //y2=1.585
r966 (  351 401 ) resistor r=5.52526 //w=0.168 //l=0.115 //layer=ply \
 //thickness=0.18 //x=77.12 //y=1.585 //x2=77.235 //y2=1.585
r967 (  350 398 ) resistor r=5.52526 //w=0.168 //l=0.115 //layer=ply \
 //thickness=0.18 //x=76.9 //y=0.93 //x2=76.785 //y2=0.93
r968 (  349 400 ) resistor r=5.52526 //w=0.168 //l=0.115 //layer=ply \
 //thickness=0.18 //x=77.12 //y=0.93 //x2=77.235 //y2=0.93
r969 (  349 350 ) resistor r=112.809 //w=0.094 //l=0.22 //layer=ply \
 //thickness=0.18 //x=77.12 //y=0.93 //x2=76.9 //y2=0.93
r970 (  348 396 ) resistor r=16.5046 //w=0.27 //l=0.135 //layer=ply \
 //thickness=0.18 //x=76.875 //y=4.97 //x2=76.74 //y2=4.97
r971 (  347 354 ) resistor r=26.9307 //w=0.15 //l=0.106066 //layer=ply \
 //thickness=0.18 //x=77.115 //y=4.97 //x2=77.19 //y2=5.045
r972 (  347 348 ) resistor r=123.064 //w=0.094 //l=0.24 //layer=ply \
 //thickness=0.18 //x=77.115 //y=4.97 //x2=76.875 //y2=4.97
r973 (  342 399 ) resistor r=39.5823 //w=0.21 //l=0.173853 //layer=ply \
 //thickness=0.18 //x=76.745 //y=1.74 //x2=76.785 //y2=1.585
r974 (  342 391 ) resistor r=182.032 //w=0.094 //l=0.355 //layer=ply \
 //thickness=0.18 //x=76.745 //y=1.74 //x2=76.745 //y2=2.095
r975 (  341 399 ) resistor r=39.5823 //w=0.21 //l=0.173853 //layer=ply \
 //thickness=0.18 //x=76.745 //y=1.43 //x2=76.785 //y2=1.585
r976 (  340 398 ) resistor r=45.1352 //w=0.168 //l=0.173853 //layer=ply \
 //thickness=0.18 //x=76.745 //y=1.085 //x2=76.785 //y2=0.93
r977 (  340 341 ) resistor r=176.904 //w=0.094 //l=0.345 //layer=ply \
 //thickness=0.18 //x=76.745 //y=1.085 //x2=76.745 //y2=1.43
r978 (  337 386 ) resistor r=70.3348 //w=0.233 //l=0.414367 //layer=ply \
 //thickness=0.18 //x=76.31 //y=5.045 //x2=75.97 //y2=4.88
r979 (  336 388 ) resistor r=45.1352 //w=0.168 //l=0.173853 //layer=ply \
 //thickness=0.18 //x=76.305 //y=1.39 //x2=76.265 //y2=1.545
r980 (  335 387 ) resistor r=45.1352 //w=0.168 //l=0.173853 //layer=ply \
 //thickness=0.18 //x=76.305 //y=1.045 //x2=76.265 //y2=0.89
r981 (  335 336 ) resistor r=176.904 //w=0.094 //l=0.345 //layer=ply \
 //thickness=0.18 //x=76.305 //y=1.045 //x2=76.305 //y2=1.39
r982 (  333 383 ) resistor r=10.701 //w=0.21 //l=0.115 //layer=ply \
 //thickness=0.18 //x=75.93 //y=1.545 //x2=75.815 //y2=1.545
r983 (  332 388 ) resistor r=5.52526 //w=0.168 //l=0.115 //layer=ply \
 //thickness=0.18 //x=76.15 //y=1.545 //x2=76.265 //y2=1.545
r984 (  331 382 ) resistor r=5.52526 //w=0.168 //l=0.115 //layer=ply \
 //thickness=0.18 //x=75.93 //y=0.89 //x2=75.815 //y2=0.89
r985 (  330 387 ) resistor r=5.52526 //w=0.168 //l=0.115 //layer=ply \
 //thickness=0.18 //x=76.15 //y=0.89 //x2=76.265 //y2=0.89
r986 (  330 331 ) resistor r=112.809 //w=0.094 //l=0.22 //layer=ply \
 //thickness=0.18 //x=76.15 //y=0.89 //x2=75.93 //y2=0.89
r987 (  327 384 ) resistor r=13.0941 //w=0.233 //l=0.165 //layer=ply \
 //thickness=0.18 //x=75.87 //y=5.045 //x2=75.87 //y2=4.88
r988 (  326 381 ) resistor r=34.8111 //w=0.27 //l=0.264953 //layer=ply \
 //thickness=0.18 //x=75.775 //y=2.095 //x2=75.97 //y2=2.26
r989 (  325 383 ) resistor r=39.5823 //w=0.21 //l=0.173853 //layer=ply \
 //thickness=0.18 //x=75.775 //y=1.7 //x2=75.815 //y2=1.545
r990 (  325 326 ) resistor r=202.543 //w=0.094 //l=0.395 //layer=ply \
 //thickness=0.18 //x=75.775 //y=1.7 //x2=75.775 //y2=2.095
r991 (  324 383 ) resistor r=39.5823 //w=0.21 //l=0.173853 //layer=ply \
 //thickness=0.18 //x=75.775 //y=1.39 //x2=75.815 //y2=1.545
r992 (  323 382 ) resistor r=45.1352 //w=0.168 //l=0.173853 //layer=ply \
 //thickness=0.18 //x=75.775 //y=1.045 //x2=75.815 //y2=0.89
r993 (  323 324 ) resistor r=176.904 //w=0.094 //l=0.345 //layer=ply \
 //thickness=0.18 //x=75.775 //y=1.045 //x2=75.775 //y2=1.39
r994 (  322 379 ) resistor r=45.1352 //w=0.168 //l=0.173853 //layer=ply \
 //thickness=0.18 //x=64.325 //y=1.43 //x2=64.285 //y2=1.585
r995 (  321 378 ) resistor r=45.1352 //w=0.168 //l=0.173853 //layer=ply \
 //thickness=0.18 //x=64.325 //y=1.085 //x2=64.285 //y2=0.93
r996 (  321 322 ) resistor r=176.904 //w=0.094 //l=0.345 //layer=ply \
 //thickness=0.18 //x=64.325 //y=1.085 //x2=64.325 //y2=1.43
r997 (  316 377 ) resistor r=10.701 //w=0.21 //l=0.115 //layer=ply \
 //thickness=0.18 //x=63.95 //y=1.585 //x2=63.835 //y2=1.585
r998 (  315 379 ) resistor r=5.52526 //w=0.168 //l=0.115 //layer=ply \
 //thickness=0.18 //x=64.17 //y=1.585 //x2=64.285 //y2=1.585
r999 (  314 376 ) resistor r=5.52526 //w=0.168 //l=0.115 //layer=ply \
 //thickness=0.18 //x=63.95 //y=0.93 //x2=63.835 //y2=0.93
r1000 (  313 378 ) resistor r=5.52526 //w=0.168 //l=0.115 //layer=ply \
 //thickness=0.18 //x=64.17 //y=0.93 //x2=64.285 //y2=0.93
r1001 (  313 314 ) resistor r=112.809 //w=0.094 //l=0.22 //layer=ply \
 //thickness=0.18 //x=64.17 //y=0.93 //x2=63.95 //y2=0.93
r1002 (  312 374 ) resistor r=16.5046 //w=0.27 //l=0.135 //layer=ply \
 //thickness=0.18 //x=63.925 //y=4.97 //x2=63.79 //y2=4.97
r1003 (  311 318 ) resistor r=26.9307 //w=0.15 //l=0.106066 //layer=ply \
 //thickness=0.18 //x=64.165 //y=4.97 //x2=64.24 //y2=5.045
r1004 (  311 312 ) resistor r=123.064 //w=0.094 //l=0.24 //layer=ply \
 //thickness=0.18 //x=64.165 //y=4.97 //x2=63.925 //y2=4.97
r1005 (  306 377 ) resistor r=39.5823 //w=0.21 //l=0.173853 //layer=ply \
 //thickness=0.18 //x=63.795 //y=1.74 //x2=63.835 //y2=1.585
r1006 (  306 369 ) resistor r=182.032 //w=0.094 //l=0.355 //layer=ply \
 //thickness=0.18 //x=63.795 //y=1.74 //x2=63.795 //y2=2.095
r1007 (  305 377 ) resistor r=39.5823 //w=0.21 //l=0.173853 //layer=ply \
 //thickness=0.18 //x=63.795 //y=1.43 //x2=63.835 //y2=1.585
r1008 (  304 376 ) resistor r=45.1352 //w=0.168 //l=0.173853 //layer=ply \
 //thickness=0.18 //x=63.795 //y=1.085 //x2=63.835 //y2=0.93
r1009 (  304 305 ) resistor r=176.904 //w=0.094 //l=0.345 //layer=ply \
 //thickness=0.18 //x=63.795 //y=1.085 //x2=63.795 //y2=1.43
r1010 (  299 301 ) resistor r=26.9307 //w=0.15 //l=0.106066 //layer=ply \
 //thickness=0.18 //x=53.965 //y=4.97 //x2=54.04 //y2=5.045
r1011 (  299 300 ) resistor r=148.702 //w=0.094 //l=0.29 //layer=ply \
 //thickness=0.18 //x=53.965 //y=4.97 //x2=53.675 //y2=4.97
r1012 (  298 366 ) resistor r=45.1352 //w=0.168 //l=0.173853 //layer=ply \
 //thickness=0.18 //x=53.63 //y=1.4 //x2=53.59 //y2=1.555
r1013 (  297 365 ) resistor r=45.1352 //w=0.168 //l=0.173853 //layer=ply \
 //thickness=0.18 //x=53.63 //y=1.055 //x2=53.59 //y2=0.9
r1014 (  297 298 ) resistor r=176.904 //w=0.094 //l=0.345 //layer=ply \
 //thickness=0.18 //x=53.63 //y=1.055 //x2=53.63 //y2=1.4
r1015 (  294 300 ) resistor r=22.7971 //w=0.269 //l=0.106066 //layer=ply \
 //thickness=0.18 //x=53.6 //y=5.045 //x2=53.675 //y2=4.97
r1016 (  294 364 ) resistor r=35.8364 //w=0.269 //l=0.270185 //layer=ply \
 //thickness=0.18 //x=53.6 //y=5.045 //x2=53.4 //y2=4.88
r1017 (  292 360 ) resistor r=10.701 //w=0.21 //l=0.115 //layer=ply \
 //thickness=0.18 //x=53.255 //y=1.555 //x2=53.14 //y2=1.555
r1018 (  291 366 ) resistor r=5.52526 //w=0.168 //l=0.115 //layer=ply \
 //thickness=0.18 //x=53.475 //y=1.555 //x2=53.59 //y2=1.555
r1019 (  290 359 ) resistor r=5.52526 //w=0.168 //l=0.115 //layer=ply \
 //thickness=0.18 //x=53.255 //y=0.9 //x2=53.14 //y2=0.9
r1020 (  289 365 ) resistor r=5.52526 //w=0.168 //l=0.115 //layer=ply \
 //thickness=0.18 //x=53.475 //y=0.9 //x2=53.59 //y2=0.9
r1021 (  289 290 ) resistor r=112.809 //w=0.094 //l=0.22 //layer=ply \
 //thickness=0.18 //x=53.475 //y=0.9 //x2=53.255 //y2=0.9
r1022 (  288 362 ) resistor r=58.7805 //w=0.246 //l=0.373497 //layer=ply \
 //thickness=0.18 //x=53.1 //y=2.095 //x2=53.4 //y2=2.26
r1023 (  287 360 ) resistor r=39.5823 //w=0.21 //l=0.173853 //layer=ply \
 //thickness=0.18 //x=53.1 //y=1.71 //x2=53.14 //y2=1.555
r1024 (  287 288 ) resistor r=197.415 //w=0.094 //l=0.385 //layer=ply \
 //thickness=0.18 //x=53.1 //y=1.71 //x2=53.1 //y2=2.095
r1025 (  286 360 ) resistor r=39.5823 //w=0.21 //l=0.173853 //layer=ply \
 //thickness=0.18 //x=53.1 //y=1.4 //x2=53.14 //y2=1.555
r1026 (  285 359 ) resistor r=45.1352 //w=0.168 //l=0.173853 //layer=ply \
 //thickness=0.18 //x=53.1 //y=1.055 //x2=53.14 //y2=0.9
r1027 (  285 286 ) resistor r=176.904 //w=0.094 //l=0.345 //layer=ply \
 //thickness=0.18 //x=53.1 //y=1.055 //x2=53.1 //y2=1.4
r1028 (  284 354 ) resistor r=592.245 //w=0.094 //l=1.155 //layer=ply \
 //thickness=0.18 //x=77.19 //y=6.2 //x2=77.19 //y2=5.045
r1029 (  283 397 ) resistor r=592.245 //w=0.094 //l=1.155 //layer=ply \
 //thickness=0.18 //x=76.75 //y=6.2 //x2=76.75 //y2=5.045
r1030 (  282 337 ) resistor r=592.245 //w=0.094 //l=1.155 //layer=ply \
 //thickness=0.18 //x=76.31 //y=6.2 //x2=76.31 //y2=5.045
r1031 (  281 327 ) resistor r=592.245 //w=0.094 //l=1.155 //layer=ply \
 //thickness=0.18 //x=75.87 //y=6.2 //x2=75.87 //y2=5.045
r1032 (  280 318 ) resistor r=592.245 //w=0.094 //l=1.155 //layer=ply \
 //thickness=0.18 //x=64.24 //y=6.2 //x2=64.24 //y2=5.045
r1033 (  279 375 ) resistor r=592.245 //w=0.094 //l=1.155 //layer=ply \
 //thickness=0.18 //x=63.8 //y=6.2 //x2=63.8 //y2=5.045
r1034 (  278 301 ) resistor r=592.245 //w=0.094 //l=1.155 //layer=ply \
 //thickness=0.18 //x=54.04 //y=6.2 //x2=54.04 //y2=5.045
r1035 (  277 294 ) resistor r=592.245 //w=0.094 //l=1.155 //layer=ply \
 //thickness=0.18 //x=53.6 //y=6.2 //x2=53.6 //y2=5.045
r1036 (  276 351 ) resistor r=56.4043 //w=0.094 //l=0.11 //layer=ply \
 //thickness=0.18 //x=77.01 //y=1.585 //x2=77.12 //y2=1.585
r1037 (  276 352 ) resistor r=56.4043 //w=0.094 //l=0.11 //layer=ply \
 //thickness=0.18 //x=77.01 //y=1.585 //x2=76.9 //y2=1.585
r1038 (  275 332 ) resistor r=56.4043 //w=0.094 //l=0.11 //layer=ply \
 //thickness=0.18 //x=76.04 //y=1.545 //x2=76.15 //y2=1.545
r1039 (  275 333 ) resistor r=56.4043 //w=0.094 //l=0.11 //layer=ply \
 //thickness=0.18 //x=76.04 //y=1.545 //x2=75.93 //y2=1.545
r1040 (  274 315 ) resistor r=56.4043 //w=0.094 //l=0.11 //layer=ply \
 //thickness=0.18 //x=64.06 //y=1.585 //x2=64.17 //y2=1.585
r1041 (  274 316 ) resistor r=56.4043 //w=0.094 //l=0.11 //layer=ply \
 //thickness=0.18 //x=64.06 //y=1.585 //x2=63.95 //y2=1.585
r1042 (  273 291 ) resistor r=56.4043 //w=0.094 //l=0.11 //layer=ply \
 //thickness=0.18 //x=53.365 //y=1.555 //x2=53.475 //y2=1.555
r1043 (  273 292 ) resistor r=56.4043 //w=0.094 //l=0.11 //layer=ply \
 //thickness=0.18 //x=53.365 //y=1.555 //x2=53.255 //y2=1.555
r1044 (  269 394 ) resistor r=152 //w=0.17 //l=0.17 //layer=licon //count=1 \
 //x=76.74 //y=4.88 //x2=76.74 //y2=4.88
r1045 (  260 390 ) resistor r=152 //w=0.17 //l=0.17 //layer=licon //count=1 \
 //x=76.71 //y=2.26 //x2=76.71 //y2=2.26
r1046 (  255 386 ) resistor r=152 //w=0.17 //l=0.17 //layer=licon //count=1 \
 //x=75.97 //y=4.88 //x2=75.97 //y2=4.88
r1047 (  246 381 ) resistor r=152 //w=0.17 //l=0.17 //layer=licon //count=1 \
 //x=75.97 //y=2.26 //x2=75.97 //y2=2.26
r1048 (  229 411 ) resistor r=23.615 //w=0.187 //l=0.345 //layer=li \
 //thickness=0.1 //x=73.34 //y=5.56 //x2=73.34 //y2=5.905
r1049 (  221 410 ) resistor r=23.615 //w=0.187 //l=0.345 //layer=li \
 //thickness=0.1 //x=72.46 //y=5.56 //x2=72.46 //y2=5.905
r1050 (  213 409 ) resistor r=23.615 //w=0.187 //l=0.345 //layer=li \
 //thickness=0.1 //x=71.58 //y=5.56 //x2=71.58 //y2=5.905
r1051 (  196 408 ) resistor r=23.615 //w=0.187 //l=0.345 //layer=li \
 //thickness=0.1 //x=68.53 //y=5.56 //x2=68.53 //y2=5.905
r1052 (  188 407 ) resistor r=23.615 //w=0.187 //l=0.345 //layer=li \
 //thickness=0.1 //x=67.65 //y=5.56 //x2=67.65 //y2=5.905
r1053 (  180 406 ) resistor r=23.615 //w=0.187 //l=0.345 //layer=li \
 //thickness=0.1 //x=66.77 //y=5.56 //x2=66.77 //y2=5.905
r1054 (  175 372 ) resistor r=152 //w=0.17 //l=0.17 //layer=licon //count=1 \
 //x=63.79 //y=4.88 //x2=63.79 //y2=4.88
r1055 (  166 368 ) resistor r=152 //w=0.17 //l=0.17 //layer=licon //count=1 \
 //x=63.76 //y=2.26 //x2=63.76 //y2=2.26
r1056 (  161 364 ) resistor r=152 //w=0.17 //l=0.17 //layer=licon //count=1 \
 //x=53.4 //y=4.88 //x2=53.4 //y2=4.88
r1057 (  152 362 ) resistor r=152 //w=0.17 //l=0.17 //layer=licon //count=1 \
 //x=53.4 //y=2.26 //x2=53.4 //y2=2.26
r1058 (  148 149 ) resistor r=0.10734 //w=0.281 //l=0.16 //layer=m2 \
 //thickness=0.36 //x=76.7 //y=4.255 //x2=76.54 //y2=4.255
r1059 (  146 149 ) resistor r=0.400763 //w=0.131 //l=0.42 //layer=m2 \
 //thickness=0.36 //x=76.12 //y=4.25 //x2=76.54 //y2=4.25
r1060 (  144 146 ) resistor r=0.10734 //w=0.281 //l=0.16 //layer=m2 \
 //thickness=0.36 //x=75.96 //y=4.285 //x2=76.12 //y2=4.285
r1061 (  144 145 ) resistor r=0.10734 //w=0.281 //l=0.16 //layer=m2 \
 //thickness=0.36 //x=75.96 //y=4.285 //x2=75.8 //y2=4.285
r1062 (  134 136 ) resistor r=0.10734 //w=0.281 //l=0.16 //layer=m2 \
 //thickness=0.36 //x=53.4 //y=4.26 //x2=53.56 //y2=4.26
r1063 (  130 142 ) resistor r=0.108234 //w=0.187 //l=0.178885 //layer=m2 \
 //thickness=0.36 //x=74.28 //y=4.25 //x2=74.12 //y2=4.29
r1064 (  130 145 ) resistor r=1.45038 //w=0.131 //l=1.52 //layer=m2 \
 //thickness=0.36 //x=74.28 //y=4.25 //x2=75.8 //y2=4.25
r1065 (  128 140 ) resistor r=1.08991 //w=0.196 //l=1.70999 //layer=m2 \
 //thickness=0.36 //x=71.02 //y=4.265 //x2=69.315 //y2=4.255
r1066 (  127 142 ) resistor r=1.84286 //w=0.187 //l=2.76747 //layer=m2 \
 //thickness=0.36 //x=71.365 //y=4.265 //x2=74.12 //y2=4.29
r1067 (  127 128 ) resistor r=0.329198 //w=0.131 //l=0.345 //layer=m2 \
 //thickness=0.36 //x=71.365 //y=4.265 //x2=71.02 //y2=4.265
r1068 (  126 138 ) resistor r=0.112172 //w=0.179 //l=0.16 //layer=m2 \
 //thickness=0.36 //x=63.925 //y=4.25 //x2=63.765 //y2=4.25
r1069 (  125 140 ) resistor r=0.104578 //w=0.196 //l=0.162481 //layer=m2 \
 //thickness=0.36 //x=69.155 //y=4.25 //x2=69.315 //y2=4.255
r1070 (  125 126 ) resistor r=4.99046 //w=0.131 //l=5.23 //layer=m2 \
 //thickness=0.36 //x=69.155 //y=4.25 //x2=63.925 //y2=4.25
r1071 (  123 138 ) resistor r=3.726 //w=0.179 //l=5.34249 //layer=m2 \
 //thickness=0.36 //x=58.43 //y=4.265 //x2=63.765 //y2=4.25
r1072 (  123 124 ) resistor r=0.329198 //w=0.131 //l=0.345 //layer=m2 \
 //thickness=0.36 //x=58.43 //y=4.265 //x2=58.085 //y2=4.265
r1073 (  121 124 ) resistor r=0.1875 //w=0.17 //l=0.262393 //layer=m2 \
 //thickness=0.36 //x=57.83 //y=4.25 //x2=58.085 //y2=4.265
r1074 (  121 122 ) resistor r=0.997137 //w=0.131 //l=1.045 //layer=m2 \
 //thickness=0.36 //x=57.83 //y=4.25 //x2=56.785 //y2=4.25
r1075 (  119 122 ) resistor r=0.125 //w=0.17 //l=0.179722 //layer=m2 \
 //thickness=0.36 //x=56.615 //y=4.27 //x2=56.785 //y2=4.25
r1076 (  119 120 ) resistor r=0.367366 //w=0.131 //l=0.385 //layer=m2 \
 //thickness=0.36 //x=56.615 //y=4.27 //x2=56.23 //y2=4.27
r1077 (  117 120 ) resistor r=0.1875 //w=0.17 //l=0.264811 //layer=m2 \
 //thickness=0.36 //x=55.975 //y=4.25 //x2=56.23 //y2=4.27
r1078 (  117 136 ) resistor r=2.30439 //w=0.131 //l=2.415 //layer=m2 \
 //thickness=0.36 //x=55.975 //y=4.25 //x2=53.56 //y2=4.25
r1079 (  116 269 ) resistor r=9.3 //w=0.17 //l=0.17 //layer=mcon //count=1 \
 //x=76.74 //y=4.88 //x2=76.74 //y2=4.88
r1080 (  112 260 ) resistor r=9.3 //w=0.17 //l=0.17 //layer=mcon //count=1 \
 //x=76.71 //y=2.26 //x2=76.71 //y2=2.26
r1081 (  112 114 ) resistor r=0.0936408 //w=0.196 //l=0.125 //layer=m1 \
 //thickness=0.36 //x=76.712 //y=2.26 //x2=76.712 //y2=2.385
r1082 (  110 148 ) resistor r=4.5 //w=0.15 //l=0.15 //layer=via1 //count=1 \
 //x=76.7 //y=4.255 //x2=76.7 //y2=4.255
r1083 (  108 110 ) resistor r=0.00168464 //w=0.371 //l=0.005 //layer=m1 \
 //thickness=0.36 //x=76.652 //y=4.25 //x2=76.652 //y2=4.255
r1084 (  104 255 ) resistor r=9.3 //w=0.17 //l=0.17 //layer=mcon //count=1 \
 //x=75.97 //y=4.88 //x2=75.97 //y2=4.88
r1085 (  104 105 ) resistor r=0.103207 //w=0.196 //l=0.14 //layer=m1 \
 //thickness=0.36 //x=75.972 //y=4.88 //x2=75.972 //y2=4.74
r1086 (  101 246 ) resistor r=9.3 //w=0.17 //l=0.17 //layer=mcon //count=1 \
 //x=75.97 //y=2.26 //x2=75.97 //y2=2.26
r1087 (  99 144 ) resistor r=4.5 //w=0.15 //l=0.15 //layer=via1 //count=1 \
 //x=75.96 //y=4.285 //x2=75.96 //y2=4.285
r1088 (  97 99 ) resistor r=0.0117925 //w=0.371 //l=0.035 //layer=m1 \
 //thickness=0.36 //x=75.912 //y=4.25 //x2=75.912 //y2=4.285
r1089 (  95 142 ) resistor r=4.5 //w=0.15 //l=0.15 //layer=via1 //count=1 \
 //x=74.12 //y=4.29 //x2=74.12 //y2=4.29
r1090 (  93 95 ) resistor r=0.0132979 //w=0.376 //l=0.04 //layer=m1 \
 //thickness=0.36 //x=74.172 //y=4.25 //x2=74.172 //y2=4.29
r1091 (  91 403 ) resistor r=9.3 //w=0.17 //l=0.17 //layer=mcon //count=1 \
 //x=73.635 //y=1.19 //x2=73.635 //y2=1.19
r1092 (  89 229 ) resistor r=9.3 //w=0.17 //l=0.17 //layer=mcon //count=1 \
 //x=73.34 //y=5.56 //x2=73.34 //y2=5.56
r1093 (  86 221 ) resistor r=9.3 //w=0.17 //l=0.17 //layer=mcon //count=1 \
 //x=72.46 //y=5.56 //x2=72.46 //y2=5.56
r1094 (  84 86 ) resistor r=0.121228 //w=0.232 //l=0.225 //layer=m1 \
 //thickness=0.36 //x=72.46 //y=5.335 //x2=72.46 //y2=5.56
r1095 (  83 213 ) resistor r=9.3 //w=0.17 //l=0.17 //layer=mcon //count=1 \
 //x=71.58 //y=5.56 //x2=71.58 //y2=5.56
r1096 (  81 83 ) resistor r=0.129608 //w=0.217 //l=0.225 //layer=m1 \
 //thickness=0.36 //x=71.582 //y=5.335 //x2=71.582 //y2=5.56
r1097 (  80 140 ) resistor r=4.5 //w=0.15 //l=0.15 //layer=via1 //count=1 \
 //x=69.315 //y=4.255 //x2=69.315 //y2=4.255
r1098 (  78 80 ) resistor r=0.00164908 //w=0.379 //l=0.005 //layer=m1 \
 //thickness=0.36 //x=69.26 //y=4.25 //x2=69.26 //y2=4.255
r1099 (  76 402 ) resistor r=9.3 //w=0.17 //l=0.17 //layer=mcon //count=1 \
 //x=68.825 //y=1.19 //x2=68.825 //y2=1.19
r1100 (  74 196 ) resistor r=9.3 //w=0.17 //l=0.17 //layer=mcon //count=1 \
 //x=68.53 //y=5.56 //x2=68.53 //y2=5.56
r1101 (  71 188 ) resistor r=9.3 //w=0.17 //l=0.17 //layer=mcon //count=1 \
 //x=67.65 //y=5.56 //x2=67.65 //y2=5.56
r1102 (  69 71 ) resistor r=0.121228 //w=0.232 //l=0.225 //layer=m1 \
 //thickness=0.36 //x=67.65 //y=5.335 //x2=67.65 //y2=5.56
r1103 (  68 180 ) resistor r=9.3 //w=0.17 //l=0.17 //layer=mcon //count=1 \
 //x=66.77 //y=5.56 //x2=66.77 //y2=5.56
r1104 (  66 68 ) resistor r=0.129608 //w=0.217 //l=0.225 //layer=m1 \
 //thickness=0.36 //x=66.772 //y=5.335 //x2=66.772 //y2=5.56
r1105 (  65 175 ) resistor r=9.3 //w=0.17 //l=0.17 //layer=mcon //count=1 \
 //x=63.79 //y=4.88 //x2=63.79 //y2=4.88
r1106 (  61 166 ) resistor r=9.3 //w=0.17 //l=0.17 //layer=mcon //count=1 \
 //x=63.76 //y=2.26 //x2=63.76 //y2=2.26
r1107 (  61 63 ) resistor r=0.0936408 //w=0.196 //l=0.125 //layer=m1 \
 //thickness=0.36 //x=63.762 //y=2.26 //x2=63.762 //y2=2.385
r1108 (  58 138 ) resistor r=4.5 //w=0.15 //l=0.15 //layer=via1 //count=1 \
 //x=63.765 //y=4.25 //x2=63.765 //y2=4.25
r1109 (  56 134 ) resistor r=4.5 //w=0.15 //l=0.15 //layer=via1 //count=1 \
 //x=53.4 //y=4.26 //x2=53.4 //y2=4.26
r1110 (  54 56 ) resistor r=0.00332447 //w=0.376 //l=0.01 //layer=m1 \
 //thickness=0.36 //x=53.452 //y=4.25 //x2=53.452 //y2=4.26
r1111 (  52 161 ) resistor r=9.3 //w=0.17 //l=0.17 //layer=mcon //count=1 \
 //x=53.4 //y=4.88 //x2=53.4 //y2=4.88
r1112 (  50 152 ) resistor r=9.3 //w=0.17 //l=0.17 //layer=mcon //count=1 \
 //x=53.4 //y=2.26 //x2=53.4 //y2=2.26
r1113 (  48 116 ) resistor r=0.0878548 //w=0.228 //l=0.159295 //layer=m1 \
 //thickness=0.36 //x=76.71 //y=4.735 //x2=76.74 //y2=4.88
r1114 (  47 110 ) resistor r=0.0909648 //w=0.371 //l=0.186762 //layer=m1 \
 //thickness=0.36 //x=76.71 //y=4.415 //x2=76.652 //y2=4.255
r1115 (  47 48 ) resistor r=0.305344 //w=0.131 //l=0.32 //layer=m1 \
 //thickness=0.36 //x=76.71 //y=4.415 //x2=76.71 //y2=4.735
r1116 (  46 108 ) resistor r=0.0892801 //w=0.371 //l=0.1817 //layer=m1 \
 //thickness=0.36 //x=76.71 //y=4.095 //x2=76.652 //y2=4.25
r1117 (  46 114 ) resistor r=1.63168 //w=0.131 //l=1.71 //layer=m1 \
 //thickness=0.36 //x=76.71 //y=4.095 //x2=76.71 //y2=2.385
r1118 (  43 99 ) resistor r=0.0909648 //w=0.371 //l=0.186762 //layer=m1 \
 //thickness=0.36 //x=75.97 //y=4.445 //x2=75.912 //y2=4.285
r1119 (  43 105 ) resistor r=0.281489 //w=0.131 //l=0.295 //layer=m1 \
 //thickness=0.36 //x=75.97 //y=4.445 //x2=75.97 //y2=4.74
r1120 (  42 97 ) resistor r=0.0791723 //w=0.371 //l=0.151245 //layer=m1 \
 //thickness=0.36 //x=75.97 //y=4.125 //x2=75.912 //y2=4.25
r1121 (  41 101 ) resistor r=0.0933015 //w=0.201 //l=0.125 //layer=m1 \
 //thickness=0.36 //x=75.97 //y=2.385 //x2=75.97 //y2=2.26
r1122 (  41 42 ) resistor r=1.66031 //w=0.131 //l=1.74 //layer=m1 \
 //thickness=0.36 //x=75.97 //y=2.385 //x2=75.97 //y2=4.125
r1123 (  39 95 ) resistor r=0.0911593 //w=0.376 //l=0.184174 //layer=m1 \
 //thickness=0.36 //x=74.12 //y=4.45 //x2=74.172 //y2=4.29
r1124 (  39 40 ) resistor r=0.763359 //w=0.131 //l=0.8 //layer=m1 \
 //thickness=0.36 //x=74.12 //y=4.45 //x2=74.12 //y2=5.25
r1125 (  38 93 ) resistor r=0.0778615 //w=0.376 //l=0.143666 //layer=m1 \
 //thickness=0.36 //x=74.12 //y=4.13 //x2=74.172 //y2=4.25
r1126 (  37 38 ) resistor r=2.09924 //w=0.131 //l=2.2 //layer=m1 \
 //thickness=0.36 //x=74.12 //y=1.93 //x2=74.12 //y2=4.13
r1127 (  35 37 ) resistor r=0.0698411 //w=0.17 //l=0.120208 //layer=m1 \
 //thickness=0.36 //x=74.035 //y=1.845 //x2=74.12 //y2=1.93
r1128 (  35 36 ) resistor r=0.300573 //w=0.131 //l=0.315 //layer=m1 \
 //thickness=0.36 //x=74.035 //y=1.845 //x2=73.72 //y2=1.845
r1129 (  34 36 ) resistor r=0.0698411 //w=0.17 //l=0.120208 //layer=m1 \
 //thickness=0.36 //x=73.635 //y=1.76 //x2=73.72 //y2=1.845
r1130 (  33 91 ) resistor r=0.0717383 //w=0.224 //l=0.115 //layer=m1 \
 //thickness=0.36 //x=73.635 //y=1.305 //x2=73.635 //y2=1.19
r1131 (  33 34 ) resistor r=0.43416 //w=0.131 //l=0.455 //layer=m1 \
 //thickness=0.36 //x=73.635 //y=1.305 //x2=73.635 //y2=1.76
r1132 (  32 87 ) resistor r=0.0675342 //w=0.23 //l=0.115 //layer=m1 \
 //thickness=0.36 //x=73.455 //y=5.335 //x2=73.34 //y2=5.335
r1133 (  31 40 ) resistor r=0.0698411 //w=0.17 //l=0.120208 //layer=m1 \
 //thickness=0.36 //x=74.035 //y=5.335 //x2=74.12 //y2=5.25
r1134 (  31 32 ) resistor r=0.553435 //w=0.131 //l=0.58 //layer=m1 \
 //thickness=0.36 //x=74.035 //y=5.335 //x2=73.455 //y2=5.335
r1135 (  30 89 ) resistor r=0.00118313 //w=0.23 //layer=m1 //thickness=0.36 \
 //x=73.34 //y=5.56 //x2=73.34 //y2=5.56
r1136 (  29 87 ) resistor r=0.002872 //w=0.34 //l=0.085 //layer=m1 \
 //thickness=0.36 //x=73.34 //y=5.42 //x2=73.34 //y2=5.335
r1137 (  29 30 ) resistor r=0.091623 //w=0.191 //l=0.14 //layer=m1 \
 //thickness=0.36 //x=73.34 //y=5.42 //x2=73.34 //y2=5.56
r1138 (  28 84 ) resistor r=0.0262263 //w=0.232 //l=0.12 //layer=m1 \
 //thickness=0.36 //x=72.58 //y=5.335 //x2=72.46 //y2=5.335
r1139 (  27 87 ) resistor r=0.0675342 //w=0.23 //l=0.115 //layer=m1 \
 //thickness=0.36 //x=73.225 //y=5.335 //x2=73.34 //y2=5.335
r1140 (  27 28 ) resistor r=0.615458 //w=0.131 //l=0.645 //layer=m1 \
 //thickness=0.36 //x=73.225 //y=5.335 //x2=72.58 //y2=5.335
r1141 (  26 81 ) resistor r=0.0222262 //w=0.217 //l=0.118 //layer=m1 \
 //thickness=0.36 //x=71.7 //y=5.335 //x2=71.582 //y2=5.335
r1142 (  25 84 ) resistor r=0.0262263 //w=0.232 //l=0.12 //layer=m1 \
 //thickness=0.36 //x=72.34 //y=5.335 //x2=72.46 //y2=5.335
r1143 (  25 26 ) resistor r=0.610687 //w=0.131 //l=0.64 //layer=m1 \
 //thickness=0.36 //x=72.34 //y=5.335 //x2=71.7 //y2=5.335
r1144 (  23 80 ) resistor r=0.0912814 //w=0.379 //l=0.183303 //layer=m1 \
 //thickness=0.36 //x=69.31 //y=4.415 //x2=69.26 //y2=4.255
r1145 (  23 24 ) resistor r=0.796756 //w=0.131 //l=0.835 //layer=m1 \
 //thickness=0.36 //x=69.31 //y=4.415 //x2=69.31 //y2=5.25
r1146 (  22 78 ) resistor r=0.0896323 //w=0.379 //l=0.178255 //layer=m1 \
 //thickness=0.36 //x=69.31 //y=4.095 //x2=69.26 //y2=4.25
r1147 (  21 22 ) resistor r=2.06584 //w=0.131 //l=2.165 //layer=m1 \
 //thickness=0.36 //x=69.31 //y=1.93 //x2=69.31 //y2=4.095
r1148 (  19 21 ) resistor r=0.0698411 //w=0.17 //l=0.120208 //layer=m1 \
 //thickness=0.36 //x=69.225 //y=1.845 //x2=69.31 //y2=1.93
r1149 (  19 20 ) resistor r=0.300573 //w=0.131 //l=0.315 //layer=m1 \
 //thickness=0.36 //x=69.225 //y=1.845 //x2=68.91 //y2=1.845
r1150 (  18 20 ) resistor r=0.0698411 //w=0.17 //l=0.120208 //layer=m1 \
 //thickness=0.36 //x=68.825 //y=1.76 //x2=68.91 //y2=1.845
r1151 (  17 76 ) resistor r=0.0717383 //w=0.224 //l=0.115 //layer=m1 \
 //thickness=0.36 //x=68.825 //y=1.305 //x2=68.825 //y2=1.19
r1152 (  17 18 ) resistor r=0.43416 //w=0.131 //l=0.455 //layer=m1 \
 //thickness=0.36 //x=68.825 //y=1.305 //x2=68.825 //y2=1.76
r1153 (  16 72 ) resistor r=0.0675342 //w=0.23 //l=0.115 //layer=m1 \
 //thickness=0.36 //x=68.645 //y=5.335 //x2=68.53 //y2=5.335
r1154 (  15 24 ) resistor r=0.0698411 //w=0.17 //l=0.120208 //layer=m1 \
 //thickness=0.36 //x=69.225 //y=5.335 //x2=69.31 //y2=5.25
r1155 (  15 16 ) resistor r=0.553435 //w=0.131 //l=0.58 //layer=m1 \
 //thickness=0.36 //x=69.225 //y=5.335 //x2=68.645 //y2=5.335
r1156 (  14 74 ) resistor r=0.00118313 //w=0.23 //layer=m1 //thickness=0.36 \
 //x=68.53 //y=5.56 //x2=68.53 //y2=5.56
r1157 (  13 72 ) resistor r=0.002872 //w=0.34 //l=0.085 //layer=m1 \
 //thickness=0.36 //x=68.53 //y=5.42 //x2=68.53 //y2=5.335
r1158 (  13 14 ) resistor r=0.091623 //w=0.191 //l=0.14 //layer=m1 \
 //thickness=0.36 //x=68.53 //y=5.42 //x2=68.53 //y2=5.56
r1159 (  12 69 ) resistor r=0.0262263 //w=0.232 //l=0.12 //layer=m1 \
 //thickness=0.36 //x=67.77 //y=5.335 //x2=67.65 //y2=5.335
r1160 (  11 72 ) resistor r=0.0675342 //w=0.23 //l=0.115 //layer=m1 \
 //thickness=0.36 //x=68.415 //y=5.335 //x2=68.53 //y2=5.335
r1161 (  11 12 ) resistor r=0.615458 //w=0.131 //l=0.645 //layer=m1 \
 //thickness=0.36 //x=68.415 //y=5.335 //x2=67.77 //y2=5.335
r1162 (  10 66 ) resistor r=0.0222262 //w=0.217 //l=0.118 //layer=m1 \
 //thickness=0.36 //x=66.89 //y=5.335 //x2=66.772 //y2=5.335
r1163 (  9 69 ) resistor r=0.0262263 //w=0.232 //l=0.12 //layer=m1 \
 //thickness=0.36 //x=67.53 //y=5.335 //x2=67.65 //y2=5.335
r1164 (  9 10 ) resistor r=0.610687 //w=0.131 //l=0.64 //layer=m1 \
 //thickness=0.36 //x=67.53 //y=5.335 //x2=66.89 //y2=5.335
r1165 (  8 65 ) resistor r=0.0878548 //w=0.228 //l=0.159295 //layer=m1 \
 //thickness=0.36 //x=63.76 //y=4.735 //x2=63.79 //y2=4.88
r1166 (  7 58 ) resistor r=0.0912814 //w=0.379 //l=0.183303 //layer=m1 \
 //thickness=0.36 //x=63.76 //y=4.41 //x2=63.71 //y2=4.25
r1167 (  7 8 ) resistor r=0.310115 //w=0.131 //l=0.325 //layer=m1 \
 //thickness=0.36 //x=63.76 //y=4.41 //x2=63.76 //y2=4.735
r1168 (  6 58 ) resistor r=0.0912814 //w=0.379 //l=0.183303 //layer=m1 \
 //thickness=0.36 //x=63.76 //y=4.09 //x2=63.71 //y2=4.25
r1169 (  6 63 ) resistor r=1.62691 //w=0.131 //l=1.705 //layer=m1 \
 //thickness=0.36 //x=63.76 //y=4.09 //x2=63.76 //y2=2.385
r1170 (  4 52 ) resistor r=0.0760407 //w=0.238 //l=0.125 //layer=m1 \
 //thickness=0.36 //x=53.4 //y=4.755 //x2=53.4 //y2=4.88
r1171 (  3 56 ) resistor r=0.0911593 //w=0.376 //l=0.184174 //layer=m1 \
 //thickness=0.36 //x=53.4 //y=4.42 //x2=53.452 //y2=4.26
r1172 (  3 4 ) resistor r=0.319656 //w=0.131 //l=0.335 //layer=m1 \
 //thickness=0.36 //x=53.4 //y=4.42 //x2=53.4 //y2=4.755
r1173 (  2 54 ) resistor r=0.0878349 //w=0.376 //l=0.174069 //layer=m1 \
 //thickness=0.36 //x=53.4 //y=4.1 //x2=53.452 //y2=4.25
r1174 (  1 50 ) resistor r=0.0719237 //w=0.222 //l=0.115 //layer=m1 \
 //thickness=0.36 //x=53.4 //y=2.375 //x2=53.4 //y2=2.26
r1175 (  1 2 ) resistor r=1.64599 //w=0.131 //l=1.725 //layer=m1 \
 //thickness=0.36 //x=53.4 //y=2.375 //x2=53.4 //y2=4.1
ends PM_TMRDFFRNQNX1\%noxref_14

subckt PM_TMRDFFRNQNX1\%noxref_15 ( 1 2 3 4 7 12 13 15 16 18 19 20 21 22 23 24 \
 25 27 30 31 33 34 35 36 38 39 40 42 43 47 52 53 55 56 58 59 60 61 62 63 64 65 \
 66 67 68 69 70 76 81 82 85 87 90 98 100 103 106 112 115 118 121 122 126 127 \
 130 132 135 139 147 152 155 160 162 164 166 168 169 170 171 172 174 176 177 \
 179 180 182 183 184 186 189 193 204 205 214 215 218 227 232 240 257 266 271 \
 279 287 304 313 318 326 343 352 357 366 372 377 382 383 384 385 386 387 388 \
 389 390 391 392 393 394 395 396 397 398 399 403 404 405 410 412 415 416 420 \
 421 422 427 429 432 433 434 435 436 437 441 443 446 447 451 452 453 454 455 \
 457 463 464 465 466 470 471 472 473 477 479 482 483 484 485 489 490 491 492 \
 496 498 504 505 507 508 513 517 518 523 532 544 557 560 561 562 566 567 568 \
 569 570 571 572 )
c1305 ( 562 0 ) capacitor c=0.00878249f //x=63.87 //y=1.085
c1306 ( 561 0 ) capacitor c=0.00885916f //x=60.495 //y=1.095
c1307 ( 560 0 ) capacitor c=0.00878249f //x=50.92 //y=1.085
c1308 ( 557 0 ) capacitor c=0.0692896f //x=82.63 //y=4.885
c1309 ( 544 0 ) capacitor c=0.0575534f //x=78.93 //y=2.26
c1310 ( 532 0 ) capacitor c=0.0682508f //x=63.02 //y=4.88
c1311 ( 523 0 ) capacitor c=0.0710579f //x=55.62 //y=4.88
c1312 ( 518 0 ) capacitor c=0.0278202f //x=55.62 //y=2.095
c1313 ( 517 0 ) capacitor c=0.0479324f //x=55.62 //y=2.26
c1314 ( 513 0 ) capacitor c=0.0710579f //x=47.48 //y=4.88
c1315 ( 508 0 ) capacitor c=0.0278202f //x=47.48 //y=2.095
c1316 ( 507 0 ) capacitor c=0.0479125f //x=47.48 //y=2.26
c1317 ( 505 0 ) capacitor c=0.0344584f //x=82.965 //y=1.39
c1318 ( 504 0 ) capacitor c=0.0188421f //x=82.965 //y=1.045
c1319 ( 498 0 ) capacitor c=0.0141798f //x=82.81 //y=1.545
c1320 ( 496 0 ) capacitor c=0.0160622f //x=82.81 //y=0.89
c1321 ( 492 0 ) capacitor c=0.103881f //x=82.435 //y=2.095
c1322 ( 491 0 ) capacitor c=0.0227978f //x=82.435 //y=1.7
c1323 ( 490 0 ) capacitor c=0.0234352f //x=82.435 //y=1.39
c1324 ( 489 0 ) capacitor c=0.0200371f //x=82.435 //y=1.045
c1325 ( 485 0 ) capacitor c=0.0318956f //x=79.635 //y=1.39
c1326 ( 484 0 ) capacitor c=0.0186809f //x=79.635 //y=1.045
c1327 ( 483 0 ) capacitor c=0.0625156f //x=79.275 //y=4.975
c1328 ( 482 0 ) capacitor c=0.0375163f //x=79.565 //y=4.975
c1329 ( 479 0 ) capacitor c=0.0157936f //x=79.48 //y=1.545
c1330 ( 477 0 ) capacitor c=0.0158553f //x=79.48 //y=0.89
c1331 ( 473 0 ) capacitor c=0.0302441f //x=79.105 //y=2.095
c1332 ( 472 0 ) capacitor c=0.0238107f //x=79.105 //y=1.7
c1333 ( 471 0 ) capacitor c=0.0234359f //x=79.105 //y=1.39
c1334 ( 470 0 ) capacitor c=0.0199332f //x=79.105 //y=1.045
c1335 ( 466 0 ) capacitor c=0.0612936f //x=66.625 //y=4.97
c1336 ( 465 0 ) capacitor c=0.0376642f //x=66.915 //y=4.97
c1337 ( 464 0 ) capacitor c=0.0346489f //x=66.58 //y=1.4
c1338 ( 463 0 ) capacitor c=0.018692f //x=66.58 //y=1.055
c1339 ( 457 0 ) capacitor c=0.0137077f //x=66.425 //y=1.555
c1340 ( 455 0 ) capacitor c=0.0158585f //x=66.425 //y=0.9
c1341 ( 454 0 ) capacitor c=0.101012f //x=66.05 //y=2.095
c1342 ( 453 0 ) capacitor c=0.0229444f //x=66.05 //y=1.71
c1343 ( 452 0 ) capacitor c=0.0234359f //x=66.05 //y=1.4
c1344 ( 451 0 ) capacitor c=0.019815f //x=66.05 //y=1.055
c1345 ( 447 0 ) capacitor c=0.0318956f //x=63.355 //y=1.39
c1346 ( 446 0 ) capacitor c=0.0186809f //x=63.355 //y=1.045
c1347 ( 443 0 ) capacitor c=0.0141821f //x=63.2 //y=1.545
c1348 ( 441 0 ) capacitor c=0.0158553f //x=63.2 //y=0.89
c1349 ( 437 0 ) capacitor c=0.0854195f //x=62.825 //y=2.095
c1350 ( 436 0 ) capacitor c=0.0229235f //x=62.825 //y=1.7
c1351 ( 435 0 ) capacitor c=0.0234359f //x=62.825 //y=1.39
c1352 ( 434 0 ) capacitor c=0.0198759f //x=62.825 //y=1.045
c1353 ( 433 0 ) capacitor c=0.0443175f //x=56.14 //y=1.44
c1354 ( 432 0 ) capacitor c=0.0199703f //x=56.14 //y=1.095
c1355 ( 429 0 ) capacitor c=0.0162526f //x=55.985 //y=1.595
c1356 ( 427 0 ) capacitor c=0.0157807f //x=55.985 //y=0.94
c1357 ( 422 0 ) capacitor c=0.0220935f //x=55.61 //y=1.75
c1358 ( 421 0 ) capacitor c=0.0207489f //x=55.61 //y=1.44
c1359 ( 420 0 ) capacitor c=0.0194091f //x=55.61 //y=1.095
c1360 ( 416 0 ) capacitor c=0.0443175f //x=48 //y=1.44
c1361 ( 415 0 ) capacitor c=0.0199703f //x=48 //y=1.095
c1362 ( 412 0 ) capacitor c=0.0162526f //x=47.845 //y=1.595
c1363 ( 410 0 ) capacitor c=0.0157807f //x=47.845 //y=0.94
c1364 ( 405 0 ) capacitor c=0.0220935f //x=47.47 //y=1.75
c1365 ( 404 0 ) capacitor c=0.0207489f //x=47.47 //y=1.44
c1366 ( 403 0 ) capacitor c=0.0194091f //x=47.47 //y=1.095
c1367 ( 399 0 ) capacitor c=0.111167f //x=82.96 //y=6.205
c1368 ( 398 0 ) capacitor c=0.154978f //x=82.52 //y=6.205
c1369 ( 397 0 ) capacitor c=0.110282f //x=79.64 //y=6.205
c1370 ( 396 0 ) capacitor c=0.155219f //x=79.2 //y=6.205
c1371 ( 395 0 ) capacitor c=0.110208f //x=66.99 //y=6.2
c1372 ( 394 0 ) capacitor c=0.158957f //x=66.55 //y=6.2
c1373 ( 393 0 ) capacitor c=0.110369f //x=63.36 //y=6.2
c1374 ( 392 0 ) capacitor c=0.154619f //x=62.92 //y=6.2
c1375 ( 391 0 ) capacitor c=0.159671f //x=55.8 //y=6.2
c1376 ( 390 0 ) capacitor c=0.110208f //x=55.36 //y=6.2
c1377 ( 389 0 ) capacitor c=0.159671f //x=47.66 //y=6.2
c1378 ( 388 0 ) capacitor c=0.110208f //x=47.22 //y=6.2
c1379 ( 377 0 ) capacitor c=0.0156727f //x=82.63 //y=4.62
c1380 ( 372 0 ) capacitor c=0.00133484f //x=82.63 //y=2.26
c1381 ( 366 0 ) capacitor c=0.0126258f //x=78.93 //y=4.62
c1382 ( 357 0 ) capacitor c=8.37642e-19 //x=78.93 //y=2.26
c1383 ( 352 0 ) capacitor c=0.0014751f //x=66.35 //y=4.88
c1384 ( 343 0 ) capacitor c=0.0012618f //x=66.35 //y=2.26
c1385 ( 326 0 ) capacitor c=0.0322017f //x=64.02 //y=5.56
c1386 ( 318 0 ) capacitor c=0.0290143f //x=63.14 //y=5.56
c1387 ( 313 0 ) capacitor c=8.13425e-19 //x=63.02 //y=4.88
c1388 ( 304 0 ) capacitor c=7.85889e-19 //x=63.02 //y=2.26
c1389 ( 287 0 ) capacitor c=0.0292634f //x=60.39 //y=5.56
c1390 ( 279 0 ) capacitor c=0.029137f //x=59.51 //y=5.56
c1391 ( 271 0 ) capacitor c=0.0278099f //x=58.63 //y=5.56
c1392 ( 266 0 ) capacitor c=7.7417e-19 //x=55.62 //y=4.88
c1393 ( 257 0 ) capacitor c=0.00101179f //x=55.62 //y=2.26
c1394 ( 240 0 ) capacitor c=0.0322017f //x=51.07 //y=5.56
c1395 ( 232 0 ) capacitor c=0.0291657f //x=50.19 //y=5.56
c1396 ( 227 0 ) capacitor c=7.7417e-19 //x=47.48 //y=4.88
c1397 ( 218 0 ) capacitor c=0.00101179f //x=47.48 //y=2.26
c1398 ( 215 0 ) capacitor c=0.0710304f //x=82.475 //y=4.64
c1399 ( 214 0 ) capacitor c=0.00642399f //x=82.635 //y=4.64
c1400 ( 205 0 ) capacitor c=6.92089e-19 //x=64.66 //y=3.515
c1401 ( 204 0 ) capacitor c=0.00937613f //x=64.34 //y=3.515
c1402 ( 193 0 ) capacitor c=6.14881e-19 //x=47.64 //y=3.525
c1403 ( 189 0 ) capacitor c=0.00530528f //x=79.095 //y=4.62
c1404 ( 186 0 ) capacitor c=0.0561044f //x=73.595 //y=3.48
c1405 ( 184 0 ) capacitor c=0.0175613f //x=72.995 //y=3.51
c1406 ( 183 0 ) capacitor c=0.0467586f //x=70.935 //y=3.495
c1407 ( 182 0 ) capacitor c=0.00605663f //x=71.365 //y=3.495
c1408 ( 180 0 ) capacitor c=0.0193753f //x=66.195 //y=3.51
c1409 ( 179 0 ) capacitor c=4.64216e-19 //x=63.18 //y=3.51
c1410 ( 177 0 ) capacitor c=0.0234723f //x=61.335 //y=3.51
c1411 ( 176 0 ) capacitor c=0.0189392f //x=62.86 //y=3.51
c1412 ( 174 0 ) capacitor c=0.00228713f //x=58.43 //y=3.495
c1413 ( 172 0 ) capacitor c=0.0164618f //x=57.83 //y=3.51
c1414 ( 171 0 ) capacitor c=0.00364857f //x=56.15 //y=3.5
c1415 ( 170 0 ) capacitor c=0.00615936f //x=56.58 //y=3.5
c1416 ( 169 0 ) capacitor c=0.0111389f //x=51.71 //y=3.51
c1417 ( 168 0 ) capacitor c=0.0537541f //x=55.46 //y=3.51
c1418 ( 166 0 ) capacitor c=0.00221586f //x=50.27 //y=3.48
c1419 ( 164 0 ) capacitor c=0.0155684f //x=49.67 //y=3.51
c1420 ( 162 0 ) capacitor c=0.0062702f //x=48.435 //y=3.48
c1421 ( 160 0 ) capacitor c=0.0030116f //x=47.835 //y=3.51
c1422 ( 155 0 ) capacitor c=0.0127073f //x=82.63 //y=4.62
c1423 ( 152 0 ) capacitor c=0.0130954f //x=78.93 //y=4.62
c1424 ( 147 0 ) capacitor c=0.015329f //x=78.92 //y=3.51
c1425 ( 139 0 ) capacitor c=0.0170693f //x=66.35 //y=3.51
c1426 ( 135 0 ) capacitor c=0.016938f //x=64.5 //y=3.51
c1427 ( 132 0 ) capacitor c=0.0108728f //x=64.06 //y=1.18
c1428 ( 130 0 ) capacitor c=5.78613e-19 //x=64.02 //y=5.56
c1429 ( 127 0 ) capacitor c=0.010659f //x=64.02 //y=5.38
c1430 ( 126 0 ) capacitor c=0.00837128f //x=63.14 //y=5.56
c1431 ( 122 0 ) capacitor c=0.0268056f //x=63.022 //y=4.74
c1432 ( 121 0 ) capacitor c=0.00611114f //x=63.02 //y=4.88
c1433 ( 118 0 ) capacitor c=0.00463527f //x=63.02 //y=2.26
c1434 ( 115 0 ) capacitor c=0.0161834f //x=63.02 //y=3.51
c1435 ( 112 0 ) capacitor c=0.0170515f //x=61.17 //y=3.51
c1436 ( 106 0 ) capacitor c=0.00112339f //x=60.39 //y=5.335
c1437 ( 103 0 ) capacitor c=0.00759146f //x=59.51 //y=5.335
c1438 ( 100 0 ) capacitor c=0.0111234f //x=58.632 //y=5.335
c1439 ( 98 0 ) capacitor c=0.0148558f //x=55.62 //y=3.51
c1440 ( 90 0 ) capacitor c=0.0158589f //x=51.55 //y=3.51
c1441 ( 87 0 ) capacitor c=0.0112415f //x=51.11 //y=1.18
c1442 ( 85 0 ) capacitor c=5.78613e-19 //x=51.07 //y=5.56
c1443 ( 82 0 ) capacitor c=0.0108004f //x=51.07 //y=5.38
c1444 ( 81 0 ) capacitor c=0.00936169f //x=50.19 //y=5.56
c1445 ( 76 0 ) capacitor c=0.0150828f //x=47.48 //y=3.51
c1446 ( 70 0 ) capacitor c=0.078238f //x=82.63 //y=4.475
c1447 ( 69 0 ) capacitor c=0.00894425f //x=82.63 //y=2.385
c1448 ( 68 0 ) capacitor c=0.0180081f //x=78.93 //y=4.46
c1449 ( 67 0 ) capacitor c=0.0134395f //x=78.93 //y=3.67
c1450 ( 66 0 ) capacitor c=0.0264416f //x=78.93 //y=3.35
c1451 ( 65 0 ) capacitor c=0.00530172f //x=78.93 //y=2.375
c1452 ( 64 0 ) capacitor c=0.0382053f //x=66.35 //y=4.755
c1453 ( 63 0 ) capacitor c=0.0145929f //x=66.35 //y=3.675
c1454 ( 62 0 ) capacitor c=0.0298948f //x=66.35 //y=3.355
c1455 ( 61 0 ) capacitor c=0.00495287f //x=66.35 //y=2.375
c1456 ( 60 0 ) capacitor c=0.0419718f //x=64.5 //y=5.295
c1457 ( 59 0 ) capacitor c=0.0134337f //x=64.5 //y=3.675
c1458 ( 58 0 ) capacitor c=0.0388571f //x=64.5 //y=3.355
c1459 ( 56 0 ) capacitor c=0.00458458f //x=64.145 //y=1.835
c1460 ( 55 0 ) capacitor c=0.0120653f //x=64.415 //y=1.835
c1461 ( 53 0 ) capacitor c=0.0116495f //x=64.415 //y=5.38
c1462 ( 52 0 ) capacitor c=0.0134247f //x=64.06 //y=1.75
c1463 ( 47 0 ) capacitor c=0.013452f //x=63.905 //y=5.38
c1464 ( 43 0 ) capacitor c=0.0131563f //x=63.02 //y=3.67
c1465 ( 42 0 ) capacitor c=0.02559f //x=63.02 //y=3.35
c1466 ( 40 0 ) capacitor c=0.0424466f //x=61.17 //y=5.25
c1467 ( 39 0 ) capacitor c=0.013011f //x=61.17 //y=3.67
c1468 ( 38 0 ) capacitor c=0.0368608f //x=61.17 //y=3.35
c1469 ( 36 0 ) capacitor c=0.00493487f //x=60.77 //y=1.845
c1470 ( 35 0 ) capacitor c=0.0128695f //x=61.085 //y=1.845
c1471 ( 34 0 ) capacitor c=0.0136833f //x=60.685 //y=1.76
c1472 ( 33 0 ) capacitor c=0.0107052f //x=60.685 //y=1.305
c1473 ( 31 0 ) capacitor c=0.0237967f //x=61.085 //y=5.335
c1474 ( 30 0 ) capacitor c=0.00906713f //x=60.39 //y=5.56
c1475 ( 27 0 ) capacitor c=0.019596f //x=60.275 //y=5.335
c1476 ( 25 0 ) capacitor c=0.015236f //x=59.39 //y=5.335
c1477 ( 24 0 ) capacitor c=0.0286235f //x=55.62 //y=4.75
c1478 ( 23 0 ) capacitor c=0.0129401f //x=55.62 //y=3.67
c1479 ( 22 0 ) capacitor c=0.0229166f //x=55.62 //y=3.35
c1480 ( 21 0 ) capacitor c=0.00556102f //x=55.62 //y=2.375
c1481 ( 20 0 ) capacitor c=0.040289f //x=51.55 //y=5.295
c1482 ( 19 0 ) capacitor c=0.0138102f //x=51.55 //y=3.69
c1483 ( 18 0 ) capacitor c=0.0389807f //x=51.55 //y=3.37
c1484 ( 16 0 ) capacitor c=0.00466468f //x=51.195 //y=1.835
c1485 ( 15 0 ) capacitor c=0.0120842f //x=51.465 //y=1.835
c1486 ( 13 0 ) capacitor c=0.0112149f //x=51.465 //y=5.38
c1487 ( 12 0 ) capacitor c=0.0134844f //x=51.11 //y=1.75
c1488 ( 7 0 ) capacitor c=0.0134407f //x=50.955 //y=5.38
c1489 ( 4 0 ) capacitor c=0.0267759f //x=47.48 //y=4.75
c1490 ( 3 0 ) capacitor c=0.0132072f //x=47.48 //y=3.685
c1491 ( 2 0 ) capacitor c=0.0232096f //x=47.48 //y=3.365
c1492 ( 1 0 ) capacitor c=0.00550278f //x=47.48 //y=2.375
r1493 (  555 557 ) resistor r=22.7554 //w=0.233 //l=0.11 //layer=ply \
 //thickness=0.18 //x=82.52 //y=4.885 //x2=82.63 //y2=4.885
r1494 (  530 532 ) resistor r=20.6867 //w=0.233 //l=0.1 //layer=ply \
 //thickness=0.18 //x=62.92 //y=4.88 //x2=63.02 //y2=4.88
r1495 (  517 518 ) resistor r=52.7279 //w=0.214 //l=0.165 //layer=ply \
 //thickness=0.18 //x=55.62 //y=2.26 //x2=55.62 //y2=2.095
r1496 (  507 508 ) resistor r=52.7279 //w=0.214 //l=0.165 //layer=ply \
 //thickness=0.18 //x=47.48 //y=2.26 //x2=47.48 //y2=2.095
r1497 (  505 559 ) resistor r=45.1352 //w=0.168 //l=0.173853 //layer=ply \
 //thickness=0.18 //x=82.965 //y=1.39 //x2=82.925 //y2=1.545
r1498 (  504 558 ) resistor r=45.1352 //w=0.168 //l=0.173853 //layer=ply \
 //thickness=0.18 //x=82.965 //y=1.045 //x2=82.925 //y2=0.89
r1499 (  504 505 ) resistor r=176.904 //w=0.094 //l=0.345 //layer=ply \
 //thickness=0.18 //x=82.965 //y=1.045 //x2=82.965 //y2=1.39
r1500 (  501 557 ) resistor r=68.2661 //w=0.233 //l=0.404166 //layer=ply \
 //thickness=0.18 //x=82.96 //y=5.05 //x2=82.63 //y2=4.885
r1501 (  499 554 ) resistor r=10.701 //w=0.21 //l=0.115 //layer=ply \
 //thickness=0.18 //x=82.59 //y=1.545 //x2=82.475 //y2=1.545
r1502 (  498 559 ) resistor r=5.52526 //w=0.168 //l=0.115 //layer=ply \
 //thickness=0.18 //x=82.81 //y=1.545 //x2=82.925 //y2=1.545
r1503 (  497 553 ) resistor r=5.52526 //w=0.168 //l=0.115 //layer=ply \
 //thickness=0.18 //x=82.59 //y=0.89 //x2=82.475 //y2=0.89
r1504 (  496 558 ) resistor r=5.52526 //w=0.168 //l=0.115 //layer=ply \
 //thickness=0.18 //x=82.81 //y=0.89 //x2=82.925 //y2=0.89
r1505 (  496 497 ) resistor r=112.809 //w=0.094 //l=0.22 //layer=ply \
 //thickness=0.18 //x=82.81 //y=0.89 //x2=82.59 //y2=0.89
r1506 (  493 555 ) resistor r=13.0941 //w=0.233 //l=0.165 //layer=ply \
 //thickness=0.18 //x=82.52 //y=5.05 //x2=82.52 //y2=4.885
r1507 (  492 552 ) resistor r=34.8111 //w=0.27 //l=0.264953 //layer=ply \
 //thickness=0.18 //x=82.435 //y=2.095 //x2=82.63 //y2=2.26
r1508 (  491 554 ) resistor r=39.5823 //w=0.21 //l=0.173853 //layer=ply \
 //thickness=0.18 //x=82.435 //y=1.7 //x2=82.475 //y2=1.545
r1509 (  491 492 ) resistor r=202.543 //w=0.094 //l=0.395 //layer=ply \
 //thickness=0.18 //x=82.435 //y=1.7 //x2=82.435 //y2=2.095
r1510 (  490 554 ) resistor r=39.5823 //w=0.21 //l=0.173853 //layer=ply \
 //thickness=0.18 //x=82.435 //y=1.39 //x2=82.475 //y2=1.545
r1511 (  489 553 ) resistor r=45.1352 //w=0.168 //l=0.173853 //layer=ply \
 //thickness=0.18 //x=82.435 //y=1.045 //x2=82.475 //y2=0.89
r1512 (  489 490 ) resistor r=176.904 //w=0.094 //l=0.345 //layer=ply \
 //thickness=0.18 //x=82.435 //y=1.045 //x2=82.435 //y2=1.39
r1513 (  485 550 ) resistor r=45.1352 //w=0.168 //l=0.173853 //layer=ply \
 //thickness=0.18 //x=79.635 //y=1.39 //x2=79.595 //y2=1.545
r1514 (  484 549 ) resistor r=45.1352 //w=0.168 //l=0.173853 //layer=ply \
 //thickness=0.18 //x=79.635 //y=1.045 //x2=79.595 //y2=0.89
r1515 (  484 485 ) resistor r=176.904 //w=0.094 //l=0.345 //layer=ply \
 //thickness=0.18 //x=79.635 //y=1.045 //x2=79.635 //y2=1.39
r1516 (  482 486 ) resistor r=26.9307 //w=0.15 //l=0.106066 //layer=ply \
 //thickness=0.18 //x=79.565 //y=4.975 //x2=79.64 //y2=5.05
r1517 (  482 483 ) resistor r=148.702 //w=0.094 //l=0.29 //layer=ply \
 //thickness=0.18 //x=79.565 //y=4.975 //x2=79.275 //y2=4.975
r1518 (  480 548 ) resistor r=10.701 //w=0.21 //l=0.115 //layer=ply \
 //thickness=0.18 //x=79.26 //y=1.545 //x2=79.145 //y2=1.545
r1519 (  479 550 ) resistor r=5.52526 //w=0.168 //l=0.115 //layer=ply \
 //thickness=0.18 //x=79.48 //y=1.545 //x2=79.595 //y2=1.545
r1520 (  478 547 ) resistor r=5.52526 //w=0.168 //l=0.115 //layer=ply \
 //thickness=0.18 //x=79.26 //y=0.89 //x2=79.145 //y2=0.89
r1521 (  477 549 ) resistor r=5.52526 //w=0.168 //l=0.115 //layer=ply \
 //thickness=0.18 //x=79.48 //y=0.89 //x2=79.595 //y2=0.89
r1522 (  477 478 ) resistor r=112.809 //w=0.094 //l=0.22 //layer=ply \
 //thickness=0.18 //x=79.48 //y=0.89 //x2=79.26 //y2=0.89
r1523 (  474 483 ) resistor r=22.1787 //w=0.252 //l=0.106066 //layer=ply \
 //thickness=0.18 //x=79.2 //y=5.05 //x2=79.275 //y2=4.975
r1524 (  474 546 ) resistor r=51.6429 //w=0.252 //l=0.34271 //layer=ply \
 //thickness=0.18 //x=79.2 //y=5.05 //x2=78.93 //y2=4.885
r1525 (  473 544 ) resistor r=30.4513 //w=0.277 //l=0.243926 //layer=ply \
 //thickness=0.18 //x=79.105 //y=2.095 //x2=78.93 //y2=2.26
r1526 (  472 548 ) resistor r=39.5823 //w=0.21 //l=0.173853 //layer=ply \
 //thickness=0.18 //x=79.105 //y=1.7 //x2=79.145 //y2=1.545
r1527 (  472 473 ) resistor r=202.543 //w=0.094 //l=0.395 //layer=ply \
 //thickness=0.18 //x=79.105 //y=1.7 //x2=79.105 //y2=2.095
r1528 (  471 548 ) resistor r=39.5823 //w=0.21 //l=0.173853 //layer=ply \
 //thickness=0.18 //x=79.105 //y=1.39 //x2=79.145 //y2=1.545
r1529 (  470 547 ) resistor r=45.1352 //w=0.168 //l=0.173853 //layer=ply \
 //thickness=0.18 //x=79.105 //y=1.045 //x2=79.145 //y2=0.89
r1530 (  470 471 ) resistor r=176.904 //w=0.094 //l=0.345 //layer=ply \
 //thickness=0.18 //x=79.105 //y=1.045 //x2=79.105 //y2=1.39
r1531 (  465 467 ) resistor r=26.9307 //w=0.15 //l=0.106066 //layer=ply \
 //thickness=0.18 //x=66.915 //y=4.97 //x2=66.99 //y2=5.045
r1532 (  465 466 ) resistor r=148.702 //w=0.094 //l=0.29 //layer=ply \
 //thickness=0.18 //x=66.915 //y=4.97 //x2=66.625 //y2=4.97
r1533 (  464 542 ) resistor r=45.1352 //w=0.168 //l=0.173853 //layer=ply \
 //thickness=0.18 //x=66.58 //y=1.4 //x2=66.54 //y2=1.555
r1534 (  463 541 ) resistor r=45.1352 //w=0.168 //l=0.173853 //layer=ply \
 //thickness=0.18 //x=66.58 //y=1.055 //x2=66.54 //y2=0.9
r1535 (  463 464 ) resistor r=176.904 //w=0.094 //l=0.345 //layer=ply \
 //thickness=0.18 //x=66.58 //y=1.055 //x2=66.58 //y2=1.4
r1536 (  460 466 ) resistor r=22.7971 //w=0.269 //l=0.106066 //layer=ply \
 //thickness=0.18 //x=66.55 //y=5.045 //x2=66.625 //y2=4.97
r1537 (  460 540 ) resistor r=35.8364 //w=0.269 //l=0.270185 //layer=ply \
 //thickness=0.18 //x=66.55 //y=5.045 //x2=66.35 //y2=4.88
r1538 (  458 536 ) resistor r=10.701 //w=0.21 //l=0.115 //layer=ply \
 //thickness=0.18 //x=66.205 //y=1.555 //x2=66.09 //y2=1.555
r1539 (  457 542 ) resistor r=5.52526 //w=0.168 //l=0.115 //layer=ply \
 //thickness=0.18 //x=66.425 //y=1.555 //x2=66.54 //y2=1.555
r1540 (  456 535 ) resistor r=5.52526 //w=0.168 //l=0.115 //layer=ply \
 //thickness=0.18 //x=66.205 //y=0.9 //x2=66.09 //y2=0.9
r1541 (  455 541 ) resistor r=5.52526 //w=0.168 //l=0.115 //layer=ply \
 //thickness=0.18 //x=66.425 //y=0.9 //x2=66.54 //y2=0.9
r1542 (  455 456 ) resistor r=112.809 //w=0.094 //l=0.22 //layer=ply \
 //thickness=0.18 //x=66.425 //y=0.9 //x2=66.205 //y2=0.9
r1543 (  454 538 ) resistor r=58.7805 //w=0.246 //l=0.373497 //layer=ply \
 //thickness=0.18 //x=66.05 //y=2.095 //x2=66.35 //y2=2.26
r1544 (  453 536 ) resistor r=39.5823 //w=0.21 //l=0.173853 //layer=ply \
 //thickness=0.18 //x=66.05 //y=1.71 //x2=66.09 //y2=1.555
r1545 (  453 454 ) resistor r=197.415 //w=0.094 //l=0.385 //layer=ply \
 //thickness=0.18 //x=66.05 //y=1.71 //x2=66.05 //y2=2.095
r1546 (  452 536 ) resistor r=39.5823 //w=0.21 //l=0.173853 //layer=ply \
 //thickness=0.18 //x=66.05 //y=1.4 //x2=66.09 //y2=1.555
r1547 (  451 535 ) resistor r=45.1352 //w=0.168 //l=0.173853 //layer=ply \
 //thickness=0.18 //x=66.05 //y=1.055 //x2=66.09 //y2=0.9
r1548 (  451 452 ) resistor r=176.904 //w=0.094 //l=0.345 //layer=ply \
 //thickness=0.18 //x=66.05 //y=1.055 //x2=66.05 //y2=1.4
r1549 (  448 532 ) resistor r=70.3348 //w=0.233 //l=0.414367 //layer=ply \
 //thickness=0.18 //x=63.36 //y=5.045 //x2=63.02 //y2=4.88
r1550 (  447 534 ) resistor r=45.1352 //w=0.168 //l=0.173853 //layer=ply \
 //thickness=0.18 //x=63.355 //y=1.39 //x2=63.315 //y2=1.545
r1551 (  446 533 ) resistor r=45.1352 //w=0.168 //l=0.173853 //layer=ply \
 //thickness=0.18 //x=63.355 //y=1.045 //x2=63.315 //y2=0.89
r1552 (  446 447 ) resistor r=176.904 //w=0.094 //l=0.345 //layer=ply \
 //thickness=0.18 //x=63.355 //y=1.045 //x2=63.355 //y2=1.39
r1553 (  444 529 ) resistor r=10.701 //w=0.21 //l=0.115 //layer=ply \
 //thickness=0.18 //x=62.98 //y=1.545 //x2=62.865 //y2=1.545
r1554 (  443 534 ) resistor r=5.52526 //w=0.168 //l=0.115 //layer=ply \
 //thickness=0.18 //x=63.2 //y=1.545 //x2=63.315 //y2=1.545
r1555 (  442 528 ) resistor r=5.52526 //w=0.168 //l=0.115 //layer=ply \
 //thickness=0.18 //x=62.98 //y=0.89 //x2=62.865 //y2=0.89
r1556 (  441 533 ) resistor r=5.52526 //w=0.168 //l=0.115 //layer=ply \
 //thickness=0.18 //x=63.2 //y=0.89 //x2=63.315 //y2=0.89
r1557 (  441 442 ) resistor r=112.809 //w=0.094 //l=0.22 //layer=ply \
 //thickness=0.18 //x=63.2 //y=0.89 //x2=62.98 //y2=0.89
r1558 (  438 530 ) resistor r=13.0941 //w=0.233 //l=0.165 //layer=ply \
 //thickness=0.18 //x=62.92 //y=5.045 //x2=62.92 //y2=4.88
r1559 (  437 527 ) resistor r=34.8111 //w=0.27 //l=0.264953 //layer=ply \
 //thickness=0.18 //x=62.825 //y=2.095 //x2=63.02 //y2=2.26
r1560 (  436 529 ) resistor r=39.5823 //w=0.21 //l=0.173853 //layer=ply \
 //thickness=0.18 //x=62.825 //y=1.7 //x2=62.865 //y2=1.545
r1561 (  436 437 ) resistor r=202.543 //w=0.094 //l=0.395 //layer=ply \
 //thickness=0.18 //x=62.825 //y=1.7 //x2=62.825 //y2=2.095
r1562 (  435 529 ) resistor r=39.5823 //w=0.21 //l=0.173853 //layer=ply \
 //thickness=0.18 //x=62.825 //y=1.39 //x2=62.865 //y2=1.545
r1563 (  434 528 ) resistor r=45.1352 //w=0.168 //l=0.173853 //layer=ply \
 //thickness=0.18 //x=62.825 //y=1.045 //x2=62.865 //y2=0.89
r1564 (  434 435 ) resistor r=176.904 //w=0.094 //l=0.345 //layer=ply \
 //thickness=0.18 //x=62.825 //y=1.045 //x2=62.825 //y2=1.39
r1565 (  433 525 ) resistor r=45.1352 //w=0.168 //l=0.173853 //layer=ply \
 //thickness=0.18 //x=56.14 //y=1.44 //x2=56.1 //y2=1.595
r1566 (  432 524 ) resistor r=45.1352 //w=0.168 //l=0.173853 //layer=ply \
 //thickness=0.18 //x=56.14 //y=1.095 //x2=56.1 //y2=0.94
r1567 (  432 433 ) resistor r=176.904 //w=0.094 //l=0.345 //layer=ply \
 //thickness=0.18 //x=56.14 //y=1.095 //x2=56.14 //y2=1.44
r1568 (  430 521 ) resistor r=10.701 //w=0.21 //l=0.115 //layer=ply \
 //thickness=0.18 //x=55.765 //y=1.595 //x2=55.65 //y2=1.595
r1569 (  429 525 ) resistor r=5.52526 //w=0.168 //l=0.115 //layer=ply \
 //thickness=0.18 //x=55.985 //y=1.595 //x2=56.1 //y2=1.595
r1570 (  428 520 ) resistor r=5.52526 //w=0.168 //l=0.115 //layer=ply \
 //thickness=0.18 //x=55.765 //y=0.94 //x2=55.65 //y2=0.94
r1571 (  427 524 ) resistor r=5.52526 //w=0.168 //l=0.115 //layer=ply \
 //thickness=0.18 //x=55.985 //y=0.94 //x2=56.1 //y2=0.94
r1572 (  427 428 ) resistor r=112.809 //w=0.094 //l=0.22 //layer=ply \
 //thickness=0.18 //x=55.985 //y=0.94 //x2=55.765 //y2=0.94
r1573 (  424 523 ) resistor r=37.236 //w=0.233 //l=0.249199 //layer=ply \
 //thickness=0.18 //x=55.8 //y=5.045 //x2=55.62 //y2=4.88
r1574 (  422 521 ) resistor r=39.5823 //w=0.21 //l=0.173853 //layer=ply \
 //thickness=0.18 //x=55.61 //y=1.75 //x2=55.65 //y2=1.595
r1575 (  422 518 ) resistor r=176.904 //w=0.094 //l=0.345 //layer=ply \
 //thickness=0.18 //x=55.61 //y=1.75 //x2=55.61 //y2=2.095
r1576 (  421 521 ) resistor r=39.5823 //w=0.21 //l=0.173853 //layer=ply \
 //thickness=0.18 //x=55.61 //y=1.44 //x2=55.65 //y2=1.595
r1577 (  420 520 ) resistor r=45.1352 //w=0.168 //l=0.173853 //layer=ply \
 //thickness=0.18 //x=55.61 //y=1.095 //x2=55.65 //y2=0.94
r1578 (  420 421 ) resistor r=176.904 //w=0.094 //l=0.345 //layer=ply \
 //thickness=0.18 //x=55.61 //y=1.095 //x2=55.61 //y2=1.44
r1579 (  417 523 ) resistor r=53.7854 //w=0.233 //l=0.332415 //layer=ply \
 //thickness=0.18 //x=55.36 //y=5.045 //x2=55.62 //y2=4.88
r1580 (  416 515 ) resistor r=45.1352 //w=0.168 //l=0.173853 //layer=ply \
 //thickness=0.18 //x=48 //y=1.44 //x2=47.96 //y2=1.595
r1581 (  415 514 ) resistor r=45.1352 //w=0.168 //l=0.173853 //layer=ply \
 //thickness=0.18 //x=48 //y=1.095 //x2=47.96 //y2=0.94
r1582 (  415 416 ) resistor r=176.904 //w=0.094 //l=0.345 //layer=ply \
 //thickness=0.18 //x=48 //y=1.095 //x2=48 //y2=1.44
r1583 (  413 511 ) resistor r=10.701 //w=0.21 //l=0.115 //layer=ply \
 //thickness=0.18 //x=47.625 //y=1.595 //x2=47.51 //y2=1.595
r1584 (  412 515 ) resistor r=5.52526 //w=0.168 //l=0.115 //layer=ply \
 //thickness=0.18 //x=47.845 //y=1.595 //x2=47.96 //y2=1.595
r1585 (  411 510 ) resistor r=5.52526 //w=0.168 //l=0.115 //layer=ply \
 //thickness=0.18 //x=47.625 //y=0.94 //x2=47.51 //y2=0.94
r1586 (  410 514 ) resistor r=5.52526 //w=0.168 //l=0.115 //layer=ply \
 //thickness=0.18 //x=47.845 //y=0.94 //x2=47.96 //y2=0.94
r1587 (  410 411 ) resistor r=112.809 //w=0.094 //l=0.22 //layer=ply \
 //thickness=0.18 //x=47.845 //y=0.94 //x2=47.625 //y2=0.94
r1588 (  407 513 ) resistor r=37.236 //w=0.233 //l=0.249199 //layer=ply \
 //thickness=0.18 //x=47.66 //y=5.045 //x2=47.48 //y2=4.88
r1589 (  405 511 ) resistor r=39.5823 //w=0.21 //l=0.173853 //layer=ply \
 //thickness=0.18 //x=47.47 //y=1.75 //x2=47.51 //y2=1.595
r1590 (  405 508 ) resistor r=176.904 //w=0.094 //l=0.345 //layer=ply \
 //thickness=0.18 //x=47.47 //y=1.75 //x2=47.47 //y2=2.095
r1591 (  404 511 ) resistor r=39.5823 //w=0.21 //l=0.173853 //layer=ply \
 //thickness=0.18 //x=47.47 //y=1.44 //x2=47.51 //y2=1.595
r1592 (  403 510 ) resistor r=45.1352 //w=0.168 //l=0.173853 //layer=ply \
 //thickness=0.18 //x=47.47 //y=1.095 //x2=47.51 //y2=0.94
r1593 (  403 404 ) resistor r=176.904 //w=0.094 //l=0.345 //layer=ply \
 //thickness=0.18 //x=47.47 //y=1.095 //x2=47.47 //y2=1.44
r1594 (  400 513 ) resistor r=53.7854 //w=0.233 //l=0.332415 //layer=ply \
 //thickness=0.18 //x=47.22 //y=5.045 //x2=47.48 //y2=4.88
r1595 (  399 501 ) resistor r=592.245 //w=0.094 //l=1.155 //layer=ply \
 //thickness=0.18 //x=82.96 //y=6.205 //x2=82.96 //y2=5.05
r1596 (  398 493 ) resistor r=592.245 //w=0.094 //l=1.155 //layer=ply \
 //thickness=0.18 //x=82.52 //y=6.205 //x2=82.52 //y2=5.05
r1597 (  397 486 ) resistor r=592.245 //w=0.094 //l=1.155 //layer=ply \
 //thickness=0.18 //x=79.64 //y=6.205 //x2=79.64 //y2=5.05
r1598 (  396 474 ) resistor r=592.245 //w=0.094 //l=1.155 //layer=ply \
 //thickness=0.18 //x=79.2 //y=6.205 //x2=79.2 //y2=5.05
r1599 (  395 467 ) resistor r=592.245 //w=0.094 //l=1.155 //layer=ply \
 //thickness=0.18 //x=66.99 //y=6.2 //x2=66.99 //y2=5.045
r1600 (  394 460 ) resistor r=592.245 //w=0.094 //l=1.155 //layer=ply \
 //thickness=0.18 //x=66.55 //y=6.2 //x2=66.55 //y2=5.045
r1601 (  393 448 ) resistor r=592.245 //w=0.094 //l=1.155 //layer=ply \
 //thickness=0.18 //x=63.36 //y=6.2 //x2=63.36 //y2=5.045
r1602 (  392 438 ) resistor r=592.245 //w=0.094 //l=1.155 //layer=ply \
 //thickness=0.18 //x=62.92 //y=6.2 //x2=62.92 //y2=5.045
r1603 (  391 424 ) resistor r=592.245 //w=0.094 //l=1.155 //layer=ply \
 //thickness=0.18 //x=55.8 //y=6.2 //x2=55.8 //y2=5.045
r1604 (  390 417 ) resistor r=592.245 //w=0.094 //l=1.155 //layer=ply \
 //thickness=0.18 //x=55.36 //y=6.2 //x2=55.36 //y2=5.045
r1605 (  389 407 ) resistor r=592.245 //w=0.094 //l=1.155 //layer=ply \
 //thickness=0.18 //x=47.66 //y=6.2 //x2=47.66 //y2=5.045
r1606 (  388 400 ) resistor r=592.245 //w=0.094 //l=1.155 //layer=ply \
 //thickness=0.18 //x=47.22 //y=6.2 //x2=47.22 //y2=5.045
r1607 (  387 498 ) resistor r=56.4043 //w=0.094 //l=0.11 //layer=ply \
 //thickness=0.18 //x=82.7 //y=1.545 //x2=82.81 //y2=1.545
r1608 (  387 499 ) resistor r=56.4043 //w=0.094 //l=0.11 //layer=ply \
 //thickness=0.18 //x=82.7 //y=1.545 //x2=82.59 //y2=1.545
r1609 (  386 479 ) resistor r=56.4043 //w=0.094 //l=0.11 //layer=ply \
 //thickness=0.18 //x=79.37 //y=1.545 //x2=79.48 //y2=1.545
r1610 (  386 480 ) resistor r=56.4043 //w=0.094 //l=0.11 //layer=ply \
 //thickness=0.18 //x=79.37 //y=1.545 //x2=79.26 //y2=1.545
r1611 (  385 457 ) resistor r=56.4043 //w=0.094 //l=0.11 //layer=ply \
 //thickness=0.18 //x=66.315 //y=1.555 //x2=66.425 //y2=1.555
r1612 (  385 458 ) resistor r=56.4043 //w=0.094 //l=0.11 //layer=ply \
 //thickness=0.18 //x=66.315 //y=1.555 //x2=66.205 //y2=1.555
r1613 (  384 443 ) resistor r=56.4043 //w=0.094 //l=0.11 //layer=ply \
 //thickness=0.18 //x=63.09 //y=1.545 //x2=63.2 //y2=1.545
r1614 (  384 444 ) resistor r=56.4043 //w=0.094 //l=0.11 //layer=ply \
 //thickness=0.18 //x=63.09 //y=1.545 //x2=62.98 //y2=1.545
r1615 (  383 429 ) resistor r=56.4043 //w=0.094 //l=0.11 //layer=ply \
 //thickness=0.18 //x=55.875 //y=1.595 //x2=55.985 //y2=1.595
r1616 (  383 430 ) resistor r=56.4043 //w=0.094 //l=0.11 //layer=ply \
 //thickness=0.18 //x=55.875 //y=1.595 //x2=55.765 //y2=1.595
r1617 (  382 412 ) resistor r=56.4043 //w=0.094 //l=0.11 //layer=ply \
 //thickness=0.18 //x=47.735 //y=1.595 //x2=47.845 //y2=1.595
r1618 (  382 413 ) resistor r=56.4043 //w=0.094 //l=0.11 //layer=ply \
 //thickness=0.18 //x=47.735 //y=1.595 //x2=47.625 //y2=1.595
r1619 (  380 557 ) resistor r=152 //w=0.17 //l=0.17 //layer=licon //count=1 \
 //x=82.63 //y=4.885 //x2=82.63 //y2=4.885
r1620 (  377 380 ) resistor r=18.139 //w=0.187 //l=0.265 //layer=li \
 //thickness=0.1 //x=82.63 //y=4.62 //x2=82.63 //y2=4.885
r1621 (  372 552 ) resistor r=152 //w=0.17 //l=0.17 //layer=licon //count=1 \
 //x=82.63 //y=2.26 //x2=82.63 //y2=2.26
r1622 (  369 546 ) resistor r=152 //w=0.17 //l=0.17 //layer=licon //count=1 \
 //x=78.93 //y=4.885 //x2=78.93 //y2=4.885
r1623 (  366 369 ) resistor r=18.139 //w=0.187 //l=0.265 //layer=li \
 //thickness=0.1 //x=78.93 //y=4.62 //x2=78.93 //y2=4.885
r1624 (  357 544 ) resistor r=152 //w=0.17 //l=0.17 //layer=licon //count=1 \
 //x=78.93 //y=2.26 //x2=78.93 //y2=2.26
r1625 (  352 540 ) resistor r=152 //w=0.17 //l=0.17 //layer=licon //count=1 \
 //x=66.35 //y=4.88 //x2=66.35 //y2=4.88
r1626 (  343 538 ) resistor r=152 //w=0.17 //l=0.17 //layer=licon //count=1 \
 //x=66.35 //y=2.26 //x2=66.35 //y2=2.26
r1627 (  326 572 ) resistor r=23.615 //w=0.187 //l=0.345 //layer=li \
 //thickness=0.1 //x=64.02 //y=5.56 //x2=64.02 //y2=5.905
r1628 (  318 571 ) resistor r=23.615 //w=0.187 //l=0.345 //layer=li \
 //thickness=0.1 //x=63.14 //y=5.56 //x2=63.14 //y2=5.905
r1629 (  313 532 ) resistor r=152 //w=0.17 //l=0.17 //layer=licon //count=1 \
 //x=63.02 //y=4.88 //x2=63.02 //y2=4.88
r1630 (  304 527 ) resistor r=152 //w=0.17 //l=0.17 //layer=licon //count=1 \
 //x=63.02 //y=2.26 //x2=63.02 //y2=2.26
r1631 (  287 570 ) resistor r=23.615 //w=0.187 //l=0.345 //layer=li \
 //thickness=0.1 //x=60.39 //y=5.56 //x2=60.39 //y2=5.905
r1632 (  279 569 ) resistor r=23.615 //w=0.187 //l=0.345 //layer=li \
 //thickness=0.1 //x=59.51 //y=5.56 //x2=59.51 //y2=5.905
r1633 (  271 568 ) resistor r=23.615 //w=0.187 //l=0.345 //layer=li \
 //thickness=0.1 //x=58.63 //y=5.56 //x2=58.63 //y2=5.905
r1634 (  266 523 ) resistor r=152 //w=0.17 //l=0.17 //layer=licon //count=1 \
 //x=55.62 //y=4.88 //x2=55.62 //y2=4.88
r1635 (  257 517 ) resistor r=152 //w=0.17 //l=0.17 //layer=licon //count=1 \
 //x=55.62 //y=2.26 //x2=55.62 //y2=2.26
r1636 (  240 567 ) resistor r=23.615 //w=0.187 //l=0.345 //layer=li \
 //thickness=0.1 //x=51.07 //y=5.56 //x2=51.07 //y2=5.905
r1637 (  232 566 ) resistor r=23.615 //w=0.187 //l=0.345 //layer=li \
 //thickness=0.1 //x=50.19 //y=5.56 //x2=50.19 //y2=5.905
r1638 (  227 513 ) resistor r=152 //w=0.17 //l=0.17 //layer=licon //count=1 \
 //x=47.48 //y=4.88 //x2=47.48 //y2=4.88
r1639 (  218 507 ) resistor r=152 //w=0.17 //l=0.17 //layer=licon //count=1 \
 //x=47.48 //y=2.26 //x2=47.48 //y2=2.26
r1640 (  214 215 ) resistor r=0.10734 //w=0.281 //l=0.16 //layer=m2 \
 //thickness=0.36 //x=82.635 //y=4.64 //x2=82.475 //y2=4.64
r1641 (  203 205 ) resistor r=0.10734 //w=0.281 //l=0.16 //layer=m2 \
 //thickness=0.36 //x=64.5 //y=3.515 //x2=64.66 //y2=3.515
r1642 (  203 204 ) resistor r=0.10734 //w=0.281 //l=0.16 //layer=m2 \
 //thickness=0.36 //x=64.5 //y=3.515 //x2=64.34 //y2=3.515
r1643 (  191 193 ) resistor r=0.10734 //w=0.281 //l=0.16 //layer=m2 \
 //thickness=0.36 //x=47.48 //y=3.525 //x2=47.64 //y2=3.525
r1644 (  189 211 ) resistor r=0.10734 //w=0.281 //l=0.16 //layer=m2 \
 //thickness=0.36 //x=79.095 //y=4.62 //x2=78.935 //y2=4.62
r1645 (  189 215 ) resistor r=3.22519 //w=0.131 //l=3.38 //layer=m2 \
 //thickness=0.36 //x=79.095 //y=4.62 //x2=82.475 //y2=4.62
r1646 (  186 209 ) resistor r=3.71902 //w=0.179 //l=5.33998 //layer=m2 \
 //thickness=0.36 //x=73.595 //y=3.48 //x2=78.92 //y2=3.51
r1647 (  186 187 ) resistor r=0.410305 //w=0.131 //l=0.43 //layer=m2 \
 //thickness=0.36 //x=73.595 //y=3.48 //x2=73.165 //y2=3.48
r1648 (  184 187 ) resistor r=0.125 //w=0.17 //l=0.184391 //layer=m2 \
 //thickness=0.36 //x=72.995 //y=3.51 //x2=73.165 //y2=3.48
r1649 (  184 185 ) resistor r=1.31202 //w=0.131 //l=1.375 //layer=m2 \
 //thickness=0.36 //x=72.995 //y=3.51 //x2=71.62 //y2=3.51
r1650 (  183 207 ) resistor r=3.1636 //w=0.181 //l=4.58999 //layer=m2 \
 //thickness=0.36 //x=70.935 //y=3.495 //x2=66.355 //y2=3.515
r1651 (  182 185 ) resistor r=0.1875 //w=0.17 //l=0.262393 //layer=m2 \
 //thickness=0.36 //x=71.365 //y=3.495 //x2=71.62 //y2=3.51
r1652 (  182 183 ) resistor r=0.410305 //w=0.131 //l=0.43 //layer=m2 \
 //thickness=0.36 //x=71.365 //y=3.495 //x2=70.935 //y2=3.495
r1653 (  180 207 ) resistor r=0.111117 //w=0.181 //l=0.162481 //layer=m2 \
 //thickness=0.36 //x=66.195 //y=3.51 //x2=66.355 //y2=3.515
r1654 (  180 205 ) resistor r=1.46469 //w=0.131 //l=1.535 //layer=m2 \
 //thickness=0.36 //x=66.195 //y=3.51 //x2=64.66 //y2=3.51
r1655 (  179 201 ) resistor r=0.10734 //w=0.281 //l=0.16 //layer=m2 \
 //thickness=0.36 //x=63.18 //y=3.51 //x2=63.02 //y2=3.51
r1656 (  179 204 ) resistor r=1.10687 //w=0.131 //l=1.16 //layer=m2 \
 //thickness=0.36 //x=63.18 //y=3.51 //x2=64.34 //y2=3.51
r1657 (  177 199 ) resistor r=0.108234 //w=0.187 //l=0.16 //layer=m2 \
 //thickness=0.36 //x=61.335 //y=3.51 //x2=61.175 //y2=3.51
r1658 (  176 201 ) resistor r=0.10734 //w=0.281 //l=0.16 //layer=m2 \
 //thickness=0.36 //x=62.86 //y=3.51 //x2=63.02 //y2=3.51
r1659 (  176 177 ) resistor r=1.45515 //w=0.131 //l=1.525 //layer=m2 \
 //thickness=0.36 //x=62.86 //y=3.51 //x2=61.335 //y2=3.51
r1660 (  174 199 ) resistor r=1.83617 //w=0.187 //l=2.75249 //layer=m2 \
 //thickness=0.36 //x=58.43 //y=3.495 //x2=61.175 //y2=3.51
r1661 (  174 175 ) resistor r=0.410305 //w=0.131 //l=0.43 //layer=m2 \
 //thickness=0.36 //x=58.43 //y=3.495 //x2=58 //y2=3.495
r1662 (  172 175 ) resistor r=0.125 //w=0.17 //l=0.177341 //layer=m2 \
 //thickness=0.36 //x=57.83 //y=3.51 //x2=58 //y2=3.495
r1663 (  172 173 ) resistor r=0.949427 //w=0.131 //l=0.995 //layer=m2 \
 //thickness=0.36 //x=57.83 //y=3.51 //x2=56.835 //y2=3.51
r1664 (  171 197 ) resistor r=0.286843 //w=0.24 //l=0.534977 //layer=m2 \
 //thickness=0.36 //x=56.15 //y=3.5 //x2=55.62 //y2=3.51
r1665 (  170 173 ) resistor r=0.1875 //w=0.17 //l=0.259952 //layer=m2 \
 //thickness=0.36 //x=56.58 //y=3.5 //x2=56.835 //y2=3.51
r1666 (  170 171 ) resistor r=0.410305 //w=0.131 //l=0.43 //layer=m2 \
 //thickness=0.36 //x=56.58 //y=3.5 //x2=56.15 //y2=3.5
r1667 (  169 195 ) resistor r=0.10188 //w=0.204 //l=0.169706 //layer=m2 \
 //thickness=0.36 //x=51.71 //y=3.51 //x2=51.55 //y2=3.53
r1668 (  168 197 ) resistor r=0.0941343 //w=0.24 //l=0.16 //layer=m2 \
 //thickness=0.36 //x=55.46 //y=3.51 //x2=55.62 //y2=3.51
r1669 (  168 169 ) resistor r=3.57824 //w=0.131 //l=3.75 //layer=m2 \
 //thickness=0.36 //x=55.46 //y=3.51 //x2=51.71 //y2=3.51
r1670 (  166 195 ) resistor r=0.788154 //w=0.204 //l=1.30476 //layer=m2 \
 //thickness=0.36 //x=50.27 //y=3.48 //x2=51.55 //y2=3.53
r1671 (  166 167 ) resistor r=0.410305 //w=0.131 //l=0.43 //layer=m2 \
 //thickness=0.36 //x=50.27 //y=3.48 //x2=49.84 //y2=3.48
r1672 (  164 167 ) resistor r=0.125 //w=0.17 //l=0.184391 //layer=m2 \
 //thickness=0.36 //x=49.67 //y=3.51 //x2=49.84 //y2=3.48
r1673 (  164 165 ) resistor r=0.935115 //w=0.131 //l=0.98 //layer=m2 \
 //thickness=0.36 //x=49.67 //y=3.51 //x2=48.69 //y2=3.51
r1674 (  162 165 ) resistor r=0.1875 //w=0.17 //l=0.269583 //layer=m2 \
 //thickness=0.36 //x=48.435 //y=3.48 //x2=48.69 //y2=3.51
r1675 (  162 163 ) resistor r=0.410305 //w=0.131 //l=0.43 //layer=m2 \
 //thickness=0.36 //x=48.435 //y=3.48 //x2=48.005 //y2=3.48
r1676 (  160 163 ) resistor r=0.125 //w=0.17 //l=0.184391 //layer=m2 \
 //thickness=0.36 //x=47.835 //y=3.51 //x2=48.005 //y2=3.48
r1677 (  160 193 ) resistor r=0.186069 //w=0.131 //l=0.195 //layer=m2 \
 //thickness=0.36 //x=47.835 //y=3.51 //x2=47.64 //y2=3.51
r1678 (  159 372 ) resistor r=9.3 //w=0.17 //l=0.17 //layer=mcon //count=1 \
 //x=82.63 //y=2.26 //x2=82.63 //y2=2.26
r1679 (  157 214 ) resistor r=4.5 //w=0.15 //l=0.15 //layer=via1 //count=1 \
 //x=82.635 //y=4.64 //x2=82.635 //y2=4.64
r1680 (  155 377 ) resistor r=9.3 //w=0.17 //l=0.17 //layer=mcon //count=1 \
 //x=82.63 //y=4.62 //x2=82.63 //y2=4.62
r1681 (  155 157 ) resistor r=0.00659631 //w=0.379 //l=0.02 //layer=m1 \
 //thickness=0.36 //x=82.58 //y=4.62 //x2=82.58 //y2=4.64
r1682 (  152 366 ) resistor r=9.3 //w=0.17 //l=0.17 //layer=mcon //count=1 \
 //x=78.93 //y=4.62 //x2=78.93 //y2=4.62
r1683 (  152 211 ) resistor r=4.5 //w=0.15 //l=0.15 //layer=via1 //count=1 \
 //x=78.935 //y=4.62 //x2=78.935 //y2=4.62
r1684 (  150 357 ) resistor r=9.3 //w=0.17 //l=0.17 //layer=mcon //count=1 \
 //x=78.93 //y=2.26 //x2=78.93 //y2=2.26
r1685 (  147 209 ) resistor r=4.5 //w=0.15 //l=0.15 //layer=via1 //count=1 \
 //x=78.92 //y=3.51 //x2=78.92 //y2=3.51
r1686 (  145 352 ) resistor r=9.3 //w=0.17 //l=0.17 //layer=mcon //count=1 \
 //x=66.35 //y=4.88 //x2=66.35 //y2=4.88
r1687 (  143 343 ) resistor r=9.3 //w=0.17 //l=0.17 //layer=mcon //count=1 \
 //x=66.35 //y=2.26 //x2=66.35 //y2=2.26
r1688 (  141 207 ) resistor r=4.5 //w=0.15 //l=0.15 //layer=via1 //count=1 \
 //x=66.355 //y=3.515 //x2=66.355 //y2=3.515
r1689 (  139 141 ) resistor r=0.00164908 //w=0.379 //l=0.005 //layer=m1 \
 //thickness=0.36 //x=66.3 //y=3.51 //x2=66.3 //y2=3.515
r1690 (  137 203 ) resistor r=4.5 //w=0.15 //l=0.15 //layer=via1 //count=1 \
 //x=64.5 //y=3.515 //x2=64.5 //y2=3.515
r1691 (  135 137 ) resistor r=0.00166223 //w=0.376 //l=0.005 //layer=m1 \
 //thickness=0.36 //x=64.552 //y=3.51 //x2=64.552 //y2=3.515
r1692 (  132 562 ) resistor r=9.3 //w=0.17 //l=0.17 //layer=mcon //count=1 \
 //x=64.06 //y=1.18 //x2=64.06 //y2=1.18
r1693 (  130 326 ) resistor r=9.3 //w=0.17 //l=0.17 //layer=mcon //count=1 \
 //x=64.02 //y=5.56 //x2=64.02 //y2=5.56
r1694 (  127 130 ) resistor r=0.117801 //w=0.191 //l=0.18 //layer=m1 \
 //thickness=0.36 //x=64.02 //y=5.38 //x2=64.02 //y2=5.56
r1695 (  126 318 ) resistor r=9.3 //w=0.17 //l=0.17 //layer=mcon //count=1 \
 //x=63.14 //y=5.56 //x2=63.14 //y2=5.56
r1696 (  124 126 ) resistor r=0.10274 //w=0.219 //l=0.18 //layer=m1 \
 //thickness=0.36 //x=63.14 //y=5.38 //x2=63.14 //y2=5.56
r1697 (  121 313 ) resistor r=9.3 //w=0.17 //l=0.17 //layer=mcon //count=1 \
 //x=63.02 //y=4.88 //x2=63.02 //y2=4.88
r1698 (  121 122 ) resistor r=0.103207 //w=0.196 //l=0.14 //layer=m1 \
 //thickness=0.36 //x=63.022 //y=4.88 //x2=63.022 //y2=4.74
r1699 (  118 304 ) resistor r=9.3 //w=0.17 //l=0.17 //layer=mcon //count=1 \
 //x=63.02 //y=2.26 //x2=63.02 //y2=2.26
r1700 (  115 201 ) resistor r=4.5 //w=0.15 //l=0.15 //layer=via1 //count=1 \
 //x=63.02 //y=3.51 //x2=63.02 //y2=3.51
r1701 (  112 199 ) resistor r=4.5 //w=0.15 //l=0.15 //layer=via1 //count=1 \
 //x=61.175 //y=3.51 //x2=61.175 //y2=3.51
r1702 (  110 561 ) resistor r=9.3 //w=0.17 //l=0.17 //layer=mcon //count=1 \
 //x=60.685 //y=1.19 //x2=60.685 //y2=1.19
r1703 (  108 287 ) resistor r=9.3 //w=0.17 //l=0.17 //layer=mcon //count=1 \
 //x=60.39 //y=5.56 //x2=60.39 //y2=5.56
r1704 (  105 279 ) resistor r=9.3 //w=0.17 //l=0.17 //layer=mcon //count=1 \
 //x=59.51 //y=5.56 //x2=59.51 //y2=5.56
r1705 (  103 105 ) resistor r=0.121228 //w=0.232 //l=0.225 //layer=m1 \
 //thickness=0.36 //x=59.51 //y=5.335 //x2=59.51 //y2=5.56
r1706 (  102 271 ) resistor r=9.3 //w=0.17 //l=0.17 //layer=mcon //count=1 \
 //x=58.63 //y=5.56 //x2=58.63 //y2=5.56
r1707 (  100 102 ) resistor r=0.129608 //w=0.217 //l=0.225 //layer=m1 \
 //thickness=0.36 //x=58.632 //y=5.335 //x2=58.632 //y2=5.56
r1708 (  98 197 ) resistor r=4.5 //w=0.15 //l=0.15 //layer=via1 //count=1 \
 //x=55.62 //y=3.51 //x2=55.62 //y2=3.51
r1709 (  96 266 ) resistor r=9.3 //w=0.17 //l=0.17 //layer=mcon //count=1 \
 //x=55.62 //y=4.88 //x2=55.62 //y2=4.88
r1710 (  94 257 ) resistor r=9.3 //w=0.17 //l=0.17 //layer=mcon //count=1 \
 //x=55.62 //y=2.26 //x2=55.62 //y2=2.26
r1711 (  92 195 ) resistor r=4.5 //w=0.15 //l=0.15 //layer=via1 //count=1 \
 //x=51.55 //y=3.53 //x2=51.55 //y2=3.53
r1712 (  90 92 ) resistor r=0.00664894 //w=0.376 //l=0.02 //layer=m1 \
 //thickness=0.36 //x=51.497 //y=3.51 //x2=51.497 //y2=3.53
r1713 (  87 560 ) resistor r=9.3 //w=0.17 //l=0.17 //layer=mcon //count=1 \
 //x=51.11 //y=1.18 //x2=51.11 //y2=1.18
r1714 (  85 240 ) resistor r=9.3 //w=0.17 //l=0.17 //layer=mcon //count=1 \
 //x=51.07 //y=5.56 //x2=51.07 //y2=5.56
r1715 (  82 85 ) resistor r=0.117801 //w=0.191 //l=0.18 //layer=m1 \
 //thickness=0.36 //x=51.07 //y=5.38 //x2=51.07 //y2=5.56
r1716 (  81 232 ) resistor r=9.3 //w=0.17 //l=0.17 //layer=mcon //count=1 \
 //x=50.19 //y=5.56 //x2=50.19 //y2=5.56
r1717 (  79 81 ) resistor r=0.10274 //w=0.219 //l=0.18 //layer=m1 \
 //thickness=0.36 //x=50.19 //y=5.38 //x2=50.19 //y2=5.56
r1718 (  78 191 ) resistor r=4.5 //w=0.15 //l=0.15 //layer=via1 //count=1 \
 //x=47.48 //y=3.525 //x2=47.48 //y2=3.525
r1719 (  76 78 ) resistor r=0.0049867 //w=0.376 //l=0.015 //layer=m1 \
 //thickness=0.36 //x=47.532 //y=3.51 //x2=47.532 //y2=3.525
r1720 (  74 227 ) resistor r=9.3 //w=0.17 //l=0.17 //layer=mcon //count=1 \
 //x=47.48 //y=4.88 //x2=47.48 //y2=4.88
r1721 (  72 218 ) resistor r=9.3 //w=0.17 //l=0.17 //layer=mcon //count=1 \
 //x=47.48 //y=2.26 //x2=47.48 //y2=2.26
r1722 (  70 155 ) resistor r=0.0863342 //w=0.379 //l=0.168152 //layer=m1 \
 //thickness=0.36 //x=82.63 //y=4.475 //x2=82.58 //y2=4.62
r1723 (  69 159 ) resistor r=0.0761125 //w=0.237 //l=0.126491 //layer=m1 \
 //thickness=0.36 //x=82.63 //y=2.385 //x2=82.627 //y2=2.26
r1724 (  69 70 ) resistor r=1.99427 //w=0.131 //l=2.09 //layer=m1 \
 //thickness=0.36 //x=82.63 //y=2.385 //x2=82.63 //y2=4.475
r1725 (  68 152 ) resistor r=0.0898201 //w=0.322 //l=0.185472 //layer=m1 \
 //thickness=0.36 //x=78.93 //y=4.46 //x2=78.985 //y2=4.62
r1726 (  67 147 ) resistor r=0.0909648 //w=0.371 //l=0.186762 //layer=m1 \
 //thickness=0.36 //x=78.93 //y=3.67 //x2=78.872 //y2=3.51
r1727 (  67 68 ) resistor r=0.753817 //w=0.131 //l=0.79 //layer=m1 \
 //thickness=0.36 //x=78.93 //y=3.67 //x2=78.93 //y2=4.46
r1728 (  66 147 ) resistor r=0.0909648 //w=0.371 //l=0.186762 //layer=m1 \
 //thickness=0.36 //x=78.93 //y=3.35 //x2=78.872 //y2=3.51
r1729 (  65 150 ) resistor r=0.0717383 //w=0.224 //l=0.115 //layer=m1 \
 //thickness=0.36 //x=78.93 //y=2.375 //x2=78.93 //y2=2.26
r1730 (  65 66 ) resistor r=0.930344 //w=0.131 //l=0.975 //layer=m1 \
 //thickness=0.36 //x=78.93 //y=2.375 //x2=78.93 //y2=3.35
r1731 (  64 145 ) resistor r=0.0760407 //w=0.238 //l=0.125 //layer=m1 \
 //thickness=0.36 //x=66.35 //y=4.755 //x2=66.35 //y2=4.88
r1732 (  63 141 ) resistor r=0.0912814 //w=0.379 //l=0.183303 //layer=m1 \
 //thickness=0.36 //x=66.35 //y=3.675 //x2=66.3 //y2=3.515
r1733 (  63 64 ) resistor r=1.03053 //w=0.131 //l=1.08 //layer=m1 \
 //thickness=0.36 //x=66.35 //y=3.675 //x2=66.35 //y2=4.755
r1734 (  62 139 ) resistor r=0.0896323 //w=0.379 //l=0.178255 //layer=m1 \
 //thickness=0.36 //x=66.35 //y=3.355 //x2=66.3 //y2=3.51
r1735 (  61 143 ) resistor r=0.0719237 //w=0.222 //l=0.115 //layer=m1 \
 //thickness=0.36 //x=66.35 //y=2.375 //x2=66.35 //y2=2.26
r1736 (  61 62 ) resistor r=0.935115 //w=0.131 //l=0.98 //layer=m1 \
 //thickness=0.36 //x=66.35 //y=2.375 //x2=66.35 //y2=3.355
r1737 (  59 137 ) resistor r=0.0911593 //w=0.376 //l=0.184174 //layer=m1 \
 //thickness=0.36 //x=64.5 //y=3.675 //x2=64.552 //y2=3.515
r1738 (  59 60 ) resistor r=1.5458 //w=0.131 //l=1.62 //layer=m1 \
 //thickness=0.36 //x=64.5 //y=3.675 //x2=64.5 //y2=5.295
r1739 (  58 135 ) resistor r=0.0894971 //w=0.376 //l=0.179123 //layer=m1 \
 //thickness=0.36 //x=64.5 //y=3.355 //x2=64.552 //y2=3.51
r1740 (  57 58 ) resistor r=1.36927 //w=0.131 //l=1.435 //layer=m1 \
 //thickness=0.36 //x=64.5 //y=1.92 //x2=64.5 //y2=3.355
r1741 (  55 57 ) resistor r=0.0698411 //w=0.17 //l=0.120208 //layer=m1 \
 //thickness=0.36 //x=64.415 //y=1.835 //x2=64.5 //y2=1.92
r1742 (  55 56 ) resistor r=0.257634 //w=0.131 //l=0.27 //layer=m1 \
 //thickness=0.36 //x=64.415 //y=1.835 //x2=64.145 //y2=1.835
r1743 (  54 127 ) resistor r=0.0257089 //w=0.23 //l=0.115 //layer=m1 \
 //thickness=0.36 //x=64.135 //y=5.38 //x2=64.02 //y2=5.38
r1744 (  53 60 ) resistor r=0.0698411 //w=0.17 //l=0.120208 //layer=m1 \
 //thickness=0.36 //x=64.415 //y=5.38 //x2=64.5 //y2=5.295
r1745 (  53 54 ) resistor r=0.267176 //w=0.131 //l=0.28 //layer=m1 \
 //thickness=0.36 //x=64.415 //y=5.38 //x2=64.135 //y2=5.38
r1746 (  52 56 ) resistor r=0.0698411 //w=0.17 //l=0.120208 //layer=m1 \
 //thickness=0.36 //x=64.06 //y=1.75 //x2=64.145 //y2=1.835
r1747 (  51 132 ) resistor r=0.0913624 //w=0.191 //l=0.12 //layer=m1 \
 //thickness=0.36 //x=64.06 //y=1.3 //x2=64.06 //y2=1.18
r1748 (  51 52 ) resistor r=0.429389 //w=0.131 //l=0.45 //layer=m1 \
 //thickness=0.36 //x=64.06 //y=1.3 //x2=64.06 //y2=1.75
r1749 (  48 124 ) resistor r=0.0227762 //w=0.219 //l=0.115 //layer=m1 \
 //thickness=0.36 //x=63.255 //y=5.38 //x2=63.14 //y2=5.38
r1750 (  47 127 ) resistor r=0.0257089 //w=0.23 //l=0.115 //layer=m1 \
 //thickness=0.36 //x=63.905 //y=5.38 //x2=64.02 //y2=5.38
r1751 (  47 48 ) resistor r=0.620229 //w=0.131 //l=0.65 //layer=m1 \
 //thickness=0.36 //x=63.905 //y=5.38 //x2=63.255 //y2=5.38
r1752 (  43 115 ) resistor r=0.0911593 //w=0.376 //l=0.184608 //layer=m1 \
 //thickness=0.36 //x=63.02 //y=3.67 //x2=62.967 //y2=3.51
r1753 (  43 122 ) resistor r=1.02099 //w=0.131 //l=1.07 //layer=m1 \
 //thickness=0.36 //x=63.02 //y=3.67 //x2=63.02 //y2=4.74
r1754 (  42 115 ) resistor r=0.0911593 //w=0.376 //l=0.184608 //layer=m1 \
 //thickness=0.36 //x=63.02 //y=3.35 //x2=62.967 //y2=3.51
r1755 (  41 118 ) resistor r=0.0933015 //w=0.201 //l=0.125 //layer=m1 \
 //thickness=0.36 //x=63.02 //y=2.385 //x2=63.02 //y2=2.26
r1756 (  41 42 ) resistor r=0.920802 //w=0.131 //l=0.965 //layer=m1 \
 //thickness=0.36 //x=63.02 //y=2.385 //x2=63.02 //y2=3.35
r1757 (  39 112 ) resistor r=0.0910802 //w=0.374 //l=0.185472 //layer=m1 \
 //thickness=0.36 //x=61.17 //y=3.67 //x2=61.225 //y2=3.51
r1758 (  39 40 ) resistor r=1.50763 //w=0.131 //l=1.58 //layer=m1 \
 //thickness=0.36 //x=61.17 //y=3.67 //x2=61.17 //y2=5.25
r1759 (  38 112 ) resistor r=0.0910802 //w=0.374 //l=0.185472 //layer=m1 \
 //thickness=0.36 //x=61.17 //y=3.35 //x2=61.225 //y2=3.51
r1760 (  37 38 ) resistor r=1.35496 //w=0.131 //l=1.42 //layer=m1 \
 //thickness=0.36 //x=61.17 //y=1.93 //x2=61.17 //y2=3.35
r1761 (  35 37 ) resistor r=0.0698411 //w=0.17 //l=0.120208 //layer=m1 \
 //thickness=0.36 //x=61.085 //y=1.845 //x2=61.17 //y2=1.93
r1762 (  35 36 ) resistor r=0.300573 //w=0.131 //l=0.315 //layer=m1 \
 //thickness=0.36 //x=61.085 //y=1.845 //x2=60.77 //y2=1.845
r1763 (  34 36 ) resistor r=0.0698411 //w=0.17 //l=0.120208 //layer=m1 \
 //thickness=0.36 //x=60.685 //y=1.76 //x2=60.77 //y2=1.845
r1764 (  33 110 ) resistor r=0.0717383 //w=0.224 //l=0.115 //layer=m1 \
 //thickness=0.36 //x=60.685 //y=1.305 //x2=60.685 //y2=1.19
r1765 (  33 34 ) resistor r=0.43416 //w=0.131 //l=0.455 //layer=m1 \
 //thickness=0.36 //x=60.685 //y=1.305 //x2=60.685 //y2=1.76
r1766 (  32 106 ) resistor r=0.0675342 //w=0.23 //l=0.115 //layer=m1 \
 //thickness=0.36 //x=60.505 //y=5.335 //x2=60.39 //y2=5.335
r1767 (  31 40 ) resistor r=0.0698411 //w=0.17 //l=0.120208 //layer=m1 \
 //thickness=0.36 //x=61.085 //y=5.335 //x2=61.17 //y2=5.25
r1768 (  31 32 ) resistor r=0.553435 //w=0.131 //l=0.58 //layer=m1 \
 //thickness=0.36 //x=61.085 //y=5.335 //x2=60.505 //y2=5.335
r1769 (  30 108 ) resistor r=0.00118313 //w=0.23 //layer=m1 //thickness=0.36 \
 //x=60.39 //y=5.56 //x2=60.39 //y2=5.56
r1770 (  29 106 ) resistor r=0.002872 //w=0.34 //l=0.085 //layer=m1 \
 //thickness=0.36 //x=60.39 //y=5.42 //x2=60.39 //y2=5.335
r1771 (  29 30 ) resistor r=0.091623 //w=0.191 //l=0.14 //layer=m1 \
 //thickness=0.36 //x=60.39 //y=5.42 //x2=60.39 //y2=5.56
r1772 (  28 103 ) resistor r=0.0262263 //w=0.232 //l=0.12 //layer=m1 \
 //thickness=0.36 //x=59.63 //y=5.335 //x2=59.51 //y2=5.335
r1773 (  27 106 ) resistor r=0.0675342 //w=0.23 //l=0.115 //layer=m1 \
 //thickness=0.36 //x=60.275 //y=5.335 //x2=60.39 //y2=5.335
r1774 (  27 28 ) resistor r=0.615458 //w=0.131 //l=0.645 //layer=m1 \
 //thickness=0.36 //x=60.275 //y=5.335 //x2=59.63 //y2=5.335
r1775 (  26 100 ) resistor r=0.0222262 //w=0.217 //l=0.118 //layer=m1 \
 //thickness=0.36 //x=58.75 //y=5.335 //x2=58.632 //y2=5.335
r1776 (  25 103 ) resistor r=0.0262263 //w=0.232 //l=0.12 //layer=m1 \
 //thickness=0.36 //x=59.39 //y=5.335 //x2=59.51 //y2=5.335
r1777 (  25 26 ) resistor r=0.610687 //w=0.131 //l=0.64 //layer=m1 \
 //thickness=0.36 //x=59.39 //y=5.335 //x2=58.75 //y2=5.335
r1778 (  24 96 ) resistor r=0.0801089 //w=0.224 //l=0.13 //layer=m1 \
 //thickness=0.36 //x=55.62 //y=4.75 //x2=55.62 //y2=4.88
r1779 (  23 98 ) resistor r=0.0911593 //w=0.376 //l=0.184174 //layer=m1 \
 //thickness=0.36 //x=55.62 //y=3.67 //x2=55.672 //y2=3.51
r1780 (  23 24 ) resistor r=1.03053 //w=0.131 //l=1.08 //layer=m1 \
 //thickness=0.36 //x=55.62 //y=3.67 //x2=55.62 //y2=4.75
r1781 (  22 98 ) resistor r=0.0911593 //w=0.376 //l=0.184174 //layer=m1 \
 //thickness=0.36 //x=55.62 //y=3.35 //x2=55.672 //y2=3.51
r1782 (  21 94 ) resistor r=0.0719237 //w=0.222 //l=0.115 //layer=m1 \
 //thickness=0.36 //x=55.62 //y=2.375 //x2=55.62 //y2=2.26
r1783 (  21 22 ) resistor r=0.930344 //w=0.131 //l=0.975 //layer=m1 \
 //thickness=0.36 //x=55.62 //y=2.375 //x2=55.62 //y2=3.35
r1784 (  19 92 ) resistor r=0.0911593 //w=0.376 //l=0.184608 //layer=m1 \
 //thickness=0.36 //x=51.55 //y=3.69 //x2=51.497 //y2=3.53
r1785 (  19 20 ) resistor r=1.53149 //w=0.131 //l=1.605 //layer=m1 \
 //thickness=0.36 //x=51.55 //y=3.69 //x2=51.55 //y2=5.295
r1786 (  18 90 ) resistor r=0.0845104 //w=0.376 //l=0.164378 //layer=m1 \
 //thickness=0.36 //x=51.55 //y=3.37 //x2=51.497 //y2=3.51
r1787 (  17 18 ) resistor r=1.38359 //w=0.131 //l=1.45 //layer=m1 \
 //thickness=0.36 //x=51.55 //y=1.92 //x2=51.55 //y2=3.37
r1788 (  15 17 ) resistor r=0.0698411 //w=0.17 //l=0.120208 //layer=m1 \
 //thickness=0.36 //x=51.465 //y=1.835 //x2=51.55 //y2=1.92
r1789 (  15 16 ) resistor r=0.257634 //w=0.131 //l=0.27 //layer=m1 \
 //thickness=0.36 //x=51.465 //y=1.835 //x2=51.195 //y2=1.835
r1790 (  14 82 ) resistor r=0.0257089 //w=0.23 //l=0.115 //layer=m1 \
 //thickness=0.36 //x=51.185 //y=5.38 //x2=51.07 //y2=5.38
r1791 (  13 20 ) resistor r=0.0698411 //w=0.17 //l=0.120208 //layer=m1 \
 //thickness=0.36 //x=51.465 //y=5.38 //x2=51.55 //y2=5.295
r1792 (  13 14 ) resistor r=0.267176 //w=0.131 //l=0.28 //layer=m1 \
 //thickness=0.36 //x=51.465 //y=5.38 //x2=51.185 //y2=5.38
r1793 (  12 16 ) resistor r=0.0698411 //w=0.17 //l=0.120208 //layer=m1 \
 //thickness=0.36 //x=51.11 //y=1.75 //x2=51.195 //y2=1.835
r1794 (  11 87 ) resistor r=0.0913624 //w=0.191 //l=0.12 //layer=m1 \
 //thickness=0.36 //x=51.11 //y=1.3 //x2=51.11 //y2=1.18
r1795 (  11 12 ) resistor r=0.429389 //w=0.131 //l=0.45 //layer=m1 \
 //thickness=0.36 //x=51.11 //y=1.3 //x2=51.11 //y2=1.75
r1796 (  8 79 ) resistor r=0.0227762 //w=0.219 //l=0.115 //layer=m1 \
 //thickness=0.36 //x=50.305 //y=5.38 //x2=50.19 //y2=5.38
r1797 (  7 82 ) resistor r=0.0257089 //w=0.23 //l=0.115 //layer=m1 \
 //thickness=0.36 //x=50.955 //y=5.38 //x2=51.07 //y2=5.38
r1798 (  7 8 ) resistor r=0.620229 //w=0.131 //l=0.65 //layer=m1 \
 //thickness=0.36 //x=50.955 //y=5.38 //x2=50.305 //y2=5.38
r1799 (  4 74 ) resistor r=0.0801089 //w=0.224 //l=0.13 //layer=m1 \
 //thickness=0.36 //x=47.48 //y=4.75 //x2=47.48 //y2=4.88
r1800 (  3 78 ) resistor r=0.0911593 //w=0.376 //l=0.184174 //layer=m1 \
 //thickness=0.36 //x=47.48 //y=3.685 //x2=47.532 //y2=3.525
r1801 (  3 4 ) resistor r=1.01622 //w=0.131 //l=1.065 //layer=m1 \
 //thickness=0.36 //x=47.48 //y=3.685 //x2=47.48 //y2=4.75
r1802 (  2 76 ) resistor r=0.0861726 //w=0.376 //l=0.169012 //layer=m1 \
 //thickness=0.36 //x=47.48 //y=3.365 //x2=47.532 //y2=3.51
r1803 (  1 72 ) resistor r=0.0719237 //w=0.222 //l=0.115 //layer=m1 \
 //thickness=0.36 //x=47.48 //y=2.375 //x2=47.48 //y2=2.26
r1804 (  1 2 ) resistor r=0.944656 //w=0.131 //l=0.99 //layer=m1 \
 //thickness=0.36 //x=47.48 //y=2.375 //x2=47.48 //y2=3.365
ends PM_TMRDFFRNQNX1\%noxref_15

subckt PM_TMRDFFRNQNX1\%noxref_16 ( 1 2 3 4 7 12 13 15 16 18 19 20 21 22 23 24 \
 25 26 32 37 38 41 43 46 52 65 67 68 69 71 73 75 77 79 81 83 85 87 89 91 93 95 \
 97 99 101 103 105 107 114 122 124 125 128 137 142 150 167 176 181 186 190 191 \
 192 193 194 195 196 197 198 202 203 204 209 211 214 215 219 220 221 222 223 \
 225 228 231 232 233 234 235 236 237 238 242 244 247 248 249 250 255 256 261 \
 273 280 282 283 )
c791 ( 280 0 ) capacitor c=0.00878249f //x=25.02 //y=1.085
c792 ( 273 0 ) capacitor c=0.0586737f //x=85.59 //y=2.26
c793 ( 261 0 ) capacitor c=0.0710579f //x=21.58 //y=4.88
c794 ( 256 0 ) capacitor c=0.0278202f //x=21.58 //y=2.095
c795 ( 255 0 ) capacitor c=0.0468631f //x=21.58 //y=2.26
c796 ( 250 0 ) capacitor c=0.0318956f //x=86.295 //y=1.39
c797 ( 249 0 ) capacitor c=0.0186809f //x=86.295 //y=1.045
c798 ( 248 0 ) capacitor c=0.0659968f //x=85.935 //y=4.975
c799 ( 247 0 ) capacitor c=0.0373387f //x=86.225 //y=4.975
c800 ( 244 0 ) capacitor c=0.0157936f //x=86.14 //y=1.545
c801 ( 242 0 ) capacitor c=0.0158553f //x=86.14 //y=0.89
c802 ( 238 0 ) capacitor c=0.0302441f //x=85.765 //y=2.095
c803 ( 237 0 ) capacitor c=0.0238107f //x=85.765 //y=1.7
c804 ( 236 0 ) capacitor c=0.0234359f //x=85.765 //y=1.39
c805 ( 235 0 ) capacitor c=0.0199332f //x=85.765 //y=1.045
c806 ( 234 0 ) capacitor c=0.0927638f //x=83.935 //y=2.095
c807 ( 233 0 ) capacitor c=0.0251353f //x=83.935 //y=1.74
c808 ( 232 0 ) capacitor c=0.0234318f //x=83.935 //y=1.43
c809 ( 231 0 ) capacitor c=0.0192547f //x=83.935 //y=1.085
c810 ( 228 0 ) capacitor c=0.0714656f //x=83.84 //y=5.05
c811 ( 225 0 ) capacitor c=0.0186579f //x=83.78 //y=1.585
c812 ( 223 0 ) capacitor c=0.0157803f //x=83.78 //y=0.93
c813 ( 222 0 ) capacitor c=0.0134011f //x=83.475 //y=4.975
c814 ( 221 0 ) capacitor c=0.0243282f //x=83.765 //y=4.975
c815 ( 220 0 ) capacitor c=0.0364928f //x=83.405 //y=1.43
c816 ( 219 0 ) capacitor c=0.0174823f //x=83.405 //y=1.085
c817 ( 215 0 ) capacitor c=0.0443175f //x=22.1 //y=1.44
c818 ( 214 0 ) capacitor c=0.0199703f //x=22.1 //y=1.095
c819 ( 211 0 ) capacitor c=0.0162526f //x=21.945 //y=1.595
c820 ( 209 0 ) capacitor c=0.0157807f //x=21.945 //y=0.94
c821 ( 204 0 ) capacitor c=0.0220935f //x=21.57 //y=1.75
c822 ( 203 0 ) capacitor c=0.0207489f //x=21.57 //y=1.44
c823 ( 202 0 ) capacitor c=0.0194091f //x=21.57 //y=1.095
c824 ( 198 0 ) capacitor c=0.11081f //x=86.3 //y=6.205
c825 ( 197 0 ) capacitor c=0.154997f //x=85.86 //y=6.205
c826 ( 196 0 ) capacitor c=0.155934f //x=83.84 //y=6.205
c827 ( 195 0 ) capacitor c=0.110594f //x=83.4 //y=6.205
c828 ( 194 0 ) capacitor c=0.159671f //x=21.76 //y=6.2
c829 ( 193 0 ) capacitor c=0.110208f //x=21.32 //y=6.2
c830 ( 186 0 ) capacitor c=7.7962e-19 //x=85.59 //y=4.885
c831 ( 181 0 ) capacitor c=7.89145e-19 //x=85.59 //y=2.26
c832 ( 176 0 ) capacitor c=7.79163e-19 //x=84.11 //y=4.885
c833 ( 167 0 ) capacitor c=4.74639e-19 //x=84.11 //y=2.26
c834 ( 150 0 ) capacitor c=0.0322017f //x=25.17 //y=5.56
c835 ( 142 0 ) capacitor c=0.0290435f //x=24.29 //y=5.56
c836 ( 137 0 ) capacitor c=7.7417e-19 //x=21.58 //y=4.88
c837 ( 128 0 ) capacitor c=7.43216e-19 //x=21.58 //y=2.26
c838 ( 125 0 ) capacitor c=0.0208859f //x=85.425 //y=2.27
c839 ( 124 0 ) capacitor c=0.00241177f //x=85.585 //y=2.27
c840 ( 122 0 ) capacitor c=0.00129603f //x=84.275 //y=2.27
c841 ( 114 0 ) capacitor c=5.98389e-19 //x=21.735 //y=3.155
c842 ( 107 0 ) capacitor c=0.11655f //x=79.135 //y=3.125
c843 ( 105 0 ) capacitor c=0.232392f //x=78.535 //y=3.14
c844 ( 103 0 ) capacitor c=0.00602915f //x=66.57 //y=3.13
c845 ( 101 0 ) capacitor c=0.0185118f //x=65.97 //y=3.14
c846 ( 99 0 ) capacitor c=0.0075058f //x=64.715 //y=3.13
c847 ( 97 0 ) capacitor c=0.00690874f //x=64.115 //y=3.14
c848 ( 95 0 ) capacitor c=0.0056712f //x=63.235 //y=3.125
c849 ( 93 0 ) capacitor c=0.0185731f //x=62.635 //y=3.14
c850 ( 91 0 ) capacitor c=0.00790392f //x=61.39 //y=3.125
c851 ( 89 0 ) capacitor c=0.0512159f //x=60.79 //y=3.14
c852 ( 87 0 ) capacitor c=0.00454802f //x=55.835 //y=3.125
c853 ( 85 0 ) capacitor c=0.160454f //x=55.235 //y=3.14
c854 ( 83 0 ) capacitor c=0.00594697f //x=40.67 //y=3.13
c855 ( 81 0 ) capacitor c=0.0157576f //x=40.07 //y=3.14
c856 ( 79 0 ) capacitor c=0.00596875f //x=38.81 //y=3.13
c857 ( 77 0 ) capacitor c=0.00681881f //x=38.21 //y=3.14
c858 ( 75 0 ) capacitor c=0.00534409f //x=37.335 //y=3.125
c859 ( 73 0 ) capacitor c=0.0155657f //x=36.735 //y=3.14
c860 ( 71 0 ) capacitor c=0.00616696f //x=35.49 //y=3.125
c861 ( 69 0 ) capacitor c=0.0477183f //x=34.89 //y=3.14
c862 ( 68 0 ) capacitor c=0.0611852f //x=29.505 //y=3.125
c863 ( 67 0 ) capacitor c=0.00475936f //x=29.935 //y=3.125
c864 ( 65 0 ) capacitor c=0.0502842f //x=25.49 //y=3.14
c865 ( 52 0 ) capacitor c=0.0150405f //x=84.11 //y=3.14
c866 ( 46 0 ) capacitor c=0.0158166f //x=25.65 //y=3.14
c867 ( 43 0 ) capacitor c=0.0112415f //x=25.21 //y=1.18
c868 ( 41 0 ) capacitor c=5.78613e-19 //x=25.17 //y=5.56
c869 ( 38 0 ) capacitor c=0.0108004f //x=25.17 //y=5.38
c870 ( 37 0 ) capacitor c=0.00887516f //x=24.29 //y=5.56
c871 ( 32 0 ) capacitor c=0.0145644f //x=21.58 //y=3.14
c872 ( 26 0 ) capacitor c=0.0768184f //x=85.59 //y=4.755
c873 ( 25 0 ) capacitor c=0.00995077f //x=85.59 //y=2.43
c874 ( 24 0 ) capacitor c=0.0565097f //x=84.11 //y=4.76
c875 ( 23 0 ) capacitor c=0.0138675f //x=84.11 //y=3.29
c876 ( 22 0 ) capacitor c=0.0152353f //x=84.11 //y=2.97
c877 ( 21 0 ) capacitor c=0.0100739f //x=84.11 //y=2.43
c878 ( 20 0 ) capacitor c=0.0571725f //x=25.65 //y=5.295
c879 ( 19 0 ) capacitor c=0.0138106f //x=25.65 //y=3.315
c880 ( 18 0 ) capacitor c=0.0273346f //x=25.65 //y=2.995
c881 ( 16 0 ) capacitor c=0.00466468f //x=25.295 //y=1.835
c882 ( 15 0 ) capacitor c=0.0118312f //x=25.565 //y=1.835
c883 ( 13 0 ) capacitor c=0.0114168f //x=25.565 //y=5.38
c884 ( 12 0 ) capacitor c=0.0134844f //x=25.21 //y=1.75
c885 ( 7 0 ) capacitor c=0.0134407f //x=25.055 //y=5.38
c886 ( 4 0 ) capacitor c=0.0415401f //x=21.58 //y=4.75
c887 ( 3 0 ) capacitor c=0.0127772f //x=21.58 //y=3.315
c888 ( 2 0 ) capacitor c=0.0129767f //x=21.58 //y=2.995
c889 ( 1 0 ) capacitor c=0.00550278f //x=21.58 //y=2.375
r890 (  255 256 ) resistor r=52.7279 //w=0.214 //l=0.165 //layer=ply \
 //thickness=0.18 //x=21.58 //y=2.26 //x2=21.58 //y2=2.095
r891 (  250 279 ) resistor r=45.1352 //w=0.168 //l=0.173853 //layer=ply \
 //thickness=0.18 //x=86.295 //y=1.39 //x2=86.255 //y2=1.545
r892 (  249 278 ) resistor r=45.1352 //w=0.168 //l=0.173853 //layer=ply \
 //thickness=0.18 //x=86.295 //y=1.045 //x2=86.255 //y2=0.89
r893 (  249 250 ) resistor r=176.904 //w=0.094 //l=0.345 //layer=ply \
 //thickness=0.18 //x=86.295 //y=1.045 //x2=86.295 //y2=1.39
r894 (  247 251 ) resistor r=26.9307 //w=0.15 //l=0.106066 //layer=ply \
 //thickness=0.18 //x=86.225 //y=4.975 //x2=86.3 //y2=5.05
r895 (  247 248 ) resistor r=148.702 //w=0.094 //l=0.29 //layer=ply \
 //thickness=0.18 //x=86.225 //y=4.975 //x2=85.935 //y2=4.975
r896 (  245 277 ) resistor r=10.701 //w=0.21 //l=0.115 //layer=ply \
 //thickness=0.18 //x=85.92 //y=1.545 //x2=85.805 //y2=1.545
r897 (  244 279 ) resistor r=5.52526 //w=0.168 //l=0.115 //layer=ply \
 //thickness=0.18 //x=86.14 //y=1.545 //x2=86.255 //y2=1.545
r898 (  243 276 ) resistor r=5.52526 //w=0.168 //l=0.115 //layer=ply \
 //thickness=0.18 //x=85.92 //y=0.89 //x2=85.805 //y2=0.89
r899 (  242 278 ) resistor r=5.52526 //w=0.168 //l=0.115 //layer=ply \
 //thickness=0.18 //x=86.14 //y=0.89 //x2=86.255 //y2=0.89
r900 (  242 243 ) resistor r=112.809 //w=0.094 //l=0.22 //layer=ply \
 //thickness=0.18 //x=86.14 //y=0.89 //x2=85.92 //y2=0.89
r901 (  239 248 ) resistor r=22.1787 //w=0.252 //l=0.106066 //layer=ply \
 //thickness=0.18 //x=85.86 //y=5.05 //x2=85.935 //y2=4.975
r902 (  239 275 ) resistor r=51.6429 //w=0.252 //l=0.34271 //layer=ply \
 //thickness=0.18 //x=85.86 //y=5.05 //x2=85.59 //y2=4.885
r903 (  238 273 ) resistor r=30.4513 //w=0.277 //l=0.243926 //layer=ply \
 //thickness=0.18 //x=85.765 //y=2.095 //x2=85.59 //y2=2.26
r904 (  237 277 ) resistor r=39.5823 //w=0.21 //l=0.173853 //layer=ply \
 //thickness=0.18 //x=85.765 //y=1.7 //x2=85.805 //y2=1.545
r905 (  237 238 ) resistor r=202.543 //w=0.094 //l=0.395 //layer=ply \
 //thickness=0.18 //x=85.765 //y=1.7 //x2=85.765 //y2=2.095
r906 (  236 277 ) resistor r=39.5823 //w=0.21 //l=0.173853 //layer=ply \
 //thickness=0.18 //x=85.765 //y=1.39 //x2=85.805 //y2=1.545
r907 (  235 276 ) resistor r=45.1352 //w=0.168 //l=0.173853 //layer=ply \
 //thickness=0.18 //x=85.765 //y=1.045 //x2=85.805 //y2=0.89
r908 (  235 236 ) resistor r=176.904 //w=0.094 //l=0.345 //layer=ply \
 //thickness=0.18 //x=85.765 //y=1.045 //x2=85.765 //y2=1.39
r909 (  234 269 ) resistor r=30.4513 //w=0.277 //l=0.243926 //layer=ply \
 //thickness=0.18 //x=83.935 //y=2.095 //x2=84.11 //y2=2.26
r910 (  233 267 ) resistor r=39.5823 //w=0.21 //l=0.173853 //layer=ply \
 //thickness=0.18 //x=83.935 //y=1.74 //x2=83.895 //y2=1.585
r911 (  233 234 ) resistor r=182.032 //w=0.094 //l=0.355 //layer=ply \
 //thickness=0.18 //x=83.935 //y=1.74 //x2=83.935 //y2=2.095
r912 (  232 267 ) resistor r=39.5823 //w=0.21 //l=0.173853 //layer=ply \
 //thickness=0.18 //x=83.935 //y=1.43 //x2=83.895 //y2=1.585
r913 (  231 266 ) resistor r=45.1352 //w=0.168 //l=0.173853 //layer=ply \
 //thickness=0.18 //x=83.935 //y=1.085 //x2=83.895 //y2=0.93
r914 (  231 232 ) resistor r=176.904 //w=0.094 //l=0.345 //layer=ply \
 //thickness=0.18 //x=83.935 //y=1.085 //x2=83.935 //y2=1.43
r915 (  228 271 ) resistor r=51.6429 //w=0.252 //l=0.34271 //layer=ply \
 //thickness=0.18 //x=83.84 //y=5.05 //x2=84.11 //y2=4.885
r916 (  226 265 ) resistor r=5.52526 //w=0.168 //l=0.115 //layer=ply \
 //thickness=0.18 //x=83.56 //y=1.585 //x2=83.445 //y2=1.585
r917 (  225 267 ) resistor r=10.701 //w=0.21 //l=0.115 //layer=ply \
 //thickness=0.18 //x=83.78 //y=1.585 //x2=83.895 //y2=1.585
r918 (  224 264 ) resistor r=5.52526 //w=0.168 //l=0.115 //layer=ply \
 //thickness=0.18 //x=83.56 //y=0.93 //x2=83.445 //y2=0.93
r919 (  223 266 ) resistor r=5.52526 //w=0.168 //l=0.115 //layer=ply \
 //thickness=0.18 //x=83.78 //y=0.93 //x2=83.895 //y2=0.93
r920 (  223 224 ) resistor r=112.809 //w=0.094 //l=0.22 //layer=ply \
 //thickness=0.18 //x=83.78 //y=0.93 //x2=83.56 //y2=0.93
r921 (  221 228 ) resistor r=22.1787 //w=0.252 //l=0.106066 //layer=ply \
 //thickness=0.18 //x=83.765 //y=4.975 //x2=83.84 //y2=5.05
r922 (  221 222 ) resistor r=148.702 //w=0.094 //l=0.29 //layer=ply \
 //thickness=0.18 //x=83.765 //y=4.975 //x2=83.475 //y2=4.975
r923 (  220 265 ) resistor r=45.1352 //w=0.168 //l=0.173853 //layer=ply \
 //thickness=0.18 //x=83.405 //y=1.43 //x2=83.445 //y2=1.585
r924 (  219 264 ) resistor r=45.1352 //w=0.168 //l=0.173853 //layer=ply \
 //thickness=0.18 //x=83.405 //y=1.085 //x2=83.445 //y2=0.93
r925 (  219 220 ) resistor r=176.904 //w=0.094 //l=0.345 //layer=ply \
 //thickness=0.18 //x=83.405 //y=1.085 //x2=83.405 //y2=1.43
r926 (  216 222 ) resistor r=26.9307 //w=0.15 //l=0.106066 //layer=ply \
 //thickness=0.18 //x=83.4 //y=5.05 //x2=83.475 //y2=4.975
r927 (  215 263 ) resistor r=45.1352 //w=0.168 //l=0.173853 //layer=ply \
 //thickness=0.18 //x=22.1 //y=1.44 //x2=22.06 //y2=1.595
r928 (  214 262 ) resistor r=45.1352 //w=0.168 //l=0.173853 //layer=ply \
 //thickness=0.18 //x=22.1 //y=1.095 //x2=22.06 //y2=0.94
r929 (  214 215 ) resistor r=176.904 //w=0.094 //l=0.345 //layer=ply \
 //thickness=0.18 //x=22.1 //y=1.095 //x2=22.1 //y2=1.44
r930 (  212 259 ) resistor r=10.701 //w=0.21 //l=0.115 //layer=ply \
 //thickness=0.18 //x=21.725 //y=1.595 //x2=21.61 //y2=1.595
r931 (  211 263 ) resistor r=5.52526 //w=0.168 //l=0.115 //layer=ply \
 //thickness=0.18 //x=21.945 //y=1.595 //x2=22.06 //y2=1.595
r932 (  210 258 ) resistor r=5.52526 //w=0.168 //l=0.115 //layer=ply \
 //thickness=0.18 //x=21.725 //y=0.94 //x2=21.61 //y2=0.94
r933 (  209 262 ) resistor r=5.52526 //w=0.168 //l=0.115 //layer=ply \
 //thickness=0.18 //x=21.945 //y=0.94 //x2=22.06 //y2=0.94
r934 (  209 210 ) resistor r=112.809 //w=0.094 //l=0.22 //layer=ply \
 //thickness=0.18 //x=21.945 //y=0.94 //x2=21.725 //y2=0.94
r935 (  206 261 ) resistor r=37.236 //w=0.233 //l=0.249199 //layer=ply \
 //thickness=0.18 //x=21.76 //y=5.045 //x2=21.58 //y2=4.88
r936 (  204 259 ) resistor r=39.5823 //w=0.21 //l=0.173853 //layer=ply \
 //thickness=0.18 //x=21.57 //y=1.75 //x2=21.61 //y2=1.595
r937 (  204 256 ) resistor r=176.904 //w=0.094 //l=0.345 //layer=ply \
 //thickness=0.18 //x=21.57 //y=1.75 //x2=21.57 //y2=2.095
r938 (  203 259 ) resistor r=39.5823 //w=0.21 //l=0.173853 //layer=ply \
 //thickness=0.18 //x=21.57 //y=1.44 //x2=21.61 //y2=1.595
r939 (  202 258 ) resistor r=45.1352 //w=0.168 //l=0.173853 //layer=ply \
 //thickness=0.18 //x=21.57 //y=1.095 //x2=21.61 //y2=0.94
r940 (  202 203 ) resistor r=176.904 //w=0.094 //l=0.345 //layer=ply \
 //thickness=0.18 //x=21.57 //y=1.095 //x2=21.57 //y2=1.44
r941 (  199 261 ) resistor r=53.7854 //w=0.233 //l=0.332415 //layer=ply \
 //thickness=0.18 //x=21.32 //y=5.045 //x2=21.58 //y2=4.88
r942 (  198 251 ) resistor r=592.245 //w=0.094 //l=1.155 //layer=ply \
 //thickness=0.18 //x=86.3 //y=6.205 //x2=86.3 //y2=5.05
r943 (  197 239 ) resistor r=592.245 //w=0.094 //l=1.155 //layer=ply \
 //thickness=0.18 //x=85.86 //y=6.205 //x2=85.86 //y2=5.05
r944 (  196 228 ) resistor r=592.245 //w=0.094 //l=1.155 //layer=ply \
 //thickness=0.18 //x=83.84 //y=6.205 //x2=83.84 //y2=5.05
r945 (  195 216 ) resistor r=592.245 //w=0.094 //l=1.155 //layer=ply \
 //thickness=0.18 //x=83.4 //y=6.205 //x2=83.4 //y2=5.05
r946 (  194 206 ) resistor r=592.245 //w=0.094 //l=1.155 //layer=ply \
 //thickness=0.18 //x=21.76 //y=6.2 //x2=21.76 //y2=5.045
r947 (  193 199 ) resistor r=592.245 //w=0.094 //l=1.155 //layer=ply \
 //thickness=0.18 //x=21.32 //y=6.2 //x2=21.32 //y2=5.045
r948 (  192 244 ) resistor r=56.4043 //w=0.094 //l=0.11 //layer=ply \
 //thickness=0.18 //x=86.03 //y=1.545 //x2=86.14 //y2=1.545
r949 (  192 245 ) resistor r=56.4043 //w=0.094 //l=0.11 //layer=ply \
 //thickness=0.18 //x=86.03 //y=1.545 //x2=85.92 //y2=1.545
r950 (  191 225 ) resistor r=56.4043 //w=0.094 //l=0.11 //layer=ply \
 //thickness=0.18 //x=83.67 //y=1.585 //x2=83.78 //y2=1.585
r951 (  191 226 ) resistor r=56.4043 //w=0.094 //l=0.11 //layer=ply \
 //thickness=0.18 //x=83.67 //y=1.585 //x2=83.56 //y2=1.585
r952 (  190 211 ) resistor r=56.4043 //w=0.094 //l=0.11 //layer=ply \
 //thickness=0.18 //x=21.835 //y=1.595 //x2=21.945 //y2=1.595
r953 (  190 212 ) resistor r=56.4043 //w=0.094 //l=0.11 //layer=ply \
 //thickness=0.18 //x=21.835 //y=1.595 //x2=21.725 //y2=1.595
r954 (  186 275 ) resistor r=152 //w=0.17 //l=0.17 //layer=licon //count=1 \
 //x=85.59 //y=4.885 //x2=85.59 //y2=4.885
r955 (  181 273 ) resistor r=152 //w=0.17 //l=0.17 //layer=licon //count=1 \
 //x=85.59 //y=2.26 //x2=85.59 //y2=2.26
r956 (  176 271 ) resistor r=152 //w=0.17 //l=0.17 //layer=licon //count=1 \
 //x=84.11 //y=4.885 //x2=84.11 //y2=4.885
r957 (  167 269 ) resistor r=152 //w=0.17 //l=0.17 //layer=licon //count=1 \
 //x=84.11 //y=2.26 //x2=84.11 //y2=2.26
r958 (  150 283 ) resistor r=23.615 //w=0.187 //l=0.345 //layer=li \
 //thickness=0.1 //x=25.17 //y=5.56 //x2=25.17 //y2=5.905
r959 (  142 282 ) resistor r=23.615 //w=0.187 //l=0.345 //layer=li \
 //thickness=0.1 //x=24.29 //y=5.56 //x2=24.29 //y2=5.905
r960 (  137 261 ) resistor r=152 //w=0.17 //l=0.17 //layer=licon //count=1 \
 //x=21.58 //y=4.88 //x2=21.58 //y2=4.88
r961 (  128 255 ) resistor r=152 //w=0.17 //l=0.17 //layer=licon //count=1 \
 //x=21.58 //y=2.26 //x2=21.58 //y2=2.26
r962 (  124 125 ) resistor r=0.10734 //w=0.281 //l=0.16 //layer=m2 \
 //thickness=0.36 //x=85.585 //y=2.27 //x2=85.425 //y2=2.27
r963 (  122 125 ) resistor r=1.09733 //w=0.131 //l=1.15 //layer=m2 \
 //thickness=0.36 //x=84.275 //y=2.26 //x2=85.425 //y2=2.26
r964 (  120 122 ) resistor r=0.10734 //w=0.281 //l=0.16 //layer=m2 \
 //thickness=0.36 //x=84.115 //y=2.27 //x2=84.275 //y2=2.27
r965 (  112 114 ) resistor r=0.10734 //w=0.281 //l=0.16 //layer=m2 \
 //thickness=0.36 //x=21.575 //y=3.155 //x2=21.735 //y2=3.155
r966 (  107 118 ) resistor r=3.45192 //w=0.18 //l=4.9725 //layer=m2 \
 //thickness=0.36 //x=79.135 //y=3.125 //x2=84.105 //y2=3.13
r967 (  107 108 ) resistor r=0.410305 //w=0.131 //l=0.43 //layer=m2 \
 //thickness=0.36 //x=79.135 //y=3.125 //x2=78.705 //y2=3.125
r968 (  105 108 ) resistor r=0.125 //w=0.17 //l=0.177341 //layer=m2 \
 //thickness=0.36 //x=78.535 //y=3.14 //x2=78.705 //y2=3.125
r969 (  105 106 ) resistor r=11.1737 //w=0.131 //l=11.71 //layer=m2 \
 //thickness=0.36 //x=78.535 //y=3.14 //x2=66.825 //y2=3.14
r970 (  103 106 ) resistor r=0.1875 //w=0.17 //l=0.259952 //layer=m2 \
 //thickness=0.36 //x=66.57 //y=3.13 //x2=66.825 //y2=3.14
r971 (  103 104 ) resistor r=0.410305 //w=0.131 //l=0.43 //layer=m2 \
 //thickness=0.36 //x=66.57 //y=3.13 //x2=66.14 //y2=3.13
r972 (  101 104 ) resistor r=0.125 //w=0.17 //l=0.174929 //layer=m2 \
 //thickness=0.36 //x=65.97 //y=3.14 //x2=66.14 //y2=3.13
r973 (  101 102 ) resistor r=0.954198 //w=0.131 //l=1 //layer=m2 \
 //thickness=0.36 //x=65.97 //y=3.14 //x2=64.97 //y2=3.14
r974 (  99 102 ) resistor r=0.1875 //w=0.17 //l=0.259952 //layer=m2 \
 //thickness=0.36 //x=64.715 //y=3.13 //x2=64.97 //y2=3.14
r975 (  99 100 ) resistor r=0.410305 //w=0.131 //l=0.43 //layer=m2 \
 //thickness=0.36 //x=64.715 //y=3.13 //x2=64.285 //y2=3.13
r976 (  97 100 ) resistor r=0.125 //w=0.17 //l=0.174929 //layer=m2 \
 //thickness=0.36 //x=64.115 //y=3.14 //x2=64.285 //y2=3.13
r977 (  97 98 ) resistor r=0.596374 //w=0.131 //l=0.625 //layer=m2 \
 //thickness=0.36 //x=64.115 //y=3.14 //x2=63.49 //y2=3.14
r978 (  95 98 ) resistor r=0.1875 //w=0.17 //l=0.262393 //layer=m2 \
 //thickness=0.36 //x=63.235 //y=3.125 //x2=63.49 //y2=3.14
r979 (  95 96 ) resistor r=0.410305 //w=0.131 //l=0.43 //layer=m2 \
 //thickness=0.36 //x=63.235 //y=3.125 //x2=62.805 //y2=3.125
r980 (  93 96 ) resistor r=0.125 //w=0.17 //l=0.177341 //layer=m2 \
 //thickness=0.36 //x=62.635 //y=3.14 //x2=62.805 //y2=3.125
r981 (  93 94 ) resistor r=0.944656 //w=0.131 //l=0.99 //layer=m2 \
 //thickness=0.36 //x=62.635 //y=3.14 //x2=61.645 //y2=3.14
r982 (  91 94 ) resistor r=0.1875 //w=0.17 //l=0.262393 //layer=m2 \
 //thickness=0.36 //x=61.39 //y=3.125 //x2=61.645 //y2=3.14
r983 (  91 92 ) resistor r=0.410305 //w=0.131 //l=0.43 //layer=m2 \
 //thickness=0.36 //x=61.39 //y=3.125 //x2=60.96 //y2=3.125
r984 (  89 92 ) resistor r=0.125 //w=0.17 //l=0.177341 //layer=m2 \
 //thickness=0.36 //x=60.79 //y=3.14 //x2=60.96 //y2=3.125
r985 (  89 90 ) resistor r=4.48473 //w=0.131 //l=4.7 //layer=m2 \
 //thickness=0.36 //x=60.79 //y=3.14 //x2=56.09 //y2=3.14
r986 (  87 90 ) resistor r=0.1875 //w=0.17 //l=0.262393 //layer=m2 \
 //thickness=0.36 //x=55.835 //y=3.125 //x2=56.09 //y2=3.14
r987 (  87 88 ) resistor r=0.410305 //w=0.131 //l=0.43 //layer=m2 \
 //thickness=0.36 //x=55.835 //y=3.125 //x2=55.405 //y2=3.125
r988 (  85 88 ) resistor r=0.125 //w=0.17 //l=0.177341 //layer=m2 \
 //thickness=0.36 //x=55.235 //y=3.14 //x2=55.405 //y2=3.125
r989 (  85 86 ) resistor r=13.6546 //w=0.131 //l=14.31 //layer=m2 \
 //thickness=0.36 //x=55.235 //y=3.14 //x2=40.925 //y2=3.14
r990 (  83 86 ) resistor r=0.1875 //w=0.17 //l=0.259952 //layer=m2 \
 //thickness=0.36 //x=40.67 //y=3.13 //x2=40.925 //y2=3.14
r991 (  83 84 ) resistor r=0.410305 //w=0.131 //l=0.43 //layer=m2 \
 //thickness=0.36 //x=40.67 //y=3.13 //x2=40.24 //y2=3.13
r992 (  81 84 ) resistor r=0.125 //w=0.17 //l=0.174929 //layer=m2 \
 //thickness=0.36 //x=40.07 //y=3.14 //x2=40.24 //y2=3.13
r993 (  81 82 ) resistor r=0.958969 //w=0.131 //l=1.005 //layer=m2 \
 //thickness=0.36 //x=40.07 //y=3.14 //x2=39.065 //y2=3.14
r994 (  79 82 ) resistor r=0.1875 //w=0.17 //l=0.259952 //layer=m2 \
 //thickness=0.36 //x=38.81 //y=3.13 //x2=39.065 //y2=3.14
r995 (  79 80 ) resistor r=0.410305 //w=0.131 //l=0.43 //layer=m2 \
 //thickness=0.36 //x=38.81 //y=3.13 //x2=38.38 //y2=3.13
r996 (  77 80 ) resistor r=0.125 //w=0.17 //l=0.174929 //layer=m2 \
 //thickness=0.36 //x=38.21 //y=3.14 //x2=38.38 //y2=3.13
r997 (  77 78 ) resistor r=0.591603 //w=0.131 //l=0.62 //layer=m2 \
 //thickness=0.36 //x=38.21 //y=3.14 //x2=37.59 //y2=3.14
r998 (  75 78 ) resistor r=0.1875 //w=0.17 //l=0.262393 //layer=m2 \
 //thickness=0.36 //x=37.335 //y=3.125 //x2=37.59 //y2=3.14
r999 (  75 76 ) resistor r=0.410305 //w=0.131 //l=0.43 //layer=m2 \
 //thickness=0.36 //x=37.335 //y=3.125 //x2=36.905 //y2=3.125
r1000 (  73 76 ) resistor r=0.125 //w=0.17 //l=0.177341 //layer=m2 \
 //thickness=0.36 //x=36.735 //y=3.14 //x2=36.905 //y2=3.125
r1001 (  73 74 ) resistor r=0.944656 //w=0.131 //l=0.99 //layer=m2 \
 //thickness=0.36 //x=36.735 //y=3.14 //x2=35.745 //y2=3.14
r1002 (  71 74 ) resistor r=0.1875 //w=0.17 //l=0.262393 //layer=m2 \
 //thickness=0.36 //x=35.49 //y=3.125 //x2=35.745 //y2=3.14
r1003 (  71 72 ) resistor r=0.410305 //w=0.131 //l=0.43 //layer=m2 \
 //thickness=0.36 //x=35.49 //y=3.125 //x2=35.06 //y2=3.125
r1004 (  69 72 ) resistor r=0.125 //w=0.17 //l=0.177341 //layer=m2 \
 //thickness=0.36 //x=34.89 //y=3.14 //x2=35.06 //y2=3.125
r1005 (  69 70 ) resistor r=4.48473 //w=0.131 //l=4.7 //layer=m2 \
 //thickness=0.36 //x=34.89 //y=3.14 //x2=30.19 //y2=3.14
r1006 (  68 116 ) resistor r=2.64838 //w=0.182 //l=3.86997 //layer=m2 \
 //thickness=0.36 //x=29.505 //y=3.125 //x2=25.65 //y2=3.155
r1007 (  67 70 ) resistor r=0.1875 //w=0.17 //l=0.262393 //layer=m2 \
 //thickness=0.36 //x=29.935 //y=3.125 //x2=30.19 //y2=3.14
r1008 (  67 68 ) resistor r=0.410305 //w=0.131 //l=0.43 //layer=m2 \
 //thickness=0.36 //x=29.935 //y=3.125 //x2=29.505 //y2=3.125
r1009 (  65 116 ) resistor r=0.110608 //w=0.182 //l=0.167332 //layer=m2 \
 //thickness=0.36 //x=25.49 //y=3.14 //x2=25.65 //y2=3.155
r1010 (  65 114 ) resistor r=3.58302 //w=0.131 //l=3.755 //layer=m2 \
 //thickness=0.36 //x=25.49 //y=3.14 //x2=21.735 //y2=3.14
r1011 (  64 186 ) resistor r=9.3 //w=0.17 //l=0.17 //layer=mcon //count=1 \
 //x=85.59 //y=4.885 //x2=85.59 //y2=4.885
r1012 (  62 124 ) resistor r=4.5 //w=0.15 //l=0.15 //layer=via1 //count=1 \
 //x=85.585 //y=2.27 //x2=85.585 //y2=2.27
r1013 (  60 181 ) resistor r=9.3 //w=0.17 //l=0.17 //layer=mcon //count=1 \
 //x=85.59 //y=2.26 //x2=85.59 //y2=2.26
r1014 (  60 62 ) resistor r=0.00334225 //w=0.374 //l=0.01 //layer=m1 \
 //thickness=0.36 //x=85.535 //y=2.26 //x2=85.535 //y2=2.27
r1015 (  58 120 ) resistor r=4.5 //w=0.15 //l=0.15 //layer=via1 //count=1 \
 //x=84.115 //y=2.27 //x2=84.115 //y2=2.27
r1016 (  56 167 ) resistor r=9.3 //w=0.17 //l=0.17 //layer=mcon //count=1 \
 //x=84.11 //y=2.26 //x2=84.11 //y2=2.26
r1017 (  56 58 ) resistor r=0.00334225 //w=0.374 //l=0.01 //layer=m1 \
 //thickness=0.36 //x=84.165 //y=2.26 //x2=84.165 //y2=2.27
r1018 (  54 176 ) resistor r=9.3 //w=0.17 //l=0.17 //layer=mcon //count=1 \
 //x=84.11 //y=4.885 //x2=84.11 //y2=4.885
r1019 (  50 118 ) resistor r=4.5 //w=0.15 //l=0.15 //layer=via1 //count=1 \
 //x=84.105 //y=3.13 //x2=84.105 //y2=3.13
r1020 (  50 52 ) resistor r=0.00334225 //w=0.374 //l=0.01 //layer=m1 \
 //thickness=0.36 //x=84.055 //y=3.13 //x2=84.055 //y2=3.14
r1021 (  48 116 ) resistor r=4.5 //w=0.15 //l=0.15 //layer=via1 //count=1 \
 //x=25.65 //y=3.155 //x2=25.65 //y2=3.155
r1022 (  46 48 ) resistor r=0.0049867 //w=0.376 //l=0.015 //layer=m1 \
 //thickness=0.36 //x=25.597 //y=3.14 //x2=25.597 //y2=3.155
r1023 (  43 280 ) resistor r=9.3 //w=0.17 //l=0.17 //layer=mcon //count=1 \
 //x=25.21 //y=1.18 //x2=25.21 //y2=1.18
r1024 (  41 150 ) resistor r=9.3 //w=0.17 //l=0.17 //layer=mcon //count=1 \
 //x=25.17 //y=5.56 //x2=25.17 //y2=5.56
r1025 (  38 41 ) resistor r=0.117801 //w=0.191 //l=0.18 //layer=m1 \
 //thickness=0.36 //x=25.17 //y=5.38 //x2=25.17 //y2=5.56
r1026 (  37 142 ) resistor r=9.3 //w=0.17 //l=0.17 //layer=mcon //count=1 \
 //x=24.29 //y=5.56 //x2=24.29 //y2=5.56
r1027 (  35 37 ) resistor r=0.10274 //w=0.219 //l=0.18 //layer=m1 \
 //thickness=0.36 //x=24.29 //y=5.38 //x2=24.29 //y2=5.56
r1028 (  34 112 ) resistor r=4.5 //w=0.15 //l=0.15 //layer=via1 //count=1 \
 //x=21.575 //y=3.155 //x2=21.575 //y2=3.155
r1029 (  32 34 ) resistor r=0.00494723 //w=0.379 //l=0.015 //layer=m1 \
 //thickness=0.36 //x=21.63 //y=3.14 //x2=21.63 //y2=3.155
r1030 (  30 137 ) resistor r=9.3 //w=0.17 //l=0.17 //layer=mcon //count=1 \
 //x=21.58 //y=4.88 //x2=21.58 //y2=4.88
r1031 (  28 128 ) resistor r=9.3 //w=0.17 //l=0.17 //layer=mcon //count=1 \
 //x=21.58 //y=2.26 //x2=21.58 //y2=2.26
r1032 (  26 64 ) resistor r=0.0777782 //w=0.252 //l=0.131491 //layer=m1 \
 //thickness=0.36 //x=85.59 //y=4.755 //x2=85.587 //y2=4.885
r1033 (  25 62 ) resistor r=0.0910802 //w=0.374 //l=0.185472 //layer=m1 \
 //thickness=0.36 //x=85.59 //y=2.43 //x2=85.535 //y2=2.27
r1034 (  25 26 ) resistor r=2.21851 //w=0.131 //l=2.325 //layer=m1 \
 //thickness=0.36 //x=85.59 //y=2.43 //x2=85.59 //y2=4.755
r1035 (  24 54 ) resistor r=0.075298 //w=0.252 //l=0.125 //layer=m1 \
 //thickness=0.36 //x=84.11 //y=4.76 //x2=84.11 //y2=4.885
r1036 (  23 52 ) resistor r=0.0877379 //w=0.374 //l=0.175357 //layer=m1 \
 //thickness=0.36 //x=84.11 //y=3.29 //x2=84.055 //y2=3.14
r1037 (  23 24 ) resistor r=1.40267 //w=0.131 //l=1.47 //layer=m1 \
 //thickness=0.36 //x=84.11 //y=3.29 //x2=84.11 //y2=4.76
r1038 (  22 50 ) resistor r=0.0910802 //w=0.374 //l=0.185472 //layer=m1 \
 //thickness=0.36 //x=84.11 //y=2.97 //x2=84.055 //y2=3.13
r1039 (  21 58 ) resistor r=0.0910802 //w=0.374 //l=0.185472 //layer=m1 \
 //thickness=0.36 //x=84.11 //y=2.43 //x2=84.165 //y2=2.27
r1040 (  21 22 ) resistor r=0.515267 //w=0.131 //l=0.54 //layer=m1 \
 //thickness=0.36 //x=84.11 //y=2.43 //x2=84.11 //y2=2.97
r1041 (  19 48 ) resistor r=0.0911593 //w=0.376 //l=0.184608 //layer=m1 \
 //thickness=0.36 //x=25.65 //y=3.315 //x2=25.597 //y2=3.155
r1042 (  19 20 ) resistor r=1.88931 //w=0.131 //l=1.98 //layer=m1 \
 //thickness=0.36 //x=25.65 //y=3.315 //x2=25.65 //y2=5.295
r1043 (  18 46 ) resistor r=0.0861726 //w=0.376 //l=0.16944 //layer=m1 \
 //thickness=0.36 //x=25.65 //y=2.995 //x2=25.597 //y2=3.14
r1044 (  17 18 ) resistor r=1.02576 //w=0.131 //l=1.075 //layer=m1 \
 //thickness=0.36 //x=25.65 //y=1.92 //x2=25.65 //y2=2.995
r1045 (  15 17 ) resistor r=0.0698411 //w=0.17 //l=0.120208 //layer=m1 \
 //thickness=0.36 //x=25.565 //y=1.835 //x2=25.65 //y2=1.92
r1046 (  15 16 ) resistor r=0.257634 //w=0.131 //l=0.27 //layer=m1 \
 //thickness=0.36 //x=25.565 //y=1.835 //x2=25.295 //y2=1.835
r1047 (  14 38 ) resistor r=0.0257089 //w=0.23 //l=0.115 //layer=m1 \
 //thickness=0.36 //x=25.285 //y=5.38 //x2=25.17 //y2=5.38
r1048 (  13 20 ) resistor r=0.0698411 //w=0.17 //l=0.120208 //layer=m1 \
 //thickness=0.36 //x=25.565 //y=5.38 //x2=25.65 //y2=5.295
r1049 (  13 14 ) resistor r=0.267176 //w=0.131 //l=0.28 //layer=m1 \
 //thickness=0.36 //x=25.565 //y=5.38 //x2=25.285 //y2=5.38
r1050 (  12 16 ) resistor r=0.0698411 //w=0.17 //l=0.120208 //layer=m1 \
 //thickness=0.36 //x=25.21 //y=1.75 //x2=25.295 //y2=1.835
r1051 (  11 43 ) resistor r=0.0913624 //w=0.191 //l=0.12 //layer=m1 \
 //thickness=0.36 //x=25.21 //y=1.3 //x2=25.21 //y2=1.18
r1052 (  11 12 ) resistor r=0.429389 //w=0.131 //l=0.45 //layer=m1 \
 //thickness=0.36 //x=25.21 //y=1.3 //x2=25.21 //y2=1.75
r1053 (  8 35 ) resistor r=0.0227762 //w=0.219 //l=0.115 //layer=m1 \
 //thickness=0.36 //x=24.405 //y=5.38 //x2=24.29 //y2=5.38
r1054 (  7 38 ) resistor r=0.0257089 //w=0.23 //l=0.115 //layer=m1 \
 //thickness=0.36 //x=25.055 //y=5.38 //x2=25.17 //y2=5.38
r1055 (  7 8 ) resistor r=0.620229 //w=0.131 //l=0.65 //layer=m1 \
 //thickness=0.36 //x=25.055 //y=5.38 //x2=24.405 //y2=5.38
r1056 (  4 30 ) resistor r=0.0801089 //w=0.224 //l=0.13 //layer=m1 \
 //thickness=0.36 //x=21.58 //y=4.75 //x2=21.58 //y2=4.88
r1057 (  3 34 ) resistor r=0.0912814 //w=0.379 //l=0.183303 //layer=m1 \
 //thickness=0.36 //x=21.58 //y=3.315 //x2=21.63 //y2=3.155
r1058 (  3 4 ) resistor r=1.36927 //w=0.131 //l=1.435 //layer=m1 \
 //thickness=0.36 //x=21.58 //y=3.315 //x2=21.58 //y2=4.75
r1059 (  2 32 ) resistor r=0.0863342 //w=0.379 //l=0.168152 //layer=m1 \
 //thickness=0.36 //x=21.58 //y=2.995 //x2=21.63 //y2=3.14
r1060 (  1 28 ) resistor r=0.0719237 //w=0.222 //l=0.115 //layer=m1 \
 //thickness=0.36 //x=21.58 //y=2.375 //x2=21.58 //y2=2.26
r1061 (  1 2 ) resistor r=0.591603 //w=0.131 //l=0.62 //layer=m1 \
 //thickness=0.36 //x=21.58 //y=2.375 //x2=21.58 //y2=2.995
ends PM_TMRDFFRNQNX1\%noxref_16

subckt PM_TMRDFFRNQNX1\%noxref_17 ( 1 2 3 4 7 12 13 15 16 18 19 20 21 22 23 24 \
 25 26 27 28 36 39 40 43 45 48 58 62 67 69 71 72 74 78 84 85 88 97 102 110 127 \
 136 141 150 154 155 156 157 158 159 160 161 162 166 167 168 173 175 178 179 \
 180 181 182 187 189 191 197 198 199 200 201 206 208 210 216 217 219 220 225 \
 229 230 233 241 242 245 253 255 256 )
c582 ( 253 0 ) capacitor c=0.00878249f //x=76.82 //y=1.085
c583 ( 245 0 ) capacitor c=0.0370698f //x=86.72 //y=4.885
c584 ( 242 0 ) capacitor c=0.030265f //x=86.7 //y=2.095
c585 ( 241 0 ) capacitor c=0.0512002f //x=86.7 //y=2.26
c586 ( 233 0 ) capacitor c=0.0387879f //x=80.08 //y=4.885
c587 ( 230 0 ) capacitor c=0.0300885f //x=80.04 //y=2.095
c588 ( 229 0 ) capacitor c=0.0554483f //x=80.04 //y=2.26
c589 ( 225 0 ) capacitor c=0.0653822f //x=73.38 //y=4.88
c590 ( 220 0 ) capacitor c=0.0278202f //x=73.38 //y=2.095
c591 ( 219 0 ) capacitor c=0.0502771f //x=73.38 //y=2.26
c592 ( 217 0 ) capacitor c=0.0237734f //x=87.265 //y=1.435
c593 ( 216 0 ) capacitor c=0.0191782f //x=87.265 //y=1.085
c594 ( 210 0 ) capacitor c=0.0361171f //x=87.11 //y=1.585
c595 ( 208 0 ) capacitor c=0.0157803f //x=87.11 //y=0.93
c596 ( 206 0 ) capacitor c=0.0376354f //x=87.105 //y=4.975
c597 ( 201 0 ) capacitor c=0.020493f //x=86.735 //y=1.74
c598 ( 200 0 ) capacitor c=0.0167049f //x=86.735 //y=1.435
c599 ( 199 0 ) capacitor c=0.0174993f //x=86.735 //y=1.085
c600 ( 198 0 ) capacitor c=0.0443648f //x=80.605 //y=1.43
c601 ( 197 0 ) capacitor c=0.0192211f //x=80.605 //y=1.085
c602 ( 191 0 ) capacitor c=0.0186579f //x=80.45 //y=1.585
c603 ( 189 0 ) capacitor c=0.0157795f //x=80.45 //y=0.93
c604 ( 187 0 ) capacitor c=0.0351351f //x=80.445 //y=4.975
c605 ( 182 0 ) capacitor c=0.0209124f //x=80.075 //y=1.74
c606 ( 181 0 ) capacitor c=0.016848f //x=80.075 //y=1.43
c607 ( 180 0 ) capacitor c=0.0174777f //x=80.075 //y=1.085
c608 ( 179 0 ) capacitor c=0.0443175f //x=73.9 //y=1.44
c609 ( 178 0 ) capacitor c=0.0199703f //x=73.9 //y=1.095
c610 ( 175 0 ) capacitor c=0.0162526f //x=73.745 //y=1.595
c611 ( 173 0 ) capacitor c=0.0157807f //x=73.745 //y=0.94
c612 ( 168 0 ) capacitor c=0.0220935f //x=73.37 //y=1.75
c613 ( 167 0 ) capacitor c=0.0207489f //x=73.37 //y=1.44
c614 ( 166 0 ) capacitor c=0.0194091f //x=73.37 //y=1.095
c615 ( 162 0 ) capacitor c=0.155887f //x=87.18 //y=6.205
c616 ( 161 0 ) capacitor c=0.1106f //x=86.74 //y=6.205
c617 ( 160 0 ) capacitor c=0.154859f //x=80.52 //y=6.205
c618 ( 159 0 ) capacitor c=0.110573f //x=80.08 //y=6.205
c619 ( 158 0 ) capacitor c=0.159671f //x=73.56 //y=6.2
c620 ( 157 0 ) capacitor c=0.110208f //x=73.12 //y=6.2
c621 ( 150 0 ) capacitor c=8.10734e-19 //x=86.72 //y=4.885
c622 ( 141 0 ) capacitor c=0.00105273f //x=86.7 //y=2.26
c623 ( 136 0 ) capacitor c=0.00173056f //x=80.08 //y=4.885
c624 ( 127 0 ) capacitor c=0.00152737f //x=80.04 //y=2.26
c625 ( 110 0 ) capacitor c=0.0320929f //x=76.97 //y=5.56
c626 ( 102 0 ) capacitor c=0.0289929f //x=76.09 //y=5.56
c627 ( 97 0 ) capacitor c=7.7417e-19 //x=73.38 //y=4.88
c628 ( 88 0 ) capacitor c=0.00101179f //x=73.38 //y=2.26
c629 ( 85 0 ) capacitor c=0.147361f //x=86.555 //y=4.21
c630 ( 84 0 ) capacitor c=0.00479868f //x=86.715 //y=4.21
c631 ( 78 0 ) capacitor c=6.13673e-19 //x=73.54 //y=3.865
c632 ( 74 0 ) capacitor c=0.0216726f //x=80.2 //y=4.252
c633 ( 72 0 ) capacitor c=0.0511296f //x=78.79 //y=3.895
c634 ( 71 0 ) capacitor c=0.00166309f //x=79.135 //y=3.895
c635 ( 69 0 ) capacitor c=0.00315672f //x=76.915 //y=3.87
c636 ( 67 0 ) capacitor c=0.0291388f //x=76.315 //y=3.88
c637 ( 62 0 ) capacitor c=0.0148587f //x=86.7 //y=4.25
c638 ( 58 0 ) capacitor c=0.0166522f //x=80.04 //y=4.25
c639 ( 48 0 ) capacitor c=0.0156971f //x=77.45 //y=3.88
c640 ( 45 0 ) capacitor c=0.0114156f //x=77.01 //y=1.18
c641 ( 43 0 ) capacitor c=5.78613e-19 //x=76.97 //y=5.56
c642 ( 40 0 ) capacitor c=0.0116708f //x=76.97 //y=5.38
c643 ( 39 0 ) capacitor c=0.00924419f //x=76.09 //y=5.56
c644 ( 36 0 ) capacitor c=0.0165507f //x=73.38 //y=3.88
c645 ( 28 0 ) capacitor c=0.0124358f //x=86.7 //y=4.74
c646 ( 27 0 ) capacitor c=0.0110536f //x=86.7 //y=4.37
c647 ( 26 0 ) capacitor c=0.0479813f //x=86.7 //y=4.05
c648 ( 25 0 ) capacitor c=0.00651439f //x=86.7 //y=2.38
c649 ( 24 0 ) capacitor c=0.0169891f //x=80.04 //y=4.71
c650 ( 23 0 ) capacitor c=0.0130793f //x=80.04 //y=4.365
c651 ( 22 0 ) capacitor c=0.0560062f //x=80.04 //y=4.045
c652 ( 21 0 ) capacitor c=0.00920415f //x=80.04 //y=2.375
c653 ( 20 0 ) capacitor c=0.027973f //x=77.45 //y=5.295
c654 ( 19 0 ) capacitor c=0.0124784f //x=77.45 //y=4.055
c655 ( 18 0 ) capacitor c=0.046716f //x=77.45 //y=3.735
c656 ( 16 0 ) capacitor c=0.00619787f //x=77.095 //y=1.835
c657 ( 15 0 ) capacitor c=0.0147414f //x=77.365 //y=1.835
c658 ( 13 0 ) capacitor c=0.0108239f //x=77.365 //y=5.38
c659 ( 12 0 ) capacitor c=0.0116169f //x=77.01 //y=1.75
c660 ( 7 0 ) capacitor c=0.0136546f //x=76.855 //y=5.38
c661 ( 4 0 ) capacitor c=0.0203742f //x=73.38 //y=4.75
c662 ( 3 0 ) capacitor c=0.0113845f //x=73.38 //y=4.025
c663 ( 2 0 ) capacitor c=0.0342845f //x=73.38 //y=3.705
c664 ( 1 0 ) capacitor c=0.00690423f //x=73.38 //y=2.375
r665 (  247 248 ) resistor r=32.4568 //w=0.214 //l=0.075 //layer=ply \
 //thickness=0.18 //x=86.72 //y=4.975 //x2=86.72 //y2=5.05
r666 (  245 247 ) resistor r=20.271 //w=0.214 //l=0.09 //layer=ply \
 //thickness=0.18 //x=86.72 //y=4.885 //x2=86.72 //y2=4.975
r667 (  241 242 ) resistor r=52.7279 //w=0.214 //l=0.165 //layer=ply \
 //thickness=0.18 //x=86.7 //y=2.26 //x2=86.7 //y2=2.095
r668 (  233 235 ) resistor r=20.271 //w=0.214 //l=0.09 //layer=ply \
 //thickness=0.18 //x=80.08 //y=4.885 //x2=80.08 //y2=4.975
r669 (  229 230 ) resistor r=52.7279 //w=0.214 //l=0.165 //layer=ply \
 //thickness=0.18 //x=80.04 //y=2.26 //x2=80.04 //y2=2.095
r670 (  219 220 ) resistor r=52.7279 //w=0.214 //l=0.165 //layer=ply \
 //thickness=0.18 //x=73.38 //y=2.26 //x2=73.38 //y2=2.095
r671 (  217 252 ) resistor r=4.95774 //w=0.164 //l=0.112 //layer=ply \
 //thickness=0.18 //x=87.265 //y=1.435 //x2=87.265 //y2=1.547
r672 (  216 251 ) resistor r=45.1352 //w=0.168 //l=0.173853 //layer=ply \
 //thickness=0.18 //x=87.265 //y=1.085 //x2=87.225 //y2=0.93
r673 (  216 217 ) resistor r=179.468 //w=0.094 //l=0.35 //layer=ply \
 //thickness=0.18 //x=87.265 //y=1.085 //x2=87.265 //y2=1.435
r674 (  211 250 ) resistor r=10.8103 //w=0.211 //l=0.115 //layer=ply \
 //thickness=0.18 //x=86.89 //y=1.585 //x2=86.775 //y2=1.585
r675 (  210 252 ) resistor r=45.9962 //w=0.164 //l=0.17296 //layer=ply \
 //thickness=0.18 //x=87.11 //y=1.585 //x2=87.265 //y2=1.547
r676 (  209 249 ) resistor r=5.52526 //w=0.168 //l=0.115 //layer=ply \
 //thickness=0.18 //x=86.89 //y=0.93 //x2=86.775 //y2=0.93
r677 (  208 251 ) resistor r=5.52526 //w=0.168 //l=0.115 //layer=ply \
 //thickness=0.18 //x=87.11 //y=0.93 //x2=87.225 //y2=0.93
r678 (  208 209 ) resistor r=112.809 //w=0.094 //l=0.22 //layer=ply \
 //thickness=0.18 //x=87.11 //y=0.93 //x2=86.89 //y2=0.93
r679 (  207 247 ) resistor r=16.5046 //w=0.27 //l=0.135 //layer=ply \
 //thickness=0.18 //x=86.855 //y=4.975 //x2=86.72 //y2=4.975
r680 (  206 213 ) resistor r=26.9307 //w=0.15 //l=0.106066 //layer=ply \
 //thickness=0.18 //x=87.105 //y=4.975 //x2=87.18 //y2=5.05
r681 (  206 207 ) resistor r=128.191 //w=0.094 //l=0.25 //layer=ply \
 //thickness=0.18 //x=87.105 //y=4.975 //x2=86.855 //y2=4.975
r682 (  201 250 ) resistor r=39.5036 //w=0.211 //l=0.173853 //layer=ply \
 //thickness=0.18 //x=86.735 //y=1.74 //x2=86.775 //y2=1.585
r683 (  201 242 ) resistor r=182.032 //w=0.094 //l=0.355 //layer=ply \
 //thickness=0.18 //x=86.735 //y=1.74 //x2=86.735 //y2=2.095
r684 (  200 250 ) resistor r=38.3614 //w=0.211 //l=0.168819 //layer=ply \
 //thickness=0.18 //x=86.735 //y=1.435 //x2=86.775 //y2=1.585
r685 (  199 249 ) resistor r=45.1352 //w=0.168 //l=0.173853 //layer=ply \
 //thickness=0.18 //x=86.735 //y=1.085 //x2=86.775 //y2=0.93
r686 (  199 200 ) resistor r=179.468 //w=0.094 //l=0.35 //layer=ply \
 //thickness=0.18 //x=86.735 //y=1.085 //x2=86.735 //y2=1.435
r687 (  198 239 ) resistor r=45.1352 //w=0.168 //l=0.173853 //layer=ply \
 //thickness=0.18 //x=80.605 //y=1.43 //x2=80.565 //y2=1.585
r688 (  197 238 ) resistor r=45.1352 //w=0.168 //l=0.173853 //layer=ply \
 //thickness=0.18 //x=80.605 //y=1.085 //x2=80.565 //y2=0.93
r689 (  197 198 ) resistor r=176.904 //w=0.094 //l=0.345 //layer=ply \
 //thickness=0.18 //x=80.605 //y=1.085 //x2=80.605 //y2=1.43
r690 (  192 237 ) resistor r=10.701 //w=0.21 //l=0.115 //layer=ply \
 //thickness=0.18 //x=80.23 //y=1.585 //x2=80.115 //y2=1.585
r691 (  191 239 ) resistor r=5.52526 //w=0.168 //l=0.115 //layer=ply \
 //thickness=0.18 //x=80.45 //y=1.585 //x2=80.565 //y2=1.585
r692 (  190 236 ) resistor r=5.52526 //w=0.168 //l=0.115 //layer=ply \
 //thickness=0.18 //x=80.23 //y=0.93 //x2=80.115 //y2=0.93
r693 (  189 238 ) resistor r=5.52526 //w=0.168 //l=0.115 //layer=ply \
 //thickness=0.18 //x=80.45 //y=0.93 //x2=80.565 //y2=0.93
r694 (  189 190 ) resistor r=112.809 //w=0.094 //l=0.22 //layer=ply \
 //thickness=0.18 //x=80.45 //y=0.93 //x2=80.23 //y2=0.93
r695 (  188 235 ) resistor r=16.5046 //w=0.27 //l=0.135 //layer=ply \
 //thickness=0.18 //x=80.215 //y=4.975 //x2=80.08 //y2=4.975
r696 (  187 194 ) resistor r=26.9307 //w=0.15 //l=0.106066 //layer=ply \
 //thickness=0.18 //x=80.445 //y=4.975 //x2=80.52 //y2=5.05
r697 (  187 188 ) resistor r=117.936 //w=0.094 //l=0.23 //layer=ply \
 //thickness=0.18 //x=80.445 //y=4.975 //x2=80.215 //y2=4.975
r698 (  184 235 ) resistor r=32.4568 //w=0.214 //l=0.075 //layer=ply \
 //thickness=0.18 //x=80.08 //y=5.05 //x2=80.08 //y2=4.975
r699 (  182 237 ) resistor r=39.5823 //w=0.21 //l=0.173853 //layer=ply \
 //thickness=0.18 //x=80.075 //y=1.74 //x2=80.115 //y2=1.585
r700 (  182 230 ) resistor r=182.032 //w=0.094 //l=0.355 //layer=ply \
 //thickness=0.18 //x=80.075 //y=1.74 //x2=80.075 //y2=2.095
r701 (  181 237 ) resistor r=39.5823 //w=0.21 //l=0.173853 //layer=ply \
 //thickness=0.18 //x=80.075 //y=1.43 //x2=80.115 //y2=1.585
r702 (  180 236 ) resistor r=45.1352 //w=0.168 //l=0.173853 //layer=ply \
 //thickness=0.18 //x=80.075 //y=1.085 //x2=80.115 //y2=0.93
r703 (  180 181 ) resistor r=176.904 //w=0.094 //l=0.345 //layer=ply \
 //thickness=0.18 //x=80.075 //y=1.085 //x2=80.075 //y2=1.43
r704 (  179 227 ) resistor r=45.1352 //w=0.168 //l=0.173853 //layer=ply \
 //thickness=0.18 //x=73.9 //y=1.44 //x2=73.86 //y2=1.595
r705 (  178 226 ) resistor r=45.1352 //w=0.168 //l=0.173853 //layer=ply \
 //thickness=0.18 //x=73.9 //y=1.095 //x2=73.86 //y2=0.94
r706 (  178 179 ) resistor r=176.904 //w=0.094 //l=0.345 //layer=ply \
 //thickness=0.18 //x=73.9 //y=1.095 //x2=73.9 //y2=1.44
r707 (  176 223 ) resistor r=10.701 //w=0.21 //l=0.115 //layer=ply \
 //thickness=0.18 //x=73.525 //y=1.595 //x2=73.41 //y2=1.595
r708 (  175 227 ) resistor r=5.52526 //w=0.168 //l=0.115 //layer=ply \
 //thickness=0.18 //x=73.745 //y=1.595 //x2=73.86 //y2=1.595
r709 (  174 222 ) resistor r=5.52526 //w=0.168 //l=0.115 //layer=ply \
 //thickness=0.18 //x=73.525 //y=0.94 //x2=73.41 //y2=0.94
r710 (  173 226 ) resistor r=5.52526 //w=0.168 //l=0.115 //layer=ply \
 //thickness=0.18 //x=73.745 //y=0.94 //x2=73.86 //y2=0.94
r711 (  173 174 ) resistor r=112.809 //w=0.094 //l=0.22 //layer=ply \
 //thickness=0.18 //x=73.745 //y=0.94 //x2=73.525 //y2=0.94
r712 (  170 225 ) resistor r=37.236 //w=0.233 //l=0.249199 //layer=ply \
 //thickness=0.18 //x=73.56 //y=5.045 //x2=73.38 //y2=4.88
r713 (  168 223 ) resistor r=39.5823 //w=0.21 //l=0.173853 //layer=ply \
 //thickness=0.18 //x=73.37 //y=1.75 //x2=73.41 //y2=1.595
r714 (  168 220 ) resistor r=176.904 //w=0.094 //l=0.345 //layer=ply \
 //thickness=0.18 //x=73.37 //y=1.75 //x2=73.37 //y2=2.095
r715 (  167 223 ) resistor r=39.5823 //w=0.21 //l=0.173853 //layer=ply \
 //thickness=0.18 //x=73.37 //y=1.44 //x2=73.41 //y2=1.595
r716 (  166 222 ) resistor r=45.1352 //w=0.168 //l=0.173853 //layer=ply \
 //thickness=0.18 //x=73.37 //y=1.095 //x2=73.41 //y2=0.94
r717 (  166 167 ) resistor r=176.904 //w=0.094 //l=0.345 //layer=ply \
 //thickness=0.18 //x=73.37 //y=1.095 //x2=73.37 //y2=1.44
r718 (  163 225 ) resistor r=53.7854 //w=0.233 //l=0.332415 //layer=ply \
 //thickness=0.18 //x=73.12 //y=5.045 //x2=73.38 //y2=4.88
r719 (  162 213 ) resistor r=592.245 //w=0.094 //l=1.155 //layer=ply \
 //thickness=0.18 //x=87.18 //y=6.205 //x2=87.18 //y2=5.05
r720 (  161 248 ) resistor r=592.245 //w=0.094 //l=1.155 //layer=ply \
 //thickness=0.18 //x=86.74 //y=6.205 //x2=86.74 //y2=5.05
r721 (  160 194 ) resistor r=592.245 //w=0.094 //l=1.155 //layer=ply \
 //thickness=0.18 //x=80.52 //y=6.205 //x2=80.52 //y2=5.05
r722 (  159 184 ) resistor r=592.245 //w=0.094 //l=1.155 //layer=ply \
 //thickness=0.18 //x=80.08 //y=6.205 //x2=80.08 //y2=5.05
r723 (  158 170 ) resistor r=592.245 //w=0.094 //l=1.155 //layer=ply \
 //thickness=0.18 //x=73.56 //y=6.2 //x2=73.56 //y2=5.045
r724 (  157 163 ) resistor r=592.245 //w=0.094 //l=1.155 //layer=ply \
 //thickness=0.18 //x=73.12 //y=6.2 //x2=73.12 //y2=5.045
r725 (  156 210 ) resistor r=56.4043 //w=0.094 //l=0.11 //layer=ply \
 //thickness=0.18 //x=87 //y=1.585 //x2=87.11 //y2=1.585
r726 (  156 211 ) resistor r=56.4043 //w=0.094 //l=0.11 //layer=ply \
 //thickness=0.18 //x=87 //y=1.585 //x2=86.89 //y2=1.585
r727 (  155 191 ) resistor r=56.4043 //w=0.094 //l=0.11 //layer=ply \
 //thickness=0.18 //x=80.34 //y=1.585 //x2=80.45 //y2=1.585
r728 (  155 192 ) resistor r=56.4043 //w=0.094 //l=0.11 //layer=ply \
 //thickness=0.18 //x=80.34 //y=1.585 //x2=80.23 //y2=1.585
r729 (  154 175 ) resistor r=56.4043 //w=0.094 //l=0.11 //layer=ply \
 //thickness=0.18 //x=73.635 //y=1.595 //x2=73.745 //y2=1.595
r730 (  154 176 ) resistor r=56.4043 //w=0.094 //l=0.11 //layer=ply \
 //thickness=0.18 //x=73.635 //y=1.595 //x2=73.525 //y2=1.595
r731 (  150 245 ) resistor r=152 //w=0.17 //l=0.17 //layer=licon //count=1 \
 //x=86.72 //y=4.885 //x2=86.72 //y2=4.885
r732 (  141 241 ) resistor r=152 //w=0.17 //l=0.17 //layer=licon //count=1 \
 //x=86.7 //y=2.26 //x2=86.7 //y2=2.26
r733 (  136 233 ) resistor r=152 //w=0.17 //l=0.17 //layer=licon //count=1 \
 //x=80.08 //y=4.885 //x2=80.08 //y2=4.885
r734 (  127 229 ) resistor r=152 //w=0.17 //l=0.17 //layer=licon //count=1 \
 //x=80.04 //y=2.26 //x2=80.04 //y2=2.26
r735 (  110 256 ) resistor r=23.615 //w=0.187 //l=0.345 //layer=li \
 //thickness=0.1 //x=76.97 //y=5.56 //x2=76.97 //y2=5.905
r736 (  102 255 ) resistor r=23.615 //w=0.187 //l=0.345 //layer=li \
 //thickness=0.1 //x=76.09 //y=5.56 //x2=76.09 //y2=5.905
r737 (  97 225 ) resistor r=152 //w=0.17 //l=0.17 //layer=licon //count=1 \
 //x=73.38 //y=4.88 //x2=73.38 //y2=4.88
r738 (  88 219 ) resistor r=152 //w=0.17 //l=0.17 //layer=licon //count=1 \
 //x=73.38 //y=2.26 //x2=73.38 //y2=2.26
r739 (  84 85 ) resistor r=0.104807 //w=0.281 //l=0.16 //layer=m2 \
 //thickness=0.36 //x=86.715 //y=4.21 //x2=86.555 //y2=4.21
r740 (  76 78 ) resistor r=0.10734 //w=0.281 //l=0.16 //layer=m2 \
 //thickness=0.36 //x=73.38 //y=3.865 //x2=73.54 //y2=3.865
r741 (  74 82 ) resistor r=0.0892547 //w=0.274 //l=0.358175 //layer=m2 \
 //thickness=0.36 //x=80.2 //y=4.252 //x2=80.04 //y2=3.965
r742 (  74 85 ) resistor r=5.84099 //w=0.136 //l=6.355 //layer=m2 \
 //thickness=0.36 //x=80.2 //y=4.252 //x2=86.555 //y2=4.252
r743 (  72 80 ) resistor r=0.863507 //w=0.196 //l=1.35 //layer=m2 \
 //thickness=0.36 //x=78.79 //y=3.895 //x2=77.44 //y2=3.895
r744 (  71 82 ) resistor r=0.430765 //w=0.274 //l=0.939348 //layer=m2 \
 //thickness=0.36 //x=79.135 //y=3.895 //x2=80.04 //y2=3.965
r745 (  71 72 ) resistor r=0.329198 //w=0.131 //l=0.345 //layer=m2 \
 //thickness=0.36 //x=79.135 //y=3.895 //x2=78.79 //y2=3.895
r746 (  69 80 ) resistor r=0.337359 //w=0.196 //l=0.537355 //layer=m2 \
 //thickness=0.36 //x=76.915 //y=3.87 //x2=77.44 //y2=3.895
r747 (  69 70 ) resistor r=0.410305 //w=0.131 //l=0.43 //layer=m2 \
 //thickness=0.36 //x=76.915 //y=3.87 //x2=76.485 //y2=3.87
r748 (  67 70 ) resistor r=0.125 //w=0.17 //l=0.174929 //layer=m2 \
 //thickness=0.36 //x=76.315 //y=3.88 //x2=76.485 //y2=3.87
r749 (  67 78 ) resistor r=2.6479 //w=0.131 //l=2.775 //layer=m2 \
 //thickness=0.36 //x=76.315 //y=3.88 //x2=73.54 //y2=3.88
r750 (  66 150 ) resistor r=9.3 //w=0.17 //l=0.17 //layer=mcon //count=1 \
 //x=86.72 //y=4.885 //x2=86.72 //y2=4.885
r751 (  64 141 ) resistor r=9.3 //w=0.17 //l=0.17 //layer=mcon //count=1 \
 //x=86.7 //y=2.26 //x2=86.7 //y2=2.26
r752 (  60 84 ) resistor r=4.5 //w=0.15 //l=0.15 //layer=via1 //count=1 \
 //x=86.715 //y=4.21 //x2=86.715 //y2=4.21
r753 (  60 62 ) resistor r=0.0130208 //w=0.384 //l=0.04 //layer=m1 \
 //thickness=0.36 //x=86.655 //y=4.21 //x2=86.655 //y2=4.25
r754 (  56 82 ) resistor r=4.5 //w=0.15 //l=0.15 //layer=via1 //count=1 \
 //x=80.04 //y=4.205 //x2=80.04 //y2=4.205
r755 (  56 58 ) resistor r=0.0149601 //w=0.376 //l=0.045 //layer=m1 \
 //thickness=0.36 //x=80.092 //y=4.205 //x2=80.092 //y2=4.25
r756 (  54 136 ) resistor r=9.3 //w=0.17 //l=0.17 //layer=mcon //count=1 \
 //x=80.08 //y=4.885 //x2=80.08 //y2=4.885
r757 (  52 127 ) resistor r=9.3 //w=0.17 //l=0.17 //layer=mcon //count=1 \
 //x=80.04 //y=2.26 //x2=80.04 //y2=2.26
r758 (  50 80 ) resistor r=4.5 //w=0.15 //l=0.15 //layer=via1 //count=1 \
 //x=77.44 //y=3.895 //x2=77.44 //y2=3.895
r759 (  48 50 ) resistor r=0.00505391 //w=0.371 //l=0.015 //layer=m1 \
 //thickness=0.36 //x=77.392 //y=3.88 //x2=77.392 //y2=3.895
r760 (  45 253 ) resistor r=9.3 //w=0.17 //l=0.17 //layer=mcon //count=1 \
 //x=77.01 //y=1.18 //x2=77.01 //y2=1.18
r761 (  43 110 ) resistor r=9.3 //w=0.17 //l=0.17 //layer=mcon //count=1 \
 //x=76.97 //y=5.56 //x2=76.97 //y2=5.56
r762 (  40 43 ) resistor r=0.117801 //w=0.191 //l=0.18 //layer=m1 \
 //thickness=0.36 //x=76.97 //y=5.38 //x2=76.97 //y2=5.56
r763 (  39 102 ) resistor r=9.3 //w=0.17 //l=0.17 //layer=mcon //count=1 \
 //x=76.09 //y=5.56 //x2=76.09 //y2=5.56
r764 (  37 39 ) resistor r=0.10274 //w=0.219 //l=0.18 //layer=m1 \
 //thickness=0.36 //x=76.09 //y=5.38 //x2=76.09 //y2=5.56
r765 (  34 76 ) resistor r=4.5 //w=0.15 //l=0.15 //layer=via1 //count=1 \
 //x=73.38 //y=3.865 //x2=73.38 //y2=3.865
r766 (  34 36 ) resistor r=0.0049867 //w=0.376 //l=0.015 //layer=m1 \
 //thickness=0.36 //x=73.432 //y=3.865 //x2=73.432 //y2=3.88
r767 (  32 97 ) resistor r=9.3 //w=0.17 //l=0.17 //layer=mcon //count=1 \
 //x=73.38 //y=4.88 //x2=73.38 //y2=4.88
r768 (  30 88 ) resistor r=9.3 //w=0.17 //l=0.17 //layer=mcon //count=1 \
 //x=73.38 //y=2.26 //x2=73.38 //y2=2.26
r769 (  28 66 ) resistor r=0.0893515 //w=0.219 //l=0.154677 //layer=m1 \
 //thickness=0.36 //x=86.7 //y=4.74 //x2=86.72 //y2=4.885
r770 (  27 62 ) resistor r=0.0784723 //w=0.384 //l=0.140712 //layer=m1 \
 //thickness=0.36 //x=86.7 //y=4.37 //x2=86.655 //y2=4.25
r771 (  27 28 ) resistor r=0.353053 //w=0.131 //l=0.37 //layer=m1 \
 //thickness=0.36 //x=86.7 //y=4.37 //x2=86.7 //y2=4.74
r772 (  26 60 ) resistor r=0.0914932 //w=0.384 //l=0.181108 //layer=m1 \
 //thickness=0.36 //x=86.7 //y=4.05 //x2=86.655 //y2=4.21
r773 (  25 64 ) resistor r=0.0744285 //w=0.225 //l=0.12 //layer=m1 \
 //thickness=0.36 //x=86.7 //y=2.38 //x2=86.7 //y2=2.26
r774 (  25 26 ) resistor r=1.59351 //w=0.131 //l=1.67 //layer=m1 \
 //thickness=0.36 //x=86.7 //y=2.38 //x2=86.7 //y2=4.05
r775 (  24 54 ) resistor r=0.100665 //w=0.248 //l=0.193972 //layer=m1 \
 //thickness=0.36 //x=80.04 //y=4.71 //x2=80.08 //y2=4.885
r776 (  23 58 ) resistor r=0.0761992 //w=0.376 //l=0.138582 //layer=m1 \
 //thickness=0.36 //x=80.04 //y=4.365 //x2=80.092 //y2=4.25
r777 (  23 24 ) resistor r=0.329198 //w=0.131 //l=0.345 //layer=m1 \
 //thickness=0.36 //x=80.04 //y=4.365 //x2=80.04 //y2=4.71
r778 (  22 56 ) resistor r=0.0911593 //w=0.376 //l=0.184174 //layer=m1 \
 //thickness=0.36 //x=80.04 //y=4.045 //x2=80.092 //y2=4.205
r779 (  21 52 ) resistor r=0.0717383 //w=0.224 //l=0.115 //layer=m1 \
 //thickness=0.36 //x=80.04 //y=2.375 //x2=80.04 //y2=2.26
r780 (  21 22 ) resistor r=1.59351 //w=0.131 //l=1.67 //layer=m1 \
 //thickness=0.36 //x=80.04 //y=2.375 //x2=80.04 //y2=4.045
r781 (  19 50 ) resistor r=0.0909648 //w=0.371 //l=0.186762 //layer=m1 \
 //thickness=0.36 //x=77.45 //y=4.055 //x2=77.392 //y2=3.895
r782 (  19 20 ) resistor r=1.18321 //w=0.131 //l=1.24 //layer=m1 \
 //thickness=0.36 //x=77.45 //y=4.055 //x2=77.45 //y2=5.295
r783 (  18 48 ) resistor r=0.0859108 //w=0.371 //l=0.171566 //layer=m1 \
 //thickness=0.36 //x=77.45 //y=3.735 //x2=77.392 //y2=3.88
r784 (  17 18 ) resistor r=1.73187 //w=0.131 //l=1.815 //layer=m1 \
 //thickness=0.36 //x=77.45 //y=1.92 //x2=77.45 //y2=3.735
r785 (  15 17 ) resistor r=0.0698411 //w=0.17 //l=0.120208 //layer=m1 \
 //thickness=0.36 //x=77.365 //y=1.835 //x2=77.45 //y2=1.92
r786 (  15 16 ) resistor r=0.257634 //w=0.131 //l=0.27 //layer=m1 \
 //thickness=0.36 //x=77.365 //y=1.835 //x2=77.095 //y2=1.835
r787 (  14 40 ) resistor r=0.0257089 //w=0.23 //l=0.115 //layer=m1 \
 //thickness=0.36 //x=77.085 //y=5.38 //x2=76.97 //y2=5.38
r788 (  13 20 ) resistor r=0.0698411 //w=0.17 //l=0.120208 //layer=m1 \
 //thickness=0.36 //x=77.365 //y=5.38 //x2=77.45 //y2=5.295
r789 (  13 14 ) resistor r=0.267176 //w=0.131 //l=0.28 //layer=m1 \
 //thickness=0.36 //x=77.365 //y=5.38 //x2=77.085 //y2=5.38
r790 (  12 16 ) resistor r=0.0698411 //w=0.17 //l=0.120208 //layer=m1 \
 //thickness=0.36 //x=77.01 //y=1.75 //x2=77.095 //y2=1.835
r791 (  11 45 ) resistor r=0.0913624 //w=0.191 //l=0.12 //layer=m1 \
 //thickness=0.36 //x=77.01 //y=1.3 //x2=77.01 //y2=1.18
r792 (  11 12 ) resistor r=0.429389 //w=0.131 //l=0.45 //layer=m1 \
 //thickness=0.36 //x=77.01 //y=1.3 //x2=77.01 //y2=1.75
r793 (  8 37 ) resistor r=0.0227762 //w=0.219 //l=0.115 //layer=m1 \
 //thickness=0.36 //x=76.205 //y=5.38 //x2=76.09 //y2=5.38
r794 (  7 40 ) resistor r=0.0257089 //w=0.23 //l=0.115 //layer=m1 \
 //thickness=0.36 //x=76.855 //y=5.38 //x2=76.97 //y2=5.38
r795 (  7 8 ) resistor r=0.620229 //w=0.131 //l=0.65 //layer=m1 \
 //thickness=0.36 //x=76.855 //y=5.38 //x2=76.205 //y2=5.38
r796 (  4 32 ) resistor r=0.0801089 //w=0.224 //l=0.13 //layer=m1 \
 //thickness=0.36 //x=73.38 //y=4.75 //x2=73.38 //y2=4.88
r797 (  3 36 ) resistor r=0.0861726 //w=0.376 //l=0.169012 //layer=m1 \
 //thickness=0.36 //x=73.38 //y=4.025 //x2=73.432 //y2=3.88
r798 (  3 4 ) resistor r=0.691794 //w=0.131 //l=0.725 //layer=m1 \
 //thickness=0.36 //x=73.38 //y=4.025 //x2=73.38 //y2=4.75
r799 (  2 34 ) resistor r=0.0911593 //w=0.376 //l=0.184174 //layer=m1 \
 //thickness=0.36 //x=73.38 //y=3.705 //x2=73.432 //y2=3.865
r800 (  1 30 ) resistor r=0.0719237 //w=0.222 //l=0.115 //layer=m1 \
 //thickness=0.36 //x=73.38 //y=2.375 //x2=73.38 //y2=2.26
r801 (  1 2 ) resistor r=1.26908 //w=0.131 //l=1.33 //layer=m1 \
 //thickness=0.36 //x=73.38 //y=2.375 //x2=73.38 //y2=3.705
ends PM_TMRDFFRNQNX1\%noxref_17

subckt PM_TMRDFFRNQNX1\%QN ( 1 2 3 4 5 6 7 8 9 11 12 13 15 16 28 32 35 38 52 \
 55 56 58 59 68 76 93 94 95 99 100 )
c211 ( 95 0 ) capacitor c=0.009897f //x=86.81 //y=1.085
c212 ( 94 0 ) capacitor c=0.0110388f //x=83.48 //y=1.085
c213 ( 93 0 ) capacitor c=0.0110842f //x=80.15 //y=1.085
c214 ( 76 0 ) capacitor c=0.0265472f //x=86.96 //y=5.56
c215 ( 68 0 ) capacitor c=0.0232072f //x=86.08 //y=5.56
c216 ( 59 0 ) capacitor c=0.0846633f //x=86.835 //y=1.405
c217 ( 58 0 ) capacitor c=0.0257508f //x=86.995 //y=1.405
c218 ( 56 0 ) capacitor c=0.00731967f //x=83.8 //y=1.405
c219 ( 55 0 ) capacitor c=0.0847663f //x=83.54 //y=1.405
c220 ( 52 0 ) capacitor c=0.0031611f //x=80.505 //y=1.405
c221 ( 38 0 ) capacitor c=0.01557f //x=86.957 //y=5.39
c222 ( 35 0 ) capacitor c=0.0155006f //x=86.08 //y=5.39
c223 ( 32 0 ) capacitor c=0.00890301f //x=83.67 //y=1.36
c224 ( 28 0 ) capacitor c=0.00591007f //x=80.34 //y=1.36
c225 ( 16 0 ) capacitor c=0.00834076f //x=87.085 //y=1.825
c226 ( 15 0 ) capacitor c=0.0162177f //x=87.355 //y=1.825
c227 ( 13 0 ) capacitor c=0.0128896f //x=87.355 //y=5.39
c228 ( 12 0 ) capacitor c=0.00871794f //x=87 //y=1.74
c229 ( 11 0 ) capacitor c=0.00698506f //x=87 //y=1.535
c230 ( 9 0 ) capacitor c=0.0116295f //x=86.835 //y=5.39
c231 ( 1 0 ) capacitor c=0.132496f //x=87.44 //y=2.4
r232 (  92 93 ) resistor r=13.3953 //w=0.172 //l=0.18 //layer=li \
 //thickness=0.1 //x=80.337 //y=1.36 //x2=80.337 //y2=1.18
r233 (  87 95 ) resistor r=12.3209 //w=0.187 //l=0.18 //layer=li \
 //thickness=0.1 //x=87 //y=1.36 //x2=87 //y2=1.18
r234 (  76 100 ) resistor r=23.2727 //w=0.187 //l=0.34 //layer=li \
 //thickness=0.1 //x=86.96 //y=5.56 //x2=86.96 //y2=5.9
r235 (  68 99 ) resistor r=23.2727 //w=0.187 //l=0.34 //layer=li \
 //thickness=0.1 //x=86.08 //y=5.56 //x2=86.08 //y2=5.9
r236 (  65 94 ) resistor r=12.3209 //w=0.187 //l=0.18 //layer=li \
 //thickness=0.1 //x=83.67 //y=1.36 //x2=83.67 //y2=1.18
r237 (  58 59 ) resistor r=0.10734 //w=0.281 //l=0.16 //layer=m2 \
 //thickness=0.36 //x=86.995 //y=1.405 //x2=86.835 //y2=1.405
r238 (  56 59 ) resistor r=2.89599 //w=0.131 //l=3.035 //layer=m2 \
 //thickness=0.36 //x=83.8 //y=1.36 //x2=86.835 //y2=1.36
r239 (  54 56 ) resistor r=0.0942778 //w=0.221 //l=0.13 //layer=m2 \
 //thickness=0.36 //x=83.67 //y=1.405 //x2=83.8 //y2=1.405
r240 (  54 55 ) resistor r=0.0942778 //w=0.221 //l=0.13 //layer=m2 \
 //thickness=0.36 //x=83.67 //y=1.405 //x2=83.54 //y2=1.405
r241 (  52 55 ) resistor r=2.89599 //w=0.131 //l=3.035 //layer=m2 \
 //thickness=0.36 //x=80.505 //y=1.36 //x2=83.54 //y2=1.36
r242 (  50 52 ) resistor r=0.10734 //w=0.281 //l=0.16 //layer=m2 \
 //thickness=0.36 //x=80.345 //y=1.405 //x2=80.505 //y2=1.405
r243 (  44 58 ) resistor r=4.5 //w=0.15 //l=0.15 //layer=via1 //count=1 \
 //x=86.995 //y=1.405 //x2=86.995 //y2=1.405
r244 (  42 87 ) resistor r=9.3 //w=0.17 //l=0.17 //layer=mcon //count=1 //x=87 \
 //y=1.36 //x2=87 //y2=1.36
r245 (  42 44 ) resistor r=0.0163043 //w=0.345 //l=0.045 //layer=m1 \
 //thickness=0.36 //x=86.94 //y=1.36 //x2=86.94 //y2=1.405
r246 (  40 76 ) resistor r=9.3 //w=0.17 //l=0.17 //layer=mcon //count=1 \
 //x=86.96 //y=5.56 //x2=86.96 //y2=5.56
r247 (  38 40 ) resistor r=0.0944444 //w=0.225 //l=0.17 //layer=m1 \
 //thickness=0.36 //x=86.957 //y=5.39 //x2=86.957 //y2=5.56
r248 (  37 68 ) resistor r=9.3 //w=0.17 //l=0.17 //layer=mcon //count=1 \
 //x=86.08 //y=5.56 //x2=86.08 //y2=5.56
r249 (  35 37 ) resistor r=0.0936123 //w=0.227 //l=0.17 //layer=m1 \
 //thickness=0.36 //x=86.08 //y=5.39 //x2=86.08 //y2=5.56
r250 (  34 54 ) resistor r=4.5 //w=0.15 //l=0.15 //layer=via1 //count=1 \
 //x=83.67 //y=1.405 //x2=83.67 //y2=1.405
r251 (  32 65 ) resistor r=9.3 //w=0.17 //l=0.17 //layer=mcon //count=1 \
 //x=83.67 //y=1.36 //x2=83.67 //y2=1.36
r252 (  32 34 ) resistor r=0.0163043 //w=0.345 //l=0.045 //layer=m1 \
 //thickness=0.36 //x=83.61 //y=1.36 //x2=83.61 //y2=1.405
r253 (  30 50 ) resistor r=4.5 //w=0.15 //l=0.15 //layer=via1 //count=1 \
 //x=80.345 //y=1.405 //x2=80.345 //y2=1.405
r254 (  28 92 ) resistor r=9.3 //w=0.17 //l=0.17 //layer=mcon //count=1 \
 //x=80.34 //y=1.36 //x2=80.34 //y2=1.36
r255 (  28 30 ) resistor r=0.0150401 //w=0.374 //l=0.045 //layer=m1 \
 //thickness=0.36 //x=80.395 //y=1.36 //x2=80.395 //y2=1.405
r256 (  15 17 ) resistor r=0.0698411 //w=0.17 //l=0.120208 //layer=m1 \
 //thickness=0.36 //x=87.355 //y=1.825 //x2=87.44 //y2=1.91
r257 (  15 16 ) resistor r=0.257634 //w=0.131 //l=0.27 //layer=m1 \
 //thickness=0.36 //x=87.355 //y=1.825 //x2=87.085 //y2=1.825
r258 (  14 38 ) resistor r=0.0243946 //w=0.225 //l=0.123 //layer=m1 \
 //thickness=0.36 //x=87.08 //y=5.39 //x2=86.957 //y2=5.39
r259 (  13 18 ) resistor r=0.0698411 //w=0.17 //l=0.120208 //layer=m1 \
 //thickness=0.36 //x=87.355 //y=5.39 //x2=87.44 //y2=5.305
r260 (  13 14 ) resistor r=0.262405 //w=0.131 //l=0.275 //layer=m1 \
 //thickness=0.36 //x=87.355 //y=5.39 //x2=87.08 //y2=5.39
r261 (  12 16 ) resistor r=0.0698411 //w=0.17 //l=0.120208 //layer=m1 \
 //thickness=0.36 //x=87 //y=1.74 //x2=87.085 //y2=1.825
r262 (  11 44 ) resistor r=0.0792909 //w=0.345 //l=0.157162 //layer=m1 \
 //thickness=0.36 //x=87 //y=1.535 //x2=86.94 //y2=1.405
r263 (  11 12 ) resistor r=0.195611 //w=0.131 //l=0.205 //layer=m1 \
 //thickness=0.36 //x=87 //y=1.535 //x2=87 //y2=1.74
r264 (  10 35 ) resistor r=0.0249239 //w=0.227 //l=0.125 //layer=m1 \
 //thickness=0.36 //x=86.205 //y=5.39 //x2=86.08 //y2=5.39
r265 (  9 38 ) resistor r=0.0243946 //w=0.225 //l=0.122 //layer=m1 \
 //thickness=0.36 //x=86.835 //y=5.39 //x2=86.957 //y2=5.39
r266 (  9 10 ) resistor r=0.601145 //w=0.131 //l=0.63 //layer=m1 \
 //thickness=0.36 //x=86.835 //y=5.39 //x2=86.205 //y2=5.39
r267 (  8 18 ) resistor r=0.300573 //w=0.131 //l=0.315 //layer=m1 \
 //thickness=0.36 //x=87.44 //y=4.99 //x2=87.44 //y2=5.305
r268 (  7 8 ) resistor r=0.353053 //w=0.131 //l=0.37 //layer=m1 \
 //thickness=0.36 //x=87.44 //y=4.62 //x2=87.44 //y2=4.99
r269 (  6 7 ) resistor r=0.353053 //w=0.131 //l=0.37 //layer=m1 \
 //thickness=0.36 //x=87.44 //y=4.25 //x2=87.44 //y2=4.62
r270 (  5 6 ) resistor r=0.353053 //w=0.131 //l=0.37 //layer=m1 \
 //thickness=0.36 //x=87.44 //y=3.88 //x2=87.44 //y2=4.25
r271 (  4 5 ) resistor r=0.353053 //w=0.131 //l=0.37 //layer=m1 \
 //thickness=0.36 //x=87.44 //y=3.51 //x2=87.44 //y2=3.88
r272 (  3 4 ) resistor r=0.353053 //w=0.131 //l=0.37 //layer=m1 \
 //thickness=0.36 //x=87.44 //y=3.14 //x2=87.44 //y2=3.51
r273 (  2 3 ) resistor r=0.353053 //w=0.131 //l=0.37 //layer=m1 \
 //thickness=0.36 //x=87.44 //y=2.77 //x2=87.44 //y2=3.14
r274 (  1 2 ) resistor r=0.353053 //w=0.131 //l=0.37 //layer=m1 \
 //thickness=0.36 //x=87.44 //y=2.4 //x2=87.44 //y2=2.77
r275 (  1 17 ) resistor r=0.467557 //w=0.131 //l=0.49 //layer=m1 \
 //thickness=0.36 //x=87.44 //y=2.4 //x2=87.44 //y2=1.91
ends PM_TMRDFFRNQNX1\%QN

subckt PM_TMRDFFRNQNX1\%noxref_19 ( 1 131 132 133 135 136 137 141 142 155 210 \
 219 229 237 247 265 275 283 293 309 317 343 351 361 371 387 395 405 415 431 \
 441 467 477 487 495 511 521 531 539 555 565 589 599 607 617 635 645 653 663 \
 679 687 713 721 731 741 757 765 775 785 801 811 837 847 857 865 881 891 901 \
 909 925 935 947 982 997 1004 1009 1014 1020 1026 1030 1036 1042 1047 1052 \
 1057 1062 1068 1074 1078 1084 1090 1095 1096 1097 1098 1099 1100 1101 1102 \
 1103 1104 1105 1106 1107 1108 1109 1110 1111 1112 1113 1114 1115 1116 1117 \
 1118 1119 1120 1121 1122 1123 1124 1125 1126 1127 1128 1129 1130 1131 1132 \
 1133 1134 1135 1136 1137 1138 1139 1140 1141 1142 1143 1144 1145 1146 1147 \
 1148 1149 1150 1151 1152 1153 1154 1155 1156 1157 1158 1159 1160 1161 1162 \
 1163 1164 1165 1166 )
c1400 ( 1166 0 ) capacitor c=0.0424825f //x=80.595 //y=5.205
c1401 ( 1165 0 ) capacitor c=0.0223606f //x=79.715 //y=5.205
c1402 ( 1164 0 ) capacitor c=0.0508965f //x=78.845 //y=5.205
c1403 ( 1163 0 ) capacitor c=0.0393089f //x=77.265 //y=5.2
c1404 ( 1162 0 ) capacitor c=0.0247431f //x=76.385 //y=5.2
c1405 ( 1161 0 ) capacitor c=0.062629f //x=75.515 //y=5.2
c1406 ( 1160 0 ) capacitor c=0.0466891f //x=73.635 //y=5.2
c1407 ( 1159 0 ) capacitor c=0.0255836f //x=72.755 //y=5.2
c1408 ( 1158 0 ) capacitor c=0.0256114f //x=71.875 //y=5.2
c1409 ( 1157 0 ) capacitor c=0.0675934f //x=71.005 //y=5.2
c1410 ( 1156 0 ) capacitor c=0.0466891f //x=68.825 //y=5.2
c1411 ( 1155 0 ) capacitor c=0.025617f //x=67.945 //y=5.2
c1412 ( 1154 0 ) capacitor c=0.0255777f //x=67.065 //y=5.2
c1413 ( 1153 0 ) capacitor c=0.0675298f //x=66.195 //y=5.2
c1414 ( 1152 0 ) capacitor c=0.039544f //x=64.315 //y=5.2
c1415 ( 1151 0 ) capacitor c=0.0248174f //x=63.435 //y=5.2
c1416 ( 1150 0 ) capacitor c=0.0628113f //x=62.565 //y=5.2
c1417 ( 1149 0 ) capacitor c=0.0466891f //x=60.685 //y=5.2
c1418 ( 1148 0 ) capacitor c=0.0255836f //x=59.805 //y=5.2
c1419 ( 1147 0 ) capacitor c=0.0256114f //x=58.925 //y=5.2
c1420 ( 1146 0 ) capacitor c=0.0676343f //x=58.055 //y=5.2
c1421 ( 1145 0 ) capacitor c=0.0466891f //x=55.875 //y=5.2
c1422 ( 1144 0 ) capacitor c=0.025617f //x=54.995 //y=5.2
c1423 ( 1143 0 ) capacitor c=0.0255777f //x=54.115 //y=5.2
c1424 ( 1142 0 ) capacitor c=0.067436f //x=53.245 //y=5.2
c1425 ( 1141 0 ) capacitor c=0.039544f //x=51.365 //y=5.2
c1426 ( 1140 0 ) capacitor c=0.0248174f //x=50.485 //y=5.2
c1427 ( 1139 0 ) capacitor c=0.0627254f //x=49.615 //y=5.2
c1428 ( 1138 0 ) capacitor c=0.0466891f //x=47.735 //y=5.2
c1429 ( 1137 0 ) capacitor c=0.0255836f //x=46.855 //y=5.2
c1430 ( 1136 0 ) capacitor c=0.0256114f //x=45.975 //y=5.2
c1431 ( 1135 0 ) capacitor c=0.0675744f //x=45.105 //y=5.2
c1432 ( 1134 0 ) capacitor c=0.0466891f //x=42.925 //y=5.2
c1433 ( 1133 0 ) capacitor c=0.025617f //x=42.045 //y=5.2
c1434 ( 1132 0 ) capacitor c=0.0255777f //x=41.165 //y=5.2
c1435 ( 1131 0 ) capacitor c=0.0675298f //x=40.295 //y=5.2
c1436 ( 1130 0 ) capacitor c=0.039544f //x=38.415 //y=5.2
c1437 ( 1129 0 ) capacitor c=0.0248174f //x=37.535 //y=5.2
c1438 ( 1128 0 ) capacitor c=0.0628113f //x=36.665 //y=5.2
c1439 ( 1127 0 ) capacitor c=0.0466891f //x=34.785 //y=5.2
c1440 ( 1126 0 ) capacitor c=0.0255836f //x=33.905 //y=5.2
c1441 ( 1125 0 ) capacitor c=0.0256114f //x=33.025 //y=5.2
c1442 ( 1124 0 ) capacitor c=0.0676343f //x=32.155 //y=5.2
c1443 ( 1123 0 ) capacitor c=0.0466891f //x=29.975 //y=5.2
c1444 ( 1122 0 ) capacitor c=0.025617f //x=29.095 //y=5.2
c1445 ( 1121 0 ) capacitor c=0.0255777f //x=28.215 //y=5.2
c1446 ( 1120 0 ) capacitor c=0.067436f //x=27.345 //y=5.2
c1447 ( 1119 0 ) capacitor c=0.0397412f //x=25.465 //y=5.2
c1448 ( 1118 0 ) capacitor c=0.0248174f //x=24.585 //y=5.2
c1449 ( 1117 0 ) capacitor c=0.062426f //x=23.715 //y=5.2
c1450 ( 1116 0 ) capacitor c=0.0466891f //x=21.835 //y=5.2
c1451 ( 1115 0 ) capacitor c=0.0255836f //x=20.955 //y=5.2
c1452 ( 1114 0 ) capacitor c=0.0256114f //x=20.075 //y=5.2
c1453 ( 1113 0 ) capacitor c=0.0675744f //x=19.205 //y=5.2
c1454 ( 1112 0 ) capacitor c=0.0466891f //x=17.025 //y=5.2
c1455 ( 1111 0 ) capacitor c=0.025617f //x=16.145 //y=5.2
c1456 ( 1110 0 ) capacitor c=0.0255777f //x=15.265 //y=5.2
c1457 ( 1109 0 ) capacitor c=0.0674699f //x=14.395 //y=5.2
c1458 ( 1108 0 ) capacitor c=0.039544f //x=12.515 //y=5.2
c1459 ( 1107 0 ) capacitor c=0.0248174f //x=11.635 //y=5.2
c1460 ( 1106 0 ) capacitor c=0.0628113f //x=10.765 //y=5.2
c1461 ( 1105 0 ) capacitor c=0.0466891f //x=8.885 //y=5.2
c1462 ( 1104 0 ) capacitor c=0.0255836f //x=8.005 //y=5.2
c1463 ( 1103 0 ) capacitor c=0.0256114f //x=7.125 //y=5.2
c1464 ( 1102 0 ) capacitor c=0.0676346f //x=6.255 //y=5.2
c1465 ( 1101 0 ) capacitor c=0.0466891f //x=4.075 //y=5.2
c1466 ( 1100 0 ) capacitor c=0.025617f //x=3.195 //y=5.2
c1467 ( 1099 0 ) capacitor c=0.0256114f //x=2.315 //y=5.2
c1468 ( 1098 0 ) capacitor c=0.0693233f //x=1.445 //y=5.2
c1469 ( 1097 0 ) capacitor c=0.121249f //x=84.85 //y=7.585
c1470 ( 1096 0 ) capacitor c=0.125864f //x=81.52 //y=7.585
c1471 ( 1095 0 ) capacitor c=0.123835f //x=78.19 //y=7.585
c1472 ( 1094 0 ) capacitor c=0.00597439f //x=77.45 //y=7.58
c1473 ( 1092 0 ) capacitor c=0.00597439f //x=76.53 //y=7.585
c1474 ( 1091 0 ) capacitor c=0.00597439f //x=75.65 //y=7.585
c1475 ( 1090 0 ) capacitor c=0.144111f //x=74.86 //y=7.585
c1476 ( 1089 0 ) capacitor c=0.00597439f //x=73.75 //y=7.58
c1477 ( 1087 0 ) capacitor c=0.00597439f //x=72.9 //y=7.585
c1478 ( 1086 0 ) capacitor c=0.00597439f //x=72.02 //y=7.585
c1479 ( 1085 0 ) capacitor c=0.00597439f //x=71.14 //y=7.585
c1480 ( 1084 0 ) capacitor c=0.16206f //x=70.05 //y=7.585
c1481 ( 1083 0 ) capacitor c=0.00597439f //x=68.94 //y=7.58
c1482 ( 1081 0 ) capacitor c=0.00597439f //x=68.09 //y=7.585
c1483 ( 1080 0 ) capacitor c=0.00597439f //x=67.21 //y=7.585
c1484 ( 1079 0 ) capacitor c=0.00597439f //x=66.33 //y=7.585
c1485 ( 1078 0 ) capacitor c=0.144432f //x=65.24 //y=7.585
c1486 ( 1077 0 ) capacitor c=0.00597439f //x=64.46 //y=7.585
c1487 ( 1076 0 ) capacitor c=0.00597439f //x=63.58 //y=7.585
c1488 ( 1075 0 ) capacitor c=0.00597439f //x=62.7 //y=7.585
c1489 ( 1074 0 ) capacitor c=0.145153f //x=61.91 //y=7.585
c1490 ( 1073 0 ) capacitor c=0.00597439f //x=60.83 //y=7.585
c1491 ( 1072 0 ) capacitor c=0.00597439f //x=59.95 //y=7.585
c1492 ( 1071 0 ) capacitor c=0.00597439f //x=59.07 //y=7.585
c1493 ( 1070 0 ) capacitor c=0.00597439f //x=58.21 //y=7.58
c1494 ( 1068 0 ) capacitor c=0.163341f //x=57.1 //y=7.585
c1495 ( 1067 0 ) capacitor c=0.00597439f //x=56.02 //y=7.585
c1496 ( 1066 0 ) capacitor c=0.00597439f //x=55.14 //y=7.585
c1497 ( 1065 0 ) capacitor c=0.00597439f //x=54.26 //y=7.585
c1498 ( 1064 0 ) capacitor c=0.00597439f //x=53.4 //y=7.58
c1499 ( 1062 0 ) capacitor c=0.145506f //x=52.29 //y=7.585
c1500 ( 1061 0 ) capacitor c=0.00597439f //x=51.51 //y=7.585
c1501 ( 1060 0 ) capacitor c=0.00597439f //x=50.63 //y=7.585
c1502 ( 1059 0 ) capacitor c=0.00597439f //x=49.7 //y=7.58
c1503 ( 1057 0 ) capacitor c=0.145153f //x=48.96 //y=7.585
c1504 ( 1056 0 ) capacitor c=0.00597439f //x=47.88 //y=7.585
c1505 ( 1055 0 ) capacitor c=0.00597439f //x=47 //y=7.585
c1506 ( 1054 0 ) capacitor c=0.00597439f //x=46.12 //y=7.585
c1507 ( 1053 0 ) capacitor c=0.00597439f //x=45.24 //y=7.585
c1508 ( 1052 0 ) capacitor c=0.16219f //x=44.15 //y=7.585
c1509 ( 1051 0 ) capacitor c=0.00597439f //x=43.07 //y=7.585
c1510 ( 1050 0 ) capacitor c=0.00597439f //x=42.19 //y=7.585
c1511 ( 1049 0 ) capacitor c=0.00597439f //x=41.31 //y=7.585
c1512 ( 1048 0 ) capacitor c=0.00597439f //x=40.43 //y=7.585
c1513 ( 1047 0 ) capacitor c=0.144432f //x=39.34 //y=7.585
c1514 ( 1046 0 ) capacitor c=0.00597439f //x=38.6 //y=7.58
c1515 ( 1044 0 ) capacitor c=0.00597439f //x=37.68 //y=7.585
c1516 ( 1043 0 ) capacitor c=0.00597439f //x=36.8 //y=7.585
c1517 ( 1042 0 ) capacitor c=0.145153f //x=36.01 //y=7.585
c1518 ( 1041 0 ) capacitor c=0.00597439f //x=34.9 //y=7.58
c1519 ( 1039 0 ) capacitor c=0.00597439f //x=34.05 //y=7.585
c1520 ( 1038 0 ) capacitor c=0.00597439f //x=33.17 //y=7.585
c1521 ( 1037 0 ) capacitor c=0.00597439f //x=32.29 //y=7.585
c1522 ( 1036 0 ) capacitor c=0.163341f //x=31.2 //y=7.585
c1523 ( 1035 0 ) capacitor c=0.00597439f //x=30.09 //y=7.58
c1524 ( 1033 0 ) capacitor c=0.00597439f //x=29.24 //y=7.585
c1525 ( 1032 0 ) capacitor c=0.00597439f //x=28.36 //y=7.585
c1526 ( 1031 0 ) capacitor c=0.00597439f //x=27.48 //y=7.585
c1527 ( 1030 0 ) capacitor c=0.145755f //x=26.39 //y=7.585
c1528 ( 1029 0 ) capacitor c=0.00597439f //x=25.61 //y=7.585
c1529 ( 1028 0 ) capacitor c=0.00597439f //x=24.73 //y=7.585
c1530 ( 1027 0 ) capacitor c=0.00597439f //x=23.85 //y=7.585
c1531 ( 1026 0 ) capacitor c=0.143489f //x=23.06 //y=7.585
c1532 ( 1025 0 ) capacitor c=0.00597439f //x=21.98 //y=7.585
c1533 ( 1024 0 ) capacitor c=0.00597439f //x=21.1 //y=7.585
c1534 ( 1023 0 ) capacitor c=0.00597439f //x=20.22 //y=7.585
c1535 ( 1022 0 ) capacitor c=0.00597439f //x=19.36 //y=7.58
c1536 ( 1020 0 ) capacitor c=0.16219f //x=18.25 //y=7.585
c1537 ( 1019 0 ) capacitor c=0.00597439f //x=17.17 //y=7.585
c1538 ( 1018 0 ) capacitor c=0.00597439f //x=16.29 //y=7.585
c1539 ( 1017 0 ) capacitor c=0.00597439f //x=15.41 //y=7.585
c1540 ( 1016 0 ) capacitor c=0.00597439f //x=14.55 //y=7.58
c1541 ( 1014 0 ) capacitor c=0.144432f //x=13.44 //y=7.585
c1542 ( 1013 0 ) capacitor c=0.00597439f //x=12.66 //y=7.585
c1543 ( 1012 0 ) capacitor c=0.00597439f //x=11.78 //y=7.585
c1544 ( 1011 0 ) capacitor c=0.00597439f //x=10.85 //y=7.58
c1545 ( 1009 0 ) capacitor c=0.145153f //x=10.11 //y=7.585
c1546 ( 1008 0 ) capacitor c=0.00597439f //x=9.03 //y=7.585
c1547 ( 1007 0 ) capacitor c=0.00597439f //x=8.15 //y=7.585
c1548 ( 1006 0 ) capacitor c=0.00597439f //x=7.27 //y=7.585
c1549 ( 1005 0 ) capacitor c=0.00597439f //x=6.39 //y=7.585
c1550 ( 1004 0 ) capacitor c=0.163341f //x=5.3 //y=7.585
c1551 ( 1003 0 ) capacitor c=0.00597439f //x=4.22 //y=7.585
c1552 ( 1002 0 ) capacitor c=0.00597439f //x=3.34 //y=7.585
c1553 ( 1001 0 ) capacitor c=0.00597439f //x=2.46 //y=7.585
c1554 ( 1000 0 ) capacitor c=0.00597439f //x=1.58 //y=7.585
c1555 ( 997 0 ) capacitor c=0.369119f //x=87.44 //y=7.58
c1556 ( 982 0 ) capacitor c=0.131873f //x=84.68 //y=7.585
c1557 ( 947 0 ) capacitor c=0.133054f //x=81.35 //y=7.585
c1558 ( 943 0 ) capacitor c=0.0277785f //x=78.02 //y=7.585
c1559 ( 935 0 ) capacitor c=0.0287376f //x=77.325 //y=7.585
c1560 ( 925 0 ) capacitor c=0.0291748f //x=76.445 //y=7.585
c1561 ( 913 0 ) capacitor c=0.0283511f //x=75.565 //y=7.585
c1562 ( 909 0 ) capacitor c=0.0416617f //x=74.69 //y=7.585
c1563 ( 901 0 ) capacitor c=0.0288858f //x=73.695 //y=7.585
c1564 ( 891 0 ) capacitor c=0.0289326f //x=72.815 //y=7.585
c1565 ( 881 0 ) capacitor c=0.0290299f //x=71.935 //y=7.585
c1566 ( 869 0 ) capacitor c=0.0455283f //x=71.055 //y=7.585
c1567 ( 865 0 ) capacitor c=0.0427734f //x=69.88 //y=7.585
c1568 ( 857 0 ) capacitor c=0.0288858f //x=68.885 //y=7.585
c1569 ( 847 0 ) capacitor c=0.0289326f //x=68.005 //y=7.585
c1570 ( 837 0 ) capacitor c=0.0290299f //x=67.125 //y=7.585
c1571 ( 825 0 ) capacitor c=0.0455283f //x=66.245 //y=7.585
c1572 ( 821 0 ) capacitor c=0.0277785f //x=65.07 //y=7.585
c1573 ( 811 0 ) capacitor c=0.0287376f //x=64.375 //y=7.585
c1574 ( 801 0 ) capacitor c=0.0291078f //x=63.495 //y=7.585
c1575 ( 791 0 ) capacitor c=0.0283511f //x=62.615 //y=7.585
c1576 ( 785 0 ) capacitor c=0.042257f //x=61.74 //y=7.585
c1577 ( 775 0 ) capacitor c=0.0288858f //x=60.745 //y=7.585
c1578 ( 765 0 ) capacitor c=0.0289326f //x=59.865 //y=7.585
c1579 ( 757 0 ) capacitor c=0.0290299f //x=58.985 //y=7.585
c1580 ( 747 0 ) capacitor c=0.0455283f //x=58.105 //y=7.585
c1581 ( 741 0 ) capacitor c=0.042257f //x=56.93 //y=7.585
c1582 ( 731 0 ) capacitor c=0.0288858f //x=55.935 //y=7.585
c1583 ( 721 0 ) capacitor c=0.0289326f //x=55.055 //y=7.585
c1584 ( 713 0 ) capacitor c=0.0289834f //x=54.175 //y=7.585
c1585 ( 703 0 ) capacitor c=0.0454931f //x=53.295 //y=7.585
c1586 ( 697 0 ) capacitor c=0.0277785f //x=52.12 //y=7.585
c1587 ( 687 0 ) capacitor c=0.0287376f //x=51.425 //y=7.585
c1588 ( 679 0 ) capacitor c=0.0291078f //x=50.545 //y=7.585
c1589 ( 669 0 ) capacitor c=0.0283511f //x=49.665 //y=7.585
c1590 ( 663 0 ) capacitor c=0.042257f //x=48.79 //y=7.585
c1591 ( 653 0 ) capacitor c=0.0288858f //x=47.795 //y=7.585
c1592 ( 645 0 ) capacitor c=0.0289326f //x=46.915 //y=7.585
c1593 ( 635 0 ) capacitor c=0.0290299f //x=46.035 //y=7.585
c1594 ( 623 0 ) capacitor c=0.0455283f //x=45.155 //y=7.585
c1595 ( 617 0 ) capacitor c=0.0427734f //x=43.98 //y=7.585
c1596 ( 607 0 ) capacitor c=0.0288858f //x=42.985 //y=7.585
c1597 ( 599 0 ) capacitor c=0.0289326f //x=42.105 //y=7.585
c1598 ( 589 0 ) capacitor c=0.0290299f //x=41.225 //y=7.585
c1599 ( 577 0 ) capacitor c=0.0455283f //x=40.345 //y=7.585
c1600 ( 573 0 ) capacitor c=0.0277785f //x=39.17 //y=7.585
c1601 ( 565 0 ) capacitor c=0.0287376f //x=38.475 //y=7.585
c1602 ( 555 0 ) capacitor c=0.0291078f //x=37.595 //y=7.585
c1603 ( 543 0 ) capacitor c=0.0283511f //x=36.715 //y=7.585
c1604 ( 539 0 ) capacitor c=0.042257f //x=35.84 //y=7.585
c1605 ( 531 0 ) capacitor c=0.0288858f //x=34.845 //y=7.585
c1606 ( 521 0 ) capacitor c=0.0289326f //x=33.965 //y=7.585
c1607 ( 511 0 ) capacitor c=0.0290299f //x=33.085 //y=7.585
c1608 ( 499 0 ) capacitor c=0.0455283f //x=32.205 //y=7.585
c1609 ( 495 0 ) capacitor c=0.042257f //x=31.03 //y=7.585
c1610 ( 487 0 ) capacitor c=0.0288858f //x=30.035 //y=7.585
c1611 ( 477 0 ) capacitor c=0.0289326f //x=29.155 //y=7.585
c1612 ( 467 0 ) capacitor c=0.0289834f //x=28.275 //y=7.585
c1613 ( 455 0 ) capacitor c=0.0454931f //x=27.395 //y=7.585
c1614 ( 451 0 ) capacitor c=0.0277785f //x=26.22 //y=7.585
c1615 ( 441 0 ) capacitor c=0.0287376f //x=25.525 //y=7.585
c1616 ( 431 0 ) capacitor c=0.0291709f //x=24.645 //y=7.585
c1617 ( 421 0 ) capacitor c=0.0283511f //x=23.765 //y=7.585
c1618 ( 415 0 ) capacitor c=0.0416617f //x=22.89 //y=7.585
c1619 ( 405 0 ) capacitor c=0.0288858f //x=21.895 //y=7.585
c1620 ( 395 0 ) capacitor c=0.0289326f //x=21.015 //y=7.585
c1621 ( 387 0 ) capacitor c=0.0290299f //x=20.135 //y=7.585
c1622 ( 377 0 ) capacitor c=0.0455283f //x=19.255 //y=7.585
c1623 ( 371 0 ) capacitor c=0.0427734f //x=18.08 //y=7.585
c1624 ( 361 0 ) capacitor c=0.0288858f //x=17.085 //y=7.585
c1625 ( 351 0 ) capacitor c=0.0289326f //x=16.205 //y=7.585
c1626 ( 343 0 ) capacitor c=0.0290299f //x=15.325 //y=7.585
c1627 ( 333 0 ) capacitor c=0.0455283f //x=14.445 //y=7.585
c1628 ( 327 0 ) capacitor c=0.0277785f //x=13.27 //y=7.585
c1629 ( 317 0 ) capacitor c=0.0287376f //x=12.575 //y=7.585
c1630 ( 309 0 ) capacitor c=0.0291078f //x=11.695 //y=7.585
c1631 ( 299 0 ) capacitor c=0.0283511f //x=10.815 //y=7.585
c1632 ( 293 0 ) capacitor c=0.042257f //x=9.94 //y=7.585
c1633 ( 283 0 ) capacitor c=0.0288858f //x=8.945 //y=7.585
c1634 ( 275 0 ) capacitor c=0.0289326f //x=8.065 //y=7.585
c1635 ( 265 0 ) capacitor c=0.0290299f //x=7.185 //y=7.585
c1636 ( 253 0 ) capacitor c=0.0455283f //x=6.305 //y=7.585
c1637 ( 247 0 ) capacitor c=0.042257f //x=5.13 //y=7.585
c1638 ( 237 0 ) capacitor c=0.0288858f //x=4.135 //y=7.585
c1639 ( 229 0 ) capacitor c=0.0289326f //x=3.255 //y=7.585
c1640 ( 219 0 ) capacitor c=0.0289834f //x=2.375 //y=7.585
c1641 ( 210 0 ) capacitor c=0.253533f //x=1.23 //y=7.58
c1642 ( 207 0 ) capacitor c=0.0454931f //x=1.495 //y=7.585
c1643 ( 202 0 ) capacitor c=0.00499323f //x=80.74 //y=7.585
c1644 ( 199 0 ) capacitor c=0.00499323f //x=79.86 //y=7.585
c1645 ( 194 0 ) capacitor c=0.00499323f //x=78.93 //y=7.58
c1646 ( 155 0 ) capacitor c=0.270843f //x=87.44 //y=7.58
c1647 ( 142 0 ) capacitor c=0.00657976f //x=80.74 //y=7.41
c1648 ( 141 0 ) capacitor c=0.00827249f //x=80.74 //y=7.035
c1649 ( 137 0 ) capacitor c=0.0220779f //x=80.655 //y=7.585
c1650 ( 136 0 ) capacitor c=0.00369726f //x=79.86 //y=7.41
c1651 ( 135 0 ) capacitor c=0.00650208f //x=79.86 //y=7.035
c1652 ( 133 0 ) capacitor c=0.02242f //x=79.775 //y=7.585
c1653 ( 132 0 ) capacitor c=0.0090067f //x=78.98 //y=7.41
c1654 ( 131 0 ) capacitor c=0.0125184f //x=78.98 //y=7.035
c1655 ( 1 0 ) capacitor c=2.80685f //x=78.895 //y=7.585
r1656 (  995 997 ) resistor r=38.7139 //w=0.367 //l=1.11 //layer=li \
 //thickness=0.1 //x=86.33 //y=7.585 //x2=87.44 //y2=7.585
r1657 (  993 995 ) resistor r=38.7139 //w=0.367 //l=1.11 //layer=li \
 //thickness=0.1 //x=85.22 //y=7.585 //x2=86.33 //y2=7.585
r1658 (  991 1097 ) resistor r=5.29055 //w=0.35 //l=0.17 //layer=li \
 //thickness=0.1 //x=85.02 //y=7.585 //x2=84.85 //y2=7.585
r1659 (  991 993 ) resistor r=6.97548 //w=0.367 //l=0.2 //layer=li \
 //thickness=0.1 //x=85.02 //y=7.585 //x2=85.22 //y2=7.585
r1660 (  985 987 ) resistor r=38.7139 //w=0.367 //l=1.11 //layer=li \
 //thickness=0.1 //x=82.63 //y=7.585 //x2=83.74 //y2=7.585
r1661 (  983 1096 ) resistor r=5.29055 //w=0.35 //l=0.17 //layer=li \
 //thickness=0.1 //x=81.69 //y=7.585 //x2=81.52 //y2=7.585
r1662 (  983 985 ) resistor r=32.7847 //w=0.367 //l=0.94 //layer=li \
 //thickness=0.1 //x=81.69 //y=7.585 //x2=82.63 //y2=7.585
r1663 (  982 1097 ) resistor r=5.29055 //w=0.35 //l=0.17 //layer=li \
 //thickness=0.1 //x=84.68 //y=7.585 //x2=84.85 //y2=7.585
r1664 (  982 987 ) resistor r=32.7847 //w=0.367 //l=0.94 //layer=li \
 //thickness=0.1 //x=84.68 //y=7.585 //x2=83.74 //y2=7.585
r1665 (  978 1166 ) resistor r=23.2727 //w=0.187 //l=0.34 //layer=li \
 //thickness=0.1 //x=80.74 //y=6.92 //x2=80.74 //y2=6.58
r1666 (  963 1164 ) resistor r=23.2727 //w=0.187 //l=0.34 //layer=li \
 //thickness=0.1 //x=78.98 //y=6.92 //x2=78.98 //y2=6.58
r1667 (  952 954 ) resistor r=38.7139 //w=0.367 //l=1.11 //layer=li \
 //thickness=0.1 //x=80.04 //y=7.585 //x2=81.15 //y2=7.585
r1668 (  950 952 ) resistor r=38.7139 //w=0.367 //l=1.11 //layer=li \
 //thickness=0.1 //x=78.93 //y=7.585 //x2=80.04 //y2=7.585
r1669 (  948 1095 ) resistor r=5.29055 //w=0.35 //l=0.17 //layer=li \
 //thickness=0.1 //x=78.36 //y=7.585 //x2=78.19 //y2=7.585
r1670 (  948 950 ) resistor r=19.8801 //w=0.367 //l=0.57 //layer=li \
 //thickness=0.1 //x=78.36 //y=7.585 //x2=78.93 //y2=7.585
r1671 (  947 1096 ) resistor r=5.29055 //w=0.35 //l=0.17 //layer=li \
 //thickness=0.1 //x=81.35 //y=7.585 //x2=81.52 //y2=7.585
r1672 (  947 954 ) resistor r=6.97548 //w=0.367 //l=0.2 //layer=li \
 //thickness=0.1 //x=81.35 //y=7.585 //x2=81.15 //y2=7.585
r1673 (  944 1094 ) resistor r=2.87058 //w=0.35 //l=0.085 //layer=li \
 //thickness=0.1 //x=77.495 //y=7.585 //x2=77.41 //y2=7.585
r1674 (  943 1095 ) resistor r=5.29055 //w=0.35 //l=0.17 //layer=li \
 //thickness=0.1 //x=78.02 //y=7.585 //x2=78.19 //y2=7.585
r1675 (  943 944 ) resistor r=18.3106 //w=0.367 //l=0.525 //layer=li \
 //thickness=0.1 //x=78.02 //y=7.585 //x2=77.495 //y2=7.585
r1676 (  937 1094 ) resistor r=4.23183 //w=0.7 //l=0.175 //layer=li \
 //thickness=0.1 //x=77.41 //y=7.41 //x2=77.41 //y2=7.585
r1677 (  937 1163 ) resistor r=33.1979 //w=0.187 //l=0.485 //layer=li \
 //thickness=0.1 //x=77.41 //y=7.41 //x2=77.41 //y2=6.925
r1678 (  936 1092 ) resistor r=2.87058 //w=0.35 //l=0.085 //layer=li \
 //thickness=0.1 //x=76.615 //y=7.585 //x2=76.53 //y2=7.585
r1679 (  935 1094 ) resistor r=2.87058 //w=0.35 //l=0.085 //layer=li \
 //thickness=0.1 //x=77.325 //y=7.585 //x2=77.41 //y2=7.585
r1680 (  935 936 ) resistor r=24.7629 //w=0.367 //l=0.71 //layer=li \
 //thickness=0.1 //x=77.325 //y=7.585 //x2=76.615 //y2=7.585
r1681 (  929 1092 ) resistor r=4.23183 //w=0.7 //l=0.175 //layer=li \
 //thickness=0.1 //x=76.53 //y=7.41 //x2=76.53 //y2=7.585
r1682 (  929 1162 ) resistor r=33.1979 //w=0.187 //l=0.485 //layer=li \
 //thickness=0.1 //x=76.53 //y=7.41 //x2=76.53 //y2=6.925
r1683 (  926 1091 ) resistor r=2.87058 //w=0.35 //l=0.085 //layer=li \
 //thickness=0.1 //x=75.735 //y=7.585 //x2=75.65 //y2=7.585
r1684 (  926 928 ) resistor r=21.1008 //w=0.367 //l=0.605 //layer=li \
 //thickness=0.1 //x=75.735 //y=7.585 //x2=76.34 //y2=7.585
r1685 (  925 1092 ) resistor r=2.87058 //w=0.35 //l=0.085 //layer=li \
 //thickness=0.1 //x=76.445 //y=7.585 //x2=76.53 //y2=7.585
r1686 (  925 928 ) resistor r=3.66213 //w=0.367 //l=0.105 //layer=li \
 //thickness=0.1 //x=76.445 //y=7.585 //x2=76.34 //y2=7.585
r1687 (  917 1091 ) resistor r=4.23183 //w=0.7 //l=0.175 //layer=li \
 //thickness=0.1 //x=75.65 //y=7.41 //x2=75.65 //y2=7.585
r1688 (  917 1161 ) resistor r=56.4706 //w=0.187 //l=0.825 //layer=li \
 //thickness=0.1 //x=75.65 //y=7.41 //x2=75.65 //y2=6.585
r1689 (  914 1090 ) resistor r=5.29055 //w=0.35 //l=0.17 //layer=li \
 //thickness=0.1 //x=75.03 //y=7.585 //x2=74.86 //y2=7.585
r1690 (  914 916 ) resistor r=6.97548 //w=0.367 //l=0.2 //layer=li \
 //thickness=0.1 //x=75.03 //y=7.585 //x2=75.23 //y2=7.585
r1691 (  913 1091 ) resistor r=2.87058 //w=0.35 //l=0.085 //layer=li \
 //thickness=0.1 //x=75.565 //y=7.585 //x2=75.65 //y2=7.585
r1692 (  913 916 ) resistor r=11.6839 //w=0.367 //l=0.335 //layer=li \
 //thickness=0.1 //x=75.565 //y=7.585 //x2=75.23 //y2=7.585
r1693 (  910 1089 ) resistor r=2.87058 //w=0.35 //l=0.085 //layer=li \
 //thickness=0.1 //x=73.865 //y=7.585 //x2=73.78 //y2=7.585
r1694 (  909 1090 ) resistor r=5.29055 //w=0.35 //l=0.17 //layer=li \
 //thickness=0.1 //x=74.69 //y=7.585 //x2=74.86 //y2=7.585
r1695 (  909 910 ) resistor r=28.7738 //w=0.367 //l=0.825 //layer=li \
 //thickness=0.1 //x=74.69 //y=7.585 //x2=73.865 //y2=7.585
r1696 (  903 1089 ) resistor r=4.23183 //w=0.7 //l=0.175 //layer=li \
 //thickness=0.1 //x=73.78 //y=7.41 //x2=73.78 //y2=7.585
r1697 (  903 1160 ) resistor r=33.1979 //w=0.187 //l=0.485 //layer=li \
 //thickness=0.1 //x=73.78 //y=7.41 //x2=73.78 //y2=6.925
r1698 (  902 1087 ) resistor r=2.87058 //w=0.35 //l=0.085 //layer=li \
 //thickness=0.1 //x=72.985 //y=7.585 //x2=72.9 //y2=7.585
r1699 (  901 1089 ) resistor r=2.87058 //w=0.35 //l=0.085 //layer=li \
 //thickness=0.1 //x=73.695 //y=7.585 //x2=73.78 //y2=7.585
r1700 (  901 902 ) resistor r=24.7629 //w=0.367 //l=0.71 //layer=li \
 //thickness=0.1 //x=73.695 //y=7.585 //x2=72.985 //y2=7.585
r1701 (  895 1087 ) resistor r=4.23183 //w=0.7 //l=0.175 //layer=li \
 //thickness=0.1 //x=72.9 //y=7.41 //x2=72.9 //y2=7.585
r1702 (  895 1159 ) resistor r=33.1979 //w=0.187 //l=0.485 //layer=li \
 //thickness=0.1 //x=72.9 //y=7.41 //x2=72.9 //y2=6.925
r1703 (  892 1086 ) resistor r=2.87058 //w=0.35 //l=0.085 //layer=li \
 //thickness=0.1 //x=72.105 //y=7.585 //x2=72.02 //y2=7.585
r1704 (  892 894 ) resistor r=18.6594 //w=0.367 //l=0.535 //layer=li \
 //thickness=0.1 //x=72.105 //y=7.585 //x2=72.64 //y2=7.585
r1705 (  891 1087 ) resistor r=2.87058 //w=0.35 //l=0.085 //layer=li \
 //thickness=0.1 //x=72.815 //y=7.585 //x2=72.9 //y2=7.585
r1706 (  891 894 ) resistor r=6.10354 //w=0.367 //l=0.175 //layer=li \
 //thickness=0.1 //x=72.815 //y=7.585 //x2=72.64 //y2=7.585
r1707 (  885 1086 ) resistor r=4.23183 //w=0.7 //l=0.175 //layer=li \
 //thickness=0.1 //x=72.02 //y=7.41 //x2=72.02 //y2=7.585
r1708 (  885 1158 ) resistor r=33.1979 //w=0.187 //l=0.485 //layer=li \
 //thickness=0.1 //x=72.02 //y=7.41 //x2=72.02 //y2=6.925
r1709 (  882 1085 ) resistor r=2.87058 //w=0.35 //l=0.085 //layer=li \
 //thickness=0.1 //x=71.225 //y=7.585 //x2=71.14 //y2=7.585
r1710 (  882 884 ) resistor r=10.6376 //w=0.367 //l=0.305 //layer=li \
 //thickness=0.1 //x=71.225 //y=7.585 //x2=71.53 //y2=7.585
r1711 (  881 1086 ) resistor r=2.87058 //w=0.35 //l=0.085 //layer=li \
 //thickness=0.1 //x=71.935 //y=7.585 //x2=72.02 //y2=7.585
r1712 (  881 884 ) resistor r=14.1253 //w=0.367 //l=0.405 //layer=li \
 //thickness=0.1 //x=71.935 //y=7.585 //x2=71.53 //y2=7.585
r1713 (  873 1085 ) resistor r=4.23183 //w=0.7 //l=0.175 //layer=li \
 //thickness=0.1 //x=71.14 //y=7.41 //x2=71.14 //y2=7.585
r1714 (  873 1157 ) resistor r=56.4706 //w=0.187 //l=0.825 //layer=li \
 //thickness=0.1 //x=71.14 //y=7.41 //x2=71.14 //y2=6.585
r1715 (  870 1084 ) resistor r=5.29055 //w=0.35 //l=0.17 //layer=li \
 //thickness=0.1 //x=70.22 //y=7.585 //x2=70.05 //y2=7.585
r1716 (  870 872 ) resistor r=6.97548 //w=0.367 //l=0.2 //layer=li \
 //thickness=0.1 //x=70.22 //y=7.585 //x2=70.42 //y2=7.585
r1717 (  869 1085 ) resistor r=2.87058 //w=0.35 //l=0.085 //layer=li \
 //thickness=0.1 //x=71.055 //y=7.585 //x2=71.14 //y2=7.585
r1718 (  869 872 ) resistor r=22.1471 //w=0.367 //l=0.635 //layer=li \
 //thickness=0.1 //x=71.055 //y=7.585 //x2=70.42 //y2=7.585
r1719 (  866 1083 ) resistor r=2.87058 //w=0.35 //l=0.085 //layer=li \
 //thickness=0.1 //x=69.055 //y=7.585 //x2=68.97 //y2=7.585
r1720 (  865 1084 ) resistor r=5.29055 //w=0.35 //l=0.17 //layer=li \
 //thickness=0.1 //x=69.88 //y=7.585 //x2=70.05 //y2=7.585
r1721 (  865 866 ) resistor r=28.7738 //w=0.367 //l=0.825 //layer=li \
 //thickness=0.1 //x=69.88 //y=7.585 //x2=69.055 //y2=7.585
r1722 (  859 1083 ) resistor r=4.23183 //w=0.7 //l=0.175 //layer=li \
 //thickness=0.1 //x=68.97 //y=7.41 //x2=68.97 //y2=7.585
r1723 (  859 1156 ) resistor r=33.1979 //w=0.187 //l=0.485 //layer=li \
 //thickness=0.1 //x=68.97 //y=7.41 //x2=68.97 //y2=6.925
r1724 (  858 1081 ) resistor r=2.87058 //w=0.35 //l=0.085 //layer=li \
 //thickness=0.1 //x=68.175 //y=7.585 //x2=68.09 //y2=7.585
r1725 (  857 1083 ) resistor r=2.87058 //w=0.35 //l=0.085 //layer=li \
 //thickness=0.1 //x=68.885 //y=7.585 //x2=68.97 //y2=7.585
r1726 (  857 858 ) resistor r=24.7629 //w=0.367 //l=0.71 //layer=li \
 //thickness=0.1 //x=68.885 //y=7.585 //x2=68.175 //y2=7.585
r1727 (  851 1081 ) resistor r=4.23183 //w=0.7 //l=0.175 //layer=li \
 //thickness=0.1 //x=68.09 //y=7.41 //x2=68.09 //y2=7.585
r1728 (  851 1155 ) resistor r=33.1979 //w=0.187 //l=0.485 //layer=li \
 //thickness=0.1 //x=68.09 //y=7.41 //x2=68.09 //y2=6.925
r1729 (  848 1080 ) resistor r=2.87058 //w=0.35 //l=0.085 //layer=li \
 //thickness=0.1 //x=67.295 //y=7.585 //x2=67.21 //y2=7.585
r1730 (  848 850 ) resistor r=18.6594 //w=0.367 //l=0.535 //layer=li \
 //thickness=0.1 //x=67.295 //y=7.585 //x2=67.83 //y2=7.585
r1731 (  847 1081 ) resistor r=2.87058 //w=0.35 //l=0.085 //layer=li \
 //thickness=0.1 //x=68.005 //y=7.585 //x2=68.09 //y2=7.585
r1732 (  847 850 ) resistor r=6.10354 //w=0.367 //l=0.175 //layer=li \
 //thickness=0.1 //x=68.005 //y=7.585 //x2=67.83 //y2=7.585
r1733 (  841 1080 ) resistor r=4.23183 //w=0.7 //l=0.175 //layer=li \
 //thickness=0.1 //x=67.21 //y=7.41 //x2=67.21 //y2=7.585
r1734 (  841 1154 ) resistor r=33.1979 //w=0.187 //l=0.485 //layer=li \
 //thickness=0.1 //x=67.21 //y=7.41 //x2=67.21 //y2=6.925
r1735 (  838 1079 ) resistor r=2.87058 //w=0.35 //l=0.085 //layer=li \
 //thickness=0.1 //x=66.415 //y=7.585 //x2=66.33 //y2=7.585
r1736 (  838 840 ) resistor r=10.6376 //w=0.367 //l=0.305 //layer=li \
 //thickness=0.1 //x=66.415 //y=7.585 //x2=66.72 //y2=7.585
r1737 (  837 1080 ) resistor r=2.87058 //w=0.35 //l=0.085 //layer=li \
 //thickness=0.1 //x=67.125 //y=7.585 //x2=67.21 //y2=7.585
r1738 (  837 840 ) resistor r=14.1253 //w=0.367 //l=0.405 //layer=li \
 //thickness=0.1 //x=67.125 //y=7.585 //x2=66.72 //y2=7.585
r1739 (  829 1079 ) resistor r=4.23183 //w=0.7 //l=0.175 //layer=li \
 //thickness=0.1 //x=66.33 //y=7.41 //x2=66.33 //y2=7.585
r1740 (  829 1153 ) resistor r=56.4706 //w=0.187 //l=0.825 //layer=li \
 //thickness=0.1 //x=66.33 //y=7.41 //x2=66.33 //y2=6.585
r1741 (  826 1078 ) resistor r=5.29055 //w=0.35 //l=0.17 //layer=li \
 //thickness=0.1 //x=65.41 //y=7.585 //x2=65.24 //y2=7.585
r1742 (  826 828 ) resistor r=6.97548 //w=0.367 //l=0.2 //layer=li \
 //thickness=0.1 //x=65.41 //y=7.585 //x2=65.61 //y2=7.585
r1743 (  825 1079 ) resistor r=2.87058 //w=0.35 //l=0.085 //layer=li \
 //thickness=0.1 //x=66.245 //y=7.585 //x2=66.33 //y2=7.585
r1744 (  825 828 ) resistor r=22.1471 //w=0.367 //l=0.635 //layer=li \
 //thickness=0.1 //x=66.245 //y=7.585 //x2=65.61 //y2=7.585
r1745 (  822 1077 ) resistor r=2.87058 //w=0.35 //l=0.085 //layer=li \
 //thickness=0.1 //x=64.545 //y=7.585 //x2=64.46 //y2=7.585
r1746 (  821 1078 ) resistor r=5.29055 //w=0.35 //l=0.17 //layer=li \
 //thickness=0.1 //x=65.07 //y=7.585 //x2=65.24 //y2=7.585
r1747 (  821 822 ) resistor r=18.3106 //w=0.367 //l=0.525 //layer=li \
 //thickness=0.1 //x=65.07 //y=7.585 //x2=64.545 //y2=7.585
r1748 (  815 1077 ) resistor r=4.23183 //w=0.7 //l=0.175 //layer=li \
 //thickness=0.1 //x=64.46 //y=7.41 //x2=64.46 //y2=7.585
r1749 (  815 1152 ) resistor r=33.1979 //w=0.187 //l=0.485 //layer=li \
 //thickness=0.1 //x=64.46 //y=7.41 //x2=64.46 //y2=6.925
r1750 (  812 1076 ) resistor r=2.87058 //w=0.35 //l=0.085 //layer=li \
 //thickness=0.1 //x=63.665 //y=7.585 //x2=63.58 //y2=7.585
r1751 (  812 814 ) resistor r=16.218 //w=0.367 //l=0.465 //layer=li \
 //thickness=0.1 //x=63.665 //y=7.585 //x2=64.13 //y2=7.585
r1752 (  811 1077 ) resistor r=2.87058 //w=0.35 //l=0.085 //layer=li \
 //thickness=0.1 //x=64.375 //y=7.585 //x2=64.46 //y2=7.585
r1753 (  811 814 ) resistor r=8.54496 //w=0.367 //l=0.245 //layer=li \
 //thickness=0.1 //x=64.375 //y=7.585 //x2=64.13 //y2=7.585
r1754 (  805 1076 ) resistor r=4.23183 //w=0.7 //l=0.175 //layer=li \
 //thickness=0.1 //x=63.58 //y=7.41 //x2=63.58 //y2=7.585
r1755 (  805 1151 ) resistor r=33.1979 //w=0.187 //l=0.485 //layer=li \
 //thickness=0.1 //x=63.58 //y=7.41 //x2=63.58 //y2=6.925
r1756 (  802 1075 ) resistor r=2.87058 //w=0.35 //l=0.085 //layer=li \
 //thickness=0.1 //x=62.785 //y=7.585 //x2=62.7 //y2=7.585
r1757 (  802 804 ) resistor r=8.19619 //w=0.367 //l=0.235 //layer=li \
 //thickness=0.1 //x=62.785 //y=7.585 //x2=63.02 //y2=7.585
r1758 (  801 1076 ) resistor r=2.87058 //w=0.35 //l=0.085 //layer=li \
 //thickness=0.1 //x=63.495 //y=7.585 //x2=63.58 //y2=7.585
r1759 (  801 804 ) resistor r=16.5668 //w=0.367 //l=0.475 //layer=li \
 //thickness=0.1 //x=63.495 //y=7.585 //x2=63.02 //y2=7.585
r1760 (  793 1075 ) resistor r=4.23183 //w=0.7 //l=0.175 //layer=li \
 //thickness=0.1 //x=62.7 //y=7.41 //x2=62.7 //y2=7.585
r1761 (  793 1150 ) resistor r=56.4706 //w=0.187 //l=0.825 //layer=li \
 //thickness=0.1 //x=62.7 //y=7.41 //x2=62.7 //y2=6.585
r1762 (  792 1074 ) resistor r=5.29055 //w=0.35 //l=0.17 //layer=li \
 //thickness=0.1 //x=62.08 //y=7.585 //x2=61.91 //y2=7.585
r1763 (  791 1075 ) resistor r=2.87058 //w=0.35 //l=0.085 //layer=li \
 //thickness=0.1 //x=62.615 //y=7.585 //x2=62.7 //y2=7.585
r1764 (  791 792 ) resistor r=18.6594 //w=0.367 //l=0.535 //layer=li \
 //thickness=0.1 //x=62.615 //y=7.585 //x2=62.08 //y2=7.585
r1765 (  786 1073 ) resistor r=2.87058 //w=0.35 //l=0.085 //layer=li \
 //thickness=0.1 //x=60.915 //y=7.585 //x2=60.83 //y2=7.585
r1766 (  786 788 ) resistor r=21.7984 //w=0.367 //l=0.625 //layer=li \
 //thickness=0.1 //x=60.915 //y=7.585 //x2=61.54 //y2=7.585
r1767 (  785 1074 ) resistor r=5.29055 //w=0.35 //l=0.17 //layer=li \
 //thickness=0.1 //x=61.74 //y=7.585 //x2=61.91 //y2=7.585
r1768 (  785 788 ) resistor r=6.97548 //w=0.367 //l=0.2 //layer=li \
 //thickness=0.1 //x=61.74 //y=7.585 //x2=61.54 //y2=7.585
r1769 (  779 1073 ) resistor r=4.23183 //w=0.7 //l=0.175 //layer=li \
 //thickness=0.1 //x=60.83 //y=7.41 //x2=60.83 //y2=7.585
r1770 (  779 1149 ) resistor r=33.1979 //w=0.187 //l=0.485 //layer=li \
 //thickness=0.1 //x=60.83 //y=7.41 //x2=60.83 //y2=6.925
r1771 (  776 1072 ) resistor r=2.87058 //w=0.35 //l=0.085 //layer=li \
 //thickness=0.1 //x=60.035 //y=7.585 //x2=59.95 //y2=7.585
r1772 (  776 778 ) resistor r=13.7766 //w=0.367 //l=0.395 //layer=li \
 //thickness=0.1 //x=60.035 //y=7.585 //x2=60.43 //y2=7.585
r1773 (  775 1073 ) resistor r=2.87058 //w=0.35 //l=0.085 //layer=li \
 //thickness=0.1 //x=60.745 //y=7.585 //x2=60.83 //y2=7.585
r1774 (  775 778 ) resistor r=10.9864 //w=0.367 //l=0.315 //layer=li \
 //thickness=0.1 //x=60.745 //y=7.585 //x2=60.43 //y2=7.585
r1775 (  769 1072 ) resistor r=4.23183 //w=0.7 //l=0.175 //layer=li \
 //thickness=0.1 //x=59.95 //y=7.41 //x2=59.95 //y2=7.585
r1776 (  769 1148 ) resistor r=33.1979 //w=0.187 //l=0.485 //layer=li \
 //thickness=0.1 //x=59.95 //y=7.41 //x2=59.95 //y2=6.925
r1777 (  766 1071 ) resistor r=2.87058 //w=0.35 //l=0.085 //layer=li \
 //thickness=0.1 //x=59.155 //y=7.585 //x2=59.07 //y2=7.585
r1778 (  766 768 ) resistor r=5.75477 //w=0.367 //l=0.165 //layer=li \
 //thickness=0.1 //x=59.155 //y=7.585 //x2=59.32 //y2=7.585
r1779 (  765 1072 ) resistor r=2.87058 //w=0.35 //l=0.085 //layer=li \
 //thickness=0.1 //x=59.865 //y=7.585 //x2=59.95 //y2=7.585
r1780 (  765 768 ) resistor r=19.0082 //w=0.367 //l=0.545 //layer=li \
 //thickness=0.1 //x=59.865 //y=7.585 //x2=59.32 //y2=7.585
r1781 (  759 1071 ) resistor r=4.23183 //w=0.7 //l=0.175 //layer=li \
 //thickness=0.1 //x=59.07 //y=7.41 //x2=59.07 //y2=7.585
r1782 (  759 1147 ) resistor r=33.1979 //w=0.187 //l=0.485 //layer=li \
 //thickness=0.1 //x=59.07 //y=7.41 //x2=59.07 //y2=6.925
r1783 (  758 1070 ) resistor r=2.87058 //w=0.35 //l=0.085 //layer=li \
 //thickness=0.1 //x=58.275 //y=7.585 //x2=58.19 //y2=7.585
r1784 (  757 1071 ) resistor r=2.87058 //w=0.35 //l=0.085 //layer=li \
 //thickness=0.1 //x=58.985 //y=7.585 //x2=59.07 //y2=7.585
r1785 (  757 758 ) resistor r=24.7629 //w=0.367 //l=0.71 //layer=li \
 //thickness=0.1 //x=58.985 //y=7.585 //x2=58.275 //y2=7.585
r1786 (  749 1070 ) resistor r=4.23183 //w=0.7 //l=0.175 //layer=li \
 //thickness=0.1 //x=58.19 //y=7.41 //x2=58.19 //y2=7.585
r1787 (  749 1146 ) resistor r=56.4706 //w=0.187 //l=0.825 //layer=li \
 //thickness=0.1 //x=58.19 //y=7.41 //x2=58.19 //y2=6.585
r1788 (  748 1068 ) resistor r=5.29055 //w=0.35 //l=0.17 //layer=li \
 //thickness=0.1 //x=57.27 //y=7.585 //x2=57.1 //y2=7.585
r1789 (  747 1070 ) resistor r=2.87058 //w=0.35 //l=0.085 //layer=li \
 //thickness=0.1 //x=58.105 //y=7.585 //x2=58.19 //y2=7.585
r1790 (  747 748 ) resistor r=29.1226 //w=0.367 //l=0.835 //layer=li \
 //thickness=0.1 //x=58.105 //y=7.585 //x2=57.27 //y2=7.585
r1791 (  742 1067 ) resistor r=2.87058 //w=0.35 //l=0.085 //layer=li \
 //thickness=0.1 //x=56.105 //y=7.585 //x2=56.02 //y2=7.585
r1792 (  742 744 ) resistor r=21.7984 //w=0.367 //l=0.625 //layer=li \
 //thickness=0.1 //x=56.105 //y=7.585 //x2=56.73 //y2=7.585
r1793 (  741 1068 ) resistor r=5.29055 //w=0.35 //l=0.17 //layer=li \
 //thickness=0.1 //x=56.93 //y=7.585 //x2=57.1 //y2=7.585
r1794 (  741 744 ) resistor r=6.97548 //w=0.367 //l=0.2 //layer=li \
 //thickness=0.1 //x=56.93 //y=7.585 //x2=56.73 //y2=7.585
r1795 (  735 1067 ) resistor r=4.23183 //w=0.7 //l=0.175 //layer=li \
 //thickness=0.1 //x=56.02 //y=7.41 //x2=56.02 //y2=7.585
r1796 (  735 1145 ) resistor r=33.1979 //w=0.187 //l=0.485 //layer=li \
 //thickness=0.1 //x=56.02 //y=7.41 //x2=56.02 //y2=6.925
r1797 (  732 1066 ) resistor r=2.87058 //w=0.35 //l=0.085 //layer=li \
 //thickness=0.1 //x=55.225 //y=7.585 //x2=55.14 //y2=7.585
r1798 (  732 734 ) resistor r=13.7766 //w=0.367 //l=0.395 //layer=li \
 //thickness=0.1 //x=55.225 //y=7.585 //x2=55.62 //y2=7.585
r1799 (  731 1067 ) resistor r=2.87058 //w=0.35 //l=0.085 //layer=li \
 //thickness=0.1 //x=55.935 //y=7.585 //x2=56.02 //y2=7.585
r1800 (  731 734 ) resistor r=10.9864 //w=0.367 //l=0.315 //layer=li \
 //thickness=0.1 //x=55.935 //y=7.585 //x2=55.62 //y2=7.585
r1801 (  725 1066 ) resistor r=4.23183 //w=0.7 //l=0.175 //layer=li \
 //thickness=0.1 //x=55.14 //y=7.41 //x2=55.14 //y2=7.585
r1802 (  725 1144 ) resistor r=33.1979 //w=0.187 //l=0.485 //layer=li \
 //thickness=0.1 //x=55.14 //y=7.41 //x2=55.14 //y2=6.925
r1803 (  722 1065 ) resistor r=2.87058 //w=0.35 //l=0.085 //layer=li \
 //thickness=0.1 //x=54.345 //y=7.585 //x2=54.26 //y2=7.585
r1804 (  722 724 ) resistor r=5.75477 //w=0.367 //l=0.165 //layer=li \
 //thickness=0.1 //x=54.345 //y=7.585 //x2=54.51 //y2=7.585
r1805 (  721 1066 ) resistor r=2.87058 //w=0.35 //l=0.085 //layer=li \
 //thickness=0.1 //x=55.055 //y=7.585 //x2=55.14 //y2=7.585
r1806 (  721 724 ) resistor r=19.0082 //w=0.367 //l=0.545 //layer=li \
 //thickness=0.1 //x=55.055 //y=7.585 //x2=54.51 //y2=7.585
r1807 (  715 1065 ) resistor r=4.23183 //w=0.7 //l=0.175 //layer=li \
 //thickness=0.1 //x=54.26 //y=7.41 //x2=54.26 //y2=7.585
r1808 (  715 1143 ) resistor r=33.1979 //w=0.187 //l=0.485 //layer=li \
 //thickness=0.1 //x=54.26 //y=7.41 //x2=54.26 //y2=6.925
r1809 (  714 1064 ) resistor r=2.87058 //w=0.35 //l=0.085 //layer=li \
 //thickness=0.1 //x=53.465 //y=7.585 //x2=53.38 //y2=7.585
r1810 (  713 1065 ) resistor r=2.87058 //w=0.35 //l=0.085 //layer=li \
 //thickness=0.1 //x=54.175 //y=7.585 //x2=54.26 //y2=7.585
r1811 (  713 714 ) resistor r=24.7629 //w=0.367 //l=0.71 //layer=li \
 //thickness=0.1 //x=54.175 //y=7.585 //x2=53.465 //y2=7.585
r1812 (  705 1064 ) resistor r=4.23183 //w=0.7 //l=0.175 //layer=li \
 //thickness=0.1 //x=53.38 //y=7.41 //x2=53.38 //y2=7.585
r1813 (  705 1142 ) resistor r=56.4706 //w=0.187 //l=0.825 //layer=li \
 //thickness=0.1 //x=53.38 //y=7.41 //x2=53.38 //y2=6.585
r1814 (  704 1062 ) resistor r=5.29055 //w=0.35 //l=0.17 //layer=li \
 //thickness=0.1 //x=52.46 //y=7.585 //x2=52.29 //y2=7.585
r1815 (  703 1064 ) resistor r=2.87058 //w=0.35 //l=0.085 //layer=li \
 //thickness=0.1 //x=53.295 //y=7.585 //x2=53.38 //y2=7.585
r1816 (  703 704 ) resistor r=29.1226 //w=0.367 //l=0.835 //layer=li \
 //thickness=0.1 //x=53.295 //y=7.585 //x2=52.46 //y2=7.585
r1817 (  698 1061 ) resistor r=2.87058 //w=0.35 //l=0.085 //layer=li \
 //thickness=0.1 //x=51.595 //y=7.585 //x2=51.51 //y2=7.585
r1818 (  698 700 ) resistor r=11.3351 //w=0.367 //l=0.325 //layer=li \
 //thickness=0.1 //x=51.595 //y=7.585 //x2=51.92 //y2=7.585
r1819 (  697 1062 ) resistor r=5.29055 //w=0.35 //l=0.17 //layer=li \
 //thickness=0.1 //x=52.12 //y=7.585 //x2=52.29 //y2=7.585
r1820 (  697 700 ) resistor r=6.97548 //w=0.367 //l=0.2 //layer=li \
 //thickness=0.1 //x=52.12 //y=7.585 //x2=51.92 //y2=7.585
r1821 (  691 1061 ) resistor r=4.23183 //w=0.7 //l=0.175 //layer=li \
 //thickness=0.1 //x=51.51 //y=7.41 //x2=51.51 //y2=7.585
r1822 (  691 1141 ) resistor r=33.1979 //w=0.187 //l=0.485 //layer=li \
 //thickness=0.1 //x=51.51 //y=7.41 //x2=51.51 //y2=6.925
r1823 (  688 1060 ) resistor r=2.87058 //w=0.35 //l=0.085 //layer=li \
 //thickness=0.1 //x=50.715 //y=7.585 //x2=50.63 //y2=7.585
r1824 (  688 690 ) resistor r=3.31335 //w=0.367 //l=0.095 //layer=li \
 //thickness=0.1 //x=50.715 //y=7.585 //x2=50.81 //y2=7.585
r1825 (  687 1061 ) resistor r=2.87058 //w=0.35 //l=0.085 //layer=li \
 //thickness=0.1 //x=51.425 //y=7.585 //x2=51.51 //y2=7.585
r1826 (  687 690 ) resistor r=21.4496 //w=0.367 //l=0.615 //layer=li \
 //thickness=0.1 //x=51.425 //y=7.585 //x2=50.81 //y2=7.585
r1827 (  681 1060 ) resistor r=4.23183 //w=0.7 //l=0.175 //layer=li \
 //thickness=0.1 //x=50.63 //y=7.41 //x2=50.63 //y2=7.585
r1828 (  681 1140 ) resistor r=33.1979 //w=0.187 //l=0.485 //layer=li \
 //thickness=0.1 //x=50.63 //y=7.41 //x2=50.63 //y2=6.925
r1829 (  680 1059 ) resistor r=2.87058 //w=0.35 //l=0.085 //layer=li \
 //thickness=0.1 //x=49.835 //y=7.585 //x2=49.75 //y2=7.585
r1830 (  679 1060 ) resistor r=2.87058 //w=0.35 //l=0.085 //layer=li \
 //thickness=0.1 //x=50.545 //y=7.585 //x2=50.63 //y2=7.585
r1831 (  679 680 ) resistor r=24.7629 //w=0.367 //l=0.71 //layer=li \
 //thickness=0.1 //x=50.545 //y=7.585 //x2=49.835 //y2=7.585
r1832 (  671 1059 ) resistor r=4.23183 //w=0.7 //l=0.175 //layer=li \
 //thickness=0.1 //x=49.75 //y=7.41 //x2=49.75 //y2=7.585
r1833 (  671 1139 ) resistor r=56.4706 //w=0.187 //l=0.825 //layer=li \
 //thickness=0.1 //x=49.75 //y=7.41 //x2=49.75 //y2=6.585
r1834 (  670 1057 ) resistor r=5.29055 //w=0.35 //l=0.17 //layer=li \
 //thickness=0.1 //x=49.13 //y=7.585 //x2=48.96 //y2=7.585
r1835 (  669 1059 ) resistor r=2.87058 //w=0.35 //l=0.085 //layer=li \
 //thickness=0.1 //x=49.665 //y=7.585 //x2=49.75 //y2=7.585
r1836 (  669 670 ) resistor r=18.6594 //w=0.367 //l=0.535 //layer=li \
 //thickness=0.1 //x=49.665 //y=7.585 //x2=49.13 //y2=7.585
r1837 (  664 1056 ) resistor r=2.87058 //w=0.35 //l=0.085 //layer=li \
 //thickness=0.1 //x=47.965 //y=7.585 //x2=47.88 //y2=7.585
r1838 (  664 666 ) resistor r=8.89373 //w=0.367 //l=0.255 //layer=li \
 //thickness=0.1 //x=47.965 //y=7.585 //x2=48.22 //y2=7.585
r1839 (  663 1057 ) resistor r=5.29055 //w=0.35 //l=0.17 //layer=li \
 //thickness=0.1 //x=48.79 //y=7.585 //x2=48.96 //y2=7.585
r1840 (  663 666 ) resistor r=19.8801 //w=0.367 //l=0.57 //layer=li \
 //thickness=0.1 //x=48.79 //y=7.585 //x2=48.22 //y2=7.585
r1841 (  657 1056 ) resistor r=4.23183 //w=0.7 //l=0.175 //layer=li \
 //thickness=0.1 //x=47.88 //y=7.41 //x2=47.88 //y2=7.585
r1842 (  657 1138 ) resistor r=33.1979 //w=0.187 //l=0.485 //layer=li \
 //thickness=0.1 //x=47.88 //y=7.41 //x2=47.88 //y2=6.925
r1843 (  654 1055 ) resistor r=2.87058 //w=0.35 //l=0.085 //layer=li \
 //thickness=0.1 //x=47.085 //y=7.585 //x2=47 //y2=7.585
r1844 (  654 656 ) resistor r=0.871935 //w=0.367 //l=0.025 //layer=li \
 //thickness=0.1 //x=47.085 //y=7.585 //x2=47.11 //y2=7.585
r1845 (  653 1056 ) resistor r=2.87058 //w=0.35 //l=0.085 //layer=li \
 //thickness=0.1 //x=47.795 //y=7.585 //x2=47.88 //y2=7.585
r1846 (  653 656 ) resistor r=23.891 //w=0.367 //l=0.685 //layer=li \
 //thickness=0.1 //x=47.795 //y=7.585 //x2=47.11 //y2=7.585
r1847 (  647 1055 ) resistor r=4.23183 //w=0.7 //l=0.175 //layer=li \
 //thickness=0.1 //x=47 //y=7.41 //x2=47 //y2=7.585
r1848 (  647 1137 ) resistor r=33.1979 //w=0.187 //l=0.485 //layer=li \
 //thickness=0.1 //x=47 //y=7.41 //x2=47 //y2=6.925
r1849 (  646 1054 ) resistor r=2.87058 //w=0.35 //l=0.085 //layer=li \
 //thickness=0.1 //x=46.205 //y=7.585 //x2=46.12 //y2=7.585
r1850 (  645 1055 ) resistor r=2.87058 //w=0.35 //l=0.085 //layer=li \
 //thickness=0.1 //x=46.915 //y=7.585 //x2=47 //y2=7.585
r1851 (  645 646 ) resistor r=24.7629 //w=0.367 //l=0.71 //layer=li \
 //thickness=0.1 //x=46.915 //y=7.585 //x2=46.205 //y2=7.585
r1852 (  639 1054 ) resistor r=4.23183 //w=0.7 //l=0.175 //layer=li \
 //thickness=0.1 //x=46.12 //y=7.41 //x2=46.12 //y2=7.585
r1853 (  639 1136 ) resistor r=33.1979 //w=0.187 //l=0.485 //layer=li \
 //thickness=0.1 //x=46.12 //y=7.41 //x2=46.12 //y2=6.925
r1854 (  636 1053 ) resistor r=2.87058 //w=0.35 //l=0.085 //layer=li \
 //thickness=0.1 //x=45.325 //y=7.585 //x2=45.24 //y2=7.585
r1855 (  636 638 ) resistor r=23.5422 //w=0.367 //l=0.675 //layer=li \
 //thickness=0.1 //x=45.325 //y=7.585 //x2=46 //y2=7.585
r1856 (  635 1054 ) resistor r=2.87058 //w=0.35 //l=0.085 //layer=li \
 //thickness=0.1 //x=46.035 //y=7.585 //x2=46.12 //y2=7.585
r1857 (  635 638 ) resistor r=1.22071 //w=0.367 //l=0.035 //layer=li \
 //thickness=0.1 //x=46.035 //y=7.585 //x2=46 //y2=7.585
r1858 (  627 1053 ) resistor r=4.23183 //w=0.7 //l=0.175 //layer=li \
 //thickness=0.1 //x=45.24 //y=7.41 //x2=45.24 //y2=7.585
r1859 (  627 1135 ) resistor r=56.4706 //w=0.187 //l=0.825 //layer=li \
 //thickness=0.1 //x=45.24 //y=7.41 //x2=45.24 //y2=6.585
r1860 (  624 1052 ) resistor r=5.29055 //w=0.35 //l=0.17 //layer=li \
 //thickness=0.1 //x=44.32 //y=7.585 //x2=44.15 //y2=7.585
r1861 (  624 626 ) resistor r=19.8801 //w=0.367 //l=0.57 //layer=li \
 //thickness=0.1 //x=44.32 //y=7.585 //x2=44.89 //y2=7.585
r1862 (  623 1053 ) resistor r=2.87058 //w=0.35 //l=0.085 //layer=li \
 //thickness=0.1 //x=45.155 //y=7.585 //x2=45.24 //y2=7.585
r1863 (  623 626 ) resistor r=9.24251 //w=0.367 //l=0.265 //layer=li \
 //thickness=0.1 //x=45.155 //y=7.585 //x2=44.89 //y2=7.585
r1864 (  618 1051 ) resistor r=2.87058 //w=0.35 //l=0.085 //layer=li \
 //thickness=0.1 //x=43.155 //y=7.585 //x2=43.07 //y2=7.585
r1865 (  618 620 ) resistor r=8.89373 //w=0.367 //l=0.255 //layer=li \
 //thickness=0.1 //x=43.155 //y=7.585 //x2=43.41 //y2=7.585
r1866 (  617 1052 ) resistor r=5.29055 //w=0.35 //l=0.17 //layer=li \
 //thickness=0.1 //x=43.98 //y=7.585 //x2=44.15 //y2=7.585
r1867 (  617 620 ) resistor r=19.8801 //w=0.367 //l=0.57 //layer=li \
 //thickness=0.1 //x=43.98 //y=7.585 //x2=43.41 //y2=7.585
r1868 (  611 1051 ) resistor r=4.23183 //w=0.7 //l=0.175 //layer=li \
 //thickness=0.1 //x=43.07 //y=7.41 //x2=43.07 //y2=7.585
r1869 (  611 1134 ) resistor r=33.1979 //w=0.187 //l=0.485 //layer=li \
 //thickness=0.1 //x=43.07 //y=7.41 //x2=43.07 //y2=6.925
r1870 (  608 1050 ) resistor r=2.87058 //w=0.35 //l=0.085 //layer=li \
 //thickness=0.1 //x=42.275 //y=7.585 //x2=42.19 //y2=7.585
r1871 (  608 610 ) resistor r=0.871935 //w=0.367 //l=0.025 //layer=li \
 //thickness=0.1 //x=42.275 //y=7.585 //x2=42.3 //y2=7.585
r1872 (  607 1051 ) resistor r=2.87058 //w=0.35 //l=0.085 //layer=li \
 //thickness=0.1 //x=42.985 //y=7.585 //x2=43.07 //y2=7.585
r1873 (  607 610 ) resistor r=23.891 //w=0.367 //l=0.685 //layer=li \
 //thickness=0.1 //x=42.985 //y=7.585 //x2=42.3 //y2=7.585
r1874 (  601 1050 ) resistor r=4.23183 //w=0.7 //l=0.175 //layer=li \
 //thickness=0.1 //x=42.19 //y=7.41 //x2=42.19 //y2=7.585
r1875 (  601 1133 ) resistor r=33.1979 //w=0.187 //l=0.485 //layer=li \
 //thickness=0.1 //x=42.19 //y=7.41 //x2=42.19 //y2=6.925
r1876 (  600 1049 ) resistor r=2.87058 //w=0.35 //l=0.085 //layer=li \
 //thickness=0.1 //x=41.395 //y=7.585 //x2=41.31 //y2=7.585
r1877 (  599 1050 ) resistor r=2.87058 //w=0.35 //l=0.085 //layer=li \
 //thickness=0.1 //x=42.105 //y=7.585 //x2=42.19 //y2=7.585
r1878 (  599 600 ) resistor r=24.7629 //w=0.367 //l=0.71 //layer=li \
 //thickness=0.1 //x=42.105 //y=7.585 //x2=41.395 //y2=7.585
r1879 (  593 1049 ) resistor r=4.23183 //w=0.7 //l=0.175 //layer=li \
 //thickness=0.1 //x=41.31 //y=7.41 //x2=41.31 //y2=7.585
r1880 (  593 1132 ) resistor r=33.1979 //w=0.187 //l=0.485 //layer=li \
 //thickness=0.1 //x=41.31 //y=7.41 //x2=41.31 //y2=6.925
r1881 (  590 1048 ) resistor r=2.87058 //w=0.35 //l=0.085 //layer=li \
 //thickness=0.1 //x=40.515 //y=7.585 //x2=40.43 //y2=7.585
r1882 (  590 592 ) resistor r=23.5422 //w=0.367 //l=0.675 //layer=li \
 //thickness=0.1 //x=40.515 //y=7.585 //x2=41.19 //y2=7.585
r1883 (  589 1049 ) resistor r=2.87058 //w=0.35 //l=0.085 //layer=li \
 //thickness=0.1 //x=41.225 //y=7.585 //x2=41.31 //y2=7.585
r1884 (  589 592 ) resistor r=1.22071 //w=0.367 //l=0.035 //layer=li \
 //thickness=0.1 //x=41.225 //y=7.585 //x2=41.19 //y2=7.585
r1885 (  581 1048 ) resistor r=4.23183 //w=0.7 //l=0.175 //layer=li \
 //thickness=0.1 //x=40.43 //y=7.41 //x2=40.43 //y2=7.585
r1886 (  581 1131 ) resistor r=56.4706 //w=0.187 //l=0.825 //layer=li \
 //thickness=0.1 //x=40.43 //y=7.41 //x2=40.43 //y2=6.585
r1887 (  578 1047 ) resistor r=5.29055 //w=0.35 //l=0.17 //layer=li \
 //thickness=0.1 //x=39.51 //y=7.585 //x2=39.34 //y2=7.585
r1888 (  578 580 ) resistor r=19.8801 //w=0.367 //l=0.57 //layer=li \
 //thickness=0.1 //x=39.51 //y=7.585 //x2=40.08 //y2=7.585
r1889 (  577 1048 ) resistor r=2.87058 //w=0.35 //l=0.085 //layer=li \
 //thickness=0.1 //x=40.345 //y=7.585 //x2=40.43 //y2=7.585
r1890 (  577 580 ) resistor r=9.24251 //w=0.367 //l=0.265 //layer=li \
 //thickness=0.1 //x=40.345 //y=7.585 //x2=40.08 //y2=7.585
r1891 (  574 1046 ) resistor r=2.87058 //w=0.35 //l=0.085 //layer=li \
 //thickness=0.1 //x=38.645 //y=7.585 //x2=38.56 //y2=7.585
r1892 (  573 1047 ) resistor r=5.29055 //w=0.35 //l=0.17 //layer=li \
 //thickness=0.1 //x=39.17 //y=7.585 //x2=39.34 //y2=7.585
r1893 (  573 574 ) resistor r=18.3106 //w=0.367 //l=0.525 //layer=li \
 //thickness=0.1 //x=39.17 //y=7.585 //x2=38.645 //y2=7.585
r1894 (  567 1046 ) resistor r=4.23183 //w=0.7 //l=0.175 //layer=li \
 //thickness=0.1 //x=38.56 //y=7.41 //x2=38.56 //y2=7.585
r1895 (  567 1130 ) resistor r=33.1979 //w=0.187 //l=0.485 //layer=li \
 //thickness=0.1 //x=38.56 //y=7.41 //x2=38.56 //y2=6.925
r1896 (  566 1044 ) resistor r=2.87058 //w=0.35 //l=0.085 //layer=li \
 //thickness=0.1 //x=37.765 //y=7.585 //x2=37.68 //y2=7.585
r1897 (  565 1046 ) resistor r=2.87058 //w=0.35 //l=0.085 //layer=li \
 //thickness=0.1 //x=38.475 //y=7.585 //x2=38.56 //y2=7.585
r1898 (  565 566 ) resistor r=24.7629 //w=0.367 //l=0.71 //layer=li \
 //thickness=0.1 //x=38.475 //y=7.585 //x2=37.765 //y2=7.585
r1899 (  559 1044 ) resistor r=4.23183 //w=0.7 //l=0.175 //layer=li \
 //thickness=0.1 //x=37.68 //y=7.41 //x2=37.68 //y2=7.585
r1900 (  559 1129 ) resistor r=33.1979 //w=0.187 //l=0.485 //layer=li \
 //thickness=0.1 //x=37.68 //y=7.41 //x2=37.68 //y2=6.925
r1901 (  556 1043 ) resistor r=2.87058 //w=0.35 //l=0.085 //layer=li \
 //thickness=0.1 //x=36.885 //y=7.585 //x2=36.8 //y2=7.585
r1902 (  556 558 ) resistor r=21.1008 //w=0.367 //l=0.605 //layer=li \
 //thickness=0.1 //x=36.885 //y=7.585 //x2=37.49 //y2=7.585
r1903 (  555 1044 ) resistor r=2.87058 //w=0.35 //l=0.085 //layer=li \
 //thickness=0.1 //x=37.595 //y=7.585 //x2=37.68 //y2=7.585
r1904 (  555 558 ) resistor r=3.66213 //w=0.367 //l=0.105 //layer=li \
 //thickness=0.1 //x=37.595 //y=7.585 //x2=37.49 //y2=7.585
r1905 (  547 1043 ) resistor r=4.23183 //w=0.7 //l=0.175 //layer=li \
 //thickness=0.1 //x=36.8 //y=7.41 //x2=36.8 //y2=7.585
r1906 (  547 1128 ) resistor r=56.4706 //w=0.187 //l=0.825 //layer=li \
 //thickness=0.1 //x=36.8 //y=7.41 //x2=36.8 //y2=6.585
r1907 (  544 1042 ) resistor r=5.29055 //w=0.35 //l=0.17 //layer=li \
 //thickness=0.1 //x=36.18 //y=7.585 //x2=36.01 //y2=7.585
r1908 (  544 546 ) resistor r=6.97548 //w=0.367 //l=0.2 //layer=li \
 //thickness=0.1 //x=36.18 //y=7.585 //x2=36.38 //y2=7.585
r1909 (  543 1043 ) resistor r=2.87058 //w=0.35 //l=0.085 //layer=li \
 //thickness=0.1 //x=36.715 //y=7.585 //x2=36.8 //y2=7.585
r1910 (  543 546 ) resistor r=11.6839 //w=0.367 //l=0.335 //layer=li \
 //thickness=0.1 //x=36.715 //y=7.585 //x2=36.38 //y2=7.585
r1911 (  540 1041 ) resistor r=2.87058 //w=0.35 //l=0.085 //layer=li \
 //thickness=0.1 //x=35.015 //y=7.585 //x2=34.93 //y2=7.585
r1912 (  539 1042 ) resistor r=5.29055 //w=0.35 //l=0.17 //layer=li \
 //thickness=0.1 //x=35.84 //y=7.585 //x2=36.01 //y2=7.585
r1913 (  539 540 ) resistor r=28.7738 //w=0.367 //l=0.825 //layer=li \
 //thickness=0.1 //x=35.84 //y=7.585 //x2=35.015 //y2=7.585
r1914 (  533 1041 ) resistor r=4.23183 //w=0.7 //l=0.175 //layer=li \
 //thickness=0.1 //x=34.93 //y=7.41 //x2=34.93 //y2=7.585
r1915 (  533 1127 ) resistor r=33.1979 //w=0.187 //l=0.485 //layer=li \
 //thickness=0.1 //x=34.93 //y=7.41 //x2=34.93 //y2=6.925
r1916 (  532 1039 ) resistor r=2.87058 //w=0.35 //l=0.085 //layer=li \
 //thickness=0.1 //x=34.135 //y=7.585 //x2=34.05 //y2=7.585
r1917 (  531 1041 ) resistor r=2.87058 //w=0.35 //l=0.085 //layer=li \
 //thickness=0.1 //x=34.845 //y=7.585 //x2=34.93 //y2=7.585
r1918 (  531 532 ) resistor r=24.7629 //w=0.367 //l=0.71 //layer=li \
 //thickness=0.1 //x=34.845 //y=7.585 //x2=34.135 //y2=7.585
r1919 (  525 1039 ) resistor r=4.23183 //w=0.7 //l=0.175 //layer=li \
 //thickness=0.1 //x=34.05 //y=7.41 //x2=34.05 //y2=7.585
r1920 (  525 1126 ) resistor r=33.1979 //w=0.187 //l=0.485 //layer=li \
 //thickness=0.1 //x=34.05 //y=7.41 //x2=34.05 //y2=6.925
r1921 (  522 1038 ) resistor r=2.87058 //w=0.35 //l=0.085 //layer=li \
 //thickness=0.1 //x=33.255 //y=7.585 //x2=33.17 //y2=7.585
r1922 (  522 524 ) resistor r=18.6594 //w=0.367 //l=0.535 //layer=li \
 //thickness=0.1 //x=33.255 //y=7.585 //x2=33.79 //y2=7.585
r1923 (  521 1039 ) resistor r=2.87058 //w=0.35 //l=0.085 //layer=li \
 //thickness=0.1 //x=33.965 //y=7.585 //x2=34.05 //y2=7.585
r1924 (  521 524 ) resistor r=6.10354 //w=0.367 //l=0.175 //layer=li \
 //thickness=0.1 //x=33.965 //y=7.585 //x2=33.79 //y2=7.585
r1925 (  515 1038 ) resistor r=4.23183 //w=0.7 //l=0.175 //layer=li \
 //thickness=0.1 //x=33.17 //y=7.41 //x2=33.17 //y2=7.585
r1926 (  515 1125 ) resistor r=33.1979 //w=0.187 //l=0.485 //layer=li \
 //thickness=0.1 //x=33.17 //y=7.41 //x2=33.17 //y2=6.925
r1927 (  512 1037 ) resistor r=2.87058 //w=0.35 //l=0.085 //layer=li \
 //thickness=0.1 //x=32.375 //y=7.585 //x2=32.29 //y2=7.585
r1928 (  512 514 ) resistor r=10.6376 //w=0.367 //l=0.305 //layer=li \
 //thickness=0.1 //x=32.375 //y=7.585 //x2=32.68 //y2=7.585
r1929 (  511 1038 ) resistor r=2.87058 //w=0.35 //l=0.085 //layer=li \
 //thickness=0.1 //x=33.085 //y=7.585 //x2=33.17 //y2=7.585
r1930 (  511 514 ) resistor r=14.1253 //w=0.367 //l=0.405 //layer=li \
 //thickness=0.1 //x=33.085 //y=7.585 //x2=32.68 //y2=7.585
r1931 (  503 1037 ) resistor r=4.23183 //w=0.7 //l=0.175 //layer=li \
 //thickness=0.1 //x=32.29 //y=7.41 //x2=32.29 //y2=7.585
r1932 (  503 1124 ) resistor r=56.4706 //w=0.187 //l=0.825 //layer=li \
 //thickness=0.1 //x=32.29 //y=7.41 //x2=32.29 //y2=6.585
r1933 (  500 1036 ) resistor r=5.29055 //w=0.35 //l=0.17 //layer=li \
 //thickness=0.1 //x=31.37 //y=7.585 //x2=31.2 //y2=7.585
r1934 (  500 502 ) resistor r=6.97548 //w=0.367 //l=0.2 //layer=li \
 //thickness=0.1 //x=31.37 //y=7.585 //x2=31.57 //y2=7.585
r1935 (  499 1037 ) resistor r=2.87058 //w=0.35 //l=0.085 //layer=li \
 //thickness=0.1 //x=32.205 //y=7.585 //x2=32.29 //y2=7.585
r1936 (  499 502 ) resistor r=22.1471 //w=0.367 //l=0.635 //layer=li \
 //thickness=0.1 //x=32.205 //y=7.585 //x2=31.57 //y2=7.585
r1937 (  496 1035 ) resistor r=2.87058 //w=0.35 //l=0.085 //layer=li \
 //thickness=0.1 //x=30.205 //y=7.585 //x2=30.12 //y2=7.585
r1938 (  495 1036 ) resistor r=5.29055 //w=0.35 //l=0.17 //layer=li \
 //thickness=0.1 //x=31.03 //y=7.585 //x2=31.2 //y2=7.585
r1939 (  495 496 ) resistor r=28.7738 //w=0.367 //l=0.825 //layer=li \
 //thickness=0.1 //x=31.03 //y=7.585 //x2=30.205 //y2=7.585
r1940 (  489 1035 ) resistor r=4.23183 //w=0.7 //l=0.175 //layer=li \
 //thickness=0.1 //x=30.12 //y=7.41 //x2=30.12 //y2=7.585
r1941 (  489 1123 ) resistor r=33.1979 //w=0.187 //l=0.485 //layer=li \
 //thickness=0.1 //x=30.12 //y=7.41 //x2=30.12 //y2=6.925
r1942 (  488 1033 ) resistor r=2.87058 //w=0.35 //l=0.085 //layer=li \
 //thickness=0.1 //x=29.325 //y=7.585 //x2=29.24 //y2=7.585
r1943 (  487 1035 ) resistor r=2.87058 //w=0.35 //l=0.085 //layer=li \
 //thickness=0.1 //x=30.035 //y=7.585 //x2=30.12 //y2=7.585
r1944 (  487 488 ) resistor r=24.7629 //w=0.367 //l=0.71 //layer=li \
 //thickness=0.1 //x=30.035 //y=7.585 //x2=29.325 //y2=7.585
r1945 (  481 1033 ) resistor r=4.23183 //w=0.7 //l=0.175 //layer=li \
 //thickness=0.1 //x=29.24 //y=7.41 //x2=29.24 //y2=7.585
r1946 (  481 1122 ) resistor r=33.1979 //w=0.187 //l=0.485 //layer=li \
 //thickness=0.1 //x=29.24 //y=7.41 //x2=29.24 //y2=6.925
r1947 (  478 1032 ) resistor r=2.87058 //w=0.35 //l=0.085 //layer=li \
 //thickness=0.1 //x=28.445 //y=7.585 //x2=28.36 //y2=7.585
r1948 (  478 480 ) resistor r=18.6594 //w=0.367 //l=0.535 //layer=li \
 //thickness=0.1 //x=28.445 //y=7.585 //x2=28.98 //y2=7.585
r1949 (  477 1033 ) resistor r=2.87058 //w=0.35 //l=0.085 //layer=li \
 //thickness=0.1 //x=29.155 //y=7.585 //x2=29.24 //y2=7.585
r1950 (  477 480 ) resistor r=6.10354 //w=0.367 //l=0.175 //layer=li \
 //thickness=0.1 //x=29.155 //y=7.585 //x2=28.98 //y2=7.585
r1951 (  471 1032 ) resistor r=4.23183 //w=0.7 //l=0.175 //layer=li \
 //thickness=0.1 //x=28.36 //y=7.41 //x2=28.36 //y2=7.585
r1952 (  471 1121 ) resistor r=33.1979 //w=0.187 //l=0.485 //layer=li \
 //thickness=0.1 //x=28.36 //y=7.41 //x2=28.36 //y2=6.925
r1953 (  468 1031 ) resistor r=2.87058 //w=0.35 //l=0.085 //layer=li \
 //thickness=0.1 //x=27.565 //y=7.585 //x2=27.48 //y2=7.585
r1954 (  468 470 ) resistor r=10.6376 //w=0.367 //l=0.305 //layer=li \
 //thickness=0.1 //x=27.565 //y=7.585 //x2=27.87 //y2=7.585
r1955 (  467 1032 ) resistor r=2.87058 //w=0.35 //l=0.085 //layer=li \
 //thickness=0.1 //x=28.275 //y=7.585 //x2=28.36 //y2=7.585
r1956 (  467 470 ) resistor r=14.1253 //w=0.367 //l=0.405 //layer=li \
 //thickness=0.1 //x=28.275 //y=7.585 //x2=27.87 //y2=7.585
r1957 (  459 1031 ) resistor r=4.23183 //w=0.7 //l=0.175 //layer=li \
 //thickness=0.1 //x=27.48 //y=7.41 //x2=27.48 //y2=7.585
r1958 (  459 1120 ) resistor r=56.4706 //w=0.187 //l=0.825 //layer=li \
 //thickness=0.1 //x=27.48 //y=7.41 //x2=27.48 //y2=6.585
r1959 (  456 1030 ) resistor r=5.29055 //w=0.35 //l=0.17 //layer=li \
 //thickness=0.1 //x=26.56 //y=7.585 //x2=26.39 //y2=7.585
r1960 (  456 458 ) resistor r=6.97548 //w=0.367 //l=0.2 //layer=li \
 //thickness=0.1 //x=26.56 //y=7.585 //x2=26.76 //y2=7.585
r1961 (  455 1031 ) resistor r=2.87058 //w=0.35 //l=0.085 //layer=li \
 //thickness=0.1 //x=27.395 //y=7.585 //x2=27.48 //y2=7.585
r1962 (  455 458 ) resistor r=22.1471 //w=0.367 //l=0.635 //layer=li \
 //thickness=0.1 //x=27.395 //y=7.585 //x2=26.76 //y2=7.585
r1963 (  452 1029 ) resistor r=2.87058 //w=0.35 //l=0.085 //layer=li \
 //thickness=0.1 //x=25.695 //y=7.585 //x2=25.61 //y2=7.585
r1964 (  451 1030 ) resistor r=5.29055 //w=0.35 //l=0.17 //layer=li \
 //thickness=0.1 //x=26.22 //y=7.585 //x2=26.39 //y2=7.585
r1965 (  451 452 ) resistor r=18.3106 //w=0.367 //l=0.525 //layer=li \
 //thickness=0.1 //x=26.22 //y=7.585 //x2=25.695 //y2=7.585
r1966 (  445 1029 ) resistor r=4.23183 //w=0.7 //l=0.175 //layer=li \
 //thickness=0.1 //x=25.61 //y=7.41 //x2=25.61 //y2=7.585
r1967 (  445 1119 ) resistor r=33.1979 //w=0.187 //l=0.485 //layer=li \
 //thickness=0.1 //x=25.61 //y=7.41 //x2=25.61 //y2=6.925
r1968 (  442 1028 ) resistor r=2.87058 //w=0.35 //l=0.085 //layer=li \
 //thickness=0.1 //x=24.815 //y=7.585 //x2=24.73 //y2=7.585
r1969 (  442 444 ) resistor r=16.218 //w=0.367 //l=0.465 //layer=li \
 //thickness=0.1 //x=24.815 //y=7.585 //x2=25.28 //y2=7.585
r1970 (  441 1029 ) resistor r=2.87058 //w=0.35 //l=0.085 //layer=li \
 //thickness=0.1 //x=25.525 //y=7.585 //x2=25.61 //y2=7.585
r1971 (  441 444 ) resistor r=8.54496 //w=0.367 //l=0.245 //layer=li \
 //thickness=0.1 //x=25.525 //y=7.585 //x2=25.28 //y2=7.585
r1972 (  435 1028 ) resistor r=4.23183 //w=0.7 //l=0.175 //layer=li \
 //thickness=0.1 //x=24.73 //y=7.41 //x2=24.73 //y2=7.585
r1973 (  435 1118 ) resistor r=33.1979 //w=0.187 //l=0.485 //layer=li \
 //thickness=0.1 //x=24.73 //y=7.41 //x2=24.73 //y2=6.925
r1974 (  432 1027 ) resistor r=2.87058 //w=0.35 //l=0.085 //layer=li \
 //thickness=0.1 //x=23.935 //y=7.585 //x2=23.85 //y2=7.585
r1975 (  432 434 ) resistor r=8.19619 //w=0.367 //l=0.235 //layer=li \
 //thickness=0.1 //x=23.935 //y=7.585 //x2=24.17 //y2=7.585
r1976 (  431 1028 ) resistor r=2.87058 //w=0.35 //l=0.085 //layer=li \
 //thickness=0.1 //x=24.645 //y=7.585 //x2=24.73 //y2=7.585
r1977 (  431 434 ) resistor r=16.5668 //w=0.367 //l=0.475 //layer=li \
 //thickness=0.1 //x=24.645 //y=7.585 //x2=24.17 //y2=7.585
r1978 (  423 1027 ) resistor r=4.23183 //w=0.7 //l=0.175 //layer=li \
 //thickness=0.1 //x=23.85 //y=7.41 //x2=23.85 //y2=7.585
r1979 (  423 1117 ) resistor r=56.4706 //w=0.187 //l=0.825 //layer=li \
 //thickness=0.1 //x=23.85 //y=7.41 //x2=23.85 //y2=6.585
r1980 (  422 1026 ) resistor r=5.29055 //w=0.35 //l=0.17 //layer=li \
 //thickness=0.1 //x=23.23 //y=7.585 //x2=23.06 //y2=7.585
r1981 (  421 1027 ) resistor r=2.87058 //w=0.35 //l=0.085 //layer=li \
 //thickness=0.1 //x=23.765 //y=7.585 //x2=23.85 //y2=7.585
r1982 (  421 422 ) resistor r=18.6594 //w=0.367 //l=0.535 //layer=li \
 //thickness=0.1 //x=23.765 //y=7.585 //x2=23.23 //y2=7.585
r1983 (  416 1025 ) resistor r=2.87058 //w=0.35 //l=0.085 //layer=li \
 //thickness=0.1 //x=22.065 //y=7.585 //x2=21.98 //y2=7.585
r1984 (  416 418 ) resistor r=21.7984 //w=0.367 //l=0.625 //layer=li \
 //thickness=0.1 //x=22.065 //y=7.585 //x2=22.69 //y2=7.585
r1985 (  415 1026 ) resistor r=5.29055 //w=0.35 //l=0.17 //layer=li \
 //thickness=0.1 //x=22.89 //y=7.585 //x2=23.06 //y2=7.585
r1986 (  415 418 ) resistor r=6.97548 //w=0.367 //l=0.2 //layer=li \
 //thickness=0.1 //x=22.89 //y=7.585 //x2=22.69 //y2=7.585
r1987 (  409 1025 ) resistor r=4.23183 //w=0.7 //l=0.175 //layer=li \
 //thickness=0.1 //x=21.98 //y=7.41 //x2=21.98 //y2=7.585
r1988 (  409 1116 ) resistor r=33.1979 //w=0.187 //l=0.485 //layer=li \
 //thickness=0.1 //x=21.98 //y=7.41 //x2=21.98 //y2=6.925
r1989 (  406 1024 ) resistor r=2.87058 //w=0.35 //l=0.085 //layer=li \
 //thickness=0.1 //x=21.185 //y=7.585 //x2=21.1 //y2=7.585
r1990 (  406 408 ) resistor r=13.7766 //w=0.367 //l=0.395 //layer=li \
 //thickness=0.1 //x=21.185 //y=7.585 //x2=21.58 //y2=7.585
r1991 (  405 1025 ) resistor r=2.87058 //w=0.35 //l=0.085 //layer=li \
 //thickness=0.1 //x=21.895 //y=7.585 //x2=21.98 //y2=7.585
r1992 (  405 408 ) resistor r=10.9864 //w=0.367 //l=0.315 //layer=li \
 //thickness=0.1 //x=21.895 //y=7.585 //x2=21.58 //y2=7.585
r1993 (  399 1024 ) resistor r=4.23183 //w=0.7 //l=0.175 //layer=li \
 //thickness=0.1 //x=21.1 //y=7.41 //x2=21.1 //y2=7.585
r1994 (  399 1115 ) resistor r=33.1979 //w=0.187 //l=0.485 //layer=li \
 //thickness=0.1 //x=21.1 //y=7.41 //x2=21.1 //y2=6.925
r1995 (  396 1023 ) resistor r=2.87058 //w=0.35 //l=0.085 //layer=li \
 //thickness=0.1 //x=20.305 //y=7.585 //x2=20.22 //y2=7.585
r1996 (  396 398 ) resistor r=5.75477 //w=0.367 //l=0.165 //layer=li \
 //thickness=0.1 //x=20.305 //y=7.585 //x2=20.47 //y2=7.585
r1997 (  395 1024 ) resistor r=2.87058 //w=0.35 //l=0.085 //layer=li \
 //thickness=0.1 //x=21.015 //y=7.585 //x2=21.1 //y2=7.585
r1998 (  395 398 ) resistor r=19.0082 //w=0.367 //l=0.545 //layer=li \
 //thickness=0.1 //x=21.015 //y=7.585 //x2=20.47 //y2=7.585
r1999 (  389 1023 ) resistor r=4.23183 //w=0.7 //l=0.175 //layer=li \
 //thickness=0.1 //x=20.22 //y=7.41 //x2=20.22 //y2=7.585
r2000 (  389 1114 ) resistor r=33.1979 //w=0.187 //l=0.485 //layer=li \
 //thickness=0.1 //x=20.22 //y=7.41 //x2=20.22 //y2=6.925
r2001 (  388 1022 ) resistor r=2.87058 //w=0.35 //l=0.085 //layer=li \
 //thickness=0.1 //x=19.425 //y=7.585 //x2=19.34 //y2=7.585
r2002 (  387 1023 ) resistor r=2.87058 //w=0.35 //l=0.085 //layer=li \
 //thickness=0.1 //x=20.135 //y=7.585 //x2=20.22 //y2=7.585
r2003 (  387 388 ) resistor r=24.7629 //w=0.367 //l=0.71 //layer=li \
 //thickness=0.1 //x=20.135 //y=7.585 //x2=19.425 //y2=7.585
r2004 (  379 1022 ) resistor r=4.23183 //w=0.7 //l=0.175 //layer=li \
 //thickness=0.1 //x=19.34 //y=7.41 //x2=19.34 //y2=7.585
r2005 (  379 1113 ) resistor r=56.4706 //w=0.187 //l=0.825 //layer=li \
 //thickness=0.1 //x=19.34 //y=7.41 //x2=19.34 //y2=6.585
r2006 (  378 1020 ) resistor r=5.29055 //w=0.35 //l=0.17 //layer=li \
 //thickness=0.1 //x=18.42 //y=7.585 //x2=18.25 //y2=7.585
r2007 (  377 1022 ) resistor r=2.87058 //w=0.35 //l=0.085 //layer=li \
 //thickness=0.1 //x=19.255 //y=7.585 //x2=19.34 //y2=7.585
r2008 (  377 378 ) resistor r=29.1226 //w=0.367 //l=0.835 //layer=li \
 //thickness=0.1 //x=19.255 //y=7.585 //x2=18.42 //y2=7.585
r2009 (  372 1019 ) resistor r=2.87058 //w=0.35 //l=0.085 //layer=li \
 //thickness=0.1 //x=17.255 //y=7.585 //x2=17.17 //y2=7.585
r2010 (  372 374 ) resistor r=21.7984 //w=0.367 //l=0.625 //layer=li \
 //thickness=0.1 //x=17.255 //y=7.585 //x2=17.88 //y2=7.585
r2011 (  371 1020 ) resistor r=5.29055 //w=0.35 //l=0.17 //layer=li \
 //thickness=0.1 //x=18.08 //y=7.585 //x2=18.25 //y2=7.585
r2012 (  371 374 ) resistor r=6.97548 //w=0.367 //l=0.2 //layer=li \
 //thickness=0.1 //x=18.08 //y=7.585 //x2=17.88 //y2=7.585
r2013 (  365 1019 ) resistor r=4.23183 //w=0.7 //l=0.175 //layer=li \
 //thickness=0.1 //x=17.17 //y=7.41 //x2=17.17 //y2=7.585
r2014 (  365 1112 ) resistor r=33.1979 //w=0.187 //l=0.485 //layer=li \
 //thickness=0.1 //x=17.17 //y=7.41 //x2=17.17 //y2=6.925
r2015 (  362 1018 ) resistor r=2.87058 //w=0.35 //l=0.085 //layer=li \
 //thickness=0.1 //x=16.375 //y=7.585 //x2=16.29 //y2=7.585
r2016 (  362 364 ) resistor r=13.7766 //w=0.367 //l=0.395 //layer=li \
 //thickness=0.1 //x=16.375 //y=7.585 //x2=16.77 //y2=7.585
r2017 (  361 1019 ) resistor r=2.87058 //w=0.35 //l=0.085 //layer=li \
 //thickness=0.1 //x=17.085 //y=7.585 //x2=17.17 //y2=7.585
r2018 (  361 364 ) resistor r=10.9864 //w=0.367 //l=0.315 //layer=li \
 //thickness=0.1 //x=17.085 //y=7.585 //x2=16.77 //y2=7.585
r2019 (  355 1018 ) resistor r=4.23183 //w=0.7 //l=0.175 //layer=li \
 //thickness=0.1 //x=16.29 //y=7.41 //x2=16.29 //y2=7.585
r2020 (  355 1111 ) resistor r=33.1979 //w=0.187 //l=0.485 //layer=li \
 //thickness=0.1 //x=16.29 //y=7.41 //x2=16.29 //y2=6.925
r2021 (  352 1017 ) resistor r=2.87058 //w=0.35 //l=0.085 //layer=li \
 //thickness=0.1 //x=15.495 //y=7.585 //x2=15.41 //y2=7.585
r2022 (  352 354 ) resistor r=5.75477 //w=0.367 //l=0.165 //layer=li \
 //thickness=0.1 //x=15.495 //y=7.585 //x2=15.66 //y2=7.585
r2023 (  351 1018 ) resistor r=2.87058 //w=0.35 //l=0.085 //layer=li \
 //thickness=0.1 //x=16.205 //y=7.585 //x2=16.29 //y2=7.585
r2024 (  351 354 ) resistor r=19.0082 //w=0.367 //l=0.545 //layer=li \
 //thickness=0.1 //x=16.205 //y=7.585 //x2=15.66 //y2=7.585
r2025 (  345 1017 ) resistor r=4.23183 //w=0.7 //l=0.175 //layer=li \
 //thickness=0.1 //x=15.41 //y=7.41 //x2=15.41 //y2=7.585
r2026 (  345 1110 ) resistor r=33.1979 //w=0.187 //l=0.485 //layer=li \
 //thickness=0.1 //x=15.41 //y=7.41 //x2=15.41 //y2=6.925
r2027 (  344 1016 ) resistor r=2.87058 //w=0.35 //l=0.085 //layer=li \
 //thickness=0.1 //x=14.615 //y=7.585 //x2=14.53 //y2=7.585
r2028 (  343 1017 ) resistor r=2.87058 //w=0.35 //l=0.085 //layer=li \
 //thickness=0.1 //x=15.325 //y=7.585 //x2=15.41 //y2=7.585
r2029 (  343 344 ) resistor r=24.7629 //w=0.367 //l=0.71 //layer=li \
 //thickness=0.1 //x=15.325 //y=7.585 //x2=14.615 //y2=7.585
r2030 (  335 1016 ) resistor r=4.23183 //w=0.7 //l=0.175 //layer=li \
 //thickness=0.1 //x=14.53 //y=7.41 //x2=14.53 //y2=7.585
r2031 (  335 1109 ) resistor r=56.4706 //w=0.187 //l=0.825 //layer=li \
 //thickness=0.1 //x=14.53 //y=7.41 //x2=14.53 //y2=6.585
r2032 (  334 1014 ) resistor r=5.29055 //w=0.35 //l=0.17 //layer=li \
 //thickness=0.1 //x=13.61 //y=7.585 //x2=13.44 //y2=7.585
r2033 (  333 1016 ) resistor r=2.87058 //w=0.35 //l=0.085 //layer=li \
 //thickness=0.1 //x=14.445 //y=7.585 //x2=14.53 //y2=7.585
r2034 (  333 334 ) resistor r=29.1226 //w=0.367 //l=0.835 //layer=li \
 //thickness=0.1 //x=14.445 //y=7.585 //x2=13.61 //y2=7.585
r2035 (  328 1013 ) resistor r=2.87058 //w=0.35 //l=0.085 //layer=li \
 //thickness=0.1 //x=12.745 //y=7.585 //x2=12.66 //y2=7.585
r2036 (  328 330 ) resistor r=11.3351 //w=0.367 //l=0.325 //layer=li \
 //thickness=0.1 //x=12.745 //y=7.585 //x2=13.07 //y2=7.585
r2037 (  327 1014 ) resistor r=5.29055 //w=0.35 //l=0.17 //layer=li \
 //thickness=0.1 //x=13.27 //y=7.585 //x2=13.44 //y2=7.585
r2038 (  327 330 ) resistor r=6.97548 //w=0.367 //l=0.2 //layer=li \
 //thickness=0.1 //x=13.27 //y=7.585 //x2=13.07 //y2=7.585
r2039 (  321 1013 ) resistor r=4.23183 //w=0.7 //l=0.175 //layer=li \
 //thickness=0.1 //x=12.66 //y=7.41 //x2=12.66 //y2=7.585
r2040 (  321 1108 ) resistor r=33.1979 //w=0.187 //l=0.485 //layer=li \
 //thickness=0.1 //x=12.66 //y=7.41 //x2=12.66 //y2=6.925
r2041 (  318 1012 ) resistor r=2.87058 //w=0.35 //l=0.085 //layer=li \
 //thickness=0.1 //x=11.865 //y=7.585 //x2=11.78 //y2=7.585
r2042 (  318 320 ) resistor r=3.31335 //w=0.367 //l=0.095 //layer=li \
 //thickness=0.1 //x=11.865 //y=7.585 //x2=11.96 //y2=7.585
r2043 (  317 1013 ) resistor r=2.87058 //w=0.35 //l=0.085 //layer=li \
 //thickness=0.1 //x=12.575 //y=7.585 //x2=12.66 //y2=7.585
r2044 (  317 320 ) resistor r=21.4496 //w=0.367 //l=0.615 //layer=li \
 //thickness=0.1 //x=12.575 //y=7.585 //x2=11.96 //y2=7.585
r2045 (  311 1012 ) resistor r=4.23183 //w=0.7 //l=0.175 //layer=li \
 //thickness=0.1 //x=11.78 //y=7.41 //x2=11.78 //y2=7.585
r2046 (  311 1107 ) resistor r=33.1979 //w=0.187 //l=0.485 //layer=li \
 //thickness=0.1 //x=11.78 //y=7.41 //x2=11.78 //y2=6.925
r2047 (  310 1011 ) resistor r=2.87058 //w=0.35 //l=0.085 //layer=li \
 //thickness=0.1 //x=10.985 //y=7.585 //x2=10.9 //y2=7.585
r2048 (  309 1012 ) resistor r=2.87058 //w=0.35 //l=0.085 //layer=li \
 //thickness=0.1 //x=11.695 //y=7.585 //x2=11.78 //y2=7.585
r2049 (  309 310 ) resistor r=24.7629 //w=0.367 //l=0.71 //layer=li \
 //thickness=0.1 //x=11.695 //y=7.585 //x2=10.985 //y2=7.585
r2050 (  301 1011 ) resistor r=4.23183 //w=0.7 //l=0.175 //layer=li \
 //thickness=0.1 //x=10.9 //y=7.41 //x2=10.9 //y2=7.585
r2051 (  301 1106 ) resistor r=56.4706 //w=0.187 //l=0.825 //layer=li \
 //thickness=0.1 //x=10.9 //y=7.41 //x2=10.9 //y2=6.585
r2052 (  300 1009 ) resistor r=5.29055 //w=0.35 //l=0.17 //layer=li \
 //thickness=0.1 //x=10.28 //y=7.585 //x2=10.11 //y2=7.585
r2053 (  299 1011 ) resistor r=2.87058 //w=0.35 //l=0.085 //layer=li \
 //thickness=0.1 //x=10.815 //y=7.585 //x2=10.9 //y2=7.585
r2054 (  299 300 ) resistor r=18.6594 //w=0.367 //l=0.535 //layer=li \
 //thickness=0.1 //x=10.815 //y=7.585 //x2=10.28 //y2=7.585
r2055 (  294 1008 ) resistor r=2.87058 //w=0.35 //l=0.085 //layer=li \
 //thickness=0.1 //x=9.115 //y=7.585 //x2=9.03 //y2=7.585
r2056 (  294 296 ) resistor r=8.89373 //w=0.367 //l=0.255 //layer=li \
 //thickness=0.1 //x=9.115 //y=7.585 //x2=9.37 //y2=7.585
r2057 (  293 1009 ) resistor r=5.29055 //w=0.35 //l=0.17 //layer=li \
 //thickness=0.1 //x=9.94 //y=7.585 //x2=10.11 //y2=7.585
r2058 (  293 296 ) resistor r=19.8801 //w=0.367 //l=0.57 //layer=li \
 //thickness=0.1 //x=9.94 //y=7.585 //x2=9.37 //y2=7.585
r2059 (  287 1008 ) resistor r=4.23183 //w=0.7 //l=0.175 //layer=li \
 //thickness=0.1 //x=9.03 //y=7.41 //x2=9.03 //y2=7.585
r2060 (  287 1105 ) resistor r=33.1979 //w=0.187 //l=0.485 //layer=li \
 //thickness=0.1 //x=9.03 //y=7.41 //x2=9.03 //y2=6.925
r2061 (  284 1007 ) resistor r=2.87058 //w=0.35 //l=0.085 //layer=li \
 //thickness=0.1 //x=8.235 //y=7.585 //x2=8.15 //y2=7.585
r2062 (  284 286 ) resistor r=0.871935 //w=0.367 //l=0.025 //layer=li \
 //thickness=0.1 //x=8.235 //y=7.585 //x2=8.26 //y2=7.585
r2063 (  283 1008 ) resistor r=2.87058 //w=0.35 //l=0.085 //layer=li \
 //thickness=0.1 //x=8.945 //y=7.585 //x2=9.03 //y2=7.585
r2064 (  283 286 ) resistor r=23.891 //w=0.367 //l=0.685 //layer=li \
 //thickness=0.1 //x=8.945 //y=7.585 //x2=8.26 //y2=7.585
r2065 (  277 1007 ) resistor r=4.23183 //w=0.7 //l=0.175 //layer=li \
 //thickness=0.1 //x=8.15 //y=7.41 //x2=8.15 //y2=7.585
r2066 (  277 1104 ) resistor r=33.1979 //w=0.187 //l=0.485 //layer=li \
 //thickness=0.1 //x=8.15 //y=7.41 //x2=8.15 //y2=6.925
r2067 (  276 1006 ) resistor r=2.87058 //w=0.35 //l=0.085 //layer=li \
 //thickness=0.1 //x=7.355 //y=7.585 //x2=7.27 //y2=7.585
r2068 (  275 1007 ) resistor r=2.87058 //w=0.35 //l=0.085 //layer=li \
 //thickness=0.1 //x=8.065 //y=7.585 //x2=8.15 //y2=7.585
r2069 (  275 276 ) resistor r=24.7629 //w=0.367 //l=0.71 //layer=li \
 //thickness=0.1 //x=8.065 //y=7.585 //x2=7.355 //y2=7.585
r2070 (  269 1006 ) resistor r=4.23183 //w=0.7 //l=0.175 //layer=li \
 //thickness=0.1 //x=7.27 //y=7.41 //x2=7.27 //y2=7.585
r2071 (  269 1103 ) resistor r=33.1979 //w=0.187 //l=0.485 //layer=li \
 //thickness=0.1 //x=7.27 //y=7.41 //x2=7.27 //y2=6.925
r2072 (  266 1005 ) resistor r=2.87058 //w=0.35 //l=0.085 //layer=li \
 //thickness=0.1 //x=6.475 //y=7.585 //x2=6.39 //y2=7.585
r2073 (  266 268 ) resistor r=23.5422 //w=0.367 //l=0.675 //layer=li \
 //thickness=0.1 //x=6.475 //y=7.585 //x2=7.15 //y2=7.585
r2074 (  265 1006 ) resistor r=2.87058 //w=0.35 //l=0.085 //layer=li \
 //thickness=0.1 //x=7.185 //y=7.585 //x2=7.27 //y2=7.585
r2075 (  265 268 ) resistor r=1.22071 //w=0.367 //l=0.035 //layer=li \
 //thickness=0.1 //x=7.185 //y=7.585 //x2=7.15 //y2=7.585
r2076 (  257 1005 ) resistor r=4.23183 //w=0.7 //l=0.175 //layer=li \
 //thickness=0.1 //x=6.39 //y=7.41 //x2=6.39 //y2=7.585
r2077 (  257 1102 ) resistor r=56.4706 //w=0.187 //l=0.825 //layer=li \
 //thickness=0.1 //x=6.39 //y=7.41 //x2=6.39 //y2=6.585
r2078 (  254 1004 ) resistor r=5.29055 //w=0.35 //l=0.17 //layer=li \
 //thickness=0.1 //x=5.47 //y=7.585 //x2=5.3 //y2=7.585
r2079 (  254 256 ) resistor r=19.8801 //w=0.367 //l=0.57 //layer=li \
 //thickness=0.1 //x=5.47 //y=7.585 //x2=6.04 //y2=7.585
r2080 (  253 1005 ) resistor r=2.87058 //w=0.35 //l=0.085 //layer=li \
 //thickness=0.1 //x=6.305 //y=7.585 //x2=6.39 //y2=7.585
r2081 (  253 256 ) resistor r=9.24251 //w=0.367 //l=0.265 //layer=li \
 //thickness=0.1 //x=6.305 //y=7.585 //x2=6.04 //y2=7.585
r2082 (  248 1003 ) resistor r=2.87058 //w=0.35 //l=0.085 //layer=li \
 //thickness=0.1 //x=4.305 //y=7.585 //x2=4.22 //y2=7.585
r2083 (  248 250 ) resistor r=8.89373 //w=0.367 //l=0.255 //layer=li \
 //thickness=0.1 //x=4.305 //y=7.585 //x2=4.56 //y2=7.585
r2084 (  247 1004 ) resistor r=5.29055 //w=0.35 //l=0.17 //layer=li \
 //thickness=0.1 //x=5.13 //y=7.585 //x2=5.3 //y2=7.585
r2085 (  247 250 ) resistor r=19.8801 //w=0.367 //l=0.57 //layer=li \
 //thickness=0.1 //x=5.13 //y=7.585 //x2=4.56 //y2=7.585
r2086 (  241 1003 ) resistor r=4.23183 //w=0.7 //l=0.175 //layer=li \
 //thickness=0.1 //x=4.22 //y=7.41 //x2=4.22 //y2=7.585
r2087 (  241 1101 ) resistor r=33.1979 //w=0.187 //l=0.485 //layer=li \
 //thickness=0.1 //x=4.22 //y=7.41 //x2=4.22 //y2=6.925
r2088 (  238 1002 ) resistor r=2.87058 //w=0.35 //l=0.085 //layer=li \
 //thickness=0.1 //x=3.425 //y=7.585 //x2=3.34 //y2=7.585
r2089 (  238 240 ) resistor r=0.871935 //w=0.367 //l=0.025 //layer=li \
 //thickness=0.1 //x=3.425 //y=7.585 //x2=3.45 //y2=7.585
r2090 (  237 1003 ) resistor r=2.87058 //w=0.35 //l=0.085 //layer=li \
 //thickness=0.1 //x=4.135 //y=7.585 //x2=4.22 //y2=7.585
r2091 (  237 240 ) resistor r=23.891 //w=0.367 //l=0.685 //layer=li \
 //thickness=0.1 //x=4.135 //y=7.585 //x2=3.45 //y2=7.585
r2092 (  231 1002 ) resistor r=4.23183 //w=0.7 //l=0.175 //layer=li \
 //thickness=0.1 //x=3.34 //y=7.41 //x2=3.34 //y2=7.585
r2093 (  231 1100 ) resistor r=33.1979 //w=0.187 //l=0.485 //layer=li \
 //thickness=0.1 //x=3.34 //y=7.41 //x2=3.34 //y2=6.925
r2094 (  230 1001 ) resistor r=2.87058 //w=0.35 //l=0.085 //layer=li \
 //thickness=0.1 //x=2.545 //y=7.585 //x2=2.46 //y2=7.585
r2095 (  229 1002 ) resistor r=2.87058 //w=0.35 //l=0.085 //layer=li \
 //thickness=0.1 //x=3.255 //y=7.585 //x2=3.34 //y2=7.585
r2096 (  229 230 ) resistor r=24.7629 //w=0.367 //l=0.71 //layer=li \
 //thickness=0.1 //x=3.255 //y=7.585 //x2=2.545 //y2=7.585
r2097 (  223 1001 ) resistor r=4.23183 //w=0.7 //l=0.175 //layer=li \
 //thickness=0.1 //x=2.46 //y=7.41 //x2=2.46 //y2=7.585
r2098 (  223 1099 ) resistor r=33.1979 //w=0.187 //l=0.485 //layer=li \
 //thickness=0.1 //x=2.46 //y=7.41 //x2=2.46 //y2=6.925
r2099 (  220 1000 ) resistor r=2.87058 //w=0.35 //l=0.085 //layer=li \
 //thickness=0.1 //x=1.665 //y=7.585 //x2=1.58 //y2=7.585
r2100 (  220 222 ) resistor r=23.5422 //w=0.367 //l=0.675 //layer=li \
 //thickness=0.1 //x=1.665 //y=7.585 //x2=2.34 //y2=7.585
r2101 (  219 1001 ) resistor r=2.87058 //w=0.35 //l=0.085 //layer=li \
 //thickness=0.1 //x=2.375 //y=7.585 //x2=2.46 //y2=7.585
r2102 (  219 222 ) resistor r=1.22071 //w=0.367 //l=0.035 //layer=li \
 //thickness=0.1 //x=2.375 //y=7.585 //x2=2.34 //y2=7.585
r2103 (  211 1000 ) resistor r=4.23183 //w=0.7 //l=0.175 //layer=li \
 //thickness=0.1 //x=1.58 //y=7.41 //x2=1.58 //y2=7.585
r2104 (  211 1098 ) resistor r=56.4706 //w=0.187 //l=0.825 //layer=li \
 //thickness=0.1 //x=1.58 //y=7.41 //x2=1.58 //y2=6.585
r2105 (  207 1000 ) resistor r=2.87058 //w=0.35 //l=0.085 //layer=li \
 //thickness=0.1 //x=1.495 //y=7.585 //x2=1.58 //y2=7.585
r2106 (  207 210 ) resistor r=9.24251 //w=0.367 //l=0.265 //layer=li \
 //thickness=0.1 //x=1.495 //y=7.585 //x2=1.23 //y2=7.585
r2107 (  204 978 ) resistor r=9.3 //w=0.17 //l=0.17 //layer=mcon //count=1 \
 //x=80.74 //y=6.92 //x2=80.74 //y2=6.92
r2108 (  201 1165 ) resistor r=9.3 //w=0.17 //l=0.17 //layer=mcon //count=1 \
 //x=79.86 //y=6.92 //x2=79.86 //y2=6.92
r2109 (  198 963 ) resistor r=9.3 //w=0.17 //l=0.17 //layer=mcon //count=1 \
 //x=78.98 //y=6.92 //x2=78.98 //y2=6.92
r2110 (  194 950 ) resistor r=3.1 //w=0.17 //l=0.51 //layer=mcon //count=3 \
 //x=78.93 //y=7.58 //x2=78.93 //y2=7.58
r2111 (  155 997 ) resistor r=3.1 //w=0.17 //l=0.51 //layer=mcon //count=3 \
 //x=87.44 //y=7.58 //x2=87.44 //y2=7.58
r2112 (  153 995 ) resistor r=3.1 //w=0.17 //l=0.51 //layer=mcon //count=3 \
 //x=86.33 //y=7.58 //x2=86.33 //y2=7.58
r2113 (  153 155 ) resistor r=0.446141 //w=0.311 //l=1.11 //layer=m1 \
 //thickness=0.36 //x=86.33 //y=7.585 //x2=87.44 //y2=7.585
r2114 (  151 993 ) resistor r=3.1 //w=0.17 //l=0.51 //layer=mcon //count=3 \
 //x=85.22 //y=7.58 //x2=85.22 //y2=7.58
r2115 (  151 153 ) resistor r=0.446141 //w=0.311 //l=1.11 //layer=m1 \
 //thickness=0.36 //x=85.22 //y=7.585 //x2=86.33 //y2=7.585
r2116 (  149 987 ) resistor r=3.1 //w=0.17 //l=0.51 //layer=mcon //count=3 \
 //x=83.74 //y=7.58 //x2=83.74 //y2=7.58
r2117 (  149 151 ) resistor r=0.594855 //w=0.311 //l=1.48 //layer=m1 \
 //thickness=0.36 //x=83.74 //y=7.585 //x2=85.22 //y2=7.585
r2118 (  147 985 ) resistor r=3.1 //w=0.17 //l=0.51 //layer=mcon //count=3 \
 //x=82.63 //y=7.58 //x2=82.63 //y2=7.58
r2119 (  147 149 ) resistor r=0.446141 //w=0.311 //l=1.11 //layer=m1 \
 //thickness=0.36 //x=82.63 //y=7.585 //x2=83.74 //y2=7.585
r2120 (  145 954 ) resistor r=3.1 //w=0.17 //l=0.51 //layer=mcon //count=3 \
 //x=81.15 //y=7.58 //x2=81.15 //y2=7.58
r2121 (  145 147 ) resistor r=0.594855 //w=0.311 //l=1.48 //layer=m1 \
 //thickness=0.36 //x=81.15 //y=7.585 //x2=82.63 //y2=7.585
r2122 (  143 202 ) resistor r=0.028033 //w=0.35 //l=0.085 //layer=m1 \
 //thickness=0.36 //x=80.825 //y=7.585 //x2=80.74 //y2=7.585
r2123 (  143 145 ) resistor r=0.130627 //w=0.311 //l=0.325 //layer=m1 \
 //thickness=0.36 //x=80.825 //y=7.585 //x2=81.15 //y2=7.585
r2124 (  142 202 ) resistor r=0.0413265 //w=0.7 //l=0.175 //layer=m1 \
 //thickness=0.36 //x=80.74 //y=7.41 //x2=80.74 //y2=7.585
r2125 (  141 204 ) resistor r=0.0715665 //w=0.226 //l=0.115 //layer=m1 \
 //thickness=0.36 //x=80.74 //y=7.035 //x2=80.74 //y2=6.92
r2126 (  141 142 ) resistor r=0.357824 //w=0.131 //l=0.375 //layer=m1 \
 //thickness=0.36 //x=80.74 //y=7.035 //x2=80.74 //y2=7.41
r2127 (  140 952 ) resistor r=3.1 //w=0.17 //l=0.51 //layer=mcon //count=3 \
 //x=80.04 //y=7.58 //x2=80.04 //y2=7.58
r2128 (  138 199 ) resistor r=0.028033 //w=0.35 //l=0.085 //layer=m1 \
 //thickness=0.36 //x=79.945 //y=7.585 //x2=79.86 //y2=7.585
r2129 (  138 140 ) resistor r=0.0381833 //w=0.311 //l=0.095 //layer=m1 \
 //thickness=0.36 //x=79.945 //y=7.585 //x2=80.04 //y2=7.585
r2130 (  137 202 ) resistor r=0.028033 //w=0.35 //l=0.085 //layer=m1 \
 //thickness=0.36 //x=80.655 //y=7.585 //x2=80.74 //y2=7.585
r2131 (  137 140 ) resistor r=0.247186 //w=0.311 //l=0.615 //layer=m1 \
 //thickness=0.36 //x=80.655 //y=7.585 //x2=80.04 //y2=7.585
r2132 (  136 199 ) resistor r=0.0413265 //w=0.7 //l=0.175 //layer=m1 \
 //thickness=0.36 //x=79.86 //y=7.41 //x2=79.86 //y2=7.585
r2133 (  135 201 ) resistor r=0.0715665 //w=0.226 //l=0.117473 //layer=m1 \
 //thickness=0.36 //x=79.86 //y=7.035 //x2=79.865 //y2=6.92
r2134 (  135 136 ) resistor r=0.357824 //w=0.131 //l=0.375 //layer=m1 \
 //thickness=0.36 //x=79.86 //y=7.035 //x2=79.86 //y2=7.41
r2135 (  134 194 ) resistor r=0.028033 //w=0.35 //l=0.085 //layer=m1 \
 //thickness=0.36 //x=79.065 //y=7.585 //x2=78.98 //y2=7.585
r2136 (  133 199 ) resistor r=0.028033 //w=0.35 //l=0.085 //layer=m1 \
 //thickness=0.36 //x=79.775 //y=7.585 //x2=79.86 //y2=7.585
r2137 (  133 134 ) resistor r=0.28537 //w=0.311 //l=0.71 //layer=m1 \
 //thickness=0.36 //x=79.775 //y=7.585 //x2=79.065 //y2=7.585
r2138 (  132 194 ) resistor r=0.0413265 //w=0.7 //l=0.175 //layer=m1 \
 //thickness=0.36 //x=78.98 //y=7.41 //x2=78.98 //y2=7.585
r2139 (  131 198 ) resistor r=0.0712609 //w=0.23 //l=0.11649 //layer=m1 \
 //thickness=0.36 //x=78.98 //y=7.035 //x2=78.977 //y2=6.92
r2140 (  131 132 ) resistor r=0.357824 //w=0.131 //l=0.375 //layer=m1 \
 //thickness=0.36 //x=78.98 //y=7.035 //x2=78.98 //y2=7.41
r2141 (  130 1094 ) resistor r=3.1 //w=0.17 //l=0.51 //layer=mcon //count=3 \
 //x=77.45 //y=7.58 //x2=77.45 //y2=7.58
r2142 (  128 928 ) resistor r=3.1 //w=0.17 //l=0.51 //layer=mcon //count=3 \
 //x=76.34 //y=7.58 //x2=76.34 //y2=7.58
r2143 (  128 130 ) resistor r=0.446141 //w=0.311 //l=1.11 //layer=m1 \
 //thickness=0.36 //x=76.34 //y=7.585 //x2=77.45 //y2=7.585
r2144 (  126 916 ) resistor r=3.1 //w=0.17 //l=0.51 //layer=mcon //count=3 \
 //x=75.23 //y=7.58 //x2=75.23 //y2=7.58
r2145 (  126 128 ) resistor r=0.446141 //w=0.311 //l=1.11 //layer=m1 \
 //thickness=0.36 //x=75.23 //y=7.585 //x2=76.34 //y2=7.585
r2146 (  124 1089 ) resistor r=3.1 //w=0.17 //l=0.51 //layer=mcon //count=3 \
 //x=73.75 //y=7.58 //x2=73.75 //y2=7.58
r2147 (  124 126 ) resistor r=0.594855 //w=0.311 //l=1.48 //layer=m1 \
 //thickness=0.36 //x=73.75 //y=7.585 //x2=75.23 //y2=7.585
r2148 (  122 894 ) resistor r=3.1 //w=0.17 //l=0.51 //layer=mcon //count=3 \
 //x=72.64 //y=7.58 //x2=72.64 //y2=7.58
r2149 (  122 124 ) resistor r=0.446141 //w=0.311 //l=1.11 //layer=m1 \
 //thickness=0.36 //x=72.64 //y=7.585 //x2=73.75 //y2=7.585
r2150 (  120 884 ) resistor r=3.1 //w=0.17 //l=0.51 //layer=mcon //count=3 \
 //x=71.53 //y=7.58 //x2=71.53 //y2=7.58
r2151 (  120 122 ) resistor r=0.446141 //w=0.311 //l=1.11 //layer=m1 \
 //thickness=0.36 //x=71.53 //y=7.585 //x2=72.64 //y2=7.585
r2152 (  118 872 ) resistor r=3.1 //w=0.17 //l=0.51 //layer=mcon //count=3 \
 //x=70.42 //y=7.58 //x2=70.42 //y2=7.58
r2153 (  118 120 ) resistor r=0.446141 //w=0.311 //l=1.11 //layer=m1 \
 //thickness=0.36 //x=70.42 //y=7.585 //x2=71.53 //y2=7.585
r2154 (  116 1083 ) resistor r=3.1 //w=0.17 //l=0.51 //layer=mcon //count=3 \
 //x=68.94 //y=7.58 //x2=68.94 //y2=7.58
r2155 (  116 118 ) resistor r=0.594855 //w=0.311 //l=1.48 //layer=m1 \
 //thickness=0.36 //x=68.94 //y=7.585 //x2=70.42 //y2=7.585
r2156 (  114 850 ) resistor r=3.1 //w=0.17 //l=0.51 //layer=mcon //count=3 \
 //x=67.83 //y=7.58 //x2=67.83 //y2=7.58
r2157 (  114 116 ) resistor r=0.446141 //w=0.311 //l=1.11 //layer=m1 \
 //thickness=0.36 //x=67.83 //y=7.585 //x2=68.94 //y2=7.585
r2158 (  112 840 ) resistor r=3.1 //w=0.17 //l=0.51 //layer=mcon //count=3 \
 //x=66.72 //y=7.58 //x2=66.72 //y2=7.58
r2159 (  112 114 ) resistor r=0.446141 //w=0.311 //l=1.11 //layer=m1 \
 //thickness=0.36 //x=66.72 //y=7.585 //x2=67.83 //y2=7.585
r2160 (  110 828 ) resistor r=3.1 //w=0.17 //l=0.51 //layer=mcon //count=3 \
 //x=65.61 //y=7.58 //x2=65.61 //y2=7.58
r2161 (  110 112 ) resistor r=0.446141 //w=0.311 //l=1.11 //layer=m1 \
 //thickness=0.36 //x=65.61 //y=7.585 //x2=66.72 //y2=7.585
r2162 (  108 814 ) resistor r=3.1 //w=0.17 //l=0.51 //layer=mcon //count=3 \
 //x=64.13 //y=7.58 //x2=64.13 //y2=7.58
r2163 (  108 110 ) resistor r=0.594855 //w=0.311 //l=1.48 //layer=m1 \
 //thickness=0.36 //x=64.13 //y=7.585 //x2=65.61 //y2=7.585
r2164 (  106 804 ) resistor r=3.1 //w=0.17 //l=0.51 //layer=mcon //count=3 \
 //x=63.02 //y=7.58 //x2=63.02 //y2=7.58
r2165 (  106 108 ) resistor r=0.446141 //w=0.311 //l=1.11 //layer=m1 \
 //thickness=0.36 //x=63.02 //y=7.585 //x2=64.13 //y2=7.585
r2166 (  104 788 ) resistor r=3.1 //w=0.17 //l=0.51 //layer=mcon //count=3 \
 //x=61.54 //y=7.58 //x2=61.54 //y2=7.58
r2167 (  104 106 ) resistor r=0.594855 //w=0.311 //l=1.48 //layer=m1 \
 //thickness=0.36 //x=61.54 //y=7.585 //x2=63.02 //y2=7.585
r2168 (  102 778 ) resistor r=3.1 //w=0.17 //l=0.51 //layer=mcon //count=3 \
 //x=60.43 //y=7.58 //x2=60.43 //y2=7.58
r2169 (  102 104 ) resistor r=0.446141 //w=0.311 //l=1.11 //layer=m1 \
 //thickness=0.36 //x=60.43 //y=7.585 //x2=61.54 //y2=7.585
r2170 (  100 768 ) resistor r=3.1 //w=0.17 //l=0.51 //layer=mcon //count=3 \
 //x=59.32 //y=7.58 //x2=59.32 //y2=7.58
r2171 (  100 102 ) resistor r=0.446141 //w=0.311 //l=1.11 //layer=m1 \
 //thickness=0.36 //x=59.32 //y=7.585 //x2=60.43 //y2=7.585
r2172 (  98 1070 ) resistor r=3.1 //w=0.17 //l=0.51 //layer=mcon //count=3 \
 //x=58.21 //y=7.58 //x2=58.21 //y2=7.58
r2173 (  98 100 ) resistor r=0.446141 //w=0.311 //l=1.11 //layer=m1 \
 //thickness=0.36 //x=58.21 //y=7.585 //x2=59.32 //y2=7.585
r2174 (  96 744 ) resistor r=3.1 //w=0.17 //l=0.51 //layer=mcon //count=3 \
 //x=56.73 //y=7.58 //x2=56.73 //y2=7.58
r2175 (  96 98 ) resistor r=0.594855 //w=0.311 //l=1.48 //layer=m1 \
 //thickness=0.36 //x=56.73 //y=7.585 //x2=58.21 //y2=7.585
r2176 (  94 734 ) resistor r=3.1 //w=0.17 //l=0.51 //layer=mcon //count=3 \
 //x=55.62 //y=7.58 //x2=55.62 //y2=7.58
r2177 (  94 96 ) resistor r=0.446141 //w=0.311 //l=1.11 //layer=m1 \
 //thickness=0.36 //x=55.62 //y=7.585 //x2=56.73 //y2=7.585
r2178 (  92 724 ) resistor r=3.1 //w=0.17 //l=0.51 //layer=mcon //count=3 \
 //x=54.51 //y=7.58 //x2=54.51 //y2=7.58
r2179 (  92 94 ) resistor r=0.446141 //w=0.311 //l=1.11 //layer=m1 \
 //thickness=0.36 //x=54.51 //y=7.585 //x2=55.62 //y2=7.585
r2180 (  90 1064 ) resistor r=3.1 //w=0.17 //l=0.51 //layer=mcon //count=3 \
 //x=53.4 //y=7.58 //x2=53.4 //y2=7.58
r2181 (  90 92 ) resistor r=0.446141 //w=0.311 //l=1.11 //layer=m1 \
 //thickness=0.36 //x=53.4 //y=7.585 //x2=54.51 //y2=7.585
r2182 (  88 700 ) resistor r=3.1 //w=0.17 //l=0.51 //layer=mcon //count=3 \
 //x=51.92 //y=7.58 //x2=51.92 //y2=7.58
r2183 (  88 90 ) resistor r=0.594855 //w=0.311 //l=1.48 //layer=m1 \
 //thickness=0.36 //x=51.92 //y=7.585 //x2=53.4 //y2=7.585
r2184 (  86 690 ) resistor r=3.1 //w=0.17 //l=0.51 //layer=mcon //count=3 \
 //x=50.81 //y=7.58 //x2=50.81 //y2=7.58
r2185 (  86 88 ) resistor r=0.446141 //w=0.311 //l=1.11 //layer=m1 \
 //thickness=0.36 //x=50.81 //y=7.585 //x2=51.92 //y2=7.585
r2186 (  84 1059 ) resistor r=3.1 //w=0.17 //l=0.51 //layer=mcon //count=3 \
 //x=49.7 //y=7.58 //x2=49.7 //y2=7.58
r2187 (  84 86 ) resistor r=0.446141 //w=0.311 //l=1.11 //layer=m1 \
 //thickness=0.36 //x=49.7 //y=7.585 //x2=50.81 //y2=7.585
r2188 (  82 666 ) resistor r=3.1 //w=0.17 //l=0.51 //layer=mcon //count=3 \
 //x=48.22 //y=7.58 //x2=48.22 //y2=7.58
r2189 (  82 84 ) resistor r=0.594855 //w=0.311 //l=1.48 //layer=m1 \
 //thickness=0.36 //x=48.22 //y=7.585 //x2=49.7 //y2=7.585
r2190 (  80 656 ) resistor r=3.1 //w=0.17 //l=0.51 //layer=mcon //count=3 \
 //x=47.11 //y=7.58 //x2=47.11 //y2=7.58
r2191 (  80 82 ) resistor r=0.446141 //w=0.311 //l=1.11 //layer=m1 \
 //thickness=0.36 //x=47.11 //y=7.585 //x2=48.22 //y2=7.585
r2192 (  78 638 ) resistor r=3.1 //w=0.17 //l=0.51 //layer=mcon //count=3 \
 //x=46 //y=7.58 //x2=46 //y2=7.58
r2193 (  78 80 ) resistor r=0.446141 //w=0.311 //l=1.11 //layer=m1 \
 //thickness=0.36 //x=46 //y=7.585 //x2=47.11 //y2=7.585
r2194 (  76 626 ) resistor r=3.1 //w=0.17 //l=0.51 //layer=mcon //count=3 \
 //x=44.89 //y=7.58 //x2=44.89 //y2=7.58
r2195 (  76 78 ) resistor r=0.446141 //w=0.311 //l=1.11 //layer=m1 \
 //thickness=0.36 //x=44.89 //y=7.585 //x2=46 //y2=7.585
r2196 (  74 620 ) resistor r=3.1 //w=0.17 //l=0.51 //layer=mcon //count=3 \
 //x=43.41 //y=7.58 //x2=43.41 //y2=7.58
r2197 (  74 76 ) resistor r=0.594855 //w=0.311 //l=1.48 //layer=m1 \
 //thickness=0.36 //x=43.41 //y=7.585 //x2=44.89 //y2=7.585
r2198 (  72 610 ) resistor r=3.1 //w=0.17 //l=0.51 //layer=mcon //count=3 \
 //x=42.3 //y=7.58 //x2=42.3 //y2=7.58
r2199 (  72 74 ) resistor r=0.446141 //w=0.311 //l=1.11 //layer=m1 \
 //thickness=0.36 //x=42.3 //y=7.585 //x2=43.41 //y2=7.585
r2200 (  70 592 ) resistor r=3.1 //w=0.17 //l=0.51 //layer=mcon //count=3 \
 //x=41.19 //y=7.58 //x2=41.19 //y2=7.58
r2201 (  70 72 ) resistor r=0.446141 //w=0.311 //l=1.11 //layer=m1 \
 //thickness=0.36 //x=41.19 //y=7.585 //x2=42.3 //y2=7.585
r2202 (  68 580 ) resistor r=3.1 //w=0.17 //l=0.51 //layer=mcon //count=3 \
 //x=40.08 //y=7.58 //x2=40.08 //y2=7.58
r2203 (  68 70 ) resistor r=0.446141 //w=0.311 //l=1.11 //layer=m1 \
 //thickness=0.36 //x=40.08 //y=7.585 //x2=41.19 //y2=7.585
r2204 (  66 1046 ) resistor r=3.1 //w=0.17 //l=0.51 //layer=mcon //count=3 \
 //x=38.6 //y=7.58 //x2=38.6 //y2=7.58
r2205 (  66 68 ) resistor r=0.594855 //w=0.311 //l=1.48 //layer=m1 \
 //thickness=0.36 //x=38.6 //y=7.585 //x2=40.08 //y2=7.585
r2206 (  64 558 ) resistor r=3.1 //w=0.17 //l=0.51 //layer=mcon //count=3 \
 //x=37.49 //y=7.58 //x2=37.49 //y2=7.58
r2207 (  64 66 ) resistor r=0.446141 //w=0.311 //l=1.11 //layer=m1 \
 //thickness=0.36 //x=37.49 //y=7.585 //x2=38.6 //y2=7.585
r2208 (  62 546 ) resistor r=3.1 //w=0.17 //l=0.51 //layer=mcon //count=3 \
 //x=36.38 //y=7.58 //x2=36.38 //y2=7.58
r2209 (  62 64 ) resistor r=0.446141 //w=0.311 //l=1.11 //layer=m1 \
 //thickness=0.36 //x=36.38 //y=7.585 //x2=37.49 //y2=7.585
r2210 (  60 1041 ) resistor r=3.1 //w=0.17 //l=0.51 //layer=mcon //count=3 \
 //x=34.9 //y=7.58 //x2=34.9 //y2=7.58
r2211 (  60 62 ) resistor r=0.594855 //w=0.311 //l=1.48 //layer=m1 \
 //thickness=0.36 //x=34.9 //y=7.585 //x2=36.38 //y2=7.585
r2212 (  58 524 ) resistor r=3.1 //w=0.17 //l=0.51 //layer=mcon //count=3 \
 //x=33.79 //y=7.58 //x2=33.79 //y2=7.58
r2213 (  58 60 ) resistor r=0.446141 //w=0.311 //l=1.11 //layer=m1 \
 //thickness=0.36 //x=33.79 //y=7.585 //x2=34.9 //y2=7.585
r2214 (  56 514 ) resistor r=3.1 //w=0.17 //l=0.51 //layer=mcon //count=3 \
 //x=32.68 //y=7.58 //x2=32.68 //y2=7.58
r2215 (  56 58 ) resistor r=0.446141 //w=0.311 //l=1.11 //layer=m1 \
 //thickness=0.36 //x=32.68 //y=7.585 //x2=33.79 //y2=7.585
r2216 (  54 502 ) resistor r=3.1 //w=0.17 //l=0.51 //layer=mcon //count=3 \
 //x=31.57 //y=7.58 //x2=31.57 //y2=7.58
r2217 (  54 56 ) resistor r=0.446141 //w=0.311 //l=1.11 //layer=m1 \
 //thickness=0.36 //x=31.57 //y=7.585 //x2=32.68 //y2=7.585
r2218 (  52 1035 ) resistor r=3.1 //w=0.17 //l=0.51 //layer=mcon //count=3 \
 //x=30.09 //y=7.58 //x2=30.09 //y2=7.58
r2219 (  52 54 ) resistor r=0.594855 //w=0.311 //l=1.48 //layer=m1 \
 //thickness=0.36 //x=30.09 //y=7.585 //x2=31.57 //y2=7.585
r2220 (  50 480 ) resistor r=3.1 //w=0.17 //l=0.51 //layer=mcon //count=3 \
 //x=28.98 //y=7.58 //x2=28.98 //y2=7.58
r2221 (  50 52 ) resistor r=0.446141 //w=0.311 //l=1.11 //layer=m1 \
 //thickness=0.36 //x=28.98 //y=7.585 //x2=30.09 //y2=7.585
r2222 (  48 470 ) resistor r=3.1 //w=0.17 //l=0.51 //layer=mcon //count=3 \
 //x=27.87 //y=7.58 //x2=27.87 //y2=7.58
r2223 (  48 50 ) resistor r=0.446141 //w=0.311 //l=1.11 //layer=m1 \
 //thickness=0.36 //x=27.87 //y=7.585 //x2=28.98 //y2=7.585
r2224 (  46 458 ) resistor r=3.1 //w=0.17 //l=0.51 //layer=mcon //count=3 \
 //x=26.76 //y=7.58 //x2=26.76 //y2=7.58
r2225 (  46 48 ) resistor r=0.446141 //w=0.311 //l=1.11 //layer=m1 \
 //thickness=0.36 //x=26.76 //y=7.585 //x2=27.87 //y2=7.585
r2226 (  44 444 ) resistor r=3.1 //w=0.17 //l=0.51 //layer=mcon //count=3 \
 //x=25.28 //y=7.58 //x2=25.28 //y2=7.58
r2227 (  44 46 ) resistor r=0.594855 //w=0.311 //l=1.48 //layer=m1 \
 //thickness=0.36 //x=25.28 //y=7.585 //x2=26.76 //y2=7.585
r2228 (  42 434 ) resistor r=3.1 //w=0.17 //l=0.51 //layer=mcon //count=3 \
 //x=24.17 //y=7.58 //x2=24.17 //y2=7.58
r2229 (  42 44 ) resistor r=0.446141 //w=0.311 //l=1.11 //layer=m1 \
 //thickness=0.36 //x=24.17 //y=7.585 //x2=25.28 //y2=7.585
r2230 (  40 418 ) resistor r=3.1 //w=0.17 //l=0.51 //layer=mcon //count=3 \
 //x=22.69 //y=7.58 //x2=22.69 //y2=7.58
r2231 (  40 42 ) resistor r=0.594855 //w=0.311 //l=1.48 //layer=m1 \
 //thickness=0.36 //x=22.69 //y=7.585 //x2=24.17 //y2=7.585
r2232 (  38 408 ) resistor r=3.1 //w=0.17 //l=0.51 //layer=mcon //count=3 \
 //x=21.58 //y=7.58 //x2=21.58 //y2=7.58
r2233 (  38 40 ) resistor r=0.446141 //w=0.311 //l=1.11 //layer=m1 \
 //thickness=0.36 //x=21.58 //y=7.585 //x2=22.69 //y2=7.585
r2234 (  36 398 ) resistor r=3.1 //w=0.17 //l=0.51 //layer=mcon //count=3 \
 //x=20.47 //y=7.58 //x2=20.47 //y2=7.58
r2235 (  36 38 ) resistor r=0.446141 //w=0.311 //l=1.11 //layer=m1 \
 //thickness=0.36 //x=20.47 //y=7.585 //x2=21.58 //y2=7.585
r2236 (  34 1022 ) resistor r=3.1 //w=0.17 //l=0.51 //layer=mcon //count=3 \
 //x=19.36 //y=7.58 //x2=19.36 //y2=7.58
r2237 (  34 36 ) resistor r=0.446141 //w=0.311 //l=1.11 //layer=m1 \
 //thickness=0.36 //x=19.36 //y=7.585 //x2=20.47 //y2=7.585
r2238 (  32 374 ) resistor r=3.1 //w=0.17 //l=0.51 //layer=mcon //count=3 \
 //x=17.88 //y=7.58 //x2=17.88 //y2=7.58
r2239 (  32 34 ) resistor r=0.594855 //w=0.311 //l=1.48 //layer=m1 \
 //thickness=0.36 //x=17.88 //y=7.585 //x2=19.36 //y2=7.585
r2240 (  30 364 ) resistor r=3.1 //w=0.17 //l=0.51 //layer=mcon //count=3 \
 //x=16.77 //y=7.58 //x2=16.77 //y2=7.58
r2241 (  30 32 ) resistor r=0.446141 //w=0.311 //l=1.11 //layer=m1 \
 //thickness=0.36 //x=16.77 //y=7.585 //x2=17.88 //y2=7.585
r2242 (  28 354 ) resistor r=3.1 //w=0.17 //l=0.51 //layer=mcon //count=3 \
 //x=15.66 //y=7.58 //x2=15.66 //y2=7.58
r2243 (  28 30 ) resistor r=0.446141 //w=0.311 //l=1.11 //layer=m1 \
 //thickness=0.36 //x=15.66 //y=7.585 //x2=16.77 //y2=7.585
r2244 (  26 1016 ) resistor r=3.1 //w=0.17 //l=0.51 //layer=mcon //count=3 \
 //x=14.55 //y=7.58 //x2=14.55 //y2=7.58
r2245 (  26 28 ) resistor r=0.446141 //w=0.311 //l=1.11 //layer=m1 \
 //thickness=0.36 //x=14.55 //y=7.585 //x2=15.66 //y2=7.585
r2246 (  24 330 ) resistor r=3.1 //w=0.17 //l=0.51 //layer=mcon //count=3 \
 //x=13.07 //y=7.58 //x2=13.07 //y2=7.58
r2247 (  24 26 ) resistor r=0.594855 //w=0.311 //l=1.48 //layer=m1 \
 //thickness=0.36 //x=13.07 //y=7.585 //x2=14.55 //y2=7.585
r2248 (  22 320 ) resistor r=3.1 //w=0.17 //l=0.51 //layer=mcon //count=3 \
 //x=11.96 //y=7.58 //x2=11.96 //y2=7.58
r2249 (  22 24 ) resistor r=0.446141 //w=0.311 //l=1.11 //layer=m1 \
 //thickness=0.36 //x=11.96 //y=7.585 //x2=13.07 //y2=7.585
r2250 (  20 1011 ) resistor r=3.1 //w=0.17 //l=0.51 //layer=mcon //count=3 \
 //x=10.85 //y=7.58 //x2=10.85 //y2=7.58
r2251 (  20 22 ) resistor r=0.446141 //w=0.311 //l=1.11 //layer=m1 \
 //thickness=0.36 //x=10.85 //y=7.585 //x2=11.96 //y2=7.585
r2252 (  18 296 ) resistor r=3.1 //w=0.17 //l=0.51 //layer=mcon //count=3 \
 //x=9.37 //y=7.58 //x2=9.37 //y2=7.58
r2253 (  18 20 ) resistor r=0.594855 //w=0.311 //l=1.48 //layer=m1 \
 //thickness=0.36 //x=9.37 //y=7.585 //x2=10.85 //y2=7.585
r2254 (  16 286 ) resistor r=3.1 //w=0.17 //l=0.51 //layer=mcon //count=3 \
 //x=8.26 //y=7.58 //x2=8.26 //y2=7.58
r2255 (  16 18 ) resistor r=0.446141 //w=0.311 //l=1.11 //layer=m1 \
 //thickness=0.36 //x=8.26 //y=7.585 //x2=9.37 //y2=7.585
r2256 (  14 268 ) resistor r=3.1 //w=0.17 //l=0.51 //layer=mcon //count=3 \
 //x=7.15 //y=7.58 //x2=7.15 //y2=7.58
r2257 (  14 16 ) resistor r=0.446141 //w=0.311 //l=1.11 //layer=m1 \
 //thickness=0.36 //x=7.15 //y=7.585 //x2=8.26 //y2=7.585
r2258 (  12 256 ) resistor r=3.1 //w=0.17 //l=0.51 //layer=mcon //count=3 \
 //x=6.04 //y=7.58 //x2=6.04 //y2=7.58
r2259 (  12 14 ) resistor r=0.446141 //w=0.311 //l=1.11 //layer=m1 \
 //thickness=0.36 //x=6.04 //y=7.585 //x2=7.15 //y2=7.585
r2260 (  10 250 ) resistor r=3.1 //w=0.17 //l=0.51 //layer=mcon //count=3 \
 //x=4.56 //y=7.58 //x2=4.56 //y2=7.58
r2261 (  10 12 ) resistor r=0.594855 //w=0.311 //l=1.48 //layer=m1 \
 //thickness=0.36 //x=4.56 //y=7.585 //x2=6.04 //y2=7.585
r2262 (  8 240 ) resistor r=3.1 //w=0.17 //l=0.51 //layer=mcon //count=3 \
 //x=3.45 //y=7.58 //x2=3.45 //y2=7.58
r2263 (  8 10 ) resistor r=0.446141 //w=0.311 //l=1.11 //layer=m1 \
 //thickness=0.36 //x=3.45 //y=7.585 //x2=4.56 //y2=7.585
r2264 (  6 222 ) resistor r=3.1 //w=0.17 //l=0.51 //layer=mcon //count=3 \
 //x=2.34 //y=7.58 //x2=2.34 //y2=7.58
r2265 (  6 8 ) resistor r=0.446141 //w=0.311 //l=1.11 //layer=m1 \
 //thickness=0.36 //x=2.34 //y=7.585 //x2=3.45 //y2=7.585
r2266 (  3 210 ) resistor r=3.1 //w=0.17 //l=0.51 //layer=mcon //count=3 \
 //x=1.23 //y=7.58 //x2=1.23 //y2=7.58
r2267 (  3 6 ) resistor r=0.446141 //w=0.311 //l=1.11 //layer=m1 \
 //thickness=0.36 //x=1.23 //y=7.585 //x2=2.34 //y2=7.585
r2268 (  1 194 ) resistor r=0.028033 //w=0.35 //l=0.085 //layer=m1 \
 //thickness=0.36 //x=78.895 //y=7.585 //x2=78.98 //y2=7.585
r2269 (  1 130 ) resistor r=0.580788 //w=0.311 //l=1.445 //layer=m1 \
 //thickness=0.36 //x=78.895 //y=7.585 //x2=77.45 //y2=7.585
ends PM_TMRDFFRNQNX1\%noxref_19

subckt PM_TMRDFFRNQNX1\%noxref_20 ( 5 7 15 19 30 33 34 )
c63 ( 34 0 ) capacitor c=0.0464972f //x=3.455 //y=0.555
c64 ( 33 0 ) capacitor c=0.0198861f //x=2.35 //y=1.09
c65 ( 30 0 ) capacitor c=0.00141302f //x=3.59 //y=1.175
c66 ( 19 0 ) capacitor c=0.00692795f //x=4.56 //y=0.805
c67 ( 15 0 ) capacitor c=0.0154966f //x=4.475 //y=0.72
c68 ( 7 0 ) capacitor c=0.00689459f //x=3.59 //y=0.805
c69 ( 5 0 ) capacitor c=0.0288646f //x=3.505 //y=1.175
r70 (  19 34 ) resistor r=3.57586 //w=0.17 //l=0.125 //layer=li \
 //thickness=0.1 //x=4.56 //y=0.805 //x2=4.56 //y2=0.68
r71 (  19 34 ) resistor r=18.139 //w=0.187 //l=0.265 //layer=li \
 //thickness=0.1 //x=4.56 //y=0.805 //x2=4.56 //y2=1.07
r72 (  16 34 ) resistor r=3.57586 //w=0.17 //l=0.103078 //layer=li \
 //thickness=0.1 //x=3.675 //y=0.72 //x2=3.59 //y2=0.68
r73 (  16 34 ) resistor r=27.3797 //w=0.187 //l=0.4 //layer=li //thickness=0.1 \
 //x=3.675 //y=0.72 //x2=4.075 //y2=0.72
r74 (  15 34 ) resistor r=3.57586 //w=0.17 //l=0.103078 //layer=li \
 //thickness=0.1 //x=4.475 //y=0.72 //x2=4.56 //y2=0.68
r75 (  15 34 ) resistor r=27.3797 //w=0.187 //l=0.4 //layer=li //thickness=0.1 \
 //x=4.475 //y=0.72 //x2=4.075 //y2=0.72
r76 (  11 30 ) resistor r=5.4201 //w=0.17 //l=0.085 //layer=li //thickness=0.1 \
 //x=3.59 //y=1.26 //x2=3.59 //y2=1.175
r77 (  11 34 ) resistor r=10.2674 //w=0.187 //l=0.15 //layer=li \
 //thickness=0.1 //x=3.59 //y=1.26 //x2=3.59 //y2=1.41
r78 (  8 30 ) resistor r=5.4201 //w=0.17 //l=0.085 //layer=li //thickness=0.1 \
 //x=3.59 //y=1.09 //x2=3.59 //y2=1.175
r79 (  8 34 ) resistor r=1.36898 //w=0.187 //l=0.02 //layer=li //thickness=0.1 \
 //x=3.59 //y=1.09 //x2=3.59 //y2=1.07
r80 (  7 34 ) resistor r=3.57586 //w=0.17 //l=0.125 //layer=li //thickness=0.1 \
 //x=3.59 //y=0.805 //x2=3.59 //y2=0.68
r81 (  7 34 ) resistor r=18.139 //w=0.187 //l=0.265 //layer=li //thickness=0.1 \
 //x=3.59 //y=0.805 //x2=3.59 //y2=1.07
r82 (  6 33 ) resistor r=0.751729 //w=0.17 //l=0.085 //layer=li \
 //thickness=0.1 //x=2.625 //y=1.175 //x2=2.54 //y2=1.175
r83 (  5 30 ) resistor r=1.40859 //w=0.34 //l=0.085 //layer=li //thickness=0.1 \
 //x=3.505 //y=1.175 //x2=3.59 //y2=1.175
r84 (  5 6 ) resistor r=60.2353 //w=0.187 //l=0.88 //layer=li //thickness=0.1 \
 //x=3.505 //y=1.175 //x2=2.625 //y2=1.175
ends PM_TMRDFFRNQNX1\%noxref_20

subckt PM_TMRDFFRNQNX1\%noxref_21 ( 5 7 15 19 30 33 34 )
c69 ( 34 0 ) capacitor c=0.0450634f //x=8.265 //y=0.555
c70 ( 33 0 ) capacitor c=0.0192636f //x=7.16 //y=1.09
c71 ( 30 0 ) capacitor c=0.00141302f //x=8.4 //y=1.175
c72 ( 19 0 ) capacitor c=0.00695768f //x=9.37 //y=0.805
c73 ( 15 0 ) capacitor c=0.0153419f //x=9.285 //y=0.72
c74 ( 7 0 ) capacitor c=0.00689476f //x=8.4 //y=0.805
c75 ( 5 0 ) capacitor c=0.0241574f //x=8.315 //y=1.175
r76 (  19 34 ) resistor r=3.57586 //w=0.17 //l=0.125 //layer=li \
 //thickness=0.1 //x=9.37 //y=0.805 //x2=9.37 //y2=0.68
r77 (  19 34 ) resistor r=18.139 //w=0.187 //l=0.265 //layer=li \
 //thickness=0.1 //x=9.37 //y=0.805 //x2=9.37 //y2=1.07
r78 (  16 34 ) resistor r=3.57586 //w=0.17 //l=0.103078 //layer=li \
 //thickness=0.1 //x=8.485 //y=0.72 //x2=8.4 //y2=0.68
r79 (  16 34 ) resistor r=27.3797 //w=0.187 //l=0.4 //layer=li //thickness=0.1 \
 //x=8.485 //y=0.72 //x2=8.885 //y2=0.72
r80 (  15 34 ) resistor r=3.57586 //w=0.17 //l=0.103078 //layer=li \
 //thickness=0.1 //x=9.285 //y=0.72 //x2=9.37 //y2=0.68
r81 (  15 34 ) resistor r=27.3797 //w=0.187 //l=0.4 //layer=li //thickness=0.1 \
 //x=9.285 //y=0.72 //x2=8.885 //y2=0.72
r82 (  11 30 ) resistor r=5.4201 //w=0.17 //l=0.085 //layer=li //thickness=0.1 \
 //x=8.4 //y=1.26 //x2=8.4 //y2=1.175
r83 (  11 34 ) resistor r=10.2674 //w=0.187 //l=0.15 //layer=li \
 //thickness=0.1 //x=8.4 //y=1.26 //x2=8.4 //y2=1.41
r84 (  8 30 ) resistor r=5.4201 //w=0.17 //l=0.085 //layer=li //thickness=0.1 \
 //x=8.4 //y=1.09 //x2=8.4 //y2=1.175
r85 (  8 34 ) resistor r=1.36898 //w=0.187 //l=0.02 //layer=li //thickness=0.1 \
 //x=8.4 //y=1.09 //x2=8.4 //y2=1.07
r86 (  7 34 ) resistor r=3.57586 //w=0.17 //l=0.125 //layer=li //thickness=0.1 \
 //x=8.4 //y=0.805 //x2=8.4 //y2=0.68
r87 (  7 34 ) resistor r=18.139 //w=0.187 //l=0.265 //layer=li //thickness=0.1 \
 //x=8.4 //y=0.805 //x2=8.4 //y2=1.07
r88 (  6 33 ) resistor r=0.751729 //w=0.17 //l=0.085 //layer=li \
 //thickness=0.1 //x=7.435 //y=1.175 //x2=7.35 //y2=1.175
r89 (  5 30 ) resistor r=1.40859 //w=0.34 //l=0.085 //layer=li //thickness=0.1 \
 //x=8.315 //y=1.175 //x2=8.4 //y2=1.175
r90 (  5 6 ) resistor r=60.2353 //w=0.187 //l=0.88 //layer=li //thickness=0.1 \
 //x=8.315 //y=1.175 //x2=7.435 //y2=1.175
ends PM_TMRDFFRNQNX1\%noxref_21

subckt PM_TMRDFFRNQNX1\%noxref_22 ( 5 7 15 19 30 33 34 )
c67 ( 34 0 ) capacitor c=0.0455032f //x=16.405 //y=0.555
c68 ( 33 0 ) capacitor c=0.019478f //x=15.3 //y=1.09
c69 ( 30 0 ) capacitor c=0.00141302f //x=16.54 //y=1.175
c70 ( 19 0 ) capacitor c=0.00692795f //x=17.51 //y=0.805
c71 ( 15 0 ) capacitor c=0.0153419f //x=17.425 //y=0.72
c72 ( 7 0 ) capacitor c=0.00689459f //x=16.54 //y=0.805
c73 ( 5 0 ) capacitor c=0.0235962f //x=16.455 //y=1.175
r74 (  19 34 ) resistor r=3.57586 //w=0.17 //l=0.125 //layer=li \
 //thickness=0.1 //x=17.51 //y=0.805 //x2=17.51 //y2=0.68
r75 (  19 34 ) resistor r=18.139 //w=0.187 //l=0.265 //layer=li \
 //thickness=0.1 //x=17.51 //y=0.805 //x2=17.51 //y2=1.07
r76 (  16 34 ) resistor r=3.57586 //w=0.17 //l=0.103078 //layer=li \
 //thickness=0.1 //x=16.625 //y=0.72 //x2=16.54 //y2=0.68
r77 (  16 34 ) resistor r=27.3797 //w=0.187 //l=0.4 //layer=li //thickness=0.1 \
 //x=16.625 //y=0.72 //x2=17.025 //y2=0.72
r78 (  15 34 ) resistor r=3.57586 //w=0.17 //l=0.103078 //layer=li \
 //thickness=0.1 //x=17.425 //y=0.72 //x2=17.51 //y2=0.68
r79 (  15 34 ) resistor r=27.3797 //w=0.187 //l=0.4 //layer=li //thickness=0.1 \
 //x=17.425 //y=0.72 //x2=17.025 //y2=0.72
r80 (  11 30 ) resistor r=5.4201 //w=0.17 //l=0.085 //layer=li //thickness=0.1 \
 //x=16.54 //y=1.26 //x2=16.54 //y2=1.175
r81 (  11 34 ) resistor r=10.2674 //w=0.187 //l=0.15 //layer=li \
 //thickness=0.1 //x=16.54 //y=1.26 //x2=16.54 //y2=1.41
r82 (  8 30 ) resistor r=5.4201 //w=0.17 //l=0.085 //layer=li //thickness=0.1 \
 //x=16.54 //y=1.09 //x2=16.54 //y2=1.175
r83 (  8 34 ) resistor r=1.36898 //w=0.187 //l=0.02 //layer=li //thickness=0.1 \
 //x=16.54 //y=1.09 //x2=16.54 //y2=1.07
r84 (  7 34 ) resistor r=3.57586 //w=0.17 //l=0.125 //layer=li //thickness=0.1 \
 //x=16.54 //y=0.805 //x2=16.54 //y2=0.68
r85 (  7 34 ) resistor r=18.139 //w=0.187 //l=0.265 //layer=li //thickness=0.1 \
 //x=16.54 //y=0.805 //x2=16.54 //y2=1.07
r86 (  6 33 ) resistor r=0.751729 //w=0.17 //l=0.085 //layer=li \
 //thickness=0.1 //x=15.575 //y=1.175 //x2=15.49 //y2=1.175
r87 (  5 30 ) resistor r=1.40859 //w=0.34 //l=0.085 //layer=li //thickness=0.1 \
 //x=16.455 //y=1.175 //x2=16.54 //y2=1.175
r88 (  5 6 ) resistor r=60.2353 //w=0.187 //l=0.88 //layer=li //thickness=0.1 \
 //x=16.455 //y=1.175 //x2=15.575 //y2=1.175
ends PM_TMRDFFRNQNX1\%noxref_22

subckt PM_TMRDFFRNQNX1\%noxref_23 ( 5 7 15 19 30 33 34 )
c69 ( 34 0 ) capacitor c=0.0454561f //x=21.215 //y=0.555
c70 ( 33 0 ) capacitor c=0.0186047f //x=20.11 //y=1.09
c71 ( 30 0 ) capacitor c=0.00141302f //x=21.35 //y=1.175
c72 ( 19 0 ) capacitor c=0.00695768f //x=22.32 //y=0.805
c73 ( 15 0 ) capacitor c=0.0155355f //x=22.235 //y=0.72
c74 ( 7 0 ) capacitor c=0.00689476f //x=21.35 //y=0.805
c75 ( 5 0 ) capacitor c=0.0235962f //x=21.265 //y=1.175
r76 (  19 34 ) resistor r=3.57586 //w=0.17 //l=0.125 //layer=li \
 //thickness=0.1 //x=22.32 //y=0.805 //x2=22.32 //y2=0.68
r77 (  19 34 ) resistor r=18.139 //w=0.187 //l=0.265 //layer=li \
 //thickness=0.1 //x=22.32 //y=0.805 //x2=22.32 //y2=1.07
r78 (  16 34 ) resistor r=3.57586 //w=0.17 //l=0.103078 //layer=li \
 //thickness=0.1 //x=21.435 //y=0.72 //x2=21.35 //y2=0.68
r79 (  16 34 ) resistor r=27.3797 //w=0.187 //l=0.4 //layer=li //thickness=0.1 \
 //x=21.435 //y=0.72 //x2=21.835 //y2=0.72
r80 (  15 34 ) resistor r=3.57586 //w=0.17 //l=0.103078 //layer=li \
 //thickness=0.1 //x=22.235 //y=0.72 //x2=22.32 //y2=0.68
r81 (  15 34 ) resistor r=27.3797 //w=0.187 //l=0.4 //layer=li //thickness=0.1 \
 //x=22.235 //y=0.72 //x2=21.835 //y2=0.72
r82 (  11 30 ) resistor r=5.4201 //w=0.17 //l=0.085 //layer=li //thickness=0.1 \
 //x=21.35 //y=1.26 //x2=21.35 //y2=1.175
r83 (  11 34 ) resistor r=10.2674 //w=0.187 //l=0.15 //layer=li \
 //thickness=0.1 //x=21.35 //y=1.26 //x2=21.35 //y2=1.41
r84 (  8 30 ) resistor r=5.4201 //w=0.17 //l=0.085 //layer=li //thickness=0.1 \
 //x=21.35 //y=1.09 //x2=21.35 //y2=1.175
r85 (  8 34 ) resistor r=1.36898 //w=0.187 //l=0.02 //layer=li //thickness=0.1 \
 //x=21.35 //y=1.09 //x2=21.35 //y2=1.07
r86 (  7 34 ) resistor r=3.57586 //w=0.17 //l=0.125 //layer=li //thickness=0.1 \
 //x=21.35 //y=0.805 //x2=21.35 //y2=0.68
r87 (  7 34 ) resistor r=18.139 //w=0.187 //l=0.265 //layer=li //thickness=0.1 \
 //x=21.35 //y=0.805 //x2=21.35 //y2=1.07
r88 (  6 33 ) resistor r=0.751729 //w=0.17 //l=0.085 //layer=li \
 //thickness=0.1 //x=20.385 //y=1.175 //x2=20.3 //y2=1.175
r89 (  5 30 ) resistor r=1.40859 //w=0.34 //l=0.085 //layer=li //thickness=0.1 \
 //x=21.265 //y=1.175 //x2=21.35 //y2=1.175
r90 (  5 6 ) resistor r=60.2353 //w=0.187 //l=0.88 //layer=li //thickness=0.1 \
 //x=21.265 //y=1.175 //x2=20.385 //y2=1.175
ends PM_TMRDFFRNQNX1\%noxref_23

subckt PM_TMRDFFRNQNX1\%noxref_24 ( 5 7 15 19 30 33 34 )
c67 ( 34 0 ) capacitor c=0.0455026f //x=29.355 //y=0.555
c68 ( 33 0 ) capacitor c=0.0194934f //x=28.25 //y=1.09
c69 ( 30 0 ) capacitor c=0.00141302f //x=29.49 //y=1.175
c70 ( 19 0 ) capacitor c=0.00692795f //x=30.46 //y=0.805
c71 ( 15 0 ) capacitor c=0.0155081f //x=30.375 //y=0.72
c72 ( 7 0 ) capacitor c=0.00689459f //x=29.49 //y=0.805
c73 ( 5 0 ) capacitor c=0.0235962f //x=29.405 //y=1.175
r74 (  19 34 ) resistor r=3.57586 //w=0.17 //l=0.125 //layer=li \
 //thickness=0.1 //x=30.46 //y=0.805 //x2=30.46 //y2=0.68
r75 (  19 34 ) resistor r=18.139 //w=0.187 //l=0.265 //layer=li \
 //thickness=0.1 //x=30.46 //y=0.805 //x2=30.46 //y2=1.07
r76 (  16 34 ) resistor r=3.57586 //w=0.17 //l=0.103078 //layer=li \
 //thickness=0.1 //x=29.575 //y=0.72 //x2=29.49 //y2=0.68
r77 (  16 34 ) resistor r=27.3797 //w=0.187 //l=0.4 //layer=li //thickness=0.1 \
 //x=29.575 //y=0.72 //x2=29.975 //y2=0.72
r78 (  15 34 ) resistor r=3.57586 //w=0.17 //l=0.103078 //layer=li \
 //thickness=0.1 //x=30.375 //y=0.72 //x2=30.46 //y2=0.68
r79 (  15 34 ) resistor r=27.3797 //w=0.187 //l=0.4 //layer=li //thickness=0.1 \
 //x=30.375 //y=0.72 //x2=29.975 //y2=0.72
r80 (  11 30 ) resistor r=5.4201 //w=0.17 //l=0.085 //layer=li //thickness=0.1 \
 //x=29.49 //y=1.26 //x2=29.49 //y2=1.175
r81 (  11 34 ) resistor r=10.2674 //w=0.187 //l=0.15 //layer=li \
 //thickness=0.1 //x=29.49 //y=1.26 //x2=29.49 //y2=1.41
r82 (  8 30 ) resistor r=5.4201 //w=0.17 //l=0.085 //layer=li //thickness=0.1 \
 //x=29.49 //y=1.09 //x2=29.49 //y2=1.175
r83 (  8 34 ) resistor r=1.36898 //w=0.187 //l=0.02 //layer=li //thickness=0.1 \
 //x=29.49 //y=1.09 //x2=29.49 //y2=1.07
r84 (  7 34 ) resistor r=3.57586 //w=0.17 //l=0.125 //layer=li //thickness=0.1 \
 //x=29.49 //y=0.805 //x2=29.49 //y2=0.68
r85 (  7 34 ) resistor r=18.139 //w=0.187 //l=0.265 //layer=li //thickness=0.1 \
 //x=29.49 //y=0.805 //x2=29.49 //y2=1.07
r86 (  6 33 ) resistor r=0.751729 //w=0.17 //l=0.085 //layer=li \
 //thickness=0.1 //x=28.525 //y=1.175 //x2=28.44 //y2=1.175
r87 (  5 30 ) resistor r=1.40859 //w=0.34 //l=0.085 //layer=li //thickness=0.1 \
 //x=29.405 //y=1.175 //x2=29.49 //y2=1.175
r88 (  5 6 ) resistor r=60.2353 //w=0.187 //l=0.88 //layer=li //thickness=0.1 \
 //x=29.405 //y=1.175 //x2=28.525 //y2=1.175
ends PM_TMRDFFRNQNX1\%noxref_24

subckt PM_TMRDFFRNQNX1\%noxref_25 ( 5 7 15 19 30 33 34 )
c68 ( 34 0 ) capacitor c=0.0449068f //x=34.165 //y=0.555
c69 ( 33 0 ) capacitor c=0.019228f //x=33.06 //y=1.09
c70 ( 30 0 ) capacitor c=0.00141302f //x=34.3 //y=1.175
c71 ( 19 0 ) capacitor c=0.00695768f //x=35.27 //y=0.805
c72 ( 15 0 ) capacitor c=0.0153419f //x=35.185 //y=0.72
c73 ( 7 0 ) capacitor c=0.00689476f //x=34.3 //y=0.805
c74 ( 5 0 ) capacitor c=0.0235923f //x=34.215 //y=1.175
r75 (  19 34 ) resistor r=3.57586 //w=0.17 //l=0.125 //layer=li \
 //thickness=0.1 //x=35.27 //y=0.805 //x2=35.27 //y2=0.68
r76 (  19 34 ) resistor r=18.139 //w=0.187 //l=0.265 //layer=li \
 //thickness=0.1 //x=35.27 //y=0.805 //x2=35.27 //y2=1.07
r77 (  16 34 ) resistor r=3.57586 //w=0.17 //l=0.103078 //layer=li \
 //thickness=0.1 //x=34.385 //y=0.72 //x2=34.3 //y2=0.68
r78 (  16 34 ) resistor r=27.3797 //w=0.187 //l=0.4 //layer=li //thickness=0.1 \
 //x=34.385 //y=0.72 //x2=34.785 //y2=0.72
r79 (  15 34 ) resistor r=3.57586 //w=0.17 //l=0.103078 //layer=li \
 //thickness=0.1 //x=35.185 //y=0.72 //x2=35.27 //y2=0.68
r80 (  15 34 ) resistor r=27.3797 //w=0.187 //l=0.4 //layer=li //thickness=0.1 \
 //x=35.185 //y=0.72 //x2=34.785 //y2=0.72
r81 (  11 30 ) resistor r=5.4201 //w=0.17 //l=0.085 //layer=li //thickness=0.1 \
 //x=34.3 //y=1.26 //x2=34.3 //y2=1.175
r82 (  11 34 ) resistor r=10.2674 //w=0.187 //l=0.15 //layer=li \
 //thickness=0.1 //x=34.3 //y=1.26 //x2=34.3 //y2=1.41
r83 (  8 30 ) resistor r=5.4201 //w=0.17 //l=0.085 //layer=li //thickness=0.1 \
 //x=34.3 //y=1.09 //x2=34.3 //y2=1.175
r84 (  8 34 ) resistor r=1.36898 //w=0.187 //l=0.02 //layer=li //thickness=0.1 \
 //x=34.3 //y=1.09 //x2=34.3 //y2=1.07
r85 (  7 34 ) resistor r=3.57586 //w=0.17 //l=0.125 //layer=li //thickness=0.1 \
 //x=34.3 //y=0.805 //x2=34.3 //y2=0.68
r86 (  7 34 ) resistor r=18.139 //w=0.187 //l=0.265 //layer=li //thickness=0.1 \
 //x=34.3 //y=0.805 //x2=34.3 //y2=1.07
r87 (  6 33 ) resistor r=0.751729 //w=0.17 //l=0.085 //layer=li \
 //thickness=0.1 //x=33.335 //y=1.175 //x2=33.25 //y2=1.175
r88 (  5 30 ) resistor r=1.40859 //w=0.34 //l=0.085 //layer=li //thickness=0.1 \
 //x=34.215 //y=1.175 //x2=34.3 //y2=1.175
r89 (  5 6 ) resistor r=60.2353 //w=0.187 //l=0.88 //layer=li //thickness=0.1 \
 //x=34.215 //y=1.175 //x2=33.335 //y2=1.175
ends PM_TMRDFFRNQNX1\%noxref_25

subckt PM_TMRDFFRNQNX1\%noxref_26 ( 5 7 15 19 30 33 34 )
c67 ( 34 0 ) capacitor c=0.0455032f //x=42.305 //y=0.555
c68 ( 33 0 ) capacitor c=0.019478f //x=41.2 //y=1.09
c69 ( 30 0 ) capacitor c=0.00141302f //x=42.44 //y=1.175
c70 ( 19 0 ) capacitor c=0.00692795f //x=43.41 //y=0.805
c71 ( 15 0 ) capacitor c=0.0153419f //x=43.325 //y=0.72
c72 ( 7 0 ) capacitor c=0.00689459f //x=42.44 //y=0.805
c73 ( 5 0 ) capacitor c=0.0235962f //x=42.355 //y=1.175
r74 (  19 34 ) resistor r=3.57586 //w=0.17 //l=0.125 //layer=li \
 //thickness=0.1 //x=43.41 //y=0.805 //x2=43.41 //y2=0.68
r75 (  19 34 ) resistor r=18.139 //w=0.187 //l=0.265 //layer=li \
 //thickness=0.1 //x=43.41 //y=0.805 //x2=43.41 //y2=1.07
r76 (  16 34 ) resistor r=3.57586 //w=0.17 //l=0.103078 //layer=li \
 //thickness=0.1 //x=42.525 //y=0.72 //x2=42.44 //y2=0.68
r77 (  16 34 ) resistor r=27.3797 //w=0.187 //l=0.4 //layer=li //thickness=0.1 \
 //x=42.525 //y=0.72 //x2=42.925 //y2=0.72
r78 (  15 34 ) resistor r=3.57586 //w=0.17 //l=0.103078 //layer=li \
 //thickness=0.1 //x=43.325 //y=0.72 //x2=43.41 //y2=0.68
r79 (  15 34 ) resistor r=27.3797 //w=0.187 //l=0.4 //layer=li //thickness=0.1 \
 //x=43.325 //y=0.72 //x2=42.925 //y2=0.72
r80 (  11 30 ) resistor r=5.4201 //w=0.17 //l=0.085 //layer=li //thickness=0.1 \
 //x=42.44 //y=1.26 //x2=42.44 //y2=1.175
r81 (  11 34 ) resistor r=10.2674 //w=0.187 //l=0.15 //layer=li \
 //thickness=0.1 //x=42.44 //y=1.26 //x2=42.44 //y2=1.41
r82 (  8 30 ) resistor r=5.4201 //w=0.17 //l=0.085 //layer=li //thickness=0.1 \
 //x=42.44 //y=1.09 //x2=42.44 //y2=1.175
r83 (  8 34 ) resistor r=1.36898 //w=0.187 //l=0.02 //layer=li //thickness=0.1 \
 //x=42.44 //y=1.09 //x2=42.44 //y2=1.07
r84 (  7 34 ) resistor r=3.57586 //w=0.17 //l=0.125 //layer=li //thickness=0.1 \
 //x=42.44 //y=0.805 //x2=42.44 //y2=0.68
r85 (  7 34 ) resistor r=18.139 //w=0.187 //l=0.265 //layer=li //thickness=0.1 \
 //x=42.44 //y=0.805 //x2=42.44 //y2=1.07
r86 (  6 33 ) resistor r=0.751729 //w=0.17 //l=0.085 //layer=li \
 //thickness=0.1 //x=41.475 //y=1.175 //x2=41.39 //y2=1.175
r87 (  5 30 ) resistor r=1.40859 //w=0.34 //l=0.085 //layer=li //thickness=0.1 \
 //x=42.355 //y=1.175 //x2=42.44 //y2=1.175
r88 (  5 6 ) resistor r=60.2353 //w=0.187 //l=0.88 //layer=li //thickness=0.1 \
 //x=42.355 //y=1.175 //x2=41.475 //y2=1.175
ends PM_TMRDFFRNQNX1\%noxref_26

subckt PM_TMRDFFRNQNX1\%noxref_27 ( 5 7 15 19 30 33 34 )
c68 ( 34 0 ) capacitor c=0.0454145f //x=47.115 //y=0.555
c69 ( 33 0 ) capacitor c=0.0186047f //x=46.01 //y=1.09
c70 ( 30 0 ) capacitor c=0.00141302f //x=47.25 //y=1.175
c71 ( 19 0 ) capacitor c=0.00695768f //x=48.22 //y=0.805
c72 ( 15 0 ) capacitor c=0.0155072f //x=48.135 //y=0.72
c73 ( 7 0 ) capacitor c=0.00689476f //x=47.25 //y=0.805
c74 ( 5 0 ) capacitor c=0.0235962f //x=47.165 //y=1.175
r75 (  19 34 ) resistor r=3.57586 //w=0.17 //l=0.125 //layer=li \
 //thickness=0.1 //x=48.22 //y=0.805 //x2=48.22 //y2=0.68
r76 (  19 34 ) resistor r=18.139 //w=0.187 //l=0.265 //layer=li \
 //thickness=0.1 //x=48.22 //y=0.805 //x2=48.22 //y2=1.07
r77 (  16 34 ) resistor r=3.57586 //w=0.17 //l=0.103078 //layer=li \
 //thickness=0.1 //x=47.335 //y=0.72 //x2=47.25 //y2=0.68
r78 (  16 34 ) resistor r=27.3797 //w=0.187 //l=0.4 //layer=li //thickness=0.1 \
 //x=47.335 //y=0.72 //x2=47.735 //y2=0.72
r79 (  15 34 ) resistor r=3.57586 //w=0.17 //l=0.103078 //layer=li \
 //thickness=0.1 //x=48.135 //y=0.72 //x2=48.22 //y2=0.68
r80 (  15 34 ) resistor r=27.3797 //w=0.187 //l=0.4 //layer=li //thickness=0.1 \
 //x=48.135 //y=0.72 //x2=47.735 //y2=0.72
r81 (  11 30 ) resistor r=5.4201 //w=0.17 //l=0.085 //layer=li //thickness=0.1 \
 //x=47.25 //y=1.26 //x2=47.25 //y2=1.175
r82 (  11 34 ) resistor r=10.2674 //w=0.187 //l=0.15 //layer=li \
 //thickness=0.1 //x=47.25 //y=1.26 //x2=47.25 //y2=1.41
r83 (  8 30 ) resistor r=5.4201 //w=0.17 //l=0.085 //layer=li //thickness=0.1 \
 //x=47.25 //y=1.09 //x2=47.25 //y2=1.175
r84 (  8 34 ) resistor r=1.36898 //w=0.187 //l=0.02 //layer=li //thickness=0.1 \
 //x=47.25 //y=1.09 //x2=47.25 //y2=1.07
r85 (  7 34 ) resistor r=3.57586 //w=0.17 //l=0.125 //layer=li //thickness=0.1 \
 //x=47.25 //y=0.805 //x2=47.25 //y2=0.68
r86 (  7 34 ) resistor r=18.139 //w=0.187 //l=0.265 //layer=li //thickness=0.1 \
 //x=47.25 //y=0.805 //x2=47.25 //y2=1.07
r87 (  6 33 ) resistor r=0.751729 //w=0.17 //l=0.085 //layer=li \
 //thickness=0.1 //x=46.285 //y=1.175 //x2=46.2 //y2=1.175
r88 (  5 30 ) resistor r=1.40859 //w=0.34 //l=0.085 //layer=li //thickness=0.1 \
 //x=47.165 //y=1.175 //x2=47.25 //y2=1.175
r89 (  5 6 ) resistor r=60.2353 //w=0.187 //l=0.88 //layer=li //thickness=0.1 \
 //x=47.165 //y=1.175 //x2=46.285 //y2=1.175
ends PM_TMRDFFRNQNX1\%noxref_27

subckt PM_TMRDFFRNQNX1\%noxref_28 ( 5 7 15 19 30 33 34 )
c67 ( 34 0 ) capacitor c=0.0455026f //x=55.255 //y=0.555
c68 ( 33 0 ) capacitor c=0.0194934f //x=54.15 //y=1.09
c69 ( 30 0 ) capacitor c=0.00141302f //x=55.39 //y=1.175
c70 ( 19 0 ) capacitor c=0.00692795f //x=56.36 //y=0.805
c71 ( 15 0 ) capacitor c=0.0155081f //x=56.275 //y=0.72
c72 ( 7 0 ) capacitor c=0.00689459f //x=55.39 //y=0.805
c73 ( 5 0 ) capacitor c=0.0235962f //x=55.305 //y=1.175
r74 (  19 34 ) resistor r=3.57586 //w=0.17 //l=0.125 //layer=li \
 //thickness=0.1 //x=56.36 //y=0.805 //x2=56.36 //y2=0.68
r75 (  19 34 ) resistor r=18.139 //w=0.187 //l=0.265 //layer=li \
 //thickness=0.1 //x=56.36 //y=0.805 //x2=56.36 //y2=1.07
r76 (  16 34 ) resistor r=3.57586 //w=0.17 //l=0.103078 //layer=li \
 //thickness=0.1 //x=55.475 //y=0.72 //x2=55.39 //y2=0.68
r77 (  16 34 ) resistor r=27.3797 //w=0.187 //l=0.4 //layer=li //thickness=0.1 \
 //x=55.475 //y=0.72 //x2=55.875 //y2=0.72
r78 (  15 34 ) resistor r=3.57586 //w=0.17 //l=0.103078 //layer=li \
 //thickness=0.1 //x=56.275 //y=0.72 //x2=56.36 //y2=0.68
r79 (  15 34 ) resistor r=27.3797 //w=0.187 //l=0.4 //layer=li //thickness=0.1 \
 //x=56.275 //y=0.72 //x2=55.875 //y2=0.72
r80 (  11 30 ) resistor r=5.4201 //w=0.17 //l=0.085 //layer=li //thickness=0.1 \
 //x=55.39 //y=1.26 //x2=55.39 //y2=1.175
r81 (  11 34 ) resistor r=10.2674 //w=0.187 //l=0.15 //layer=li \
 //thickness=0.1 //x=55.39 //y=1.26 //x2=55.39 //y2=1.41
r82 (  8 30 ) resistor r=5.4201 //w=0.17 //l=0.085 //layer=li //thickness=0.1 \
 //x=55.39 //y=1.09 //x2=55.39 //y2=1.175
r83 (  8 34 ) resistor r=1.36898 //w=0.187 //l=0.02 //layer=li //thickness=0.1 \
 //x=55.39 //y=1.09 //x2=55.39 //y2=1.07
r84 (  7 34 ) resistor r=3.57586 //w=0.17 //l=0.125 //layer=li //thickness=0.1 \
 //x=55.39 //y=0.805 //x2=55.39 //y2=0.68
r85 (  7 34 ) resistor r=18.139 //w=0.187 //l=0.265 //layer=li //thickness=0.1 \
 //x=55.39 //y=0.805 //x2=55.39 //y2=1.07
r86 (  6 33 ) resistor r=0.751729 //w=0.17 //l=0.085 //layer=li \
 //thickness=0.1 //x=54.425 //y=1.175 //x2=54.34 //y2=1.175
r87 (  5 30 ) resistor r=1.40859 //w=0.34 //l=0.085 //layer=li //thickness=0.1 \
 //x=55.305 //y=1.175 //x2=55.39 //y2=1.175
r88 (  5 6 ) resistor r=60.2353 //w=0.187 //l=0.88 //layer=li //thickness=0.1 \
 //x=55.305 //y=1.175 //x2=54.425 //y2=1.175
ends PM_TMRDFFRNQNX1\%noxref_28

subckt PM_TMRDFFRNQNX1\%noxref_29 ( 5 7 15 19 30 33 34 )
c68 ( 34 0 ) capacitor c=0.0449068f //x=60.065 //y=0.555
c69 ( 33 0 ) capacitor c=0.0192736f //x=58.96 //y=1.09
c70 ( 30 0 ) capacitor c=0.00141302f //x=60.2 //y=1.175
c71 ( 19 0 ) capacitor c=0.00695768f //x=61.17 //y=0.805
c72 ( 15 0 ) capacitor c=0.0153419f //x=61.085 //y=0.72
c73 ( 7 0 ) capacitor c=0.00689476f //x=60.2 //y=0.805
c74 ( 5 0 ) capacitor c=0.0235962f //x=60.115 //y=1.175
r75 (  19 34 ) resistor r=3.57586 //w=0.17 //l=0.125 //layer=li \
 //thickness=0.1 //x=61.17 //y=0.805 //x2=61.17 //y2=0.68
r76 (  19 34 ) resistor r=18.139 //w=0.187 //l=0.265 //layer=li \
 //thickness=0.1 //x=61.17 //y=0.805 //x2=61.17 //y2=1.07
r77 (  16 34 ) resistor r=3.57586 //w=0.17 //l=0.103078 //layer=li \
 //thickness=0.1 //x=60.285 //y=0.72 //x2=60.2 //y2=0.68
r78 (  16 34 ) resistor r=27.3797 //w=0.187 //l=0.4 //layer=li //thickness=0.1 \
 //x=60.285 //y=0.72 //x2=60.685 //y2=0.72
r79 (  15 34 ) resistor r=3.57586 //w=0.17 //l=0.103078 //layer=li \
 //thickness=0.1 //x=61.085 //y=0.72 //x2=61.17 //y2=0.68
r80 (  15 34 ) resistor r=27.3797 //w=0.187 //l=0.4 //layer=li //thickness=0.1 \
 //x=61.085 //y=0.72 //x2=60.685 //y2=0.72
r81 (  11 30 ) resistor r=5.4201 //w=0.17 //l=0.085 //layer=li //thickness=0.1 \
 //x=60.2 //y=1.26 //x2=60.2 //y2=1.175
r82 (  11 34 ) resistor r=10.2674 //w=0.187 //l=0.15 //layer=li \
 //thickness=0.1 //x=60.2 //y=1.26 //x2=60.2 //y2=1.41
r83 (  8 30 ) resistor r=5.4201 //w=0.17 //l=0.085 //layer=li //thickness=0.1 \
 //x=60.2 //y=1.09 //x2=60.2 //y2=1.175
r84 (  8 34 ) resistor r=1.36898 //w=0.187 //l=0.02 //layer=li //thickness=0.1 \
 //x=60.2 //y=1.09 //x2=60.2 //y2=1.07
r85 (  7 34 ) resistor r=3.57586 //w=0.17 //l=0.125 //layer=li //thickness=0.1 \
 //x=60.2 //y=0.805 //x2=60.2 //y2=0.68
r86 (  7 34 ) resistor r=18.139 //w=0.187 //l=0.265 //layer=li //thickness=0.1 \
 //x=60.2 //y=0.805 //x2=60.2 //y2=1.07
r87 (  6 33 ) resistor r=0.751729 //w=0.17 //l=0.085 //layer=li \
 //thickness=0.1 //x=59.235 //y=1.175 //x2=59.15 //y2=1.175
r88 (  5 30 ) resistor r=1.40859 //w=0.34 //l=0.085 //layer=li //thickness=0.1 \
 //x=60.115 //y=1.175 //x2=60.2 //y2=1.175
r89 (  5 6 ) resistor r=60.2353 //w=0.187 //l=0.88 //layer=li //thickness=0.1 \
 //x=60.115 //y=1.175 //x2=59.235 //y2=1.175
ends PM_TMRDFFRNQNX1\%noxref_29

subckt PM_TMRDFFRNQNX1\%noxref_30 ( 1 2 3 4 10 12 21 25 26 27 28 29 30 32 38 \
 39 40 41 42 50 )
c141 ( 50 0 ) capacitor c=0.0369044f //x=59.32 //y=4.88
c142 ( 42 0 ) capacitor c=0.0309248f //x=59.655 //y=4.97
c143 ( 41 0 ) capacitor c=0.0817558f //x=59.41 //y=2.095
c144 ( 40 0 ) capacitor c=0.0170266f //x=59.41 //y=1.63
c145 ( 39 0 ) capacitor c=0.018609f //x=59.41 //y=1.4
c146 ( 38 0 ) capacitor c=0.0186599f //x=59.41 //y=1.09
c147 ( 32 0 ) capacitor c=0.0146988f //x=59.255 //y=1.555
c148 ( 30 0 ) capacitor c=0.0148531f //x=59.255 //y=0.935
c149 ( 29 0 ) capacitor c=0.0334406f //x=58.885 //y=1.4
c150 ( 28 0 ) capacitor c=0.0173191f //x=58.885 //y=1.09
c151 ( 27 0 ) capacitor c=0.110208f //x=59.73 //y=6.2
c152 ( 26 0 ) capacitor c=0.110214f //x=59.29 //y=6.2
c153 ( 21 0 ) capacitor c=0.00129935f //x=59.32 //y=4.88
c154 ( 12 0 ) capacitor c=9.49278e-19 //x=59.32 //y=2.26
c155 ( 10 0 ) capacitor c=0.0159525f //x=59.32 //y=2.77
c156 ( 4 0 ) capacitor c=0.0547103f //x=59.32 //y=4.765
c157 ( 3 0 ) capacitor c=0.0107525f //x=59.32 //y=2.885
c158 ( 2 0 ) capacitor c=0.00494398f //x=59.32 //y=2.655
c159 ( 1 0 ) capacitor c=0.00382585f //x=59.32 //y=2.375
r160 (  52 53 ) resistor r=32.4568 //w=0.214 //l=0.075 //layer=ply \
 //thickness=0.18 //x=59.32 //y=4.97 //x2=59.32 //y2=5.045
r161 (  50 52 ) resistor r=20.271 //w=0.214 //l=0.09 //layer=ply \
 //thickness=0.18 //x=59.32 //y=4.88 //x2=59.32 //y2=4.97
r162 (  43 52 ) resistor r=16.5046 //w=0.27 //l=0.135 //layer=ply \
 //thickness=0.18 //x=59.455 //y=4.97 //x2=59.32 //y2=4.97
r163 (  42 44 ) resistor r=26.9307 //w=0.15 //l=0.106066 //layer=ply \
 //thickness=0.18 //x=59.655 //y=4.97 //x2=59.73 //y2=5.045
r164 (  42 43 ) resistor r=102.553 //w=0.094 //l=0.2 //layer=ply \
 //thickness=0.18 //x=59.655 //y=4.97 //x2=59.455 //y2=4.97
r165 (  41 57 ) resistor r=38.6777 //w=0.284 //l=0.198997 //layer=ply \
 //thickness=0.18 //x=59.41 //y=2.095 //x2=59.335 //y2=2.26
r166 (  40 55 ) resistor r=21.2976 //w=0.217 //l=0.0928709 //layer=ply \
 //thickness=0.18 //x=59.41 //y=1.63 //x2=59.37 //y2=1.555
r167 (  40 41 ) resistor r=238.436 //w=0.094 //l=0.465 //layer=ply \
 //thickness=0.18 //x=59.41 //y=1.63 //x2=59.41 //y2=2.095
r168 (  39 55 ) resistor r=39.0671 //w=0.217 //l=0.173853 //layer=ply \
 //thickness=0.18 //x=59.41 //y=1.4 //x2=59.37 //y2=1.555
r169 (  38 54 ) resistor r=45.1352 //w=0.168 //l=0.173853 //layer=ply \
 //thickness=0.18 //x=59.41 //y=1.09 //x2=59.37 //y2=0.935
r170 (  38 39 ) resistor r=158.957 //w=0.094 //l=0.31 //layer=ply \
 //thickness=0.18 //x=59.41 //y=1.09 //x2=59.41 //y2=1.4
r171 (  33 48 ) resistor r=5.52526 //w=0.168 //l=0.115 //layer=ply \
 //thickness=0.18 //x=59.04 //y=1.555 //x2=58.925 //y2=1.555
r172 (  32 55 ) resistor r=11.4558 //w=0.217 //l=0.115 //layer=ply \
 //thickness=0.18 //x=59.255 //y=1.555 //x2=59.37 //y2=1.555
r173 (  31 47 ) resistor r=5.52526 //w=0.168 //l=0.115 //layer=ply \
 //thickness=0.18 //x=59.04 //y=0.935 //x2=58.925 //y2=0.935
r174 (  30 54 ) resistor r=5.52526 //w=0.168 //l=0.115 //layer=ply \
 //thickness=0.18 //x=59.255 //y=0.935 //x2=59.37 //y2=0.935
r175 (  30 31 ) resistor r=110.245 //w=0.094 //l=0.215 //layer=ply \
 //thickness=0.18 //x=59.255 //y=0.935 //x2=59.04 //y2=0.935
r176 (  29 48 ) resistor r=45.1352 //w=0.168 //l=0.173853 //layer=ply \
 //thickness=0.18 //x=58.885 //y=1.4 //x2=58.925 //y2=1.555
r177 (  28 47 ) resistor r=45.1352 //w=0.168 //l=0.173853 //layer=ply \
 //thickness=0.18 //x=58.885 //y=1.09 //x2=58.925 //y2=0.935
r178 (  28 29 ) resistor r=158.957 //w=0.094 //l=0.31 //layer=ply \
 //thickness=0.18 //x=58.885 //y=1.09 //x2=58.885 //y2=1.4
r179 (  27 44 ) resistor r=592.245 //w=0.094 //l=1.155 //layer=ply \
 //thickness=0.18 //x=59.73 //y=6.2 //x2=59.73 //y2=5.045
r180 (  26 53 ) resistor r=592.245 //w=0.094 //l=1.155 //layer=ply \
 //thickness=0.18 //x=59.29 //y=6.2 //x2=59.29 //y2=5.045
r181 (  25 32 ) resistor r=55.3787 //w=0.094 //l=0.108 //layer=ply \
 //thickness=0.18 //x=59.147 //y=1.555 //x2=59.255 //y2=1.555
r182 (  25 33 ) resistor r=54.866 //w=0.094 //l=0.107 //layer=ply \
 //thickness=0.18 //x=59.147 //y=1.555 //x2=59.04 //y2=1.555
r183 (  21 50 ) resistor r=152 //w=0.17 //l=0.17 //layer=licon //count=1 \
 //x=59.32 //y=4.88 //x2=59.32 //y2=4.88
r184 (  12 57 ) resistor r=152 //w=0.17 //l=0.17 //layer=licon //count=1 \
 //x=59.32 //y=2.26 //x2=59.32 //y2=2.26
r185 (  8 21 ) resistor r=9.3 //w=0.17 //l=0.17 //layer=mcon //count=1 \
 //x=59.32 //y=4.88 //x2=59.32 //y2=4.88
r186 (  6 12 ) resistor r=9.3 //w=0.17 //l=0.17 //layer=mcon //count=1 \
 //x=59.32 //y=2.26 //x2=59.32 //y2=2.26
r187 (  4 8 ) resistor r=0.0717383 //w=0.224 //l=0.115 //layer=m1 \
 //thickness=0.36 //x=59.32 //y=4.765 //x2=59.32 //y2=4.88
r188 (  3 10 ) resistor r=0.0752589 //w=0.364 //l=0.141863 //layer=m1 \
 //thickness=0.36 //x=59.32 //y=2.885 //x2=59.38 //y2=2.77
r189 (  3 4 ) resistor r=1.79389 //w=0.131 //l=1.88 //layer=m1 \
 //thickness=0.36 //x=59.32 //y=2.885 //x2=59.32 //y2=4.765
r190 (  2 10 ) resistor r=0.0752589 //w=0.364 //l=0.141863 //layer=m1 \
 //thickness=0.36 //x=59.32 //y=2.655 //x2=59.38 //y2=2.77
r191 (  1 6 ) resistor r=0.0715665 //w=0.226 //l=0.115996 //layer=m1 \
 //thickness=0.36 //x=59.32 //y=2.375 //x2=59.322 //y2=2.26
r192 (  1 2 ) resistor r=0.267176 //w=0.131 //l=0.28 //layer=m1 \
 //thickness=0.36 //x=59.32 //y=2.375 //x2=59.32 //y2=2.655
ends PM_TMRDFFRNQNX1\%noxref_30

subckt PM_TMRDFFRNQNX1\%noxref_31 ( 5 7 15 19 30 33 34 )
c67 ( 34 0 ) capacitor c=0.0455032f //x=68.205 //y=0.555
c68 ( 33 0 ) capacitor c=0.019478f //x=67.1 //y=1.09
c69 ( 30 0 ) capacitor c=0.00141302f //x=68.34 //y=1.175
c70 ( 19 0 ) capacitor c=0.00692795f //x=69.31 //y=0.805
c71 ( 15 0 ) capacitor c=0.0153419f //x=69.225 //y=0.72
c72 ( 7 0 ) capacitor c=0.00689459f //x=68.34 //y=0.805
c73 ( 5 0 ) capacitor c=0.0235962f //x=68.255 //y=1.175
r74 (  19 34 ) resistor r=3.57586 //w=0.17 //l=0.125 //layer=li \
 //thickness=0.1 //x=69.31 //y=0.805 //x2=69.31 //y2=0.68
r75 (  19 34 ) resistor r=18.139 //w=0.187 //l=0.265 //layer=li \
 //thickness=0.1 //x=69.31 //y=0.805 //x2=69.31 //y2=1.07
r76 (  16 34 ) resistor r=3.57586 //w=0.17 //l=0.103078 //layer=li \
 //thickness=0.1 //x=68.425 //y=0.72 //x2=68.34 //y2=0.68
r77 (  16 34 ) resistor r=27.3797 //w=0.187 //l=0.4 //layer=li //thickness=0.1 \
 //x=68.425 //y=0.72 //x2=68.825 //y2=0.72
r78 (  15 34 ) resistor r=3.57586 //w=0.17 //l=0.103078 //layer=li \
 //thickness=0.1 //x=69.225 //y=0.72 //x2=69.31 //y2=0.68
r79 (  15 34 ) resistor r=27.3797 //w=0.187 //l=0.4 //layer=li //thickness=0.1 \
 //x=69.225 //y=0.72 //x2=68.825 //y2=0.72
r80 (  11 30 ) resistor r=5.4201 //w=0.17 //l=0.085 //layer=li //thickness=0.1 \
 //x=68.34 //y=1.26 //x2=68.34 //y2=1.175
r81 (  11 34 ) resistor r=10.2674 //w=0.187 //l=0.15 //layer=li \
 //thickness=0.1 //x=68.34 //y=1.26 //x2=68.34 //y2=1.41
r82 (  8 30 ) resistor r=5.4201 //w=0.17 //l=0.085 //layer=li //thickness=0.1 \
 //x=68.34 //y=1.09 //x2=68.34 //y2=1.175
r83 (  8 34 ) resistor r=1.36898 //w=0.187 //l=0.02 //layer=li //thickness=0.1 \
 //x=68.34 //y=1.09 //x2=68.34 //y2=1.07
r84 (  7 34 ) resistor r=3.57586 //w=0.17 //l=0.125 //layer=li //thickness=0.1 \
 //x=68.34 //y=0.805 //x2=68.34 //y2=0.68
r85 (  7 34 ) resistor r=18.139 //w=0.187 //l=0.265 //layer=li //thickness=0.1 \
 //x=68.34 //y=0.805 //x2=68.34 //y2=1.07
r86 (  6 33 ) resistor r=0.751729 //w=0.17 //l=0.085 //layer=li \
 //thickness=0.1 //x=67.375 //y=1.175 //x2=67.29 //y2=1.175
r87 (  5 30 ) resistor r=1.40859 //w=0.34 //l=0.085 //layer=li //thickness=0.1 \
 //x=68.255 //y=1.175 //x2=68.34 //y2=1.175
r88 (  5 6 ) resistor r=60.2353 //w=0.187 //l=0.88 //layer=li //thickness=0.1 \
 //x=68.255 //y=1.175 //x2=67.375 //y2=1.175
ends PM_TMRDFFRNQNX1\%noxref_31

subckt PM_TMRDFFRNQNX1\%noxref_32 ( 5 7 15 19 30 33 34 )
c68 ( 34 0 ) capacitor c=0.0459825f //x=73.015 //y=0.555
c69 ( 33 0 ) capacitor c=0.0186047f //x=71.91 //y=1.09
c70 ( 30 0 ) capacitor c=0.00141302f //x=73.15 //y=1.175
c71 ( 19 0 ) capacitor c=0.00695768f //x=74.12 //y=0.805
c72 ( 15 0 ) capacitor c=0.0155081f //x=74.035 //y=0.72
c73 ( 7 0 ) capacitor c=0.00689476f //x=73.15 //y=0.805
c74 ( 5 0 ) capacitor c=0.0247635f //x=73.065 //y=1.175
r75 (  19 34 ) resistor r=3.57586 //w=0.17 //l=0.125 //layer=li \
 //thickness=0.1 //x=74.12 //y=0.805 //x2=74.12 //y2=0.68
r76 (  19 34 ) resistor r=18.139 //w=0.187 //l=0.265 //layer=li \
 //thickness=0.1 //x=74.12 //y=0.805 //x2=74.12 //y2=1.07
r77 (  16 34 ) resistor r=3.57586 //w=0.17 //l=0.103078 //layer=li \
 //thickness=0.1 //x=73.235 //y=0.72 //x2=73.15 //y2=0.68
r78 (  16 34 ) resistor r=27.3797 //w=0.187 //l=0.4 //layer=li //thickness=0.1 \
 //x=73.235 //y=0.72 //x2=73.635 //y2=0.72
r79 (  15 34 ) resistor r=3.57586 //w=0.17 //l=0.103078 //layer=li \
 //thickness=0.1 //x=74.035 //y=0.72 //x2=74.12 //y2=0.68
r80 (  15 34 ) resistor r=27.3797 //w=0.187 //l=0.4 //layer=li //thickness=0.1 \
 //x=74.035 //y=0.72 //x2=73.635 //y2=0.72
r81 (  11 30 ) resistor r=5.4201 //w=0.17 //l=0.085 //layer=li //thickness=0.1 \
 //x=73.15 //y=1.26 //x2=73.15 //y2=1.175
r82 (  11 34 ) resistor r=10.2674 //w=0.187 //l=0.15 //layer=li \
 //thickness=0.1 //x=73.15 //y=1.26 //x2=73.15 //y2=1.41
r83 (  8 30 ) resistor r=5.4201 //w=0.17 //l=0.085 //layer=li //thickness=0.1 \
 //x=73.15 //y=1.09 //x2=73.15 //y2=1.175
r84 (  8 34 ) resistor r=1.36898 //w=0.187 //l=0.02 //layer=li //thickness=0.1 \
 //x=73.15 //y=1.09 //x2=73.15 //y2=1.07
r85 (  7 34 ) resistor r=3.57586 //w=0.17 //l=0.125 //layer=li //thickness=0.1 \
 //x=73.15 //y=0.805 //x2=73.15 //y2=0.68
r86 (  7 34 ) resistor r=18.139 //w=0.187 //l=0.265 //layer=li //thickness=0.1 \
 //x=73.15 //y=0.805 //x2=73.15 //y2=1.07
r87 (  6 33 ) resistor r=0.751729 //w=0.17 //l=0.085 //layer=li \
 //thickness=0.1 //x=72.185 //y=1.175 //x2=72.1 //y2=1.175
r88 (  5 30 ) resistor r=1.40859 //w=0.34 //l=0.085 //layer=li //thickness=0.1 \
 //x=73.065 //y=1.175 //x2=73.15 //y2=1.175
r89 (  5 6 ) resistor r=60.2353 //w=0.187 //l=0.88 //layer=li //thickness=0.1 \
 //x=73.065 //y=1.175 //x2=72.185 //y2=1.175
ends PM_TMRDFFRNQNX1\%noxref_32

subckt PM_TMRDFFRNQNX1\%noxref_33 ( 1 3 4 5 7 9 19 25 27 30 40 49 71 72 73 74 \
 75 )
c161 ( 75 0 ) capacitor c=0.0354016f //x=83.915 //y=5.205
c162 ( 74 0 ) capacitor c=0.0241107f //x=83.035 //y=5.205
c163 ( 72 0 ) capacitor c=0.00544792f //x=80.155 //y=5.205
c164 ( 71 0 ) capacitor c=0.00516996f //x=79.275 //y=5.205
c165 ( 49 0 ) capacitor c=0.0508454f //x=82.3 //y=5.39
c166 ( 40 0 ) capacitor c=0.0362911f //x=80.3 //y=5.39
c167 ( 30 0 ) capacitor c=0.0293961f //x=79.42 //y=5.56
c168 ( 27 0 ) capacitor c=0.00984489f //x=84.06 //y=6.92
c169 ( 25 0 ) capacitor c=0.0059844f //x=83.177 //y=7.09
c170 ( 19 0 ) capacitor c=0.00975753f //x=82.3 //y=6.92
c171 ( 9 0 ) capacitor c=0.014892f //x=79.422 //y=5.39
c172 ( 7 0 ) capacitor c=0.00787288f //x=83.945 //y=7.09
c173 ( 5 0 ) capacitor c=0.00659042f //x=83.06 //y=7.09
c174 ( 4 0 ) capacitor c=0.0054878f //x=80.415 //y=5.39
c175 ( 3 0 ) capacitor c=0.0636102f //x=82.185 //y=5.39
c176 ( 1 0 ) capacitor c=0.0145996f //x=80.185 //y=5.39
r177 (  49 73 ) resistor r=58.1818 //w=0.187 //l=0.85 //layer=li \
 //thickness=0.1 //x=82.3 //y=5.39 //x2=82.3 //y2=6.24
r178 (  40 72 ) resistor r=58.1818 //w=0.187 //l=0.85 //layer=li \
 //thickness=0.1 //x=80.3 //y=5.39 //x2=80.3 //y2=6.24
r179 (  30 71 ) resistor r=23.2727 //w=0.187 //l=0.34 //layer=li \
 //thickness=0.1 //x=79.42 //y=5.56 //x2=79.42 //y2=5.9
r180 (  27 75 ) resistor r=9.3 //w=0.17 //l=0.17 //layer=mcon //count=1 \
 //x=84.06 //y=6.92 //x2=84.06 //y2=6.92
r181 (  27 28 ) resistor r=0.0988372 //w=0.215 //l=0.17 //layer=m1 \
 //thickness=0.36 //x=84.062 //y=6.92 //x2=84.062 //y2=7.09
r182 (  24 74 ) resistor r=9.3 //w=0.17 //l=0.17 //layer=mcon //count=1 \
 //x=83.18 //y=6.92 //x2=83.18 //y2=6.92
r183 (  24 25 ) resistor r=0.0940266 //w=0.226 //l=0.17 //layer=m1 \
 //thickness=0.36 //x=83.177 //y=6.92 //x2=83.177 //y2=7.09
r184 (  22 49 ) resistor r=9.3 //w=0.17 //l=0.17 //layer=mcon //count=1 \
 //x=82.3 //y=5.39 //x2=82.3 //y2=5.39
r185 (  19 73 ) resistor r=9.3 //w=0.17 //l=0.17 //layer=mcon //count=1 \
 //x=82.3 //y=6.92 //x2=82.3 //y2=6.92
r186 (  19 20 ) resistor r=0.0979263 //w=0.217 //l=0.17 //layer=m1 \
 //thickness=0.36 //x=82.302 //y=6.92 //x2=82.302 //y2=7.09
r187 (  15 40 ) resistor r=9.3 //w=0.17 //l=0.17 //layer=mcon //count=1 \
 //x=80.3 //y=5.39 //x2=80.3 //y2=5.39
r188 (  11 30 ) resistor r=9.3 //w=0.17 //l=0.17 //layer=mcon //count=1 \
 //x=79.42 //y=5.56 //x2=79.42 //y2=5.56
r189 (  9 11 ) resistor r=0.0944444 //w=0.225 //l=0.17 //layer=m1 \
 //thickness=0.36 //x=79.422 //y=5.39 //x2=79.422 //y2=5.56
r190 (  8 25 ) resistor r=0.0246599 //w=0.226 //l=0.118 //layer=m1 \
 //thickness=0.36 //x=83.295 //y=7.09 //x2=83.177 //y2=7.09
r191 (  7 28 ) resistor r=0.0216707 //w=0.215 //l=0.117 //layer=m1 \
 //thickness=0.36 //x=83.945 //y=7.09 //x2=84.062 //y2=7.09
r192 (  7 8 ) resistor r=0.620229 //w=0.131 //l=0.65 //layer=m1 \
 //thickness=0.36 //x=83.945 //y=7.09 //x2=83.295 //y2=7.09
r193 (  6 20 ) resistor r=0.0222262 //w=0.217 //l=0.118 //layer=m1 \
 //thickness=0.36 //x=82.42 //y=7.09 //x2=82.302 //y2=7.09
r194 (  5 25 ) resistor r=0.0246599 //w=0.226 //l=0.117 //layer=m1 \
 //thickness=0.36 //x=83.06 //y=7.09 //x2=83.177 //y2=7.09
r195 (  5 6 ) resistor r=0.610687 //w=0.131 //l=0.64 //layer=m1 \
 //thickness=0.36 //x=83.06 //y=7.09 //x2=82.42 //y2=7.09
r196 (  4 15 ) resistor r=0.0880901 //w=0.191 //l=0.115 //layer=m1 \
 //thickness=0.36 //x=80.415 //y=5.39 //x2=80.3 //y2=5.39
r197 (  3 22 ) resistor r=0.0717383 //w=0.224 //l=0.115 //layer=m1 \
 //thickness=0.36 //x=82.185 //y=5.39 //x2=82.3 //y2=5.39
r198 (  3 4 ) resistor r=1.68893 //w=0.131 //l=1.77 //layer=m1 \
 //thickness=0.36 //x=82.185 //y=5.39 //x2=80.415 //y2=5.39
r199 (  2 9 ) resistor r=0.0243946 //w=0.225 //l=0.123 //layer=m1 \
 //thickness=0.36 //x=79.545 //y=5.39 //x2=79.422 //y2=5.39
r200 (  1 15 ) resistor r=0.0880901 //w=0.191 //l=0.115 //layer=m1 \
 //thickness=0.36 //x=80.185 //y=5.39 //x2=80.3 //y2=5.39
r201 (  1 2 ) resistor r=0.610687 //w=0.131 //l=0.64 //layer=m1 \
 //thickness=0.36 //x=80.185 //y=5.39 //x2=79.545 //y2=5.39
ends PM_TMRDFFRNQNX1\%noxref_33

subckt PM_TMRDFFRNQNX1\%noxref_34 ( 1 3 4 5 7 9 13 15 21 23 26 38 60 61 62 63 )
c122 ( 63 0 ) capacitor c=0.0346626f //x=87.255 //y=5.205
c123 ( 62 0 ) capacitor c=0.0239063f //x=86.375 //y=5.205
c124 ( 38 0 ) capacitor c=0.0496943f //x=85.64 //y=5.39
c125 ( 26 0 ) capacitor c=0.0229521f //x=82.74 //y=5.56
c126 ( 23 0 ) capacitor c=0.0159821f //x=87.4 //y=6.92
c127 ( 21 0 ) capacitor c=0.00566376f //x=86.52 //y=7.09
c128 ( 15 0 ) capacitor c=0.00945187f //x=85.64 //y=6.92
c129 ( 13 0 ) capacitor c=0.0163615f //x=83.62 //y=5.39
c130 ( 9 0 ) capacitor c=0.0150333f //x=82.74 //y=5.39
c131 ( 7 0 ) capacitor c=0.0068287f //x=87.27 //y=7.09
c132 ( 5 0 ) capacitor c=0.00878908f //x=86.405 //y=7.09
c133 ( 4 0 ) capacitor c=0.00822986f //x=83.735 //y=5.39
c134 ( 3 0 ) capacitor c=0.0564661f //x=85.525 //y=5.39
c135 ( 1 0 ) capacitor c=0.0183136f //x=83.505 //y=5.39
r136 (  38 61 ) resistor r=58.1818 //w=0.187 //l=0.85 //layer=li \
 //thickness=0.1 //x=85.64 //y=5.39 //x2=85.64 //y2=6.24
r137 (  26 60 ) resistor r=23.2727 //w=0.187 //l=0.34 //layer=li \
 //thickness=0.1 //x=82.74 //y=5.56 //x2=82.74 //y2=5.9
r138 (  23 63 ) resistor r=9.3 //w=0.17 //l=0.17 //layer=mcon //count=1 \
 //x=87.4 //y=6.92 //x2=87.4 //y2=6.92
r139 (  23 24 ) resistor r=0.0923913 //w=0.23 //l=0.17 //layer=m1 \
 //thickness=0.36 //x=87.395 //y=6.92 //x2=87.395 //y2=7.09
r140 (  20 62 ) resistor r=9.3 //w=0.17 //l=0.17 //layer=mcon //count=1 \
 //x=86.52 //y=6.92 //x2=86.52 //y2=6.92
r141 (  20 21 ) resistor r=0.0957207 //w=0.222 //l=0.17 //layer=m1 \
 //thickness=0.36 //x=86.52 //y=6.92 //x2=86.52 //y2=7.09
r142 (  18 38 ) resistor r=9.3 //w=0.17 //l=0.17 //layer=mcon //count=1 \
 //x=85.64 //y=5.39 //x2=85.64 //y2=5.39
r143 (  15 61 ) resistor r=9.3 //w=0.17 //l=0.17 //layer=mcon //count=1 \
 //x=85.64 //y=6.92 //x2=85.64 //y2=6.92
r144 (  15 16 ) resistor r=0.100236 //w=0.212 //l=0.17 //layer=m1 \
 //thickness=0.36 //x=85.64 //y=6.92 //x2=85.64 //y2=7.09
r145 (  11 26 ) resistor r=9.3 //w=0.17 //l=0.17 //layer=mcon //count=1 \
 //x=82.74 //y=5.56 //x2=82.74 //y2=5.56
r146 (  9 11 ) resistor r=0.100236 //w=0.212 //l=0.17 //layer=m1 \
 //thickness=0.36 //x=82.74 //y=5.39 //x2=82.74 //y2=5.56
r147 (  8 21 ) resistor r=0.0235912 //w=0.222 //l=0.115 //layer=m1 \
 //thickness=0.36 //x=86.635 //y=7.09 //x2=86.52 //y2=7.09
r148 (  7 24 ) resistor r=0.0257089 //w=0.23 //l=0.125 //layer=m1 \
 //thickness=0.36 //x=87.27 //y=7.09 //x2=87.395 //y2=7.09
r149 (  7 8 ) resistor r=0.605916 //w=0.131 //l=0.635 //layer=m1 \
 //thickness=0.36 //x=87.27 //y=7.09 //x2=86.635 //y2=7.09
r150 (  6 16 ) resistor r=0.0208269 //w=0.212 //l=0.115 //layer=m1 \
 //thickness=0.36 //x=85.755 //y=7.09 //x2=85.64 //y2=7.09
r151 (  5 21 ) resistor r=0.0235912 //w=0.222 //l=0.115 //layer=m1 \
 //thickness=0.36 //x=86.405 //y=7.09 //x2=86.52 //y2=7.09
r152 (  5 6 ) resistor r=0.620229 //w=0.131 //l=0.65 //layer=m1 \
 //thickness=0.36 //x=86.405 //y=7.09 //x2=85.755 //y2=7.09
r153 (  4 13 ) resistor r=0.0880901 //w=0.191 //l=0.115 //layer=m1 \
 //thickness=0.36 //x=83.735 //y=5.39 //x2=83.62 //y2=5.39
r154 (  3 18 ) resistor r=0.0717383 //w=0.224 //l=0.115 //layer=m1 \
 //thickness=0.36 //x=85.525 //y=5.39 //x2=85.64 //y2=5.39
r155 (  3 4 ) resistor r=1.70802 //w=0.131 //l=1.79 //layer=m1 \
 //thickness=0.36 //x=85.525 //y=5.39 //x2=83.735 //y2=5.39
r156 (  2 9 ) resistor r=0.0208269 //w=0.212 //l=0.115 //layer=m1 \
 //thickness=0.36 //x=82.855 //y=5.39 //x2=82.74 //y2=5.39
r157 (  1 13 ) resistor r=0.0880901 //w=0.191 //l=0.115 //layer=m1 \
 //thickness=0.36 //x=83.505 //y=5.39 //x2=83.62 //y2=5.39
r158 (  1 2 ) resistor r=0.620229 //w=0.131 //l=0.65 //layer=m1 \
 //thickness=0.36 //x=83.505 //y=5.39 //x2=82.855 //y2=5.39
ends PM_TMRDFFRNQNX1\%noxref_34

subckt PM_TMRDFFRNQNX1\%GND ( 1 5 6 17 18 30 37 38 47 48 58 65 66 77 78 90 99 \
 100 111 112 124 131 132 141 142 152 159 160 171 172 184 193 194 202 209 214 \
 217 221 225 226 230 235 240 241 246 250 254 255 259 263 267 268 272 277 282 \
 283 288 292 296 297 304 308 311 314 328 345 360 377 394 407 424 441 456 473 \
 491 506 523 540 553 570 587 602 617 632 640 641 642 643 644 645 646 647 648 \
 649 650 651 652 653 654 655 656 657 658 659 660 661 662 663 664 665 666 667 \
 668 669 670 671 672 673 674 675 676 677 678 679 )
c1565 ( 679 0 ) capacitor c=0.00828027f //x=85.84 //y=1.045
c1566 ( 678 0 ) capacitor c=0.0083251f //x=79.18 //y=1.045
c1567 ( 677 0 ) capacitor c=0.00843555f //x=75.85 //y=1.045
c1568 ( 676 0 ) capacitor c=0.00840423f //x=70.935 //y=1.055
c1569 ( 675 0 ) capacitor c=0.00840423f //x=66.125 //y=1.055
c1570 ( 674 0 ) capacitor c=0.00843555f //x=62.9 //y=1.045
c1571 ( 673 0 ) capacitor c=0.00840423f //x=57.985 //y=1.055
c1572 ( 672 0 ) capacitor c=0.00840423f //x=53.175 //y=1.055
c1573 ( 671 0 ) capacitor c=0.00843555f //x=49.95 //y=1.045
c1574 ( 670 0 ) capacitor c=0.00840423f //x=45.035 //y=1.055
c1575 ( 669 0 ) capacitor c=0.00840423f //x=40.225 //y=1.055
c1576 ( 668 0 ) capacitor c=0.00843555f //x=37 //y=1.045
c1577 ( 667 0 ) capacitor c=0.00840423f //x=32.085 //y=1.055
c1578 ( 666 0 ) capacitor c=0.00840423f //x=27.275 //y=1.055
c1579 ( 665 0 ) capacitor c=0.00843555f //x=24.05 //y=1.045
c1580 ( 664 0 ) capacitor c=0.00840423f //x=19.135 //y=1.055
c1581 ( 663 0 ) capacitor c=0.00840423f //x=14.325 //y=1.055
c1582 ( 662 0 ) capacitor c=0.00843555f //x=11.1 //y=1.045
c1583 ( 661 0 ) capacitor c=0.00840423f //x=6.185 //y=1.055
c1584 ( 660 0 ) capacitor c=0.00840423f //x=1.375 //y=1.055
c1585 ( 659 0 ) capacitor c=0.110423f //x=84.85 //y=0.175
c1586 ( 658 0 ) capacitor c=0.123957f //x=81.52 //y=0.175
c1587 ( 657 0 ) capacitor c=0.114503f //x=78.19 //y=0.175
c1588 ( 656 0 ) capacitor c=0.118684f //x=74.86 //y=0.175
c1589 ( 655 0 ) capacitor c=0.114177f //x=70.05 //y=0.175
c1590 ( 654 0 ) capacitor c=0.112855f //x=65.24 //y=0.175
c1591 ( 653 0 ) capacitor c=0.11997f //x=61.91 //y=0.175
c1592 ( 652 0 ) capacitor c=0.114256f //x=57.1 //y=0.175
c1593 ( 651 0 ) capacitor c=0.112554f //x=52.29 //y=0.175
c1594 ( 650 0 ) capacitor c=0.118197f //x=48.96 //y=0.175
c1595 ( 649 0 ) capacitor c=0.114306f //x=44.15 //y=0.175
c1596 ( 648 0 ) capacitor c=0.112554f //x=39.34 //y=0.175
c1597 ( 647 0 ) capacitor c=0.118478f //x=36.01 //y=0.175
c1598 ( 646 0 ) capacitor c=0.114256f //x=31.2 //y=0.175
c1599 ( 645 0 ) capacitor c=0.112554f //x=26.39 //y=0.175
c1600 ( 644 0 ) capacitor c=0.118197f //x=23.06 //y=0.175
c1601 ( 643 0 ) capacitor c=0.1147f //x=18.25 //y=0.175
c1602 ( 642 0 ) capacitor c=0.112709f //x=13.44 //y=0.175
c1603 ( 641 0 ) capacitor c=0.118632f //x=10.11 //y=0.175
c1604 ( 640 0 ) capacitor c=0.114221f //x=5.3 //y=0.175
c1605 ( 632 0 ) capacitor c=0.333047f //x=87.44 //y=0.18
c1606 ( 617 0 ) capacitor c=0.118825f //x=84.68 //y=0.175
c1607 ( 602 0 ) capacitor c=0.121639f //x=81.35 //y=0.175
c1608 ( 587 0 ) capacitor c=0.126434f //x=78.02 //y=0.175
c1609 ( 570 0 ) capacitor c=0.178514f //x=74.69 //y=0.175
c1610 ( 553 0 ) capacitor c=0.176416f //x=69.88 //y=0.175
c1611 ( 540 0 ) capacitor c=0.118875f //x=65.07 //y=0.175
c1612 ( 523 0 ) capacitor c=0.176416f //x=61.74 //y=0.175
c1613 ( 506 0 ) capacitor c=0.176415f //x=56.93 //y=0.175
c1614 ( 491 0 ) capacitor c=0.11901f //x=52.12 //y=0.175
c1615 ( 473 0 ) capacitor c=0.176415f //x=48.79 //y=0.175
c1616 ( 456 0 ) capacitor c=0.176416f //x=43.98 //y=0.175
c1617 ( 441 0 ) capacitor c=0.118875f //x=39.17 //y=0.175
c1618 ( 424 0 ) capacitor c=0.176415f //x=35.84 //y=0.175
c1619 ( 407 0 ) capacitor c=0.176415f //x=31.03 //y=0.175
c1620 ( 394 0 ) capacitor c=0.119029f //x=26.22 //y=0.175
c1621 ( 377 0 ) capacitor c=0.176424f //x=22.89 //y=0.175
c1622 ( 360 0 ) capacitor c=0.176416f //x=18.08 //y=0.175
c1623 ( 345 0 ) capacitor c=0.118875f //x=13.27 //y=0.175
c1624 ( 328 0 ) capacitor c=0.179332f //x=9.94 //y=0.175
c1625 ( 314 0 ) capacitor c=0.197064f //x=1.23 //y=0.18
c1626 ( 311 0 ) capacitor c=0.181456f //x=5.13 //y=0.175
c1627 ( 305 0 ) capacitor c=0.00509083f //x=86.03 //y=0.175
c1628 ( 304 0 ) capacitor c=0.0256262f //x=82.63 //y=0.18
c1629 ( 300 0 ) capacitor c=0.00509083f //x=79.37 //y=0.175
c1630 ( 299 0 ) capacitor c=0.00509083f //x=76.04 //y=0.175
c1631 ( 297 0 ) capacitor c=0.0235363f //x=76.037 //y=1.005
c1632 ( 296 0 ) capacitor c=0.0135614f //x=76.04 //y=1.135
c1633 ( 294 0 ) capacitor c=0.00509414f //x=71.125 //y=0.175
c1634 ( 292 0 ) capacitor c=0.0140345f //x=71.125 //y=1.145
c1635 ( 290 0 ) capacitor c=0.00509414f //x=66.315 //y=0.175
c1636 ( 288 0 ) capacitor c=0.0131639f //x=66.315 //y=1.145
c1637 ( 286 0 ) capacitor c=0.00509083f //x=63.02 //y=0.18
c1638 ( 283 0 ) capacitor c=0.0234055f //x=63.087 //y=1.005
c1639 ( 282 0 ) capacitor c=0.01353f //x=63.09 //y=1.135
c1640 ( 280 0 ) capacitor c=0.00509414f //x=58.21 //y=0.18
c1641 ( 277 0 ) capacitor c=0.014142f //x=58.175 //y=1.145
c1642 ( 275 0 ) capacitor c=0.00509414f //x=53.4 //y=0.18
c1643 ( 272 0 ) capacitor c=0.0131758f //x=53.365 //y=1.145
c1644 ( 270 0 ) capacitor c=0.00509083f //x=50.14 //y=0.175
c1645 ( 268 0 ) capacitor c=0.0234055f //x=50.137 //y=1.005
c1646 ( 267 0 ) capacitor c=0.013506f //x=50.14 //y=1.135
c1647 ( 265 0 ) capacitor c=0.00509414f //x=45.225 //y=0.175
c1648 ( 263 0 ) capacitor c=0.0140335f //x=45.225 //y=1.145
c1649 ( 261 0 ) capacitor c=0.00509414f //x=40.415 //y=0.175
c1650 ( 259 0 ) capacitor c=0.0131639f //x=40.415 //y=1.145
c1651 ( 257 0 ) capacitor c=0.00509083f //x=37.19 //y=0.175
c1652 ( 255 0 ) capacitor c=0.0234055f //x=37.187 //y=1.005
c1653 ( 254 0 ) capacitor c=0.01353f //x=37.19 //y=1.135
c1654 ( 252 0 ) capacitor c=0.00509414f //x=32.275 //y=0.175
c1655 ( 250 0 ) capacitor c=0.014142f //x=32.275 //y=1.145
c1656 ( 248 0 ) capacitor c=0.00509414f //x=27.465 //y=0.175
c1657 ( 246 0 ) capacitor c=0.0131758f //x=27.465 //y=1.145
c1658 ( 244 0 ) capacitor c=0.00509083f //x=24.17 //y=0.18
c1659 ( 241 0 ) capacitor c=0.0234055f //x=24.237 //y=1.005
c1660 ( 240 0 ) capacitor c=0.0134526f //x=24.24 //y=1.135
c1661 ( 238 0 ) capacitor c=0.00509414f //x=19.36 //y=0.18
c1662 ( 235 0 ) capacitor c=0.0140335f //x=19.325 //y=1.145
c1663 ( 233 0 ) capacitor c=0.00509414f //x=14.55 //y=0.18
c1664 ( 230 0 ) capacitor c=0.013104f //x=14.515 //y=1.145
c1665 ( 228 0 ) capacitor c=0.00509083f //x=11.29 //y=0.175
c1666 ( 226 0 ) capacitor c=0.0234055f //x=11.287 //y=1.005
c1667 ( 225 0 ) capacitor c=0.01353f //x=11.29 //y=1.135
c1668 ( 223 0 ) capacitor c=0.00509414f //x=6.375 //y=0.175
c1669 ( 221 0 ) capacitor c=0.014205f //x=6.375 //y=1.145
c1670 ( 219 0 ) capacitor c=0.00509414f //x=1.565 //y=0.175
c1671 ( 217 0 ) capacitor c=0.0170404f //x=1.565 //y=1.145
c1672 ( 214 0 ) capacitor c=0.102594f //x=87.44 //y=0.18
c1673 ( 209 0 ) capacitor c=0.0435289f //x=86.03 //y=1.02
c1674 ( 202 0 ) capacitor c=0.107614f //x=85.945 //y=0.175
c1675 ( 194 0 ) capacitor c=0.112566f //x=82.615 //y=0.175
c1676 ( 193 0 ) capacitor c=0.0359644f //x=79.37 //y=1.015
c1677 ( 184 0 ) capacitor c=0.109956f //x=79.285 //y=0.175
c1678 ( 172 0 ) capacitor c=0.15491f //x=75.955 //y=0.175
c1679 ( 171 0 ) capacitor c=0.0302305f //x=71.125 //y=1.015
c1680 ( 160 0 ) capacitor c=0.150267f //x=71.04 //y=0.175
c1681 ( 159 0 ) capacitor c=0.0253397f //x=66.315 //y=1.015
c1682 ( 152 0 ) capacitor c=0.105424f //x=66.23 //y=0.175
c1683 ( 142 0 ) capacitor c=0.15436f //x=63.005 //y=0.175
c1684 ( 141 0 ) capacitor c=0.0302305f //x=58.175 //y=1.015
c1685 ( 132 0 ) capacitor c=0.149273f //x=58.09 //y=0.175
c1686 ( 131 0 ) capacitor c=0.0253397f //x=53.365 //y=1.015
c1687 ( 124 0 ) capacitor c=0.106799f //x=53.28 //y=0.175
c1688 ( 112 0 ) capacitor c=0.154648f //x=50.055 //y=0.175
c1689 ( 111 0 ) capacitor c=0.0302305f //x=45.225 //y=1.015
c1690 ( 100 0 ) capacitor c=0.150267f //x=45.14 //y=0.175
c1691 ( 99 0 ) capacitor c=0.0253397f //x=40.415 //y=1.015
c1692 ( 90 0 ) capacitor c=0.105424f //x=40.33 //y=0.175
c1693 ( 78 0 ) capacitor c=0.15436f //x=37.105 //y=0.175
c1694 ( 77 0 ) capacitor c=0.0302305f //x=32.275 //y=1.015
c1695 ( 66 0 ) capacitor c=0.149273f //x=32.19 //y=0.175
c1696 ( 65 0 ) capacitor c=0.0253397f //x=27.465 //y=1.015
c1697 ( 58 0 ) capacitor c=0.106786f //x=27.38 //y=0.175
c1698 ( 48 0 ) capacitor c=0.154828f //x=24.155 //y=0.175
c1699 ( 47 0 ) capacitor c=0.0302305f //x=19.325 //y=1.015
c1700 ( 38 0 ) capacitor c=0.150267f //x=19.24 //y=0.175
c1701 ( 37 0 ) capacitor c=0.0253397f //x=14.515 //y=1.015
c1702 ( 30 0 ) capacitor c=0.105424f //x=14.43 //y=0.175
c1703 ( 18 0 ) capacitor c=0.154392f //x=11.205 //y=0.175
c1704 ( 17 0 ) capacitor c=0.0302305f //x=6.375 //y=1.015
c1705 ( 6 0 ) capacitor c=0.149367f //x=6.29 //y=0.175
c1706 ( 5 0 ) capacitor c=0.0302305f //x=1.565 //y=1.015
c1707 ( 1 0 ) capacitor c=0.0710427f //x=1.48 //y=0.175
r1708 (  630 632 ) resistor r=38.7139 //w=0.367 //l=1.11 //layer=li \
 //thickness=0.1 //x=86.33 //y=0.175 //x2=87.44 //y2=0.175
r1709 (  628 630 ) resistor r=38.7139 //w=0.367 //l=1.11 //layer=li \
 //thickness=0.1 //x=85.22 //y=0.175 //x2=86.33 //y2=0.175
r1710 (  626 659 ) resistor r=5.29055 //w=0.35 //l=0.17 //layer=li \
 //thickness=0.1 //x=85.02 //y=0.175 //x2=84.85 //y2=0.175
r1711 (  626 628 ) resistor r=6.97548 //w=0.367 //l=0.2 //layer=li \
 //thickness=0.1 //x=85.02 //y=0.175 //x2=85.22 //y2=0.175
r1712 (  620 622 ) resistor r=38.7139 //w=0.367 //l=1.11 //layer=li \
 //thickness=0.1 //x=82.63 //y=0.175 //x2=83.74 //y2=0.175
r1713 (  618 658 ) resistor r=5.29055 //w=0.35 //l=0.17 //layer=li \
 //thickness=0.1 //x=81.69 //y=0.175 //x2=81.52 //y2=0.175
r1714 (  618 620 ) resistor r=32.7847 //w=0.367 //l=0.94 //layer=li \
 //thickness=0.1 //x=81.69 //y=0.175 //x2=82.63 //y2=0.175
r1715 (  617 659 ) resistor r=5.29055 //w=0.35 //l=0.17 //layer=li \
 //thickness=0.1 //x=84.68 //y=0.175 //x2=84.85 //y2=0.175
r1716 (  617 622 ) resistor r=32.7847 //w=0.367 //l=0.94 //layer=li \
 //thickness=0.1 //x=84.68 //y=0.175 //x2=83.74 //y2=0.175
r1717 (  607 609 ) resistor r=38.7139 //w=0.367 //l=1.11 //layer=li \
 //thickness=0.1 //x=80.04 //y=0.175 //x2=81.15 //y2=0.175
r1718 (  605 607 ) resistor r=38.7139 //w=0.367 //l=1.11 //layer=li \
 //thickness=0.1 //x=78.93 //y=0.175 //x2=80.04 //y2=0.175
r1719 (  603 657 ) resistor r=5.29055 //w=0.35 //l=0.17 //layer=li \
 //thickness=0.1 //x=78.36 //y=0.175 //x2=78.19 //y2=0.175
r1720 (  603 605 ) resistor r=19.8801 //w=0.367 //l=0.57 //layer=li \
 //thickness=0.1 //x=78.36 //y=0.175 //x2=78.93 //y2=0.175
r1721 (  602 658 ) resistor r=5.29055 //w=0.35 //l=0.17 //layer=li \
 //thickness=0.1 //x=81.35 //y=0.175 //x2=81.52 //y2=0.175
r1722 (  602 609 ) resistor r=6.97548 //w=0.367 //l=0.2 //layer=li \
 //thickness=0.1 //x=81.35 //y=0.175 //x2=81.15 //y2=0.175
r1723 (  592 594 ) resistor r=38.7139 //w=0.367 //l=1.11 //layer=li \
 //thickness=0.1 //x=76.34 //y=0.175 //x2=77.45 //y2=0.175
r1724 (  590 592 ) resistor r=38.7139 //w=0.367 //l=1.11 //layer=li \
 //thickness=0.1 //x=75.23 //y=0.175 //x2=76.34 //y2=0.175
r1725 (  588 656 ) resistor r=5.29055 //w=0.35 //l=0.17 //layer=li \
 //thickness=0.1 //x=75.03 //y=0.175 //x2=74.86 //y2=0.175
r1726 (  588 590 ) resistor r=6.97548 //w=0.367 //l=0.2 //layer=li \
 //thickness=0.1 //x=75.03 //y=0.175 //x2=75.23 //y2=0.175
r1727 (  587 657 ) resistor r=5.29055 //w=0.35 //l=0.17 //layer=li \
 //thickness=0.1 //x=78.02 //y=0.175 //x2=78.19 //y2=0.175
r1728 (  587 594 ) resistor r=19.8801 //w=0.367 //l=0.57 //layer=li \
 //thickness=0.1 //x=78.02 //y=0.175 //x2=77.45 //y2=0.175
r1729 (  577 579 ) resistor r=38.7139 //w=0.367 //l=1.11 //layer=li \
 //thickness=0.1 //x=72.64 //y=0.175 //x2=73.75 //y2=0.175
r1730 (  575 577 ) resistor r=38.7139 //w=0.367 //l=1.11 //layer=li \
 //thickness=0.1 //x=71.53 //y=0.175 //x2=72.64 //y2=0.175
r1731 (  573 575 ) resistor r=38.7139 //w=0.367 //l=1.11 //layer=li \
 //thickness=0.1 //x=70.42 //y=0.175 //x2=71.53 //y2=0.175
r1732 (  571 655 ) resistor r=5.29055 //w=0.35 //l=0.17 //layer=li \
 //thickness=0.1 //x=70.22 //y=0.175 //x2=70.05 //y2=0.175
r1733 (  571 573 ) resistor r=6.97548 //w=0.367 //l=0.2 //layer=li \
 //thickness=0.1 //x=70.22 //y=0.175 //x2=70.42 //y2=0.175
r1734 (  570 656 ) resistor r=5.29055 //w=0.35 //l=0.17 //layer=li \
 //thickness=0.1 //x=74.69 //y=0.175 //x2=74.86 //y2=0.175
r1735 (  570 579 ) resistor r=32.7847 //w=0.367 //l=0.94 //layer=li \
 //thickness=0.1 //x=74.69 //y=0.175 //x2=73.75 //y2=0.175
r1736 (  560 562 ) resistor r=38.7139 //w=0.367 //l=1.11 //layer=li \
 //thickness=0.1 //x=67.83 //y=0.175 //x2=68.94 //y2=0.175
r1737 (  558 560 ) resistor r=38.7139 //w=0.367 //l=1.11 //layer=li \
 //thickness=0.1 //x=66.72 //y=0.175 //x2=67.83 //y2=0.175
r1738 (  556 558 ) resistor r=38.7139 //w=0.367 //l=1.11 //layer=li \
 //thickness=0.1 //x=65.61 //y=0.175 //x2=66.72 //y2=0.175
r1739 (  554 654 ) resistor r=5.29055 //w=0.35 //l=0.17 //layer=li \
 //thickness=0.1 //x=65.41 //y=0.175 //x2=65.24 //y2=0.175
r1740 (  554 556 ) resistor r=6.97548 //w=0.367 //l=0.2 //layer=li \
 //thickness=0.1 //x=65.41 //y=0.175 //x2=65.61 //y2=0.175
r1741 (  553 655 ) resistor r=5.29055 //w=0.35 //l=0.17 //layer=li \
 //thickness=0.1 //x=69.88 //y=0.175 //x2=70.05 //y2=0.175
r1742 (  553 562 ) resistor r=32.7847 //w=0.367 //l=0.94 //layer=li \
 //thickness=0.1 //x=69.88 //y=0.175 //x2=68.94 //y2=0.175
r1743 (  543 545 ) resistor r=38.7139 //w=0.367 //l=1.11 //layer=li \
 //thickness=0.1 //x=63.02 //y=0.175 //x2=64.13 //y2=0.175
r1744 (  541 653 ) resistor r=5.29055 //w=0.35 //l=0.17 //layer=li \
 //thickness=0.1 //x=62.08 //y=0.175 //x2=61.91 //y2=0.175
r1745 (  541 543 ) resistor r=32.7847 //w=0.367 //l=0.94 //layer=li \
 //thickness=0.1 //x=62.08 //y=0.175 //x2=63.02 //y2=0.175
r1746 (  540 654 ) resistor r=5.29055 //w=0.35 //l=0.17 //layer=li \
 //thickness=0.1 //x=65.07 //y=0.175 //x2=65.24 //y2=0.175
r1747 (  540 545 ) resistor r=32.7847 //w=0.367 //l=0.94 //layer=li \
 //thickness=0.1 //x=65.07 //y=0.175 //x2=64.13 //y2=0.175
r1748 (  530 532 ) resistor r=38.7139 //w=0.367 //l=1.11 //layer=li \
 //thickness=0.1 //x=60.43 //y=0.175 //x2=61.54 //y2=0.175
r1749 (  528 530 ) resistor r=38.7139 //w=0.367 //l=1.11 //layer=li \
 //thickness=0.1 //x=59.32 //y=0.175 //x2=60.43 //y2=0.175
r1750 (  526 528 ) resistor r=38.7139 //w=0.367 //l=1.11 //layer=li \
 //thickness=0.1 //x=58.21 //y=0.175 //x2=59.32 //y2=0.175
r1751 (  524 652 ) resistor r=5.29055 //w=0.35 //l=0.17 //layer=li \
 //thickness=0.1 //x=57.27 //y=0.175 //x2=57.1 //y2=0.175
r1752 (  524 526 ) resistor r=32.7847 //w=0.367 //l=0.94 //layer=li \
 //thickness=0.1 //x=57.27 //y=0.175 //x2=58.21 //y2=0.175
r1753 (  523 653 ) resistor r=5.29055 //w=0.35 //l=0.17 //layer=li \
 //thickness=0.1 //x=61.74 //y=0.175 //x2=61.91 //y2=0.175
r1754 (  523 532 ) resistor r=6.97548 //w=0.367 //l=0.2 //layer=li \
 //thickness=0.1 //x=61.74 //y=0.175 //x2=61.54 //y2=0.175
r1755 (  513 515 ) resistor r=38.7139 //w=0.367 //l=1.11 //layer=li \
 //thickness=0.1 //x=55.62 //y=0.175 //x2=56.73 //y2=0.175
r1756 (  511 513 ) resistor r=38.7139 //w=0.367 //l=1.11 //layer=li \
 //thickness=0.1 //x=54.51 //y=0.175 //x2=55.62 //y2=0.175
r1757 (  509 511 ) resistor r=38.7139 //w=0.367 //l=1.11 //layer=li \
 //thickness=0.1 //x=53.4 //y=0.175 //x2=54.51 //y2=0.175
r1758 (  507 651 ) resistor r=5.29055 //w=0.35 //l=0.17 //layer=li \
 //thickness=0.1 //x=52.46 //y=0.175 //x2=52.29 //y2=0.175
r1759 (  507 509 ) resistor r=32.7847 //w=0.367 //l=0.94 //layer=li \
 //thickness=0.1 //x=52.46 //y=0.175 //x2=53.4 //y2=0.175
r1760 (  506 652 ) resistor r=5.29055 //w=0.35 //l=0.17 //layer=li \
 //thickness=0.1 //x=56.93 //y=0.175 //x2=57.1 //y2=0.175
r1761 (  506 515 ) resistor r=6.97548 //w=0.367 //l=0.2 //layer=li \
 //thickness=0.1 //x=56.93 //y=0.175 //x2=56.73 //y2=0.175
r1762 (  496 498 ) resistor r=38.7139 //w=0.367 //l=1.11 //layer=li \
 //thickness=0.1 //x=50.81 //y=0.175 //x2=51.92 //y2=0.175
r1763 (  494 496 ) resistor r=38.7139 //w=0.367 //l=1.11 //layer=li \
 //thickness=0.1 //x=49.7 //y=0.175 //x2=50.81 //y2=0.175
r1764 (  492 650 ) resistor r=5.29055 //w=0.35 //l=0.17 //layer=li \
 //thickness=0.1 //x=49.13 //y=0.175 //x2=48.96 //y2=0.175
r1765 (  492 494 ) resistor r=19.8801 //w=0.367 //l=0.57 //layer=li \
 //thickness=0.1 //x=49.13 //y=0.175 //x2=49.7 //y2=0.175
r1766 (  491 651 ) resistor r=5.29055 //w=0.35 //l=0.17 //layer=li \
 //thickness=0.1 //x=52.12 //y=0.175 //x2=52.29 //y2=0.175
r1767 (  491 498 ) resistor r=6.97548 //w=0.367 //l=0.2 //layer=li \
 //thickness=0.1 //x=52.12 //y=0.175 //x2=51.92 //y2=0.175
r1768 (  481 483 ) resistor r=38.7139 //w=0.367 //l=1.11 //layer=li \
 //thickness=0.1 //x=47.11 //y=0.175 //x2=48.22 //y2=0.175
r1769 (  479 481 ) resistor r=38.7139 //w=0.367 //l=1.11 //layer=li \
 //thickness=0.1 //x=46 //y=0.175 //x2=47.11 //y2=0.175
r1770 (  477 479 ) resistor r=38.7139 //w=0.367 //l=1.11 //layer=li \
 //thickness=0.1 //x=44.89 //y=0.175 //x2=46 //y2=0.175
r1771 (  474 649 ) resistor r=5.29055 //w=0.35 //l=0.17 //layer=li \
 //thickness=0.1 //x=44.32 //y=0.175 //x2=44.15 //y2=0.175
r1772 (  473 650 ) resistor r=5.29055 //w=0.35 //l=0.17 //layer=li \
 //thickness=0.1 //x=48.79 //y=0.175 //x2=48.96 //y2=0.175
r1773 (  473 483 ) resistor r=19.8801 //w=0.367 //l=0.57 //layer=li \
 //thickness=0.1 //x=48.79 //y=0.175 //x2=48.22 //y2=0.175
r1774 (  463 465 ) resistor r=38.7139 //w=0.367 //l=1.11 //layer=li \
 //thickness=0.1 //x=42.3 //y=0.175 //x2=43.41 //y2=0.175
r1775 (  461 463 ) resistor r=38.7139 //w=0.367 //l=1.11 //layer=li \
 //thickness=0.1 //x=41.19 //y=0.175 //x2=42.3 //y2=0.175
r1776 (  459 461 ) resistor r=38.7139 //w=0.367 //l=1.11 //layer=li \
 //thickness=0.1 //x=40.08 //y=0.175 //x2=41.19 //y2=0.175
r1777 (  457 648 ) resistor r=5.29055 //w=0.35 //l=0.17 //layer=li \
 //thickness=0.1 //x=39.51 //y=0.175 //x2=39.34 //y2=0.175
r1778 (  457 459 ) resistor r=19.8801 //w=0.367 //l=0.57 //layer=li \
 //thickness=0.1 //x=39.51 //y=0.175 //x2=40.08 //y2=0.175
r1779 (  456 649 ) resistor r=5.29055 //w=0.35 //l=0.17 //layer=li \
 //thickness=0.1 //x=43.98 //y=0.175 //x2=44.15 //y2=0.175
r1780 (  456 465 ) resistor r=19.8801 //w=0.367 //l=0.57 //layer=li \
 //thickness=0.1 //x=43.98 //y=0.175 //x2=43.41 //y2=0.175
r1781 (  446 448 ) resistor r=38.7139 //w=0.367 //l=1.11 //layer=li \
 //thickness=0.1 //x=37.49 //y=0.175 //x2=38.6 //y2=0.175
r1782 (  444 446 ) resistor r=38.7139 //w=0.367 //l=1.11 //layer=li \
 //thickness=0.1 //x=36.38 //y=0.175 //x2=37.49 //y2=0.175
r1783 (  442 647 ) resistor r=5.29055 //w=0.35 //l=0.17 //layer=li \
 //thickness=0.1 //x=36.18 //y=0.175 //x2=36.01 //y2=0.175
r1784 (  442 444 ) resistor r=6.97548 //w=0.367 //l=0.2 //layer=li \
 //thickness=0.1 //x=36.18 //y=0.175 //x2=36.38 //y2=0.175
r1785 (  441 648 ) resistor r=5.29055 //w=0.35 //l=0.17 //layer=li \
 //thickness=0.1 //x=39.17 //y=0.175 //x2=39.34 //y2=0.175
r1786 (  441 448 ) resistor r=19.8801 //w=0.367 //l=0.57 //layer=li \
 //thickness=0.1 //x=39.17 //y=0.175 //x2=38.6 //y2=0.175
r1787 (  431 433 ) resistor r=38.7139 //w=0.367 //l=1.11 //layer=li \
 //thickness=0.1 //x=33.79 //y=0.175 //x2=34.9 //y2=0.175
r1788 (  429 431 ) resistor r=38.7139 //w=0.367 //l=1.11 //layer=li \
 //thickness=0.1 //x=32.68 //y=0.175 //x2=33.79 //y2=0.175
r1789 (  427 429 ) resistor r=38.7139 //w=0.367 //l=1.11 //layer=li \
 //thickness=0.1 //x=31.57 //y=0.175 //x2=32.68 //y2=0.175
r1790 (  425 646 ) resistor r=5.29055 //w=0.35 //l=0.17 //layer=li \
 //thickness=0.1 //x=31.37 //y=0.175 //x2=31.2 //y2=0.175
r1791 (  425 427 ) resistor r=6.97548 //w=0.367 //l=0.2 //layer=li \
 //thickness=0.1 //x=31.37 //y=0.175 //x2=31.57 //y2=0.175
r1792 (  424 647 ) resistor r=5.29055 //w=0.35 //l=0.17 //layer=li \
 //thickness=0.1 //x=35.84 //y=0.175 //x2=36.01 //y2=0.175
r1793 (  424 433 ) resistor r=32.7847 //w=0.367 //l=0.94 //layer=li \
 //thickness=0.1 //x=35.84 //y=0.175 //x2=34.9 //y2=0.175
r1794 (  414 416 ) resistor r=38.7139 //w=0.367 //l=1.11 //layer=li \
 //thickness=0.1 //x=28.98 //y=0.175 //x2=30.09 //y2=0.175
r1795 (  412 414 ) resistor r=38.7139 //w=0.367 //l=1.11 //layer=li \
 //thickness=0.1 //x=27.87 //y=0.175 //x2=28.98 //y2=0.175
r1796 (  410 412 ) resistor r=38.7139 //w=0.367 //l=1.11 //layer=li \
 //thickness=0.1 //x=26.76 //y=0.175 //x2=27.87 //y2=0.175
r1797 (  408 645 ) resistor r=5.29055 //w=0.35 //l=0.17 //layer=li \
 //thickness=0.1 //x=26.56 //y=0.175 //x2=26.39 //y2=0.175
r1798 (  408 410 ) resistor r=6.97548 //w=0.367 //l=0.2 //layer=li \
 //thickness=0.1 //x=26.56 //y=0.175 //x2=26.76 //y2=0.175
r1799 (  407 646 ) resistor r=5.29055 //w=0.35 //l=0.17 //layer=li \
 //thickness=0.1 //x=31.03 //y=0.175 //x2=31.2 //y2=0.175
r1800 (  407 416 ) resistor r=32.7847 //w=0.367 //l=0.94 //layer=li \
 //thickness=0.1 //x=31.03 //y=0.175 //x2=30.09 //y2=0.175
r1801 (  397 399 ) resistor r=38.7139 //w=0.367 //l=1.11 //layer=li \
 //thickness=0.1 //x=24.17 //y=0.175 //x2=25.28 //y2=0.175
r1802 (  395 644 ) resistor r=5.29055 //w=0.35 //l=0.17 //layer=li \
 //thickness=0.1 //x=23.23 //y=0.175 //x2=23.06 //y2=0.175
r1803 (  395 397 ) resistor r=32.7847 //w=0.367 //l=0.94 //layer=li \
 //thickness=0.1 //x=23.23 //y=0.175 //x2=24.17 //y2=0.175
r1804 (  394 645 ) resistor r=5.29055 //w=0.35 //l=0.17 //layer=li \
 //thickness=0.1 //x=26.22 //y=0.175 //x2=26.39 //y2=0.175
r1805 (  394 399 ) resistor r=32.7847 //w=0.367 //l=0.94 //layer=li \
 //thickness=0.1 //x=26.22 //y=0.175 //x2=25.28 //y2=0.175
r1806 (  384 386 ) resistor r=38.7139 //w=0.367 //l=1.11 //layer=li \
 //thickness=0.1 //x=21.58 //y=0.175 //x2=22.69 //y2=0.175
r1807 (  382 384 ) resistor r=38.7139 //w=0.367 //l=1.11 //layer=li \
 //thickness=0.1 //x=20.47 //y=0.175 //x2=21.58 //y2=0.175
r1808 (  380 382 ) resistor r=38.7139 //w=0.367 //l=1.11 //layer=li \
 //thickness=0.1 //x=19.36 //y=0.175 //x2=20.47 //y2=0.175
r1809 (  378 643 ) resistor r=5.29055 //w=0.35 //l=0.17 //layer=li \
 //thickness=0.1 //x=18.42 //y=0.175 //x2=18.25 //y2=0.175
r1810 (  378 380 ) resistor r=32.7847 //w=0.367 //l=0.94 //layer=li \
 //thickness=0.1 //x=18.42 //y=0.175 //x2=19.36 //y2=0.175
r1811 (  377 644 ) resistor r=5.29055 //w=0.35 //l=0.17 //layer=li \
 //thickness=0.1 //x=22.89 //y=0.175 //x2=23.06 //y2=0.175
r1812 (  377 386 ) resistor r=6.97548 //w=0.367 //l=0.2 //layer=li \
 //thickness=0.1 //x=22.89 //y=0.175 //x2=22.69 //y2=0.175
r1813 (  367 369 ) resistor r=38.7139 //w=0.367 //l=1.11 //layer=li \
 //thickness=0.1 //x=16.77 //y=0.175 //x2=17.88 //y2=0.175
r1814 (  365 367 ) resistor r=38.7139 //w=0.367 //l=1.11 //layer=li \
 //thickness=0.1 //x=15.66 //y=0.175 //x2=16.77 //y2=0.175
r1815 (  363 365 ) resistor r=38.7139 //w=0.367 //l=1.11 //layer=li \
 //thickness=0.1 //x=14.55 //y=0.175 //x2=15.66 //y2=0.175
r1816 (  361 642 ) resistor r=5.29055 //w=0.35 //l=0.17 //layer=li \
 //thickness=0.1 //x=13.61 //y=0.175 //x2=13.44 //y2=0.175
r1817 (  361 363 ) resistor r=32.7847 //w=0.367 //l=0.94 //layer=li \
 //thickness=0.1 //x=13.61 //y=0.175 //x2=14.55 //y2=0.175
r1818 (  360 643 ) resistor r=5.29055 //w=0.35 //l=0.17 //layer=li \
 //thickness=0.1 //x=18.08 //y=0.175 //x2=18.25 //y2=0.175
r1819 (  360 369 ) resistor r=6.97548 //w=0.367 //l=0.2 //layer=li \
 //thickness=0.1 //x=18.08 //y=0.175 //x2=17.88 //y2=0.175
r1820 (  350 352 ) resistor r=38.7139 //w=0.367 //l=1.11 //layer=li \
 //thickness=0.1 //x=11.96 //y=0.175 //x2=13.07 //y2=0.175
r1821 (  348 350 ) resistor r=38.7139 //w=0.367 //l=1.11 //layer=li \
 //thickness=0.1 //x=10.85 //y=0.175 //x2=11.96 //y2=0.175
r1822 (  346 641 ) resistor r=5.29055 //w=0.35 //l=0.17 //layer=li \
 //thickness=0.1 //x=10.28 //y=0.175 //x2=10.11 //y2=0.175
r1823 (  346 348 ) resistor r=19.8801 //w=0.367 //l=0.57 //layer=li \
 //thickness=0.1 //x=10.28 //y=0.175 //x2=10.85 //y2=0.175
r1824 (  345 642 ) resistor r=5.29055 //w=0.35 //l=0.17 //layer=li \
 //thickness=0.1 //x=13.27 //y=0.175 //x2=13.44 //y2=0.175
r1825 (  345 352 ) resistor r=6.97548 //w=0.367 //l=0.2 //layer=li \
 //thickness=0.1 //x=13.27 //y=0.175 //x2=13.07 //y2=0.175
r1826 (  335 337 ) resistor r=38.7139 //w=0.367 //l=1.11 //layer=li \
 //thickness=0.1 //x=8.26 //y=0.175 //x2=9.37 //y2=0.175
r1827 (  333 335 ) resistor r=38.7139 //w=0.367 //l=1.11 //layer=li \
 //thickness=0.1 //x=7.15 //y=0.175 //x2=8.26 //y2=0.175
r1828 (  331 333 ) resistor r=38.7139 //w=0.367 //l=1.11 //layer=li \
 //thickness=0.1 //x=6.04 //y=0.175 //x2=7.15 //y2=0.175
r1829 (  329 640 ) resistor r=5.29055 //w=0.35 //l=0.17 //layer=li \
 //thickness=0.1 //x=5.47 //y=0.175 //x2=5.3 //y2=0.175
r1830 (  329 331 ) resistor r=19.8801 //w=0.367 //l=0.57 //layer=li \
 //thickness=0.1 //x=5.47 //y=0.175 //x2=6.04 //y2=0.175
r1831 (  328 641 ) resistor r=5.29055 //w=0.35 //l=0.17 //layer=li \
 //thickness=0.1 //x=9.94 //y=0.175 //x2=10.11 //y2=0.175
r1832 (  328 337 ) resistor r=19.8801 //w=0.367 //l=0.57 //layer=li \
 //thickness=0.1 //x=9.94 //y=0.175 //x2=9.37 //y2=0.175
r1833 (  318 320 ) resistor r=38.7139 //w=0.367 //l=1.11 //layer=li \
 //thickness=0.1 //x=3.45 //y=0.175 //x2=4.56 //y2=0.175
r1834 (  316 318 ) resistor r=38.7139 //w=0.367 //l=1.11 //layer=li \
 //thickness=0.1 //x=2.34 //y=0.175 //x2=3.45 //y2=0.175
r1835 (  314 316 ) resistor r=38.7139 //w=0.367 //l=1.11 //layer=li \
 //thickness=0.1 //x=1.23 //y=0.175 //x2=2.34 //y2=0.175
r1836 (  311 640 ) resistor r=5.29055 //w=0.35 //l=0.17 //layer=li \
 //thickness=0.1 //x=5.13 //y=0.175 //x2=5.3 //y2=0.175
r1837 (  311 320 ) resistor r=19.8801 //w=0.367 //l=0.57 //layer=li \
 //thickness=0.1 //x=5.13 //y=0.175 //x2=4.56 //y2=0.175
r1838 (  308 477 ) resistor r=19.3569 //w=0.367 //l=0.555 //layer=li \
 //thickness=0.1 //x=44.335 //y=0.175 //x2=44.89 //y2=0.175
r1839 (  308 474 ) resistor r=0.523161 //w=0.367 //l=0.015 //layer=li \
 //thickness=0.1 //x=44.335 //y=0.175 //x2=44.32 //y2=0.175
r1840 (  307 679 ) resistor r=9.3 //w=0.17 //l=0.17 //layer=mcon //count=1 \
 //x=86.03 //y=1.135 //x2=86.03 //y2=1.135
r1841 (  304 620 ) resistor r=3.1 //w=0.17 //l=0.51 //layer=mcon //count=3 \
 //x=82.63 //y=0.18 //x2=82.63 //y2=0.18
r1842 (  302 678 ) resistor r=9.3 //w=0.17 //l=0.17 //layer=mcon //count=1 \
 //x=79.37 //y=1.135 //x2=79.37 //y2=1.135
r1843 (  296 677 ) resistor r=9.3 //w=0.17 //l=0.17 //layer=mcon //count=1 \
 //x=76.04 //y=1.135 //x2=76.04 //y2=1.135
r1844 (  296 297 ) resistor r=0.0939994 //w=0.226 //l=0.13 //layer=m1 \
 //thickness=0.36 //x=76.037 //y=1.135 //x2=76.037 //y2=1.005
r1845 (  292 676 ) resistor r=9.3 //w=0.17 //l=0.17 //layer=mcon //count=1 \
 //x=71.125 //y=1.145 //x2=71.125 //y2=1.145
r1846 (  288 675 ) resistor r=9.3 //w=0.17 //l=0.17 //layer=mcon //count=1 \
 //x=66.315 //y=1.145 //x2=66.315 //y2=1.145
r1847 (  286 543 ) resistor r=3.1 //w=0.17 //l=0.51 //layer=mcon //count=3 \
 //x=63.02 //y=0.18 //x2=63.02 //y2=0.18
r1848 (  282 674 ) resistor r=9.3 //w=0.17 //l=0.17 //layer=mcon //count=1 \
 //x=63.09 //y=1.135 //x2=63.09 //y2=1.135
r1849 (  282 283 ) resistor r=0.0939994 //w=0.226 //l=0.13 //layer=m1 \
 //thickness=0.36 //x=63.087 //y=1.135 //x2=63.087 //y2=1.005
r1850 (  280 526 ) resistor r=3.1 //w=0.17 //l=0.51 //layer=mcon //count=3 \
 //x=58.21 //y=0.18 //x2=58.21 //y2=0.18
r1851 (  277 673 ) resistor r=9.3 //w=0.17 //l=0.17 //layer=mcon //count=1 \
 //x=58.175 //y=1.145 //x2=58.175 //y2=1.145
r1852 (  275 509 ) resistor r=3.1 //w=0.17 //l=0.51 //layer=mcon //count=3 \
 //x=53.4 //y=0.18 //x2=53.4 //y2=0.18
r1853 (  272 672 ) resistor r=9.3 //w=0.17 //l=0.17 //layer=mcon //count=1 \
 //x=53.365 //y=1.145 //x2=53.365 //y2=1.145
r1854 (  267 671 ) resistor r=9.3 //w=0.17 //l=0.17 //layer=mcon //count=1 \
 //x=50.14 //y=1.135 //x2=50.14 //y2=1.135
r1855 (  267 268 ) resistor r=0.0939994 //w=0.226 //l=0.13 //layer=m1 \
 //thickness=0.36 //x=50.137 //y=1.135 //x2=50.137 //y2=1.005
r1856 (  263 670 ) resistor r=9.3 //w=0.17 //l=0.17 //layer=mcon //count=1 \
 //x=45.225 //y=1.145 //x2=45.225 //y2=1.145
r1857 (  259 669 ) resistor r=9.3 //w=0.17 //l=0.17 //layer=mcon //count=1 \
 //x=40.415 //y=1.145 //x2=40.415 //y2=1.145
r1858 (  254 668 ) resistor r=9.3 //w=0.17 //l=0.17 //layer=mcon //count=1 \
 //x=37.19 //y=1.135 //x2=37.19 //y2=1.135
r1859 (  254 255 ) resistor r=0.0939994 //w=0.226 //l=0.13 //layer=m1 \
 //thickness=0.36 //x=37.187 //y=1.135 //x2=37.187 //y2=1.005
r1860 (  250 667 ) resistor r=9.3 //w=0.17 //l=0.17 //layer=mcon //count=1 \
 //x=32.275 //y=1.145 //x2=32.275 //y2=1.145
r1861 (  246 666 ) resistor r=9.3 //w=0.17 //l=0.17 //layer=mcon //count=1 \
 //x=27.465 //y=1.145 //x2=27.465 //y2=1.145
r1862 (  244 397 ) resistor r=3.1 //w=0.17 //l=0.51 //layer=mcon //count=3 \
 //x=24.17 //y=0.18 //x2=24.17 //y2=0.18
r1863 (  240 665 ) resistor r=9.3 //w=0.17 //l=0.17 //layer=mcon //count=1 \
 //x=24.24 //y=1.135 //x2=24.24 //y2=1.135
r1864 (  240 241 ) resistor r=0.0939994 //w=0.226 //l=0.13 //layer=m1 \
 //thickness=0.36 //x=24.237 //y=1.135 //x2=24.237 //y2=1.005
r1865 (  238 380 ) resistor r=3.1 //w=0.17 //l=0.51 //layer=mcon //count=3 \
 //x=19.36 //y=0.18 //x2=19.36 //y2=0.18
r1866 (  235 664 ) resistor r=9.3 //w=0.17 //l=0.17 //layer=mcon //count=1 \
 //x=19.325 //y=1.145 //x2=19.325 //y2=1.145
r1867 (  233 363 ) resistor r=3.1 //w=0.17 //l=0.51 //layer=mcon //count=3 \
 //x=14.55 //y=0.18 //x2=14.55 //y2=0.18
r1868 (  230 663 ) resistor r=9.3 //w=0.17 //l=0.17 //layer=mcon //count=1 \
 //x=14.515 //y=1.145 //x2=14.515 //y2=1.145
r1869 (  225 662 ) resistor r=9.3 //w=0.17 //l=0.17 //layer=mcon //count=1 \
 //x=11.29 //y=1.135 //x2=11.29 //y2=1.135
r1870 (  225 226 ) resistor r=0.0939994 //w=0.226 //l=0.13 //layer=m1 \
 //thickness=0.36 //x=11.287 //y=1.135 //x2=11.287 //y2=1.005
r1871 (  221 661 ) resistor r=9.3 //w=0.17 //l=0.17 //layer=mcon //count=1 \
 //x=6.375 //y=1.145 //x2=6.375 //y2=1.145
r1872 (  217 660 ) resistor r=9.3 //w=0.17 //l=0.17 //layer=mcon //count=1 \
 //x=1.565 //y=1.145 //x2=1.565 //y2=1.145
r1873 (  214 632 ) resistor r=3.1 //w=0.17 //l=0.51 //layer=mcon //count=3 \
 //x=87.44 //y=0.18 //x2=87.44 //y2=0.18
r1874 (  212 630 ) resistor r=3.1 //w=0.17 //l=0.51 //layer=mcon //count=3 \
 //x=86.33 //y=0.18 //x2=86.33 //y2=0.18
r1875 (  212 214 ) resistor r=0.446141 //w=0.311 //l=1.11 //layer=m1 \
 //thickness=0.36 //x=86.33 //y=0.175 //x2=87.44 //y2=0.175
r1876 (  210 305 ) resistor r=0.028033 //w=0.35 //l=0.085 //layer=m1 \
 //thickness=0.36 //x=86.115 //y=0.175 //x2=86.03 //y2=0.175
r1877 (  210 212 ) resistor r=0.0864148 //w=0.311 //l=0.215 //layer=m1 \
 //thickness=0.36 //x=86.115 //y=0.175 //x2=86.33 //y2=0.175
r1878 (  209 307 ) resistor r=0.0703067 //w=0.254 //l=0.11649 //layer=m1 \
 //thickness=0.36 //x=86.03 //y=1.02 //x2=86.027 //y2=1.135
r1879 (  208 305 ) resistor r=0.0413265 //w=0.7 //l=0.175 //layer=m1 \
 //thickness=0.36 //x=86.03 //y=0.35 //x2=86.03 //y2=0.175
r1880 (  208 209 ) resistor r=0.639313 //w=0.131 //l=0.67 //layer=m1 \
 //thickness=0.36 //x=86.03 //y=0.35 //x2=86.03 //y2=1.02
r1881 (  207 628 ) resistor r=3.1 //w=0.17 //l=0.51 //layer=mcon //count=3 \
 //x=85.22 //y=0.18 //x2=85.22 //y2=0.18
r1882 (  205 622 ) resistor r=3.1 //w=0.17 //l=0.51 //layer=mcon //count=3 \
 //x=83.74 //y=0.18 //x2=83.74 //y2=0.18
r1883 (  205 207 ) resistor r=0.594855 //w=0.311 //l=1.48 //layer=m1 \
 //thickness=0.36 //x=83.74 //y=0.175 //x2=85.22 //y2=0.175
r1884 (  203 304 ) resistor r=0.028033 //w=0.35 //l=0.085 //layer=m1 \
 //thickness=0.36 //x=82.785 //y=0.175 //x2=82.7 //y2=0.175
r1885 (  203 205 ) resistor r=0.383842 //w=0.311 //l=0.955 //layer=m1 \
 //thickness=0.36 //x=82.785 //y=0.175 //x2=83.74 //y2=0.175
r1886 (  202 305 ) resistor r=0.028033 //w=0.35 //l=0.085 //layer=m1 \
 //thickness=0.36 //x=85.945 //y=0.175 //x2=86.03 //y2=0.175
r1887 (  202 207 ) resistor r=0.291399 //w=0.311 //l=0.725 //layer=m1 \
 //thickness=0.36 //x=85.945 //y=0.175 //x2=85.22 //y2=0.175
r1888 (  199 609 ) resistor r=3.1 //w=0.17 //l=0.51 //layer=mcon //count=3 \
 //x=81.15 //y=0.18 //x2=81.15 //y2=0.18
r1889 (  197 607 ) resistor r=3.1 //w=0.17 //l=0.51 //layer=mcon //count=3 \
 //x=80.04 //y=0.18 //x2=80.04 //y2=0.18
r1890 (  197 199 ) resistor r=0.446141 //w=0.311 //l=1.11 //layer=m1 \
 //thickness=0.36 //x=80.04 //y=0.175 //x2=81.15 //y2=0.175
r1891 (  195 300 ) resistor r=0.028033 //w=0.35 //l=0.085 //layer=m1 \
 //thickness=0.36 //x=79.455 //y=0.175 //x2=79.37 //y2=0.175
r1892 (  195 197 ) resistor r=0.235129 //w=0.311 //l=0.585 //layer=m1 \
 //thickness=0.36 //x=79.455 //y=0.175 //x2=80.04 //y2=0.175
r1893 (  194 304 ) resistor r=0.028033 //w=0.35 //l=0.085 //layer=m1 \
 //thickness=0.36 //x=82.615 //y=0.175 //x2=82.7 //y2=0.175
r1894 (  194 199 ) resistor r=0.588826 //w=0.311 //l=1.465 //layer=m1 \
 //thickness=0.36 //x=82.615 //y=0.175 //x2=81.15 //y2=0.175
r1895 (  193 302 ) resistor r=0.0729089 //w=0.249 //l=0.120996 //layer=m1 \
 //thickness=0.36 //x=79.37 //y=1.015 //x2=79.372 //y2=1.135
r1896 (  192 300 ) resistor r=0.0413265 //w=0.7 //l=0.175 //layer=m1 \
 //thickness=0.36 //x=79.37 //y=0.35 //x2=79.37 //y2=0.175
r1897 (  192 193 ) resistor r=0.634542 //w=0.131 //l=0.665 //layer=m1 \
 //thickness=0.36 //x=79.37 //y=0.35 //x2=79.37 //y2=1.015
r1898 (  191 605 ) resistor r=3.1 //w=0.17 //l=0.51 //layer=mcon //count=3 \
 //x=78.93 //y=0.18 //x2=78.93 //y2=0.18
r1899 (  189 594 ) resistor r=3.1 //w=0.17 //l=0.51 //layer=mcon //count=3 \
 //x=77.45 //y=0.18 //x2=77.45 //y2=0.18
r1900 (  189 191 ) resistor r=0.594855 //w=0.311 //l=1.48 //layer=m1 \
 //thickness=0.36 //x=77.45 //y=0.175 //x2=78.93 //y2=0.175
r1901 (  187 592 ) resistor r=3.1 //w=0.17 //l=0.51 //layer=mcon //count=3 \
 //x=76.34 //y=0.18 //x2=76.34 //y2=0.18
r1902 (  187 189 ) resistor r=0.446141 //w=0.311 //l=1.11 //layer=m1 \
 //thickness=0.36 //x=76.34 //y=0.175 //x2=77.45 //y2=0.175
r1903 (  185 299 ) resistor r=0.028033 //w=0.35 //l=0.085 //layer=m1 \
 //thickness=0.36 //x=76.125 //y=0.175 //x2=76.04 //y2=0.175
r1904 (  185 187 ) resistor r=0.0864148 //w=0.311 //l=0.215 //layer=m1 \
 //thickness=0.36 //x=76.125 //y=0.175 //x2=76.34 //y2=0.175
r1905 (  184 300 ) resistor r=0.028033 //w=0.35 //l=0.085 //layer=m1 \
 //thickness=0.36 //x=79.285 //y=0.175 //x2=79.37 //y2=0.175
r1906 (  184 191 ) resistor r=0.142685 //w=0.311 //l=0.355 //layer=m1 \
 //thickness=0.36 //x=79.285 //y=0.175 //x2=78.93 //y2=0.175
r1907 (  182 299 ) resistor r=0.0413265 //w=0.7 //l=0.175 //layer=m1 \
 //thickness=0.36 //x=76.04 //y=0.35 //x2=76.04 //y2=0.175
r1908 (  182 297 ) resistor r=0.625 //w=0.131 //l=0.655 //layer=m1 \
 //thickness=0.36 //x=76.04 //y=0.35 //x2=76.04 //y2=1.005
r1909 (  181 590 ) resistor r=3.1 //w=0.17 //l=0.51 //layer=mcon //count=3 \
 //x=75.23 //y=0.18 //x2=75.23 //y2=0.18
r1910 (  179 579 ) resistor r=3.1 //w=0.17 //l=0.51 //layer=mcon //count=3 \
 //x=73.75 //y=0.18 //x2=73.75 //y2=0.18
r1911 (  179 181 ) resistor r=0.594855 //w=0.311 //l=1.48 //layer=m1 \
 //thickness=0.36 //x=73.75 //y=0.175 //x2=75.23 //y2=0.175
r1912 (  177 577 ) resistor r=3.1 //w=0.17 //l=0.51 //layer=mcon //count=3 \
 //x=72.64 //y=0.18 //x2=72.64 //y2=0.18
r1913 (  177 179 ) resistor r=0.446141 //w=0.311 //l=1.11 //layer=m1 \
 //thickness=0.36 //x=72.64 //y=0.175 //x2=73.75 //y2=0.175
r1914 (  175 575 ) resistor r=3.1 //w=0.17 //l=0.51 //layer=mcon //count=3 \
 //x=71.53 //y=0.18 //x2=71.53 //y2=0.18
r1915 (  175 177 ) resistor r=0.446141 //w=0.311 //l=1.11 //layer=m1 \
 //thickness=0.36 //x=71.53 //y=0.175 //x2=72.64 //y2=0.175
r1916 (  173 294 ) resistor r=0.028033 //w=0.35 //l=0.085 //layer=m1 \
 //thickness=0.36 //x=71.21 //y=0.175 //x2=71.125 //y2=0.175
r1917 (  173 175 ) resistor r=0.128617 //w=0.311 //l=0.32 //layer=m1 \
 //thickness=0.36 //x=71.21 //y=0.175 //x2=71.53 //y2=0.175
r1918 (  172 299 ) resistor r=0.028033 //w=0.35 //l=0.085 //layer=m1 \
 //thickness=0.36 //x=75.955 //y=0.175 //x2=76.04 //y2=0.175
r1919 (  172 181 ) resistor r=0.291399 //w=0.311 //l=0.725 //layer=m1 \
 //thickness=0.36 //x=75.955 //y=0.175 //x2=75.23 //y2=0.175
r1920 (  171 292 ) resistor r=0.0942778 //w=0.221 //l=0.13 //layer=m1 \
 //thickness=0.36 //x=71.125 //y=1.015 //x2=71.125 //y2=1.145
r1921 (  170 294 ) resistor r=0.0413265 //w=0.7 //l=0.175 //layer=m1 \
 //thickness=0.36 //x=71.125 //y=0.35 //x2=71.125 //y2=0.175
r1922 (  170 171 ) resistor r=0.634542 //w=0.131 //l=0.665 //layer=m1 \
 //thickness=0.36 //x=71.125 //y=0.35 //x2=71.125 //y2=1.015
r1923 (  169 573 ) resistor r=3.1 //w=0.17 //l=0.51 //layer=mcon //count=3 \
 //x=70.42 //y=0.18 //x2=70.42 //y2=0.18
r1924 (  167 562 ) resistor r=3.1 //w=0.17 //l=0.51 //layer=mcon //count=3 \
 //x=68.94 //y=0.18 //x2=68.94 //y2=0.18
r1925 (  167 169 ) resistor r=0.594855 //w=0.311 //l=1.48 //layer=m1 \
 //thickness=0.36 //x=68.94 //y=0.175 //x2=70.42 //y2=0.175
r1926 (  165 560 ) resistor r=3.1 //w=0.17 //l=0.51 //layer=mcon //count=3 \
 //x=67.83 //y=0.18 //x2=67.83 //y2=0.18
r1927 (  165 167 ) resistor r=0.446141 //w=0.311 //l=1.11 //layer=m1 \
 //thickness=0.36 //x=67.83 //y=0.175 //x2=68.94 //y2=0.175
r1928 (  163 558 ) resistor r=3.1 //w=0.17 //l=0.51 //layer=mcon //count=3 \
 //x=66.72 //y=0.18 //x2=66.72 //y2=0.18
r1929 (  163 165 ) resistor r=0.446141 //w=0.311 //l=1.11 //layer=m1 \
 //thickness=0.36 //x=66.72 //y=0.175 //x2=67.83 //y2=0.175
r1930 (  161 290 ) resistor r=0.028033 //w=0.35 //l=0.085 //layer=m1 \
 //thickness=0.36 //x=66.4 //y=0.175 //x2=66.315 //y2=0.175
r1931 (  161 163 ) resistor r=0.128617 //w=0.311 //l=0.32 //layer=m1 \
 //thickness=0.36 //x=66.4 //y=0.175 //x2=66.72 //y2=0.175
r1932 (  160 294 ) resistor r=0.028033 //w=0.35 //l=0.085 //layer=m1 \
 //thickness=0.36 //x=71.04 //y=0.175 //x2=71.125 //y2=0.175
r1933 (  160 169 ) resistor r=0.249196 //w=0.311 //l=0.62 //layer=m1 \
 //thickness=0.36 //x=71.04 //y=0.175 //x2=70.42 //y2=0.175
r1934 (  159 288 ) resistor r=0.0942778 //w=0.221 //l=0.13 //layer=m1 \
 //thickness=0.36 //x=66.315 //y=1.015 //x2=66.315 //y2=1.145
r1935 (  158 290 ) resistor r=0.0413265 //w=0.7 //l=0.175 //layer=m1 \
 //thickness=0.36 //x=66.315 //y=0.35 //x2=66.315 //y2=0.175
r1936 (  158 159 ) resistor r=0.634542 //w=0.131 //l=0.665 //layer=m1 \
 //thickness=0.36 //x=66.315 //y=0.35 //x2=66.315 //y2=1.015
r1937 (  157 556 ) resistor r=3.1 //w=0.17 //l=0.51 //layer=mcon //count=3 \
 //x=65.61 //y=0.18 //x2=65.61 //y2=0.18
r1938 (  155 545 ) resistor r=3.1 //w=0.17 //l=0.51 //layer=mcon //count=3 \
 //x=64.13 //y=0.18 //x2=64.13 //y2=0.18
r1939 (  155 157 ) resistor r=0.594855 //w=0.311 //l=1.48 //layer=m1 \
 //thickness=0.36 //x=64.13 //y=0.175 //x2=65.61 //y2=0.175
r1940 (  153 286 ) resistor r=0.028033 //w=0.35 //l=0.085 //layer=m1 \
 //thickness=0.36 //x=63.175 //y=0.175 //x2=63.09 //y2=0.175
r1941 (  153 155 ) resistor r=0.383842 //w=0.311 //l=0.955 //layer=m1 \
 //thickness=0.36 //x=63.175 //y=0.175 //x2=64.13 //y2=0.175
r1942 (  152 290 ) resistor r=0.028033 //w=0.35 //l=0.085 //layer=m1 \
 //thickness=0.36 //x=66.23 //y=0.175 //x2=66.315 //y2=0.175
r1943 (  152 157 ) resistor r=0.249196 //w=0.311 //l=0.62 //layer=m1 \
 //thickness=0.36 //x=66.23 //y=0.175 //x2=65.61 //y2=0.175
r1944 (  150 286 ) resistor r=0.0413265 //w=0.7 //l=0.175 //layer=m1 \
 //thickness=0.36 //x=63.09 //y=0.35 //x2=63.09 //y2=0.175
r1945 (  150 283 ) resistor r=0.625 //w=0.131 //l=0.655 //layer=m1 \
 //thickness=0.36 //x=63.09 //y=0.35 //x2=63.09 //y2=1.005
r1946 (  149 532 ) resistor r=3.1 //w=0.17 //l=0.51 //layer=mcon //count=3 \
 //x=61.54 //y=0.18 //x2=61.54 //y2=0.18
r1947 (  147 530 ) resistor r=3.1 //w=0.17 //l=0.51 //layer=mcon //count=3 \
 //x=60.43 //y=0.18 //x2=60.43 //y2=0.18
r1948 (  147 149 ) resistor r=0.446141 //w=0.311 //l=1.11 //layer=m1 \
 //thickness=0.36 //x=60.43 //y=0.175 //x2=61.54 //y2=0.175
r1949 (  145 528 ) resistor r=3.1 //w=0.17 //l=0.51 //layer=mcon //count=3 \
 //x=59.32 //y=0.18 //x2=59.32 //y2=0.18
r1950 (  145 147 ) resistor r=0.446141 //w=0.311 //l=1.11 //layer=m1 \
 //thickness=0.36 //x=59.32 //y=0.175 //x2=60.43 //y2=0.175
r1951 (  143 280 ) resistor r=0.028033 //w=0.35 //l=0.085 //layer=m1 \
 //thickness=0.36 //x=58.26 //y=0.175 //x2=58.175 //y2=0.175
r1952 (  143 145 ) resistor r=0.426045 //w=0.311 //l=1.06 //layer=m1 \
 //thickness=0.36 //x=58.26 //y=0.175 //x2=59.32 //y2=0.175
r1953 (  142 286 ) resistor r=0.028033 //w=0.35 //l=0.085 //layer=m1 \
 //thickness=0.36 //x=63.005 //y=0.175 //x2=63.09 //y2=0.175
r1954 (  142 149 ) resistor r=0.588826 //w=0.311 //l=1.465 //layer=m1 \
 //thickness=0.36 //x=63.005 //y=0.175 //x2=61.54 //y2=0.175
r1955 (  141 277 ) resistor r=0.0942778 //w=0.221 //l=0.13 //layer=m1 \
 //thickness=0.36 //x=58.175 //y=1.015 //x2=58.175 //y2=1.145
r1956 (  140 280 ) resistor r=0.0413265 //w=0.7 //l=0.175 //layer=m1 \
 //thickness=0.36 //x=58.175 //y=0.35 //x2=58.175 //y2=0.175
r1957 (  140 141 ) resistor r=0.634542 //w=0.131 //l=0.665 //layer=m1 \
 //thickness=0.36 //x=58.175 //y=0.35 //x2=58.175 //y2=1.015
r1958 (  139 515 ) resistor r=3.1 //w=0.17 //l=0.51 //layer=mcon //count=3 \
 //x=56.73 //y=0.18 //x2=56.73 //y2=0.18
r1959 (  137 513 ) resistor r=3.1 //w=0.17 //l=0.51 //layer=mcon //count=3 \
 //x=55.62 //y=0.18 //x2=55.62 //y2=0.18
r1960 (  137 139 ) resistor r=0.446141 //w=0.311 //l=1.11 //layer=m1 \
 //thickness=0.36 //x=55.62 //y=0.175 //x2=56.73 //y2=0.175
r1961 (  135 511 ) resistor r=3.1 //w=0.17 //l=0.51 //layer=mcon //count=3 \
 //x=54.51 //y=0.18 //x2=54.51 //y2=0.18
r1962 (  135 137 ) resistor r=0.446141 //w=0.311 //l=1.11 //layer=m1 \
 //thickness=0.36 //x=54.51 //y=0.175 //x2=55.62 //y2=0.175
r1963 (  133 275 ) resistor r=0.028033 //w=0.35 //l=0.085 //layer=m1 \
 //thickness=0.36 //x=53.45 //y=0.175 //x2=53.365 //y2=0.175
r1964 (  133 135 ) resistor r=0.426045 //w=0.311 //l=1.06 //layer=m1 \
 //thickness=0.36 //x=53.45 //y=0.175 //x2=54.51 //y2=0.175
r1965 (  132 280 ) resistor r=0.028033 //w=0.35 //l=0.085 //layer=m1 \
 //thickness=0.36 //x=58.09 //y=0.175 //x2=58.175 //y2=0.175
r1966 (  132 139 ) resistor r=0.546624 //w=0.311 //l=1.36 //layer=m1 \
 //thickness=0.36 //x=58.09 //y=0.175 //x2=56.73 //y2=0.175
r1967 (  131 272 ) resistor r=0.0942778 //w=0.221 //l=0.13 //layer=m1 \
 //thickness=0.36 //x=53.365 //y=1.015 //x2=53.365 //y2=1.145
r1968 (  130 275 ) resistor r=0.0413265 //w=0.7 //l=0.175 //layer=m1 \
 //thickness=0.36 //x=53.365 //y=0.35 //x2=53.365 //y2=0.175
r1969 (  130 131 ) resistor r=0.634542 //w=0.131 //l=0.665 //layer=m1 \
 //thickness=0.36 //x=53.365 //y=0.35 //x2=53.365 //y2=1.015
r1970 (  129 498 ) resistor r=3.1 //w=0.17 //l=0.51 //layer=mcon //count=3 \
 //x=51.92 //y=0.18 //x2=51.92 //y2=0.18
r1971 (  127 496 ) resistor r=3.1 //w=0.17 //l=0.51 //layer=mcon //count=3 \
 //x=50.81 //y=0.18 //x2=50.81 //y2=0.18
r1972 (  127 129 ) resistor r=0.446141 //w=0.311 //l=1.11 //layer=m1 \
 //thickness=0.36 //x=50.81 //y=0.175 //x2=51.92 //y2=0.175
r1973 (  125 270 ) resistor r=0.028033 //w=0.35 //l=0.085 //layer=m1 \
 //thickness=0.36 //x=50.225 //y=0.175 //x2=50.14 //y2=0.175
r1974 (  125 127 ) resistor r=0.235129 //w=0.311 //l=0.585 //layer=m1 \
 //thickness=0.36 //x=50.225 //y=0.175 //x2=50.81 //y2=0.175
r1975 (  124 275 ) resistor r=0.028033 //w=0.35 //l=0.085 //layer=m1 \
 //thickness=0.36 //x=53.28 //y=0.175 //x2=53.365 //y2=0.175
r1976 (  124 129 ) resistor r=0.546624 //w=0.311 //l=1.36 //layer=m1 \
 //thickness=0.36 //x=53.28 //y=0.175 //x2=51.92 //y2=0.175
r1977 (  122 270 ) resistor r=0.0413265 //w=0.7 //l=0.175 //layer=m1 \
 //thickness=0.36 //x=50.14 //y=0.35 //x2=50.14 //y2=0.175
r1978 (  122 268 ) resistor r=0.625 //w=0.131 //l=0.655 //layer=m1 \
 //thickness=0.36 //x=50.14 //y=0.35 //x2=50.14 //y2=1.005
r1979 (  121 494 ) resistor r=3.1 //w=0.17 //l=0.51 //layer=mcon //count=3 \
 //x=49.7 //y=0.18 //x2=49.7 //y2=0.18
r1980 (  119 483 ) resistor r=3.1 //w=0.17 //l=0.51 //layer=mcon //count=3 \
 //x=48.22 //y=0.18 //x2=48.22 //y2=0.18
r1981 (  119 121 ) resistor r=0.594855 //w=0.311 //l=1.48 //layer=m1 \
 //thickness=0.36 //x=48.22 //y=0.175 //x2=49.7 //y2=0.175
r1982 (  117 481 ) resistor r=3.1 //w=0.17 //l=0.51 //layer=mcon //count=3 \
 //x=47.11 //y=0.18 //x2=47.11 //y2=0.18
r1983 (  117 119 ) resistor r=0.446141 //w=0.311 //l=1.11 //layer=m1 \
 //thickness=0.36 //x=47.11 //y=0.175 //x2=48.22 //y2=0.175
r1984 (  115 479 ) resistor r=3.1 //w=0.17 //l=0.51 //layer=mcon //count=3 \
 //x=46 //y=0.18 //x2=46 //y2=0.18
r1985 (  115 117 ) resistor r=0.446141 //w=0.311 //l=1.11 //layer=m1 \
 //thickness=0.36 //x=46 //y=0.175 //x2=47.11 //y2=0.175
r1986 (  113 265 ) resistor r=0.028033 //w=0.35 //l=0.085 //layer=m1 \
 //thickness=0.36 //x=45.31 //y=0.175 //x2=45.225 //y2=0.175
r1987 (  113 115 ) resistor r=0.277331 //w=0.311 //l=0.69 //layer=m1 \
 //thickness=0.36 //x=45.31 //y=0.175 //x2=46 //y2=0.175
r1988 (  112 270 ) resistor r=0.028033 //w=0.35 //l=0.085 //layer=m1 \
 //thickness=0.36 //x=50.055 //y=0.175 //x2=50.14 //y2=0.175
r1989 (  112 121 ) resistor r=0.142685 //w=0.311 //l=0.355 //layer=m1 \
 //thickness=0.36 //x=50.055 //y=0.175 //x2=49.7 //y2=0.175
r1990 (  111 263 ) resistor r=0.0942778 //w=0.221 //l=0.13 //layer=m1 \
 //thickness=0.36 //x=45.225 //y=1.015 //x2=45.225 //y2=1.145
r1991 (  110 265 ) resistor r=0.0413265 //w=0.7 //l=0.175 //layer=m1 \
 //thickness=0.36 //x=45.225 //y=0.35 //x2=45.225 //y2=0.175
r1992 (  110 111 ) resistor r=0.634542 //w=0.131 //l=0.665 //layer=m1 \
 //thickness=0.36 //x=45.225 //y=0.35 //x2=45.225 //y2=1.015
r1993 (  109 477 ) resistor r=3.1 //w=0.17 //l=0.51 //layer=mcon //count=3 \
 //x=44.89 //y=0.18 //x2=44.89 //y2=0.18
r1994 (  107 465 ) resistor r=3.1 //w=0.17 //l=0.51 //layer=mcon //count=3 \
 //x=43.41 //y=0.18 //x2=43.41 //y2=0.18
r1995 (  107 109 ) resistor r=0.594855 //w=0.311 //l=1.48 //layer=m1 \
 //thickness=0.36 //x=43.41 //y=0.175 //x2=44.89 //y2=0.175
r1996 (  105 463 ) resistor r=3.1 //w=0.17 //l=0.51 //layer=mcon //count=3 \
 //x=42.3 //y=0.18 //x2=42.3 //y2=0.18
r1997 (  105 107 ) resistor r=0.446141 //w=0.311 //l=1.11 //layer=m1 \
 //thickness=0.36 //x=42.3 //y=0.175 //x2=43.41 //y2=0.175
r1998 (  103 461 ) resistor r=3.1 //w=0.17 //l=0.51 //layer=mcon //count=3 \
 //x=41.19 //y=0.18 //x2=41.19 //y2=0.18
r1999 (  103 105 ) resistor r=0.446141 //w=0.311 //l=1.11 //layer=m1 \
 //thickness=0.36 //x=41.19 //y=0.175 //x2=42.3 //y2=0.175
r2000 (  101 261 ) resistor r=0.028033 //w=0.35 //l=0.085 //layer=m1 \
 //thickness=0.36 //x=40.5 //y=0.175 //x2=40.415 //y2=0.175
r2001 (  101 103 ) resistor r=0.277331 //w=0.311 //l=0.69 //layer=m1 \
 //thickness=0.36 //x=40.5 //y=0.175 //x2=41.19 //y2=0.175
r2002 (  100 265 ) resistor r=0.028033 //w=0.35 //l=0.085 //layer=m1 \
 //thickness=0.36 //x=45.14 //y=0.175 //x2=45.225 //y2=0.175
r2003 (  100 109 ) resistor r=0.100482 //w=0.311 //l=0.25 //layer=m1 \
 //thickness=0.36 //x=45.14 //y=0.175 //x2=44.89 //y2=0.175
r2004 (  99 259 ) resistor r=0.0942778 //w=0.221 //l=0.13 //layer=m1 \
 //thickness=0.36 //x=40.415 //y=1.015 //x2=40.415 //y2=1.145
r2005 (  98 261 ) resistor r=0.0413265 //w=0.7 //l=0.175 //layer=m1 \
 //thickness=0.36 //x=40.415 //y=0.35 //x2=40.415 //y2=0.175
r2006 (  98 99 ) resistor r=0.634542 //w=0.131 //l=0.665 //layer=m1 \
 //thickness=0.36 //x=40.415 //y=0.35 //x2=40.415 //y2=1.015
r2007 (  97 459 ) resistor r=3.1 //w=0.17 //l=0.51 //layer=mcon //count=3 \
 //x=40.08 //y=0.18 //x2=40.08 //y2=0.18
r2008 (  95 448 ) resistor r=3.1 //w=0.17 //l=0.51 //layer=mcon //count=3 \
 //x=38.6 //y=0.18 //x2=38.6 //y2=0.18
r2009 (  95 97 ) resistor r=0.594855 //w=0.311 //l=1.48 //layer=m1 \
 //thickness=0.36 //x=38.6 //y=0.175 //x2=40.08 //y2=0.175
r2010 (  93 446 ) resistor r=3.1 //w=0.17 //l=0.51 //layer=mcon //count=3 \
 //x=37.49 //y=0.18 //x2=37.49 //y2=0.18
r2011 (  93 95 ) resistor r=0.446141 //w=0.311 //l=1.11 //layer=m1 \
 //thickness=0.36 //x=37.49 //y=0.175 //x2=38.6 //y2=0.175
r2012 (  91 257 ) resistor r=0.028033 //w=0.35 //l=0.085 //layer=m1 \
 //thickness=0.36 //x=37.275 //y=0.175 //x2=37.19 //y2=0.175
r2013 (  91 93 ) resistor r=0.0864148 //w=0.311 //l=0.215 //layer=m1 \
 //thickness=0.36 //x=37.275 //y=0.175 //x2=37.49 //y2=0.175
r2014 (  90 261 ) resistor r=0.028033 //w=0.35 //l=0.085 //layer=m1 \
 //thickness=0.36 //x=40.33 //y=0.175 //x2=40.415 //y2=0.175
r2015 (  90 97 ) resistor r=0.100482 //w=0.311 //l=0.25 //layer=m1 \
 //thickness=0.36 //x=40.33 //y=0.175 //x2=40.08 //y2=0.175
r2016 (  88 257 ) resistor r=0.0413265 //w=0.7 //l=0.175 //layer=m1 \
 //thickness=0.36 //x=37.19 //y=0.35 //x2=37.19 //y2=0.175
r2017 (  88 255 ) resistor r=0.625 //w=0.131 //l=0.655 //layer=m1 \
 //thickness=0.36 //x=37.19 //y=0.35 //x2=37.19 //y2=1.005
r2018 (  87 444 ) resistor r=3.1 //w=0.17 //l=0.51 //layer=mcon //count=3 \
 //x=36.38 //y=0.18 //x2=36.38 //y2=0.18
r2019 (  85 433 ) resistor r=3.1 //w=0.17 //l=0.51 //layer=mcon //count=3 \
 //x=34.9 //y=0.18 //x2=34.9 //y2=0.18
r2020 (  85 87 ) resistor r=0.594855 //w=0.311 //l=1.48 //layer=m1 \
 //thickness=0.36 //x=34.9 //y=0.175 //x2=36.38 //y2=0.175
r2021 (  83 431 ) resistor r=3.1 //w=0.17 //l=0.51 //layer=mcon //count=3 \
 //x=33.79 //y=0.18 //x2=33.79 //y2=0.18
r2022 (  83 85 ) resistor r=0.446141 //w=0.311 //l=1.11 //layer=m1 \
 //thickness=0.36 //x=33.79 //y=0.175 //x2=34.9 //y2=0.175
r2023 (  81 429 ) resistor r=3.1 //w=0.17 //l=0.51 //layer=mcon //count=3 \
 //x=32.68 //y=0.18 //x2=32.68 //y2=0.18
r2024 (  81 83 ) resistor r=0.446141 //w=0.311 //l=1.11 //layer=m1 \
 //thickness=0.36 //x=32.68 //y=0.175 //x2=33.79 //y2=0.175
r2025 (  79 252 ) resistor r=0.028033 //w=0.35 //l=0.085 //layer=m1 \
 //thickness=0.36 //x=32.36 //y=0.175 //x2=32.275 //y2=0.175
r2026 (  79 81 ) resistor r=0.128617 //w=0.311 //l=0.32 //layer=m1 \
 //thickness=0.36 //x=32.36 //y=0.175 //x2=32.68 //y2=0.175
r2027 (  78 257 ) resistor r=0.028033 //w=0.35 //l=0.085 //layer=m1 \
 //thickness=0.36 //x=37.105 //y=0.175 //x2=37.19 //y2=0.175
r2028 (  78 87 ) resistor r=0.291399 //w=0.311 //l=0.725 //layer=m1 \
 //thickness=0.36 //x=37.105 //y=0.175 //x2=36.38 //y2=0.175
r2029 (  77 250 ) resistor r=0.0942778 //w=0.221 //l=0.13 //layer=m1 \
 //thickness=0.36 //x=32.275 //y=1.015 //x2=32.275 //y2=1.145
r2030 (  76 252 ) resistor r=0.0413265 //w=0.7 //l=0.175 //layer=m1 \
 //thickness=0.36 //x=32.275 //y=0.35 //x2=32.275 //y2=0.175
r2031 (  76 77 ) resistor r=0.634542 //w=0.131 //l=0.665 //layer=m1 \
 //thickness=0.36 //x=32.275 //y=0.35 //x2=32.275 //y2=1.015
r2032 (  75 427 ) resistor r=3.1 //w=0.17 //l=0.51 //layer=mcon //count=3 \
 //x=31.57 //y=0.18 //x2=31.57 //y2=0.18
r2033 (  73 416 ) resistor r=3.1 //w=0.17 //l=0.51 //layer=mcon //count=3 \
 //x=30.09 //y=0.18 //x2=30.09 //y2=0.18
r2034 (  73 75 ) resistor r=0.594855 //w=0.311 //l=1.48 //layer=m1 \
 //thickness=0.36 //x=30.09 //y=0.175 //x2=31.57 //y2=0.175
r2035 (  71 414 ) resistor r=3.1 //w=0.17 //l=0.51 //layer=mcon //count=3 \
 //x=28.98 //y=0.18 //x2=28.98 //y2=0.18
r2036 (  71 73 ) resistor r=0.446141 //w=0.311 //l=1.11 //layer=m1 \
 //thickness=0.36 //x=28.98 //y=0.175 //x2=30.09 //y2=0.175
r2037 (  69 412 ) resistor r=3.1 //w=0.17 //l=0.51 //layer=mcon //count=3 \
 //x=27.87 //y=0.18 //x2=27.87 //y2=0.18
r2038 (  69 71 ) resistor r=0.446141 //w=0.311 //l=1.11 //layer=m1 \
 //thickness=0.36 //x=27.87 //y=0.175 //x2=28.98 //y2=0.175
r2039 (  67 248 ) resistor r=0.028033 //w=0.35 //l=0.085 //layer=m1 \
 //thickness=0.36 //x=27.55 //y=0.175 //x2=27.465 //y2=0.175
r2040 (  67 69 ) resistor r=0.128617 //w=0.311 //l=0.32 //layer=m1 \
 //thickness=0.36 //x=27.55 //y=0.175 //x2=27.87 //y2=0.175
r2041 (  66 252 ) resistor r=0.028033 //w=0.35 //l=0.085 //layer=m1 \
 //thickness=0.36 //x=32.19 //y=0.175 //x2=32.275 //y2=0.175
r2042 (  66 75 ) resistor r=0.249196 //w=0.311 //l=0.62 //layer=m1 \
 //thickness=0.36 //x=32.19 //y=0.175 //x2=31.57 //y2=0.175
r2043 (  65 246 ) resistor r=0.0942778 //w=0.221 //l=0.13 //layer=m1 \
 //thickness=0.36 //x=27.465 //y=1.015 //x2=27.465 //y2=1.145
r2044 (  64 248 ) resistor r=0.0413265 //w=0.7 //l=0.175 //layer=m1 \
 //thickness=0.36 //x=27.465 //y=0.35 //x2=27.465 //y2=0.175
r2045 (  64 65 ) resistor r=0.634542 //w=0.131 //l=0.665 //layer=m1 \
 //thickness=0.36 //x=27.465 //y=0.35 //x2=27.465 //y2=1.015
r2046 (  63 410 ) resistor r=3.1 //w=0.17 //l=0.51 //layer=mcon //count=3 \
 //x=26.76 //y=0.18 //x2=26.76 //y2=0.18
r2047 (  61 399 ) resistor r=3.1 //w=0.17 //l=0.51 //layer=mcon //count=3 \
 //x=25.28 //y=0.18 //x2=25.28 //y2=0.18
r2048 (  61 63 ) resistor r=0.594855 //w=0.311 //l=1.48 //layer=m1 \
 //thickness=0.36 //x=25.28 //y=0.175 //x2=26.76 //y2=0.175
r2049 (  59 244 ) resistor r=0.028033 //w=0.35 //l=0.085 //layer=m1 \
 //thickness=0.36 //x=24.325 //y=0.175 //x2=24.24 //y2=0.175
r2050 (  59 61 ) resistor r=0.383842 //w=0.311 //l=0.955 //layer=m1 \
 //thickness=0.36 //x=24.325 //y=0.175 //x2=25.28 //y2=0.175
r2051 (  58 248 ) resistor r=0.028033 //w=0.35 //l=0.085 //layer=m1 \
 //thickness=0.36 //x=27.38 //y=0.175 //x2=27.465 //y2=0.175
r2052 (  58 63 ) resistor r=0.249196 //w=0.311 //l=0.62 //layer=m1 \
 //thickness=0.36 //x=27.38 //y=0.175 //x2=26.76 //y2=0.175
r2053 (  56 244 ) resistor r=0.0413265 //w=0.7 //l=0.175 //layer=m1 \
 //thickness=0.36 //x=24.24 //y=0.35 //x2=24.24 //y2=0.175
r2054 (  56 241 ) resistor r=0.625 //w=0.131 //l=0.655 //layer=m1 \
 //thickness=0.36 //x=24.24 //y=0.35 //x2=24.24 //y2=1.005
r2055 (  55 386 ) resistor r=3.1 //w=0.17 //l=0.51 //layer=mcon //count=3 \
 //x=22.69 //y=0.18 //x2=22.69 //y2=0.18
r2056 (  53 384 ) resistor r=3.1 //w=0.17 //l=0.51 //layer=mcon //count=3 \
 //x=21.58 //y=0.18 //x2=21.58 //y2=0.18
r2057 (  53 55 ) resistor r=0.446141 //w=0.311 //l=1.11 //layer=m1 \
 //thickness=0.36 //x=21.58 //y=0.175 //x2=22.69 //y2=0.175
r2058 (  51 382 ) resistor r=3.1 //w=0.17 //l=0.51 //layer=mcon //count=3 \
 //x=20.47 //y=0.18 //x2=20.47 //y2=0.18
r2059 (  51 53 ) resistor r=0.446141 //w=0.311 //l=1.11 //layer=m1 \
 //thickness=0.36 //x=20.47 //y=0.175 //x2=21.58 //y2=0.175
r2060 (  49 238 ) resistor r=0.028033 //w=0.35 //l=0.085 //layer=m1 \
 //thickness=0.36 //x=19.41 //y=0.175 //x2=19.325 //y2=0.175
r2061 (  49 51 ) resistor r=0.426045 //w=0.311 //l=1.06 //layer=m1 \
 //thickness=0.36 //x=19.41 //y=0.175 //x2=20.47 //y2=0.175
r2062 (  48 244 ) resistor r=0.028033 //w=0.35 //l=0.085 //layer=m1 \
 //thickness=0.36 //x=24.155 //y=0.175 //x2=24.24 //y2=0.175
r2063 (  48 55 ) resistor r=0.588826 //w=0.311 //l=1.465 //layer=m1 \
 //thickness=0.36 //x=24.155 //y=0.175 //x2=22.69 //y2=0.175
r2064 (  47 235 ) resistor r=0.0942778 //w=0.221 //l=0.13 //layer=m1 \
 //thickness=0.36 //x=19.325 //y=1.015 //x2=19.325 //y2=1.145
r2065 (  46 238 ) resistor r=0.0413265 //w=0.7 //l=0.175 //layer=m1 \
 //thickness=0.36 //x=19.325 //y=0.35 //x2=19.325 //y2=0.175
r2066 (  46 47 ) resistor r=0.634542 //w=0.131 //l=0.665 //layer=m1 \
 //thickness=0.36 //x=19.325 //y=0.35 //x2=19.325 //y2=1.015
r2067 (  45 369 ) resistor r=3.1 //w=0.17 //l=0.51 //layer=mcon //count=3 \
 //x=17.88 //y=0.18 //x2=17.88 //y2=0.18
r2068 (  43 367 ) resistor r=3.1 //w=0.17 //l=0.51 //layer=mcon //count=3 \
 //x=16.77 //y=0.18 //x2=16.77 //y2=0.18
r2069 (  43 45 ) resistor r=0.446141 //w=0.311 //l=1.11 //layer=m1 \
 //thickness=0.36 //x=16.77 //y=0.175 //x2=17.88 //y2=0.175
r2070 (  41 365 ) resistor r=3.1 //w=0.17 //l=0.51 //layer=mcon //count=3 \
 //x=15.66 //y=0.18 //x2=15.66 //y2=0.18
r2071 (  41 43 ) resistor r=0.446141 //w=0.311 //l=1.11 //layer=m1 \
 //thickness=0.36 //x=15.66 //y=0.175 //x2=16.77 //y2=0.175
r2072 (  39 233 ) resistor r=0.028033 //w=0.35 //l=0.085 //layer=m1 \
 //thickness=0.36 //x=14.6 //y=0.175 //x2=14.515 //y2=0.175
r2073 (  39 41 ) resistor r=0.426045 //w=0.311 //l=1.06 //layer=m1 \
 //thickness=0.36 //x=14.6 //y=0.175 //x2=15.66 //y2=0.175
r2074 (  38 238 ) resistor r=0.028033 //w=0.35 //l=0.085 //layer=m1 \
 //thickness=0.36 //x=19.24 //y=0.175 //x2=19.325 //y2=0.175
r2075 (  38 45 ) resistor r=0.546624 //w=0.311 //l=1.36 //layer=m1 \
 //thickness=0.36 //x=19.24 //y=0.175 //x2=17.88 //y2=0.175
r2076 (  37 230 ) resistor r=0.0942778 //w=0.221 //l=0.13 //layer=m1 \
 //thickness=0.36 //x=14.515 //y=1.015 //x2=14.515 //y2=1.145
r2077 (  36 233 ) resistor r=0.0413265 //w=0.7 //l=0.175 //layer=m1 \
 //thickness=0.36 //x=14.515 //y=0.35 //x2=14.515 //y2=0.175
r2078 (  36 37 ) resistor r=0.634542 //w=0.131 //l=0.665 //layer=m1 \
 //thickness=0.36 //x=14.515 //y=0.35 //x2=14.515 //y2=1.015
r2079 (  35 352 ) resistor r=3.1 //w=0.17 //l=0.51 //layer=mcon //count=3 \
 //x=13.07 //y=0.18 //x2=13.07 //y2=0.18
r2080 (  33 350 ) resistor r=3.1 //w=0.17 //l=0.51 //layer=mcon //count=3 \
 //x=11.96 //y=0.18 //x2=11.96 //y2=0.18
r2081 (  33 35 ) resistor r=0.446141 //w=0.311 //l=1.11 //layer=m1 \
 //thickness=0.36 //x=11.96 //y=0.175 //x2=13.07 //y2=0.175
r2082 (  31 228 ) resistor r=0.028033 //w=0.35 //l=0.085 //layer=m1 \
 //thickness=0.36 //x=11.375 //y=0.175 //x2=11.29 //y2=0.175
r2083 (  31 33 ) resistor r=0.235129 //w=0.311 //l=0.585 //layer=m1 \
 //thickness=0.36 //x=11.375 //y=0.175 //x2=11.96 //y2=0.175
r2084 (  30 233 ) resistor r=0.028033 //w=0.35 //l=0.085 //layer=m1 \
 //thickness=0.36 //x=14.43 //y=0.175 //x2=14.515 //y2=0.175
r2085 (  30 35 ) resistor r=0.546624 //w=0.311 //l=1.36 //layer=m1 \
 //thickness=0.36 //x=14.43 //y=0.175 //x2=13.07 //y2=0.175
r2086 (  28 228 ) resistor r=0.0413265 //w=0.7 //l=0.175 //layer=m1 \
 //thickness=0.36 //x=11.29 //y=0.35 //x2=11.29 //y2=0.175
r2087 (  28 226 ) resistor r=0.625 //w=0.131 //l=0.655 //layer=m1 \
 //thickness=0.36 //x=11.29 //y=0.35 //x2=11.29 //y2=1.005
r2088 (  27 348 ) resistor r=3.1 //w=0.17 //l=0.51 //layer=mcon //count=3 \
 //x=10.85 //y=0.18 //x2=10.85 //y2=0.18
r2089 (  25 337 ) resistor r=3.1 //w=0.17 //l=0.51 //layer=mcon //count=3 \
 //x=9.37 //y=0.18 //x2=9.37 //y2=0.18
r2090 (  25 27 ) resistor r=0.594855 //w=0.311 //l=1.48 //layer=m1 \
 //thickness=0.36 //x=9.37 //y=0.175 //x2=10.85 //y2=0.175
r2091 (  23 335 ) resistor r=3.1 //w=0.17 //l=0.51 //layer=mcon //count=3 \
 //x=8.26 //y=0.18 //x2=8.26 //y2=0.18
r2092 (  23 25 ) resistor r=0.446141 //w=0.311 //l=1.11 //layer=m1 \
 //thickness=0.36 //x=8.26 //y=0.175 //x2=9.37 //y2=0.175
r2093 (  21 333 ) resistor r=3.1 //w=0.17 //l=0.51 //layer=mcon //count=3 \
 //x=7.15 //y=0.18 //x2=7.15 //y2=0.18
r2094 (  21 23 ) resistor r=0.446141 //w=0.311 //l=1.11 //layer=m1 \
 //thickness=0.36 //x=7.15 //y=0.175 //x2=8.26 //y2=0.175
r2095 (  19 223 ) resistor r=0.028033 //w=0.35 //l=0.085 //layer=m1 \
 //thickness=0.36 //x=6.46 //y=0.175 //x2=6.375 //y2=0.175
r2096 (  19 21 ) resistor r=0.277331 //w=0.311 //l=0.69 //layer=m1 \
 //thickness=0.36 //x=6.46 //y=0.175 //x2=7.15 //y2=0.175
r2097 (  18 228 ) resistor r=0.028033 //w=0.35 //l=0.085 //layer=m1 \
 //thickness=0.36 //x=11.205 //y=0.175 //x2=11.29 //y2=0.175
r2098 (  18 27 ) resistor r=0.142685 //w=0.311 //l=0.355 //layer=m1 \
 //thickness=0.36 //x=11.205 //y=0.175 //x2=10.85 //y2=0.175
r2099 (  17 221 ) resistor r=0.0942778 //w=0.221 //l=0.13 //layer=m1 \
 //thickness=0.36 //x=6.375 //y=1.015 //x2=6.375 //y2=1.145
r2100 (  16 223 ) resistor r=0.0413265 //w=0.7 //l=0.175 //layer=m1 \
 //thickness=0.36 //x=6.375 //y=0.35 //x2=6.375 //y2=0.175
r2101 (  16 17 ) resistor r=0.634542 //w=0.131 //l=0.665 //layer=m1 \
 //thickness=0.36 //x=6.375 //y=0.35 //x2=6.375 //y2=1.015
r2102 (  15 331 ) resistor r=3.1 //w=0.17 //l=0.51 //layer=mcon //count=3 \
 //x=6.04 //y=0.18 //x2=6.04 //y2=0.18
r2103 (  13 320 ) resistor r=3.1 //w=0.17 //l=0.51 //layer=mcon //count=3 \
 //x=4.56 //y=0.18 //x2=4.56 //y2=0.18
r2104 (  13 15 ) resistor r=0.594855 //w=0.311 //l=1.48 //layer=m1 \
 //thickness=0.36 //x=4.56 //y=0.175 //x2=6.04 //y2=0.175
r2105 (  11 318 ) resistor r=3.1 //w=0.17 //l=0.51 //layer=mcon //count=3 \
 //x=3.45 //y=0.18 //x2=3.45 //y2=0.18
r2106 (  11 13 ) resistor r=0.446141 //w=0.311 //l=1.11 //layer=m1 \
 //thickness=0.36 //x=3.45 //y=0.175 //x2=4.56 //y2=0.175
r2107 (  9 316 ) resistor r=3.1 //w=0.17 //l=0.51 //layer=mcon //count=3 \
 //x=2.34 //y=0.18 //x2=2.34 //y2=0.18
r2108 (  9 11 ) resistor r=0.446141 //w=0.311 //l=1.11 //layer=m1 \
 //thickness=0.36 //x=2.34 //y=0.175 //x2=3.45 //y2=0.175
r2109 (  7 219 ) resistor r=0.028033 //w=0.35 //l=0.085 //layer=m1 \
 //thickness=0.36 //x=1.65 //y=0.175 //x2=1.565 //y2=0.175
r2110 (  7 9 ) resistor r=0.277331 //w=0.311 //l=0.69 //layer=m1 \
 //thickness=0.36 //x=1.65 //y=0.175 //x2=2.34 //y2=0.175
r2111 (  6 223 ) resistor r=0.028033 //w=0.35 //l=0.085 //layer=m1 \
 //thickness=0.36 //x=6.29 //y=0.175 //x2=6.375 //y2=0.175
r2112 (  6 15 ) resistor r=0.100482 //w=0.311 //l=0.25 //layer=m1 \
 //thickness=0.36 //x=6.29 //y=0.175 //x2=6.04 //y2=0.175
r2113 (  5 217 ) resistor r=0.0942778 //w=0.221 //l=0.13 //layer=m1 \
 //thickness=0.36 //x=1.565 //y=1.015 //x2=1.565 //y2=1.145
r2114 (  4 219 ) resistor r=0.0413265 //w=0.7 //l=0.175 //layer=m1 \
 //thickness=0.36 //x=1.565 //y=0.35 //x2=1.565 //y2=0.175
r2115 (  4 5 ) resistor r=0.634542 //w=0.131 //l=0.665 //layer=m1 \
 //thickness=0.36 //x=1.565 //y=0.35 //x2=1.565 //y2=1.015
r2116 (  3 314 ) resistor r=3.1 //w=0.17 //l=0.51 //layer=mcon //count=3 \
 //x=1.23 //y=0.18 //x2=1.23 //y2=0.18
r2117 (  1 219 ) resistor r=0.028033 //w=0.35 //l=0.085 //layer=m1 \
 //thickness=0.36 //x=1.48 //y=0.175 //x2=1.565 //y2=0.175
r2118 (  1 3 ) resistor r=0.0892857 //w=0.35 //l=0.25 //layer=m1 \
 //thickness=0.36 //x=1.48 //y=0.175 //x2=1.23 //y2=0.175
ends PM_TMRDFFRNQNX1\%GND

subckt PM_TMRDFFRNQNX1\%noxref_36 ( 1 5 9 13 17 35 )
c54 ( 35 0 ) capacitor c=0.0720943f //x=0.945 //y=0.555
c55 ( 17 0 ) capacitor c=0.0221074f //x=2.935 //y=1.77
c56 ( 13 0 ) capacitor c=0.0153941f //x=2.935 //y=0.72
c57 ( 9 0 ) capacitor c=0.00772076f //x=2.05 //y=0.805
c58 ( 5 0 ) capacitor c=0.0198385f //x=1.965 //y=1.77
c59 ( 1 0 ) capacitor c=0.0109947f //x=1.08 //y=1.685
r60 (  18 35 ) resistor r=5.4201 //w=0.17 //l=0.103078 //layer=li \
 //thickness=0.1 //x=2.135 //y=1.77 //x2=2.05 //y2=1.81
r61 (  18 35 ) resistor r=27.3797 //w=0.187 //l=0.4 //layer=li //thickness=0.1 \
 //x=2.135 //y=1.77 //x2=2.535 //y2=1.77
r62 (  17 35 ) resistor r=0.751729 //w=0.17 //l=0.085 //layer=li \
 //thickness=0.1 //x=2.935 //y=1.77 //x2=3.02 //y2=1.77
r63 (  17 35 ) resistor r=27.3797 //w=0.187 //l=0.4 //layer=li //thickness=0.1 \
 //x=2.935 //y=1.77 //x2=2.535 //y2=1.77
r64 (  14 35 ) resistor r=3.57586 //w=0.17 //l=0.103078 //layer=li \
 //thickness=0.1 //x=2.135 //y=0.72 //x2=2.05 //y2=0.68
r65 (  14 35 ) resistor r=27.3797 //w=0.187 //l=0.4 //layer=li //thickness=0.1 \
 //x=2.135 //y=0.72 //x2=2.535 //y2=0.72
r66 (  13 35 ) resistor r=0.751729 //w=0.17 //l=0.085 //layer=li \
 //thickness=0.1 //x=2.935 //y=0.72 //x2=3.02 //y2=0.72
r67 (  13 35 ) resistor r=27.3797 //w=0.187 //l=0.4 //layer=li //thickness=0.1 \
 //x=2.935 //y=0.72 //x2=2.535 //y2=0.72
r68 (  10 35 ) resistor r=1.40859 //w=0.34 //l=0.125 //layer=li \
 //thickness=0.1 //x=2.05 //y=1.685 //x2=2.05 //y2=1.81
r69 (  10 35 ) resistor r=42.0963 //w=0.187 //l=0.615 //layer=li \
 //thickness=0.1 //x=2.05 //y=1.685 //x2=2.05 //y2=1.07
r70 (  9 35 ) resistor r=3.57586 //w=0.17 //l=0.125 //layer=li //thickness=0.1 \
 //x=2.05 //y=0.805 //x2=2.05 //y2=0.68
r71 (  9 35 ) resistor r=18.139 //w=0.187 //l=0.265 //layer=li //thickness=0.1 \
 //x=2.05 //y=0.805 //x2=2.05 //y2=1.07
r72 (  6 35 ) resistor r=3.57586 //w=0.17 //l=0.103078 //layer=li \
 //thickness=0.1 //x=1.165 //y=1.77 //x2=1.08 //y2=1.81
r73 (  6 35 ) resistor r=27.3797 //w=0.187 //l=0.4 //layer=li //thickness=0.1 \
 //x=1.165 //y=1.77 //x2=1.565 //y2=1.77
r74 (  5 35 ) resistor r=5.4201 //w=0.17 //l=0.103078 //layer=li \
 //thickness=0.1 //x=1.965 //y=1.77 //x2=2.05 //y2=1.81
r75 (  5 35 ) resistor r=27.3797 //w=0.187 //l=0.4 //layer=li //thickness=0.1 \
 //x=1.965 //y=1.77 //x2=1.565 //y2=1.77
r76 (  1 35 ) resistor r=3.57586 //w=0.17 //l=0.125 //layer=li //thickness=0.1 \
 //x=1.08 //y=1.685 //x2=1.08 //y2=1.81
r77 (  1 35 ) resistor r=42.0963 //w=0.187 //l=0.615 //layer=li \
 //thickness=0.1 //x=1.08 //y=1.685 //x2=1.08 //y2=1.07
ends PM_TMRDFFRNQNX1\%noxref_36

subckt PM_TMRDFFRNQNX1\%noxref_37 ( 1 5 9 13 17 35 )
c60 ( 35 0 ) capacitor c=0.0698511f //x=5.755 //y=0.555
c61 ( 17 0 ) capacitor c=0.0204253f //x=7.745 //y=1.77
c62 ( 13 0 ) capacitor c=0.0153313f //x=7.745 //y=0.72
c63 ( 9 0 ) capacitor c=0.00772076f //x=6.86 //y=0.805
c64 ( 5 0 ) capacitor c=0.0180187f //x=6.775 //y=1.77
c65 ( 1 0 ) capacitor c=0.00771772f //x=5.89 //y=1.685
r66 (  18 35 ) resistor r=5.4201 //w=0.17 //l=0.103078 //layer=li \
 //thickness=0.1 //x=6.945 //y=1.77 //x2=6.86 //y2=1.81
r67 (  18 35 ) resistor r=27.3797 //w=0.187 //l=0.4 //layer=li //thickness=0.1 \
 //x=6.945 //y=1.77 //x2=7.345 //y2=1.77
r68 (  17 35 ) resistor r=0.751729 //w=0.17 //l=0.085 //layer=li \
 //thickness=0.1 //x=7.745 //y=1.77 //x2=7.83 //y2=1.77
r69 (  17 35 ) resistor r=27.3797 //w=0.187 //l=0.4 //layer=li //thickness=0.1 \
 //x=7.745 //y=1.77 //x2=7.345 //y2=1.77
r70 (  14 35 ) resistor r=3.57586 //w=0.17 //l=0.103078 //layer=li \
 //thickness=0.1 //x=6.945 //y=0.72 //x2=6.86 //y2=0.68
r71 (  14 35 ) resistor r=27.3797 //w=0.187 //l=0.4 //layer=li //thickness=0.1 \
 //x=6.945 //y=0.72 //x2=7.345 //y2=0.72
r72 (  13 35 ) resistor r=0.751729 //w=0.17 //l=0.085 //layer=li \
 //thickness=0.1 //x=7.745 //y=0.72 //x2=7.83 //y2=0.72
r73 (  13 35 ) resistor r=27.3797 //w=0.187 //l=0.4 //layer=li //thickness=0.1 \
 //x=7.745 //y=0.72 //x2=7.345 //y2=0.72
r74 (  10 35 ) resistor r=1.40859 //w=0.34 //l=0.125 //layer=li \
 //thickness=0.1 //x=6.86 //y=1.685 //x2=6.86 //y2=1.81
r75 (  10 35 ) resistor r=42.0963 //w=0.187 //l=0.615 //layer=li \
 //thickness=0.1 //x=6.86 //y=1.685 //x2=6.86 //y2=1.07
r76 (  9 35 ) resistor r=3.57586 //w=0.17 //l=0.125 //layer=li //thickness=0.1 \
 //x=6.86 //y=0.805 //x2=6.86 //y2=0.68
r77 (  9 35 ) resistor r=18.139 //w=0.187 //l=0.265 //layer=li //thickness=0.1 \
 //x=6.86 //y=0.805 //x2=6.86 //y2=1.07
r78 (  6 35 ) resistor r=3.57586 //w=0.17 //l=0.103078 //layer=li \
 //thickness=0.1 //x=5.975 //y=1.77 //x2=5.89 //y2=1.81
r79 (  6 35 ) resistor r=27.3797 //w=0.187 //l=0.4 //layer=li //thickness=0.1 \
 //x=5.975 //y=1.77 //x2=6.375 //y2=1.77
r80 (  5 35 ) resistor r=5.4201 //w=0.17 //l=0.103078 //layer=li \
 //thickness=0.1 //x=6.775 //y=1.77 //x2=6.86 //y2=1.81
r81 (  5 35 ) resistor r=27.3797 //w=0.187 //l=0.4 //layer=li //thickness=0.1 \
 //x=6.775 //y=1.77 //x2=6.375 //y2=1.77
r82 (  1 35 ) resistor r=3.57586 //w=0.17 //l=0.125 //layer=li //thickness=0.1 \
 //x=5.89 //y=1.685 //x2=5.89 //y2=1.81
r83 (  1 35 ) resistor r=42.0963 //w=0.187 //l=0.615 //layer=li \
 //thickness=0.1 //x=5.89 //y=1.685 //x2=5.89 //y2=1.07
ends PM_TMRDFFRNQNX1\%noxref_37

subckt PM_TMRDFFRNQNX1\%noxref_38 ( 1 5 9 10 13 17 29 )
c67 ( 29 0 ) capacitor c=0.067062f //x=10.67 //y=0.545
c68 ( 17 0 ) capacitor c=0.00675704f //x=12.745 //y=0.795
c69 ( 13 0 ) capacitor c=0.0156329f //x=12.66 //y=0.71
c70 ( 10 0 ) capacitor c=0.00673372f //x=11.775 //y=1.675
c71 ( 9 0 ) capacitor c=0.00770028f //x=11.775 //y=0.795
c72 ( 5 0 ) capacitor c=0.0179513f //x=11.69 //y=1.76
c73 ( 1 0 ) capacitor c=0.00761099f //x=10.805 //y=1.675
r74 (  17 29 ) resistor r=3.57586 //w=0.17 //l=0.125 //layer=li \
 //thickness=0.1 //x=12.745 //y=0.795 //x2=12.745 //y2=0.67
r75 (  17 29 ) resistor r=18.139 //w=0.187 //l=0.265 //layer=li \
 //thickness=0.1 //x=12.745 //y=0.795 //x2=12.745 //y2=1.06
r76 (  14 29 ) resistor r=3.57586 //w=0.17 //l=0.103078 //layer=li \
 //thickness=0.1 //x=11.86 //y=0.71 //x2=11.775 //y2=0.67
r77 (  14 29 ) resistor r=27.3797 //w=0.187 //l=0.4 //layer=li //thickness=0.1 \
 //x=11.86 //y=0.71 //x2=12.26 //y2=0.71
r78 (  13 29 ) resistor r=3.57586 //w=0.17 //l=0.103078 //layer=li \
 //thickness=0.1 //x=12.66 //y=0.71 //x2=12.745 //y2=0.67
r79 (  13 29 ) resistor r=27.3797 //w=0.187 //l=0.4 //layer=li //thickness=0.1 \
 //x=12.66 //y=0.71 //x2=12.26 //y2=0.71
r80 (  10 29 ) resistor r=3.57586 //w=0.17 //l=0.125 //layer=li \
 //thickness=0.1 //x=11.775 //y=1.675 //x2=11.775 //y2=1.8
r81 (  10 29 ) resistor r=42.0963 //w=0.187 //l=0.615 //layer=li \
 //thickness=0.1 //x=11.775 //y=1.675 //x2=11.775 //y2=1.06
r82 (  9 29 ) resistor r=3.57586 //w=0.17 //l=0.125 //layer=li //thickness=0.1 \
 //x=11.775 //y=0.795 //x2=11.775 //y2=0.67
r83 (  9 29 ) resistor r=18.139 //w=0.187 //l=0.265 //layer=li //thickness=0.1 \
 //x=11.775 //y=0.795 //x2=11.775 //y2=1.06
r84 (  6 29 ) resistor r=3.57586 //w=0.17 //l=0.103078 //layer=li \
 //thickness=0.1 //x=10.89 //y=1.76 //x2=10.805 //y2=1.8
r85 (  6 29 ) resistor r=27.3797 //w=0.187 //l=0.4 //layer=li //thickness=0.1 \
 //x=10.89 //y=1.76 //x2=11.29 //y2=1.76
r86 (  5 29 ) resistor r=3.57586 //w=0.17 //l=0.103078 //layer=li \
 //thickness=0.1 //x=11.69 //y=1.76 //x2=11.775 //y2=1.8
r87 (  5 29 ) resistor r=27.3797 //w=0.187 //l=0.4 //layer=li //thickness=0.1 \
 //x=11.69 //y=1.76 //x2=11.29 //y2=1.76
r88 (  1 29 ) resistor r=3.57586 //w=0.17 //l=0.125 //layer=li //thickness=0.1 \
 //x=10.805 //y=1.675 //x2=10.805 //y2=1.8
r89 (  1 29 ) resistor r=42.0963 //w=0.187 //l=0.615 //layer=li \
 //thickness=0.1 //x=10.805 //y=1.675 //x2=10.805 //y2=1.06
ends PM_TMRDFFRNQNX1\%noxref_38

subckt PM_TMRDFFRNQNX1\%noxref_39 ( 1 5 9 13 17 35 )
c58 ( 35 0 ) capacitor c=0.068832f //x=13.895 //y=0.555
c59 ( 17 0 ) capacitor c=0.0190725f //x=15.885 //y=1.77
c60 ( 13 0 ) capacitor c=0.015325f //x=15.885 //y=0.72
c61 ( 9 0 ) capacitor c=0.00772076f //x=15 //y=0.805
c62 ( 5 0 ) capacitor c=0.0168501f //x=14.915 //y=1.77
c63 ( 1 0 ) capacitor c=0.00709556f //x=14.03 //y=1.685
r64 (  18 35 ) resistor r=5.4201 //w=0.17 //l=0.103078 //layer=li \
 //thickness=0.1 //x=15.085 //y=1.77 //x2=15 //y2=1.81
r65 (  18 35 ) resistor r=27.3797 //w=0.187 //l=0.4 //layer=li //thickness=0.1 \
 //x=15.085 //y=1.77 //x2=15.485 //y2=1.77
r66 (  17 35 ) resistor r=0.751729 //w=0.17 //l=0.085 //layer=li \
 //thickness=0.1 //x=15.885 //y=1.77 //x2=15.97 //y2=1.77
r67 (  17 35 ) resistor r=27.3797 //w=0.187 //l=0.4 //layer=li //thickness=0.1 \
 //x=15.885 //y=1.77 //x2=15.485 //y2=1.77
r68 (  14 35 ) resistor r=3.57586 //w=0.17 //l=0.103078 //layer=li \
 //thickness=0.1 //x=15.085 //y=0.72 //x2=15 //y2=0.68
r69 (  14 35 ) resistor r=27.3797 //w=0.187 //l=0.4 //layer=li //thickness=0.1 \
 //x=15.085 //y=0.72 //x2=15.485 //y2=0.72
r70 (  13 35 ) resistor r=0.751729 //w=0.17 //l=0.085 //layer=li \
 //thickness=0.1 //x=15.885 //y=0.72 //x2=15.97 //y2=0.72
r71 (  13 35 ) resistor r=27.3797 //w=0.187 //l=0.4 //layer=li //thickness=0.1 \
 //x=15.885 //y=0.72 //x2=15.485 //y2=0.72
r72 (  10 35 ) resistor r=1.40859 //w=0.34 //l=0.125 //layer=li \
 //thickness=0.1 //x=15 //y=1.685 //x2=15 //y2=1.81
r73 (  10 35 ) resistor r=42.0963 //w=0.187 //l=0.615 //layer=li \
 //thickness=0.1 //x=15 //y=1.685 //x2=15 //y2=1.07
r74 (  9 35 ) resistor r=3.57586 //w=0.17 //l=0.125 //layer=li //thickness=0.1 \
 //x=15 //y=0.805 //x2=15 //y2=0.68
r75 (  9 35 ) resistor r=18.139 //w=0.187 //l=0.265 //layer=li //thickness=0.1 \
 //x=15 //y=0.805 //x2=15 //y2=1.07
r76 (  6 35 ) resistor r=3.57586 //w=0.17 //l=0.103078 //layer=li \
 //thickness=0.1 //x=14.115 //y=1.77 //x2=14.03 //y2=1.81
r77 (  6 35 ) resistor r=27.3797 //w=0.187 //l=0.4 //layer=li //thickness=0.1 \
 //x=14.115 //y=1.77 //x2=14.515 //y2=1.77
r78 (  5 35 ) resistor r=5.4201 //w=0.17 //l=0.103078 //layer=li \
 //thickness=0.1 //x=14.915 //y=1.77 //x2=15 //y2=1.81
r79 (  5 35 ) resistor r=27.3797 //w=0.187 //l=0.4 //layer=li //thickness=0.1 \
 //x=14.915 //y=1.77 //x2=14.515 //y2=1.77
r80 (  1 35 ) resistor r=3.57586 //w=0.17 //l=0.125 //layer=li //thickness=0.1 \
 //x=14.03 //y=1.685 //x2=14.03 //y2=1.81
r81 (  1 35 ) resistor r=42.0963 //w=0.187 //l=0.615 //layer=li \
 //thickness=0.1 //x=14.03 //y=1.685 //x2=14.03 //y2=1.07
ends PM_TMRDFFRNQNX1\%noxref_39

subckt PM_TMRDFFRNQNX1\%noxref_40 ( 1 5 9 13 17 35 )
c58 ( 35 0 ) capacitor c=0.0691304f //x=18.705 //y=0.555
c59 ( 17 0 ) capacitor c=0.0188157f //x=20.695 //y=1.77
c60 ( 13 0 ) capacitor c=0.015325f //x=20.695 //y=0.72
c61 ( 9 0 ) capacitor c=0.00772076f //x=19.81 //y=0.805
c62 ( 5 0 ) capacitor c=0.0168501f //x=19.725 //y=1.77
c63 ( 1 0 ) capacitor c=0.00710458f //x=18.84 //y=1.685
r64 (  18 35 ) resistor r=5.4201 //w=0.17 //l=0.103078 //layer=li \
 //thickness=0.1 //x=19.895 //y=1.77 //x2=19.81 //y2=1.81
r65 (  18 35 ) resistor r=27.3797 //w=0.187 //l=0.4 //layer=li //thickness=0.1 \
 //x=19.895 //y=1.77 //x2=20.295 //y2=1.77
r66 (  17 35 ) resistor r=0.751729 //w=0.17 //l=0.085 //layer=li \
 //thickness=0.1 //x=20.695 //y=1.77 //x2=20.78 //y2=1.77
r67 (  17 35 ) resistor r=27.3797 //w=0.187 //l=0.4 //layer=li //thickness=0.1 \
 //x=20.695 //y=1.77 //x2=20.295 //y2=1.77
r68 (  14 35 ) resistor r=3.57586 //w=0.17 //l=0.103078 //layer=li \
 //thickness=0.1 //x=19.895 //y=0.72 //x2=19.81 //y2=0.68
r69 (  14 35 ) resistor r=27.3797 //w=0.187 //l=0.4 //layer=li //thickness=0.1 \
 //x=19.895 //y=0.72 //x2=20.295 //y2=0.72
r70 (  13 35 ) resistor r=0.751729 //w=0.17 //l=0.085 //layer=li \
 //thickness=0.1 //x=20.695 //y=0.72 //x2=20.78 //y2=0.72
r71 (  13 35 ) resistor r=27.3797 //w=0.187 //l=0.4 //layer=li //thickness=0.1 \
 //x=20.695 //y=0.72 //x2=20.295 //y2=0.72
r72 (  10 35 ) resistor r=1.40859 //w=0.34 //l=0.125 //layer=li \
 //thickness=0.1 //x=19.81 //y=1.685 //x2=19.81 //y2=1.81
r73 (  10 35 ) resistor r=42.0963 //w=0.187 //l=0.615 //layer=li \
 //thickness=0.1 //x=19.81 //y=1.685 //x2=19.81 //y2=1.07
r74 (  9 35 ) resistor r=3.57586 //w=0.17 //l=0.125 //layer=li //thickness=0.1 \
 //x=19.81 //y=0.805 //x2=19.81 //y2=0.68
r75 (  9 35 ) resistor r=18.139 //w=0.187 //l=0.265 //layer=li //thickness=0.1 \
 //x=19.81 //y=0.805 //x2=19.81 //y2=1.07
r76 (  6 35 ) resistor r=3.57586 //w=0.17 //l=0.103078 //layer=li \
 //thickness=0.1 //x=18.925 //y=1.77 //x2=18.84 //y2=1.81
r77 (  6 35 ) resistor r=27.3797 //w=0.187 //l=0.4 //layer=li //thickness=0.1 \
 //x=18.925 //y=1.77 //x2=19.325 //y2=1.77
r78 (  5 35 ) resistor r=5.4201 //w=0.17 //l=0.103078 //layer=li \
 //thickness=0.1 //x=19.725 //y=1.77 //x2=19.81 //y2=1.81
r79 (  5 35 ) resistor r=27.3797 //w=0.187 //l=0.4 //layer=li //thickness=0.1 \
 //x=19.725 //y=1.77 //x2=19.325 //y2=1.77
r80 (  1 35 ) resistor r=3.57586 //w=0.17 //l=0.125 //layer=li //thickness=0.1 \
 //x=18.84 //y=1.685 //x2=18.84 //y2=1.81
r81 (  1 35 ) resistor r=42.0963 //w=0.187 //l=0.615 //layer=li \
 //thickness=0.1 //x=18.84 //y=1.685 //x2=18.84 //y2=1.07
ends PM_TMRDFFRNQNX1\%noxref_40

subckt PM_TMRDFFRNQNX1\%noxref_41 ( 1 5 9 10 13 17 29 )
c67 ( 29 0 ) capacitor c=0.0668165f //x=23.62 //y=0.545
c68 ( 17 0 ) capacitor c=0.00675704f //x=25.695 //y=0.795
c69 ( 13 0 ) capacitor c=0.0155876f //x=25.61 //y=0.71
c70 ( 10 0 ) capacitor c=0.00673372f //x=24.725 //y=1.675
c71 ( 9 0 ) capacitor c=0.00770028f //x=24.725 //y=0.795
c72 ( 5 0 ) capacitor c=0.0179513f //x=24.64 //y=1.76
c73 ( 1 0 ) capacitor c=0.00761099f //x=23.755 //y=1.675
r74 (  17 29 ) resistor r=3.57586 //w=0.17 //l=0.125 //layer=li \
 //thickness=0.1 //x=25.695 //y=0.795 //x2=25.695 //y2=0.67
r75 (  17 29 ) resistor r=18.139 //w=0.187 //l=0.265 //layer=li \
 //thickness=0.1 //x=25.695 //y=0.795 //x2=25.695 //y2=1.06
r76 (  14 29 ) resistor r=3.57586 //w=0.17 //l=0.103078 //layer=li \
 //thickness=0.1 //x=24.81 //y=0.71 //x2=24.725 //y2=0.67
r77 (  14 29 ) resistor r=27.3797 //w=0.187 //l=0.4 //layer=li //thickness=0.1 \
 //x=24.81 //y=0.71 //x2=25.21 //y2=0.71
r78 (  13 29 ) resistor r=3.57586 //w=0.17 //l=0.103078 //layer=li \
 //thickness=0.1 //x=25.61 //y=0.71 //x2=25.695 //y2=0.67
r79 (  13 29 ) resistor r=27.3797 //w=0.187 //l=0.4 //layer=li //thickness=0.1 \
 //x=25.61 //y=0.71 //x2=25.21 //y2=0.71
r80 (  10 29 ) resistor r=3.57586 //w=0.17 //l=0.125 //layer=li \
 //thickness=0.1 //x=24.725 //y=1.675 //x2=24.725 //y2=1.8
r81 (  10 29 ) resistor r=42.0963 //w=0.187 //l=0.615 //layer=li \
 //thickness=0.1 //x=24.725 //y=1.675 //x2=24.725 //y2=1.06
r82 (  9 29 ) resistor r=3.57586 //w=0.17 //l=0.125 //layer=li //thickness=0.1 \
 //x=24.725 //y=0.795 //x2=24.725 //y2=0.67
r83 (  9 29 ) resistor r=18.139 //w=0.187 //l=0.265 //layer=li //thickness=0.1 \
 //x=24.725 //y=0.795 //x2=24.725 //y2=1.06
r84 (  6 29 ) resistor r=3.57586 //w=0.17 //l=0.103078 //layer=li \
 //thickness=0.1 //x=23.84 //y=1.76 //x2=23.755 //y2=1.8
r85 (  6 29 ) resistor r=27.3797 //w=0.187 //l=0.4 //layer=li //thickness=0.1 \
 //x=23.84 //y=1.76 //x2=24.24 //y2=1.76
r86 (  5 29 ) resistor r=3.57586 //w=0.17 //l=0.103078 //layer=li \
 //thickness=0.1 //x=24.64 //y=1.76 //x2=24.725 //y2=1.8
r87 (  5 29 ) resistor r=27.3797 //w=0.187 //l=0.4 //layer=li //thickness=0.1 \
 //x=24.64 //y=1.76 //x2=24.24 //y2=1.76
r88 (  1 29 ) resistor r=3.57586 //w=0.17 //l=0.125 //layer=li //thickness=0.1 \
 //x=23.755 //y=1.675 //x2=23.755 //y2=1.8
r89 (  1 29 ) resistor r=42.0963 //w=0.187 //l=0.615 //layer=li \
 //thickness=0.1 //x=23.755 //y=1.675 //x2=23.755 //y2=1.06
ends PM_TMRDFFRNQNX1\%noxref_41

subckt PM_TMRDFFRNQNX1\%noxref_42 ( 1 5 9 13 17 35 )
c58 ( 35 0 ) capacitor c=0.068832f //x=26.845 //y=0.555
c59 ( 17 0 ) capacitor c=0.0190725f //x=28.835 //y=1.77
c60 ( 13 0 ) capacitor c=0.015325f //x=28.835 //y=0.72
c61 ( 9 0 ) capacitor c=0.00772076f //x=27.95 //y=0.805
c62 ( 5 0 ) capacitor c=0.0168501f //x=27.865 //y=1.77
c63 ( 1 0 ) capacitor c=0.00709556f //x=26.98 //y=1.685
r64 (  18 35 ) resistor r=5.4201 //w=0.17 //l=0.103078 //layer=li \
 //thickness=0.1 //x=28.035 //y=1.77 //x2=27.95 //y2=1.81
r65 (  18 35 ) resistor r=27.3797 //w=0.187 //l=0.4 //layer=li //thickness=0.1 \
 //x=28.035 //y=1.77 //x2=28.435 //y2=1.77
r66 (  17 35 ) resistor r=0.751729 //w=0.17 //l=0.085 //layer=li \
 //thickness=0.1 //x=28.835 //y=1.77 //x2=28.92 //y2=1.77
r67 (  17 35 ) resistor r=27.3797 //w=0.187 //l=0.4 //layer=li //thickness=0.1 \
 //x=28.835 //y=1.77 //x2=28.435 //y2=1.77
r68 (  14 35 ) resistor r=3.57586 //w=0.17 //l=0.103078 //layer=li \
 //thickness=0.1 //x=28.035 //y=0.72 //x2=27.95 //y2=0.68
r69 (  14 35 ) resistor r=27.3797 //w=0.187 //l=0.4 //layer=li //thickness=0.1 \
 //x=28.035 //y=0.72 //x2=28.435 //y2=0.72
r70 (  13 35 ) resistor r=0.751729 //w=0.17 //l=0.085 //layer=li \
 //thickness=0.1 //x=28.835 //y=0.72 //x2=28.92 //y2=0.72
r71 (  13 35 ) resistor r=27.3797 //w=0.187 //l=0.4 //layer=li //thickness=0.1 \
 //x=28.835 //y=0.72 //x2=28.435 //y2=0.72
r72 (  10 35 ) resistor r=1.40859 //w=0.34 //l=0.125 //layer=li \
 //thickness=0.1 //x=27.95 //y=1.685 //x2=27.95 //y2=1.81
r73 (  10 35 ) resistor r=42.0963 //w=0.187 //l=0.615 //layer=li \
 //thickness=0.1 //x=27.95 //y=1.685 //x2=27.95 //y2=1.07
r74 (  9 35 ) resistor r=3.57586 //w=0.17 //l=0.125 //layer=li //thickness=0.1 \
 //x=27.95 //y=0.805 //x2=27.95 //y2=0.68
r75 (  9 35 ) resistor r=18.139 //w=0.187 //l=0.265 //layer=li //thickness=0.1 \
 //x=27.95 //y=0.805 //x2=27.95 //y2=1.07
r76 (  6 35 ) resistor r=3.57586 //w=0.17 //l=0.103078 //layer=li \
 //thickness=0.1 //x=27.065 //y=1.77 //x2=26.98 //y2=1.81
r77 (  6 35 ) resistor r=27.3797 //w=0.187 //l=0.4 //layer=li //thickness=0.1 \
 //x=27.065 //y=1.77 //x2=27.465 //y2=1.77
r78 (  5 35 ) resistor r=5.4201 //w=0.17 //l=0.103078 //layer=li \
 //thickness=0.1 //x=27.865 //y=1.77 //x2=27.95 //y2=1.81
r79 (  5 35 ) resistor r=27.3797 //w=0.187 //l=0.4 //layer=li //thickness=0.1 \
 //x=27.865 //y=1.77 //x2=27.465 //y2=1.77
r80 (  1 35 ) resistor r=3.57586 //w=0.17 //l=0.125 //layer=li //thickness=0.1 \
 //x=26.98 //y=1.685 //x2=26.98 //y2=1.81
r81 (  1 35 ) resistor r=42.0963 //w=0.187 //l=0.615 //layer=li \
 //thickness=0.1 //x=26.98 //y=1.685 //x2=26.98 //y2=1.07
ends PM_TMRDFFRNQNX1\%noxref_42

subckt PM_TMRDFFRNQNX1\%noxref_43 ( 1 5 9 13 17 35 )
c60 ( 35 0 ) capacitor c=0.0690793f //x=31.655 //y=0.555
c61 ( 17 0 ) capacitor c=0.0189641f //x=33.645 //y=1.77
c62 ( 13 0 ) capacitor c=0.0153235f //x=33.645 //y=0.72
c63 ( 9 0 ) capacitor c=0.00772076f //x=32.76 //y=0.805
c64 ( 5 0 ) capacitor c=0.0168501f //x=32.675 //y=1.77
c65 ( 1 0 ) capacitor c=0.00710458f //x=31.79 //y=1.685
r66 (  18 35 ) resistor r=5.4201 //w=0.17 //l=0.103078 //layer=li \
 //thickness=0.1 //x=32.845 //y=1.77 //x2=32.76 //y2=1.81
r67 (  18 35 ) resistor r=27.3797 //w=0.187 //l=0.4 //layer=li //thickness=0.1 \
 //x=32.845 //y=1.77 //x2=33.245 //y2=1.77
r68 (  17 35 ) resistor r=0.751729 //w=0.17 //l=0.085 //layer=li \
 //thickness=0.1 //x=33.645 //y=1.77 //x2=33.73 //y2=1.77
r69 (  17 35 ) resistor r=27.3797 //w=0.187 //l=0.4 //layer=li //thickness=0.1 \
 //x=33.645 //y=1.77 //x2=33.245 //y2=1.77
r70 (  14 35 ) resistor r=3.57586 //w=0.17 //l=0.103078 //layer=li \
 //thickness=0.1 //x=32.845 //y=0.72 //x2=32.76 //y2=0.68
r71 (  14 35 ) resistor r=27.3797 //w=0.187 //l=0.4 //layer=li //thickness=0.1 \
 //x=32.845 //y=0.72 //x2=33.245 //y2=0.72
r72 (  13 35 ) resistor r=0.751729 //w=0.17 //l=0.085 //layer=li \
 //thickness=0.1 //x=33.645 //y=0.72 //x2=33.73 //y2=0.72
r73 (  13 35 ) resistor r=27.3797 //w=0.187 //l=0.4 //layer=li //thickness=0.1 \
 //x=33.645 //y=0.72 //x2=33.245 //y2=0.72
r74 (  10 35 ) resistor r=1.40859 //w=0.34 //l=0.125 //layer=li \
 //thickness=0.1 //x=32.76 //y=1.685 //x2=32.76 //y2=1.81
r75 (  10 35 ) resistor r=42.0963 //w=0.187 //l=0.615 //layer=li \
 //thickness=0.1 //x=32.76 //y=1.685 //x2=32.76 //y2=1.07
r76 (  9 35 ) resistor r=3.57586 //w=0.17 //l=0.125 //layer=li //thickness=0.1 \
 //x=32.76 //y=0.805 //x2=32.76 //y2=0.68
r77 (  9 35 ) resistor r=18.139 //w=0.187 //l=0.265 //layer=li //thickness=0.1 \
 //x=32.76 //y=0.805 //x2=32.76 //y2=1.07
r78 (  6 35 ) resistor r=3.57586 //w=0.17 //l=0.103078 //layer=li \
 //thickness=0.1 //x=31.875 //y=1.77 //x2=31.79 //y2=1.81
r79 (  6 35 ) resistor r=27.3797 //w=0.187 //l=0.4 //layer=li //thickness=0.1 \
 //x=31.875 //y=1.77 //x2=32.275 //y2=1.77
r80 (  5 35 ) resistor r=5.4201 //w=0.17 //l=0.103078 //layer=li \
 //thickness=0.1 //x=32.675 //y=1.77 //x2=32.76 //y2=1.81
r81 (  5 35 ) resistor r=27.3797 //w=0.187 //l=0.4 //layer=li //thickness=0.1 \
 //x=32.675 //y=1.77 //x2=32.275 //y2=1.77
r82 (  1 35 ) resistor r=3.57586 //w=0.17 //l=0.125 //layer=li //thickness=0.1 \
 //x=31.79 //y=1.685 //x2=31.79 //y2=1.81
r83 (  1 35 ) resistor r=42.0963 //w=0.187 //l=0.615 //layer=li \
 //thickness=0.1 //x=31.79 //y=1.685 //x2=31.79 //y2=1.07
ends PM_TMRDFFRNQNX1\%noxref_43

subckt PM_TMRDFFRNQNX1\%noxref_44 ( 1 5 9 10 13 17 29 )
c67 ( 29 0 ) capacitor c=0.067062f //x=36.57 //y=0.545
c68 ( 17 0 ) capacitor c=0.00675704f //x=38.645 //y=0.795
c69 ( 13 0 ) capacitor c=0.0156329f //x=38.56 //y=0.71
c70 ( 10 0 ) capacitor c=0.00673372f //x=37.675 //y=1.675
c71 ( 9 0 ) capacitor c=0.00770028f //x=37.675 //y=0.795
c72 ( 5 0 ) capacitor c=0.0179513f //x=37.59 //y=1.76
c73 ( 1 0 ) capacitor c=0.00761099f //x=36.705 //y=1.675
r74 (  17 29 ) resistor r=3.57586 //w=0.17 //l=0.125 //layer=li \
 //thickness=0.1 //x=38.645 //y=0.795 //x2=38.645 //y2=0.67
r75 (  17 29 ) resistor r=18.139 //w=0.187 //l=0.265 //layer=li \
 //thickness=0.1 //x=38.645 //y=0.795 //x2=38.645 //y2=1.06
r76 (  14 29 ) resistor r=3.57586 //w=0.17 //l=0.103078 //layer=li \
 //thickness=0.1 //x=37.76 //y=0.71 //x2=37.675 //y2=0.67
r77 (  14 29 ) resistor r=27.3797 //w=0.187 //l=0.4 //layer=li //thickness=0.1 \
 //x=37.76 //y=0.71 //x2=38.16 //y2=0.71
r78 (  13 29 ) resistor r=3.57586 //w=0.17 //l=0.103078 //layer=li \
 //thickness=0.1 //x=38.56 //y=0.71 //x2=38.645 //y2=0.67
r79 (  13 29 ) resistor r=27.3797 //w=0.187 //l=0.4 //layer=li //thickness=0.1 \
 //x=38.56 //y=0.71 //x2=38.16 //y2=0.71
r80 (  10 29 ) resistor r=3.57586 //w=0.17 //l=0.125 //layer=li \
 //thickness=0.1 //x=37.675 //y=1.675 //x2=37.675 //y2=1.8
r81 (  10 29 ) resistor r=42.0963 //w=0.187 //l=0.615 //layer=li \
 //thickness=0.1 //x=37.675 //y=1.675 //x2=37.675 //y2=1.06
r82 (  9 29 ) resistor r=3.57586 //w=0.17 //l=0.125 //layer=li //thickness=0.1 \
 //x=37.675 //y=0.795 //x2=37.675 //y2=0.67
r83 (  9 29 ) resistor r=18.139 //w=0.187 //l=0.265 //layer=li //thickness=0.1 \
 //x=37.675 //y=0.795 //x2=37.675 //y2=1.06
r84 (  6 29 ) resistor r=3.57586 //w=0.17 //l=0.103078 //layer=li \
 //thickness=0.1 //x=36.79 //y=1.76 //x2=36.705 //y2=1.8
r85 (  6 29 ) resistor r=27.3797 //w=0.187 //l=0.4 //layer=li //thickness=0.1 \
 //x=36.79 //y=1.76 //x2=37.19 //y2=1.76
r86 (  5 29 ) resistor r=3.57586 //w=0.17 //l=0.103078 //layer=li \
 //thickness=0.1 //x=37.59 //y=1.76 //x2=37.675 //y2=1.8
r87 (  5 29 ) resistor r=27.3797 //w=0.187 //l=0.4 //layer=li //thickness=0.1 \
 //x=37.59 //y=1.76 //x2=37.19 //y2=1.76
r88 (  1 29 ) resistor r=3.57586 //w=0.17 //l=0.125 //layer=li //thickness=0.1 \
 //x=36.705 //y=1.675 //x2=36.705 //y2=1.8
r89 (  1 29 ) resistor r=42.0963 //w=0.187 //l=0.615 //layer=li \
 //thickness=0.1 //x=36.705 //y=1.675 //x2=36.705 //y2=1.06
ends PM_TMRDFFRNQNX1\%noxref_44

subckt PM_TMRDFFRNQNX1\%noxref_45 ( 1 5 9 13 17 35 )
c58 ( 35 0 ) capacitor c=0.068832f //x=39.795 //y=0.555
c59 ( 17 0 ) capacitor c=0.0190725f //x=41.785 //y=1.77
c60 ( 13 0 ) capacitor c=0.015325f //x=41.785 //y=0.72
c61 ( 9 0 ) capacitor c=0.00772076f //x=40.9 //y=0.805
c62 ( 5 0 ) capacitor c=0.0168501f //x=40.815 //y=1.77
c63 ( 1 0 ) capacitor c=0.00709556f //x=39.93 //y=1.685
r64 (  18 35 ) resistor r=5.4201 //w=0.17 //l=0.103078 //layer=li \
 //thickness=0.1 //x=40.985 //y=1.77 //x2=40.9 //y2=1.81
r65 (  18 35 ) resistor r=27.3797 //w=0.187 //l=0.4 //layer=li //thickness=0.1 \
 //x=40.985 //y=1.77 //x2=41.385 //y2=1.77
r66 (  17 35 ) resistor r=0.751729 //w=0.17 //l=0.085 //layer=li \
 //thickness=0.1 //x=41.785 //y=1.77 //x2=41.87 //y2=1.77
r67 (  17 35 ) resistor r=27.3797 //w=0.187 //l=0.4 //layer=li //thickness=0.1 \
 //x=41.785 //y=1.77 //x2=41.385 //y2=1.77
r68 (  14 35 ) resistor r=3.57586 //w=0.17 //l=0.103078 //layer=li \
 //thickness=0.1 //x=40.985 //y=0.72 //x2=40.9 //y2=0.68
r69 (  14 35 ) resistor r=27.3797 //w=0.187 //l=0.4 //layer=li //thickness=0.1 \
 //x=40.985 //y=0.72 //x2=41.385 //y2=0.72
r70 (  13 35 ) resistor r=0.751729 //w=0.17 //l=0.085 //layer=li \
 //thickness=0.1 //x=41.785 //y=0.72 //x2=41.87 //y2=0.72
r71 (  13 35 ) resistor r=27.3797 //w=0.187 //l=0.4 //layer=li //thickness=0.1 \
 //x=41.785 //y=0.72 //x2=41.385 //y2=0.72
r72 (  10 35 ) resistor r=1.40859 //w=0.34 //l=0.125 //layer=li \
 //thickness=0.1 //x=40.9 //y=1.685 //x2=40.9 //y2=1.81
r73 (  10 35 ) resistor r=42.0963 //w=0.187 //l=0.615 //layer=li \
 //thickness=0.1 //x=40.9 //y=1.685 //x2=40.9 //y2=1.07
r74 (  9 35 ) resistor r=3.57586 //w=0.17 //l=0.125 //layer=li //thickness=0.1 \
 //x=40.9 //y=0.805 //x2=40.9 //y2=0.68
r75 (  9 35 ) resistor r=18.139 //w=0.187 //l=0.265 //layer=li //thickness=0.1 \
 //x=40.9 //y=0.805 //x2=40.9 //y2=1.07
r76 (  6 35 ) resistor r=3.57586 //w=0.17 //l=0.103078 //layer=li \
 //thickness=0.1 //x=40.015 //y=1.77 //x2=39.93 //y2=1.81
r77 (  6 35 ) resistor r=27.3797 //w=0.187 //l=0.4 //layer=li //thickness=0.1 \
 //x=40.015 //y=1.77 //x2=40.415 //y2=1.77
r78 (  5 35 ) resistor r=5.4201 //w=0.17 //l=0.103078 //layer=li \
 //thickness=0.1 //x=40.815 //y=1.77 //x2=40.9 //y2=1.81
r79 (  5 35 ) resistor r=27.3797 //w=0.187 //l=0.4 //layer=li //thickness=0.1 \
 //x=40.815 //y=1.77 //x2=40.415 //y2=1.77
r80 (  1 35 ) resistor r=3.57586 //w=0.17 //l=0.125 //layer=li //thickness=0.1 \
 //x=39.93 //y=1.685 //x2=39.93 //y2=1.81
r81 (  1 35 ) resistor r=42.0963 //w=0.187 //l=0.615 //layer=li \
 //thickness=0.1 //x=39.93 //y=1.685 //x2=39.93 //y2=1.07
ends PM_TMRDFFRNQNX1\%noxref_45

subckt PM_TMRDFFRNQNX1\%noxref_46 ( 1 5 9 13 17 35 )
c58 ( 35 0 ) capacitor c=0.0691304f //x=44.605 //y=0.555
c59 ( 17 0 ) capacitor c=0.0188157f //x=46.595 //y=1.77
c60 ( 13 0 ) capacitor c=0.015325f //x=46.595 //y=0.72
c61 ( 9 0 ) capacitor c=0.00772076f //x=45.71 //y=0.805
c62 ( 5 0 ) capacitor c=0.0168501f //x=45.625 //y=1.77
c63 ( 1 0 ) capacitor c=0.00710458f //x=44.74 //y=1.685
r64 (  18 35 ) resistor r=5.4201 //w=0.17 //l=0.103078 //layer=li \
 //thickness=0.1 //x=45.795 //y=1.77 //x2=45.71 //y2=1.81
r65 (  18 35 ) resistor r=27.3797 //w=0.187 //l=0.4 //layer=li //thickness=0.1 \
 //x=45.795 //y=1.77 //x2=46.195 //y2=1.77
r66 (  17 35 ) resistor r=0.751729 //w=0.17 //l=0.085 //layer=li \
 //thickness=0.1 //x=46.595 //y=1.77 //x2=46.68 //y2=1.77
r67 (  17 35 ) resistor r=27.3797 //w=0.187 //l=0.4 //layer=li //thickness=0.1 \
 //x=46.595 //y=1.77 //x2=46.195 //y2=1.77
r68 (  14 35 ) resistor r=3.57586 //w=0.17 //l=0.103078 //layer=li \
 //thickness=0.1 //x=45.795 //y=0.72 //x2=45.71 //y2=0.68
r69 (  14 35 ) resistor r=27.3797 //w=0.187 //l=0.4 //layer=li //thickness=0.1 \
 //x=45.795 //y=0.72 //x2=46.195 //y2=0.72
r70 (  13 35 ) resistor r=0.751729 //w=0.17 //l=0.085 //layer=li \
 //thickness=0.1 //x=46.595 //y=0.72 //x2=46.68 //y2=0.72
r71 (  13 35 ) resistor r=27.3797 //w=0.187 //l=0.4 //layer=li //thickness=0.1 \
 //x=46.595 //y=0.72 //x2=46.195 //y2=0.72
r72 (  10 35 ) resistor r=1.40859 //w=0.34 //l=0.125 //layer=li \
 //thickness=0.1 //x=45.71 //y=1.685 //x2=45.71 //y2=1.81
r73 (  10 35 ) resistor r=42.0963 //w=0.187 //l=0.615 //layer=li \
 //thickness=0.1 //x=45.71 //y=1.685 //x2=45.71 //y2=1.07
r74 (  9 35 ) resistor r=3.57586 //w=0.17 //l=0.125 //layer=li //thickness=0.1 \
 //x=45.71 //y=0.805 //x2=45.71 //y2=0.68
r75 (  9 35 ) resistor r=18.139 //w=0.187 //l=0.265 //layer=li //thickness=0.1 \
 //x=45.71 //y=0.805 //x2=45.71 //y2=1.07
r76 (  6 35 ) resistor r=3.57586 //w=0.17 //l=0.103078 //layer=li \
 //thickness=0.1 //x=44.825 //y=1.77 //x2=44.74 //y2=1.81
r77 (  6 35 ) resistor r=27.3797 //w=0.187 //l=0.4 //layer=li //thickness=0.1 \
 //x=44.825 //y=1.77 //x2=45.225 //y2=1.77
r78 (  5 35 ) resistor r=5.4201 //w=0.17 //l=0.103078 //layer=li \
 //thickness=0.1 //x=45.625 //y=1.77 //x2=45.71 //y2=1.81
r79 (  5 35 ) resistor r=27.3797 //w=0.187 //l=0.4 //layer=li //thickness=0.1 \
 //x=45.625 //y=1.77 //x2=45.225 //y2=1.77
r80 (  1 35 ) resistor r=3.57586 //w=0.17 //l=0.125 //layer=li //thickness=0.1 \
 //x=44.74 //y=1.685 //x2=44.74 //y2=1.81
r81 (  1 35 ) resistor r=42.0963 //w=0.187 //l=0.615 //layer=li \
 //thickness=0.1 //x=44.74 //y=1.685 //x2=44.74 //y2=1.07
ends PM_TMRDFFRNQNX1\%noxref_46

subckt PM_TMRDFFRNQNX1\%noxref_47 ( 1 5 9 10 13 17 29 )
c67 ( 29 0 ) capacitor c=0.067062f //x=49.52 //y=0.545
c68 ( 17 0 ) capacitor c=0.00675704f //x=51.595 //y=0.795
c69 ( 13 0 ) capacitor c=0.0155876f //x=51.51 //y=0.71
c70 ( 10 0 ) capacitor c=0.00673372f //x=50.625 //y=1.675
c71 ( 9 0 ) capacitor c=0.00770028f //x=50.625 //y=0.795
c72 ( 5 0 ) capacitor c=0.0179513f //x=50.54 //y=1.76
c73 ( 1 0 ) capacitor c=0.00761099f //x=49.655 //y=1.675
r74 (  17 29 ) resistor r=3.57586 //w=0.17 //l=0.125 //layer=li \
 //thickness=0.1 //x=51.595 //y=0.795 //x2=51.595 //y2=0.67
r75 (  17 29 ) resistor r=18.139 //w=0.187 //l=0.265 //layer=li \
 //thickness=0.1 //x=51.595 //y=0.795 //x2=51.595 //y2=1.06
r76 (  14 29 ) resistor r=3.57586 //w=0.17 //l=0.103078 //layer=li \
 //thickness=0.1 //x=50.71 //y=0.71 //x2=50.625 //y2=0.67
r77 (  14 29 ) resistor r=27.3797 //w=0.187 //l=0.4 //layer=li //thickness=0.1 \
 //x=50.71 //y=0.71 //x2=51.11 //y2=0.71
r78 (  13 29 ) resistor r=3.57586 //w=0.17 //l=0.103078 //layer=li \
 //thickness=0.1 //x=51.51 //y=0.71 //x2=51.595 //y2=0.67
r79 (  13 29 ) resistor r=27.3797 //w=0.187 //l=0.4 //layer=li //thickness=0.1 \
 //x=51.51 //y=0.71 //x2=51.11 //y2=0.71
r80 (  10 29 ) resistor r=3.57586 //w=0.17 //l=0.125 //layer=li \
 //thickness=0.1 //x=50.625 //y=1.675 //x2=50.625 //y2=1.8
r81 (  10 29 ) resistor r=42.0963 //w=0.187 //l=0.615 //layer=li \
 //thickness=0.1 //x=50.625 //y=1.675 //x2=50.625 //y2=1.06
r82 (  9 29 ) resistor r=3.57586 //w=0.17 //l=0.125 //layer=li //thickness=0.1 \
 //x=50.625 //y=0.795 //x2=50.625 //y2=0.67
r83 (  9 29 ) resistor r=18.139 //w=0.187 //l=0.265 //layer=li //thickness=0.1 \
 //x=50.625 //y=0.795 //x2=50.625 //y2=1.06
r84 (  6 29 ) resistor r=3.57586 //w=0.17 //l=0.103078 //layer=li \
 //thickness=0.1 //x=49.74 //y=1.76 //x2=49.655 //y2=1.8
r85 (  6 29 ) resistor r=27.3797 //w=0.187 //l=0.4 //layer=li //thickness=0.1 \
 //x=49.74 //y=1.76 //x2=50.14 //y2=1.76
r86 (  5 29 ) resistor r=3.57586 //w=0.17 //l=0.103078 //layer=li \
 //thickness=0.1 //x=50.54 //y=1.76 //x2=50.625 //y2=1.8
r87 (  5 29 ) resistor r=27.3797 //w=0.187 //l=0.4 //layer=li //thickness=0.1 \
 //x=50.54 //y=1.76 //x2=50.14 //y2=1.76
r88 (  1 29 ) resistor r=3.57586 //w=0.17 //l=0.125 //layer=li //thickness=0.1 \
 //x=49.655 //y=1.675 //x2=49.655 //y2=1.8
r89 (  1 29 ) resistor r=42.0963 //w=0.187 //l=0.615 //layer=li \
 //thickness=0.1 //x=49.655 //y=1.675 //x2=49.655 //y2=1.06
ends PM_TMRDFFRNQNX1\%noxref_47

subckt PM_TMRDFFRNQNX1\%noxref_48 ( 1 5 9 13 17 35 )
c58 ( 35 0 ) capacitor c=0.068832f //x=52.745 //y=0.555
c59 ( 17 0 ) capacitor c=0.0190725f //x=54.735 //y=1.77
c60 ( 13 0 ) capacitor c=0.015325f //x=54.735 //y=0.72
c61 ( 9 0 ) capacitor c=0.00772076f //x=53.85 //y=0.805
c62 ( 5 0 ) capacitor c=0.0168501f //x=53.765 //y=1.77
c63 ( 1 0 ) capacitor c=0.00709556f //x=52.88 //y=1.685
r64 (  18 35 ) resistor r=5.4201 //w=0.17 //l=0.103078 //layer=li \
 //thickness=0.1 //x=53.935 //y=1.77 //x2=53.85 //y2=1.81
r65 (  18 35 ) resistor r=27.3797 //w=0.187 //l=0.4 //layer=li //thickness=0.1 \
 //x=53.935 //y=1.77 //x2=54.335 //y2=1.77
r66 (  17 35 ) resistor r=0.751729 //w=0.17 //l=0.085 //layer=li \
 //thickness=0.1 //x=54.735 //y=1.77 //x2=54.82 //y2=1.77
r67 (  17 35 ) resistor r=27.3797 //w=0.187 //l=0.4 //layer=li //thickness=0.1 \
 //x=54.735 //y=1.77 //x2=54.335 //y2=1.77
r68 (  14 35 ) resistor r=3.57586 //w=0.17 //l=0.103078 //layer=li \
 //thickness=0.1 //x=53.935 //y=0.72 //x2=53.85 //y2=0.68
r69 (  14 35 ) resistor r=27.3797 //w=0.187 //l=0.4 //layer=li //thickness=0.1 \
 //x=53.935 //y=0.72 //x2=54.335 //y2=0.72
r70 (  13 35 ) resistor r=0.751729 //w=0.17 //l=0.085 //layer=li \
 //thickness=0.1 //x=54.735 //y=0.72 //x2=54.82 //y2=0.72
r71 (  13 35 ) resistor r=27.3797 //w=0.187 //l=0.4 //layer=li //thickness=0.1 \
 //x=54.735 //y=0.72 //x2=54.335 //y2=0.72
r72 (  10 35 ) resistor r=1.40859 //w=0.34 //l=0.125 //layer=li \
 //thickness=0.1 //x=53.85 //y=1.685 //x2=53.85 //y2=1.81
r73 (  10 35 ) resistor r=42.0963 //w=0.187 //l=0.615 //layer=li \
 //thickness=0.1 //x=53.85 //y=1.685 //x2=53.85 //y2=1.07
r74 (  9 35 ) resistor r=3.57586 //w=0.17 //l=0.125 //layer=li //thickness=0.1 \
 //x=53.85 //y=0.805 //x2=53.85 //y2=0.68
r75 (  9 35 ) resistor r=18.139 //w=0.187 //l=0.265 //layer=li //thickness=0.1 \
 //x=53.85 //y=0.805 //x2=53.85 //y2=1.07
r76 (  6 35 ) resistor r=3.57586 //w=0.17 //l=0.103078 //layer=li \
 //thickness=0.1 //x=52.965 //y=1.77 //x2=52.88 //y2=1.81
r77 (  6 35 ) resistor r=27.3797 //w=0.187 //l=0.4 //layer=li //thickness=0.1 \
 //x=52.965 //y=1.77 //x2=53.365 //y2=1.77
r78 (  5 35 ) resistor r=5.4201 //w=0.17 //l=0.103078 //layer=li \
 //thickness=0.1 //x=53.765 //y=1.77 //x2=53.85 //y2=1.81
r79 (  5 35 ) resistor r=27.3797 //w=0.187 //l=0.4 //layer=li //thickness=0.1 \
 //x=53.765 //y=1.77 //x2=53.365 //y2=1.77
r80 (  1 35 ) resistor r=3.57586 //w=0.17 //l=0.125 //layer=li //thickness=0.1 \
 //x=52.88 //y=1.685 //x2=52.88 //y2=1.81
r81 (  1 35 ) resistor r=42.0963 //w=0.187 //l=0.615 //layer=li \
 //thickness=0.1 //x=52.88 //y=1.685 //x2=52.88 //y2=1.07
ends PM_TMRDFFRNQNX1\%noxref_48

subckt PM_TMRDFFRNQNX1\%noxref_49 ( 1 5 9 13 17 35 )
c58 ( 35 0 ) capacitor c=0.0690827f //x=57.555 //y=0.555
c59 ( 17 0 ) capacitor c=0.0190016f //x=59.545 //y=1.77
c60 ( 13 0 ) capacitor c=0.015325f //x=59.545 //y=0.72
c61 ( 9 0 ) capacitor c=0.00772076f //x=58.66 //y=0.805
c62 ( 5 0 ) capacitor c=0.0168501f //x=58.575 //y=1.77
c63 ( 1 0 ) capacitor c=0.00710458f //x=57.69 //y=1.685
r64 (  18 35 ) resistor r=5.4201 //w=0.17 //l=0.103078 //layer=li \
 //thickness=0.1 //x=58.745 //y=1.77 //x2=58.66 //y2=1.81
r65 (  18 35 ) resistor r=27.3797 //w=0.187 //l=0.4 //layer=li //thickness=0.1 \
 //x=58.745 //y=1.77 //x2=59.145 //y2=1.77
r66 (  17 35 ) resistor r=0.751729 //w=0.17 //l=0.085 //layer=li \
 //thickness=0.1 //x=59.545 //y=1.77 //x2=59.63 //y2=1.77
r67 (  17 35 ) resistor r=27.3797 //w=0.187 //l=0.4 //layer=li //thickness=0.1 \
 //x=59.545 //y=1.77 //x2=59.145 //y2=1.77
r68 (  14 35 ) resistor r=3.57586 //w=0.17 //l=0.103078 //layer=li \
 //thickness=0.1 //x=58.745 //y=0.72 //x2=58.66 //y2=0.68
r69 (  14 35 ) resistor r=27.3797 //w=0.187 //l=0.4 //layer=li //thickness=0.1 \
 //x=58.745 //y=0.72 //x2=59.145 //y2=0.72
r70 (  13 35 ) resistor r=0.751729 //w=0.17 //l=0.085 //layer=li \
 //thickness=0.1 //x=59.545 //y=0.72 //x2=59.63 //y2=0.72
r71 (  13 35 ) resistor r=27.3797 //w=0.187 //l=0.4 //layer=li //thickness=0.1 \
 //x=59.545 //y=0.72 //x2=59.145 //y2=0.72
r72 (  10 35 ) resistor r=1.40859 //w=0.34 //l=0.125 //layer=li \
 //thickness=0.1 //x=58.66 //y=1.685 //x2=58.66 //y2=1.81
r73 (  10 35 ) resistor r=42.0963 //w=0.187 //l=0.615 //layer=li \
 //thickness=0.1 //x=58.66 //y=1.685 //x2=58.66 //y2=1.07
r74 (  9 35 ) resistor r=3.57586 //w=0.17 //l=0.125 //layer=li //thickness=0.1 \
 //x=58.66 //y=0.805 //x2=58.66 //y2=0.68
r75 (  9 35 ) resistor r=18.139 //w=0.187 //l=0.265 //layer=li //thickness=0.1 \
 //x=58.66 //y=0.805 //x2=58.66 //y2=1.07
r76 (  6 35 ) resistor r=3.57586 //w=0.17 //l=0.103078 //layer=li \
 //thickness=0.1 //x=57.775 //y=1.77 //x2=57.69 //y2=1.81
r77 (  6 35 ) resistor r=27.3797 //w=0.187 //l=0.4 //layer=li //thickness=0.1 \
 //x=57.775 //y=1.77 //x2=58.175 //y2=1.77
r78 (  5 35 ) resistor r=5.4201 //w=0.17 //l=0.103078 //layer=li \
 //thickness=0.1 //x=58.575 //y=1.77 //x2=58.66 //y2=1.81
r79 (  5 35 ) resistor r=27.3797 //w=0.187 //l=0.4 //layer=li //thickness=0.1 \
 //x=58.575 //y=1.77 //x2=58.175 //y2=1.77
r80 (  1 35 ) resistor r=3.57586 //w=0.17 //l=0.125 //layer=li //thickness=0.1 \
 //x=57.69 //y=1.685 //x2=57.69 //y2=1.81
r81 (  1 35 ) resistor r=42.0963 //w=0.187 //l=0.615 //layer=li \
 //thickness=0.1 //x=57.69 //y=1.685 //x2=57.69 //y2=1.07
ends PM_TMRDFFRNQNX1\%noxref_49

subckt PM_TMRDFFRNQNX1\%noxref_50 ( 1 5 9 10 13 17 29 )
c67 ( 29 0 ) capacitor c=0.067062f //x=62.47 //y=0.545
c68 ( 17 0 ) capacitor c=0.00675704f //x=64.545 //y=0.795
c69 ( 13 0 ) capacitor c=0.0156329f //x=64.46 //y=0.71
c70 ( 10 0 ) capacitor c=0.00673372f //x=63.575 //y=1.675
c71 ( 9 0 ) capacitor c=0.00770028f //x=63.575 //y=0.795
c72 ( 5 0 ) capacitor c=0.0179513f //x=63.49 //y=1.76
c73 ( 1 0 ) capacitor c=0.00761099f //x=62.605 //y=1.675
r74 (  17 29 ) resistor r=3.57586 //w=0.17 //l=0.125 //layer=li \
 //thickness=0.1 //x=64.545 //y=0.795 //x2=64.545 //y2=0.67
r75 (  17 29 ) resistor r=18.139 //w=0.187 //l=0.265 //layer=li \
 //thickness=0.1 //x=64.545 //y=0.795 //x2=64.545 //y2=1.06
r76 (  14 29 ) resistor r=3.57586 //w=0.17 //l=0.103078 //layer=li \
 //thickness=0.1 //x=63.66 //y=0.71 //x2=63.575 //y2=0.67
r77 (  14 29 ) resistor r=27.3797 //w=0.187 //l=0.4 //layer=li //thickness=0.1 \
 //x=63.66 //y=0.71 //x2=64.06 //y2=0.71
r78 (  13 29 ) resistor r=3.57586 //w=0.17 //l=0.103078 //layer=li \
 //thickness=0.1 //x=64.46 //y=0.71 //x2=64.545 //y2=0.67
r79 (  13 29 ) resistor r=27.3797 //w=0.187 //l=0.4 //layer=li //thickness=0.1 \
 //x=64.46 //y=0.71 //x2=64.06 //y2=0.71
r80 (  10 29 ) resistor r=3.57586 //w=0.17 //l=0.125 //layer=li \
 //thickness=0.1 //x=63.575 //y=1.675 //x2=63.575 //y2=1.8
r81 (  10 29 ) resistor r=42.0963 //w=0.187 //l=0.615 //layer=li \
 //thickness=0.1 //x=63.575 //y=1.675 //x2=63.575 //y2=1.06
r82 (  9 29 ) resistor r=3.57586 //w=0.17 //l=0.125 //layer=li //thickness=0.1 \
 //x=63.575 //y=0.795 //x2=63.575 //y2=0.67
r83 (  9 29 ) resistor r=18.139 //w=0.187 //l=0.265 //layer=li //thickness=0.1 \
 //x=63.575 //y=0.795 //x2=63.575 //y2=1.06
r84 (  6 29 ) resistor r=3.57586 //w=0.17 //l=0.103078 //layer=li \
 //thickness=0.1 //x=62.69 //y=1.76 //x2=62.605 //y2=1.8
r85 (  6 29 ) resistor r=27.3797 //w=0.187 //l=0.4 //layer=li //thickness=0.1 \
 //x=62.69 //y=1.76 //x2=63.09 //y2=1.76
r86 (  5 29 ) resistor r=3.57586 //w=0.17 //l=0.103078 //layer=li \
 //thickness=0.1 //x=63.49 //y=1.76 //x2=63.575 //y2=1.8
r87 (  5 29 ) resistor r=27.3797 //w=0.187 //l=0.4 //layer=li //thickness=0.1 \
 //x=63.49 //y=1.76 //x2=63.09 //y2=1.76
r88 (  1 29 ) resistor r=3.57586 //w=0.17 //l=0.125 //layer=li //thickness=0.1 \
 //x=62.605 //y=1.675 //x2=62.605 //y2=1.8
r89 (  1 29 ) resistor r=42.0963 //w=0.187 //l=0.615 //layer=li \
 //thickness=0.1 //x=62.605 //y=1.675 //x2=62.605 //y2=1.06
ends PM_TMRDFFRNQNX1\%noxref_50

subckt PM_TMRDFFRNQNX1\%noxref_51 ( 1 5 9 13 17 35 )
c58 ( 35 0 ) capacitor c=0.068832f //x=65.695 //y=0.555
c59 ( 17 0 ) capacitor c=0.0190725f //x=67.685 //y=1.77
c60 ( 13 0 ) capacitor c=0.015325f //x=67.685 //y=0.72
c61 ( 9 0 ) capacitor c=0.00772076f //x=66.8 //y=0.805
c62 ( 5 0 ) capacitor c=0.0168501f //x=66.715 //y=1.77
c63 ( 1 0 ) capacitor c=0.00709556f //x=65.83 //y=1.685
r64 (  18 35 ) resistor r=5.4201 //w=0.17 //l=0.103078 //layer=li \
 //thickness=0.1 //x=66.885 //y=1.77 //x2=66.8 //y2=1.81
r65 (  18 35 ) resistor r=27.3797 //w=0.187 //l=0.4 //layer=li //thickness=0.1 \
 //x=66.885 //y=1.77 //x2=67.285 //y2=1.77
r66 (  17 35 ) resistor r=0.751729 //w=0.17 //l=0.085 //layer=li \
 //thickness=0.1 //x=67.685 //y=1.77 //x2=67.77 //y2=1.77
r67 (  17 35 ) resistor r=27.3797 //w=0.187 //l=0.4 //layer=li //thickness=0.1 \
 //x=67.685 //y=1.77 //x2=67.285 //y2=1.77
r68 (  14 35 ) resistor r=3.57586 //w=0.17 //l=0.103078 //layer=li \
 //thickness=0.1 //x=66.885 //y=0.72 //x2=66.8 //y2=0.68
r69 (  14 35 ) resistor r=27.3797 //w=0.187 //l=0.4 //layer=li //thickness=0.1 \
 //x=66.885 //y=0.72 //x2=67.285 //y2=0.72
r70 (  13 35 ) resistor r=0.751729 //w=0.17 //l=0.085 //layer=li \
 //thickness=0.1 //x=67.685 //y=0.72 //x2=67.77 //y2=0.72
r71 (  13 35 ) resistor r=27.3797 //w=0.187 //l=0.4 //layer=li //thickness=0.1 \
 //x=67.685 //y=0.72 //x2=67.285 //y2=0.72
r72 (  10 35 ) resistor r=1.40859 //w=0.34 //l=0.125 //layer=li \
 //thickness=0.1 //x=66.8 //y=1.685 //x2=66.8 //y2=1.81
r73 (  10 35 ) resistor r=42.0963 //w=0.187 //l=0.615 //layer=li \
 //thickness=0.1 //x=66.8 //y=1.685 //x2=66.8 //y2=1.07
r74 (  9 35 ) resistor r=3.57586 //w=0.17 //l=0.125 //layer=li //thickness=0.1 \
 //x=66.8 //y=0.805 //x2=66.8 //y2=0.68
r75 (  9 35 ) resistor r=18.139 //w=0.187 //l=0.265 //layer=li //thickness=0.1 \
 //x=66.8 //y=0.805 //x2=66.8 //y2=1.07
r76 (  6 35 ) resistor r=3.57586 //w=0.17 //l=0.103078 //layer=li \
 //thickness=0.1 //x=65.915 //y=1.77 //x2=65.83 //y2=1.81
r77 (  6 35 ) resistor r=27.3797 //w=0.187 //l=0.4 //layer=li //thickness=0.1 \
 //x=65.915 //y=1.77 //x2=66.315 //y2=1.77
r78 (  5 35 ) resistor r=5.4201 //w=0.17 //l=0.103078 //layer=li \
 //thickness=0.1 //x=66.715 //y=1.77 //x2=66.8 //y2=1.81
r79 (  5 35 ) resistor r=27.3797 //w=0.187 //l=0.4 //layer=li //thickness=0.1 \
 //x=66.715 //y=1.77 //x2=66.315 //y2=1.77
r80 (  1 35 ) resistor r=3.57586 //w=0.17 //l=0.125 //layer=li //thickness=0.1 \
 //x=65.83 //y=1.685 //x2=65.83 //y2=1.81
r81 (  1 35 ) resistor r=42.0963 //w=0.187 //l=0.615 //layer=li \
 //thickness=0.1 //x=65.83 //y=1.685 //x2=65.83 //y2=1.07
ends PM_TMRDFFRNQNX1\%noxref_51

subckt PM_TMRDFFRNQNX1\%noxref_52 ( 1 5 9 13 17 35 )
c58 ( 35 0 ) capacitor c=0.0695682f //x=70.505 //y=0.555
c59 ( 17 0 ) capacitor c=0.018949f //x=72.495 //y=1.77
c60 ( 13 0 ) capacitor c=0.0153552f //x=72.495 //y=0.72
c61 ( 9 0 ) capacitor c=0.00772076f //x=71.61 //y=0.805
c62 ( 5 0 ) capacitor c=0.0168501f //x=71.525 //y=1.77
c63 ( 1 0 ) capacitor c=0.00710458f //x=70.64 //y=1.685
r64 (  18 35 ) resistor r=5.4201 //w=0.17 //l=0.103078 //layer=li \
 //thickness=0.1 //x=71.695 //y=1.77 //x2=71.61 //y2=1.81
r65 (  18 35 ) resistor r=27.3797 //w=0.187 //l=0.4 //layer=li //thickness=0.1 \
 //x=71.695 //y=1.77 //x2=72.095 //y2=1.77
r66 (  17 35 ) resistor r=0.751729 //w=0.17 //l=0.085 //layer=li \
 //thickness=0.1 //x=72.495 //y=1.77 //x2=72.58 //y2=1.77
r67 (  17 35 ) resistor r=27.3797 //w=0.187 //l=0.4 //layer=li //thickness=0.1 \
 //x=72.495 //y=1.77 //x2=72.095 //y2=1.77
r68 (  14 35 ) resistor r=3.57586 //w=0.17 //l=0.103078 //layer=li \
 //thickness=0.1 //x=71.695 //y=0.72 //x2=71.61 //y2=0.68
r69 (  14 35 ) resistor r=27.3797 //w=0.187 //l=0.4 //layer=li //thickness=0.1 \
 //x=71.695 //y=0.72 //x2=72.095 //y2=0.72
r70 (  13 35 ) resistor r=0.751729 //w=0.17 //l=0.085 //layer=li \
 //thickness=0.1 //x=72.495 //y=0.72 //x2=72.58 //y2=0.72
r71 (  13 35 ) resistor r=27.3797 //w=0.187 //l=0.4 //layer=li //thickness=0.1 \
 //x=72.495 //y=0.72 //x2=72.095 //y2=0.72
r72 (  10 35 ) resistor r=1.40859 //w=0.34 //l=0.125 //layer=li \
 //thickness=0.1 //x=71.61 //y=1.685 //x2=71.61 //y2=1.81
r73 (  10 35 ) resistor r=42.0963 //w=0.187 //l=0.615 //layer=li \
 //thickness=0.1 //x=71.61 //y=1.685 //x2=71.61 //y2=1.07
r74 (  9 35 ) resistor r=3.57586 //w=0.17 //l=0.125 //layer=li //thickness=0.1 \
 //x=71.61 //y=0.805 //x2=71.61 //y2=0.68
r75 (  9 35 ) resistor r=18.139 //w=0.187 //l=0.265 //layer=li //thickness=0.1 \
 //x=71.61 //y=0.805 //x2=71.61 //y2=1.07
r76 (  6 35 ) resistor r=3.57586 //w=0.17 //l=0.103078 //layer=li \
 //thickness=0.1 //x=70.725 //y=1.77 //x2=70.64 //y2=1.81
r77 (  6 35 ) resistor r=27.3797 //w=0.187 //l=0.4 //layer=li //thickness=0.1 \
 //x=70.725 //y=1.77 //x2=71.125 //y2=1.77
r78 (  5 35 ) resistor r=5.4201 //w=0.17 //l=0.103078 //layer=li \
 //thickness=0.1 //x=71.525 //y=1.77 //x2=71.61 //y2=1.81
r79 (  5 35 ) resistor r=27.3797 //w=0.187 //l=0.4 //layer=li //thickness=0.1 \
 //x=71.525 //y=1.77 //x2=71.125 //y2=1.77
r80 (  1 35 ) resistor r=3.57586 //w=0.17 //l=0.125 //layer=li //thickness=0.1 \
 //x=70.64 //y=1.685 //x2=70.64 //y2=1.81
r81 (  1 35 ) resistor r=42.0963 //w=0.187 //l=0.615 //layer=li \
 //thickness=0.1 //x=70.64 //y=1.685 //x2=70.64 //y2=1.07
ends PM_TMRDFFRNQNX1\%noxref_52

subckt PM_TMRDFFRNQNX1\%noxref_53 ( 1 5 9 10 13 17 29 )
c67 ( 29 0 ) capacitor c=0.0672999f //x=75.42 //y=0.545
c68 ( 17 0 ) capacitor c=0.0067865f //x=77.495 //y=0.795
c69 ( 13 0 ) capacitor c=0.0156392f //x=77.41 //y=0.71
c70 ( 10 0 ) capacitor c=0.00705387f //x=76.525 //y=1.675
c71 ( 9 0 ) capacitor c=0.00770028f //x=76.525 //y=0.795
c72 ( 5 0 ) capacitor c=0.0188733f //x=76.44 //y=1.76
c73 ( 1 0 ) capacitor c=0.00799611f //x=75.555 //y=1.675
r74 (  17 29 ) resistor r=3.57586 //w=0.17 //l=0.125 //layer=li \
 //thickness=0.1 //x=77.495 //y=0.795 //x2=77.495 //y2=0.67
r75 (  17 29 ) resistor r=18.139 //w=0.187 //l=0.265 //layer=li \
 //thickness=0.1 //x=77.495 //y=0.795 //x2=77.495 //y2=1.06
r76 (  14 29 ) resistor r=3.57586 //w=0.17 //l=0.103078 //layer=li \
 //thickness=0.1 //x=76.61 //y=0.71 //x2=76.525 //y2=0.67
r77 (  14 29 ) resistor r=27.3797 //w=0.187 //l=0.4 //layer=li //thickness=0.1 \
 //x=76.61 //y=0.71 //x2=77.01 //y2=0.71
r78 (  13 29 ) resistor r=3.57586 //w=0.17 //l=0.103078 //layer=li \
 //thickness=0.1 //x=77.41 //y=0.71 //x2=77.495 //y2=0.67
r79 (  13 29 ) resistor r=27.3797 //w=0.187 //l=0.4 //layer=li //thickness=0.1 \
 //x=77.41 //y=0.71 //x2=77.01 //y2=0.71
r80 (  10 29 ) resistor r=3.57586 //w=0.17 //l=0.125 //layer=li \
 //thickness=0.1 //x=76.525 //y=1.675 //x2=76.525 //y2=1.8
r81 (  10 29 ) resistor r=42.0963 //w=0.187 //l=0.615 //layer=li \
 //thickness=0.1 //x=76.525 //y=1.675 //x2=76.525 //y2=1.06
r82 (  9 29 ) resistor r=3.57586 //w=0.17 //l=0.125 //layer=li //thickness=0.1 \
 //x=76.525 //y=0.795 //x2=76.525 //y2=0.67
r83 (  9 29 ) resistor r=18.139 //w=0.187 //l=0.265 //layer=li //thickness=0.1 \
 //x=76.525 //y=0.795 //x2=76.525 //y2=1.06
r84 (  6 29 ) resistor r=3.57586 //w=0.17 //l=0.103078 //layer=li \
 //thickness=0.1 //x=75.64 //y=1.76 //x2=75.555 //y2=1.8
r85 (  6 29 ) resistor r=27.3797 //w=0.187 //l=0.4 //layer=li //thickness=0.1 \
 //x=75.64 //y=1.76 //x2=76.04 //y2=1.76
r86 (  5 29 ) resistor r=3.57586 //w=0.17 //l=0.103078 //layer=li \
 //thickness=0.1 //x=76.44 //y=1.76 //x2=76.525 //y2=1.8
r87 (  5 29 ) resistor r=27.3797 //w=0.187 //l=0.4 //layer=li //thickness=0.1 \
 //x=76.44 //y=1.76 //x2=76.04 //y2=1.76
r88 (  1 29 ) resistor r=3.57586 //w=0.17 //l=0.125 //layer=li //thickness=0.1 \
 //x=75.555 //y=1.675 //x2=75.555 //y2=1.8
r89 (  1 29 ) resistor r=42.0963 //w=0.187 //l=0.615 //layer=li \
 //thickness=0.1 //x=75.555 //y=1.675 //x2=75.555 //y2=1.06
ends PM_TMRDFFRNQNX1\%noxref_53

subckt PM_TMRDFFRNQNX1\%noxref_54 ( 1 5 9 10 13 17 29 )
c69 ( 29 0 ) capacitor c=0.0769028f //x=78.75 //y=0.545
c70 ( 17 0 ) capacitor c=0.00678917f //x=80.825 //y=0.795
c71 ( 13 0 ) capacitor c=0.0154285f //x=80.74 //y=0.71
c72 ( 10 0 ) capacitor c=0.00780084f //x=79.855 //y=1.675
c73 ( 9 0 ) capacitor c=0.00770028f //x=79.855 //y=0.795
c74 ( 5 0 ) capacitor c=0.0216723f //x=79.77 //y=1.76
c75 ( 1 0 ) capacitor c=0.00464525f //x=78.885 //y=1.675
r76 (  17 29 ) resistor r=3.57586 //w=0.17 //l=0.125 //layer=li \
 //thickness=0.1 //x=80.825 //y=0.795 //x2=80.825 //y2=0.67
r77 (  17 29 ) resistor r=41.4118 //w=0.187 //l=0.605 //layer=li \
 //thickness=0.1 //x=80.825 //y=0.795 //x2=80.825 //y2=1.4
r78 (  14 29 ) resistor r=3.57586 //w=0.17 //l=0.103078 //layer=li \
 //thickness=0.1 //x=79.94 //y=0.71 //x2=79.855 //y2=0.67
r79 (  14 29 ) resistor r=27.0374 //w=0.187 //l=0.395 //layer=li \
 //thickness=0.1 //x=79.94 //y=0.71 //x2=80.335 //y2=0.71
r80 (  13 29 ) resistor r=3.57586 //w=0.17 //l=0.103078 //layer=li \
 //thickness=0.1 //x=80.74 //y=0.71 //x2=80.825 //y2=0.67
r81 (  13 29 ) resistor r=27.7219 //w=0.187 //l=0.405 //layer=li \
 //thickness=0.1 //x=80.74 //y=0.71 //x2=80.335 //y2=0.71
r82 (  10 29 ) resistor r=3.57586 //w=0.17 //l=0.125 //layer=li \
 //thickness=0.1 //x=79.855 //y=1.675 //x2=79.855 //y2=1.8
r83 (  10 29 ) resistor r=42.0963 //w=0.187 //l=0.615 //layer=li \
 //thickness=0.1 //x=79.855 //y=1.675 //x2=79.855 //y2=1.06
r84 (  9 29 ) resistor r=3.57586 //w=0.17 //l=0.125 //layer=li //thickness=0.1 \
 //x=79.855 //y=0.795 //x2=79.855 //y2=0.67
r85 (  9 29 ) resistor r=18.139 //w=0.187 //l=0.265 //layer=li //thickness=0.1 \
 //x=79.855 //y=0.795 //x2=79.855 //y2=1.06
r86 (  6 29 ) resistor r=3.57586 //w=0.17 //l=0.103078 //layer=li \
 //thickness=0.1 //x=78.97 //y=1.76 //x2=78.885 //y2=1.8
r87 (  6 29 ) resistor r=27.3797 //w=0.187 //l=0.4 //layer=li //thickness=0.1 \
 //x=78.97 //y=1.76 //x2=79.37 //y2=1.76
r88 (  5 29 ) resistor r=3.57586 //w=0.17 //l=0.103078 //layer=li \
 //thickness=0.1 //x=79.77 //y=1.76 //x2=79.855 //y2=1.8
r89 (  5 29 ) resistor r=27.3797 //w=0.187 //l=0.4 //layer=li //thickness=0.1 \
 //x=79.77 //y=1.76 //x2=79.37 //y2=1.76
r90 (  1 29 ) resistor r=3.57586 //w=0.17 //l=0.125 //layer=li //thickness=0.1 \
 //x=78.885 //y=1.675 //x2=78.885 //y2=1.8
r91 (  1 29 ) resistor r=42.0963 //w=0.187 //l=0.615 //layer=li \
 //thickness=0.1 //x=78.885 //y=1.675 //x2=78.885 //y2=1.06
ends PM_TMRDFFRNQNX1\%noxref_54

subckt PM_TMRDFFRNQNX1\%noxref_57 ( 1 5 9 10 13 17 29 )
c63 ( 29 0 ) capacitor c=0.07461f //x=82.08 //y=0.545
c64 ( 17 0 ) capacitor c=0.00678917f //x=84.155 //y=0.795
c65 ( 13 0 ) capacitor c=0.0158009f //x=84.07 //y=0.71
c66 ( 10 0 ) capacitor c=0.00903204f //x=83.185 //y=1.675
c67 ( 9 0 ) capacitor c=0.00770028f //x=83.185 //y=0.795
c68 ( 5 0 ) capacitor c=0.0187096f //x=83.1 //y=1.76
c69 ( 1 0 ) capacitor c=0.00881929f //x=82.215 //y=1.675
r70 (  17 29 ) resistor r=3.57586 //w=0.17 //l=0.125 //layer=li \
 //thickness=0.1 //x=84.155 //y=0.795 //x2=84.155 //y2=0.67
r71 (  17 29 ) resistor r=41.4118 //w=0.187 //l=0.605 //layer=li \
 //thickness=0.1 //x=84.155 //y=0.795 //x2=84.155 //y2=1.4
r72 (  14 29 ) resistor r=3.57586 //w=0.17 //l=0.103078 //layer=li \
 //thickness=0.1 //x=83.27 //y=0.71 //x2=83.185 //y2=0.67
r73 (  14 29 ) resistor r=27.3797 //w=0.187 //l=0.4 //layer=li //thickness=0.1 \
 //x=83.27 //y=0.71 //x2=83.67 //y2=0.71
r74 (  13 29 ) resistor r=3.57586 //w=0.17 //l=0.103078 //layer=li \
 //thickness=0.1 //x=84.07 //y=0.71 //x2=84.155 //y2=0.67
r75 (  13 29 ) resistor r=27.3797 //w=0.187 //l=0.4 //layer=li //thickness=0.1 \
 //x=84.07 //y=0.71 //x2=83.67 //y2=0.71
r76 (  10 29 ) resistor r=3.57586 //w=0.17 //l=0.125 //layer=li \
 //thickness=0.1 //x=83.185 //y=1.675 //x2=83.185 //y2=1.8
r77 (  10 29 ) resistor r=42.0963 //w=0.187 //l=0.615 //layer=li \
 //thickness=0.1 //x=83.185 //y=1.675 //x2=83.185 //y2=1.06
r78 (  9 29 ) resistor r=3.57586 //w=0.17 //l=0.125 //layer=li //thickness=0.1 \
 //x=83.185 //y=0.795 //x2=83.185 //y2=0.67
r79 (  9 29 ) resistor r=18.139 //w=0.187 //l=0.265 //layer=li //thickness=0.1 \
 //x=83.185 //y=0.795 //x2=83.185 //y2=1.06
r80 (  6 29 ) resistor r=3.57586 //w=0.17 //l=0.103078 //layer=li \
 //thickness=0.1 //x=82.3 //y=1.76 //x2=82.215 //y2=1.8
r81 (  6 29 ) resistor r=27.3797 //w=0.187 //l=0.4 //layer=li //thickness=0.1 \
 //x=82.3 //y=1.76 //x2=82.7 //y2=1.76
r82 (  5 29 ) resistor r=3.57586 //w=0.17 //l=0.103078 //layer=li \
 //thickness=0.1 //x=83.1 //y=1.76 //x2=83.185 //y2=1.8
r83 (  5 29 ) resistor r=27.3797 //w=0.187 //l=0.4 //layer=li //thickness=0.1 \
 //x=83.1 //y=1.76 //x2=82.7 //y2=1.76
r84 (  1 29 ) resistor r=3.57586 //w=0.17 //l=0.125 //layer=li //thickness=0.1 \
 //x=82.215 //y=1.675 //x2=82.215 //y2=1.8
r85 (  1 29 ) resistor r=42.0963 //w=0.187 //l=0.615 //layer=li \
 //thickness=0.1 //x=82.215 //y=1.675 //x2=82.215 //y2=1.06
ends PM_TMRDFFRNQNX1\%noxref_57

subckt PM_TMRDFFRNQNX1\%noxref_58 ( 1 5 9 10 13 17 29 )
c62 ( 29 0 ) capacitor c=0.0687486f //x=85.41 //y=0.545
c63 ( 17 0 ) capacitor c=0.00709795f //x=87.485 //y=0.795
c64 ( 13 0 ) capacitor c=0.0152565f //x=87.4 //y=0.71
c65 ( 10 0 ) capacitor c=0.0075177f //x=86.515 //y=1.675
c66 ( 9 0 ) capacitor c=0.00770028f //x=86.515 //y=0.795
c67 ( 5 0 ) capacitor c=0.0236235f //x=86.43 //y=1.76
c68 ( 1 0 ) capacitor c=0.00498306f //x=85.545 //y=1.675
r69 (  17 29 ) resistor r=3.57586 //w=0.17 //l=0.125 //layer=li \
 //thickness=0.1 //x=87.485 //y=0.795 //x2=87.485 //y2=0.67
r70 (  17 29 ) resistor r=18.139 //w=0.187 //l=0.265 //layer=li \
 //thickness=0.1 //x=87.485 //y=0.795 //x2=87.485 //y2=1.06
r71 (  14 29 ) resistor r=3.57586 //w=0.17 //l=0.103078 //layer=li \
 //thickness=0.1 //x=86.6 //y=0.71 //x2=86.515 //y2=0.67
r72 (  14 29 ) resistor r=27.3797 //w=0.187 //l=0.4 //layer=li //thickness=0.1 \
 //x=86.6 //y=0.71 //x2=87 //y2=0.71
r73 (  13 29 ) resistor r=3.57586 //w=0.17 //l=0.103078 //layer=li \
 //thickness=0.1 //x=87.4 //y=0.71 //x2=87.485 //y2=0.67
r74 (  13 29 ) resistor r=27.3797 //w=0.187 //l=0.4 //layer=li //thickness=0.1 \
 //x=87.4 //y=0.71 //x2=87 //y2=0.71
r75 (  10 29 ) resistor r=3.57586 //w=0.17 //l=0.125 //layer=li \
 //thickness=0.1 //x=86.515 //y=1.675 //x2=86.515 //y2=1.8
r76 (  10 29 ) resistor r=42.0963 //w=0.187 //l=0.615 //layer=li \
 //thickness=0.1 //x=86.515 //y=1.675 //x2=86.515 //y2=1.06
r77 (  9 29 ) resistor r=3.57586 //w=0.17 //l=0.125 //layer=li //thickness=0.1 \
 //x=86.515 //y=0.795 //x2=86.515 //y2=0.67
r78 (  9 29 ) resistor r=18.139 //w=0.187 //l=0.265 //layer=li //thickness=0.1 \
 //x=86.515 //y=0.795 //x2=86.515 //y2=1.06
r79 (  6 29 ) resistor r=3.57586 //w=0.17 //l=0.103078 //layer=li \
 //thickness=0.1 //x=85.63 //y=1.76 //x2=85.545 //y2=1.8
r80 (  6 29 ) resistor r=27.3797 //w=0.187 //l=0.4 //layer=li //thickness=0.1 \
 //x=85.63 //y=1.76 //x2=86.03 //y2=1.76
r81 (  5 29 ) resistor r=3.57586 //w=0.17 //l=0.103078 //layer=li \
 //thickness=0.1 //x=86.43 //y=1.76 //x2=86.515 //y2=1.8
r82 (  5 29 ) resistor r=27.3797 //w=0.187 //l=0.4 //layer=li //thickness=0.1 \
 //x=86.43 //y=1.76 //x2=86.03 //y2=1.76
r83 (  1 29 ) resistor r=3.57586 //w=0.17 //l=0.125 //layer=li //thickness=0.1 \
 //x=85.545 //y=1.675 //x2=85.545 //y2=1.8
r84 (  1 29 ) resistor r=42.0963 //w=0.187 //l=0.615 //layer=li \
 //thickness=0.1 //x=85.545 //y=1.675 //x2=85.545 //y2=1.06
ends PM_TMRDFFRNQNX1\%noxref_58
