// File: nand2x1_pcell.spi.pex
// Created: Thu Jan 22 07:14:06 2026
// Program "Calibre xRC"
// Version "v2023.2_27.15"
// Nominal Temperature: 30C
// Circuit Temperature: 30C
//
simulator lang=spectre
subckt PM_NAND2X1_PCELL\%noxref_1 ( 7 23 31 46 49 50 51 52 )
c55 ( 52 0 ) capacitor c=0.039252f //x=2.405 //y=5.02
c56 ( 51 0 ) capacitor c=0.0248171f //x=1.525 //y=5.02
c57 ( 50 0 ) capacitor c=0.0678368f //x=0.655 //y=5.02
c58 ( 49 0 ) capacitor c=0.249726f //x=2.59 //y=7.4
c59 ( 47 0 ) capacitor c=0.00591168f //x=1.67 //y=7.4
c60 ( 46 0 ) capacitor c=0.253193f //x=0.74 //y=7.4
c61 ( 31 0 ) capacitor c=0.0284687f //x=2.465 //y=7.4
c62 ( 23 0 ) capacitor c=0.0288404f //x=1.585 //y=7.4
c63 ( 7 0 ) capacitor c=0.150501f //x=2.59 //y=7.4
r64 (  35 49 ) resistor r=4.11603 //w=0.68 //l=0.17 //layer=li //thickness=0.1 \
 //x=2.55 //y=7.23 //x2=2.55 //y2=7.4
r65 (  35 52 ) resistor r=33.1979 //w=0.187 //l=0.485 //layer=li \
 //thickness=0.1 //x=2.55 //y=7.23 //x2=2.55 //y2=6.745
r66 (  32 47 ) resistor r=2.94794 //w=0.34 //l=0.085 //layer=li \
 //thickness=0.1 //x=1.755 //y=7.4 //x2=1.67 //y2=7.4
r67 (  32 34 ) resistor r=3.40616 //w=0.357 //l=0.095 //layer=li \
 //thickness=0.1 //x=1.755 //y=7.4 //x2=1.85 //y2=7.4
r68 (  31 49 ) resistor r=2.94794 //w=0.34 //l=0.085 //layer=li \
 //thickness=0.1 //x=2.465 //y=7.4 //x2=2.55 //y2=7.4
r69 (  31 34 ) resistor r=22.0504 //w=0.357 //l=0.615 //layer=li \
 //thickness=0.1 //x=2.465 //y=7.4 //x2=1.85 //y2=7.4
r70 (  25 47 ) resistor r=4.11603 //w=0.68 //l=0.17 //layer=li //thickness=0.1 \
 //x=1.67 //y=7.23 //x2=1.67 //y2=7.4
r71 (  25 51 ) resistor r=33.1979 //w=0.187 //l=0.485 //layer=li \
 //thickness=0.1 //x=1.67 //y=7.23 //x2=1.67 //y2=6.745
r72 (  24 46 ) resistor r=2.94794 //w=0.34 //l=0.085 //layer=li \
 //thickness=0.1 //x=0.875 //y=7.4 //x2=0.79 //y2=7.4
r73 (  23 47 ) resistor r=2.94794 //w=0.34 //l=0.085 //layer=li \
 //thickness=0.1 //x=1.585 //y=7.4 //x2=1.67 //y2=7.4
r74 (  23 24 ) resistor r=25.4566 //w=0.357 //l=0.71 //layer=li \
 //thickness=0.1 //x=1.585 //y=7.4 //x2=0.875 //y2=7.4
r75 (  15 46 ) resistor r=4.11603 //w=0.68 //l=0.17 //layer=li //thickness=0.1 \
 //x=0.79 //y=7.23 //x2=0.79 //y2=7.4
r76 (  15 50 ) resistor r=56.4706 //w=0.187 //l=0.825 //layer=li \
 //thickness=0.1 //x=0.79 //y=7.23 //x2=0.79 //y2=6.405
r77 (  7 49 ) resistor r=4.65 //w=0.17 //l=0.34 //layer=mcon //count=2 \
 //x=2.59 //y=7.4 //x2=2.59 //y2=7.4
r78 (  5 34 ) resistor r=3.1 //w=0.17 //l=0.51 //layer=mcon //count=3 //x=1.85 \
 //y=7.4 //x2=1.85 //y2=7.4
r79 (  5 7 ) resistor r=0.307309 //w=0.301 //l=0.74 //layer=m1 \
 //thickness=0.36 //x=1.85 //y=7.4 //x2=2.59 //y2=7.4
r80 (  2 46 ) resistor r=3.1 //w=0.17 //l=0.51 //layer=mcon //count=3 //x=0.74 \
 //y=7.4 //x2=0.74 //y2=7.4
r81 (  2 5 ) resistor r=0.460963 //w=0.301 //l=1.11 //layer=m1 \
 //thickness=0.36 //x=0.74 //y=7.4 //x2=1.85 //y2=7.4
ends PM_NAND2X1_PCELL\%noxref_1

subckt PM_NAND2X1_PCELL\%noxref_2 ( 4 7 8 11 16 20 21 22 23 24 25 26 30 32 35 \
 36 46 )
c80 ( 46 0 ) capacitor c=0.0682508f //x=1.11 //y=4.7
c81 ( 36 0 ) capacitor c=0.0318956f //x=1.445 //y=1.21
c82 ( 35 0 ) capacitor c=0.0186809f //x=1.445 //y=0.865
c83 ( 32 0 ) capacitor c=0.0141821f //x=1.29 //y=1.365
c84 ( 30 0 ) capacitor c=0.0158553f //x=1.29 //y=0.71
c85 ( 26 0 ) capacitor c=0.088055f //x=0.915 //y=1.915
c86 ( 25 0 ) capacitor c=0.0229235f //x=0.915 //y=1.52
c87 ( 24 0 ) capacitor c=0.0234359f //x=0.915 //y=1.21
c88 ( 23 0 ) capacitor c=0.0198759f //x=0.915 //y=0.865
c89 ( 22 0 ) capacitor c=0.110369f //x=1.45 //y=6.02
c90 ( 21 0 ) capacitor c=0.154619f //x=1.01 //y=6.02
c91 ( 16 0 ) capacitor c=8.13451e-19 //x=1.11 //y=4.7
c92 ( 11 0 ) capacitor c=7.85889e-19 //x=1.11 //y=2.08
c93 ( 8 0 ) capacitor c=0.107896f //x=1.112 //y=4.56
c94 ( 7 0 ) capacitor c=0.0113945f //x=1.11 //y=4.7
c95 ( 4 0 ) capacitor c=0.0108617f //x=1.11 //y=2.08
r96 (  44 46 ) resistor r=20.6867 //w=0.233 //l=0.1 //layer=ply \
 //thickness=0.18 //x=1.01 //y=4.7 //x2=1.11 //y2=4.7
r97 (  37 46 ) resistor r=70.3348 //w=0.233 //l=0.414367 //layer=ply \
 //thickness=0.18 //x=1.45 //y=4.865 //x2=1.11 //y2=4.7
r98 (  36 48 ) resistor r=45.1352 //w=0.168 //l=0.173853 //layer=ply \
 //thickness=0.18 //x=1.445 //y=1.21 //x2=1.405 //y2=1.365
r99 (  35 47 ) resistor r=45.1352 //w=0.168 //l=0.173853 //layer=ply \
 //thickness=0.18 //x=1.445 //y=0.865 //x2=1.405 //y2=0.71
r100 (  35 36 ) resistor r=176.904 //w=0.094 //l=0.345 //layer=ply \
 //thickness=0.18 //x=1.445 //y=0.865 //x2=1.445 //y2=1.21
r101 (  33 43 ) resistor r=10.701 //w=0.21 //l=0.115 //layer=ply \
 //thickness=0.18 //x=1.07 //y=1.365 //x2=0.955 //y2=1.365
r102 (  32 48 ) resistor r=5.52526 //w=0.168 //l=0.115 //layer=ply \
 //thickness=0.18 //x=1.29 //y=1.365 //x2=1.405 //y2=1.365
r103 (  31 42 ) resistor r=5.52526 //w=0.168 //l=0.115 //layer=ply \
 //thickness=0.18 //x=1.07 //y=0.71 //x2=0.955 //y2=0.71
r104 (  30 47 ) resistor r=5.52526 //w=0.168 //l=0.115 //layer=ply \
 //thickness=0.18 //x=1.29 //y=0.71 //x2=1.405 //y2=0.71
r105 (  30 31 ) resistor r=112.809 //w=0.094 //l=0.22 //layer=ply \
 //thickness=0.18 //x=1.29 //y=0.71 //x2=1.07 //y2=0.71
r106 (  27 44 ) resistor r=13.0941 //w=0.233 //l=0.165 //layer=ply \
 //thickness=0.18 //x=1.01 //y=4.865 //x2=1.01 //y2=4.7
r107 (  26 41 ) resistor r=34.8111 //w=0.27 //l=0.264953 //layer=ply \
 //thickness=0.18 //x=0.915 //y=1.915 //x2=1.11 //y2=2.08
r108 (  25 43 ) resistor r=39.5823 //w=0.21 //l=0.173853 //layer=ply \
 //thickness=0.18 //x=0.915 //y=1.52 //x2=0.955 //y2=1.365
r109 (  25 26 ) resistor r=202.543 //w=0.094 //l=0.395 //layer=ply \
 //thickness=0.18 //x=0.915 //y=1.52 //x2=0.915 //y2=1.915
r110 (  24 43 ) resistor r=39.5823 //w=0.21 //l=0.173853 //layer=ply \
 //thickness=0.18 //x=0.915 //y=1.21 //x2=0.955 //y2=1.365
r111 (  23 42 ) resistor r=45.1352 //w=0.168 //l=0.173853 //layer=ply \
 //thickness=0.18 //x=0.915 //y=0.865 //x2=0.955 //y2=0.71
r112 (  23 24 ) resistor r=176.904 //w=0.094 //l=0.345 //layer=ply \
 //thickness=0.18 //x=0.915 //y=0.865 //x2=0.915 //y2=1.21
r113 (  22 37 ) resistor r=592.245 //w=0.094 //l=1.155 //layer=ply \
 //thickness=0.18 //x=1.45 //y=6.02 //x2=1.45 //y2=4.865
r114 (  21 27 ) resistor r=592.245 //w=0.094 //l=1.155 //layer=ply \
 //thickness=0.18 //x=1.01 //y=6.02 //x2=1.01 //y2=4.865
r115 (  20 32 ) resistor r=56.4043 //w=0.094 //l=0.11 //layer=ply \
 //thickness=0.18 //x=1.18 //y=1.365 //x2=1.29 //y2=1.365
r116 (  20 33 ) resistor r=56.4043 //w=0.094 //l=0.11 //layer=ply \
 //thickness=0.18 //x=1.18 //y=1.365 //x2=1.07 //y2=1.365
r117 (  16 46 ) resistor r=152 //w=0.17 //l=0.17 //layer=licon //count=1 \
 //x=1.11 //y=4.7 //x2=1.11 //y2=4.7
r118 (  11 41 ) resistor r=152 //w=0.17 //l=0.17 //layer=licon //count=1 \
 //x=1.11 //y=2.08 //x2=1.11 //y2=2.08
r119 (  7 16 ) resistor r=9.3 //w=0.17 //l=0.17 //layer=mcon //count=1 \
 //x=1.11 //y=4.7 //x2=1.11 //y2=4.7
r120 (  7 8 ) resistor r=0.103207 //w=0.196 //l=0.14 //layer=m1 \
 //thickness=0.36 //x=1.112 //y=4.7 //x2=1.112 //y2=4.56
r121 (  4 11 ) resistor r=9.3 //w=0.17 //l=0.17 //layer=mcon //count=1 \
 //x=1.11 //y=2.08 //x2=1.11 //y2=2.08
r122 (  1 4 ) resistor r=0.0933015 //w=0.201 //l=0.125 //layer=m1 \
 //thickness=0.36 //x=1.11 //y=2.205 //x2=1.11 //y2=2.08
r123 (  1 8 ) resistor r=2.24714 //w=0.131 //l=2.355 //layer=m1 \
 //thickness=0.36 //x=1.11 //y=2.205 //x2=1.11 //y2=4.56
ends PM_NAND2X1_PCELL\%noxref_2

subckt PM_NAND2X1_PCELL\%noxref_4 ( 2 4 10 15 19 20 21 22 23 24 29 31 33 39 40 \
 42 43 46 )
c96 ( 46 0 ) capacitor c=0.0393541f //x=1.88 //y=4.7
c97 ( 43 0 ) capacitor c=0.0303735f //x=1.85 //y=1.915
c98 ( 42 0 ) capacitor c=0.0476996f //x=1.85 //y=2.08
c99 ( 40 0 ) capacitor c=0.0439708f //x=2.415 //y=1.25
c100 ( 39 0 ) capacitor c=0.0192582f //x=2.415 //y=0.905
c101 ( 33 0 ) capacitor c=0.0162526f //x=2.26 //y=1.405
c102 ( 31 0 ) capacitor c=0.0157807f //x=2.26 //y=0.75
c103 ( 29 0 ) capacitor c=0.0372668f //x=2.255 //y=4.79
c104 ( 24 0 ) capacitor c=0.0210762f //x=1.885 //y=1.56
c105 ( 23 0 ) capacitor c=0.0168511f //x=1.885 //y=1.25
c106 ( 22 0 ) capacitor c=0.0175485f //x=1.885 //y=0.905
c107 ( 21 0 ) capacitor c=0.155269f //x=2.33 //y=6.02
c108 ( 20 0 ) capacitor c=0.110375f //x=1.89 //y=6.02
c109 ( 15 0 ) capacitor c=8.9038e-19 //x=1.88 //y=4.7
c110 ( 10 0 ) capacitor c=7.72439e-19 //x=1.85 //y=2.08
c111 ( 4 0 ) capacitor c=0.00687137f //x=1.85 //y=2.08
c112 ( 2 0 ) capacitor c=0.0657654f //x=1.85 //y=4.555
r113 (  48 49 ) resistor r=32.4568 //w=0.214 //l=0.075 //layer=ply \
 //thickness=0.18 //x=1.88 //y=4.79 //x2=1.88 //y2=4.865
r114 (  46 48 ) resistor r=20.271 //w=0.214 //l=0.09 //layer=ply \
 //thickness=0.18 //x=1.88 //y=4.7 //x2=1.88 //y2=4.79
r115 (  42 43 ) resistor r=52.7279 //w=0.214 //l=0.165 //layer=ply \
 //thickness=0.18 //x=1.85 //y=2.08 //x2=1.85 //y2=1.915
r116 (  40 53 ) resistor r=45.1352 //w=0.168 //l=0.173853 //layer=ply \
 //thickness=0.18 //x=2.415 //y=1.25 //x2=2.375 //y2=1.405
r117 (  39 52 ) resistor r=45.1352 //w=0.168 //l=0.173853 //layer=ply \
 //thickness=0.18 //x=2.415 //y=0.905 //x2=2.375 //y2=0.75
r118 (  39 40 ) resistor r=176.904 //w=0.094 //l=0.345 //layer=ply \
 //thickness=0.18 //x=2.415 //y=0.905 //x2=2.415 //y2=1.25
r119 (  34 51 ) resistor r=10.701 //w=0.21 //l=0.115 //layer=ply \
 //thickness=0.18 //x=2.04 //y=1.405 //x2=1.925 //y2=1.405
r120 (  33 53 ) resistor r=5.52526 //w=0.168 //l=0.115 //layer=ply \
 //thickness=0.18 //x=2.26 //y=1.405 //x2=2.375 //y2=1.405
r121 (  32 50 ) resistor r=5.52526 //w=0.168 //l=0.115 //layer=ply \
 //thickness=0.18 //x=2.04 //y=0.75 //x2=1.925 //y2=0.75
r122 (  31 52 ) resistor r=5.52526 //w=0.168 //l=0.115 //layer=ply \
 //thickness=0.18 //x=2.26 //y=0.75 //x2=2.375 //y2=0.75
r123 (  31 32 ) resistor r=112.809 //w=0.094 //l=0.22 //layer=ply \
 //thickness=0.18 //x=2.26 //y=0.75 //x2=2.04 //y2=0.75
r124 (  30 48 ) resistor r=16.5046 //w=0.27 //l=0.135 //layer=ply \
 //thickness=0.18 //x=2.015 //y=4.79 //x2=1.88 //y2=4.79
r125 (  29 36 ) resistor r=26.9307 //w=0.15 //l=0.106066 //layer=ply \
 //thickness=0.18 //x=2.255 //y=4.79 //x2=2.33 //y2=4.865
r126 (  29 30 ) resistor r=123.064 //w=0.094 //l=0.24 //layer=ply \
 //thickness=0.18 //x=2.255 //y=4.79 //x2=2.015 //y2=4.79
r127 (  24 51 ) resistor r=39.5823 //w=0.21 //l=0.173853 //layer=ply \
 //thickness=0.18 //x=1.885 //y=1.56 //x2=1.925 //y2=1.405
r128 (  24 43 ) resistor r=182.032 //w=0.094 //l=0.355 //layer=ply \
 //thickness=0.18 //x=1.885 //y=1.56 //x2=1.885 //y2=1.915
r129 (  23 51 ) resistor r=39.5823 //w=0.21 //l=0.173853 //layer=ply \
 //thickness=0.18 //x=1.885 //y=1.25 //x2=1.925 //y2=1.405
r130 (  22 50 ) resistor r=45.1352 //w=0.168 //l=0.173853 //layer=ply \
 //thickness=0.18 //x=1.885 //y=0.905 //x2=1.925 //y2=0.75
r131 (  22 23 ) resistor r=176.904 //w=0.094 //l=0.345 //layer=ply \
 //thickness=0.18 //x=1.885 //y=0.905 //x2=1.885 //y2=1.25
r132 (  21 36 ) resistor r=592.245 //w=0.094 //l=1.155 //layer=ply \
 //thickness=0.18 //x=2.33 //y=6.02 //x2=2.33 //y2=4.865
r133 (  20 49 ) resistor r=592.245 //w=0.094 //l=1.155 //layer=ply \
 //thickness=0.18 //x=1.89 //y=6.02 //x2=1.89 //y2=4.865
r134 (  19 33 ) resistor r=56.4043 //w=0.094 //l=0.11 //layer=ply \
 //thickness=0.18 //x=2.15 //y=1.405 //x2=2.26 //y2=1.405
r135 (  19 34 ) resistor r=56.4043 //w=0.094 //l=0.11 //layer=ply \
 //thickness=0.18 //x=2.15 //y=1.405 //x2=2.04 //y2=1.405
r136 (  15 46 ) resistor r=152 //w=0.17 //l=0.17 //layer=licon //count=1 \
 //x=1.88 //y=4.7 //x2=1.88 //y2=4.7
r137 (  10 42 ) resistor r=152 //w=0.17 //l=0.17 //layer=licon //count=1 \
 //x=1.85 //y=2.08 //x2=1.85 //y2=2.08
r138 (  8 15 ) resistor r=9.3 //w=0.17 //l=0.17 //layer=mcon //count=1 \
 //x=1.88 //y=4.7 //x2=1.88 //y2=4.7
r139 (  4 10 ) resistor r=9.3 //w=0.17 //l=0.17 //layer=mcon //count=1 \
 //x=1.85 //y=2.08 //x2=1.85 //y2=2.08
r140 (  4 6 ) resistor r=0.0936408 //w=0.196 //l=0.125 //layer=m1 \
 //thickness=0.36 //x=1.852 //y=2.08 //x2=1.852 //y2=2.205
r141 (  2 8 ) resistor r=0.0878548 //w=0.228 //l=0.159295 //layer=m1 \
 //thickness=0.36 //x=1.85 //y=4.555 //x2=1.88 //y2=4.7
r142 (  2 6 ) resistor r=2.24237 //w=0.131 //l=2.35 //layer=m1 \
 //thickness=0.36 //x=1.85 //y=4.555 //x2=1.85 //y2=2.205
ends PM_NAND2X1_PCELL\%noxref_4

subckt PM_NAND2X1_PCELL\%noxref_5 ( 3 8 9 11 12 14 17 18 21 23 26 34 46 48 49 )
c98 ( 46 0 ) capacitor c=0.00878249f //x=1.96 //y=0.905
c99 ( 34 0 ) capacitor c=0.0326476f //x=2.11 //y=5.38
c100 ( 26 0 ) capacitor c=0.0292415f //x=1.23 //y=5.38
c101 ( 23 0 ) capacitor c=0.0150842f //x=2.15 //y=1
c102 ( 21 0 ) capacitor c=6.70882e-19 //x=2.11 //y=5.38
c103 ( 18 0 ) capacitor c=0.0159641f //x=2.11 //y=5.2
c104 ( 17 0 ) capacitor c=0.0104284f //x=1.23 //y=5.38
c105 ( 14 0 ) capacitor c=0.135879f //x=2.59 //y=5.115
c106 ( 12 0 ) capacitor c=0.00837358f //x=2.235 //y=1.655
c107 ( 11 0 ) capacitor c=0.0165738f //x=2.505 //y=1.655
c108 ( 9 0 ) capacitor c=0.0143926f //x=2.505 //y=5.2
c109 ( 8 0 ) capacitor c=0.0167748f //x=2.15 //y=1.57
c110 ( 3 0 ) capacitor c=0.019362f //x=1.995 //y=5.2
r111 (  34 49 ) resistor r=23.615 //w=0.187 //l=0.345 //layer=li \
 //thickness=0.1 //x=2.11 //y=5.38 //x2=2.11 //y2=5.725
r112 (  26 48 ) resistor r=23.615 //w=0.187 //l=0.345 //layer=li \
 //thickness=0.1 //x=1.23 //y=5.38 //x2=1.23 //y2=5.725
r113 (  23 46 ) resistor r=9.3 //w=0.17 //l=0.17 //layer=mcon //count=1 \
 //x=2.15 //y=1 //x2=2.15 //y2=1
r114 (  21 34 ) resistor r=9.3 //w=0.17 //l=0.17 //layer=mcon //count=1 \
 //x=2.11 //y=5.38 //x2=2.11 //y2=5.38
r115 (  18 21 ) resistor r=0.117801 //w=0.191 //l=0.18 //layer=m1 \
 //thickness=0.36 //x=2.11 //y=5.2 //x2=2.11 //y2=5.38
r116 (  17 26 ) resistor r=9.3 //w=0.17 //l=0.17 //layer=mcon //count=1 \
 //x=1.23 //y=5.38 //x2=1.23 //y2=5.38
r117 (  15 17 ) resistor r=0.10274 //w=0.219 //l=0.18 //layer=m1 \
 //thickness=0.36 //x=1.23 //y=5.2 //x2=1.23 //y2=5.38
r118 (  13 14 ) resistor r=3.22042 //w=0.131 //l=3.375 //layer=m1 \
 //thickness=0.36 //x=2.59 //y=1.74 //x2=2.59 //y2=5.115
r119 (  11 13 ) resistor r=0.0698411 //w=0.17 //l=0.120208 //layer=m1 \
 //thickness=0.36 //x=2.505 //y=1.655 //x2=2.59 //y2=1.74
r120 (  11 12 ) resistor r=0.257634 //w=0.131 //l=0.27 //layer=m1 \
 //thickness=0.36 //x=2.505 //y=1.655 //x2=2.235 //y2=1.655
r121 (  10 18 ) resistor r=0.0257089 //w=0.23 //l=0.115 //layer=m1 \
 //thickness=0.36 //x=2.225 //y=5.2 //x2=2.11 //y2=5.2
r122 (  9 14 ) resistor r=0.0698411 //w=0.17 //l=0.120208 //layer=m1 \
 //thickness=0.36 //x=2.505 //y=5.2 //x2=2.59 //y2=5.115
r123 (  9 10 ) resistor r=0.267176 //w=0.131 //l=0.28 //layer=m1 \
 //thickness=0.36 //x=2.505 //y=5.2 //x2=2.225 //y2=5.2
r124 (  8 12 ) resistor r=0.0698411 //w=0.17 //l=0.120208 //layer=m1 \
 //thickness=0.36 //x=2.15 //y=1.57 //x2=2.235 //y2=1.655
r125 (  7 23 ) resistor r=0.0913624 //w=0.191 //l=0.12 //layer=m1 \
 //thickness=0.36 //x=2.15 //y=1.12 //x2=2.15 //y2=1
r126 (  7 8 ) resistor r=0.429389 //w=0.131 //l=0.45 //layer=m1 \
 //thickness=0.36 //x=2.15 //y=1.12 //x2=2.15 //y2=1.57
r127 (  4 15 ) resistor r=0.0227762 //w=0.219 //l=0.115 //layer=m1 \
 //thickness=0.36 //x=1.345 //y=5.2 //x2=1.23 //y2=5.2
r128 (  3 18 ) resistor r=0.0257089 //w=0.23 //l=0.115 //layer=m1 \
 //thickness=0.36 //x=1.995 //y=5.2 //x2=2.11 //y2=5.2
r129 (  3 4 ) resistor r=0.620229 //w=0.131 //l=0.65 //layer=m1 \
 //thickness=0.36 //x=1.995 //y=5.2 //x2=1.345 //y2=5.2
ends PM_NAND2X1_PCELL\%noxref_5

subckt PM_NAND2X1_PCELL\%noxref_6 ( 1 5 9 10 13 17 29 )
c36 ( 29 0 ) capacitor c=0.0692238f //x=0.56 //y=0.365
c37 ( 17 0 ) capacitor c=0.00709791f //x=2.635 //y=0.615
c38 ( 13 0 ) capacitor c=0.0157877f //x=2.55 //y=0.53
c39 ( 10 0 ) capacitor c=0.00955329f //x=1.665 //y=1.495
c40 ( 9 0 ) capacitor c=0.00770028f //x=1.665 //y=0.615
c41 ( 5 0 ) capacitor c=0.024493f //x=1.58 //y=1.58
c42 ( 1 0 ) capacitor c=0.011504f //x=0.695 //y=1.495
r43 (  17 29 ) resistor r=3.57586 //w=0.17 //l=0.125 //layer=li \
 //thickness=0.1 //x=2.635 //y=0.615 //x2=2.635 //y2=0.49
r44 (  17 29 ) resistor r=18.139 //w=0.187 //l=0.265 //layer=li \
 //thickness=0.1 //x=2.635 //y=0.615 //x2=2.635 //y2=0.88
r45 (  14 29 ) resistor r=3.57586 //w=0.17 //l=0.103078 //layer=li \
 //thickness=0.1 //x=1.75 //y=0.53 //x2=1.665 //y2=0.49
r46 (  14 29 ) resistor r=27.3797 //w=0.187 //l=0.4 //layer=li //thickness=0.1 \
 //x=1.75 //y=0.53 //x2=2.15 //y2=0.53
r47 (  13 29 ) resistor r=3.57586 //w=0.17 //l=0.103078 //layer=li \
 //thickness=0.1 //x=2.55 //y=0.53 //x2=2.635 //y2=0.49
r48 (  13 29 ) resistor r=27.3797 //w=0.187 //l=0.4 //layer=li //thickness=0.1 \
 //x=2.55 //y=0.53 //x2=2.15 //y2=0.53
r49 (  10 29 ) resistor r=3.57586 //w=0.17 //l=0.125 //layer=li \
 //thickness=0.1 //x=1.665 //y=1.495 //x2=1.665 //y2=1.62
r50 (  10 29 ) resistor r=42.0963 //w=0.187 //l=0.615 //layer=li \
 //thickness=0.1 //x=1.665 //y=1.495 //x2=1.665 //y2=0.88
r51 (  9 29 ) resistor r=3.57586 //w=0.17 //l=0.125 //layer=li //thickness=0.1 \
 //x=1.665 //y=0.615 //x2=1.665 //y2=0.49
r52 (  9 29 ) resistor r=18.139 //w=0.187 //l=0.265 //layer=li //thickness=0.1 \
 //x=1.665 //y=0.615 //x2=1.665 //y2=0.88
r53 (  6 29 ) resistor r=3.57586 //w=0.17 //l=0.103078 //layer=li \
 //thickness=0.1 //x=0.78 //y=1.58 //x2=0.695 //y2=1.62
r54 (  6 29 ) resistor r=27.3797 //w=0.187 //l=0.4 //layer=li //thickness=0.1 \
 //x=0.78 //y=1.58 //x2=1.18 //y2=1.58
r55 (  5 29 ) resistor r=3.57586 //w=0.17 //l=0.103078 //layer=li \
 //thickness=0.1 //x=1.58 //y=1.58 //x2=1.665 //y2=1.62
r56 (  5 29 ) resistor r=27.3797 //w=0.187 //l=0.4 //layer=li //thickness=0.1 \
 //x=1.58 //y=1.58 //x2=1.18 //y2=1.58
r57 (  1 29 ) resistor r=3.57586 //w=0.17 //l=0.125 //layer=li //thickness=0.1 \
 //x=0.695 //y=1.495 //x2=0.695 //y2=1.62
r58 (  1 29 ) resistor r=42.0963 //w=0.187 //l=0.615 //layer=li \
 //thickness=0.1 //x=0.695 //y=1.495 //x2=0.695 //y2=0.88
ends PM_NAND2X1_PCELL\%noxref_6
