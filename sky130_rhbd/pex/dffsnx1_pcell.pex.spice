// File: dffsnx1_pcell.spi.pex
// Created: Sun Mar 15 12:49:13 2026
// Program "Calibre xRC"
// Version "v2023.2_27.15"
// Nominal Temperature: 30C
// Circuit Temperature: 30C
//
simulator lang=spectre
subckt PM_DFFSNX1_PCELL\%noxref_1 ( 3 8 9 11 12 14 15 16 17 18 19 20 21 22 23 \
 24 27 28 31 33 36 43 47 54 55 57 64 65 68 76 93 102 107 116 120 121 122 123 \
 124 125 126 127 128 129 130 132 138 139 140 141 145 146 147 148 149 151 157 \
 158 159 160 180 182 183 )
c394 ( 180 0 ) capacitor c=0.00878249f //x=1.96 //y=0.905
c395 ( 160 0 ) capacitor c=0.0612936f //x=9.525 //y=4.79
c396 ( 159 0 ) capacitor c=0.0376642f //x=9.815 //y=4.79
c397 ( 158 0 ) capacitor c=0.0346489f //x=9.48 //y=1.22
c398 ( 157 0 ) capacitor c=0.018692f //x=9.48 //y=0.875
c399 ( 151 0 ) capacitor c=0.0137077f //x=9.325 //y=1.375
c400 ( 149 0 ) capacitor c=0.0158585f //x=9.325 //y=0.72
c401 ( 148 0 ) capacitor c=0.0979511f //x=8.95 //y=1.915
c402 ( 147 0 ) capacitor c=0.0229444f //x=8.95 //y=1.53
c403 ( 146 0 ) capacitor c=0.0234359f //x=8.95 //y=1.22
c404 ( 145 0 ) capacitor c=0.019815f //x=8.95 //y=0.875
c405 ( 141 0 ) capacitor c=0.0612936f //x=4.715 //y=4.79
c406 ( 140 0 ) capacitor c=0.0376642f //x=5.005 //y=4.79
c407 ( 139 0 ) capacitor c=0.0346489f //x=4.67 //y=1.22
c408 ( 138 0 ) capacitor c=0.018692f //x=4.67 //y=0.875
c409 ( 132 0 ) capacitor c=0.0137077f //x=4.515 //y=1.375
c410 ( 130 0 ) capacitor c=0.0158585f //x=4.515 //y=0.72
c411 ( 129 0 ) capacitor c=0.099553f //x=4.14 //y=1.915
c412 ( 128 0 ) capacitor c=0.0229444f //x=4.14 //y=1.53
c413 ( 127 0 ) capacitor c=0.0234359f //x=4.14 //y=1.22
c414 ( 126 0 ) capacitor c=0.019815f //x=4.14 //y=0.875
c415 ( 125 0 ) capacitor c=0.110208f //x=9.89 //y=6.02
c416 ( 124 0 ) capacitor c=0.158957f //x=9.45 //y=6.02
c417 ( 123 0 ) capacitor c=0.110208f //x=5.08 //y=6.02
c418 ( 122 0 ) capacitor c=0.158957f //x=4.64 //y=6.02
c419 ( 116 0 ) capacitor c=0.0014751f //x=9.25 //y=4.7
c420 ( 107 0 ) capacitor c=9.93222e-19 //x=9.25 //y=2.08
c421 ( 102 0 ) capacitor c=0.0014751f //x=4.44 //y=4.7
c422 ( 93 0 ) capacitor c=9.93222e-19 //x=4.44 //y=2.08
c423 ( 76 0 ) capacitor c=0.0322017f //x=2.11 //y=5.38
c424 ( 68 0 ) capacitor c=0.0292415f //x=1.23 //y=5.38
c425 ( 65 0 ) capacitor c=0.130893f //x=9.09 //y=2.595
c426 ( 64 0 ) capacitor c=0.00261551f //x=9.25 //y=2.595
c427 ( 57 0 ) capacitor c=0.00271088f //x=4.6 //y=2.59
c428 ( 55 0 ) capacitor c=0.00330852f //x=2.75 //y=2.59
c429 ( 54 0 ) capacitor c=0.0532299f //x=4.28 //y=2.59
c430 ( 47 0 ) capacitor c=0.0154699f //x=9.25 //y=2.59
c431 ( 43 0 ) capacitor c=0.0146914f //x=4.44 //y=2.585
c432 ( 36 0 ) capacitor c=0.0146635f //x=2.59 //y=2.59
c433 ( 33 0 ) capacitor c=0.0116755f //x=2.15 //y=1
c434 ( 31 0 ) capacitor c=5.78613e-19 //x=2.11 //y=5.38
c435 ( 28 0 ) capacitor c=0.0112565f //x=2.11 //y=5.2
c436 ( 27 0 ) capacitor c=0.0105186f //x=1.23 //y=5.38
c437 ( 24 0 ) capacitor c=0.0681751f //x=9.25 //y=4.575
c438 ( 23 0 ) capacitor c=0.0130542f //x=9.25 //y=2.755
c439 ( 22 0 ) capacitor c=0.0052305f //x=9.25 //y=2.435
c440 ( 21 0 ) capacitor c=0.00635496f //x=9.25 //y=2.195
c441 ( 20 0 ) capacitor c=0.070083f //x=4.44 //y=4.575
c442 ( 19 0 ) capacitor c=0.0130964f //x=4.44 //y=2.75
c443 ( 18 0 ) capacitor c=0.00604005f //x=4.44 //y=2.43
c444 ( 17 0 ) capacitor c=0.00638932f //x=4.44 //y=2.195
c445 ( 16 0 ) capacitor c=0.0742593f //x=2.59 //y=5.115
c446 ( 15 0 ) capacitor c=0.0120956f //x=2.59 //y=2.75
c447 ( 14 0 ) capacitor c=0.0182566f //x=2.59 //y=2.43
c448 ( 12 0 ) capacitor c=0.00817318f //x=2.235 //y=1.655
c449 ( 11 0 ) capacitor c=0.0144018f //x=2.505 //y=1.655
c450 ( 9 0 ) capacitor c=0.0122194f //x=2.505 //y=5.2
c451 ( 8 0 ) capacitor c=0.0167748f //x=2.15 //y=1.57
c452 ( 3 0 ) capacitor c=0.0178188f //x=1.995 //y=5.2
r453 (  159 161 ) resistor r=26.9307 //w=0.15 //l=0.106066 //layer=ply \
 //thickness=0.18 //x=9.815 //y=4.79 //x2=9.89 //y2=4.865
r454 (  159 160 ) resistor r=148.702 //w=0.094 //l=0.29 //layer=ply \
 //thickness=0.18 //x=9.815 //y=4.79 //x2=9.525 //y2=4.79
r455 (  158 179 ) resistor r=45.1352 //w=0.168 //l=0.173853 //layer=ply \
 //thickness=0.18 //x=9.48 //y=1.22 //x2=9.44 //y2=1.375
r456 (  157 178 ) resistor r=45.1352 //w=0.168 //l=0.173853 //layer=ply \
 //thickness=0.18 //x=9.48 //y=0.875 //x2=9.44 //y2=0.72
r457 (  157 158 ) resistor r=176.904 //w=0.094 //l=0.345 //layer=ply \
 //thickness=0.18 //x=9.48 //y=0.875 //x2=9.48 //y2=1.22
r458 (  154 160 ) resistor r=22.7971 //w=0.269 //l=0.106066 //layer=ply \
 //thickness=0.18 //x=9.45 //y=4.865 //x2=9.525 //y2=4.79
r459 (  154 177 ) resistor r=35.8364 //w=0.269 //l=0.270185 //layer=ply \
 //thickness=0.18 //x=9.45 //y=4.865 //x2=9.25 //y2=4.7
r460 (  152 173 ) resistor r=10.701 //w=0.21 //l=0.115 //layer=ply \
 //thickness=0.18 //x=9.105 //y=1.375 //x2=8.99 //y2=1.375
r461 (  151 179 ) resistor r=5.52526 //w=0.168 //l=0.115 //layer=ply \
 //thickness=0.18 //x=9.325 //y=1.375 //x2=9.44 //y2=1.375
r462 (  150 172 ) resistor r=5.52526 //w=0.168 //l=0.115 //layer=ply \
 //thickness=0.18 //x=9.105 //y=0.72 //x2=8.99 //y2=0.72
r463 (  149 178 ) resistor r=5.52526 //w=0.168 //l=0.115 //layer=ply \
 //thickness=0.18 //x=9.325 //y=0.72 //x2=9.44 //y2=0.72
r464 (  149 150 ) resistor r=112.809 //w=0.094 //l=0.22 //layer=ply \
 //thickness=0.18 //x=9.325 //y=0.72 //x2=9.105 //y2=0.72
r465 (  148 175 ) resistor r=58.7805 //w=0.246 //l=0.373497 //layer=ply \
 //thickness=0.18 //x=8.95 //y=1.915 //x2=9.25 //y2=2.08
r466 (  147 173 ) resistor r=39.5823 //w=0.21 //l=0.173853 //layer=ply \
 //thickness=0.18 //x=8.95 //y=1.53 //x2=8.99 //y2=1.375
r467 (  147 148 ) resistor r=197.415 //w=0.094 //l=0.385 //layer=ply \
 //thickness=0.18 //x=8.95 //y=1.53 //x2=8.95 //y2=1.915
r468 (  146 173 ) resistor r=39.5823 //w=0.21 //l=0.173853 //layer=ply \
 //thickness=0.18 //x=8.95 //y=1.22 //x2=8.99 //y2=1.375
r469 (  145 172 ) resistor r=45.1352 //w=0.168 //l=0.173853 //layer=ply \
 //thickness=0.18 //x=8.95 //y=0.875 //x2=8.99 //y2=0.72
r470 (  145 146 ) resistor r=176.904 //w=0.094 //l=0.345 //layer=ply \
 //thickness=0.18 //x=8.95 //y=0.875 //x2=8.95 //y2=1.22
r471 (  140 142 ) resistor r=26.9307 //w=0.15 //l=0.106066 //layer=ply \
 //thickness=0.18 //x=5.005 //y=4.79 //x2=5.08 //y2=4.865
r472 (  140 141 ) resistor r=148.702 //w=0.094 //l=0.29 //layer=ply \
 //thickness=0.18 //x=5.005 //y=4.79 //x2=4.715 //y2=4.79
r473 (  139 171 ) resistor r=45.1352 //w=0.168 //l=0.173853 //layer=ply \
 //thickness=0.18 //x=4.67 //y=1.22 //x2=4.63 //y2=1.375
r474 (  138 170 ) resistor r=45.1352 //w=0.168 //l=0.173853 //layer=ply \
 //thickness=0.18 //x=4.67 //y=0.875 //x2=4.63 //y2=0.72
r475 (  138 139 ) resistor r=176.904 //w=0.094 //l=0.345 //layer=ply \
 //thickness=0.18 //x=4.67 //y=0.875 //x2=4.67 //y2=1.22
r476 (  135 141 ) resistor r=22.7971 //w=0.269 //l=0.106066 //layer=ply \
 //thickness=0.18 //x=4.64 //y=4.865 //x2=4.715 //y2=4.79
r477 (  135 169 ) resistor r=35.8364 //w=0.269 //l=0.270185 //layer=ply \
 //thickness=0.18 //x=4.64 //y=4.865 //x2=4.44 //y2=4.7
r478 (  133 165 ) resistor r=10.701 //w=0.21 //l=0.115 //layer=ply \
 //thickness=0.18 //x=4.295 //y=1.375 //x2=4.18 //y2=1.375
r479 (  132 171 ) resistor r=5.52526 //w=0.168 //l=0.115 //layer=ply \
 //thickness=0.18 //x=4.515 //y=1.375 //x2=4.63 //y2=1.375
r480 (  131 164 ) resistor r=5.52526 //w=0.168 //l=0.115 //layer=ply \
 //thickness=0.18 //x=4.295 //y=0.72 //x2=4.18 //y2=0.72
r481 (  130 170 ) resistor r=5.52526 //w=0.168 //l=0.115 //layer=ply \
 //thickness=0.18 //x=4.515 //y=0.72 //x2=4.63 //y2=0.72
r482 (  130 131 ) resistor r=112.809 //w=0.094 //l=0.22 //layer=ply \
 //thickness=0.18 //x=4.515 //y=0.72 //x2=4.295 //y2=0.72
r483 (  129 167 ) resistor r=58.7805 //w=0.246 //l=0.373497 //layer=ply \
 //thickness=0.18 //x=4.14 //y=1.915 //x2=4.44 //y2=2.08
r484 (  128 165 ) resistor r=39.5823 //w=0.21 //l=0.173853 //layer=ply \
 //thickness=0.18 //x=4.14 //y=1.53 //x2=4.18 //y2=1.375
r485 (  128 129 ) resistor r=197.415 //w=0.094 //l=0.385 //layer=ply \
 //thickness=0.18 //x=4.14 //y=1.53 //x2=4.14 //y2=1.915
r486 (  127 165 ) resistor r=39.5823 //w=0.21 //l=0.173853 //layer=ply \
 //thickness=0.18 //x=4.14 //y=1.22 //x2=4.18 //y2=1.375
r487 (  126 164 ) resistor r=45.1352 //w=0.168 //l=0.173853 //layer=ply \
 //thickness=0.18 //x=4.14 //y=0.875 //x2=4.18 //y2=0.72
r488 (  126 127 ) resistor r=176.904 //w=0.094 //l=0.345 //layer=ply \
 //thickness=0.18 //x=4.14 //y=0.875 //x2=4.14 //y2=1.22
r489 (  125 161 ) resistor r=592.245 //w=0.094 //l=1.155 //layer=ply \
 //thickness=0.18 //x=9.89 //y=6.02 //x2=9.89 //y2=4.865
r490 (  124 154 ) resistor r=592.245 //w=0.094 //l=1.155 //layer=ply \
 //thickness=0.18 //x=9.45 //y=6.02 //x2=9.45 //y2=4.865
r491 (  123 142 ) resistor r=592.245 //w=0.094 //l=1.155 //layer=ply \
 //thickness=0.18 //x=5.08 //y=6.02 //x2=5.08 //y2=4.865
r492 (  122 135 ) resistor r=592.245 //w=0.094 //l=1.155 //layer=ply \
 //thickness=0.18 //x=4.64 //y=6.02 //x2=4.64 //y2=4.865
r493 (  121 151 ) resistor r=56.4043 //w=0.094 //l=0.11 //layer=ply \
 //thickness=0.18 //x=9.215 //y=1.375 //x2=9.325 //y2=1.375
r494 (  121 152 ) resistor r=56.4043 //w=0.094 //l=0.11 //layer=ply \
 //thickness=0.18 //x=9.215 //y=1.375 //x2=9.105 //y2=1.375
r495 (  120 132 ) resistor r=56.4043 //w=0.094 //l=0.11 //layer=ply \
 //thickness=0.18 //x=4.405 //y=1.375 //x2=4.515 //y2=1.375
r496 (  120 133 ) resistor r=56.4043 //w=0.094 //l=0.11 //layer=ply \
 //thickness=0.18 //x=4.405 //y=1.375 //x2=4.295 //y2=1.375
r497 (  116 177 ) resistor r=152 //w=0.17 //l=0.17 //layer=licon //count=1 \
 //x=9.25 //y=4.7 //x2=9.25 //y2=4.7
r498 (  107 175 ) resistor r=152 //w=0.17 //l=0.17 //layer=licon //count=1 \
 //x=9.25 //y=2.08 //x2=9.25 //y2=2.08
r499 (  102 169 ) resistor r=152 //w=0.17 //l=0.17 //layer=licon //count=1 \
 //x=4.44 //y=4.7 //x2=4.44 //y2=4.7
r500 (  93 167 ) resistor r=152 //w=0.17 //l=0.17 //layer=licon //count=1 \
 //x=4.44 //y=2.08 //x2=4.44 //y2=2.08
r501 (  76 183 ) resistor r=23.615 //w=0.187 //l=0.345 //layer=li \
 //thickness=0.1 //x=2.11 //y=5.38 //x2=2.11 //y2=5.725
r502 (  68 182 ) resistor r=23.615 //w=0.187 //l=0.345 //layer=li \
 //thickness=0.1 //x=1.23 //y=5.38 //x2=1.23 //y2=5.725
r503 (  64 65 ) resistor r=0.10734 //w=0.281 //l=0.16 //layer=m2 \
 //thickness=0.36 //x=9.25 //y=2.595 //x2=9.09 //y2=2.595
r504 (  57 62 ) resistor r=0.10734 //w=0.281 //l=0.16 //layer=m2 \
 //thickness=0.36 //x=4.6 //y=2.59 //x2=4.44 //y2=2.59
r505 (  57 65 ) resistor r=4.28435 //w=0.131 //l=4.49 //layer=m2 \
 //thickness=0.36 //x=4.6 //y=2.59 //x2=9.09 //y2=2.59
r506 (  55 59 ) resistor r=0.10734 //w=0.281 //l=0.16 //layer=m2 \
 //thickness=0.36 //x=2.75 //y=2.59 //x2=2.59 //y2=2.59
r507 (  54 62 ) resistor r=0.10734 //w=0.281 //l=0.16 //layer=m2 \
 //thickness=0.36 //x=4.28 //y=2.59 //x2=4.44 //y2=2.59
r508 (  54 55 ) resistor r=1.45992 //w=0.131 //l=1.53 //layer=m2 \
 //thickness=0.36 //x=4.28 //y=2.59 //x2=2.75 //y2=2.59
r509 (  53 116 ) resistor r=9.3 //w=0.17 //l=0.17 //layer=mcon //count=1 \
 //x=9.25 //y=4.7 //x2=9.25 //y2=4.7
r510 (  51 107 ) resistor r=9.3 //w=0.17 //l=0.17 //layer=mcon //count=1 \
 //x=9.25 //y=2.08 //x2=9.25 //y2=2.08
r511 (  49 64 ) resistor r=4.5 //w=0.15 //l=0.15 //layer=via1 //count=1 \
 //x=9.25 //y=2.595 //x2=9.25 //y2=2.595
r512 (  47 49 ) resistor r=0.00166223 //w=0.376 //l=0.005 //layer=m1 \
 //thickness=0.36 //x=9.197 //y=2.59 //x2=9.197 //y2=2.595
r513 (  45 62 ) resistor r=4.5 //w=0.15 //l=0.15 //layer=via1 //count=1 \
 //x=4.44 //y=2.59 //x2=4.44 //y2=2.59
r514 (  43 45 ) resistor r=0.00166223 //w=0.376 //l=0.005 //layer=m1 \
 //thickness=0.36 //x=4.492 //y=2.585 //x2=4.492 //y2=2.59
r515 (  41 102 ) resistor r=9.3 //w=0.17 //l=0.17 //layer=mcon //count=1 \
 //x=4.44 //y=4.7 //x2=4.44 //y2=4.7
r516 (  39 93 ) resistor r=9.3 //w=0.17 //l=0.17 //layer=mcon //count=1 \
 //x=4.44 //y=2.08 //x2=4.44 //y2=2.08
r517 (  36 59 ) resistor r=4.5 //w=0.15 //l=0.15 //layer=via1 //count=1 \
 //x=2.59 //y=2.59 //x2=2.59 //y2=2.59
r518 (  33 180 ) resistor r=9.3 //w=0.17 //l=0.17 //layer=mcon //count=1 \
 //x=2.15 //y=1 //x2=2.15 //y2=1
r519 (  31 76 ) resistor r=9.3 //w=0.17 //l=0.17 //layer=mcon //count=1 \
 //x=2.11 //y=5.38 //x2=2.11 //y2=5.38
r520 (  28 31 ) resistor r=0.117801 //w=0.191 //l=0.18 //layer=m1 \
 //thickness=0.36 //x=2.11 //y=5.2 //x2=2.11 //y2=5.38
r521 (  27 68 ) resistor r=9.3 //w=0.17 //l=0.17 //layer=mcon //count=1 \
 //x=1.23 //y=5.38 //x2=1.23 //y2=5.38
r522 (  25 27 ) resistor r=0.10274 //w=0.219 //l=0.18 //layer=m1 \
 //thickness=0.36 //x=1.23 //y=5.2 //x2=1.23 //y2=5.38
r523 (  24 53 ) resistor r=0.0760407 //w=0.238 //l=0.125 //layer=m1 \
 //thickness=0.36 //x=9.25 //y=4.575 //x2=9.25 //y2=4.7
r524 (  23 49 ) resistor r=0.0911593 //w=0.376 //l=0.184608 //layer=m1 \
 //thickness=0.36 //x=9.25 //y=2.755 //x2=9.197 //y2=2.595
r525 (  23 24 ) resistor r=1.73664 //w=0.131 //l=1.82 //layer=m1 \
 //thickness=0.36 //x=9.25 //y=2.755 //x2=9.25 //y2=4.575
r526 (  22 47 ) resistor r=0.0894971 //w=0.376 //l=0.179555 //layer=m1 \
 //thickness=0.36 //x=9.25 //y=2.435 //x2=9.197 //y2=2.59
r527 (  21 51 ) resistor r=0.0719237 //w=0.222 //l=0.115 //layer=m1 \
 //thickness=0.36 //x=9.25 //y=2.195 //x2=9.25 //y2=2.08
r528 (  21 22 ) resistor r=0.229008 //w=0.131 //l=0.24 //layer=m1 \
 //thickness=0.36 //x=9.25 //y=2.195 //x2=9.25 //y2=2.435
r529 (  20 41 ) resistor r=0.0760407 //w=0.238 //l=0.125 //layer=m1 \
 //thickness=0.36 //x=4.44 //y=4.575 //x2=4.44 //y2=4.7
r530 (  19 45 ) resistor r=0.0911593 //w=0.376 //l=0.184174 //layer=m1 \
 //thickness=0.36 //x=4.44 //y=2.75 //x2=4.492 //y2=2.59
r531 (  19 20 ) resistor r=1.74141 //w=0.131 //l=1.825 //layer=m1 \
 //thickness=0.36 //x=4.44 //y=2.75 //x2=4.44 //y2=4.575
r532 (  18 43 ) resistor r=0.0894971 //w=0.376 //l=0.179123 //layer=m1 \
 //thickness=0.36 //x=4.44 //y=2.43 //x2=4.492 //y2=2.585
r533 (  17 39 ) resistor r=0.0719237 //w=0.222 //l=0.115 //layer=m1 \
 //thickness=0.36 //x=4.44 //y=2.195 //x2=4.44 //y2=2.08
r534 (  17 18 ) resistor r=0.224237 //w=0.131 //l=0.235 //layer=m1 \
 //thickness=0.36 //x=4.44 //y=2.195 //x2=4.44 //y2=2.43
r535 (  15 36 ) resistor r=0.0911593 //w=0.376 //l=0.184174 //layer=m1 \
 //thickness=0.36 //x=2.59 //y=2.75 //x2=2.642 //y2=2.59
r536 (  15 16 ) resistor r=2.25668 //w=0.131 //l=2.365 //layer=m1 \
 //thickness=0.36 //x=2.59 //y=2.75 //x2=2.59 //y2=5.115
r537 (  14 36 ) resistor r=0.0911593 //w=0.376 //l=0.184174 //layer=m1 \
 //thickness=0.36 //x=2.59 //y=2.43 //x2=2.642 //y2=2.59
r538 (  13 14 ) resistor r=0.658397 //w=0.131 //l=0.69 //layer=m1 \
 //thickness=0.36 //x=2.59 //y=1.74 //x2=2.59 //y2=2.43
r539 (  11 13 ) resistor r=0.0698411 //w=0.17 //l=0.120208 //layer=m1 \
 //thickness=0.36 //x=2.505 //y=1.655 //x2=2.59 //y2=1.74
r540 (  11 12 ) resistor r=0.257634 //w=0.131 //l=0.27 //layer=m1 \
 //thickness=0.36 //x=2.505 //y=1.655 //x2=2.235 //y2=1.655
r541 (  10 28 ) resistor r=0.0257089 //w=0.23 //l=0.115 //layer=m1 \
 //thickness=0.36 //x=2.225 //y=5.2 //x2=2.11 //y2=5.2
r542 (  9 16 ) resistor r=0.0698411 //w=0.17 //l=0.120208 //layer=m1 \
 //thickness=0.36 //x=2.505 //y=5.2 //x2=2.59 //y2=5.115
r543 (  9 10 ) resistor r=0.267176 //w=0.131 //l=0.28 //layer=m1 \
 //thickness=0.36 //x=2.505 //y=5.2 //x2=2.225 //y2=5.2
r544 (  8 12 ) resistor r=0.0698411 //w=0.17 //l=0.120208 //layer=m1 \
 //thickness=0.36 //x=2.15 //y=1.57 //x2=2.235 //y2=1.655
r545 (  7 33 ) resistor r=0.0913624 //w=0.191 //l=0.12 //layer=m1 \
 //thickness=0.36 //x=2.15 //y=1.12 //x2=2.15 //y2=1
r546 (  7 8 ) resistor r=0.429389 //w=0.131 //l=0.45 //layer=m1 \
 //thickness=0.36 //x=2.15 //y=1.12 //x2=2.15 //y2=1.57
r547 (  4 25 ) resistor r=0.0227762 //w=0.219 //l=0.115 //layer=m1 \
 //thickness=0.36 //x=1.345 //y=5.2 //x2=1.23 //y2=5.2
r548 (  3 28 ) resistor r=0.0257089 //w=0.23 //l=0.115 //layer=m1 \
 //thickness=0.36 //x=1.995 //y=5.2 //x2=2.11 //y2=5.2
r549 (  3 4 ) resistor r=0.620229 //w=0.131 //l=0.65 //layer=m1 \
 //thickness=0.36 //x=1.995 //y=5.2 //x2=1.345 //y2=5.2
ends PM_DFFSNX1_PCELL\%noxref_1

subckt PM_DFFSNX1_PCELL\%noxref_2 ( 1 3 6 7 9 10 11 12 14 15 16 18 19 21 24 27 \
 33 37 41 44 45 52 54 55 58 66 74 91 100 104 105 106 107 108 109 110 114 116 \
 119 120 130 133 135 136 137 )
c287 ( 133 0 ) capacitor c=0.00885916f //x=11.535 //y=0.915
c288 ( 130 0 ) capacitor c=0.0682508f //x=14.06 //y=4.7
c289 ( 120 0 ) capacitor c=0.0318956f //x=14.395 //y=1.21
c290 ( 119 0 ) capacitor c=0.0186809f //x=14.395 //y=0.865
c291 ( 116 0 ) capacitor c=0.0141821f //x=14.24 //y=1.365
c292 ( 114 0 ) capacitor c=0.0158553f //x=14.24 //y=0.71
c293 ( 110 0 ) capacitor c=0.0815114f //x=13.865 //y=1.915
c294 ( 109 0 ) capacitor c=0.0229235f //x=13.865 //y=1.52
c295 ( 108 0 ) capacitor c=0.0234359f //x=13.865 //y=1.21
c296 ( 107 0 ) capacitor c=0.0198759f //x=13.865 //y=0.865
c297 ( 106 0 ) capacitor c=0.110369f //x=14.4 //y=6.02
c298 ( 105 0 ) capacitor c=0.154619f //x=13.96 //y=6.02
c299 ( 100 0 ) capacitor c=8.13451e-19 //x=14.06 //y=4.7
c300 ( 91 0 ) capacitor c=5.17312e-19 //x=14.06 //y=2.08
c301 ( 74 0 ) capacitor c=0.0293219f //x=11.43 //y=5.38
c302 ( 66 0 ) capacitor c=0.029137f //x=10.55 //y=5.38
c303 ( 58 0 ) capacitor c=0.0278099f //x=9.67 //y=5.38
c304 ( 55 0 ) capacitor c=0.024619f //x=13.895 //y=2.605
c305 ( 54 0 ) capacitor c=7.98676e-19 //x=14.055 //y=2.605
c306 ( 52 0 ) capacitor c=0.00129706f //x=12.37 //y=2.605
c307 ( 45 0 ) capacitor c=0.054494f //x=14.062 //y=4.56
c308 ( 44 0 ) capacitor c=0.00631721f //x=14.06 //y=4.7
c309 ( 41 0 ) capacitor c=0.00463527f //x=14.06 //y=2.08
c310 ( 37 0 ) capacitor c=0.0145985f //x=14.06 //y=2.59
c311 ( 33 0 ) capacitor c=0.0149529f //x=12.21 //y=2.59
c312 ( 27 0 ) capacitor c=8.88597e-19 //x=11.43 //y=5.155
c313 ( 24 0 ) capacitor c=0.00796615f //x=10.55 //y=5.155
c314 ( 21 0 ) capacitor c=0.0111234f //x=9.672 //y=5.155
c315 ( 19 0 ) capacitor c=0.0120671f //x=14.06 //y=2.765
c316 ( 18 0 ) capacitor c=0.00384658f //x=14.06 //y=2.445
c317 ( 16 0 ) capacitor c=0.06877f //x=12.21 //y=5.07
c318 ( 15 0 ) capacitor c=0.0124098f //x=12.21 //y=2.765
c319 ( 14 0 ) capacitor c=0.0168574f //x=12.21 //y=2.445
c320 ( 12 0 ) capacitor c=0.00493487f //x=11.81 //y=1.665
c321 ( 11 0 ) capacitor c=0.0126211f //x=12.125 //y=1.665
c322 ( 10 0 ) capacitor c=0.0136149f //x=11.725 //y=1.58
c323 ( 9 0 ) capacitor c=0.0113786f //x=11.725 //y=1.125
c324 ( 7 0 ) capacitor c=0.0235567f //x=12.125 //y=5.155
c325 ( 6 0 ) capacitor c=0.00906713f //x=11.43 //y=5.38
c326 ( 3 0 ) capacitor c=0.0180822f //x=11.315 //y=5.155
c327 ( 1 0 ) capacitor c=0.0152149f //x=10.43 //y=5.155
r328 (  128 130 ) resistor r=20.6867 //w=0.233 //l=0.1 //layer=ply \
 //thickness=0.18 //x=13.96 //y=4.7 //x2=14.06 //y2=4.7
r329 (  121 130 ) resistor r=70.3348 //w=0.233 //l=0.414367 //layer=ply \
 //thickness=0.18 //x=14.4 //y=4.865 //x2=14.06 //y2=4.7
r330 (  120 132 ) resistor r=45.1352 //w=0.168 //l=0.173853 //layer=ply \
 //thickness=0.18 //x=14.395 //y=1.21 //x2=14.355 //y2=1.365
r331 (  119 131 ) resistor r=45.1352 //w=0.168 //l=0.173853 //layer=ply \
 //thickness=0.18 //x=14.395 //y=0.865 //x2=14.355 //y2=0.71
r332 (  119 120 ) resistor r=176.904 //w=0.094 //l=0.345 //layer=ply \
 //thickness=0.18 //x=14.395 //y=0.865 //x2=14.395 //y2=1.21
r333 (  117 127 ) resistor r=10.701 //w=0.21 //l=0.115 //layer=ply \
 //thickness=0.18 //x=14.02 //y=1.365 //x2=13.905 //y2=1.365
r334 (  116 132 ) resistor r=5.52526 //w=0.168 //l=0.115 //layer=ply \
 //thickness=0.18 //x=14.24 //y=1.365 //x2=14.355 //y2=1.365
r335 (  115 126 ) resistor r=5.52526 //w=0.168 //l=0.115 //layer=ply \
 //thickness=0.18 //x=14.02 //y=0.71 //x2=13.905 //y2=0.71
r336 (  114 131 ) resistor r=5.52526 //w=0.168 //l=0.115 //layer=ply \
 //thickness=0.18 //x=14.24 //y=0.71 //x2=14.355 //y2=0.71
r337 (  114 115 ) resistor r=112.809 //w=0.094 //l=0.22 //layer=ply \
 //thickness=0.18 //x=14.24 //y=0.71 //x2=14.02 //y2=0.71
r338 (  111 128 ) resistor r=13.0941 //w=0.233 //l=0.165 //layer=ply \
 //thickness=0.18 //x=13.96 //y=4.865 //x2=13.96 //y2=4.7
r339 (  110 125 ) resistor r=34.8111 //w=0.27 //l=0.264953 //layer=ply \
 //thickness=0.18 //x=13.865 //y=1.915 //x2=14.06 //y2=2.08
r340 (  109 127 ) resistor r=39.5823 //w=0.21 //l=0.173853 //layer=ply \
 //thickness=0.18 //x=13.865 //y=1.52 //x2=13.905 //y2=1.365
r341 (  109 110 ) resistor r=202.543 //w=0.094 //l=0.395 //layer=ply \
 //thickness=0.18 //x=13.865 //y=1.52 //x2=13.865 //y2=1.915
r342 (  108 127 ) resistor r=39.5823 //w=0.21 //l=0.173853 //layer=ply \
 //thickness=0.18 //x=13.865 //y=1.21 //x2=13.905 //y2=1.365
r343 (  107 126 ) resistor r=45.1352 //w=0.168 //l=0.173853 //layer=ply \
 //thickness=0.18 //x=13.865 //y=0.865 //x2=13.905 //y2=0.71
r344 (  107 108 ) resistor r=176.904 //w=0.094 //l=0.345 //layer=ply \
 //thickness=0.18 //x=13.865 //y=0.865 //x2=13.865 //y2=1.21
r345 (  106 121 ) resistor r=592.245 //w=0.094 //l=1.155 //layer=ply \
 //thickness=0.18 //x=14.4 //y=6.02 //x2=14.4 //y2=4.865
r346 (  105 111 ) resistor r=592.245 //w=0.094 //l=1.155 //layer=ply \
 //thickness=0.18 //x=13.96 //y=6.02 //x2=13.96 //y2=4.865
r347 (  104 116 ) resistor r=56.4043 //w=0.094 //l=0.11 //layer=ply \
 //thickness=0.18 //x=14.13 //y=1.365 //x2=14.24 //y2=1.365
r348 (  104 117 ) resistor r=56.4043 //w=0.094 //l=0.11 //layer=ply \
 //thickness=0.18 //x=14.13 //y=1.365 //x2=14.02 //y2=1.365
r349 (  100 130 ) resistor r=152 //w=0.17 //l=0.17 //layer=licon //count=1 \
 //x=14.06 //y=4.7 //x2=14.06 //y2=4.7
r350 (  91 125 ) resistor r=152 //w=0.17 //l=0.17 //layer=licon //count=1 \
 //x=14.06 //y=2.08 //x2=14.06 //y2=2.08
r351 (  74 137 ) resistor r=23.615 //w=0.187 //l=0.345 //layer=li \
 //thickness=0.1 //x=11.43 //y=5.38 //x2=11.43 //y2=5.725
r352 (  66 136 ) resistor r=23.615 //w=0.187 //l=0.345 //layer=li \
 //thickness=0.1 //x=10.55 //y=5.38 //x2=10.55 //y2=5.725
r353 (  58 135 ) resistor r=23.615 //w=0.187 //l=0.345 //layer=li \
 //thickness=0.1 //x=9.67 //y=5.38 //x2=9.67 //y2=5.725
r354 (  54 55 ) resistor r=0.10734 //w=0.281 //l=0.16 //layer=m2 \
 //thickness=0.36 //x=14.055 //y=2.605 //x2=13.895 //y2=2.605
r355 (  52 55 ) resistor r=1.45515 //w=0.131 //l=1.525 //layer=m2 \
 //thickness=0.36 //x=12.37 //y=2.59 //x2=13.895 //y2=2.59
r356 (  50 52 ) resistor r=0.10734 //w=0.281 //l=0.16 //layer=m2 \
 //thickness=0.36 //x=12.21 //y=2.605 //x2=12.37 //y2=2.605
r357 (  44 100 ) resistor r=9.3 //w=0.17 //l=0.17 //layer=mcon //count=1 \
 //x=14.06 //y=4.7 //x2=14.06 //y2=4.7
r358 (  44 45 ) resistor r=0.103207 //w=0.196 //l=0.14 //layer=m1 \
 //thickness=0.36 //x=14.062 //y=4.7 //x2=14.062 //y2=4.56
r359 (  41 91 ) resistor r=9.3 //w=0.17 //l=0.17 //layer=mcon //count=1 \
 //x=14.06 //y=2.08 //x2=14.06 //y2=2.08
r360 (  39 54 ) resistor r=4.5 //w=0.15 //l=0.15 //layer=via1 //count=1 \
 //x=14.055 //y=2.605 //x2=14.055 //y2=2.605
r361 (  37 39 ) resistor r=0.00501337 //w=0.374 //l=0.015 //layer=m1 \
 //thickness=0.36 //x=14.005 //y=2.59 //x2=14.005 //y2=2.605
r362 (  35 50 ) resistor r=4.5 //w=0.15 //l=0.15 //layer=via1 //count=1 \
 //x=12.21 //y=2.605 //x2=12.21 //y2=2.605
r363 (  33 35 ) resistor r=0.0049867 //w=0.376 //l=0.015 //layer=m1 \
 //thickness=0.36 //x=12.262 //y=2.59 //x2=12.262 //y2=2.605
r364 (  31 133 ) resistor r=9.3 //w=0.17 //l=0.17 //layer=mcon //count=1 \
 //x=11.725 //y=1.01 //x2=11.725 //y2=1.01
r365 (  29 74 ) resistor r=9.3 //w=0.17 //l=0.17 //layer=mcon //count=1 \
 //x=11.43 //y=5.38 //x2=11.43 //y2=5.38
r366 (  26 66 ) resistor r=9.3 //w=0.17 //l=0.17 //layer=mcon //count=1 \
 //x=10.55 //y=5.38 //x2=10.55 //y2=5.38
r367 (  24 26 ) resistor r=0.121228 //w=0.232 //l=0.225 //layer=m1 \
 //thickness=0.36 //x=10.55 //y=5.155 //x2=10.55 //y2=5.38
r368 (  23 58 ) resistor r=9.3 //w=0.17 //l=0.17 //layer=mcon //count=1 \
 //x=9.67 //y=5.38 //x2=9.67 //y2=5.38
r369 (  21 23 ) resistor r=0.129608 //w=0.217 //l=0.225 //layer=m1 \
 //thickness=0.36 //x=9.672 //y=5.155 //x2=9.672 //y2=5.38
r370 (  19 39 ) resistor r=0.0910802 //w=0.374 //l=0.185472 //layer=m1 \
 //thickness=0.36 //x=14.06 //y=2.765 //x2=14.005 //y2=2.605
r371 (  19 45 ) resistor r=1.71279 //w=0.131 //l=1.795 //layer=m1 \
 //thickness=0.36 //x=14.06 //y=2.765 //x2=14.06 //y2=4.56
r372 (  18 37 ) resistor r=0.0860668 //w=0.374 //l=0.170294 //layer=m1 \
 //thickness=0.36 //x=14.06 //y=2.445 //x2=14.005 //y2=2.59
r373 (  17 41 ) resistor r=0.0933015 //w=0.201 //l=0.125 //layer=m1 \
 //thickness=0.36 //x=14.06 //y=2.205 //x2=14.06 //y2=2.08
r374 (  17 18 ) resistor r=0.229008 //w=0.131 //l=0.24 //layer=m1 \
 //thickness=0.36 //x=14.06 //y=2.205 //x2=14.06 //y2=2.445
r375 (  15 35 ) resistor r=0.0911593 //w=0.376 //l=0.184174 //layer=m1 \
 //thickness=0.36 //x=12.21 //y=2.765 //x2=12.262 //y2=2.605
r376 (  15 16 ) resistor r=2.19943 //w=0.131 //l=2.305 //layer=m1 \
 //thickness=0.36 //x=12.21 //y=2.765 //x2=12.21 //y2=5.07
r377 (  14 33 ) resistor r=0.0861726 //w=0.376 //l=0.169012 //layer=m1 \
 //thickness=0.36 //x=12.21 //y=2.445 //x2=12.262 //y2=2.59
r378 (  13 14 ) resistor r=0.663168 //w=0.131 //l=0.695 //layer=m1 \
 //thickness=0.36 //x=12.21 //y=1.75 //x2=12.21 //y2=2.445
r379 (  11 13 ) resistor r=0.0698411 //w=0.17 //l=0.120208 //layer=m1 \
 //thickness=0.36 //x=12.125 //y=1.665 //x2=12.21 //y2=1.75
r380 (  11 12 ) resistor r=0.300573 //w=0.131 //l=0.315 //layer=m1 \
 //thickness=0.36 //x=12.125 //y=1.665 //x2=11.81 //y2=1.665
r381 (  10 12 ) resistor r=0.0698411 //w=0.17 //l=0.120208 //layer=m1 \
 //thickness=0.36 //x=11.725 //y=1.58 //x2=11.81 //y2=1.665
r382 (  9 31 ) resistor r=0.0717383 //w=0.224 //l=0.115 //layer=m1 \
 //thickness=0.36 //x=11.725 //y=1.125 //x2=11.725 //y2=1.01
r383 (  9 10 ) resistor r=0.43416 //w=0.131 //l=0.455 //layer=m1 \
 //thickness=0.36 //x=11.725 //y=1.125 //x2=11.725 //y2=1.58
r384 (  8 27 ) resistor r=0.0675342 //w=0.23 //l=0.115 //layer=m1 \
 //thickness=0.36 //x=11.545 //y=5.155 //x2=11.43 //y2=5.155
r385 (  7 16 ) resistor r=0.0698411 //w=0.17 //l=0.120208 //layer=m1 \
 //thickness=0.36 //x=12.125 //y=5.155 //x2=12.21 //y2=5.07
r386 (  7 8 ) resistor r=0.553435 //w=0.131 //l=0.58 //layer=m1 \
 //thickness=0.36 //x=12.125 //y=5.155 //x2=11.545 //y2=5.155
r387 (  6 29 ) resistor r=0.00118313 //w=0.23 //layer=m1 //thickness=0.36 \
 //x=11.43 //y=5.38 //x2=11.43 //y2=5.38
r388 (  5 27 ) resistor r=0.002872 //w=0.34 //l=0.085 //layer=m1 \
 //thickness=0.36 //x=11.43 //y=5.24 //x2=11.43 //y2=5.155
r389 (  5 6 ) resistor r=0.091623 //w=0.191 //l=0.14 //layer=m1 \
 //thickness=0.36 //x=11.43 //y=5.24 //x2=11.43 //y2=5.38
r390 (  4 24 ) resistor r=0.0262263 //w=0.232 //l=0.12 //layer=m1 \
 //thickness=0.36 //x=10.67 //y=5.155 //x2=10.55 //y2=5.155
r391 (  3 27 ) resistor r=0.0675342 //w=0.23 //l=0.115 //layer=m1 \
 //thickness=0.36 //x=11.315 //y=5.155 //x2=11.43 //y2=5.155
r392 (  3 4 ) resistor r=0.615458 //w=0.131 //l=0.645 //layer=m1 \
 //thickness=0.36 //x=11.315 //y=5.155 //x2=10.67 //y2=5.155
r393 (  2 21 ) resistor r=0.0222262 //w=0.217 //l=0.118 //layer=m1 \
 //thickness=0.36 //x=9.79 //y=5.155 //x2=9.672 //y2=5.155
r394 (  1 24 ) resistor r=0.0262263 //w=0.232 //l=0.12 //layer=m1 \
 //thickness=0.36 //x=10.43 //y=5.155 //x2=10.55 //y2=5.155
r395 (  1 2 ) resistor r=0.610687 //w=0.131 //l=0.64 //layer=m1 \
 //thickness=0.36 //x=10.43 //y=5.155 //x2=9.79 //y2=5.155
ends PM_DFFSNX1_PCELL\%noxref_2

subckt PM_DFFSNX1_PCELL\%noxref_3 ( 1 2 4 8 12 16 19 21 23 29 34 39 44 48 49 \
 50 51 52 53 54 55 56 58 64 65 66 67 68 73 74 75 80 82 84 90 91 95 104 105 108 )
c276 ( 108 0 ) capacitor c=0.0368618f //x=14.83 //y=4.7
c277 ( 105 0 ) capacitor c=0.0284095f //x=14.8 //y=1.915
c278 ( 104 0 ) capacitor c=0.0476356f //x=14.8 //y=2.08
c279 ( 95 0 ) capacitor c=0.035802f //x=5.55 //y=4.7
c280 ( 91 0 ) capacitor c=0.0439708f //x=15.365 //y=1.25
c281 ( 90 0 ) capacitor c=0.0192582f //x=15.365 //y=0.905
c282 ( 84 0 ) capacitor c=0.0162526f //x=15.21 //y=1.405
c283 ( 82 0 ) capacitor c=0.0157807f //x=15.21 //y=0.75
c284 ( 80 0 ) capacitor c=0.0352777f //x=15.205 //y=4.79
c285 ( 75 0 ) capacitor c=0.0210762f //x=14.835 //y=1.56
c286 ( 74 0 ) capacitor c=0.0168511f //x=14.835 //y=1.25
c287 ( 73 0 ) capacitor c=0.0175485f //x=14.835 //y=0.905
c288 ( 68 0 ) capacitor c=0.0305913f //x=5.885 //y=4.79
c289 ( 67 0 ) capacitor c=0.0863671f //x=5.64 //y=1.915
c290 ( 66 0 ) capacitor c=0.0170266f //x=5.64 //y=1.45
c291 ( 65 0 ) capacitor c=0.018609f //x=5.64 //y=1.22
c292 ( 64 0 ) capacitor c=0.0186599f //x=5.64 //y=0.91
c293 ( 58 0 ) capacitor c=0.0146988f //x=5.485 //y=1.375
c294 ( 56 0 ) capacitor c=0.0148531f //x=5.485 //y=0.755
c295 ( 55 0 ) capacitor c=0.0334406f //x=5.115 //y=1.22
c296 ( 54 0 ) capacitor c=0.0173191f //x=5.115 //y=0.91
c297 ( 53 0 ) capacitor c=0.155269f //x=15.28 //y=6.02
c298 ( 52 0 ) capacitor c=0.110375f //x=14.84 //y=6.02
c299 ( 51 0 ) capacitor c=0.110208f //x=5.96 //y=6.02
c300 ( 50 0 ) capacitor c=0.110214f //x=5.52 //y=6.02
c301 ( 44 0 ) capacitor c=8.63366e-19 //x=14.83 //y=4.7
c302 ( 39 0 ) capacitor c=7.72439e-19 //x=14.8 //y=2.08
c303 ( 34 0 ) capacitor c=0.00129934f //x=5.55 //y=4.7
c304 ( 29 0 ) capacitor c=0.00121786f //x=5.55 //y=2.08
c305 ( 23 0 ) capacitor c=0.00532303f //x=5.55 //y=4.44
c306 ( 21 0 ) capacitor c=0.193887f //x=7.61 //y=4.455
c307 ( 19 0 ) capacitor c=0.0322851f //x=7.01 //y=4.44
c308 ( 16 0 ) capacitor c=0.00896428f //x=14.835 //y=4.57
c309 ( 12 0 ) capacitor c=0.00504845f //x=14.8 //y=2.08
c310 ( 8 0 ) capacitor c=0.00988034f //x=5.55 //y=4.575
c311 ( 4 0 ) capacitor c=0.0496477f //x=14.8 //y=4.41
c312 ( 2 0 ) capacitor c=0.0659583f //x=5.55 //y=4.415
c313 ( 1 0 ) capacitor c=0.00562626f //x=5.55 //y=2.195
r314 (  110 111 ) resistor r=32.4568 //w=0.214 //l=0.075 //layer=ply \
 //thickness=0.18 //x=14.83 //y=4.79 //x2=14.83 //y2=4.865
r315 (  108 110 ) resistor r=20.271 //w=0.214 //l=0.09 //layer=ply \
 //thickness=0.18 //x=14.83 //y=4.7 //x2=14.83 //y2=4.79
r316 (  104 105 ) resistor r=52.7279 //w=0.214 //l=0.165 //layer=ply \
 //thickness=0.18 //x=14.8 //y=2.08 //x2=14.8 //y2=1.915
r317 (  97 98 ) resistor r=32.4568 //w=0.214 //l=0.075 //layer=ply \
 //thickness=0.18 //x=5.55 //y=4.79 //x2=5.55 //y2=4.865
r318 (  95 97 ) resistor r=20.271 //w=0.214 //l=0.09 //layer=ply \
 //thickness=0.18 //x=5.55 //y=4.7 //x2=5.55 //y2=4.79
r319 (  91 115 ) resistor r=45.1352 //w=0.168 //l=0.173853 //layer=ply \
 //thickness=0.18 //x=15.365 //y=1.25 //x2=15.325 //y2=1.405
r320 (  90 114 ) resistor r=45.1352 //w=0.168 //l=0.173853 //layer=ply \
 //thickness=0.18 //x=15.365 //y=0.905 //x2=15.325 //y2=0.75
r321 (  90 91 ) resistor r=176.904 //w=0.094 //l=0.345 //layer=ply \
 //thickness=0.18 //x=15.365 //y=0.905 //x2=15.365 //y2=1.25
r322 (  85 113 ) resistor r=10.701 //w=0.21 //l=0.115 //layer=ply \
 //thickness=0.18 //x=14.99 //y=1.405 //x2=14.875 //y2=1.405
r323 (  84 115 ) resistor r=5.52526 //w=0.168 //l=0.115 //layer=ply \
 //thickness=0.18 //x=15.21 //y=1.405 //x2=15.325 //y2=1.405
r324 (  83 112 ) resistor r=5.52526 //w=0.168 //l=0.115 //layer=ply \
 //thickness=0.18 //x=14.99 //y=0.75 //x2=14.875 //y2=0.75
r325 (  82 114 ) resistor r=5.52526 //w=0.168 //l=0.115 //layer=ply \
 //thickness=0.18 //x=15.21 //y=0.75 //x2=15.325 //y2=0.75
r326 (  82 83 ) resistor r=112.809 //w=0.094 //l=0.22 //layer=ply \
 //thickness=0.18 //x=15.21 //y=0.75 //x2=14.99 //y2=0.75
r327 (  81 110 ) resistor r=16.5046 //w=0.27 //l=0.135 //layer=ply \
 //thickness=0.18 //x=14.965 //y=4.79 //x2=14.83 //y2=4.79
r328 (  80 87 ) resistor r=26.9307 //w=0.15 //l=0.106066 //layer=ply \
 //thickness=0.18 //x=15.205 //y=4.79 //x2=15.28 //y2=4.865
r329 (  80 81 ) resistor r=123.064 //w=0.094 //l=0.24 //layer=ply \
 //thickness=0.18 //x=15.205 //y=4.79 //x2=14.965 //y2=4.79
r330 (  75 113 ) resistor r=39.5823 //w=0.21 //l=0.173853 //layer=ply \
 //thickness=0.18 //x=14.835 //y=1.56 //x2=14.875 //y2=1.405
r331 (  75 105 ) resistor r=182.032 //w=0.094 //l=0.355 //layer=ply \
 //thickness=0.18 //x=14.835 //y=1.56 //x2=14.835 //y2=1.915
r332 (  74 113 ) resistor r=39.5823 //w=0.21 //l=0.173853 //layer=ply \
 //thickness=0.18 //x=14.835 //y=1.25 //x2=14.875 //y2=1.405
r333 (  73 112 ) resistor r=45.1352 //w=0.168 //l=0.173853 //layer=ply \
 //thickness=0.18 //x=14.835 //y=0.905 //x2=14.875 //y2=0.75
r334 (  73 74 ) resistor r=176.904 //w=0.094 //l=0.345 //layer=ply \
 //thickness=0.18 //x=14.835 //y=0.905 //x2=14.835 //y2=1.25
r335 (  69 97 ) resistor r=16.5046 //w=0.27 //l=0.135 //layer=ply \
 //thickness=0.18 //x=5.685 //y=4.79 //x2=5.55 //y2=4.79
r336 (  68 70 ) resistor r=26.9307 //w=0.15 //l=0.106066 //layer=ply \
 //thickness=0.18 //x=5.885 //y=4.79 //x2=5.96 //y2=4.865
r337 (  68 69 ) resistor r=102.553 //w=0.094 //l=0.2 //layer=ply \
 //thickness=0.18 //x=5.885 //y=4.79 //x2=5.685 //y2=4.79
r338 (  67 102 ) resistor r=38.6777 //w=0.284 //l=0.198997 //layer=ply \
 //thickness=0.18 //x=5.64 //y=1.915 //x2=5.565 //y2=2.08
r339 (  66 100 ) resistor r=21.2976 //w=0.217 //l=0.0928709 //layer=ply \
 //thickness=0.18 //x=5.64 //y=1.45 //x2=5.6 //y2=1.375
r340 (  66 67 ) resistor r=238.436 //w=0.094 //l=0.465 //layer=ply \
 //thickness=0.18 //x=5.64 //y=1.45 //x2=5.64 //y2=1.915
r341 (  65 100 ) resistor r=39.0671 //w=0.217 //l=0.173853 //layer=ply \
 //thickness=0.18 //x=5.64 //y=1.22 //x2=5.6 //y2=1.375
r342 (  64 99 ) resistor r=45.1352 //w=0.168 //l=0.173853 //layer=ply \
 //thickness=0.18 //x=5.64 //y=0.91 //x2=5.6 //y2=0.755
r343 (  64 65 ) resistor r=158.957 //w=0.094 //l=0.31 //layer=ply \
 //thickness=0.18 //x=5.64 //y=0.91 //x2=5.64 //y2=1.22
r344 (  59 93 ) resistor r=5.52526 //w=0.168 //l=0.115 //layer=ply \
 //thickness=0.18 //x=5.27 //y=1.375 //x2=5.155 //y2=1.375
r345 (  58 100 ) resistor r=11.4558 //w=0.217 //l=0.115 //layer=ply \
 //thickness=0.18 //x=5.485 //y=1.375 //x2=5.6 //y2=1.375
r346 (  57 92 ) resistor r=5.52526 //w=0.168 //l=0.115 //layer=ply \
 //thickness=0.18 //x=5.27 //y=0.755 //x2=5.155 //y2=0.755
r347 (  56 99 ) resistor r=5.52526 //w=0.168 //l=0.115 //layer=ply \
 //thickness=0.18 //x=5.485 //y=0.755 //x2=5.6 //y2=0.755
r348 (  56 57 ) resistor r=110.245 //w=0.094 //l=0.215 //layer=ply \
 //thickness=0.18 //x=5.485 //y=0.755 //x2=5.27 //y2=0.755
r349 (  55 93 ) resistor r=45.1352 //w=0.168 //l=0.173853 //layer=ply \
 //thickness=0.18 //x=5.115 //y=1.22 //x2=5.155 //y2=1.375
r350 (  54 92 ) resistor r=45.1352 //w=0.168 //l=0.173853 //layer=ply \
 //thickness=0.18 //x=5.115 //y=0.91 //x2=5.155 //y2=0.755
r351 (  54 55 ) resistor r=158.957 //w=0.094 //l=0.31 //layer=ply \
 //thickness=0.18 //x=5.115 //y=0.91 //x2=5.115 //y2=1.22
r352 (  53 87 ) resistor r=592.245 //w=0.094 //l=1.155 //layer=ply \
 //thickness=0.18 //x=15.28 //y=6.02 //x2=15.28 //y2=4.865
r353 (  52 111 ) resistor r=592.245 //w=0.094 //l=1.155 //layer=ply \
 //thickness=0.18 //x=14.84 //y=6.02 //x2=14.84 //y2=4.865
r354 (  51 70 ) resistor r=592.245 //w=0.094 //l=1.155 //layer=ply \
 //thickness=0.18 //x=5.96 //y=6.02 //x2=5.96 //y2=4.865
r355 (  50 98 ) resistor r=592.245 //w=0.094 //l=1.155 //layer=ply \
 //thickness=0.18 //x=5.52 //y=6.02 //x2=5.52 //y2=4.865
r356 (  49 84 ) resistor r=56.4043 //w=0.094 //l=0.11 //layer=ply \
 //thickness=0.18 //x=15.1 //y=1.405 //x2=15.21 //y2=1.405
r357 (  49 85 ) resistor r=56.4043 //w=0.094 //l=0.11 //layer=ply \
 //thickness=0.18 //x=15.1 //y=1.405 //x2=14.99 //y2=1.405
r358 (  48 58 ) resistor r=55.3787 //w=0.094 //l=0.108 //layer=ply \
 //thickness=0.18 //x=5.377 //y=1.375 //x2=5.485 //y2=1.375
r359 (  48 59 ) resistor r=54.866 //w=0.094 //l=0.107 //layer=ply \
 //thickness=0.18 //x=5.377 //y=1.375 //x2=5.27 //y2=1.375
r360 (  44 108 ) resistor r=152 //w=0.17 //l=0.17 //layer=licon //count=1 \
 //x=14.83 //y=4.7 //x2=14.83 //y2=4.7
r361 (  39 104 ) resistor r=152 //w=0.17 //l=0.17 //layer=licon //count=1 \
 //x=14.8 //y=2.08 //x2=14.8 //y2=2.08
r362 (  34 95 ) resistor r=152 //w=0.17 //l=0.17 //layer=licon //count=1 \
 //x=5.55 //y=4.7 //x2=5.55 //y2=4.7
r363 (  29 102 ) resistor r=152 //w=0.17 //l=0.17 //layer=licon //count=1 \
 //x=5.55 //y=2.08 //x2=5.55 //y2=2.08
r364 (  23 25 ) resistor r=0.0546116 //w=0.309 //l=0.135 //layer=m2 \
 //thickness=0.36 //x=5.55 //y=4.44 //x2=5.55 //y2=4.575
r365 (  21 27 ) resistor r=5.04583 //w=0.179 //l=7.25992 //layer=m2 \
 //thickness=0.36 //x=7.61 //y=4.455 //x2=14.835 //y2=4.525
r366 (  21 22 ) resistor r=0.329198 //w=0.131 //l=0.345 //layer=m2 \
 //thickness=0.36 //x=7.61 //y=4.455 //x2=7.265 //y2=4.455
r367 (  20 23 ) resistor r=0.0433913 //w=0.309 //l=0.16 //layer=m2 \
 //thickness=0.36 //x=5.71 //y=4.44 //x2=5.55 //y2=4.44
r368 (  19 22 ) resistor r=0.1875 //w=0.17 //l=0.262393 //layer=m2 \
 //thickness=0.36 //x=7.01 //y=4.44 //x2=7.265 //y2=4.455
r369 (  19 20 ) resistor r=1.24046 //w=0.131 //l=1.3 //layer=m2 \
 //thickness=0.36 //x=7.01 //y=4.44 //x2=5.71 //y2=4.44
r370 (  18 44 ) resistor r=9.3 //w=0.17 //l=0.17 //layer=mcon //count=1 \
 //x=14.83 //y=4.7 //x2=14.83 //y2=4.7
r371 (  16 27 ) resistor r=4.5 //w=0.15 //l=0.15 //layer=via1 //count=1 \
 //x=14.835 //y=4.57 //x2=14.835 //y2=4.57
r372 (  16 18 ) resistor r=0.0547138 //w=0.297 //l=0.13 //layer=m1 \
 //thickness=0.36 //x=14.835 //y=4.57 //x2=14.835 //y2=4.7
r373 (  12 39 ) resistor r=9.3 //w=0.17 //l=0.17 //layer=mcon //count=1 \
 //x=14.8 //y=2.08 //x2=14.8 //y2=2.08
r374 (  12 14 ) resistor r=0.0936408 //w=0.196 //l=0.125 //layer=m1 \
 //thickness=0.36 //x=14.802 //y=2.08 //x2=14.802 //y2=2.205
r375 (  10 34 ) resistor r=9.3 //w=0.17 //l=0.17 //layer=mcon //count=1 \
 //x=5.55 //y=4.7 //x2=5.55 //y2=4.7
r376 (  8 25 ) resistor r=4.5 //w=0.15 //l=0.15 //layer=via1 //count=1 \
 //x=5.55 //y=4.575 //x2=5.55 //y2=4.575
r377 (  8 10 ) resistor r=0.0533276 //w=0.293 //l=0.125 //layer=m1 \
 //thickness=0.36 //x=5.55 //y=4.575 //x2=5.55 //y2=4.7
r378 (  6 29 ) resistor r=9.3 //w=0.17 //l=0.17 //layer=mcon //count=1 \
 //x=5.55 //y=2.08 //x2=5.55 //y2=2.08
r379 (  4 16 ) resistor r=0.0900052 //w=0.297 //l=0.176635 //layer=m1 \
 //thickness=0.36 //x=14.8 //y=4.41 //x2=14.835 //y2=4.57
r380 (  4 14 ) resistor r=2.10401 //w=0.131 //l=2.205 //layer=m1 \
 //thickness=0.36 //x=14.8 //y=4.41 //x2=14.8 //y2=2.205
r381 (  2 8 ) resistor r=0.090103 //w=0.293 //l=0.16 //layer=m1 \
 //thickness=0.36 //x=5.55 //y=4.415 //x2=5.55 //y2=4.575
r382 (  1 6 ) resistor r=0.0715665 //w=0.226 //l=0.115996 //layer=m1 \
 //thickness=0.36 //x=5.55 //y=2.195 //x2=5.552 //y2=2.08
r383 (  1 2 ) resistor r=2.11832 //w=0.131 //l=2.22 //layer=m1 \
 //thickness=0.36 //x=5.55 //y=2.195 //x2=5.55 //y2=4.415
ends PM_DFFSNX1_PCELL\%noxref_3

subckt PM_DFFSNX1_PCELL\%noxref_4 ( 2 3 4 5 7 10 11 13 14 15 16 18 19 20 22 23 \
 26 34 35 38 41 47 50 54 57 58 60 63 67 71 72 75 84 89 97 105 122 131 135 136 \
 137 138 139 140 141 142 143 148 150 152 158 159 160 161 162 163 167 169 172 \
 173 178 179 182 196 199 201 202 203 )
c464 ( 199 0 ) capacitor c=0.00885916f //x=6.725 //y=0.915
c465 ( 196 0 ) capacitor c=0.0634117f //x=17.39 //y=4.7
c466 ( 182 0 ) capacitor c=0.0354953f //x=1.88 //y=4.7
c467 ( 179 0 ) capacitor c=0.0284095f //x=1.85 //y=1.915
c468 ( 178 0 ) capacitor c=0.0476356f //x=1.85 //y=2.08
c469 ( 173 0 ) capacitor c=0.0318956f //x=17.725 //y=1.21
c470 ( 172 0 ) capacitor c=0.0186809f //x=17.725 //y=0.865
c471 ( 169 0 ) capacitor c=0.0141821f //x=17.57 //y=1.365
c472 ( 167 0 ) capacitor c=0.0158553f //x=17.57 //y=0.71
c473 ( 163 0 ) capacitor c=0.088055f //x=17.195 //y=1.915
c474 ( 162 0 ) capacitor c=0.0229235f //x=17.195 //y=1.52
c475 ( 161 0 ) capacitor c=0.0234359f //x=17.195 //y=1.21
c476 ( 160 0 ) capacitor c=0.0198759f //x=17.195 //y=0.865
c477 ( 159 0 ) capacitor c=0.0439708f //x=2.415 //y=1.25
c478 ( 158 0 ) capacitor c=0.0192582f //x=2.415 //y=0.905
c479 ( 152 0 ) capacitor c=0.0162526f //x=2.26 //y=1.405
c480 ( 150 0 ) capacitor c=0.0157807f //x=2.26 //y=0.75
c481 ( 148 0 ) capacitor c=0.0357885f //x=2.255 //y=4.79
c482 ( 143 0 ) capacitor c=0.0210762f //x=1.885 //y=1.56
c483 ( 142 0 ) capacitor c=0.0168511f //x=1.885 //y=1.25
c484 ( 141 0 ) capacitor c=0.0175485f //x=1.885 //y=0.905
c485 ( 140 0 ) capacitor c=0.110369f //x=17.73 //y=6.02
c486 ( 139 0 ) capacitor c=0.154619f //x=17.29 //y=6.02
c487 ( 138 0 ) capacitor c=0.155269f //x=2.33 //y=6.02
c488 ( 137 0 ) capacitor c=0.110375f //x=1.89 //y=6.02
c489 ( 131 0 ) capacitor c=5.44873e-19 //x=17.39 //y=4.7
c490 ( 122 0 ) capacitor c=7.85889e-19 //x=17.39 //y=2.08
c491 ( 105 0 ) capacitor c=0.0293709f //x=6.62 //y=5.38
c492 ( 97 0 ) capacitor c=0.029137f //x=5.74 //y=5.38
c493 ( 89 0 ) capacitor c=0.0277605f //x=4.86 //y=5.38
c494 ( 84 0 ) capacitor c=5.80955e-19 //x=1.88 //y=4.7
c495 ( 75 0 ) capacitor c=5.78095e-19 //x=1.85 //y=2.08
c496 ( 72 0 ) capacitor c=0.135006f //x=17.23 //y=4.085
c497 ( 71 0 ) capacitor c=0.00334332f //x=17.39 //y=4.085
c498 ( 67 0 ) capacitor c=0.00476965f //x=2.01 //y=4.065
c499 ( 63 0 ) capacitor c=9.20866e-19 //x=7.555 //y=4.07
c500 ( 60 0 ) capacitor c=0.14481f //x=7.235 //y=4.07
c501 ( 58 0 ) capacitor c=0.00689242f //x=17.392 //y=4.56
c502 ( 57 0 ) capacitor c=0.00587099f //x=17.39 //y=4.7
c503 ( 54 0 ) capacitor c=0.00463527f //x=17.39 //y=2.08
c504 ( 50 0 ) capacitor c=0.0145916f //x=17.39 //y=4.07
c505 ( 47 0 ) capacitor c=0.0149923f //x=7.395 //y=4.07
c506 ( 41 0 ) capacitor c=8.88597e-19 //x=6.62 //y=5.155
c507 ( 38 0 ) capacitor c=0.0073827f //x=5.74 //y=5.155
c508 ( 35 0 ) capacitor c=0.0115084f //x=4.862 //y=5.155
c509 ( 34 0 ) capacitor c=0.0143718f //x=1.85 //y=4.07
c510 ( 26 0 ) capacitor c=0.00662206f //x=1.85 //y=2.08
c511 ( 23 0 ) capacitor c=0.0118475f //x=17.39 //y=4.245
c512 ( 22 0 ) capacitor c=0.0532908f //x=17.39 //y=3.925
c513 ( 20 0 ) capacitor c=0.0222419f //x=7.4 //y=5.07
c514 ( 19 0 ) capacitor c=0.0128722f //x=7.4 //y=4.23
c515 ( 18 0 ) capacitor c=0.0651849f //x=7.4 //y=3.91
c516 ( 16 0 ) capacitor c=0.00537187f //x=7 //y=1.665
c517 ( 15 0 ) capacitor c=0.0148432f //x=7.315 //y=1.665
c518 ( 14 0 ) capacitor c=0.0167333f //x=6.915 //y=1.58
c519 ( 13 0 ) capacitor c=0.0111291f //x=6.915 //y=1.125
c520 ( 11 0 ) capacitor c=0.0223199f //x=7.315 //y=5.155
c521 ( 10 0 ) capacitor c=0.00933983f //x=6.62 //y=5.38
c522 ( 7 0 ) capacitor c=0.019596f //x=6.505 //y=5.155
c523 ( 5 0 ) capacitor c=0.0150448f //x=5.62 //y=5.155
c524 ( 4 0 ) capacitor c=0.00990813f //x=1.85 //y=4.555
c525 ( 3 0 ) capacitor c=0.00972081f //x=1.85 //y=4.225
c526 ( 2 0 ) capacitor c=0.0435661f //x=1.85 //y=3.905
r527 (  194 196 ) resistor r=20.6867 //w=0.233 //l=0.1 //layer=ply \
 //thickness=0.18 //x=17.29 //y=4.7 //x2=17.39 //y2=4.7
r528 (  184 185 ) resistor r=32.4568 //w=0.214 //l=0.075 //layer=ply \
 //thickness=0.18 //x=1.88 //y=4.79 //x2=1.88 //y2=4.865
r529 (  182 184 ) resistor r=20.271 //w=0.214 //l=0.09 //layer=ply \
 //thickness=0.18 //x=1.88 //y=4.7 //x2=1.88 //y2=4.79
r530 (  178 179 ) resistor r=52.7279 //w=0.214 //l=0.165 //layer=ply \
 //thickness=0.18 //x=1.85 //y=2.08 //x2=1.85 //y2=1.915
r531 (  174 196 ) resistor r=70.3348 //w=0.233 //l=0.414367 //layer=ply \
 //thickness=0.18 //x=17.73 //y=4.865 //x2=17.39 //y2=4.7
r532 (  173 198 ) resistor r=45.1352 //w=0.168 //l=0.173853 //layer=ply \
 //thickness=0.18 //x=17.725 //y=1.21 //x2=17.685 //y2=1.365
r533 (  172 197 ) resistor r=45.1352 //w=0.168 //l=0.173853 //layer=ply \
 //thickness=0.18 //x=17.725 //y=0.865 //x2=17.685 //y2=0.71
r534 (  172 173 ) resistor r=176.904 //w=0.094 //l=0.345 //layer=ply \
 //thickness=0.18 //x=17.725 //y=0.865 //x2=17.725 //y2=1.21
r535 (  170 193 ) resistor r=10.701 //w=0.21 //l=0.115 //layer=ply \
 //thickness=0.18 //x=17.35 //y=1.365 //x2=17.235 //y2=1.365
r536 (  169 198 ) resistor r=5.52526 //w=0.168 //l=0.115 //layer=ply \
 //thickness=0.18 //x=17.57 //y=1.365 //x2=17.685 //y2=1.365
r537 (  168 192 ) resistor r=5.52526 //w=0.168 //l=0.115 //layer=ply \
 //thickness=0.18 //x=17.35 //y=0.71 //x2=17.235 //y2=0.71
r538 (  167 197 ) resistor r=5.52526 //w=0.168 //l=0.115 //layer=ply \
 //thickness=0.18 //x=17.57 //y=0.71 //x2=17.685 //y2=0.71
r539 (  167 168 ) resistor r=112.809 //w=0.094 //l=0.22 //layer=ply \
 //thickness=0.18 //x=17.57 //y=0.71 //x2=17.35 //y2=0.71
r540 (  164 194 ) resistor r=13.0941 //w=0.233 //l=0.165 //layer=ply \
 //thickness=0.18 //x=17.29 //y=4.865 //x2=17.29 //y2=4.7
r541 (  163 191 ) resistor r=34.8111 //w=0.27 //l=0.264953 //layer=ply \
 //thickness=0.18 //x=17.195 //y=1.915 //x2=17.39 //y2=2.08
r542 (  162 193 ) resistor r=39.5823 //w=0.21 //l=0.173853 //layer=ply \
 //thickness=0.18 //x=17.195 //y=1.52 //x2=17.235 //y2=1.365
r543 (  162 163 ) resistor r=202.543 //w=0.094 //l=0.395 //layer=ply \
 //thickness=0.18 //x=17.195 //y=1.52 //x2=17.195 //y2=1.915
r544 (  161 193 ) resistor r=39.5823 //w=0.21 //l=0.173853 //layer=ply \
 //thickness=0.18 //x=17.195 //y=1.21 //x2=17.235 //y2=1.365
r545 (  160 192 ) resistor r=45.1352 //w=0.168 //l=0.173853 //layer=ply \
 //thickness=0.18 //x=17.195 //y=0.865 //x2=17.235 //y2=0.71
r546 (  160 161 ) resistor r=176.904 //w=0.094 //l=0.345 //layer=ply \
 //thickness=0.18 //x=17.195 //y=0.865 //x2=17.195 //y2=1.21
r547 (  159 189 ) resistor r=45.1352 //w=0.168 //l=0.173853 //layer=ply \
 //thickness=0.18 //x=2.415 //y=1.25 //x2=2.375 //y2=1.405
r548 (  158 188 ) resistor r=45.1352 //w=0.168 //l=0.173853 //layer=ply \
 //thickness=0.18 //x=2.415 //y=0.905 //x2=2.375 //y2=0.75
r549 (  158 159 ) resistor r=176.904 //w=0.094 //l=0.345 //layer=ply \
 //thickness=0.18 //x=2.415 //y=0.905 //x2=2.415 //y2=1.25
r550 (  153 187 ) resistor r=10.701 //w=0.21 //l=0.115 //layer=ply \
 //thickness=0.18 //x=2.04 //y=1.405 //x2=1.925 //y2=1.405
r551 (  152 189 ) resistor r=5.52526 //w=0.168 //l=0.115 //layer=ply \
 //thickness=0.18 //x=2.26 //y=1.405 //x2=2.375 //y2=1.405
r552 (  151 186 ) resistor r=5.52526 //w=0.168 //l=0.115 //layer=ply \
 //thickness=0.18 //x=2.04 //y=0.75 //x2=1.925 //y2=0.75
r553 (  150 188 ) resistor r=5.52526 //w=0.168 //l=0.115 //layer=ply \
 //thickness=0.18 //x=2.26 //y=0.75 //x2=2.375 //y2=0.75
r554 (  150 151 ) resistor r=112.809 //w=0.094 //l=0.22 //layer=ply \
 //thickness=0.18 //x=2.26 //y=0.75 //x2=2.04 //y2=0.75
r555 (  149 184 ) resistor r=16.5046 //w=0.27 //l=0.135 //layer=ply \
 //thickness=0.18 //x=2.015 //y=4.79 //x2=1.88 //y2=4.79
r556 (  148 155 ) resistor r=26.9307 //w=0.15 //l=0.106066 //layer=ply \
 //thickness=0.18 //x=2.255 //y=4.79 //x2=2.33 //y2=4.865
r557 (  148 149 ) resistor r=123.064 //w=0.094 //l=0.24 //layer=ply \
 //thickness=0.18 //x=2.255 //y=4.79 //x2=2.015 //y2=4.79
r558 (  143 187 ) resistor r=39.5823 //w=0.21 //l=0.173853 //layer=ply \
 //thickness=0.18 //x=1.885 //y=1.56 //x2=1.925 //y2=1.405
r559 (  143 179 ) resistor r=182.032 //w=0.094 //l=0.355 //layer=ply \
 //thickness=0.18 //x=1.885 //y=1.56 //x2=1.885 //y2=1.915
r560 (  142 187 ) resistor r=39.5823 //w=0.21 //l=0.173853 //layer=ply \
 //thickness=0.18 //x=1.885 //y=1.25 //x2=1.925 //y2=1.405
r561 (  141 186 ) resistor r=45.1352 //w=0.168 //l=0.173853 //layer=ply \
 //thickness=0.18 //x=1.885 //y=0.905 //x2=1.925 //y2=0.75
r562 (  141 142 ) resistor r=176.904 //w=0.094 //l=0.345 //layer=ply \
 //thickness=0.18 //x=1.885 //y=0.905 //x2=1.885 //y2=1.25
r563 (  140 174 ) resistor r=592.245 //w=0.094 //l=1.155 //layer=ply \
 //thickness=0.18 //x=17.73 //y=6.02 //x2=17.73 //y2=4.865
r564 (  139 164 ) resistor r=592.245 //w=0.094 //l=1.155 //layer=ply \
 //thickness=0.18 //x=17.29 //y=6.02 //x2=17.29 //y2=4.865
r565 (  138 155 ) resistor r=592.245 //w=0.094 //l=1.155 //layer=ply \
 //thickness=0.18 //x=2.33 //y=6.02 //x2=2.33 //y2=4.865
r566 (  137 185 ) resistor r=592.245 //w=0.094 //l=1.155 //layer=ply \
 //thickness=0.18 //x=1.89 //y=6.02 //x2=1.89 //y2=4.865
r567 (  136 169 ) resistor r=56.4043 //w=0.094 //l=0.11 //layer=ply \
 //thickness=0.18 //x=17.46 //y=1.365 //x2=17.57 //y2=1.365
r568 (  136 170 ) resistor r=56.4043 //w=0.094 //l=0.11 //layer=ply \
 //thickness=0.18 //x=17.46 //y=1.365 //x2=17.35 //y2=1.365
r569 (  135 152 ) resistor r=56.4043 //w=0.094 //l=0.11 //layer=ply \
 //thickness=0.18 //x=2.15 //y=1.405 //x2=2.26 //y2=1.405
r570 (  135 153 ) resistor r=56.4043 //w=0.094 //l=0.11 //layer=ply \
 //thickness=0.18 //x=2.15 //y=1.405 //x2=2.04 //y2=1.405
r571 (  131 196 ) resistor r=152 //w=0.17 //l=0.17 //layer=licon //count=1 \
 //x=17.39 //y=4.7 //x2=17.39 //y2=4.7
r572 (  122 191 ) resistor r=152 //w=0.17 //l=0.17 //layer=licon //count=1 \
 //x=17.39 //y=2.08 //x2=17.39 //y2=2.08
r573 (  105 203 ) resistor r=23.615 //w=0.187 //l=0.345 //layer=li \
 //thickness=0.1 //x=6.62 //y=5.38 //x2=6.62 //y2=5.725
r574 (  97 202 ) resistor r=23.615 //w=0.187 //l=0.345 //layer=li \
 //thickness=0.1 //x=5.74 //y=5.38 //x2=5.74 //y2=5.725
r575 (  89 201 ) resistor r=23.615 //w=0.187 //l=0.345 //layer=li \
 //thickness=0.1 //x=4.86 //y=5.38 //x2=4.86 //y2=5.725
r576 (  84 182 ) resistor r=152 //w=0.17 //l=0.17 //layer=licon //count=1 \
 //x=1.88 //y=4.7 //x2=1.88 //y2=4.7
r577 (  75 178 ) resistor r=152 //w=0.17 //l=0.17 //layer=licon //count=1 \
 //x=1.85 //y=2.08 //x2=1.85 //y2=2.08
r578 (  71 72 ) resistor r=0.10734 //w=0.281 //l=0.16 //layer=m2 \
 //thickness=0.36 //x=17.39 //y=4.085 //x2=17.23 //y2=4.085
r579 (  65 67 ) resistor r=0.10734 //w=0.281 //l=0.16 //layer=m2 \
 //thickness=0.36 //x=1.85 //y=4.065 //x2=2.01 //y2=4.065
r580 (  63 69 ) resistor r=0.10734 //w=0.281 //l=0.16 //layer=m2 \
 //thickness=0.36 //x=7.555 //y=4.07 //x2=7.395 //y2=4.07
r581 (  63 72 ) resistor r=9.23187 //w=0.131 //l=9.675 //layer=m2 \
 //thickness=0.36 //x=7.555 //y=4.07 //x2=17.23 //y2=4.07
r582 (  60 69 ) resistor r=0.10734 //w=0.281 //l=0.16 //layer=m2 \
 //thickness=0.36 //x=7.235 //y=4.07 //x2=7.395 //y2=4.07
r583 (  60 67 ) resistor r=4.98569 //w=0.131 //l=5.225 //layer=m2 \
 //thickness=0.36 //x=7.235 //y=4.07 //x2=2.01 //y2=4.07
r584 (  57 131 ) resistor r=9.3 //w=0.17 //l=0.17 //layer=mcon //count=1 \
 //x=17.39 //y=4.7 //x2=17.39 //y2=4.7
r585 (  57 58 ) resistor r=0.103207 //w=0.196 //l=0.14 //layer=m1 \
 //thickness=0.36 //x=17.392 //y=4.7 //x2=17.392 //y2=4.56
r586 (  54 122 ) resistor r=9.3 //w=0.17 //l=0.17 //layer=mcon //count=1 \
 //x=17.39 //y=2.08 //x2=17.39 //y2=2.08
r587 (  52 71 ) resistor r=4.5 //w=0.15 //l=0.15 //layer=via1 //count=1 \
 //x=17.39 //y=4.085 //x2=17.39 //y2=4.085
r588 (  50 52 ) resistor r=0.0049867 //w=0.376 //l=0.015 //layer=m1 \
 //thickness=0.36 //x=17.337 //y=4.07 //x2=17.337 //y2=4.085
r589 (  47 69 ) resistor r=4.5 //w=0.15 //l=0.15 //layer=via1 //count=1 \
 //x=7.395 //y=4.07 //x2=7.395 //y2=4.07
r590 (  45 199 ) resistor r=9.3 //w=0.17 //l=0.17 //layer=mcon //count=1 \
 //x=6.915 //y=1.01 //x2=6.915 //y2=1.01
r591 (  43 105 ) resistor r=9.3 //w=0.17 //l=0.17 //layer=mcon //count=1 \
 //x=6.62 //y=5.38 //x2=6.62 //y2=5.38
r592 (  40 97 ) resistor r=9.3 //w=0.17 //l=0.17 //layer=mcon //count=1 \
 //x=5.74 //y=5.38 //x2=5.74 //y2=5.38
r593 (  38 40 ) resistor r=0.121228 //w=0.232 //l=0.225 //layer=m1 \
 //thickness=0.36 //x=5.74 //y=5.155 //x2=5.74 //y2=5.38
r594 (  37 89 ) resistor r=9.3 //w=0.17 //l=0.17 //layer=mcon //count=1 \
 //x=4.86 //y=5.38 //x2=4.86 //y2=5.38
r595 (  35 37 ) resistor r=0.129608 //w=0.217 //l=0.225 //layer=m1 \
 //thickness=0.36 //x=4.862 //y=5.155 //x2=4.862 //y2=5.38
r596 (  32 65 ) resistor r=4.5 //w=0.15 //l=0.15 //layer=via1 //count=1 \
 //x=1.85 //y=4.065 //x2=1.85 //y2=4.065
r597 (  32 34 ) resistor r=0.00166223 //w=0.376 //l=0.005 //layer=m1 \
 //thickness=0.36 //x=1.902 //y=4.065 //x2=1.902 //y2=4.07
r598 (  30 84 ) resistor r=9.3 //w=0.17 //l=0.17 //layer=mcon //count=1 \
 //x=1.88 //y=4.7 //x2=1.88 //y2=4.7
r599 (  26 75 ) resistor r=9.3 //w=0.17 //l=0.17 //layer=mcon //count=1 \
 //x=1.85 //y=2.08 //x2=1.85 //y2=2.08
r600 (  26 28 ) resistor r=0.0936408 //w=0.196 //l=0.125 //layer=m1 \
 //thickness=0.36 //x=1.852 //y=2.08 //x2=1.852 //y2=2.205
r601 (  23 52 ) resistor r=0.0911593 //w=0.376 //l=0.184608 //layer=m1 \
 //thickness=0.36 //x=17.39 //y=4.245 //x2=17.337 //y2=4.085
r602 (  23 58 ) resistor r=0.300573 //w=0.131 //l=0.315 //layer=m1 \
 //thickness=0.36 //x=17.39 //y=4.245 //x2=17.39 //y2=4.56
r603 (  22 50 ) resistor r=0.0861726 //w=0.376 //l=0.16944 //layer=m1 \
 //thickness=0.36 //x=17.39 //y=3.925 //x2=17.337 //y2=4.07
r604 (  21 54 ) resistor r=0.0933015 //w=0.201 //l=0.125 //layer=m1 \
 //thickness=0.36 //x=17.39 //y=2.205 //x2=17.39 //y2=2.08
r605 (  21 22 ) resistor r=1.64122 //w=0.131 //l=1.72 //layer=m1 \
 //thickness=0.36 //x=17.39 //y=2.205 //x2=17.39 //y2=3.925
r606 (  19 47 ) resistor r=0.0911593 //w=0.376 //l=0.181989 //layer=m1 \
 //thickness=0.36 //x=7.4 //y=4.23 //x2=7.447 //y2=4.07
r607 (  19 20 ) resistor r=0.801527 //w=0.131 //l=0.84 //layer=m1 \
 //thickness=0.36 //x=7.4 //y=4.23 //x2=7.4 //y2=5.07
r608 (  18 47 ) resistor r=0.0911593 //w=0.376 //l=0.181989 //layer=m1 \
 //thickness=0.36 //x=7.4 //y=3.91 //x2=7.447 //y2=4.07
r609 (  17 18 ) resistor r=2.06107 //w=0.131 //l=2.16 //layer=m1 \
 //thickness=0.36 //x=7.4 //y=1.75 //x2=7.4 //y2=3.91
r610 (  15 17 ) resistor r=0.0698411 //w=0.17 //l=0.120208 //layer=m1 \
 //thickness=0.36 //x=7.315 //y=1.665 //x2=7.4 //y2=1.75
r611 (  15 16 ) resistor r=0.300573 //w=0.131 //l=0.315 //layer=m1 \
 //thickness=0.36 //x=7.315 //y=1.665 //x2=7 //y2=1.665
r612 (  14 16 ) resistor r=0.0698411 //w=0.17 //l=0.120208 //layer=m1 \
 //thickness=0.36 //x=6.915 //y=1.58 //x2=7 //y2=1.665
r613 (  13 45 ) resistor r=0.0717383 //w=0.224 //l=0.115 //layer=m1 \
 //thickness=0.36 //x=6.915 //y=1.125 //x2=6.915 //y2=1.01
r614 (  13 14 ) resistor r=0.43416 //w=0.131 //l=0.455 //layer=m1 \
 //thickness=0.36 //x=6.915 //y=1.125 //x2=6.915 //y2=1.58
r615 (  12 41 ) resistor r=0.0675342 //w=0.23 //l=0.115 //layer=m1 \
 //thickness=0.36 //x=6.735 //y=5.155 //x2=6.62 //y2=5.155
r616 (  11 20 ) resistor r=0.0698411 //w=0.17 //l=0.120208 //layer=m1 \
 //thickness=0.36 //x=7.315 //y=5.155 //x2=7.4 //y2=5.07
r617 (  11 12 ) resistor r=0.553435 //w=0.131 //l=0.58 //layer=m1 \
 //thickness=0.36 //x=7.315 //y=5.155 //x2=6.735 //y2=5.155
r618 (  10 43 ) resistor r=0.00118313 //w=0.23 //layer=m1 //thickness=0.36 \
 //x=6.62 //y=5.38 //x2=6.62 //y2=5.38
r619 (  9 41 ) resistor r=0.002872 //w=0.34 //l=0.085 //layer=m1 \
 //thickness=0.36 //x=6.62 //y=5.24 //x2=6.62 //y2=5.155
r620 (  9 10 ) resistor r=0.091623 //w=0.191 //l=0.14 //layer=m1 \
 //thickness=0.36 //x=6.62 //y=5.24 //x2=6.62 //y2=5.38
r621 (  8 38 ) resistor r=0.0262263 //w=0.232 //l=0.12 //layer=m1 \
 //thickness=0.36 //x=5.86 //y=5.155 //x2=5.74 //y2=5.155
r622 (  7 41 ) resistor r=0.0675342 //w=0.23 //l=0.115 //layer=m1 \
 //thickness=0.36 //x=6.505 //y=5.155 //x2=6.62 //y2=5.155
r623 (  7 8 ) resistor r=0.615458 //w=0.131 //l=0.645 //layer=m1 \
 //thickness=0.36 //x=6.505 //y=5.155 //x2=5.86 //y2=5.155
r624 (  6 35 ) resistor r=0.0222262 //w=0.217 //l=0.118 //layer=m1 \
 //thickness=0.36 //x=4.98 //y=5.155 //x2=4.862 //y2=5.155
r625 (  5 38 ) resistor r=0.0262263 //w=0.232 //l=0.12 //layer=m1 \
 //thickness=0.36 //x=5.62 //y=5.155 //x2=5.74 //y2=5.155
r626 (  5 6 ) resistor r=0.610687 //w=0.131 //l=0.64 //layer=m1 \
 //thickness=0.36 //x=5.62 //y=5.155 //x2=4.98 //y2=5.155
r627 (  4 30 ) resistor r=0.0878548 //w=0.228 //l=0.159295 //layer=m1 \
 //thickness=0.36 //x=1.85 //y=4.555 //x2=1.88 //y2=4.7
r628 (  3 34 ) resistor r=0.0894971 //w=0.376 //l=0.179123 //layer=m1 \
 //thickness=0.36 //x=1.85 //y=4.225 //x2=1.902 //y2=4.07
r629 (  3 4 ) resistor r=0.314885 //w=0.131 //l=0.33 //layer=m1 \
 //thickness=0.36 //x=1.85 //y=4.225 //x2=1.85 //y2=4.555
r630 (  2 32 ) resistor r=0.0911593 //w=0.376 //l=0.184174 //layer=m1 \
 //thickness=0.36 //x=1.85 //y=3.905 //x2=1.902 //y2=4.065
r631 (  2 28 ) resistor r=1.62214 //w=0.131 //l=1.7 //layer=m1 \
 //thickness=0.36 //x=1.85 //y=3.905 //x2=1.85 //y2=2.205
ends PM_DFFSNX1_PCELL\%noxref_4

subckt PM_DFFSNX1_PCELL\%noxref_5 ( 1 2 3 4 22 24 25 28 33 38 43 47 48 49 50 \
 51 52 53 54 55 57 63 64 65 66 67 72 73 74 76 82 83 84 85 86 94 105 )
c312 ( 105 0 ) capacitor c=0.0369044f //x=21.83 //y=4.7
c313 ( 94 0 ) capacitor c=0.0369044f //x=10.36 //y=4.7
c314 ( 86 0 ) capacitor c=0.0309248f //x=22.165 //y=4.79
c315 ( 85 0 ) capacitor c=0.0847377f //x=21.92 //y=1.915
c316 ( 84 0 ) capacitor c=0.0170266f //x=21.92 //y=1.45
c317 ( 83 0 ) capacitor c=0.018609f //x=21.92 //y=1.22
c318 ( 82 0 ) capacitor c=0.0186599f //x=21.92 //y=0.91
c319 ( 76 0 ) capacitor c=0.0146988f //x=21.765 //y=1.375
c320 ( 74 0 ) capacitor c=0.0148531f //x=21.765 //y=0.755
c321 ( 73 0 ) capacitor c=0.0334406f //x=21.395 //y=1.22
c322 ( 72 0 ) capacitor c=0.0173191f //x=21.395 //y=0.91
c323 ( 67 0 ) capacitor c=0.0309248f //x=10.695 //y=4.79
c324 ( 66 0 ) capacitor c=0.0845067f //x=10.45 //y=1.915
c325 ( 65 0 ) capacitor c=0.0170266f //x=10.45 //y=1.45
c326 ( 64 0 ) capacitor c=0.018609f //x=10.45 //y=1.22
c327 ( 63 0 ) capacitor c=0.0186599f //x=10.45 //y=0.91
c328 ( 57 0 ) capacitor c=0.0146988f //x=10.295 //y=1.375
c329 ( 55 0 ) capacitor c=0.0148531f //x=10.295 //y=0.755
c330 ( 54 0 ) capacitor c=0.0334406f //x=9.925 //y=1.22
c331 ( 53 0 ) capacitor c=0.0173191f //x=9.925 //y=0.91
c332 ( 52 0 ) capacitor c=0.110208f //x=22.24 //y=6.02
c333 ( 51 0 ) capacitor c=0.110214f //x=21.8 //y=6.02
c334 ( 50 0 ) capacitor c=0.110208f //x=10.77 //y=6.02
c335 ( 49 0 ) capacitor c=0.110214f //x=10.33 //y=6.02
c336 ( 43 0 ) capacitor c=0.00129934f //x=21.83 //y=4.7
c337 ( 38 0 ) capacitor c=0.00121786f //x=21.83 //y=2.08
c338 ( 33 0 ) capacitor c=0.00129934f //x=10.36 //y=4.7
c339 ( 28 0 ) capacitor c=0.00121786f //x=10.36 //y=2.08
c340 ( 25 0 ) capacitor c=0.303252f //x=21.66 //y=2.21
c341 ( 24 0 ) capacitor c=0.00542282f //x=21.82 //y=2.21
c342 ( 22 0 ) capacitor c=0.00542282f //x=10.52 //y=2.21
c343 ( 4 0 ) capacitor c=0.0762643f //x=21.83 //y=4.585
c344 ( 3 0 ) capacitor c=0.0114222f //x=21.83 //y=2.37
c345 ( 2 0 ) capacitor c=0.0687413f //x=10.36 //y=4.585
c346 ( 1 0 ) capacitor c=0.0112921f //x=10.36 //y=2.37
r347 (  107 108 ) resistor r=32.4568 //w=0.214 //l=0.075 //layer=ply \
 //thickness=0.18 //x=21.83 //y=4.79 //x2=21.83 //y2=4.865
r348 (  105 107 ) resistor r=20.271 //w=0.214 //l=0.09 //layer=ply \
 //thickness=0.18 //x=21.83 //y=4.7 //x2=21.83 //y2=4.79
r349 (  96 97 ) resistor r=32.4568 //w=0.214 //l=0.075 //layer=ply \
 //thickness=0.18 //x=10.36 //y=4.79 //x2=10.36 //y2=4.865
r350 (  94 96 ) resistor r=20.271 //w=0.214 //l=0.09 //layer=ply \
 //thickness=0.18 //x=10.36 //y=4.7 //x2=10.36 //y2=4.79
r351 (  87 107 ) resistor r=16.5046 //w=0.27 //l=0.135 //layer=ply \
 //thickness=0.18 //x=21.965 //y=4.79 //x2=21.83 //y2=4.79
r352 (  86 88 ) resistor r=26.9307 //w=0.15 //l=0.106066 //layer=ply \
 //thickness=0.18 //x=22.165 //y=4.79 //x2=22.24 //y2=4.865
r353 (  86 87 ) resistor r=102.553 //w=0.094 //l=0.2 //layer=ply \
 //thickness=0.18 //x=22.165 //y=4.79 //x2=21.965 //y2=4.79
r354 (  85 112 ) resistor r=38.6777 //w=0.284 //l=0.198997 //layer=ply \
 //thickness=0.18 //x=21.92 //y=1.915 //x2=21.845 //y2=2.08
r355 (  84 110 ) resistor r=21.2976 //w=0.217 //l=0.0928709 //layer=ply \
 //thickness=0.18 //x=21.92 //y=1.45 //x2=21.88 //y2=1.375
r356 (  84 85 ) resistor r=238.436 //w=0.094 //l=0.465 //layer=ply \
 //thickness=0.18 //x=21.92 //y=1.45 //x2=21.92 //y2=1.915
r357 (  83 110 ) resistor r=39.0671 //w=0.217 //l=0.173853 //layer=ply \
 //thickness=0.18 //x=21.92 //y=1.22 //x2=21.88 //y2=1.375
r358 (  82 109 ) resistor r=45.1352 //w=0.168 //l=0.173853 //layer=ply \
 //thickness=0.18 //x=21.92 //y=0.91 //x2=21.88 //y2=0.755
r359 (  82 83 ) resistor r=158.957 //w=0.094 //l=0.31 //layer=ply \
 //thickness=0.18 //x=21.92 //y=0.91 //x2=21.92 //y2=1.22
r360 (  77 103 ) resistor r=5.52526 //w=0.168 //l=0.115 //layer=ply \
 //thickness=0.18 //x=21.55 //y=1.375 //x2=21.435 //y2=1.375
r361 (  76 110 ) resistor r=11.4558 //w=0.217 //l=0.115 //layer=ply \
 //thickness=0.18 //x=21.765 //y=1.375 //x2=21.88 //y2=1.375
r362 (  75 102 ) resistor r=5.52526 //w=0.168 //l=0.115 //layer=ply \
 //thickness=0.18 //x=21.55 //y=0.755 //x2=21.435 //y2=0.755
r363 (  74 109 ) resistor r=5.52526 //w=0.168 //l=0.115 //layer=ply \
 //thickness=0.18 //x=21.765 //y=0.755 //x2=21.88 //y2=0.755
r364 (  74 75 ) resistor r=110.245 //w=0.094 //l=0.215 //layer=ply \
 //thickness=0.18 //x=21.765 //y=0.755 //x2=21.55 //y2=0.755
r365 (  73 103 ) resistor r=45.1352 //w=0.168 //l=0.173853 //layer=ply \
 //thickness=0.18 //x=21.395 //y=1.22 //x2=21.435 //y2=1.375
r366 (  72 102 ) resistor r=45.1352 //w=0.168 //l=0.173853 //layer=ply \
 //thickness=0.18 //x=21.395 //y=0.91 //x2=21.435 //y2=0.755
r367 (  72 73 ) resistor r=158.957 //w=0.094 //l=0.31 //layer=ply \
 //thickness=0.18 //x=21.395 //y=0.91 //x2=21.395 //y2=1.22
r368 (  68 96 ) resistor r=16.5046 //w=0.27 //l=0.135 //layer=ply \
 //thickness=0.18 //x=10.495 //y=4.79 //x2=10.36 //y2=4.79
r369 (  67 69 ) resistor r=26.9307 //w=0.15 //l=0.106066 //layer=ply \
 //thickness=0.18 //x=10.695 //y=4.79 //x2=10.77 //y2=4.865
r370 (  67 68 ) resistor r=102.553 //w=0.094 //l=0.2 //layer=ply \
 //thickness=0.18 //x=10.695 //y=4.79 //x2=10.495 //y2=4.79
r371 (  66 101 ) resistor r=38.6777 //w=0.284 //l=0.198997 //layer=ply \
 //thickness=0.18 //x=10.45 //y=1.915 //x2=10.375 //y2=2.08
r372 (  65 99 ) resistor r=21.2976 //w=0.217 //l=0.0928709 //layer=ply \
 //thickness=0.18 //x=10.45 //y=1.45 //x2=10.41 //y2=1.375
r373 (  65 66 ) resistor r=238.436 //w=0.094 //l=0.465 //layer=ply \
 //thickness=0.18 //x=10.45 //y=1.45 //x2=10.45 //y2=1.915
r374 (  64 99 ) resistor r=39.0671 //w=0.217 //l=0.173853 //layer=ply \
 //thickness=0.18 //x=10.45 //y=1.22 //x2=10.41 //y2=1.375
r375 (  63 98 ) resistor r=45.1352 //w=0.168 //l=0.173853 //layer=ply \
 //thickness=0.18 //x=10.45 //y=0.91 //x2=10.41 //y2=0.755
r376 (  63 64 ) resistor r=158.957 //w=0.094 //l=0.31 //layer=ply \
 //thickness=0.18 //x=10.45 //y=0.91 //x2=10.45 //y2=1.22
r377 (  58 92 ) resistor r=5.52526 //w=0.168 //l=0.115 //layer=ply \
 //thickness=0.18 //x=10.08 //y=1.375 //x2=9.965 //y2=1.375
r378 (  57 99 ) resistor r=11.4558 //w=0.217 //l=0.115 //layer=ply \
 //thickness=0.18 //x=10.295 //y=1.375 //x2=10.41 //y2=1.375
r379 (  56 91 ) resistor r=5.52526 //w=0.168 //l=0.115 //layer=ply \
 //thickness=0.18 //x=10.08 //y=0.755 //x2=9.965 //y2=0.755
r380 (  55 98 ) resistor r=5.52526 //w=0.168 //l=0.115 //layer=ply \
 //thickness=0.18 //x=10.295 //y=0.755 //x2=10.41 //y2=0.755
r381 (  55 56 ) resistor r=110.245 //w=0.094 //l=0.215 //layer=ply \
 //thickness=0.18 //x=10.295 //y=0.755 //x2=10.08 //y2=0.755
r382 (  54 92 ) resistor r=45.1352 //w=0.168 //l=0.173853 //layer=ply \
 //thickness=0.18 //x=9.925 //y=1.22 //x2=9.965 //y2=1.375
r383 (  53 91 ) resistor r=45.1352 //w=0.168 //l=0.173853 //layer=ply \
 //thickness=0.18 //x=9.925 //y=0.91 //x2=9.965 //y2=0.755
r384 (  53 54 ) resistor r=158.957 //w=0.094 //l=0.31 //layer=ply \
 //thickness=0.18 //x=9.925 //y=0.91 //x2=9.925 //y2=1.22
r385 (  52 88 ) resistor r=592.245 //w=0.094 //l=1.155 //layer=ply \
 //thickness=0.18 //x=22.24 //y=6.02 //x2=22.24 //y2=4.865
r386 (  51 108 ) resistor r=592.245 //w=0.094 //l=1.155 //layer=ply \
 //thickness=0.18 //x=21.8 //y=6.02 //x2=21.8 //y2=4.865
r387 (  50 69 ) resistor r=592.245 //w=0.094 //l=1.155 //layer=ply \
 //thickness=0.18 //x=10.77 //y=6.02 //x2=10.77 //y2=4.865
r388 (  49 97 ) resistor r=592.245 //w=0.094 //l=1.155 //layer=ply \
 //thickness=0.18 //x=10.33 //y=6.02 //x2=10.33 //y2=4.865
r389 (  48 76 ) resistor r=55.3787 //w=0.094 //l=0.108 //layer=ply \
 //thickness=0.18 //x=21.657 //y=1.375 //x2=21.765 //y2=1.375
r390 (  48 77 ) resistor r=54.866 //w=0.094 //l=0.107 //layer=ply \
 //thickness=0.18 //x=21.657 //y=1.375 //x2=21.55 //y2=1.375
r391 (  47 57 ) resistor r=55.3787 //w=0.094 //l=0.108 //layer=ply \
 //thickness=0.18 //x=10.187 //y=1.375 //x2=10.295 //y2=1.375
r392 (  47 58 ) resistor r=54.866 //w=0.094 //l=0.107 //layer=ply \
 //thickness=0.18 //x=10.187 //y=1.375 //x2=10.08 //y2=1.375
r393 (  43 105 ) resistor r=152 //w=0.17 //l=0.17 //layer=licon //count=1 \
 //x=21.83 //y=4.7 //x2=21.83 //y2=4.7
r394 (  38 112 ) resistor r=152 //w=0.17 //l=0.17 //layer=licon //count=1 \
 //x=21.83 //y=2.08 //x2=21.83 //y2=2.08
r395 (  33 94 ) resistor r=152 //w=0.17 //l=0.17 //layer=licon //count=1 \
 //x=10.36 //y=4.7 //x2=10.36 //y2=4.7
r396 (  28 101 ) resistor r=152 //w=0.17 //l=0.17 //layer=licon //count=1 \
 //x=10.36 //y=2.08 //x2=10.36 //y2=2.08
r397 (  24 25 ) resistor r=0.10734 //w=0.281 //l=0.16 //layer=m2 \
 //thickness=0.36 //x=21.82 //y=2.21 //x2=21.66 //y2=2.21
r398 (  22 25 ) resistor r=10.6298 //w=0.131 //l=11.14 //layer=m2 \
 //thickness=0.36 //x=10.52 //y=2.22 //x2=21.66 //y2=2.22
r399 (  20 22 ) resistor r=0.10734 //w=0.281 //l=0.16 //layer=m2 \
 //thickness=0.36 //x=10.36 //y=2.21 //x2=10.52 //y2=2.21
r400 (  16 24 ) resistor r=4.5 //w=0.15 //l=0.15 //layer=via1 //count=1 \
 //x=21.82 //y=2.21 //x2=21.82 //y2=2.21
r401 (  14 38 ) resistor r=9.3 //w=0.17 //l=0.17 //layer=mcon //count=1 \
 //x=21.83 //y=2.08 //x2=21.83 //y2=2.08
r402 (  14 16 ) resistor r=0.0560345 //w=0.29 //l=0.13 //layer=m1 \
 //thickness=0.36 //x=21.82 //y=2.08 //x2=21.82 //y2=2.21
r403 (  12 43 ) resistor r=9.3 //w=0.17 //l=0.17 //layer=mcon //count=1 \
 //x=21.83 //y=4.7 //x2=21.83 //y2=4.7
r404 (  10 20 ) resistor r=4.5 //w=0.15 //l=0.15 //layer=via1 //count=1 \
 //x=10.36 //y=2.21 //x2=10.36 //y2=2.21
r405 (  8 28 ) resistor r=9.3 //w=0.17 //l=0.17 //layer=mcon //count=1 \
 //x=10.36 //y=2.08 //x2=10.36 //y2=2.08
r406 (  8 10 ) resistor r=0.0560345 //w=0.29 //l=0.13 //layer=m1 \
 //thickness=0.36 //x=10.36 //y=2.08 //x2=10.36 //y2=2.21
r407 (  6 33 ) resistor r=9.3 //w=0.17 //l=0.17 //layer=mcon //count=1 \
 //x=10.36 //y=4.7 //x2=10.36 //y2=4.7
r408 (  4 12 ) resistor r=0.0717383 //w=0.224 //l=0.115 //layer=m1 \
 //thickness=0.36 //x=21.83 //y=4.585 //x2=21.83 //y2=4.7
r409 (  3 16 ) resistor r=0.0901908 //w=0.29 //l=0.164924 //layer=m1 \
 //thickness=0.36 //x=21.83 //y=2.37 //x2=21.82 //y2=2.21
r410 (  3 4 ) resistor r=2.11355 //w=0.131 //l=2.215 //layer=m1 \
 //thickness=0.36 //x=21.83 //y=2.37 //x2=21.83 //y2=4.585
r411 (  2 6 ) resistor r=0.0717383 //w=0.224 //l=0.115 //layer=m1 \
 //thickness=0.36 //x=10.36 //y=4.585 //x2=10.36 //y2=4.7
r412 (  1 10 ) resistor r=0.0901908 //w=0.29 //l=0.16 //layer=m1 \
 //thickness=0.36 //x=10.36 //y=2.37 //x2=10.36 //y2=2.21
r413 (  1 2 ) resistor r=2.11355 //w=0.131 //l=2.215 //layer=m1 \
 //thickness=0.36 //x=10.36 //y=2.37 //x2=10.36 //y2=4.585
ends PM_DFFSNX1_PCELL\%noxref_5

subckt PM_DFFSNX1_PCELL\%noxref_6 ( 1 2 3 4 5 6 7 8 11 16 17 19 20 22 23 24 25 \
 26 27 28 36 40 47 48 51 53 58 60 67 69 72 78 83 84 86 87 90 99 104 113 118 \
 126 143 152 156 157 158 159 160 161 162 163 164 168 169 170 175 177 180 181 \
 185 186 187 192 194 197 198 202 203 204 209 211 214 215 217 218 223 227 228 \
 233 237 238 243 246 248 249 )
c560 ( 246 0 ) capacitor c=0.00878249f //x=14.91 //y=0.905
c561 ( 243 0 ) capacitor c=0.0651477f //x=22.94 //y=4.7
c562 ( 238 0 ) capacitor c=0.0296417f //x=22.94 //y=1.915
c563 ( 237 0 ) capacitor c=0.0504963f //x=22.94 //y=2.08
c564 ( 233 0 ) capacitor c=0.0651619f //x=11.47 //y=4.7
c565 ( 228 0 ) capacitor c=0.0278202f //x=11.47 //y=1.915
c566 ( 227 0 ) capacitor c=0.0503043f //x=11.47 //y=2.08
c567 ( 223 0 ) capacitor c=0.0654765f //x=6.66 //y=4.7
c568 ( 218 0 ) capacitor c=0.0278202f //x=6.66 //y=1.915
c569 ( 217 0 ) capacitor c=0.0503043f //x=6.66 //y=2.08
c570 ( 215 0 ) capacitor c=0.0443175f //x=23.46 //y=1.26
c571 ( 214 0 ) capacitor c=0.0199703f //x=23.46 //y=0.915
c572 ( 211 0 ) capacitor c=0.0162526f //x=23.305 //y=1.415
c573 ( 209 0 ) capacitor c=0.0157807f //x=23.305 //y=0.76
c574 ( 204 0 ) capacitor c=0.0220935f //x=22.93 //y=1.57
c575 ( 203 0 ) capacitor c=0.0207489f //x=22.93 //y=1.26
c576 ( 202 0 ) capacitor c=0.0194091f //x=22.93 //y=0.915
c577 ( 198 0 ) capacitor c=0.0443175f //x=11.99 //y=1.26
c578 ( 197 0 ) capacitor c=0.0199703f //x=11.99 //y=0.915
c579 ( 194 0 ) capacitor c=0.0162526f //x=11.835 //y=1.415
c580 ( 192 0 ) capacitor c=0.0157807f //x=11.835 //y=0.76
c581 ( 187 0 ) capacitor c=0.0220935f //x=11.46 //y=1.57
c582 ( 186 0 ) capacitor c=0.0207489f //x=11.46 //y=1.26
c583 ( 185 0 ) capacitor c=0.0194091f //x=11.46 //y=0.915
c584 ( 181 0 ) capacitor c=0.0443175f //x=7.18 //y=1.26
c585 ( 180 0 ) capacitor c=0.0199703f //x=7.18 //y=0.915
c586 ( 177 0 ) capacitor c=0.0162526f //x=7.025 //y=1.415
c587 ( 175 0 ) capacitor c=0.0157807f //x=7.025 //y=0.76
c588 ( 170 0 ) capacitor c=0.0220935f //x=6.65 //y=1.57
c589 ( 169 0 ) capacitor c=0.0207489f //x=6.65 //y=1.26
c590 ( 168 0 ) capacitor c=0.0194091f //x=6.65 //y=0.915
c591 ( 164 0 ) capacitor c=0.161796f //x=23.12 //y=6.02
c592 ( 163 0 ) capacitor c=0.110208f //x=22.68 //y=6.02
c593 ( 162 0 ) capacitor c=0.159671f //x=11.65 //y=6.02
c594 ( 161 0 ) capacitor c=0.110208f //x=11.21 //y=6.02
c595 ( 160 0 ) capacitor c=0.159671f //x=6.84 //y=6.02
c596 ( 159 0 ) capacitor c=0.110208f //x=6.4 //y=6.02
c597 ( 152 0 ) capacitor c=7.74199e-19 //x=22.94 //y=4.7
c598 ( 143 0 ) capacitor c=0.00101179f //x=22.94 //y=2.08
c599 ( 126 0 ) capacitor c=0.0319332f //x=15.06 //y=5.38
c600 ( 118 0 ) capacitor c=0.0290186f //x=14.18 //y=5.38
c601 ( 113 0 ) capacitor c=7.74199e-19 //x=11.47 //y=4.7
c602 ( 104 0 ) capacitor c=0.00101179f //x=11.47 //y=2.08
c603 ( 99 0 ) capacitor c=7.74199e-19 //x=6.66 //y=4.7
c604 ( 90 0 ) capacitor c=0.00101179f //x=6.66 //y=2.08
c605 ( 87 0 ) capacitor c=0.211871f //x=22.78 //y=3.705
c606 ( 86 0 ) capacitor c=0.00456904f //x=22.94 //y=3.705
c607 ( 84 0 ) capacitor c=0.00100407f //x=15.695 //y=3.685
c608 ( 83 0 ) capacitor c=0.0529145f //x=15.375 //y=3.685
c609 ( 78 0 ) capacitor c=9.19301e-19 //x=6.825 //y=3.685
c610 ( 72 0 ) capacitor c=0.068274f //x=11.63 //y=3.7
c611 ( 69 0 ) capacitor c=0.00379043f //x=7.61 //y=3.685
c612 ( 67 0 ) capacitor c=0.0033427f //x=7.01 //y=3.7
c613 ( 60 0 ) capacitor c=0.0149589f //x=22.94 //y=3.7
c614 ( 58 0 ) capacitor c=0.0158493f //x=15.54 //y=3.7
c615 ( 53 0 ) capacitor c=0.0113632f //x=15.1 //y=1
c616 ( 51 0 ) capacitor c=5.78613e-19 //x=15.06 //y=5.38
c617 ( 48 0 ) capacitor c=0.0105477f //x=15.06 //y=5.2
c618 ( 47 0 ) capacitor c=0.00947836f //x=14.18 //y=5.38
c619 ( 40 0 ) capacitor c=0.0149589f //x=11.47 //y=3.7
c620 ( 36 0 ) capacitor c=0.0149589f //x=6.66 //y=3.7
c621 ( 28 0 ) capacitor c=0.0232166f //x=22.94 //y=4.57
c622 ( 27 0 ) capacitor c=0.0110064f //x=22.94 //y=3.865
c623 ( 26 0 ) capacitor c=0.0394263f //x=22.94 //y=3.545
c624 ( 25 0 ) capacitor c=0.00728218f //x=22.94 //y=2.195
c625 ( 24 0 ) capacitor c=0.0302042f //x=15.54 //y=5.115
c626 ( 23 0 ) capacitor c=0.0127059f //x=15.54 //y=3.845
c627 ( 22 0 ) capacitor c=0.0542426f //x=15.54 //y=3.525
c628 ( 20 0 ) capacitor c=0.00466468f //x=15.185 //y=1.655
c629 ( 19 0 ) capacitor c=0.0118534f //x=15.455 //y=1.655
c630 ( 17 0 ) capacitor c=0.0107481f //x=15.455 //y=5.2
c631 ( 16 0 ) capacitor c=0.0102514f //x=15.1 //y=1.57
c632 ( 11 0 ) capacitor c=0.0144196f //x=14.945 //y=5.2
c633 ( 8 0 ) capacitor c=0.0205242f //x=11.47 //y=4.57
c634 ( 7 0 ) capacitor c=0.0115897f //x=11.47 //y=3.845
c635 ( 6 0 ) capacitor c=0.0348235f //x=11.47 //y=3.525
c636 ( 5 0 ) capacitor c=0.00554287f //x=11.47 //y=2.195
c637 ( 4 0 ) capacitor c=0.0190807f //x=6.66 //y=4.57
c638 ( 3 0 ) capacitor c=0.0114282f //x=6.66 //y=3.845
c639 ( 2 0 ) capacitor c=0.0377226f //x=6.66 //y=3.525
c640 ( 1 0 ) capacitor c=0.00696087f //x=6.66 //y=2.195
r641 (  237 238 ) resistor r=52.7279 //w=0.214 //l=0.165 //layer=ply \
 //thickness=0.18 //x=22.94 //y=2.08 //x2=22.94 //y2=1.915
r642 (  227 228 ) resistor r=52.7279 //w=0.214 //l=0.165 //layer=ply \
 //thickness=0.18 //x=11.47 //y=2.08 //x2=11.47 //y2=1.915
r643 (  217 218 ) resistor r=52.7279 //w=0.214 //l=0.165 //layer=ply \
 //thickness=0.18 //x=6.66 //y=2.08 //x2=6.66 //y2=1.915
r644 (  215 245 ) resistor r=45.1352 //w=0.168 //l=0.173853 //layer=ply \
 //thickness=0.18 //x=23.46 //y=1.26 //x2=23.42 //y2=1.415
r645 (  214 244 ) resistor r=45.1352 //w=0.168 //l=0.173853 //layer=ply \
 //thickness=0.18 //x=23.46 //y=0.915 //x2=23.42 //y2=0.76
r646 (  214 215 ) resistor r=176.904 //w=0.094 //l=0.345 //layer=ply \
 //thickness=0.18 //x=23.46 //y=0.915 //x2=23.46 //y2=1.26
r647 (  212 241 ) resistor r=10.701 //w=0.21 //l=0.115 //layer=ply \
 //thickness=0.18 //x=23.085 //y=1.415 //x2=22.97 //y2=1.415
r648 (  211 245 ) resistor r=5.52526 //w=0.168 //l=0.115 //layer=ply \
 //thickness=0.18 //x=23.305 //y=1.415 //x2=23.42 //y2=1.415
r649 (  210 240 ) resistor r=5.52526 //w=0.168 //l=0.115 //layer=ply \
 //thickness=0.18 //x=23.085 //y=0.76 //x2=22.97 //y2=0.76
r650 (  209 244 ) resistor r=5.52526 //w=0.168 //l=0.115 //layer=ply \
 //thickness=0.18 //x=23.305 //y=0.76 //x2=23.42 //y2=0.76
r651 (  209 210 ) resistor r=112.809 //w=0.094 //l=0.22 //layer=ply \
 //thickness=0.18 //x=23.305 //y=0.76 //x2=23.085 //y2=0.76
r652 (  206 243 ) resistor r=37.236 //w=0.233 //l=0.249199 //layer=ply \
 //thickness=0.18 //x=23.12 //y=4.865 //x2=22.94 //y2=4.7
r653 (  204 241 ) resistor r=39.5823 //w=0.21 //l=0.173853 //layer=ply \
 //thickness=0.18 //x=22.93 //y=1.57 //x2=22.97 //y2=1.415
r654 (  204 238 ) resistor r=176.904 //w=0.094 //l=0.345 //layer=ply \
 //thickness=0.18 //x=22.93 //y=1.57 //x2=22.93 //y2=1.915
r655 (  203 241 ) resistor r=39.5823 //w=0.21 //l=0.173853 //layer=ply \
 //thickness=0.18 //x=22.93 //y=1.26 //x2=22.97 //y2=1.415
r656 (  202 240 ) resistor r=45.1352 //w=0.168 //l=0.173853 //layer=ply \
 //thickness=0.18 //x=22.93 //y=0.915 //x2=22.97 //y2=0.76
r657 (  202 203 ) resistor r=176.904 //w=0.094 //l=0.345 //layer=ply \
 //thickness=0.18 //x=22.93 //y=0.915 //x2=22.93 //y2=1.26
r658 (  199 243 ) resistor r=53.7854 //w=0.233 //l=0.332415 //layer=ply \
 //thickness=0.18 //x=22.68 //y=4.865 //x2=22.94 //y2=4.7
r659 (  198 235 ) resistor r=45.1352 //w=0.168 //l=0.173853 //layer=ply \
 //thickness=0.18 //x=11.99 //y=1.26 //x2=11.95 //y2=1.415
r660 (  197 234 ) resistor r=45.1352 //w=0.168 //l=0.173853 //layer=ply \
 //thickness=0.18 //x=11.99 //y=0.915 //x2=11.95 //y2=0.76
r661 (  197 198 ) resistor r=176.904 //w=0.094 //l=0.345 //layer=ply \
 //thickness=0.18 //x=11.99 //y=0.915 //x2=11.99 //y2=1.26
r662 (  195 231 ) resistor r=10.701 //w=0.21 //l=0.115 //layer=ply \
 //thickness=0.18 //x=11.615 //y=1.415 //x2=11.5 //y2=1.415
r663 (  194 235 ) resistor r=5.52526 //w=0.168 //l=0.115 //layer=ply \
 //thickness=0.18 //x=11.835 //y=1.415 //x2=11.95 //y2=1.415
r664 (  193 230 ) resistor r=5.52526 //w=0.168 //l=0.115 //layer=ply \
 //thickness=0.18 //x=11.615 //y=0.76 //x2=11.5 //y2=0.76
r665 (  192 234 ) resistor r=5.52526 //w=0.168 //l=0.115 //layer=ply \
 //thickness=0.18 //x=11.835 //y=0.76 //x2=11.95 //y2=0.76
r666 (  192 193 ) resistor r=112.809 //w=0.094 //l=0.22 //layer=ply \
 //thickness=0.18 //x=11.835 //y=0.76 //x2=11.615 //y2=0.76
r667 (  189 233 ) resistor r=37.236 //w=0.233 //l=0.249199 //layer=ply \
 //thickness=0.18 //x=11.65 //y=4.865 //x2=11.47 //y2=4.7
r668 (  187 231 ) resistor r=39.5823 //w=0.21 //l=0.173853 //layer=ply \
 //thickness=0.18 //x=11.46 //y=1.57 //x2=11.5 //y2=1.415
r669 (  187 228 ) resistor r=176.904 //w=0.094 //l=0.345 //layer=ply \
 //thickness=0.18 //x=11.46 //y=1.57 //x2=11.46 //y2=1.915
r670 (  186 231 ) resistor r=39.5823 //w=0.21 //l=0.173853 //layer=ply \
 //thickness=0.18 //x=11.46 //y=1.26 //x2=11.5 //y2=1.415
r671 (  185 230 ) resistor r=45.1352 //w=0.168 //l=0.173853 //layer=ply \
 //thickness=0.18 //x=11.46 //y=0.915 //x2=11.5 //y2=0.76
r672 (  185 186 ) resistor r=176.904 //w=0.094 //l=0.345 //layer=ply \
 //thickness=0.18 //x=11.46 //y=0.915 //x2=11.46 //y2=1.26
r673 (  182 233 ) resistor r=53.7854 //w=0.233 //l=0.332415 //layer=ply \
 //thickness=0.18 //x=11.21 //y=4.865 //x2=11.47 //y2=4.7
r674 (  181 225 ) resistor r=45.1352 //w=0.168 //l=0.173853 //layer=ply \
 //thickness=0.18 //x=7.18 //y=1.26 //x2=7.14 //y2=1.415
r675 (  180 224 ) resistor r=45.1352 //w=0.168 //l=0.173853 //layer=ply \
 //thickness=0.18 //x=7.18 //y=0.915 //x2=7.14 //y2=0.76
r676 (  180 181 ) resistor r=176.904 //w=0.094 //l=0.345 //layer=ply \
 //thickness=0.18 //x=7.18 //y=0.915 //x2=7.18 //y2=1.26
r677 (  178 221 ) resistor r=10.701 //w=0.21 //l=0.115 //layer=ply \
 //thickness=0.18 //x=6.805 //y=1.415 //x2=6.69 //y2=1.415
r678 (  177 225 ) resistor r=5.52526 //w=0.168 //l=0.115 //layer=ply \
 //thickness=0.18 //x=7.025 //y=1.415 //x2=7.14 //y2=1.415
r679 (  176 220 ) resistor r=5.52526 //w=0.168 //l=0.115 //layer=ply \
 //thickness=0.18 //x=6.805 //y=0.76 //x2=6.69 //y2=0.76
r680 (  175 224 ) resistor r=5.52526 //w=0.168 //l=0.115 //layer=ply \
 //thickness=0.18 //x=7.025 //y=0.76 //x2=7.14 //y2=0.76
r681 (  175 176 ) resistor r=112.809 //w=0.094 //l=0.22 //layer=ply \
 //thickness=0.18 //x=7.025 //y=0.76 //x2=6.805 //y2=0.76
r682 (  172 223 ) resistor r=37.236 //w=0.233 //l=0.249199 //layer=ply \
 //thickness=0.18 //x=6.84 //y=4.865 //x2=6.66 //y2=4.7
r683 (  170 221 ) resistor r=39.5823 //w=0.21 //l=0.173853 //layer=ply \
 //thickness=0.18 //x=6.65 //y=1.57 //x2=6.69 //y2=1.415
r684 (  170 218 ) resistor r=176.904 //w=0.094 //l=0.345 //layer=ply \
 //thickness=0.18 //x=6.65 //y=1.57 //x2=6.65 //y2=1.915
r685 (  169 221 ) resistor r=39.5823 //w=0.21 //l=0.173853 //layer=ply \
 //thickness=0.18 //x=6.65 //y=1.26 //x2=6.69 //y2=1.415
r686 (  168 220 ) resistor r=45.1352 //w=0.168 //l=0.173853 //layer=ply \
 //thickness=0.18 //x=6.65 //y=0.915 //x2=6.69 //y2=0.76
r687 (  168 169 ) resistor r=176.904 //w=0.094 //l=0.345 //layer=ply \
 //thickness=0.18 //x=6.65 //y=0.915 //x2=6.65 //y2=1.26
r688 (  165 223 ) resistor r=53.7854 //w=0.233 //l=0.332415 //layer=ply \
 //thickness=0.18 //x=6.4 //y=4.865 //x2=6.66 //y2=4.7
r689 (  164 206 ) resistor r=592.245 //w=0.094 //l=1.155 //layer=ply \
 //thickness=0.18 //x=23.12 //y=6.02 //x2=23.12 //y2=4.865
r690 (  163 199 ) resistor r=592.245 //w=0.094 //l=1.155 //layer=ply \
 //thickness=0.18 //x=22.68 //y=6.02 //x2=22.68 //y2=4.865
r691 (  162 189 ) resistor r=592.245 //w=0.094 //l=1.155 //layer=ply \
 //thickness=0.18 //x=11.65 //y=6.02 //x2=11.65 //y2=4.865
r692 (  161 182 ) resistor r=592.245 //w=0.094 //l=1.155 //layer=ply \
 //thickness=0.18 //x=11.21 //y=6.02 //x2=11.21 //y2=4.865
r693 (  160 172 ) resistor r=592.245 //w=0.094 //l=1.155 //layer=ply \
 //thickness=0.18 //x=6.84 //y=6.02 //x2=6.84 //y2=4.865
r694 (  159 165 ) resistor r=592.245 //w=0.094 //l=1.155 //layer=ply \
 //thickness=0.18 //x=6.4 //y=6.02 //x2=6.4 //y2=4.865
r695 (  158 211 ) resistor r=56.4043 //w=0.094 //l=0.11 //layer=ply \
 //thickness=0.18 //x=23.195 //y=1.415 //x2=23.305 //y2=1.415
r696 (  158 212 ) resistor r=56.4043 //w=0.094 //l=0.11 //layer=ply \
 //thickness=0.18 //x=23.195 //y=1.415 //x2=23.085 //y2=1.415
r697 (  157 194 ) resistor r=56.4043 //w=0.094 //l=0.11 //layer=ply \
 //thickness=0.18 //x=11.725 //y=1.415 //x2=11.835 //y2=1.415
r698 (  157 195 ) resistor r=56.4043 //w=0.094 //l=0.11 //layer=ply \
 //thickness=0.18 //x=11.725 //y=1.415 //x2=11.615 //y2=1.415
r699 (  156 177 ) resistor r=56.4043 //w=0.094 //l=0.11 //layer=ply \
 //thickness=0.18 //x=6.915 //y=1.415 //x2=7.025 //y2=1.415
r700 (  156 178 ) resistor r=56.4043 //w=0.094 //l=0.11 //layer=ply \
 //thickness=0.18 //x=6.915 //y=1.415 //x2=6.805 //y2=1.415
r701 (  152 243 ) resistor r=152 //w=0.17 //l=0.17 //layer=licon //count=1 \
 //x=22.94 //y=4.7 //x2=22.94 //y2=4.7
r702 (  143 237 ) resistor r=152 //w=0.17 //l=0.17 //layer=licon //count=1 \
 //x=22.94 //y=2.08 //x2=22.94 //y2=2.08
r703 (  126 249 ) resistor r=23.615 //w=0.187 //l=0.345 //layer=li \
 //thickness=0.1 //x=15.06 //y=5.38 //x2=15.06 //y2=5.725
r704 (  118 248 ) resistor r=23.615 //w=0.187 //l=0.345 //layer=li \
 //thickness=0.1 //x=14.18 //y=5.38 //x2=14.18 //y2=5.725
r705 (  113 233 ) resistor r=152 //w=0.17 //l=0.17 //layer=licon //count=1 \
 //x=11.47 //y=4.7 //x2=11.47 //y2=4.7
r706 (  104 227 ) resistor r=152 //w=0.17 //l=0.17 //layer=licon //count=1 \
 //x=11.47 //y=2.08 //x2=11.47 //y2=2.08
r707 (  99 223 ) resistor r=152 //w=0.17 //l=0.17 //layer=licon //count=1 \
 //x=6.66 //y=4.7 //x2=6.66 //y2=4.7
r708 (  90 217 ) resistor r=152 //w=0.17 //l=0.17 //layer=licon //count=1 \
 //x=6.66 //y=2.08 //x2=6.66 //y2=2.08
r709 (  86 87 ) resistor r=0.10734 //w=0.281 //l=0.16 //layer=m2 \
 //thickness=0.36 //x=22.94 //y=3.705 //x2=22.78 //y2=3.705
r710 (  84 87 ) resistor r=6.7605 //w=0.131 //l=7.085 //layer=m2 \
 //thickness=0.36 //x=15.695 //y=3.7 //x2=22.78 //y2=3.7
r711 (  82 84 ) resistor r=0.10734 //w=0.281 //l=0.16 //layer=m2 \
 //thickness=0.36 //x=15.535 //y=3.685 //x2=15.695 //y2=3.685
r712 (  82 83 ) resistor r=0.10734 //w=0.281 //l=0.16 //layer=m2 \
 //thickness=0.36 //x=15.535 //y=3.685 //x2=15.375 //y2=3.685
r713 (  76 78 ) resistor r=0.10734 //w=0.281 //l=0.16 //layer=m2 \
 //thickness=0.36 //x=6.665 //y=3.685 //x2=6.825 //y2=3.685
r714 (  72 80 ) resistor r=0.110608 //w=0.182 //l=0.167332 //layer=m2 \
 //thickness=0.36 //x=11.63 //y=3.7 //x2=11.47 //y2=3.685
r715 (  72 83 ) resistor r=3.57347 //w=0.131 //l=3.745 //layer=m2 \
 //thickness=0.36 //x=11.63 //y=3.7 //x2=15.375 //y2=3.7
r716 (  69 80 ) resistor r=2.65182 //w=0.182 //l=3.86 //layer=m2 \
 //thickness=0.36 //x=7.61 //y=3.685 //x2=11.47 //y2=3.685
r717 (  69 70 ) resistor r=0.410305 //w=0.131 //l=0.43 //layer=m2 \
 //thickness=0.36 //x=7.61 //y=3.685 //x2=7.18 //y2=3.685
r718 (  67 70 ) resistor r=0.125 //w=0.17 //l=0.177341 //layer=m2 \
 //thickness=0.36 //x=7.01 //y=3.7 //x2=7.18 //y2=3.685
r719 (  67 78 ) resistor r=0.176527 //w=0.131 //l=0.185 //layer=m2 \
 //thickness=0.36 //x=7.01 //y=3.7 //x2=6.825 //y2=3.7
r720 (  66 152 ) resistor r=9.3 //w=0.17 //l=0.17 //layer=mcon //count=1 \
 //x=22.94 //y=4.7 //x2=22.94 //y2=4.7
r721 (  64 143 ) resistor r=9.3 //w=0.17 //l=0.17 //layer=mcon //count=1 \
 //x=22.94 //y=2.08 //x2=22.94 //y2=2.08
r722 (  62 86 ) resistor r=4.5 //w=0.15 //l=0.15 //layer=via1 //count=1 \
 //x=22.94 //y=3.705 //x2=22.94 //y2=3.705
r723 (  60 62 ) resistor r=0.00166223 //w=0.376 //l=0.005 //layer=m1 \
 //thickness=0.36 //x=22.887 //y=3.7 //x2=22.887 //y2=3.705
r724 (  56 82 ) resistor r=4.5 //w=0.15 //l=0.15 //layer=via1 //count=1 \
 //x=15.535 //y=3.685 //x2=15.535 //y2=3.685
r725 (  56 58 ) resistor r=0.00501337 //w=0.374 //l=0.015 //layer=m1 \
 //thickness=0.36 //x=15.485 //y=3.685 //x2=15.485 //y2=3.7
r726 (  53 246 ) resistor r=9.3 //w=0.17 //l=0.17 //layer=mcon //count=1 \
 //x=15.1 //y=1 //x2=15.1 //y2=1
r727 (  51 126 ) resistor r=9.3 //w=0.17 //l=0.17 //layer=mcon //count=1 \
 //x=15.06 //y=5.38 //x2=15.06 //y2=5.38
r728 (  48 51 ) resistor r=0.117801 //w=0.191 //l=0.18 //layer=m1 \
 //thickness=0.36 //x=15.06 //y=5.2 //x2=15.06 //y2=5.38
r729 (  47 118 ) resistor r=9.3 //w=0.17 //l=0.17 //layer=mcon //count=1 \
 //x=14.18 //y=5.38 //x2=14.18 //y2=5.38
r730 (  45 47 ) resistor r=0.10274 //w=0.219 //l=0.18 //layer=m1 \
 //thickness=0.36 //x=14.18 //y=5.2 //x2=14.18 //y2=5.38
r731 (  44 113 ) resistor r=9.3 //w=0.17 //l=0.17 //layer=mcon //count=1 \
 //x=11.47 //y=4.7 //x2=11.47 //y2=4.7
r732 (  42 104 ) resistor r=9.3 //w=0.17 //l=0.17 //layer=mcon //count=1 \
 //x=11.47 //y=2.08 //x2=11.47 //y2=2.08
r733 (  38 80 ) resistor r=4.5 //w=0.15 //l=0.15 //layer=via1 //count=1 \
 //x=11.47 //y=3.685 //x2=11.47 //y2=3.685
r734 (  38 40 ) resistor r=0.0049867 //w=0.376 //l=0.015 //layer=m1 \
 //thickness=0.36 //x=11.417 //y=3.685 //x2=11.417 //y2=3.7
r735 (  34 76 ) resistor r=4.5 //w=0.15 //l=0.15 //layer=via1 //count=1 \
 //x=6.665 //y=3.685 //x2=6.665 //y2=3.685
r736 (  34 36 ) resistor r=0.00501337 //w=0.374 //l=0.015 //layer=m1 \
 //thickness=0.36 //x=6.715 //y=3.685 //x2=6.715 //y2=3.7
r737 (  32 99 ) resistor r=9.3 //w=0.17 //l=0.17 //layer=mcon //count=1 \
 //x=6.66 //y=4.7 //x2=6.66 //y2=4.7
r738 (  30 90 ) resistor r=9.3 //w=0.17 //l=0.17 //layer=mcon //count=1 \
 //x=6.66 //y=2.08 //x2=6.66 //y2=2.08
r739 (  28 66 ) resistor r=0.0801089 //w=0.224 //l=0.13 //layer=m1 \
 //thickness=0.36 //x=22.94 //y=4.57 //x2=22.94 //y2=4.7
r740 (  27 62 ) resistor r=0.0911593 //w=0.376 //l=0.184608 //layer=m1 \
 //thickness=0.36 //x=22.94 //y=3.865 //x2=22.887 //y2=3.705
r741 (  27 28 ) resistor r=0.67271 //w=0.131 //l=0.705 //layer=m1 \
 //thickness=0.36 //x=22.94 //y=3.865 //x2=22.94 //y2=4.57
r742 (  26 60 ) resistor r=0.0894971 //w=0.376 //l=0.179555 //layer=m1 \
 //thickness=0.36 //x=22.94 //y=3.545 //x2=22.887 //y2=3.7
r743 (  25 64 ) resistor r=0.0719237 //w=0.222 //l=0.115 //layer=m1 \
 //thickness=0.36 //x=22.94 //y=2.195 //x2=22.94 //y2=2.08
r744 (  25 26 ) resistor r=1.28817 //w=0.131 //l=1.35 //layer=m1 \
 //thickness=0.36 //x=22.94 //y=2.195 //x2=22.94 //y2=3.545
r745 (  23 58 ) resistor r=0.0860668 //w=0.374 //l=0.170294 //layer=m1 \
 //thickness=0.36 //x=15.54 //y=3.845 //x2=15.485 //y2=3.7
r746 (  23 24 ) resistor r=1.21183 //w=0.131 //l=1.27 //layer=m1 \
 //thickness=0.36 //x=15.54 //y=3.845 //x2=15.54 //y2=5.115
r747 (  22 56 ) resistor r=0.0910802 //w=0.374 //l=0.185472 //layer=m1 \
 //thickness=0.36 //x=15.54 //y=3.525 //x2=15.485 //y2=3.685
r748 (  21 22 ) resistor r=1.70324 //w=0.131 //l=1.785 //layer=m1 \
 //thickness=0.36 //x=15.54 //y=1.74 //x2=15.54 //y2=3.525
r749 (  19 21 ) resistor r=0.0698411 //w=0.17 //l=0.120208 //layer=m1 \
 //thickness=0.36 //x=15.455 //y=1.655 //x2=15.54 //y2=1.74
r750 (  19 20 ) resistor r=0.257634 //w=0.131 //l=0.27 //layer=m1 \
 //thickness=0.36 //x=15.455 //y=1.655 //x2=15.185 //y2=1.655
r751 (  18 48 ) resistor r=0.0257089 //w=0.23 //l=0.115 //layer=m1 \
 //thickness=0.36 //x=15.175 //y=5.2 //x2=15.06 //y2=5.2
r752 (  17 24 ) resistor r=0.0698411 //w=0.17 //l=0.120208 //layer=m1 \
 //thickness=0.36 //x=15.455 //y=5.2 //x2=15.54 //y2=5.115
r753 (  17 18 ) resistor r=0.267176 //w=0.131 //l=0.28 //layer=m1 \
 //thickness=0.36 //x=15.455 //y=5.2 //x2=15.175 //y2=5.2
r754 (  16 20 ) resistor r=0.0698411 //w=0.17 //l=0.120208 //layer=m1 \
 //thickness=0.36 //x=15.1 //y=1.57 //x2=15.185 //y2=1.655
r755 (  15 53 ) resistor r=0.0913624 //w=0.191 //l=0.12 //layer=m1 \
 //thickness=0.36 //x=15.1 //y=1.12 //x2=15.1 //y2=1
r756 (  15 16 ) resistor r=0.429389 //w=0.131 //l=0.45 //layer=m1 \
 //thickness=0.36 //x=15.1 //y=1.12 //x2=15.1 //y2=1.57
r757 (  12 45 ) resistor r=0.0227762 //w=0.219 //l=0.115 //layer=m1 \
 //thickness=0.36 //x=14.295 //y=5.2 //x2=14.18 //y2=5.2
r758 (  11 48 ) resistor r=0.0257089 //w=0.23 //l=0.115 //layer=m1 \
 //thickness=0.36 //x=14.945 //y=5.2 //x2=15.06 //y2=5.2
r759 (  11 12 ) resistor r=0.620229 //w=0.131 //l=0.65 //layer=m1 \
 //thickness=0.36 //x=14.945 //y=5.2 //x2=14.295 //y2=5.2
r760 (  8 44 ) resistor r=0.0801089 //w=0.224 //l=0.13 //layer=m1 \
 //thickness=0.36 //x=11.47 //y=4.57 //x2=11.47 //y2=4.7
r761 (  7 40 ) resistor r=0.0861726 //w=0.376 //l=0.16944 //layer=m1 \
 //thickness=0.36 //x=11.47 //y=3.845 //x2=11.417 //y2=3.7
r762 (  7 8 ) resistor r=0.691794 //w=0.131 //l=0.725 //layer=m1 \
 //thickness=0.36 //x=11.47 //y=3.845 //x2=11.47 //y2=4.57
r763 (  6 38 ) resistor r=0.0911593 //w=0.376 //l=0.184608 //layer=m1 \
 //thickness=0.36 //x=11.47 //y=3.525 //x2=11.417 //y2=3.685
r764 (  5 42 ) resistor r=0.0719237 //w=0.222 //l=0.115 //layer=m1 \
 //thickness=0.36 //x=11.47 //y=2.195 //x2=11.47 //y2=2.08
r765 (  5 6 ) resistor r=1.26908 //w=0.131 //l=1.33 //layer=m1 \
 //thickness=0.36 //x=11.47 //y=2.195 //x2=11.47 //y2=3.525
r766 (  4 32 ) resistor r=0.0801089 //w=0.224 //l=0.13 //layer=m1 \
 //thickness=0.36 //x=6.66 //y=4.57 //x2=6.66 //y2=4.7
r767 (  3 36 ) resistor r=0.0860668 //w=0.374 //l=0.170294 //layer=m1 \
 //thickness=0.36 //x=6.66 //y=3.845 //x2=6.715 //y2=3.7
r768 (  3 4 ) resistor r=0.691794 //w=0.131 //l=0.725 //layer=m1 \
 //thickness=0.36 //x=6.66 //y=3.845 //x2=6.66 //y2=4.57
r769 (  2 34 ) resistor r=0.0910802 //w=0.374 //l=0.185472 //layer=m1 \
 //thickness=0.36 //x=6.66 //y=3.525 //x2=6.715 //y2=3.685
r770 (  1 30 ) resistor r=0.0719237 //w=0.222 //l=0.115 //layer=m1 \
 //thickness=0.36 //x=6.66 //y=2.195 //x2=6.66 //y2=2.08
r771 (  1 2 ) resistor r=1.26908 //w=0.131 //l=1.33 //layer=m1 \
 //thickness=0.36 //x=6.66 //y=2.195 //x2=6.66 //y2=3.525
ends PM_DFFSNX1_PCELL\%noxref_6

subckt PM_DFFSNX1_PCELL\%noxref_7 ( 41 67 75 101 109 119 129 145 153 163 173 \
 189 199 225 235 259 269 277 290 294 297 303 309 313 318 323 324 325 326 327 \
 328 329 330 331 332 333 334 335 336 337 338 339 340 341 342 343 )
c382 ( 343 0 ) capacitor c=0.0466888f //x=23.195 //y=5.02
c383 ( 342 0 ) capacitor c=0.025619f //x=22.315 //y=5.02
c384 ( 341 0 ) capacitor c=0.0255774f //x=21.435 //y=5.02
c385 ( 340 0 ) capacitor c=0.0675971f //x=20.565 //y=5.02
c386 ( 339 0 ) capacitor c=0.039252f //x=18.685 //y=5.02
c387 ( 338 0 ) capacitor c=0.0248171f //x=17.805 //y=5.02
c388 ( 337 0 ) capacitor c=0.062188f //x=16.935 //y=5.02
c389 ( 336 0 ) capacitor c=0.0393085f //x=15.355 //y=5.02
c390 ( 335 0 ) capacitor c=0.0248171f //x=14.475 //y=5.02
c391 ( 334 0 ) capacitor c=0.0629524f //x=13.605 //y=5.02
c392 ( 333 0 ) capacitor c=0.0466888f //x=11.725 //y=5.02
c393 ( 332 0 ) capacitor c=0.0255832f //x=10.845 //y=5.02
c394 ( 331 0 ) capacitor c=0.0256111f //x=9.965 //y=5.02
c395 ( 330 0 ) capacitor c=0.0677117f //x=9.095 //y=5.02
c396 ( 329 0 ) capacitor c=0.0466888f //x=6.915 //y=5.02
c397 ( 328 0 ) capacitor c=0.0256166f //x=6.035 //y=5.02
c398 ( 327 0 ) capacitor c=0.0255774f //x=5.155 //y=5.02
c399 ( 326 0 ) capacitor c=0.0676653f //x=4.285 //y=5.02
c400 ( 325 0 ) capacitor c=0.0399064f //x=2.405 //y=5.02
c401 ( 324 0 ) capacitor c=0.0248171f //x=1.525 //y=5.02
c402 ( 323 0 ) capacitor c=0.0678368f //x=0.655 //y=5.02
c403 ( 322 0 ) capacitor c=0.00591168f //x=23.34 //y=7.4
c404 ( 321 0 ) capacitor c=0.00591168f //x=22.46 //y=7.4
c405 ( 320 0 ) capacitor c=0.00591168f //x=21.58 //y=7.4
c406 ( 319 0 ) capacitor c=0.00591168f //x=20.7 //y=7.4
c407 ( 318 0 ) capacitor c=0.146712f //x=19.61 //y=7.4
c408 ( 317 0 ) capacitor c=0.00591168f //x=18.87 //y=7.4
c409 ( 315 0 ) capacitor c=0.00591168f //x=17.95 //y=7.4
c410 ( 314 0 ) capacitor c=0.00591168f //x=17.07 //y=7.4
c411 ( 313 0 ) capacitor c=0.127266f //x=16.28 //y=7.4
c412 ( 312 0 ) capacitor c=0.00591168f //x=15.5 //y=7.4
c413 ( 311 0 ) capacitor c=0.00591168f //x=14.62 //y=7.4
c414 ( 310 0 ) capacitor c=0.00591168f //x=13.74 //y=7.4
c415 ( 309 0 ) capacitor c=0.14555f //x=12.95 //y=7.4
c416 ( 308 0 ) capacitor c=0.00591168f //x=11.87 //y=7.4
c417 ( 307 0 ) capacitor c=0.00591168f //x=10.99 //y=7.4
c418 ( 306 0 ) capacitor c=0.00591168f //x=10.11 //y=7.4
c419 ( 305 0 ) capacitor c=0.00591168f //x=9.25 //y=7.4
c420 ( 303 0 ) capacitor c=0.162076f //x=8.14 //y=7.4
c421 ( 302 0 ) capacitor c=0.00591168f //x=7.06 //y=7.4
c422 ( 301 0 ) capacitor c=0.00591168f //x=6.18 //y=7.4
c423 ( 300 0 ) capacitor c=0.00591168f //x=5.3 //y=7.4
c424 ( 299 0 ) capacitor c=0.00591168f //x=4.44 //y=7.4
c425 ( 297 0 ) capacitor c=0.144776f //x=3.33 //y=7.4
c426 ( 296 0 ) capacitor c=0.00591168f //x=2.55 //y=7.4
c427 ( 295 0 ) capacitor c=0.00591168f //x=1.67 //y=7.4
c428 ( 294 0 ) capacitor c=0.252482f //x=0.74 //y=7.4
c429 ( 290 0 ) capacitor c=0.275834f //x=23.68 //y=7.4
c430 ( 277 0 ) capacitor c=0.0286174f //x=23.255 //y=7.4
c431 ( 269 0 ) capacitor c=0.0286648f //x=22.375 //y=7.4
c432 ( 259 0 ) capacitor c=0.0287602f //x=21.495 //y=7.4
c433 ( 247 0 ) capacitor c=0.0452081f //x=20.615 //y=7.4
c434 ( 243 0 ) capacitor c=0.0275781f //x=19.44 //y=7.4
c435 ( 235 0 ) capacitor c=0.0284687f //x=18.745 //y=7.4
c436 ( 225 0 ) capacitor c=0.0289054f //x=17.865 //y=7.4
c437 ( 213 0 ) capacitor c=0.0281468f //x=16.985 //y=7.4
c438 ( 209 0 ) capacitor c=0.0275781f //x=16.11 //y=7.4
c439 ( 199 0 ) capacitor c=0.0284688f //x=15.415 //y=7.4
c440 ( 189 0 ) capacitor c=0.0288404f //x=14.535 //y=7.4
c441 ( 179 0 ) capacitor c=0.0281468f //x=13.655 //y=7.4
c442 ( 173 0 ) capacitor c=0.0419403f //x=12.78 //y=7.4
c443 ( 163 0 ) capacitor c=0.0286174f //x=11.785 //y=7.4
c444 ( 153 0 ) capacitor c=0.0286648f //x=10.905 //y=7.4
c445 ( 145 0 ) capacitor c=0.0287602f //x=10.025 //y=7.4
c446 ( 135 0 ) capacitor c=0.0452081f //x=9.145 //y=7.4
c447 ( 129 0 ) capacitor c=0.0413966f //x=7.97 //y=7.4
c448 ( 119 0 ) capacitor c=0.0286174f //x=6.975 //y=7.4
c449 ( 109 0 ) capacitor c=0.0285759f //x=6.095 //y=7.4
c450 ( 101 0 ) capacitor c=0.0287602f //x=5.215 //y=7.4
c451 ( 91 0 ) capacitor c=0.0452081f //x=4.335 //y=7.4
c452 ( 85 0 ) capacitor c=0.0275781f //x=3.16 //y=7.4
c453 ( 75 0 ) capacitor c=0.0284688f //x=2.465 //y=7.4
c454 ( 67 0 ) capacitor c=0.0288404f //x=1.585 //y=7.4
c455 ( 41 0 ) capacitor c=0.899512f //x=23.68 //y=7.4
r456 (  288 322 ) resistor r=2.94794 //w=0.34 //l=0.085 //layer=li \
 //thickness=0.1 //x=23.425 //y=7.4 //x2=23.34 //y2=7.4
r457 (  288 290 ) resistor r=9.14286 //w=0.357 //l=0.255 //layer=li \
 //thickness=0.1 //x=23.425 //y=7.4 //x2=23.68 //y2=7.4
r458 (  281 322 ) resistor r=4.11603 //w=0.68 //l=0.17 //layer=li \
 //thickness=0.1 //x=23.34 //y=7.23 //x2=23.34 //y2=7.4
r459 (  281 343 ) resistor r=33.1979 //w=0.187 //l=0.485 //layer=li \
 //thickness=0.1 //x=23.34 //y=7.23 //x2=23.34 //y2=6.745
r460 (  278 321 ) resistor r=2.94794 //w=0.34 //l=0.085 //layer=li \
 //thickness=0.1 //x=22.545 //y=7.4 //x2=22.46 //y2=7.4
r461 (  278 280 ) resistor r=0.896359 //w=0.357 //l=0.025 //layer=li \
 //thickness=0.1 //x=22.545 //y=7.4 //x2=22.57 //y2=7.4
r462 (  277 322 ) resistor r=2.94794 //w=0.34 //l=0.085 //layer=li \
 //thickness=0.1 //x=23.255 //y=7.4 //x2=23.34 //y2=7.4
r463 (  277 280 ) resistor r=24.5602 //w=0.357 //l=0.685 //layer=li \
 //thickness=0.1 //x=23.255 //y=7.4 //x2=22.57 //y2=7.4
r464 (  271 321 ) resistor r=4.11603 //w=0.68 //l=0.17 //layer=li \
 //thickness=0.1 //x=22.46 //y=7.23 //x2=22.46 //y2=7.4
r465 (  271 342 ) resistor r=33.1979 //w=0.187 //l=0.485 //layer=li \
 //thickness=0.1 //x=22.46 //y=7.23 //x2=22.46 //y2=6.745
r466 (  270 320 ) resistor r=2.94794 //w=0.34 //l=0.085 //layer=li \
 //thickness=0.1 //x=21.665 //y=7.4 //x2=21.58 //y2=7.4
r467 (  269 321 ) resistor r=2.94794 //w=0.34 //l=0.085 //layer=li \
 //thickness=0.1 //x=22.375 //y=7.4 //x2=22.46 //y2=7.4
r468 (  269 270 ) resistor r=25.4566 //w=0.357 //l=0.71 //layer=li \
 //thickness=0.1 //x=22.375 //y=7.4 //x2=21.665 //y2=7.4
r469 (  263 320 ) resistor r=4.11603 //w=0.68 //l=0.17 //layer=li \
 //thickness=0.1 //x=21.58 //y=7.23 //x2=21.58 //y2=7.4
r470 (  263 341 ) resistor r=33.1979 //w=0.187 //l=0.485 //layer=li \
 //thickness=0.1 //x=21.58 //y=7.23 //x2=21.58 //y2=6.745
r471 (  260 319 ) resistor r=2.94794 //w=0.34 //l=0.085 //layer=li \
 //thickness=0.1 //x=20.785 //y=7.4 //x2=20.7 //y2=7.4
r472 (  260 262 ) resistor r=24.2017 //w=0.357 //l=0.675 //layer=li \
 //thickness=0.1 //x=20.785 //y=7.4 //x2=21.46 //y2=7.4
r473 (  259 320 ) resistor r=2.94794 //w=0.34 //l=0.085 //layer=li \
 //thickness=0.1 //x=21.495 //y=7.4 //x2=21.58 //y2=7.4
r474 (  259 262 ) resistor r=1.2549 //w=0.357 //l=0.035 //layer=li \
 //thickness=0.1 //x=21.495 //y=7.4 //x2=21.46 //y2=7.4
r475 (  251 319 ) resistor r=4.11603 //w=0.68 //l=0.17 //layer=li \
 //thickness=0.1 //x=20.7 //y=7.23 //x2=20.7 //y2=7.4
r476 (  251 340 ) resistor r=56.4706 //w=0.187 //l=0.825 //layer=li \
 //thickness=0.1 //x=20.7 //y=7.23 //x2=20.7 //y2=6.405
r477 (  248 318 ) resistor r=5.4201 //w=0.34 //l=0.17 //layer=li \
 //thickness=0.1 //x=19.78 //y=7.4 //x2=19.61 //y2=7.4
r478 (  248 250 ) resistor r=20.437 //w=0.357 //l=0.57 //layer=li \
 //thickness=0.1 //x=19.78 //y=7.4 //x2=20.35 //y2=7.4
r479 (  247 319 ) resistor r=2.94794 //w=0.34 //l=0.085 //layer=li \
 //thickness=0.1 //x=20.615 //y=7.4 //x2=20.7 //y2=7.4
r480 (  247 250 ) resistor r=9.5014 //w=0.357 //l=0.265 //layer=li \
 //thickness=0.1 //x=20.615 //y=7.4 //x2=20.35 //y2=7.4
r481 (  244 317 ) resistor r=2.94794 //w=0.34 //l=0.085 //layer=li \
 //thickness=0.1 //x=18.915 //y=7.4 //x2=18.83 //y2=7.4
r482 (  243 318 ) resistor r=5.4201 //w=0.34 //l=0.17 //layer=li \
 //thickness=0.1 //x=19.44 //y=7.4 //x2=19.61 //y2=7.4
r483 (  243 244 ) resistor r=18.8235 //w=0.357 //l=0.525 //layer=li \
 //thickness=0.1 //x=19.44 //y=7.4 //x2=18.915 //y2=7.4
r484 (  237 317 ) resistor r=4.11603 //w=0.68 //l=0.17 //layer=li \
 //thickness=0.1 //x=18.83 //y=7.23 //x2=18.83 //y2=7.4
r485 (  237 339 ) resistor r=33.1979 //w=0.187 //l=0.485 //layer=li \
 //thickness=0.1 //x=18.83 //y=7.23 //x2=18.83 //y2=6.745
r486 (  236 315 ) resistor r=2.94794 //w=0.34 //l=0.085 //layer=li \
 //thickness=0.1 //x=18.035 //y=7.4 //x2=17.95 //y2=7.4
r487 (  235 317 ) resistor r=2.94794 //w=0.34 //l=0.085 //layer=li \
 //thickness=0.1 //x=18.745 //y=7.4 //x2=18.83 //y2=7.4
r488 (  235 236 ) resistor r=25.4566 //w=0.357 //l=0.71 //layer=li \
 //thickness=0.1 //x=18.745 //y=7.4 //x2=18.035 //y2=7.4
r489 (  229 315 ) resistor r=4.11603 //w=0.68 //l=0.17 //layer=li \
 //thickness=0.1 //x=17.95 //y=7.23 //x2=17.95 //y2=7.4
r490 (  229 338 ) resistor r=33.1979 //w=0.187 //l=0.485 //layer=li \
 //thickness=0.1 //x=17.95 //y=7.23 //x2=17.95 //y2=6.745
r491 (  226 314 ) resistor r=2.94794 //w=0.34 //l=0.085 //layer=li \
 //thickness=0.1 //x=17.155 //y=7.4 //x2=17.07 //y2=7.4
r492 (  226 228 ) resistor r=21.6919 //w=0.357 //l=0.605 //layer=li \
 //thickness=0.1 //x=17.155 //y=7.4 //x2=17.76 //y2=7.4
r493 (  225 315 ) resistor r=2.94794 //w=0.34 //l=0.085 //layer=li \
 //thickness=0.1 //x=17.865 //y=7.4 //x2=17.95 //y2=7.4
r494 (  225 228 ) resistor r=3.76471 //w=0.357 //l=0.105 //layer=li \
 //thickness=0.1 //x=17.865 //y=7.4 //x2=17.76 //y2=7.4
r495 (  217 314 ) resistor r=4.11603 //w=0.68 //l=0.17 //layer=li \
 //thickness=0.1 //x=17.07 //y=7.23 //x2=17.07 //y2=7.4
r496 (  217 337 ) resistor r=56.4706 //w=0.187 //l=0.825 //layer=li \
 //thickness=0.1 //x=17.07 //y=7.23 //x2=17.07 //y2=6.405
r497 (  214 313 ) resistor r=5.4201 //w=0.34 //l=0.17 //layer=li \
 //thickness=0.1 //x=16.45 //y=7.4 //x2=16.28 //y2=7.4
r498 (  214 216 ) resistor r=7.17087 //w=0.357 //l=0.2 //layer=li \
 //thickness=0.1 //x=16.45 //y=7.4 //x2=16.65 //y2=7.4
r499 (  213 314 ) resistor r=2.94794 //w=0.34 //l=0.085 //layer=li \
 //thickness=0.1 //x=16.985 //y=7.4 //x2=17.07 //y2=7.4
r500 (  213 216 ) resistor r=12.0112 //w=0.357 //l=0.335 //layer=li \
 //thickness=0.1 //x=16.985 //y=7.4 //x2=16.65 //y2=7.4
r501 (  210 312 ) resistor r=2.94794 //w=0.34 //l=0.085 //layer=li \
 //thickness=0.1 //x=15.585 //y=7.4 //x2=15.5 //y2=7.4
r502 (  209 313 ) resistor r=5.4201 //w=0.34 //l=0.17 //layer=li \
 //thickness=0.1 //x=16.11 //y=7.4 //x2=16.28 //y2=7.4
r503 (  209 210 ) resistor r=18.8235 //w=0.357 //l=0.525 //layer=li \
 //thickness=0.1 //x=16.11 //y=7.4 //x2=15.585 //y2=7.4
r504 (  203 312 ) resistor r=4.11603 //w=0.68 //l=0.17 //layer=li \
 //thickness=0.1 //x=15.5 //y=7.23 //x2=15.5 //y2=7.4
r505 (  203 336 ) resistor r=33.1979 //w=0.187 //l=0.485 //layer=li \
 //thickness=0.1 //x=15.5 //y=7.23 //x2=15.5 //y2=6.745
r506 (  200 311 ) resistor r=2.94794 //w=0.34 //l=0.085 //layer=li \
 //thickness=0.1 //x=14.705 //y=7.4 //x2=14.62 //y2=7.4
r507 (  200 202 ) resistor r=16.6723 //w=0.357 //l=0.465 //layer=li \
 //thickness=0.1 //x=14.705 //y=7.4 //x2=15.17 //y2=7.4
r508 (  199 312 ) resistor r=2.94794 //w=0.34 //l=0.085 //layer=li \
 //thickness=0.1 //x=15.415 //y=7.4 //x2=15.5 //y2=7.4
r509 (  199 202 ) resistor r=8.78431 //w=0.357 //l=0.245 //layer=li \
 //thickness=0.1 //x=15.415 //y=7.4 //x2=15.17 //y2=7.4
r510 (  193 311 ) resistor r=4.11603 //w=0.68 //l=0.17 //layer=li \
 //thickness=0.1 //x=14.62 //y=7.23 //x2=14.62 //y2=7.4
r511 (  193 335 ) resistor r=33.1979 //w=0.187 //l=0.485 //layer=li \
 //thickness=0.1 //x=14.62 //y=7.23 //x2=14.62 //y2=6.745
r512 (  190 310 ) resistor r=2.94794 //w=0.34 //l=0.085 //layer=li \
 //thickness=0.1 //x=13.825 //y=7.4 //x2=13.74 //y2=7.4
r513 (  190 192 ) resistor r=8.42577 //w=0.357 //l=0.235 //layer=li \
 //thickness=0.1 //x=13.825 //y=7.4 //x2=14.06 //y2=7.4
r514 (  189 311 ) resistor r=2.94794 //w=0.34 //l=0.085 //layer=li \
 //thickness=0.1 //x=14.535 //y=7.4 //x2=14.62 //y2=7.4
r515 (  189 192 ) resistor r=17.0308 //w=0.357 //l=0.475 //layer=li \
 //thickness=0.1 //x=14.535 //y=7.4 //x2=14.06 //y2=7.4
r516 (  181 310 ) resistor r=4.11603 //w=0.68 //l=0.17 //layer=li \
 //thickness=0.1 //x=13.74 //y=7.23 //x2=13.74 //y2=7.4
r517 (  181 334 ) resistor r=56.4706 //w=0.187 //l=0.825 //layer=li \
 //thickness=0.1 //x=13.74 //y=7.23 //x2=13.74 //y2=6.405
r518 (  180 309 ) resistor r=5.4201 //w=0.34 //l=0.17 //layer=li \
 //thickness=0.1 //x=13.12 //y=7.4 //x2=12.95 //y2=7.4
r519 (  179 310 ) resistor r=2.94794 //w=0.34 //l=0.085 //layer=li \
 //thickness=0.1 //x=13.655 //y=7.4 //x2=13.74 //y2=7.4
r520 (  179 180 ) resistor r=19.1821 //w=0.357 //l=0.535 //layer=li \
 //thickness=0.1 //x=13.655 //y=7.4 //x2=13.12 //y2=7.4
r521 (  174 308 ) resistor r=2.94794 //w=0.34 //l=0.085 //layer=li \
 //thickness=0.1 //x=11.955 //y=7.4 //x2=11.87 //y2=7.4
r522 (  174 176 ) resistor r=22.409 //w=0.357 //l=0.625 //layer=li \
 //thickness=0.1 //x=11.955 //y=7.4 //x2=12.58 //y2=7.4
r523 (  173 309 ) resistor r=5.4201 //w=0.34 //l=0.17 //layer=li \
 //thickness=0.1 //x=12.78 //y=7.4 //x2=12.95 //y2=7.4
r524 (  173 176 ) resistor r=7.17087 //w=0.357 //l=0.2 //layer=li \
 //thickness=0.1 //x=12.78 //y=7.4 //x2=12.58 //y2=7.4
r525 (  167 308 ) resistor r=4.11603 //w=0.68 //l=0.17 //layer=li \
 //thickness=0.1 //x=11.87 //y=7.23 //x2=11.87 //y2=7.4
r526 (  167 333 ) resistor r=33.1979 //w=0.187 //l=0.485 //layer=li \
 //thickness=0.1 //x=11.87 //y=7.23 //x2=11.87 //y2=6.745
r527 (  164 307 ) resistor r=2.94794 //w=0.34 //l=0.085 //layer=li \
 //thickness=0.1 //x=11.075 //y=7.4 //x2=10.99 //y2=7.4
r528 (  164 166 ) resistor r=14.1625 //w=0.357 //l=0.395 //layer=li \
 //thickness=0.1 //x=11.075 //y=7.4 //x2=11.47 //y2=7.4
r529 (  163 308 ) resistor r=2.94794 //w=0.34 //l=0.085 //layer=li \
 //thickness=0.1 //x=11.785 //y=7.4 //x2=11.87 //y2=7.4
r530 (  163 166 ) resistor r=11.2941 //w=0.357 //l=0.315 //layer=li \
 //thickness=0.1 //x=11.785 //y=7.4 //x2=11.47 //y2=7.4
r531 (  157 307 ) resistor r=4.11603 //w=0.68 //l=0.17 //layer=li \
 //thickness=0.1 //x=10.99 //y=7.23 //x2=10.99 //y2=7.4
r532 (  157 332 ) resistor r=33.1979 //w=0.187 //l=0.485 //layer=li \
 //thickness=0.1 //x=10.99 //y=7.23 //x2=10.99 //y2=6.745
r533 (  154 306 ) resistor r=2.94794 //w=0.34 //l=0.085 //layer=li \
 //thickness=0.1 //x=10.195 //y=7.4 //x2=10.11 //y2=7.4
r534 (  154 156 ) resistor r=5.91597 //w=0.357 //l=0.165 //layer=li \
 //thickness=0.1 //x=10.195 //y=7.4 //x2=10.36 //y2=7.4
r535 (  153 307 ) resistor r=2.94794 //w=0.34 //l=0.085 //layer=li \
 //thickness=0.1 //x=10.905 //y=7.4 //x2=10.99 //y2=7.4
r536 (  153 156 ) resistor r=19.5406 //w=0.357 //l=0.545 //layer=li \
 //thickness=0.1 //x=10.905 //y=7.4 //x2=10.36 //y2=7.4
r537 (  147 306 ) resistor r=4.11603 //w=0.68 //l=0.17 //layer=li \
 //thickness=0.1 //x=10.11 //y=7.23 //x2=10.11 //y2=7.4
r538 (  147 331 ) resistor r=33.1979 //w=0.187 //l=0.485 //layer=li \
 //thickness=0.1 //x=10.11 //y=7.23 //x2=10.11 //y2=6.745
r539 (  146 305 ) resistor r=2.94794 //w=0.34 //l=0.085 //layer=li \
 //thickness=0.1 //x=9.315 //y=7.4 //x2=9.23 //y2=7.4
r540 (  145 306 ) resistor r=2.94794 //w=0.34 //l=0.085 //layer=li \
 //thickness=0.1 //x=10.025 //y=7.4 //x2=10.11 //y2=7.4
r541 (  145 146 ) resistor r=25.4566 //w=0.357 //l=0.71 //layer=li \
 //thickness=0.1 //x=10.025 //y=7.4 //x2=9.315 //y2=7.4
r542 (  137 305 ) resistor r=4.11603 //w=0.68 //l=0.17 //layer=li \
 //thickness=0.1 //x=9.23 //y=7.23 //x2=9.23 //y2=7.4
r543 (  137 330 ) resistor r=56.4706 //w=0.187 //l=0.825 //layer=li \
 //thickness=0.1 //x=9.23 //y=7.23 //x2=9.23 //y2=6.405
r544 (  136 303 ) resistor r=5.4201 //w=0.34 //l=0.17 //layer=li \
 //thickness=0.1 //x=8.31 //y=7.4 //x2=8.14 //y2=7.4
r545 (  135 305 ) resistor r=2.94794 //w=0.34 //l=0.085 //layer=li \
 //thickness=0.1 //x=9.145 //y=7.4 //x2=9.23 //y2=7.4
r546 (  135 136 ) resistor r=29.9384 //w=0.357 //l=0.835 //layer=li \
 //thickness=0.1 //x=9.145 //y=7.4 //x2=8.31 //y2=7.4
r547 (  130 302 ) resistor r=2.94794 //w=0.34 //l=0.085 //layer=li \
 //thickness=0.1 //x=7.145 //y=7.4 //x2=7.06 //y2=7.4
r548 (  130 132 ) resistor r=22.409 //w=0.357 //l=0.625 //layer=li \
 //thickness=0.1 //x=7.145 //y=7.4 //x2=7.77 //y2=7.4
r549 (  129 303 ) resistor r=5.4201 //w=0.34 //l=0.17 //layer=li \
 //thickness=0.1 //x=7.97 //y=7.4 //x2=8.14 //y2=7.4
r550 (  129 132 ) resistor r=7.17087 //w=0.357 //l=0.2 //layer=li \
 //thickness=0.1 //x=7.97 //y=7.4 //x2=7.77 //y2=7.4
r551 (  123 302 ) resistor r=4.11603 //w=0.68 //l=0.17 //layer=li \
 //thickness=0.1 //x=7.06 //y=7.23 //x2=7.06 //y2=7.4
r552 (  123 329 ) resistor r=33.1979 //w=0.187 //l=0.485 //layer=li \
 //thickness=0.1 //x=7.06 //y=7.23 //x2=7.06 //y2=6.745
r553 (  120 301 ) resistor r=2.94794 //w=0.34 //l=0.085 //layer=li \
 //thickness=0.1 //x=6.265 //y=7.4 //x2=6.18 //y2=7.4
r554 (  120 122 ) resistor r=14.1625 //w=0.357 //l=0.395 //layer=li \
 //thickness=0.1 //x=6.265 //y=7.4 //x2=6.66 //y2=7.4
r555 (  119 302 ) resistor r=2.94794 //w=0.34 //l=0.085 //layer=li \
 //thickness=0.1 //x=6.975 //y=7.4 //x2=7.06 //y2=7.4
r556 (  119 122 ) resistor r=11.2941 //w=0.357 //l=0.315 //layer=li \
 //thickness=0.1 //x=6.975 //y=7.4 //x2=6.66 //y2=7.4
r557 (  113 301 ) resistor r=4.11603 //w=0.68 //l=0.17 //layer=li \
 //thickness=0.1 //x=6.18 //y=7.23 //x2=6.18 //y2=7.4
r558 (  113 328 ) resistor r=33.1979 //w=0.187 //l=0.485 //layer=li \
 //thickness=0.1 //x=6.18 //y=7.23 //x2=6.18 //y2=6.745
r559 (  110 300 ) resistor r=2.94794 //w=0.34 //l=0.085 //layer=li \
 //thickness=0.1 //x=5.385 //y=7.4 //x2=5.3 //y2=7.4
r560 (  110 112 ) resistor r=5.91597 //w=0.357 //l=0.165 //layer=li \
 //thickness=0.1 //x=5.385 //y=7.4 //x2=5.55 //y2=7.4
r561 (  109 301 ) resistor r=2.94794 //w=0.34 //l=0.085 //layer=li \
 //thickness=0.1 //x=6.095 //y=7.4 //x2=6.18 //y2=7.4
r562 (  109 112 ) resistor r=19.5406 //w=0.357 //l=0.545 //layer=li \
 //thickness=0.1 //x=6.095 //y=7.4 //x2=5.55 //y2=7.4
r563 (  103 300 ) resistor r=4.11603 //w=0.68 //l=0.17 //layer=li \
 //thickness=0.1 //x=5.3 //y=7.23 //x2=5.3 //y2=7.4
r564 (  103 327 ) resistor r=33.1979 //w=0.187 //l=0.485 //layer=li \
 //thickness=0.1 //x=5.3 //y=7.23 //x2=5.3 //y2=6.745
r565 (  102 299 ) resistor r=2.94794 //w=0.34 //l=0.085 //layer=li \
 //thickness=0.1 //x=4.505 //y=7.4 //x2=4.42 //y2=7.4
r566 (  101 300 ) resistor r=2.94794 //w=0.34 //l=0.085 //layer=li \
 //thickness=0.1 //x=5.215 //y=7.4 //x2=5.3 //y2=7.4
r567 (  101 102 ) resistor r=25.4566 //w=0.357 //l=0.71 //layer=li \
 //thickness=0.1 //x=5.215 //y=7.4 //x2=4.505 //y2=7.4
r568 (  93 299 ) resistor r=4.11603 //w=0.68 //l=0.17 //layer=li \
 //thickness=0.1 //x=4.42 //y=7.23 //x2=4.42 //y2=7.4
r569 (  93 326 ) resistor r=56.4706 //w=0.187 //l=0.825 //layer=li \
 //thickness=0.1 //x=4.42 //y=7.23 //x2=4.42 //y2=6.405
r570 (  92 297 ) resistor r=5.4201 //w=0.34 //l=0.17 //layer=li \
 //thickness=0.1 //x=3.5 //y=7.4 //x2=3.33 //y2=7.4
r571 (  91 299 ) resistor r=2.94794 //w=0.34 //l=0.085 //layer=li \
 //thickness=0.1 //x=4.335 //y=7.4 //x2=4.42 //y2=7.4
r572 (  91 92 ) resistor r=29.9384 //w=0.357 //l=0.835 //layer=li \
 //thickness=0.1 //x=4.335 //y=7.4 //x2=3.5 //y2=7.4
r573 (  86 296 ) resistor r=2.94794 //w=0.34 //l=0.085 //layer=li \
 //thickness=0.1 //x=2.635 //y=7.4 //x2=2.55 //y2=7.4
r574 (  86 88 ) resistor r=11.6527 //w=0.357 //l=0.325 //layer=li \
 //thickness=0.1 //x=2.635 //y=7.4 //x2=2.96 //y2=7.4
r575 (  85 297 ) resistor r=5.4201 //w=0.34 //l=0.17 //layer=li \
 //thickness=0.1 //x=3.16 //y=7.4 //x2=3.33 //y2=7.4
r576 (  85 88 ) resistor r=7.17087 //w=0.357 //l=0.2 //layer=li \
 //thickness=0.1 //x=3.16 //y=7.4 //x2=2.96 //y2=7.4
r577 (  79 296 ) resistor r=4.11603 //w=0.68 //l=0.17 //layer=li \
 //thickness=0.1 //x=2.55 //y=7.23 //x2=2.55 //y2=7.4
r578 (  79 325 ) resistor r=33.1979 //w=0.187 //l=0.485 //layer=li \
 //thickness=0.1 //x=2.55 //y=7.23 //x2=2.55 //y2=6.745
r579 (  76 295 ) resistor r=2.94794 //w=0.34 //l=0.085 //layer=li \
 //thickness=0.1 //x=1.755 //y=7.4 //x2=1.67 //y2=7.4
r580 (  76 78 ) resistor r=3.40616 //w=0.357 //l=0.095 //layer=li \
 //thickness=0.1 //x=1.755 //y=7.4 //x2=1.85 //y2=7.4
r581 (  75 296 ) resistor r=2.94794 //w=0.34 //l=0.085 //layer=li \
 //thickness=0.1 //x=2.465 //y=7.4 //x2=2.55 //y2=7.4
r582 (  75 78 ) resistor r=22.0504 //w=0.357 //l=0.615 //layer=li \
 //thickness=0.1 //x=2.465 //y=7.4 //x2=1.85 //y2=7.4
r583 (  69 295 ) resistor r=4.11603 //w=0.68 //l=0.17 //layer=li \
 //thickness=0.1 //x=1.67 //y=7.23 //x2=1.67 //y2=7.4
r584 (  69 324 ) resistor r=33.1979 //w=0.187 //l=0.485 //layer=li \
 //thickness=0.1 //x=1.67 //y=7.23 //x2=1.67 //y2=6.745
r585 (  68 294 ) resistor r=2.94794 //w=0.34 //l=0.085 //layer=li \
 //thickness=0.1 //x=0.875 //y=7.4 //x2=0.79 //y2=7.4
r586 (  67 295 ) resistor r=2.94794 //w=0.34 //l=0.085 //layer=li \
 //thickness=0.1 //x=1.585 //y=7.4 //x2=1.67 //y2=7.4
r587 (  67 68 ) resistor r=25.4566 //w=0.357 //l=0.71 //layer=li \
 //thickness=0.1 //x=1.585 //y=7.4 //x2=0.875 //y2=7.4
r588 (  59 294 ) resistor r=4.11603 //w=0.68 //l=0.17 //layer=li \
 //thickness=0.1 //x=0.79 //y=7.23 //x2=0.79 //y2=7.4
r589 (  59 323 ) resistor r=56.4706 //w=0.187 //l=0.825 //layer=li \
 //thickness=0.1 //x=0.79 //y=7.23 //x2=0.79 //y2=6.405
r590 (  41 290 ) resistor r=3.1 //w=0.17 //l=0.51 //layer=mcon //count=3 \
 //x=23.68 //y=7.4 //x2=23.68 //y2=7.4
r591 (  39 280 ) resistor r=3.1 //w=0.17 //l=0.51 //layer=mcon //count=3 \
 //x=22.57 //y=7.4 //x2=22.57 //y2=7.4
r592 (  39 41 ) resistor r=0.460963 //w=0.301 //l=1.11 //layer=m1 \
 //thickness=0.36 //x=22.57 //y=7.4 //x2=23.68 //y2=7.4
r593 (  37 262 ) resistor r=3.1 //w=0.17 //l=0.51 //layer=mcon //count=3 \
 //x=21.46 //y=7.4 //x2=21.46 //y2=7.4
r594 (  37 39 ) resistor r=0.460963 //w=0.301 //l=1.11 //layer=m1 \
 //thickness=0.36 //x=21.46 //y=7.4 //x2=22.57 //y2=7.4
r595 (  35 250 ) resistor r=3.1 //w=0.17 //l=0.51 //layer=mcon //count=3 \
 //x=20.35 //y=7.4 //x2=20.35 //y2=7.4
r596 (  35 37 ) resistor r=0.460963 //w=0.301 //l=1.11 //layer=m1 \
 //thickness=0.36 //x=20.35 //y=7.4 //x2=21.46 //y2=7.4
r597 (  33 317 ) resistor r=3.1 //w=0.17 //l=0.51 //layer=mcon //count=3 \
 //x=18.87 //y=7.4 //x2=18.87 //y2=7.4
r598 (  33 35 ) resistor r=0.614618 //w=0.301 //l=1.48 //layer=m1 \
 //thickness=0.36 //x=18.87 //y=7.4 //x2=20.35 //y2=7.4
r599 (  31 228 ) resistor r=3.1 //w=0.17 //l=0.51 //layer=mcon //count=3 \
 //x=17.76 //y=7.4 //x2=17.76 //y2=7.4
r600 (  31 33 ) resistor r=0.460963 //w=0.301 //l=1.11 //layer=m1 \
 //thickness=0.36 //x=17.76 //y=7.4 //x2=18.87 //y2=7.4
r601 (  29 216 ) resistor r=3.1 //w=0.17 //l=0.51 //layer=mcon //count=3 \
 //x=16.65 //y=7.4 //x2=16.65 //y2=7.4
r602 (  29 31 ) resistor r=0.460963 //w=0.301 //l=1.11 //layer=m1 \
 //thickness=0.36 //x=16.65 //y=7.4 //x2=17.76 //y2=7.4
r603 (  27 202 ) resistor r=3.1 //w=0.17 //l=0.51 //layer=mcon //count=3 \
 //x=15.17 //y=7.4 //x2=15.17 //y2=7.4
r604 (  27 29 ) resistor r=0.614618 //w=0.301 //l=1.48 //layer=m1 \
 //thickness=0.36 //x=15.17 //y=7.4 //x2=16.65 //y2=7.4
r605 (  25 192 ) resistor r=3.1 //w=0.17 //l=0.51 //layer=mcon //count=3 \
 //x=14.06 //y=7.4 //x2=14.06 //y2=7.4
r606 (  25 27 ) resistor r=0.460963 //w=0.301 //l=1.11 //layer=m1 \
 //thickness=0.36 //x=14.06 //y=7.4 //x2=15.17 //y2=7.4
r607 (  23 176 ) resistor r=3.1 //w=0.17 //l=0.51 //layer=mcon //count=3 \
 //x=12.58 //y=7.4 //x2=12.58 //y2=7.4
r608 (  23 25 ) resistor r=0.614618 //w=0.301 //l=1.48 //layer=m1 \
 //thickness=0.36 //x=12.58 //y=7.4 //x2=14.06 //y2=7.4
r609 (  21 166 ) resistor r=3.1 //w=0.17 //l=0.51 //layer=mcon //count=3 \
 //x=11.47 //y=7.4 //x2=11.47 //y2=7.4
r610 (  21 23 ) resistor r=0.460963 //w=0.301 //l=1.11 //layer=m1 \
 //thickness=0.36 //x=11.47 //y=7.4 //x2=12.58 //y2=7.4
r611 (  19 156 ) resistor r=3.1 //w=0.17 //l=0.51 //layer=mcon //count=3 \
 //x=10.36 //y=7.4 //x2=10.36 //y2=7.4
r612 (  19 21 ) resistor r=0.460963 //w=0.301 //l=1.11 //layer=m1 \
 //thickness=0.36 //x=10.36 //y=7.4 //x2=11.47 //y2=7.4
r613 (  17 305 ) resistor r=3.1 //w=0.17 //l=0.51 //layer=mcon //count=3 \
 //x=9.25 //y=7.4 //x2=9.25 //y2=7.4
r614 (  17 19 ) resistor r=0.460963 //w=0.301 //l=1.11 //layer=m1 \
 //thickness=0.36 //x=9.25 //y=7.4 //x2=10.36 //y2=7.4
r615 (  15 132 ) resistor r=3.1 //w=0.17 //l=0.51 //layer=mcon //count=3 \
 //x=7.77 //y=7.4 //x2=7.77 //y2=7.4
r616 (  15 17 ) resistor r=0.614618 //w=0.301 //l=1.48 //layer=m1 \
 //thickness=0.36 //x=7.77 //y=7.4 //x2=9.25 //y2=7.4
r617 (  13 122 ) resistor r=3.1 //w=0.17 //l=0.51 //layer=mcon //count=3 \
 //x=6.66 //y=7.4 //x2=6.66 //y2=7.4
r618 (  13 15 ) resistor r=0.460963 //w=0.301 //l=1.11 //layer=m1 \
 //thickness=0.36 //x=6.66 //y=7.4 //x2=7.77 //y2=7.4
r619 (  11 112 ) resistor r=3.1 //w=0.17 //l=0.51 //layer=mcon //count=3 \
 //x=5.55 //y=7.4 //x2=5.55 //y2=7.4
r620 (  11 13 ) resistor r=0.460963 //w=0.301 //l=1.11 //layer=m1 \
 //thickness=0.36 //x=5.55 //y=7.4 //x2=6.66 //y2=7.4
r621 (  9 299 ) resistor r=3.1 //w=0.17 //l=0.51 //layer=mcon //count=3 \
 //x=4.44 //y=7.4 //x2=4.44 //y2=7.4
r622 (  9 11 ) resistor r=0.460963 //w=0.301 //l=1.11 //layer=m1 \
 //thickness=0.36 //x=4.44 //y=7.4 //x2=5.55 //y2=7.4
r623 (  7 88 ) resistor r=3.1 //w=0.17 //l=0.51 //layer=mcon //count=3 \
 //x=2.96 //y=7.4 //x2=2.96 //y2=7.4
r624 (  7 9 ) resistor r=0.614618 //w=0.301 //l=1.48 //layer=m1 \
 //thickness=0.36 //x=2.96 //y=7.4 //x2=4.44 //y2=7.4
r625 (  5 78 ) resistor r=3.1 //w=0.17 //l=0.51 //layer=mcon //count=3 \
 //x=1.85 //y=7.4 //x2=1.85 //y2=7.4
r626 (  5 7 ) resistor r=0.460963 //w=0.301 //l=1.11 //layer=m1 \
 //thickness=0.36 //x=1.85 //y=7.4 //x2=2.96 //y2=7.4
r627 (  2 294 ) resistor r=3.1 //w=0.17 //l=0.51 //layer=mcon //count=3 \
 //x=0.74 //y=7.4 //x2=0.74 //y2=7.4
r628 (  2 5 ) resistor r=0.460963 //w=0.301 //l=1.11 //layer=m1 \
 //thickness=0.36 //x=0.74 //y=7.4 //x2=1.85 //y2=7.4
ends PM_DFFSNX1_PCELL\%noxref_7

subckt PM_DFFSNX1_PCELL\%noxref_8 ( 4 7 8 11 16 20 21 22 23 24 25 26 30 32 35 \
 36 46 )
c100 ( 46 0 ) capacitor c=0.0682508f //x=1.11 //y=4.7
c101 ( 36 0 ) capacitor c=0.0318956f //x=1.445 //y=1.21
c102 ( 35 0 ) capacitor c=0.0186809f //x=1.445 //y=0.865
c103 ( 32 0 ) capacitor c=0.0141821f //x=1.29 //y=1.365
c104 ( 30 0 ) capacitor c=0.0158553f //x=1.29 //y=0.71
c105 ( 26 0 ) capacitor c=0.088055f //x=0.915 //y=1.915
c106 ( 25 0 ) capacitor c=0.0229235f //x=0.915 //y=1.52
c107 ( 24 0 ) capacitor c=0.0234359f //x=0.915 //y=1.21
c108 ( 23 0 ) capacitor c=0.0198759f //x=0.915 //y=0.865
c109 ( 22 0 ) capacitor c=0.110369f //x=1.45 //y=6.02
c110 ( 21 0 ) capacitor c=0.154619f //x=1.01 //y=6.02
c111 ( 16 0 ) capacitor c=8.13451e-19 //x=1.11 //y=4.7
c112 ( 11 0 ) capacitor c=7.85889e-19 //x=1.11 //y=2.08
c113 ( 8 0 ) capacitor c=0.103649f //x=1.112 //y=4.56
c114 ( 7 0 ) capacitor c=0.0113945f //x=1.11 //y=4.7
c115 ( 4 0 ) capacitor c=0.0108617f //x=1.11 //y=2.08
r116 (  44 46 ) resistor r=20.6867 //w=0.233 //l=0.1 //layer=ply \
 //thickness=0.18 //x=1.01 //y=4.7 //x2=1.11 //y2=4.7
r117 (  37 46 ) resistor r=70.3348 //w=0.233 //l=0.414367 //layer=ply \
 //thickness=0.18 //x=1.45 //y=4.865 //x2=1.11 //y2=4.7
r118 (  36 48 ) resistor r=45.1352 //w=0.168 //l=0.173853 //layer=ply \
 //thickness=0.18 //x=1.445 //y=1.21 //x2=1.405 //y2=1.365
r119 (  35 47 ) resistor r=45.1352 //w=0.168 //l=0.173853 //layer=ply \
 //thickness=0.18 //x=1.445 //y=0.865 //x2=1.405 //y2=0.71
r120 (  35 36 ) resistor r=176.904 //w=0.094 //l=0.345 //layer=ply \
 //thickness=0.18 //x=1.445 //y=0.865 //x2=1.445 //y2=1.21
r121 (  33 43 ) resistor r=10.701 //w=0.21 //l=0.115 //layer=ply \
 //thickness=0.18 //x=1.07 //y=1.365 //x2=0.955 //y2=1.365
r122 (  32 48 ) resistor r=5.52526 //w=0.168 //l=0.115 //layer=ply \
 //thickness=0.18 //x=1.29 //y=1.365 //x2=1.405 //y2=1.365
r123 (  31 42 ) resistor r=5.52526 //w=0.168 //l=0.115 //layer=ply \
 //thickness=0.18 //x=1.07 //y=0.71 //x2=0.955 //y2=0.71
r124 (  30 47 ) resistor r=5.52526 //w=0.168 //l=0.115 //layer=ply \
 //thickness=0.18 //x=1.29 //y=0.71 //x2=1.405 //y2=0.71
r125 (  30 31 ) resistor r=112.809 //w=0.094 //l=0.22 //layer=ply \
 //thickness=0.18 //x=1.29 //y=0.71 //x2=1.07 //y2=0.71
r126 (  27 44 ) resistor r=13.0941 //w=0.233 //l=0.165 //layer=ply \
 //thickness=0.18 //x=1.01 //y=4.865 //x2=1.01 //y2=4.7
r127 (  26 41 ) resistor r=34.8111 //w=0.27 //l=0.264953 //layer=ply \
 //thickness=0.18 //x=0.915 //y=1.915 //x2=1.11 //y2=2.08
r128 (  25 43 ) resistor r=39.5823 //w=0.21 //l=0.173853 //layer=ply \
 //thickness=0.18 //x=0.915 //y=1.52 //x2=0.955 //y2=1.365
r129 (  25 26 ) resistor r=202.543 //w=0.094 //l=0.395 //layer=ply \
 //thickness=0.18 //x=0.915 //y=1.52 //x2=0.915 //y2=1.915
r130 (  24 43 ) resistor r=39.5823 //w=0.21 //l=0.173853 //layer=ply \
 //thickness=0.18 //x=0.915 //y=1.21 //x2=0.955 //y2=1.365
r131 (  23 42 ) resistor r=45.1352 //w=0.168 //l=0.173853 //layer=ply \
 //thickness=0.18 //x=0.915 //y=0.865 //x2=0.955 //y2=0.71
r132 (  23 24 ) resistor r=176.904 //w=0.094 //l=0.345 //layer=ply \
 //thickness=0.18 //x=0.915 //y=0.865 //x2=0.915 //y2=1.21
r133 (  22 37 ) resistor r=592.245 //w=0.094 //l=1.155 //layer=ply \
 //thickness=0.18 //x=1.45 //y=6.02 //x2=1.45 //y2=4.865
r134 (  21 27 ) resistor r=592.245 //w=0.094 //l=1.155 //layer=ply \
 //thickness=0.18 //x=1.01 //y=6.02 //x2=1.01 //y2=4.865
r135 (  20 32 ) resistor r=56.4043 //w=0.094 //l=0.11 //layer=ply \
 //thickness=0.18 //x=1.18 //y=1.365 //x2=1.29 //y2=1.365
r136 (  20 33 ) resistor r=56.4043 //w=0.094 //l=0.11 //layer=ply \
 //thickness=0.18 //x=1.18 //y=1.365 //x2=1.07 //y2=1.365
r137 (  16 46 ) resistor r=152 //w=0.17 //l=0.17 //layer=licon //count=1 \
 //x=1.11 //y=4.7 //x2=1.11 //y2=4.7
r138 (  11 41 ) resistor r=152 //w=0.17 //l=0.17 //layer=licon //count=1 \
 //x=1.11 //y=2.08 //x2=1.11 //y2=2.08
r139 (  7 16 ) resistor r=9.3 //w=0.17 //l=0.17 //layer=mcon //count=1 \
 //x=1.11 //y=4.7 //x2=1.11 //y2=4.7
r140 (  7 8 ) resistor r=0.103207 //w=0.196 //l=0.14 //layer=m1 \
 //thickness=0.36 //x=1.112 //y=4.7 //x2=1.112 //y2=4.56
r141 (  4 11 ) resistor r=9.3 //w=0.17 //l=0.17 //layer=mcon //count=1 \
 //x=1.11 //y=2.08 //x2=1.11 //y2=2.08
r142 (  1 4 ) resistor r=0.0933015 //w=0.201 //l=0.125 //layer=m1 \
 //thickness=0.36 //x=1.11 //y=2.205 //x2=1.11 //y2=2.08
r143 (  1 8 ) resistor r=2.24714 //w=0.131 //l=2.355 //layer=m1 \
 //thickness=0.36 //x=1.11 //y=2.205 //x2=1.11 //y2=4.56
ends PM_DFFSNX1_PCELL\%noxref_8

subckt PM_DFFSNX1_PCELL\%noxref_9 ( 5 7 15 19 30 33 34 )
c69 ( 34 0 ) capacitor c=0.0457851f //x=6.295 //y=0.375
c70 ( 33 0 ) capacitor c=0.0195185f //x=5.19 //y=0.91
c71 ( 30 0 ) capacitor c=0.00141302f //x=6.43 //y=0.995
c72 ( 19 0 ) capacitor c=0.00692795f //x=7.4 //y=0.625
c73 ( 15 0 ) capacitor c=0.0154984f //x=7.315 //y=0.54
c74 ( 7 0 ) capacitor c=0.00689459f //x=6.43 //y=0.625
c75 ( 5 0 ) capacitor c=0.0243665f //x=6.345 //y=0.995
r76 (  19 34 ) resistor r=3.57586 //w=0.17 //l=0.125 //layer=li \
 //thickness=0.1 //x=7.4 //y=0.625 //x2=7.4 //y2=0.5
r77 (  19 34 ) resistor r=18.139 //w=0.187 //l=0.265 //layer=li \
 //thickness=0.1 //x=7.4 //y=0.625 //x2=7.4 //y2=0.89
r78 (  16 34 ) resistor r=3.57586 //w=0.17 //l=0.103078 //layer=li \
 //thickness=0.1 //x=6.515 //y=0.54 //x2=6.43 //y2=0.5
r79 (  16 34 ) resistor r=27.3797 //w=0.187 //l=0.4 //layer=li //thickness=0.1 \
 //x=6.515 //y=0.54 //x2=6.915 //y2=0.54
r80 (  15 34 ) resistor r=3.57586 //w=0.17 //l=0.103078 //layer=li \
 //thickness=0.1 //x=7.315 //y=0.54 //x2=7.4 //y2=0.5
r81 (  15 34 ) resistor r=27.3797 //w=0.187 //l=0.4 //layer=li //thickness=0.1 \
 //x=7.315 //y=0.54 //x2=6.915 //y2=0.54
r82 (  11 30 ) resistor r=5.4201 //w=0.17 //l=0.085 //layer=li //thickness=0.1 \
 //x=6.43 //y=1.08 //x2=6.43 //y2=0.995
r83 (  11 34 ) resistor r=10.2674 //w=0.187 //l=0.15 //layer=li \
 //thickness=0.1 //x=6.43 //y=1.08 //x2=6.43 //y2=1.23
r84 (  8 30 ) resistor r=5.4201 //w=0.17 //l=0.085 //layer=li //thickness=0.1 \
 //x=6.43 //y=0.91 //x2=6.43 //y2=0.995
r85 (  8 34 ) resistor r=1.36898 //w=0.187 //l=0.02 //layer=li //thickness=0.1 \
 //x=6.43 //y=0.91 //x2=6.43 //y2=0.89
r86 (  7 34 ) resistor r=3.57586 //w=0.17 //l=0.125 //layer=li //thickness=0.1 \
 //x=6.43 //y=0.625 //x2=6.43 //y2=0.5
r87 (  7 34 ) resistor r=18.139 //w=0.187 //l=0.265 //layer=li //thickness=0.1 \
 //x=6.43 //y=0.625 //x2=6.43 //y2=0.89
r88 (  6 33 ) resistor r=0.751729 //w=0.17 //l=0.085 //layer=li \
 //thickness=0.1 //x=5.465 //y=0.995 //x2=5.38 //y2=0.995
r89 (  5 30 ) resistor r=1.40859 //w=0.34 //l=0.085 //layer=li //thickness=0.1 \
 //x=6.345 //y=0.995 //x2=6.43 //y2=0.995
r90 (  5 6 ) resistor r=60.2353 //w=0.187 //l=0.88 //layer=li //thickness=0.1 \
 //x=6.345 //y=0.995 //x2=5.465 //y2=0.995
ends PM_DFFSNX1_PCELL\%noxref_9

subckt PM_DFFSNX1_PCELL\%noxref_10 ( 5 7 15 19 30 33 34 )
c70 ( 34 0 ) capacitor c=0.044206f //x=11.105 //y=0.375
c71 ( 33 0 ) capacitor c=0.0193556f //x=10 //y=0.91
c72 ( 30 0 ) capacitor c=0.00141302f //x=11.24 //y=0.995
c73 ( 19 0 ) capacitor c=0.00695768f //x=12.21 //y=0.625
c74 ( 15 0 ) capacitor c=0.0154882f //x=12.125 //y=0.54
c75 ( 7 0 ) capacitor c=0.00689476f //x=11.24 //y=0.625
c76 ( 5 0 ) capacitor c=0.0237752f //x=11.155 //y=0.995
r77 (  19 34 ) resistor r=3.57586 //w=0.17 //l=0.125 //layer=li \
 //thickness=0.1 //x=12.21 //y=0.625 //x2=12.21 //y2=0.5
r78 (  19 34 ) resistor r=18.139 //w=0.187 //l=0.265 //layer=li \
 //thickness=0.1 //x=12.21 //y=0.625 //x2=12.21 //y2=0.89
r79 (  16 34 ) resistor r=3.57586 //w=0.17 //l=0.103078 //layer=li \
 //thickness=0.1 //x=11.325 //y=0.54 //x2=11.24 //y2=0.5
r80 (  16 34 ) resistor r=27.3797 //w=0.187 //l=0.4 //layer=li //thickness=0.1 \
 //x=11.325 //y=0.54 //x2=11.725 //y2=0.54
r81 (  15 34 ) resistor r=3.57586 //w=0.17 //l=0.103078 //layer=li \
 //thickness=0.1 //x=12.125 //y=0.54 //x2=12.21 //y2=0.5
r82 (  15 34 ) resistor r=27.3797 //w=0.187 //l=0.4 //layer=li //thickness=0.1 \
 //x=12.125 //y=0.54 //x2=11.725 //y2=0.54
r83 (  11 30 ) resistor r=5.4201 //w=0.17 //l=0.085 //layer=li //thickness=0.1 \
 //x=11.24 //y=1.08 //x2=11.24 //y2=0.995
r84 (  11 34 ) resistor r=10.2674 //w=0.187 //l=0.15 //layer=li \
 //thickness=0.1 //x=11.24 //y=1.08 //x2=11.24 //y2=1.23
r85 (  8 30 ) resistor r=5.4201 //w=0.17 //l=0.085 //layer=li //thickness=0.1 \
 //x=11.24 //y=0.91 //x2=11.24 //y2=0.995
r86 (  8 34 ) resistor r=1.36898 //w=0.187 //l=0.02 //layer=li //thickness=0.1 \
 //x=11.24 //y=0.91 //x2=11.24 //y2=0.89
r87 (  7 34 ) resistor r=3.57586 //w=0.17 //l=0.125 //layer=li //thickness=0.1 \
 //x=11.24 //y=0.625 //x2=11.24 //y2=0.5
r88 (  7 34 ) resistor r=18.139 //w=0.187 //l=0.265 //layer=li //thickness=0.1 \
 //x=11.24 //y=0.625 //x2=11.24 //y2=0.89
r89 (  6 33 ) resistor r=0.751729 //w=0.17 //l=0.085 //layer=li \
 //thickness=0.1 //x=10.275 //y=0.995 //x2=10.19 //y2=0.995
r90 (  5 30 ) resistor r=1.40859 //w=0.34 //l=0.085 //layer=li //thickness=0.1 \
 //x=11.155 //y=0.995 //x2=11.24 //y2=0.995
r91 (  5 6 ) resistor r=60.2353 //w=0.187 //l=0.88 //layer=li //thickness=0.1 \
 //x=11.155 //y=0.995 //x2=10.275 //y2=0.995
ends PM_DFFSNX1_PCELL\%noxref_10

subckt PM_DFFSNX1_PCELL\%noxref_11 ( 2 4 10 15 19 20 21 22 23 24 29 31 33 39 \
 40 42 43 46 )
c105 ( 46 0 ) capacitor c=0.0393541f //x=18.16 //y=4.7
c106 ( 43 0 ) capacitor c=0.0303735f //x=18.13 //y=1.915
c107 ( 42 0 ) capacitor c=0.0476996f //x=18.13 //y=2.08
c108 ( 40 0 ) capacitor c=0.0439708f //x=18.695 //y=1.25
c109 ( 39 0 ) capacitor c=0.0192582f //x=18.695 //y=0.905
c110 ( 33 0 ) capacitor c=0.0162526f //x=18.54 //y=1.405
c111 ( 31 0 ) capacitor c=0.0157807f //x=18.54 //y=0.75
c112 ( 29 0 ) capacitor c=0.0372668f //x=18.535 //y=4.79
c113 ( 24 0 ) capacitor c=0.0210762f //x=18.165 //y=1.56
c114 ( 23 0 ) capacitor c=0.0168511f //x=18.165 //y=1.25
c115 ( 22 0 ) capacitor c=0.0175485f //x=18.165 //y=0.905
c116 ( 21 0 ) capacitor c=0.155269f //x=18.61 //y=6.02
c117 ( 20 0 ) capacitor c=0.110375f //x=18.17 //y=6.02
c118 ( 15 0 ) capacitor c=8.9038e-19 //x=18.16 //y=4.7
c119 ( 10 0 ) capacitor c=7.72439e-19 //x=18.13 //y=2.08
c120 ( 4 0 ) capacitor c=0.00522644f //x=18.13 //y=2.08
c121 ( 2 0 ) capacitor c=0.0600981f //x=18.13 //y=4.555
r122 (  48 49 ) resistor r=32.4568 //w=0.214 //l=0.075 //layer=ply \
 //thickness=0.18 //x=18.16 //y=4.79 //x2=18.16 //y2=4.865
r123 (  46 48 ) resistor r=20.271 //w=0.214 //l=0.09 //layer=ply \
 //thickness=0.18 //x=18.16 //y=4.7 //x2=18.16 //y2=4.79
r124 (  42 43 ) resistor r=52.7279 //w=0.214 //l=0.165 //layer=ply \
 //thickness=0.18 //x=18.13 //y=2.08 //x2=18.13 //y2=1.915
r125 (  40 53 ) resistor r=45.1352 //w=0.168 //l=0.173853 //layer=ply \
 //thickness=0.18 //x=18.695 //y=1.25 //x2=18.655 //y2=1.405
r126 (  39 52 ) resistor r=45.1352 //w=0.168 //l=0.173853 //layer=ply \
 //thickness=0.18 //x=18.695 //y=0.905 //x2=18.655 //y2=0.75
r127 (  39 40 ) resistor r=176.904 //w=0.094 //l=0.345 //layer=ply \
 //thickness=0.18 //x=18.695 //y=0.905 //x2=18.695 //y2=1.25
r128 (  34 51 ) resistor r=10.701 //w=0.21 //l=0.115 //layer=ply \
 //thickness=0.18 //x=18.32 //y=1.405 //x2=18.205 //y2=1.405
r129 (  33 53 ) resistor r=5.52526 //w=0.168 //l=0.115 //layer=ply \
 //thickness=0.18 //x=18.54 //y=1.405 //x2=18.655 //y2=1.405
r130 (  32 50 ) resistor r=5.52526 //w=0.168 //l=0.115 //layer=ply \
 //thickness=0.18 //x=18.32 //y=0.75 //x2=18.205 //y2=0.75
r131 (  31 52 ) resistor r=5.52526 //w=0.168 //l=0.115 //layer=ply \
 //thickness=0.18 //x=18.54 //y=0.75 //x2=18.655 //y2=0.75
r132 (  31 32 ) resistor r=112.809 //w=0.094 //l=0.22 //layer=ply \
 //thickness=0.18 //x=18.54 //y=0.75 //x2=18.32 //y2=0.75
r133 (  30 48 ) resistor r=16.5046 //w=0.27 //l=0.135 //layer=ply \
 //thickness=0.18 //x=18.295 //y=4.79 //x2=18.16 //y2=4.79
r134 (  29 36 ) resistor r=26.9307 //w=0.15 //l=0.106066 //layer=ply \
 //thickness=0.18 //x=18.535 //y=4.79 //x2=18.61 //y2=4.865
r135 (  29 30 ) resistor r=123.064 //w=0.094 //l=0.24 //layer=ply \
 //thickness=0.18 //x=18.535 //y=4.79 //x2=18.295 //y2=4.79
r136 (  24 51 ) resistor r=39.5823 //w=0.21 //l=0.173853 //layer=ply \
 //thickness=0.18 //x=18.165 //y=1.56 //x2=18.205 //y2=1.405
r137 (  24 43 ) resistor r=182.032 //w=0.094 //l=0.355 //layer=ply \
 //thickness=0.18 //x=18.165 //y=1.56 //x2=18.165 //y2=1.915
r138 (  23 51 ) resistor r=39.5823 //w=0.21 //l=0.173853 //layer=ply \
 //thickness=0.18 //x=18.165 //y=1.25 //x2=18.205 //y2=1.405
r139 (  22 50 ) resistor r=45.1352 //w=0.168 //l=0.173853 //layer=ply \
 //thickness=0.18 //x=18.165 //y=0.905 //x2=18.205 //y2=0.75
r140 (  22 23 ) resistor r=176.904 //w=0.094 //l=0.345 //layer=ply \
 //thickness=0.18 //x=18.165 //y=0.905 //x2=18.165 //y2=1.25
r141 (  21 36 ) resistor r=592.245 //w=0.094 //l=1.155 //layer=ply \
 //thickness=0.18 //x=18.61 //y=6.02 //x2=18.61 //y2=4.865
r142 (  20 49 ) resistor r=592.245 //w=0.094 //l=1.155 //layer=ply \
 //thickness=0.18 //x=18.17 //y=6.02 //x2=18.17 //y2=4.865
r143 (  19 33 ) resistor r=56.4043 //w=0.094 //l=0.11 //layer=ply \
 //thickness=0.18 //x=18.43 //y=1.405 //x2=18.54 //y2=1.405
r144 (  19 34 ) resistor r=56.4043 //w=0.094 //l=0.11 //layer=ply \
 //thickness=0.18 //x=18.43 //y=1.405 //x2=18.32 //y2=1.405
r145 (  15 46 ) resistor r=152 //w=0.17 //l=0.17 //layer=licon //count=1 \
 //x=18.16 //y=4.7 //x2=18.16 //y2=4.7
r146 (  10 42 ) resistor r=152 //w=0.17 //l=0.17 //layer=licon //count=1 \
 //x=18.13 //y=2.08 //x2=18.13 //y2=2.08
r147 (  8 15 ) resistor r=9.3 //w=0.17 //l=0.17 //layer=mcon //count=1 \
 //x=18.16 //y=4.7 //x2=18.16 //y2=4.7
r148 (  4 10 ) resistor r=9.3 //w=0.17 //l=0.17 //layer=mcon //count=1 \
 //x=18.13 //y=2.08 //x2=18.13 //y2=2.08
r149 (  4 6 ) resistor r=0.0936408 //w=0.196 //l=0.125 //layer=m1 \
 //thickness=0.36 //x=18.132 //y=2.08 //x2=18.132 //y2=2.205
r150 (  2 8 ) resistor r=0.0878548 //w=0.228 //l=0.159295 //layer=m1 \
 //thickness=0.36 //x=18.13 //y=4.555 //x2=18.16 //y2=4.7
r151 (  2 6 ) resistor r=2.24237 //w=0.131 //l=2.35 //layer=m1 \
 //thickness=0.36 //x=18.13 //y=4.555 //x2=18.13 //y2=2.205
ends PM_DFFSNX1_PCELL\%noxref_11

subckt PM_DFFSNX1_PCELL\%noxref_12 ( 3 8 9 11 12 14 17 18 21 23 26 34 46 48 49 )
c129 ( 46 0 ) capacitor c=0.00878249f //x=18.24 //y=0.905
c130 ( 34 0 ) capacitor c=0.0322017f //x=18.39 //y=5.38
c131 ( 26 0 ) capacitor c=0.0290435f //x=17.51 //y=5.38
c132 ( 23 0 ) capacitor c=0.0112381f //x=18.43 //y=1
c133 ( 21 0 ) capacitor c=5.78613e-19 //x=18.39 //y=5.38
c134 ( 18 0 ) capacitor c=0.0119906f //x=18.39 //y=5.2
c135 ( 17 0 ) capacitor c=0.00911838f //x=17.51 //y=5.38
c136 ( 14 0 ) capacitor c=0.0934889f //x=18.87 //y=5.115
c137 ( 12 0 ) capacitor c=0.00465779f //x=18.515 //y=1.655
c138 ( 11 0 ) capacitor c=0.0120681f //x=18.785 //y=1.655
c139 ( 9 0 ) capacitor c=0.012621f //x=18.785 //y=5.2
c140 ( 8 0 ) capacitor c=0.0133876f //x=18.43 //y=1.57
c141 ( 3 0 ) capacitor c=0.0157454f //x=18.275 //y=5.2
r142 (  34 49 ) resistor r=23.615 //w=0.187 //l=0.345 //layer=li \
 //thickness=0.1 //x=18.39 //y=5.38 //x2=18.39 //y2=5.725
r143 (  26 48 ) resistor r=23.615 //w=0.187 //l=0.345 //layer=li \
 //thickness=0.1 //x=17.51 //y=5.38 //x2=17.51 //y2=5.725
r144 (  23 46 ) resistor r=9.3 //w=0.17 //l=0.17 //layer=mcon //count=1 \
 //x=18.43 //y=1 //x2=18.43 //y2=1
r145 (  21 34 ) resistor r=9.3 //w=0.17 //l=0.17 //layer=mcon //count=1 \
 //x=18.39 //y=5.38 //x2=18.39 //y2=5.38
r146 (  18 21 ) resistor r=0.117801 //w=0.191 //l=0.18 //layer=m1 \
 //thickness=0.36 //x=18.39 //y=5.2 //x2=18.39 //y2=5.38
r147 (  17 26 ) resistor r=9.3 //w=0.17 //l=0.17 //layer=mcon //count=1 \
 //x=17.51 //y=5.38 //x2=17.51 //y2=5.38
r148 (  15 17 ) resistor r=0.10274 //w=0.219 //l=0.18 //layer=m1 \
 //thickness=0.36 //x=17.51 //y=5.2 //x2=17.51 //y2=5.38
r149 (  13 14 ) resistor r=3.22042 //w=0.131 //l=3.375 //layer=m1 \
 //thickness=0.36 //x=18.87 //y=1.74 //x2=18.87 //y2=5.115
r150 (  11 13 ) resistor r=0.0698411 //w=0.17 //l=0.120208 //layer=m1 \
 //thickness=0.36 //x=18.785 //y=1.655 //x2=18.87 //y2=1.74
r151 (  11 12 ) resistor r=0.257634 //w=0.131 //l=0.27 //layer=m1 \
 //thickness=0.36 //x=18.785 //y=1.655 //x2=18.515 //y2=1.655
r152 (  10 18 ) resistor r=0.0257089 //w=0.23 //l=0.115 //layer=m1 \
 //thickness=0.36 //x=18.505 //y=5.2 //x2=18.39 //y2=5.2
r153 (  9 14 ) resistor r=0.0698411 //w=0.17 //l=0.120208 //layer=m1 \
 //thickness=0.36 //x=18.785 //y=5.2 //x2=18.87 //y2=5.115
r154 (  9 10 ) resistor r=0.267176 //w=0.131 //l=0.28 //layer=m1 \
 //thickness=0.36 //x=18.785 //y=5.2 //x2=18.505 //y2=5.2
r155 (  8 12 ) resistor r=0.0698411 //w=0.17 //l=0.120208 //layer=m1 \
 //thickness=0.36 //x=18.43 //y=1.57 //x2=18.515 //y2=1.655
r156 (  7 23 ) resistor r=0.0913624 //w=0.191 //l=0.12 //layer=m1 \
 //thickness=0.36 //x=18.43 //y=1.12 //x2=18.43 //y2=1
r157 (  7 8 ) resistor r=0.429389 //w=0.131 //l=0.45 //layer=m1 \
 //thickness=0.36 //x=18.43 //y=1.12 //x2=18.43 //y2=1.57
r158 (  4 15 ) resistor r=0.0227762 //w=0.219 //l=0.115 //layer=m1 \
 //thickness=0.36 //x=17.625 //y=5.2 //x2=17.51 //y2=5.2
r159 (  3 18 ) resistor r=0.0257089 //w=0.23 //l=0.115 //layer=m1 \
 //thickness=0.36 //x=18.275 //y=5.2 //x2=18.39 //y2=5.2
r160 (  3 4 ) resistor r=0.620229 //w=0.131 //l=0.65 //layer=m1 \
 //thickness=0.36 //x=18.275 //y=5.2 //x2=17.625 //y2=5.2
ends PM_DFFSNX1_PCELL\%noxref_12

subckt PM_DFFSNX1_PCELL\%noxref_13 ( 1 7 14 15 24 25 35 43 52 59 62 63 67 72 \
 77 78 83 84 88 93 96 108 125 142 155 179 187 188 189 190 191 192 193 194 195 \
 196 197 )
c465 ( 197 0 ) capacitor c=0.00840423f //x=20.495 //y=0.875
c466 ( 196 0 ) capacitor c=0.00843555f //x=17.27 //y=0.865
c467 ( 195 0 ) capacitor c=0.00843555f //x=13.94 //y=0.865
c468 ( 194 0 ) capacitor c=0.00840423f //x=9.025 //y=0.875
c469 ( 193 0 ) capacitor c=0.00840423f //x=4.215 //y=0.875
c470 ( 192 0 ) capacitor c=0.00843555f //x=0.99 //y=0.865
c471 ( 191 0 ) capacitor c=0.113123f //x=19.61 //y=0
c472 ( 190 0 ) capacitor c=0.117967f //x=16.28 //y=0
c473 ( 189 0 ) capacitor c=0.113206f //x=12.95 //y=0
c474 ( 188 0 ) capacitor c=0.112088f //x=8.14 //y=0
c475 ( 187 0 ) capacitor c=0.107689f //x=3.33 //y=0
c476 ( 179 0 ) capacitor c=0.368186f //x=23.68 //y=0
c477 ( 155 0 ) capacitor c=0.117601f //x=19.44 //y=0
c478 ( 142 0 ) capacitor c=0.117601f //x=16.11 //y=0
c479 ( 125 0 ) capacitor c=0.177104f //x=12.78 //y=0
c480 ( 108 0 ) capacitor c=0.179213f //x=7.97 //y=0
c481 ( 96 0 ) capacitor c=0.183052f //x=0.74 //y=0
c482 ( 93 0 ) capacitor c=0.123925f //x=3.16 //y=0
c483 ( 90 0 ) capacitor c=0.00509083f //x=20.685 //y=0
c484 ( 88 0 ) capacitor c=0.0125941f //x=20.685 //y=0.965
c485 ( 86 0 ) capacitor c=0.0050875f //x=17.46 //y=0
c486 ( 84 0 ) capacitor c=0.0187613f //x=17.457 //y=0.825
c487 ( 83 0 ) capacitor c=0.0124186f //x=17.46 //y=0.955
c488 ( 81 0 ) capacitor c=0.0050875f //x=14.06 //y=0
c489 ( 78 0 ) capacitor c=0.0235363f //x=14.127 //y=0.825
c490 ( 77 0 ) capacitor c=0.0134704f //x=14.13 //y=0.955
c491 ( 75 0 ) capacitor c=0.00509083f //x=9.25 //y=0
c492 ( 72 0 ) capacitor c=0.0140803f //x=9.215 //y=0.965
c493 ( 70 0 ) capacitor c=0.00509083f //x=4.44 //y=0
c494 ( 67 0 ) capacitor c=0.0133083f //x=4.405 //y=0.965
c495 ( 65 0 ) capacitor c=0.0050875f //x=1.18 //y=0
c496 ( 63 0 ) capacitor c=0.0234055f //x=1.177 //y=0.825
c497 ( 62 0 ) capacitor c=0.0161529f //x=1.18 //y=0.955
c498 ( 59 0 ) capacitor c=0.128873f //x=23.68 //y=0
c499 ( 52 0 ) capacitor c=0.0253397f //x=20.685 //y=0.835
c500 ( 43 0 ) capacitor c=0.106532f //x=20.6 //y=0
c501 ( 35 0 ) capacitor c=0.111957f //x=17.375 //y=0
c502 ( 25 0 ) capacitor c=0.153878f //x=14.045 //y=0
c503 ( 24 0 ) capacitor c=0.0302305f //x=9.215 //y=0.835
c504 ( 15 0 ) capacitor c=0.149284f //x=9.13 //y=0
c505 ( 14 0 ) capacitor c=0.0253397f //x=4.405 //y=0.835
c506 ( 7 0 ) capacitor c=0.104987f //x=4.32 //y=0
c507 ( 1 0 ) capacitor c=0.0587616f //x=1.095 //y=0
r508 (  177 179 ) resistor r=39.7983 //w=0.357 //l=1.11 //layer=li \
 //thickness=0.1 //x=22.57 //y=0 //x2=23.68 //y2=0
r509 (  175 177 ) resistor r=39.7983 //w=0.357 //l=1.11 //layer=li \
 //thickness=0.1 //x=21.46 //y=0 //x2=22.57 //y2=0
r510 (  173 175 ) resistor r=39.7983 //w=0.357 //l=1.11 //layer=li \
 //thickness=0.1 //x=20.35 //y=0 //x2=21.46 //y2=0
r511 (  171 191 ) resistor r=5.4201 //w=0.34 //l=0.17 //layer=li \
 //thickness=0.1 //x=19.78 //y=0 //x2=19.61 //y2=0
r512 (  171 173 ) resistor r=20.437 //w=0.357 //l=0.57 //layer=li \
 //thickness=0.1 //x=19.78 //y=0 //x2=20.35 //y2=0
r513 (  160 162 ) resistor r=39.7983 //w=0.357 //l=1.11 //layer=li \
 //thickness=0.1 //x=17.76 //y=0 //x2=18.87 //y2=0
r514 (  158 160 ) resistor r=39.7983 //w=0.357 //l=1.11 //layer=li \
 //thickness=0.1 //x=16.65 //y=0 //x2=17.76 //y2=0
r515 (  156 190 ) resistor r=5.4201 //w=0.34 //l=0.17 //layer=li \
 //thickness=0.1 //x=16.45 //y=0 //x2=16.28 //y2=0
r516 (  156 158 ) resistor r=7.17087 //w=0.357 //l=0.2 //layer=li \
 //thickness=0.1 //x=16.45 //y=0 //x2=16.65 //y2=0
r517 (  155 191 ) resistor r=5.4201 //w=0.34 //l=0.17 //layer=li \
 //thickness=0.1 //x=19.44 //y=0 //x2=19.61 //y2=0
r518 (  155 162 ) resistor r=20.437 //w=0.357 //l=0.57 //layer=li \
 //thickness=0.1 //x=19.44 //y=0 //x2=18.87 //y2=0
r519 (  145 147 ) resistor r=39.7983 //w=0.357 //l=1.11 //layer=li \
 //thickness=0.1 //x=14.06 //y=0 //x2=15.17 //y2=0
r520 (  143 189 ) resistor r=5.4201 //w=0.34 //l=0.17 //layer=li \
 //thickness=0.1 //x=13.12 //y=0 //x2=12.95 //y2=0
r521 (  143 145 ) resistor r=33.7031 //w=0.357 //l=0.94 //layer=li \
 //thickness=0.1 //x=13.12 //y=0 //x2=14.06 //y2=0
r522 (  142 190 ) resistor r=5.4201 //w=0.34 //l=0.17 //layer=li \
 //thickness=0.1 //x=16.11 //y=0 //x2=16.28 //y2=0
r523 (  142 147 ) resistor r=33.7031 //w=0.357 //l=0.94 //layer=li \
 //thickness=0.1 //x=16.11 //y=0 //x2=15.17 //y2=0
r524 (  132 134 ) resistor r=39.7983 //w=0.357 //l=1.11 //layer=li \
 //thickness=0.1 //x=11.47 //y=0 //x2=12.58 //y2=0
r525 (  130 132 ) resistor r=39.7983 //w=0.357 //l=1.11 //layer=li \
 //thickness=0.1 //x=10.36 //y=0 //x2=11.47 //y2=0
r526 (  128 130 ) resistor r=39.7983 //w=0.357 //l=1.11 //layer=li \
 //thickness=0.1 //x=9.25 //y=0 //x2=10.36 //y2=0
r527 (  126 188 ) resistor r=5.4201 //w=0.34 //l=0.17 //layer=li \
 //thickness=0.1 //x=8.31 //y=0 //x2=8.14 //y2=0
r528 (  126 128 ) resistor r=33.7031 //w=0.357 //l=0.94 //layer=li \
 //thickness=0.1 //x=8.31 //y=0 //x2=9.25 //y2=0
r529 (  125 189 ) resistor r=5.4201 //w=0.34 //l=0.17 //layer=li \
 //thickness=0.1 //x=12.78 //y=0 //x2=12.95 //y2=0
r530 (  125 134 ) resistor r=7.17087 //w=0.357 //l=0.2 //layer=li \
 //thickness=0.1 //x=12.78 //y=0 //x2=12.58 //y2=0
r531 (  115 117 ) resistor r=39.7983 //w=0.357 //l=1.11 //layer=li \
 //thickness=0.1 //x=6.66 //y=0 //x2=7.77 //y2=0
r532 (  113 115 ) resistor r=39.7983 //w=0.357 //l=1.11 //layer=li \
 //thickness=0.1 //x=5.55 //y=0 //x2=6.66 //y2=0
r533 (  111 113 ) resistor r=39.7983 //w=0.357 //l=1.11 //layer=li \
 //thickness=0.1 //x=4.44 //y=0 //x2=5.55 //y2=0
r534 (  109 187 ) resistor r=5.4201 //w=0.34 //l=0.17 //layer=li \
 //thickness=0.1 //x=3.5 //y=0 //x2=3.33 //y2=0
r535 (  109 111 ) resistor r=33.7031 //w=0.357 //l=0.94 //layer=li \
 //thickness=0.1 //x=3.5 //y=0 //x2=4.44 //y2=0
r536 (  108 188 ) resistor r=5.4201 //w=0.34 //l=0.17 //layer=li \
 //thickness=0.1 //x=7.97 //y=0 //x2=8.14 //y2=0
r537 (  108 117 ) resistor r=7.17087 //w=0.357 //l=0.2 //layer=li \
 //thickness=0.1 //x=7.97 //y=0 //x2=7.77 //y2=0
r538 (  98 100 ) resistor r=39.7983 //w=0.357 //l=1.11 //layer=li \
 //thickness=0.1 //x=1.85 //y=0 //x2=2.96 //y2=0
r539 (  96 98 ) resistor r=39.7983 //w=0.357 //l=1.11 //layer=li \
 //thickness=0.1 //x=0.74 //y=0 //x2=1.85 //y2=0
r540 (  93 187 ) resistor r=5.4201 //w=0.34 //l=0.17 //layer=li \
 //thickness=0.1 //x=3.16 //y=0 //x2=3.33 //y2=0
r541 (  93 100 ) resistor r=7.17087 //w=0.357 //l=0.2 //layer=li \
 //thickness=0.1 //x=3.16 //y=0 //x2=2.96 //y2=0
r542 (  88 197 ) resistor r=9.3 //w=0.17 //l=0.17 //layer=mcon //count=1 \
 //x=20.685 //y=0.965 //x2=20.685 //y2=0.965
r543 (  83 196 ) resistor r=9.3 //w=0.17 //l=0.17 //layer=mcon //count=1 \
 //x=17.46 //y=0.955 //x2=17.46 //y2=0.955
r544 (  83 84 ) resistor r=0.0939994 //w=0.226 //l=0.13 //layer=m1 \
 //thickness=0.36 //x=17.457 //y=0.955 //x2=17.457 //y2=0.825
r545 (  81 145 ) resistor r=3.1 //w=0.17 //l=0.51 //layer=mcon //count=3 \
 //x=14.06 //y=0 //x2=14.06 //y2=0
r546 (  77 195 ) resistor r=9.3 //w=0.17 //l=0.17 //layer=mcon //count=1 \
 //x=14.13 //y=0.955 //x2=14.13 //y2=0.955
r547 (  77 78 ) resistor r=0.0939994 //w=0.226 //l=0.13 //layer=m1 \
 //thickness=0.36 //x=14.127 //y=0.955 //x2=14.127 //y2=0.825
r548 (  75 128 ) resistor r=3.1 //w=0.17 //l=0.51 //layer=mcon //count=3 \
 //x=9.25 //y=0 //x2=9.25 //y2=0
r549 (  72 194 ) resistor r=9.3 //w=0.17 //l=0.17 //layer=mcon //count=1 \
 //x=9.215 //y=0.965 //x2=9.215 //y2=0.965
r550 (  70 111 ) resistor r=3.1 //w=0.17 //l=0.51 //layer=mcon //count=3 \
 //x=4.44 //y=0 //x2=4.44 //y2=0
r551 (  67 193 ) resistor r=9.3 //w=0.17 //l=0.17 //layer=mcon //count=1 \
 //x=4.405 //y=0.965 //x2=4.405 //y2=0.965
r552 (  62 192 ) resistor r=9.3 //w=0.17 //l=0.17 //layer=mcon //count=1 \
 //x=1.18 //y=0.955 //x2=1.18 //y2=0.955
r553 (  62 63 ) resistor r=0.0939994 //w=0.226 //l=0.13 //layer=m1 \
 //thickness=0.36 //x=1.177 //y=0.955 //x2=1.177 //y2=0.825
r554 (  59 179 ) resistor r=3.1 //w=0.17 //l=0.51 //layer=mcon //count=3 \
 //x=23.68 //y=0 //x2=23.68 //y2=0
r555 (  57 177 ) resistor r=3.1 //w=0.17 //l=0.51 //layer=mcon //count=3 \
 //x=22.57 //y=0 //x2=22.57 //y2=0
r556 (  57 59 ) resistor r=0.460963 //w=0.301 //l=1.11 //layer=m1 \
 //thickness=0.36 //x=22.57 //y=0 //x2=23.68 //y2=0
r557 (  55 175 ) resistor r=3.1 //w=0.17 //l=0.51 //layer=mcon //count=3 \
 //x=21.46 //y=0 //x2=21.46 //y2=0
r558 (  55 57 ) resistor r=0.460963 //w=0.301 //l=1.11 //layer=m1 \
 //thickness=0.36 //x=21.46 //y=0 //x2=22.57 //y2=0
r559 (  53 90 ) resistor r=0.0287885 //w=0.34 //l=0.085 //layer=m1 \
 //thickness=0.36 //x=20.77 //y=0 //x2=20.685 //y2=0
r560 (  53 55 ) resistor r=0.286545 //w=0.301 //l=0.69 //layer=m1 \
 //thickness=0.36 //x=20.77 //y=0 //x2=21.46 //y2=0
r561 (  52 88 ) resistor r=0.0942778 //w=0.221 //l=0.13 //layer=m1 \
 //thickness=0.36 //x=20.685 //y=0.835 //x2=20.685 //y2=0.965
r562 (  51 90 ) resistor r=0.0401957 //w=0.68 //l=0.17 //layer=m1 \
 //thickness=0.36 //x=20.685 //y=0.17 //x2=20.685 //y2=0
r563 (  51 52 ) resistor r=0.634542 //w=0.131 //l=0.665 //layer=m1 \
 //thickness=0.36 //x=20.685 //y=0.17 //x2=20.685 //y2=0.835
r564 (  50 173 ) resistor r=3.1 //w=0.17 //l=0.51 //layer=mcon //count=3 \
 //x=20.35 //y=0 //x2=20.35 //y2=0
r565 (  48 162 ) resistor r=3.1 //w=0.17 //l=0.51 //layer=mcon //count=3 \
 //x=18.87 //y=0 //x2=18.87 //y2=0
r566 (  48 50 ) resistor r=0.614618 //w=0.301 //l=1.48 //layer=m1 \
 //thickness=0.36 //x=18.87 //y=0 //x2=20.35 //y2=0
r567 (  46 160 ) resistor r=3.1 //w=0.17 //l=0.51 //layer=mcon //count=3 \
 //x=17.76 //y=0 //x2=17.76 //y2=0
r568 (  46 48 ) resistor r=0.460963 //w=0.301 //l=1.11 //layer=m1 \
 //thickness=0.36 //x=17.76 //y=0 //x2=18.87 //y2=0
r569 (  44 86 ) resistor r=0.0287885 //w=0.34 //l=0.085 //layer=m1 \
 //thickness=0.36 //x=17.545 //y=0 //x2=17.46 //y2=0
r570 (  44 46 ) resistor r=0.0892857 //w=0.301 //l=0.215 //layer=m1 \
 //thickness=0.36 //x=17.545 //y=0 //x2=17.76 //y2=0
r571 (  43 90 ) resistor r=0.0287885 //w=0.34 //l=0.085 //layer=m1 \
 //thickness=0.36 //x=20.6 //y=0 //x2=20.685 //y2=0
r572 (  43 50 ) resistor r=0.103821 //w=0.301 //l=0.25 //layer=m1 \
 //thickness=0.36 //x=20.6 //y=0 //x2=20.35 //y2=0
r573 (  41 86 ) resistor r=0.0401957 //w=0.68 //l=0.17 //layer=m1 \
 //thickness=0.36 //x=17.46 //y=0.17 //x2=17.46 //y2=0
r574 (  41 84 ) resistor r=0.625 //w=0.131 //l=0.655 //layer=m1 \
 //thickness=0.36 //x=17.46 //y=0.17 //x2=17.46 //y2=0.825
r575 (  40 158 ) resistor r=3.1 //w=0.17 //l=0.51 //layer=mcon //count=3 \
 //x=16.65 //y=0 //x2=16.65 //y2=0
r576 (  38 147 ) resistor r=3.1 //w=0.17 //l=0.51 //layer=mcon //count=3 \
 //x=15.17 //y=0 //x2=15.17 //y2=0
r577 (  38 40 ) resistor r=0.614618 //w=0.301 //l=1.48 //layer=m1 \
 //thickness=0.36 //x=15.17 //y=0 //x2=16.65 //y2=0
r578 (  36 81 ) resistor r=0.0287885 //w=0.34 //l=0.085 //layer=m1 \
 //thickness=0.36 //x=14.215 //y=0 //x2=14.13 //y2=0
r579 (  36 38 ) resistor r=0.396595 //w=0.301 //l=0.955 //layer=m1 \
 //thickness=0.36 //x=14.215 //y=0 //x2=15.17 //y2=0
r580 (  35 86 ) resistor r=0.0287885 //w=0.34 //l=0.085 //layer=m1 \
 //thickness=0.36 //x=17.375 //y=0 //x2=17.46 //y2=0
r581 (  35 40 ) resistor r=0.30108 //w=0.301 //l=0.725 //layer=m1 \
 //thickness=0.36 //x=17.375 //y=0 //x2=16.65 //y2=0
r582 (  33 81 ) resistor r=0.0401957 //w=0.68 //l=0.17 //layer=m1 \
 //thickness=0.36 //x=14.13 //y=0.17 //x2=14.13 //y2=0
r583 (  33 78 ) resistor r=0.625 //w=0.131 //l=0.655 //layer=m1 \
 //thickness=0.36 //x=14.13 //y=0.17 //x2=14.13 //y2=0.825
r584 (  32 134 ) resistor r=3.1 //w=0.17 //l=0.51 //layer=mcon //count=3 \
 //x=12.58 //y=0 //x2=12.58 //y2=0
r585 (  30 132 ) resistor r=3.1 //w=0.17 //l=0.51 //layer=mcon //count=3 \
 //x=11.47 //y=0 //x2=11.47 //y2=0
r586 (  30 32 ) resistor r=0.460963 //w=0.301 //l=1.11 //layer=m1 \
 //thickness=0.36 //x=11.47 //y=0 //x2=12.58 //y2=0
r587 (  28 130 ) resistor r=3.1 //w=0.17 //l=0.51 //layer=mcon //count=3 \
 //x=10.36 //y=0 //x2=10.36 //y2=0
r588 (  28 30 ) resistor r=0.460963 //w=0.301 //l=1.11 //layer=m1 \
 //thickness=0.36 //x=10.36 //y=0 //x2=11.47 //y2=0
r589 (  26 75 ) resistor r=0.0287885 //w=0.34 //l=0.085 //layer=m1 \
 //thickness=0.36 //x=9.3 //y=0 //x2=9.215 //y2=0
r590 (  26 28 ) resistor r=0.440199 //w=0.301 //l=1.06 //layer=m1 \
 //thickness=0.36 //x=9.3 //y=0 //x2=10.36 //y2=0
r591 (  25 81 ) resistor r=0.0287885 //w=0.34 //l=0.085 //layer=m1 \
 //thickness=0.36 //x=14.045 //y=0 //x2=14.13 //y2=0
r592 (  25 32 ) resistor r=0.608389 //w=0.301 //l=1.465 //layer=m1 \
 //thickness=0.36 //x=14.045 //y=0 //x2=12.58 //y2=0
r593 (  24 72 ) resistor r=0.0942778 //w=0.221 //l=0.13 //layer=m1 \
 //thickness=0.36 //x=9.215 //y=0.835 //x2=9.215 //y2=0.965
r594 (  23 75 ) resistor r=0.0401957 //w=0.68 //l=0.17 //layer=m1 \
 //thickness=0.36 //x=9.215 //y=0.17 //x2=9.215 //y2=0
r595 (  23 24 ) resistor r=0.634542 //w=0.131 //l=0.665 //layer=m1 \
 //thickness=0.36 //x=9.215 //y=0.17 //x2=9.215 //y2=0.835
r596 (  22 117 ) resistor r=3.1 //w=0.17 //l=0.51 //layer=mcon //count=3 \
 //x=7.77 //y=0 //x2=7.77 //y2=0
r597 (  20 115 ) resistor r=3.1 //w=0.17 //l=0.51 //layer=mcon //count=3 \
 //x=6.66 //y=0 //x2=6.66 //y2=0
r598 (  20 22 ) resistor r=0.460963 //w=0.301 //l=1.11 //layer=m1 \
 //thickness=0.36 //x=6.66 //y=0 //x2=7.77 //y2=0
r599 (  18 113 ) resistor r=3.1 //w=0.17 //l=0.51 //layer=mcon //count=3 \
 //x=5.55 //y=0 //x2=5.55 //y2=0
r600 (  18 20 ) resistor r=0.460963 //w=0.301 //l=1.11 //layer=m1 \
 //thickness=0.36 //x=5.55 //y=0 //x2=6.66 //y2=0
r601 (  16 70 ) resistor r=0.0287885 //w=0.34 //l=0.085 //layer=m1 \
 //thickness=0.36 //x=4.49 //y=0 //x2=4.405 //y2=0
r602 (  16 18 ) resistor r=0.440199 //w=0.301 //l=1.06 //layer=m1 \
 //thickness=0.36 //x=4.49 //y=0 //x2=5.55 //y2=0
r603 (  15 75 ) resistor r=0.0287885 //w=0.34 //l=0.085 //layer=m1 \
 //thickness=0.36 //x=9.13 //y=0 //x2=9.215 //y2=0
r604 (  15 22 ) resistor r=0.564784 //w=0.301 //l=1.36 //layer=m1 \
 //thickness=0.36 //x=9.13 //y=0 //x2=7.77 //y2=0
r605 (  14 67 ) resistor r=0.0942778 //w=0.221 //l=0.13 //layer=m1 \
 //thickness=0.36 //x=4.405 //y=0.835 //x2=4.405 //y2=0.965
r606 (  13 70 ) resistor r=0.0401957 //w=0.68 //l=0.17 //layer=m1 \
 //thickness=0.36 //x=4.405 //y=0.17 //x2=4.405 //y2=0
r607 (  13 14 ) resistor r=0.634542 //w=0.131 //l=0.665 //layer=m1 \
 //thickness=0.36 //x=4.405 //y=0.17 //x2=4.405 //y2=0.835
r608 (  12 100 ) resistor r=3.1 //w=0.17 //l=0.51 //layer=mcon //count=3 \
 //x=2.96 //y=0 //x2=2.96 //y2=0
r609 (  10 98 ) resistor r=3.1 //w=0.17 //l=0.51 //layer=mcon //count=3 \
 //x=1.85 //y=0 //x2=1.85 //y2=0
r610 (  10 12 ) resistor r=0.460963 //w=0.301 //l=1.11 //layer=m1 \
 //thickness=0.36 //x=1.85 //y=0 //x2=2.96 //y2=0
r611 (  8 65 ) resistor r=0.0287885 //w=0.34 //l=0.085 //layer=m1 \
 //thickness=0.36 //x=1.265 //y=0 //x2=1.18 //y2=0
r612 (  8 10 ) resistor r=0.24294 //w=0.301 //l=0.585 //layer=m1 \
 //thickness=0.36 //x=1.265 //y=0 //x2=1.85 //y2=0
r613 (  7 70 ) resistor r=0.0287885 //w=0.34 //l=0.085 //layer=m1 \
 //thickness=0.36 //x=4.32 //y=0 //x2=4.405 //y2=0
r614 (  7 12 ) resistor r=0.564784 //w=0.301 //l=1.36 //layer=m1 \
 //thickness=0.36 //x=4.32 //y=0 //x2=2.96 //y2=0
r615 (  5 65 ) resistor r=0.0401957 //w=0.68 //l=0.17 //layer=m1 \
 //thickness=0.36 //x=1.18 //y=0.17 //x2=1.18 //y2=0
r616 (  5 63 ) resistor r=0.625 //w=0.131 //l=0.655 //layer=m1 \
 //thickness=0.36 //x=1.18 //y=0.17 //x2=1.18 //y2=0.825
r617 (  3 96 ) resistor r=3.1 //w=0.17 //l=0.51 //layer=mcon //count=3 \
 //x=0.74 //y=0 //x2=0.74 //y2=0
r618 (  1 65 ) resistor r=0.0287885 //w=0.34 //l=0.085 //layer=m1 \
 //thickness=0.36 //x=1.095 //y=0 //x2=1.18 //y2=0
r619 (  1 3 ) resistor r=0.147425 //w=0.301 //l=0.355 //layer=m1 \
 //thickness=0.36 //x=1.095 //y=0 //x2=0.74 //y2=0
ends PM_DFFSNX1_PCELL\%noxref_13

subckt PM_DFFSNX1_PCELL\%noxref_14 ( 1 2 8 13 17 18 19 20 21 22 23 24 26 32 33 \
 34 35 )
c99 ( 35 0 ) capacitor c=0.0612936f //x=20.995 //y=4.79
c100 ( 34 0 ) capacitor c=0.0376642f //x=21.285 //y=4.79
c101 ( 33 0 ) capacitor c=0.0346489f //x=20.95 //y=1.22
c102 ( 32 0 ) capacitor c=0.018692f //x=20.95 //y=0.875
c103 ( 26 0 ) capacitor c=0.0137077f //x=20.795 //y=1.375
c104 ( 24 0 ) capacitor c=0.0158585f //x=20.795 //y=0.72
c105 ( 23 0 ) capacitor c=0.103534f //x=20.42 //y=1.915
c106 ( 22 0 ) capacitor c=0.0229444f //x=20.42 //y=1.53
c107 ( 21 0 ) capacitor c=0.0234359f //x=20.42 //y=1.22
c108 ( 20 0 ) capacitor c=0.019815f //x=20.42 //y=0.875
c109 ( 19 0 ) capacitor c=0.110208f //x=21.36 //y=6.02
c110 ( 18 0 ) capacitor c=0.158957f //x=20.92 //y=6.02
c111 ( 13 0 ) capacitor c=0.0014751f //x=20.72 //y=4.7
c112 ( 8 0 ) capacitor c=0.0012618f //x=20.72 //y=2.08
c113 ( 2 0 ) capacitor c=0.0895544f //x=20.72 //y=4.575
c114 ( 1 0 ) capacitor c=0.00473074f //x=20.72 //y=2.195
r115 (  34 36 ) resistor r=26.9307 //w=0.15 //l=0.106066 //layer=ply \
 //thickness=0.18 //x=21.285 //y=4.79 //x2=21.36 //y2=4.865
r116 (  34 35 ) resistor r=148.702 //w=0.094 //l=0.29 //layer=ply \
 //thickness=0.18 //x=21.285 //y=4.79 //x2=20.995 //y2=4.79
r117 (  33 46 ) resistor r=45.1352 //w=0.168 //l=0.173853 //layer=ply \
 //thickness=0.18 //x=20.95 //y=1.22 //x2=20.91 //y2=1.375
r118 (  32 45 ) resistor r=45.1352 //w=0.168 //l=0.173853 //layer=ply \
 //thickness=0.18 //x=20.95 //y=0.875 //x2=20.91 //y2=0.72
r119 (  32 33 ) resistor r=176.904 //w=0.094 //l=0.345 //layer=ply \
 //thickness=0.18 //x=20.95 //y=0.875 //x2=20.95 //y2=1.22
r120 (  29 35 ) resistor r=22.7971 //w=0.269 //l=0.106066 //layer=ply \
 //thickness=0.18 //x=20.92 //y=4.865 //x2=20.995 //y2=4.79
r121 (  29 44 ) resistor r=35.8364 //w=0.269 //l=0.270185 //layer=ply \
 //thickness=0.18 //x=20.92 //y=4.865 //x2=20.72 //y2=4.7
r122 (  27 40 ) resistor r=10.701 //w=0.21 //l=0.115 //layer=ply \
 //thickness=0.18 //x=20.575 //y=1.375 //x2=20.46 //y2=1.375
r123 (  26 46 ) resistor r=5.52526 //w=0.168 //l=0.115 //layer=ply \
 //thickness=0.18 //x=20.795 //y=1.375 //x2=20.91 //y2=1.375
r124 (  25 39 ) resistor r=5.52526 //w=0.168 //l=0.115 //layer=ply \
 //thickness=0.18 //x=20.575 //y=0.72 //x2=20.46 //y2=0.72
r125 (  24 45 ) resistor r=5.52526 //w=0.168 //l=0.115 //layer=ply \
 //thickness=0.18 //x=20.795 //y=0.72 //x2=20.91 //y2=0.72
r126 (  24 25 ) resistor r=112.809 //w=0.094 //l=0.22 //layer=ply \
 //thickness=0.18 //x=20.795 //y=0.72 //x2=20.575 //y2=0.72
r127 (  23 42 ) resistor r=58.7805 //w=0.246 //l=0.373497 //layer=ply \
 //thickness=0.18 //x=20.42 //y=1.915 //x2=20.72 //y2=2.08
r128 (  22 40 ) resistor r=39.5823 //w=0.21 //l=0.173853 //layer=ply \
 //thickness=0.18 //x=20.42 //y=1.53 //x2=20.46 //y2=1.375
r129 (  22 23 ) resistor r=197.415 //w=0.094 //l=0.385 //layer=ply \
 //thickness=0.18 //x=20.42 //y=1.53 //x2=20.42 //y2=1.915
r130 (  21 40 ) resistor r=39.5823 //w=0.21 //l=0.173853 //layer=ply \
 //thickness=0.18 //x=20.42 //y=1.22 //x2=20.46 //y2=1.375
r131 (  20 39 ) resistor r=45.1352 //w=0.168 //l=0.173853 //layer=ply \
 //thickness=0.18 //x=20.42 //y=0.875 //x2=20.46 //y2=0.72
r132 (  20 21 ) resistor r=176.904 //w=0.094 //l=0.345 //layer=ply \
 //thickness=0.18 //x=20.42 //y=0.875 //x2=20.42 //y2=1.22
r133 (  19 36 ) resistor r=592.245 //w=0.094 //l=1.155 //layer=ply \
 //thickness=0.18 //x=21.36 //y=6.02 //x2=21.36 //y2=4.865
r134 (  18 29 ) resistor r=592.245 //w=0.094 //l=1.155 //layer=ply \
 //thickness=0.18 //x=20.92 //y=6.02 //x2=20.92 //y2=4.865
r135 (  17 26 ) resistor r=56.4043 //w=0.094 //l=0.11 //layer=ply \
 //thickness=0.18 //x=20.685 //y=1.375 //x2=20.795 //y2=1.375
r136 (  17 27 ) resistor r=56.4043 //w=0.094 //l=0.11 //layer=ply \
 //thickness=0.18 //x=20.685 //y=1.375 //x2=20.575 //y2=1.375
r137 (  13 44 ) resistor r=152 //w=0.17 //l=0.17 //layer=licon //count=1 \
 //x=20.72 //y=4.7 //x2=20.72 //y2=4.7
r138 (  8 42 ) resistor r=152 //w=0.17 //l=0.17 //layer=licon //count=1 \
 //x=20.72 //y=2.08 //x2=20.72 //y2=2.08
r139 (  6 13 ) resistor r=9.3 //w=0.17 //l=0.17 //layer=mcon //count=1 \
 //x=20.72 //y=4.7 //x2=20.72 //y2=4.7
r140 (  4 8 ) resistor r=9.3 //w=0.17 //l=0.17 //layer=mcon //count=1 \
 //x=20.72 //y=2.08 //x2=20.72 //y2=2.08
r141 (  2 6 ) resistor r=0.0760407 //w=0.238 //l=0.125 //layer=m1 \
 //thickness=0.36 //x=20.72 //y=4.575 //x2=20.72 //y2=4.7
r142 (  1 4 ) resistor r=0.0719237 //w=0.222 //l=0.115 //layer=m1 \
 //thickness=0.36 //x=20.72 //y=2.195 //x2=20.72 //y2=2.08
r143 (  1 2 ) resistor r=2.27099 //w=0.131 //l=2.38 //layer=m1 \
 //thickness=0.36 //x=20.72 //y=2.195 //x2=20.72 //y2=4.575
ends PM_DFFSNX1_PCELL\%noxref_14

subckt PM_DFFSNX1_PCELL\%noxref_15 ( 5 7 15 19 30 33 34 )
c63 ( 34 0 ) capacitor c=0.0462219f //x=22.575 //y=0.375
c64 ( 33 0 ) capacitor c=0.0189324f //x=21.47 //y=0.91
c65 ( 30 0 ) capacitor c=0.00141302f //x=22.71 //y=0.995
c66 ( 19 0 ) capacitor c=0.00745448f //x=23.68 //y=0.625
c67 ( 15 0 ) capacitor c=0.015487f //x=23.595 //y=0.54
c68 ( 7 0 ) capacitor c=0.00681713f //x=22.71 //y=0.625
c69 ( 5 0 ) capacitor c=0.0288646f //x=22.625 //y=0.995
r70 (  19 34 ) resistor r=3.57586 //w=0.17 //l=0.125 //layer=li \
 //thickness=0.1 //x=23.68 //y=0.625 //x2=23.68 //y2=0.5
r71 (  19 34 ) resistor r=18.139 //w=0.187 //l=0.265 //layer=li \
 //thickness=0.1 //x=23.68 //y=0.625 //x2=23.68 //y2=0.89
r72 (  16 34 ) resistor r=3.57586 //w=0.17 //l=0.103078 //layer=li \
 //thickness=0.1 //x=22.795 //y=0.54 //x2=22.71 //y2=0.5
r73 (  16 34 ) resistor r=27.3797 //w=0.187 //l=0.4 //layer=li //thickness=0.1 \
 //x=22.795 //y=0.54 //x2=23.195 //y2=0.54
r74 (  15 34 ) resistor r=3.57586 //w=0.17 //l=0.103078 //layer=li \
 //thickness=0.1 //x=23.595 //y=0.54 //x2=23.68 //y2=0.5
r75 (  15 34 ) resistor r=27.3797 //w=0.187 //l=0.4 //layer=li //thickness=0.1 \
 //x=23.595 //y=0.54 //x2=23.195 //y2=0.54
r76 (  11 30 ) resistor r=5.4201 //w=0.17 //l=0.085 //layer=li //thickness=0.1 \
 //x=22.71 //y=1.08 //x2=22.71 //y2=0.995
r77 (  11 34 ) resistor r=10.2674 //w=0.187 //l=0.15 //layer=li \
 //thickness=0.1 //x=22.71 //y=1.08 //x2=22.71 //y2=1.23
r78 (  8 30 ) resistor r=5.4201 //w=0.17 //l=0.085 //layer=li //thickness=0.1 \
 //x=22.71 //y=0.91 //x2=22.71 //y2=0.995
r79 (  8 34 ) resistor r=1.36898 //w=0.187 //l=0.02 //layer=li //thickness=0.1 \
 //x=22.71 //y=0.91 //x2=22.71 //y2=0.89
r80 (  7 34 ) resistor r=3.57586 //w=0.17 //l=0.125 //layer=li //thickness=0.1 \
 //x=22.71 //y=0.625 //x2=22.71 //y2=0.5
r81 (  7 34 ) resistor r=18.139 //w=0.187 //l=0.265 //layer=li //thickness=0.1 \
 //x=22.71 //y=0.625 //x2=22.71 //y2=0.89
r82 (  6 33 ) resistor r=0.751729 //w=0.17 //l=0.085 //layer=li \
 //thickness=0.1 //x=21.745 //y=0.995 //x2=21.66 //y2=0.995
r83 (  5 30 ) resistor r=1.40859 //w=0.34 //l=0.085 //layer=li //thickness=0.1 \
 //x=22.625 //y=0.995 //x2=22.71 //y2=0.995
r84 (  5 6 ) resistor r=60.2353 //w=0.187 //l=0.88 //layer=li //thickness=0.1 \
 //x=22.625 //y=0.995 //x2=21.745 //y2=0.995
ends PM_DFFSNX1_PCELL\%noxref_15

subckt PM_DFFSNX1_PCELL\%noxref_16 ( 1 3 6 7 9 10 11 12 14 15 18 21 27 35 43 \
 55 57 58 59 )
c131 ( 55 0 ) capacitor c=0.00885916f //x=23.005 //y=0.915
c132 ( 43 0 ) capacitor c=0.0293753f //x=22.9 //y=5.38
c133 ( 35 0 ) capacitor c=0.029137f //x=22.02 //y=5.38
c134 ( 27 0 ) capacitor c=0.0277605f //x=21.14 //y=5.38
c135 ( 21 0 ) capacitor c=9.65912e-19 //x=22.9 //y=5.155
c136 ( 18 0 ) capacitor c=0.00814399f //x=22.02 //y=5.155
c137 ( 15 0 ) capacitor c=0.0117279f //x=21.142 //y=5.155
c138 ( 14 0 ) capacitor c=0.13212f //x=23.68 //y=5.07
c139 ( 12 0 ) capacitor c=0.00722566f //x=23.28 //y=1.665
c140 ( 11 0 ) capacitor c=0.018414f //x=23.595 //y=1.665
c141 ( 10 0 ) capacitor c=0.0167333f //x=23.195 //y=1.58
c142 ( 9 0 ) capacitor c=0.0143761f //x=23.195 //y=1.125
c143 ( 7 0 ) capacitor c=0.0293403f //x=23.595 //y=5.155
c144 ( 6 0 ) capacitor c=0.0124512f //x=22.9 //y=5.38
c145 ( 3 0 ) capacitor c=0.018914f //x=22.785 //y=5.155
c146 ( 1 0 ) capacitor c=0.0158145f //x=21.9 //y=5.155
r147 (  43 59 ) resistor r=23.615 //w=0.187 //l=0.345 //layer=li \
 //thickness=0.1 //x=22.9 //y=5.38 //x2=22.9 //y2=5.725
r148 (  35 58 ) resistor r=23.615 //w=0.187 //l=0.345 //layer=li \
 //thickness=0.1 //x=22.02 //y=5.38 //x2=22.02 //y2=5.725
r149 (  27 57 ) resistor r=23.615 //w=0.187 //l=0.345 //layer=li \
 //thickness=0.1 //x=21.14 //y=5.38 //x2=21.14 //y2=5.725
r150 (  25 55 ) resistor r=9.3 //w=0.17 //l=0.17 //layer=mcon //count=1 \
 //x=23.195 //y=1.01 //x2=23.195 //y2=1.01
r151 (  23 43 ) resistor r=9.3 //w=0.17 //l=0.17 //layer=mcon //count=1 \
 //x=22.9 //y=5.38 //x2=22.9 //y2=5.38
r152 (  20 35 ) resistor r=9.3 //w=0.17 //l=0.17 //layer=mcon //count=1 \
 //x=22.02 //y=5.38 //x2=22.02 //y2=5.38
r153 (  18 20 ) resistor r=0.121228 //w=0.232 //l=0.225 //layer=m1 \
 //thickness=0.36 //x=22.02 //y=5.155 //x2=22.02 //y2=5.38
r154 (  17 27 ) resistor r=9.3 //w=0.17 //l=0.17 //layer=mcon //count=1 \
 //x=21.14 //y=5.38 //x2=21.14 //y2=5.38
r155 (  15 17 ) resistor r=0.129608 //w=0.217 //l=0.225 //layer=m1 \
 //thickness=0.36 //x=21.142 //y=5.155 //x2=21.142 //y2=5.38
r156 (  13 14 ) resistor r=3.16794 //w=0.131 //l=3.32 //layer=m1 \
 //thickness=0.36 //x=23.68 //y=1.75 //x2=23.68 //y2=5.07
r157 (  11 13 ) resistor r=0.0698411 //w=0.17 //l=0.120208 //layer=m1 \
 //thickness=0.36 //x=23.595 //y=1.665 //x2=23.68 //y2=1.75
r158 (  11 12 ) resistor r=0.300573 //w=0.131 //l=0.315 //layer=m1 \
 //thickness=0.36 //x=23.595 //y=1.665 //x2=23.28 //y2=1.665
r159 (  10 12 ) resistor r=0.0698411 //w=0.17 //l=0.120208 //layer=m1 \
 //thickness=0.36 //x=23.195 //y=1.58 //x2=23.28 //y2=1.665
r160 (  9 25 ) resistor r=0.0717383 //w=0.224 //l=0.115 //layer=m1 \
 //thickness=0.36 //x=23.195 //y=1.125 //x2=23.195 //y2=1.01
r161 (  9 10 ) resistor r=0.43416 //w=0.131 //l=0.455 //layer=m1 \
 //thickness=0.36 //x=23.195 //y=1.125 //x2=23.195 //y2=1.58
r162 (  8 21 ) resistor r=0.0675342 //w=0.23 //l=0.115 //layer=m1 \
 //thickness=0.36 //x=23.015 //y=5.155 //x2=22.9 //y2=5.155
r163 (  7 14 ) resistor r=0.0698411 //w=0.17 //l=0.120208 //layer=m1 \
 //thickness=0.36 //x=23.595 //y=5.155 //x2=23.68 //y2=5.07
r164 (  7 8 ) resistor r=0.553435 //w=0.131 //l=0.58 //layer=m1 \
 //thickness=0.36 //x=23.595 //y=5.155 //x2=23.015 //y2=5.155
r165 (  6 23 ) resistor r=0.00118313 //w=0.23 //layer=m1 //thickness=0.36 \
 //x=22.9 //y=5.38 //x2=22.9 //y2=5.38
r166 (  5 21 ) resistor r=0.002872 //w=0.34 //l=0.085 //layer=m1 \
 //thickness=0.36 //x=22.9 //y=5.24 //x2=22.9 //y2=5.155
r167 (  5 6 ) resistor r=0.091623 //w=0.191 //l=0.14 //layer=m1 \
 //thickness=0.36 //x=22.9 //y=5.24 //x2=22.9 //y2=5.38
r168 (  4 18 ) resistor r=0.0262263 //w=0.232 //l=0.12 //layer=m1 \
 //thickness=0.36 //x=22.14 //y=5.155 //x2=22.02 //y2=5.155
r169 (  3 21 ) resistor r=0.0675342 //w=0.23 //l=0.115 //layer=m1 \
 //thickness=0.36 //x=22.785 //y=5.155 //x2=22.9 //y2=5.155
r170 (  3 4 ) resistor r=0.615458 //w=0.131 //l=0.645 //layer=m1 \
 //thickness=0.36 //x=22.785 //y=5.155 //x2=22.14 //y2=5.155
r171 (  2 15 ) resistor r=0.0222262 //w=0.217 //l=0.118 //layer=m1 \
 //thickness=0.36 //x=21.26 //y=5.155 //x2=21.142 //y2=5.155
r172 (  1 18 ) resistor r=0.0262263 //w=0.232 //l=0.12 //layer=m1 \
 //thickness=0.36 //x=21.9 //y=5.155 //x2=22.02 //y2=5.155
r173 (  1 2 ) resistor r=0.610687 //w=0.131 //l=0.64 //layer=m1 \
 //thickness=0.36 //x=21.9 //y=5.155 //x2=21.26 //y2=5.155
ends PM_DFFSNX1_PCELL\%noxref_16

subckt PM_DFFSNX1_PCELL\%noxref_17 ( 1 5 9 10 13 17 29 )
c60 ( 29 0 ) capacitor c=0.0672418f //x=0.56 //y=0.365
c61 ( 17 0 ) capacitor c=0.00675704f //x=2.635 //y=0.615
c62 ( 13 0 ) capacitor c=0.0157477f //x=2.55 //y=0.53
c63 ( 10 0 ) capacitor c=0.0091713f //x=1.665 //y=1.495
c64 ( 9 0 ) capacitor c=0.00770028f //x=1.665 //y=0.615
c65 ( 5 0 ) capacitor c=0.0246013f //x=1.58 //y=1.58
c66 ( 1 0 ) capacitor c=0.0115037f //x=0.695 //y=1.495
r67 (  17 29 ) resistor r=3.57586 //w=0.17 //l=0.125 //layer=li \
 //thickness=0.1 //x=2.635 //y=0.615 //x2=2.635 //y2=0.49
r68 (  17 29 ) resistor r=18.139 //w=0.187 //l=0.265 //layer=li \
 //thickness=0.1 //x=2.635 //y=0.615 //x2=2.635 //y2=0.88
r69 (  14 29 ) resistor r=3.57586 //w=0.17 //l=0.103078 //layer=li \
 //thickness=0.1 //x=1.75 //y=0.53 //x2=1.665 //y2=0.49
r70 (  14 29 ) resistor r=27.3797 //w=0.187 //l=0.4 //layer=li //thickness=0.1 \
 //x=1.75 //y=0.53 //x2=2.15 //y2=0.53
r71 (  13 29 ) resistor r=3.57586 //w=0.17 //l=0.103078 //layer=li \
 //thickness=0.1 //x=2.55 //y=0.53 //x2=2.635 //y2=0.49
r72 (  13 29 ) resistor r=27.3797 //w=0.187 //l=0.4 //layer=li //thickness=0.1 \
 //x=2.55 //y=0.53 //x2=2.15 //y2=0.53
r73 (  10 29 ) resistor r=3.57586 //w=0.17 //l=0.125 //layer=li \
 //thickness=0.1 //x=1.665 //y=1.495 //x2=1.665 //y2=1.62
r74 (  10 29 ) resistor r=42.0963 //w=0.187 //l=0.615 //layer=li \
 //thickness=0.1 //x=1.665 //y=1.495 //x2=1.665 //y2=0.88
r75 (  9 29 ) resistor r=3.57586 //w=0.17 //l=0.125 //layer=li //thickness=0.1 \
 //x=1.665 //y=0.615 //x2=1.665 //y2=0.49
r76 (  9 29 ) resistor r=18.139 //w=0.187 //l=0.265 //layer=li //thickness=0.1 \
 //x=1.665 //y=0.615 //x2=1.665 //y2=0.88
r77 (  6 29 ) resistor r=3.57586 //w=0.17 //l=0.103078 //layer=li \
 //thickness=0.1 //x=0.78 //y=1.58 //x2=0.695 //y2=1.62
r78 (  6 29 ) resistor r=27.3797 //w=0.187 //l=0.4 //layer=li //thickness=0.1 \
 //x=0.78 //y=1.58 //x2=1.18 //y2=1.58
r79 (  5 29 ) resistor r=3.57586 //w=0.17 //l=0.103078 //layer=li \
 //thickness=0.1 //x=1.58 //y=1.58 //x2=1.665 //y2=1.62
r80 (  5 29 ) resistor r=27.3797 //w=0.187 //l=0.4 //layer=li //thickness=0.1 \
 //x=1.58 //y=1.58 //x2=1.18 //y2=1.58
r81 (  1 29 ) resistor r=3.57586 //w=0.17 //l=0.125 //layer=li //thickness=0.1 \
 //x=0.695 //y=1.495 //x2=0.695 //y2=1.62
r82 (  1 29 ) resistor r=42.0963 //w=0.187 //l=0.615 //layer=li \
 //thickness=0.1 //x=0.695 //y=1.495 //x2=0.695 //y2=0.88
ends PM_DFFSNX1_PCELL\%noxref_17

subckt PM_DFFSNX1_PCELL\%noxref_18 ( 1 5 9 13 17 35 )
c60 ( 35 0 ) capacitor c=0.0691972f //x=3.785 //y=0.375
c61 ( 17 0 ) capacitor c=0.0195855f //x=5.775 //y=1.59
c62 ( 13 0 ) capacitor c=0.015342f //x=5.775 //y=0.54
c63 ( 9 0 ) capacitor c=0.00772076f //x=4.89 //y=0.625
c64 ( 5 0 ) capacitor c=0.0168722f //x=4.805 //y=1.59
c65 ( 1 0 ) capacitor c=0.00726193f //x=3.92 //y=1.505
r66 (  18 35 ) resistor r=5.4201 //w=0.17 //l=0.103078 //layer=li \
 //thickness=0.1 //x=4.975 //y=1.59 //x2=4.89 //y2=1.63
r67 (  18 35 ) resistor r=27.3797 //w=0.187 //l=0.4 //layer=li //thickness=0.1 \
 //x=4.975 //y=1.59 //x2=5.375 //y2=1.59
r68 (  17 35 ) resistor r=0.751729 //w=0.17 //l=0.085 //layer=li \
 //thickness=0.1 //x=5.775 //y=1.59 //x2=5.86 //y2=1.59
r69 (  17 35 ) resistor r=27.3797 //w=0.187 //l=0.4 //layer=li //thickness=0.1 \
 //x=5.775 //y=1.59 //x2=5.375 //y2=1.59
r70 (  14 35 ) resistor r=3.57586 //w=0.17 //l=0.103078 //layer=li \
 //thickness=0.1 //x=4.975 //y=0.54 //x2=4.89 //y2=0.5
r71 (  14 35 ) resistor r=27.3797 //w=0.187 //l=0.4 //layer=li //thickness=0.1 \
 //x=4.975 //y=0.54 //x2=5.375 //y2=0.54
r72 (  13 35 ) resistor r=0.751729 //w=0.17 //l=0.085 //layer=li \
 //thickness=0.1 //x=5.775 //y=0.54 //x2=5.86 //y2=0.54
r73 (  13 35 ) resistor r=27.3797 //w=0.187 //l=0.4 //layer=li //thickness=0.1 \
 //x=5.775 //y=0.54 //x2=5.375 //y2=0.54
r74 (  10 35 ) resistor r=1.40859 //w=0.34 //l=0.125 //layer=li \
 //thickness=0.1 //x=4.89 //y=1.505 //x2=4.89 //y2=1.63
r75 (  10 35 ) resistor r=42.0963 //w=0.187 //l=0.615 //layer=li \
 //thickness=0.1 //x=4.89 //y=1.505 //x2=4.89 //y2=0.89
r76 (  9 35 ) resistor r=3.57586 //w=0.17 //l=0.125 //layer=li //thickness=0.1 \
 //x=4.89 //y=0.625 //x2=4.89 //y2=0.5
r77 (  9 35 ) resistor r=18.139 //w=0.187 //l=0.265 //layer=li //thickness=0.1 \
 //x=4.89 //y=0.625 //x2=4.89 //y2=0.89
r78 (  6 35 ) resistor r=3.57586 //w=0.17 //l=0.103078 //layer=li \
 //thickness=0.1 //x=4.005 //y=1.59 //x2=3.92 //y2=1.63
r79 (  6 35 ) resistor r=27.3797 //w=0.187 //l=0.4 //layer=li //thickness=0.1 \
 //x=4.005 //y=1.59 //x2=4.405 //y2=1.59
r80 (  5 35 ) resistor r=5.4201 //w=0.17 //l=0.103078 //layer=li \
 //thickness=0.1 //x=4.805 //y=1.59 //x2=4.89 //y2=1.63
r81 (  5 35 ) resistor r=27.3797 //w=0.187 //l=0.4 //layer=li //thickness=0.1 \
 //x=4.805 //y=1.59 //x2=4.405 //y2=1.59
r82 (  1 35 ) resistor r=3.57586 //w=0.17 //l=0.125 //layer=li //thickness=0.1 \
 //x=3.92 //y=1.505 //x2=3.92 //y2=1.63
r83 (  1 35 ) resistor r=42.0963 //w=0.187 //l=0.615 //layer=li \
 //thickness=0.1 //x=3.92 //y=1.505 //x2=3.92 //y2=0.89
ends PM_DFFSNX1_PCELL\%noxref_18

subckt PM_DFFSNX1_PCELL\%noxref_19 ( 1 5 9 13 17 35 )
c60 ( 35 0 ) capacitor c=0.0699708f //x=8.595 //y=0.375
c61 ( 17 0 ) capacitor c=0.0209666f //x=10.585 //y=1.59
c62 ( 13 0 ) capacitor c=0.0153215f //x=10.585 //y=0.54
c63 ( 9 0 ) capacitor c=0.00772076f //x=9.7 //y=0.625
c64 ( 5 0 ) capacitor c=0.0178423f //x=9.615 //y=1.59
c65 ( 1 0 ) capacitor c=0.00727095f //x=8.73 //y=1.505
r66 (  18 35 ) resistor r=5.4201 //w=0.17 //l=0.103078 //layer=li \
 //thickness=0.1 //x=9.785 //y=1.59 //x2=9.7 //y2=1.63
r67 (  18 35 ) resistor r=27.3797 //w=0.187 //l=0.4 //layer=li //thickness=0.1 \
 //x=9.785 //y=1.59 //x2=10.185 //y2=1.59
r68 (  17 35 ) resistor r=0.751729 //w=0.17 //l=0.085 //layer=li \
 //thickness=0.1 //x=10.585 //y=1.59 //x2=10.67 //y2=1.59
r69 (  17 35 ) resistor r=27.3797 //w=0.187 //l=0.4 //layer=li //thickness=0.1 \
 //x=10.585 //y=1.59 //x2=10.185 //y2=1.59
r70 (  14 35 ) resistor r=3.57586 //w=0.17 //l=0.103078 //layer=li \
 //thickness=0.1 //x=9.785 //y=0.54 //x2=9.7 //y2=0.5
r71 (  14 35 ) resistor r=27.3797 //w=0.187 //l=0.4 //layer=li //thickness=0.1 \
 //x=9.785 //y=0.54 //x2=10.185 //y2=0.54
r72 (  13 35 ) resistor r=0.751729 //w=0.17 //l=0.085 //layer=li \
 //thickness=0.1 //x=10.585 //y=0.54 //x2=10.67 //y2=0.54
r73 (  13 35 ) resistor r=27.3797 //w=0.187 //l=0.4 //layer=li //thickness=0.1 \
 //x=10.585 //y=0.54 //x2=10.185 //y2=0.54
r74 (  10 35 ) resistor r=1.40859 //w=0.34 //l=0.125 //layer=li \
 //thickness=0.1 //x=9.7 //y=1.505 //x2=9.7 //y2=1.63
r75 (  10 35 ) resistor r=42.0963 //w=0.187 //l=0.615 //layer=li \
 //thickness=0.1 //x=9.7 //y=1.505 //x2=9.7 //y2=0.89
r76 (  9 35 ) resistor r=3.57586 //w=0.17 //l=0.125 //layer=li //thickness=0.1 \
 //x=9.7 //y=0.625 //x2=9.7 //y2=0.5
r77 (  9 35 ) resistor r=18.139 //w=0.187 //l=0.265 //layer=li //thickness=0.1 \
 //x=9.7 //y=0.625 //x2=9.7 //y2=0.89
r78 (  6 35 ) resistor r=3.57586 //w=0.17 //l=0.103078 //layer=li \
 //thickness=0.1 //x=8.815 //y=1.59 //x2=8.73 //y2=1.63
r79 (  6 35 ) resistor r=27.3797 //w=0.187 //l=0.4 //layer=li //thickness=0.1 \
 //x=8.815 //y=1.59 //x2=9.215 //y2=1.59
r80 (  5 35 ) resistor r=5.4201 //w=0.17 //l=0.103078 //layer=li \
 //thickness=0.1 //x=9.615 //y=1.59 //x2=9.7 //y2=1.63
r81 (  5 35 ) resistor r=27.3797 //w=0.187 //l=0.4 //layer=li //thickness=0.1 \
 //x=9.615 //y=1.59 //x2=9.215 //y2=1.59
r82 (  1 35 ) resistor r=3.57586 //w=0.17 //l=0.125 //layer=li //thickness=0.1 \
 //x=8.73 //y=1.505 //x2=8.73 //y2=1.63
r83 (  1 35 ) resistor r=42.0963 //w=0.187 //l=0.615 //layer=li \
 //thickness=0.1 //x=8.73 //y=1.505 //x2=8.73 //y2=0.89
ends PM_DFFSNX1_PCELL\%noxref_19

subckt PM_DFFSNX1_PCELL\%noxref_20 ( 1 5 9 10 13 17 29 )
c67 ( 29 0 ) capacitor c=0.0671873f //x=13.51 //y=0.365
c68 ( 17 0 ) capacitor c=0.0067865f //x=15.585 //y=0.615
c69 ( 13 0 ) capacitor c=0.0154977f //x=15.5 //y=0.53
c70 ( 10 0 ) capacitor c=0.00678687f //x=14.615 //y=1.495
c71 ( 9 0 ) capacitor c=0.00770028f //x=14.615 //y=0.615
c72 ( 5 0 ) capacitor c=0.0179209f //x=14.53 //y=1.58
c73 ( 1 0 ) capacitor c=0.00761099f //x=13.645 //y=1.495
r74 (  17 29 ) resistor r=3.57586 //w=0.17 //l=0.125 //layer=li \
 //thickness=0.1 //x=15.585 //y=0.615 //x2=15.585 //y2=0.49
r75 (  17 29 ) resistor r=18.139 //w=0.187 //l=0.265 //layer=li \
 //thickness=0.1 //x=15.585 //y=0.615 //x2=15.585 //y2=0.88
r76 (  14 29 ) resistor r=3.57586 //w=0.17 //l=0.103078 //layer=li \
 //thickness=0.1 //x=14.7 //y=0.53 //x2=14.615 //y2=0.49
r77 (  14 29 ) resistor r=27.3797 //w=0.187 //l=0.4 //layer=li //thickness=0.1 \
 //x=14.7 //y=0.53 //x2=15.1 //y2=0.53
r78 (  13 29 ) resistor r=3.57586 //w=0.17 //l=0.103078 //layer=li \
 //thickness=0.1 //x=15.5 //y=0.53 //x2=15.585 //y2=0.49
r79 (  13 29 ) resistor r=27.3797 //w=0.187 //l=0.4 //layer=li //thickness=0.1 \
 //x=15.5 //y=0.53 //x2=15.1 //y2=0.53
r80 (  10 29 ) resistor r=3.57586 //w=0.17 //l=0.125 //layer=li \
 //thickness=0.1 //x=14.615 //y=1.495 //x2=14.615 //y2=1.62
r81 (  10 29 ) resistor r=42.0963 //w=0.187 //l=0.615 //layer=li \
 //thickness=0.1 //x=14.615 //y=1.495 //x2=14.615 //y2=0.88
r82 (  9 29 ) resistor r=3.57586 //w=0.17 //l=0.125 //layer=li //thickness=0.1 \
 //x=14.615 //y=0.615 //x2=14.615 //y2=0.49
r83 (  9 29 ) resistor r=18.139 //w=0.187 //l=0.265 //layer=li //thickness=0.1 \
 //x=14.615 //y=0.615 //x2=14.615 //y2=0.88
r84 (  6 29 ) resistor r=3.57586 //w=0.17 //l=0.103078 //layer=li \
 //thickness=0.1 //x=13.73 //y=1.58 //x2=13.645 //y2=1.62
r85 (  6 29 ) resistor r=27.3797 //w=0.187 //l=0.4 //layer=li //thickness=0.1 \
 //x=13.73 //y=1.58 //x2=14.13 //y2=1.58
r86 (  5 29 ) resistor r=3.57586 //w=0.17 //l=0.103078 //layer=li \
 //thickness=0.1 //x=14.53 //y=1.58 //x2=14.615 //y2=1.62
r87 (  5 29 ) resistor r=27.3797 //w=0.187 //l=0.4 //layer=li //thickness=0.1 \
 //x=14.53 //y=1.58 //x2=14.13 //y2=1.58
r88 (  1 29 ) resistor r=3.57586 //w=0.17 //l=0.125 //layer=li //thickness=0.1 \
 //x=13.645 //y=1.495 //x2=13.645 //y2=1.62
r89 (  1 29 ) resistor r=42.0963 //w=0.187 //l=0.615 //layer=li \
 //thickness=0.1 //x=13.645 //y=1.495 //x2=13.645 //y2=0.88
ends PM_DFFSNX1_PCELL\%noxref_20

subckt PM_DFFSNX1_PCELL\%noxref_21 ( 1 5 9 10 13 17 29 )
c66 ( 29 0 ) capacitor c=0.0666509f //x=16.84 //y=0.365
c67 ( 17 0 ) capacitor c=0.00675704f //x=18.915 //y=0.615
c68 ( 13 0 ) capacitor c=0.0154977f //x=18.83 //y=0.53
c69 ( 10 0 ) capacitor c=0.00666504f //x=17.945 //y=1.495
c70 ( 9 0 ) capacitor c=0.00770028f //x=17.945 //y=0.615
c71 ( 5 0 ) capacitor c=0.0179513f //x=17.86 //y=1.58
c72 ( 1 0 ) capacitor c=0.00760142f //x=16.975 //y=1.495
r73 (  17 29 ) resistor r=3.57586 //w=0.17 //l=0.125 //layer=li \
 //thickness=0.1 //x=18.915 //y=0.615 //x2=18.915 //y2=0.49
r74 (  17 29 ) resistor r=18.139 //w=0.187 //l=0.265 //layer=li \
 //thickness=0.1 //x=18.915 //y=0.615 //x2=18.915 //y2=0.88
r75 (  14 29 ) resistor r=3.57586 //w=0.17 //l=0.103078 //layer=li \
 //thickness=0.1 //x=18.03 //y=0.53 //x2=17.945 //y2=0.49
r76 (  14 29 ) resistor r=27.3797 //w=0.187 //l=0.4 //layer=li //thickness=0.1 \
 //x=18.03 //y=0.53 //x2=18.43 //y2=0.53
r77 (  13 29 ) resistor r=3.57586 //w=0.17 //l=0.103078 //layer=li \
 //thickness=0.1 //x=18.83 //y=0.53 //x2=18.915 //y2=0.49
r78 (  13 29 ) resistor r=27.3797 //w=0.187 //l=0.4 //layer=li //thickness=0.1 \
 //x=18.83 //y=0.53 //x2=18.43 //y2=0.53
r79 (  10 29 ) resistor r=3.57586 //w=0.17 //l=0.125 //layer=li \
 //thickness=0.1 //x=17.945 //y=1.495 //x2=17.945 //y2=1.62
r80 (  10 29 ) resistor r=42.0963 //w=0.187 //l=0.615 //layer=li \
 //thickness=0.1 //x=17.945 //y=1.495 //x2=17.945 //y2=0.88
r81 (  9 29 ) resistor r=3.57586 //w=0.17 //l=0.125 //layer=li //thickness=0.1 \
 //x=17.945 //y=0.615 //x2=17.945 //y2=0.49
r82 (  9 29 ) resistor r=18.139 //w=0.187 //l=0.265 //layer=li //thickness=0.1 \
 //x=17.945 //y=0.615 //x2=17.945 //y2=0.88
r83 (  6 29 ) resistor r=3.57586 //w=0.17 //l=0.103078 //layer=li \
 //thickness=0.1 //x=17.06 //y=1.58 //x2=16.975 //y2=1.62
r84 (  6 29 ) resistor r=27.3797 //w=0.187 //l=0.4 //layer=li //thickness=0.1 \
 //x=17.06 //y=1.58 //x2=17.46 //y2=1.58
r85 (  5 29 ) resistor r=3.57586 //w=0.17 //l=0.103078 //layer=li \
 //thickness=0.1 //x=17.86 //y=1.58 //x2=17.945 //y2=1.62
r86 (  5 29 ) resistor r=27.3797 //w=0.187 //l=0.4 //layer=li //thickness=0.1 \
 //x=17.86 //y=1.58 //x2=17.46 //y2=1.58
r87 (  1 29 ) resistor r=3.57586 //w=0.17 //l=0.125 //layer=li //thickness=0.1 \
 //x=16.975 //y=1.495 //x2=16.975 //y2=1.62
r88 (  1 29 ) resistor r=42.0963 //w=0.187 //l=0.615 //layer=li \
 //thickness=0.1 //x=16.975 //y=1.495 //x2=16.975 //y2=0.88
ends PM_DFFSNX1_PCELL\%noxref_21

subckt PM_DFFSNX1_PCELL\%noxref_22 ( 1 5 9 13 17 35 )
c57 ( 35 0 ) capacitor c=0.0700921f //x=20.065 //y=0.375
c58 ( 17 0 ) capacitor c=0.0192236f //x=22.055 //y=1.59
c59 ( 13 0 ) capacitor c=0.0153834f //x=22.055 //y=0.54
c60 ( 9 0 ) capacitor c=0.00772076f //x=21.17 //y=0.625
c61 ( 5 0 ) capacitor c=0.0167423f //x=21.085 //y=1.59
c62 ( 1 0 ) capacitor c=0.00709556f //x=20.2 //y=1.505
r63 (  18 35 ) resistor r=5.4201 //w=0.17 //l=0.103078 //layer=li \
 //thickness=0.1 //x=21.255 //y=1.59 //x2=21.17 //y2=1.63
r64 (  18 35 ) resistor r=27.3797 //w=0.187 //l=0.4 //layer=li //thickness=0.1 \
 //x=21.255 //y=1.59 //x2=21.655 //y2=1.59
r65 (  17 35 ) resistor r=0.751729 //w=0.17 //l=0.085 //layer=li \
 //thickness=0.1 //x=22.055 //y=1.59 //x2=22.14 //y2=1.59
r66 (  17 35 ) resistor r=27.3797 //w=0.187 //l=0.4 //layer=li //thickness=0.1 \
 //x=22.055 //y=1.59 //x2=21.655 //y2=1.59
r67 (  14 35 ) resistor r=3.57586 //w=0.17 //l=0.103078 //layer=li \
 //thickness=0.1 //x=21.255 //y=0.54 //x2=21.17 //y2=0.5
r68 (  14 35 ) resistor r=27.3797 //w=0.187 //l=0.4 //layer=li //thickness=0.1 \
 //x=21.255 //y=0.54 //x2=21.655 //y2=0.54
r69 (  13 35 ) resistor r=0.751729 //w=0.17 //l=0.085 //layer=li \
 //thickness=0.1 //x=22.055 //y=0.54 //x2=22.14 //y2=0.54
r70 (  13 35 ) resistor r=27.3797 //w=0.187 //l=0.4 //layer=li //thickness=0.1 \
 //x=22.055 //y=0.54 //x2=21.655 //y2=0.54
r71 (  10 35 ) resistor r=1.40859 //w=0.34 //l=0.125 //layer=li \
 //thickness=0.1 //x=21.17 //y=1.505 //x2=21.17 //y2=1.63
r72 (  10 35 ) resistor r=42.0963 //w=0.187 //l=0.615 //layer=li \
 //thickness=0.1 //x=21.17 //y=1.505 //x2=21.17 //y2=0.89
r73 (  9 35 ) resistor r=3.57586 //w=0.17 //l=0.125 //layer=li //thickness=0.1 \
 //x=21.17 //y=0.625 //x2=21.17 //y2=0.5
r74 (  9 35 ) resistor r=18.139 //w=0.187 //l=0.265 //layer=li //thickness=0.1 \
 //x=21.17 //y=0.625 //x2=21.17 //y2=0.89
r75 (  6 35 ) resistor r=3.57586 //w=0.17 //l=0.103078 //layer=li \
 //thickness=0.1 //x=20.285 //y=1.59 //x2=20.2 //y2=1.63
r76 (  6 35 ) resistor r=27.3797 //w=0.187 //l=0.4 //layer=li //thickness=0.1 \
 //x=20.285 //y=1.59 //x2=20.685 //y2=1.59
r77 (  5 35 ) resistor r=5.4201 //w=0.17 //l=0.103078 //layer=li \
 //thickness=0.1 //x=21.085 //y=1.59 //x2=21.17 //y2=1.63
r78 (  5 35 ) resistor r=27.3797 //w=0.187 //l=0.4 //layer=li //thickness=0.1 \
 //x=21.085 //y=1.59 //x2=20.685 //y2=1.59
r79 (  1 35 ) resistor r=3.57586 //w=0.17 //l=0.125 //layer=li //thickness=0.1 \
 //x=20.2 //y=1.505 //x2=20.2 //y2=1.63
r80 (  1 35 ) resistor r=42.0963 //w=0.187 //l=0.615 //layer=li \
 //thickness=0.1 //x=20.2 //y=1.505 //x2=20.2 //y2=0.89
ends PM_DFFSNX1_PCELL\%noxref_22
