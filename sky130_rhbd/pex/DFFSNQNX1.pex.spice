// File: DFFSNQNX1.spi.pex
// Created: Tue Apr 29 10:40:26 2025
// Program "Calibre xRC"
// Version "v2023.2_27.15"
// Nominal Temperature: 30C
// Circuit Temperature: 30C
//
simulator lang=spectre
subckt PM_DFFSNQNX1\%GND ( 1 43 47 50 55 63 69 79 85 95 101 107 115 123 138 \
 144 147 150 153 155 158 159 160 161 162 163 )
c289 ( 163 0 ) capacitor c=0.0226075f //x=20.93 //y=1.055
c290 ( 162 0 ) capacitor c=0.0207408f //x=17.705 //y=1.045
c291 ( 161 0 ) capacitor c=0.0207408f //x=14.375 //y=1.045
c292 ( 160 0 ) capacitor c=0.0226206f //x=9.46 //y=1.055
c293 ( 159 0 ) capacitor c=0.0226323f //x=4.65 //y=1.055
c294 ( 158 0 ) capacitor c=0.0208628f //x=1.425 //y=1.045
c295 ( 156 0 ) capacitor c=0.00446464f //x=21.12 //y=0.175
c296 ( 155 0 ) capacitor c=0.10409f //x=20.045 //y=0.175
c297 ( 154 0 ) capacitor c=0.00446416f //x=17.895 //y=0.175
c298 ( 153 0 ) capacitor c=0.106406f //x=16.715 //y=0.175
c299 ( 152 0 ) capacitor c=0.00446416f //x=14.495 //y=0.18
c300 ( 150 0 ) capacitor c=0.108374f //x=13.385 //y=0.175
c301 ( 149 0 ) capacitor c=0.00446464f //x=9.685 //y=0.18
c302 ( 147 0 ) capacitor c=0.108361f //x=8.575 //y=0.175
c303 ( 146 0 ) capacitor c=0.00446464f //x=4.875 //y=0.18
c304 ( 144 0 ) capacitor c=0.105439f //x=3.765 //y=0.175
c305 ( 143 0 ) capacitor c=0.00446416f //x=1.615 //y=0.175
c306 ( 138 0 ) capacitor c=0.347799f //x=24.115 //y=0.18
c307 ( 123 0 ) capacitor c=0.0342713f //x=21.035 //y=0.175
c308 ( 115 0 ) capacitor c=0.0728385f //x=19.875 //y=0.175
c309 ( 107 0 ) capacitor c=0.0392405f //x=17.81 //y=0.175
c310 ( 101 0 ) capacitor c=0.0727058f //x=16.545 //y=0.175
c311 ( 95 0 ) capacitor c=0.0392405f //x=14.48 //y=0.175
c312 ( 85 0 ) capacitor c=0.13511f //x=13.215 //y=0.175
c313 ( 79 0 ) capacitor c=0.0342869f //x=9.565 //y=0.175
c314 ( 69 0 ) capacitor c=0.135219f //x=8.405 //y=0.175
c315 ( 63 0 ) capacitor c=0.0342869f //x=4.755 //y=0.175
c316 ( 55 0 ) capacitor c=0.0729644f //x=3.595 //y=0.175
c317 ( 50 0 ) capacitor c=0.194784f //x=1.175 //y=0.18
c318 ( 47 0 ) capacitor c=0.0430284f //x=1.53 //y=0.175
c319 ( 43 0 ) capacitor c=0.812239f //x=24.115 //y=0.18
r320 (  136 138 ) resistor r=38.7139 //w=0.367 //l=1.11 //layer=li \
 //thickness=0.1 //x=23.005 //y=0.175 //x2=24.115 //y2=0.175
r321 (  134 136 ) resistor r=38.7139 //w=0.367 //l=1.11 //layer=li \
 //thickness=0.1 //x=21.895 //y=0.175 //x2=23.005 //y2=0.175
r322 (  132 156 ) resistor r=2.87058 //w=0.35 //l=0.085 //layer=li \
 //thickness=0.1 //x=21.205 //y=0.175 //x2=21.12 //y2=0.175
r323 (  132 134 ) resistor r=24.0654 //w=0.367 //l=0.69 //layer=li \
 //thickness=0.1 //x=21.205 //y=0.175 //x2=21.895 //y2=0.175
r324 (  127 156 ) resistor r=4.23183 //w=0.7 //l=0.175 //layer=li \
 //thickness=0.1 //x=21.12 //y=0.35 //x2=21.12 //y2=0.175
r325 (  127 163 ) resistor r=54.4171 //w=0.187 //l=0.795 //layer=li \
 //thickness=0.1 //x=21.12 //y=0.35 //x2=21.12 //y2=1.145
r326 (  124 155 ) resistor r=5.29055 //w=0.35 //l=0.17 //layer=li \
 //thickness=0.1 //x=20.215 //y=0.175 //x2=20.045 //y2=0.175
r327 (  124 126 ) resistor r=19.8801 //w=0.367 //l=0.57 //layer=li \
 //thickness=0.1 //x=20.215 //y=0.175 //x2=20.785 //y2=0.175
r328 (  123 156 ) resistor r=2.87058 //w=0.35 //l=0.085 //layer=li \
 //thickness=0.1 //x=21.035 //y=0.175 //x2=21.12 //y2=0.175
r329 (  123 126 ) resistor r=8.71935 //w=0.367 //l=0.25 //layer=li \
 //thickness=0.1 //x=21.035 //y=0.175 //x2=20.785 //y2=0.175
r330 (  118 120 ) resistor r=38.7139 //w=0.367 //l=1.11 //layer=li \
 //thickness=0.1 //x=18.195 //y=0.175 //x2=19.305 //y2=0.175
r331 (  116 154 ) resistor r=2.87058 //w=0.35 //l=0.085 //layer=li \
 //thickness=0.1 //x=17.98 //y=0.175 //x2=17.895 //y2=0.175
r332 (  116 118 ) resistor r=7.49864 //w=0.367 //l=0.215 //layer=li \
 //thickness=0.1 //x=17.98 //y=0.175 //x2=18.195 //y2=0.175
r333 (  115 155 ) resistor r=5.29055 //w=0.35 //l=0.17 //layer=li \
 //thickness=0.1 //x=19.875 //y=0.175 //x2=20.045 //y2=0.175
r334 (  115 120 ) resistor r=19.8801 //w=0.367 //l=0.57 //layer=li \
 //thickness=0.1 //x=19.875 //y=0.175 //x2=19.305 //y2=0.175
r335 (  111 154 ) resistor r=4.23183 //w=0.7 //l=0.175 //layer=li \
 //thickness=0.1 //x=17.895 //y=0.35 //x2=17.895 //y2=0.175
r336 (  111 162 ) resistor r=53.7326 //w=0.187 //l=0.785 //layer=li \
 //thickness=0.1 //x=17.895 //y=0.35 //x2=17.895 //y2=1.135
r337 (  108 153 ) resistor r=5.29055 //w=0.35 //l=0.17 //layer=li \
 //thickness=0.1 //x=16.885 //y=0.175 //x2=16.715 //y2=0.175
r338 (  108 110 ) resistor r=6.97548 //w=0.367 //l=0.2 //layer=li \
 //thickness=0.1 //x=16.885 //y=0.175 //x2=17.085 //y2=0.175
r339 (  107 154 ) resistor r=2.87058 //w=0.35 //l=0.085 //layer=li \
 //thickness=0.1 //x=17.81 //y=0.175 //x2=17.895 //y2=0.175
r340 (  107 110 ) resistor r=25.2861 //w=0.367 //l=0.725 //layer=li \
 //thickness=0.1 //x=17.81 //y=0.175 //x2=17.085 //y2=0.175
r341 (  102 152 ) resistor r=2.87058 //w=0.35 //l=0.085 //layer=li \
 //thickness=0.1 //x=14.65 //y=0.175 //x2=14.565 //y2=0.175
r342 (  102 104 ) resistor r=33.3079 //w=0.367 //l=0.955 //layer=li \
 //thickness=0.1 //x=14.65 //y=0.175 //x2=15.605 //y2=0.175
r343 (  101 153 ) resistor r=5.29055 //w=0.35 //l=0.17 //layer=li \
 //thickness=0.1 //x=16.545 //y=0.175 //x2=16.715 //y2=0.175
r344 (  101 104 ) resistor r=32.7847 //w=0.367 //l=0.94 //layer=li \
 //thickness=0.1 //x=16.545 //y=0.175 //x2=15.605 //y2=0.175
r345 (  97 152 ) resistor r=4.23183 //w=0.7 //l=0.175 //layer=li \
 //thickness=0.1 //x=14.565 //y=0.35 //x2=14.565 //y2=0.175
r346 (  97 161 ) resistor r=53.7326 //w=0.187 //l=0.785 //layer=li \
 //thickness=0.1 //x=14.565 //y=0.35 //x2=14.565 //y2=1.135
r347 (  96 150 ) resistor r=5.29055 //w=0.35 //l=0.17 //layer=li \
 //thickness=0.1 //x=13.555 //y=0.175 //x2=13.385 //y2=0.175
r348 (  95 152 ) resistor r=2.87058 //w=0.35 //l=0.085 //layer=li \
 //thickness=0.1 //x=14.48 //y=0.175 //x2=14.565 //y2=0.175
r349 (  95 96 ) resistor r=32.2616 //w=0.367 //l=0.925 //layer=li \
 //thickness=0.1 //x=14.48 //y=0.175 //x2=13.555 //y2=0.175
r350 (  90 92 ) resistor r=38.7139 //w=0.367 //l=1.11 //layer=li \
 //thickness=0.1 //x=11.905 //y=0.175 //x2=13.015 //y2=0.175
r351 (  88 90 ) resistor r=38.7139 //w=0.367 //l=1.11 //layer=li \
 //thickness=0.1 //x=10.795 //y=0.175 //x2=11.905 //y2=0.175
r352 (  86 149 ) resistor r=2.87058 //w=0.35 //l=0.085 //layer=li \
 //thickness=0.1 //x=9.735 //y=0.175 //x2=9.65 //y2=0.175
r353 (  86 88 ) resistor r=36.97 //w=0.367 //l=1.06 //layer=li //thickness=0.1 \
 //x=9.735 //y=0.175 //x2=10.795 //y2=0.175
r354 (  85 150 ) resistor r=5.29055 //w=0.35 //l=0.17 //layer=li \
 //thickness=0.1 //x=13.215 //y=0.175 //x2=13.385 //y2=0.175
r355 (  85 92 ) resistor r=6.97548 //w=0.367 //l=0.2 //layer=li \
 //thickness=0.1 //x=13.215 //y=0.175 //x2=13.015 //y2=0.175
r356 (  81 149 ) resistor r=4.23183 //w=0.7 //l=0.175 //layer=li \
 //thickness=0.1 //x=9.65 //y=0.35 //x2=9.65 //y2=0.175
r357 (  81 160 ) resistor r=54.4171 //w=0.187 //l=0.795 //layer=li \
 //thickness=0.1 //x=9.65 //y=0.35 //x2=9.65 //y2=1.145
r358 (  80 147 ) resistor r=5.29055 //w=0.35 //l=0.17 //layer=li \
 //thickness=0.1 //x=8.745 //y=0.175 //x2=8.575 //y2=0.175
r359 (  79 149 ) resistor r=2.87058 //w=0.35 //l=0.085 //layer=li \
 //thickness=0.1 //x=9.565 //y=0.175 //x2=9.65 //y2=0.175
r360 (  79 80 ) resistor r=28.5995 //w=0.367 //l=0.82 //layer=li \
 //thickness=0.1 //x=9.565 //y=0.175 //x2=8.745 //y2=0.175
r361 (  74 76 ) resistor r=38.7139 //w=0.367 //l=1.11 //layer=li \
 //thickness=0.1 //x=7.095 //y=0.175 //x2=8.205 //y2=0.175
r362 (  72 74 ) resistor r=38.7139 //w=0.367 //l=1.11 //layer=li \
 //thickness=0.1 //x=5.985 //y=0.175 //x2=7.095 //y2=0.175
r363 (  70 146 ) resistor r=2.87058 //w=0.35 //l=0.085 //layer=li \
 //thickness=0.1 //x=4.925 //y=0.175 //x2=4.84 //y2=0.175
r364 (  70 72 ) resistor r=36.97 //w=0.367 //l=1.06 //layer=li //thickness=0.1 \
 //x=4.925 //y=0.175 //x2=5.985 //y2=0.175
r365 (  69 147 ) resistor r=5.29055 //w=0.35 //l=0.17 //layer=li \
 //thickness=0.1 //x=8.405 //y=0.175 //x2=8.575 //y2=0.175
r366 (  69 76 ) resistor r=6.97548 //w=0.367 //l=0.2 //layer=li \
 //thickness=0.1 //x=8.405 //y=0.175 //x2=8.205 //y2=0.175
r367 (  65 146 ) resistor r=4.23183 //w=0.7 //l=0.175 //layer=li \
 //thickness=0.1 //x=4.84 //y=0.35 //x2=4.84 //y2=0.175
r368 (  65 159 ) resistor r=54.4171 //w=0.187 //l=0.795 //layer=li \
 //thickness=0.1 //x=4.84 //y=0.35 //x2=4.84 //y2=1.145
r369 (  64 144 ) resistor r=5.29055 //w=0.35 //l=0.17 //layer=li \
 //thickness=0.1 //x=3.935 //y=0.175 //x2=3.765 //y2=0.175
r370 (  63 146 ) resistor r=2.87058 //w=0.35 //l=0.085 //layer=li \
 //thickness=0.1 //x=4.755 //y=0.175 //x2=4.84 //y2=0.175
r371 (  63 64 ) resistor r=28.5995 //w=0.367 //l=0.82 //layer=li \
 //thickness=0.1 //x=4.755 //y=0.175 //x2=3.935 //y2=0.175
r372 (  58 60 ) resistor r=38.7139 //w=0.367 //l=1.11 //layer=li \
 //thickness=0.1 //x=2.285 //y=0.175 //x2=3.395 //y2=0.175
r373 (  56 143 ) resistor r=2.87058 //w=0.35 //l=0.085 //layer=li \
 //thickness=0.1 //x=1.7 //y=0.175 //x2=1.615 //y2=0.175
r374 (  56 58 ) resistor r=20.4033 //w=0.367 //l=0.585 //layer=li \
 //thickness=0.1 //x=1.7 //y=0.175 //x2=2.285 //y2=0.175
r375 (  55 144 ) resistor r=5.29055 //w=0.35 //l=0.17 //layer=li \
 //thickness=0.1 //x=3.595 //y=0.175 //x2=3.765 //y2=0.175
r376 (  55 60 ) resistor r=6.97548 //w=0.367 //l=0.2 //layer=li \
 //thickness=0.1 //x=3.595 //y=0.175 //x2=3.395 //y2=0.175
r377 (  51 143 ) resistor r=4.23183 //w=0.7 //l=0.175 //layer=li \
 //thickness=0.1 //x=1.615 //y=0.35 //x2=1.615 //y2=0.175
r378 (  51 158 ) resistor r=53.7326 //w=0.187 //l=0.785 //layer=li \
 //thickness=0.1 //x=1.615 //y=0.35 //x2=1.615 //y2=1.135
r379 (  47 143 ) resistor r=2.87058 //w=0.35 //l=0.085 //layer=li \
 //thickness=0.1 //x=1.53 //y=0.175 //x2=1.615 //y2=0.175
r380 (  47 50 ) resistor r=12.3815 //w=0.367 //l=0.355 //layer=li \
 //thickness=0.1 //x=1.53 //y=0.175 //x2=1.175 //y2=0.175
r381 (  43 138 ) resistor r=3.1 //w=0.17 //l=0.51 //layer=mcon //count=3 \
 //x=24.115 //y=0.18 //x2=24.115 //y2=0.18
r382 (  41 136 ) resistor r=3.1 //w=0.17 //l=0.51 //layer=mcon //count=3 \
 //x=23.005 //y=0.18 //x2=23.005 //y2=0.18
r383 (  41 43 ) resistor r=0.446141 //w=0.311 //l=1.11 //layer=m1 \
 //thickness=0.36 //x=23.005 //y=0.175 //x2=24.115 //y2=0.175
r384 (  39 134 ) resistor r=3.1 //w=0.17 //l=0.51 //layer=mcon //count=3 \
 //x=21.895 //y=0.18 //x2=21.895 //y2=0.18
r385 (  39 41 ) resistor r=0.446141 //w=0.311 //l=1.11 //layer=m1 \
 //thickness=0.36 //x=21.895 //y=0.175 //x2=23.005 //y2=0.175
r386 (  37 126 ) resistor r=3.1 //w=0.17 //l=0.51 //layer=mcon //count=3 \
 //x=20.785 //y=0.18 //x2=20.785 //y2=0.18
r387 (  37 39 ) resistor r=0.446141 //w=0.311 //l=1.11 //layer=m1 \
 //thickness=0.36 //x=20.785 //y=0.175 //x2=21.895 //y2=0.175
r388 (  35 120 ) resistor r=3.1 //w=0.17 //l=0.51 //layer=mcon //count=3 \
 //x=19.305 //y=0.18 //x2=19.305 //y2=0.18
r389 (  35 37 ) resistor r=0.594855 //w=0.311 //l=1.48 //layer=m1 \
 //thickness=0.36 //x=19.305 //y=0.175 //x2=20.785 //y2=0.175
r390 (  33 118 ) resistor r=3.1 //w=0.17 //l=0.51 //layer=mcon //count=3 \
 //x=18.195 //y=0.18 //x2=18.195 //y2=0.18
r391 (  33 35 ) resistor r=0.446141 //w=0.311 //l=1.11 //layer=m1 \
 //thickness=0.36 //x=18.195 //y=0.175 //x2=19.305 //y2=0.175
r392 (  31 110 ) resistor r=3.1 //w=0.17 //l=0.51 //layer=mcon //count=3 \
 //x=17.085 //y=0.18 //x2=17.085 //y2=0.18
r393 (  31 33 ) resistor r=0.446141 //w=0.311 //l=1.11 //layer=m1 \
 //thickness=0.36 //x=17.085 //y=0.175 //x2=18.195 //y2=0.175
r394 (  29 104 ) resistor r=3.1 //w=0.17 //l=0.51 //layer=mcon //count=3 \
 //x=15.605 //y=0.18 //x2=15.605 //y2=0.18
r395 (  29 31 ) resistor r=0.594855 //w=0.311 //l=1.48 //layer=m1 \
 //thickness=0.36 //x=15.605 //y=0.175 //x2=17.085 //y2=0.175
r396 (  27 152 ) resistor r=3.1 //w=0.17 //l=0.51 //layer=mcon //count=3 \
 //x=14.495 //y=0.18 //x2=14.495 //y2=0.18
r397 (  27 29 ) resistor r=0.446141 //w=0.311 //l=1.11 //layer=m1 \
 //thickness=0.36 //x=14.495 //y=0.175 //x2=15.605 //y2=0.175
r398 (  25 92 ) resistor r=3.1 //w=0.17 //l=0.51 //layer=mcon //count=3 \
 //x=13.015 //y=0.18 //x2=13.015 //y2=0.18
r399 (  25 27 ) resistor r=0.594855 //w=0.311 //l=1.48 //layer=m1 \
 //thickness=0.36 //x=13.015 //y=0.175 //x2=14.495 //y2=0.175
r400 (  22 90 ) resistor r=3.1 //w=0.17 //l=0.51 //layer=mcon //count=3 \
 //x=11.905 //y=0.18 //x2=11.905 //y2=0.18
r401 (  20 88 ) resistor r=3.1 //w=0.17 //l=0.51 //layer=mcon //count=3 \
 //x=10.795 //y=0.18 //x2=10.795 //y2=0.18
r402 (  20 22 ) resistor r=0.446141 //w=0.311 //l=1.11 //layer=m1 \
 //thickness=0.36 //x=10.795 //y=0.175 //x2=11.905 //y2=0.175
r403 (  18 149 ) resistor r=3.1 //w=0.17 //l=0.51 //layer=mcon //count=3 \
 //x=9.685 //y=0.18 //x2=9.685 //y2=0.18
r404 (  18 20 ) resistor r=0.446141 //w=0.311 //l=1.11 //layer=m1 \
 //thickness=0.36 //x=9.685 //y=0.175 //x2=10.795 //y2=0.175
r405 (  16 76 ) resistor r=3.1 //w=0.17 //l=0.51 //layer=mcon //count=3 \
 //x=8.205 //y=0.18 //x2=8.205 //y2=0.18
r406 (  16 18 ) resistor r=0.594855 //w=0.311 //l=1.48 //layer=m1 \
 //thickness=0.36 //x=8.205 //y=0.175 //x2=9.685 //y2=0.175
r407 (  14 74 ) resistor r=3.1 //w=0.17 //l=0.51 //layer=mcon //count=3 \
 //x=7.095 //y=0.18 //x2=7.095 //y2=0.18
r408 (  14 16 ) resistor r=0.446141 //w=0.311 //l=1.11 //layer=m1 \
 //thickness=0.36 //x=7.095 //y=0.175 //x2=8.205 //y2=0.175
r409 (  12 72 ) resistor r=3.1 //w=0.17 //l=0.51 //layer=mcon //count=3 \
 //x=5.985 //y=0.18 //x2=5.985 //y2=0.18
r410 (  12 14 ) resistor r=0.446141 //w=0.311 //l=1.11 //layer=m1 \
 //thickness=0.36 //x=5.985 //y=0.175 //x2=7.095 //y2=0.175
r411 (  10 146 ) resistor r=3.1 //w=0.17 //l=0.51 //layer=mcon //count=3 \
 //x=4.875 //y=0.18 //x2=4.875 //y2=0.18
r412 (  10 12 ) resistor r=0.446141 //w=0.311 //l=1.11 //layer=m1 \
 //thickness=0.36 //x=4.875 //y=0.175 //x2=5.985 //y2=0.175
r413 (  8 60 ) resistor r=3.1 //w=0.17 //l=0.51 //layer=mcon //count=3 \
 //x=3.395 //y=0.18 //x2=3.395 //y2=0.18
r414 (  8 10 ) resistor r=0.594855 //w=0.311 //l=1.48 //layer=m1 \
 //thickness=0.36 //x=3.395 //y=0.175 //x2=4.875 //y2=0.175
r415 (  6 58 ) resistor r=3.1 //w=0.17 //l=0.51 //layer=mcon //count=3 \
 //x=2.285 //y=0.18 //x2=2.285 //y2=0.18
r416 (  6 8 ) resistor r=0.446141 //w=0.311 //l=1.11 //layer=m1 \
 //thickness=0.36 //x=2.285 //y=0.175 //x2=3.395 //y2=0.175
r417 (  3 50 ) resistor r=3.1 //w=0.17 //l=0.51 //layer=mcon //count=3 \
 //x=1.175 //y=0.18 //x2=1.175 //y2=0.18
r418 (  3 6 ) resistor r=0.446141 //w=0.311 //l=1.11 //layer=m1 \
 //thickness=0.36 //x=1.175 //y=0.175 //x2=2.285 //y2=0.175
r419 (  1 25 ) resistor r=0.126608 //w=0.311 //l=0.315 //layer=m1 \
 //thickness=0.36 //x=12.7 //y=0.175 //x2=13.015 //y2=0.175
r420 (  1 22 ) resistor r=0.319534 //w=0.311 //l=0.795 //layer=m1 \
 //thickness=0.36 //x=12.7 //y=0.175 //x2=11.905 //y2=0.175
ends PM_DFFSNQNX1\%GND

subckt PM_DFFSNQNX1\%VDD ( 1 43 55 63 73 79 87 95 105 115 121 129 137 147 157 \
 163 171 181 191 195 205 215 223 237 247 255 268 274 277 283 289 293 298 304 \
 305 306 307 308 309 310 311 312 313 314 315 316 317 318 319 320 321 322 323 \
 324 )
c312 ( 324 0 ) capacitor c=0.0454189f //x=23.63 //y=5.2
c313 ( 323 0 ) capacitor c=0.0243053f //x=22.75 //y=5.2
c314 ( 322 0 ) capacitor c=0.0243053f //x=21.87 //y=5.2
c315 ( 321 0 ) capacitor c=0.0532751f //x=21 //y=5.2
c316 ( 320 0 ) capacitor c=0.0382118f //x=19.12 //y=5.2
c317 ( 319 0 ) capacitor c=0.0241471f //x=18.24 //y=5.2
c318 ( 318 0 ) capacitor c=0.0493661f //x=17.37 //y=5.2
c319 ( 317 0 ) capacitor c=0.0381506f //x=15.79 //y=5.2
c320 ( 316 0 ) capacitor c=0.0240074f //x=14.91 //y=5.2
c321 ( 315 0 ) capacitor c=0.0492093f //x=14.04 //y=5.2
c322 ( 314 0 ) capacitor c=0.045218f //x=12.16 //y=5.2
c323 ( 313 0 ) capacitor c=0.0241521f //x=11.28 //y=5.2
c324 ( 312 0 ) capacitor c=0.0241521f //x=10.4 //y=5.2
c325 ( 311 0 ) capacitor c=0.053132f //x=9.53 //y=5.2
c326 ( 310 0 ) capacitor c=0.045218f //x=7.35 //y=5.2
c327 ( 309 0 ) capacitor c=0.0241521f //x=6.47 //y=5.2
c328 ( 308 0 ) capacitor c=0.0242401f //x=5.59 //y=5.2
c329 ( 307 0 ) capacitor c=0.0532367f //x=4.72 //y=5.2
c330 ( 306 0 ) capacitor c=0.0381506f //x=2.84 //y=5.2
c331 ( 305 0 ) capacitor c=0.0242461f //x=1.96 //y=5.2
c332 ( 304 0 ) capacitor c=0.0531988f //x=1.09 //y=5.2
c333 ( 302 0 ) capacitor c=0.00597439f //x=23.775 //y=7.585
c334 ( 301 0 ) capacitor c=0.00597439f //x=22.895 //y=7.585
c335 ( 300 0 ) capacitor c=0.00597439f //x=22.015 //y=7.585
c336 ( 299 0 ) capacitor c=0.00597439f //x=21.135 //y=7.585
c337 ( 298 0 ) capacitor c=0.139333f //x=20.045 //y=7.585
c338 ( 297 0 ) capacitor c=0.00597439f //x=19.305 //y=7.58
c339 ( 295 0 ) capacitor c=0.00597439f //x=18.385 //y=7.585
c340 ( 294 0 ) capacitor c=0.00597439f //x=17.505 //y=7.585
c341 ( 293 0 ) capacitor c=0.116288f //x=16.715 //y=7.585
c342 ( 292 0 ) capacitor c=0.00597439f //x=15.935 //y=7.585
c343 ( 291 0 ) capacitor c=0.00597439f //x=15.055 //y=7.585
c344 ( 290 0 ) capacitor c=0.00597439f //x=14.175 //y=7.585
c345 ( 289 0 ) capacitor c=0.134644f //x=13.385 //y=7.585
c346 ( 288 0 ) capacitor c=0.00597439f //x=12.305 //y=7.585
c347 ( 287 0 ) capacitor c=0.00597439f //x=11.425 //y=7.585
c348 ( 286 0 ) capacitor c=0.00597439f //x=10.545 //y=7.585
c349 ( 285 0 ) capacitor c=0.00597439f //x=9.685 //y=7.58
c350 ( 283 0 ) capacitor c=0.155205f //x=8.575 //y=7.585
c351 ( 282 0 ) capacitor c=0.00597439f //x=7.495 //y=7.585
c352 ( 281 0 ) capacitor c=0.00597439f //x=6.615 //y=7.585
c353 ( 280 0 ) capacitor c=0.00597439f //x=5.735 //y=7.585
c354 ( 279 0 ) capacitor c=0.00597439f //x=4.875 //y=7.58
c355 ( 277 0 ) capacitor c=0.137526f //x=3.765 //y=7.585
c356 ( 276 0 ) capacitor c=0.00597439f //x=2.985 //y=7.585
c357 ( 275 0 ) capacitor c=0.00597439f //x=2.105 //y=7.585
c358 ( 274 0 ) capacitor c=0.2641f //x=1.175 //y=7.58
c359 ( 268 0 ) capacitor c=0.294316f //x=24.115 //y=7.58
c360 ( 255 0 ) capacitor c=0.0287829f //x=23.69 //y=7.585
c361 ( 247 0 ) capacitor c=0.028888f //x=22.81 //y=7.585
c362 ( 237 0 ) capacitor c=0.0294771f //x=21.93 //y=7.585
c363 ( 227 0 ) capacitor c=0.0455283f //x=21.05 //y=7.585
c364 ( 223 0 ) capacitor c=0.0273569f //x=19.875 //y=7.585
c365 ( 215 0 ) capacitor c=0.0287734f //x=19.18 //y=7.585
c366 ( 205 0 ) capacitor c=0.029371f //x=18.3 //y=7.585
c367 ( 195 0 ) capacitor c=0.024303f //x=17.42 //y=7.585
c368 ( 191 0 ) capacitor c=0.0238235f //x=16.545 //y=7.585
c369 ( 181 0 ) capacitor c=0.0292139f //x=15.85 //y=7.585
c370 ( 171 0 ) capacitor c=0.0291028f //x=14.97 //y=7.585
c371 ( 163 0 ) capacitor c=0.024303f //x=14.09 //y=7.585
c372 ( 157 0 ) capacitor c=0.0397734f //x=13.215 //y=7.585
c373 ( 147 0 ) capacitor c=0.0291138f //x=12.22 //y=7.585
c374 ( 137 0 ) capacitor c=0.0290172f //x=11.34 //y=7.585
c375 ( 129 0 ) capacitor c=0.0287649f //x=10.46 //y=7.585
c376 ( 121 0 ) capacitor c=0.0386886f //x=9.58 //y=7.585
c377 ( 115 0 ) capacitor c=0.0397734f //x=8.405 //y=7.585
c378 ( 105 0 ) capacitor c=0.0291138f //x=7.41 //y=7.585
c379 ( 95 0 ) capacitor c=0.0291349f //x=6.53 //y=7.585
c380 ( 87 0 ) capacitor c=0.0287792f //x=5.65 //y=7.585
c381 ( 79 0 ) capacitor c=0.0386886f //x=4.77 //y=7.585
c382 ( 73 0 ) capacitor c=0.0238235f //x=3.595 //y=7.585
c383 ( 63 0 ) capacitor c=0.0291286f //x=2.9 //y=7.585
c384 ( 55 0 ) capacitor c=0.0289072f //x=2.02 //y=7.585
c385 ( 43 0 ) capacitor c=0.888673f //x=24.115 //y=7.58
r386 (  266 302 ) resistor r=2.87058 //w=0.35 //l=0.085 //layer=li \
 //thickness=0.1 //x=23.86 //y=7.585 //x2=23.775 //y2=7.585
r387 (  266 268 ) resistor r=8.89373 //w=0.367 //l=0.255 //layer=li \
 //thickness=0.1 //x=23.86 //y=7.585 //x2=24.115 //y2=7.585
r388 (  259 302 ) resistor r=4.23183 //w=0.7 //l=0.175 //layer=li \
 //thickness=0.1 //x=23.775 //y=7.41 //x2=23.775 //y2=7.585
r389 (  259 324 ) resistor r=33.1979 //w=0.187 //l=0.485 //layer=li \
 //thickness=0.1 //x=23.775 //y=7.41 //x2=23.775 //y2=6.925
r390 (  256 301 ) resistor r=2.87058 //w=0.35 //l=0.085 //layer=li \
 //thickness=0.1 //x=22.98 //y=7.585 //x2=22.895 //y2=7.585
r391 (  256 258 ) resistor r=0.871935 //w=0.367 //l=0.025 //layer=li \
 //thickness=0.1 //x=22.98 //y=7.585 //x2=23.005 //y2=7.585
r392 (  255 302 ) resistor r=2.87058 //w=0.35 //l=0.085 //layer=li \
 //thickness=0.1 //x=23.69 //y=7.585 //x2=23.775 //y2=7.585
r393 (  255 258 ) resistor r=23.891 //w=0.367 //l=0.685 //layer=li \
 //thickness=0.1 //x=23.69 //y=7.585 //x2=23.005 //y2=7.585
r394 (  249 301 ) resistor r=4.23183 //w=0.7 //l=0.175 //layer=li \
 //thickness=0.1 //x=22.895 //y=7.41 //x2=22.895 //y2=7.585
r395 (  249 323 ) resistor r=33.1979 //w=0.187 //l=0.485 //layer=li \
 //thickness=0.1 //x=22.895 //y=7.41 //x2=22.895 //y2=6.925
r396 (  248 300 ) resistor r=2.87058 //w=0.35 //l=0.085 //layer=li \
 //thickness=0.1 //x=22.1 //y=7.585 //x2=22.015 //y2=7.585
r397 (  247 301 ) resistor r=2.87058 //w=0.35 //l=0.085 //layer=li \
 //thickness=0.1 //x=22.81 //y=7.585 //x2=22.895 //y2=7.585
r398 (  247 248 ) resistor r=24.7629 //w=0.367 //l=0.71 //layer=li \
 //thickness=0.1 //x=22.81 //y=7.585 //x2=22.1 //y2=7.585
r399 (  241 300 ) resistor r=4.23183 //w=0.7 //l=0.175 //layer=li \
 //thickness=0.1 //x=22.015 //y=7.41 //x2=22.015 //y2=7.585
r400 (  241 322 ) resistor r=33.1979 //w=0.187 //l=0.485 //layer=li \
 //thickness=0.1 //x=22.015 //y=7.41 //x2=22.015 //y2=6.925
r401 (  238 299 ) resistor r=2.87058 //w=0.35 //l=0.085 //layer=li \
 //thickness=0.1 //x=21.22 //y=7.585 //x2=21.135 //y2=7.585
r402 (  238 240 ) resistor r=23.5422 //w=0.367 //l=0.675 //layer=li \
 //thickness=0.1 //x=21.22 //y=7.585 //x2=21.895 //y2=7.585
r403 (  237 300 ) resistor r=2.87058 //w=0.35 //l=0.085 //layer=li \
 //thickness=0.1 //x=21.93 //y=7.585 //x2=22.015 //y2=7.585
r404 (  237 240 ) resistor r=1.22071 //w=0.367 //l=0.035 //layer=li \
 //thickness=0.1 //x=21.93 //y=7.585 //x2=21.895 //y2=7.585
r405 (  231 299 ) resistor r=4.23183 //w=0.7 //l=0.175 //layer=li \
 //thickness=0.1 //x=21.135 //y=7.41 //x2=21.135 //y2=7.585
r406 (  231 321 ) resistor r=56.4706 //w=0.187 //l=0.825 //layer=li \
 //thickness=0.1 //x=21.135 //y=7.41 //x2=21.135 //y2=6.585
r407 (  228 298 ) resistor r=5.29055 //w=0.35 //l=0.17 //layer=li \
 //thickness=0.1 //x=20.215 //y=7.585 //x2=20.045 //y2=7.585
r408 (  228 230 ) resistor r=19.8801 //w=0.367 //l=0.57 //layer=li \
 //thickness=0.1 //x=20.215 //y=7.585 //x2=20.785 //y2=7.585
r409 (  227 299 ) resistor r=2.87058 //w=0.35 //l=0.085 //layer=li \
 //thickness=0.1 //x=21.05 //y=7.585 //x2=21.135 //y2=7.585
r410 (  227 230 ) resistor r=9.24251 //w=0.367 //l=0.265 //layer=li \
 //thickness=0.1 //x=21.05 //y=7.585 //x2=20.785 //y2=7.585
r411 (  224 297 ) resistor r=2.87058 //w=0.35 //l=0.085 //layer=li \
 //thickness=0.1 //x=19.35 //y=7.585 //x2=19.265 //y2=7.585
r412 (  223 298 ) resistor r=5.29055 //w=0.35 //l=0.17 //layer=li \
 //thickness=0.1 //x=19.875 //y=7.585 //x2=20.045 //y2=7.585
r413 (  223 224 ) resistor r=18.3106 //w=0.367 //l=0.525 //layer=li \
 //thickness=0.1 //x=19.875 //y=7.585 //x2=19.35 //y2=7.585
r414 (  217 297 ) resistor r=4.23183 //w=0.7 //l=0.175 //layer=li \
 //thickness=0.1 //x=19.265 //y=7.41 //x2=19.265 //y2=7.585
r415 (  217 320 ) resistor r=33.1979 //w=0.187 //l=0.485 //layer=li \
 //thickness=0.1 //x=19.265 //y=7.41 //x2=19.265 //y2=6.925
r416 (  216 295 ) resistor r=2.87058 //w=0.35 //l=0.085 //layer=li \
 //thickness=0.1 //x=18.47 //y=7.585 //x2=18.385 //y2=7.585
r417 (  215 297 ) resistor r=2.87058 //w=0.35 //l=0.085 //layer=li \
 //thickness=0.1 //x=19.18 //y=7.585 //x2=19.265 //y2=7.585
r418 (  215 216 ) resistor r=24.7629 //w=0.367 //l=0.71 //layer=li \
 //thickness=0.1 //x=19.18 //y=7.585 //x2=18.47 //y2=7.585
r419 (  209 295 ) resistor r=4.23183 //w=0.7 //l=0.175 //layer=li \
 //thickness=0.1 //x=18.385 //y=7.41 //x2=18.385 //y2=7.585
r420 (  209 319 ) resistor r=33.1979 //w=0.187 //l=0.485 //layer=li \
 //thickness=0.1 //x=18.385 //y=7.41 //x2=18.385 //y2=6.925
r421 (  206 294 ) resistor r=2.87058 //w=0.35 //l=0.085 //layer=li \
 //thickness=0.1 //x=17.59 //y=7.585 //x2=17.505 //y2=7.585
r422 (  206 208 ) resistor r=21.1008 //w=0.367 //l=0.605 //layer=li \
 //thickness=0.1 //x=17.59 //y=7.585 //x2=18.195 //y2=7.585
r423 (  205 295 ) resistor r=2.87058 //w=0.35 //l=0.085 //layer=li \
 //thickness=0.1 //x=18.3 //y=7.585 //x2=18.385 //y2=7.585
r424 (  205 208 ) resistor r=3.66213 //w=0.367 //l=0.105 //layer=li \
 //thickness=0.1 //x=18.3 //y=7.585 //x2=18.195 //y2=7.585
r425 (  199 294 ) resistor r=4.23183 //w=0.7 //l=0.175 //layer=li \
 //thickness=0.1 //x=17.505 //y=7.41 //x2=17.505 //y2=7.585
r426 (  199 318 ) resistor r=56.4706 //w=0.187 //l=0.825 //layer=li \
 //thickness=0.1 //x=17.505 //y=7.41 //x2=17.505 //y2=6.585
r427 (  196 293 ) resistor r=5.29055 //w=0.35 //l=0.17 //layer=li \
 //thickness=0.1 //x=16.885 //y=7.585 //x2=16.715 //y2=7.585
r428 (  196 198 ) resistor r=6.97548 //w=0.367 //l=0.2 //layer=li \
 //thickness=0.1 //x=16.885 //y=7.585 //x2=17.085 //y2=7.585
r429 (  195 294 ) resistor r=2.87058 //w=0.35 //l=0.085 //layer=li \
 //thickness=0.1 //x=17.42 //y=7.585 //x2=17.505 //y2=7.585
r430 (  195 198 ) resistor r=11.6839 //w=0.367 //l=0.335 //layer=li \
 //thickness=0.1 //x=17.42 //y=7.585 //x2=17.085 //y2=7.585
r431 (  192 292 ) resistor r=2.87058 //w=0.35 //l=0.085 //layer=li \
 //thickness=0.1 //x=16.02 //y=7.585 //x2=15.935 //y2=7.585
r432 (  191 293 ) resistor r=5.29055 //w=0.35 //l=0.17 //layer=li \
 //thickness=0.1 //x=16.545 //y=7.585 //x2=16.715 //y2=7.585
r433 (  191 192 ) resistor r=18.3106 //w=0.367 //l=0.525 //layer=li \
 //thickness=0.1 //x=16.545 //y=7.585 //x2=16.02 //y2=7.585
r434 (  185 292 ) resistor r=4.23183 //w=0.7 //l=0.175 //layer=li \
 //thickness=0.1 //x=15.935 //y=7.41 //x2=15.935 //y2=7.585
r435 (  185 317 ) resistor r=33.1979 //w=0.187 //l=0.485 //layer=li \
 //thickness=0.1 //x=15.935 //y=7.41 //x2=15.935 //y2=6.925
r436 (  182 291 ) resistor r=2.87058 //w=0.35 //l=0.085 //layer=li \
 //thickness=0.1 //x=15.14 //y=7.585 //x2=15.055 //y2=7.585
r437 (  182 184 ) resistor r=16.218 //w=0.367 //l=0.465 //layer=li \
 //thickness=0.1 //x=15.14 //y=7.585 //x2=15.605 //y2=7.585
r438 (  181 292 ) resistor r=2.87058 //w=0.35 //l=0.085 //layer=li \
 //thickness=0.1 //x=15.85 //y=7.585 //x2=15.935 //y2=7.585
r439 (  181 184 ) resistor r=8.54496 //w=0.367 //l=0.245 //layer=li \
 //thickness=0.1 //x=15.85 //y=7.585 //x2=15.605 //y2=7.585
r440 (  175 291 ) resistor r=4.23183 //w=0.7 //l=0.175 //layer=li \
 //thickness=0.1 //x=15.055 //y=7.41 //x2=15.055 //y2=7.585
r441 (  175 316 ) resistor r=33.1979 //w=0.187 //l=0.485 //layer=li \
 //thickness=0.1 //x=15.055 //y=7.41 //x2=15.055 //y2=6.925
r442 (  172 290 ) resistor r=2.87058 //w=0.35 //l=0.085 //layer=li \
 //thickness=0.1 //x=14.26 //y=7.585 //x2=14.175 //y2=7.585
r443 (  172 174 ) resistor r=8.19619 //w=0.367 //l=0.235 //layer=li \
 //thickness=0.1 //x=14.26 //y=7.585 //x2=14.495 //y2=7.585
r444 (  171 291 ) resistor r=2.87058 //w=0.35 //l=0.085 //layer=li \
 //thickness=0.1 //x=14.97 //y=7.585 //x2=15.055 //y2=7.585
r445 (  171 174 ) resistor r=16.5668 //w=0.367 //l=0.475 //layer=li \
 //thickness=0.1 //x=14.97 //y=7.585 //x2=14.495 //y2=7.585
r446 (  165 290 ) resistor r=4.23183 //w=0.7 //l=0.175 //layer=li \
 //thickness=0.1 //x=14.175 //y=7.41 //x2=14.175 //y2=7.585
r447 (  165 315 ) resistor r=56.4706 //w=0.187 //l=0.825 //layer=li \
 //thickness=0.1 //x=14.175 //y=7.41 //x2=14.175 //y2=6.585
r448 (  164 289 ) resistor r=5.29055 //w=0.35 //l=0.17 //layer=li \
 //thickness=0.1 //x=13.555 //y=7.585 //x2=13.385 //y2=7.585
r449 (  163 290 ) resistor r=2.87058 //w=0.35 //l=0.085 //layer=li \
 //thickness=0.1 //x=14.09 //y=7.585 //x2=14.175 //y2=7.585
r450 (  163 164 ) resistor r=18.6594 //w=0.367 //l=0.535 //layer=li \
 //thickness=0.1 //x=14.09 //y=7.585 //x2=13.555 //y2=7.585
r451 (  158 288 ) resistor r=2.87058 //w=0.35 //l=0.085 //layer=li \
 //thickness=0.1 //x=12.39 //y=7.585 //x2=12.305 //y2=7.585
r452 (  158 160 ) resistor r=21.7984 //w=0.367 //l=0.625 //layer=li \
 //thickness=0.1 //x=12.39 //y=7.585 //x2=13.015 //y2=7.585
r453 (  157 289 ) resistor r=5.29055 //w=0.35 //l=0.17 //layer=li \
 //thickness=0.1 //x=13.215 //y=7.585 //x2=13.385 //y2=7.585
r454 (  157 160 ) resistor r=6.97548 //w=0.367 //l=0.2 //layer=li \
 //thickness=0.1 //x=13.215 //y=7.585 //x2=13.015 //y2=7.585
r455 (  151 288 ) resistor r=4.23183 //w=0.7 //l=0.175 //layer=li \
 //thickness=0.1 //x=12.305 //y=7.41 //x2=12.305 //y2=7.585
r456 (  151 314 ) resistor r=33.1979 //w=0.187 //l=0.485 //layer=li \
 //thickness=0.1 //x=12.305 //y=7.41 //x2=12.305 //y2=6.925
r457 (  148 287 ) resistor r=2.87058 //w=0.35 //l=0.085 //layer=li \
 //thickness=0.1 //x=11.51 //y=7.585 //x2=11.425 //y2=7.585
r458 (  148 150 ) resistor r=13.7766 //w=0.367 //l=0.395 //layer=li \
 //thickness=0.1 //x=11.51 //y=7.585 //x2=11.905 //y2=7.585
r459 (  147 288 ) resistor r=2.87058 //w=0.35 //l=0.085 //layer=li \
 //thickness=0.1 //x=12.22 //y=7.585 //x2=12.305 //y2=7.585
r460 (  147 150 ) resistor r=10.9864 //w=0.367 //l=0.315 //layer=li \
 //thickness=0.1 //x=12.22 //y=7.585 //x2=11.905 //y2=7.585
r461 (  141 287 ) resistor r=4.23183 //w=0.7 //l=0.175 //layer=li \
 //thickness=0.1 //x=11.425 //y=7.41 //x2=11.425 //y2=7.585
r462 (  141 313 ) resistor r=33.1979 //w=0.187 //l=0.485 //layer=li \
 //thickness=0.1 //x=11.425 //y=7.41 //x2=11.425 //y2=6.925
r463 (  138 286 ) resistor r=2.87058 //w=0.35 //l=0.085 //layer=li \
 //thickness=0.1 //x=10.63 //y=7.585 //x2=10.545 //y2=7.585
r464 (  138 140 ) resistor r=5.75477 //w=0.367 //l=0.165 //layer=li \
 //thickness=0.1 //x=10.63 //y=7.585 //x2=10.795 //y2=7.585
r465 (  137 287 ) resistor r=2.87058 //w=0.35 //l=0.085 //layer=li \
 //thickness=0.1 //x=11.34 //y=7.585 //x2=11.425 //y2=7.585
r466 (  137 140 ) resistor r=19.0082 //w=0.367 //l=0.545 //layer=li \
 //thickness=0.1 //x=11.34 //y=7.585 //x2=10.795 //y2=7.585
r467 (  131 286 ) resistor r=4.23183 //w=0.7 //l=0.175 //layer=li \
 //thickness=0.1 //x=10.545 //y=7.41 //x2=10.545 //y2=7.585
r468 (  131 312 ) resistor r=33.1979 //w=0.187 //l=0.485 //layer=li \
 //thickness=0.1 //x=10.545 //y=7.41 //x2=10.545 //y2=6.925
r469 (  130 285 ) resistor r=2.87058 //w=0.35 //l=0.085 //layer=li \
 //thickness=0.1 //x=9.75 //y=7.585 //x2=9.665 //y2=7.585
r470 (  129 286 ) resistor r=2.87058 //w=0.35 //l=0.085 //layer=li \
 //thickness=0.1 //x=10.46 //y=7.585 //x2=10.545 //y2=7.585
r471 (  129 130 ) resistor r=24.7629 //w=0.367 //l=0.71 //layer=li \
 //thickness=0.1 //x=10.46 //y=7.585 //x2=9.75 //y2=7.585
r472 (  123 285 ) resistor r=4.23183 //w=0.7 //l=0.175 //layer=li \
 //thickness=0.1 //x=9.665 //y=7.41 //x2=9.665 //y2=7.585
r473 (  123 311 ) resistor r=56.4706 //w=0.187 //l=0.825 //layer=li \
 //thickness=0.1 //x=9.665 //y=7.41 //x2=9.665 //y2=6.585
r474 (  122 283 ) resistor r=5.29055 //w=0.35 //l=0.17 //layer=li \
 //thickness=0.1 //x=8.745 //y=7.585 //x2=8.575 //y2=7.585
r475 (  121 285 ) resistor r=2.87058 //w=0.35 //l=0.085 //layer=li \
 //thickness=0.1 //x=9.58 //y=7.585 //x2=9.665 //y2=7.585
r476 (  121 122 ) resistor r=29.1226 //w=0.367 //l=0.835 //layer=li \
 //thickness=0.1 //x=9.58 //y=7.585 //x2=8.745 //y2=7.585
r477 (  116 282 ) resistor r=2.87058 //w=0.35 //l=0.085 //layer=li \
 //thickness=0.1 //x=7.58 //y=7.585 //x2=7.495 //y2=7.585
r478 (  116 118 ) resistor r=21.7984 //w=0.367 //l=0.625 //layer=li \
 //thickness=0.1 //x=7.58 //y=7.585 //x2=8.205 //y2=7.585
r479 (  115 283 ) resistor r=5.29055 //w=0.35 //l=0.17 //layer=li \
 //thickness=0.1 //x=8.405 //y=7.585 //x2=8.575 //y2=7.585
r480 (  115 118 ) resistor r=6.97548 //w=0.367 //l=0.2 //layer=li \
 //thickness=0.1 //x=8.405 //y=7.585 //x2=8.205 //y2=7.585
r481 (  109 282 ) resistor r=4.23183 //w=0.7 //l=0.175 //layer=li \
 //thickness=0.1 //x=7.495 //y=7.41 //x2=7.495 //y2=7.585
r482 (  109 310 ) resistor r=33.1979 //w=0.187 //l=0.485 //layer=li \
 //thickness=0.1 //x=7.495 //y=7.41 //x2=7.495 //y2=6.925
r483 (  106 281 ) resistor r=2.87058 //w=0.35 //l=0.085 //layer=li \
 //thickness=0.1 //x=6.7 //y=7.585 //x2=6.615 //y2=7.585
r484 (  106 108 ) resistor r=13.7766 //w=0.367 //l=0.395 //layer=li \
 //thickness=0.1 //x=6.7 //y=7.585 //x2=7.095 //y2=7.585
r485 (  105 282 ) resistor r=2.87058 //w=0.35 //l=0.085 //layer=li \
 //thickness=0.1 //x=7.41 //y=7.585 //x2=7.495 //y2=7.585
r486 (  105 108 ) resistor r=10.9864 //w=0.367 //l=0.315 //layer=li \
 //thickness=0.1 //x=7.41 //y=7.585 //x2=7.095 //y2=7.585
r487 (  99 281 ) resistor r=4.23183 //w=0.7 //l=0.175 //layer=li \
 //thickness=0.1 //x=6.615 //y=7.41 //x2=6.615 //y2=7.585
r488 (  99 309 ) resistor r=33.1979 //w=0.187 //l=0.485 //layer=li \
 //thickness=0.1 //x=6.615 //y=7.41 //x2=6.615 //y2=6.925
r489 (  96 280 ) resistor r=2.87058 //w=0.35 //l=0.085 //layer=li \
 //thickness=0.1 //x=5.82 //y=7.585 //x2=5.735 //y2=7.585
r490 (  96 98 ) resistor r=5.75477 //w=0.367 //l=0.165 //layer=li \
 //thickness=0.1 //x=5.82 //y=7.585 //x2=5.985 //y2=7.585
r491 (  95 281 ) resistor r=2.87058 //w=0.35 //l=0.085 //layer=li \
 //thickness=0.1 //x=6.53 //y=7.585 //x2=6.615 //y2=7.585
r492 (  95 98 ) resistor r=19.0082 //w=0.367 //l=0.545 //layer=li \
 //thickness=0.1 //x=6.53 //y=7.585 //x2=5.985 //y2=7.585
r493 (  89 280 ) resistor r=4.23183 //w=0.7 //l=0.175 //layer=li \
 //thickness=0.1 //x=5.735 //y=7.41 //x2=5.735 //y2=7.585
r494 (  89 308 ) resistor r=33.1979 //w=0.187 //l=0.485 //layer=li \
 //thickness=0.1 //x=5.735 //y=7.41 //x2=5.735 //y2=6.925
r495 (  88 279 ) resistor r=2.87058 //w=0.35 //l=0.085 //layer=li \
 //thickness=0.1 //x=4.94 //y=7.585 //x2=4.855 //y2=7.585
r496 (  87 280 ) resistor r=2.87058 //w=0.35 //l=0.085 //layer=li \
 //thickness=0.1 //x=5.65 //y=7.585 //x2=5.735 //y2=7.585
r497 (  87 88 ) resistor r=24.7629 //w=0.367 //l=0.71 //layer=li \
 //thickness=0.1 //x=5.65 //y=7.585 //x2=4.94 //y2=7.585
r498 (  81 279 ) resistor r=4.23183 //w=0.7 //l=0.175 //layer=li \
 //thickness=0.1 //x=4.855 //y=7.41 //x2=4.855 //y2=7.585
r499 (  81 307 ) resistor r=56.4706 //w=0.187 //l=0.825 //layer=li \
 //thickness=0.1 //x=4.855 //y=7.41 //x2=4.855 //y2=6.585
r500 (  80 277 ) resistor r=5.29055 //w=0.35 //l=0.17 //layer=li \
 //thickness=0.1 //x=3.935 //y=7.585 //x2=3.765 //y2=7.585
r501 (  79 279 ) resistor r=2.87058 //w=0.35 //l=0.085 //layer=li \
 //thickness=0.1 //x=4.77 //y=7.585 //x2=4.855 //y2=7.585
r502 (  79 80 ) resistor r=29.1226 //w=0.367 //l=0.835 //layer=li \
 //thickness=0.1 //x=4.77 //y=7.585 //x2=3.935 //y2=7.585
r503 (  74 276 ) resistor r=2.87058 //w=0.35 //l=0.085 //layer=li \
 //thickness=0.1 //x=3.07 //y=7.585 //x2=2.985 //y2=7.585
r504 (  74 76 ) resistor r=11.3351 //w=0.367 //l=0.325 //layer=li \
 //thickness=0.1 //x=3.07 //y=7.585 //x2=3.395 //y2=7.585
r505 (  73 277 ) resistor r=5.29055 //w=0.35 //l=0.17 //layer=li \
 //thickness=0.1 //x=3.595 //y=7.585 //x2=3.765 //y2=7.585
r506 (  73 76 ) resistor r=6.97548 //w=0.367 //l=0.2 //layer=li \
 //thickness=0.1 //x=3.595 //y=7.585 //x2=3.395 //y2=7.585
r507 (  67 276 ) resistor r=4.23183 //w=0.7 //l=0.175 //layer=li \
 //thickness=0.1 //x=2.985 //y=7.41 //x2=2.985 //y2=7.585
r508 (  67 306 ) resistor r=33.1979 //w=0.187 //l=0.485 //layer=li \
 //thickness=0.1 //x=2.985 //y=7.41 //x2=2.985 //y2=6.925
r509 (  64 275 ) resistor r=2.87058 //w=0.35 //l=0.085 //layer=li \
 //thickness=0.1 //x=2.19 //y=7.585 //x2=2.105 //y2=7.585
r510 (  64 66 ) resistor r=3.31335 //w=0.367 //l=0.095 //layer=li \
 //thickness=0.1 //x=2.19 //y=7.585 //x2=2.285 //y2=7.585
r511 (  63 276 ) resistor r=2.87058 //w=0.35 //l=0.085 //layer=li \
 //thickness=0.1 //x=2.9 //y=7.585 //x2=2.985 //y2=7.585
r512 (  63 66 ) resistor r=21.4496 //w=0.367 //l=0.615 //layer=li \
 //thickness=0.1 //x=2.9 //y=7.585 //x2=2.285 //y2=7.585
r513 (  57 275 ) resistor r=4.23183 //w=0.7 //l=0.175 //layer=li \
 //thickness=0.1 //x=2.105 //y=7.41 //x2=2.105 //y2=7.585
r514 (  57 305 ) resistor r=33.1979 //w=0.187 //l=0.485 //layer=li \
 //thickness=0.1 //x=2.105 //y=7.41 //x2=2.105 //y2=6.925
r515 (  56 274 ) resistor r=2.87058 //w=0.35 //l=0.085 //layer=li \
 //thickness=0.1 //x=1.31 //y=7.585 //x2=1.225 //y2=7.585
r516 (  55 275 ) resistor r=2.87058 //w=0.35 //l=0.085 //layer=li \
 //thickness=0.1 //x=2.02 //y=7.585 //x2=2.105 //y2=7.585
r517 (  55 56 ) resistor r=24.7629 //w=0.367 //l=0.71 //layer=li \
 //thickness=0.1 //x=2.02 //y=7.585 //x2=1.31 //y2=7.585
r518 (  49 274 ) resistor r=4.23183 //w=0.7 //l=0.175 //layer=li \
 //thickness=0.1 //x=1.225 //y=7.41 //x2=1.225 //y2=7.585
r519 (  49 304 ) resistor r=56.4706 //w=0.187 //l=0.825 //layer=li \
 //thickness=0.1 //x=1.225 //y=7.41 //x2=1.225 //y2=6.585
r520 (  43 268 ) resistor r=3.1 //w=0.17 //l=0.51 //layer=mcon //count=3 \
 //x=24.115 //y=7.58 //x2=24.115 //y2=7.58
r521 (  41 258 ) resistor r=3.1 //w=0.17 //l=0.51 //layer=mcon //count=3 \
 //x=23.005 //y=7.58 //x2=23.005 //y2=7.58
r522 (  41 43 ) resistor r=0.446141 //w=0.311 //l=1.11 //layer=m1 \
 //thickness=0.36 //x=23.005 //y=7.585 //x2=24.115 //y2=7.585
r523 (  39 240 ) resistor r=3.1 //w=0.17 //l=0.51 //layer=mcon //count=3 \
 //x=21.895 //y=7.58 //x2=21.895 //y2=7.58
r524 (  39 41 ) resistor r=0.446141 //w=0.311 //l=1.11 //layer=m1 \
 //thickness=0.36 //x=21.895 //y=7.585 //x2=23.005 //y2=7.585
r525 (  37 230 ) resistor r=3.1 //w=0.17 //l=0.51 //layer=mcon //count=3 \
 //x=20.785 //y=7.58 //x2=20.785 //y2=7.58
r526 (  37 39 ) resistor r=0.446141 //w=0.311 //l=1.11 //layer=m1 \
 //thickness=0.36 //x=20.785 //y=7.585 //x2=21.895 //y2=7.585
r527 (  35 297 ) resistor r=3.1 //w=0.17 //l=0.51 //layer=mcon //count=3 \
 //x=19.305 //y=7.58 //x2=19.305 //y2=7.58
r528 (  35 37 ) resistor r=0.594855 //w=0.311 //l=1.48 //layer=m1 \
 //thickness=0.36 //x=19.305 //y=7.585 //x2=20.785 //y2=7.585
r529 (  33 208 ) resistor r=3.1 //w=0.17 //l=0.51 //layer=mcon //count=3 \
 //x=18.195 //y=7.58 //x2=18.195 //y2=7.58
r530 (  33 35 ) resistor r=0.446141 //w=0.311 //l=1.11 //layer=m1 \
 //thickness=0.36 //x=18.195 //y=7.585 //x2=19.305 //y2=7.585
r531 (  31 198 ) resistor r=3.1 //w=0.17 //l=0.51 //layer=mcon //count=3 \
 //x=17.085 //y=7.58 //x2=17.085 //y2=7.58
r532 (  31 33 ) resistor r=0.446141 //w=0.311 //l=1.11 //layer=m1 \
 //thickness=0.36 //x=17.085 //y=7.585 //x2=18.195 //y2=7.585
r533 (  29 184 ) resistor r=3.1 //w=0.17 //l=0.51 //layer=mcon //count=3 \
 //x=15.605 //y=7.58 //x2=15.605 //y2=7.58
r534 (  29 31 ) resistor r=0.594855 //w=0.311 //l=1.48 //layer=m1 \
 //thickness=0.36 //x=15.605 //y=7.585 //x2=17.085 //y2=7.585
r535 (  27 174 ) resistor r=3.1 //w=0.17 //l=0.51 //layer=mcon //count=3 \
 //x=14.495 //y=7.58 //x2=14.495 //y2=7.58
r536 (  27 29 ) resistor r=0.446141 //w=0.311 //l=1.11 //layer=m1 \
 //thickness=0.36 //x=14.495 //y=7.585 //x2=15.605 //y2=7.585
r537 (  25 160 ) resistor r=3.1 //w=0.17 //l=0.51 //layer=mcon //count=3 \
 //x=13.015 //y=7.58 //x2=13.015 //y2=7.58
r538 (  25 27 ) resistor r=0.594855 //w=0.311 //l=1.48 //layer=m1 \
 //thickness=0.36 //x=13.015 //y=7.585 //x2=14.495 //y2=7.585
r539 (  22 150 ) resistor r=3.1 //w=0.17 //l=0.51 //layer=mcon //count=3 \
 //x=11.905 //y=7.58 //x2=11.905 //y2=7.58
r540 (  20 140 ) resistor r=3.1 //w=0.17 //l=0.51 //layer=mcon //count=3 \
 //x=10.795 //y=7.58 //x2=10.795 //y2=7.58
r541 (  20 22 ) resistor r=0.446141 //w=0.311 //l=1.11 //layer=m1 \
 //thickness=0.36 //x=10.795 //y=7.585 //x2=11.905 //y2=7.585
r542 (  18 285 ) resistor r=3.1 //w=0.17 //l=0.51 //layer=mcon //count=3 \
 //x=9.685 //y=7.58 //x2=9.685 //y2=7.58
r543 (  18 20 ) resistor r=0.446141 //w=0.311 //l=1.11 //layer=m1 \
 //thickness=0.36 //x=9.685 //y=7.585 //x2=10.795 //y2=7.585
r544 (  16 118 ) resistor r=3.1 //w=0.17 //l=0.51 //layer=mcon //count=3 \
 //x=8.205 //y=7.58 //x2=8.205 //y2=7.58
r545 (  16 18 ) resistor r=0.594855 //w=0.311 //l=1.48 //layer=m1 \
 //thickness=0.36 //x=8.205 //y=7.585 //x2=9.685 //y2=7.585
r546 (  14 108 ) resistor r=3.1 //w=0.17 //l=0.51 //layer=mcon //count=3 \
 //x=7.095 //y=7.58 //x2=7.095 //y2=7.58
r547 (  14 16 ) resistor r=0.446141 //w=0.311 //l=1.11 //layer=m1 \
 //thickness=0.36 //x=7.095 //y=7.585 //x2=8.205 //y2=7.585
r548 (  12 98 ) resistor r=3.1 //w=0.17 //l=0.51 //layer=mcon //count=3 \
 //x=5.985 //y=7.58 //x2=5.985 //y2=7.58
r549 (  12 14 ) resistor r=0.446141 //w=0.311 //l=1.11 //layer=m1 \
 //thickness=0.36 //x=5.985 //y=7.585 //x2=7.095 //y2=7.585
r550 (  10 279 ) resistor r=3.1 //w=0.17 //l=0.51 //layer=mcon //count=3 \
 //x=4.875 //y=7.58 //x2=4.875 //y2=7.58
r551 (  10 12 ) resistor r=0.446141 //w=0.311 //l=1.11 //layer=m1 \
 //thickness=0.36 //x=4.875 //y=7.585 //x2=5.985 //y2=7.585
r552 (  8 76 ) resistor r=3.1 //w=0.17 //l=0.51 //layer=mcon //count=3 \
 //x=3.395 //y=7.58 //x2=3.395 //y2=7.58
r553 (  8 10 ) resistor r=0.594855 //w=0.311 //l=1.48 //layer=m1 \
 //thickness=0.36 //x=3.395 //y=7.585 //x2=4.875 //y2=7.585
r554 (  6 66 ) resistor r=3.1 //w=0.17 //l=0.51 //layer=mcon //count=3 \
 //x=2.285 //y=7.58 //x2=2.285 //y2=7.58
r555 (  6 8 ) resistor r=0.446141 //w=0.311 //l=1.11 //layer=m1 \
 //thickness=0.36 //x=2.285 //y=7.585 //x2=3.395 //y2=7.585
r556 (  3 274 ) resistor r=3.1 //w=0.17 //l=0.51 //layer=mcon //count=3 \
 //x=1.175 //y=7.58 //x2=1.175 //y2=7.58
r557 (  3 6 ) resistor r=0.446141 //w=0.311 //l=1.11 //layer=m1 \
 //thickness=0.36 //x=1.175 //y=7.585 //x2=2.285 //y2=7.585
r558 (  1 25 ) resistor r=0.126608 //w=0.311 //l=0.315 //layer=m1 \
 //thickness=0.36 //x=12.7 //y=7.585 //x2=13.015 //y2=7.585
r559 (  1 22 ) resistor r=0.319534 //w=0.311 //l=0.795 //layer=m1 \
 //thickness=0.36 //x=12.7 //y=7.585 //x2=11.905 //y2=7.585
ends PM_DFFSNQNX1\%VDD

subckt PM_DFFSNQNX1\%noxref_3 ( 1 2 3 4 17 18 29 31 32 36 38 46 53 54 55 56 57 \
 58 59 60 61 62 63 64 66 72 73 74 75 79 80 81 82 83 85 91 92 93 94 114 116 117 )
c255 ( 117 0 ) capacitor c=0.0220291f //x=2.4 //y=5.2
c256 ( 116 0 ) capacitor c=0.0217503f //x=1.52 //y=5.2
c257 ( 114 0 ) capacitor c=0.0084702f //x=2.395 //y=1.085
c258 ( 94 0 ) capacitor c=0.0556143f //x=9.96 //y=4.97
c259 ( 93 0 ) capacitor c=0.0293157f //x=10.25 //y=4.97
c260 ( 92 0 ) capacitor c=0.0347816f //x=9.915 //y=1.4
c261 ( 91 0 ) capacitor c=0.0187487f //x=9.915 //y=1.055
c262 ( 85 0 ) capacitor c=0.0137055f //x=9.76 //y=1.555
c263 ( 83 0 ) capacitor c=0.0149861f //x=9.76 //y=0.9
c264 ( 82 0 ) capacitor c=0.0965257f //x=9.385 //y=2.095
c265 ( 81 0 ) capacitor c=0.0229444f //x=9.385 //y=1.71
c266 ( 80 0 ) capacitor c=0.0234352f //x=9.385 //y=1.4
c267 ( 79 0 ) capacitor c=0.0198724f //x=9.385 //y=1.055
c268 ( 75 0 ) capacitor c=0.055995f //x=5.15 //y=4.97
c269 ( 74 0 ) capacitor c=0.0298189f //x=5.44 //y=4.97
c270 ( 73 0 ) capacitor c=0.0347816f //x=5.105 //y=1.4
c271 ( 72 0 ) capacitor c=0.0187487f //x=5.105 //y=1.055
c272 ( 66 0 ) capacitor c=0.0137055f //x=4.95 //y=1.555
c273 ( 64 0 ) capacitor c=0.0149861f //x=4.95 //y=0.9
c274 ( 63 0 ) capacitor c=0.0965245f //x=4.575 //y=2.095
c275 ( 62 0 ) capacitor c=0.0229444f //x=4.575 //y=1.71
c276 ( 61 0 ) capacitor c=0.0234352f //x=4.575 //y=1.4
c277 ( 60 0 ) capacitor c=0.0198724f //x=4.575 //y=1.055
c278 ( 59 0 ) capacitor c=0.110114f //x=10.325 //y=6.2
c279 ( 58 0 ) capacitor c=0.158956f //x=9.885 //y=6.2
c280 ( 57 0 ) capacitor c=0.110114f //x=5.515 //y=6.2
c281 ( 56 0 ) capacitor c=0.158956f //x=5.075 //y=6.2
c282 ( 53 0 ) capacitor c=0.0023043f //x=2.545 //y=5.38
c283 ( 46 0 ) capacitor c=0.10376f //x=9.685 //y=2.26
c284 ( 38 0 ) capacitor c=0.108374f //x=4.875 //y=2.26
c285 ( 36 0 ) capacitor c=0.114218f //x=3.025 //y=2.77
c286 ( 32 0 ) capacitor c=0.00550359f //x=2.67 //y=1.835
c287 ( 31 0 ) capacitor c=0.0140493f //x=2.94 //y=1.835
c288 ( 29 0 ) capacitor c=0.0140934f //x=2.94 //y=5.38
c289 ( 18 0 ) capacitor c=0.00326823f //x=1.75 //y=5.38
c290 ( 17 0 ) capacitor c=0.019002f //x=2.46 //y=5.38
c291 ( 4 0 ) capacitor c=0.012652f //x=5.14 //y=2.77
c292 ( 3 0 ) capacitor c=0.142723f //x=9.57 //y=2.77
c293 ( 2 0 ) capacitor c=0.0148668f //x=3.14 //y=2.77
c294 ( 1 0 ) capacitor c=0.0543359f //x=4.73 //y=2.77
r295 (  93 95 ) resistor r=26.9307 //w=0.15 //l=0.106066 //layer=ply \
 //thickness=0.18 //x=10.25 //y=4.97 //x2=10.325 //y2=5.045
r296 (  93 94 ) resistor r=148.702 //w=0.094 //l=0.29 //layer=ply \
 //thickness=0.18 //x=10.25 //y=4.97 //x2=9.96 //y2=4.97
r297 (  92 113 ) resistor r=45.1352 //w=0.168 //l=0.173853 //layer=ply \
 //thickness=0.18 //x=9.915 //y=1.4 //x2=9.875 //y2=1.555
r298 (  91 112 ) resistor r=45.1352 //w=0.168 //l=0.173853 //layer=ply \
 //thickness=0.18 //x=9.915 //y=1.055 //x2=9.875 //y2=0.9
r299 (  91 92 ) resistor r=176.904 //w=0.094 //l=0.345 //layer=ply \
 //thickness=0.18 //x=9.915 //y=1.055 //x2=9.915 //y2=1.4
r300 (  88 94 ) resistor r=22.7971 //w=0.269 //l=0.106066 //layer=ply \
 //thickness=0.18 //x=9.885 //y=5.045 //x2=9.96 //y2=4.97
r301 (  88 111 ) resistor r=35.8364 //w=0.269 //l=0.270185 //layer=ply \
 //thickness=0.18 //x=9.885 //y=5.045 //x2=9.685 //y2=4.88
r302 (  86 107 ) resistor r=10.701 //w=0.21 //l=0.115 //layer=ply \
 //thickness=0.18 //x=9.54 //y=1.555 //x2=9.425 //y2=1.555
r303 (  85 113 ) resistor r=5.52526 //w=0.168 //l=0.115 //layer=ply \
 //thickness=0.18 //x=9.76 //y=1.555 //x2=9.875 //y2=1.555
r304 (  84 106 ) resistor r=5.52526 //w=0.168 //l=0.115 //layer=ply \
 //thickness=0.18 //x=9.54 //y=0.9 //x2=9.425 //y2=0.9
r305 (  83 112 ) resistor r=5.52526 //w=0.168 //l=0.115 //layer=ply \
 //thickness=0.18 //x=9.76 //y=0.9 //x2=9.875 //y2=0.9
r306 (  83 84 ) resistor r=112.809 //w=0.094 //l=0.22 //layer=ply \
 //thickness=0.18 //x=9.76 //y=0.9 //x2=9.54 //y2=0.9
r307 (  82 109 ) resistor r=58.7805 //w=0.246 //l=0.373497 //layer=ply \
 //thickness=0.18 //x=9.385 //y=2.095 //x2=9.685 //y2=2.26
r308 (  81 107 ) resistor r=39.5823 //w=0.21 //l=0.173853 //layer=ply \
 //thickness=0.18 //x=9.385 //y=1.71 //x2=9.425 //y2=1.555
r309 (  81 82 ) resistor r=197.415 //w=0.094 //l=0.385 //layer=ply \
 //thickness=0.18 //x=9.385 //y=1.71 //x2=9.385 //y2=2.095
r310 (  80 107 ) resistor r=39.5823 //w=0.21 //l=0.173853 //layer=ply \
 //thickness=0.18 //x=9.385 //y=1.4 //x2=9.425 //y2=1.555
r311 (  79 106 ) resistor r=45.1352 //w=0.168 //l=0.173853 //layer=ply \
 //thickness=0.18 //x=9.385 //y=1.055 //x2=9.425 //y2=0.9
r312 (  79 80 ) resistor r=176.904 //w=0.094 //l=0.345 //layer=ply \
 //thickness=0.18 //x=9.385 //y=1.055 //x2=9.385 //y2=1.4
r313 (  74 76 ) resistor r=26.9307 //w=0.15 //l=0.106066 //layer=ply \
 //thickness=0.18 //x=5.44 //y=4.97 //x2=5.515 //y2=5.045
r314 (  74 75 ) resistor r=148.702 //w=0.094 //l=0.29 //layer=ply \
 //thickness=0.18 //x=5.44 //y=4.97 //x2=5.15 //y2=4.97
r315 (  73 105 ) resistor r=45.1352 //w=0.168 //l=0.173853 //layer=ply \
 //thickness=0.18 //x=5.105 //y=1.4 //x2=5.065 //y2=1.555
r316 (  72 104 ) resistor r=45.1352 //w=0.168 //l=0.173853 //layer=ply \
 //thickness=0.18 //x=5.105 //y=1.055 //x2=5.065 //y2=0.9
r317 (  72 73 ) resistor r=176.904 //w=0.094 //l=0.345 //layer=ply \
 //thickness=0.18 //x=5.105 //y=1.055 //x2=5.105 //y2=1.4
r318 (  69 75 ) resistor r=22.7971 //w=0.269 //l=0.106066 //layer=ply \
 //thickness=0.18 //x=5.075 //y=5.045 //x2=5.15 //y2=4.97
r319 (  69 103 ) resistor r=35.8364 //w=0.269 //l=0.270185 //layer=ply \
 //thickness=0.18 //x=5.075 //y=5.045 //x2=4.875 //y2=4.88
r320 (  67 99 ) resistor r=10.701 //w=0.21 //l=0.115 //layer=ply \
 //thickness=0.18 //x=4.73 //y=1.555 //x2=4.615 //y2=1.555
r321 (  66 105 ) resistor r=5.52526 //w=0.168 //l=0.115 //layer=ply \
 //thickness=0.18 //x=4.95 //y=1.555 //x2=5.065 //y2=1.555
r322 (  65 98 ) resistor r=5.52526 //w=0.168 //l=0.115 //layer=ply \
 //thickness=0.18 //x=4.73 //y=0.9 //x2=4.615 //y2=0.9
r323 (  64 104 ) resistor r=5.52526 //w=0.168 //l=0.115 //layer=ply \
 //thickness=0.18 //x=4.95 //y=0.9 //x2=5.065 //y2=0.9
r324 (  64 65 ) resistor r=112.809 //w=0.094 //l=0.22 //layer=ply \
 //thickness=0.18 //x=4.95 //y=0.9 //x2=4.73 //y2=0.9
r325 (  63 101 ) resistor r=58.7805 //w=0.246 //l=0.373497 //layer=ply \
 //thickness=0.18 //x=4.575 //y=2.095 //x2=4.875 //y2=2.26
r326 (  62 99 ) resistor r=39.5823 //w=0.21 //l=0.173853 //layer=ply \
 //thickness=0.18 //x=4.575 //y=1.71 //x2=4.615 //y2=1.555
r327 (  62 63 ) resistor r=197.415 //w=0.094 //l=0.385 //layer=ply \
 //thickness=0.18 //x=4.575 //y=1.71 //x2=4.575 //y2=2.095
r328 (  61 99 ) resistor r=39.5823 //w=0.21 //l=0.173853 //layer=ply \
 //thickness=0.18 //x=4.575 //y=1.4 //x2=4.615 //y2=1.555
r329 (  60 98 ) resistor r=45.1352 //w=0.168 //l=0.173853 //layer=ply \
 //thickness=0.18 //x=4.575 //y=1.055 //x2=4.615 //y2=0.9
r330 (  60 61 ) resistor r=176.904 //w=0.094 //l=0.345 //layer=ply \
 //thickness=0.18 //x=4.575 //y=1.055 //x2=4.575 //y2=1.4
r331 (  59 95 ) resistor r=592.245 //w=0.094 //l=1.155 //layer=ply \
 //thickness=0.18 //x=10.325 //y=6.2 //x2=10.325 //y2=5.045
r332 (  58 88 ) resistor r=592.245 //w=0.094 //l=1.155 //layer=ply \
 //thickness=0.18 //x=9.885 //y=6.2 //x2=9.885 //y2=5.045
r333 (  57 76 ) resistor r=592.245 //w=0.094 //l=1.155 //layer=ply \
 //thickness=0.18 //x=5.515 //y=6.2 //x2=5.515 //y2=5.045
r334 (  56 69 ) resistor r=592.245 //w=0.094 //l=1.155 //layer=ply \
 //thickness=0.18 //x=5.075 //y=6.2 //x2=5.075 //y2=5.045
r335 (  55 85 ) resistor r=56.4043 //w=0.094 //l=0.11 //layer=ply \
 //thickness=0.18 //x=9.65 //y=1.555 //x2=9.76 //y2=1.555
r336 (  55 86 ) resistor r=56.4043 //w=0.094 //l=0.11 //layer=ply \
 //thickness=0.18 //x=9.65 //y=1.555 //x2=9.54 //y2=1.555
r337 (  54 66 ) resistor r=56.4043 //w=0.094 //l=0.11 //layer=ply \
 //thickness=0.18 //x=4.84 //y=1.555 //x2=4.95 //y2=1.555
r338 (  54 67 ) resistor r=56.4043 //w=0.094 //l=0.11 //layer=ply \
 //thickness=0.18 //x=4.84 //y=1.555 //x2=4.73 //y2=1.555
r339 (  51 111 ) resistor r=152 //w=0.17 //l=0.17 //layer=licon //count=1 \
 //x=9.685 //y=4.88 //x2=9.685 //y2=4.88
r340 (  49 51 ) resistor r=144.428 //w=0.187 //l=2.11 //layer=li \
 //thickness=0.1 //x=9.685 //y=2.77 //x2=9.685 //y2=4.88
r341 (  46 109 ) resistor r=152 //w=0.17 //l=0.17 //layer=licon //count=1 \
 //x=9.685 //y=2.26 //x2=9.685 //y2=2.26
r342 (  46 49 ) resistor r=34.9091 //w=0.187 //l=0.51 //layer=li \
 //thickness=0.1 //x=9.685 //y=2.26 //x2=9.685 //y2=2.77
r343 (  43 103 ) resistor r=152 //w=0.17 //l=0.17 //layer=licon //count=1 \
 //x=4.875 //y=4.88 //x2=4.875 //y2=4.88
r344 (  41 43 ) resistor r=144.77 //w=0.187 //l=2.115 //layer=li \
 //thickness=0.1 //x=4.875 //y=2.765 //x2=4.875 //y2=4.88
r345 (  38 101 ) resistor r=152 //w=0.17 //l=0.17 //layer=licon //count=1 \
 //x=4.875 //y=2.26 //x2=4.875 //y2=2.26
r346 (  38 41 ) resistor r=34.5668 //w=0.187 //l=0.505 //layer=li \
 //thickness=0.1 //x=4.875 //y=2.26 //x2=4.875 //y2=2.765
r347 (  34 36 ) resistor r=172.834 //w=0.187 //l=2.525 //layer=li \
 //thickness=0.1 //x=3.025 //y=5.295 //x2=3.025 //y2=2.77
r348 (  33 36 ) resistor r=58.1818 //w=0.187 //l=0.85 //layer=li \
 //thickness=0.1 //x=3.025 //y=1.92 //x2=3.025 //y2=2.77
r349 (  31 33 ) resistor r=7.15173 //w=0.17 //l=0.120208 //layer=li \
 //thickness=0.1 //x=2.94 //y=1.835 //x2=3.025 //y2=1.92
r350 (  31 32 ) resistor r=18.4813 //w=0.187 //l=0.27 //layer=li \
 //thickness=0.1 //x=2.94 //y=1.835 //x2=2.67 //y2=1.835
r351 (  30 53 ) resistor r=5.4201 //w=0.17 //l=0.085 //layer=li \
 //thickness=0.1 //x=2.63 //y=5.38 //x2=2.545 //y2=5.38
r352 (  29 34 ) resistor r=7.15173 //w=0.17 //l=0.120208 //layer=li \
 //thickness=0.1 //x=2.94 //y=5.38 //x2=3.025 //y2=5.295
r353 (  29 30 ) resistor r=21.2193 //w=0.187 //l=0.31 //layer=li \
 //thickness=0.1 //x=2.94 //y=5.38 //x2=2.63 //y2=5.38
r354 (  25 32 ) resistor r=7.15173 //w=0.17 //l=0.120208 //layer=li \
 //thickness=0.1 //x=2.585 //y=1.75 //x2=2.67 //y2=1.835
r355 (  25 114 ) resistor r=39.016 //w=0.187 //l=0.57 //layer=li \
 //thickness=0.1 //x=2.585 //y=1.75 //x2=2.585 //y2=1.18
r356 (  19 53 ) resistor r=1.40859 //w=0.34 //l=0.085 //layer=li \
 //thickness=0.1 //x=2.545 //y=5.465 //x2=2.545 //y2=5.38
r357 (  19 117 ) resistor r=30.1176 //w=0.187 //l=0.44 //layer=li \
 //thickness=0.1 //x=2.545 //y=5.465 //x2=2.545 //y2=5.905
r358 (  17 53 ) resistor r=5.4201 //w=0.17 //l=0.085 //layer=li \
 //thickness=0.1 //x=2.46 //y=5.38 //x2=2.545 //y2=5.38
r359 (  17 18 ) resistor r=48.5989 //w=0.187 //l=0.71 //layer=li \
 //thickness=0.1 //x=2.46 //y=5.38 //x2=1.75 //y2=5.38
r360 (  11 18 ) resistor r=7.15173 //w=0.17 //l=0.120208 //layer=li \
 //thickness=0.1 //x=1.665 //y=5.465 //x2=1.75 //y2=5.38
r361 (  11 116 ) resistor r=30.1176 //w=0.187 //l=0.44 //layer=li \
 //thickness=0.1 //x=1.665 //y=5.465 //x2=1.665 //y2=5.905
r362 (  10 49 ) resistor r=9.3 //w=0.17 //l=0.17 //layer=mcon //count=1 \
 //x=9.685 //y=2.77 //x2=9.685 //y2=2.77
r363 (  8 41 ) resistor r=9.3 //w=0.17 //l=0.17 //layer=mcon //count=1 \
 //x=4.875 //y=2.765 //x2=4.875 //y2=2.765
r364 (  6 36 ) resistor r=9.3 //w=0.17 //l=0.17 //layer=mcon //count=1 \
 //x=3.025 //y=2.77 //x2=3.025 //y2=2.77
r365 (  4 8 ) resistor r=0.164988 //w=0.206 //l=0.267488 //layer=m1 \
 //thickness=0.36 //x=5.14 //y=2.77 //x2=4.875 //y2=2.765
r366 (  3 10 ) resistor r=0.0717383 //w=0.224 //l=0.115 //layer=m1 \
 //thickness=0.36 //x=9.57 //y=2.77 //x2=9.685 //y2=2.77
r367 (  3 4 ) resistor r=4.2271 //w=0.131 //l=4.43 //layer=m1 //thickness=0.36 \
 //x=9.57 //y=2.77 //x2=5.14 //y2=2.77
r368 (  2 6 ) resistor r=0.0717383 //w=0.224 //l=0.115 //layer=m1 \
 //thickness=0.36 //x=3.14 //y=2.77 //x2=3.025 //y2=2.77
r369 (  1 8 ) resistor r=0.0921728 //w=0.206 //l=0.147479 //layer=m1 \
 //thickness=0.36 //x=4.73 //y=2.77 //x2=4.875 //y2=2.765
r370 (  1 2 ) resistor r=1.51718 //w=0.131 //l=1.59 //layer=m1 \
 //thickness=0.36 //x=4.73 //y=2.77 //x2=3.14 //y2=2.77
ends PM_DFFSNQNX1\%noxref_3

subckt PM_DFFSNQNX1\%noxref_4 ( 1 2 13 14 21 29 35 36 40 42 49 50 51 52 53 54 \
 55 56 57 61 63 66 67 77 80 82 83 84 )
c166 ( 84 0 ) capacitor c=0.023087f //x=11.72 //y=5.2
c167 ( 83 0 ) capacitor c=0.023519f //x=10.84 //y=5.2
c168 ( 82 0 ) capacitor c=0.0224735f //x=9.96 //y=5.2
c169 ( 80 0 ) capacitor c=0.00872971f //x=11.97 //y=1.095
c170 ( 77 0 ) capacitor c=0.0588816f //x=14.495 //y=4.88
c171 ( 67 0 ) capacitor c=0.0318948f //x=14.83 //y=1.39
c172 ( 66 0 ) capacitor c=0.0187384f //x=14.83 //y=1.045
c173 ( 63 0 ) capacitor c=0.0141798f //x=14.675 //y=1.545
c174 ( 61 0 ) capacitor c=0.0149844f //x=14.675 //y=0.89
c175 ( 57 0 ) capacitor c=0.0813322f //x=14.3 //y=2.095
c176 ( 56 0 ) capacitor c=0.0229267f //x=14.3 //y=1.7
c177 ( 55 0 ) capacitor c=0.0234352f //x=14.3 //y=1.39
c178 ( 54 0 ) capacitor c=0.0199343f //x=14.3 //y=1.045
c179 ( 53 0 ) capacitor c=0.110275f //x=14.835 //y=6.2
c180 ( 52 0 ) capacitor c=0.154305f //x=14.395 //y=6.2
c181 ( 50 0 ) capacitor c=0.00106608f //x=11.865 //y=5.335
c182 ( 49 0 ) capacitor c=0.00206559f //x=10.985 //y=5.335
c183 ( 42 0 ) capacitor c=0.0900192f //x=14.495 //y=2.26
c184 ( 40 0 ) capacitor c=0.110801f //x=12.645 //y=2.77
c185 ( 36 0 ) capacitor c=0.00398962f //x=12.245 //y=1.845
c186 ( 35 0 ) capacitor c=0.0137288f //x=12.56 //y=1.845
c187 ( 29 0 ) capacitor c=0.0284988f //x=12.56 //y=5.335
c188 ( 21 0 ) capacitor c=0.0176454f //x=11.78 //y=5.335
c189 ( 14 0 ) capacitor c=0.00332903f //x=10.19 //y=5.335
c190 ( 13 0 ) capacitor c=0.0148468f //x=10.9 //y=5.335
c191 ( 2 0 ) capacitor c=0.00879187f //x=12.76 //y=2.77
c192 ( 1 0 ) capacitor c=0.0476269f //x=14.38 //y=2.77
r193 (  75 77 ) resistor r=20.6867 //w=0.233 //l=0.1 //layer=ply \
 //thickness=0.18 //x=14.395 //y=4.88 //x2=14.495 //y2=4.88
r194 (  68 77 ) resistor r=70.3348 //w=0.233 //l=0.414367 //layer=ply \
 //thickness=0.18 //x=14.835 //y=5.045 //x2=14.495 //y2=4.88
r195 (  67 79 ) resistor r=45.1352 //w=0.168 //l=0.173853 //layer=ply \
 //thickness=0.18 //x=14.83 //y=1.39 //x2=14.79 //y2=1.545
r196 (  66 78 ) resistor r=45.1352 //w=0.168 //l=0.173853 //layer=ply \
 //thickness=0.18 //x=14.83 //y=1.045 //x2=14.79 //y2=0.89
r197 (  66 67 ) resistor r=176.904 //w=0.094 //l=0.345 //layer=ply \
 //thickness=0.18 //x=14.83 //y=1.045 //x2=14.83 //y2=1.39
r198 (  64 74 ) resistor r=10.701 //w=0.21 //l=0.115 //layer=ply \
 //thickness=0.18 //x=14.455 //y=1.545 //x2=14.34 //y2=1.545
r199 (  63 79 ) resistor r=5.52526 //w=0.168 //l=0.115 //layer=ply \
 //thickness=0.18 //x=14.675 //y=1.545 //x2=14.79 //y2=1.545
r200 (  62 73 ) resistor r=5.52526 //w=0.168 //l=0.115 //layer=ply \
 //thickness=0.18 //x=14.455 //y=0.89 //x2=14.34 //y2=0.89
r201 (  61 78 ) resistor r=5.52526 //w=0.168 //l=0.115 //layer=ply \
 //thickness=0.18 //x=14.675 //y=0.89 //x2=14.79 //y2=0.89
r202 (  61 62 ) resistor r=112.809 //w=0.094 //l=0.22 //layer=ply \
 //thickness=0.18 //x=14.675 //y=0.89 //x2=14.455 //y2=0.89
r203 (  58 75 ) resistor r=13.0941 //w=0.233 //l=0.165 //layer=ply \
 //thickness=0.18 //x=14.395 //y=5.045 //x2=14.395 //y2=4.88
r204 (  57 72 ) resistor r=34.8111 //w=0.27 //l=0.264953 //layer=ply \
 //thickness=0.18 //x=14.3 //y=2.095 //x2=14.495 //y2=2.26
r205 (  56 74 ) resistor r=39.5823 //w=0.21 //l=0.173853 //layer=ply \
 //thickness=0.18 //x=14.3 //y=1.7 //x2=14.34 //y2=1.545
r206 (  56 57 ) resistor r=202.543 //w=0.094 //l=0.395 //layer=ply \
 //thickness=0.18 //x=14.3 //y=1.7 //x2=14.3 //y2=2.095
r207 (  55 74 ) resistor r=39.5823 //w=0.21 //l=0.173853 //layer=ply \
 //thickness=0.18 //x=14.3 //y=1.39 //x2=14.34 //y2=1.545
r208 (  54 73 ) resistor r=45.1352 //w=0.168 //l=0.173853 //layer=ply \
 //thickness=0.18 //x=14.3 //y=1.045 //x2=14.34 //y2=0.89
r209 (  54 55 ) resistor r=176.904 //w=0.094 //l=0.345 //layer=ply \
 //thickness=0.18 //x=14.3 //y=1.045 //x2=14.3 //y2=1.39
r210 (  53 68 ) resistor r=592.245 //w=0.094 //l=1.155 //layer=ply \
 //thickness=0.18 //x=14.835 //y=6.2 //x2=14.835 //y2=5.045
r211 (  52 58 ) resistor r=592.245 //w=0.094 //l=1.155 //layer=ply \
 //thickness=0.18 //x=14.395 //y=6.2 //x2=14.395 //y2=5.045
r212 (  51 63 ) resistor r=56.4043 //w=0.094 //l=0.11 //layer=ply \
 //thickness=0.18 //x=14.565 //y=1.545 //x2=14.675 //y2=1.545
r213 (  51 64 ) resistor r=56.4043 //w=0.094 //l=0.11 //layer=ply \
 //thickness=0.18 //x=14.565 //y=1.545 //x2=14.455 //y2=1.545
r214 (  47 77 ) resistor r=152 //w=0.17 //l=0.17 //layer=licon //count=1 \
 //x=14.495 //y=4.88 //x2=14.495 //y2=4.88
r215 (  45 47 ) resistor r=144.428 //w=0.187 //l=2.11 //layer=li \
 //thickness=0.1 //x=14.495 //y=2.77 //x2=14.495 //y2=4.88
r216 (  42 72 ) resistor r=152 //w=0.17 //l=0.17 //layer=licon //count=1 \
 //x=14.495 //y=2.26 //x2=14.495 //y2=2.26
r217 (  42 45 ) resistor r=34.9091 //w=0.187 //l=0.51 //layer=li \
 //thickness=0.1 //x=14.495 //y=2.26 //x2=14.495 //y2=2.77
r218 (  38 40 ) resistor r=169.754 //w=0.187 //l=2.48 //layer=li \
 //thickness=0.1 //x=12.645 //y=5.25 //x2=12.645 //y2=2.77
r219 (  37 40 ) resistor r=57.4973 //w=0.187 //l=0.84 //layer=li \
 //thickness=0.1 //x=12.645 //y=1.93 //x2=12.645 //y2=2.77
r220 (  35 37 ) resistor r=7.15173 //w=0.17 //l=0.120208 //layer=li \
 //thickness=0.1 //x=12.56 //y=1.845 //x2=12.645 //y2=1.93
r221 (  35 36 ) resistor r=21.5615 //w=0.187 //l=0.315 //layer=li \
 //thickness=0.1 //x=12.56 //y=1.845 //x2=12.245 //y2=1.845
r222 (  31 36 ) resistor r=7.15173 //w=0.17 //l=0.120208 //layer=li \
 //thickness=0.1 //x=12.16 //y=1.76 //x2=12.245 //y2=1.845
r223 (  31 80 ) resistor r=39.016 //w=0.187 //l=0.57 //layer=li \
 //thickness=0.1 //x=12.16 //y=1.76 //x2=12.16 //y2=1.19
r224 (  30 50 ) resistor r=5.4201 //w=0.17 //l=0.085 //layer=li \
 //thickness=0.1 //x=11.95 //y=5.335 //x2=11.865 //y2=5.335
r225 (  29 38 ) resistor r=7.15173 //w=0.17 //l=0.120208 //layer=li \
 //thickness=0.1 //x=12.56 //y=5.335 //x2=12.645 //y2=5.25
r226 (  29 30 ) resistor r=41.754 //w=0.187 //l=0.61 //layer=li \
 //thickness=0.1 //x=12.56 //y=5.335 //x2=11.95 //y2=5.335
r227 (  23 50 ) resistor r=1.40859 //w=0.34 //l=0.085 //layer=li \
 //thickness=0.1 //x=11.865 //y=5.42 //x2=11.865 //y2=5.335
r228 (  23 84 ) resistor r=33.1979 //w=0.187 //l=0.485 //layer=li \
 //thickness=0.1 //x=11.865 //y=5.42 //x2=11.865 //y2=5.905
r229 (  22 49 ) resistor r=5.4201 //w=0.17 //l=0.085 //layer=li \
 //thickness=0.1 //x=11.07 //y=5.335 //x2=10.985 //y2=5.335
r230 (  21 50 ) resistor r=5.4201 //w=0.17 //l=0.085 //layer=li \
 //thickness=0.1 //x=11.78 //y=5.335 //x2=11.865 //y2=5.335
r231 (  21 22 ) resistor r=48.5989 //w=0.187 //l=0.71 //layer=li \
 //thickness=0.1 //x=11.78 //y=5.335 //x2=11.07 //y2=5.335
r232 (  15 49 ) resistor r=1.40859 //w=0.34 //l=0.085 //layer=li \
 //thickness=0.1 //x=10.985 //y=5.42 //x2=10.985 //y2=5.335
r233 (  15 83 ) resistor r=33.1979 //w=0.187 //l=0.485 //layer=li \
 //thickness=0.1 //x=10.985 //y=5.42 //x2=10.985 //y2=5.905
r234 (  13 49 ) resistor r=5.4201 //w=0.17 //l=0.085 //layer=li \
 //thickness=0.1 //x=10.9 //y=5.335 //x2=10.985 //y2=5.335
r235 (  13 14 ) resistor r=48.5989 //w=0.187 //l=0.71 //layer=li \
 //thickness=0.1 //x=10.9 //y=5.335 //x2=10.19 //y2=5.335
r236 (  7 14 ) resistor r=7.15173 //w=0.17 //l=0.120208 //layer=li \
 //thickness=0.1 //x=10.105 //y=5.42 //x2=10.19 //y2=5.335
r237 (  7 82 ) resistor r=33.1979 //w=0.187 //l=0.485 //layer=li \
 //thickness=0.1 //x=10.105 //y=5.42 //x2=10.105 //y2=5.905
r238 (  6 45 ) resistor r=9.3 //w=0.17 //l=0.17 //layer=mcon //count=1 \
 //x=14.495 //y=2.77 //x2=14.495 //y2=2.77
r239 (  4 40 ) resistor r=9.3 //w=0.17 //l=0.17 //layer=mcon //count=1 \
 //x=12.645 //y=2.77 //x2=12.645 //y2=2.77
r240 (  2 4 ) resistor r=0.0717383 //w=0.224 //l=0.115 //layer=m1 \
 //thickness=0.36 //x=12.76 //y=2.77 //x2=12.645 //y2=2.77
r241 (  1 6 ) resistor r=0.0717383 //w=0.224 //l=0.115 //layer=m1 \
 //thickness=0.36 //x=14.38 //y=2.77 //x2=14.495 //y2=2.77
r242 (  1 2 ) resistor r=1.5458 //w=0.131 //l=1.62 //layer=m1 //thickness=0.36 \
 //x=14.38 //y=2.77 //x2=12.76 //y2=2.77
ends PM_DFFSNQNX1\%noxref_4

subckt PM_DFFSNQNX1\%CLK ( 1 2 7 8 9 10 11 12 13 14 17 27 31 38 43 46 50 56 59 \
 65 66 67 68 69 70 71 72 73 75 81 82 83 84 85 90 91 92 97 99 101 107 108 112 \
 121 122 125 )
c227 ( 125 0 ) capacitor c=0.0321632f //x=15.265 //y=4.88
c228 ( 122 0 ) capacitor c=0.0279499f //x=15.235 //y=2.095
c229 ( 121 0 ) capacitor c=0.0422597f //x=15.235 //y=2.26
c230 ( 112 0 ) capacitor c=0.0334004f //x=5.985 //y=4.88
c231 ( 108 0 ) capacitor c=0.0429696f //x=15.8 //y=1.43
c232 ( 107 0 ) capacitor c=0.0192208f //x=15.8 //y=1.085
c233 ( 101 0 ) capacitor c=0.0148884f //x=15.645 //y=1.585
c234 ( 99 0 ) capacitor c=0.0157803f //x=15.645 //y=0.93
c235 ( 97 0 ) capacitor c=0.0299681f //x=15.64 //y=4.97
c236 ( 92 0 ) capacitor c=0.0204188f //x=15.27 //y=1.74
c237 ( 91 0 ) capacitor c=0.0168481f //x=15.27 //y=1.43
c238 ( 90 0 ) capacitor c=0.0174783f //x=15.27 //y=1.085
c239 ( 85 0 ) capacitor c=0.0242579f //x=6.32 //y=4.97
c240 ( 84 0 ) capacitor c=0.082575f //x=6.075 //y=2.095
c241 ( 83 0 ) capacitor c=0.0170266f //x=6.075 //y=1.63
c242 ( 82 0 ) capacitor c=0.018609f //x=6.075 //y=1.4
c243 ( 81 0 ) capacitor c=0.0187309f //x=6.075 //y=1.09
c244 ( 75 0 ) capacitor c=0.014725f //x=5.92 //y=1.555
c245 ( 73 0 ) capacitor c=0.0146567f //x=5.92 //y=0.935
c246 ( 72 0 ) capacitor c=0.0335408f //x=5.55 //y=1.4
c247 ( 71 0 ) capacitor c=0.0173761f //x=5.55 //y=1.09
c248 ( 70 0 ) capacitor c=0.15358f //x=15.715 //y=6.2
c249 ( 69 0 ) capacitor c=0.110281f //x=15.275 //y=6.2
c250 ( 68 0 ) capacitor c=0.110114f //x=6.395 //y=6.2
c251 ( 67 0 ) capacitor c=0.11012f //x=5.955 //y=6.2
c252 ( 59 0 ) capacitor c=0.00706355f //x=15.262 //y=3.425
c253 ( 56 0 ) capacitor c=0.00700901f //x=15.262 //y=3.055
c254 ( 50 0 ) capacitor c=0.0217067f //x=6.012 //y=4.535
c255 ( 46 0 ) capacitor c=0.00846054f //x=6.012 //y=3.795
c256 ( 43 0 ) capacitor c=0.00874422f //x=6.012 //y=3.425
c257 ( 38 0 ) capacitor c=0.028079f //x=15.235 //y=4.535
c258 ( 31 0 ) capacitor c=0.010526f //x=15.235 //y=2.26
c259 ( 27 0 ) capacitor c=0.00474631f //x=5.985 //y=4.88
c260 ( 17 0 ) capacitor c=0.0284803f //x=5.985 //y=2.26
c261 ( 14 0 ) capacitor c=0.00768895f //x=15.29 //y=4.62
c262 ( 13 0 ) capacitor c=0.00738092f //x=15.29 //y=3.51
c263 ( 12 0 ) capacitor c=0.00710549f //x=15.29 //y=3.14
c264 ( 11 0 ) capacitor c=0.00613649f //x=15.29 //y=2.77
c265 ( 10 0 ) capacitor c=0.00579039f //x=6.04 //y=4.62
c266 ( 9 0 ) capacitor c=0.00804715f //x=6.04 //y=3.88
c267 ( 8 0 ) capacitor c=0.0084861f //x=6.04 //y=3.51
c268 ( 7 0 ) capacitor c=0.00846992f //x=6.04 //y=3.14
c269 ( 2 0 ) capacitor c=0.0154682f //x=6.1 //y=4.62
c270 ( 1 0 ) capacitor c=0.207289f //x=15.12 //y=4.62
r271 (  127 128 ) resistor r=32.4568 //w=0.214 //l=0.075 //layer=ply \
 //thickness=0.18 //x=15.265 //y=4.97 //x2=15.265 //y2=5.045
r272 (  125 127 ) resistor r=20.271 //w=0.214 //l=0.09 //layer=ply \
 //thickness=0.18 //x=15.265 //y=4.88 //x2=15.265 //y2=4.97
r273 (  121 122 ) resistor r=52.7279 //w=0.214 //l=0.165 //layer=ply \
 //thickness=0.18 //x=15.235 //y=2.26 //x2=15.235 //y2=2.095
r274 (  114 115 ) resistor r=32.4568 //w=0.214 //l=0.075 //layer=ply \
 //thickness=0.18 //x=5.985 //y=4.97 //x2=5.985 //y2=5.045
r275 (  112 114 ) resistor r=20.271 //w=0.214 //l=0.09 //layer=ply \
 //thickness=0.18 //x=5.985 //y=4.88 //x2=5.985 //y2=4.97
r276 (  108 132 ) resistor r=45.1352 //w=0.168 //l=0.173853 //layer=ply \
 //thickness=0.18 //x=15.8 //y=1.43 //x2=15.76 //y2=1.585
r277 (  107 131 ) resistor r=45.1352 //w=0.168 //l=0.173853 //layer=ply \
 //thickness=0.18 //x=15.8 //y=1.085 //x2=15.76 //y2=0.93
r278 (  107 108 ) resistor r=176.904 //w=0.094 //l=0.345 //layer=ply \
 //thickness=0.18 //x=15.8 //y=1.085 //x2=15.8 //y2=1.43
r279 (  102 130 ) resistor r=10.701 //w=0.21 //l=0.115 //layer=ply \
 //thickness=0.18 //x=15.425 //y=1.585 //x2=15.31 //y2=1.585
r280 (  101 132 ) resistor r=5.52526 //w=0.168 //l=0.115 //layer=ply \
 //thickness=0.18 //x=15.645 //y=1.585 //x2=15.76 //y2=1.585
r281 (  100 129 ) resistor r=5.52526 //w=0.168 //l=0.115 //layer=ply \
 //thickness=0.18 //x=15.425 //y=0.93 //x2=15.31 //y2=0.93
r282 (  99 131 ) resistor r=5.52526 //w=0.168 //l=0.115 //layer=ply \
 //thickness=0.18 //x=15.645 //y=0.93 //x2=15.76 //y2=0.93
r283 (  99 100 ) resistor r=112.809 //w=0.094 //l=0.22 //layer=ply \
 //thickness=0.18 //x=15.645 //y=0.93 //x2=15.425 //y2=0.93
r284 (  98 127 ) resistor r=16.5046 //w=0.27 //l=0.135 //layer=ply \
 //thickness=0.18 //x=15.4 //y=4.97 //x2=15.265 //y2=4.97
r285 (  97 104 ) resistor r=26.9307 //w=0.15 //l=0.106066 //layer=ply \
 //thickness=0.18 //x=15.64 //y=4.97 //x2=15.715 //y2=5.045
r286 (  97 98 ) resistor r=123.064 //w=0.094 //l=0.24 //layer=ply \
 //thickness=0.18 //x=15.64 //y=4.97 //x2=15.4 //y2=4.97
r287 (  92 130 ) resistor r=39.5823 //w=0.21 //l=0.173853 //layer=ply \
 //thickness=0.18 //x=15.27 //y=1.74 //x2=15.31 //y2=1.585
r288 (  92 122 ) resistor r=182.032 //w=0.094 //l=0.355 //layer=ply \
 //thickness=0.18 //x=15.27 //y=1.74 //x2=15.27 //y2=2.095
r289 (  91 130 ) resistor r=39.5823 //w=0.21 //l=0.173853 //layer=ply \
 //thickness=0.18 //x=15.27 //y=1.43 //x2=15.31 //y2=1.585
r290 (  90 129 ) resistor r=45.1352 //w=0.168 //l=0.173853 //layer=ply \
 //thickness=0.18 //x=15.27 //y=1.085 //x2=15.31 //y2=0.93
r291 (  90 91 ) resistor r=176.904 //w=0.094 //l=0.345 //layer=ply \
 //thickness=0.18 //x=15.27 //y=1.085 //x2=15.27 //y2=1.43
r292 (  86 114 ) resistor r=16.5046 //w=0.27 //l=0.135 //layer=ply \
 //thickness=0.18 //x=6.12 //y=4.97 //x2=5.985 //y2=4.97
r293 (  85 87 ) resistor r=26.9307 //w=0.15 //l=0.106066 //layer=ply \
 //thickness=0.18 //x=6.32 //y=4.97 //x2=6.395 //y2=5.045
r294 (  85 86 ) resistor r=102.553 //w=0.094 //l=0.2 //layer=ply \
 //thickness=0.18 //x=6.32 //y=4.97 //x2=6.12 //y2=4.97
r295 (  84 119 ) resistor r=38.6777 //w=0.284 //l=0.198997 //layer=ply \
 //thickness=0.18 //x=6.075 //y=2.095 //x2=6 //y2=2.26
r296 (  83 117 ) resistor r=21.2976 //w=0.217 //l=0.0928709 //layer=ply \
 //thickness=0.18 //x=6.075 //y=1.63 //x2=6.035 //y2=1.555
r297 (  83 84 ) resistor r=238.436 //w=0.094 //l=0.465 //layer=ply \
 //thickness=0.18 //x=6.075 //y=1.63 //x2=6.075 //y2=2.095
r298 (  82 117 ) resistor r=39.0671 //w=0.217 //l=0.173853 //layer=ply \
 //thickness=0.18 //x=6.075 //y=1.4 //x2=6.035 //y2=1.555
r299 (  81 116 ) resistor r=45.1352 //w=0.168 //l=0.173853 //layer=ply \
 //thickness=0.18 //x=6.075 //y=1.09 //x2=6.035 //y2=0.935
r300 (  81 82 ) resistor r=158.957 //w=0.094 //l=0.31 //layer=ply \
 //thickness=0.18 //x=6.075 //y=1.09 //x2=6.075 //y2=1.4
r301 (  76 110 ) resistor r=5.52526 //w=0.168 //l=0.115 //layer=ply \
 //thickness=0.18 //x=5.705 //y=1.555 //x2=5.59 //y2=1.555
r302 (  75 117 ) resistor r=11.4558 //w=0.217 //l=0.115 //layer=ply \
 //thickness=0.18 //x=5.92 //y=1.555 //x2=6.035 //y2=1.555
r303 (  74 109 ) resistor r=5.52526 //w=0.168 //l=0.115 //layer=ply \
 //thickness=0.18 //x=5.705 //y=0.935 //x2=5.59 //y2=0.935
r304 (  73 116 ) resistor r=5.52526 //w=0.168 //l=0.115 //layer=ply \
 //thickness=0.18 //x=5.92 //y=0.935 //x2=6.035 //y2=0.935
r305 (  73 74 ) resistor r=110.245 //w=0.094 //l=0.215 //layer=ply \
 //thickness=0.18 //x=5.92 //y=0.935 //x2=5.705 //y2=0.935
r306 (  72 110 ) resistor r=45.1352 //w=0.168 //l=0.173853 //layer=ply \
 //thickness=0.18 //x=5.55 //y=1.4 //x2=5.59 //y2=1.555
r307 (  71 109 ) resistor r=45.1352 //w=0.168 //l=0.173853 //layer=ply \
 //thickness=0.18 //x=5.55 //y=1.09 //x2=5.59 //y2=0.935
r308 (  71 72 ) resistor r=158.957 //w=0.094 //l=0.31 //layer=ply \
 //thickness=0.18 //x=5.55 //y=1.09 //x2=5.55 //y2=1.4
r309 (  70 104 ) resistor r=592.245 //w=0.094 //l=1.155 //layer=ply \
 //thickness=0.18 //x=15.715 //y=6.2 //x2=15.715 //y2=5.045
r310 (  69 128 ) resistor r=592.245 //w=0.094 //l=1.155 //layer=ply \
 //thickness=0.18 //x=15.275 //y=6.2 //x2=15.275 //y2=5.045
r311 (  68 87 ) resistor r=592.245 //w=0.094 //l=1.155 //layer=ply \
 //thickness=0.18 //x=6.395 //y=6.2 //x2=6.395 //y2=5.045
r312 (  67 115 ) resistor r=592.245 //w=0.094 //l=1.155 //layer=ply \
 //thickness=0.18 //x=5.955 //y=6.2 //x2=5.955 //y2=5.045
r313 (  66 101 ) resistor r=56.4043 //w=0.094 //l=0.11 //layer=ply \
 //thickness=0.18 //x=15.535 //y=1.585 //x2=15.645 //y2=1.585
r314 (  66 102 ) resistor r=56.4043 //w=0.094 //l=0.11 //layer=ply \
 //thickness=0.18 //x=15.535 //y=1.585 //x2=15.425 //y2=1.585
r315 (  65 75 ) resistor r=55.3787 //w=0.094 //l=0.108 //layer=ply \
 //thickness=0.18 //x=5.812 //y=1.555 //x2=5.92 //y2=1.555
r316 (  65 76 ) resistor r=54.866 //w=0.094 //l=0.107 //layer=ply \
 //thickness=0.18 //x=5.812 //y=1.555 //x2=5.705 //y2=1.555
r317 (  64 125 ) resistor r=152 //w=0.17 //l=0.17 //layer=licon //count=1 \
 //x=15.265 //y=4.88 //x2=15.265 //y2=4.88
r318 (  57 59 ) resistor r=13.6898 //w=0.187 //l=0.2 //layer=li \
 //thickness=0.1 //x=15.235 //y=3.225 //x2=15.235 //y2=3.425
r319 (  54 56 ) resistor r=13.6898 //w=0.187 //l=0.2 //layer=li \
 //thickness=0.1 //x=15.235 //y=2.855 //x2=15.235 //y2=3.055
r320 (  47 50 ) resistor r=39.016 //w=0.187 //l=0.57 //layer=li \
 //thickness=0.1 //x=5.985 //y=3.965 //x2=5.985 //y2=4.535
r321 (  44 46 ) resistor r=13.6898 //w=0.187 //l=0.2 //layer=li \
 //thickness=0.1 //x=5.985 //y=3.595 //x2=5.985 //y2=3.795
r322 (  41 43 ) resistor r=13.6898 //w=0.187 //l=0.2 //layer=li \
 //thickness=0.1 //x=5.985 //y=3.225 //x2=5.985 //y2=3.425
r323 (  38 60 ) resistor r=64.3422 //w=0.187 //l=0.94 //layer=li \
 //thickness=0.1 //x=15.235 //y=4.535 //x2=15.235 //y2=3.595
r324 (  31 121 ) resistor r=152 //w=0.17 //l=0.17 //layer=licon //count=1 \
 //x=15.235 //y=2.26 //x2=15.235 //y2=2.26
r325 (  31 53 ) resistor r=29.0909 //w=0.187 //l=0.425 //layer=li \
 //thickness=0.1 //x=15.235 //y=2.26 //x2=15.235 //y2=2.685
r326 (  27 112 ) resistor r=152 //w=0.17 //l=0.17 //layer=licon //count=1 \
 //x=5.985 //y=4.88 //x2=5.985 //y2=4.88
r327 (  27 51 ) resistor r=11.9786 //w=0.187 //l=0.175 //layer=li \
 //thickness=0.1 //x=5.985 //y=4.88 //x2=5.985 //y2=4.705
r328 (  17 119 ) resistor r=152 //w=0.17 //l=0.17 //layer=licon //count=1 \
 //x=5.985 //y=2.26 //x2=5.985 //y2=2.26
r329 (  17 40 ) resistor r=54.4171 //w=0.187 //l=0.795 //layer=li \
 //thickness=0.1 //x=5.985 //y=2.26 //x2=5.985 //y2=3.055
r330 (  14 64 ) resistor r=16.7236 //w=0.199 //l=0.26 //layer=li \
 //thickness=0.1 //x=15.262 //y=4.62 //x2=15.262 //y2=4.88
r331 (  14 38 ) resistor r=5.77545 //w=0.199 //l=0.0975705 //layer=li \
 //thickness=0.1 //x=15.262 //y=4.62 //x2=15.235 //y2=4.535
r332 (  13 60 ) resistor r=5.1957 //w=0.242 //l=0.085 //layer=li \
 //thickness=0.1 //x=15.262 //y=3.51 //x2=15.262 //y2=3.595
r333 (  13 59 ) resistor r=5.1957 //w=0.242 //l=0.085 //layer=li \
 //thickness=0.1 //x=15.262 //y=3.51 //x2=15.262 //y2=3.425
r334 (  12 57 ) resistor r=5.1957 //w=0.242 //l=0.085 //layer=li \
 //thickness=0.1 //x=15.262 //y=3.14 //x2=15.262 //y2=3.225
r335 (  12 56 ) resistor r=5.1957 //w=0.242 //l=0.085 //layer=li \
 //thickness=0.1 //x=15.262 //y=3.14 //x2=15.262 //y2=3.055
r336 (  11 54 ) resistor r=5.1957 //w=0.242 //l=0.085 //layer=li \
 //thickness=0.1 //x=15.262 //y=2.77 //x2=15.262 //y2=2.855
r337 (  11 53 ) resistor r=5.1957 //w=0.242 //l=0.085 //layer=li \
 //thickness=0.1 //x=15.262 //y=2.77 //x2=15.262 //y2=2.685
r338 (  10 51 ) resistor r=5.1957 //w=0.242 //l=0.085 //layer=li \
 //thickness=0.1 //x=6.012 //y=4.62 //x2=6.012 //y2=4.705
r339 (  10 50 ) resistor r=5.1957 //w=0.242 //l=0.085 //layer=li \
 //thickness=0.1 //x=6.012 //y=4.62 //x2=6.012 //y2=4.535
r340 (  9 47 ) resistor r=5.1957 //w=0.242 //l=0.085 //layer=li \
 //thickness=0.1 //x=6.012 //y=3.88 //x2=6.012 //y2=3.965
r341 (  9 46 ) resistor r=5.1957 //w=0.242 //l=0.085 //layer=li \
 //thickness=0.1 //x=6.012 //y=3.88 //x2=6.012 //y2=3.795
r342 (  8 44 ) resistor r=5.1957 //w=0.242 //l=0.085 //layer=li \
 //thickness=0.1 //x=6.012 //y=3.51 //x2=6.012 //y2=3.595
r343 (  8 43 ) resistor r=5.1957 //w=0.242 //l=0.085 //layer=li \
 //thickness=0.1 //x=6.012 //y=3.51 //x2=6.012 //y2=3.425
r344 (  7 41 ) resistor r=5.1957 //w=0.242 //l=0.085 //layer=li \
 //thickness=0.1 //x=6.012 //y=3.14 //x2=6.012 //y2=3.225
r345 (  7 40 ) resistor r=5.1957 //w=0.242 //l=0.085 //layer=li \
 //thickness=0.1 //x=6.012 //y=3.14 //x2=6.012 //y2=3.055
r346 (  6 14 ) resistor r=9.3 //w=0.17 //l=0.17 //layer=mcon //count=1 \
 //x=15.235 //y=4.62 //x2=15.235 //y2=4.62
r347 (  4 10 ) resistor r=9.3 //w=0.17 //l=0.17 //layer=mcon //count=1 \
 //x=5.985 //y=4.62 //x2=5.985 //y2=4.62
r348 (  2 4 ) resistor r=0.0717383 //w=0.224 //l=0.115 //layer=m1 \
 //thickness=0.36 //x=6.1 //y=4.62 //x2=5.985 //y2=4.62
r349 (  1 6 ) resistor r=0.0717383 //w=0.224 //l=0.115 //layer=m1 \
 //thickness=0.36 //x=15.12 //y=4.62 //x2=15.235 //y2=4.62
r350 (  1 2 ) resistor r=8.60687 //w=0.131 //l=9.02 //layer=m1 \
 //thickness=0.36 //x=15.12 //y=4.62 //x2=6.1 //y2=4.62
ends PM_DFFSNQNX1\%CLK

subckt PM_DFFSNQNX1\%noxref_6 ( 1 2 3 4 11 13 23 24 31 39 45 46 50 52 61 62 64 \
 65 67 68 69 70 71 72 73 74 75 80 82 84 90 91 92 93 94 95 99 101 104 105 110 \
 111 114 128 131 133 134 135 )
c307 ( 135 0 ) capacitor c=0.023087f //x=6.91 //y=5.2
c308 ( 134 0 ) capacitor c=0.023519f //x=6.03 //y=5.2
c309 ( 133 0 ) capacitor c=0.0224735f //x=5.15 //y=5.2
c310 ( 131 0 ) capacitor c=0.00853354f //x=7.16 //y=1.095
c311 ( 128 0 ) capacitor c=0.0597793f //x=17.825 //y=4.88
c312 ( 114 0 ) capacitor c=0.0331534f //x=2.315 //y=4.88
c313 ( 111 0 ) capacitor c=0.0279499f //x=2.285 //y=2.095
c314 ( 110 0 ) capacitor c=0.0437152f //x=2.285 //y=2.26
c315 ( 105 0 ) capacitor c=0.0318948f //x=18.16 //y=1.39
c316 ( 104 0 ) capacitor c=0.0187384f //x=18.16 //y=1.045
c317 ( 101 0 ) capacitor c=0.0141798f //x=18.005 //y=1.545
c318 ( 99 0 ) capacitor c=0.0149844f //x=18.005 //y=0.89
c319 ( 95 0 ) capacitor c=0.0813322f //x=17.63 //y=2.095
c320 ( 94 0 ) capacitor c=0.0229267f //x=17.63 //y=1.7
c321 ( 93 0 ) capacitor c=0.0234352f //x=17.63 //y=1.39
c322 ( 92 0 ) capacitor c=0.0199343f //x=17.63 //y=1.045
c323 ( 91 0 ) capacitor c=0.0429696f //x=2.85 //y=1.43
c324 ( 90 0 ) capacitor c=0.0192208f //x=2.85 //y=1.085
c325 ( 84 0 ) capacitor c=0.0158629f //x=2.695 //y=1.585
c326 ( 82 0 ) capacitor c=0.0157803f //x=2.695 //y=0.93
c327 ( 80 0 ) capacitor c=0.0299681f //x=2.69 //y=4.97
c328 ( 75 0 ) capacitor c=0.0205163f //x=2.32 //y=1.74
c329 ( 74 0 ) capacitor c=0.0168481f //x=2.32 //y=1.43
c330 ( 73 0 ) capacitor c=0.0174783f //x=2.32 //y=1.085
c331 ( 72 0 ) capacitor c=0.110275f //x=18.165 //y=6.2
c332 ( 71 0 ) capacitor c=0.154305f //x=17.725 //y=6.2
c333 ( 70 0 ) capacitor c=0.15358f //x=2.765 //y=6.2
c334 ( 69 0 ) capacitor c=0.110281f //x=2.325 //y=6.2
c335 ( 65 0 ) capacitor c=0.0792985f //x=7.832 //y=4.085
c336 ( 64 0 ) capacitor c=0.0101843f //x=7.83 //y=4.25
c337 ( 62 0 ) capacitor c=0.00106608f //x=7.055 //y=5.335
c338 ( 61 0 ) capacitor c=0.00179642f //x=6.175 //y=5.335
c339 ( 52 0 ) capacitor c=0.0934008f //x=17.825 //y=2.26
c340 ( 50 0 ) capacitor c=0.0237587f //x=7.835 //y=5.25
c341 ( 46 0 ) capacitor c=0.00431225f //x=7.435 //y=1.845
c342 ( 45 0 ) capacitor c=0.0141453f //x=7.75 //y=1.845
c343 ( 39 0 ) capacitor c=0.0281378f //x=7.75 //y=5.335
c344 ( 31 0 ) capacitor c=0.0176454f //x=6.97 //y=5.335
c345 ( 24 0 ) capacitor c=0.00351598f //x=5.38 //y=5.335
c346 ( 23 0 ) capacitor c=0.0154549f //x=6.09 //y=5.335
c347 ( 13 0 ) capacitor c=0.0780437f //x=2.285 //y=2.26
c348 ( 11 0 ) capacitor c=0.00453889f //x=2.285 //y=4.715
c349 ( 4 0 ) capacitor c=0.00551102f //x=7.945 //y=4.25
c350 ( 3 0 ) capacitor c=0.180342f //x=17.71 //y=4.25
c351 ( 2 0 ) capacitor c=0.0180257f //x=2.4 //y=4.25
c352 ( 1 0 ) capacitor c=0.158504f //x=7.715 //y=4.25
r353 (  126 128 ) resistor r=20.6867 //w=0.233 //l=0.1 //layer=ply \
 //thickness=0.18 //x=17.725 //y=4.88 //x2=17.825 //y2=4.88
r354 (  116 117 ) resistor r=32.4568 //w=0.214 //l=0.075 //layer=ply \
 //thickness=0.18 //x=2.315 //y=4.97 //x2=2.315 //y2=5.045
r355 (  114 116 ) resistor r=20.271 //w=0.214 //l=0.09 //layer=ply \
 //thickness=0.18 //x=2.315 //y=4.88 //x2=2.315 //y2=4.97
r356 (  110 111 ) resistor r=52.7279 //w=0.214 //l=0.165 //layer=ply \
 //thickness=0.18 //x=2.285 //y=2.26 //x2=2.285 //y2=2.095
r357 (  106 128 ) resistor r=70.3348 //w=0.233 //l=0.414367 //layer=ply \
 //thickness=0.18 //x=18.165 //y=5.045 //x2=17.825 //y2=4.88
r358 (  105 130 ) resistor r=45.1352 //w=0.168 //l=0.173853 //layer=ply \
 //thickness=0.18 //x=18.16 //y=1.39 //x2=18.12 //y2=1.545
r359 (  104 129 ) resistor r=45.1352 //w=0.168 //l=0.173853 //layer=ply \
 //thickness=0.18 //x=18.16 //y=1.045 //x2=18.12 //y2=0.89
r360 (  104 105 ) resistor r=176.904 //w=0.094 //l=0.345 //layer=ply \
 //thickness=0.18 //x=18.16 //y=1.045 //x2=18.16 //y2=1.39
r361 (  102 125 ) resistor r=10.701 //w=0.21 //l=0.115 //layer=ply \
 //thickness=0.18 //x=17.785 //y=1.545 //x2=17.67 //y2=1.545
r362 (  101 130 ) resistor r=5.52526 //w=0.168 //l=0.115 //layer=ply \
 //thickness=0.18 //x=18.005 //y=1.545 //x2=18.12 //y2=1.545
r363 (  100 124 ) resistor r=5.52526 //w=0.168 //l=0.115 //layer=ply \
 //thickness=0.18 //x=17.785 //y=0.89 //x2=17.67 //y2=0.89
r364 (  99 129 ) resistor r=5.52526 //w=0.168 //l=0.115 //layer=ply \
 //thickness=0.18 //x=18.005 //y=0.89 //x2=18.12 //y2=0.89
r365 (  99 100 ) resistor r=112.809 //w=0.094 //l=0.22 //layer=ply \
 //thickness=0.18 //x=18.005 //y=0.89 //x2=17.785 //y2=0.89
r366 (  96 126 ) resistor r=13.0941 //w=0.233 //l=0.165 //layer=ply \
 //thickness=0.18 //x=17.725 //y=5.045 //x2=17.725 //y2=4.88
r367 (  95 123 ) resistor r=34.8111 //w=0.27 //l=0.264953 //layer=ply \
 //thickness=0.18 //x=17.63 //y=2.095 //x2=17.825 //y2=2.26
r368 (  94 125 ) resistor r=39.5823 //w=0.21 //l=0.173853 //layer=ply \
 //thickness=0.18 //x=17.63 //y=1.7 //x2=17.67 //y2=1.545
r369 (  94 95 ) resistor r=202.543 //w=0.094 //l=0.395 //layer=ply \
 //thickness=0.18 //x=17.63 //y=1.7 //x2=17.63 //y2=2.095
r370 (  93 125 ) resistor r=39.5823 //w=0.21 //l=0.173853 //layer=ply \
 //thickness=0.18 //x=17.63 //y=1.39 //x2=17.67 //y2=1.545
r371 (  92 124 ) resistor r=45.1352 //w=0.168 //l=0.173853 //layer=ply \
 //thickness=0.18 //x=17.63 //y=1.045 //x2=17.67 //y2=0.89
r372 (  92 93 ) resistor r=176.904 //w=0.094 //l=0.345 //layer=ply \
 //thickness=0.18 //x=17.63 //y=1.045 //x2=17.63 //y2=1.39
r373 (  91 121 ) resistor r=45.1352 //w=0.168 //l=0.173853 //layer=ply \
 //thickness=0.18 //x=2.85 //y=1.43 //x2=2.81 //y2=1.585
r374 (  90 120 ) resistor r=45.1352 //w=0.168 //l=0.173853 //layer=ply \
 //thickness=0.18 //x=2.85 //y=1.085 //x2=2.81 //y2=0.93
r375 (  90 91 ) resistor r=176.904 //w=0.094 //l=0.345 //layer=ply \
 //thickness=0.18 //x=2.85 //y=1.085 //x2=2.85 //y2=1.43
r376 (  85 119 ) resistor r=10.701 //w=0.21 //l=0.115 //layer=ply \
 //thickness=0.18 //x=2.475 //y=1.585 //x2=2.36 //y2=1.585
r377 (  84 121 ) resistor r=5.52526 //w=0.168 //l=0.115 //layer=ply \
 //thickness=0.18 //x=2.695 //y=1.585 //x2=2.81 //y2=1.585
r378 (  83 118 ) resistor r=5.52526 //w=0.168 //l=0.115 //layer=ply \
 //thickness=0.18 //x=2.475 //y=0.93 //x2=2.36 //y2=0.93
r379 (  82 120 ) resistor r=5.52526 //w=0.168 //l=0.115 //layer=ply \
 //thickness=0.18 //x=2.695 //y=0.93 //x2=2.81 //y2=0.93
r380 (  82 83 ) resistor r=112.809 //w=0.094 //l=0.22 //layer=ply \
 //thickness=0.18 //x=2.695 //y=0.93 //x2=2.475 //y2=0.93
r381 (  81 116 ) resistor r=16.5046 //w=0.27 //l=0.135 //layer=ply \
 //thickness=0.18 //x=2.45 //y=4.97 //x2=2.315 //y2=4.97
r382 (  80 87 ) resistor r=26.9307 //w=0.15 //l=0.106066 //layer=ply \
 //thickness=0.18 //x=2.69 //y=4.97 //x2=2.765 //y2=5.045
r383 (  80 81 ) resistor r=123.064 //w=0.094 //l=0.24 //layer=ply \
 //thickness=0.18 //x=2.69 //y=4.97 //x2=2.45 //y2=4.97
r384 (  75 119 ) resistor r=39.5823 //w=0.21 //l=0.173853 //layer=ply \
 //thickness=0.18 //x=2.32 //y=1.74 //x2=2.36 //y2=1.585
r385 (  75 111 ) resistor r=182.032 //w=0.094 //l=0.355 //layer=ply \
 //thickness=0.18 //x=2.32 //y=1.74 //x2=2.32 //y2=2.095
r386 (  74 119 ) resistor r=39.5823 //w=0.21 //l=0.173853 //layer=ply \
 //thickness=0.18 //x=2.32 //y=1.43 //x2=2.36 //y2=1.585
r387 (  73 118 ) resistor r=45.1352 //w=0.168 //l=0.173853 //layer=ply \
 //thickness=0.18 //x=2.32 //y=1.085 //x2=2.36 //y2=0.93
r388 (  73 74 ) resistor r=176.904 //w=0.094 //l=0.345 //layer=ply \
 //thickness=0.18 //x=2.32 //y=1.085 //x2=2.32 //y2=1.43
r389 (  72 106 ) resistor r=592.245 //w=0.094 //l=1.155 //layer=ply \
 //thickness=0.18 //x=18.165 //y=6.2 //x2=18.165 //y2=5.045
r390 (  71 96 ) resistor r=592.245 //w=0.094 //l=1.155 //layer=ply \
 //thickness=0.18 //x=17.725 //y=6.2 //x2=17.725 //y2=5.045
r391 (  70 87 ) resistor r=592.245 //w=0.094 //l=1.155 //layer=ply \
 //thickness=0.18 //x=2.765 //y=6.2 //x2=2.765 //y2=5.045
r392 (  69 117 ) resistor r=592.245 //w=0.094 //l=1.155 //layer=ply \
 //thickness=0.18 //x=2.325 //y=6.2 //x2=2.325 //y2=5.045
r393 (  68 101 ) resistor r=56.4043 //w=0.094 //l=0.11 //layer=ply \
 //thickness=0.18 //x=17.895 //y=1.545 //x2=18.005 //y2=1.545
r394 (  68 102 ) resistor r=56.4043 //w=0.094 //l=0.11 //layer=ply \
 //thickness=0.18 //x=17.895 //y=1.545 //x2=17.785 //y2=1.545
r395 (  67 84 ) resistor r=56.4043 //w=0.094 //l=0.11 //layer=ply \
 //thickness=0.18 //x=2.585 //y=1.585 //x2=2.695 //y2=1.585
r396 (  67 85 ) resistor r=56.4043 //w=0.094 //l=0.11 //layer=ply \
 //thickness=0.18 //x=2.585 //y=1.585 //x2=2.475 //y2=1.585
r397 (  64 66 ) resistor r=11 //w=0.192 //l=0.165 //layer=li //thickness=0.1 \
 //x=7.832 //y=4.25 //x2=7.832 //y2=4.415
r398 (  64 65 ) resistor r=11 //w=0.192 //l=0.165 //layer=li //thickness=0.1 \
 //x=7.832 //y=4.25 //x2=7.832 //y2=4.085
r399 (  60 114 ) resistor r=152 //w=0.17 //l=0.17 //layer=licon //count=1 \
 //x=2.315 //y=4.88 //x2=2.315 //y2=4.88
r400 (  57 128 ) resistor r=152 //w=0.17 //l=0.17 //layer=licon //count=1 \
 //x=17.825 //y=4.88 //x2=17.825 //y2=4.88
r401 (  55 57 ) resistor r=43.123 //w=0.187 //l=0.63 //layer=li \
 //thickness=0.1 //x=17.825 //y=4.25 //x2=17.825 //y2=4.88
r402 (  52 123 ) resistor r=152 //w=0.17 //l=0.17 //layer=licon //count=1 \
 //x=17.825 //y=2.26 //x2=17.825 //y2=2.26
r403 (  52 55 ) resistor r=136.214 //w=0.187 //l=1.99 //layer=li \
 //thickness=0.1 //x=17.825 //y=2.26 //x2=17.825 //y2=4.25
r404 (  50 66 ) resistor r=57.1551 //w=0.187 //l=0.835 //layer=li \
 //thickness=0.1 //x=7.835 //y=5.25 //x2=7.835 //y2=4.415
r405 (  47 65 ) resistor r=147.508 //w=0.187 //l=2.155 //layer=li \
 //thickness=0.1 //x=7.835 //y=1.93 //x2=7.835 //y2=4.085
r406 (  45 47 ) resistor r=7.15173 //w=0.17 //l=0.120208 //layer=li \
 //thickness=0.1 //x=7.75 //y=1.845 //x2=7.835 //y2=1.93
r407 (  45 46 ) resistor r=21.5615 //w=0.187 //l=0.315 //layer=li \
 //thickness=0.1 //x=7.75 //y=1.845 //x2=7.435 //y2=1.845
r408 (  41 46 ) resistor r=7.15173 //w=0.17 //l=0.120208 //layer=li \
 //thickness=0.1 //x=7.35 //y=1.76 //x2=7.435 //y2=1.845
r409 (  41 131 ) resistor r=39.016 //w=0.187 //l=0.57 //layer=li \
 //thickness=0.1 //x=7.35 //y=1.76 //x2=7.35 //y2=1.19
r410 (  40 62 ) resistor r=5.4201 //w=0.17 //l=0.085 //layer=li \
 //thickness=0.1 //x=7.14 //y=5.335 //x2=7.055 //y2=5.335
r411 (  39 50 ) resistor r=7.15173 //w=0.17 //l=0.120208 //layer=li \
 //thickness=0.1 //x=7.75 //y=5.335 //x2=7.835 //y2=5.25
r412 (  39 40 ) resistor r=41.754 //w=0.187 //l=0.61 //layer=li \
 //thickness=0.1 //x=7.75 //y=5.335 //x2=7.14 //y2=5.335
r413 (  33 62 ) resistor r=1.40859 //w=0.34 //l=0.085 //layer=li \
 //thickness=0.1 //x=7.055 //y=5.42 //x2=7.055 //y2=5.335
r414 (  33 135 ) resistor r=33.1979 //w=0.187 //l=0.485 //layer=li \
 //thickness=0.1 //x=7.055 //y=5.42 //x2=7.055 //y2=5.905
r415 (  32 61 ) resistor r=5.4201 //w=0.17 //l=0.085 //layer=li \
 //thickness=0.1 //x=6.26 //y=5.335 //x2=6.175 //y2=5.335
r416 (  31 62 ) resistor r=5.4201 //w=0.17 //l=0.085 //layer=li \
 //thickness=0.1 //x=6.97 //y=5.335 //x2=7.055 //y2=5.335
r417 (  31 32 ) resistor r=48.5989 //w=0.187 //l=0.71 //layer=li \
 //thickness=0.1 //x=6.97 //y=5.335 //x2=6.26 //y2=5.335
r418 (  25 61 ) resistor r=1.40859 //w=0.34 //l=0.085 //layer=li \
 //thickness=0.1 //x=6.175 //y=5.42 //x2=6.175 //y2=5.335
r419 (  25 134 ) resistor r=33.1979 //w=0.187 //l=0.485 //layer=li \
 //thickness=0.1 //x=6.175 //y=5.42 //x2=6.175 //y2=5.905
r420 (  23 61 ) resistor r=5.4201 //w=0.17 //l=0.085 //layer=li \
 //thickness=0.1 //x=6.09 //y=5.335 //x2=6.175 //y2=5.335
r421 (  23 24 ) resistor r=48.5989 //w=0.187 //l=0.71 //layer=li \
 //thickness=0.1 //x=6.09 //y=5.335 //x2=5.38 //y2=5.335
r422 (  17 24 ) resistor r=7.15173 //w=0.17 //l=0.120208 //layer=li \
 //thickness=0.1 //x=5.295 //y=5.42 //x2=5.38 //y2=5.335
r423 (  17 133 ) resistor r=33.1979 //w=0.187 //l=0.485 //layer=li \
 //thickness=0.1 //x=5.295 //y=5.42 //x2=5.295 //y2=5.905
r424 (  13 110 ) resistor r=152 //w=0.17 //l=0.17 //layer=licon //count=1 \
 //x=2.285 //y=2.26 //x2=2.285 //y2=2.26
r425 (  13 16 ) resistor r=136.214 //w=0.187 //l=1.99 //layer=li \
 //thickness=0.1 //x=2.285 //y=2.26 //x2=2.285 //y2=4.25
r426 (  11 60 ) resistor r=11.4737 //w=0.186 //l=0.172337 //layer=li \
 //thickness=0.1 //x=2.285 //y=4.715 //x2=2.3 //y2=4.88
r427 (  11 16 ) resistor r=31.8289 //w=0.187 //l=0.465 //layer=li \
 //thickness=0.1 //x=2.285 //y=4.715 //x2=2.285 //y2=4.25
r428 (  10 55 ) resistor r=9.3 //w=0.17 //l=0.17 //layer=mcon //count=1 \
 //x=17.825 //y=4.25 //x2=17.825 //y2=4.25
r429 (  8 64 ) resistor r=9.3 //w=0.17 //l=0.17 //layer=mcon //count=1 \
 //x=7.83 //y=4.25 //x2=7.83 //y2=4.25
r430 (  6 16 ) resistor r=9.3 //w=0.17 //l=0.17 //layer=mcon //count=1 \
 //x=2.285 //y=4.25 //x2=2.285 //y2=4.25
r431 (  4 8 ) resistor r=0.0880901 //w=0.191 //l=0.115 //layer=m1 \
 //thickness=0.36 //x=7.945 //y=4.25 //x2=7.83 //y2=4.25
r432 (  3 10 ) resistor r=0.0717383 //w=0.224 //l=0.115 //layer=m1 \
 //thickness=0.36 //x=17.71 //y=4.25 //x2=17.825 //y2=4.25
r433 (  3 4 ) resistor r=9.31775 //w=0.131 //l=9.765 //layer=m1 \
 //thickness=0.36 //x=17.71 //y=4.25 //x2=7.945 //y2=4.25
r434 (  2 6 ) resistor r=0.0717383 //w=0.224 //l=0.115 //layer=m1 \
 //thickness=0.36 //x=2.4 //y=4.25 //x2=2.285 //y2=4.25
r435 (  1 8 ) resistor r=0.0880901 //w=0.191 //l=0.115 //layer=m1 \
 //thickness=0.36 //x=7.715 //y=4.25 //x2=7.83 //y2=4.25
r436 (  1 2 ) resistor r=5.07156 //w=0.131 //l=5.315 //layer=m1 \
 //thickness=0.36 //x=7.715 //y=4.25 //x2=2.4 //y2=4.25
ends PM_DFFSNQNX1\%noxref_6

subckt PM_DFFSNQNX1\%noxref_7 ( 3 5 8 11 12 13 14 15 16 21 23 25 31 32 34 35 \
 38 )
c82 ( 38 0 ) capacitor c=0.0332623f //x=18.595 //y=4.88
c83 ( 35 0 ) capacitor c=0.0279499f //x=18.565 //y=2.095
c84 ( 34 0 ) capacitor c=0.0422904f //x=18.565 //y=2.26
c85 ( 32 0 ) capacitor c=0.0429696f //x=19.13 //y=1.43
c86 ( 31 0 ) capacitor c=0.0192208f //x=19.13 //y=1.085
c87 ( 25 0 ) capacitor c=0.0148884f //x=18.975 //y=1.585
c88 ( 23 0 ) capacitor c=0.0157803f //x=18.975 //y=0.93
c89 ( 21 0 ) capacitor c=0.0306375f //x=18.97 //y=4.97
c90 ( 16 0 ) capacitor c=0.0205163f //x=18.6 //y=1.74
c91 ( 15 0 ) capacitor c=0.0168481f //x=18.6 //y=1.43
c92 ( 14 0 ) capacitor c=0.0174783f //x=18.6 //y=1.085
c93 ( 13 0 ) capacitor c=0.15358f //x=19.045 //y=6.2
c94 ( 12 0 ) capacitor c=0.110281f //x=18.605 //y=6.2
c95 ( 8 0 ) capacitor c=0.0167922f //x=18.565 //y=3.51
c96 ( 5 0 ) capacitor c=0.0737809f //x=18.565 //y=2.26
c97 ( 3 0 ) capacitor c=0.00453889f //x=18.565 //y=4.715
r98 (  40 41 ) resistor r=32.4568 //w=0.214 //l=0.075 //layer=ply \
 //thickness=0.18 //x=18.595 //y=4.97 //x2=18.595 //y2=5.045
r99 (  38 40 ) resistor r=20.271 //w=0.214 //l=0.09 //layer=ply \
 //thickness=0.18 //x=18.595 //y=4.88 //x2=18.595 //y2=4.97
r100 (  34 35 ) resistor r=52.7279 //w=0.214 //l=0.165 //layer=ply \
 //thickness=0.18 //x=18.565 //y=2.26 //x2=18.565 //y2=2.095
r101 (  32 45 ) resistor r=45.1352 //w=0.168 //l=0.173853 //layer=ply \
 //thickness=0.18 //x=19.13 //y=1.43 //x2=19.09 //y2=1.585
r102 (  31 44 ) resistor r=45.1352 //w=0.168 //l=0.173853 //layer=ply \
 //thickness=0.18 //x=19.13 //y=1.085 //x2=19.09 //y2=0.93
r103 (  31 32 ) resistor r=176.904 //w=0.094 //l=0.345 //layer=ply \
 //thickness=0.18 //x=19.13 //y=1.085 //x2=19.13 //y2=1.43
r104 (  26 43 ) resistor r=10.701 //w=0.21 //l=0.115 //layer=ply \
 //thickness=0.18 //x=18.755 //y=1.585 //x2=18.64 //y2=1.585
r105 (  25 45 ) resistor r=5.52526 //w=0.168 //l=0.115 //layer=ply \
 //thickness=0.18 //x=18.975 //y=1.585 //x2=19.09 //y2=1.585
r106 (  24 42 ) resistor r=5.52526 //w=0.168 //l=0.115 //layer=ply \
 //thickness=0.18 //x=18.755 //y=0.93 //x2=18.64 //y2=0.93
r107 (  23 44 ) resistor r=5.52526 //w=0.168 //l=0.115 //layer=ply \
 //thickness=0.18 //x=18.975 //y=0.93 //x2=19.09 //y2=0.93
r108 (  23 24 ) resistor r=112.809 //w=0.094 //l=0.22 //layer=ply \
 //thickness=0.18 //x=18.975 //y=0.93 //x2=18.755 //y2=0.93
r109 (  22 40 ) resistor r=16.5046 //w=0.27 //l=0.135 //layer=ply \
 //thickness=0.18 //x=18.73 //y=4.97 //x2=18.595 //y2=4.97
r110 (  21 28 ) resistor r=26.9307 //w=0.15 //l=0.106066 //layer=ply \
 //thickness=0.18 //x=18.97 //y=4.97 //x2=19.045 //y2=5.045
r111 (  21 22 ) resistor r=123.064 //w=0.094 //l=0.24 //layer=ply \
 //thickness=0.18 //x=18.97 //y=4.97 //x2=18.73 //y2=4.97
r112 (  16 43 ) resistor r=39.5823 //w=0.21 //l=0.173853 //layer=ply \
 //thickness=0.18 //x=18.6 //y=1.74 //x2=18.64 //y2=1.585
r113 (  16 35 ) resistor r=182.032 //w=0.094 //l=0.355 //layer=ply \
 //thickness=0.18 //x=18.6 //y=1.74 //x2=18.6 //y2=2.095
r114 (  15 43 ) resistor r=39.5823 //w=0.21 //l=0.173853 //layer=ply \
 //thickness=0.18 //x=18.6 //y=1.43 //x2=18.64 //y2=1.585
r115 (  14 42 ) resistor r=45.1352 //w=0.168 //l=0.173853 //layer=ply \
 //thickness=0.18 //x=18.6 //y=1.085 //x2=18.64 //y2=0.93
r116 (  14 15 ) resistor r=176.904 //w=0.094 //l=0.345 //layer=ply \
 //thickness=0.18 //x=18.6 //y=1.085 //x2=18.6 //y2=1.43
r117 (  13 28 ) resistor r=592.245 //w=0.094 //l=1.155 //layer=ply \
 //thickness=0.18 //x=19.045 //y=6.2 //x2=19.045 //y2=5.045
r118 (  12 41 ) resistor r=592.245 //w=0.094 //l=1.155 //layer=ply \
 //thickness=0.18 //x=18.605 //y=6.2 //x2=18.605 //y2=5.045
r119 (  11 25 ) resistor r=56.4043 //w=0.094 //l=0.11 //layer=ply \
 //thickness=0.18 //x=18.865 //y=1.585 //x2=18.975 //y2=1.585
r120 (  11 26 ) resistor r=56.4043 //w=0.094 //l=0.11 //layer=ply \
 //thickness=0.18 //x=18.865 //y=1.585 //x2=18.755 //y2=1.585
r121 (  10 38 ) resistor r=152 //w=0.17 //l=0.17 //layer=licon //count=1 \
 //x=18.595 //y=4.88 //x2=18.595 //y2=4.88
r122 (  5 34 ) resistor r=152 //w=0.17 //l=0.17 //layer=licon //count=1 \
 //x=18.565 //y=2.26 //x2=18.565 //y2=2.26
r123 (  5 8 ) resistor r=85.5615 //w=0.187 //l=1.25 //layer=li //thickness=0.1 \
 //x=18.565 //y=2.26 //x2=18.565 //y2=3.51
r124 (  3 10 ) resistor r=11.4737 //w=0.186 //l=0.172337 //layer=li \
 //thickness=0.1 //x=18.565 //y=4.715 //x2=18.58 //y2=4.88
r125 (  3 8 ) resistor r=82.4813 //w=0.187 //l=1.205 //layer=li \
 //thickness=0.1 //x=18.565 //y=4.715 //x2=18.565 //y2=3.51
ends PM_DFFSNQNX1\%noxref_7

subckt PM_DFFSNQNX1\%QN ( 7 8 9 10 11 12 13 14 15 22 23 34 36 37 49 52 62 64 \
 66 70 73 76 79 86 89 92 94 95 96 97 98 99 100 101 103 109 110 111 112 124 126 \
 127 )
c173 ( 127 0 ) capacitor c=0.0220291f //x=18.68 //y=5.2
c174 ( 126 0 ) capacitor c=0.0217503f //x=17.8 //y=5.2
c175 ( 124 0 ) capacitor c=0.0084702f //x=18.675 //y=1.085
c176 ( 112 0 ) capacitor c=0.0558903f //x=21.43 //y=4.97
c177 ( 111 0 ) capacitor c=0.0305765f //x=21.72 //y=4.97
c178 ( 110 0 ) capacitor c=0.0347816f //x=21.385 //y=1.4
c179 ( 109 0 ) capacitor c=0.0187487f //x=21.385 //y=1.055
c180 ( 103 0 ) capacitor c=0.0137055f //x=21.23 //y=1.555
c181 ( 101 0 ) capacitor c=0.0149861f //x=21.23 //y=0.9
c182 ( 100 0 ) capacitor c=0.096037f //x=20.855 //y=2.095
c183 ( 99 0 ) capacitor c=0.0228993f //x=20.855 //y=1.71
c184 ( 98 0 ) capacitor c=0.0234352f //x=20.855 //y=1.4
c185 ( 97 0 ) capacitor c=0.0198724f //x=20.855 //y=1.055
c186 ( 96 0 ) capacitor c=0.110114f //x=21.795 //y=6.2
c187 ( 95 0 ) capacitor c=0.158956f //x=21.355 //y=6.2
c188 ( 92 0 ) capacitor c=0.0084898f //x=21.182 //y=4.535
c189 ( 89 0 ) capacitor c=0.0388046f //x=21.182 //y=4.165
c190 ( 86 0 ) capacitor c=0.00909136f //x=21.182 //y=3.055
c191 ( 79 0 ) capacitor c=0.00494433f //x=19.332 //y=4.905
c192 ( 76 0 ) capacitor c=0.00662546f //x=19.332 //y=4.535
c193 ( 73 0 ) capacitor c=0.0353986f //x=19.332 //y=4.165
c194 ( 70 0 ) capacitor c=0.00806081f //x=19.332 //y=3.055
c195 ( 66 0 ) capacitor c=0.0207113f //x=19.332 //y=2.685
c196 ( 64 0 ) capacitor c=0.0024826f //x=18.825 //y=5.38
c197 ( 62 0 ) capacitor c=0.00621636f //x=21.155 //y=4.88
c198 ( 52 0 ) capacitor c=0.012099f //x=21.155 //y=2.26
c199 ( 49 0 ) capacitor c=0.005033f //x=19.305 //y=5.295
c200 ( 37 0 ) capacitor c=0.00404073f //x=18.95 //y=1.835
c201 ( 36 0 ) capacitor c=0.0122201f //x=19.22 //y=1.835
c202 ( 34 0 ) capacitor c=0.0143719f //x=19.22 //y=5.38
c203 ( 23 0 ) capacitor c=0.00272496f //x=18.03 //y=5.38
c204 ( 22 0 ) capacitor c=0.0155386f //x=18.74 //y=5.38
c205 ( 15 0 ) capacitor c=0.00713941f //x=21.21 //y=4.62
c206 ( 14 0 ) capacitor c=0.00943872f //x=21.21 //y=4.25
c207 ( 13 0 ) capacitor c=0.0398997f //x=21.21 //y=3.14
c208 ( 12 0 ) capacitor c=0.00817166f //x=21.21 //y=2.77
c209 ( 11 0 ) capacitor c=0.00610872f //x=19.36 //y=4.99
c210 ( 10 0 ) capacitor c=0.00667177f //x=19.36 //y=4.62
c211 ( 9 0 ) capacitor c=0.00833817f //x=19.36 //y=4.25
c212 ( 8 0 ) capacitor c=0.0206264f //x=19.36 //y=3.14
c213 ( 7 0 ) capacitor c=0.00721802f //x=19.36 //y=2.77
r214 (  111 113 ) resistor r=26.9307 //w=0.15 //l=0.106066 //layer=ply \
 //thickness=0.18 //x=21.72 //y=4.97 //x2=21.795 //y2=5.045
r215 (  111 112 ) resistor r=148.702 //w=0.094 //l=0.29 //layer=ply \
 //thickness=0.18 //x=21.72 //y=4.97 //x2=21.43 //y2=4.97
r216 (  110 123 ) resistor r=45.1352 //w=0.168 //l=0.173853 //layer=ply \
 //thickness=0.18 //x=21.385 //y=1.4 //x2=21.345 //y2=1.555
r217 (  109 122 ) resistor r=45.1352 //w=0.168 //l=0.173853 //layer=ply \
 //thickness=0.18 //x=21.385 //y=1.055 //x2=21.345 //y2=0.9
r218 (  109 110 ) resistor r=176.904 //w=0.094 //l=0.345 //layer=ply \
 //thickness=0.18 //x=21.385 //y=1.055 //x2=21.385 //y2=1.4
r219 (  106 112 ) resistor r=22.7971 //w=0.269 //l=0.106066 //layer=ply \
 //thickness=0.18 //x=21.355 //y=5.045 //x2=21.43 //y2=4.97
r220 (  106 121 ) resistor r=35.8364 //w=0.269 //l=0.270185 //layer=ply \
 //thickness=0.18 //x=21.355 //y=5.045 //x2=21.155 //y2=4.88
r221 (  104 117 ) resistor r=10.701 //w=0.21 //l=0.115 //layer=ply \
 //thickness=0.18 //x=21.01 //y=1.555 //x2=20.895 //y2=1.555
r222 (  103 123 ) resistor r=5.52526 //w=0.168 //l=0.115 //layer=ply \
 //thickness=0.18 //x=21.23 //y=1.555 //x2=21.345 //y2=1.555
r223 (  102 116 ) resistor r=5.52526 //w=0.168 //l=0.115 //layer=ply \
 //thickness=0.18 //x=21.01 //y=0.9 //x2=20.895 //y2=0.9
r224 (  101 122 ) resistor r=5.52526 //w=0.168 //l=0.115 //layer=ply \
 //thickness=0.18 //x=21.23 //y=0.9 //x2=21.345 //y2=0.9
r225 (  101 102 ) resistor r=112.809 //w=0.094 //l=0.22 //layer=ply \
 //thickness=0.18 //x=21.23 //y=0.9 //x2=21.01 //y2=0.9
r226 (  100 119 ) resistor r=58.7805 //w=0.246 //l=0.373497 //layer=ply \
 //thickness=0.18 //x=20.855 //y=2.095 //x2=21.155 //y2=2.26
r227 (  99 117 ) resistor r=39.5823 //w=0.21 //l=0.173853 //layer=ply \
 //thickness=0.18 //x=20.855 //y=1.71 //x2=20.895 //y2=1.555
r228 (  99 100 ) resistor r=197.415 //w=0.094 //l=0.385 //layer=ply \
 //thickness=0.18 //x=20.855 //y=1.71 //x2=20.855 //y2=2.095
r229 (  98 117 ) resistor r=39.5823 //w=0.21 //l=0.173853 //layer=ply \
 //thickness=0.18 //x=20.855 //y=1.4 //x2=20.895 //y2=1.555
r230 (  97 116 ) resistor r=45.1352 //w=0.168 //l=0.173853 //layer=ply \
 //thickness=0.18 //x=20.855 //y=1.055 //x2=20.895 //y2=0.9
r231 (  97 98 ) resistor r=176.904 //w=0.094 //l=0.345 //layer=ply \
 //thickness=0.18 //x=20.855 //y=1.055 //x2=20.855 //y2=1.4
r232 (  96 113 ) resistor r=592.245 //w=0.094 //l=1.155 //layer=ply \
 //thickness=0.18 //x=21.795 //y=6.2 //x2=21.795 //y2=5.045
r233 (  95 106 ) resistor r=592.245 //w=0.094 //l=1.155 //layer=ply \
 //thickness=0.18 //x=21.355 //y=6.2 //x2=21.355 //y2=5.045
r234 (  94 103 ) resistor r=56.4043 //w=0.094 //l=0.11 //layer=ply \
 //thickness=0.18 //x=21.12 //y=1.555 //x2=21.23 //y2=1.555
r235 (  94 104 ) resistor r=56.4043 //w=0.094 //l=0.11 //layer=ply \
 //thickness=0.18 //x=21.12 //y=1.555 //x2=21.01 //y2=1.555
r236 (  90 92 ) resistor r=13.6898 //w=0.187 //l=0.2 //layer=li \
 //thickness=0.1 //x=21.155 //y=4.335 //x2=21.155 //y2=4.535
r237 (  87 89 ) resistor r=64.3422 //w=0.187 //l=0.94 //layer=li \
 //thickness=0.1 //x=21.155 //y=3.225 //x2=21.155 //y2=4.165
r238 (  83 86 ) resistor r=13.6898 //w=0.187 //l=0.2 //layer=li \
 //thickness=0.1 //x=21.155 //y=2.855 //x2=21.155 //y2=3.055
r239 (  77 79 ) resistor r=13.6898 //w=0.187 //l=0.2 //layer=li \
 //thickness=0.1 //x=19.305 //y=4.705 //x2=19.305 //y2=4.905
r240 (  74 76 ) resistor r=13.6898 //w=0.187 //l=0.2 //layer=li \
 //thickness=0.1 //x=19.305 //y=4.335 //x2=19.305 //y2=4.535
r241 (  71 73 ) resistor r=64.3422 //w=0.187 //l=0.94 //layer=li \
 //thickness=0.1 //x=19.305 //y=3.225 //x2=19.305 //y2=4.165
r242 (  67 70 ) resistor r=13.6898 //w=0.187 //l=0.2 //layer=li \
 //thickness=0.1 //x=19.305 //y=2.855 //x2=19.305 //y2=3.055
r243 (  62 121 ) resistor r=152 //w=0.17 //l=0.17 //layer=licon //count=1 \
 //x=21.155 //y=4.88 //x2=21.155 //y2=4.88
r244 (  62 93 ) resistor r=11.9786 //w=0.187 //l=0.175 //layer=li \
 //thickness=0.1 //x=21.155 //y=4.88 //x2=21.155 //y2=4.705
r245 (  52 119 ) resistor r=152 //w=0.17 //l=0.17 //layer=licon //count=1 \
 //x=21.155 //y=2.26 //x2=21.155 //y2=2.26
r246 (  52 82 ) resistor r=29.0909 //w=0.187 //l=0.425 //layer=li \
 //thickness=0.1 //x=21.155 //y=2.26 //x2=21.155 //y2=2.685
r247 (  49 80 ) resistor r=15.0588 //w=0.187 //l=0.22 //layer=li \
 //thickness=0.1 //x=19.305 //y=5.295 //x2=19.305 //y2=5.075
r248 (  38 66 ) resistor r=52.3636 //w=0.187 //l=0.765 //layer=li \
 //thickness=0.1 //x=19.305 //y=1.92 //x2=19.305 //y2=2.685
r249 (  36 38 ) resistor r=7.15173 //w=0.17 //l=0.120208 //layer=li \
 //thickness=0.1 //x=19.22 //y=1.835 //x2=19.305 //y2=1.92
r250 (  36 37 ) resistor r=18.4813 //w=0.187 //l=0.27 //layer=li \
 //thickness=0.1 //x=19.22 //y=1.835 //x2=18.95 //y2=1.835
r251 (  35 64 ) resistor r=5.4201 //w=0.17 //l=0.085 //layer=li \
 //thickness=0.1 //x=18.91 //y=5.38 //x2=18.825 //y2=5.38
r252 (  34 49 ) resistor r=7.15173 //w=0.17 //l=0.120208 //layer=li \
 //thickness=0.1 //x=19.22 //y=5.38 //x2=19.305 //y2=5.295
r253 (  34 35 ) resistor r=21.2193 //w=0.187 //l=0.31 //layer=li \
 //thickness=0.1 //x=19.22 //y=5.38 //x2=18.91 //y2=5.38
r254 (  30 37 ) resistor r=7.15173 //w=0.17 //l=0.120208 //layer=li \
 //thickness=0.1 //x=18.865 //y=1.75 //x2=18.95 //y2=1.835
r255 (  30 124 ) resistor r=39.016 //w=0.187 //l=0.57 //layer=li \
 //thickness=0.1 //x=18.865 //y=1.75 //x2=18.865 //y2=1.18
r256 (  24 64 ) resistor r=1.40859 //w=0.34 //l=0.085 //layer=li \
 //thickness=0.1 //x=18.825 //y=5.465 //x2=18.825 //y2=5.38
r257 (  24 127 ) resistor r=30.1176 //w=0.187 //l=0.44 //layer=li \
 //thickness=0.1 //x=18.825 //y=5.465 //x2=18.825 //y2=5.905
r258 (  22 64 ) resistor r=5.4201 //w=0.17 //l=0.085 //layer=li \
 //thickness=0.1 //x=18.74 //y=5.38 //x2=18.825 //y2=5.38
r259 (  22 23 ) resistor r=48.5989 //w=0.187 //l=0.71 //layer=li \
 //thickness=0.1 //x=18.74 //y=5.38 //x2=18.03 //y2=5.38
r260 (  16 23 ) resistor r=7.15173 //w=0.17 //l=0.120208 //layer=li \
 //thickness=0.1 //x=17.945 //y=5.465 //x2=18.03 //y2=5.38
r261 (  16 126 ) resistor r=30.1176 //w=0.187 //l=0.44 //layer=li \
 //thickness=0.1 //x=17.945 //y=5.465 //x2=17.945 //y2=5.905
r262 (  15 93 ) resistor r=5.1957 //w=0.242 //l=0.085 //layer=li \
 //thickness=0.1 //x=21.182 //y=4.62 //x2=21.182 //y2=4.705
r263 (  15 92 ) resistor r=5.1957 //w=0.242 //l=0.085 //layer=li \
 //thickness=0.1 //x=21.182 //y=4.62 //x2=21.182 //y2=4.535
r264 (  14 90 ) resistor r=5.1957 //w=0.242 //l=0.085 //layer=li \
 //thickness=0.1 //x=21.182 //y=4.25 //x2=21.182 //y2=4.335
r265 (  14 89 ) resistor r=5.1957 //w=0.242 //l=0.085 //layer=li \
 //thickness=0.1 //x=21.182 //y=4.25 //x2=21.182 //y2=4.165
r266 (  13 87 ) resistor r=5.1957 //w=0.242 //l=0.085 //layer=li \
 //thickness=0.1 //x=21.182 //y=3.14 //x2=21.182 //y2=3.225
r267 (  13 86 ) resistor r=5.1957 //w=0.242 //l=0.085 //layer=li \
 //thickness=0.1 //x=21.182 //y=3.14 //x2=21.182 //y2=3.055
r268 (  12 83 ) resistor r=5.1957 //w=0.242 //l=0.085 //layer=li \
 //thickness=0.1 //x=21.182 //y=2.77 //x2=21.182 //y2=2.855
r269 (  12 82 ) resistor r=5.1957 //w=0.242 //l=0.085 //layer=li \
 //thickness=0.1 //x=21.182 //y=2.77 //x2=21.182 //y2=2.685
r270 (  11 80 ) resistor r=5.1957 //w=0.242 //l=0.085 //layer=li \
 //thickness=0.1 //x=19.332 //y=4.99 //x2=19.332 //y2=5.075
r271 (  11 79 ) resistor r=5.1957 //w=0.242 //l=0.085 //layer=li \
 //thickness=0.1 //x=19.332 //y=4.99 //x2=19.332 //y2=4.905
r272 (  10 77 ) resistor r=5.1957 //w=0.242 //l=0.085 //layer=li \
 //thickness=0.1 //x=19.332 //y=4.62 //x2=19.332 //y2=4.705
r273 (  10 76 ) resistor r=5.1957 //w=0.242 //l=0.085 //layer=li \
 //thickness=0.1 //x=19.332 //y=4.62 //x2=19.332 //y2=4.535
r274 (  9 74 ) resistor r=5.1957 //w=0.242 //l=0.085 //layer=li \
 //thickness=0.1 //x=19.332 //y=4.25 //x2=19.332 //y2=4.335
r275 (  9 73 ) resistor r=5.1957 //w=0.242 //l=0.085 //layer=li \
 //thickness=0.1 //x=19.332 //y=4.25 //x2=19.332 //y2=4.165
r276 (  8 71 ) resistor r=5.1957 //w=0.242 //l=0.085 //layer=li \
 //thickness=0.1 //x=19.332 //y=3.14 //x2=19.332 //y2=3.225
r277 (  8 70 ) resistor r=5.1957 //w=0.242 //l=0.085 //layer=li \
 //thickness=0.1 //x=19.332 //y=3.14 //x2=19.332 //y2=3.055
r278 (  7 67 ) resistor r=5.1957 //w=0.242 //l=0.085 //layer=li \
 //thickness=0.1 //x=19.332 //y=2.77 //x2=19.332 //y2=2.855
r279 (  7 66 ) resistor r=5.1957 //w=0.242 //l=0.085 //layer=li \
 //thickness=0.1 //x=19.332 //y=2.77 //x2=19.332 //y2=2.685
ends PM_DFFSNQNX1\%QN

subckt PM_DFFSNQNX1\%SN ( 1 2 7 8 9 10 11 12 13 14 15 16 24 26 36 39 42 45 52 \
 55 58 61 67 68 69 70 71 72 73 74 75 77 83 84 85 86 87 92 93 94 96 102 103 104 \
 105 106 114 125 )
c267 ( 125 0 ) capacitor c=0.0334527f //x=22.265 //y=4.88
c268 ( 114 0 ) capacitor c=0.0335551f //x=10.795 //y=4.88
c269 ( 106 0 ) capacitor c=0.0252436f //x=22.6 //y=4.97
c270 ( 105 0 ) capacitor c=0.0826449f //x=22.355 //y=2.095
c271 ( 104 0 ) capacitor c=0.0170266f //x=22.355 //y=1.63
c272 ( 103 0 ) capacitor c=0.018609f //x=22.355 //y=1.4
c273 ( 102 0 ) capacitor c=0.0187309f //x=22.355 //y=1.09
c274 ( 96 0 ) capacitor c=0.014725f //x=22.2 //y=1.555
c275 ( 94 0 ) capacitor c=0.0146567f //x=22.2 //y=0.935
c276 ( 93 0 ) capacitor c=0.0335408f //x=21.83 //y=1.4
c277 ( 92 0 ) capacitor c=0.0173761f //x=21.83 //y=1.09
c278 ( 87 0 ) capacitor c=0.0245352f //x=11.13 //y=4.97
c279 ( 86 0 ) capacitor c=0.0822684f //x=10.885 //y=2.095
c280 ( 85 0 ) capacitor c=0.0170266f //x=10.885 //y=1.63
c281 ( 84 0 ) capacitor c=0.018609f //x=10.885 //y=1.4
c282 ( 83 0 ) capacitor c=0.0187309f //x=10.885 //y=1.09
c283 ( 77 0 ) capacitor c=0.014725f //x=10.73 //y=1.555
c284 ( 75 0 ) capacitor c=0.0146567f //x=10.73 //y=0.935
c285 ( 74 0 ) capacitor c=0.0335408f //x=10.36 //y=1.4
c286 ( 73 0 ) capacitor c=0.0173761f //x=10.36 //y=1.09
c287 ( 72 0 ) capacitor c=0.110114f //x=22.675 //y=6.2
c288 ( 71 0 ) capacitor c=0.11012f //x=22.235 //y=6.2
c289 ( 70 0 ) capacitor c=0.110114f //x=11.205 //y=6.2
c290 ( 69 0 ) capacitor c=0.11012f //x=10.765 //y=6.2
c291 ( 61 0 ) capacitor c=0.00874422f //x=22.292 //y=4.535
c292 ( 58 0 ) capacitor c=0.0348515f //x=22.292 //y=4.165
c293 ( 55 0 ) capacitor c=0.00853967f //x=22.292 //y=3.055
c294 ( 52 0 ) capacitor c=0.00736593f //x=22.292 //y=2.685
c295 ( 45 0 ) capacitor c=0.00874422f //x=10.822 //y=3.425
c296 ( 42 0 ) capacitor c=0.00859256f //x=10.822 //y=3.055
c297 ( 39 0 ) capacitor c=0.00720846f //x=10.822 //y=2.685
c298 ( 36 0 ) capacitor c=0.00520319f //x=22.265 //y=4.88
c299 ( 26 0 ) capacitor c=0.00607906f //x=22.265 //y=2.485
c300 ( 24 0 ) capacitor c=0.0439505f //x=10.795 //y=4.88
c301 ( 16 0 ) capacitor c=0.00597499f //x=10.795 //y=2.485
c302 ( 15 0 ) capacitor c=0.00691989f //x=22.32 //y=4.62
c303 ( 14 0 ) capacitor c=0.00882245f //x=22.32 //y=4.25
c304 ( 13 0 ) capacitor c=0.00804276f //x=22.32 //y=3.14
c305 ( 12 0 ) capacitor c=0.00823261f //x=22.32 //y=2.77
c306 ( 10 0 ) capacitor c=0.00905774f //x=10.85 //y=3.51
c307 ( 9 0 ) capacitor c=0.00838372f //x=10.85 //y=3.14
c308 ( 8 0 ) capacitor c=0.00734312f //x=10.85 //y=2.77
c309 ( 2 0 ) capacitor c=0.0161412f //x=10.91 //y=2.4
c310 ( 1 0 ) capacitor c=0.290292f //x=22.15 //y=2.4
r311 (  127 128 ) resistor r=32.4568 //w=0.214 //l=0.075 //layer=ply \
 //thickness=0.18 //x=22.265 //y=4.97 //x2=22.265 //y2=5.045
r312 (  125 127 ) resistor r=20.271 //w=0.214 //l=0.09 //layer=ply \
 //thickness=0.18 //x=22.265 //y=4.88 //x2=22.265 //y2=4.97
r313 (  116 117 ) resistor r=32.4568 //w=0.214 //l=0.075 //layer=ply \
 //thickness=0.18 //x=10.795 //y=4.97 //x2=10.795 //y2=5.045
r314 (  114 116 ) resistor r=20.271 //w=0.214 //l=0.09 //layer=ply \
 //thickness=0.18 //x=10.795 //y=4.88 //x2=10.795 //y2=4.97
r315 (  107 127 ) resistor r=16.5046 //w=0.27 //l=0.135 //layer=ply \
 //thickness=0.18 //x=22.4 //y=4.97 //x2=22.265 //y2=4.97
r316 (  106 108 ) resistor r=26.9307 //w=0.15 //l=0.106066 //layer=ply \
 //thickness=0.18 //x=22.6 //y=4.97 //x2=22.675 //y2=5.045
r317 (  106 107 ) resistor r=102.553 //w=0.094 //l=0.2 //layer=ply \
 //thickness=0.18 //x=22.6 //y=4.97 //x2=22.4 //y2=4.97
r318 (  105 132 ) resistor r=38.6777 //w=0.284 //l=0.198997 //layer=ply \
 //thickness=0.18 //x=22.355 //y=2.095 //x2=22.28 //y2=2.26
r319 (  104 130 ) resistor r=21.2976 //w=0.217 //l=0.0928709 //layer=ply \
 //thickness=0.18 //x=22.355 //y=1.63 //x2=22.315 //y2=1.555
r320 (  104 105 ) resistor r=238.436 //w=0.094 //l=0.465 //layer=ply \
 //thickness=0.18 //x=22.355 //y=1.63 //x2=22.355 //y2=2.095
r321 (  103 130 ) resistor r=39.0671 //w=0.217 //l=0.173853 //layer=ply \
 //thickness=0.18 //x=22.355 //y=1.4 //x2=22.315 //y2=1.555
r322 (  102 129 ) resistor r=45.1352 //w=0.168 //l=0.173853 //layer=ply \
 //thickness=0.18 //x=22.355 //y=1.09 //x2=22.315 //y2=0.935
r323 (  102 103 ) resistor r=158.957 //w=0.094 //l=0.31 //layer=ply \
 //thickness=0.18 //x=22.355 //y=1.09 //x2=22.355 //y2=1.4
r324 (  97 123 ) resistor r=5.52526 //w=0.168 //l=0.115 //layer=ply \
 //thickness=0.18 //x=21.985 //y=1.555 //x2=21.87 //y2=1.555
r325 (  96 130 ) resistor r=11.4558 //w=0.217 //l=0.115 //layer=ply \
 //thickness=0.18 //x=22.2 //y=1.555 //x2=22.315 //y2=1.555
r326 (  95 122 ) resistor r=5.52526 //w=0.168 //l=0.115 //layer=ply \
 //thickness=0.18 //x=21.985 //y=0.935 //x2=21.87 //y2=0.935
r327 (  94 129 ) resistor r=5.52526 //w=0.168 //l=0.115 //layer=ply \
 //thickness=0.18 //x=22.2 //y=0.935 //x2=22.315 //y2=0.935
r328 (  94 95 ) resistor r=110.245 //w=0.094 //l=0.215 //layer=ply \
 //thickness=0.18 //x=22.2 //y=0.935 //x2=21.985 //y2=0.935
r329 (  93 123 ) resistor r=45.1352 //w=0.168 //l=0.173853 //layer=ply \
 //thickness=0.18 //x=21.83 //y=1.4 //x2=21.87 //y2=1.555
r330 (  92 122 ) resistor r=45.1352 //w=0.168 //l=0.173853 //layer=ply \
 //thickness=0.18 //x=21.83 //y=1.09 //x2=21.87 //y2=0.935
r331 (  92 93 ) resistor r=158.957 //w=0.094 //l=0.31 //layer=ply \
 //thickness=0.18 //x=21.83 //y=1.09 //x2=21.83 //y2=1.4
r332 (  88 116 ) resistor r=16.5046 //w=0.27 //l=0.135 //layer=ply \
 //thickness=0.18 //x=10.93 //y=4.97 //x2=10.795 //y2=4.97
r333 (  87 89 ) resistor r=26.9307 //w=0.15 //l=0.106066 //layer=ply \
 //thickness=0.18 //x=11.13 //y=4.97 //x2=11.205 //y2=5.045
r334 (  87 88 ) resistor r=102.553 //w=0.094 //l=0.2 //layer=ply \
 //thickness=0.18 //x=11.13 //y=4.97 //x2=10.93 //y2=4.97
r335 (  86 121 ) resistor r=38.6777 //w=0.284 //l=0.198997 //layer=ply \
 //thickness=0.18 //x=10.885 //y=2.095 //x2=10.81 //y2=2.26
r336 (  85 119 ) resistor r=21.2976 //w=0.217 //l=0.0928709 //layer=ply \
 //thickness=0.18 //x=10.885 //y=1.63 //x2=10.845 //y2=1.555
r337 (  85 86 ) resistor r=238.436 //w=0.094 //l=0.465 //layer=ply \
 //thickness=0.18 //x=10.885 //y=1.63 //x2=10.885 //y2=2.095
r338 (  84 119 ) resistor r=39.0671 //w=0.217 //l=0.173853 //layer=ply \
 //thickness=0.18 //x=10.885 //y=1.4 //x2=10.845 //y2=1.555
r339 (  83 118 ) resistor r=45.1352 //w=0.168 //l=0.173853 //layer=ply \
 //thickness=0.18 //x=10.885 //y=1.09 //x2=10.845 //y2=0.935
r340 (  83 84 ) resistor r=158.957 //w=0.094 //l=0.31 //layer=ply \
 //thickness=0.18 //x=10.885 //y=1.09 //x2=10.885 //y2=1.4
r341 (  78 112 ) resistor r=5.52526 //w=0.168 //l=0.115 //layer=ply \
 //thickness=0.18 //x=10.515 //y=1.555 //x2=10.4 //y2=1.555
r342 (  77 119 ) resistor r=11.4558 //w=0.217 //l=0.115 //layer=ply \
 //thickness=0.18 //x=10.73 //y=1.555 //x2=10.845 //y2=1.555
r343 (  76 111 ) resistor r=5.52526 //w=0.168 //l=0.115 //layer=ply \
 //thickness=0.18 //x=10.515 //y=0.935 //x2=10.4 //y2=0.935
r344 (  75 118 ) resistor r=5.52526 //w=0.168 //l=0.115 //layer=ply \
 //thickness=0.18 //x=10.73 //y=0.935 //x2=10.845 //y2=0.935
r345 (  75 76 ) resistor r=110.245 //w=0.094 //l=0.215 //layer=ply \
 //thickness=0.18 //x=10.73 //y=0.935 //x2=10.515 //y2=0.935
r346 (  74 112 ) resistor r=45.1352 //w=0.168 //l=0.173853 //layer=ply \
 //thickness=0.18 //x=10.36 //y=1.4 //x2=10.4 //y2=1.555
r347 (  73 111 ) resistor r=45.1352 //w=0.168 //l=0.173853 //layer=ply \
 //thickness=0.18 //x=10.36 //y=1.09 //x2=10.4 //y2=0.935
r348 (  73 74 ) resistor r=158.957 //w=0.094 //l=0.31 //layer=ply \
 //thickness=0.18 //x=10.36 //y=1.09 //x2=10.36 //y2=1.4
r349 (  72 108 ) resistor r=592.245 //w=0.094 //l=1.155 //layer=ply \
 //thickness=0.18 //x=22.675 //y=6.2 //x2=22.675 //y2=5.045
r350 (  71 128 ) resistor r=592.245 //w=0.094 //l=1.155 //layer=ply \
 //thickness=0.18 //x=22.235 //y=6.2 //x2=22.235 //y2=5.045
r351 (  70 89 ) resistor r=592.245 //w=0.094 //l=1.155 //layer=ply \
 //thickness=0.18 //x=11.205 //y=6.2 //x2=11.205 //y2=5.045
r352 (  69 117 ) resistor r=592.245 //w=0.094 //l=1.155 //layer=ply \
 //thickness=0.18 //x=10.765 //y=6.2 //x2=10.765 //y2=5.045
r353 (  68 96 ) resistor r=55.3787 //w=0.094 //l=0.108 //layer=ply \
 //thickness=0.18 //x=22.092 //y=1.555 //x2=22.2 //y2=1.555
r354 (  68 97 ) resistor r=54.866 //w=0.094 //l=0.107 //layer=ply \
 //thickness=0.18 //x=22.092 //y=1.555 //x2=21.985 //y2=1.555
r355 (  67 77 ) resistor r=55.3787 //w=0.094 //l=0.108 //layer=ply \
 //thickness=0.18 //x=10.622 //y=1.555 //x2=10.73 //y2=1.555
r356 (  67 78 ) resistor r=54.866 //w=0.094 //l=0.107 //layer=ply \
 //thickness=0.18 //x=10.622 //y=1.555 //x2=10.515 //y2=1.555
r357 (  64 132 ) resistor r=152 //w=0.17 //l=0.17 //layer=licon //count=1 \
 //x=22.265 //y=2.26 //x2=22.265 //y2=2.26
r358 (  59 61 ) resistor r=13.6898 //w=0.187 //l=0.2 //layer=li \
 //thickness=0.1 //x=22.265 //y=4.335 //x2=22.265 //y2=4.535
r359 (  56 58 ) resistor r=64.3422 //w=0.187 //l=0.94 //layer=li \
 //thickness=0.1 //x=22.265 //y=3.225 //x2=22.265 //y2=4.165
r360 (  53 55 ) resistor r=13.6898 //w=0.187 //l=0.2 //layer=li \
 //thickness=0.1 //x=22.265 //y=2.855 //x2=22.265 //y2=3.055
r361 (  48 121 ) resistor r=152 //w=0.17 //l=0.17 //layer=licon //count=1 \
 //x=10.795 //y=2.26 //x2=10.795 //y2=2.26
r362 (  43 45 ) resistor r=13.6898 //w=0.187 //l=0.2 //layer=li \
 //thickness=0.1 //x=10.795 //y=3.225 //x2=10.795 //y2=3.425
r363 (  40 42 ) resistor r=13.6898 //w=0.187 //l=0.2 //layer=li \
 //thickness=0.1 //x=10.795 //y=2.855 //x2=10.795 //y2=3.055
r364 (  36 125 ) resistor r=152 //w=0.17 //l=0.17 //layer=licon //count=1 \
 //x=22.265 //y=4.88 //x2=22.265 //y2=4.88
r365 (  36 62 ) resistor r=11.9786 //w=0.187 //l=0.175 //layer=li \
 //thickness=0.1 //x=22.265 //y=4.88 //x2=22.265 //y2=4.705
r366 (  26 52 ) resistor r=13.6898 //w=0.187 //l=0.2 //layer=li \
 //thickness=0.1 //x=22.265 //y=2.485 //x2=22.265 //y2=2.685
r367 (  24 114 ) resistor r=152 //w=0.17 //l=0.17 //layer=licon //count=1 \
 //x=10.795 //y=4.88 //x2=10.795 //y2=4.88
r368 (  24 46 ) resistor r=87.9572 //w=0.187 //l=1.285 //layer=li \
 //thickness=0.1 //x=10.795 //y=4.88 //x2=10.795 //y2=3.595
r369 (  16 39 ) resistor r=13.6898 //w=0.187 //l=0.2 //layer=li \
 //thickness=0.1 //x=10.795 //y=2.485 //x2=10.795 //y2=2.685
r370 (  15 62 ) resistor r=5.1957 //w=0.242 //l=0.085 //layer=li \
 //thickness=0.1 //x=22.292 //y=4.62 //x2=22.292 //y2=4.705
r371 (  15 61 ) resistor r=5.1957 //w=0.242 //l=0.085 //layer=li \
 //thickness=0.1 //x=22.292 //y=4.62 //x2=22.292 //y2=4.535
r372 (  14 59 ) resistor r=5.1957 //w=0.242 //l=0.085 //layer=li \
 //thickness=0.1 //x=22.292 //y=4.25 //x2=22.292 //y2=4.335
r373 (  14 58 ) resistor r=5.1957 //w=0.242 //l=0.085 //layer=li \
 //thickness=0.1 //x=22.292 //y=4.25 //x2=22.292 //y2=4.165
r374 (  13 56 ) resistor r=5.1957 //w=0.242 //l=0.085 //layer=li \
 //thickness=0.1 //x=22.292 //y=3.14 //x2=22.292 //y2=3.225
r375 (  13 55 ) resistor r=5.1957 //w=0.242 //l=0.085 //layer=li \
 //thickness=0.1 //x=22.292 //y=3.14 //x2=22.292 //y2=3.055
r376 (  12 53 ) resistor r=5.1957 //w=0.242 //l=0.085 //layer=li \
 //thickness=0.1 //x=22.292 //y=2.77 //x2=22.292 //y2=2.855
r377 (  12 52 ) resistor r=5.1957 //w=0.242 //l=0.085 //layer=li \
 //thickness=0.1 //x=22.292 //y=2.77 //x2=22.292 //y2=2.685
r378 (  11 26 ) resistor r=5.83724 //w=0.194 //l=0.0975705 //layer=li \
 //thickness=0.1 //x=22.292 //y=2.4 //x2=22.265 //y2=2.485
r379 (  11 64 ) resistor r=9.23711 //w=0.194 //l=0.14 //layer=li \
 //thickness=0.1 //x=22.292 //y=2.4 //x2=22.292 //y2=2.26
r380 (  10 46 ) resistor r=5.1957 //w=0.242 //l=0.085 //layer=li \
 //thickness=0.1 //x=10.822 //y=3.51 //x2=10.822 //y2=3.595
r381 (  10 45 ) resistor r=5.1957 //w=0.242 //l=0.085 //layer=li \
 //thickness=0.1 //x=10.822 //y=3.51 //x2=10.822 //y2=3.425
r382 (  9 43 ) resistor r=5.1957 //w=0.242 //l=0.085 //layer=li \
 //thickness=0.1 //x=10.822 //y=3.14 //x2=10.822 //y2=3.225
r383 (  9 42 ) resistor r=5.1957 //w=0.242 //l=0.085 //layer=li \
 //thickness=0.1 //x=10.822 //y=3.14 //x2=10.822 //y2=3.055
r384 (  8 40 ) resistor r=5.1957 //w=0.242 //l=0.085 //layer=li \
 //thickness=0.1 //x=10.822 //y=2.77 //x2=10.822 //y2=2.855
r385 (  8 39 ) resistor r=5.1957 //w=0.242 //l=0.085 //layer=li \
 //thickness=0.1 //x=10.822 //y=2.77 //x2=10.822 //y2=2.685
r386 (  7 16 ) resistor r=5.83724 //w=0.194 //l=0.0975705 //layer=li \
 //thickness=0.1 //x=10.822 //y=2.4 //x2=10.795 //y2=2.485
r387 (  7 48 ) resistor r=9.23711 //w=0.194 //l=0.14 //layer=li \
 //thickness=0.1 //x=10.822 //y=2.4 //x2=10.822 //y2=2.26
r388 (  6 11 ) resistor r=9.3 //w=0.17 //l=0.17 //layer=mcon //count=1 \
 //x=22.265 //y=2.4 //x2=22.265 //y2=2.4
r389 (  4 7 ) resistor r=9.3 //w=0.17 //l=0.17 //layer=mcon //count=1 \
 //x=10.795 //y=2.4 //x2=10.795 //y2=2.4
r390 (  2 4 ) resistor r=0.0717383 //w=0.224 //l=0.115 //layer=m1 \
 //thickness=0.36 //x=10.91 //y=2.4 //x2=10.795 //y2=2.4
r391 (  1 6 ) resistor r=0.0717383 //w=0.224 //l=0.115 //layer=m1 \
 //thickness=0.36 //x=22.15 //y=2.4 //x2=22.265 //y2=2.4
r392 (  1 2 ) resistor r=10.7252 //w=0.131 //l=11.24 //layer=m1 \
 //thickness=0.36 //x=22.15 //y=2.4 //x2=10.91 //y2=2.4
ends PM_DFFSNQNX1\%SN

subckt PM_DFFSNQNX1\%noxref_10 ( 1 2 3 4 5 6 16 24 37 38 49 51 52 56 58 65 66 \
 67 68 69 70 71 72 73 74 78 79 80 85 87 90 91 95 96 97 102 104 107 108 112 113 \
 114 119 121 124 125 127 128 133 137 138 143 147 148 153 156 158 159 )
c358 ( 159 0 ) capacitor c=0.0220291f //x=15.35 //y=5.2
c359 ( 158 0 ) capacitor c=0.0217503f //x=14.47 //y=5.2
c360 ( 156 0 ) capacitor c=0.00866655f //x=15.345 //y=1.085
c361 ( 153 0 ) capacitor c=0.0617593f //x=23.375 //y=4.88
c362 ( 148 0 ) capacitor c=0.0273931f //x=23.375 //y=2.095
c363 ( 147 0 ) capacitor c=0.0470973f //x=23.375 //y=2.26
c364 ( 143 0 ) capacitor c=0.0587755f //x=11.905 //y=4.88
c365 ( 138 0 ) capacitor c=0.0273931f //x=11.905 //y=2.095
c366 ( 137 0 ) capacitor c=0.0462455f //x=11.905 //y=2.26
c367 ( 133 0 ) capacitor c=0.058931f //x=7.095 //y=4.88
c368 ( 128 0 ) capacitor c=0.0267105f //x=7.095 //y=2.095
c369 ( 127 0 ) capacitor c=0.0457054f //x=7.095 //y=2.26
c370 ( 125 0 ) capacitor c=0.0432517f //x=23.895 //y=1.44
c371 ( 124 0 ) capacitor c=0.0200379f //x=23.895 //y=1.095
c372 ( 121 0 ) capacitor c=0.0158629f //x=23.74 //y=1.595
c373 ( 119 0 ) capacitor c=0.0157803f //x=23.74 //y=0.94
c374 ( 114 0 ) capacitor c=0.0218028f //x=23.365 //y=1.75
c375 ( 113 0 ) capacitor c=0.0207459f //x=23.365 //y=1.44
c376 ( 112 0 ) capacitor c=0.0194308f //x=23.365 //y=1.095
c377 ( 108 0 ) capacitor c=0.0432517f //x=12.425 //y=1.44
c378 ( 107 0 ) capacitor c=0.0200379f //x=12.425 //y=1.095
c379 ( 104 0 ) capacitor c=0.0148873f //x=12.27 //y=1.595
c380 ( 102 0 ) capacitor c=0.0157803f //x=12.27 //y=0.94
c381 ( 97 0 ) capacitor c=0.0218028f //x=11.895 //y=1.75
c382 ( 96 0 ) capacitor c=0.0207459f //x=11.895 //y=1.44
c383 ( 95 0 ) capacitor c=0.0194308f //x=11.895 //y=1.095
c384 ( 91 0 ) capacitor c=0.0432517f //x=7.615 //y=1.44
c385 ( 90 0 ) capacitor c=0.0200379f //x=7.615 //y=1.095
c386 ( 87 0 ) capacitor c=0.0158629f //x=7.46 //y=1.595
c387 ( 85 0 ) capacitor c=0.0157803f //x=7.46 //y=0.94
c388 ( 80 0 ) capacitor c=0.0218028f //x=7.085 //y=1.75
c389 ( 79 0 ) capacitor c=0.0207459f //x=7.085 //y=1.44
c390 ( 78 0 ) capacitor c=0.0194308f //x=7.085 //y=1.095
c391 ( 74 0 ) capacitor c=0.158794f //x=23.555 //y=6.2
c392 ( 73 0 ) capacitor c=0.110114f //x=23.115 //y=6.2
c393 ( 72 0 ) capacitor c=0.158794f //x=12.085 //y=6.2
c394 ( 71 0 ) capacitor c=0.110114f //x=11.645 //y=6.2
c395 ( 70 0 ) capacitor c=0.158048f //x=7.275 //y=6.2
c396 ( 69 0 ) capacitor c=0.110114f //x=6.835 //y=6.2
c397 ( 65 0 ) capacitor c=0.0023043f //x=15.495 //y=5.38
c398 ( 58 0 ) capacitor c=0.0911864f //x=23.375 //y=2.26
c399 ( 56 0 ) capacitor c=0.110298f //x=15.975 //y=3.88
c400 ( 52 0 ) capacitor c=0.00404073f //x=15.62 //y=1.835
c401 ( 51 0 ) capacitor c=0.0122201f //x=15.89 //y=1.835
c402 ( 49 0 ) capacitor c=0.0140462f //x=15.89 //y=5.38
c403 ( 38 0 ) capacitor c=0.00251635f //x=14.7 //y=5.38
c404 ( 37 0 ) capacitor c=0.0141817f //x=15.41 //y=5.38
c405 ( 24 0 ) capacitor c=0.0854939f //x=11.905 //y=2.26
c406 ( 16 0 ) capacitor c=0.0863174f //x=7.095 //y=2.26
c407 ( 6 0 ) capacitor c=0.00472158f //x=16.09 //y=3.88
c408 ( 5 0 ) capacitor c=0.212874f //x=23.26 //y=3.88
c409 ( 4 0 ) capacitor c=0.00493991f //x=12.02 //y=3.88
c410 ( 3 0 ) capacitor c=0.0798595f //x=15.86 //y=3.88
c411 ( 2 0 ) capacitor c=0.0147097f //x=7.21 //y=3.88
c412 ( 1 0 ) capacitor c=0.104657f //x=11.79 //y=3.88
r413 (  147 148 ) resistor r=52.7279 //w=0.214 //l=0.165 //layer=ply \
 //thickness=0.18 //x=23.375 //y=2.26 //x2=23.375 //y2=2.095
r414 (  137 138 ) resistor r=52.7279 //w=0.214 //l=0.165 //layer=ply \
 //thickness=0.18 //x=11.905 //y=2.26 //x2=11.905 //y2=2.095
r415 (  127 128 ) resistor r=52.7279 //w=0.214 //l=0.165 //layer=ply \
 //thickness=0.18 //x=7.095 //y=2.26 //x2=7.095 //y2=2.095
r416 (  125 155 ) resistor r=45.1352 //w=0.168 //l=0.173853 //layer=ply \
 //thickness=0.18 //x=23.895 //y=1.44 //x2=23.855 //y2=1.595
r417 (  124 154 ) resistor r=45.1352 //w=0.168 //l=0.173853 //layer=ply \
 //thickness=0.18 //x=23.895 //y=1.095 //x2=23.855 //y2=0.94
r418 (  124 125 ) resistor r=176.904 //w=0.094 //l=0.345 //layer=ply \
 //thickness=0.18 //x=23.895 //y=1.095 //x2=23.895 //y2=1.44
r419 (  122 151 ) resistor r=10.701 //w=0.21 //l=0.115 //layer=ply \
 //thickness=0.18 //x=23.52 //y=1.595 //x2=23.405 //y2=1.595
r420 (  121 155 ) resistor r=5.52526 //w=0.168 //l=0.115 //layer=ply \
 //thickness=0.18 //x=23.74 //y=1.595 //x2=23.855 //y2=1.595
r421 (  120 150 ) resistor r=5.52526 //w=0.168 //l=0.115 //layer=ply \
 //thickness=0.18 //x=23.52 //y=0.94 //x2=23.405 //y2=0.94
r422 (  119 154 ) resistor r=5.52526 //w=0.168 //l=0.115 //layer=ply \
 //thickness=0.18 //x=23.74 //y=0.94 //x2=23.855 //y2=0.94
r423 (  119 120 ) resistor r=112.809 //w=0.094 //l=0.22 //layer=ply \
 //thickness=0.18 //x=23.74 //y=0.94 //x2=23.52 //y2=0.94
r424 (  116 153 ) resistor r=37.236 //w=0.233 //l=0.249199 //layer=ply \
 //thickness=0.18 //x=23.555 //y=5.045 //x2=23.375 //y2=4.88
r425 (  114 151 ) resistor r=39.5823 //w=0.21 //l=0.173853 //layer=ply \
 //thickness=0.18 //x=23.365 //y=1.75 //x2=23.405 //y2=1.595
r426 (  114 148 ) resistor r=176.904 //w=0.094 //l=0.345 //layer=ply \
 //thickness=0.18 //x=23.365 //y=1.75 //x2=23.365 //y2=2.095
r427 (  113 151 ) resistor r=39.5823 //w=0.21 //l=0.173853 //layer=ply \
 //thickness=0.18 //x=23.365 //y=1.44 //x2=23.405 //y2=1.595
r428 (  112 150 ) resistor r=45.1352 //w=0.168 //l=0.173853 //layer=ply \
 //thickness=0.18 //x=23.365 //y=1.095 //x2=23.405 //y2=0.94
r429 (  112 113 ) resistor r=176.904 //w=0.094 //l=0.345 //layer=ply \
 //thickness=0.18 //x=23.365 //y=1.095 //x2=23.365 //y2=1.44
r430 (  109 153 ) resistor r=53.7854 //w=0.233 //l=0.332415 //layer=ply \
 //thickness=0.18 //x=23.115 //y=5.045 //x2=23.375 //y2=4.88
r431 (  108 145 ) resistor r=45.1352 //w=0.168 //l=0.173853 //layer=ply \
 //thickness=0.18 //x=12.425 //y=1.44 //x2=12.385 //y2=1.595
r432 (  107 144 ) resistor r=45.1352 //w=0.168 //l=0.173853 //layer=ply \
 //thickness=0.18 //x=12.425 //y=1.095 //x2=12.385 //y2=0.94
r433 (  107 108 ) resistor r=176.904 //w=0.094 //l=0.345 //layer=ply \
 //thickness=0.18 //x=12.425 //y=1.095 //x2=12.425 //y2=1.44
r434 (  105 141 ) resistor r=10.701 //w=0.21 //l=0.115 //layer=ply \
 //thickness=0.18 //x=12.05 //y=1.595 //x2=11.935 //y2=1.595
r435 (  104 145 ) resistor r=5.52526 //w=0.168 //l=0.115 //layer=ply \
 //thickness=0.18 //x=12.27 //y=1.595 //x2=12.385 //y2=1.595
r436 (  103 140 ) resistor r=5.52526 //w=0.168 //l=0.115 //layer=ply \
 //thickness=0.18 //x=12.05 //y=0.94 //x2=11.935 //y2=0.94
r437 (  102 144 ) resistor r=5.52526 //w=0.168 //l=0.115 //layer=ply \
 //thickness=0.18 //x=12.27 //y=0.94 //x2=12.385 //y2=0.94
r438 (  102 103 ) resistor r=112.809 //w=0.094 //l=0.22 //layer=ply \
 //thickness=0.18 //x=12.27 //y=0.94 //x2=12.05 //y2=0.94
r439 (  99 143 ) resistor r=37.236 //w=0.233 //l=0.249199 //layer=ply \
 //thickness=0.18 //x=12.085 //y=5.045 //x2=11.905 //y2=4.88
r440 (  97 141 ) resistor r=39.5823 //w=0.21 //l=0.173853 //layer=ply \
 //thickness=0.18 //x=11.895 //y=1.75 //x2=11.935 //y2=1.595
r441 (  97 138 ) resistor r=176.904 //w=0.094 //l=0.345 //layer=ply \
 //thickness=0.18 //x=11.895 //y=1.75 //x2=11.895 //y2=2.095
r442 (  96 141 ) resistor r=39.5823 //w=0.21 //l=0.173853 //layer=ply \
 //thickness=0.18 //x=11.895 //y=1.44 //x2=11.935 //y2=1.595
r443 (  95 140 ) resistor r=45.1352 //w=0.168 //l=0.173853 //layer=ply \
 //thickness=0.18 //x=11.895 //y=1.095 //x2=11.935 //y2=0.94
r444 (  95 96 ) resistor r=176.904 //w=0.094 //l=0.345 //layer=ply \
 //thickness=0.18 //x=11.895 //y=1.095 //x2=11.895 //y2=1.44
r445 (  92 143 ) resistor r=53.7854 //w=0.233 //l=0.332415 //layer=ply \
 //thickness=0.18 //x=11.645 //y=5.045 //x2=11.905 //y2=4.88
r446 (  91 135 ) resistor r=45.1352 //w=0.168 //l=0.173853 //layer=ply \
 //thickness=0.18 //x=7.615 //y=1.44 //x2=7.575 //y2=1.595
r447 (  90 134 ) resistor r=45.1352 //w=0.168 //l=0.173853 //layer=ply \
 //thickness=0.18 //x=7.615 //y=1.095 //x2=7.575 //y2=0.94
r448 (  90 91 ) resistor r=176.904 //w=0.094 //l=0.345 //layer=ply \
 //thickness=0.18 //x=7.615 //y=1.095 //x2=7.615 //y2=1.44
r449 (  88 131 ) resistor r=10.701 //w=0.21 //l=0.115 //layer=ply \
 //thickness=0.18 //x=7.24 //y=1.595 //x2=7.125 //y2=1.595
r450 (  87 135 ) resistor r=5.52526 //w=0.168 //l=0.115 //layer=ply \
 //thickness=0.18 //x=7.46 //y=1.595 //x2=7.575 //y2=1.595
r451 (  86 130 ) resistor r=5.52526 //w=0.168 //l=0.115 //layer=ply \
 //thickness=0.18 //x=7.24 //y=0.94 //x2=7.125 //y2=0.94
r452 (  85 134 ) resistor r=5.52526 //w=0.168 //l=0.115 //layer=ply \
 //thickness=0.18 //x=7.46 //y=0.94 //x2=7.575 //y2=0.94
r453 (  85 86 ) resistor r=112.809 //w=0.094 //l=0.22 //layer=ply \
 //thickness=0.18 //x=7.46 //y=0.94 //x2=7.24 //y2=0.94
r454 (  82 133 ) resistor r=37.236 //w=0.233 //l=0.249199 //layer=ply \
 //thickness=0.18 //x=7.275 //y=5.045 //x2=7.095 //y2=4.88
r455 (  80 131 ) resistor r=39.5823 //w=0.21 //l=0.173853 //layer=ply \
 //thickness=0.18 //x=7.085 //y=1.75 //x2=7.125 //y2=1.595
r456 (  80 128 ) resistor r=176.904 //w=0.094 //l=0.345 //layer=ply \
 //thickness=0.18 //x=7.085 //y=1.75 //x2=7.085 //y2=2.095
r457 (  79 131 ) resistor r=39.5823 //w=0.21 //l=0.173853 //layer=ply \
 //thickness=0.18 //x=7.085 //y=1.44 //x2=7.125 //y2=1.595
r458 (  78 130 ) resistor r=45.1352 //w=0.168 //l=0.173853 //layer=ply \
 //thickness=0.18 //x=7.085 //y=1.095 //x2=7.125 //y2=0.94
r459 (  78 79 ) resistor r=176.904 //w=0.094 //l=0.345 //layer=ply \
 //thickness=0.18 //x=7.085 //y=1.095 //x2=7.085 //y2=1.44
r460 (  75 133 ) resistor r=53.7854 //w=0.233 //l=0.332415 //layer=ply \
 //thickness=0.18 //x=6.835 //y=5.045 //x2=7.095 //y2=4.88
r461 (  74 116 ) resistor r=592.245 //w=0.094 //l=1.155 //layer=ply \
 //thickness=0.18 //x=23.555 //y=6.2 //x2=23.555 //y2=5.045
r462 (  73 109 ) resistor r=592.245 //w=0.094 //l=1.155 //layer=ply \
 //thickness=0.18 //x=23.115 //y=6.2 //x2=23.115 //y2=5.045
r463 (  72 99 ) resistor r=592.245 //w=0.094 //l=1.155 //layer=ply \
 //thickness=0.18 //x=12.085 //y=6.2 //x2=12.085 //y2=5.045
r464 (  71 92 ) resistor r=592.245 //w=0.094 //l=1.155 //layer=ply \
 //thickness=0.18 //x=11.645 //y=6.2 //x2=11.645 //y2=5.045
r465 (  70 82 ) resistor r=592.245 //w=0.094 //l=1.155 //layer=ply \
 //thickness=0.18 //x=7.275 //y=6.2 //x2=7.275 //y2=5.045
r466 (  69 75 ) resistor r=592.245 //w=0.094 //l=1.155 //layer=ply \
 //thickness=0.18 //x=6.835 //y=6.2 //x2=6.835 //y2=5.045
r467 (  68 121 ) resistor r=56.4043 //w=0.094 //l=0.11 //layer=ply \
 //thickness=0.18 //x=23.63 //y=1.595 //x2=23.74 //y2=1.595
r468 (  68 122 ) resistor r=56.4043 //w=0.094 //l=0.11 //layer=ply \
 //thickness=0.18 //x=23.63 //y=1.595 //x2=23.52 //y2=1.595
r469 (  67 104 ) resistor r=56.4043 //w=0.094 //l=0.11 //layer=ply \
 //thickness=0.18 //x=12.16 //y=1.595 //x2=12.27 //y2=1.595
r470 (  67 105 ) resistor r=56.4043 //w=0.094 //l=0.11 //layer=ply \
 //thickness=0.18 //x=12.16 //y=1.595 //x2=12.05 //y2=1.595
r471 (  66 87 ) resistor r=56.4043 //w=0.094 //l=0.11 //layer=ply \
 //thickness=0.18 //x=7.35 //y=1.595 //x2=7.46 //y2=1.595
r472 (  66 88 ) resistor r=56.4043 //w=0.094 //l=0.11 //layer=ply \
 //thickness=0.18 //x=7.35 //y=1.595 //x2=7.24 //y2=1.595
r473 (  63 153 ) resistor r=152 //w=0.17 //l=0.17 //layer=licon //count=1 \
 //x=23.375 //y=4.88 //x2=23.375 //y2=4.88
r474 (  61 63 ) resistor r=68.4492 //w=0.187 //l=1 //layer=li //thickness=0.1 \
 //x=23.375 //y=3.88 //x2=23.375 //y2=4.88
r475 (  58 147 ) resistor r=152 //w=0.17 //l=0.17 //layer=licon //count=1 \
 //x=23.375 //y=2.26 //x2=23.375 //y2=2.26
r476 (  58 61 ) resistor r=110.888 //w=0.187 //l=1.62 //layer=li \
 //thickness=0.1 //x=23.375 //y=2.26 //x2=23.375 //y2=3.88
r477 (  54 56 ) resistor r=96.8556 //w=0.187 //l=1.415 //layer=li \
 //thickness=0.1 //x=15.975 //y=5.295 //x2=15.975 //y2=3.88
r478 (  53 56 ) resistor r=134.16 //w=0.187 //l=1.96 //layer=li \
 //thickness=0.1 //x=15.975 //y=1.92 //x2=15.975 //y2=3.88
r479 (  51 53 ) resistor r=7.15173 //w=0.17 //l=0.120208 //layer=li \
 //thickness=0.1 //x=15.89 //y=1.835 //x2=15.975 //y2=1.92
r480 (  51 52 ) resistor r=18.4813 //w=0.187 //l=0.27 //layer=li \
 //thickness=0.1 //x=15.89 //y=1.835 //x2=15.62 //y2=1.835
r481 (  50 65 ) resistor r=5.4201 //w=0.17 //l=0.085 //layer=li \
 //thickness=0.1 //x=15.58 //y=5.38 //x2=15.495 //y2=5.38
r482 (  49 54 ) resistor r=7.15173 //w=0.17 //l=0.120208 //layer=li \
 //thickness=0.1 //x=15.89 //y=5.38 //x2=15.975 //y2=5.295
r483 (  49 50 ) resistor r=21.2193 //w=0.187 //l=0.31 //layer=li \
 //thickness=0.1 //x=15.89 //y=5.38 //x2=15.58 //y2=5.38
r484 (  45 52 ) resistor r=7.15173 //w=0.17 //l=0.120208 //layer=li \
 //thickness=0.1 //x=15.535 //y=1.75 //x2=15.62 //y2=1.835
r485 (  45 156 ) resistor r=39.016 //w=0.187 //l=0.57 //layer=li \
 //thickness=0.1 //x=15.535 //y=1.75 //x2=15.535 //y2=1.18
r486 (  39 65 ) resistor r=1.40859 //w=0.34 //l=0.085 //layer=li \
 //thickness=0.1 //x=15.495 //y=5.465 //x2=15.495 //y2=5.38
r487 (  39 159 ) resistor r=30.1176 //w=0.187 //l=0.44 //layer=li \
 //thickness=0.1 //x=15.495 //y=5.465 //x2=15.495 //y2=5.905
r488 (  37 65 ) resistor r=5.4201 //w=0.17 //l=0.085 //layer=li \
 //thickness=0.1 //x=15.41 //y=5.38 //x2=15.495 //y2=5.38
r489 (  37 38 ) resistor r=48.5989 //w=0.187 //l=0.71 //layer=li \
 //thickness=0.1 //x=15.41 //y=5.38 //x2=14.7 //y2=5.38
r490 (  31 38 ) resistor r=7.15173 //w=0.17 //l=0.120208 //layer=li \
 //thickness=0.1 //x=14.615 //y=5.465 //x2=14.7 //y2=5.38
r491 (  31 158 ) resistor r=30.1176 //w=0.187 //l=0.44 //layer=li \
 //thickness=0.1 //x=14.615 //y=5.465 //x2=14.615 //y2=5.905
r492 (  29 143 ) resistor r=152 //w=0.17 //l=0.17 //layer=licon //count=1 \
 //x=11.905 //y=4.88 //x2=11.905 //y2=4.88
r493 (  27 29 ) resistor r=68.4492 //w=0.187 //l=1 //layer=li //thickness=0.1 \
 //x=11.905 //y=3.88 //x2=11.905 //y2=4.88
r494 (  24 137 ) resistor r=152 //w=0.17 //l=0.17 //layer=licon //count=1 \
 //x=11.905 //y=2.26 //x2=11.905 //y2=2.26
r495 (  24 27 ) resistor r=110.888 //w=0.187 //l=1.62 //layer=li \
 //thickness=0.1 //x=11.905 //y=2.26 //x2=11.905 //y2=3.88
r496 (  21 133 ) resistor r=152 //w=0.17 //l=0.17 //layer=licon //count=1 \
 //x=7.095 //y=4.88 //x2=7.095 //y2=4.88
r497 (  19 21 ) resistor r=68.4492 //w=0.187 //l=1 //layer=li //thickness=0.1 \
 //x=7.095 //y=3.88 //x2=7.095 //y2=4.88
r498 (  16 127 ) resistor r=152 //w=0.17 //l=0.17 //layer=licon //count=1 \
 //x=7.095 //y=2.26 //x2=7.095 //y2=2.26
r499 (  16 19 ) resistor r=110.888 //w=0.187 //l=1.62 //layer=li \
 //thickness=0.1 //x=7.095 //y=2.26 //x2=7.095 //y2=3.88
r500 (  14 61 ) resistor r=9.3 //w=0.17 //l=0.17 //layer=mcon //count=1 \
 //x=23.375 //y=3.88 //x2=23.375 //y2=3.88
r501 (  12 56 ) resistor r=9.3 //w=0.17 //l=0.17 //layer=mcon //count=1 \
 //x=15.975 //y=3.88 //x2=15.975 //y2=3.88
r502 (  10 27 ) resistor r=9.3 //w=0.17 //l=0.17 //layer=mcon //count=1 \
 //x=11.905 //y=3.88 //x2=11.905 //y2=3.88
r503 (  8 19 ) resistor r=9.3 //w=0.17 //l=0.17 //layer=mcon //count=1 \
 //x=7.095 //y=3.88 //x2=7.095 //y2=3.88
r504 (  6 12 ) resistor r=0.0880901 //w=0.191 //l=0.115 //layer=m1 \
 //thickness=0.36 //x=16.09 //y=3.88 //x2=15.975 //y2=3.88
r505 (  5 14 ) resistor r=0.0717383 //w=0.224 //l=0.115 //layer=m1 \
 //thickness=0.36 //x=23.26 //y=3.88 //x2=23.375 //y2=3.88
r506 (  5 6 ) resistor r=6.8416 //w=0.131 //l=7.17 //layer=m1 //thickness=0.36 \
 //x=23.26 //y=3.88 //x2=16.09 //y2=3.88
r507 (  4 10 ) resistor r=0.0880901 //w=0.191 //l=0.115 //layer=m1 \
 //thickness=0.36 //x=12.02 //y=3.88 //x2=11.905 //y2=3.88
r508 (  3 12 ) resistor r=0.0880901 //w=0.191 //l=0.115 //layer=m1 \
 //thickness=0.36 //x=15.86 //y=3.88 //x2=15.975 //y2=3.88
r509 (  3 4 ) resistor r=3.66412 //w=0.131 //l=3.84 //layer=m1 \
 //thickness=0.36 //x=15.86 //y=3.88 //x2=12.02 //y2=3.88
r510 (  2 8 ) resistor r=0.0717383 //w=0.224 //l=0.115 //layer=m1 \
 //thickness=0.36 //x=7.21 //y=3.88 //x2=7.095 //y2=3.88
r511 (  1 10 ) resistor r=0.0880901 //w=0.191 //l=0.115 //layer=m1 \
 //thickness=0.36 //x=11.79 //y=3.88 //x2=11.905 //y2=3.88
r512 (  1 2 ) resistor r=4.37023 //w=0.131 //l=4.58 //layer=m1 \
 //thickness=0.36 //x=11.79 //y=3.88 //x2=7.21 //y2=3.88
ends PM_DFFSNQNX1\%noxref_10

subckt PM_DFFSNQNX1\%noxref_11 ( 11 12 19 27 33 34 38 39 40 41 43 44 45 )
c98 ( 45 0 ) capacitor c=0.023087f //x=23.19 //y=5.2
c99 ( 44 0 ) capacitor c=0.023519f //x=22.31 //y=5.2
c100 ( 43 0 ) capacitor c=0.0224735f //x=21.43 //y=5.2
c101 ( 41 0 ) capacitor c=0.00853354f //x=23.44 //y=1.095
c102 ( 40 0 ) capacitor c=0.00125237f //x=23.335 //y=5.335
c103 ( 39 0 ) capacitor c=0.00209354f //x=22.455 //y=5.335
c104 ( 38 0 ) capacitor c=0.256306f //x=24.115 //y=3.51
c105 ( 34 0 ) capacitor c=0.00493499f //x=23.715 //y=1.845
c106 ( 33 0 ) capacitor c=0.0154014f //x=24.03 //y=1.845
c107 ( 27 0 ) capacitor c=0.0304842f //x=24.03 //y=5.335
c108 ( 19 0 ) capacitor c=0.0191592f //x=23.25 //y=5.335
c109 ( 12 0 ) capacitor c=0.00369455f //x=21.66 //y=5.335
c110 ( 11 0 ) capacitor c=0.0159676f //x=22.37 //y=5.335
r111 (  36 38 ) resistor r=119.102 //w=0.187 //l=1.74 //layer=li \
 //thickness=0.1 //x=24.115 //y=5.25 //x2=24.115 //y2=3.51
r112 (  35 38 ) resistor r=108.15 //w=0.187 //l=1.58 //layer=li \
 //thickness=0.1 //x=24.115 //y=1.93 //x2=24.115 //y2=3.51
r113 (  33 35 ) resistor r=7.15173 //w=0.17 //l=0.120208 //layer=li \
 //thickness=0.1 //x=24.03 //y=1.845 //x2=24.115 //y2=1.93
r114 (  33 34 ) resistor r=21.5615 //w=0.187 //l=0.315 //layer=li \
 //thickness=0.1 //x=24.03 //y=1.845 //x2=23.715 //y2=1.845
r115 (  29 34 ) resistor r=7.15173 //w=0.17 //l=0.120208 //layer=li \
 //thickness=0.1 //x=23.63 //y=1.76 //x2=23.715 //y2=1.845
r116 (  29 41 ) resistor r=39.016 //w=0.187 //l=0.57 //layer=li \
 //thickness=0.1 //x=23.63 //y=1.76 //x2=23.63 //y2=1.19
r117 (  28 40 ) resistor r=5.4201 //w=0.17 //l=0.085 //layer=li \
 //thickness=0.1 //x=23.42 //y=5.335 //x2=23.335 //y2=5.335
r118 (  27 36 ) resistor r=7.15173 //w=0.17 //l=0.120208 //layer=li \
 //thickness=0.1 //x=24.03 //y=5.335 //x2=24.115 //y2=5.25
r119 (  27 28 ) resistor r=41.754 //w=0.187 //l=0.61 //layer=li \
 //thickness=0.1 //x=24.03 //y=5.335 //x2=23.42 //y2=5.335
r120 (  21 40 ) resistor r=1.40859 //w=0.34 //l=0.085 //layer=li \
 //thickness=0.1 //x=23.335 //y=5.42 //x2=23.335 //y2=5.335
r121 (  21 45 ) resistor r=33.1979 //w=0.187 //l=0.485 //layer=li \
 //thickness=0.1 //x=23.335 //y=5.42 //x2=23.335 //y2=5.905
r122 (  20 39 ) resistor r=5.4201 //w=0.17 //l=0.085 //layer=li \
 //thickness=0.1 //x=22.54 //y=5.335 //x2=22.455 //y2=5.335
r123 (  19 40 ) resistor r=5.4201 //w=0.17 //l=0.085 //layer=li \
 //thickness=0.1 //x=23.25 //y=5.335 //x2=23.335 //y2=5.335
r124 (  19 20 ) resistor r=48.5989 //w=0.187 //l=0.71 //layer=li \
 //thickness=0.1 //x=23.25 //y=5.335 //x2=22.54 //y2=5.335
r125 (  13 39 ) resistor r=1.40859 //w=0.34 //l=0.085 //layer=li \
 //thickness=0.1 //x=22.455 //y=5.42 //x2=22.455 //y2=5.335
r126 (  13 44 ) resistor r=33.1979 //w=0.187 //l=0.485 //layer=li \
 //thickness=0.1 //x=22.455 //y=5.42 //x2=22.455 //y2=5.905
r127 (  11 39 ) resistor r=5.4201 //w=0.17 //l=0.085 //layer=li \
 //thickness=0.1 //x=22.37 //y=5.335 //x2=22.455 //y2=5.335
r128 (  11 12 ) resistor r=48.5989 //w=0.187 //l=0.71 //layer=li \
 //thickness=0.1 //x=22.37 //y=5.335 //x2=21.66 //y2=5.335
r129 (  5 12 ) resistor r=7.15173 //w=0.17 //l=0.120208 //layer=li \
 //thickness=0.1 //x=21.575 //y=5.42 //x2=21.66 //y2=5.335
r130 (  5 43 ) resistor r=33.1979 //w=0.187 //l=0.485 //layer=li \
 //thickness=0.1 //x=21.575 //y=5.42 //x2=21.575 //y2=5.905
ends PM_DFFSNQNX1\%noxref_11

subckt PM_DFFSNQNX1\%D ( 1 2 3 4 5 6 7 8 22 25 28 31 34 37 40 45 46 47 48 49 \
 50 51 55 57 60 61 71 )
c85 ( 71 0 ) capacitor c=0.0657939f //x=1.545 //y=4.88
c86 ( 61 0 ) capacitor c=0.0318948f //x=1.88 //y=1.39
c87 ( 60 0 ) capacitor c=0.0187384f //x=1.88 //y=1.045
c88 ( 57 0 ) capacitor c=0.0141798f //x=1.725 //y=1.545
c89 ( 55 0 ) capacitor c=0.0149844f //x=1.725 //y=0.89
c90 ( 51 0 ) capacitor c=0.0848676f //x=1.35 //y=2.095
c91 ( 50 0 ) capacitor c=0.0229722f //x=1.35 //y=1.7
c92 ( 49 0 ) capacitor c=0.0234352f //x=1.35 //y=1.39
c93 ( 48 0 ) capacitor c=0.0199343f //x=1.35 //y=1.045
c94 ( 47 0 ) capacitor c=0.110275f //x=1.885 //y=6.2
c95 ( 46 0 ) capacitor c=0.154305f //x=1.445 //y=6.2
c96 ( 40 0 ) capacitor c=0.00744842f //x=1.572 //y=4.535
c97 ( 37 0 ) capacitor c=0.0107864f //x=1.572 //y=4.165
c98 ( 34 0 ) capacitor c=0.0108927f //x=1.572 //y=3.795
c99 ( 31 0 ) capacitor c=0.0108927f //x=1.572 //y=3.425
c100 ( 28 0 ) capacitor c=0.0100927f //x=1.572 //y=3.055
c101 ( 25 0 ) capacitor c=0.00662874f //x=1.572 //y=2.685
c102 ( 22 0 ) capacitor c=0.004519f //x=1.545 //y=4.88
c103 ( 8 0 ) capacitor c=0.00612718f //x=1.545 //y=2.485
c104 ( 7 0 ) capacitor c=0.00587277f //x=1.6 //y=4.62
c105 ( 6 0 ) capacitor c=0.00886977f //x=1.6 //y=4.25
c106 ( 5 0 ) capacitor c=0.0103491f //x=1.6 //y=3.88
c107 ( 4 0 ) capacitor c=0.0104361f //x=1.6 //y=3.51
c108 ( 3 0 ) capacitor c=0.0103412f //x=1.6 //y=3.14
c109 ( 2 0 ) capacitor c=0.00693726f //x=1.6 //y=2.77
r110 (  69 71 ) resistor r=20.6867 //w=0.233 //l=0.1 //layer=ply \
 //thickness=0.18 //x=1.445 //y=4.88 //x2=1.545 //y2=4.88
r111 (  62 71 ) resistor r=70.3348 //w=0.233 //l=0.414367 //layer=ply \
 //thickness=0.18 //x=1.885 //y=5.045 //x2=1.545 //y2=4.88
r112 (  61 73 ) resistor r=45.1352 //w=0.168 //l=0.173853 //layer=ply \
 //thickness=0.18 //x=1.88 //y=1.39 //x2=1.84 //y2=1.545
r113 (  60 72 ) resistor r=45.1352 //w=0.168 //l=0.173853 //layer=ply \
 //thickness=0.18 //x=1.88 //y=1.045 //x2=1.84 //y2=0.89
r114 (  60 61 ) resistor r=176.904 //w=0.094 //l=0.345 //layer=ply \
 //thickness=0.18 //x=1.88 //y=1.045 //x2=1.88 //y2=1.39
r115 (  58 68 ) resistor r=10.701 //w=0.21 //l=0.115 //layer=ply \
 //thickness=0.18 //x=1.505 //y=1.545 //x2=1.39 //y2=1.545
r116 (  57 73 ) resistor r=5.52526 //w=0.168 //l=0.115 //layer=ply \
 //thickness=0.18 //x=1.725 //y=1.545 //x2=1.84 //y2=1.545
r117 (  56 67 ) resistor r=5.52526 //w=0.168 //l=0.115 //layer=ply \
 //thickness=0.18 //x=1.505 //y=0.89 //x2=1.39 //y2=0.89
r118 (  55 72 ) resistor r=5.52526 //w=0.168 //l=0.115 //layer=ply \
 //thickness=0.18 //x=1.725 //y=0.89 //x2=1.84 //y2=0.89
r119 (  55 56 ) resistor r=112.809 //w=0.094 //l=0.22 //layer=ply \
 //thickness=0.18 //x=1.725 //y=0.89 //x2=1.505 //y2=0.89
r120 (  52 69 ) resistor r=13.0941 //w=0.233 //l=0.165 //layer=ply \
 //thickness=0.18 //x=1.445 //y=5.045 //x2=1.445 //y2=4.88
r121 (  51 66 ) resistor r=34.8111 //w=0.27 //l=0.264953 //layer=ply \
 //thickness=0.18 //x=1.35 //y=2.095 //x2=1.545 //y2=2.26
r122 (  50 68 ) resistor r=39.5823 //w=0.21 //l=0.173853 //layer=ply \
 //thickness=0.18 //x=1.35 //y=1.7 //x2=1.39 //y2=1.545
r123 (  50 51 ) resistor r=202.543 //w=0.094 //l=0.395 //layer=ply \
 //thickness=0.18 //x=1.35 //y=1.7 //x2=1.35 //y2=2.095
r124 (  49 68 ) resistor r=39.5823 //w=0.21 //l=0.173853 //layer=ply \
 //thickness=0.18 //x=1.35 //y=1.39 //x2=1.39 //y2=1.545
r125 (  48 67 ) resistor r=45.1352 //w=0.168 //l=0.173853 //layer=ply \
 //thickness=0.18 //x=1.35 //y=1.045 //x2=1.39 //y2=0.89
r126 (  48 49 ) resistor r=176.904 //w=0.094 //l=0.345 //layer=ply \
 //thickness=0.18 //x=1.35 //y=1.045 //x2=1.35 //y2=1.39
r127 (  47 62 ) resistor r=592.245 //w=0.094 //l=1.155 //layer=ply \
 //thickness=0.18 //x=1.885 //y=6.2 //x2=1.885 //y2=5.045
r128 (  46 52 ) resistor r=592.245 //w=0.094 //l=1.155 //layer=ply \
 //thickness=0.18 //x=1.445 //y=6.2 //x2=1.445 //y2=5.045
r129 (  45 57 ) resistor r=56.4043 //w=0.094 //l=0.11 //layer=ply \
 //thickness=0.18 //x=1.615 //y=1.545 //x2=1.725 //y2=1.545
r130 (  45 58 ) resistor r=56.4043 //w=0.094 //l=0.11 //layer=ply \
 //thickness=0.18 //x=1.615 //y=1.545 //x2=1.505 //y2=1.545
r131 (  43 66 ) resistor r=152 //w=0.17 //l=0.17 //layer=licon //count=1 \
 //x=1.545 //y=2.26 //x2=1.545 //y2=2.26
r132 (  38 40 ) resistor r=13.6898 //w=0.187 //l=0.2 //layer=li \
 //thickness=0.1 //x=1.545 //y=4.335 //x2=1.545 //y2=4.535
r133 (  35 37 ) resistor r=13.6898 //w=0.187 //l=0.2 //layer=li \
 //thickness=0.1 //x=1.545 //y=3.965 //x2=1.545 //y2=4.165
r134 (  32 34 ) resistor r=13.6898 //w=0.187 //l=0.2 //layer=li \
 //thickness=0.1 //x=1.545 //y=3.595 //x2=1.545 //y2=3.795
r135 (  29 31 ) resistor r=13.6898 //w=0.187 //l=0.2 //layer=li \
 //thickness=0.1 //x=1.545 //y=3.225 //x2=1.545 //y2=3.425
r136 (  26 28 ) resistor r=13.6898 //w=0.187 //l=0.2 //layer=li \
 //thickness=0.1 //x=1.545 //y=2.855 //x2=1.545 //y2=3.055
r137 (  22 71 ) resistor r=152 //w=0.17 //l=0.17 //layer=licon //count=1 \
 //x=1.545 //y=4.88 //x2=1.545 //y2=4.88
r138 (  22 41 ) resistor r=11.9786 //w=0.187 //l=0.175 //layer=li \
 //thickness=0.1 //x=1.545 //y=4.88 //x2=1.545 //y2=4.705
r139 (  8 25 ) resistor r=13.6898 //w=0.187 //l=0.2 //layer=li //thickness=0.1 \
 //x=1.545 //y=2.485 //x2=1.545 //y2=2.685
r140 (  7 41 ) resistor r=5.1957 //w=0.242 //l=0.085 //layer=li \
 //thickness=0.1 //x=1.572 //y=4.62 //x2=1.572 //y2=4.705
r141 (  7 40 ) resistor r=5.1957 //w=0.242 //l=0.085 //layer=li \
 //thickness=0.1 //x=1.572 //y=4.62 //x2=1.572 //y2=4.535
r142 (  6 38 ) resistor r=5.1957 //w=0.242 //l=0.085 //layer=li \
 //thickness=0.1 //x=1.572 //y=4.25 //x2=1.572 //y2=4.335
r143 (  6 37 ) resistor r=5.1957 //w=0.242 //l=0.085 //layer=li \
 //thickness=0.1 //x=1.572 //y=4.25 //x2=1.572 //y2=4.165
r144 (  5 35 ) resistor r=5.1957 //w=0.242 //l=0.085 //layer=li \
 //thickness=0.1 //x=1.572 //y=3.88 //x2=1.572 //y2=3.965
r145 (  5 34 ) resistor r=5.1957 //w=0.242 //l=0.085 //layer=li \
 //thickness=0.1 //x=1.572 //y=3.88 //x2=1.572 //y2=3.795
r146 (  4 32 ) resistor r=5.1957 //w=0.242 //l=0.085 //layer=li \
 //thickness=0.1 //x=1.572 //y=3.51 //x2=1.572 //y2=3.595
r147 (  4 31 ) resistor r=5.1957 //w=0.242 //l=0.085 //layer=li \
 //thickness=0.1 //x=1.572 //y=3.51 //x2=1.572 //y2=3.425
r148 (  3 29 ) resistor r=5.1957 //w=0.242 //l=0.085 //layer=li \
 //thickness=0.1 //x=1.572 //y=3.14 //x2=1.572 //y2=3.225
r149 (  3 28 ) resistor r=5.1957 //w=0.242 //l=0.085 //layer=li \
 //thickness=0.1 //x=1.572 //y=3.14 //x2=1.572 //y2=3.055
r150 (  2 26 ) resistor r=5.1957 //w=0.242 //l=0.085 //layer=li \
 //thickness=0.1 //x=1.572 //y=2.77 //x2=1.572 //y2=2.855
r151 (  2 25 ) resistor r=5.1957 //w=0.242 //l=0.085 //layer=li \
 //thickness=0.1 //x=1.572 //y=2.77 //x2=1.572 //y2=2.685
r152 (  1 8 ) resistor r=5.83724 //w=0.194 //l=0.0975705 //layer=li \
 //thickness=0.1 //x=1.572 //y=2.4 //x2=1.545 //y2=2.485
r153 (  1 43 ) resistor r=9.23711 //w=0.194 //l=0.14 //layer=li \
 //thickness=0.1 //x=1.572 //y=2.4 //x2=1.572 //y2=2.26
ends PM_DFFSNQNX1\%D

subckt PM_DFFSNQNX1\%noxref_13 ( 1 5 9 10 13 17 29 )
c49 ( 29 0 ) capacitor c=0.0632971f //x=0.995 //y=0.545
c50 ( 17 0 ) capacitor c=0.0072343f //x=3.07 //y=0.795
c51 ( 13 0 ) capacitor c=0.015427f //x=2.985 //y=0.71
c52 ( 10 0 ) capacitor c=0.00896024f //x=2.1 //y=1.675
c53 ( 9 0 ) capacitor c=0.006761f //x=2.1 //y=0.795
c54 ( 5 0 ) capacitor c=0.0248811f //x=2.015 //y=1.76
c55 ( 1 0 ) capacitor c=0.0113547f //x=1.13 //y=1.675
r56 (  17 29 ) resistor r=3.57586 //w=0.17 //l=0.125 //layer=li \
 //thickness=0.1 //x=3.07 //y=0.795 //x2=3.07 //y2=0.67
r57 (  17 29 ) resistor r=18.139 //w=0.187 //l=0.265 //layer=li \
 //thickness=0.1 //x=3.07 //y=0.795 //x2=3.07 //y2=1.06
r58 (  14 29 ) resistor r=3.57586 //w=0.17 //l=0.103078 //layer=li \
 //thickness=0.1 //x=2.185 //y=0.71 //x2=2.1 //y2=0.67
r59 (  14 29 ) resistor r=27.3797 //w=0.187 //l=0.4 //layer=li //thickness=0.1 \
 //x=2.185 //y=0.71 //x2=2.585 //y2=0.71
r60 (  13 29 ) resistor r=3.57586 //w=0.17 //l=0.103078 //layer=li \
 //thickness=0.1 //x=2.985 //y=0.71 //x2=3.07 //y2=0.67
r61 (  13 29 ) resistor r=27.3797 //w=0.187 //l=0.4 //layer=li //thickness=0.1 \
 //x=2.985 //y=0.71 //x2=2.585 //y2=0.71
r62 (  10 29 ) resistor r=3.57586 //w=0.17 //l=0.125 //layer=li \
 //thickness=0.1 //x=2.1 //y=1.675 //x2=2.1 //y2=1.8
r63 (  10 29 ) resistor r=42.0963 //w=0.187 //l=0.615 //layer=li \
 //thickness=0.1 //x=2.1 //y=1.675 //x2=2.1 //y2=1.06
r64 (  9 29 ) resistor r=3.57586 //w=0.17 //l=0.125 //layer=li //thickness=0.1 \
 //x=2.1 //y=0.795 //x2=2.1 //y2=0.67
r65 (  9 29 ) resistor r=18.139 //w=0.187 //l=0.265 //layer=li //thickness=0.1 \
 //x=2.1 //y=0.795 //x2=2.1 //y2=1.06
r66 (  6 29 ) resistor r=3.57586 //w=0.17 //l=0.103078 //layer=li \
 //thickness=0.1 //x=1.215 //y=1.76 //x2=1.13 //y2=1.8
r67 (  6 29 ) resistor r=27.3797 //w=0.187 //l=0.4 //layer=li //thickness=0.1 \
 //x=1.215 //y=1.76 //x2=1.615 //y2=1.76
r68 (  5 29 ) resistor r=3.57586 //w=0.17 //l=0.103078 //layer=li \
 //thickness=0.1 //x=2.015 //y=1.76 //x2=2.1 //y2=1.8
r69 (  5 29 ) resistor r=27.3797 //w=0.187 //l=0.4 //layer=li //thickness=0.1 \
 //x=2.015 //y=1.76 //x2=1.615 //y2=1.76
r70 (  1 29 ) resistor r=3.57586 //w=0.17 //l=0.125 //layer=li //thickness=0.1 \
 //x=1.13 //y=1.675 //x2=1.13 //y2=1.8
r71 (  1 29 ) resistor r=42.0963 //w=0.187 //l=0.615 //layer=li \
 //thickness=0.1 //x=1.13 //y=1.675 //x2=1.13 //y2=1.06
ends PM_DFFSNQNX1\%noxref_13

subckt PM_DFFSNQNX1\%noxref_14 ( 1 5 9 13 17 35 )
c53 ( 35 0 ) capacitor c=0.0680128f //x=4.22 //y=0.555
c54 ( 17 0 ) capacitor c=0.0184245f //x=6.21 //y=1.77
c55 ( 13 0 ) capacitor c=0.0155484f //x=6.21 //y=0.72
c56 ( 9 0 ) capacitor c=0.00678203f //x=5.325 //y=0.805
c57 ( 5 0 ) capacitor c=0.017077f //x=5.24 //y=1.77
c58 ( 1 0 ) capacitor c=0.00729042f //x=4.355 //y=1.685
r59 (  18 35 ) resistor r=5.4201 //w=0.17 //l=0.103078 //layer=li \
 //thickness=0.1 //x=5.41 //y=1.77 //x2=5.325 //y2=1.81
r60 (  18 35 ) resistor r=27.3797 //w=0.187 //l=0.4 //layer=li //thickness=0.1 \
 //x=5.41 //y=1.77 //x2=5.81 //y2=1.77
r61 (  17 35 ) resistor r=0.751729 //w=0.17 //l=0.085 //layer=li \
 //thickness=0.1 //x=6.21 //y=1.77 //x2=6.295 //y2=1.77
r62 (  17 35 ) resistor r=27.3797 //w=0.187 //l=0.4 //layer=li //thickness=0.1 \
 //x=6.21 //y=1.77 //x2=5.81 //y2=1.77
r63 (  14 35 ) resistor r=3.57586 //w=0.17 //l=0.103078 //layer=li \
 //thickness=0.1 //x=5.41 //y=0.72 //x2=5.325 //y2=0.68
r64 (  14 35 ) resistor r=27.3797 //w=0.187 //l=0.4 //layer=li //thickness=0.1 \
 //x=5.41 //y=0.72 //x2=5.81 //y2=0.72
r65 (  13 35 ) resistor r=0.751729 //w=0.17 //l=0.085 //layer=li \
 //thickness=0.1 //x=6.21 //y=0.72 //x2=6.295 //y2=0.72
r66 (  13 35 ) resistor r=27.3797 //w=0.187 //l=0.4 //layer=li //thickness=0.1 \
 //x=6.21 //y=0.72 //x2=5.81 //y2=0.72
r67 (  10 35 ) resistor r=1.40859 //w=0.34 //l=0.125 //layer=li \
 //thickness=0.1 //x=5.325 //y=1.685 //x2=5.325 //y2=1.81
r68 (  10 35 ) resistor r=42.0963 //w=0.187 //l=0.615 //layer=li \
 //thickness=0.1 //x=5.325 //y=1.685 //x2=5.325 //y2=1.07
r69 (  9 35 ) resistor r=3.57586 //w=0.17 //l=0.125 //layer=li //thickness=0.1 \
 //x=5.325 //y=0.805 //x2=5.325 //y2=0.68
r70 (  9 35 ) resistor r=18.139 //w=0.187 //l=0.265 //layer=li //thickness=0.1 \
 //x=5.325 //y=0.805 //x2=5.325 //y2=1.07
r71 (  6 35 ) resistor r=3.57586 //w=0.17 //l=0.103078 //layer=li \
 //thickness=0.1 //x=4.44 //y=1.77 //x2=4.355 //y2=1.81
r72 (  6 35 ) resistor r=27.3797 //w=0.187 //l=0.4 //layer=li //thickness=0.1 \
 //x=4.44 //y=1.77 //x2=4.84 //y2=1.77
r73 (  5 35 ) resistor r=5.4201 //w=0.17 //l=0.103078 //layer=li \
 //thickness=0.1 //x=5.24 //y=1.77 //x2=5.325 //y2=1.81
r74 (  5 35 ) resistor r=27.3797 //w=0.187 //l=0.4 //layer=li //thickness=0.1 \
 //x=5.24 //y=1.77 //x2=4.84 //y2=1.77
r75 (  1 35 ) resistor r=3.57586 //w=0.17 //l=0.125 //layer=li //thickness=0.1 \
 //x=4.355 //y=1.685 //x2=4.355 //y2=1.81
r76 (  1 35 ) resistor r=42.0963 //w=0.187 //l=0.615 //layer=li \
 //thickness=0.1 //x=4.355 //y=1.685 //x2=4.355 //y2=1.07
ends PM_DFFSNQNX1\%noxref_14

subckt PM_DFFSNQNX1\%noxref_15 ( 1 3 11 15 25 28 29 )
c53 ( 29 0 ) capacitor c=0.041888f //x=6.73 //y=0.555
c54 ( 28 0 ) capacitor c=0.00460056f //x=5.625 //y=1.09
c55 ( 25 0 ) capacitor c=0.00156479f //x=6.865 //y=1.175
c56 ( 15 0 ) capacitor c=0.00737666f //x=7.835 //y=0.805
c57 ( 11 0 ) capacitor c=0.0145763f //x=7.75 //y=0.72
c58 ( 3 0 ) capacitor c=0.00718386f //x=6.865 //y=0.805
c59 ( 1 0 ) capacitor c=0.022894f //x=6.78 //y=1.175
r60 (  15 29 ) resistor r=3.57586 //w=0.17 //l=0.125 //layer=li \
 //thickness=0.1 //x=7.835 //y=0.805 //x2=7.835 //y2=0.68
r61 (  15 29 ) resistor r=18.139 //w=0.187 //l=0.265 //layer=li \
 //thickness=0.1 //x=7.835 //y=0.805 //x2=7.835 //y2=1.07
r62 (  12 29 ) resistor r=3.57586 //w=0.17 //l=0.103078 //layer=li \
 //thickness=0.1 //x=6.95 //y=0.72 //x2=6.865 //y2=0.68
r63 (  12 29 ) resistor r=27.3797 //w=0.187 //l=0.4 //layer=li //thickness=0.1 \
 //x=6.95 //y=0.72 //x2=7.35 //y2=0.72
r64 (  11 29 ) resistor r=3.57586 //w=0.17 //l=0.103078 //layer=li \
 //thickness=0.1 //x=7.75 //y=0.72 //x2=7.835 //y2=0.68
r65 (  11 29 ) resistor r=27.3797 //w=0.187 //l=0.4 //layer=li //thickness=0.1 \
 //x=7.75 //y=0.72 //x2=7.35 //y2=0.72
r66 (  7 25 ) resistor r=5.4201 //w=0.17 //l=0.085 //layer=li //thickness=0.1 \
 //x=6.865 //y=1.26 //x2=6.865 //y2=1.175
r67 (  7 29 ) resistor r=10.2674 //w=0.187 //l=0.15 //layer=li //thickness=0.1 \
 //x=6.865 //y=1.26 //x2=6.865 //y2=1.41
r68 (  4 25 ) resistor r=5.4201 //w=0.17 //l=0.085 //layer=li //thickness=0.1 \
 //x=6.865 //y=1.09 //x2=6.865 //y2=1.175
r69 (  4 29 ) resistor r=1.36898 //w=0.187 //l=0.02 //layer=li //thickness=0.1 \
 //x=6.865 //y=1.09 //x2=6.865 //y2=1.07
r70 (  3 29 ) resistor r=3.57586 //w=0.17 //l=0.125 //layer=li //thickness=0.1 \
 //x=6.865 //y=0.805 //x2=6.865 //y2=0.68
r71 (  3 29 ) resistor r=18.139 //w=0.187 //l=0.265 //layer=li //thickness=0.1 \
 //x=6.865 //y=0.805 //x2=6.865 //y2=1.07
r72 (  2 28 ) resistor r=0.751729 //w=0.17 //l=0.085 //layer=li \
 //thickness=0.1 //x=5.9 //y=1.175 //x2=5.815 //y2=1.175
r73 (  1 25 ) resistor r=1.40859 //w=0.34 //l=0.085 //layer=li //thickness=0.1 \
 //x=6.78 //y=1.175 //x2=6.865 //y2=1.175
r74 (  1 2 ) resistor r=60.2353 //w=0.187 //l=0.88 //layer=li //thickness=0.1 \
 //x=6.78 //y=1.175 //x2=5.9 //y2=1.175
ends PM_DFFSNQNX1\%noxref_15

subckt PM_DFFSNQNX1\%noxref_16 ( 1 5 9 13 17 35 )
c54 ( 35 0 ) capacitor c=0.0685332f //x=9.03 //y=0.555
c55 ( 17 0 ) capacitor c=0.0201146f //x=11.02 //y=1.77
c56 ( 13 0 ) capacitor c=0.0155144f //x=11.02 //y=0.72
c57 ( 9 0 ) capacitor c=0.00678203f //x=10.135 //y=0.805
c58 ( 5 0 ) capacitor c=0.0181938f //x=10.05 //y=1.77
c59 ( 1 0 ) capacitor c=0.00729042f //x=9.165 //y=1.685
r60 (  18 35 ) resistor r=5.4201 //w=0.17 //l=0.103078 //layer=li \
 //thickness=0.1 //x=10.22 //y=1.77 //x2=10.135 //y2=1.81
r61 (  18 35 ) resistor r=27.3797 //w=0.187 //l=0.4 //layer=li //thickness=0.1 \
 //x=10.22 //y=1.77 //x2=10.62 //y2=1.77
r62 (  17 35 ) resistor r=0.751729 //w=0.17 //l=0.085 //layer=li \
 //thickness=0.1 //x=11.02 //y=1.77 //x2=11.105 //y2=1.77
r63 (  17 35 ) resistor r=27.3797 //w=0.187 //l=0.4 //layer=li //thickness=0.1 \
 //x=11.02 //y=1.77 //x2=10.62 //y2=1.77
r64 (  14 35 ) resistor r=3.57586 //w=0.17 //l=0.103078 //layer=li \
 //thickness=0.1 //x=10.22 //y=0.72 //x2=10.135 //y2=0.68
r65 (  14 35 ) resistor r=27.3797 //w=0.187 //l=0.4 //layer=li //thickness=0.1 \
 //x=10.22 //y=0.72 //x2=10.62 //y2=0.72
r66 (  13 35 ) resistor r=0.751729 //w=0.17 //l=0.085 //layer=li \
 //thickness=0.1 //x=11.02 //y=0.72 //x2=11.105 //y2=0.72
r67 (  13 35 ) resistor r=27.3797 //w=0.187 //l=0.4 //layer=li //thickness=0.1 \
 //x=11.02 //y=0.72 //x2=10.62 //y2=0.72
r68 (  10 35 ) resistor r=1.40859 //w=0.34 //l=0.125 //layer=li \
 //thickness=0.1 //x=10.135 //y=1.685 //x2=10.135 //y2=1.81
r69 (  10 35 ) resistor r=42.0963 //w=0.187 //l=0.615 //layer=li \
 //thickness=0.1 //x=10.135 //y=1.685 //x2=10.135 //y2=1.07
r70 (  9 35 ) resistor r=3.57586 //w=0.17 //l=0.125 //layer=li //thickness=0.1 \
 //x=10.135 //y=0.805 //x2=10.135 //y2=0.68
r71 (  9 35 ) resistor r=18.139 //w=0.187 //l=0.265 //layer=li //thickness=0.1 \
 //x=10.135 //y=0.805 //x2=10.135 //y2=1.07
r72 (  6 35 ) resistor r=3.57586 //w=0.17 //l=0.103078 //layer=li \
 //thickness=0.1 //x=9.25 //y=1.77 //x2=9.165 //y2=1.81
r73 (  6 35 ) resistor r=27.3797 //w=0.187 //l=0.4 //layer=li //thickness=0.1 \
 //x=9.25 //y=1.77 //x2=9.65 //y2=1.77
r74 (  5 35 ) resistor r=5.4201 //w=0.17 //l=0.103078 //layer=li \
 //thickness=0.1 //x=10.05 //y=1.77 //x2=10.135 //y2=1.81
r75 (  5 35 ) resistor r=27.3797 //w=0.187 //l=0.4 //layer=li //thickness=0.1 \
 //x=10.05 //y=1.77 //x2=9.65 //y2=1.77
r76 (  1 35 ) resistor r=3.57586 //w=0.17 //l=0.125 //layer=li //thickness=0.1 \
 //x=9.165 //y=1.685 //x2=9.165 //y2=1.81
r77 (  1 35 ) resistor r=42.0963 //w=0.187 //l=0.615 //layer=li \
 //thickness=0.1 //x=9.165 //y=1.685 //x2=9.165 //y2=1.07
ends PM_DFFSNQNX1\%noxref_16

subckt PM_DFFSNQNX1\%noxref_17 ( 1 3 11 15 25 28 29 )
c53 ( 29 0 ) capacitor c=0.0414744f //x=11.54 //y=0.555
c54 ( 28 0 ) capacitor c=0.00461914f //x=10.435 //y=1.09
c55 ( 25 0 ) capacitor c=0.00156479f //x=11.675 //y=1.175
c56 ( 15 0 ) capacitor c=0.00737666f //x=12.645 //y=0.805
c57 ( 11 0 ) capacitor c=0.0144274f //x=12.56 //y=0.72
c58 ( 3 0 ) capacitor c=0.00718386f //x=11.675 //y=0.805
c59 ( 1 0 ) capacitor c=0.0219986f //x=11.59 //y=1.175
r60 (  15 29 ) resistor r=3.57586 //w=0.17 //l=0.125 //layer=li \
 //thickness=0.1 //x=12.645 //y=0.805 //x2=12.645 //y2=0.68
r61 (  15 29 ) resistor r=18.139 //w=0.187 //l=0.265 //layer=li \
 //thickness=0.1 //x=12.645 //y=0.805 //x2=12.645 //y2=1.07
r62 (  12 29 ) resistor r=3.57586 //w=0.17 //l=0.103078 //layer=li \
 //thickness=0.1 //x=11.76 //y=0.72 //x2=11.675 //y2=0.68
r63 (  12 29 ) resistor r=27.3797 //w=0.187 //l=0.4 //layer=li //thickness=0.1 \
 //x=11.76 //y=0.72 //x2=12.16 //y2=0.72
r64 (  11 29 ) resistor r=3.57586 //w=0.17 //l=0.103078 //layer=li \
 //thickness=0.1 //x=12.56 //y=0.72 //x2=12.645 //y2=0.68
r65 (  11 29 ) resistor r=27.3797 //w=0.187 //l=0.4 //layer=li //thickness=0.1 \
 //x=12.56 //y=0.72 //x2=12.16 //y2=0.72
r66 (  7 25 ) resistor r=5.4201 //w=0.17 //l=0.085 //layer=li //thickness=0.1 \
 //x=11.675 //y=1.26 //x2=11.675 //y2=1.175
r67 (  7 29 ) resistor r=10.2674 //w=0.187 //l=0.15 //layer=li //thickness=0.1 \
 //x=11.675 //y=1.26 //x2=11.675 //y2=1.41
r68 (  4 25 ) resistor r=5.4201 //w=0.17 //l=0.085 //layer=li //thickness=0.1 \
 //x=11.675 //y=1.09 //x2=11.675 //y2=1.175
r69 (  4 29 ) resistor r=1.36898 //w=0.187 //l=0.02 //layer=li //thickness=0.1 \
 //x=11.675 //y=1.09 //x2=11.675 //y2=1.07
r70 (  3 29 ) resistor r=3.57586 //w=0.17 //l=0.125 //layer=li //thickness=0.1 \
 //x=11.675 //y=0.805 //x2=11.675 //y2=0.68
r71 (  3 29 ) resistor r=18.139 //w=0.187 //l=0.265 //layer=li //thickness=0.1 \
 //x=11.675 //y=0.805 //x2=11.675 //y2=1.07
r72 (  2 28 ) resistor r=0.751729 //w=0.17 //l=0.085 //layer=li \
 //thickness=0.1 //x=10.71 //y=1.175 //x2=10.625 //y2=1.175
r73 (  1 25 ) resistor r=1.40859 //w=0.34 //l=0.085 //layer=li //thickness=0.1 \
 //x=11.59 //y=1.175 //x2=11.675 //y2=1.175
r74 (  1 2 ) resistor r=60.2353 //w=0.187 //l=0.88 //layer=li //thickness=0.1 \
 //x=11.59 //y=1.175 //x2=10.71 //y2=1.175
ends PM_DFFSNQNX1\%noxref_17

subckt PM_DFFSNQNX1\%noxref_18 ( 1 5 9 10 13 17 29 )
c53 ( 29 0 ) capacitor c=0.0632682f //x=13.945 //y=0.545
c54 ( 17 0 ) capacitor c=0.00722223f //x=16.02 //y=0.795
c55 ( 13 0 ) capacitor c=0.0145149f //x=15.935 //y=0.71
c56 ( 10 0 ) capacitor c=0.00582081f //x=15.05 //y=1.675
c57 ( 9 0 ) capacitor c=0.006761f //x=15.05 //y=0.795
c58 ( 5 0 ) capacitor c=0.0173046f //x=14.965 //y=1.76
c59 ( 1 0 ) capacitor c=0.00733328f //x=14.08 //y=1.675
r60 (  17 29 ) resistor r=3.57586 //w=0.17 //l=0.125 //layer=li \
 //thickness=0.1 //x=16.02 //y=0.795 //x2=16.02 //y2=0.67
r61 (  17 29 ) resistor r=18.139 //w=0.187 //l=0.265 //layer=li \
 //thickness=0.1 //x=16.02 //y=0.795 //x2=16.02 //y2=1.06
r62 (  14 29 ) resistor r=3.57586 //w=0.17 //l=0.103078 //layer=li \
 //thickness=0.1 //x=15.135 //y=0.71 //x2=15.05 //y2=0.67
r63 (  14 29 ) resistor r=27.3797 //w=0.187 //l=0.4 //layer=li //thickness=0.1 \
 //x=15.135 //y=0.71 //x2=15.535 //y2=0.71
r64 (  13 29 ) resistor r=3.57586 //w=0.17 //l=0.103078 //layer=li \
 //thickness=0.1 //x=15.935 //y=0.71 //x2=16.02 //y2=0.67
r65 (  13 29 ) resistor r=27.3797 //w=0.187 //l=0.4 //layer=li //thickness=0.1 \
 //x=15.935 //y=0.71 //x2=15.535 //y2=0.71
r66 (  10 29 ) resistor r=3.57586 //w=0.17 //l=0.125 //layer=li \
 //thickness=0.1 //x=15.05 //y=1.675 //x2=15.05 //y2=1.8
r67 (  10 29 ) resistor r=42.0963 //w=0.187 //l=0.615 //layer=li \
 //thickness=0.1 //x=15.05 //y=1.675 //x2=15.05 //y2=1.06
r68 (  9 29 ) resistor r=3.57586 //w=0.17 //l=0.125 //layer=li //thickness=0.1 \
 //x=15.05 //y=0.795 //x2=15.05 //y2=0.67
r69 (  9 29 ) resistor r=18.139 //w=0.187 //l=0.265 //layer=li //thickness=0.1 \
 //x=15.05 //y=0.795 //x2=15.05 //y2=1.06
r70 (  6 29 ) resistor r=3.57586 //w=0.17 //l=0.103078 //layer=li \
 //thickness=0.1 //x=14.165 //y=1.76 //x2=14.08 //y2=1.8
r71 (  6 29 ) resistor r=27.3797 //w=0.187 //l=0.4 //layer=li //thickness=0.1 \
 //x=14.165 //y=1.76 //x2=14.565 //y2=1.76
r72 (  5 29 ) resistor r=3.57586 //w=0.17 //l=0.103078 //layer=li \
 //thickness=0.1 //x=14.965 //y=1.76 //x2=15.05 //y2=1.8
r73 (  5 29 ) resistor r=27.3797 //w=0.187 //l=0.4 //layer=li //thickness=0.1 \
 //x=14.965 //y=1.76 //x2=14.565 //y2=1.76
r74 (  1 29 ) resistor r=3.57586 //w=0.17 //l=0.125 //layer=li //thickness=0.1 \
 //x=14.08 //y=1.675 //x2=14.08 //y2=1.8
r75 (  1 29 ) resistor r=42.0963 //w=0.187 //l=0.615 //layer=li \
 //thickness=0.1 //x=14.08 //y=1.675 //x2=14.08 //y2=1.06
ends PM_DFFSNQNX1\%noxref_18

subckt PM_DFFSNQNX1\%noxref_19 ( 1 5 9 10 13 17 29 )
c53 ( 29 0 ) capacitor c=0.0631115f //x=17.275 //y=0.545
c54 ( 17 0 ) capacitor c=0.0072343f //x=19.35 //y=0.795
c55 ( 13 0 ) capacitor c=0.0145084f //x=19.265 //y=0.71
c56 ( 10 0 ) capacitor c=0.00582081f //x=18.38 //y=1.675
c57 ( 9 0 ) capacitor c=0.006761f //x=18.38 //y=0.795
c58 ( 5 0 ) capacitor c=0.0173046f //x=18.295 //y=1.76
c59 ( 1 0 ) capacitor c=0.00733328f //x=17.41 //y=1.675
r60 (  17 29 ) resistor r=3.57586 //w=0.17 //l=0.125 //layer=li \
 //thickness=0.1 //x=19.35 //y=0.795 //x2=19.35 //y2=0.67
r61 (  17 29 ) resistor r=18.139 //w=0.187 //l=0.265 //layer=li \
 //thickness=0.1 //x=19.35 //y=0.795 //x2=19.35 //y2=1.06
r62 (  14 29 ) resistor r=3.57586 //w=0.17 //l=0.103078 //layer=li \
 //thickness=0.1 //x=18.465 //y=0.71 //x2=18.38 //y2=0.67
r63 (  14 29 ) resistor r=27.3797 //w=0.187 //l=0.4 //layer=li //thickness=0.1 \
 //x=18.465 //y=0.71 //x2=18.865 //y2=0.71
r64 (  13 29 ) resistor r=3.57586 //w=0.17 //l=0.103078 //layer=li \
 //thickness=0.1 //x=19.265 //y=0.71 //x2=19.35 //y2=0.67
r65 (  13 29 ) resistor r=27.3797 //w=0.187 //l=0.4 //layer=li //thickness=0.1 \
 //x=19.265 //y=0.71 //x2=18.865 //y2=0.71
r66 (  10 29 ) resistor r=3.57586 //w=0.17 //l=0.125 //layer=li \
 //thickness=0.1 //x=18.38 //y=1.675 //x2=18.38 //y2=1.8
r67 (  10 29 ) resistor r=42.0963 //w=0.187 //l=0.615 //layer=li \
 //thickness=0.1 //x=18.38 //y=1.675 //x2=18.38 //y2=1.06
r68 (  9 29 ) resistor r=3.57586 //w=0.17 //l=0.125 //layer=li //thickness=0.1 \
 //x=18.38 //y=0.795 //x2=18.38 //y2=0.67
r69 (  9 29 ) resistor r=18.139 //w=0.187 //l=0.265 //layer=li //thickness=0.1 \
 //x=18.38 //y=0.795 //x2=18.38 //y2=1.06
r70 (  6 29 ) resistor r=3.57586 //w=0.17 //l=0.103078 //layer=li \
 //thickness=0.1 //x=17.495 //y=1.76 //x2=17.41 //y2=1.8
r71 (  6 29 ) resistor r=27.3797 //w=0.187 //l=0.4 //layer=li //thickness=0.1 \
 //x=17.495 //y=1.76 //x2=17.895 //y2=1.76
r72 (  5 29 ) resistor r=3.57586 //w=0.17 //l=0.103078 //layer=li \
 //thickness=0.1 //x=18.295 //y=1.76 //x2=18.38 //y2=1.8
r73 (  5 29 ) resistor r=27.3797 //w=0.187 //l=0.4 //layer=li //thickness=0.1 \
 //x=18.295 //y=1.76 //x2=17.895 //y2=1.76
r74 (  1 29 ) resistor r=3.57586 //w=0.17 //l=0.125 //layer=li //thickness=0.1 \
 //x=17.41 //y=1.675 //x2=17.41 //y2=1.8
r75 (  1 29 ) resistor r=42.0963 //w=0.187 //l=0.615 //layer=li \
 //thickness=0.1 //x=17.41 //y=1.675 //x2=17.41 //y2=1.06
ends PM_DFFSNQNX1\%noxref_19

subckt PM_DFFSNQNX1\%noxref_20 ( 1 5 9 13 17 35 )
c51 ( 35 0 ) capacitor c=0.0683476f //x=20.5 //y=0.555
c52 ( 17 0 ) capacitor c=0.017493f //x=22.49 //y=1.77
c53 ( 13 0 ) capacitor c=0.0155406f //x=22.49 //y=0.72
c54 ( 9 0 ) capacitor c=0.00678203f //x=21.605 //y=0.805
c55 ( 5 0 ) capacitor c=0.016138f //x=21.52 //y=1.77
c56 ( 1 0 ) capacitor c=0.00696517f //x=20.635 //y=1.685
r57 (  18 35 ) resistor r=5.4201 //w=0.17 //l=0.103078 //layer=li \
 //thickness=0.1 //x=21.69 //y=1.77 //x2=21.605 //y2=1.81
r58 (  18 35 ) resistor r=27.3797 //w=0.187 //l=0.4 //layer=li //thickness=0.1 \
 //x=21.69 //y=1.77 //x2=22.09 //y2=1.77
r59 (  17 35 ) resistor r=0.751729 //w=0.17 //l=0.085 //layer=li \
 //thickness=0.1 //x=22.49 //y=1.77 //x2=22.575 //y2=1.77
r60 (  17 35 ) resistor r=27.3797 //w=0.187 //l=0.4 //layer=li //thickness=0.1 \
 //x=22.49 //y=1.77 //x2=22.09 //y2=1.77
r61 (  14 35 ) resistor r=3.57586 //w=0.17 //l=0.103078 //layer=li \
 //thickness=0.1 //x=21.69 //y=0.72 //x2=21.605 //y2=0.68
r62 (  14 35 ) resistor r=27.3797 //w=0.187 //l=0.4 //layer=li //thickness=0.1 \
 //x=21.69 //y=0.72 //x2=22.09 //y2=0.72
r63 (  13 35 ) resistor r=0.751729 //w=0.17 //l=0.085 //layer=li \
 //thickness=0.1 //x=22.49 //y=0.72 //x2=22.575 //y2=0.72
r64 (  13 35 ) resistor r=27.3797 //w=0.187 //l=0.4 //layer=li //thickness=0.1 \
 //x=22.49 //y=0.72 //x2=22.09 //y2=0.72
r65 (  10 35 ) resistor r=1.40859 //w=0.34 //l=0.125 //layer=li \
 //thickness=0.1 //x=21.605 //y=1.685 //x2=21.605 //y2=1.81
r66 (  10 35 ) resistor r=42.0963 //w=0.187 //l=0.615 //layer=li \
 //thickness=0.1 //x=21.605 //y=1.685 //x2=21.605 //y2=1.07
r67 (  9 35 ) resistor r=3.57586 //w=0.17 //l=0.125 //layer=li //thickness=0.1 \
 //x=21.605 //y=0.805 //x2=21.605 //y2=0.68
r68 (  9 35 ) resistor r=18.139 //w=0.187 //l=0.265 //layer=li //thickness=0.1 \
 //x=21.605 //y=0.805 //x2=21.605 //y2=1.07
r69 (  6 35 ) resistor r=3.57586 //w=0.17 //l=0.103078 //layer=li \
 //thickness=0.1 //x=20.72 //y=1.77 //x2=20.635 //y2=1.81
r70 (  6 35 ) resistor r=27.3797 //w=0.187 //l=0.4 //layer=li //thickness=0.1 \
 //x=20.72 //y=1.77 //x2=21.12 //y2=1.77
r71 (  5 35 ) resistor r=5.4201 //w=0.17 //l=0.103078 //layer=li \
 //thickness=0.1 //x=21.52 //y=1.77 //x2=21.605 //y2=1.81
r72 (  5 35 ) resistor r=27.3797 //w=0.187 //l=0.4 //layer=li //thickness=0.1 \
 //x=21.52 //y=1.77 //x2=21.12 //y2=1.77
r73 (  1 35 ) resistor r=3.57586 //w=0.17 //l=0.125 //layer=li //thickness=0.1 \
 //x=20.635 //y=1.685 //x2=20.635 //y2=1.81
r74 (  1 35 ) resistor r=42.0963 //w=0.187 //l=0.615 //layer=li \
 //thickness=0.1 //x=20.635 //y=1.685 //x2=20.635 //y2=1.07
ends PM_DFFSNQNX1\%noxref_20

subckt PM_DFFSNQNX1\%noxref_21 ( 1 3 11 15 25 28 29 )
c50 ( 29 0 ) capacitor c=0.0425456f //x=23.01 //y=0.555
c51 ( 28 0 ) capacitor c=0.00457437f //x=21.905 //y=1.09
c52 ( 25 0 ) capacitor c=0.00156479f //x=23.145 //y=1.175
c53 ( 15 0 ) capacitor c=0.00737666f //x=24.115 //y=0.805
c54 ( 11 0 ) capacitor c=0.0147903f //x=24.03 //y=0.72
c55 ( 3 0 ) capacitor c=0.00718386f //x=23.145 //y=0.805
c56 ( 1 0 ) capacitor c=0.0239823f //x=23.06 //y=1.175
r57 (  15 29 ) resistor r=3.57586 //w=0.17 //l=0.125 //layer=li \
 //thickness=0.1 //x=24.115 //y=0.805 //x2=24.115 //y2=0.68
r58 (  15 29 ) resistor r=18.139 //w=0.187 //l=0.265 //layer=li \
 //thickness=0.1 //x=24.115 //y=0.805 //x2=24.115 //y2=1.07
r59 (  12 29 ) resistor r=3.57586 //w=0.17 //l=0.103078 //layer=li \
 //thickness=0.1 //x=23.23 //y=0.72 //x2=23.145 //y2=0.68
r60 (  12 29 ) resistor r=27.3797 //w=0.187 //l=0.4 //layer=li //thickness=0.1 \
 //x=23.23 //y=0.72 //x2=23.63 //y2=0.72
r61 (  11 29 ) resistor r=3.57586 //w=0.17 //l=0.103078 //layer=li \
 //thickness=0.1 //x=24.03 //y=0.72 //x2=24.115 //y2=0.68
r62 (  11 29 ) resistor r=27.3797 //w=0.187 //l=0.4 //layer=li //thickness=0.1 \
 //x=24.03 //y=0.72 //x2=23.63 //y2=0.72
r63 (  7 25 ) resistor r=5.4201 //w=0.17 //l=0.085 //layer=li //thickness=0.1 \
 //x=23.145 //y=1.26 //x2=23.145 //y2=1.175
r64 (  7 29 ) resistor r=10.2674 //w=0.187 //l=0.15 //layer=li //thickness=0.1 \
 //x=23.145 //y=1.26 //x2=23.145 //y2=1.41
r65 (  4 25 ) resistor r=5.4201 //w=0.17 //l=0.085 //layer=li //thickness=0.1 \
 //x=23.145 //y=1.09 //x2=23.145 //y2=1.175
r66 (  4 29 ) resistor r=1.36898 //w=0.187 //l=0.02 //layer=li //thickness=0.1 \
 //x=23.145 //y=1.09 //x2=23.145 //y2=1.07
r67 (  3 29 ) resistor r=3.57586 //w=0.17 //l=0.125 //layer=li //thickness=0.1 \
 //x=23.145 //y=0.805 //x2=23.145 //y2=0.68
r68 (  3 29 ) resistor r=18.139 //w=0.187 //l=0.265 //layer=li //thickness=0.1 \
 //x=23.145 //y=0.805 //x2=23.145 //y2=1.07
r69 (  2 28 ) resistor r=0.751729 //w=0.17 //l=0.085 //layer=li \
 //thickness=0.1 //x=22.18 //y=1.175 //x2=22.095 //y2=1.175
r70 (  1 25 ) resistor r=1.40859 //w=0.34 //l=0.085 //layer=li //thickness=0.1 \
 //x=23.06 //y=1.175 //x2=23.145 //y2=1.175
r71 (  1 2 ) resistor r=60.2353 //w=0.187 //l=0.88 //layer=li //thickness=0.1 \
 //x=23.06 //y=1.175 //x2=22.18 //y2=1.175
ends PM_DFFSNQNX1\%noxref_21
