// File: DFFSNQNX1.spi.pex
// Created: Sun Mar 15 12:40:45 2026
// Program "Calibre xRC"
// Version "v2023.2_27.15"
// Nominal Temperature: 30C
// Circuit Temperature: 30C
//
simulator lang=spectre
subckt PM_DFFSNQNX1\%noxref_1 ( 3 8 9 11 12 14 15 16 17 18 19 20 21 22 23 24 \
 27 28 31 33 36 43 47 54 55 57 64 65 68 76 93 102 107 116 120 121 122 123 124 \
 125 126 127 128 129 130 132 138 139 140 141 145 146 147 148 149 151 157 158 \
 159 160 180 182 183 )
c396 ( 180 0 ) capacitor c=0.00878249f //x=2.395 //y=1.085
c397 ( 160 0 ) capacitor c=0.0612936f //x=9.96 //y=4.97
c398 ( 159 0 ) capacitor c=0.0376642f //x=10.25 //y=4.97
c399 ( 158 0 ) capacitor c=0.0346489f //x=9.915 //y=1.4
c400 ( 157 0 ) capacitor c=0.018692f //x=9.915 //y=1.055
c401 ( 151 0 ) capacitor c=0.0137077f //x=9.76 //y=1.555
c402 ( 149 0 ) capacitor c=0.0158585f //x=9.76 //y=0.9
c403 ( 148 0 ) capacitor c=0.0979511f //x=9.385 //y=2.095
c404 ( 147 0 ) capacitor c=0.0229444f //x=9.385 //y=1.71
c405 ( 146 0 ) capacitor c=0.0234359f //x=9.385 //y=1.4
c406 ( 145 0 ) capacitor c=0.019815f //x=9.385 //y=1.055
c407 ( 141 0 ) capacitor c=0.0612936f //x=5.15 //y=4.97
c408 ( 140 0 ) capacitor c=0.0376642f //x=5.44 //y=4.97
c409 ( 139 0 ) capacitor c=0.0346489f //x=5.105 //y=1.4
c410 ( 138 0 ) capacitor c=0.018692f //x=5.105 //y=1.055
c411 ( 132 0 ) capacitor c=0.0137077f //x=4.95 //y=1.555
c412 ( 130 0 ) capacitor c=0.0158585f //x=4.95 //y=0.9
c413 ( 129 0 ) capacitor c=0.099553f //x=4.575 //y=2.095
c414 ( 128 0 ) capacitor c=0.0229444f //x=4.575 //y=1.71
c415 ( 127 0 ) capacitor c=0.0234359f //x=4.575 //y=1.4
c416 ( 126 0 ) capacitor c=0.019815f //x=4.575 //y=1.055
c417 ( 125 0 ) capacitor c=0.110208f //x=10.325 //y=6.2
c418 ( 124 0 ) capacitor c=0.158957f //x=9.885 //y=6.2
c419 ( 123 0 ) capacitor c=0.110208f //x=5.515 //y=6.2
c420 ( 122 0 ) capacitor c=0.158957f //x=5.075 //y=6.2
c421 ( 116 0 ) capacitor c=0.0014751f //x=9.685 //y=4.88
c422 ( 107 0 ) capacitor c=9.93222e-19 //x=9.685 //y=2.26
c423 ( 102 0 ) capacitor c=0.0014751f //x=4.875 //y=4.88
c424 ( 93 0 ) capacitor c=9.93222e-19 //x=4.875 //y=2.26
c425 ( 76 0 ) capacitor c=0.0322017f //x=2.545 //y=5.56
c426 ( 68 0 ) capacitor c=0.0292415f //x=1.665 //y=5.56
c427 ( 65 0 ) capacitor c=0.130893f //x=9.525 //y=2.775
c428 ( 64 0 ) capacitor c=0.00261551f //x=9.685 //y=2.775
c429 ( 57 0 ) capacitor c=0.00271088f //x=5.035 //y=2.77
c430 ( 55 0 ) capacitor c=0.00330852f //x=3.185 //y=2.77
c431 ( 54 0 ) capacitor c=0.0532299f //x=4.715 //y=2.77
c432 ( 47 0 ) capacitor c=0.0154699f //x=9.685 //y=2.77
c433 ( 43 0 ) capacitor c=0.0146914f //x=4.875 //y=2.765
c434 ( 36 0 ) capacitor c=0.0146635f //x=3.025 //y=2.77
c435 ( 33 0 ) capacitor c=0.0116755f //x=2.585 //y=1.18
c436 ( 31 0 ) capacitor c=5.78613e-19 //x=2.545 //y=5.56
c437 ( 28 0 ) capacitor c=0.0112565f //x=2.545 //y=5.38
c438 ( 27 0 ) capacitor c=0.0105186f //x=1.665 //y=5.56
c439 ( 24 0 ) capacitor c=0.0681753f //x=9.685 //y=4.755
c440 ( 23 0 ) capacitor c=0.0130542f //x=9.685 //y=2.935
c441 ( 22 0 ) capacitor c=0.0052305f //x=9.685 //y=2.615
c442 ( 21 0 ) capacitor c=0.00635496f //x=9.685 //y=2.375
c443 ( 20 0 ) capacitor c=0.0700832f //x=4.875 //y=4.755
c444 ( 19 0 ) capacitor c=0.0130965f //x=4.875 //y=2.93
c445 ( 18 0 ) capacitor c=0.00604005f //x=4.875 //y=2.61
c446 ( 17 0 ) capacitor c=0.00638932f //x=4.875 //y=2.375
c447 ( 16 0 ) capacitor c=0.0742593f //x=3.025 //y=5.295
c448 ( 15 0 ) capacitor c=0.0120956f //x=3.025 //y=2.93
c449 ( 14 0 ) capacitor c=0.0182566f //x=3.025 //y=2.61
c450 ( 12 0 ) capacitor c=0.00817318f //x=2.67 //y=1.835
c451 ( 11 0 ) capacitor c=0.0144018f //x=2.94 //y=1.835
c452 ( 9 0 ) capacitor c=0.0122194f //x=2.94 //y=5.38
c453 ( 8 0 ) capacitor c=0.0167748f //x=2.585 //y=1.75
c454 ( 3 0 ) capacitor c=0.0178188f //x=2.43 //y=5.38
r455 (  159 161 ) resistor r=26.9307 //w=0.15 //l=0.106066 //layer=ply \
 //thickness=0.18 //x=10.25 //y=4.97 //x2=10.325 //y2=5.045
r456 (  159 160 ) resistor r=148.702 //w=0.094 //l=0.29 //layer=ply \
 //thickness=0.18 //x=10.25 //y=4.97 //x2=9.96 //y2=4.97
r457 (  158 179 ) resistor r=45.1352 //w=0.168 //l=0.173853 //layer=ply \
 //thickness=0.18 //x=9.915 //y=1.4 //x2=9.875 //y2=1.555
r458 (  157 178 ) resistor r=45.1352 //w=0.168 //l=0.173853 //layer=ply \
 //thickness=0.18 //x=9.915 //y=1.055 //x2=9.875 //y2=0.9
r459 (  157 158 ) resistor r=176.904 //w=0.094 //l=0.345 //layer=ply \
 //thickness=0.18 //x=9.915 //y=1.055 //x2=9.915 //y2=1.4
r460 (  154 160 ) resistor r=22.7971 //w=0.269 //l=0.106066 //layer=ply \
 //thickness=0.18 //x=9.885 //y=5.045 //x2=9.96 //y2=4.97
r461 (  154 177 ) resistor r=35.8364 //w=0.269 //l=0.270185 //layer=ply \
 //thickness=0.18 //x=9.885 //y=5.045 //x2=9.685 //y2=4.88
r462 (  152 173 ) resistor r=10.701 //w=0.21 //l=0.115 //layer=ply \
 //thickness=0.18 //x=9.54 //y=1.555 //x2=9.425 //y2=1.555
r463 (  151 179 ) resistor r=5.52526 //w=0.168 //l=0.115 //layer=ply \
 //thickness=0.18 //x=9.76 //y=1.555 //x2=9.875 //y2=1.555
r464 (  150 172 ) resistor r=5.52526 //w=0.168 //l=0.115 //layer=ply \
 //thickness=0.18 //x=9.54 //y=0.9 //x2=9.425 //y2=0.9
r465 (  149 178 ) resistor r=5.52526 //w=0.168 //l=0.115 //layer=ply \
 //thickness=0.18 //x=9.76 //y=0.9 //x2=9.875 //y2=0.9
r466 (  149 150 ) resistor r=112.809 //w=0.094 //l=0.22 //layer=ply \
 //thickness=0.18 //x=9.76 //y=0.9 //x2=9.54 //y2=0.9
r467 (  148 175 ) resistor r=58.7805 //w=0.246 //l=0.373497 //layer=ply \
 //thickness=0.18 //x=9.385 //y=2.095 //x2=9.685 //y2=2.26
r468 (  147 173 ) resistor r=39.5823 //w=0.21 //l=0.173853 //layer=ply \
 //thickness=0.18 //x=9.385 //y=1.71 //x2=9.425 //y2=1.555
r469 (  147 148 ) resistor r=197.415 //w=0.094 //l=0.385 //layer=ply \
 //thickness=0.18 //x=9.385 //y=1.71 //x2=9.385 //y2=2.095
r470 (  146 173 ) resistor r=39.5823 //w=0.21 //l=0.173853 //layer=ply \
 //thickness=0.18 //x=9.385 //y=1.4 //x2=9.425 //y2=1.555
r471 (  145 172 ) resistor r=45.1352 //w=0.168 //l=0.173853 //layer=ply \
 //thickness=0.18 //x=9.385 //y=1.055 //x2=9.425 //y2=0.9
r472 (  145 146 ) resistor r=176.904 //w=0.094 //l=0.345 //layer=ply \
 //thickness=0.18 //x=9.385 //y=1.055 //x2=9.385 //y2=1.4
r473 (  140 142 ) resistor r=26.9307 //w=0.15 //l=0.106066 //layer=ply \
 //thickness=0.18 //x=5.44 //y=4.97 //x2=5.515 //y2=5.045
r474 (  140 141 ) resistor r=148.702 //w=0.094 //l=0.29 //layer=ply \
 //thickness=0.18 //x=5.44 //y=4.97 //x2=5.15 //y2=4.97
r475 (  139 171 ) resistor r=45.1352 //w=0.168 //l=0.173853 //layer=ply \
 //thickness=0.18 //x=5.105 //y=1.4 //x2=5.065 //y2=1.555
r476 (  138 170 ) resistor r=45.1352 //w=0.168 //l=0.173853 //layer=ply \
 //thickness=0.18 //x=5.105 //y=1.055 //x2=5.065 //y2=0.9
r477 (  138 139 ) resistor r=176.904 //w=0.094 //l=0.345 //layer=ply \
 //thickness=0.18 //x=5.105 //y=1.055 //x2=5.105 //y2=1.4
r478 (  135 141 ) resistor r=22.7971 //w=0.269 //l=0.106066 //layer=ply \
 //thickness=0.18 //x=5.075 //y=5.045 //x2=5.15 //y2=4.97
r479 (  135 169 ) resistor r=35.8364 //w=0.269 //l=0.270185 //layer=ply \
 //thickness=0.18 //x=5.075 //y=5.045 //x2=4.875 //y2=4.88
r480 (  133 165 ) resistor r=10.701 //w=0.21 //l=0.115 //layer=ply \
 //thickness=0.18 //x=4.73 //y=1.555 //x2=4.615 //y2=1.555
r481 (  132 171 ) resistor r=5.52526 //w=0.168 //l=0.115 //layer=ply \
 //thickness=0.18 //x=4.95 //y=1.555 //x2=5.065 //y2=1.555
r482 (  131 164 ) resistor r=5.52526 //w=0.168 //l=0.115 //layer=ply \
 //thickness=0.18 //x=4.73 //y=0.9 //x2=4.615 //y2=0.9
r483 (  130 170 ) resistor r=5.52526 //w=0.168 //l=0.115 //layer=ply \
 //thickness=0.18 //x=4.95 //y=0.9 //x2=5.065 //y2=0.9
r484 (  130 131 ) resistor r=112.809 //w=0.094 //l=0.22 //layer=ply \
 //thickness=0.18 //x=4.95 //y=0.9 //x2=4.73 //y2=0.9
r485 (  129 167 ) resistor r=58.7805 //w=0.246 //l=0.373497 //layer=ply \
 //thickness=0.18 //x=4.575 //y=2.095 //x2=4.875 //y2=2.26
r486 (  128 165 ) resistor r=39.5823 //w=0.21 //l=0.173853 //layer=ply \
 //thickness=0.18 //x=4.575 //y=1.71 //x2=4.615 //y2=1.555
r487 (  128 129 ) resistor r=197.415 //w=0.094 //l=0.385 //layer=ply \
 //thickness=0.18 //x=4.575 //y=1.71 //x2=4.575 //y2=2.095
r488 (  127 165 ) resistor r=39.5823 //w=0.21 //l=0.173853 //layer=ply \
 //thickness=0.18 //x=4.575 //y=1.4 //x2=4.615 //y2=1.555
r489 (  126 164 ) resistor r=45.1352 //w=0.168 //l=0.173853 //layer=ply \
 //thickness=0.18 //x=4.575 //y=1.055 //x2=4.615 //y2=0.9
r490 (  126 127 ) resistor r=176.904 //w=0.094 //l=0.345 //layer=ply \
 //thickness=0.18 //x=4.575 //y=1.055 //x2=4.575 //y2=1.4
r491 (  125 161 ) resistor r=592.245 //w=0.094 //l=1.155 //layer=ply \
 //thickness=0.18 //x=10.325 //y=6.2 //x2=10.325 //y2=5.045
r492 (  124 154 ) resistor r=592.245 //w=0.094 //l=1.155 //layer=ply \
 //thickness=0.18 //x=9.885 //y=6.2 //x2=9.885 //y2=5.045
r493 (  123 142 ) resistor r=592.245 //w=0.094 //l=1.155 //layer=ply \
 //thickness=0.18 //x=5.515 //y=6.2 //x2=5.515 //y2=5.045
r494 (  122 135 ) resistor r=592.245 //w=0.094 //l=1.155 //layer=ply \
 //thickness=0.18 //x=5.075 //y=6.2 //x2=5.075 //y2=5.045
r495 (  121 151 ) resistor r=56.4043 //w=0.094 //l=0.11 //layer=ply \
 //thickness=0.18 //x=9.65 //y=1.555 //x2=9.76 //y2=1.555
r496 (  121 152 ) resistor r=56.4043 //w=0.094 //l=0.11 //layer=ply \
 //thickness=0.18 //x=9.65 //y=1.555 //x2=9.54 //y2=1.555
r497 (  120 132 ) resistor r=56.4043 //w=0.094 //l=0.11 //layer=ply \
 //thickness=0.18 //x=4.84 //y=1.555 //x2=4.95 //y2=1.555
r498 (  120 133 ) resistor r=56.4043 //w=0.094 //l=0.11 //layer=ply \
 //thickness=0.18 //x=4.84 //y=1.555 //x2=4.73 //y2=1.555
r499 (  116 177 ) resistor r=152 //w=0.17 //l=0.17 //layer=licon //count=1 \
 //x=9.685 //y=4.88 //x2=9.685 //y2=4.88
r500 (  107 175 ) resistor r=152 //w=0.17 //l=0.17 //layer=licon //count=1 \
 //x=9.685 //y=2.26 //x2=9.685 //y2=2.26
r501 (  102 169 ) resistor r=152 //w=0.17 //l=0.17 //layer=licon //count=1 \
 //x=4.875 //y=4.88 //x2=4.875 //y2=4.88
r502 (  93 167 ) resistor r=152 //w=0.17 //l=0.17 //layer=licon //count=1 \
 //x=4.875 //y=2.26 //x2=4.875 //y2=2.26
r503 (  76 183 ) resistor r=23.615 //w=0.187 //l=0.345 //layer=li \
 //thickness=0.1 //x=2.545 //y=5.56 //x2=2.545 //y2=5.905
r504 (  68 182 ) resistor r=23.615 //w=0.187 //l=0.345 //layer=li \
 //thickness=0.1 //x=1.665 //y=5.56 //x2=1.665 //y2=5.905
r505 (  64 65 ) resistor r=0.10734 //w=0.281 //l=0.16 //layer=m2 \
 //thickness=0.36 //x=9.685 //y=2.775 //x2=9.525 //y2=2.775
r506 (  57 62 ) resistor r=0.10734 //w=0.281 //l=0.16 //layer=m2 \
 //thickness=0.36 //x=5.035 //y=2.77 //x2=4.875 //y2=2.77
r507 (  57 65 ) resistor r=4.28435 //w=0.131 //l=4.49 //layer=m2 \
 //thickness=0.36 //x=5.035 //y=2.77 //x2=9.525 //y2=2.77
r508 (  55 59 ) resistor r=0.10734 //w=0.281 //l=0.16 //layer=m2 \
 //thickness=0.36 //x=3.185 //y=2.77 //x2=3.025 //y2=2.77
r509 (  54 62 ) resistor r=0.10734 //w=0.281 //l=0.16 //layer=m2 \
 //thickness=0.36 //x=4.715 //y=2.77 //x2=4.875 //y2=2.77
r510 (  54 55 ) resistor r=1.45992 //w=0.131 //l=1.53 //layer=m2 \
 //thickness=0.36 //x=4.715 //y=2.77 //x2=3.185 //y2=2.77
r511 (  53 116 ) resistor r=9.3 //w=0.17 //l=0.17 //layer=mcon //count=1 \
 //x=9.685 //y=4.88 //x2=9.685 //y2=4.88
r512 (  51 107 ) resistor r=9.3 //w=0.17 //l=0.17 //layer=mcon //count=1 \
 //x=9.685 //y=2.26 //x2=9.685 //y2=2.26
r513 (  49 64 ) resistor r=4.5 //w=0.15 //l=0.15 //layer=via1 //count=1 \
 //x=9.685 //y=2.775 //x2=9.685 //y2=2.775
r514 (  47 49 ) resistor r=0.00166223 //w=0.376 //l=0.005 //layer=m1 \
 //thickness=0.36 //x=9.632 //y=2.77 //x2=9.632 //y2=2.775
r515 (  45 62 ) resistor r=4.5 //w=0.15 //l=0.15 //layer=via1 //count=1 \
 //x=4.875 //y=2.77 //x2=4.875 //y2=2.77
r516 (  43 45 ) resistor r=0.00166223 //w=0.376 //l=0.005 //layer=m1 \
 //thickness=0.36 //x=4.927 //y=2.765 //x2=4.927 //y2=2.77
r517 (  41 102 ) resistor r=9.3 //w=0.17 //l=0.17 //layer=mcon //count=1 \
 //x=4.875 //y=4.88 //x2=4.875 //y2=4.88
r518 (  39 93 ) resistor r=9.3 //w=0.17 //l=0.17 //layer=mcon //count=1 \
 //x=4.875 //y=2.26 //x2=4.875 //y2=2.26
r519 (  36 59 ) resistor r=4.5 //w=0.15 //l=0.15 //layer=via1 //count=1 \
 //x=3.025 //y=2.77 //x2=3.025 //y2=2.77
r520 (  33 180 ) resistor r=9.3 //w=0.17 //l=0.17 //layer=mcon //count=1 \
 //x=2.585 //y=1.18 //x2=2.585 //y2=1.18
r521 (  31 76 ) resistor r=9.3 //w=0.17 //l=0.17 //layer=mcon //count=1 \
 //x=2.545 //y=5.56 //x2=2.545 //y2=5.56
r522 (  28 31 ) resistor r=0.117801 //w=0.191 //l=0.18 //layer=m1 \
 //thickness=0.36 //x=2.545 //y=5.38 //x2=2.545 //y2=5.56
r523 (  27 68 ) resistor r=9.3 //w=0.17 //l=0.17 //layer=mcon //count=1 \
 //x=1.665 //y=5.56 //x2=1.665 //y2=5.56
r524 (  25 27 ) resistor r=0.10274 //w=0.219 //l=0.18 //layer=m1 \
 //thickness=0.36 //x=1.665 //y=5.38 //x2=1.665 //y2=5.56
r525 (  24 53 ) resistor r=0.0760407 //w=0.238 //l=0.125 //layer=m1 \
 //thickness=0.36 //x=9.685 //y=4.755 //x2=9.685 //y2=4.88
r526 (  23 49 ) resistor r=0.0911593 //w=0.376 //l=0.184608 //layer=m1 \
 //thickness=0.36 //x=9.685 //y=2.935 //x2=9.632 //y2=2.775
r527 (  23 24 ) resistor r=1.73664 //w=0.131 //l=1.82 //layer=m1 \
 //thickness=0.36 //x=9.685 //y=2.935 //x2=9.685 //y2=4.755
r528 (  22 47 ) resistor r=0.0894971 //w=0.376 //l=0.179555 //layer=m1 \
 //thickness=0.36 //x=9.685 //y=2.615 //x2=9.632 //y2=2.77
r529 (  21 51 ) resistor r=0.0719237 //w=0.222 //l=0.115 //layer=m1 \
 //thickness=0.36 //x=9.685 //y=2.375 //x2=9.685 //y2=2.26
r530 (  21 22 ) resistor r=0.229008 //w=0.131 //l=0.24 //layer=m1 \
 //thickness=0.36 //x=9.685 //y=2.375 //x2=9.685 //y2=2.615
r531 (  20 41 ) resistor r=0.0760407 //w=0.238 //l=0.125 //layer=m1 \
 //thickness=0.36 //x=4.875 //y=4.755 //x2=4.875 //y2=4.88
r532 (  19 45 ) resistor r=0.0911593 //w=0.376 //l=0.184174 //layer=m1 \
 //thickness=0.36 //x=4.875 //y=2.93 //x2=4.927 //y2=2.77
r533 (  19 20 ) resistor r=1.74141 //w=0.131 //l=1.825 //layer=m1 \
 //thickness=0.36 //x=4.875 //y=2.93 //x2=4.875 //y2=4.755
r534 (  18 43 ) resistor r=0.0894971 //w=0.376 //l=0.179123 //layer=m1 \
 //thickness=0.36 //x=4.875 //y=2.61 //x2=4.927 //y2=2.765
r535 (  17 39 ) resistor r=0.0719237 //w=0.222 //l=0.115 //layer=m1 \
 //thickness=0.36 //x=4.875 //y=2.375 //x2=4.875 //y2=2.26
r536 (  17 18 ) resistor r=0.224237 //w=0.131 //l=0.235 //layer=m1 \
 //thickness=0.36 //x=4.875 //y=2.375 //x2=4.875 //y2=2.61
r537 (  15 36 ) resistor r=0.0911593 //w=0.376 //l=0.184174 //layer=m1 \
 //thickness=0.36 //x=3.025 //y=2.93 //x2=3.077 //y2=2.77
r538 (  15 16 ) resistor r=2.25668 //w=0.131 //l=2.365 //layer=m1 \
 //thickness=0.36 //x=3.025 //y=2.93 //x2=3.025 //y2=5.295
r539 (  14 36 ) resistor r=0.0911593 //w=0.376 //l=0.184174 //layer=m1 \
 //thickness=0.36 //x=3.025 //y=2.61 //x2=3.077 //y2=2.77
r540 (  13 14 ) resistor r=0.658397 //w=0.131 //l=0.69 //layer=m1 \
 //thickness=0.36 //x=3.025 //y=1.92 //x2=3.025 //y2=2.61
r541 (  11 13 ) resistor r=0.0698411 //w=0.17 //l=0.120208 //layer=m1 \
 //thickness=0.36 //x=2.94 //y=1.835 //x2=3.025 //y2=1.92
r542 (  11 12 ) resistor r=0.257634 //w=0.131 //l=0.27 //layer=m1 \
 //thickness=0.36 //x=2.94 //y=1.835 //x2=2.67 //y2=1.835
r543 (  10 28 ) resistor r=0.0257089 //w=0.23 //l=0.115 //layer=m1 \
 //thickness=0.36 //x=2.66 //y=5.38 //x2=2.545 //y2=5.38
r544 (  9 16 ) resistor r=0.0698411 //w=0.17 //l=0.120208 //layer=m1 \
 //thickness=0.36 //x=2.94 //y=5.38 //x2=3.025 //y2=5.295
r545 (  9 10 ) resistor r=0.267176 //w=0.131 //l=0.28 //layer=m1 \
 //thickness=0.36 //x=2.94 //y=5.38 //x2=2.66 //y2=5.38
r546 (  8 12 ) resistor r=0.0698411 //w=0.17 //l=0.120208 //layer=m1 \
 //thickness=0.36 //x=2.585 //y=1.75 //x2=2.67 //y2=1.835
r547 (  7 33 ) resistor r=0.0913624 //w=0.191 //l=0.12 //layer=m1 \
 //thickness=0.36 //x=2.585 //y=1.3 //x2=2.585 //y2=1.18
r548 (  7 8 ) resistor r=0.429389 //w=0.131 //l=0.45 //layer=m1 \
 //thickness=0.36 //x=2.585 //y=1.3 //x2=2.585 //y2=1.75
r549 (  4 25 ) resistor r=0.0227762 //w=0.219 //l=0.115 //layer=m1 \
 //thickness=0.36 //x=1.78 //y=5.38 //x2=1.665 //y2=5.38
r550 (  3 28 ) resistor r=0.0257089 //w=0.23 //l=0.115 //layer=m1 \
 //thickness=0.36 //x=2.43 //y=5.38 //x2=2.545 //y2=5.38
r551 (  3 4 ) resistor r=0.620229 //w=0.131 //l=0.65 //layer=m1 \
 //thickness=0.36 //x=2.43 //y=5.38 //x2=1.78 //y2=5.38
ends PM_DFFSNQNX1\%noxref_1

subckt PM_DFFSNQNX1\%noxref_2 ( 1 3 6 7 9 10 11 12 14 15 16 18 19 21 24 27 33 \
 37 41 44 45 52 54 55 58 66 74 91 100 104 105 106 107 108 109 110 114 116 119 \
 120 130 133 135 136 137 )
c287 ( 133 0 ) capacitor c=0.00885916f //x=11.97 //y=1.095
c288 ( 130 0 ) capacitor c=0.0682508f //x=14.495 //y=4.88
c289 ( 120 0 ) capacitor c=0.0318956f //x=14.83 //y=1.39
c290 ( 119 0 ) capacitor c=0.0186809f //x=14.83 //y=1.045
c291 ( 116 0 ) capacitor c=0.0141821f //x=14.675 //y=1.545
c292 ( 114 0 ) capacitor c=0.0158553f //x=14.675 //y=0.89
c293 ( 110 0 ) capacitor c=0.0815114f //x=14.3 //y=2.095
c294 ( 109 0 ) capacitor c=0.0229235f //x=14.3 //y=1.7
c295 ( 108 0 ) capacitor c=0.0234359f //x=14.3 //y=1.39
c296 ( 107 0 ) capacitor c=0.0198759f //x=14.3 //y=1.045
c297 ( 106 0 ) capacitor c=0.110369f //x=14.835 //y=6.2
c298 ( 105 0 ) capacitor c=0.154619f //x=14.395 //y=6.2
c299 ( 100 0 ) capacitor c=8.13425e-19 //x=14.495 //y=4.88
c300 ( 91 0 ) capacitor c=5.17312e-19 //x=14.495 //y=2.26
c301 ( 74 0 ) capacitor c=0.0293219f //x=11.865 //y=5.56
c302 ( 66 0 ) capacitor c=0.029137f //x=10.985 //y=5.56
c303 ( 58 0 ) capacitor c=0.0278099f //x=10.105 //y=5.56
c304 ( 55 0 ) capacitor c=0.024619f //x=14.33 //y=2.785
c305 ( 54 0 ) capacitor c=7.98676e-19 //x=14.49 //y=2.785
c306 ( 52 0 ) capacitor c=0.00129706f //x=12.805 //y=2.785
c307 ( 45 0 ) capacitor c=0.054494f //x=14.497 //y=4.74
c308 ( 44 0 ) capacitor c=0.00631721f //x=14.495 //y=4.88
c309 ( 41 0 ) capacitor c=0.00463527f //x=14.495 //y=2.26
c310 ( 37 0 ) capacitor c=0.0145985f //x=14.495 //y=2.77
c311 ( 33 0 ) capacitor c=0.0149529f //x=12.645 //y=2.77
c312 ( 27 0 ) capacitor c=8.88597e-19 //x=11.865 //y=5.335
c313 ( 24 0 ) capacitor c=0.00796615f //x=10.985 //y=5.335
c314 ( 21 0 ) capacitor c=0.0111234f //x=10.107 //y=5.335
c315 ( 19 0 ) capacitor c=0.0120672f //x=14.495 //y=2.945
c316 ( 18 0 ) capacitor c=0.00384658f //x=14.495 //y=2.625
c317 ( 16 0 ) capacitor c=0.06877f //x=12.645 //y=5.25
c318 ( 15 0 ) capacitor c=0.0124098f //x=12.645 //y=2.945
c319 ( 14 0 ) capacitor c=0.0168574f //x=12.645 //y=2.625
c320 ( 12 0 ) capacitor c=0.00493487f //x=12.245 //y=1.845
c321 ( 11 0 ) capacitor c=0.0126211f //x=12.56 //y=1.845
c322 ( 10 0 ) capacitor c=0.0136149f //x=12.16 //y=1.76
c323 ( 9 0 ) capacitor c=0.0113786f //x=12.16 //y=1.305
c324 ( 7 0 ) capacitor c=0.0235567f //x=12.56 //y=5.335
c325 ( 6 0 ) capacitor c=0.00906713f //x=11.865 //y=5.56
c326 ( 3 0 ) capacitor c=0.0180822f //x=11.75 //y=5.335
c327 ( 1 0 ) capacitor c=0.0152149f //x=10.865 //y=5.335
r328 (  128 130 ) resistor r=20.6867 //w=0.233 //l=0.1 //layer=ply \
 //thickness=0.18 //x=14.395 //y=4.88 //x2=14.495 //y2=4.88
r329 (  121 130 ) resistor r=70.3348 //w=0.233 //l=0.414367 //layer=ply \
 //thickness=0.18 //x=14.835 //y=5.045 //x2=14.495 //y2=4.88
r330 (  120 132 ) resistor r=45.1352 //w=0.168 //l=0.173853 //layer=ply \
 //thickness=0.18 //x=14.83 //y=1.39 //x2=14.79 //y2=1.545
r331 (  119 131 ) resistor r=45.1352 //w=0.168 //l=0.173853 //layer=ply \
 //thickness=0.18 //x=14.83 //y=1.045 //x2=14.79 //y2=0.89
r332 (  119 120 ) resistor r=176.904 //w=0.094 //l=0.345 //layer=ply \
 //thickness=0.18 //x=14.83 //y=1.045 //x2=14.83 //y2=1.39
r333 (  117 127 ) resistor r=10.701 //w=0.21 //l=0.115 //layer=ply \
 //thickness=0.18 //x=14.455 //y=1.545 //x2=14.34 //y2=1.545
r334 (  116 132 ) resistor r=5.52526 //w=0.168 //l=0.115 //layer=ply \
 //thickness=0.18 //x=14.675 //y=1.545 //x2=14.79 //y2=1.545
r335 (  115 126 ) resistor r=5.52526 //w=0.168 //l=0.115 //layer=ply \
 //thickness=0.18 //x=14.455 //y=0.89 //x2=14.34 //y2=0.89
r336 (  114 131 ) resistor r=5.52526 //w=0.168 //l=0.115 //layer=ply \
 //thickness=0.18 //x=14.675 //y=0.89 //x2=14.79 //y2=0.89
r337 (  114 115 ) resistor r=112.809 //w=0.094 //l=0.22 //layer=ply \
 //thickness=0.18 //x=14.675 //y=0.89 //x2=14.455 //y2=0.89
r338 (  111 128 ) resistor r=13.0941 //w=0.233 //l=0.165 //layer=ply \
 //thickness=0.18 //x=14.395 //y=5.045 //x2=14.395 //y2=4.88
r339 (  110 125 ) resistor r=34.8111 //w=0.27 //l=0.264953 //layer=ply \
 //thickness=0.18 //x=14.3 //y=2.095 //x2=14.495 //y2=2.26
r340 (  109 127 ) resistor r=39.5823 //w=0.21 //l=0.173853 //layer=ply \
 //thickness=0.18 //x=14.3 //y=1.7 //x2=14.34 //y2=1.545
r341 (  109 110 ) resistor r=202.543 //w=0.094 //l=0.395 //layer=ply \
 //thickness=0.18 //x=14.3 //y=1.7 //x2=14.3 //y2=2.095
r342 (  108 127 ) resistor r=39.5823 //w=0.21 //l=0.173853 //layer=ply \
 //thickness=0.18 //x=14.3 //y=1.39 //x2=14.34 //y2=1.545
r343 (  107 126 ) resistor r=45.1352 //w=0.168 //l=0.173853 //layer=ply \
 //thickness=0.18 //x=14.3 //y=1.045 //x2=14.34 //y2=0.89
r344 (  107 108 ) resistor r=176.904 //w=0.094 //l=0.345 //layer=ply \
 //thickness=0.18 //x=14.3 //y=1.045 //x2=14.3 //y2=1.39
r345 (  106 121 ) resistor r=592.245 //w=0.094 //l=1.155 //layer=ply \
 //thickness=0.18 //x=14.835 //y=6.2 //x2=14.835 //y2=5.045
r346 (  105 111 ) resistor r=592.245 //w=0.094 //l=1.155 //layer=ply \
 //thickness=0.18 //x=14.395 //y=6.2 //x2=14.395 //y2=5.045
r347 (  104 116 ) resistor r=56.4043 //w=0.094 //l=0.11 //layer=ply \
 //thickness=0.18 //x=14.565 //y=1.545 //x2=14.675 //y2=1.545
r348 (  104 117 ) resistor r=56.4043 //w=0.094 //l=0.11 //layer=ply \
 //thickness=0.18 //x=14.565 //y=1.545 //x2=14.455 //y2=1.545
r349 (  100 130 ) resistor r=152 //w=0.17 //l=0.17 //layer=licon //count=1 \
 //x=14.495 //y=4.88 //x2=14.495 //y2=4.88
r350 (  91 125 ) resistor r=152 //w=0.17 //l=0.17 //layer=licon //count=1 \
 //x=14.495 //y=2.26 //x2=14.495 //y2=2.26
r351 (  74 137 ) resistor r=23.615 //w=0.187 //l=0.345 //layer=li \
 //thickness=0.1 //x=11.865 //y=5.56 //x2=11.865 //y2=5.905
r352 (  66 136 ) resistor r=23.615 //w=0.187 //l=0.345 //layer=li \
 //thickness=0.1 //x=10.985 //y=5.56 //x2=10.985 //y2=5.905
r353 (  58 135 ) resistor r=23.615 //w=0.187 //l=0.345 //layer=li \
 //thickness=0.1 //x=10.105 //y=5.56 //x2=10.105 //y2=5.905
r354 (  54 55 ) resistor r=0.10734 //w=0.281 //l=0.16 //layer=m2 \
 //thickness=0.36 //x=14.49 //y=2.785 //x2=14.33 //y2=2.785
r355 (  52 55 ) resistor r=1.45515 //w=0.131 //l=1.525 //layer=m2 \
 //thickness=0.36 //x=12.805 //y=2.77 //x2=14.33 //y2=2.77
r356 (  50 52 ) resistor r=0.10734 //w=0.281 //l=0.16 //layer=m2 \
 //thickness=0.36 //x=12.645 //y=2.785 //x2=12.805 //y2=2.785
r357 (  44 100 ) resistor r=9.3 //w=0.17 //l=0.17 //layer=mcon //count=1 \
 //x=14.495 //y=4.88 //x2=14.495 //y2=4.88
r358 (  44 45 ) resistor r=0.103207 //w=0.196 //l=0.14 //layer=m1 \
 //thickness=0.36 //x=14.497 //y=4.88 //x2=14.497 //y2=4.74
r359 (  41 91 ) resistor r=9.3 //w=0.17 //l=0.17 //layer=mcon //count=1 \
 //x=14.495 //y=2.26 //x2=14.495 //y2=2.26
r360 (  39 54 ) resistor r=4.5 //w=0.15 //l=0.15 //layer=via1 //count=1 \
 //x=14.49 //y=2.785 //x2=14.49 //y2=2.785
r361 (  37 39 ) resistor r=0.00501337 //w=0.374 //l=0.015 //layer=m1 \
 //thickness=0.36 //x=14.44 //y=2.77 //x2=14.44 //y2=2.785
r362 (  35 50 ) resistor r=4.5 //w=0.15 //l=0.15 //layer=via1 //count=1 \
 //x=12.645 //y=2.785 //x2=12.645 //y2=2.785
r363 (  33 35 ) resistor r=0.0049867 //w=0.376 //l=0.015 //layer=m1 \
 //thickness=0.36 //x=12.697 //y=2.77 //x2=12.697 //y2=2.785
r364 (  31 133 ) resistor r=9.3 //w=0.17 //l=0.17 //layer=mcon //count=1 \
 //x=12.16 //y=1.19 //x2=12.16 //y2=1.19
r365 (  29 74 ) resistor r=9.3 //w=0.17 //l=0.17 //layer=mcon //count=1 \
 //x=11.865 //y=5.56 //x2=11.865 //y2=5.56
r366 (  26 66 ) resistor r=9.3 //w=0.17 //l=0.17 //layer=mcon //count=1 \
 //x=10.985 //y=5.56 //x2=10.985 //y2=5.56
r367 (  24 26 ) resistor r=0.121228 //w=0.232 //l=0.225 //layer=m1 \
 //thickness=0.36 //x=10.985 //y=5.335 //x2=10.985 //y2=5.56
r368 (  23 58 ) resistor r=9.3 //w=0.17 //l=0.17 //layer=mcon //count=1 \
 //x=10.105 //y=5.56 //x2=10.105 //y2=5.56
r369 (  21 23 ) resistor r=0.129608 //w=0.217 //l=0.225 //layer=m1 \
 //thickness=0.36 //x=10.107 //y=5.335 //x2=10.107 //y2=5.56
r370 (  19 39 ) resistor r=0.0910802 //w=0.374 //l=0.185472 //layer=m1 \
 //thickness=0.36 //x=14.495 //y=2.945 //x2=14.44 //y2=2.785
r371 (  19 45 ) resistor r=1.71279 //w=0.131 //l=1.795 //layer=m1 \
 //thickness=0.36 //x=14.495 //y=2.945 //x2=14.495 //y2=4.74
r372 (  18 37 ) resistor r=0.0860668 //w=0.374 //l=0.170294 //layer=m1 \
 //thickness=0.36 //x=14.495 //y=2.625 //x2=14.44 //y2=2.77
r373 (  17 41 ) resistor r=0.0933015 //w=0.201 //l=0.125 //layer=m1 \
 //thickness=0.36 //x=14.495 //y=2.385 //x2=14.495 //y2=2.26
r374 (  17 18 ) resistor r=0.229008 //w=0.131 //l=0.24 //layer=m1 \
 //thickness=0.36 //x=14.495 //y=2.385 //x2=14.495 //y2=2.625
r375 (  15 35 ) resistor r=0.0911593 //w=0.376 //l=0.184174 //layer=m1 \
 //thickness=0.36 //x=12.645 //y=2.945 //x2=12.697 //y2=2.785
r376 (  15 16 ) resistor r=2.19943 //w=0.131 //l=2.305 //layer=m1 \
 //thickness=0.36 //x=12.645 //y=2.945 //x2=12.645 //y2=5.25
r377 (  14 33 ) resistor r=0.0861726 //w=0.376 //l=0.169012 //layer=m1 \
 //thickness=0.36 //x=12.645 //y=2.625 //x2=12.697 //y2=2.77
r378 (  13 14 ) resistor r=0.663168 //w=0.131 //l=0.695 //layer=m1 \
 //thickness=0.36 //x=12.645 //y=1.93 //x2=12.645 //y2=2.625
r379 (  11 13 ) resistor r=0.0698411 //w=0.17 //l=0.120208 //layer=m1 \
 //thickness=0.36 //x=12.56 //y=1.845 //x2=12.645 //y2=1.93
r380 (  11 12 ) resistor r=0.300573 //w=0.131 //l=0.315 //layer=m1 \
 //thickness=0.36 //x=12.56 //y=1.845 //x2=12.245 //y2=1.845
r381 (  10 12 ) resistor r=0.0698411 //w=0.17 //l=0.120208 //layer=m1 \
 //thickness=0.36 //x=12.16 //y=1.76 //x2=12.245 //y2=1.845
r382 (  9 31 ) resistor r=0.0717383 //w=0.224 //l=0.115 //layer=m1 \
 //thickness=0.36 //x=12.16 //y=1.305 //x2=12.16 //y2=1.19
r383 (  9 10 ) resistor r=0.43416 //w=0.131 //l=0.455 //layer=m1 \
 //thickness=0.36 //x=12.16 //y=1.305 //x2=12.16 //y2=1.76
r384 (  8 27 ) resistor r=0.0675342 //w=0.23 //l=0.115 //layer=m1 \
 //thickness=0.36 //x=11.98 //y=5.335 //x2=11.865 //y2=5.335
r385 (  7 16 ) resistor r=0.0698411 //w=0.17 //l=0.120208 //layer=m1 \
 //thickness=0.36 //x=12.56 //y=5.335 //x2=12.645 //y2=5.25
r386 (  7 8 ) resistor r=0.553435 //w=0.131 //l=0.58 //layer=m1 \
 //thickness=0.36 //x=12.56 //y=5.335 //x2=11.98 //y2=5.335
r387 (  6 29 ) resistor r=0.00118313 //w=0.23 //layer=m1 //thickness=0.36 \
 //x=11.865 //y=5.56 //x2=11.865 //y2=5.56
r388 (  5 27 ) resistor r=0.002872 //w=0.34 //l=0.085 //layer=m1 \
 //thickness=0.36 //x=11.865 //y=5.42 //x2=11.865 //y2=5.335
r389 (  5 6 ) resistor r=0.091623 //w=0.191 //l=0.14 //layer=m1 \
 //thickness=0.36 //x=11.865 //y=5.42 //x2=11.865 //y2=5.56
r390 (  4 24 ) resistor r=0.0262263 //w=0.232 //l=0.12 //layer=m1 \
 //thickness=0.36 //x=11.105 //y=5.335 //x2=10.985 //y2=5.335
r391 (  3 27 ) resistor r=0.0675342 //w=0.23 //l=0.115 //layer=m1 \
 //thickness=0.36 //x=11.75 //y=5.335 //x2=11.865 //y2=5.335
r392 (  3 4 ) resistor r=0.615458 //w=0.131 //l=0.645 //layer=m1 \
 //thickness=0.36 //x=11.75 //y=5.335 //x2=11.105 //y2=5.335
r393 (  2 21 ) resistor r=0.0222262 //w=0.217 //l=0.118 //layer=m1 \
 //thickness=0.36 //x=10.225 //y=5.335 //x2=10.107 //y2=5.335
r394 (  1 24 ) resistor r=0.0262263 //w=0.232 //l=0.12 //layer=m1 \
 //thickness=0.36 //x=10.865 //y=5.335 //x2=10.985 //y2=5.335
r395 (  1 2 ) resistor r=0.610687 //w=0.131 //l=0.64 //layer=m1 \
 //thickness=0.36 //x=10.865 //y=5.335 //x2=10.225 //y2=5.335
ends PM_DFFSNQNX1\%noxref_2

subckt PM_DFFSNQNX1\%CLK ( 1 2 3 4 5 6 7 8 9 23 27 32 35 37 39 45 50 55 60 64 \
 65 66 67 68 69 70 71 72 74 80 81 82 83 84 89 90 91 96 98 100 106 107 111 120 \
 121 124 )
c277 ( 124 0 ) capacitor c=0.0368618f //x=15.265 //y=4.88
c278 ( 121 0 ) capacitor c=0.0284095f //x=15.235 //y=2.095
c279 ( 120 0 ) capacitor c=0.0476356f //x=15.235 //y=2.26
c280 ( 111 0 ) capacitor c=0.035802f //x=5.985 //y=4.88
c281 ( 107 0 ) capacitor c=0.0439708f //x=15.8 //y=1.43
c282 ( 106 0 ) capacitor c=0.0192582f //x=15.8 //y=1.085
c283 ( 100 0 ) capacitor c=0.0162526f //x=15.645 //y=1.585
c284 ( 98 0 ) capacitor c=0.0157807f //x=15.645 //y=0.93
c285 ( 96 0 ) capacitor c=0.0352777f //x=15.64 //y=4.97
c286 ( 91 0 ) capacitor c=0.0210762f //x=15.27 //y=1.74
c287 ( 90 0 ) capacitor c=0.0168511f //x=15.27 //y=1.43
c288 ( 89 0 ) capacitor c=0.0175485f //x=15.27 //y=1.085
c289 ( 84 0 ) capacitor c=0.0305913f //x=6.32 //y=4.97
c290 ( 83 0 ) capacitor c=0.0863671f //x=6.075 //y=2.095
c291 ( 82 0 ) capacitor c=0.0170266f //x=6.075 //y=1.63
c292 ( 81 0 ) capacitor c=0.018609f //x=6.075 //y=1.4
c293 ( 80 0 ) capacitor c=0.0186599f //x=6.075 //y=1.09
c294 ( 74 0 ) capacitor c=0.0146988f //x=5.92 //y=1.555
c295 ( 72 0 ) capacitor c=0.0148531f //x=5.92 //y=0.935
c296 ( 71 0 ) capacitor c=0.0334406f //x=5.55 //y=1.4
c297 ( 70 0 ) capacitor c=0.0173191f //x=5.55 //y=1.09
c298 ( 69 0 ) capacitor c=0.155269f //x=15.715 //y=6.2
c299 ( 68 0 ) capacitor c=0.110375f //x=15.275 //y=6.2
c300 ( 67 0 ) capacitor c=0.110208f //x=6.395 //y=6.2
c301 ( 66 0 ) capacitor c=0.110214f //x=5.955 //y=6.2
c302 ( 60 0 ) capacitor c=8.63406e-19 //x=15.265 //y=4.88
c303 ( 55 0 ) capacitor c=7.72439e-19 //x=15.235 //y=2.26
c304 ( 50 0 ) capacitor c=0.00129935f //x=5.985 //y=4.88
c305 ( 45 0 ) capacitor c=0.00121786f //x=5.985 //y=2.26
c306 ( 39 0 ) capacitor c=0.00532303f //x=5.985 //y=4.62
c307 ( 37 0 ) capacitor c=0.193887f //x=8.045 //y=4.635
c308 ( 35 0 ) capacitor c=0.0322851f //x=7.445 //y=4.62
c309 ( 32 0 ) capacitor c=0.00896434f //x=15.27 //y=4.75
c310 ( 27 0 ) capacitor c=0.00504845f //x=15.235 //y=2.26
c311 ( 23 0 ) capacitor c=0.00988043f //x=5.985 //y=4.755
c312 ( 9 0 ) capacitor c=0.00562626f //x=5.985 //y=2.375
c313 ( 4 0 ) capacitor c=0.0490504f //x=15.235 //y=2.77
c314 ( 1 0 ) capacitor c=0.0659583f //x=5.985 //y=3.14
r315 (  126 127 ) resistor r=32.4568 //w=0.214 //l=0.075 //layer=ply \
 //thickness=0.18 //x=15.265 //y=4.97 //x2=15.265 //y2=5.045
r316 (  124 126 ) resistor r=20.271 //w=0.214 //l=0.09 //layer=ply \
 //thickness=0.18 //x=15.265 //y=4.88 //x2=15.265 //y2=4.97
r317 (  120 121 ) resistor r=52.7279 //w=0.214 //l=0.165 //layer=ply \
 //thickness=0.18 //x=15.235 //y=2.26 //x2=15.235 //y2=2.095
r318 (  113 114 ) resistor r=32.4568 //w=0.214 //l=0.075 //layer=ply \
 //thickness=0.18 //x=5.985 //y=4.97 //x2=5.985 //y2=5.045
r319 (  111 113 ) resistor r=20.271 //w=0.214 //l=0.09 //layer=ply \
 //thickness=0.18 //x=5.985 //y=4.88 //x2=5.985 //y2=4.97
r320 (  107 131 ) resistor r=45.1352 //w=0.168 //l=0.173853 //layer=ply \
 //thickness=0.18 //x=15.8 //y=1.43 //x2=15.76 //y2=1.585
r321 (  106 130 ) resistor r=45.1352 //w=0.168 //l=0.173853 //layer=ply \
 //thickness=0.18 //x=15.8 //y=1.085 //x2=15.76 //y2=0.93
r322 (  106 107 ) resistor r=176.904 //w=0.094 //l=0.345 //layer=ply \
 //thickness=0.18 //x=15.8 //y=1.085 //x2=15.8 //y2=1.43
r323 (  101 129 ) resistor r=10.701 //w=0.21 //l=0.115 //layer=ply \
 //thickness=0.18 //x=15.425 //y=1.585 //x2=15.31 //y2=1.585
r324 (  100 131 ) resistor r=5.52526 //w=0.168 //l=0.115 //layer=ply \
 //thickness=0.18 //x=15.645 //y=1.585 //x2=15.76 //y2=1.585
r325 (  99 128 ) resistor r=5.52526 //w=0.168 //l=0.115 //layer=ply \
 //thickness=0.18 //x=15.425 //y=0.93 //x2=15.31 //y2=0.93
r326 (  98 130 ) resistor r=5.52526 //w=0.168 //l=0.115 //layer=ply \
 //thickness=0.18 //x=15.645 //y=0.93 //x2=15.76 //y2=0.93
r327 (  98 99 ) resistor r=112.809 //w=0.094 //l=0.22 //layer=ply \
 //thickness=0.18 //x=15.645 //y=0.93 //x2=15.425 //y2=0.93
r328 (  97 126 ) resistor r=16.5046 //w=0.27 //l=0.135 //layer=ply \
 //thickness=0.18 //x=15.4 //y=4.97 //x2=15.265 //y2=4.97
r329 (  96 103 ) resistor r=26.9307 //w=0.15 //l=0.106066 //layer=ply \
 //thickness=0.18 //x=15.64 //y=4.97 //x2=15.715 //y2=5.045
r330 (  96 97 ) resistor r=123.064 //w=0.094 //l=0.24 //layer=ply \
 //thickness=0.18 //x=15.64 //y=4.97 //x2=15.4 //y2=4.97
r331 (  91 129 ) resistor r=39.5823 //w=0.21 //l=0.173853 //layer=ply \
 //thickness=0.18 //x=15.27 //y=1.74 //x2=15.31 //y2=1.585
r332 (  91 121 ) resistor r=182.032 //w=0.094 //l=0.355 //layer=ply \
 //thickness=0.18 //x=15.27 //y=1.74 //x2=15.27 //y2=2.095
r333 (  90 129 ) resistor r=39.5823 //w=0.21 //l=0.173853 //layer=ply \
 //thickness=0.18 //x=15.27 //y=1.43 //x2=15.31 //y2=1.585
r334 (  89 128 ) resistor r=45.1352 //w=0.168 //l=0.173853 //layer=ply \
 //thickness=0.18 //x=15.27 //y=1.085 //x2=15.31 //y2=0.93
r335 (  89 90 ) resistor r=176.904 //w=0.094 //l=0.345 //layer=ply \
 //thickness=0.18 //x=15.27 //y=1.085 //x2=15.27 //y2=1.43
r336 (  85 113 ) resistor r=16.5046 //w=0.27 //l=0.135 //layer=ply \
 //thickness=0.18 //x=6.12 //y=4.97 //x2=5.985 //y2=4.97
r337 (  84 86 ) resistor r=26.9307 //w=0.15 //l=0.106066 //layer=ply \
 //thickness=0.18 //x=6.32 //y=4.97 //x2=6.395 //y2=5.045
r338 (  84 85 ) resistor r=102.553 //w=0.094 //l=0.2 //layer=ply \
 //thickness=0.18 //x=6.32 //y=4.97 //x2=6.12 //y2=4.97
r339 (  83 118 ) resistor r=38.6777 //w=0.284 //l=0.198997 //layer=ply \
 //thickness=0.18 //x=6.075 //y=2.095 //x2=6 //y2=2.26
r340 (  82 116 ) resistor r=21.2976 //w=0.217 //l=0.0928709 //layer=ply \
 //thickness=0.18 //x=6.075 //y=1.63 //x2=6.035 //y2=1.555
r341 (  82 83 ) resistor r=238.436 //w=0.094 //l=0.465 //layer=ply \
 //thickness=0.18 //x=6.075 //y=1.63 //x2=6.075 //y2=2.095
r342 (  81 116 ) resistor r=39.0671 //w=0.217 //l=0.173853 //layer=ply \
 //thickness=0.18 //x=6.075 //y=1.4 //x2=6.035 //y2=1.555
r343 (  80 115 ) resistor r=45.1352 //w=0.168 //l=0.173853 //layer=ply \
 //thickness=0.18 //x=6.075 //y=1.09 //x2=6.035 //y2=0.935
r344 (  80 81 ) resistor r=158.957 //w=0.094 //l=0.31 //layer=ply \
 //thickness=0.18 //x=6.075 //y=1.09 //x2=6.075 //y2=1.4
r345 (  75 109 ) resistor r=5.52526 //w=0.168 //l=0.115 //layer=ply \
 //thickness=0.18 //x=5.705 //y=1.555 //x2=5.59 //y2=1.555
r346 (  74 116 ) resistor r=11.4558 //w=0.217 //l=0.115 //layer=ply \
 //thickness=0.18 //x=5.92 //y=1.555 //x2=6.035 //y2=1.555
r347 (  73 108 ) resistor r=5.52526 //w=0.168 //l=0.115 //layer=ply \
 //thickness=0.18 //x=5.705 //y=0.935 //x2=5.59 //y2=0.935
r348 (  72 115 ) resistor r=5.52526 //w=0.168 //l=0.115 //layer=ply \
 //thickness=0.18 //x=5.92 //y=0.935 //x2=6.035 //y2=0.935
r349 (  72 73 ) resistor r=110.245 //w=0.094 //l=0.215 //layer=ply \
 //thickness=0.18 //x=5.92 //y=0.935 //x2=5.705 //y2=0.935
r350 (  71 109 ) resistor r=45.1352 //w=0.168 //l=0.173853 //layer=ply \
 //thickness=0.18 //x=5.55 //y=1.4 //x2=5.59 //y2=1.555
r351 (  70 108 ) resistor r=45.1352 //w=0.168 //l=0.173853 //layer=ply \
 //thickness=0.18 //x=5.55 //y=1.09 //x2=5.59 //y2=0.935
r352 (  70 71 ) resistor r=158.957 //w=0.094 //l=0.31 //layer=ply \
 //thickness=0.18 //x=5.55 //y=1.09 //x2=5.55 //y2=1.4
r353 (  69 103 ) resistor r=592.245 //w=0.094 //l=1.155 //layer=ply \
 //thickness=0.18 //x=15.715 //y=6.2 //x2=15.715 //y2=5.045
r354 (  68 127 ) resistor r=592.245 //w=0.094 //l=1.155 //layer=ply \
 //thickness=0.18 //x=15.275 //y=6.2 //x2=15.275 //y2=5.045
r355 (  67 86 ) resistor r=592.245 //w=0.094 //l=1.155 //layer=ply \
 //thickness=0.18 //x=6.395 //y=6.2 //x2=6.395 //y2=5.045
r356 (  66 114 ) resistor r=592.245 //w=0.094 //l=1.155 //layer=ply \
 //thickness=0.18 //x=5.955 //y=6.2 //x2=5.955 //y2=5.045
r357 (  65 100 ) resistor r=56.4043 //w=0.094 //l=0.11 //layer=ply \
 //thickness=0.18 //x=15.535 //y=1.585 //x2=15.645 //y2=1.585
r358 (  65 101 ) resistor r=56.4043 //w=0.094 //l=0.11 //layer=ply \
 //thickness=0.18 //x=15.535 //y=1.585 //x2=15.425 //y2=1.585
r359 (  64 74 ) resistor r=55.3787 //w=0.094 //l=0.108 //layer=ply \
 //thickness=0.18 //x=5.812 //y=1.555 //x2=5.92 //y2=1.555
r360 (  64 75 ) resistor r=54.866 //w=0.094 //l=0.107 //layer=ply \
 //thickness=0.18 //x=5.812 //y=1.555 //x2=5.705 //y2=1.555
r361 (  60 124 ) resistor r=152 //w=0.17 //l=0.17 //layer=licon //count=1 \
 //x=15.265 //y=4.88 //x2=15.265 //y2=4.88
r362 (  55 120 ) resistor r=152 //w=0.17 //l=0.17 //layer=licon //count=1 \
 //x=15.235 //y=2.26 //x2=15.235 //y2=2.26
r363 (  50 111 ) resistor r=152 //w=0.17 //l=0.17 //layer=licon //count=1 \
 //x=5.985 //y=4.88 //x2=5.985 //y2=4.88
r364 (  45 118 ) resistor r=152 //w=0.17 //l=0.17 //layer=licon //count=1 \
 //x=5.985 //y=2.26 //x2=5.985 //y2=2.26
r365 (  39 41 ) resistor r=0.0546116 //w=0.309 //l=0.135 //layer=m2 \
 //thickness=0.36 //x=5.985 //y=4.62 //x2=5.985 //y2=4.755
r366 (  37 43 ) resistor r=5.04583 //w=0.179 //l=7.25992 //layer=m2 \
 //thickness=0.36 //x=8.045 //y=4.635 //x2=15.27 //y2=4.705
r367 (  37 38 ) resistor r=0.329198 //w=0.131 //l=0.345 //layer=m2 \
 //thickness=0.36 //x=8.045 //y=4.635 //x2=7.7 //y2=4.635
r368 (  36 39 ) resistor r=0.0433913 //w=0.309 //l=0.16 //layer=m2 \
 //thickness=0.36 //x=6.145 //y=4.62 //x2=5.985 //y2=4.62
r369 (  35 38 ) resistor r=0.1875 //w=0.17 //l=0.262393 //layer=m2 \
 //thickness=0.36 //x=7.445 //y=4.62 //x2=7.7 //y2=4.635
r370 (  35 36 ) resistor r=1.24046 //w=0.131 //l=1.3 //layer=m2 \
 //thickness=0.36 //x=7.445 //y=4.62 //x2=6.145 //y2=4.62
r371 (  34 60 ) resistor r=9.3 //w=0.17 //l=0.17 //layer=mcon //count=1 \
 //x=15.265 //y=4.88 //x2=15.265 //y2=4.88
r372 (  32 43 ) resistor r=4.5 //w=0.15 //l=0.15 //layer=via1 //count=1 \
 //x=15.27 //y=4.75 //x2=15.27 //y2=4.75
r373 (  32 34 ) resistor r=0.0547138 //w=0.297 //l=0.13 //layer=m1 \
 //thickness=0.36 //x=15.27 //y=4.75 //x2=15.27 //y2=4.88
r374 (  27 55 ) resistor r=9.3 //w=0.17 //l=0.17 //layer=mcon //count=1 \
 //x=15.235 //y=2.26 //x2=15.235 //y2=2.26
r375 (  27 29 ) resistor r=0.0936408 //w=0.196 //l=0.125 //layer=m1 \
 //thickness=0.36 //x=15.237 //y=2.26 //x2=15.237 //y2=2.385
r376 (  25 50 ) resistor r=9.3 //w=0.17 //l=0.17 //layer=mcon //count=1 \
 //x=5.985 //y=4.88 //x2=5.985 //y2=4.88
r377 (  23 41 ) resistor r=4.5 //w=0.15 //l=0.15 //layer=via1 //count=1 \
 //x=5.985 //y=4.755 //x2=5.985 //y2=4.755
r378 (  23 25 ) resistor r=0.0533276 //w=0.293 //l=0.125 //layer=m1 \
 //thickness=0.36 //x=5.985 //y=4.755 //x2=5.985 //y2=4.88
r379 (  20 45 ) resistor r=9.3 //w=0.17 //l=0.17 //layer=mcon //count=1 \
 //x=5.985 //y=2.26 //x2=5.985 //y2=2.26
r380 (  9 20 ) resistor r=0.0715665 //w=0.226 //l=0.115996 //layer=m1 \
 //thickness=0.36 //x=5.985 //y=2.375 //x2=5.987 //y2=2.26
r381 (  8 32 ) resistor r=0.0547138 //w=0.297 //l=0.13 //layer=m1 \
 //thickness=0.36 //x=15.27 //y=4.62 //x2=15.27 //y2=4.75
r382 (  8 15 ) resistor r=0.0352913 //w=0.297 //l=0.047697 //layer=m1 \
 //thickness=0.36 //x=15.27 //y=4.62 //x2=15.235 //y2=4.59
r383 (  7 23 ) resistor r=0.0575939 //w=0.293 //l=0.135 //layer=m1 \
 //thickness=0.36 //x=5.985 //y=4.62 //x2=5.985 //y2=4.755
r384 (  7 10 ) resistor r=0.0325091 //w=0.293 //l=0.025 //layer=m1 \
 //thickness=0.36 //x=5.985 //y=4.62 //x2=5.985 //y2=4.595
r385 (  6 15 ) resistor r=1.03053 //w=0.131 //l=1.08 //layer=m1 \
 //thickness=0.36 //x=15.235 //y=3.51 //x2=15.235 //y2=4.59
r386 (  5 6 ) resistor r=0.353053 //w=0.131 //l=0.37 //layer=m1 \
 //thickness=0.36 //x=15.235 //y=3.14 //x2=15.235 //y2=3.51
r387 (  4 5 ) resistor r=0.353053 //w=0.131 //l=0.37 //layer=m1 \
 //thickness=0.36 //x=15.235 //y=2.77 //x2=15.235 //y2=3.14
r388 (  4 29 ) resistor r=0.367366 //w=0.131 //l=0.385 //layer=m1 \
 //thickness=0.36 //x=15.235 //y=2.77 //x2=15.235 //y2=2.385
r389 (  3 10 ) resistor r=0.682252 //w=0.131 //l=0.715 //layer=m1 \
 //thickness=0.36 //x=5.985 //y=3.88 //x2=5.985 //y2=4.595
r390 (  2 3 ) resistor r=0.353053 //w=0.131 //l=0.37 //layer=m1 \
 //thickness=0.36 //x=5.985 //y=3.51 //x2=5.985 //y2=3.88
r391 (  1 2 ) resistor r=0.353053 //w=0.131 //l=0.37 //layer=m1 \
 //thickness=0.36 //x=5.985 //y=3.14 //x2=5.985 //y2=3.51
r392 (  1 9 ) resistor r=0.729962 //w=0.131 //l=0.765 //layer=m1 \
 //thickness=0.36 //x=5.985 //y=3.14 //x2=5.985 //y2=2.375
ends PM_DFFSNQNX1\%CLK

subckt PM_DFFSNQNX1\%noxref_4 ( 2 3 4 5 7 10 11 13 14 15 16 18 19 20 22 23 26 \
 34 35 38 41 47 50 54 57 58 60 63 67 71 72 75 84 89 97 105 122 131 135 136 137 \
 138 139 140 141 142 143 148 150 152 158 159 160 161 162 163 167 169 172 173 \
 178 179 182 196 199 201 202 203 )
c469 ( 199 0 ) capacitor c=0.00885916f //x=7.16 //y=1.095
c470 ( 196 0 ) capacitor c=0.0634117f //x=17.825 //y=4.88
c471 ( 182 0 ) capacitor c=0.0354953f //x=2.315 //y=4.88
c472 ( 179 0 ) capacitor c=0.0284095f //x=2.285 //y=2.095
c473 ( 178 0 ) capacitor c=0.0476356f //x=2.285 //y=2.26
c474 ( 173 0 ) capacitor c=0.0318956f //x=18.16 //y=1.39
c475 ( 172 0 ) capacitor c=0.0186809f //x=18.16 //y=1.045
c476 ( 169 0 ) capacitor c=0.0141821f //x=18.005 //y=1.545
c477 ( 167 0 ) capacitor c=0.0158553f //x=18.005 //y=0.89
c478 ( 163 0 ) capacitor c=0.088055f //x=17.63 //y=2.095
c479 ( 162 0 ) capacitor c=0.0229235f //x=17.63 //y=1.7
c480 ( 161 0 ) capacitor c=0.0234359f //x=17.63 //y=1.39
c481 ( 160 0 ) capacitor c=0.0198759f //x=17.63 //y=1.045
c482 ( 159 0 ) capacitor c=0.0439708f //x=2.85 //y=1.43
c483 ( 158 0 ) capacitor c=0.0192582f //x=2.85 //y=1.085
c484 ( 152 0 ) capacitor c=0.0162526f //x=2.695 //y=1.585
c485 ( 150 0 ) capacitor c=0.0157807f //x=2.695 //y=0.93
c486 ( 148 0 ) capacitor c=0.0357885f //x=2.69 //y=4.97
c487 ( 143 0 ) capacitor c=0.0210762f //x=2.32 //y=1.74
c488 ( 142 0 ) capacitor c=0.0168511f //x=2.32 //y=1.43
c489 ( 141 0 ) capacitor c=0.0175485f //x=2.32 //y=1.085
c490 ( 140 0 ) capacitor c=0.110369f //x=18.165 //y=6.2
c491 ( 139 0 ) capacitor c=0.154619f //x=17.725 //y=6.2
c492 ( 138 0 ) capacitor c=0.155269f //x=2.765 //y=6.2
c493 ( 137 0 ) capacitor c=0.110375f //x=2.325 //y=6.2
c494 ( 131 0 ) capacitor c=5.44848e-19 //x=17.825 //y=4.88
c495 ( 122 0 ) capacitor c=7.85889e-19 //x=17.825 //y=2.26
c496 ( 105 0 ) capacitor c=0.0293709f //x=7.055 //y=5.56
c497 ( 97 0 ) capacitor c=0.029137f //x=6.175 //y=5.56
c498 ( 89 0 ) capacitor c=0.0277605f //x=5.295 //y=5.56
c499 ( 84 0 ) capacitor c=5.80994e-19 //x=2.315 //y=4.88
c500 ( 75 0 ) capacitor c=5.78095e-19 //x=2.285 //y=2.26
c501 ( 72 0 ) capacitor c=0.135006f //x=17.665 //y=4.265
c502 ( 71 0 ) capacitor c=0.00334332f //x=17.825 //y=4.265
c503 ( 67 0 ) capacitor c=0.00476965f //x=2.445 //y=4.245
c504 ( 63 0 ) capacitor c=9.20866e-19 //x=7.99 //y=4.25
c505 ( 60 0 ) capacitor c=0.14481f //x=7.67 //y=4.25
c506 ( 58 0 ) capacitor c=0.00689242f //x=17.827 //y=4.74
c507 ( 57 0 ) capacitor c=0.00587099f //x=17.825 //y=4.88
c508 ( 54 0 ) capacitor c=0.00463527f //x=17.825 //y=2.26
c509 ( 50 0 ) capacitor c=0.0145916f //x=17.825 //y=4.25
c510 ( 47 0 ) capacitor c=0.0149922f //x=7.83 //y=4.25
c511 ( 41 0 ) capacitor c=8.88597e-19 //x=7.055 //y=5.335
c512 ( 38 0 ) capacitor c=0.0073827f //x=6.175 //y=5.335
c513 ( 35 0 ) capacitor c=0.0115084f //x=5.297 //y=5.335
c514 ( 34 0 ) capacitor c=0.0143718f //x=2.285 //y=4.25
c515 ( 26 0 ) capacitor c=0.00662206f //x=2.285 //y=2.26
c516 ( 23 0 ) capacitor c=0.0118473f //x=17.825 //y=4.425
c517 ( 22 0 ) capacitor c=0.0476387f //x=17.825 //y=4.105
c518 ( 20 0 ) capacitor c=0.0222419f //x=7.835 //y=5.25
c519 ( 19 0 ) capacitor c=0.0128722f //x=7.835 //y=4.41
c520 ( 18 0 ) capacitor c=0.0651849f //x=7.835 //y=4.09
c521 ( 16 0 ) capacitor c=0.00537187f //x=7.435 //y=1.845
c522 ( 15 0 ) capacitor c=0.0148432f //x=7.75 //y=1.845
c523 ( 14 0 ) capacitor c=0.0167333f //x=7.35 //y=1.76
c524 ( 13 0 ) capacitor c=0.0111291f //x=7.35 //y=1.305
c525 ( 11 0 ) capacitor c=0.0223199f //x=7.75 //y=5.335
c526 ( 10 0 ) capacitor c=0.00933983f //x=7.055 //y=5.56
c527 ( 7 0 ) capacitor c=0.019596f //x=6.94 //y=5.335
c528 ( 5 0 ) capacitor c=0.0150448f //x=6.055 //y=5.335
c529 ( 4 0 ) capacitor c=0.00990813f //x=2.285 //y=4.735
c530 ( 3 0 ) capacitor c=0.00972098f //x=2.285 //y=4.405
c531 ( 2 0 ) capacitor c=0.0435661f //x=2.285 //y=4.085
r532 (  194 196 ) resistor r=20.6867 //w=0.233 //l=0.1 //layer=ply \
 //thickness=0.18 //x=17.725 //y=4.88 //x2=17.825 //y2=4.88
r533 (  184 185 ) resistor r=32.4568 //w=0.214 //l=0.075 //layer=ply \
 //thickness=0.18 //x=2.315 //y=4.97 //x2=2.315 //y2=5.045
r534 (  182 184 ) resistor r=20.271 //w=0.214 //l=0.09 //layer=ply \
 //thickness=0.18 //x=2.315 //y=4.88 //x2=2.315 //y2=4.97
r535 (  178 179 ) resistor r=52.7279 //w=0.214 //l=0.165 //layer=ply \
 //thickness=0.18 //x=2.285 //y=2.26 //x2=2.285 //y2=2.095
r536 (  174 196 ) resistor r=70.3348 //w=0.233 //l=0.414367 //layer=ply \
 //thickness=0.18 //x=18.165 //y=5.045 //x2=17.825 //y2=4.88
r537 (  173 198 ) resistor r=45.1352 //w=0.168 //l=0.173853 //layer=ply \
 //thickness=0.18 //x=18.16 //y=1.39 //x2=18.12 //y2=1.545
r538 (  172 197 ) resistor r=45.1352 //w=0.168 //l=0.173853 //layer=ply \
 //thickness=0.18 //x=18.16 //y=1.045 //x2=18.12 //y2=0.89
r539 (  172 173 ) resistor r=176.904 //w=0.094 //l=0.345 //layer=ply \
 //thickness=0.18 //x=18.16 //y=1.045 //x2=18.16 //y2=1.39
r540 (  170 193 ) resistor r=10.701 //w=0.21 //l=0.115 //layer=ply \
 //thickness=0.18 //x=17.785 //y=1.545 //x2=17.67 //y2=1.545
r541 (  169 198 ) resistor r=5.52526 //w=0.168 //l=0.115 //layer=ply \
 //thickness=0.18 //x=18.005 //y=1.545 //x2=18.12 //y2=1.545
r542 (  168 192 ) resistor r=5.52526 //w=0.168 //l=0.115 //layer=ply \
 //thickness=0.18 //x=17.785 //y=0.89 //x2=17.67 //y2=0.89
r543 (  167 197 ) resistor r=5.52526 //w=0.168 //l=0.115 //layer=ply \
 //thickness=0.18 //x=18.005 //y=0.89 //x2=18.12 //y2=0.89
r544 (  167 168 ) resistor r=112.809 //w=0.094 //l=0.22 //layer=ply \
 //thickness=0.18 //x=18.005 //y=0.89 //x2=17.785 //y2=0.89
r545 (  164 194 ) resistor r=13.0941 //w=0.233 //l=0.165 //layer=ply \
 //thickness=0.18 //x=17.725 //y=5.045 //x2=17.725 //y2=4.88
r546 (  163 191 ) resistor r=34.8111 //w=0.27 //l=0.264953 //layer=ply \
 //thickness=0.18 //x=17.63 //y=2.095 //x2=17.825 //y2=2.26
r547 (  162 193 ) resistor r=39.5823 //w=0.21 //l=0.173853 //layer=ply \
 //thickness=0.18 //x=17.63 //y=1.7 //x2=17.67 //y2=1.545
r548 (  162 163 ) resistor r=202.543 //w=0.094 //l=0.395 //layer=ply \
 //thickness=0.18 //x=17.63 //y=1.7 //x2=17.63 //y2=2.095
r549 (  161 193 ) resistor r=39.5823 //w=0.21 //l=0.173853 //layer=ply \
 //thickness=0.18 //x=17.63 //y=1.39 //x2=17.67 //y2=1.545
r550 (  160 192 ) resistor r=45.1352 //w=0.168 //l=0.173853 //layer=ply \
 //thickness=0.18 //x=17.63 //y=1.045 //x2=17.67 //y2=0.89
r551 (  160 161 ) resistor r=176.904 //w=0.094 //l=0.345 //layer=ply \
 //thickness=0.18 //x=17.63 //y=1.045 //x2=17.63 //y2=1.39
r552 (  159 189 ) resistor r=45.1352 //w=0.168 //l=0.173853 //layer=ply \
 //thickness=0.18 //x=2.85 //y=1.43 //x2=2.81 //y2=1.585
r553 (  158 188 ) resistor r=45.1352 //w=0.168 //l=0.173853 //layer=ply \
 //thickness=0.18 //x=2.85 //y=1.085 //x2=2.81 //y2=0.93
r554 (  158 159 ) resistor r=176.904 //w=0.094 //l=0.345 //layer=ply \
 //thickness=0.18 //x=2.85 //y=1.085 //x2=2.85 //y2=1.43
r555 (  153 187 ) resistor r=10.701 //w=0.21 //l=0.115 //layer=ply \
 //thickness=0.18 //x=2.475 //y=1.585 //x2=2.36 //y2=1.585
r556 (  152 189 ) resistor r=5.52526 //w=0.168 //l=0.115 //layer=ply \
 //thickness=0.18 //x=2.695 //y=1.585 //x2=2.81 //y2=1.585
r557 (  151 186 ) resistor r=5.52526 //w=0.168 //l=0.115 //layer=ply \
 //thickness=0.18 //x=2.475 //y=0.93 //x2=2.36 //y2=0.93
r558 (  150 188 ) resistor r=5.52526 //w=0.168 //l=0.115 //layer=ply \
 //thickness=0.18 //x=2.695 //y=0.93 //x2=2.81 //y2=0.93
r559 (  150 151 ) resistor r=112.809 //w=0.094 //l=0.22 //layer=ply \
 //thickness=0.18 //x=2.695 //y=0.93 //x2=2.475 //y2=0.93
r560 (  149 184 ) resistor r=16.5046 //w=0.27 //l=0.135 //layer=ply \
 //thickness=0.18 //x=2.45 //y=4.97 //x2=2.315 //y2=4.97
r561 (  148 155 ) resistor r=26.9307 //w=0.15 //l=0.106066 //layer=ply \
 //thickness=0.18 //x=2.69 //y=4.97 //x2=2.765 //y2=5.045
r562 (  148 149 ) resistor r=123.064 //w=0.094 //l=0.24 //layer=ply \
 //thickness=0.18 //x=2.69 //y=4.97 //x2=2.45 //y2=4.97
r563 (  143 187 ) resistor r=39.5823 //w=0.21 //l=0.173853 //layer=ply \
 //thickness=0.18 //x=2.32 //y=1.74 //x2=2.36 //y2=1.585
r564 (  143 179 ) resistor r=182.032 //w=0.094 //l=0.355 //layer=ply \
 //thickness=0.18 //x=2.32 //y=1.74 //x2=2.32 //y2=2.095
r565 (  142 187 ) resistor r=39.5823 //w=0.21 //l=0.173853 //layer=ply \
 //thickness=0.18 //x=2.32 //y=1.43 //x2=2.36 //y2=1.585
r566 (  141 186 ) resistor r=45.1352 //w=0.168 //l=0.173853 //layer=ply \
 //thickness=0.18 //x=2.32 //y=1.085 //x2=2.36 //y2=0.93
r567 (  141 142 ) resistor r=176.904 //w=0.094 //l=0.345 //layer=ply \
 //thickness=0.18 //x=2.32 //y=1.085 //x2=2.32 //y2=1.43
r568 (  140 174 ) resistor r=592.245 //w=0.094 //l=1.155 //layer=ply \
 //thickness=0.18 //x=18.165 //y=6.2 //x2=18.165 //y2=5.045
r569 (  139 164 ) resistor r=592.245 //w=0.094 //l=1.155 //layer=ply \
 //thickness=0.18 //x=17.725 //y=6.2 //x2=17.725 //y2=5.045
r570 (  138 155 ) resistor r=592.245 //w=0.094 //l=1.155 //layer=ply \
 //thickness=0.18 //x=2.765 //y=6.2 //x2=2.765 //y2=5.045
r571 (  137 185 ) resistor r=592.245 //w=0.094 //l=1.155 //layer=ply \
 //thickness=0.18 //x=2.325 //y=6.2 //x2=2.325 //y2=5.045
r572 (  136 169 ) resistor r=56.4043 //w=0.094 //l=0.11 //layer=ply \
 //thickness=0.18 //x=17.895 //y=1.545 //x2=18.005 //y2=1.545
r573 (  136 170 ) resistor r=56.4043 //w=0.094 //l=0.11 //layer=ply \
 //thickness=0.18 //x=17.895 //y=1.545 //x2=17.785 //y2=1.545
r574 (  135 152 ) resistor r=56.4043 //w=0.094 //l=0.11 //layer=ply \
 //thickness=0.18 //x=2.585 //y=1.585 //x2=2.695 //y2=1.585
r575 (  135 153 ) resistor r=56.4043 //w=0.094 //l=0.11 //layer=ply \
 //thickness=0.18 //x=2.585 //y=1.585 //x2=2.475 //y2=1.585
r576 (  131 196 ) resistor r=152 //w=0.17 //l=0.17 //layer=licon //count=1 \
 //x=17.825 //y=4.88 //x2=17.825 //y2=4.88
r577 (  122 191 ) resistor r=152 //w=0.17 //l=0.17 //layer=licon //count=1 \
 //x=17.825 //y=2.26 //x2=17.825 //y2=2.26
r578 (  105 203 ) resistor r=23.615 //w=0.187 //l=0.345 //layer=li \
 //thickness=0.1 //x=7.055 //y=5.56 //x2=7.055 //y2=5.905
r579 (  97 202 ) resistor r=23.615 //w=0.187 //l=0.345 //layer=li \
 //thickness=0.1 //x=6.175 //y=5.56 //x2=6.175 //y2=5.905
r580 (  89 201 ) resistor r=23.615 //w=0.187 //l=0.345 //layer=li \
 //thickness=0.1 //x=5.295 //y=5.56 //x2=5.295 //y2=5.905
r581 (  84 182 ) resistor r=152 //w=0.17 //l=0.17 //layer=licon //count=1 \
 //x=2.315 //y=4.88 //x2=2.315 //y2=4.88
r582 (  75 178 ) resistor r=152 //w=0.17 //l=0.17 //layer=licon //count=1 \
 //x=2.285 //y=2.26 //x2=2.285 //y2=2.26
r583 (  71 72 ) resistor r=0.10734 //w=0.281 //l=0.16 //layer=m2 \
 //thickness=0.36 //x=17.825 //y=4.265 //x2=17.665 //y2=4.265
r584 (  65 67 ) resistor r=0.10734 //w=0.281 //l=0.16 //layer=m2 \
 //thickness=0.36 //x=2.285 //y=4.245 //x2=2.445 //y2=4.245
r585 (  63 69 ) resistor r=0.10734 //w=0.281 //l=0.16 //layer=m2 \
 //thickness=0.36 //x=7.99 //y=4.25 //x2=7.83 //y2=4.25
r586 (  63 72 ) resistor r=9.23187 //w=0.131 //l=9.675 //layer=m2 \
 //thickness=0.36 //x=7.99 //y=4.25 //x2=17.665 //y2=4.25
r587 (  60 69 ) resistor r=0.10734 //w=0.281 //l=0.16 //layer=m2 \
 //thickness=0.36 //x=7.67 //y=4.25 //x2=7.83 //y2=4.25
r588 (  60 67 ) resistor r=4.98569 //w=0.131 //l=5.225 //layer=m2 \
 //thickness=0.36 //x=7.67 //y=4.25 //x2=2.445 //y2=4.25
r589 (  57 131 ) resistor r=9.3 //w=0.17 //l=0.17 //layer=mcon //count=1 \
 //x=17.825 //y=4.88 //x2=17.825 //y2=4.88
r590 (  57 58 ) resistor r=0.103207 //w=0.196 //l=0.14 //layer=m1 \
 //thickness=0.36 //x=17.827 //y=4.88 //x2=17.827 //y2=4.74
r591 (  54 122 ) resistor r=9.3 //w=0.17 //l=0.17 //layer=mcon //count=1 \
 //x=17.825 //y=2.26 //x2=17.825 //y2=2.26
r592 (  52 71 ) resistor r=4.5 //w=0.15 //l=0.15 //layer=via1 //count=1 \
 //x=17.825 //y=4.265 //x2=17.825 //y2=4.265
r593 (  50 52 ) resistor r=0.0049867 //w=0.376 //l=0.015 //layer=m1 \
 //thickness=0.36 //x=17.772 //y=4.25 //x2=17.772 //y2=4.265
r594 (  47 69 ) resistor r=4.5 //w=0.15 //l=0.15 //layer=via1 //count=1 \
 //x=7.83 //y=4.25 //x2=7.83 //y2=4.25
r595 (  45 199 ) resistor r=9.3 //w=0.17 //l=0.17 //layer=mcon //count=1 \
 //x=7.35 //y=1.19 //x2=7.35 //y2=1.19
r596 (  43 105 ) resistor r=9.3 //w=0.17 //l=0.17 //layer=mcon //count=1 \
 //x=7.055 //y=5.56 //x2=7.055 //y2=5.56
r597 (  40 97 ) resistor r=9.3 //w=0.17 //l=0.17 //layer=mcon //count=1 \
 //x=6.175 //y=5.56 //x2=6.175 //y2=5.56
r598 (  38 40 ) resistor r=0.121228 //w=0.232 //l=0.225 //layer=m1 \
 //thickness=0.36 //x=6.175 //y=5.335 //x2=6.175 //y2=5.56
r599 (  37 89 ) resistor r=9.3 //w=0.17 //l=0.17 //layer=mcon //count=1 \
 //x=5.295 //y=5.56 //x2=5.295 //y2=5.56
r600 (  35 37 ) resistor r=0.129608 //w=0.217 //l=0.225 //layer=m1 \
 //thickness=0.36 //x=5.297 //y=5.335 //x2=5.297 //y2=5.56
r601 (  32 65 ) resistor r=4.5 //w=0.15 //l=0.15 //layer=via1 //count=1 \
 //x=2.285 //y=4.245 //x2=2.285 //y2=4.245
r602 (  32 34 ) resistor r=0.00166223 //w=0.376 //l=0.005 //layer=m1 \
 //thickness=0.36 //x=2.337 //y=4.245 //x2=2.337 //y2=4.25
r603 (  30 84 ) resistor r=9.3 //w=0.17 //l=0.17 //layer=mcon //count=1 \
 //x=2.315 //y=4.88 //x2=2.315 //y2=4.88
r604 (  26 75 ) resistor r=9.3 //w=0.17 //l=0.17 //layer=mcon //count=1 \
 //x=2.285 //y=2.26 //x2=2.285 //y2=2.26
r605 (  26 28 ) resistor r=0.0936408 //w=0.196 //l=0.125 //layer=m1 \
 //thickness=0.36 //x=2.287 //y=2.26 //x2=2.287 //y2=2.385
r606 (  23 52 ) resistor r=0.0911593 //w=0.376 //l=0.184608 //layer=m1 \
 //thickness=0.36 //x=17.825 //y=4.425 //x2=17.772 //y2=4.265
r607 (  23 58 ) resistor r=0.300573 //w=0.131 //l=0.315 //layer=m1 \
 //thickness=0.36 //x=17.825 //y=4.425 //x2=17.825 //y2=4.74
r608 (  22 50 ) resistor r=0.0861726 //w=0.376 //l=0.16944 //layer=m1 \
 //thickness=0.36 //x=17.825 //y=4.105 //x2=17.772 //y2=4.25
r609 (  21 54 ) resistor r=0.0933015 //w=0.201 //l=0.125 //layer=m1 \
 //thickness=0.36 //x=17.825 //y=2.385 //x2=17.825 //y2=2.26
r610 (  21 22 ) resistor r=1.64122 //w=0.131 //l=1.72 //layer=m1 \
 //thickness=0.36 //x=17.825 //y=2.385 //x2=17.825 //y2=4.105
r611 (  19 47 ) resistor r=0.0911593 //w=0.376 //l=0.181989 //layer=m1 \
 //thickness=0.36 //x=7.835 //y=4.41 //x2=7.882 //y2=4.25
r612 (  19 20 ) resistor r=0.801527 //w=0.131 //l=0.84 //layer=m1 \
 //thickness=0.36 //x=7.835 //y=4.41 //x2=7.835 //y2=5.25
r613 (  18 47 ) resistor r=0.0911593 //w=0.376 //l=0.181989 //layer=m1 \
 //thickness=0.36 //x=7.835 //y=4.09 //x2=7.882 //y2=4.25
r614 (  17 18 ) resistor r=2.06107 //w=0.131 //l=2.16 //layer=m1 \
 //thickness=0.36 //x=7.835 //y=1.93 //x2=7.835 //y2=4.09
r615 (  15 17 ) resistor r=0.0698411 //w=0.17 //l=0.120208 //layer=m1 \
 //thickness=0.36 //x=7.75 //y=1.845 //x2=7.835 //y2=1.93
r616 (  15 16 ) resistor r=0.300573 //w=0.131 //l=0.315 //layer=m1 \
 //thickness=0.36 //x=7.75 //y=1.845 //x2=7.435 //y2=1.845
r617 (  14 16 ) resistor r=0.0698411 //w=0.17 //l=0.120208 //layer=m1 \
 //thickness=0.36 //x=7.35 //y=1.76 //x2=7.435 //y2=1.845
r618 (  13 45 ) resistor r=0.0717383 //w=0.224 //l=0.115 //layer=m1 \
 //thickness=0.36 //x=7.35 //y=1.305 //x2=7.35 //y2=1.19
r619 (  13 14 ) resistor r=0.43416 //w=0.131 //l=0.455 //layer=m1 \
 //thickness=0.36 //x=7.35 //y=1.305 //x2=7.35 //y2=1.76
r620 (  12 41 ) resistor r=0.0675342 //w=0.23 //l=0.115 //layer=m1 \
 //thickness=0.36 //x=7.17 //y=5.335 //x2=7.055 //y2=5.335
r621 (  11 20 ) resistor r=0.0698411 //w=0.17 //l=0.120208 //layer=m1 \
 //thickness=0.36 //x=7.75 //y=5.335 //x2=7.835 //y2=5.25
r622 (  11 12 ) resistor r=0.553435 //w=0.131 //l=0.58 //layer=m1 \
 //thickness=0.36 //x=7.75 //y=5.335 //x2=7.17 //y2=5.335
r623 (  10 43 ) resistor r=0.00118313 //w=0.23 //layer=m1 //thickness=0.36 \
 //x=7.055 //y=5.56 //x2=7.055 //y2=5.56
r624 (  9 41 ) resistor r=0.002872 //w=0.34 //l=0.085 //layer=m1 \
 //thickness=0.36 //x=7.055 //y=5.42 //x2=7.055 //y2=5.335
r625 (  9 10 ) resistor r=0.091623 //w=0.191 //l=0.14 //layer=m1 \
 //thickness=0.36 //x=7.055 //y=5.42 //x2=7.055 //y2=5.56
r626 (  8 38 ) resistor r=0.0262263 //w=0.232 //l=0.12 //layer=m1 \
 //thickness=0.36 //x=6.295 //y=5.335 //x2=6.175 //y2=5.335
r627 (  7 41 ) resistor r=0.0675342 //w=0.23 //l=0.115 //layer=m1 \
 //thickness=0.36 //x=6.94 //y=5.335 //x2=7.055 //y2=5.335
r628 (  7 8 ) resistor r=0.615458 //w=0.131 //l=0.645 //layer=m1 \
 //thickness=0.36 //x=6.94 //y=5.335 //x2=6.295 //y2=5.335
r629 (  6 35 ) resistor r=0.0222262 //w=0.217 //l=0.118 //layer=m1 \
 //thickness=0.36 //x=5.415 //y=5.335 //x2=5.297 //y2=5.335
r630 (  5 38 ) resistor r=0.0262263 //w=0.232 //l=0.12 //layer=m1 \
 //thickness=0.36 //x=6.055 //y=5.335 //x2=6.175 //y2=5.335
r631 (  5 6 ) resistor r=0.610687 //w=0.131 //l=0.64 //layer=m1 \
 //thickness=0.36 //x=6.055 //y=5.335 //x2=5.415 //y2=5.335
r632 (  4 30 ) resistor r=0.0878548 //w=0.228 //l=0.159295 //layer=m1 \
 //thickness=0.36 //x=2.285 //y=4.735 //x2=2.315 //y2=4.88
r633 (  3 34 ) resistor r=0.0894971 //w=0.376 //l=0.179123 //layer=m1 \
 //thickness=0.36 //x=2.285 //y=4.405 //x2=2.337 //y2=4.25
r634 (  3 4 ) resistor r=0.314885 //w=0.131 //l=0.33 //layer=m1 \
 //thickness=0.36 //x=2.285 //y=4.405 //x2=2.285 //y2=4.735
r635 (  2 32 ) resistor r=0.0911593 //w=0.376 //l=0.184174 //layer=m1 \
 //thickness=0.36 //x=2.285 //y=4.085 //x2=2.337 //y2=4.245
r636 (  2 28 ) resistor r=1.62214 //w=0.131 //l=1.7 //layer=m1 \
 //thickness=0.36 //x=2.285 //y=4.085 //x2=2.285 //y2=2.385
ends PM_DFFSNQNX1\%noxref_4

subckt PM_DFFSNQNX1\%QN ( 1 2 3 4 5 6 7 8 9 12 17 18 20 21 25 30 33 34 39 40 \
 43 45 64 66 67 70 78 95 104 108 109 110 111 112 113 114 115 117 123 124 125 \
 126 138 140 141 )
c276 ( 138 0 ) capacitor c=0.00878249f //x=18.675 //y=1.085
c277 ( 126 0 ) capacitor c=0.0612936f //x=21.43 //y=4.97
c278 ( 125 0 ) capacitor c=0.0376642f //x=21.72 //y=4.97
c279 ( 124 0 ) capacitor c=0.0346489f //x=21.385 //y=1.4
c280 ( 123 0 ) capacitor c=0.018692f //x=21.385 //y=1.055
c281 ( 117 0 ) capacitor c=0.0137077f //x=21.23 //y=1.555
c282 ( 115 0 ) capacitor c=0.0158585f //x=21.23 //y=0.9
c283 ( 114 0 ) capacitor c=0.0982562f //x=20.855 //y=2.095
c284 ( 113 0 ) capacitor c=0.0229444f //x=20.855 //y=1.71
c285 ( 112 0 ) capacitor c=0.0234359f //x=20.855 //y=1.4
c286 ( 111 0 ) capacitor c=0.019815f //x=20.855 //y=1.055
c287 ( 110 0 ) capacitor c=0.110208f //x=21.795 //y=6.2
c288 ( 109 0 ) capacitor c=0.158957f //x=21.355 //y=6.2
c289 ( 104 0 ) capacitor c=0.0014751f //x=21.155 //y=4.88
c290 ( 95 0 ) capacitor c=9.93222e-19 //x=21.155 //y=2.26
c291 ( 78 0 ) capacitor c=0.0322017f //x=18.825 //y=5.56
c292 ( 70 0 ) capacitor c=0.0290435f //x=17.945 //y=5.56
c293 ( 67 0 ) capacitor c=0.0228509f //x=21 //y=3.125
c294 ( 66 0 ) capacitor c=6.88652e-19 //x=21.16 //y=3.125
c295 ( 64 0 ) capacitor c=8.63658e-19 //x=19.47 //y=3.12
c296 ( 45 0 ) capacitor c=0.0111172f //x=18.865 //y=1.18
c297 ( 43 0 ) capacitor c=5.78613e-19 //x=18.825 //y=5.56
c298 ( 40 0 ) capacitor c=0.0121411f //x=18.825 //y=5.38
c299 ( 39 0 ) capacitor c=0.00911838f //x=17.945 //y=5.56
c300 ( 34 0 ) capacitor c=0.00660887f //x=21.155 //y=4.755
c301 ( 33 0 ) capacitor c=0.0146803f //x=21.155 //y=3.285
c302 ( 30 0 ) capacitor c=0.00473091f //x=21.155 //y=2.375
c303 ( 25 0 ) capacitor c=0.013469f //x=19.305 //y=3.28
c304 ( 21 0 ) capacitor c=0.00454594f //x=18.95 //y=1.835
c305 ( 20 0 ) capacitor c=0.0119544f //x=19.22 //y=1.835
c306 ( 18 0 ) capacitor c=0.0123722f //x=19.22 //y=5.38
c307 ( 17 0 ) capacitor c=0.0133876f //x=18.865 //y=1.75
c308 ( 12 0 ) capacitor c=0.0151309f //x=18.71 //y=5.38
c309 ( 9 0 ) capacitor c=0.0166725f //x=21.155 //y=3.14
c310 ( 8 0 ) capacitor c=0.0171618f //x=19.305 //y=3.14
c311 ( 6 0 ) capacitor c=0.0474419f //x=21.155 //y=4.25
c312 ( 5 0 ) capacitor c=0.0164286f //x=21.155 //y=2.77
c313 ( 2 0 ) capacitor c=0.0532099f //x=19.305 //y=4.25
c314 ( 1 0 ) capacitor c=0.0268035f //x=19.305 //y=2.77
r315 (  125 127 ) resistor r=26.9307 //w=0.15 //l=0.106066 //layer=ply \
 //thickness=0.18 //x=21.72 //y=4.97 //x2=21.795 //y2=5.045
r316 (  125 126 ) resistor r=148.702 //w=0.094 //l=0.29 //layer=ply \
 //thickness=0.18 //x=21.72 //y=4.97 //x2=21.43 //y2=4.97
r317 (  124 137 ) resistor r=45.1352 //w=0.168 //l=0.173853 //layer=ply \
 //thickness=0.18 //x=21.385 //y=1.4 //x2=21.345 //y2=1.555
r318 (  123 136 ) resistor r=45.1352 //w=0.168 //l=0.173853 //layer=ply \
 //thickness=0.18 //x=21.385 //y=1.055 //x2=21.345 //y2=0.9
r319 (  123 124 ) resistor r=176.904 //w=0.094 //l=0.345 //layer=ply \
 //thickness=0.18 //x=21.385 //y=1.055 //x2=21.385 //y2=1.4
r320 (  120 126 ) resistor r=22.7971 //w=0.269 //l=0.106066 //layer=ply \
 //thickness=0.18 //x=21.355 //y=5.045 //x2=21.43 //y2=4.97
r321 (  120 135 ) resistor r=35.8364 //w=0.269 //l=0.270185 //layer=ply \
 //thickness=0.18 //x=21.355 //y=5.045 //x2=21.155 //y2=4.88
r322 (  118 131 ) resistor r=10.701 //w=0.21 //l=0.115 //layer=ply \
 //thickness=0.18 //x=21.01 //y=1.555 //x2=20.895 //y2=1.555
r323 (  117 137 ) resistor r=5.52526 //w=0.168 //l=0.115 //layer=ply \
 //thickness=0.18 //x=21.23 //y=1.555 //x2=21.345 //y2=1.555
r324 (  116 130 ) resistor r=5.52526 //w=0.168 //l=0.115 //layer=ply \
 //thickness=0.18 //x=21.01 //y=0.9 //x2=20.895 //y2=0.9
r325 (  115 136 ) resistor r=5.52526 //w=0.168 //l=0.115 //layer=ply \
 //thickness=0.18 //x=21.23 //y=0.9 //x2=21.345 //y2=0.9
r326 (  115 116 ) resistor r=112.809 //w=0.094 //l=0.22 //layer=ply \
 //thickness=0.18 //x=21.23 //y=0.9 //x2=21.01 //y2=0.9
r327 (  114 133 ) resistor r=58.7805 //w=0.246 //l=0.373497 //layer=ply \
 //thickness=0.18 //x=20.855 //y=2.095 //x2=21.155 //y2=2.26
r328 (  113 131 ) resistor r=39.5823 //w=0.21 //l=0.173853 //layer=ply \
 //thickness=0.18 //x=20.855 //y=1.71 //x2=20.895 //y2=1.555
r329 (  113 114 ) resistor r=197.415 //w=0.094 //l=0.385 //layer=ply \
 //thickness=0.18 //x=20.855 //y=1.71 //x2=20.855 //y2=2.095
r330 (  112 131 ) resistor r=39.5823 //w=0.21 //l=0.173853 //layer=ply \
 //thickness=0.18 //x=20.855 //y=1.4 //x2=20.895 //y2=1.555
r331 (  111 130 ) resistor r=45.1352 //w=0.168 //l=0.173853 //layer=ply \
 //thickness=0.18 //x=20.855 //y=1.055 //x2=20.895 //y2=0.9
r332 (  111 112 ) resistor r=176.904 //w=0.094 //l=0.345 //layer=ply \
 //thickness=0.18 //x=20.855 //y=1.055 //x2=20.855 //y2=1.4
r333 (  110 127 ) resistor r=592.245 //w=0.094 //l=1.155 //layer=ply \
 //thickness=0.18 //x=21.795 //y=6.2 //x2=21.795 //y2=5.045
r334 (  109 120 ) resistor r=592.245 //w=0.094 //l=1.155 //layer=ply \
 //thickness=0.18 //x=21.355 //y=6.2 //x2=21.355 //y2=5.045
r335 (  108 117 ) resistor r=56.4043 //w=0.094 //l=0.11 //layer=ply \
 //thickness=0.18 //x=21.12 //y=1.555 //x2=21.23 //y2=1.555
r336 (  108 118 ) resistor r=56.4043 //w=0.094 //l=0.11 //layer=ply \
 //thickness=0.18 //x=21.12 //y=1.555 //x2=21.01 //y2=1.555
r337 (  104 135 ) resistor r=152 //w=0.17 //l=0.17 //layer=licon //count=1 \
 //x=21.155 //y=4.88 //x2=21.155 //y2=4.88
r338 (  95 133 ) resistor r=152 //w=0.17 //l=0.17 //layer=licon //count=1 \
 //x=21.155 //y=2.26 //x2=21.155 //y2=2.26
r339 (  78 141 ) resistor r=23.615 //w=0.187 //l=0.345 //layer=li \
 //thickness=0.1 //x=18.825 //y=5.56 //x2=18.825 //y2=5.905
r340 (  70 140 ) resistor r=23.615 //w=0.187 //l=0.345 //layer=li \
 //thickness=0.1 //x=17.945 //y=5.56 //x2=17.945 //y2=5.905
r341 (  66 67 ) resistor r=0.10734 //w=0.281 //l=0.16 //layer=m2 \
 //thickness=0.36 //x=21.16 //y=3.125 //x2=21 //y2=3.125
r342 (  64 67 ) resistor r=1.45992 //w=0.131 //l=1.53 //layer=m2 \
 //thickness=0.36 //x=19.47 //y=3.14 //x2=21 //y2=3.14
r343 (  62 64 ) resistor r=0.10734 //w=0.281 //l=0.16 //layer=m2 \
 //thickness=0.36 //x=19.31 //y=3.12 //x2=19.47 //y2=3.12
r344 (  58 104 ) resistor r=9.3 //w=0.17 //l=0.17 //layer=mcon //count=1 \
 //x=21.155 //y=4.88 //x2=21.155 //y2=4.88
r345 (  56 95 ) resistor r=9.3 //w=0.17 //l=0.17 //layer=mcon //count=1 \
 //x=21.155 //y=2.26 //x2=21.155 //y2=2.26
r346 (  52 66 ) resistor r=4.5 //w=0.15 //l=0.15 //layer=via1 //count=1 \
 //x=21.16 //y=3.125 //x2=21.16 //y2=3.125
r347 (  48 62 ) resistor r=4.5 //w=0.15 //l=0.15 //layer=via1 //count=1 \
 //x=19.31 //y=3.12 //x2=19.31 //y2=3.12
r348 (  45 138 ) resistor r=9.3 //w=0.17 //l=0.17 //layer=mcon //count=1 \
 //x=18.865 //y=1.18 //x2=18.865 //y2=1.18
r349 (  43 78 ) resistor r=9.3 //w=0.17 //l=0.17 //layer=mcon //count=1 \
 //x=18.825 //y=5.56 //x2=18.825 //y2=5.56
r350 (  40 43 ) resistor r=0.117801 //w=0.191 //l=0.18 //layer=m1 \
 //thickness=0.36 //x=18.825 //y=5.38 //x2=18.825 //y2=5.56
r351 (  39 70 ) resistor r=9.3 //w=0.17 //l=0.17 //layer=mcon //count=1 \
 //x=17.945 //y=5.56 //x2=17.945 //y2=5.56
r352 (  37 39 ) resistor r=0.10274 //w=0.219 //l=0.18 //layer=m1 \
 //thickness=0.36 //x=17.945 //y=5.38 //x2=17.945 //y2=5.56
r353 (  34 58 ) resistor r=0.0760407 //w=0.238 //l=0.125 //layer=m1 \
 //thickness=0.36 //x=21.155 //y=4.755 //x2=21.155 //y2=4.88
r354 (  31 52 ) resistor r=0.0912814 //w=0.379 //l=0.183303 //layer=m1 \
 //thickness=0.36 //x=21.155 //y=2.965 //x2=21.105 //y2=3.125
r355 (  30 56 ) resistor r=0.0719237 //w=0.222 //l=0.115 //layer=m1 \
 //thickness=0.36 //x=21.155 //y=2.375 //x2=21.155 //y2=2.26
r356 (  23 48 ) resistor r=0.0910802 //w=0.374 //l=0.185472 //layer=m1 \
 //thickness=0.36 //x=19.305 //y=2.96 //x2=19.36 //y2=3.12
r357 (  20 22 ) resistor r=0.0698411 //w=0.17 //l=0.120208 //layer=m1 \
 //thickness=0.36 //x=19.22 //y=1.835 //x2=19.305 //y2=1.92
r358 (  20 21 ) resistor r=0.257634 //w=0.131 //l=0.27 //layer=m1 \
 //thickness=0.36 //x=19.22 //y=1.835 //x2=18.95 //y2=1.835
r359 (  19 40 ) resistor r=0.0257089 //w=0.23 //l=0.115 //layer=m1 \
 //thickness=0.36 //x=18.94 //y=5.38 //x2=18.825 //y2=5.38
r360 (  18 26 ) resistor r=0.0698411 //w=0.17 //l=0.120208 //layer=m1 \
 //thickness=0.36 //x=19.22 //y=5.38 //x2=19.305 //y2=5.295
r361 (  18 19 ) resistor r=0.267176 //w=0.131 //l=0.28 //layer=m1 \
 //thickness=0.36 //x=19.22 //y=5.38 //x2=18.94 //y2=5.38
r362 (  17 21 ) resistor r=0.0698411 //w=0.17 //l=0.120208 //layer=m1 \
 //thickness=0.36 //x=18.865 //y=1.75 //x2=18.95 //y2=1.835
r363 (  16 45 ) resistor r=0.0913624 //w=0.191 //l=0.12 //layer=m1 \
 //thickness=0.36 //x=18.865 //y=1.3 //x2=18.865 //y2=1.18
r364 (  16 17 ) resistor r=0.429389 //w=0.131 //l=0.45 //layer=m1 \
 //thickness=0.36 //x=18.865 //y=1.3 //x2=18.865 //y2=1.75
r365 (  13 37 ) resistor r=0.0227762 //w=0.219 //l=0.115 //layer=m1 \
 //thickness=0.36 //x=18.06 //y=5.38 //x2=17.945 //y2=5.38
r366 (  12 40 ) resistor r=0.0257089 //w=0.23 //l=0.115 //layer=m1 \
 //thickness=0.36 //x=18.71 //y=5.38 //x2=18.825 //y2=5.38
r367 (  12 13 ) resistor r=0.620229 //w=0.131 //l=0.65 //layer=m1 \
 //thickness=0.36 //x=18.71 //y=5.38 //x2=18.06 //y2=5.38
r368 (  9 33 ) resistor r=0.0863342 //w=0.379 //l=0.168152 //layer=m1 \
 //thickness=0.36 //x=21.105 //y=3.14 //x2=21.155 //y2=3.285
r369 (  9 52 ) resistor r=0.00494723 //w=0.379 //l=0.015 //layer=m1 \
 //thickness=0.36 //x=21.105 //y=3.14 //x2=21.105 //y2=3.125
r370 (  8 25 ) resistor r=0.0843957 //w=0.374 //l=0.165227 //layer=m1 \
 //thickness=0.36 //x=19.36 //y=3.14 //x2=19.305 //y2=3.28
r371 (  8 48 ) resistor r=0.00668449 //w=0.374 //l=0.02 //layer=m1 \
 //thickness=0.36 //x=19.36 //y=3.14 //x2=19.36 //y2=3.12
r372 (  7 34 ) resistor r=0.128817 //w=0.131 //l=0.135 //layer=m1 \
 //thickness=0.36 //x=21.155 //y=4.62 //x2=21.155 //y2=4.755
r373 (  6 7 ) resistor r=0.353053 //w=0.131 //l=0.37 //layer=m1 \
 //thickness=0.36 //x=21.155 //y=4.25 //x2=21.155 //y2=4.62
r374 (  6 33 ) resistor r=0.920802 //w=0.131 //l=0.965 //layer=m1 \
 //thickness=0.36 //x=21.155 //y=4.25 //x2=21.155 //y2=3.285
r375 (  5 31 ) resistor r=0.186069 //w=0.131 //l=0.195 //layer=m1 \
 //thickness=0.36 //x=21.155 //y=2.77 //x2=21.155 //y2=2.965
r376 (  5 30 ) resistor r=0.376908 //w=0.131 //l=0.395 //layer=m1 \
 //thickness=0.36 //x=21.155 //y=2.77 //x2=21.155 //y2=2.375
r377 (  4 26 ) resistor r=0.291031 //w=0.131 //l=0.305 //layer=m1 \
 //thickness=0.36 //x=19.305 //y=4.99 //x2=19.305 //y2=5.295
r378 (  3 4 ) resistor r=0.353053 //w=0.131 //l=0.37 //layer=m1 \
 //thickness=0.36 //x=19.305 //y=4.62 //x2=19.305 //y2=4.99
r379 (  2 3 ) resistor r=0.353053 //w=0.131 //l=0.37 //layer=m1 \
 //thickness=0.36 //x=19.305 //y=4.25 //x2=19.305 //y2=4.62
r380 (  2 25 ) resistor r=0.925573 //w=0.131 //l=0.97 //layer=m1 \
 //thickness=0.36 //x=19.305 //y=4.25 //x2=19.305 //y2=3.28
r381 (  1 23 ) resistor r=0.181298 //w=0.131 //l=0.19 //layer=m1 \
 //thickness=0.36 //x=19.305 //y=2.77 //x2=19.305 //y2=2.96
r382 (  1 22 ) resistor r=0.811069 //w=0.131 //l=0.85 //layer=m1 \
 //thickness=0.36 //x=19.305 //y=2.77 //x2=19.305 //y2=1.92
ends PM_DFFSNQNX1\%QN

subckt PM_DFFSNQNX1\%SN ( 1 2 3 4 5 6 7 8 9 10 11 15 16 40 42 43 46 51 56 61 \
 65 66 67 68 69 70 71 72 73 75 81 82 83 84 85 90 91 92 94 100 101 102 103 104 \
 112 123 )
c339 ( 123 0 ) capacitor c=0.0369044f //x=22.265 //y=4.88
c340 ( 112 0 ) capacitor c=0.0369044f //x=10.795 //y=4.88
c341 ( 104 0 ) capacitor c=0.0309248f //x=22.6 //y=4.97
c342 ( 103 0 ) capacitor c=0.0847377f //x=22.355 //y=2.095
c343 ( 102 0 ) capacitor c=0.0170266f //x=22.355 //y=1.63
c344 ( 101 0 ) capacitor c=0.018609f //x=22.355 //y=1.4
c345 ( 100 0 ) capacitor c=0.0186599f //x=22.355 //y=1.09
c346 ( 94 0 ) capacitor c=0.0146988f //x=22.2 //y=1.555
c347 ( 92 0 ) capacitor c=0.0148531f //x=22.2 //y=0.935
c348 ( 91 0 ) capacitor c=0.0334406f //x=21.83 //y=1.4
c349 ( 90 0 ) capacitor c=0.0173191f //x=21.83 //y=1.09
c350 ( 85 0 ) capacitor c=0.0309248f //x=11.13 //y=4.97
c351 ( 84 0 ) capacitor c=0.0845067f //x=10.885 //y=2.095
c352 ( 83 0 ) capacitor c=0.0170266f //x=10.885 //y=1.63
c353 ( 82 0 ) capacitor c=0.018609f //x=10.885 //y=1.4
c354 ( 81 0 ) capacitor c=0.0186599f //x=10.885 //y=1.09
c355 ( 75 0 ) capacitor c=0.0146988f //x=10.73 //y=1.555
c356 ( 73 0 ) capacitor c=0.0148531f //x=10.73 //y=0.935
c357 ( 72 0 ) capacitor c=0.0334406f //x=10.36 //y=1.4
c358 ( 71 0 ) capacitor c=0.0173191f //x=10.36 //y=1.09
c359 ( 70 0 ) capacitor c=0.110208f //x=22.675 //y=6.2
c360 ( 69 0 ) capacitor c=0.110214f //x=22.235 //y=6.2
c361 ( 68 0 ) capacitor c=0.110208f //x=11.205 //y=6.2
c362 ( 67 0 ) capacitor c=0.110214f //x=10.765 //y=6.2
c363 ( 61 0 ) capacitor c=0.00129935f //x=22.265 //y=4.88
c364 ( 56 0 ) capacitor c=0.00121786f //x=22.265 //y=2.26
c365 ( 51 0 ) capacitor c=0.00129935f //x=10.795 //y=4.88
c366 ( 46 0 ) capacitor c=0.00121786f //x=10.795 //y=2.26
c367 ( 43 0 ) capacitor c=0.287254f //x=22.095 //y=2.39
c368 ( 42 0 ) capacitor c=0.00526425f //x=22.255 //y=2.39
c369 ( 40 0 ) capacitor c=0.00542282f //x=10.955 //y=2.39
c370 ( 16 0 ) capacitor c=0.00505177f //x=22.265 //y=4.765
c371 ( 15 0 ) capacitor c=0.0114047f //x=22.265 //y=2.55
c372 ( 11 0 ) capacitor c=0.00505177f //x=10.795 //y=4.765
c373 ( 10 0 ) capacitor c=0.0112921f //x=10.795 //y=2.55
c374 ( 4 0 ) capacitor c=0.0639167f //x=22.265 //y=2.77
c375 ( 1 0 ) capacitor c=0.0636895f //x=10.795 //y=2.77
r376 (  125 126 ) resistor r=32.4568 //w=0.214 //l=0.075 //layer=ply \
 //thickness=0.18 //x=22.265 //y=4.97 //x2=22.265 //y2=5.045
r377 (  123 125 ) resistor r=20.271 //w=0.214 //l=0.09 //layer=ply \
 //thickness=0.18 //x=22.265 //y=4.88 //x2=22.265 //y2=4.97
r378 (  114 115 ) resistor r=32.4568 //w=0.214 //l=0.075 //layer=ply \
 //thickness=0.18 //x=10.795 //y=4.97 //x2=10.795 //y2=5.045
r379 (  112 114 ) resistor r=20.271 //w=0.214 //l=0.09 //layer=ply \
 //thickness=0.18 //x=10.795 //y=4.88 //x2=10.795 //y2=4.97
r380 (  105 125 ) resistor r=16.5046 //w=0.27 //l=0.135 //layer=ply \
 //thickness=0.18 //x=22.4 //y=4.97 //x2=22.265 //y2=4.97
r381 (  104 106 ) resistor r=26.9307 //w=0.15 //l=0.106066 //layer=ply \
 //thickness=0.18 //x=22.6 //y=4.97 //x2=22.675 //y2=5.045
r382 (  104 105 ) resistor r=102.553 //w=0.094 //l=0.2 //layer=ply \
 //thickness=0.18 //x=22.6 //y=4.97 //x2=22.4 //y2=4.97
r383 (  103 130 ) resistor r=38.6777 //w=0.284 //l=0.198997 //layer=ply \
 //thickness=0.18 //x=22.355 //y=2.095 //x2=22.28 //y2=2.26
r384 (  102 128 ) resistor r=21.2976 //w=0.217 //l=0.0928709 //layer=ply \
 //thickness=0.18 //x=22.355 //y=1.63 //x2=22.315 //y2=1.555
r385 (  102 103 ) resistor r=238.436 //w=0.094 //l=0.465 //layer=ply \
 //thickness=0.18 //x=22.355 //y=1.63 //x2=22.355 //y2=2.095
r386 (  101 128 ) resistor r=39.0671 //w=0.217 //l=0.173853 //layer=ply \
 //thickness=0.18 //x=22.355 //y=1.4 //x2=22.315 //y2=1.555
r387 (  100 127 ) resistor r=45.1352 //w=0.168 //l=0.173853 //layer=ply \
 //thickness=0.18 //x=22.355 //y=1.09 //x2=22.315 //y2=0.935
r388 (  100 101 ) resistor r=158.957 //w=0.094 //l=0.31 //layer=ply \
 //thickness=0.18 //x=22.355 //y=1.09 //x2=22.355 //y2=1.4
r389 (  95 121 ) resistor r=5.52526 //w=0.168 //l=0.115 //layer=ply \
 //thickness=0.18 //x=21.985 //y=1.555 //x2=21.87 //y2=1.555
r390 (  94 128 ) resistor r=11.4558 //w=0.217 //l=0.115 //layer=ply \
 //thickness=0.18 //x=22.2 //y=1.555 //x2=22.315 //y2=1.555
r391 (  93 120 ) resistor r=5.52526 //w=0.168 //l=0.115 //layer=ply \
 //thickness=0.18 //x=21.985 //y=0.935 //x2=21.87 //y2=0.935
r392 (  92 127 ) resistor r=5.52526 //w=0.168 //l=0.115 //layer=ply \
 //thickness=0.18 //x=22.2 //y=0.935 //x2=22.315 //y2=0.935
r393 (  92 93 ) resistor r=110.245 //w=0.094 //l=0.215 //layer=ply \
 //thickness=0.18 //x=22.2 //y=0.935 //x2=21.985 //y2=0.935
r394 (  91 121 ) resistor r=45.1352 //w=0.168 //l=0.173853 //layer=ply \
 //thickness=0.18 //x=21.83 //y=1.4 //x2=21.87 //y2=1.555
r395 (  90 120 ) resistor r=45.1352 //w=0.168 //l=0.173853 //layer=ply \
 //thickness=0.18 //x=21.83 //y=1.09 //x2=21.87 //y2=0.935
r396 (  90 91 ) resistor r=158.957 //w=0.094 //l=0.31 //layer=ply \
 //thickness=0.18 //x=21.83 //y=1.09 //x2=21.83 //y2=1.4
r397 (  86 114 ) resistor r=16.5046 //w=0.27 //l=0.135 //layer=ply \
 //thickness=0.18 //x=10.93 //y=4.97 //x2=10.795 //y2=4.97
r398 (  85 87 ) resistor r=26.9307 //w=0.15 //l=0.106066 //layer=ply \
 //thickness=0.18 //x=11.13 //y=4.97 //x2=11.205 //y2=5.045
r399 (  85 86 ) resistor r=102.553 //w=0.094 //l=0.2 //layer=ply \
 //thickness=0.18 //x=11.13 //y=4.97 //x2=10.93 //y2=4.97
r400 (  84 119 ) resistor r=38.6777 //w=0.284 //l=0.198997 //layer=ply \
 //thickness=0.18 //x=10.885 //y=2.095 //x2=10.81 //y2=2.26
r401 (  83 117 ) resistor r=21.2976 //w=0.217 //l=0.0928709 //layer=ply \
 //thickness=0.18 //x=10.885 //y=1.63 //x2=10.845 //y2=1.555
r402 (  83 84 ) resistor r=238.436 //w=0.094 //l=0.465 //layer=ply \
 //thickness=0.18 //x=10.885 //y=1.63 //x2=10.885 //y2=2.095
r403 (  82 117 ) resistor r=39.0671 //w=0.217 //l=0.173853 //layer=ply \
 //thickness=0.18 //x=10.885 //y=1.4 //x2=10.845 //y2=1.555
r404 (  81 116 ) resistor r=45.1352 //w=0.168 //l=0.173853 //layer=ply \
 //thickness=0.18 //x=10.885 //y=1.09 //x2=10.845 //y2=0.935
r405 (  81 82 ) resistor r=158.957 //w=0.094 //l=0.31 //layer=ply \
 //thickness=0.18 //x=10.885 //y=1.09 //x2=10.885 //y2=1.4
r406 (  76 110 ) resistor r=5.52526 //w=0.168 //l=0.115 //layer=ply \
 //thickness=0.18 //x=10.515 //y=1.555 //x2=10.4 //y2=1.555
r407 (  75 117 ) resistor r=11.4558 //w=0.217 //l=0.115 //layer=ply \
 //thickness=0.18 //x=10.73 //y=1.555 //x2=10.845 //y2=1.555
r408 (  74 109 ) resistor r=5.52526 //w=0.168 //l=0.115 //layer=ply \
 //thickness=0.18 //x=10.515 //y=0.935 //x2=10.4 //y2=0.935
r409 (  73 116 ) resistor r=5.52526 //w=0.168 //l=0.115 //layer=ply \
 //thickness=0.18 //x=10.73 //y=0.935 //x2=10.845 //y2=0.935
r410 (  73 74 ) resistor r=110.245 //w=0.094 //l=0.215 //layer=ply \
 //thickness=0.18 //x=10.73 //y=0.935 //x2=10.515 //y2=0.935
r411 (  72 110 ) resistor r=45.1352 //w=0.168 //l=0.173853 //layer=ply \
 //thickness=0.18 //x=10.36 //y=1.4 //x2=10.4 //y2=1.555
r412 (  71 109 ) resistor r=45.1352 //w=0.168 //l=0.173853 //layer=ply \
 //thickness=0.18 //x=10.36 //y=1.09 //x2=10.4 //y2=0.935
r413 (  71 72 ) resistor r=158.957 //w=0.094 //l=0.31 //layer=ply \
 //thickness=0.18 //x=10.36 //y=1.09 //x2=10.36 //y2=1.4
r414 (  70 106 ) resistor r=592.245 //w=0.094 //l=1.155 //layer=ply \
 //thickness=0.18 //x=22.675 //y=6.2 //x2=22.675 //y2=5.045
r415 (  69 126 ) resistor r=592.245 //w=0.094 //l=1.155 //layer=ply \
 //thickness=0.18 //x=22.235 //y=6.2 //x2=22.235 //y2=5.045
r416 (  68 87 ) resistor r=592.245 //w=0.094 //l=1.155 //layer=ply \
 //thickness=0.18 //x=11.205 //y=6.2 //x2=11.205 //y2=5.045
r417 (  67 115 ) resistor r=592.245 //w=0.094 //l=1.155 //layer=ply \
 //thickness=0.18 //x=10.765 //y=6.2 //x2=10.765 //y2=5.045
r418 (  66 94 ) resistor r=55.3787 //w=0.094 //l=0.108 //layer=ply \
 //thickness=0.18 //x=22.092 //y=1.555 //x2=22.2 //y2=1.555
r419 (  66 95 ) resistor r=54.866 //w=0.094 //l=0.107 //layer=ply \
 //thickness=0.18 //x=22.092 //y=1.555 //x2=21.985 //y2=1.555
r420 (  65 75 ) resistor r=55.3787 //w=0.094 //l=0.108 //layer=ply \
 //thickness=0.18 //x=10.622 //y=1.555 //x2=10.73 //y2=1.555
r421 (  65 76 ) resistor r=54.866 //w=0.094 //l=0.107 //layer=ply \
 //thickness=0.18 //x=10.622 //y=1.555 //x2=10.515 //y2=1.555
r422 (  61 123 ) resistor r=152 //w=0.17 //l=0.17 //layer=licon //count=1 \
 //x=22.265 //y=4.88 //x2=22.265 //y2=4.88
r423 (  56 130 ) resistor r=152 //w=0.17 //l=0.17 //layer=licon //count=1 \
 //x=22.265 //y=2.26 //x2=22.265 //y2=2.26
r424 (  51 112 ) resistor r=152 //w=0.17 //l=0.17 //layer=licon //count=1 \
 //x=10.795 //y=4.88 //x2=10.795 //y2=4.88
r425 (  46 119 ) resistor r=152 //w=0.17 //l=0.17 //layer=licon //count=1 \
 //x=10.795 //y=2.26 //x2=10.795 //y2=2.26
r426 (  42 43 ) resistor r=0.10734 //w=0.281 //l=0.16 //layer=m2 \
 //thickness=0.36 //x=22.255 //y=2.39 //x2=22.095 //y2=2.39
r427 (  40 43 ) resistor r=10.6298 //w=0.131 //l=11.14 //layer=m2 \
 //thickness=0.36 //x=10.955 //y=2.4 //x2=22.095 //y2=2.4
r428 (  38 40 ) resistor r=0.10734 //w=0.281 //l=0.16 //layer=m2 \
 //thickness=0.36 //x=10.795 //y=2.39 //x2=10.955 //y2=2.39
r429 (  33 42 ) resistor r=4.5 //w=0.15 //l=0.15 //layer=via1 //count=1 \
 //x=22.255 //y=2.39 //x2=22.255 //y2=2.39
r430 (  31 56 ) resistor r=9.3 //w=0.17 //l=0.17 //layer=mcon //count=1 \
 //x=22.265 //y=2.26 //x2=22.265 //y2=2.26
r431 (  31 33 ) resistor r=0.0560345 //w=0.29 //l=0.13 //layer=m1 \
 //thickness=0.36 //x=22.255 //y=2.26 //x2=22.255 //y2=2.39
r432 (  29 61 ) resistor r=9.3 //w=0.17 //l=0.17 //layer=mcon //count=1 \
 //x=22.265 //y=4.88 //x2=22.265 //y2=4.88
r433 (  26 38 ) resistor r=4.5 //w=0.15 //l=0.15 //layer=via1 //count=1 \
 //x=10.795 //y=2.39 //x2=10.795 //y2=2.39
r434 (  24 46 ) resistor r=9.3 //w=0.17 //l=0.17 //layer=mcon //count=1 \
 //x=10.795 //y=2.26 //x2=10.795 //y2=2.26
r435 (  24 26 ) resistor r=0.0560345 //w=0.29 //l=0.13 //layer=m1 \
 //thickness=0.36 //x=10.795 //y=2.26 //x2=10.795 //y2=2.39
r436 (  22 51 ) resistor r=9.3 //w=0.17 //l=0.17 //layer=mcon //count=1 \
 //x=10.795 //y=4.88 //x2=10.795 //y2=4.88
r437 (  16 29 ) resistor r=0.0717383 //w=0.224 //l=0.115 //layer=m1 \
 //thickness=0.36 //x=22.265 //y=4.765 //x2=22.265 //y2=4.88
r438 (  11 22 ) resistor r=0.0717383 //w=0.224 //l=0.115 //layer=m1 \
 //thickness=0.36 //x=10.795 //y=4.765 //x2=10.795 //y2=4.88
r439 (  9 15 ) resistor r=0.0858804 //w=0.29 //l=0.154919 //layer=m1 \
 //thickness=0.36 //x=22.255 //y=2.4 //x2=22.265 //y2=2.55
r440 (  9 33 ) resistor r=0.00431034 //w=0.29 //l=0.01 //layer=m1 \
 //thickness=0.36 //x=22.255 //y=2.4 //x2=22.255 //y2=2.39
r441 (  8 10 ) resistor r=0.0858804 //w=0.29 //l=0.15 //layer=m1 \
 //thickness=0.36 //x=10.795 //y=2.4 //x2=10.795 //y2=2.55
r442 (  8 26 ) resistor r=0.00431034 //w=0.29 //l=0.01 //layer=m1 \
 //thickness=0.36 //x=10.795 //y=2.4 //x2=10.795 //y2=2.39
r443 (  7 16 ) resistor r=0.138359 //w=0.131 //l=0.145 //layer=m1 \
 //thickness=0.36 //x=22.265 //y=4.62 //x2=22.265 //y2=4.765
r444 (  6 7 ) resistor r=0.353053 //w=0.131 //l=0.37 //layer=m1 \
 //thickness=0.36 //x=22.265 //y=4.25 //x2=22.265 //y2=4.62
r445 (  5 6 ) resistor r=1.05916 //w=0.131 //l=1.11 //layer=m1 \
 //thickness=0.36 //x=22.265 //y=3.14 //x2=22.265 //y2=4.25
r446 (  4 5 ) resistor r=0.353053 //w=0.131 //l=0.37 //layer=m1 \
 //thickness=0.36 //x=22.265 //y=2.77 //x2=22.265 //y2=3.14
r447 (  4 15 ) resistor r=0.209924 //w=0.131 //l=0.22 //layer=m1 \
 //thickness=0.36 //x=22.265 //y=2.77 //x2=22.265 //y2=2.55
r448 (  3 11 ) resistor r=1.19752 //w=0.131 //l=1.255 //layer=m1 \
 //thickness=0.36 //x=10.795 //y=3.51 //x2=10.795 //y2=4.765
r449 (  2 3 ) resistor r=0.353053 //w=0.131 //l=0.37 //layer=m1 \
 //thickness=0.36 //x=10.795 //y=3.14 //x2=10.795 //y2=3.51
r450 (  1 2 ) resistor r=0.353053 //w=0.131 //l=0.37 //layer=m1 \
 //thickness=0.36 //x=10.795 //y=2.77 //x2=10.795 //y2=3.14
r451 (  1 10 ) resistor r=0.209924 //w=0.131 //l=0.22 //layer=m1 \
 //thickness=0.36 //x=10.795 //y=2.77 //x2=10.795 //y2=2.55
ends PM_DFFSNQNX1\%SN

subckt PM_DFFSNQNX1\%noxref_7 ( 1 2 3 4 5 6 7 8 11 16 17 19 20 22 23 24 25 26 \
 27 28 36 40 47 48 51 53 58 60 67 69 72 78 83 84 86 87 90 99 104 113 118 126 \
 143 152 156 157 158 159 160 161 162 163 164 168 169 170 175 177 180 181 185 \
 186 187 192 194 197 198 202 203 204 209 211 214 215 217 218 223 227 228 233 \
 237 238 243 246 248 249 )
c573 ( 246 0 ) capacitor c=0.00878249f //x=15.345 //y=1.085
c574 ( 243 0 ) capacitor c=0.0651477f //x=23.375 //y=4.88
c575 ( 238 0 ) capacitor c=0.0278202f //x=23.375 //y=2.095
c576 ( 237 0 ) capacitor c=0.0503043f //x=23.375 //y=2.26
c577 ( 233 0 ) capacitor c=0.0651619f //x=11.905 //y=4.88
c578 ( 228 0 ) capacitor c=0.0278202f //x=11.905 //y=2.095
c579 ( 227 0 ) capacitor c=0.0503043f //x=11.905 //y=2.26
c580 ( 223 0 ) capacitor c=0.0654765f //x=7.095 //y=4.88
c581 ( 218 0 ) capacitor c=0.0278202f //x=7.095 //y=2.095
c582 ( 217 0 ) capacitor c=0.0503043f //x=7.095 //y=2.26
c583 ( 215 0 ) capacitor c=0.0443175f //x=23.895 //y=1.44
c584 ( 214 0 ) capacitor c=0.0199703f //x=23.895 //y=1.095
c585 ( 211 0 ) capacitor c=0.0162526f //x=23.74 //y=1.595
c586 ( 209 0 ) capacitor c=0.0157807f //x=23.74 //y=0.94
c587 ( 204 0 ) capacitor c=0.0220935f //x=23.365 //y=1.75
c588 ( 203 0 ) capacitor c=0.0207489f //x=23.365 //y=1.44
c589 ( 202 0 ) capacitor c=0.0194091f //x=23.365 //y=1.095
c590 ( 198 0 ) capacitor c=0.0443175f //x=12.425 //y=1.44
c591 ( 197 0 ) capacitor c=0.0199703f //x=12.425 //y=1.095
c592 ( 194 0 ) capacitor c=0.0162526f //x=12.27 //y=1.595
c593 ( 192 0 ) capacitor c=0.0157807f //x=12.27 //y=0.94
c594 ( 187 0 ) capacitor c=0.0220935f //x=11.895 //y=1.75
c595 ( 186 0 ) capacitor c=0.0207489f //x=11.895 //y=1.44
c596 ( 185 0 ) capacitor c=0.0194091f //x=11.895 //y=1.095
c597 ( 181 0 ) capacitor c=0.0443175f //x=7.615 //y=1.44
c598 ( 180 0 ) capacitor c=0.0199703f //x=7.615 //y=1.095
c599 ( 177 0 ) capacitor c=0.0162526f //x=7.46 //y=1.595
c600 ( 175 0 ) capacitor c=0.0157807f //x=7.46 //y=0.94
c601 ( 170 0 ) capacitor c=0.0220935f //x=7.085 //y=1.75
c602 ( 169 0 ) capacitor c=0.0207489f //x=7.085 //y=1.44
c603 ( 168 0 ) capacitor c=0.0194091f //x=7.085 //y=1.095
c604 ( 164 0 ) capacitor c=0.159671f //x=23.555 //y=6.2
c605 ( 163 0 ) capacitor c=0.110208f //x=23.115 //y=6.2
c606 ( 162 0 ) capacitor c=0.159671f //x=12.085 //y=6.2
c607 ( 161 0 ) capacitor c=0.110208f //x=11.645 //y=6.2
c608 ( 160 0 ) capacitor c=0.159671f //x=7.275 //y=6.2
c609 ( 159 0 ) capacitor c=0.110208f //x=6.835 //y=6.2
c610 ( 152 0 ) capacitor c=7.7417e-19 //x=23.375 //y=4.88
c611 ( 143 0 ) capacitor c=0.00101179f //x=23.375 //y=2.26
c612 ( 126 0 ) capacitor c=0.0319332f //x=15.495 //y=5.56
c613 ( 118 0 ) capacitor c=0.0290186f //x=14.615 //y=5.56
c614 ( 113 0 ) capacitor c=7.7417e-19 //x=11.905 //y=4.88
c615 ( 104 0 ) capacitor c=0.00101179f //x=11.905 //y=2.26
c616 ( 99 0 ) capacitor c=7.7417e-19 //x=7.095 //y=4.88
c617 ( 90 0 ) capacitor c=0.00101179f //x=7.095 //y=2.26
c618 ( 87 0 ) capacitor c=0.171188f //x=23.215 //y=3.885
c619 ( 86 0 ) capacitor c=0.00193875f //x=23.375 //y=3.885
c620 ( 84 0 ) capacitor c=0.00100407f //x=16.13 //y=3.865
c621 ( 83 0 ) capacitor c=0.0529145f //x=15.81 //y=3.865
c622 ( 78 0 ) capacitor c=9.19301e-19 //x=7.26 //y=3.865
c623 ( 72 0 ) capacitor c=0.068274f //x=12.065 //y=3.88
c624 ( 69 0 ) capacitor c=0.00379043f //x=8.045 //y=3.865
c625 ( 67 0 ) capacitor c=0.0033427f //x=7.445 //y=3.88
c626 ( 60 0 ) capacitor c=0.0149589f //x=23.375 //y=3.88
c627 ( 58 0 ) capacitor c=0.0158493f //x=15.975 //y=3.88
c628 ( 53 0 ) capacitor c=0.0113632f //x=15.535 //y=1.18
c629 ( 51 0 ) capacitor c=5.78613e-19 //x=15.495 //y=5.56
c630 ( 48 0 ) capacitor c=0.0105477f //x=15.495 //y=5.38
c631 ( 47 0 ) capacitor c=0.00947836f //x=14.615 //y=5.56
c632 ( 40 0 ) capacitor c=0.0149589f //x=11.905 //y=3.88
c633 ( 36 0 ) capacitor c=0.0149589f //x=7.095 //y=3.88
c634 ( 28 0 ) capacitor c=0.0232166f //x=23.375 //y=4.75
c635 ( 27 0 ) capacitor c=0.0112357f //x=23.375 //y=4.045
c636 ( 26 0 ) capacitor c=0.0330025f //x=23.375 //y=3.725
c637 ( 25 0 ) capacitor c=0.00694371f //x=23.375 //y=2.375
c638 ( 24 0 ) capacitor c=0.0288622f //x=15.975 //y=5.295
c639 ( 23 0 ) capacitor c=0.012706f //x=15.975 //y=4.025
c640 ( 22 0 ) capacitor c=0.0510352f //x=15.975 //y=3.705
c641 ( 20 0 ) capacitor c=0.00466468f //x=15.62 //y=1.835
c642 ( 19 0 ) capacitor c=0.0118534f //x=15.89 //y=1.835
c643 ( 17 0 ) capacitor c=0.0107481f //x=15.89 //y=5.38
c644 ( 16 0 ) capacitor c=0.0102514f //x=15.535 //y=1.75
c645 ( 11 0 ) capacitor c=0.0144196f //x=15.38 //y=5.38
c646 ( 8 0 ) capacitor c=0.0205242f //x=11.905 //y=4.75
c647 ( 7 0 ) capacitor c=0.0115898f //x=11.905 //y=4.025
c648 ( 6 0 ) capacitor c=0.0348235f //x=11.905 //y=3.705
c649 ( 5 0 ) capacitor c=0.00554287f //x=11.905 //y=2.375
c650 ( 4 0 ) capacitor c=0.0190807f //x=7.095 //y=4.75
c651 ( 3 0 ) capacitor c=0.0114284f //x=7.095 //y=4.025
c652 ( 2 0 ) capacitor c=0.0377226f //x=7.095 //y=3.705
c653 ( 1 0 ) capacitor c=0.00696087f //x=7.095 //y=2.375
r654 (  237 238 ) resistor r=52.7279 //w=0.214 //l=0.165 //layer=ply \
 //thickness=0.18 //x=23.375 //y=2.26 //x2=23.375 //y2=2.095
r655 (  227 228 ) resistor r=52.7279 //w=0.214 //l=0.165 //layer=ply \
 //thickness=0.18 //x=11.905 //y=2.26 //x2=11.905 //y2=2.095
r656 (  217 218 ) resistor r=52.7279 //w=0.214 //l=0.165 //layer=ply \
 //thickness=0.18 //x=7.095 //y=2.26 //x2=7.095 //y2=2.095
r657 (  215 245 ) resistor r=45.1352 //w=0.168 //l=0.173853 //layer=ply \
 //thickness=0.18 //x=23.895 //y=1.44 //x2=23.855 //y2=1.595
r658 (  214 244 ) resistor r=45.1352 //w=0.168 //l=0.173853 //layer=ply \
 //thickness=0.18 //x=23.895 //y=1.095 //x2=23.855 //y2=0.94
r659 (  214 215 ) resistor r=176.904 //w=0.094 //l=0.345 //layer=ply \
 //thickness=0.18 //x=23.895 //y=1.095 //x2=23.895 //y2=1.44
r660 (  212 241 ) resistor r=10.701 //w=0.21 //l=0.115 //layer=ply \
 //thickness=0.18 //x=23.52 //y=1.595 //x2=23.405 //y2=1.595
r661 (  211 245 ) resistor r=5.52526 //w=0.168 //l=0.115 //layer=ply \
 //thickness=0.18 //x=23.74 //y=1.595 //x2=23.855 //y2=1.595
r662 (  210 240 ) resistor r=5.52526 //w=0.168 //l=0.115 //layer=ply \
 //thickness=0.18 //x=23.52 //y=0.94 //x2=23.405 //y2=0.94
r663 (  209 244 ) resistor r=5.52526 //w=0.168 //l=0.115 //layer=ply \
 //thickness=0.18 //x=23.74 //y=0.94 //x2=23.855 //y2=0.94
r664 (  209 210 ) resistor r=112.809 //w=0.094 //l=0.22 //layer=ply \
 //thickness=0.18 //x=23.74 //y=0.94 //x2=23.52 //y2=0.94
r665 (  206 243 ) resistor r=37.236 //w=0.233 //l=0.249199 //layer=ply \
 //thickness=0.18 //x=23.555 //y=5.045 //x2=23.375 //y2=4.88
r666 (  204 241 ) resistor r=39.5823 //w=0.21 //l=0.173853 //layer=ply \
 //thickness=0.18 //x=23.365 //y=1.75 //x2=23.405 //y2=1.595
r667 (  204 238 ) resistor r=176.904 //w=0.094 //l=0.345 //layer=ply \
 //thickness=0.18 //x=23.365 //y=1.75 //x2=23.365 //y2=2.095
r668 (  203 241 ) resistor r=39.5823 //w=0.21 //l=0.173853 //layer=ply \
 //thickness=0.18 //x=23.365 //y=1.44 //x2=23.405 //y2=1.595
r669 (  202 240 ) resistor r=45.1352 //w=0.168 //l=0.173853 //layer=ply \
 //thickness=0.18 //x=23.365 //y=1.095 //x2=23.405 //y2=0.94
r670 (  202 203 ) resistor r=176.904 //w=0.094 //l=0.345 //layer=ply \
 //thickness=0.18 //x=23.365 //y=1.095 //x2=23.365 //y2=1.44
r671 (  199 243 ) resistor r=53.7854 //w=0.233 //l=0.332415 //layer=ply \
 //thickness=0.18 //x=23.115 //y=5.045 //x2=23.375 //y2=4.88
r672 (  198 235 ) resistor r=45.1352 //w=0.168 //l=0.173853 //layer=ply \
 //thickness=0.18 //x=12.425 //y=1.44 //x2=12.385 //y2=1.595
r673 (  197 234 ) resistor r=45.1352 //w=0.168 //l=0.173853 //layer=ply \
 //thickness=0.18 //x=12.425 //y=1.095 //x2=12.385 //y2=0.94
r674 (  197 198 ) resistor r=176.904 //w=0.094 //l=0.345 //layer=ply \
 //thickness=0.18 //x=12.425 //y=1.095 //x2=12.425 //y2=1.44
r675 (  195 231 ) resistor r=10.701 //w=0.21 //l=0.115 //layer=ply \
 //thickness=0.18 //x=12.05 //y=1.595 //x2=11.935 //y2=1.595
r676 (  194 235 ) resistor r=5.52526 //w=0.168 //l=0.115 //layer=ply \
 //thickness=0.18 //x=12.27 //y=1.595 //x2=12.385 //y2=1.595
r677 (  193 230 ) resistor r=5.52526 //w=0.168 //l=0.115 //layer=ply \
 //thickness=0.18 //x=12.05 //y=0.94 //x2=11.935 //y2=0.94
r678 (  192 234 ) resistor r=5.52526 //w=0.168 //l=0.115 //layer=ply \
 //thickness=0.18 //x=12.27 //y=0.94 //x2=12.385 //y2=0.94
r679 (  192 193 ) resistor r=112.809 //w=0.094 //l=0.22 //layer=ply \
 //thickness=0.18 //x=12.27 //y=0.94 //x2=12.05 //y2=0.94
r680 (  189 233 ) resistor r=37.236 //w=0.233 //l=0.249199 //layer=ply \
 //thickness=0.18 //x=12.085 //y=5.045 //x2=11.905 //y2=4.88
r681 (  187 231 ) resistor r=39.5823 //w=0.21 //l=0.173853 //layer=ply \
 //thickness=0.18 //x=11.895 //y=1.75 //x2=11.935 //y2=1.595
r682 (  187 228 ) resistor r=176.904 //w=0.094 //l=0.345 //layer=ply \
 //thickness=0.18 //x=11.895 //y=1.75 //x2=11.895 //y2=2.095
r683 (  186 231 ) resistor r=39.5823 //w=0.21 //l=0.173853 //layer=ply \
 //thickness=0.18 //x=11.895 //y=1.44 //x2=11.935 //y2=1.595
r684 (  185 230 ) resistor r=45.1352 //w=0.168 //l=0.173853 //layer=ply \
 //thickness=0.18 //x=11.895 //y=1.095 //x2=11.935 //y2=0.94
r685 (  185 186 ) resistor r=176.904 //w=0.094 //l=0.345 //layer=ply \
 //thickness=0.18 //x=11.895 //y=1.095 //x2=11.895 //y2=1.44
r686 (  182 233 ) resistor r=53.7854 //w=0.233 //l=0.332415 //layer=ply \
 //thickness=0.18 //x=11.645 //y=5.045 //x2=11.905 //y2=4.88
r687 (  181 225 ) resistor r=45.1352 //w=0.168 //l=0.173853 //layer=ply \
 //thickness=0.18 //x=7.615 //y=1.44 //x2=7.575 //y2=1.595
r688 (  180 224 ) resistor r=45.1352 //w=0.168 //l=0.173853 //layer=ply \
 //thickness=0.18 //x=7.615 //y=1.095 //x2=7.575 //y2=0.94
r689 (  180 181 ) resistor r=176.904 //w=0.094 //l=0.345 //layer=ply \
 //thickness=0.18 //x=7.615 //y=1.095 //x2=7.615 //y2=1.44
r690 (  178 221 ) resistor r=10.701 //w=0.21 //l=0.115 //layer=ply \
 //thickness=0.18 //x=7.24 //y=1.595 //x2=7.125 //y2=1.595
r691 (  177 225 ) resistor r=5.52526 //w=0.168 //l=0.115 //layer=ply \
 //thickness=0.18 //x=7.46 //y=1.595 //x2=7.575 //y2=1.595
r692 (  176 220 ) resistor r=5.52526 //w=0.168 //l=0.115 //layer=ply \
 //thickness=0.18 //x=7.24 //y=0.94 //x2=7.125 //y2=0.94
r693 (  175 224 ) resistor r=5.52526 //w=0.168 //l=0.115 //layer=ply \
 //thickness=0.18 //x=7.46 //y=0.94 //x2=7.575 //y2=0.94
r694 (  175 176 ) resistor r=112.809 //w=0.094 //l=0.22 //layer=ply \
 //thickness=0.18 //x=7.46 //y=0.94 //x2=7.24 //y2=0.94
r695 (  172 223 ) resistor r=37.236 //w=0.233 //l=0.249199 //layer=ply \
 //thickness=0.18 //x=7.275 //y=5.045 //x2=7.095 //y2=4.88
r696 (  170 221 ) resistor r=39.5823 //w=0.21 //l=0.173853 //layer=ply \
 //thickness=0.18 //x=7.085 //y=1.75 //x2=7.125 //y2=1.595
r697 (  170 218 ) resistor r=176.904 //w=0.094 //l=0.345 //layer=ply \
 //thickness=0.18 //x=7.085 //y=1.75 //x2=7.085 //y2=2.095
r698 (  169 221 ) resistor r=39.5823 //w=0.21 //l=0.173853 //layer=ply \
 //thickness=0.18 //x=7.085 //y=1.44 //x2=7.125 //y2=1.595
r699 (  168 220 ) resistor r=45.1352 //w=0.168 //l=0.173853 //layer=ply \
 //thickness=0.18 //x=7.085 //y=1.095 //x2=7.125 //y2=0.94
r700 (  168 169 ) resistor r=176.904 //w=0.094 //l=0.345 //layer=ply \
 //thickness=0.18 //x=7.085 //y=1.095 //x2=7.085 //y2=1.44
r701 (  165 223 ) resistor r=53.7854 //w=0.233 //l=0.332415 //layer=ply \
 //thickness=0.18 //x=6.835 //y=5.045 //x2=7.095 //y2=4.88
r702 (  164 206 ) resistor r=592.245 //w=0.094 //l=1.155 //layer=ply \
 //thickness=0.18 //x=23.555 //y=6.2 //x2=23.555 //y2=5.045
r703 (  163 199 ) resistor r=592.245 //w=0.094 //l=1.155 //layer=ply \
 //thickness=0.18 //x=23.115 //y=6.2 //x2=23.115 //y2=5.045
r704 (  162 189 ) resistor r=592.245 //w=0.094 //l=1.155 //layer=ply \
 //thickness=0.18 //x=12.085 //y=6.2 //x2=12.085 //y2=5.045
r705 (  161 182 ) resistor r=592.245 //w=0.094 //l=1.155 //layer=ply \
 //thickness=0.18 //x=11.645 //y=6.2 //x2=11.645 //y2=5.045
r706 (  160 172 ) resistor r=592.245 //w=0.094 //l=1.155 //layer=ply \
 //thickness=0.18 //x=7.275 //y=6.2 //x2=7.275 //y2=5.045
r707 (  159 165 ) resistor r=592.245 //w=0.094 //l=1.155 //layer=ply \
 //thickness=0.18 //x=6.835 //y=6.2 //x2=6.835 //y2=5.045
r708 (  158 211 ) resistor r=56.4043 //w=0.094 //l=0.11 //layer=ply \
 //thickness=0.18 //x=23.63 //y=1.595 //x2=23.74 //y2=1.595
r709 (  158 212 ) resistor r=56.4043 //w=0.094 //l=0.11 //layer=ply \
 //thickness=0.18 //x=23.63 //y=1.595 //x2=23.52 //y2=1.595
r710 (  157 194 ) resistor r=56.4043 //w=0.094 //l=0.11 //layer=ply \
 //thickness=0.18 //x=12.16 //y=1.595 //x2=12.27 //y2=1.595
r711 (  157 195 ) resistor r=56.4043 //w=0.094 //l=0.11 //layer=ply \
 //thickness=0.18 //x=12.16 //y=1.595 //x2=12.05 //y2=1.595
r712 (  156 177 ) resistor r=56.4043 //w=0.094 //l=0.11 //layer=ply \
 //thickness=0.18 //x=7.35 //y=1.595 //x2=7.46 //y2=1.595
r713 (  156 178 ) resistor r=56.4043 //w=0.094 //l=0.11 //layer=ply \
 //thickness=0.18 //x=7.35 //y=1.595 //x2=7.24 //y2=1.595
r714 (  152 243 ) resistor r=152 //w=0.17 //l=0.17 //layer=licon //count=1 \
 //x=23.375 //y=4.88 //x2=23.375 //y2=4.88
r715 (  143 237 ) resistor r=152 //w=0.17 //l=0.17 //layer=licon //count=1 \
 //x=23.375 //y=2.26 //x2=23.375 //y2=2.26
r716 (  126 249 ) resistor r=23.615 //w=0.187 //l=0.345 //layer=li \
 //thickness=0.1 //x=15.495 //y=5.56 //x2=15.495 //y2=5.905
r717 (  118 248 ) resistor r=23.615 //w=0.187 //l=0.345 //layer=li \
 //thickness=0.1 //x=14.615 //y=5.56 //x2=14.615 //y2=5.905
r718 (  113 233 ) resistor r=152 //w=0.17 //l=0.17 //layer=licon //count=1 \
 //x=11.905 //y=4.88 //x2=11.905 //y2=4.88
r719 (  104 227 ) resistor r=152 //w=0.17 //l=0.17 //layer=licon //count=1 \
 //x=11.905 //y=2.26 //x2=11.905 //y2=2.26
r720 (  99 223 ) resistor r=152 //w=0.17 //l=0.17 //layer=licon //count=1 \
 //x=7.095 //y=4.88 //x2=7.095 //y2=4.88
r721 (  90 217 ) resistor r=152 //w=0.17 //l=0.17 //layer=licon //count=1 \
 //x=7.095 //y=2.26 //x2=7.095 //y2=2.26
r722 (  86 87 ) resistor r=0.10734 //w=0.281 //l=0.16 //layer=m2 \
 //thickness=0.36 //x=23.375 //y=3.885 //x2=23.215 //y2=3.885
r723 (  84 87 ) resistor r=6.7605 //w=0.131 //l=7.085 //layer=m2 \
 //thickness=0.36 //x=16.13 //y=3.88 //x2=23.215 //y2=3.88
r724 (  82 84 ) resistor r=0.10734 //w=0.281 //l=0.16 //layer=m2 \
 //thickness=0.36 //x=15.97 //y=3.865 //x2=16.13 //y2=3.865
r725 (  82 83 ) resistor r=0.10734 //w=0.281 //l=0.16 //layer=m2 \
 //thickness=0.36 //x=15.97 //y=3.865 //x2=15.81 //y2=3.865
r726 (  76 78 ) resistor r=0.10734 //w=0.281 //l=0.16 //layer=m2 \
 //thickness=0.36 //x=7.1 //y=3.865 //x2=7.26 //y2=3.865
r727 (  72 80 ) resistor r=0.110608 //w=0.182 //l=0.167332 //layer=m2 \
 //thickness=0.36 //x=12.065 //y=3.88 //x2=11.905 //y2=3.865
r728 (  72 83 ) resistor r=3.57347 //w=0.131 //l=3.745 //layer=m2 \
 //thickness=0.36 //x=12.065 //y=3.88 //x2=15.81 //y2=3.88
r729 (  69 80 ) resistor r=2.65182 //w=0.182 //l=3.86 //layer=m2 \
 //thickness=0.36 //x=8.045 //y=3.865 //x2=11.905 //y2=3.865
r730 (  69 70 ) resistor r=0.410305 //w=0.131 //l=0.43 //layer=m2 \
 //thickness=0.36 //x=8.045 //y=3.865 //x2=7.615 //y2=3.865
r731 (  67 70 ) resistor r=0.125 //w=0.17 //l=0.177341 //layer=m2 \
 //thickness=0.36 //x=7.445 //y=3.88 //x2=7.615 //y2=3.865
r732 (  67 78 ) resistor r=0.176527 //w=0.131 //l=0.185 //layer=m2 \
 //thickness=0.36 //x=7.445 //y=3.88 //x2=7.26 //y2=3.88
r733 (  66 152 ) resistor r=9.3 //w=0.17 //l=0.17 //layer=mcon //count=1 \
 //x=23.375 //y=4.88 //x2=23.375 //y2=4.88
r734 (  64 143 ) resistor r=9.3 //w=0.17 //l=0.17 //layer=mcon //count=1 \
 //x=23.375 //y=2.26 //x2=23.375 //y2=2.26
r735 (  62 86 ) resistor r=4.5 //w=0.15 //l=0.15 //layer=via1 //count=1 \
 //x=23.375 //y=3.885 //x2=23.375 //y2=3.885
r736 (  60 62 ) resistor r=0.00166223 //w=0.376 //l=0.005 //layer=m1 \
 //thickness=0.36 //x=23.322 //y=3.88 //x2=23.322 //y2=3.885
r737 (  56 82 ) resistor r=4.5 //w=0.15 //l=0.15 //layer=via1 //count=1 \
 //x=15.97 //y=3.865 //x2=15.97 //y2=3.865
r738 (  56 58 ) resistor r=0.00501337 //w=0.374 //l=0.015 //layer=m1 \
 //thickness=0.36 //x=15.92 //y=3.865 //x2=15.92 //y2=3.88
r739 (  53 246 ) resistor r=9.3 //w=0.17 //l=0.17 //layer=mcon //count=1 \
 //x=15.535 //y=1.18 //x2=15.535 //y2=1.18
r740 (  51 126 ) resistor r=9.3 //w=0.17 //l=0.17 //layer=mcon //count=1 \
 //x=15.495 //y=5.56 //x2=15.495 //y2=5.56
r741 (  48 51 ) resistor r=0.117801 //w=0.191 //l=0.18 //layer=m1 \
 //thickness=0.36 //x=15.495 //y=5.38 //x2=15.495 //y2=5.56
r742 (  47 118 ) resistor r=9.3 //w=0.17 //l=0.17 //layer=mcon //count=1 \
 //x=14.615 //y=5.56 //x2=14.615 //y2=5.56
r743 (  45 47 ) resistor r=0.10274 //w=0.219 //l=0.18 //layer=m1 \
 //thickness=0.36 //x=14.615 //y=5.38 //x2=14.615 //y2=5.56
r744 (  44 113 ) resistor r=9.3 //w=0.17 //l=0.17 //layer=mcon //count=1 \
 //x=11.905 //y=4.88 //x2=11.905 //y2=4.88
r745 (  42 104 ) resistor r=9.3 //w=0.17 //l=0.17 //layer=mcon //count=1 \
 //x=11.905 //y=2.26 //x2=11.905 //y2=2.26
r746 (  38 80 ) resistor r=4.5 //w=0.15 //l=0.15 //layer=via1 //count=1 \
 //x=11.905 //y=3.865 //x2=11.905 //y2=3.865
r747 (  38 40 ) resistor r=0.0049867 //w=0.376 //l=0.015 //layer=m1 \
 //thickness=0.36 //x=11.852 //y=3.865 //x2=11.852 //y2=3.88
r748 (  34 76 ) resistor r=4.5 //w=0.15 //l=0.15 //layer=via1 //count=1 \
 //x=7.1 //y=3.865 //x2=7.1 //y2=3.865
r749 (  34 36 ) resistor r=0.00501337 //w=0.374 //l=0.015 //layer=m1 \
 //thickness=0.36 //x=7.15 //y=3.865 //x2=7.15 //y2=3.88
r750 (  32 99 ) resistor r=9.3 //w=0.17 //l=0.17 //layer=mcon //count=1 \
 //x=7.095 //y=4.88 //x2=7.095 //y2=4.88
r751 (  30 90 ) resistor r=9.3 //w=0.17 //l=0.17 //layer=mcon //count=1 \
 //x=7.095 //y=2.26 //x2=7.095 //y2=2.26
r752 (  28 66 ) resistor r=0.0801089 //w=0.224 //l=0.13 //layer=m1 \
 //thickness=0.36 //x=23.375 //y=4.75 //x2=23.375 //y2=4.88
r753 (  27 62 ) resistor r=0.0911593 //w=0.376 //l=0.184608 //layer=m1 \
 //thickness=0.36 //x=23.375 //y=4.045 //x2=23.322 //y2=3.885
r754 (  27 28 ) resistor r=0.67271 //w=0.131 //l=0.705 //layer=m1 \
 //thickness=0.36 //x=23.375 //y=4.045 //x2=23.375 //y2=4.75
r755 (  26 60 ) resistor r=0.0894971 //w=0.376 //l=0.179555 //layer=m1 \
 //thickness=0.36 //x=23.375 //y=3.725 //x2=23.322 //y2=3.88
r756 (  25 64 ) resistor r=0.0719237 //w=0.222 //l=0.115 //layer=m1 \
 //thickness=0.36 //x=23.375 //y=2.375 //x2=23.375 //y2=2.26
r757 (  25 26 ) resistor r=1.28817 //w=0.131 //l=1.35 //layer=m1 \
 //thickness=0.36 //x=23.375 //y=2.375 //x2=23.375 //y2=3.725
r758 (  23 58 ) resistor r=0.0860668 //w=0.374 //l=0.170294 //layer=m1 \
 //thickness=0.36 //x=15.975 //y=4.025 //x2=15.92 //y2=3.88
r759 (  23 24 ) resistor r=1.21183 //w=0.131 //l=1.27 //layer=m1 \
 //thickness=0.36 //x=15.975 //y=4.025 //x2=15.975 //y2=5.295
r760 (  22 56 ) resistor r=0.0910802 //w=0.374 //l=0.185472 //layer=m1 \
 //thickness=0.36 //x=15.975 //y=3.705 //x2=15.92 //y2=3.865
r761 (  21 22 ) resistor r=1.70324 //w=0.131 //l=1.785 //layer=m1 \
 //thickness=0.36 //x=15.975 //y=1.92 //x2=15.975 //y2=3.705
r762 (  19 21 ) resistor r=0.0698411 //w=0.17 //l=0.120208 //layer=m1 \
 //thickness=0.36 //x=15.89 //y=1.835 //x2=15.975 //y2=1.92
r763 (  19 20 ) resistor r=0.257634 //w=0.131 //l=0.27 //layer=m1 \
 //thickness=0.36 //x=15.89 //y=1.835 //x2=15.62 //y2=1.835
r764 (  18 48 ) resistor r=0.0257089 //w=0.23 //l=0.115 //layer=m1 \
 //thickness=0.36 //x=15.61 //y=5.38 //x2=15.495 //y2=5.38
r765 (  17 24 ) resistor r=0.0698411 //w=0.17 //l=0.120208 //layer=m1 \
 //thickness=0.36 //x=15.89 //y=5.38 //x2=15.975 //y2=5.295
r766 (  17 18 ) resistor r=0.267176 //w=0.131 //l=0.28 //layer=m1 \
 //thickness=0.36 //x=15.89 //y=5.38 //x2=15.61 //y2=5.38
r767 (  16 20 ) resistor r=0.0698411 //w=0.17 //l=0.120208 //layer=m1 \
 //thickness=0.36 //x=15.535 //y=1.75 //x2=15.62 //y2=1.835
r768 (  15 53 ) resistor r=0.0913624 //w=0.191 //l=0.12 //layer=m1 \
 //thickness=0.36 //x=15.535 //y=1.3 //x2=15.535 //y2=1.18
r769 (  15 16 ) resistor r=0.429389 //w=0.131 //l=0.45 //layer=m1 \
 //thickness=0.36 //x=15.535 //y=1.3 //x2=15.535 //y2=1.75
r770 (  12 45 ) resistor r=0.0227762 //w=0.219 //l=0.115 //layer=m1 \
 //thickness=0.36 //x=14.73 //y=5.38 //x2=14.615 //y2=5.38
r771 (  11 48 ) resistor r=0.0257089 //w=0.23 //l=0.115 //layer=m1 \
 //thickness=0.36 //x=15.38 //y=5.38 //x2=15.495 //y2=5.38
r772 (  11 12 ) resistor r=0.620229 //w=0.131 //l=0.65 //layer=m1 \
 //thickness=0.36 //x=15.38 //y=5.38 //x2=14.73 //y2=5.38
r773 (  8 44 ) resistor r=0.0801089 //w=0.224 //l=0.13 //layer=m1 \
 //thickness=0.36 //x=11.905 //y=4.75 //x2=11.905 //y2=4.88
r774 (  7 40 ) resistor r=0.0861726 //w=0.376 //l=0.16944 //layer=m1 \
 //thickness=0.36 //x=11.905 //y=4.025 //x2=11.852 //y2=3.88
r775 (  7 8 ) resistor r=0.691794 //w=0.131 //l=0.725 //layer=m1 \
 //thickness=0.36 //x=11.905 //y=4.025 //x2=11.905 //y2=4.75
r776 (  6 38 ) resistor r=0.0911593 //w=0.376 //l=0.184608 //layer=m1 \
 //thickness=0.36 //x=11.905 //y=3.705 //x2=11.852 //y2=3.865
r777 (  5 42 ) resistor r=0.0719237 //w=0.222 //l=0.115 //layer=m1 \
 //thickness=0.36 //x=11.905 //y=2.375 //x2=11.905 //y2=2.26
r778 (  5 6 ) resistor r=1.26908 //w=0.131 //l=1.33 //layer=m1 \
 //thickness=0.36 //x=11.905 //y=2.375 //x2=11.905 //y2=3.705
r779 (  4 32 ) resistor r=0.0801089 //w=0.224 //l=0.13 //layer=m1 \
 //thickness=0.36 //x=7.095 //y=4.75 //x2=7.095 //y2=4.88
r780 (  3 36 ) resistor r=0.0860668 //w=0.374 //l=0.170294 //layer=m1 \
 //thickness=0.36 //x=7.095 //y=4.025 //x2=7.15 //y2=3.88
r781 (  3 4 ) resistor r=0.691794 //w=0.131 //l=0.725 //layer=m1 \
 //thickness=0.36 //x=7.095 //y=4.025 //x2=7.095 //y2=4.75
r782 (  2 34 ) resistor r=0.0910802 //w=0.374 //l=0.185472 //layer=m1 \
 //thickness=0.36 //x=7.095 //y=3.705 //x2=7.15 //y2=3.865
r783 (  1 30 ) resistor r=0.0719237 //w=0.222 //l=0.115 //layer=m1 \
 //thickness=0.36 //x=7.095 //y=2.375 //x2=7.095 //y2=2.26
r784 (  1 2 ) resistor r=1.26908 //w=0.131 //l=1.33 //layer=m1 \
 //thickness=0.36 //x=7.095 //y=2.375 //x2=7.095 //y2=3.705
ends PM_DFFSNQNX1\%noxref_7

subckt PM_DFFSNQNX1\%noxref_8 ( 2 3 4 5 7 10 11 13 14 15 16 18 19 20 22 30 31 \
 34 37 45 46 48 53 57 66 71 79 87 103 104 105 106 107 108 113 115 117 123 124 \
 126 127 130 138 140 141 142 )
c288 ( 138 0 ) capacitor c=0.00885916f //x=23.44 //y=1.095
c289 ( 130 0 ) capacitor c=0.0393541f //x=18.595 //y=4.88
c290 ( 127 0 ) capacitor c=0.0284095f //x=18.565 //y=2.095
c291 ( 126 0 ) capacitor c=0.0450457f //x=18.565 //y=2.26
c292 ( 124 0 ) capacitor c=0.0439708f //x=19.13 //y=1.43
c293 ( 123 0 ) capacitor c=0.0192582f //x=19.13 //y=1.085
c294 ( 117 0 ) capacitor c=0.0162526f //x=18.975 //y=1.585
c295 ( 115 0 ) capacitor c=0.0157807f //x=18.975 //y=0.93
c296 ( 113 0 ) capacitor c=0.0372668f //x=18.97 //y=4.97
c297 ( 108 0 ) capacitor c=0.0210762f //x=18.6 //y=1.74
c298 ( 107 0 ) capacitor c=0.0168511f //x=18.6 //y=1.43
c299 ( 106 0 ) capacitor c=0.0175485f //x=18.6 //y=1.085
c300 ( 105 0 ) capacitor c=0.155269f //x=19.045 //y=6.2
c301 ( 104 0 ) capacitor c=0.110375f //x=18.605 //y=6.2
c302 ( 87 0 ) capacitor c=0.0293753f //x=23.335 //y=5.56
c303 ( 79 0 ) capacitor c=0.029137f //x=22.455 //y=5.56
c304 ( 71 0 ) capacitor c=0.0277605f //x=21.575 //y=5.56
c305 ( 66 0 ) capacitor c=8.90417e-19 //x=18.595 //y=4.88
c306 ( 57 0 ) capacitor c=5.78095e-19 //x=18.565 //y=2.26
c307 ( 53 0 ) capacitor c=6.75554e-19 //x=18.725 //y=3.495
c308 ( 48 0 ) capacitor c=0.0322059f //x=23.59 //y=3.5
c309 ( 46 0 ) capacitor c=0.0646261f //x=22.99 //y=3.51
c310 ( 45 0 ) capacitor c=0.0184543f //x=24.115 //y=3.51
c311 ( 37 0 ) capacitor c=9.65912e-19 //x=23.335 //y=5.335
c312 ( 34 0 ) capacitor c=0.00814399f //x=22.455 //y=5.335
c313 ( 31 0 ) capacitor c=0.0117279f //x=21.577 //y=5.335
c314 ( 30 0 ) capacitor c=0.0146597f //x=18.565 //y=3.51
c315 ( 22 0 ) capacitor c=0.00504845f //x=18.565 //y=2.26
c316 ( 20 0 ) capacitor c=0.0643667f //x=24.115 //y=5.25
c317 ( 19 0 ) capacitor c=0.012798f //x=24.115 //y=3.665
c318 ( 18 0 ) capacitor c=0.0562638f //x=24.115 //y=3.345
c319 ( 16 0 ) capacitor c=0.00680051f //x=23.715 //y=1.845
c320 ( 15 0 ) capacitor c=0.0162607f //x=24.03 //y=1.845
c321 ( 14 0 ) capacitor c=0.0167333f //x=23.63 //y=1.76
c322 ( 13 0 ) capacitor c=0.0143761f //x=23.63 //y=1.305
c323 ( 11 0 ) capacitor c=0.0273252f //x=24.03 //y=5.335
c324 ( 10 0 ) capacitor c=0.0124512f //x=23.335 //y=5.56
c325 ( 7 0 ) capacitor c=0.018914f //x=23.22 //y=5.335
c326 ( 5 0 ) capacitor c=0.0158145f //x=22.335 //y=5.335
c327 ( 4 0 ) capacitor c=0.0264461f //x=18.565 //y=4.735
c328 ( 3 0 ) capacitor c=0.010467f //x=18.565 //y=3.655
c329 ( 2 0 ) capacitor c=0.0190559f //x=18.565 //y=3.335
r330 (  132 133 ) resistor r=32.4568 //w=0.214 //l=0.075 //layer=ply \
 //thickness=0.18 //x=18.595 //y=4.97 //x2=18.595 //y2=5.045
r331 (  130 132 ) resistor r=20.271 //w=0.214 //l=0.09 //layer=ply \
 //thickness=0.18 //x=18.595 //y=4.88 //x2=18.595 //y2=4.97
r332 (  126 127 ) resistor r=52.7279 //w=0.214 //l=0.165 //layer=ply \
 //thickness=0.18 //x=18.565 //y=2.26 //x2=18.565 //y2=2.095
r333 (  124 137 ) resistor r=45.1352 //w=0.168 //l=0.173853 //layer=ply \
 //thickness=0.18 //x=19.13 //y=1.43 //x2=19.09 //y2=1.585
r334 (  123 136 ) resistor r=45.1352 //w=0.168 //l=0.173853 //layer=ply \
 //thickness=0.18 //x=19.13 //y=1.085 //x2=19.09 //y2=0.93
r335 (  123 124 ) resistor r=176.904 //w=0.094 //l=0.345 //layer=ply \
 //thickness=0.18 //x=19.13 //y=1.085 //x2=19.13 //y2=1.43
r336 (  118 135 ) resistor r=10.701 //w=0.21 //l=0.115 //layer=ply \
 //thickness=0.18 //x=18.755 //y=1.585 //x2=18.64 //y2=1.585
r337 (  117 137 ) resistor r=5.52526 //w=0.168 //l=0.115 //layer=ply \
 //thickness=0.18 //x=18.975 //y=1.585 //x2=19.09 //y2=1.585
r338 (  116 134 ) resistor r=5.52526 //w=0.168 //l=0.115 //layer=ply \
 //thickness=0.18 //x=18.755 //y=0.93 //x2=18.64 //y2=0.93
r339 (  115 136 ) resistor r=5.52526 //w=0.168 //l=0.115 //layer=ply \
 //thickness=0.18 //x=18.975 //y=0.93 //x2=19.09 //y2=0.93
r340 (  115 116 ) resistor r=112.809 //w=0.094 //l=0.22 //layer=ply \
 //thickness=0.18 //x=18.975 //y=0.93 //x2=18.755 //y2=0.93
r341 (  114 132 ) resistor r=16.5046 //w=0.27 //l=0.135 //layer=ply \
 //thickness=0.18 //x=18.73 //y=4.97 //x2=18.595 //y2=4.97
r342 (  113 120 ) resistor r=26.9307 //w=0.15 //l=0.106066 //layer=ply \
 //thickness=0.18 //x=18.97 //y=4.97 //x2=19.045 //y2=5.045
r343 (  113 114 ) resistor r=123.064 //w=0.094 //l=0.24 //layer=ply \
 //thickness=0.18 //x=18.97 //y=4.97 //x2=18.73 //y2=4.97
r344 (  108 135 ) resistor r=39.5823 //w=0.21 //l=0.173853 //layer=ply \
 //thickness=0.18 //x=18.6 //y=1.74 //x2=18.64 //y2=1.585
r345 (  108 127 ) resistor r=182.032 //w=0.094 //l=0.355 //layer=ply \
 //thickness=0.18 //x=18.6 //y=1.74 //x2=18.6 //y2=2.095
r346 (  107 135 ) resistor r=39.5823 //w=0.21 //l=0.173853 //layer=ply \
 //thickness=0.18 //x=18.6 //y=1.43 //x2=18.64 //y2=1.585
r347 (  106 134 ) resistor r=45.1352 //w=0.168 //l=0.173853 //layer=ply \
 //thickness=0.18 //x=18.6 //y=1.085 //x2=18.64 //y2=0.93
r348 (  106 107 ) resistor r=176.904 //w=0.094 //l=0.345 //layer=ply \
 //thickness=0.18 //x=18.6 //y=1.085 //x2=18.6 //y2=1.43
r349 (  105 120 ) resistor r=592.245 //w=0.094 //l=1.155 //layer=ply \
 //thickness=0.18 //x=19.045 //y=6.2 //x2=19.045 //y2=5.045
r350 (  104 133 ) resistor r=592.245 //w=0.094 //l=1.155 //layer=ply \
 //thickness=0.18 //x=18.605 //y=6.2 //x2=18.605 //y2=5.045
r351 (  103 117 ) resistor r=56.4043 //w=0.094 //l=0.11 //layer=ply \
 //thickness=0.18 //x=18.865 //y=1.585 //x2=18.975 //y2=1.585
r352 (  103 118 ) resistor r=56.4043 //w=0.094 //l=0.11 //layer=ply \
 //thickness=0.18 //x=18.865 //y=1.585 //x2=18.755 //y2=1.585
r353 (  87 142 ) resistor r=23.615 //w=0.187 //l=0.345 //layer=li \
 //thickness=0.1 //x=23.335 //y=5.56 //x2=23.335 //y2=5.905
r354 (  79 141 ) resistor r=23.615 //w=0.187 //l=0.345 //layer=li \
 //thickness=0.1 //x=22.455 //y=5.56 //x2=22.455 //y2=5.905
r355 (  71 140 ) resistor r=23.615 //w=0.187 //l=0.345 //layer=li \
 //thickness=0.1 //x=21.575 //y=5.56 //x2=21.575 //y2=5.905
r356 (  66 130 ) resistor r=152 //w=0.17 //l=0.17 //layer=licon //count=1 \
 //x=18.595 //y=4.88 //x2=18.595 //y2=4.88
r357 (  57 126 ) resistor r=152 //w=0.17 //l=0.17 //layer=licon //count=1 \
 //x=18.565 //y=2.26 //x2=18.565 //y2=2.26
r358 (  51 53 ) resistor r=0.10734 //w=0.281 //l=0.16 //layer=m2 \
 //thickness=0.36 //x=18.565 //y=3.495 //x2=18.725 //y2=3.495
r359 (  48 55 ) resistor r=0.28331 //w=0.241 //l=0.527494 //layer=m2 \
 //thickness=0.36 //x=23.59 //y=3.5 //x2=24.115 //y2=3.505
r360 (  48 49 ) resistor r=0.410305 //w=0.131 //l=0.43 //layer=m2 \
 //thickness=0.36 //x=23.59 //y=3.5 //x2=23.16 //y2=3.5
r361 (  46 49 ) resistor r=0.125 //w=0.17 //l=0.174929 //layer=m2 \
 //thickness=0.36 //x=22.99 //y=3.51 //x2=23.16 //y2=3.5
r362 (  46 53 ) resistor r=4.06966 //w=0.131 //l=4.265 //layer=m2 \
 //thickness=0.36 //x=22.99 //y=3.51 //x2=18.725 //y2=3.51
r363 (  43 55 ) resistor r=4.5 //w=0.15 //l=0.15 //layer=via1 //count=1 \
 //x=24.115 //y=3.505 //x2=24.115 //y2=3.505
r364 (  43 45 ) resistor r=0.00166223 //w=0.376 //l=0.005 //layer=m1 \
 //thickness=0.36 //x=24.062 //y=3.505 //x2=24.062 //y2=3.51
r365 (  41 138 ) resistor r=9.3 //w=0.17 //l=0.17 //layer=mcon //count=1 \
 //x=23.63 //y=1.19 //x2=23.63 //y2=1.19
r366 (  39 87 ) resistor r=9.3 //w=0.17 //l=0.17 //layer=mcon //count=1 \
 //x=23.335 //y=5.56 //x2=23.335 //y2=5.56
r367 (  36 79 ) resistor r=9.3 //w=0.17 //l=0.17 //layer=mcon //count=1 \
 //x=22.455 //y=5.56 //x2=22.455 //y2=5.56
r368 (  34 36 ) resistor r=0.121228 //w=0.232 //l=0.225 //layer=m1 \
 //thickness=0.36 //x=22.455 //y=5.335 //x2=22.455 //y2=5.56
r369 (  33 71 ) resistor r=9.3 //w=0.17 //l=0.17 //layer=mcon //count=1 \
 //x=21.575 //y=5.56 //x2=21.575 //y2=5.56
r370 (  31 33 ) resistor r=0.129608 //w=0.217 //l=0.225 //layer=m1 \
 //thickness=0.36 //x=21.577 //y=5.335 //x2=21.577 //y2=5.56
r371 (  28 51 ) resistor r=4.5 //w=0.15 //l=0.15 //layer=via1 //count=1 \
 //x=18.565 //y=3.495 //x2=18.565 //y2=3.495
r372 (  28 30 ) resistor r=0.0049867 //w=0.376 //l=0.015 //layer=m1 \
 //thickness=0.36 //x=18.617 //y=3.495 //x2=18.617 //y2=3.51
r373 (  26 66 ) resistor r=9.3 //w=0.17 //l=0.17 //layer=mcon //count=1 \
 //x=18.595 //y=4.88 //x2=18.595 //y2=4.88
r374 (  22 57 ) resistor r=9.3 //w=0.17 //l=0.17 //layer=mcon //count=1 \
 //x=18.565 //y=2.26 //x2=18.565 //y2=2.26
r375 (  22 24 ) resistor r=0.0936408 //w=0.196 //l=0.125 //layer=m1 \
 //thickness=0.36 //x=18.567 //y=2.26 //x2=18.567 //y2=2.385
r376 (  19 45 ) resistor r=0.0894971 //w=0.376 //l=0.179555 //layer=m1 \
 //thickness=0.36 //x=24.115 //y=3.665 //x2=24.062 //y2=3.51
r377 (  19 20 ) resistor r=1.5124 //w=0.131 //l=1.585 //layer=m1 \
 //thickness=0.36 //x=24.115 //y=3.665 //x2=24.115 //y2=5.25
r378 (  18 43 ) resistor r=0.0911593 //w=0.376 //l=0.184608 //layer=m1 \
 //thickness=0.36 //x=24.115 //y=3.345 //x2=24.062 //y2=3.505
r379 (  17 18 ) resistor r=1.35019 //w=0.131 //l=1.415 //layer=m1 \
 //thickness=0.36 //x=24.115 //y=1.93 //x2=24.115 //y2=3.345
r380 (  15 17 ) resistor r=0.0698411 //w=0.17 //l=0.120208 //layer=m1 \
 //thickness=0.36 //x=24.03 //y=1.845 //x2=24.115 //y2=1.93
r381 (  15 16 ) resistor r=0.300573 //w=0.131 //l=0.315 //layer=m1 \
 //thickness=0.36 //x=24.03 //y=1.845 //x2=23.715 //y2=1.845
r382 (  14 16 ) resistor r=0.0698411 //w=0.17 //l=0.120208 //layer=m1 \
 //thickness=0.36 //x=23.63 //y=1.76 //x2=23.715 //y2=1.845
r383 (  13 41 ) resistor r=0.0717383 //w=0.224 //l=0.115 //layer=m1 \
 //thickness=0.36 //x=23.63 //y=1.305 //x2=23.63 //y2=1.19
r384 (  13 14 ) resistor r=0.43416 //w=0.131 //l=0.455 //layer=m1 \
 //thickness=0.36 //x=23.63 //y=1.305 //x2=23.63 //y2=1.76
r385 (  12 37 ) resistor r=0.0675342 //w=0.23 //l=0.115 //layer=m1 \
 //thickness=0.36 //x=23.45 //y=5.335 //x2=23.335 //y2=5.335
r386 (  11 20 ) resistor r=0.0698411 //w=0.17 //l=0.120208 //layer=m1 \
 //thickness=0.36 //x=24.03 //y=5.335 //x2=24.115 //y2=5.25
r387 (  11 12 ) resistor r=0.553435 //w=0.131 //l=0.58 //layer=m1 \
 //thickness=0.36 //x=24.03 //y=5.335 //x2=23.45 //y2=5.335
r388 (  10 39 ) resistor r=0.00118313 //w=0.23 //layer=m1 //thickness=0.36 \
 //x=23.335 //y=5.56 //x2=23.335 //y2=5.56
r389 (  9 37 ) resistor r=0.002872 //w=0.34 //l=0.085 //layer=m1 \
 //thickness=0.36 //x=23.335 //y=5.42 //x2=23.335 //y2=5.335
r390 (  9 10 ) resistor r=0.091623 //w=0.191 //l=0.14 //layer=m1 \
 //thickness=0.36 //x=23.335 //y=5.42 //x2=23.335 //y2=5.56
r391 (  8 34 ) resistor r=0.0262263 //w=0.232 //l=0.12 //layer=m1 \
 //thickness=0.36 //x=22.575 //y=5.335 //x2=22.455 //y2=5.335
r392 (  7 37 ) resistor r=0.0675342 //w=0.23 //l=0.115 //layer=m1 \
 //thickness=0.36 //x=23.22 //y=5.335 //x2=23.335 //y2=5.335
r393 (  7 8 ) resistor r=0.615458 //w=0.131 //l=0.645 //layer=m1 \
 //thickness=0.36 //x=23.22 //y=5.335 //x2=22.575 //y2=5.335
r394 (  6 31 ) resistor r=0.0222262 //w=0.217 //l=0.118 //layer=m1 \
 //thickness=0.36 //x=21.695 //y=5.335 //x2=21.577 //y2=5.335
r395 (  5 34 ) resistor r=0.0262263 //w=0.232 //l=0.12 //layer=m1 \
 //thickness=0.36 //x=22.335 //y=5.335 //x2=22.455 //y2=5.335
r396 (  5 6 ) resistor r=0.610687 //w=0.131 //l=0.64 //layer=m1 \
 //thickness=0.36 //x=22.335 //y=5.335 //x2=21.695 //y2=5.335
r397 (  4 26 ) resistor r=0.0878548 //w=0.228 //l=0.159295 //layer=m1 \
 //thickness=0.36 //x=18.565 //y=4.735 //x2=18.595 //y2=4.88
r398 (  3 30 ) resistor r=0.0861726 //w=0.376 //l=0.169012 //layer=m1 \
 //thickness=0.36 //x=18.565 //y=3.655 //x2=18.617 //y2=3.51
r399 (  3 4 ) resistor r=1.03053 //w=0.131 //l=1.08 //layer=m1 \
 //thickness=0.36 //x=18.565 //y=3.655 //x2=18.565 //y2=4.735
r400 (  2 28 ) resistor r=0.0911593 //w=0.376 //l=0.184174 //layer=m1 \
 //thickness=0.36 //x=18.565 //y=3.335 //x2=18.617 //y2=3.495
r401 (  2 24 ) resistor r=0.906489 //w=0.131 //l=0.95 //layer=m1 \
 //thickness=0.36 //x=18.565 //y=3.335 //x2=18.565 //y2=2.385
ends PM_DFFSNQNX1\%noxref_8

subckt PM_DFFSNQNX1\%VDD ( 1 43 69 77 103 111 121 131 147 155 165 175 191 201 \
 227 237 261 271 279 292 298 301 307 313 317 322 328 329 330 331 332 333 334 \
 335 336 337 338 339 340 341 342 343 344 345 346 347 348 )
c386 ( 348 0 ) capacitor c=0.0466891f //x=23.63 //y=5.2
c387 ( 347 0 ) capacitor c=0.0256194f //x=22.75 //y=5.2
c388 ( 346 0 ) capacitor c=0.0255777f //x=21.87 //y=5.2
c389 ( 345 0 ) capacitor c=0.0676042f //x=21 //y=5.2
c390 ( 344 0 ) capacitor c=0.0397412f //x=19.12 //y=5.2
c391 ( 343 0 ) capacitor c=0.0248174f //x=18.24 //y=5.2
c392 ( 342 0 ) capacitor c=0.0621883f //x=17.37 //y=5.2
c393 ( 341 0 ) capacitor c=0.0393089f //x=15.79 //y=5.2
c394 ( 340 0 ) capacitor c=0.0248174f //x=14.91 //y=5.2
c395 ( 339 0 ) capacitor c=0.0629527f //x=14.04 //y=5.2
c396 ( 338 0 ) capacitor c=0.0466891f //x=12.16 //y=5.2
c397 ( 337 0 ) capacitor c=0.0255836f //x=11.28 //y=5.2
c398 ( 336 0 ) capacitor c=0.0256114f //x=10.4 //y=5.2
c399 ( 335 0 ) capacitor c=0.0677118f //x=9.53 //y=5.2
c400 ( 334 0 ) capacitor c=0.0466891f //x=7.35 //y=5.2
c401 ( 333 0 ) capacitor c=0.025617f //x=6.47 //y=5.2
c402 ( 332 0 ) capacitor c=0.0255777f //x=5.59 //y=5.2
c403 ( 331 0 ) capacitor c=0.0676654f //x=4.72 //y=5.2
c404 ( 330 0 ) capacitor c=0.0399069f //x=2.84 //y=5.2
c405 ( 329 0 ) capacitor c=0.0248174f //x=1.96 //y=5.2
c406 ( 328 0 ) capacitor c=0.0678368f //x=1.09 //y=5.2
c407 ( 326 0 ) capacitor c=0.00597439f //x=23.775 //y=7.585
c408 ( 325 0 ) capacitor c=0.00597439f //x=22.895 //y=7.585
c409 ( 324 0 ) capacitor c=0.00597439f //x=22.015 //y=7.585
c410 ( 323 0 ) capacitor c=0.00597439f //x=21.135 //y=7.585
c411 ( 322 0 ) capacitor c=0.146838f //x=20.045 //y=7.585
c412 ( 321 0 ) capacitor c=0.00597439f //x=19.305 //y=7.58
c413 ( 319 0 ) capacitor c=0.00597439f //x=18.385 //y=7.585
c414 ( 318 0 ) capacitor c=0.00597439f //x=17.505 //y=7.585
c415 ( 317 0 ) capacitor c=0.127335f //x=16.715 //y=7.585
c416 ( 316 0 ) capacitor c=0.00597439f //x=15.935 //y=7.585
c417 ( 315 0 ) capacitor c=0.00597439f //x=15.055 //y=7.585
c418 ( 314 0 ) capacitor c=0.00597439f //x=14.175 //y=7.585
c419 ( 313 0 ) capacitor c=0.145673f //x=13.385 //y=7.585
c420 ( 312 0 ) capacitor c=0.00597439f //x=12.305 //y=7.585
c421 ( 311 0 ) capacitor c=0.00597439f //x=11.425 //y=7.585
c422 ( 310 0 ) capacitor c=0.00597439f //x=10.545 //y=7.585
c423 ( 309 0 ) capacitor c=0.00597439f //x=9.685 //y=7.58
c424 ( 307 0 ) capacitor c=0.162199f //x=8.575 //y=7.585
c425 ( 306 0 ) capacitor c=0.00597439f //x=7.495 //y=7.585
c426 ( 305 0 ) capacitor c=0.00597439f //x=6.615 //y=7.585
c427 ( 304 0 ) capacitor c=0.00597439f //x=5.735 //y=7.585
c428 ( 303 0 ) capacitor c=0.00597439f //x=4.875 //y=7.58
c429 ( 301 0 ) capacitor c=0.144899f //x=3.765 //y=7.585
c430 ( 300 0 ) capacitor c=0.00597439f //x=2.985 //y=7.585
c431 ( 299 0 ) capacitor c=0.00597439f //x=2.105 //y=7.585
c432 ( 298 0 ) capacitor c=0.268271f //x=1.175 //y=7.58
c433 ( 292 0 ) capacitor c=0.297896f //x=24.115 //y=7.58
c434 ( 279 0 ) capacitor c=0.0288858f //x=23.69 //y=7.585
c435 ( 271 0 ) capacitor c=0.0289326f //x=22.81 //y=7.585
c436 ( 261 0 ) capacitor c=0.0290299f //x=21.93 //y=7.585
c437 ( 249 0 ) capacitor c=0.0455283f //x=21.05 //y=7.585
c438 ( 245 0 ) capacitor c=0.0277785f //x=19.875 //y=7.585
c439 ( 237 0 ) capacitor c=0.0287375f //x=19.18 //y=7.585
c440 ( 227 0 ) capacitor c=0.0291726f //x=18.3 //y=7.585
c441 ( 215 0 ) capacitor c=0.0283511f //x=17.42 //y=7.585
c442 ( 211 0 ) capacitor c=0.0277785f //x=16.545 //y=7.585
c443 ( 201 0 ) capacitor c=0.0287377f //x=15.85 //y=7.585
c444 ( 191 0 ) capacitor c=0.0291078f //x=14.97 //y=7.585
c445 ( 181 0 ) capacitor c=0.0283511f //x=14.09 //y=7.585
c446 ( 175 0 ) capacitor c=0.042257f //x=13.215 //y=7.585
c447 ( 165 0 ) capacitor c=0.0288858f //x=12.22 //y=7.585
c448 ( 155 0 ) capacitor c=0.0289326f //x=11.34 //y=7.585
c449 ( 147 0 ) capacitor c=0.0290299f //x=10.46 //y=7.585
c450 ( 137 0 ) capacitor c=0.0455283f //x=9.58 //y=7.585
c451 ( 131 0 ) capacitor c=0.041708f //x=8.405 //y=7.585
c452 ( 121 0 ) capacitor c=0.0288858f //x=7.41 //y=7.585
c453 ( 111 0 ) capacitor c=0.0288437f //x=6.53 //y=7.585
c454 ( 103 0 ) capacitor c=0.0290299f //x=5.65 //y=7.585
c455 ( 93 0 ) capacitor c=0.0455283f //x=4.77 //y=7.585
c456 ( 87 0 ) capacitor c=0.0277785f //x=3.595 //y=7.585
c457 ( 77 0 ) capacitor c=0.0287376f //x=2.9 //y=7.585
c458 ( 69 0 ) capacitor c=0.0291078f //x=2.02 //y=7.585
c459 ( 43 0 ) capacitor c=0.933677f //x=24.115 //y=7.58
r460 (  290 326 ) resistor r=2.87058 //w=0.35 //l=0.085 //layer=li \
 //thickness=0.1 //x=23.86 //y=7.585 //x2=23.775 //y2=7.585
r461 (  290 292 ) resistor r=8.89373 //w=0.367 //l=0.255 //layer=li \
 //thickness=0.1 //x=23.86 //y=7.585 //x2=24.115 //y2=7.585
r462 (  283 326 ) resistor r=4.23183 //w=0.7 //l=0.175 //layer=li \
 //thickness=0.1 //x=23.775 //y=7.41 //x2=23.775 //y2=7.585
r463 (  283 348 ) resistor r=33.1979 //w=0.187 //l=0.485 //layer=li \
 //thickness=0.1 //x=23.775 //y=7.41 //x2=23.775 //y2=6.925
r464 (  280 325 ) resistor r=2.87058 //w=0.35 //l=0.085 //layer=li \
 //thickness=0.1 //x=22.98 //y=7.585 //x2=22.895 //y2=7.585
r465 (  280 282 ) resistor r=0.871935 //w=0.367 //l=0.025 //layer=li \
 //thickness=0.1 //x=22.98 //y=7.585 //x2=23.005 //y2=7.585
r466 (  279 326 ) resistor r=2.87058 //w=0.35 //l=0.085 //layer=li \
 //thickness=0.1 //x=23.69 //y=7.585 //x2=23.775 //y2=7.585
r467 (  279 282 ) resistor r=23.891 //w=0.367 //l=0.685 //layer=li \
 //thickness=0.1 //x=23.69 //y=7.585 //x2=23.005 //y2=7.585
r468 (  273 325 ) resistor r=4.23183 //w=0.7 //l=0.175 //layer=li \
 //thickness=0.1 //x=22.895 //y=7.41 //x2=22.895 //y2=7.585
r469 (  273 347 ) resistor r=33.1979 //w=0.187 //l=0.485 //layer=li \
 //thickness=0.1 //x=22.895 //y=7.41 //x2=22.895 //y2=6.925
r470 (  272 324 ) resistor r=2.87058 //w=0.35 //l=0.085 //layer=li \
 //thickness=0.1 //x=22.1 //y=7.585 //x2=22.015 //y2=7.585
r471 (  271 325 ) resistor r=2.87058 //w=0.35 //l=0.085 //layer=li \
 //thickness=0.1 //x=22.81 //y=7.585 //x2=22.895 //y2=7.585
r472 (  271 272 ) resistor r=24.7629 //w=0.367 //l=0.71 //layer=li \
 //thickness=0.1 //x=22.81 //y=7.585 //x2=22.1 //y2=7.585
r473 (  265 324 ) resistor r=4.23183 //w=0.7 //l=0.175 //layer=li \
 //thickness=0.1 //x=22.015 //y=7.41 //x2=22.015 //y2=7.585
r474 (  265 346 ) resistor r=33.1979 //w=0.187 //l=0.485 //layer=li \
 //thickness=0.1 //x=22.015 //y=7.41 //x2=22.015 //y2=6.925
r475 (  262 323 ) resistor r=2.87058 //w=0.35 //l=0.085 //layer=li \
 //thickness=0.1 //x=21.22 //y=7.585 //x2=21.135 //y2=7.585
r476 (  262 264 ) resistor r=23.5422 //w=0.367 //l=0.675 //layer=li \
 //thickness=0.1 //x=21.22 //y=7.585 //x2=21.895 //y2=7.585
r477 (  261 324 ) resistor r=2.87058 //w=0.35 //l=0.085 //layer=li \
 //thickness=0.1 //x=21.93 //y=7.585 //x2=22.015 //y2=7.585
r478 (  261 264 ) resistor r=1.22071 //w=0.367 //l=0.035 //layer=li \
 //thickness=0.1 //x=21.93 //y=7.585 //x2=21.895 //y2=7.585
r479 (  253 323 ) resistor r=4.23183 //w=0.7 //l=0.175 //layer=li \
 //thickness=0.1 //x=21.135 //y=7.41 //x2=21.135 //y2=7.585
r480 (  253 345 ) resistor r=56.4706 //w=0.187 //l=0.825 //layer=li \
 //thickness=0.1 //x=21.135 //y=7.41 //x2=21.135 //y2=6.585
r481 (  250 322 ) resistor r=5.29055 //w=0.35 //l=0.17 //layer=li \
 //thickness=0.1 //x=20.215 //y=7.585 //x2=20.045 //y2=7.585
r482 (  250 252 ) resistor r=19.8801 //w=0.367 //l=0.57 //layer=li \
 //thickness=0.1 //x=20.215 //y=7.585 //x2=20.785 //y2=7.585
r483 (  249 323 ) resistor r=2.87058 //w=0.35 //l=0.085 //layer=li \
 //thickness=0.1 //x=21.05 //y=7.585 //x2=21.135 //y2=7.585
r484 (  249 252 ) resistor r=9.24251 //w=0.367 //l=0.265 //layer=li \
 //thickness=0.1 //x=21.05 //y=7.585 //x2=20.785 //y2=7.585
r485 (  246 321 ) resistor r=2.87058 //w=0.35 //l=0.085 //layer=li \
 //thickness=0.1 //x=19.35 //y=7.585 //x2=19.265 //y2=7.585
r486 (  245 322 ) resistor r=5.29055 //w=0.35 //l=0.17 //layer=li \
 //thickness=0.1 //x=19.875 //y=7.585 //x2=20.045 //y2=7.585
r487 (  245 246 ) resistor r=18.3106 //w=0.367 //l=0.525 //layer=li \
 //thickness=0.1 //x=19.875 //y=7.585 //x2=19.35 //y2=7.585
r488 (  239 321 ) resistor r=4.23183 //w=0.7 //l=0.175 //layer=li \
 //thickness=0.1 //x=19.265 //y=7.41 //x2=19.265 //y2=7.585
r489 (  239 344 ) resistor r=33.1979 //w=0.187 //l=0.485 //layer=li \
 //thickness=0.1 //x=19.265 //y=7.41 //x2=19.265 //y2=6.925
r490 (  238 319 ) resistor r=2.87058 //w=0.35 //l=0.085 //layer=li \
 //thickness=0.1 //x=18.47 //y=7.585 //x2=18.385 //y2=7.585
r491 (  237 321 ) resistor r=2.87058 //w=0.35 //l=0.085 //layer=li \
 //thickness=0.1 //x=19.18 //y=7.585 //x2=19.265 //y2=7.585
r492 (  237 238 ) resistor r=24.7629 //w=0.367 //l=0.71 //layer=li \
 //thickness=0.1 //x=19.18 //y=7.585 //x2=18.47 //y2=7.585
r493 (  231 319 ) resistor r=4.23183 //w=0.7 //l=0.175 //layer=li \
 //thickness=0.1 //x=18.385 //y=7.41 //x2=18.385 //y2=7.585
r494 (  231 343 ) resistor r=33.1979 //w=0.187 //l=0.485 //layer=li \
 //thickness=0.1 //x=18.385 //y=7.41 //x2=18.385 //y2=6.925
r495 (  228 318 ) resistor r=2.87058 //w=0.35 //l=0.085 //layer=li \
 //thickness=0.1 //x=17.59 //y=7.585 //x2=17.505 //y2=7.585
r496 (  228 230 ) resistor r=21.1008 //w=0.367 //l=0.605 //layer=li \
 //thickness=0.1 //x=17.59 //y=7.585 //x2=18.195 //y2=7.585
r497 (  227 319 ) resistor r=2.87058 //w=0.35 //l=0.085 //layer=li \
 //thickness=0.1 //x=18.3 //y=7.585 //x2=18.385 //y2=7.585
r498 (  227 230 ) resistor r=3.66213 //w=0.367 //l=0.105 //layer=li \
 //thickness=0.1 //x=18.3 //y=7.585 //x2=18.195 //y2=7.585
r499 (  219 318 ) resistor r=4.23183 //w=0.7 //l=0.175 //layer=li \
 //thickness=0.1 //x=17.505 //y=7.41 //x2=17.505 //y2=7.585
r500 (  219 342 ) resistor r=56.4706 //w=0.187 //l=0.825 //layer=li \
 //thickness=0.1 //x=17.505 //y=7.41 //x2=17.505 //y2=6.585
r501 (  216 317 ) resistor r=5.29055 //w=0.35 //l=0.17 //layer=li \
 //thickness=0.1 //x=16.885 //y=7.585 //x2=16.715 //y2=7.585
r502 (  216 218 ) resistor r=6.97548 //w=0.367 //l=0.2 //layer=li \
 //thickness=0.1 //x=16.885 //y=7.585 //x2=17.085 //y2=7.585
r503 (  215 318 ) resistor r=2.87058 //w=0.35 //l=0.085 //layer=li \
 //thickness=0.1 //x=17.42 //y=7.585 //x2=17.505 //y2=7.585
r504 (  215 218 ) resistor r=11.6839 //w=0.367 //l=0.335 //layer=li \
 //thickness=0.1 //x=17.42 //y=7.585 //x2=17.085 //y2=7.585
r505 (  212 316 ) resistor r=2.87058 //w=0.35 //l=0.085 //layer=li \
 //thickness=0.1 //x=16.02 //y=7.585 //x2=15.935 //y2=7.585
r506 (  211 317 ) resistor r=5.29055 //w=0.35 //l=0.17 //layer=li \
 //thickness=0.1 //x=16.545 //y=7.585 //x2=16.715 //y2=7.585
r507 (  211 212 ) resistor r=18.3106 //w=0.367 //l=0.525 //layer=li \
 //thickness=0.1 //x=16.545 //y=7.585 //x2=16.02 //y2=7.585
r508 (  205 316 ) resistor r=4.23183 //w=0.7 //l=0.175 //layer=li \
 //thickness=0.1 //x=15.935 //y=7.41 //x2=15.935 //y2=7.585
r509 (  205 341 ) resistor r=33.1979 //w=0.187 //l=0.485 //layer=li \
 //thickness=0.1 //x=15.935 //y=7.41 //x2=15.935 //y2=6.925
r510 (  202 315 ) resistor r=2.87058 //w=0.35 //l=0.085 //layer=li \
 //thickness=0.1 //x=15.14 //y=7.585 //x2=15.055 //y2=7.585
r511 (  202 204 ) resistor r=16.218 //w=0.367 //l=0.465 //layer=li \
 //thickness=0.1 //x=15.14 //y=7.585 //x2=15.605 //y2=7.585
r512 (  201 316 ) resistor r=2.87058 //w=0.35 //l=0.085 //layer=li \
 //thickness=0.1 //x=15.85 //y=7.585 //x2=15.935 //y2=7.585
r513 (  201 204 ) resistor r=8.54496 //w=0.367 //l=0.245 //layer=li \
 //thickness=0.1 //x=15.85 //y=7.585 //x2=15.605 //y2=7.585
r514 (  195 315 ) resistor r=4.23183 //w=0.7 //l=0.175 //layer=li \
 //thickness=0.1 //x=15.055 //y=7.41 //x2=15.055 //y2=7.585
r515 (  195 340 ) resistor r=33.1979 //w=0.187 //l=0.485 //layer=li \
 //thickness=0.1 //x=15.055 //y=7.41 //x2=15.055 //y2=6.925
r516 (  192 314 ) resistor r=2.87058 //w=0.35 //l=0.085 //layer=li \
 //thickness=0.1 //x=14.26 //y=7.585 //x2=14.175 //y2=7.585
r517 (  192 194 ) resistor r=8.19619 //w=0.367 //l=0.235 //layer=li \
 //thickness=0.1 //x=14.26 //y=7.585 //x2=14.495 //y2=7.585
r518 (  191 315 ) resistor r=2.87058 //w=0.35 //l=0.085 //layer=li \
 //thickness=0.1 //x=14.97 //y=7.585 //x2=15.055 //y2=7.585
r519 (  191 194 ) resistor r=16.5668 //w=0.367 //l=0.475 //layer=li \
 //thickness=0.1 //x=14.97 //y=7.585 //x2=14.495 //y2=7.585
r520 (  183 314 ) resistor r=4.23183 //w=0.7 //l=0.175 //layer=li \
 //thickness=0.1 //x=14.175 //y=7.41 //x2=14.175 //y2=7.585
r521 (  183 339 ) resistor r=56.4706 //w=0.187 //l=0.825 //layer=li \
 //thickness=0.1 //x=14.175 //y=7.41 //x2=14.175 //y2=6.585
r522 (  182 313 ) resistor r=5.29055 //w=0.35 //l=0.17 //layer=li \
 //thickness=0.1 //x=13.555 //y=7.585 //x2=13.385 //y2=7.585
r523 (  181 314 ) resistor r=2.87058 //w=0.35 //l=0.085 //layer=li \
 //thickness=0.1 //x=14.09 //y=7.585 //x2=14.175 //y2=7.585
r524 (  181 182 ) resistor r=18.6594 //w=0.367 //l=0.535 //layer=li \
 //thickness=0.1 //x=14.09 //y=7.585 //x2=13.555 //y2=7.585
r525 (  176 312 ) resistor r=2.87058 //w=0.35 //l=0.085 //layer=li \
 //thickness=0.1 //x=12.39 //y=7.585 //x2=12.305 //y2=7.585
r526 (  176 178 ) resistor r=21.7984 //w=0.367 //l=0.625 //layer=li \
 //thickness=0.1 //x=12.39 //y=7.585 //x2=13.015 //y2=7.585
r527 (  175 313 ) resistor r=5.29055 //w=0.35 //l=0.17 //layer=li \
 //thickness=0.1 //x=13.215 //y=7.585 //x2=13.385 //y2=7.585
r528 (  175 178 ) resistor r=6.97548 //w=0.367 //l=0.2 //layer=li \
 //thickness=0.1 //x=13.215 //y=7.585 //x2=13.015 //y2=7.585
r529 (  169 312 ) resistor r=4.23183 //w=0.7 //l=0.175 //layer=li \
 //thickness=0.1 //x=12.305 //y=7.41 //x2=12.305 //y2=7.585
r530 (  169 338 ) resistor r=33.1979 //w=0.187 //l=0.485 //layer=li \
 //thickness=0.1 //x=12.305 //y=7.41 //x2=12.305 //y2=6.925
r531 (  166 311 ) resistor r=2.87058 //w=0.35 //l=0.085 //layer=li \
 //thickness=0.1 //x=11.51 //y=7.585 //x2=11.425 //y2=7.585
r532 (  166 168 ) resistor r=13.7766 //w=0.367 //l=0.395 //layer=li \
 //thickness=0.1 //x=11.51 //y=7.585 //x2=11.905 //y2=7.585
r533 (  165 312 ) resistor r=2.87058 //w=0.35 //l=0.085 //layer=li \
 //thickness=0.1 //x=12.22 //y=7.585 //x2=12.305 //y2=7.585
r534 (  165 168 ) resistor r=10.9864 //w=0.367 //l=0.315 //layer=li \
 //thickness=0.1 //x=12.22 //y=7.585 //x2=11.905 //y2=7.585
r535 (  159 311 ) resistor r=4.23183 //w=0.7 //l=0.175 //layer=li \
 //thickness=0.1 //x=11.425 //y=7.41 //x2=11.425 //y2=7.585
r536 (  159 337 ) resistor r=33.1979 //w=0.187 //l=0.485 //layer=li \
 //thickness=0.1 //x=11.425 //y=7.41 //x2=11.425 //y2=6.925
r537 (  156 310 ) resistor r=2.87058 //w=0.35 //l=0.085 //layer=li \
 //thickness=0.1 //x=10.63 //y=7.585 //x2=10.545 //y2=7.585
r538 (  156 158 ) resistor r=5.75477 //w=0.367 //l=0.165 //layer=li \
 //thickness=0.1 //x=10.63 //y=7.585 //x2=10.795 //y2=7.585
r539 (  155 311 ) resistor r=2.87058 //w=0.35 //l=0.085 //layer=li \
 //thickness=0.1 //x=11.34 //y=7.585 //x2=11.425 //y2=7.585
r540 (  155 158 ) resistor r=19.0082 //w=0.367 //l=0.545 //layer=li \
 //thickness=0.1 //x=11.34 //y=7.585 //x2=10.795 //y2=7.585
r541 (  149 310 ) resistor r=4.23183 //w=0.7 //l=0.175 //layer=li \
 //thickness=0.1 //x=10.545 //y=7.41 //x2=10.545 //y2=7.585
r542 (  149 336 ) resistor r=33.1979 //w=0.187 //l=0.485 //layer=li \
 //thickness=0.1 //x=10.545 //y=7.41 //x2=10.545 //y2=6.925
r543 (  148 309 ) resistor r=2.87058 //w=0.35 //l=0.085 //layer=li \
 //thickness=0.1 //x=9.75 //y=7.585 //x2=9.665 //y2=7.585
r544 (  147 310 ) resistor r=2.87058 //w=0.35 //l=0.085 //layer=li \
 //thickness=0.1 //x=10.46 //y=7.585 //x2=10.545 //y2=7.585
r545 (  147 148 ) resistor r=24.7629 //w=0.367 //l=0.71 //layer=li \
 //thickness=0.1 //x=10.46 //y=7.585 //x2=9.75 //y2=7.585
r546 (  139 309 ) resistor r=4.23183 //w=0.7 //l=0.175 //layer=li \
 //thickness=0.1 //x=9.665 //y=7.41 //x2=9.665 //y2=7.585
r547 (  139 335 ) resistor r=56.4706 //w=0.187 //l=0.825 //layer=li \
 //thickness=0.1 //x=9.665 //y=7.41 //x2=9.665 //y2=6.585
r548 (  138 307 ) resistor r=5.29055 //w=0.35 //l=0.17 //layer=li \
 //thickness=0.1 //x=8.745 //y=7.585 //x2=8.575 //y2=7.585
r549 (  137 309 ) resistor r=2.87058 //w=0.35 //l=0.085 //layer=li \
 //thickness=0.1 //x=9.58 //y=7.585 //x2=9.665 //y2=7.585
r550 (  137 138 ) resistor r=29.1226 //w=0.367 //l=0.835 //layer=li \
 //thickness=0.1 //x=9.58 //y=7.585 //x2=8.745 //y2=7.585
r551 (  132 306 ) resistor r=2.87058 //w=0.35 //l=0.085 //layer=li \
 //thickness=0.1 //x=7.58 //y=7.585 //x2=7.495 //y2=7.585
r552 (  132 134 ) resistor r=21.7984 //w=0.367 //l=0.625 //layer=li \
 //thickness=0.1 //x=7.58 //y=7.585 //x2=8.205 //y2=7.585
r553 (  131 307 ) resistor r=5.29055 //w=0.35 //l=0.17 //layer=li \
 //thickness=0.1 //x=8.405 //y=7.585 //x2=8.575 //y2=7.585
r554 (  131 134 ) resistor r=6.97548 //w=0.367 //l=0.2 //layer=li \
 //thickness=0.1 //x=8.405 //y=7.585 //x2=8.205 //y2=7.585
r555 (  125 306 ) resistor r=4.23183 //w=0.7 //l=0.175 //layer=li \
 //thickness=0.1 //x=7.495 //y=7.41 //x2=7.495 //y2=7.585
r556 (  125 334 ) resistor r=33.1979 //w=0.187 //l=0.485 //layer=li \
 //thickness=0.1 //x=7.495 //y=7.41 //x2=7.495 //y2=6.925
r557 (  122 305 ) resistor r=2.87058 //w=0.35 //l=0.085 //layer=li \
 //thickness=0.1 //x=6.7 //y=7.585 //x2=6.615 //y2=7.585
r558 (  122 124 ) resistor r=13.7766 //w=0.367 //l=0.395 //layer=li \
 //thickness=0.1 //x=6.7 //y=7.585 //x2=7.095 //y2=7.585
r559 (  121 306 ) resistor r=2.87058 //w=0.35 //l=0.085 //layer=li \
 //thickness=0.1 //x=7.41 //y=7.585 //x2=7.495 //y2=7.585
r560 (  121 124 ) resistor r=10.9864 //w=0.367 //l=0.315 //layer=li \
 //thickness=0.1 //x=7.41 //y=7.585 //x2=7.095 //y2=7.585
r561 (  115 305 ) resistor r=4.23183 //w=0.7 //l=0.175 //layer=li \
 //thickness=0.1 //x=6.615 //y=7.41 //x2=6.615 //y2=7.585
r562 (  115 333 ) resistor r=33.1979 //w=0.187 //l=0.485 //layer=li \
 //thickness=0.1 //x=6.615 //y=7.41 //x2=6.615 //y2=6.925
r563 (  112 304 ) resistor r=2.87058 //w=0.35 //l=0.085 //layer=li \
 //thickness=0.1 //x=5.82 //y=7.585 //x2=5.735 //y2=7.585
r564 (  112 114 ) resistor r=5.75477 //w=0.367 //l=0.165 //layer=li \
 //thickness=0.1 //x=5.82 //y=7.585 //x2=5.985 //y2=7.585
r565 (  111 305 ) resistor r=2.87058 //w=0.35 //l=0.085 //layer=li \
 //thickness=0.1 //x=6.53 //y=7.585 //x2=6.615 //y2=7.585
r566 (  111 114 ) resistor r=19.0082 //w=0.367 //l=0.545 //layer=li \
 //thickness=0.1 //x=6.53 //y=7.585 //x2=5.985 //y2=7.585
r567 (  105 304 ) resistor r=4.23183 //w=0.7 //l=0.175 //layer=li \
 //thickness=0.1 //x=5.735 //y=7.41 //x2=5.735 //y2=7.585
r568 (  105 332 ) resistor r=33.1979 //w=0.187 //l=0.485 //layer=li \
 //thickness=0.1 //x=5.735 //y=7.41 //x2=5.735 //y2=6.925
r569 (  104 303 ) resistor r=2.87058 //w=0.35 //l=0.085 //layer=li \
 //thickness=0.1 //x=4.94 //y=7.585 //x2=4.855 //y2=7.585
r570 (  103 304 ) resistor r=2.87058 //w=0.35 //l=0.085 //layer=li \
 //thickness=0.1 //x=5.65 //y=7.585 //x2=5.735 //y2=7.585
r571 (  103 104 ) resistor r=24.7629 //w=0.367 //l=0.71 //layer=li \
 //thickness=0.1 //x=5.65 //y=7.585 //x2=4.94 //y2=7.585
r572 (  95 303 ) resistor r=4.23183 //w=0.7 //l=0.175 //layer=li \
 //thickness=0.1 //x=4.855 //y=7.41 //x2=4.855 //y2=7.585
r573 (  95 331 ) resistor r=56.4706 //w=0.187 //l=0.825 //layer=li \
 //thickness=0.1 //x=4.855 //y=7.41 //x2=4.855 //y2=6.585
r574 (  94 301 ) resistor r=5.29055 //w=0.35 //l=0.17 //layer=li \
 //thickness=0.1 //x=3.935 //y=7.585 //x2=3.765 //y2=7.585
r575 (  93 303 ) resistor r=2.87058 //w=0.35 //l=0.085 //layer=li \
 //thickness=0.1 //x=4.77 //y=7.585 //x2=4.855 //y2=7.585
r576 (  93 94 ) resistor r=29.1226 //w=0.367 //l=0.835 //layer=li \
 //thickness=0.1 //x=4.77 //y=7.585 //x2=3.935 //y2=7.585
r577 (  88 300 ) resistor r=2.87058 //w=0.35 //l=0.085 //layer=li \
 //thickness=0.1 //x=3.07 //y=7.585 //x2=2.985 //y2=7.585
r578 (  88 90 ) resistor r=11.3351 //w=0.367 //l=0.325 //layer=li \
 //thickness=0.1 //x=3.07 //y=7.585 //x2=3.395 //y2=7.585
r579 (  87 301 ) resistor r=5.29055 //w=0.35 //l=0.17 //layer=li \
 //thickness=0.1 //x=3.595 //y=7.585 //x2=3.765 //y2=7.585
r580 (  87 90 ) resistor r=6.97548 //w=0.367 //l=0.2 //layer=li \
 //thickness=0.1 //x=3.595 //y=7.585 //x2=3.395 //y2=7.585
r581 (  81 300 ) resistor r=4.23183 //w=0.7 //l=0.175 //layer=li \
 //thickness=0.1 //x=2.985 //y=7.41 //x2=2.985 //y2=7.585
r582 (  81 330 ) resistor r=33.1979 //w=0.187 //l=0.485 //layer=li \
 //thickness=0.1 //x=2.985 //y=7.41 //x2=2.985 //y2=6.925
r583 (  78 299 ) resistor r=2.87058 //w=0.35 //l=0.085 //layer=li \
 //thickness=0.1 //x=2.19 //y=7.585 //x2=2.105 //y2=7.585
r584 (  78 80 ) resistor r=3.31335 //w=0.367 //l=0.095 //layer=li \
 //thickness=0.1 //x=2.19 //y=7.585 //x2=2.285 //y2=7.585
r585 (  77 300 ) resistor r=2.87058 //w=0.35 //l=0.085 //layer=li \
 //thickness=0.1 //x=2.9 //y=7.585 //x2=2.985 //y2=7.585
r586 (  77 80 ) resistor r=21.4496 //w=0.367 //l=0.615 //layer=li \
 //thickness=0.1 //x=2.9 //y=7.585 //x2=2.285 //y2=7.585
r587 (  71 299 ) resistor r=4.23183 //w=0.7 //l=0.175 //layer=li \
 //thickness=0.1 //x=2.105 //y=7.41 //x2=2.105 //y2=7.585
r588 (  71 329 ) resistor r=33.1979 //w=0.187 //l=0.485 //layer=li \
 //thickness=0.1 //x=2.105 //y=7.41 //x2=2.105 //y2=6.925
r589 (  70 298 ) resistor r=2.87058 //w=0.35 //l=0.085 //layer=li \
 //thickness=0.1 //x=1.31 //y=7.585 //x2=1.225 //y2=7.585
r590 (  69 299 ) resistor r=2.87058 //w=0.35 //l=0.085 //layer=li \
 //thickness=0.1 //x=2.02 //y=7.585 //x2=2.105 //y2=7.585
r591 (  69 70 ) resistor r=24.7629 //w=0.367 //l=0.71 //layer=li \
 //thickness=0.1 //x=2.02 //y=7.585 //x2=1.31 //y2=7.585
r592 (  61 298 ) resistor r=4.23183 //w=0.7 //l=0.175 //layer=li \
 //thickness=0.1 //x=1.225 //y=7.41 //x2=1.225 //y2=7.585
r593 (  61 328 ) resistor r=56.4706 //w=0.187 //l=0.825 //layer=li \
 //thickness=0.1 //x=1.225 //y=7.41 //x2=1.225 //y2=6.585
r594 (  43 292 ) resistor r=3.1 //w=0.17 //l=0.51 //layer=mcon //count=3 \
 //x=24.115 //y=7.58 //x2=24.115 //y2=7.58
r595 (  41 282 ) resistor r=3.1 //w=0.17 //l=0.51 //layer=mcon //count=3 \
 //x=23.005 //y=7.58 //x2=23.005 //y2=7.58
r596 (  41 43 ) resistor r=0.446141 //w=0.311 //l=1.11 //layer=m1 \
 //thickness=0.36 //x=23.005 //y=7.585 //x2=24.115 //y2=7.585
r597 (  39 264 ) resistor r=3.1 //w=0.17 //l=0.51 //layer=mcon //count=3 \
 //x=21.895 //y=7.58 //x2=21.895 //y2=7.58
r598 (  39 41 ) resistor r=0.446141 //w=0.311 //l=1.11 //layer=m1 \
 //thickness=0.36 //x=21.895 //y=7.585 //x2=23.005 //y2=7.585
r599 (  37 252 ) resistor r=3.1 //w=0.17 //l=0.51 //layer=mcon //count=3 \
 //x=20.785 //y=7.58 //x2=20.785 //y2=7.58
r600 (  37 39 ) resistor r=0.446141 //w=0.311 //l=1.11 //layer=m1 \
 //thickness=0.36 //x=20.785 //y=7.585 //x2=21.895 //y2=7.585
r601 (  35 321 ) resistor r=3.1 //w=0.17 //l=0.51 //layer=mcon //count=3 \
 //x=19.305 //y=7.58 //x2=19.305 //y2=7.58
r602 (  35 37 ) resistor r=0.594855 //w=0.311 //l=1.48 //layer=m1 \
 //thickness=0.36 //x=19.305 //y=7.585 //x2=20.785 //y2=7.585
r603 (  33 230 ) resistor r=3.1 //w=0.17 //l=0.51 //layer=mcon //count=3 \
 //x=18.195 //y=7.58 //x2=18.195 //y2=7.58
r604 (  33 35 ) resistor r=0.446141 //w=0.311 //l=1.11 //layer=m1 \
 //thickness=0.36 //x=18.195 //y=7.585 //x2=19.305 //y2=7.585
r605 (  31 218 ) resistor r=3.1 //w=0.17 //l=0.51 //layer=mcon //count=3 \
 //x=17.085 //y=7.58 //x2=17.085 //y2=7.58
r606 (  31 33 ) resistor r=0.446141 //w=0.311 //l=1.11 //layer=m1 \
 //thickness=0.36 //x=17.085 //y=7.585 //x2=18.195 //y2=7.585
r607 (  29 204 ) resistor r=3.1 //w=0.17 //l=0.51 //layer=mcon //count=3 \
 //x=15.605 //y=7.58 //x2=15.605 //y2=7.58
r608 (  29 31 ) resistor r=0.594855 //w=0.311 //l=1.48 //layer=m1 \
 //thickness=0.36 //x=15.605 //y=7.585 //x2=17.085 //y2=7.585
r609 (  27 194 ) resistor r=3.1 //w=0.17 //l=0.51 //layer=mcon //count=3 \
 //x=14.495 //y=7.58 //x2=14.495 //y2=7.58
r610 (  27 29 ) resistor r=0.446141 //w=0.311 //l=1.11 //layer=m1 \
 //thickness=0.36 //x=14.495 //y=7.585 //x2=15.605 //y2=7.585
r611 (  25 178 ) resistor r=3.1 //w=0.17 //l=0.51 //layer=mcon //count=3 \
 //x=13.015 //y=7.58 //x2=13.015 //y2=7.58
r612 (  25 27 ) resistor r=0.594855 //w=0.311 //l=1.48 //layer=m1 \
 //thickness=0.36 //x=13.015 //y=7.585 //x2=14.495 //y2=7.585
r613 (  22 168 ) resistor r=3.1 //w=0.17 //l=0.51 //layer=mcon //count=3 \
 //x=11.905 //y=7.58 //x2=11.905 //y2=7.58
r614 (  20 158 ) resistor r=3.1 //w=0.17 //l=0.51 //layer=mcon //count=3 \
 //x=10.795 //y=7.58 //x2=10.795 //y2=7.58
r615 (  20 22 ) resistor r=0.446141 //w=0.311 //l=1.11 //layer=m1 \
 //thickness=0.36 //x=10.795 //y=7.585 //x2=11.905 //y2=7.585
r616 (  18 309 ) resistor r=3.1 //w=0.17 //l=0.51 //layer=mcon //count=3 \
 //x=9.685 //y=7.58 //x2=9.685 //y2=7.58
r617 (  18 20 ) resistor r=0.446141 //w=0.311 //l=1.11 //layer=m1 \
 //thickness=0.36 //x=9.685 //y=7.585 //x2=10.795 //y2=7.585
r618 (  16 134 ) resistor r=3.1 //w=0.17 //l=0.51 //layer=mcon //count=3 \
 //x=8.205 //y=7.58 //x2=8.205 //y2=7.58
r619 (  16 18 ) resistor r=0.594855 //w=0.311 //l=1.48 //layer=m1 \
 //thickness=0.36 //x=8.205 //y=7.585 //x2=9.685 //y2=7.585
r620 (  14 124 ) resistor r=3.1 //w=0.17 //l=0.51 //layer=mcon //count=3 \
 //x=7.095 //y=7.58 //x2=7.095 //y2=7.58
r621 (  14 16 ) resistor r=0.446141 //w=0.311 //l=1.11 //layer=m1 \
 //thickness=0.36 //x=7.095 //y=7.585 //x2=8.205 //y2=7.585
r622 (  12 114 ) resistor r=3.1 //w=0.17 //l=0.51 //layer=mcon //count=3 \
 //x=5.985 //y=7.58 //x2=5.985 //y2=7.58
r623 (  12 14 ) resistor r=0.446141 //w=0.311 //l=1.11 //layer=m1 \
 //thickness=0.36 //x=5.985 //y=7.585 //x2=7.095 //y2=7.585
r624 (  10 303 ) resistor r=3.1 //w=0.17 //l=0.51 //layer=mcon //count=3 \
 //x=4.875 //y=7.58 //x2=4.875 //y2=7.58
r625 (  10 12 ) resistor r=0.446141 //w=0.311 //l=1.11 //layer=m1 \
 //thickness=0.36 //x=4.875 //y=7.585 //x2=5.985 //y2=7.585
r626 (  8 90 ) resistor r=3.1 //w=0.17 //l=0.51 //layer=mcon //count=3 \
 //x=3.395 //y=7.58 //x2=3.395 //y2=7.58
r627 (  8 10 ) resistor r=0.594855 //w=0.311 //l=1.48 //layer=m1 \
 //thickness=0.36 //x=3.395 //y=7.585 //x2=4.875 //y2=7.585
r628 (  6 80 ) resistor r=3.1 //w=0.17 //l=0.51 //layer=mcon //count=3 \
 //x=2.285 //y=7.58 //x2=2.285 //y2=7.58
r629 (  6 8 ) resistor r=0.446141 //w=0.311 //l=1.11 //layer=m1 \
 //thickness=0.36 //x=2.285 //y=7.585 //x2=3.395 //y2=7.585
r630 (  3 298 ) resistor r=3.1 //w=0.17 //l=0.51 //layer=mcon //count=3 \
 //x=1.175 //y=7.58 //x2=1.175 //y2=7.58
r631 (  3 6 ) resistor r=0.446141 //w=0.311 //l=1.11 //layer=m1 \
 //thickness=0.36 //x=1.175 //y=7.585 //x2=2.285 //y2=7.585
r632 (  1 25 ) resistor r=0.126608 //w=0.311 //l=0.315 //layer=m1 \
 //thickness=0.36 //x=12.7 //y=7.585 //x2=13.015 //y2=7.585
r633 (  1 22 ) resistor r=0.319534 //w=0.311 //l=0.795 //layer=m1 \
 //thickness=0.36 //x=12.7 //y=7.585 //x2=11.905 //y2=7.585
ends PM_DFFSNQNX1\%VDD

subckt PM_DFFSNQNX1\%D ( 1 2 3 4 5 6 7 18 21 25 30 34 35 36 37 38 39 40 44 46 \
 49 50 60 )
c100 ( 60 0 ) capacitor c=0.0682508f //x=1.545 //y=4.88
c101 ( 50 0 ) capacitor c=0.0318956f //x=1.88 //y=1.39
c102 ( 49 0 ) capacitor c=0.0186809f //x=1.88 //y=1.045
c103 ( 46 0 ) capacitor c=0.0141821f //x=1.725 //y=1.545
c104 ( 44 0 ) capacitor c=0.0158553f //x=1.725 //y=0.89
c105 ( 40 0 ) capacitor c=0.088055f //x=1.35 //y=2.095
c106 ( 39 0 ) capacitor c=0.0229235f //x=1.35 //y=1.7
c107 ( 38 0 ) capacitor c=0.0234359f //x=1.35 //y=1.39
c108 ( 37 0 ) capacitor c=0.0198759f //x=1.35 //y=1.045
c109 ( 36 0 ) capacitor c=0.110369f //x=1.885 //y=6.2
c110 ( 35 0 ) capacitor c=0.154619f //x=1.445 //y=6.2
c111 ( 30 0 ) capacitor c=8.13425e-19 //x=1.545 //y=4.88
c112 ( 25 0 ) capacitor c=7.85889e-19 //x=1.545 //y=2.26
c113 ( 21 0 ) capacitor c=0.0113945f //x=1.545 //y=4.88
c114 ( 18 0 ) capacitor c=0.0108617f //x=1.545 //y=2.26
c115 ( 1 0 ) capacitor c=0.103649f //x=1.545 //y=2.4
r116 (  58 60 ) resistor r=20.6867 //w=0.233 //l=0.1 //layer=ply \
 //thickness=0.18 //x=1.445 //y=4.88 //x2=1.545 //y2=4.88
r117 (  51 60 ) resistor r=70.3348 //w=0.233 //l=0.414367 //layer=ply \
 //thickness=0.18 //x=1.885 //y=5.045 //x2=1.545 //y2=4.88
r118 (  50 62 ) resistor r=45.1352 //w=0.168 //l=0.173853 //layer=ply \
 //thickness=0.18 //x=1.88 //y=1.39 //x2=1.84 //y2=1.545
r119 (  49 61 ) resistor r=45.1352 //w=0.168 //l=0.173853 //layer=ply \
 //thickness=0.18 //x=1.88 //y=1.045 //x2=1.84 //y2=0.89
r120 (  49 50 ) resistor r=176.904 //w=0.094 //l=0.345 //layer=ply \
 //thickness=0.18 //x=1.88 //y=1.045 //x2=1.88 //y2=1.39
r121 (  47 57 ) resistor r=10.701 //w=0.21 //l=0.115 //layer=ply \
 //thickness=0.18 //x=1.505 //y=1.545 //x2=1.39 //y2=1.545
r122 (  46 62 ) resistor r=5.52526 //w=0.168 //l=0.115 //layer=ply \
 //thickness=0.18 //x=1.725 //y=1.545 //x2=1.84 //y2=1.545
r123 (  45 56 ) resistor r=5.52526 //w=0.168 //l=0.115 //layer=ply \
 //thickness=0.18 //x=1.505 //y=0.89 //x2=1.39 //y2=0.89
r124 (  44 61 ) resistor r=5.52526 //w=0.168 //l=0.115 //layer=ply \
 //thickness=0.18 //x=1.725 //y=0.89 //x2=1.84 //y2=0.89
r125 (  44 45 ) resistor r=112.809 //w=0.094 //l=0.22 //layer=ply \
 //thickness=0.18 //x=1.725 //y=0.89 //x2=1.505 //y2=0.89
r126 (  41 58 ) resistor r=13.0941 //w=0.233 //l=0.165 //layer=ply \
 //thickness=0.18 //x=1.445 //y=5.045 //x2=1.445 //y2=4.88
r127 (  40 55 ) resistor r=34.8111 //w=0.27 //l=0.264953 //layer=ply \
 //thickness=0.18 //x=1.35 //y=2.095 //x2=1.545 //y2=2.26
r128 (  39 57 ) resistor r=39.5823 //w=0.21 //l=0.173853 //layer=ply \
 //thickness=0.18 //x=1.35 //y=1.7 //x2=1.39 //y2=1.545
r129 (  39 40 ) resistor r=202.543 //w=0.094 //l=0.395 //layer=ply \
 //thickness=0.18 //x=1.35 //y=1.7 //x2=1.35 //y2=2.095
r130 (  38 57 ) resistor r=39.5823 //w=0.21 //l=0.173853 //layer=ply \
 //thickness=0.18 //x=1.35 //y=1.39 //x2=1.39 //y2=1.545
r131 (  37 56 ) resistor r=45.1352 //w=0.168 //l=0.173853 //layer=ply \
 //thickness=0.18 //x=1.35 //y=1.045 //x2=1.39 //y2=0.89
r132 (  37 38 ) resistor r=176.904 //w=0.094 //l=0.345 //layer=ply \
 //thickness=0.18 //x=1.35 //y=1.045 //x2=1.35 //y2=1.39
r133 (  36 51 ) resistor r=592.245 //w=0.094 //l=1.155 //layer=ply \
 //thickness=0.18 //x=1.885 //y=6.2 //x2=1.885 //y2=5.045
r134 (  35 41 ) resistor r=592.245 //w=0.094 //l=1.155 //layer=ply \
 //thickness=0.18 //x=1.445 //y=6.2 //x2=1.445 //y2=5.045
r135 (  34 46 ) resistor r=56.4043 //w=0.094 //l=0.11 //layer=ply \
 //thickness=0.18 //x=1.615 //y=1.545 //x2=1.725 //y2=1.545
r136 (  34 47 ) resistor r=56.4043 //w=0.094 //l=0.11 //layer=ply \
 //thickness=0.18 //x=1.615 //y=1.545 //x2=1.505 //y2=1.545
r137 (  30 60 ) resistor r=152 //w=0.17 //l=0.17 //layer=licon //count=1 \
 //x=1.545 //y=4.88 //x2=1.545 //y2=4.88
r138 (  25 55 ) resistor r=152 //w=0.17 //l=0.17 //layer=licon //count=1 \
 //x=1.545 //y=2.26 //x2=1.545 //y2=2.26
r139 (  21 30 ) resistor r=9.3 //w=0.17 //l=0.17 //layer=mcon //count=1 \
 //x=1.545 //y=4.88 //x2=1.545 //y2=4.88
r140 (  21 22 ) resistor r=0.103207 //w=0.196 //l=0.14 //layer=m1 \
 //thickness=0.36 //x=1.547 //y=4.88 //x2=1.547 //y2=4.74
r141 (  18 25 ) resistor r=9.3 //w=0.17 //l=0.17 //layer=mcon //count=1 \
 //x=1.545 //y=2.26 //x2=1.545 //y2=2.26
r142 (  8 18 ) resistor r=0.0933015 //w=0.201 //l=0.125 //layer=m1 \
 //thickness=0.36 //x=1.545 //y=2.385 //x2=1.545 //y2=2.26
r143 (  7 22 ) resistor r=0.114504 //w=0.131 //l=0.12 //layer=m1 \
 //thickness=0.36 //x=1.545 //y=4.62 //x2=1.545 //y2=4.74
r144 (  6 7 ) resistor r=0.353053 //w=0.131 //l=0.37 //layer=m1 \
 //thickness=0.36 //x=1.545 //y=4.25 //x2=1.545 //y2=4.62
r145 (  5 6 ) resistor r=0.353053 //w=0.131 //l=0.37 //layer=m1 \
 //thickness=0.36 //x=1.545 //y=3.88 //x2=1.545 //y2=4.25
r146 (  4 5 ) resistor r=0.353053 //w=0.131 //l=0.37 //layer=m1 \
 //thickness=0.36 //x=1.545 //y=3.51 //x2=1.545 //y2=3.88
r147 (  3 4 ) resistor r=0.353053 //w=0.131 //l=0.37 //layer=m1 \
 //thickness=0.36 //x=1.545 //y=3.14 //x2=1.545 //y2=3.51
r148 (  2 3 ) resistor r=0.353053 //w=0.131 //l=0.37 //layer=m1 \
 //thickness=0.36 //x=1.545 //y=2.77 //x2=1.545 //y2=3.14
r149 (  1 2 ) resistor r=0.353053 //w=0.131 //l=0.37 //layer=m1 \
 //thickness=0.36 //x=1.545 //y=2.4 //x2=1.545 //y2=2.77
r150 (  1 8 ) resistor r=0.014313 //w=0.131 //l=0.015 //layer=m1 \
 //thickness=0.36 //x=1.545 //y=2.4 //x2=1.545 //y2=2.385
ends PM_DFFSNQNX1\%D

subckt PM_DFFSNQNX1\%noxref_11 ( 5 7 15 19 30 33 34 )
c69 ( 34 0 ) capacitor c=0.0457851f //x=6.73 //y=0.555
c70 ( 33 0 ) capacitor c=0.0195185f //x=5.625 //y=1.09
c71 ( 30 0 ) capacitor c=0.00141302f //x=6.865 //y=1.175
c72 ( 19 0 ) capacitor c=0.00692795f //x=7.835 //y=0.805
c73 ( 15 0 ) capacitor c=0.0154984f //x=7.75 //y=0.72
c74 ( 7 0 ) capacitor c=0.00689459f //x=6.865 //y=0.805
c75 ( 5 0 ) capacitor c=0.0243665f //x=6.78 //y=1.175
r76 (  19 34 ) resistor r=3.57586 //w=0.17 //l=0.125 //layer=li \
 //thickness=0.1 //x=7.835 //y=0.805 //x2=7.835 //y2=0.68
r77 (  19 34 ) resistor r=18.139 //w=0.187 //l=0.265 //layer=li \
 //thickness=0.1 //x=7.835 //y=0.805 //x2=7.835 //y2=1.07
r78 (  16 34 ) resistor r=3.57586 //w=0.17 //l=0.103078 //layer=li \
 //thickness=0.1 //x=6.95 //y=0.72 //x2=6.865 //y2=0.68
r79 (  16 34 ) resistor r=27.3797 //w=0.187 //l=0.4 //layer=li //thickness=0.1 \
 //x=6.95 //y=0.72 //x2=7.35 //y2=0.72
r80 (  15 34 ) resistor r=3.57586 //w=0.17 //l=0.103078 //layer=li \
 //thickness=0.1 //x=7.75 //y=0.72 //x2=7.835 //y2=0.68
r81 (  15 34 ) resistor r=27.3797 //w=0.187 //l=0.4 //layer=li //thickness=0.1 \
 //x=7.75 //y=0.72 //x2=7.35 //y2=0.72
r82 (  11 30 ) resistor r=5.4201 //w=0.17 //l=0.085 //layer=li //thickness=0.1 \
 //x=6.865 //y=1.26 //x2=6.865 //y2=1.175
r83 (  11 34 ) resistor r=10.2674 //w=0.187 //l=0.15 //layer=li \
 //thickness=0.1 //x=6.865 //y=1.26 //x2=6.865 //y2=1.41
r84 (  8 30 ) resistor r=5.4201 //w=0.17 //l=0.085 //layer=li //thickness=0.1 \
 //x=6.865 //y=1.09 //x2=6.865 //y2=1.175
r85 (  8 34 ) resistor r=1.36898 //w=0.187 //l=0.02 //layer=li //thickness=0.1 \
 //x=6.865 //y=1.09 //x2=6.865 //y2=1.07
r86 (  7 34 ) resistor r=3.57586 //w=0.17 //l=0.125 //layer=li //thickness=0.1 \
 //x=6.865 //y=0.805 //x2=6.865 //y2=0.68
r87 (  7 34 ) resistor r=18.139 //w=0.187 //l=0.265 //layer=li //thickness=0.1 \
 //x=6.865 //y=0.805 //x2=6.865 //y2=1.07
r88 (  6 33 ) resistor r=0.751729 //w=0.17 //l=0.085 //layer=li \
 //thickness=0.1 //x=5.9 //y=1.175 //x2=5.815 //y2=1.175
r89 (  5 30 ) resistor r=1.40859 //w=0.34 //l=0.085 //layer=li //thickness=0.1 \
 //x=6.78 //y=1.175 //x2=6.865 //y2=1.175
r90 (  5 6 ) resistor r=60.2353 //w=0.187 //l=0.88 //layer=li //thickness=0.1 \
 //x=6.78 //y=1.175 //x2=5.9 //y2=1.175
ends PM_DFFSNQNX1\%noxref_11

subckt PM_DFFSNQNX1\%noxref_12 ( 5 7 15 19 30 33 34 )
c70 ( 34 0 ) capacitor c=0.044206f //x=11.54 //y=0.555
c71 ( 33 0 ) capacitor c=0.0193556f //x=10.435 //y=1.09
c72 ( 30 0 ) capacitor c=0.00141302f //x=11.675 //y=1.175
c73 ( 19 0 ) capacitor c=0.00695768f //x=12.645 //y=0.805
c74 ( 15 0 ) capacitor c=0.0154882f //x=12.56 //y=0.72
c75 ( 7 0 ) capacitor c=0.00689476f //x=11.675 //y=0.805
c76 ( 5 0 ) capacitor c=0.0237752f //x=11.59 //y=1.175
r77 (  19 34 ) resistor r=3.57586 //w=0.17 //l=0.125 //layer=li \
 //thickness=0.1 //x=12.645 //y=0.805 //x2=12.645 //y2=0.68
r78 (  19 34 ) resistor r=18.139 //w=0.187 //l=0.265 //layer=li \
 //thickness=0.1 //x=12.645 //y=0.805 //x2=12.645 //y2=1.07
r79 (  16 34 ) resistor r=3.57586 //w=0.17 //l=0.103078 //layer=li \
 //thickness=0.1 //x=11.76 //y=0.72 //x2=11.675 //y2=0.68
r80 (  16 34 ) resistor r=27.3797 //w=0.187 //l=0.4 //layer=li //thickness=0.1 \
 //x=11.76 //y=0.72 //x2=12.16 //y2=0.72
r81 (  15 34 ) resistor r=3.57586 //w=0.17 //l=0.103078 //layer=li \
 //thickness=0.1 //x=12.56 //y=0.72 //x2=12.645 //y2=0.68
r82 (  15 34 ) resistor r=27.3797 //w=0.187 //l=0.4 //layer=li //thickness=0.1 \
 //x=12.56 //y=0.72 //x2=12.16 //y2=0.72
r83 (  11 30 ) resistor r=5.4201 //w=0.17 //l=0.085 //layer=li //thickness=0.1 \
 //x=11.675 //y=1.26 //x2=11.675 //y2=1.175
r84 (  11 34 ) resistor r=10.2674 //w=0.187 //l=0.15 //layer=li \
 //thickness=0.1 //x=11.675 //y=1.26 //x2=11.675 //y2=1.41
r85 (  8 30 ) resistor r=5.4201 //w=0.17 //l=0.085 //layer=li //thickness=0.1 \
 //x=11.675 //y=1.09 //x2=11.675 //y2=1.175
r86 (  8 34 ) resistor r=1.36898 //w=0.187 //l=0.02 //layer=li //thickness=0.1 \
 //x=11.675 //y=1.09 //x2=11.675 //y2=1.07
r87 (  7 34 ) resistor r=3.57586 //w=0.17 //l=0.125 //layer=li //thickness=0.1 \
 //x=11.675 //y=0.805 //x2=11.675 //y2=0.68
r88 (  7 34 ) resistor r=18.139 //w=0.187 //l=0.265 //layer=li //thickness=0.1 \
 //x=11.675 //y=0.805 //x2=11.675 //y2=1.07
r89 (  6 33 ) resistor r=0.751729 //w=0.17 //l=0.085 //layer=li \
 //thickness=0.1 //x=10.71 //y=1.175 //x2=10.625 //y2=1.175
r90 (  5 30 ) resistor r=1.40859 //w=0.34 //l=0.085 //layer=li //thickness=0.1 \
 //x=11.59 //y=1.175 //x2=11.675 //y2=1.175
r91 (  5 6 ) resistor r=60.2353 //w=0.187 //l=0.88 //layer=li //thickness=0.1 \
 //x=11.59 //y=1.175 //x2=10.71 //y2=1.175
ends PM_DFFSNQNX1\%noxref_12

subckt PM_DFFSNQNX1\%GND ( 1 2 8 15 16 25 26 37 45 54 61 64 65 69 74 79 80 85 \
 86 90 95 98 110 127 144 157 181 191 192 193 194 195 197 198 199 200 201 202 )
c468 ( 202 0 ) capacitor c=0.00840423f //x=20.93 //y=1.055
c469 ( 201 0 ) capacitor c=0.00843555f //x=17.705 //y=1.045
c470 ( 200 0 ) capacitor c=0.00843555f //x=14.375 //y=1.045
c471 ( 199 0 ) capacitor c=0.00840423f //x=9.46 //y=1.055
c472 ( 198 0 ) capacitor c=0.00840423f //x=4.65 //y=1.055
c473 ( 197 0 ) capacitor c=0.00843555f //x=1.425 //y=1.045
c474 ( 195 0 ) capacitor c=0.112855f //x=20.045 //y=0.175
c475 ( 194 0 ) capacitor c=0.117968f //x=16.715 //y=0.175
c476 ( 193 0 ) capacitor c=0.113332f //x=13.385 //y=0.175
c477 ( 192 0 ) capacitor c=0.112214f //x=8.575 //y=0.175
c478 ( 191 0 ) capacitor c=0.107815f //x=3.765 //y=0.175
c479 ( 181 0 ) capacitor c=0.391528f //x=24.115 //y=0.18
c480 ( 157 0 ) capacitor c=0.118923f //x=19.875 //y=0.175
c481 ( 144 0 ) capacitor c=0.118923f //x=16.545 //y=0.175
c482 ( 127 0 ) capacitor c=0.179219f //x=13.215 //y=0.175
c483 ( 110 0 ) capacitor c=0.181344f //x=8.405 //y=0.175
c484 ( 98 0 ) capacitor c=0.198574f //x=1.175 //y=0.18
c485 ( 95 0 ) capacitor c=0.12525f //x=3.595 //y=0.175
c486 ( 92 0 ) capacitor c=0.00509414f //x=21.12 //y=0.175
c487 ( 90 0 ) capacitor c=0.0125123f //x=21.12 //y=1.145
c488 ( 88 0 ) capacitor c=0.00509083f //x=17.895 //y=0.175
c489 ( 86 0 ) capacitor c=0.0187613f //x=17.892 //y=1.005
c490 ( 85 0 ) capacitor c=0.0124186f //x=17.895 //y=1.135
c491 ( 83 0 ) capacitor c=0.00509083f //x=14.495 //y=0.18
c492 ( 80 0 ) capacitor c=0.0235363f //x=14.562 //y=1.005
c493 ( 79 0 ) capacitor c=0.0134704f //x=14.565 //y=1.135
c494 ( 77 0 ) capacitor c=0.00509414f //x=9.685 //y=0.18
c495 ( 74 0 ) capacitor c=0.0140803f //x=9.65 //y=1.145
c496 ( 72 0 ) capacitor c=0.00509414f //x=4.875 //y=0.18
c497 ( 69 0 ) capacitor c=0.0133083f //x=4.84 //y=1.145
c498 ( 67 0 ) capacitor c=0.00509083f //x=1.615 //y=0.175
c499 ( 65 0 ) capacitor c=0.0234055f //x=1.612 //y=1.005
c500 ( 64 0 ) capacitor c=0.0161529f //x=1.615 //y=1.135
c501 ( 61 0 ) capacitor c=0.148844f //x=24.115 //y=0.18
c502 ( 54 0 ) capacitor c=0.0253397f //x=21.12 //y=1.015
c503 ( 45 0 ) capacitor c=0.105233f //x=21.035 //y=0.175
c504 ( 37 0 ) capacitor c=0.112206f //x=17.81 //y=0.175
c505 ( 26 0 ) capacitor c=0.154224f //x=14.48 //y=0.175
c506 ( 25 0 ) capacitor c=0.0302305f //x=9.65 //y=1.015
c507 ( 16 0 ) capacitor c=0.149617f //x=9.565 //y=0.175
c508 ( 15 0 ) capacitor c=0.0253397f //x=4.84 //y=1.015
c509 ( 8 0 ) capacitor c=0.105216f //x=4.755 //y=0.175
c510 ( 2 0 ) capacitor c=0.0734614f //x=1.53 //y=0.175
r511 (  179 181 ) resistor r=38.7139 //w=0.367 //l=1.11 //layer=li \
 //thickness=0.1 //x=23.005 //y=0.175 //x2=24.115 //y2=0.175
r512 (  177 179 ) resistor r=38.7139 //w=0.367 //l=1.11 //layer=li \
 //thickness=0.1 //x=21.895 //y=0.175 //x2=23.005 //y2=0.175
r513 (  175 177 ) resistor r=38.7139 //w=0.367 //l=1.11 //layer=li \
 //thickness=0.1 //x=20.785 //y=0.175 //x2=21.895 //y2=0.175
r514 (  173 195 ) resistor r=5.29055 //w=0.35 //l=0.17 //layer=li \
 //thickness=0.1 //x=20.215 //y=0.175 //x2=20.045 //y2=0.175
r515 (  173 175 ) resistor r=19.8801 //w=0.367 //l=0.57 //layer=li \
 //thickness=0.1 //x=20.215 //y=0.175 //x2=20.785 //y2=0.175
r516 (  162 164 ) resistor r=38.7139 //w=0.367 //l=1.11 //layer=li \
 //thickness=0.1 //x=18.195 //y=0.175 //x2=19.305 //y2=0.175
r517 (  160 162 ) resistor r=38.7139 //w=0.367 //l=1.11 //layer=li \
 //thickness=0.1 //x=17.085 //y=0.175 //x2=18.195 //y2=0.175
r518 (  158 194 ) resistor r=5.29055 //w=0.35 //l=0.17 //layer=li \
 //thickness=0.1 //x=16.885 //y=0.175 //x2=16.715 //y2=0.175
r519 (  158 160 ) resistor r=6.97548 //w=0.367 //l=0.2 //layer=li \
 //thickness=0.1 //x=16.885 //y=0.175 //x2=17.085 //y2=0.175
r520 (  157 195 ) resistor r=5.29055 //w=0.35 //l=0.17 //layer=li \
 //thickness=0.1 //x=19.875 //y=0.175 //x2=20.045 //y2=0.175
r521 (  157 164 ) resistor r=19.8801 //w=0.367 //l=0.57 //layer=li \
 //thickness=0.1 //x=19.875 //y=0.175 //x2=19.305 //y2=0.175
r522 (  147 149 ) resistor r=38.7139 //w=0.367 //l=1.11 //layer=li \
 //thickness=0.1 //x=14.495 //y=0.175 //x2=15.605 //y2=0.175
r523 (  145 193 ) resistor r=5.29055 //w=0.35 //l=0.17 //layer=li \
 //thickness=0.1 //x=13.555 //y=0.175 //x2=13.385 //y2=0.175
r524 (  145 147 ) resistor r=32.7847 //w=0.367 //l=0.94 //layer=li \
 //thickness=0.1 //x=13.555 //y=0.175 //x2=14.495 //y2=0.175
r525 (  144 194 ) resistor r=5.29055 //w=0.35 //l=0.17 //layer=li \
 //thickness=0.1 //x=16.545 //y=0.175 //x2=16.715 //y2=0.175
r526 (  144 149 ) resistor r=32.7847 //w=0.367 //l=0.94 //layer=li \
 //thickness=0.1 //x=16.545 //y=0.175 //x2=15.605 //y2=0.175
r527 (  134 136 ) resistor r=38.7139 //w=0.367 //l=1.11 //layer=li \
 //thickness=0.1 //x=11.905 //y=0.175 //x2=13.015 //y2=0.175
r528 (  132 134 ) resistor r=38.7139 //w=0.367 //l=1.11 //layer=li \
 //thickness=0.1 //x=10.795 //y=0.175 //x2=11.905 //y2=0.175
r529 (  130 132 ) resistor r=38.7139 //w=0.367 //l=1.11 //layer=li \
 //thickness=0.1 //x=9.685 //y=0.175 //x2=10.795 //y2=0.175
r530 (  128 192 ) resistor r=5.29055 //w=0.35 //l=0.17 //layer=li \
 //thickness=0.1 //x=8.745 //y=0.175 //x2=8.575 //y2=0.175
r531 (  128 130 ) resistor r=32.7847 //w=0.367 //l=0.94 //layer=li \
 //thickness=0.1 //x=8.745 //y=0.175 //x2=9.685 //y2=0.175
r532 (  127 193 ) resistor r=5.29055 //w=0.35 //l=0.17 //layer=li \
 //thickness=0.1 //x=13.215 //y=0.175 //x2=13.385 //y2=0.175
r533 (  127 136 ) resistor r=6.97548 //w=0.367 //l=0.2 //layer=li \
 //thickness=0.1 //x=13.215 //y=0.175 //x2=13.015 //y2=0.175
r534 (  117 119 ) resistor r=38.7139 //w=0.367 //l=1.11 //layer=li \
 //thickness=0.1 //x=7.095 //y=0.175 //x2=8.205 //y2=0.175
r535 (  115 117 ) resistor r=38.7139 //w=0.367 //l=1.11 //layer=li \
 //thickness=0.1 //x=5.985 //y=0.175 //x2=7.095 //y2=0.175
r536 (  113 115 ) resistor r=38.7139 //w=0.367 //l=1.11 //layer=li \
 //thickness=0.1 //x=4.875 //y=0.175 //x2=5.985 //y2=0.175
r537 (  111 191 ) resistor r=5.29055 //w=0.35 //l=0.17 //layer=li \
 //thickness=0.1 //x=3.935 //y=0.175 //x2=3.765 //y2=0.175
r538 (  111 113 ) resistor r=32.7847 //w=0.367 //l=0.94 //layer=li \
 //thickness=0.1 //x=3.935 //y=0.175 //x2=4.875 //y2=0.175
r539 (  110 192 ) resistor r=5.29055 //w=0.35 //l=0.17 //layer=li \
 //thickness=0.1 //x=8.405 //y=0.175 //x2=8.575 //y2=0.175
r540 (  110 119 ) resistor r=6.97548 //w=0.367 //l=0.2 //layer=li \
 //thickness=0.1 //x=8.405 //y=0.175 //x2=8.205 //y2=0.175
r541 (  100 102 ) resistor r=38.7139 //w=0.367 //l=1.11 //layer=li \
 //thickness=0.1 //x=2.285 //y=0.175 //x2=3.395 //y2=0.175
r542 (  98 100 ) resistor r=38.7139 //w=0.367 //l=1.11 //layer=li \
 //thickness=0.1 //x=1.175 //y=0.175 //x2=2.285 //y2=0.175
r543 (  95 191 ) resistor r=5.29055 //w=0.35 //l=0.17 //layer=li \
 //thickness=0.1 //x=3.595 //y=0.175 //x2=3.765 //y2=0.175
r544 (  95 102 ) resistor r=6.97548 //w=0.367 //l=0.2 //layer=li \
 //thickness=0.1 //x=3.595 //y=0.175 //x2=3.395 //y2=0.175
r545 (  90 202 ) resistor r=9.3 //w=0.17 //l=0.17 //layer=mcon //count=1 \
 //x=21.12 //y=1.145 //x2=21.12 //y2=1.145
r546 (  85 201 ) resistor r=9.3 //w=0.17 //l=0.17 //layer=mcon //count=1 \
 //x=17.895 //y=1.135 //x2=17.895 //y2=1.135
r547 (  85 86 ) resistor r=0.0939994 //w=0.226 //l=0.13 //layer=m1 \
 //thickness=0.36 //x=17.892 //y=1.135 //x2=17.892 //y2=1.005
r548 (  83 147 ) resistor r=3.1 //w=0.17 //l=0.51 //layer=mcon //count=3 \
 //x=14.495 //y=0.18 //x2=14.495 //y2=0.18
r549 (  79 200 ) resistor r=9.3 //w=0.17 //l=0.17 //layer=mcon //count=1 \
 //x=14.565 //y=1.135 //x2=14.565 //y2=1.135
r550 (  79 80 ) resistor r=0.0939994 //w=0.226 //l=0.13 //layer=m1 \
 //thickness=0.36 //x=14.562 //y=1.135 //x2=14.562 //y2=1.005
r551 (  77 130 ) resistor r=3.1 //w=0.17 //l=0.51 //layer=mcon //count=3 \
 //x=9.685 //y=0.18 //x2=9.685 //y2=0.18
r552 (  74 199 ) resistor r=9.3 //w=0.17 //l=0.17 //layer=mcon //count=1 \
 //x=9.65 //y=1.145 //x2=9.65 //y2=1.145
r553 (  72 113 ) resistor r=3.1 //w=0.17 //l=0.51 //layer=mcon //count=3 \
 //x=4.875 //y=0.18 //x2=4.875 //y2=0.18
r554 (  69 198 ) resistor r=9.3 //w=0.17 //l=0.17 //layer=mcon //count=1 \
 //x=4.84 //y=1.145 //x2=4.84 //y2=1.145
r555 (  64 197 ) resistor r=9.3 //w=0.17 //l=0.17 //layer=mcon //count=1 \
 //x=1.615 //y=1.135 //x2=1.615 //y2=1.135
r556 (  64 65 ) resistor r=0.0939994 //w=0.226 //l=0.13 //layer=m1 \
 //thickness=0.36 //x=1.612 //y=1.135 //x2=1.612 //y2=1.005
r557 (  61 181 ) resistor r=3.1 //w=0.17 //l=0.51 //layer=mcon //count=3 \
 //x=24.115 //y=0.18 //x2=24.115 //y2=0.18
r558 (  59 179 ) resistor r=3.1 //w=0.17 //l=0.51 //layer=mcon //count=3 \
 //x=23.005 //y=0.18 //x2=23.005 //y2=0.18
r559 (  59 61 ) resistor r=0.446141 //w=0.311 //l=1.11 //layer=m1 \
 //thickness=0.36 //x=23.005 //y=0.175 //x2=24.115 //y2=0.175
r560 (  57 177 ) resistor r=3.1 //w=0.17 //l=0.51 //layer=mcon //count=3 \
 //x=21.895 //y=0.18 //x2=21.895 //y2=0.18
r561 (  57 59 ) resistor r=0.446141 //w=0.311 //l=1.11 //layer=m1 \
 //thickness=0.36 //x=21.895 //y=0.175 //x2=23.005 //y2=0.175
r562 (  55 92 ) resistor r=0.028033 //w=0.35 //l=0.085 //layer=m1 \
 //thickness=0.36 //x=21.205 //y=0.175 //x2=21.12 //y2=0.175
r563 (  55 57 ) resistor r=0.277331 //w=0.311 //l=0.69 //layer=m1 \
 //thickness=0.36 //x=21.205 //y=0.175 //x2=21.895 //y2=0.175
r564 (  54 90 ) resistor r=0.0942778 //w=0.221 //l=0.13 //layer=m1 \
 //thickness=0.36 //x=21.12 //y=1.015 //x2=21.12 //y2=1.145
r565 (  53 92 ) resistor r=0.0413265 //w=0.7 //l=0.175 //layer=m1 \
 //thickness=0.36 //x=21.12 //y=0.35 //x2=21.12 //y2=0.175
r566 (  53 54 ) resistor r=0.634542 //w=0.131 //l=0.665 //layer=m1 \
 //thickness=0.36 //x=21.12 //y=0.35 //x2=21.12 //y2=1.015
r567 (  52 175 ) resistor r=3.1 //w=0.17 //l=0.51 //layer=mcon //count=3 \
 //x=20.785 //y=0.18 //x2=20.785 //y2=0.18
r568 (  50 164 ) resistor r=3.1 //w=0.17 //l=0.51 //layer=mcon //count=3 \
 //x=19.305 //y=0.18 //x2=19.305 //y2=0.18
r569 (  50 52 ) resistor r=0.594855 //w=0.311 //l=1.48 //layer=m1 \
 //thickness=0.36 //x=19.305 //y=0.175 //x2=20.785 //y2=0.175
r570 (  48 162 ) resistor r=3.1 //w=0.17 //l=0.51 //layer=mcon //count=3 \
 //x=18.195 //y=0.18 //x2=18.195 //y2=0.18
r571 (  48 50 ) resistor r=0.446141 //w=0.311 //l=1.11 //layer=m1 \
 //thickness=0.36 //x=18.195 //y=0.175 //x2=19.305 //y2=0.175
r572 (  46 88 ) resistor r=0.028033 //w=0.35 //l=0.085 //layer=m1 \
 //thickness=0.36 //x=17.98 //y=0.175 //x2=17.895 //y2=0.175
r573 (  46 48 ) resistor r=0.0864148 //w=0.311 //l=0.215 //layer=m1 \
 //thickness=0.36 //x=17.98 //y=0.175 //x2=18.195 //y2=0.175
r574 (  45 92 ) resistor r=0.028033 //w=0.35 //l=0.085 //layer=m1 \
 //thickness=0.36 //x=21.035 //y=0.175 //x2=21.12 //y2=0.175
r575 (  45 52 ) resistor r=0.100482 //w=0.311 //l=0.25 //layer=m1 \
 //thickness=0.36 //x=21.035 //y=0.175 //x2=20.785 //y2=0.175
r576 (  43 88 ) resistor r=0.0413265 //w=0.7 //l=0.175 //layer=m1 \
 //thickness=0.36 //x=17.895 //y=0.35 //x2=17.895 //y2=0.175
r577 (  43 86 ) resistor r=0.625 //w=0.131 //l=0.655 //layer=m1 \
 //thickness=0.36 //x=17.895 //y=0.35 //x2=17.895 //y2=1.005
r578 (  42 160 ) resistor r=3.1 //w=0.17 //l=0.51 //layer=mcon //count=3 \
 //x=17.085 //y=0.18 //x2=17.085 //y2=0.18
r579 (  40 149 ) resistor r=3.1 //w=0.17 //l=0.51 //layer=mcon //count=3 \
 //x=15.605 //y=0.18 //x2=15.605 //y2=0.18
r580 (  40 42 ) resistor r=0.594855 //w=0.311 //l=1.48 //layer=m1 \
 //thickness=0.36 //x=15.605 //y=0.175 //x2=17.085 //y2=0.175
r581 (  38 83 ) resistor r=0.028033 //w=0.35 //l=0.085 //layer=m1 \
 //thickness=0.36 //x=14.65 //y=0.175 //x2=14.565 //y2=0.175
r582 (  38 40 ) resistor r=0.383842 //w=0.311 //l=0.955 //layer=m1 \
 //thickness=0.36 //x=14.65 //y=0.175 //x2=15.605 //y2=0.175
r583 (  37 88 ) resistor r=0.028033 //w=0.35 //l=0.085 //layer=m1 \
 //thickness=0.36 //x=17.81 //y=0.175 //x2=17.895 //y2=0.175
r584 (  37 42 ) resistor r=0.291399 //w=0.311 //l=0.725 //layer=m1 \
 //thickness=0.36 //x=17.81 //y=0.175 //x2=17.085 //y2=0.175
r585 (  35 83 ) resistor r=0.0413265 //w=0.7 //l=0.175 //layer=m1 \
 //thickness=0.36 //x=14.565 //y=0.35 //x2=14.565 //y2=0.175
r586 (  35 80 ) resistor r=0.625 //w=0.131 //l=0.655 //layer=m1 \
 //thickness=0.36 //x=14.565 //y=0.35 //x2=14.565 //y2=1.005
r587 (  34 136 ) resistor r=3.1 //w=0.17 //l=0.51 //layer=mcon //count=3 \
 //x=13.015 //y=0.18 //x2=13.015 //y2=0.18
r588 (  31 134 ) resistor r=3.1 //w=0.17 //l=0.51 //layer=mcon //count=3 \
 //x=11.905 //y=0.18 //x2=11.905 //y2=0.18
r589 (  29 132 ) resistor r=3.1 //w=0.17 //l=0.51 //layer=mcon //count=3 \
 //x=10.795 //y=0.18 //x2=10.795 //y2=0.18
r590 (  29 31 ) resistor r=0.446141 //w=0.311 //l=1.11 //layer=m1 \
 //thickness=0.36 //x=10.795 //y=0.175 //x2=11.905 //y2=0.175
r591 (  27 77 ) resistor r=0.028033 //w=0.35 //l=0.085 //layer=m1 \
 //thickness=0.36 //x=9.735 //y=0.175 //x2=9.65 //y2=0.175
r592 (  27 29 ) resistor r=0.426045 //w=0.311 //l=1.06 //layer=m1 \
 //thickness=0.36 //x=9.735 //y=0.175 //x2=10.795 //y2=0.175
r593 (  26 83 ) resistor r=0.028033 //w=0.35 //l=0.085 //layer=m1 \
 //thickness=0.36 //x=14.48 //y=0.175 //x2=14.565 //y2=0.175
r594 (  26 34 ) resistor r=0.588826 //w=0.311 //l=1.465 //layer=m1 \
 //thickness=0.36 //x=14.48 //y=0.175 //x2=13.015 //y2=0.175
r595 (  25 74 ) resistor r=0.0942778 //w=0.221 //l=0.13 //layer=m1 \
 //thickness=0.36 //x=9.65 //y=1.015 //x2=9.65 //y2=1.145
r596 (  24 77 ) resistor r=0.0413265 //w=0.7 //l=0.175 //layer=m1 \
 //thickness=0.36 //x=9.65 //y=0.35 //x2=9.65 //y2=0.175
r597 (  24 25 ) resistor r=0.634542 //w=0.131 //l=0.665 //layer=m1 \
 //thickness=0.36 //x=9.65 //y=0.35 //x2=9.65 //y2=1.015
r598 (  23 119 ) resistor r=3.1 //w=0.17 //l=0.51 //layer=mcon //count=3 \
 //x=8.205 //y=0.18 //x2=8.205 //y2=0.18
r599 (  21 117 ) resistor r=3.1 //w=0.17 //l=0.51 //layer=mcon //count=3 \
 //x=7.095 //y=0.18 //x2=7.095 //y2=0.18
r600 (  21 23 ) resistor r=0.446141 //w=0.311 //l=1.11 //layer=m1 \
 //thickness=0.36 //x=7.095 //y=0.175 //x2=8.205 //y2=0.175
r601 (  19 115 ) resistor r=3.1 //w=0.17 //l=0.51 //layer=mcon //count=3 \
 //x=5.985 //y=0.18 //x2=5.985 //y2=0.18
r602 (  19 21 ) resistor r=0.446141 //w=0.311 //l=1.11 //layer=m1 \
 //thickness=0.36 //x=5.985 //y=0.175 //x2=7.095 //y2=0.175
r603 (  17 72 ) resistor r=0.028033 //w=0.35 //l=0.085 //layer=m1 \
 //thickness=0.36 //x=4.925 //y=0.175 //x2=4.84 //y2=0.175
r604 (  17 19 ) resistor r=0.426045 //w=0.311 //l=1.06 //layer=m1 \
 //thickness=0.36 //x=4.925 //y=0.175 //x2=5.985 //y2=0.175
r605 (  16 77 ) resistor r=0.028033 //w=0.35 //l=0.085 //layer=m1 \
 //thickness=0.36 //x=9.565 //y=0.175 //x2=9.65 //y2=0.175
r606 (  16 23 ) resistor r=0.546624 //w=0.311 //l=1.36 //layer=m1 \
 //thickness=0.36 //x=9.565 //y=0.175 //x2=8.205 //y2=0.175
r607 (  15 69 ) resistor r=0.0942778 //w=0.221 //l=0.13 //layer=m1 \
 //thickness=0.36 //x=4.84 //y=1.015 //x2=4.84 //y2=1.145
r608 (  14 72 ) resistor r=0.0413265 //w=0.7 //l=0.175 //layer=m1 \
 //thickness=0.36 //x=4.84 //y=0.35 //x2=4.84 //y2=0.175
r609 (  14 15 ) resistor r=0.634542 //w=0.131 //l=0.665 //layer=m1 \
 //thickness=0.36 //x=4.84 //y=0.35 //x2=4.84 //y2=1.015
r610 (  13 102 ) resistor r=3.1 //w=0.17 //l=0.51 //layer=mcon //count=3 \
 //x=3.395 //y=0.18 //x2=3.395 //y2=0.18
r611 (  11 100 ) resistor r=3.1 //w=0.17 //l=0.51 //layer=mcon //count=3 \
 //x=2.285 //y=0.18 //x2=2.285 //y2=0.18
r612 (  11 13 ) resistor r=0.446141 //w=0.311 //l=1.11 //layer=m1 \
 //thickness=0.36 //x=2.285 //y=0.175 //x2=3.395 //y2=0.175
r613 (  9 67 ) resistor r=0.028033 //w=0.35 //l=0.085 //layer=m1 \
 //thickness=0.36 //x=1.7 //y=0.175 //x2=1.615 //y2=0.175
r614 (  9 11 ) resistor r=0.235129 //w=0.311 //l=0.585 //layer=m1 \
 //thickness=0.36 //x=1.7 //y=0.175 //x2=2.285 //y2=0.175
r615 (  8 72 ) resistor r=0.028033 //w=0.35 //l=0.085 //layer=m1 \
 //thickness=0.36 //x=4.755 //y=0.175 //x2=4.84 //y2=0.175
r616 (  8 13 ) resistor r=0.546624 //w=0.311 //l=1.36 //layer=m1 \
 //thickness=0.36 //x=4.755 //y=0.175 //x2=3.395 //y2=0.175
r617 (  6 67 ) resistor r=0.0413265 //w=0.7 //l=0.175 //layer=m1 \
 //thickness=0.36 //x=1.615 //y=0.35 //x2=1.615 //y2=0.175
r618 (  6 65 ) resistor r=0.625 //w=0.131 //l=0.655 //layer=m1 \
 //thickness=0.36 //x=1.615 //y=0.35 //x2=1.615 //y2=1.005
r619 (  4 98 ) resistor r=3.1 //w=0.17 //l=0.51 //layer=mcon //count=3 \
 //x=1.175 //y=0.18 //x2=1.175 //y2=0.18
r620 (  2 67 ) resistor r=0.028033 //w=0.35 //l=0.085 //layer=m1 \
 //thickness=0.36 //x=1.53 //y=0.175 //x2=1.615 //y2=0.175
r621 (  2 4 ) resistor r=0.142685 //w=0.311 //l=0.355 //layer=m1 \
 //thickness=0.36 //x=1.53 //y=0.175 //x2=1.175 //y2=0.175
r622 (  1 34 ) resistor r=0.126608 //w=0.311 //l=0.315 //layer=m1 \
 //thickness=0.36 //x=12.7 //y=0.175 //x2=13.015 //y2=0.175
r623 (  1 31 ) resistor r=0.319534 //w=0.311 //l=0.795 //layer=m1 \
 //thickness=0.36 //x=12.7 //y=0.175 //x2=11.905 //y2=0.175
ends PM_DFFSNQNX1\%GND

subckt PM_DFFSNQNX1\%noxref_14 ( 5 7 15 19 30 33 34 )
c64 ( 34 0 ) capacitor c=0.0463124f //x=23.01 //y=0.555
c65 ( 33 0 ) capacitor c=0.0189324f //x=21.905 //y=1.09
c66 ( 30 0 ) capacitor c=0.00141302f //x=23.145 //y=1.175
c67 ( 19 0 ) capacitor c=0.00745448f //x=24.115 //y=0.805
c68 ( 15 0 ) capacitor c=0.015487f //x=24.03 //y=0.72
c69 ( 7 0 ) capacitor c=0.00681713f //x=23.145 //y=0.805
c70 ( 5 0 ) capacitor c=0.0288646f //x=23.06 //y=1.175
r71 (  19 34 ) resistor r=3.57586 //w=0.17 //l=0.125 //layer=li \
 //thickness=0.1 //x=24.115 //y=0.805 //x2=24.115 //y2=0.68
r72 (  19 34 ) resistor r=18.139 //w=0.187 //l=0.265 //layer=li \
 //thickness=0.1 //x=24.115 //y=0.805 //x2=24.115 //y2=1.07
r73 (  16 34 ) resistor r=3.57586 //w=0.17 //l=0.103078 //layer=li \
 //thickness=0.1 //x=23.23 //y=0.72 //x2=23.145 //y2=0.68
r74 (  16 34 ) resistor r=27.3797 //w=0.187 //l=0.4 //layer=li //thickness=0.1 \
 //x=23.23 //y=0.72 //x2=23.63 //y2=0.72
r75 (  15 34 ) resistor r=3.57586 //w=0.17 //l=0.103078 //layer=li \
 //thickness=0.1 //x=24.03 //y=0.72 //x2=24.115 //y2=0.68
r76 (  15 34 ) resistor r=27.3797 //w=0.187 //l=0.4 //layer=li //thickness=0.1 \
 //x=24.03 //y=0.72 //x2=23.63 //y2=0.72
r77 (  11 30 ) resistor r=5.4201 //w=0.17 //l=0.085 //layer=li //thickness=0.1 \
 //x=23.145 //y=1.26 //x2=23.145 //y2=1.175
r78 (  11 34 ) resistor r=10.2674 //w=0.187 //l=0.15 //layer=li \
 //thickness=0.1 //x=23.145 //y=1.26 //x2=23.145 //y2=1.41
r79 (  8 30 ) resistor r=5.4201 //w=0.17 //l=0.085 //layer=li //thickness=0.1 \
 //x=23.145 //y=1.09 //x2=23.145 //y2=1.175
r80 (  8 34 ) resistor r=1.36898 //w=0.187 //l=0.02 //layer=li //thickness=0.1 \
 //x=23.145 //y=1.09 //x2=23.145 //y2=1.07
r81 (  7 34 ) resistor r=3.57586 //w=0.17 //l=0.125 //layer=li //thickness=0.1 \
 //x=23.145 //y=0.805 //x2=23.145 //y2=0.68
r82 (  7 34 ) resistor r=18.139 //w=0.187 //l=0.265 //layer=li //thickness=0.1 \
 //x=23.145 //y=0.805 //x2=23.145 //y2=1.07
r83 (  6 33 ) resistor r=0.751729 //w=0.17 //l=0.085 //layer=li \
 //thickness=0.1 //x=22.18 //y=1.175 //x2=22.095 //y2=1.175
r84 (  5 30 ) resistor r=1.40859 //w=0.34 //l=0.085 //layer=li //thickness=0.1 \
 //x=23.06 //y=1.175 //x2=23.145 //y2=1.175
r85 (  5 6 ) resistor r=60.2353 //w=0.187 //l=0.88 //layer=li //thickness=0.1 \
 //x=23.06 //y=1.175 //x2=22.18 //y2=1.175
ends PM_DFFSNQNX1\%noxref_14

subckt PM_DFFSNQNX1\%noxref_15 ( 1 5 9 10 13 17 29 )
c60 ( 29 0 ) capacitor c=0.0672418f //x=0.995 //y=0.545
c61 ( 17 0 ) capacitor c=0.00675704f //x=3.07 //y=0.795
c62 ( 13 0 ) capacitor c=0.0157477f //x=2.985 //y=0.71
c63 ( 10 0 ) capacitor c=0.0091713f //x=2.1 //y=1.675
c64 ( 9 0 ) capacitor c=0.00770028f //x=2.1 //y=0.795
c65 ( 5 0 ) capacitor c=0.0246013f //x=2.015 //y=1.76
c66 ( 1 0 ) capacitor c=0.0115037f //x=1.13 //y=1.675
r67 (  17 29 ) resistor r=3.57586 //w=0.17 //l=0.125 //layer=li \
 //thickness=0.1 //x=3.07 //y=0.795 //x2=3.07 //y2=0.67
r68 (  17 29 ) resistor r=18.139 //w=0.187 //l=0.265 //layer=li \
 //thickness=0.1 //x=3.07 //y=0.795 //x2=3.07 //y2=1.06
r69 (  14 29 ) resistor r=3.57586 //w=0.17 //l=0.103078 //layer=li \
 //thickness=0.1 //x=2.185 //y=0.71 //x2=2.1 //y2=0.67
r70 (  14 29 ) resistor r=27.3797 //w=0.187 //l=0.4 //layer=li //thickness=0.1 \
 //x=2.185 //y=0.71 //x2=2.585 //y2=0.71
r71 (  13 29 ) resistor r=3.57586 //w=0.17 //l=0.103078 //layer=li \
 //thickness=0.1 //x=2.985 //y=0.71 //x2=3.07 //y2=0.67
r72 (  13 29 ) resistor r=27.3797 //w=0.187 //l=0.4 //layer=li //thickness=0.1 \
 //x=2.985 //y=0.71 //x2=2.585 //y2=0.71
r73 (  10 29 ) resistor r=3.57586 //w=0.17 //l=0.125 //layer=li \
 //thickness=0.1 //x=2.1 //y=1.675 //x2=2.1 //y2=1.8
r74 (  10 29 ) resistor r=42.0963 //w=0.187 //l=0.615 //layer=li \
 //thickness=0.1 //x=2.1 //y=1.675 //x2=2.1 //y2=1.06
r75 (  9 29 ) resistor r=3.57586 //w=0.17 //l=0.125 //layer=li //thickness=0.1 \
 //x=2.1 //y=0.795 //x2=2.1 //y2=0.67
r76 (  9 29 ) resistor r=18.139 //w=0.187 //l=0.265 //layer=li //thickness=0.1 \
 //x=2.1 //y=0.795 //x2=2.1 //y2=1.06
r77 (  6 29 ) resistor r=3.57586 //w=0.17 //l=0.103078 //layer=li \
 //thickness=0.1 //x=1.215 //y=1.76 //x2=1.13 //y2=1.8
r78 (  6 29 ) resistor r=27.3797 //w=0.187 //l=0.4 //layer=li //thickness=0.1 \
 //x=1.215 //y=1.76 //x2=1.615 //y2=1.76
r79 (  5 29 ) resistor r=3.57586 //w=0.17 //l=0.103078 //layer=li \
 //thickness=0.1 //x=2.015 //y=1.76 //x2=2.1 //y2=1.8
r80 (  5 29 ) resistor r=27.3797 //w=0.187 //l=0.4 //layer=li //thickness=0.1 \
 //x=2.015 //y=1.76 //x2=1.615 //y2=1.76
r81 (  1 29 ) resistor r=3.57586 //w=0.17 //l=0.125 //layer=li //thickness=0.1 \
 //x=1.13 //y=1.675 //x2=1.13 //y2=1.8
r82 (  1 29 ) resistor r=42.0963 //w=0.187 //l=0.615 //layer=li \
 //thickness=0.1 //x=1.13 //y=1.675 //x2=1.13 //y2=1.06
ends PM_DFFSNQNX1\%noxref_15

subckt PM_DFFSNQNX1\%noxref_16 ( 1 5 9 13 17 35 )
c60 ( 35 0 ) capacitor c=0.0691972f //x=4.22 //y=0.555
c61 ( 17 0 ) capacitor c=0.0195855f //x=6.21 //y=1.77
c62 ( 13 0 ) capacitor c=0.015342f //x=6.21 //y=0.72
c63 ( 9 0 ) capacitor c=0.00772076f //x=5.325 //y=0.805
c64 ( 5 0 ) capacitor c=0.0168722f //x=5.24 //y=1.77
c65 ( 1 0 ) capacitor c=0.00726193f //x=4.355 //y=1.685
r66 (  18 35 ) resistor r=5.4201 //w=0.17 //l=0.103078 //layer=li \
 //thickness=0.1 //x=5.41 //y=1.77 //x2=5.325 //y2=1.81
r67 (  18 35 ) resistor r=27.3797 //w=0.187 //l=0.4 //layer=li //thickness=0.1 \
 //x=5.41 //y=1.77 //x2=5.81 //y2=1.77
r68 (  17 35 ) resistor r=0.751729 //w=0.17 //l=0.085 //layer=li \
 //thickness=0.1 //x=6.21 //y=1.77 //x2=6.295 //y2=1.77
r69 (  17 35 ) resistor r=27.3797 //w=0.187 //l=0.4 //layer=li //thickness=0.1 \
 //x=6.21 //y=1.77 //x2=5.81 //y2=1.77
r70 (  14 35 ) resistor r=3.57586 //w=0.17 //l=0.103078 //layer=li \
 //thickness=0.1 //x=5.41 //y=0.72 //x2=5.325 //y2=0.68
r71 (  14 35 ) resistor r=27.3797 //w=0.187 //l=0.4 //layer=li //thickness=0.1 \
 //x=5.41 //y=0.72 //x2=5.81 //y2=0.72
r72 (  13 35 ) resistor r=0.751729 //w=0.17 //l=0.085 //layer=li \
 //thickness=0.1 //x=6.21 //y=0.72 //x2=6.295 //y2=0.72
r73 (  13 35 ) resistor r=27.3797 //w=0.187 //l=0.4 //layer=li //thickness=0.1 \
 //x=6.21 //y=0.72 //x2=5.81 //y2=0.72
r74 (  10 35 ) resistor r=1.40859 //w=0.34 //l=0.125 //layer=li \
 //thickness=0.1 //x=5.325 //y=1.685 //x2=5.325 //y2=1.81
r75 (  10 35 ) resistor r=42.0963 //w=0.187 //l=0.615 //layer=li \
 //thickness=0.1 //x=5.325 //y=1.685 //x2=5.325 //y2=1.07
r76 (  9 35 ) resistor r=3.57586 //w=0.17 //l=0.125 //layer=li //thickness=0.1 \
 //x=5.325 //y=0.805 //x2=5.325 //y2=0.68
r77 (  9 35 ) resistor r=18.139 //w=0.187 //l=0.265 //layer=li //thickness=0.1 \
 //x=5.325 //y=0.805 //x2=5.325 //y2=1.07
r78 (  6 35 ) resistor r=3.57586 //w=0.17 //l=0.103078 //layer=li \
 //thickness=0.1 //x=4.44 //y=1.77 //x2=4.355 //y2=1.81
r79 (  6 35 ) resistor r=27.3797 //w=0.187 //l=0.4 //layer=li //thickness=0.1 \
 //x=4.44 //y=1.77 //x2=4.84 //y2=1.77
r80 (  5 35 ) resistor r=5.4201 //w=0.17 //l=0.103078 //layer=li \
 //thickness=0.1 //x=5.24 //y=1.77 //x2=5.325 //y2=1.81
r81 (  5 35 ) resistor r=27.3797 //w=0.187 //l=0.4 //layer=li //thickness=0.1 \
 //x=5.24 //y=1.77 //x2=4.84 //y2=1.77
r82 (  1 35 ) resistor r=3.57586 //w=0.17 //l=0.125 //layer=li //thickness=0.1 \
 //x=4.355 //y=1.685 //x2=4.355 //y2=1.81
r83 (  1 35 ) resistor r=42.0963 //w=0.187 //l=0.615 //layer=li \
 //thickness=0.1 //x=4.355 //y=1.685 //x2=4.355 //y2=1.07
ends PM_DFFSNQNX1\%noxref_16

subckt PM_DFFSNQNX1\%noxref_17 ( 1 5 9 13 17 35 )
c60 ( 35 0 ) capacitor c=0.0699708f //x=9.03 //y=0.555
c61 ( 17 0 ) capacitor c=0.0209666f //x=11.02 //y=1.77
c62 ( 13 0 ) capacitor c=0.0153215f //x=11.02 //y=0.72
c63 ( 9 0 ) capacitor c=0.00772076f //x=10.135 //y=0.805
c64 ( 5 0 ) capacitor c=0.0178423f //x=10.05 //y=1.77
c65 ( 1 0 ) capacitor c=0.00727095f //x=9.165 //y=1.685
r66 (  18 35 ) resistor r=5.4201 //w=0.17 //l=0.103078 //layer=li \
 //thickness=0.1 //x=10.22 //y=1.77 //x2=10.135 //y2=1.81
r67 (  18 35 ) resistor r=27.3797 //w=0.187 //l=0.4 //layer=li //thickness=0.1 \
 //x=10.22 //y=1.77 //x2=10.62 //y2=1.77
r68 (  17 35 ) resistor r=0.751729 //w=0.17 //l=0.085 //layer=li \
 //thickness=0.1 //x=11.02 //y=1.77 //x2=11.105 //y2=1.77
r69 (  17 35 ) resistor r=27.3797 //w=0.187 //l=0.4 //layer=li //thickness=0.1 \
 //x=11.02 //y=1.77 //x2=10.62 //y2=1.77
r70 (  14 35 ) resistor r=3.57586 //w=0.17 //l=0.103078 //layer=li \
 //thickness=0.1 //x=10.22 //y=0.72 //x2=10.135 //y2=0.68
r71 (  14 35 ) resistor r=27.3797 //w=0.187 //l=0.4 //layer=li //thickness=0.1 \
 //x=10.22 //y=0.72 //x2=10.62 //y2=0.72
r72 (  13 35 ) resistor r=0.751729 //w=0.17 //l=0.085 //layer=li \
 //thickness=0.1 //x=11.02 //y=0.72 //x2=11.105 //y2=0.72
r73 (  13 35 ) resistor r=27.3797 //w=0.187 //l=0.4 //layer=li //thickness=0.1 \
 //x=11.02 //y=0.72 //x2=10.62 //y2=0.72
r74 (  10 35 ) resistor r=1.40859 //w=0.34 //l=0.125 //layer=li \
 //thickness=0.1 //x=10.135 //y=1.685 //x2=10.135 //y2=1.81
r75 (  10 35 ) resistor r=42.0963 //w=0.187 //l=0.615 //layer=li \
 //thickness=0.1 //x=10.135 //y=1.685 //x2=10.135 //y2=1.07
r76 (  9 35 ) resistor r=3.57586 //w=0.17 //l=0.125 //layer=li //thickness=0.1 \
 //x=10.135 //y=0.805 //x2=10.135 //y2=0.68
r77 (  9 35 ) resistor r=18.139 //w=0.187 //l=0.265 //layer=li //thickness=0.1 \
 //x=10.135 //y=0.805 //x2=10.135 //y2=1.07
r78 (  6 35 ) resistor r=3.57586 //w=0.17 //l=0.103078 //layer=li \
 //thickness=0.1 //x=9.25 //y=1.77 //x2=9.165 //y2=1.81
r79 (  6 35 ) resistor r=27.3797 //w=0.187 //l=0.4 //layer=li //thickness=0.1 \
 //x=9.25 //y=1.77 //x2=9.65 //y2=1.77
r80 (  5 35 ) resistor r=5.4201 //w=0.17 //l=0.103078 //layer=li \
 //thickness=0.1 //x=10.05 //y=1.77 //x2=10.135 //y2=1.81
r81 (  5 35 ) resistor r=27.3797 //w=0.187 //l=0.4 //layer=li //thickness=0.1 \
 //x=10.05 //y=1.77 //x2=9.65 //y2=1.77
r82 (  1 35 ) resistor r=3.57586 //w=0.17 //l=0.125 //layer=li //thickness=0.1 \
 //x=9.165 //y=1.685 //x2=9.165 //y2=1.81
r83 (  1 35 ) resistor r=42.0963 //w=0.187 //l=0.615 //layer=li \
 //thickness=0.1 //x=9.165 //y=1.685 //x2=9.165 //y2=1.07
ends PM_DFFSNQNX1\%noxref_17

subckt PM_DFFSNQNX1\%noxref_18 ( 1 5 9 10 13 17 29 )
c67 ( 29 0 ) capacitor c=0.0671873f //x=13.945 //y=0.545
c68 ( 17 0 ) capacitor c=0.0067865f //x=16.02 //y=0.795
c69 ( 13 0 ) capacitor c=0.0154977f //x=15.935 //y=0.71
c70 ( 10 0 ) capacitor c=0.00678687f //x=15.05 //y=1.675
c71 ( 9 0 ) capacitor c=0.00770028f //x=15.05 //y=0.795
c72 ( 5 0 ) capacitor c=0.0179209f //x=14.965 //y=1.76
c73 ( 1 0 ) capacitor c=0.00761099f //x=14.08 //y=1.675
r74 (  17 29 ) resistor r=3.57586 //w=0.17 //l=0.125 //layer=li \
 //thickness=0.1 //x=16.02 //y=0.795 //x2=16.02 //y2=0.67
r75 (  17 29 ) resistor r=18.139 //w=0.187 //l=0.265 //layer=li \
 //thickness=0.1 //x=16.02 //y=0.795 //x2=16.02 //y2=1.06
r76 (  14 29 ) resistor r=3.57586 //w=0.17 //l=0.103078 //layer=li \
 //thickness=0.1 //x=15.135 //y=0.71 //x2=15.05 //y2=0.67
r77 (  14 29 ) resistor r=27.3797 //w=0.187 //l=0.4 //layer=li //thickness=0.1 \
 //x=15.135 //y=0.71 //x2=15.535 //y2=0.71
r78 (  13 29 ) resistor r=3.57586 //w=0.17 //l=0.103078 //layer=li \
 //thickness=0.1 //x=15.935 //y=0.71 //x2=16.02 //y2=0.67
r79 (  13 29 ) resistor r=27.3797 //w=0.187 //l=0.4 //layer=li //thickness=0.1 \
 //x=15.935 //y=0.71 //x2=15.535 //y2=0.71
r80 (  10 29 ) resistor r=3.57586 //w=0.17 //l=0.125 //layer=li \
 //thickness=0.1 //x=15.05 //y=1.675 //x2=15.05 //y2=1.8
r81 (  10 29 ) resistor r=42.0963 //w=0.187 //l=0.615 //layer=li \
 //thickness=0.1 //x=15.05 //y=1.675 //x2=15.05 //y2=1.06
r82 (  9 29 ) resistor r=3.57586 //w=0.17 //l=0.125 //layer=li //thickness=0.1 \
 //x=15.05 //y=0.795 //x2=15.05 //y2=0.67
r83 (  9 29 ) resistor r=18.139 //w=0.187 //l=0.265 //layer=li //thickness=0.1 \
 //x=15.05 //y=0.795 //x2=15.05 //y2=1.06
r84 (  6 29 ) resistor r=3.57586 //w=0.17 //l=0.103078 //layer=li \
 //thickness=0.1 //x=14.165 //y=1.76 //x2=14.08 //y2=1.8
r85 (  6 29 ) resistor r=27.3797 //w=0.187 //l=0.4 //layer=li //thickness=0.1 \
 //x=14.165 //y=1.76 //x2=14.565 //y2=1.76
r86 (  5 29 ) resistor r=3.57586 //w=0.17 //l=0.103078 //layer=li \
 //thickness=0.1 //x=14.965 //y=1.76 //x2=15.05 //y2=1.8
r87 (  5 29 ) resistor r=27.3797 //w=0.187 //l=0.4 //layer=li //thickness=0.1 \
 //x=14.965 //y=1.76 //x2=14.565 //y2=1.76
r88 (  1 29 ) resistor r=3.57586 //w=0.17 //l=0.125 //layer=li //thickness=0.1 \
 //x=14.08 //y=1.675 //x2=14.08 //y2=1.8
r89 (  1 29 ) resistor r=42.0963 //w=0.187 //l=0.615 //layer=li \
 //thickness=0.1 //x=14.08 //y=1.675 //x2=14.08 //y2=1.06
ends PM_DFFSNQNX1\%noxref_18

subckt PM_DFFSNQNX1\%noxref_19 ( 1 5 9 10 13 17 29 )
c70 ( 29 0 ) capacitor c=0.0665132f //x=17.275 //y=0.545
c71 ( 17 0 ) capacitor c=0.00675704f //x=19.35 //y=0.795
c72 ( 13 0 ) capacitor c=0.0154977f //x=19.265 //y=0.71
c73 ( 10 0 ) capacitor c=0.00673372f //x=18.38 //y=1.675
c74 ( 9 0 ) capacitor c=0.00770028f //x=18.38 //y=0.795
c75 ( 5 0 ) capacitor c=0.0179513f //x=18.295 //y=1.76
c76 ( 1 0 ) capacitor c=0.0076012f //x=17.41 //y=1.675
r77 (  17 29 ) resistor r=3.57586 //w=0.17 //l=0.125 //layer=li \
 //thickness=0.1 //x=19.35 //y=0.795 //x2=19.35 //y2=0.67
r78 (  17 29 ) resistor r=18.139 //w=0.187 //l=0.265 //layer=li \
 //thickness=0.1 //x=19.35 //y=0.795 //x2=19.35 //y2=1.06
r79 (  14 29 ) resistor r=3.57586 //w=0.17 //l=0.103078 //layer=li \
 //thickness=0.1 //x=18.465 //y=0.71 //x2=18.38 //y2=0.67
r80 (  14 29 ) resistor r=27.3797 //w=0.187 //l=0.4 //layer=li //thickness=0.1 \
 //x=18.465 //y=0.71 //x2=18.865 //y2=0.71
r81 (  13 29 ) resistor r=3.57586 //w=0.17 //l=0.103078 //layer=li \
 //thickness=0.1 //x=19.265 //y=0.71 //x2=19.35 //y2=0.67
r82 (  13 29 ) resistor r=27.3797 //w=0.187 //l=0.4 //layer=li //thickness=0.1 \
 //x=19.265 //y=0.71 //x2=18.865 //y2=0.71
r83 (  10 29 ) resistor r=3.57586 //w=0.17 //l=0.125 //layer=li \
 //thickness=0.1 //x=18.38 //y=1.675 //x2=18.38 //y2=1.8
r84 (  10 29 ) resistor r=42.0963 //w=0.187 //l=0.615 //layer=li \
 //thickness=0.1 //x=18.38 //y=1.675 //x2=18.38 //y2=1.06
r85 (  9 29 ) resistor r=3.57586 //w=0.17 //l=0.125 //layer=li //thickness=0.1 \
 //x=18.38 //y=0.795 //x2=18.38 //y2=0.67
r86 (  9 29 ) resistor r=18.139 //w=0.187 //l=0.265 //layer=li //thickness=0.1 \
 //x=18.38 //y=0.795 //x2=18.38 //y2=1.06
r87 (  6 29 ) resistor r=3.57586 //w=0.17 //l=0.103078 //layer=li \
 //thickness=0.1 //x=17.495 //y=1.76 //x2=17.41 //y2=1.8
r88 (  6 29 ) resistor r=27.3797 //w=0.187 //l=0.4 //layer=li //thickness=0.1 \
 //x=17.495 //y=1.76 //x2=17.895 //y2=1.76
r89 (  5 29 ) resistor r=3.57586 //w=0.17 //l=0.103078 //layer=li \
 //thickness=0.1 //x=18.295 //y=1.76 //x2=18.38 //y2=1.8
r90 (  5 29 ) resistor r=27.3797 //w=0.187 //l=0.4 //layer=li //thickness=0.1 \
 //x=18.295 //y=1.76 //x2=17.895 //y2=1.76
r91 (  1 29 ) resistor r=3.57586 //w=0.17 //l=0.125 //layer=li //thickness=0.1 \
 //x=17.41 //y=1.675 //x2=17.41 //y2=1.8
r92 (  1 29 ) resistor r=42.0963 //w=0.187 //l=0.615 //layer=li \
 //thickness=0.1 //x=17.41 //y=1.675 //x2=17.41 //y2=1.06
ends PM_DFFSNQNX1\%noxref_19

subckt PM_DFFSNQNX1\%noxref_20 ( 1 5 9 13 17 35 )
c57 ( 35 0 ) capacitor c=0.0698687f //x=20.5 //y=0.555
c58 ( 17 0 ) capacitor c=0.019149f //x=22.49 //y=1.77
c59 ( 13 0 ) capacitor c=0.0153834f //x=22.49 //y=0.72
c60 ( 9 0 ) capacitor c=0.00772076f //x=21.605 //y=0.805
c61 ( 5 0 ) capacitor c=0.0167423f //x=21.52 //y=1.77
c62 ( 1 0 ) capacitor c=0.00709556f //x=20.635 //y=1.685
r63 (  18 35 ) resistor r=5.4201 //w=0.17 //l=0.103078 //layer=li \
 //thickness=0.1 //x=21.69 //y=1.77 //x2=21.605 //y2=1.81
r64 (  18 35 ) resistor r=27.3797 //w=0.187 //l=0.4 //layer=li //thickness=0.1 \
 //x=21.69 //y=1.77 //x2=22.09 //y2=1.77
r65 (  17 35 ) resistor r=0.751729 //w=0.17 //l=0.085 //layer=li \
 //thickness=0.1 //x=22.49 //y=1.77 //x2=22.575 //y2=1.77
r66 (  17 35 ) resistor r=27.3797 //w=0.187 //l=0.4 //layer=li //thickness=0.1 \
 //x=22.49 //y=1.77 //x2=22.09 //y2=1.77
r67 (  14 35 ) resistor r=3.57586 //w=0.17 //l=0.103078 //layer=li \
 //thickness=0.1 //x=21.69 //y=0.72 //x2=21.605 //y2=0.68
r68 (  14 35 ) resistor r=27.3797 //w=0.187 //l=0.4 //layer=li //thickness=0.1 \
 //x=21.69 //y=0.72 //x2=22.09 //y2=0.72
r69 (  13 35 ) resistor r=0.751729 //w=0.17 //l=0.085 //layer=li \
 //thickness=0.1 //x=22.49 //y=0.72 //x2=22.575 //y2=0.72
r70 (  13 35 ) resistor r=27.3797 //w=0.187 //l=0.4 //layer=li //thickness=0.1 \
 //x=22.49 //y=0.72 //x2=22.09 //y2=0.72
r71 (  10 35 ) resistor r=1.40859 //w=0.34 //l=0.125 //layer=li \
 //thickness=0.1 //x=21.605 //y=1.685 //x2=21.605 //y2=1.81
r72 (  10 35 ) resistor r=42.0963 //w=0.187 //l=0.615 //layer=li \
 //thickness=0.1 //x=21.605 //y=1.685 //x2=21.605 //y2=1.07
r73 (  9 35 ) resistor r=3.57586 //w=0.17 //l=0.125 //layer=li //thickness=0.1 \
 //x=21.605 //y=0.805 //x2=21.605 //y2=0.68
r74 (  9 35 ) resistor r=18.139 //w=0.187 //l=0.265 //layer=li //thickness=0.1 \
 //x=21.605 //y=0.805 //x2=21.605 //y2=1.07
r75 (  6 35 ) resistor r=3.57586 //w=0.17 //l=0.103078 //layer=li \
 //thickness=0.1 //x=20.72 //y=1.77 //x2=20.635 //y2=1.81
r76 (  6 35 ) resistor r=27.3797 //w=0.187 //l=0.4 //layer=li //thickness=0.1 \
 //x=20.72 //y=1.77 //x2=21.12 //y2=1.77
r77 (  5 35 ) resistor r=5.4201 //w=0.17 //l=0.103078 //layer=li \
 //thickness=0.1 //x=21.52 //y=1.77 //x2=21.605 //y2=1.81
r78 (  5 35 ) resistor r=27.3797 //w=0.187 //l=0.4 //layer=li //thickness=0.1 \
 //x=21.52 //y=1.77 //x2=21.12 //y2=1.77
r79 (  1 35 ) resistor r=3.57586 //w=0.17 //l=0.125 //layer=li //thickness=0.1 \
 //x=20.635 //y=1.685 //x2=20.635 //y2=1.81
r80 (  1 35 ) resistor r=42.0963 //w=0.187 //l=0.615 //layer=li \
 //thickness=0.1 //x=20.635 //y=1.685 //x2=20.635 //y2=1.07
ends PM_DFFSNQNX1\%noxref_20
