// File: NOR3X1.spi.NOR3X1.pxi
// Created: Fri Feb 20 10:14:10 2026
//
simulator lang=spectre
x_PM_NOR3X1\%GND ( GND N_GND_c_2_p N_GND_c_3_p N_GND_c_16_p N_GND_c_27_p \
 N_GND_c_15_p N_GND_c_1_p N_GND_M0_noxref_s )  PM_NOR3X1\%GND
x_PM_NOR3X1\%noxref_2 ( N_noxref_2_c_73_p N_noxref_2_c_114_p N_noxref_2_c_75_p \
 N_noxref_2_c_85_p N_noxref_2_c_86_p N_noxref_2_c_97_p N_noxref_2_c_76_p \
 N_noxref_2_c_87_p N_noxref_2_M3_noxref_s N_noxref_2_M4_noxref_d \
 N_noxref_2_M6_noxref_d )  PM_NOR3X1\%noxref_2
x_PM_NOR3X1\%A ( A A A A A A A N_A_c_164_n N_A_c_177_n N_A_c_180_n N_A_c_167_n \
 N_A_M0_noxref_g N_A_M3_noxref_g N_A_M4_noxref_g N_A_c_169_n N_A_c_229_p \
 N_A_c_230_p N_A_c_171_n N_A_c_252_p N_A_c_253_p N_A_c_191_n N_A_c_173_n \
 N_A_c_175_n N_A_c_192_n )  PM_NOR3X1\%A
x_PM_NOR3X1\%VDD ( VDD N_VDD_c_277_n N_VDD_c_281_n N_VDD_c_287_n N_VDD_c_291_n \
 N_VDD_c_275_n N_VDD_c_276_n N_VDD_M3_noxref_d )  PM_NOR3X1\%VDD
x_PM_NOR3X1\%B ( B B B B B B B N_B_c_349_n N_B_c_361_n N_B_c_350_n N_B_c_363_n \
 N_B_M1_noxref_g N_B_M5_noxref_g N_B_M6_noxref_g N_B_c_353_n N_B_c_393_n \
 N_B_c_396_n N_B_c_442_p N_B_c_464_p N_B_c_355_n N_B_c_356_n N_B_c_400_n \
 N_B_c_358_n N_B_c_404_n N_B_c_371_n )  PM_NOR3X1\%B
x_PM_NOR3X1\%C ( C C C C C C C N_C_c_480_n N_C_c_490_n N_C_c_481_n N_C_c_491_n \
 N_C_M2_noxref_g N_C_M7_noxref_g N_C_M8_noxref_g N_C_c_483_n N_C_c_512_n \
 N_C_c_514_n N_C_c_516_n N_C_c_561_p N_C_c_485_n N_C_c_533_p N_C_c_486_n \
 N_C_c_519_n N_C_c_494_n N_C_c_488_n N_C_c_523_n )  PM_NOR3X1\%C
x_PM_NOR3X1\%noxref_7 ( N_noxref_7_c_588_n N_noxref_7_c_591_n \
 N_noxref_7_c_609_n N_noxref_7_c_593_n N_noxref_7_c_597_n N_noxref_7_c_600_n \
 N_noxref_7_c_601_n N_noxref_7_c_605_n N_noxref_7_M5_noxref_d \
 N_noxref_7_M7_noxref_s N_noxref_7_M8_noxref_d )  PM_NOR3X1\%noxref_7
x_PM_NOR3X1\%Y ( Y Y Y Y Y Y Y N_Y_c_664_n N_Y_c_668_n N_Y_c_669_n N_Y_c_703_n \
 N_Y_c_673_n N_Y_c_677_n N_Y_c_678_n N_Y_c_682_n N_Y_c_686_n N_Y_c_688_n \
 N_Y_c_734_n N_Y_c_792_n N_Y_c_704_n N_Y_c_705_n N_Y_M0_noxref_d \
 N_Y_M1_noxref_d N_Y_M2_noxref_d N_Y_M7_noxref_d )  PM_NOR3X1\%Y
cc_1 ( N_GND_c_1_p A ) capacitor c=0.0119787f //x=1.23 //y=0.18 //x2=1.6 \
 //y2=2.77
cc_2 ( N_GND_c_2_p N_A_c_164_n ) capacitor c=7.00629e-19 //x=4.56 //y=0.18 \
 //x2=1.6 //y2=2.425
cc_3 ( N_GND_c_3_p N_A_c_164_n ) capacitor c=9.81943e-19 //x=2.07 //y=0.71 \
 //x2=1.6 //y2=2.425
cc_4 ( N_GND_c_1_p N_A_c_164_n ) capacitor c=0.00920582f //x=1.23 //y=0.18 \
 //x2=1.6 //y2=2.425
cc_5 ( N_GND_c_3_p N_A_c_167_n ) capacitor c=4.19546e-19 //x=2.07 //y=0.71 \
 //x2=1.6 //y2=2.26
cc_6 ( N_GND_c_1_p N_A_c_167_n ) capacitor c=0.00368165f //x=1.23 //y=0.18 \
 //x2=1.6 //y2=2.26
cc_7 ( N_GND_c_3_p N_A_c_169_n ) capacitor c=0.0209625f //x=2.07 //y=0.71 \
 //x2=1.405 //y2=1.085
cc_8 ( N_GND_M0_noxref_s N_A_c_169_n ) capacitor c=0.033078f //x=1.05 \
 //y=0.545 //x2=1.405 //y2=1.085
cc_9 ( N_GND_c_3_p N_A_c_171_n ) capacitor c=2.1838e-19 //x=2.07 //y=0.71 \
 //x2=1.405 //y2=2.095
cc_10 ( N_GND_c_1_p N_A_c_171_n ) capacitor c=0.0121558f //x=1.23 //y=0.18 \
 //x2=1.405 //y2=2.095
cc_11 ( N_GND_c_3_p N_A_c_173_n ) capacitor c=0.00805599f //x=2.07 //y=0.71 \
 //x2=1.935 //y2=1.085
cc_12 ( N_GND_M0_noxref_s N_A_c_173_n ) capacitor c=0.00617417f //x=1.05 \
 //y=0.545 //x2=1.935 //y2=1.085
cc_13 ( N_GND_M0_noxref_s N_A_c_175_n ) capacitor c=0.00120103f //x=1.05 \
 //y=0.545 //x2=1.935 //y2=1.43
cc_14 ( N_GND_c_1_p N_VDD_c_275_n ) capacitor c=0.00989514f //x=1.23 //y=0.18 \
 //x2=1.23 //y2=7.58
cc_15 ( N_GND_c_15_p N_VDD_c_276_n ) capacitor c=0.00989514f //x=4.56 //y=0.18 \
 //x2=4.56 //y2=7.58
cc_16 ( N_GND_c_16_p N_B_c_349_n ) capacitor c=6.15173e-19 //x=3.04 //y=0.71 \
 //x2=2.34 //y2=2.39
cc_17 ( N_GND_c_16_p N_B_c_350_n ) capacitor c=9.05712e-19 //x=3.04 //y=0.71 \
 //x2=2.34 //y2=2.26
cc_18 ( N_GND_c_15_p N_B_c_350_n ) capacitor c=2.74946e-19 //x=4.56 //y=0.18 \
 //x2=2.34 //y2=2.26
cc_19 ( N_GND_c_1_p N_B_c_350_n ) capacitor c=5.03552e-19 //x=1.23 //y=0.18 \
 //x2=2.34 //y2=2.26
cc_20 ( N_GND_c_16_p N_B_c_353_n ) capacitor c=0.0207598f //x=3.04 //y=0.71 \
 //x2=2.375 //y2=1.085
cc_21 ( N_GND_M0_noxref_s N_B_c_353_n ) capacitor c=0.00732593f //x=1.05 \
 //y=0.545 //x2=2.375 //y2=1.085
cc_22 ( N_GND_M0_noxref_s N_B_c_355_n ) capacitor c=0.00120679f //x=1.05 \
 //y=0.545 //x2=2.75 //y2=1.585
cc_23 ( N_GND_c_16_p N_B_c_356_n ) capacitor c=0.00805599f //x=3.04 //y=0.71 \
 //x2=2.905 //y2=1.085
cc_24 ( N_GND_M0_noxref_s N_B_c_356_n ) capacitor c=0.00617003f //x=1.05 \
 //y=0.545 //x2=2.905 //y2=1.085
cc_25 ( N_GND_c_16_p N_B_c_358_n ) capacitor c=2.1838e-19 //x=3.04 //y=0.71 \
 //x2=2.34 //y2=2.26
cc_26 ( N_GND_M0_noxref_s N_B_c_358_n ) capacitor c=0.0011812f //x=1.05 \
 //y=0.545 //x2=2.34 //y2=2.26
cc_27 ( N_GND_c_27_p N_C_c_480_n ) capacitor c=7.66217e-19 //x=4.01 //y=0.71 \
 //x2=3.45 //y2=2.405
cc_28 ( N_GND_c_27_p N_C_c_481_n ) capacitor c=0.00100208f //x=4.01 //y=0.71 \
 //x2=3.45 //y2=2.26
cc_29 ( N_GND_c_15_p N_C_c_481_n ) capacitor c=0.00172597f //x=4.56 //y=0.18 \
 //x2=3.45 //y2=2.26
cc_30 ( N_GND_c_27_p N_C_c_483_n ) capacitor c=0.0208435f //x=4.01 //y=0.71 \
 //x2=3.345 //y2=1.085
cc_31 ( N_GND_M0_noxref_s N_C_c_483_n ) capacitor c=0.00732593f //x=1.05 \
 //y=0.545 //x2=3.345 //y2=1.085
cc_32 ( N_GND_M0_noxref_s N_C_c_485_n ) capacitor c=0.00271091f //x=1.05 \
 //y=0.545 //x2=3.72 //y2=1.585
cc_33 ( N_GND_c_27_p N_C_c_486_n ) capacitor c=0.00825432f //x=4.01 //y=0.71 \
 //x2=3.875 //y2=1.085
cc_34 ( N_GND_M0_noxref_s N_C_c_486_n ) capacitor c=0.0143707f //x=1.05 \
 //y=0.545 //x2=3.875 //y2=1.085
cc_35 ( N_GND_c_27_p N_C_c_488_n ) capacitor c=2.1838e-19 //x=4.01 //y=0.71 \
 //x2=3.345 //y2=2.26
cc_36 ( N_GND_c_2_p N_Y_c_664_n ) capacitor c=0.0100308f //x=4.56 //y=0.18 \
 //x2=1.67 //y2=1.31
cc_37 ( N_GND_c_3_p N_Y_c_664_n ) capacitor c=0.00400023f //x=2.07 //y=0.71 \
 //x2=1.67 //y2=1.31
cc_38 ( N_GND_c_15_p N_Y_c_664_n ) capacitor c=2.87802e-19 //x=4.56 //y=0.18 \
 //x2=1.67 //y2=1.31
cc_39 ( N_GND_M0_noxref_s N_Y_c_664_n ) capacitor c=0.0106681f //x=1.05 \
 //y=0.545 //x2=1.67 //y2=1.31
cc_40 ( N_GND_M0_noxref_s N_Y_c_668_n ) capacitor c=0.0281176f //x=1.05 \
 //y=0.545 //x2=1.67 //y2=1.75
cc_41 ( N_GND_c_2_p N_Y_c_669_n ) capacitor c=0.00677967f //x=4.56 //y=0.18 \
 //x2=2.555 //y2=1.835
cc_42 ( N_GND_c_3_p N_Y_c_669_n ) capacitor c=0.00128856f //x=2.07 //y=0.71 \
 //x2=2.555 //y2=1.835
cc_43 ( N_GND_c_16_p N_Y_c_669_n ) capacitor c=0.0010475f //x=3.04 //y=0.71 \
 //x2=2.555 //y2=1.835
cc_44 ( N_GND_M0_noxref_s N_Y_c_669_n ) capacitor c=0.00857119f //x=1.05 \
 //y=0.545 //x2=2.555 //y2=1.835
cc_45 ( N_GND_c_2_p N_Y_c_673_n ) capacitor c=0.0100704f //x=4.56 //y=0.18 \
 //x2=2.64 //y2=1.31
cc_46 ( N_GND_c_16_p N_Y_c_673_n ) capacitor c=0.00431488f //x=3.04 //y=0.71 \
 //x2=2.64 //y2=1.31
cc_47 ( N_GND_c_15_p N_Y_c_673_n ) capacitor c=2.87802e-19 //x=4.56 //y=0.18 \
 //x2=2.64 //y2=1.31
cc_48 ( N_GND_M0_noxref_s N_Y_c_673_n ) capacitor c=0.00695238f //x=1.05 \
 //y=0.545 //x2=2.64 //y2=1.31
cc_49 ( N_GND_M0_noxref_s N_Y_c_677_n ) capacitor c=0.00901608f //x=1.05 \
 //y=0.545 //x2=2.64 //y2=1.75
cc_50 ( N_GND_c_2_p N_Y_c_678_n ) capacitor c=0.00678034f //x=4.56 //y=0.18 \
 //x2=3.525 //y2=1.835
cc_51 ( N_GND_c_16_p N_Y_c_678_n ) capacitor c=0.00128856f //x=3.04 //y=0.71 \
 //x2=3.525 //y2=1.835
cc_52 ( N_GND_c_27_p N_Y_c_678_n ) capacitor c=0.00176314f //x=4.01 //y=0.71 \
 //x2=3.525 //y2=1.835
cc_53 ( N_GND_M0_noxref_s N_Y_c_678_n ) capacitor c=0.00884276f //x=1.05 \
 //y=0.545 //x2=3.525 //y2=1.835
cc_54 ( N_GND_c_2_p N_Y_c_682_n ) capacitor c=0.00984227f //x=4.56 //y=0.18 \
 //x2=3.61 //y2=1.325
cc_55 ( N_GND_c_27_p N_Y_c_682_n ) capacitor c=0.00398909f //x=4.01 //y=0.71 \
 //x2=3.61 //y2=1.325
cc_56 ( N_GND_c_15_p N_Y_c_682_n ) capacitor c=2.87802e-19 //x=4.56 //y=0.18 \
 //x2=3.61 //y2=1.325
cc_57 ( N_GND_M0_noxref_s N_Y_c_682_n ) capacitor c=0.0113255f //x=1.05 \
 //y=0.545 //x2=3.61 //y2=1.325
cc_58 ( N_GND_c_15_p N_Y_c_686_n ) capacitor c=0.00484928f //x=4.56 //y=0.18 \
 //x2=3.61 //y2=1.75
cc_59 ( N_GND_M0_noxref_s N_Y_c_686_n ) capacitor c=0.0117003f //x=1.05 \
 //y=0.545 //x2=3.61 //y2=1.75
cc_60 ( N_GND_c_2_p N_Y_c_688_n ) capacitor c=0.00904113f //x=4.56 //y=0.18 \
 //x2=4.105 //y2=1.835
cc_61 ( N_GND_c_27_p N_Y_c_688_n ) capacitor c=0.00348283f //x=4.01 //y=0.71 \
 //x2=4.105 //y2=1.835
cc_62 ( N_GND_c_15_p N_Y_c_688_n ) capacitor c=0.0292347f //x=4.56 //y=0.18 \
 //x2=4.105 //y2=1.835
cc_63 ( N_GND_M0_noxref_s N_Y_c_688_n ) capacitor c=0.0108215f //x=1.05 \
 //y=0.545 //x2=4.105 //y2=1.835
cc_64 ( N_GND_c_2_p N_Y_M0_noxref_d ) capacitor c=3.01769e-19 //x=4.56 \
 //y=0.18 //x2=1.48 //y2=1.085
cc_65 ( N_GND_c_3_p N_Y_M0_noxref_d ) capacitor c=0.00910163f //x=2.07 \
 //y=0.71 //x2=1.48 //y2=1.085
cc_66 ( N_GND_M0_noxref_s N_Y_M0_noxref_d ) capacitor c=0.0275007f //x=1.05 \
 //y=0.545 //x2=1.48 //y2=1.085
cc_67 ( N_GND_c_2_p N_Y_M1_noxref_d ) capacitor c=3.01769e-19 //x=4.56 \
 //y=0.18 //x2=2.45 //y2=1.085
cc_68 ( N_GND_c_16_p N_Y_M1_noxref_d ) capacitor c=0.00910163f //x=3.04 \
 //y=0.71 //x2=2.45 //y2=1.085
cc_69 ( N_GND_M0_noxref_s N_Y_M1_noxref_d ) capacitor c=0.0274981f //x=1.05 \
 //y=0.545 //x2=2.45 //y2=1.085
cc_70 ( N_GND_c_2_p N_Y_M2_noxref_d ) capacitor c=3.01769e-19 //x=4.56 \
 //y=0.18 //x2=3.42 //y2=1.085
cc_71 ( N_GND_c_27_p N_Y_M2_noxref_d ) capacitor c=0.00910163f //x=4.01 \
 //y=0.71 //x2=3.42 //y2=1.085
cc_72 ( N_GND_M0_noxref_s N_Y_M2_noxref_d ) capacitor c=0.0274983f //x=1.05 \
 //y=0.545 //x2=3.42 //y2=1.085
cc_73 ( N_noxref_2_c_73_p N_A_c_164_n ) capacitor c=3.49728e-19 //x=2.045 \
 //y=5.39 //x2=1.6 //y2=2.425
cc_74 ( N_noxref_2_c_73_p N_A_c_177_n ) capacitor c=0.00780885f //x=2.045 \
 //y=5.39 //x2=1.445 //y2=4.885
cc_75 ( N_noxref_2_c_75_p N_A_c_177_n ) capacitor c=0.0239345f //x=1.282 \
 //y=5.39 //x2=1.445 //y2=4.885
cc_76 ( N_noxref_2_c_76_p N_A_c_177_n ) capacitor c=0.0022154f //x=1.28 \
 //y=5.56 //x2=1.445 //y2=4.885
cc_77 ( N_noxref_2_c_73_p N_A_c_180_n ) capacitor c=0.00104675f //x=2.045 \
 //y=5.39 //x2=1.445 //y2=4.885
cc_78 ( N_noxref_2_c_75_p N_A_c_180_n ) capacitor c=0.00565893f //x=1.282 \
 //y=5.39 //x2=1.445 //y2=4.885
cc_79 ( N_noxref_2_c_76_p N_A_c_180_n ) capacitor c=0.00126834f //x=1.28 \
 //y=5.56 //x2=1.445 //y2=4.885
cc_80 ( N_noxref_2_c_73_p N_A_M3_noxref_g ) capacitor c=0.00997309f //x=2.045 \
 //y=5.39 //x2=1.5 //y2=6.205
cc_81 ( N_noxref_2_c_75_p N_A_M3_noxref_g ) capacitor c=0.00429908f //x=1.282 \
 //y=5.39 //x2=1.5 //y2=6.205
cc_82 ( N_noxref_2_c_76_p N_A_M3_noxref_g ) capacitor c=0.0483843f //x=1.28 \
 //y=5.56 //x2=1.5 //y2=6.205
cc_83 ( N_noxref_2_M3_noxref_s N_A_M3_noxref_g ) capacitor c=0.00370227f \
 //x=1.145 //y=5.205 //x2=1.5 //y2=6.205
cc_84 ( N_noxref_2_c_73_p N_A_M4_noxref_g ) capacitor c=0.00967464f //x=2.045 \
 //y=5.39 //x2=1.94 //y2=6.205
cc_85 ( N_noxref_2_c_85_p N_A_M4_noxref_g ) capacitor c=0.00182852f //x=2.162 \
 //y=5.39 //x2=1.94 //y2=6.205
cc_86 ( N_noxref_2_c_86_p N_A_M4_noxref_g ) capacitor c=0.00175452f //x=2.16 \
 //y=6.92 //x2=1.94 //y2=6.205
cc_87 ( N_noxref_2_c_87_p N_A_M4_noxref_g ) capacitor c=0.0170175f //x=2.16 \
 //y=5.56 //x2=1.94 //y2=6.205
cc_88 ( N_noxref_2_c_73_p N_A_c_191_n ) capacitor c=0.00196455f //x=2.045 \
 //y=5.39 //x2=1.865 //y2=4.975
cc_89 ( N_noxref_2_c_75_p N_A_c_192_n ) capacitor c=9.17057e-19 //x=1.282 \
 //y=5.39 //x2=1.445 //y2=4.885
cc_90 ( N_noxref_2_c_76_p N_A_c_192_n ) capacitor c=0.00297041f //x=1.28 \
 //y=5.56 //x2=1.445 //y2=4.885
cc_91 ( N_noxref_2_c_73_p N_VDD_c_277_n ) capacitor c=0.00186824f //x=2.045 \
 //y=5.39 //x2=1.635 //y2=7.585
cc_92 ( N_noxref_2_c_75_p N_VDD_c_277_n ) capacitor c=3.02242e-19 //x=1.282 \
 //y=5.39 //x2=1.635 //y2=7.585
cc_93 ( N_noxref_2_c_76_p N_VDD_c_277_n ) capacitor c=0.00240365f //x=1.28 \
 //y=5.56 //x2=1.635 //y2=7.585
cc_94 ( N_noxref_2_M3_noxref_s N_VDD_c_277_n ) capacitor c=0.0245525f \
 //x=1.145 //y=5.205 //x2=1.635 //y2=7.585
cc_95 ( N_noxref_2_c_73_p N_VDD_c_281_n ) capacitor c=0.00496034f //x=2.045 \
 //y=5.39 //x2=1.72 //y2=7.035
cc_96 ( N_noxref_2_c_86_p N_VDD_c_281_n ) capacitor c=0.0375632f //x=2.16 \
 //y=6.92 //x2=1.72 //y2=7.035
cc_97 ( N_noxref_2_c_97_p N_VDD_c_281_n ) capacitor c=6.22236e-19 //x=3.04 \
 //y=6.92 //x2=1.72 //y2=7.035
cc_98 ( N_noxref_2_c_76_p N_VDD_c_281_n ) capacitor c=0.00220362f //x=1.28 \
 //y=5.56 //x2=1.72 //y2=7.035
cc_99 ( N_noxref_2_c_87_p N_VDD_c_281_n ) capacitor c=0.00220362f //x=2.16 \
 //y=5.56 //x2=1.72 //y2=7.035
cc_100 ( N_noxref_2_M3_noxref_s N_VDD_c_281_n ) capacitor c=0.0381427f \
 //x=1.145 //y=5.205 //x2=1.72 //y2=7.035
cc_101 ( N_noxref_2_c_86_p N_VDD_c_287_n ) capacitor c=0.0104314f //x=2.16 \
 //y=6.92 //x2=1.72 //y2=7.41
cc_102 ( N_noxref_2_c_76_p N_VDD_c_287_n ) capacitor c=0.00158506f //x=1.28 \
 //y=5.56 //x2=1.72 //y2=7.41
cc_103 ( N_noxref_2_c_87_p N_VDD_c_287_n ) capacitor c=4.62894e-19 //x=2.16 \
 //y=5.56 //x2=1.72 //y2=7.41
cc_104 ( N_noxref_2_M3_noxref_s N_VDD_c_287_n ) capacitor c=0.0121524f \
 //x=1.145 //y=5.205 //x2=1.72 //y2=7.41
cc_105 ( N_noxref_2_c_73_p N_VDD_c_291_n ) capacitor c=0.00198782f //x=2.045 \
 //y=5.39 //x2=4.56 //y2=7.58
cc_106 ( N_noxref_2_c_86_p N_VDD_c_291_n ) capacitor c=0.0975061f //x=2.16 \
 //y=6.92 //x2=4.56 //y2=7.58
cc_107 ( N_noxref_2_c_97_p N_VDD_c_291_n ) capacitor c=0.00214997f //x=3.04 \
 //y=6.92 //x2=4.56 //y2=7.58
cc_108 ( N_noxref_2_c_87_p N_VDD_c_291_n ) capacitor c=0.00205411f //x=2.16 \
 //y=5.56 //x2=4.56 //y2=7.58
cc_109 ( N_noxref_2_M6_noxref_d N_VDD_c_291_n ) capacitor c=0.00206569f \
 //x=2.895 //y=5.205 //x2=4.56 //y2=7.58
cc_110 ( N_noxref_2_c_75_p N_VDD_c_275_n ) capacitor c=0.0100761f //x=1.282 \
 //y=5.39 //x2=1.23 //y2=7.58
cc_111 ( N_noxref_2_c_76_p N_VDD_c_275_n ) capacitor c=0.0554809f //x=1.28 \
 //y=5.56 //x2=1.23 //y2=7.58
cc_112 ( N_noxref_2_M3_noxref_s N_VDD_c_275_n ) capacitor c=0.00790985f \
 //x=1.145 //y=5.205 //x2=1.23 //y2=7.58
cc_113 ( N_noxref_2_c_73_p N_VDD_c_276_n ) capacitor c=0.00432819f //x=2.045 \
 //y=5.39 //x2=4.56 //y2=7.58
cc_114 ( N_noxref_2_c_114_p N_VDD_c_276_n ) capacitor c=0.00219567f //x=2.925 \
 //y=7.09 //x2=4.56 //y2=7.58
cc_115 ( N_noxref_2_c_75_p N_VDD_c_276_n ) capacitor c=2.31341e-19 //x=1.282 \
 //y=5.39 //x2=4.56 //y2=7.58
cc_116 ( N_noxref_2_c_86_p N_VDD_c_276_n ) capacitor c=0.021588f //x=2.16 \
 //y=6.92 //x2=4.56 //y2=7.58
cc_117 ( N_noxref_2_c_97_p N_VDD_c_276_n ) capacitor c=0.00218784f //x=3.04 \
 //y=6.92 //x2=4.56 //y2=7.58
cc_118 ( N_noxref_2_c_76_p N_VDD_c_276_n ) capacitor c=0.0142641f //x=1.28 \
 //y=5.56 //x2=4.56 //y2=7.58
cc_119 ( N_noxref_2_c_87_p N_VDD_c_276_n ) capacitor c=0.00955358f //x=2.16 \
 //y=5.56 //x2=4.56 //y2=7.58
cc_120 ( N_noxref_2_M3_noxref_s N_VDD_c_276_n ) capacitor c=0.00421418f \
 //x=1.145 //y=5.205 //x2=4.56 //y2=7.58
cc_121 ( N_noxref_2_M6_noxref_d N_VDD_c_276_n ) capacitor c=0.00957401f \
 //x=2.895 //y=5.205 //x2=4.56 //y2=7.58
cc_122 ( N_noxref_2_c_73_p N_VDD_M3_noxref_d ) capacitor c=0.00667051f \
 //x=2.045 //y=5.39 //x2=1.575 //y2=5.205
cc_123 ( N_noxref_2_c_86_p N_VDD_M3_noxref_d ) capacitor c=0.00466156f \
 //x=2.16 //y=6.92 //x2=1.575 //y2=5.205
cc_124 ( N_noxref_2_c_76_p N_VDD_M3_noxref_d ) capacitor c=0.0736776f //x=1.28 \
 //y=5.56 //x2=1.575 //y2=5.205
cc_125 ( N_noxref_2_c_87_p N_VDD_M3_noxref_d ) capacitor c=0.0670838f //x=2.16 \
 //y=5.56 //x2=1.575 //y2=5.205
cc_126 ( N_noxref_2_M3_noxref_s N_VDD_M3_noxref_d ) capacitor c=0.00566948f \
 //x=1.145 //y=5.205 //x2=1.575 //y2=5.205
cc_127 ( N_noxref_2_c_85_p N_B_c_349_n ) capacitor c=6.32666e-19 //x=2.162 \
 //y=5.39 //x2=2.34 //y2=2.39
cc_128 ( N_noxref_2_c_114_p N_B_c_361_n ) capacitor c=0.00230547f //x=2.925 \
 //y=7.09 //x2=2.34 //y2=4.74
cc_129 ( N_noxref_2_c_85_p N_B_c_361_n ) capacitor c=0.00148837f //x=2.162 \
 //y=5.39 //x2=2.34 //y2=4.74
cc_130 ( N_noxref_2_c_114_p N_B_c_363_n ) capacitor c=0.00233465f //x=2.925 \
 //y=7.09 //x2=2.375 //y2=4.885
cc_131 ( N_noxref_2_c_114_p N_B_M5_noxref_g ) capacitor c=0.00778083f \
 //x=2.925 //y=7.09 //x2=2.38 //y2=6.205
cc_132 ( N_noxref_2_c_85_p N_B_M5_noxref_g ) capacitor c=0.0018192f //x=2.162 \
 //y=5.39 //x2=2.38 //y2=6.205
cc_133 ( N_noxref_2_c_86_p N_B_M5_noxref_g ) capacitor c=0.0018046f //x=2.16 \
 //y=6.92 //x2=2.38 //y2=6.205
cc_134 ( N_noxref_2_c_87_p N_B_M5_noxref_g ) capacitor c=0.0170175f //x=2.16 \
 //y=5.56 //x2=2.38 //y2=6.205
cc_135 ( N_noxref_2_c_114_p N_B_M6_noxref_g ) capacitor c=0.00843033f \
 //x=2.925 //y=7.09 //x2=2.82 //y2=6.205
cc_136 ( N_noxref_2_c_97_p N_B_M6_noxref_g ) capacitor c=0.00272866f //x=3.04 \
 //y=6.92 //x2=2.82 //y2=6.205
cc_137 ( N_noxref_2_M6_noxref_d N_B_M6_noxref_g ) capacitor c=0.0231499f \
 //x=2.895 //y=5.205 //x2=2.82 //y2=6.205
cc_138 ( N_noxref_2_c_85_p N_B_c_371_n ) capacitor c=6.56606e-19 //x=2.162 \
 //y=5.39 //x2=2.375 //y2=4.885
cc_139 ( N_noxref_2_c_114_p N_noxref_7_c_588_n ) capacitor c=0.00321697f \
 //x=2.925 //y=7.09 //x2=3.555 //y2=5.39
cc_140 ( N_noxref_2_c_97_p N_noxref_7_c_588_n ) capacitor c=0.00503384f \
 //x=3.04 //y=6.92 //x2=3.555 //y2=5.39
cc_141 ( N_noxref_2_M6_noxref_d N_noxref_7_c_588_n ) capacitor c=0.00659996f \
 //x=2.895 //y=5.205 //x2=3.555 //y2=5.39
cc_142 ( N_noxref_2_c_85_p N_noxref_7_c_591_n ) capacitor c=8.51609e-19 \
 //x=2.162 //y=5.39 //x2=3.64 //y2=5.77
cc_143 ( N_noxref_2_M6_noxref_d N_noxref_7_c_591_n ) capacitor c=0.00726094f \
 //x=2.895 //y=5.205 //x2=3.64 //y2=5.77
cc_144 ( N_noxref_2_c_114_p N_noxref_7_c_593_n ) capacitor c=0.00515028f \
 //x=2.925 //y=7.09 //x2=2.6 //y2=5.39
cc_145 ( N_noxref_2_c_75_p N_noxref_7_c_593_n ) capacitor c=6.44186e-19 \
 //x=1.282 //y=5.39 //x2=2.6 //y2=5.39
cc_146 ( N_noxref_2_c_85_p N_noxref_7_c_593_n ) capacitor c=0.0526233f \
 //x=2.162 //y=5.39 //x2=2.6 //y2=5.39
cc_147 ( N_noxref_2_c_87_p N_noxref_7_c_593_n ) capacitor c=0.00261162f \
 //x=2.16 //y=5.56 //x2=2.6 //y2=5.39
cc_148 ( N_noxref_2_c_86_p N_noxref_7_c_597_n ) capacitor c=4.26669e-19 \
 //x=2.16 //y=6.92 //x2=3.64 //y2=6.92
cc_149 ( N_noxref_2_c_97_p N_noxref_7_c_597_n ) capacitor c=0.036549f //x=3.04 \
 //y=6.92 //x2=3.64 //y2=6.92
cc_150 ( N_noxref_2_M6_noxref_d N_noxref_7_c_597_n ) capacitor c=0.00418103f \
 //x=2.895 //y=5.205 //x2=3.64 //y2=6.92
cc_151 ( N_noxref_2_c_97_p N_noxref_7_c_600_n ) capacitor c=4.2596e-19 \
 //x=3.04 //y=6.92 //x2=4.52 //y2=6.92
cc_152 ( N_noxref_2_c_114_p N_noxref_7_c_601_n ) capacitor c=0.00406191f \
 //x=2.925 //y=7.09 //x2=2.6 //y2=5.56
cc_153 ( N_noxref_2_c_85_p N_noxref_7_c_601_n ) capacitor c=0.00396335f \
 //x=2.162 //y=5.39 //x2=2.6 //y2=5.56
cc_154 ( N_noxref_2_c_87_p N_noxref_7_c_601_n ) capacitor c=0.0679433f \
 //x=2.16 //y=5.56 //x2=2.6 //y2=5.56
cc_155 ( N_noxref_2_M6_noxref_d N_noxref_7_c_601_n ) capacitor c=0.0468918f \
 //x=2.895 //y=5.205 //x2=2.6 //y2=5.56
cc_156 ( N_noxref_2_c_97_p N_noxref_7_c_605_n ) capacitor c=0.00161703f \
 //x=3.04 //y=6.92 //x2=3.64 //y2=5.9
cc_157 ( N_noxref_2_M6_noxref_d N_noxref_7_c_605_n ) capacitor c=0.0468546f \
 //x=2.895 //y=5.205 //x2=3.64 //y2=5.9
cc_158 ( N_noxref_2_c_73_p N_Y_c_664_n ) capacitor c=2.38306e-19 //x=2.045 \
 //y=5.39 //x2=1.67 //y2=1.31
cc_159 ( N_noxref_2_c_85_p N_Y_c_669_n ) capacitor c=0.00318142f //x=2.162 \
 //y=5.39 //x2=2.555 //y2=1.835
cc_160 ( N_noxref_2_c_73_p N_Y_c_703_n ) capacitor c=0.00292631f //x=2.045 \
 //y=5.39 //x2=1.755 //y2=1.835
cc_161 ( N_noxref_2_c_85_p N_Y_c_704_n ) capacitor c=0.00134451f //x=2.162 \
 //y=5.39 //x2=4.19 //y2=5.39
cc_162 ( N_noxref_2_M6_noxref_d N_Y_c_705_n ) capacitor c=0.00395323f \
 //x=2.895 //y=5.205 //x2=4.08 //y2=5.9
cc_163 ( N_A_M3_noxref_g N_VDD_c_281_n ) capacitor c=0.0012542f //x=1.5 \
 //y=6.205 //x2=1.72 //y2=7.035
cc_164 ( N_A_M4_noxref_g N_VDD_c_281_n ) capacitor c=0.0012542f //x=1.94 \
 //y=6.205 //x2=1.72 //y2=7.035
cc_165 ( N_A_M3_noxref_g N_VDD_c_287_n ) capacitor c=0.00205385f //x=1.5 \
 //y=6.205 //x2=1.72 //y2=7.41
cc_166 ( N_A_M4_noxref_g N_VDD_c_287_n ) capacitor c=0.00294739f //x=1.94 \
 //y=6.205 //x2=1.72 //y2=7.41
cc_167 ( A N_VDD_c_275_n ) capacitor c=0.0113632f //x=1.6 //y=2.77 //x2=1.23 \
 //y2=7.58
cc_168 ( N_A_c_177_n N_VDD_c_275_n ) capacitor c=0.00509436f //x=1.445 \
 //y=4.885 //x2=1.23 //y2=7.58
cc_169 ( N_A_c_180_n N_VDD_c_275_n ) capacitor c=0.00639333f //x=1.445 \
 //y=4.885 //x2=1.23 //y2=7.58
cc_170 ( N_A_M3_noxref_g N_VDD_c_275_n ) capacitor c=0.0165754f //x=1.5 \
 //y=6.205 //x2=1.23 //y2=7.58
cc_171 ( N_A_c_192_n N_VDD_c_275_n ) capacitor c=0.00542539f //x=1.445 \
 //y=4.885 //x2=1.23 //y2=7.58
cc_172 ( N_A_M3_noxref_g N_VDD_c_276_n ) capacitor c=0.00720181f //x=1.5 \
 //y=6.205 //x2=4.56 //y2=7.58
cc_173 ( N_A_M4_noxref_g N_VDD_c_276_n ) capacitor c=0.00760847f //x=1.94 \
 //y=6.205 //x2=4.56 //y2=7.58
cc_174 ( N_A_M3_noxref_g N_VDD_M3_noxref_d ) capacitor c=0.0130453f //x=1.5 \
 //y=6.205 //x2=1.575 //y2=5.205
cc_175 ( N_A_M4_noxref_g N_VDD_M3_noxref_d ) capacitor c=0.0146888f //x=1.94 \
 //y=6.205 //x2=1.575 //y2=5.205
cc_176 ( N_A_c_191_n N_VDD_M3_noxref_d ) capacitor c=0.00248632f //x=1.865 \
 //y=4.975 //x2=1.575 //y2=5.205
cc_177 ( A B ) capacitor c=0.0601213f //x=1.6 //y=2.77 //x2=2.34 //y2=2.4
cc_178 ( N_A_c_164_n B ) capacitor c=0.00271206f //x=1.6 //y=2.425 //x2=2.34 \
 //y2=2.4
cc_179 ( N_A_c_164_n N_B_c_349_n ) capacitor c=0.0198635f //x=1.6 //y=2.425 \
 //x2=2.34 //y2=2.39
cc_180 ( N_A_c_167_n N_B_c_349_n ) capacitor c=6.64673e-19 //x=1.6 //y=2.26 \
 //x2=2.34 //y2=2.39
cc_181 ( N_A_c_171_n N_B_c_349_n ) capacitor c=0.00160374f //x=1.405 //y=2.095 \
 //x2=2.34 //y2=2.39
cc_182 ( N_A_c_177_n N_B_c_361_n ) capacitor c=0.0625724f //x=1.445 //y=4.885 \
 //x2=2.34 //y2=4.74
cc_183 ( N_A_c_180_n N_B_c_361_n ) capacitor c=8.14108e-19 //x=1.445 //y=4.885 \
 //x2=2.34 //y2=4.74
cc_184 ( N_A_c_191_n N_B_c_361_n ) capacitor c=7.4344e-19 //x=1.865 //y=4.975 \
 //x2=2.34 //y2=4.74
cc_185 ( N_A_c_164_n N_B_c_350_n ) capacitor c=0.00412829f //x=1.6 //y=2.425 \
 //x2=2.34 //y2=2.26
cc_186 ( N_A_c_167_n N_B_c_350_n ) capacitor c=0.00444996f //x=1.6 //y=2.26 \
 //x2=2.34 //y2=2.26
cc_187 ( N_A_c_171_n N_B_c_350_n ) capacitor c=0.00284386f //x=1.405 //y=2.095 \
 //x2=2.34 //y2=2.26
cc_188 ( A N_B_c_363_n ) capacitor c=0.0023775f //x=1.6 //y=2.77 //x2=2.375 \
 //y2=4.885
cc_189 ( N_A_c_177_n N_B_c_363_n ) capacitor c=0.00153582f //x=1.445 //y=4.885 \
 //x2=2.375 //y2=4.885
cc_190 ( N_A_c_180_n N_B_c_363_n ) capacitor c=0.00234902f //x=1.445 //y=4.885 \
 //x2=2.375 //y2=4.885
cc_191 ( N_A_c_191_n N_B_c_363_n ) capacitor c=0.00112509f //x=1.865 //y=4.975 \
 //x2=2.375 //y2=4.885
cc_192 ( N_A_c_192_n N_B_c_363_n ) capacitor c=0.00121814f //x=1.445 //y=4.885 \
 //x2=2.375 //y2=4.885
cc_193 ( N_A_M3_noxref_g N_B_M5_noxref_g ) capacitor c=0.0101077f //x=1.5 \
 //y=6.205 //x2=2.38 //y2=6.205
cc_194 ( N_A_M4_noxref_g N_B_M5_noxref_g ) capacitor c=0.109254f //x=1.94 \
 //y=6.205 //x2=2.38 //y2=6.205
cc_195 ( N_A_M4_noxref_g N_B_M6_noxref_g ) capacitor c=0.00945018f //x=1.94 \
 //y=6.205 //x2=2.82 //y2=6.205
cc_196 ( N_A_c_169_n N_B_c_353_n ) capacitor c=0.00128177f //x=1.405 //y=1.085 \
 //x2=2.375 //y2=1.085
cc_197 ( N_A_c_173_n N_B_c_353_n ) capacitor c=0.0126654f //x=1.935 //y=1.085 \
 //x2=2.375 //y2=1.085
cc_198 ( N_A_c_229_p N_B_c_393_n ) capacitor c=0.00149727f //x=1.405 //y=1.43 \
 //x2=2.375 //y2=1.435
cc_199 ( N_A_c_230_p N_B_c_393_n ) capacitor c=0.00111802f //x=1.405 //y=1.74 \
 //x2=2.375 //y2=1.435
cc_200 ( N_A_c_175_n N_B_c_393_n ) capacitor c=0.0126654f //x=1.935 //y=1.43 \
 //x2=2.375 //y2=1.435
cc_201 ( N_A_c_230_p N_B_c_396_n ) capacitor c=0.00116305f //x=1.405 //y=1.74 \
 //x2=2.375 //y2=1.74
cc_202 ( N_A_c_175_n N_B_c_396_n ) capacitor c=0.00938322f //x=1.935 //y=1.43 \
 //x2=2.375 //y2=1.74
cc_203 ( N_A_c_175_n N_B_c_355_n ) capacitor c=0.00131492f //x=1.935 //y=1.43 \
 //x2=2.75 //y2=1.585
cc_204 ( N_A_c_173_n N_B_c_356_n ) capacitor c=0.00135327f //x=1.935 //y=1.085 \
 //x2=2.905 //y2=1.085
cc_205 ( N_A_c_175_n N_B_c_400_n ) capacitor c=0.00151998f //x=1.935 //y=1.43 \
 //x2=2.905 //y2=1.435
cc_206 ( N_A_c_164_n N_B_c_358_n ) capacitor c=0.00184232f //x=1.6 //y=2.425 \
 //x2=2.34 //y2=2.26
cc_207 ( N_A_c_167_n N_B_c_358_n ) capacitor c=0.00266357f //x=1.6 //y=2.26 \
 //x2=2.34 //y2=2.26
cc_208 ( N_A_c_171_n N_B_c_358_n ) capacitor c=0.0177224f //x=1.405 //y=2.095 \
 //x2=2.34 //y2=2.26
cc_209 ( N_A_c_171_n N_B_c_404_n ) capacitor c=0.00636965f //x=1.405 //y=2.095 \
 //x2=2.34 //y2=2.095
cc_210 ( A N_B_c_371_n ) capacitor c=0.00117002f //x=1.6 //y=2.77 //x2=2.375 \
 //y2=4.885
cc_211 ( N_A_c_177_n N_B_c_371_n ) capacitor c=4.66993e-19 //x=1.445 //y=4.885 \
 //x2=2.375 //y2=4.885
cc_212 ( N_A_c_180_n N_B_c_371_n ) capacitor c=0.0022472f //x=1.445 //y=4.885 \
 //x2=2.375 //y2=4.885
cc_213 ( N_A_c_191_n N_B_c_371_n ) capacitor c=0.019933f //x=1.865 //y=4.975 \
 //x2=2.375 //y2=4.885
cc_214 ( N_A_c_192_n N_B_c_371_n ) capacitor c=0.00590438f //x=1.445 //y=4.885 \
 //x2=2.375 //y2=4.885
cc_215 ( A C ) capacitor c=0.00418084f //x=1.6 //y=2.77 //x2=3.45 //y2=2.77
cc_216 ( N_A_c_180_n N_C_c_490_n ) capacitor c=2.52182e-19 //x=1.445 //y=4.885 \
 //x2=3.45 //y2=4.765
cc_217 ( N_A_c_164_n N_Y_c_664_n ) capacitor c=0.00147045f //x=1.6 //y=2.425 \
 //x2=1.67 //y2=1.31
cc_218 ( N_A_c_167_n N_Y_c_664_n ) capacitor c=7.07025e-19 //x=1.6 //y=2.26 \
 //x2=1.67 //y2=1.31
cc_219 ( N_A_c_169_n N_Y_c_664_n ) capacitor c=7.80351e-19 //x=1.405 //y=1.085 \
 //x2=1.67 //y2=1.31
cc_220 ( N_A_c_229_p N_Y_c_664_n ) capacitor c=0.00391325f //x=1.405 //y=1.43 \
 //x2=1.67 //y2=1.31
cc_221 ( N_A_c_252_p N_Y_c_664_n ) capacitor c=5.34749e-19 //x=1.78 //y=0.93 \
 //x2=1.67 //y2=1.31
cc_222 ( N_A_c_253_p N_Y_c_664_n ) capacitor c=6.20502e-19 //x=1.78 //y=1.585 \
 //x2=1.67 //y2=1.31
cc_223 ( N_A_c_173_n N_Y_c_664_n ) capacitor c=9.60468e-19 //x=1.935 //y=1.085 \
 //x2=1.67 //y2=1.31
cc_224 ( N_A_c_175_n N_Y_c_664_n ) capacitor c=0.00221072f //x=1.935 //y=1.43 \
 //x2=1.67 //y2=1.31
cc_225 ( N_A_c_229_p N_Y_c_668_n ) capacitor c=0.00127432f //x=1.405 //y=1.43 \
 //x2=1.67 //y2=1.75
cc_226 ( N_A_c_230_p N_Y_c_668_n ) capacitor c=0.00350316f //x=1.405 //y=1.74 \
 //x2=1.67 //y2=1.75
cc_227 ( N_A_c_171_n N_Y_c_668_n ) capacitor c=0.00379925f //x=1.405 //y=2.095 \
 //x2=1.67 //y2=1.75
cc_228 ( N_A_c_253_p N_Y_c_668_n ) capacitor c=0.00702073f //x=1.78 //y=1.585 \
 //x2=1.67 //y2=1.75
cc_229 ( N_A_c_175_n N_Y_c_668_n ) capacitor c=0.00253555f //x=1.935 //y=1.43 \
 //x2=1.67 //y2=1.75
cc_230 ( N_A_c_175_n N_Y_c_669_n ) capacitor c=7.25274e-19 //x=1.935 //y=1.43 \
 //x2=2.555 //y2=1.835
cc_231 ( N_A_c_164_n N_Y_c_703_n ) capacitor c=0.0171527f //x=1.6 //y=2.425 \
 //x2=1.755 //y2=1.835
cc_232 ( N_A_c_167_n N_Y_c_703_n ) capacitor c=0.00293491f //x=1.6 //y=2.26 \
 //x2=1.755 //y2=1.835
cc_233 ( N_A_c_171_n N_Y_c_703_n ) capacitor c=0.00113924f //x=1.405 //y=2.095 \
 //x2=1.755 //y2=1.835
cc_234 ( N_A_c_175_n N_Y_c_677_n ) capacitor c=6.29838e-19 //x=1.935 //y=1.43 \
 //x2=2.64 //y2=1.75
cc_235 ( N_A_c_164_n N_Y_M0_noxref_d ) capacitor c=0.00138074f //x=1.6 \
 //y=2.425 //x2=1.48 //y2=1.085
cc_236 ( N_A_c_167_n N_Y_M0_noxref_d ) capacitor c=0.00150031f //x=1.6 \
 //y=2.26 //x2=1.48 //y2=1.085
cc_237 ( N_A_c_169_n N_Y_M0_noxref_d ) capacitor c=8.46111e-19 //x=1.405 \
 //y=1.085 //x2=1.48 //y2=1.085
cc_238 ( N_A_c_229_p N_Y_M0_noxref_d ) capacitor c=0.00237422f //x=1.405 \
 //y=1.43 //x2=1.48 //y2=1.085
cc_239 ( N_A_c_171_n N_Y_M0_noxref_d ) capacitor c=4.64071e-19 //x=1.405 \
 //y=2.095 //x2=1.48 //y2=1.085
cc_240 ( N_A_c_252_p N_Y_M0_noxref_d ) capacitor c=0.0020782f //x=1.78 \
 //y=0.93 //x2=1.48 //y2=1.085
cc_241 ( N_A_c_253_p N_Y_M0_noxref_d ) capacitor c=0.00344131f //x=1.78 \
 //y=1.585 //x2=1.48 //y2=1.085
cc_242 ( N_A_c_173_n N_Y_M0_noxref_d ) capacitor c=0.00139206f //x=1.935 \
 //y=1.085 //x2=1.48 //y2=1.085
cc_243 ( N_A_c_175_n N_Y_M0_noxref_d ) capacitor c=0.00237422f //x=1.935 \
 //y=1.43 //x2=1.48 //y2=1.085
cc_244 ( N_VDD_c_276_n N_B_M5_noxref_g ) capacitor c=0.00724995f //x=4.56 \
 //y=7.58 //x2=2.38 //y2=6.205
cc_245 ( N_VDD_c_276_n N_B_M6_noxref_g ) capacitor c=0.00782837f //x=4.56 \
 //y=7.58 //x2=2.82 //y2=6.205
cc_246 ( N_VDD_c_276_n N_C_c_491_n ) capacitor c=0.0018189f //x=4.56 //y=7.58 \
 //x2=3.45 //y2=4.885
cc_247 ( N_VDD_c_276_n N_C_M7_noxref_g ) capacitor c=0.00782837f //x=4.56 \
 //y=7.58 //x2=3.86 //y2=6.205
cc_248 ( N_VDD_c_276_n N_C_M8_noxref_g ) capacitor c=0.00782837f //x=4.56 \
 //y=7.58 //x2=4.3 //y2=6.205
cc_249 ( N_VDD_c_276_n N_C_c_494_n ) capacitor c=0.0265828f //x=4.56 //y=7.58 \
 //x2=4.225 //y2=4.975
cc_250 ( N_VDD_c_291_n N_noxref_7_c_588_n ) capacitor c=0.00446119f //x=4.56 \
 //y=7.58 //x2=3.555 //y2=5.39
cc_251 ( N_VDD_c_276_n N_noxref_7_c_588_n ) capacitor c=0.00365626f //x=4.56 \
 //y=7.58 //x2=3.555 //y2=5.39
cc_252 ( N_VDD_c_276_n N_noxref_7_c_609_n ) capacitor c=0.00219567f //x=4.56 \
 //y=7.58 //x2=4.405 //y2=7.09
cc_253 ( N_VDD_c_291_n N_noxref_7_c_597_n ) capacitor c=0.0977883f //x=4.56 \
 //y=7.58 //x2=3.64 //y2=6.92
cc_254 ( N_VDD_c_276_n N_noxref_7_c_597_n ) capacitor c=0.0233554f //x=4.56 \
 //y=7.58 //x2=3.64 //y2=6.92
cc_255 ( N_VDD_c_291_n N_noxref_7_c_600_n ) capacitor c=0.00187896f //x=4.56 \
 //y=7.58 //x2=4.52 //y2=6.92
cc_256 ( N_VDD_c_276_n N_noxref_7_c_600_n ) capacitor c=0.0134265f //x=4.56 \
 //y=7.58 //x2=4.52 //y2=6.92
cc_257 ( N_VDD_c_276_n N_noxref_7_c_601_n ) capacitor c=0.00664553f //x=4.56 \
 //y=7.58 //x2=2.6 //y2=5.56
cc_258 ( N_VDD_M3_noxref_d N_noxref_7_c_601_n ) capacitor c=0.00557191f \
 //x=1.575 //y=5.205 //x2=2.6 //y2=5.56
cc_259 ( N_VDD_c_291_n N_noxref_7_c_605_n ) capacitor c=0.00206569f //x=4.56 \
 //y=7.58 //x2=3.64 //y2=5.9
cc_260 ( N_VDD_c_276_n N_noxref_7_c_605_n ) capacitor c=0.00957401f //x=4.56 \
 //y=7.58 //x2=3.64 //y2=5.9
cc_261 ( N_VDD_c_291_n N_noxref_7_M8_noxref_d ) capacitor c=0.00206569f \
 //x=4.56 //y=7.58 //x2=4.375 //y2=5.205
cc_262 ( N_VDD_c_276_n N_noxref_7_M8_noxref_d ) capacitor c=0.0534938f \
 //x=4.56 //y=7.58 //x2=4.375 //y2=5.205
cc_263 ( N_VDD_c_276_n Y ) capacitor c=0.0354f //x=4.56 //y=7.58 //x2=4.19 \
 //y2=2.4
cc_264 ( N_VDD_c_276_n N_Y_c_734_n ) capacitor c=0.0052314f //x=4.56 //y=7.58 \
 //x2=4.08 //y2=5.77
cc_265 ( N_VDD_c_276_n N_Y_c_705_n ) capacitor c=0.00925422f //x=4.56 //y=7.58 \
 //x2=4.08 //y2=5.9
cc_266 ( B C ) capacitor c=0.0722116f //x=2.34 //y=2.4 //x2=3.45 //y2=2.77
cc_267 ( N_B_c_361_n C ) capacitor c=4.97833e-19 //x=2.34 //y=4.74 //x2=3.45 \
 //y2=2.77
cc_268 ( N_B_c_363_n C ) capacitor c=3.76054e-19 //x=2.375 //y=4.885 //x2=3.45 \
 //y2=2.77
cc_269 ( B N_C_c_480_n ) capacitor c=6.43877e-19 //x=2.34 //y=2.4 //x2=3.45 \
 //y2=2.405
cc_270 ( N_B_c_349_n N_C_c_480_n ) capacitor c=0.0115855f //x=2.34 //y=2.39 \
 //x2=3.45 //y2=2.405
cc_271 ( N_B_c_350_n N_C_c_480_n ) capacitor c=5.84901e-19 //x=2.34 //y=2.26 \
 //x2=3.45 //y2=2.405
cc_272 ( N_B_c_361_n N_C_c_490_n ) capacitor c=0.0119617f //x=2.34 //y=4.74 \
 //x2=3.45 //y2=4.765
cc_273 ( N_B_c_363_n N_C_c_490_n ) capacitor c=6.02667e-19 //x=2.375 //y=4.885 \
 //x2=3.45 //y2=4.765
cc_274 ( N_B_c_349_n N_C_c_481_n ) capacitor c=4.43682e-19 //x=2.34 //y=2.39 \
 //x2=3.45 //y2=2.26
cc_275 ( N_B_c_350_n N_C_c_481_n ) capacitor c=0.00114266f //x=2.34 //y=2.26 \
 //x2=3.45 //y2=2.26
cc_276 ( N_B_c_358_n N_C_c_481_n ) capacitor c=3.80079e-19 //x=2.34 //y=2.26 \
 //x2=3.45 //y2=2.26
cc_277 ( N_B_c_361_n N_C_c_491_n ) capacitor c=6.87335e-19 //x=2.34 //y=4.74 \
 //x2=3.45 //y2=4.885
cc_278 ( N_B_c_363_n N_C_c_491_n ) capacitor c=0.00124702f //x=2.375 //y=4.885 \
 //x2=3.45 //y2=4.885
cc_279 ( N_B_c_371_n N_C_c_491_n ) capacitor c=4.01223e-19 //x=2.375 //y=4.885 \
 //x2=3.45 //y2=4.885
cc_280 ( N_B_M6_noxref_g N_C_M7_noxref_g ) capacitor c=0.0359752f //x=2.82 \
 //y=6.205 //x2=3.86 //y2=6.205
cc_281 ( N_B_c_353_n N_C_c_483_n ) capacitor c=0.00133966f //x=2.375 //y=1.085 \
 //x2=3.345 //y2=1.085
cc_282 ( N_B_c_356_n N_C_c_483_n ) capacitor c=0.00886682f //x=2.905 //y=1.085 \
 //x2=3.345 //y2=1.085
cc_283 ( N_B_c_393_n N_C_c_512_n ) capacitor c=0.0015172f //x=2.375 //y=1.435 \
 //x2=3.345 //y2=1.435
cc_284 ( N_B_c_400_n N_C_c_512_n ) capacitor c=0.00886682f //x=2.905 //y=1.435 \
 //x2=3.345 //y2=1.435
cc_285 ( N_B_c_396_n N_C_c_514_n ) capacitor c=0.00296957f //x=2.375 //y=1.74 \
 //x2=3.345 //y2=1.74
cc_286 ( N_B_c_355_n N_C_c_514_n ) capacitor c=0.0182761f //x=2.75 //y=1.585 \
 //x2=3.345 //y2=1.74
cc_287 ( N_B_c_404_n N_C_c_516_n ) capacitor c=0.00581071f //x=2.34 //y=2.095 \
 //x2=3.345 //y2=2.095
cc_288 ( N_B_c_355_n N_C_c_485_n ) capacitor c=0.00131492f //x=2.75 //y=1.585 \
 //x2=3.72 //y2=1.585
cc_289 ( N_B_c_356_n N_C_c_486_n ) capacitor c=0.00135327f //x=2.905 //y=1.085 \
 //x2=3.875 //y2=1.085
cc_290 ( N_B_c_400_n N_C_c_519_n ) capacitor c=0.0015172f //x=2.905 //y=1.435 \
 //x2=3.875 //y2=1.435
cc_291 ( N_B_c_349_n N_C_c_488_n ) capacitor c=0.00151737f //x=2.34 //y=2.39 \
 //x2=3.345 //y2=2.26
cc_292 ( N_B_c_350_n N_C_c_488_n ) capacitor c=0.0021413f //x=2.34 //y=2.26 \
 //x2=3.345 //y2=2.26
cc_293 ( N_B_c_358_n N_C_c_488_n ) capacitor c=0.00926648f //x=2.34 //y=2.26 \
 //x2=3.345 //y2=2.26
cc_294 ( N_B_c_361_n N_C_c_523_n ) capacitor c=0.00135035f //x=2.34 //y=4.74 \
 //x2=3.45 //y2=4.885
cc_295 ( N_B_c_363_n N_C_c_523_n ) capacitor c=0.00193614f //x=2.375 //y=4.885 \
 //x2=3.45 //y2=4.885
cc_296 ( N_B_c_442_p N_C_c_523_n ) capacitor c=0.0107159f //x=2.745 //y=4.975 \
 //x2=3.45 //y2=4.885
cc_297 ( N_B_c_371_n N_C_c_523_n ) capacitor c=0.0051116f //x=2.375 //y=4.885 \
 //x2=3.45 //y2=4.885
cc_298 ( N_B_M6_noxref_g N_noxref_7_c_588_n ) capacitor c=0.0108199f //x=2.82 \
 //y=6.205 //x2=3.555 //y2=5.39
cc_299 ( N_B_M6_noxref_g N_noxref_7_c_591_n ) capacitor c=0.00165119f //x=2.82 \
 //y=6.205 //x2=3.64 //y2=5.77
cc_300 ( N_B_c_361_n N_noxref_7_c_593_n ) capacitor c=9.00765e-19 //x=2.34 \
 //y=4.74 //x2=2.6 //y2=5.39
cc_301 ( N_B_M5_noxref_g N_noxref_7_c_593_n ) capacitor c=0.00186001f //x=2.38 \
 //y=6.205 //x2=2.6 //y2=5.39
cc_302 ( N_B_M6_noxref_g N_noxref_7_c_593_n ) capacitor c=0.00210236f //x=2.82 \
 //y=6.205 //x2=2.6 //y2=5.39
cc_303 ( N_B_c_442_p N_noxref_7_c_593_n ) capacitor c=0.00213157f //x=2.745 \
 //y=4.975 //x2=2.6 //y2=5.39
cc_304 ( N_B_M6_noxref_g N_noxref_7_c_597_n ) capacitor c=4.79118e-19 //x=2.82 \
 //y=6.205 //x2=3.64 //y2=6.92
cc_305 ( N_B_M5_noxref_g N_noxref_7_c_601_n ) capacitor c=0.0120591f //x=2.38 \
 //y=6.205 //x2=2.6 //y2=5.56
cc_306 ( N_B_M6_noxref_g N_noxref_7_c_601_n ) capacitor c=0.0159649f //x=2.82 \
 //y=6.205 //x2=2.6 //y2=5.56
cc_307 ( N_B_c_442_p N_noxref_7_c_601_n ) capacitor c=0.00293135f //x=2.745 \
 //y=4.975 //x2=2.6 //y2=5.56
cc_308 ( B Y ) capacitor c=0.00421067f //x=2.34 //y=2.4 //x2=4.19 //y2=2.4
cc_309 ( N_B_c_349_n Y ) capacitor c=3.05675e-19 //x=2.34 //y=2.39 //x2=4.19 \
 //y2=2.4
cc_310 ( N_B_c_396_n N_Y_c_668_n ) capacitor c=6.83023e-19 //x=2.375 //y=1.74 \
 //x2=1.67 //y2=1.75
cc_311 ( N_B_c_349_n N_Y_c_669_n ) capacitor c=0.030811f //x=2.34 //y=2.39 \
 //x2=2.555 //y2=1.835
cc_312 ( N_B_c_361_n N_Y_c_669_n ) capacitor c=3.68612e-19 //x=2.34 //y=4.74 \
 //x2=2.555 //y2=1.835
cc_313 ( N_B_c_350_n N_Y_c_669_n ) capacitor c=0.00494851f //x=2.34 //y=2.26 \
 //x2=2.555 //y2=1.835
cc_314 ( N_B_c_358_n N_Y_c_669_n ) capacitor c=0.00139093f //x=2.34 //y=2.26 \
 //x2=2.555 //y2=1.835
cc_315 ( N_B_c_404_n N_Y_c_669_n ) capacitor c=0.00778097f //x=2.34 //y=2.095 \
 //x2=2.555 //y2=1.835
cc_316 ( N_B_c_353_n N_Y_c_673_n ) capacitor c=8.454e-19 //x=2.375 //y=1.085 \
 //x2=2.64 //y2=1.31
cc_317 ( N_B_c_393_n N_Y_c_673_n ) capacitor c=0.00221072f //x=2.375 //y=1.435 \
 //x2=2.64 //y2=1.31
cc_318 ( N_B_c_464_p N_Y_c_673_n ) capacitor c=5.42035e-19 //x=2.75 //y=0.93 \
 //x2=2.64 //y2=1.31
cc_319 ( N_B_c_355_n N_Y_c_673_n ) capacitor c=7.84428e-19 //x=2.75 //y=1.585 \
 //x2=2.64 //y2=1.31
cc_320 ( N_B_c_356_n N_Y_c_673_n ) capacitor c=7.61925e-19 //x=2.905 //y=1.085 \
 //x2=2.64 //y2=1.31
cc_321 ( N_B_c_400_n N_Y_c_673_n ) capacitor c=0.00220852f //x=2.905 //y=1.435 \
 //x2=2.64 //y2=1.31
cc_322 ( N_B_c_393_n N_Y_c_677_n ) capacitor c=7.7986e-19 //x=2.375 //y=1.435 \
 //x2=2.64 //y2=1.75
cc_323 ( N_B_c_396_n N_Y_c_677_n ) capacitor c=0.00253868f //x=2.375 //y=1.74 \
 //x2=2.64 //y2=1.75
cc_324 ( N_B_c_355_n N_Y_c_677_n ) capacitor c=0.00845712f //x=2.75 //y=1.585 \
 //x2=2.64 //y2=1.75
cc_325 ( N_B_c_400_n N_Y_c_677_n ) capacitor c=7.7986e-19 //x=2.905 //y=1.435 \
 //x2=2.64 //y2=1.75
cc_326 ( N_B_c_355_n N_Y_c_678_n ) capacitor c=7.25274e-19 //x=2.75 //y=1.585 \
 //x2=3.525 //y2=1.835
cc_327 ( N_B_c_355_n N_Y_c_686_n ) capacitor c=6.29838e-19 //x=2.75 //y=1.585 \
 //x2=3.61 //y2=1.75
cc_328 ( N_B_c_353_n N_Y_M1_noxref_d ) capacitor c=8.51904e-19 //x=2.375 \
 //y=1.085 //x2=2.45 //y2=1.085
cc_329 ( N_B_c_393_n N_Y_M1_noxref_d ) capacitor c=0.00237422f //x=2.375 \
 //y=1.435 //x2=2.45 //y2=1.085
cc_330 ( N_B_c_464_p N_Y_M1_noxref_d ) capacitor c=0.0020782f //x=2.75 \
 //y=0.93 //x2=2.45 //y2=1.085
cc_331 ( N_B_c_355_n N_Y_M1_noxref_d ) capacitor c=0.00356097f //x=2.75 \
 //y=1.585 //x2=2.45 //y2=1.085
cc_332 ( N_B_c_356_n N_Y_M1_noxref_d ) capacitor c=8.55887e-19 //x=2.905 \
 //y=1.085 //x2=2.45 //y2=1.085
cc_333 ( N_B_c_400_n N_Y_M1_noxref_d ) capacitor c=0.00237422f //x=2.905 \
 //y=1.435 //x2=2.45 //y2=1.085
cc_334 ( N_C_c_480_n N_noxref_7_c_588_n ) capacitor c=3.89231e-19 //x=3.45 \
 //y=2.405 //x2=3.555 //y2=5.39
cc_335 ( N_C_c_490_n N_noxref_7_c_588_n ) capacitor c=0.02207f //x=3.45 \
 //y=4.765 //x2=3.555 //y2=5.39
cc_336 ( N_C_c_491_n N_noxref_7_c_588_n ) capacitor c=0.00449448f //x=3.45 \
 //y=4.885 //x2=3.555 //y2=5.39
cc_337 ( N_C_M7_noxref_g N_noxref_7_c_588_n ) capacitor c=0.00412344f //x=3.86 \
 //y=6.205 //x2=3.555 //y2=5.39
cc_338 ( N_C_c_523_n N_noxref_7_c_588_n ) capacitor c=0.00462848f //x=3.45 \
 //y=4.885 //x2=3.555 //y2=5.39
cc_339 ( N_C_M7_noxref_g N_noxref_7_c_591_n ) capacitor c=0.0025714f //x=3.86 \
 //y=6.205 //x2=3.64 //y2=5.77
cc_340 ( N_C_c_533_p N_noxref_7_c_591_n ) capacitor c=6.67396e-19 //x=3.785 \
 //y=4.975 //x2=3.64 //y2=5.77
cc_341 ( N_C_M7_noxref_g N_noxref_7_c_609_n ) capacitor c=0.00998354f //x=3.86 \
 //y=6.205 //x2=4.405 //y2=7.09
cc_342 ( N_C_M8_noxref_g N_noxref_7_c_609_n ) capacitor c=0.0104174f //x=4.3 \
 //y=6.205 //x2=4.405 //y2=7.09
cc_343 ( N_C_M7_noxref_g N_noxref_7_c_597_n ) capacitor c=0.00266045f //x=3.86 \
 //y=6.205 //x2=3.64 //y2=6.92
cc_344 ( N_C_M8_noxref_g N_noxref_7_c_600_n ) capacitor c=0.00394587f //x=4.3 \
 //y=6.205 //x2=4.52 //y2=6.92
cc_345 ( N_C_c_490_n N_noxref_7_c_605_n ) capacitor c=3.85234e-19 //x=3.45 \
 //y=4.765 //x2=3.64 //y2=5.9
cc_346 ( N_C_M7_noxref_g N_noxref_7_c_605_n ) capacitor c=0.0227892f //x=3.86 \
 //y=6.205 //x2=3.64 //y2=5.9
cc_347 ( N_C_c_523_n N_noxref_7_c_605_n ) capacitor c=0.00281079f //x=3.45 \
 //y=4.885 //x2=3.64 //y2=5.9
cc_348 ( N_C_M8_noxref_g N_noxref_7_M8_noxref_d ) capacitor c=0.0365206f \
 //x=4.3 //y=6.205 //x2=4.375 //y2=5.205
cc_349 ( C Y ) capacitor c=0.112702f //x=3.45 //y=2.77 //x2=4.19 //y2=2.4
cc_350 ( N_C_c_480_n Y ) capacitor c=0.0161611f //x=3.45 //y=2.405 //x2=4.19 \
 //y2=2.4
cc_351 ( N_C_c_490_n Y ) capacitor c=0.0162663f //x=3.45 //y=4.765 //x2=4.19 \
 //y2=2.4
cc_352 ( N_C_c_481_n Y ) capacitor c=0.0048697f //x=3.45 //y=2.26 //x2=4.19 \
 //y2=2.4
cc_353 ( N_C_c_491_n Y ) capacitor c=0.0055568f //x=3.45 //y=4.885 //x2=4.19 \
 //y2=2.4
cc_354 ( N_C_M7_noxref_g Y ) capacitor c=0.00478791f //x=3.86 //y=6.205 \
 //x2=4.19 //y2=2.4
cc_355 ( N_C_M8_noxref_g Y ) capacitor c=0.00450478f //x=4.3 //y=6.205 \
 //x2=4.19 //y2=2.4
cc_356 ( N_C_c_516_n Y ) capacitor c=0.00300603f //x=3.345 //y=2.095 //x2=4.19 \
 //y2=2.4
cc_357 ( N_C_c_494_n Y ) capacitor c=0.00872849f //x=4.225 //y=4.975 //x2=4.19 \
 //y2=2.4
cc_358 ( N_C_c_488_n Y ) capacitor c=0.00278769f //x=3.345 //y=2.26 //x2=4.19 \
 //y2=2.4
cc_359 ( N_C_c_523_n Y ) capacitor c=0.00140919f //x=3.45 //y=4.885 //x2=4.19 \
 //y2=2.4
cc_360 ( N_C_c_514_n N_Y_c_677_n ) capacitor c=0.00120307f //x=3.345 //y=1.74 \
 //x2=2.64 //y2=1.75
cc_361 ( N_C_c_480_n N_Y_c_678_n ) capacitor c=0.0286697f //x=3.45 //y=2.405 \
 //x2=3.525 //y2=1.835
cc_362 ( N_C_c_481_n N_Y_c_678_n ) capacitor c=0.00451545f //x=3.45 //y=2.26 \
 //x2=3.525 //y2=1.835
cc_363 ( N_C_c_516_n N_Y_c_678_n ) capacitor c=0.00915686f //x=3.345 //y=2.095 \
 //x2=3.525 //y2=1.835
cc_364 ( N_C_c_488_n N_Y_c_678_n ) capacitor c=0.00129562f //x=3.345 //y=2.26 \
 //x2=3.525 //y2=1.835
cc_365 ( N_C_c_481_n N_Y_c_682_n ) capacitor c=2.35917e-19 //x=3.45 //y=2.26 \
 //x2=3.61 //y2=1.325
cc_366 ( N_C_c_483_n N_Y_c_682_n ) capacitor c=0.00114203f //x=3.345 //y=1.085 \
 //x2=3.61 //y2=1.325
cc_367 ( N_C_c_512_n N_Y_c_682_n ) capacitor c=0.00235402f //x=3.345 //y=1.435 \
 //x2=3.61 //y2=1.325
cc_368 ( N_C_c_561_p N_Y_c_682_n ) capacitor c=5.45609e-19 //x=3.72 //y=0.93 \
 //x2=3.61 //y2=1.325
cc_369 ( N_C_c_485_n N_Y_c_682_n ) capacitor c=4.1601e-19 //x=3.72 //y=1.585 \
 //x2=3.61 //y2=1.325
cc_370 ( N_C_c_486_n N_Y_c_682_n ) capacitor c=0.00103216f //x=3.875 //y=1.085 \
 //x2=3.61 //y2=1.325
cc_371 ( N_C_c_519_n N_Y_c_682_n ) capacitor c=0.00416435f //x=3.875 //y=1.435 \
 //x2=3.61 //y2=1.325
cc_372 ( N_C_c_512_n N_Y_c_686_n ) capacitor c=7.7986e-19 //x=3.345 //y=1.435 \
 //x2=3.61 //y2=1.75
cc_373 ( N_C_c_514_n N_Y_c_686_n ) capacitor c=0.0030633f //x=3.345 //y=1.74 \
 //x2=3.61 //y2=1.75
cc_374 ( N_C_c_485_n N_Y_c_686_n ) capacitor c=0.00944764f //x=3.72 //y=1.585 \
 //x2=3.61 //y2=1.75
cc_375 ( N_C_c_519_n N_Y_c_686_n ) capacitor c=0.00135417f //x=3.875 //y=1.435 \
 //x2=3.61 //y2=1.75
cc_376 ( N_C_c_485_n N_Y_c_688_n ) capacitor c=0.0045388f //x=3.72 //y=1.585 \
 //x2=4.105 //y2=1.835
cc_377 ( N_C_M7_noxref_g N_Y_c_734_n ) capacitor c=0.00140876f //x=3.86 \
 //y=6.205 //x2=4.08 //y2=5.77
cc_378 ( N_C_M8_noxref_g N_Y_c_734_n ) capacitor c=0.00854816f //x=4.3 \
 //y=6.205 //x2=4.08 //y2=5.77
cc_379 ( N_C_c_480_n N_Y_c_792_n ) capacitor c=0.00327478f //x=3.45 //y=2.405 \
 //x2=3.61 //y2=1.835
cc_380 ( N_C_c_481_n N_Y_c_792_n ) capacitor c=0.00154812f //x=3.45 //y=2.26 \
 //x2=3.61 //y2=1.835
cc_381 ( N_C_M7_noxref_g N_Y_c_704_n ) capacitor c=0.00234737f //x=3.86 \
 //y=6.205 //x2=4.19 //y2=5.39
cc_382 ( N_C_M8_noxref_g N_Y_c_704_n ) capacitor c=0.00478286f //x=4.3 \
 //y=6.205 //x2=4.19 //y2=5.39
cc_383 ( N_C_c_494_n N_Y_c_704_n ) capacitor c=0.00162779f //x=4.225 //y=4.975 \
 //x2=4.19 //y2=5.39
cc_384 ( N_C_M7_noxref_g N_Y_c_705_n ) capacitor c=0.00896756f //x=3.86 \
 //y=6.205 //x2=4.08 //y2=5.9
cc_385 ( N_C_M8_noxref_g N_Y_c_705_n ) capacitor c=0.00896756f //x=4.3 \
 //y=6.205 //x2=4.08 //y2=5.9
cc_386 ( N_C_c_494_n N_Y_c_705_n ) capacitor c=0.00165738f //x=4.225 //y=4.975 \
 //x2=4.08 //y2=5.9
cc_387 ( N_C_c_480_n N_Y_M2_noxref_d ) capacitor c=8.91766e-19 //x=3.45 \
 //y=2.405 //x2=3.42 //y2=1.085
cc_388 ( N_C_c_481_n N_Y_M2_noxref_d ) capacitor c=5.40451e-19 //x=3.45 \
 //y=2.26 //x2=3.42 //y2=1.085
cc_389 ( N_C_c_483_n N_Y_M2_noxref_d ) capacitor c=0.00145956f //x=3.345 \
 //y=1.085 //x2=3.42 //y2=1.085
cc_390 ( N_C_c_512_n N_Y_M2_noxref_d ) capacitor c=0.00237422f //x=3.345 \
 //y=1.435 //x2=3.42 //y2=1.085
cc_391 ( N_C_c_561_p N_Y_M2_noxref_d ) capacitor c=0.0020782f //x=3.72 \
 //y=0.93 //x2=3.42 //y2=1.085
cc_392 ( N_C_c_485_n N_Y_M2_noxref_d ) capacitor c=0.003549f //x=3.72 \
 //y=1.585 //x2=3.42 //y2=1.085
cc_393 ( N_C_c_486_n N_Y_M2_noxref_d ) capacitor c=8.55887e-19 //x=3.875 \
 //y=1.085 //x2=3.42 //y2=1.085
cc_394 ( N_C_c_519_n N_Y_M2_noxref_d ) capacitor c=0.00237422f //x=3.875 \
 //y=1.435 //x2=3.42 //y2=1.085
cc_395 ( N_noxref_7_c_593_n N_Y_c_669_n ) capacitor c=0.00522451f //x=2.6 \
 //y=5.39 //x2=2.555 //y2=1.835
cc_396 ( N_noxref_7_c_588_n N_Y_c_673_n ) capacitor c=2.03695e-19 //x=3.555 \
 //y=5.39 //x2=2.64 //y2=1.31
cc_397 ( N_noxref_7_c_593_n N_Y_c_673_n ) capacitor c=2.29432e-19 //x=2.6 \
 //y=5.39 //x2=2.64 //y2=1.31
cc_398 ( N_noxref_7_c_588_n N_Y_c_678_n ) capacitor c=0.00500529f //x=3.555 \
 //y=5.39 //x2=3.525 //y2=1.835
cc_399 ( N_noxref_7_c_591_n N_Y_c_688_n ) capacitor c=3.49767e-19 //x=3.64 \
 //y=5.77 //x2=4.105 //y2=1.835
cc_400 ( N_noxref_7_c_591_n N_Y_c_734_n ) capacitor c=0.0589193f //x=3.64 \
 //y=5.77 //x2=4.08 //y2=5.77
cc_401 ( N_noxref_7_c_609_n N_Y_c_734_n ) capacitor c=0.00729607f //x=4.405 \
 //y=7.09 //x2=4.08 //y2=5.77
cc_402 ( N_noxref_7_c_593_n N_Y_c_734_n ) capacitor c=0.00100155f //x=2.6 \
 //y=5.39 //x2=4.08 //y2=5.77
cc_403 ( N_noxref_7_c_605_n N_Y_c_734_n ) capacitor c=0.00425215f //x=3.64 \
 //y=5.9 //x2=4.08 //y2=5.77
cc_404 ( N_noxref_7_M8_noxref_d N_Y_c_734_n ) capacitor c=0.00826418f \
 //x=4.375 //y=5.205 //x2=4.08 //y2=5.77
cc_405 ( N_noxref_7_c_588_n N_Y_c_704_n ) capacitor c=0.0184026f //x=3.555 \
 //y=5.39 //x2=4.19 //y2=5.39
cc_406 ( N_noxref_7_c_609_n N_Y_c_704_n ) capacitor c=0.00145412f //x=4.405 \
 //y=7.09 //x2=4.19 //y2=5.39
cc_407 ( N_noxref_7_c_601_n N_Y_c_704_n ) capacitor c=4.62901e-19 //x=2.6 \
 //y=5.56 //x2=4.19 //y2=5.39
cc_408 ( N_noxref_7_c_591_n N_Y_c_705_n ) capacitor c=0.00432732f //x=3.64 \
 //y=5.77 //x2=4.08 //y2=5.9
cc_409 ( N_noxref_7_c_609_n N_Y_c_705_n ) capacitor c=0.00368853f //x=4.405 \
 //y=7.09 //x2=4.08 //y2=5.9
cc_410 ( N_noxref_7_c_597_n N_Y_c_705_n ) capacitor c=8.19351e-19 //x=3.64 \
 //y=6.92 //x2=4.08 //y2=5.9
cc_411 ( N_noxref_7_c_600_n N_Y_c_705_n ) capacitor c=8.19351e-19 //x=4.52 \
 //y=6.92 //x2=4.08 //y2=5.9
cc_412 ( N_noxref_7_c_605_n N_Y_c_705_n ) capacitor c=0.0524362f //x=3.64 \
 //y=5.9 //x2=4.08 //y2=5.9
cc_413 ( N_noxref_7_M8_noxref_d N_Y_c_705_n ) capacitor c=0.0481518f //x=4.375 \
 //y=5.205 //x2=4.08 //y2=5.9
