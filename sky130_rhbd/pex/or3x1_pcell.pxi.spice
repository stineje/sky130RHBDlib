// File: or3x1_pcell.spi.OR3X1_PCELL.pxi
// Created: Sun Apr 12 08:43:24 2026
//
simulator lang=spectre
x_PM_OR3X1_PCELL\%noxref_1 ( N_noxref_1_c_1_p N_noxref_1_c_47_p \
 N_noxref_1_c_2_p N_noxref_1_c_70_p N_noxref_1_c_3_p N_noxref_1_c_50_p \
 N_noxref_1_c_4_p N_noxref_1_c_5_p N_noxref_1_c_33_p N_noxref_1_c_6_p \
 N_noxref_1_c_108_p N_noxref_1_c_131_p N_noxref_1_c_7_p N_noxref_1_c_109_p \
 N_noxref_1_c_35_p N_noxref_1_c_8_p N_noxref_1_c_102_p N_noxref_1_c_159_p \
 N_noxref_1_c_72_p N_noxref_1_c_9_p N_noxref_1_c_252_p N_noxref_1_c_10_p \
 N_noxref_1_c_167_p N_noxref_1_c_123_p N_noxref_1_c_37_p N_noxref_1_c_73_p \
 N_noxref_1_c_11_p N_noxref_1_c_103_p N_noxref_1_M3_noxref_g \
 N_noxref_1_M10_noxref_g N_noxref_1_M11_noxref_g N_noxref_1_c_30_p \
 N_noxref_1_c_231_p N_noxref_1_c_63_p N_noxref_1_c_39_p N_noxref_1_c_118_p \
 N_noxref_1_c_115_p N_noxref_1_c_65_p N_noxref_1_c_234_p N_noxref_1_c_32_p \
 N_noxref_1_c_67_p N_noxref_1_c_31_p N_noxref_1_M0_noxref_d \
 N_noxref_1_M1_noxref_d N_noxref_1_M2_noxref_d N_noxref_1_M8_noxref_d )  \
 PM_OR3X1_PCELL\%noxref_1
x_PM_OR3X1_PCELL\%noxref_2 ( N_noxref_2_c_276_n N_noxref_2_c_290_n \
 N_noxref_2_c_293_n N_noxref_2_c_297_n N_noxref_2_c_301_n N_noxref_2_c_303_n \
 N_noxref_2_c_307_n N_noxref_2_c_346_p N_noxref_2_c_308_n N_noxref_2_c_316_n \
 N_noxref_2_M0_noxref_s N_noxref_2_M3_noxref_s )  PM_OR3X1_PCELL\%noxref_2
x_PM_OR3X1_PCELL\%noxref_3 ( N_noxref_3_c_395_n N_noxref_3_c_448_p \
 N_noxref_3_c_402_p N_noxref_3_c_397_n N_noxref_3_c_413_p N_noxref_3_c_424_p \
 N_noxref_3_c_403_p N_noxref_3_c_414_p N_noxref_3_M4_noxref_s \
 N_noxref_3_M5_noxref_d N_noxref_3_M7_noxref_d )  PM_OR3X1_PCELL\%noxref_3
x_PM_OR3X1_PCELL\%noxref_4 ( N_noxref_4_c_491_n N_noxref_4_c_521_n \
 N_noxref_4_c_532_n N_noxref_4_c_535_n N_noxref_4_c_494_n \
 N_noxref_4_M0_noxref_g N_noxref_4_M4_noxref_g N_noxref_4_M5_noxref_g \
 N_noxref_4_c_497_n N_noxref_4_c_499_n N_noxref_4_c_502_n N_noxref_4_c_503_n \
 N_noxref_4_c_506_n N_noxref_4_c_508_n N_noxref_4_c_546_n N_noxref_4_c_511_n \
 N_noxref_4_c_513_n N_noxref_4_c_547_n )  PM_OR3X1_PCELL\%noxref_4
x_PM_OR3X1_PCELL\%noxref_5 ( N_noxref_5_c_635_n N_noxref_5_c_639_n \
 N_noxref_5_c_645_n N_noxref_5_c_603_n N_noxref_5_c_606_n N_noxref_5_c_632_n \
 N_noxref_5_c_607_n N_noxref_5_c_610_n N_noxref_5_c_618_n \
 N_noxref_5_M4_noxref_d N_noxref_5_M10_noxref_s N_noxref_5_M11_noxref_d )  \
 PM_OR3X1_PCELL\%noxref_5
x_PM_OR3X1_PCELL\%noxref_6 ( N_noxref_6_c_736_n N_noxref_6_c_738_n \
 N_noxref_6_c_741_n N_noxref_6_c_777_n N_noxref_6_M1_noxref_g \
 N_noxref_6_M6_noxref_g N_noxref_6_M7_noxref_g N_noxref_6_c_742_n \
 N_noxref_6_c_744_n N_noxref_6_c_747_n N_noxref_6_c_853_p N_noxref_6_c_749_n \
 N_noxref_6_c_751_n N_noxref_6_c_756_n N_noxref_6_c_758_n N_noxref_6_c_761_n \
 N_noxref_6_c_762_n N_noxref_6_c_785_n )  PM_OR3X1_PCELL\%noxref_6
x_PM_OR3X1_PCELL\%noxref_7 ( N_noxref_7_c_865_n N_noxref_7_c_869_n \
 N_noxref_7_c_876_n N_noxref_7_c_881_n N_noxref_7_M2_noxref_g \
 N_noxref_7_M8_noxref_g N_noxref_7_M9_noxref_g N_noxref_7_c_890_n \
 N_noxref_7_c_892_n N_noxref_7_c_895_n N_noxref_7_c_897_n N_noxref_7_c_899_n \
 N_noxref_7_c_901_n N_noxref_7_c_966_p N_noxref_7_c_905_n N_noxref_7_c_907_n \
 N_noxref_7_c_910_n N_noxref_7_c_913_n N_noxref_7_c_915_n )  \
 PM_OR3X1_PCELL\%noxref_7
x_PM_OR3X1_PCELL\%noxref_8 ( N_noxref_8_c_975_n N_noxref_8_c_978_n \
 N_noxref_8_c_981_n N_noxref_8_c_985_n N_noxref_8_c_988_n N_noxref_8_c_989_n \
 N_noxref_8_c_1008_n N_noxref_8_c_991_n N_noxref_8_M6_noxref_d \
 N_noxref_8_M8_noxref_s N_noxref_8_M9_noxref_d )  PM_OR3X1_PCELL\%noxref_8
x_PM_OR3X1_PCELL\%noxref_9 ( N_noxref_9_c_1063_n N_noxref_9_c_1071_n \
 N_noxref_9_c_1075_n N_noxref_9_c_1076_n N_noxref_9_c_1078_n \
 N_noxref_9_c_1079_n N_noxref_9_c_1082_n N_noxref_9_c_1095_n \
 N_noxref_9_c_1102_n N_noxref_9_M3_noxref_d N_noxref_9_M10_noxref_d )  \
 PM_OR3X1_PCELL\%noxref_9
cc_1 ( N_noxref_1_c_1_p N_noxref_2_c_276_n ) capacitor c=0.0100127f //x=-0.3 \
 //y=1.13 //x2=4.81 //y2=0
cc_2 ( N_noxref_1_c_2_p N_noxref_2_c_276_n ) capacitor c=0.00677167f //x=0.585 \
 //y=1.655 //x2=4.81 //y2=0
cc_3 ( N_noxref_1_c_3_p N_noxref_2_c_276_n ) capacitor c=0.0100522f //x=0.67 \
 //y=1.13 //x2=4.81 //y2=0
cc_4 ( N_noxref_1_c_4_p N_noxref_2_c_276_n ) capacitor c=0.00677234f //x=1.555 \
 //y=1.655 //x2=4.81 //y2=0
cc_5 ( N_noxref_1_c_5_p N_noxref_2_c_276_n ) capacitor c=0.00982429f //x=1.64 \
 //y=1.145 //x2=4.81 //y2=0
cc_6 ( N_noxref_1_c_6_p N_noxref_2_c_276_n ) capacitor c=0.00906037f //x=2.135 \
 //y=1.655 //x2=4.81 //y2=0
cc_7 ( N_noxref_1_c_7_p N_noxref_2_c_276_n ) capacitor c=4.99018e-19 //x=2.22 \
 //y=3.49 //x2=4.81 //y2=0
cc_8 ( N_noxref_1_c_8_p N_noxref_2_c_276_n ) capacitor c=4.49108e-19 //x=4.07 \
 //y=3.495 //x2=4.81 //y2=0
cc_9 ( N_noxref_1_c_9_p N_noxref_2_c_276_n ) capacitor c=3.99625e-19 //x=2.22 \
 //y=3.33 //x2=4.81 //y2=0
cc_10 ( N_noxref_1_c_10_p N_noxref_2_c_276_n ) capacitor c=0.00248634f \
 //x=4.07 //y=2.085 //x2=4.81 //y2=0
cc_11 ( N_noxref_1_c_11_p N_noxref_2_c_276_n ) capacitor c=7.53892e-19 \
 //x=4.07 //y=2.085 //x2=4.81 //y2=0
cc_12 ( N_noxref_1_M0_noxref_d N_noxref_2_c_276_n ) capacitor c=3.01654e-19 \
 //x=-0.49 //y=0.905 //x2=4.81 //y2=0
cc_13 ( N_noxref_1_M1_noxref_d N_noxref_2_c_276_n ) capacitor c=3.01654e-19 \
 //x=0.48 //y=0.905 //x2=4.81 //y2=0
cc_14 ( N_noxref_1_M2_noxref_d N_noxref_2_c_276_n ) capacitor c=3.01654e-19 \
 //x=1.45 //y=0.905 //x2=4.81 //y2=0
cc_15 ( N_noxref_1_c_1_p N_noxref_2_c_290_n ) capacitor c=0.00400023f //x=-0.3 \
 //y=1.13 //x2=0.1 //y2=0.53
cc_16 ( N_noxref_1_c_2_p N_noxref_2_c_290_n ) capacitor c=0.00128856f \
 //x=0.585 //y=1.655 //x2=0.1 //y2=0.53
cc_17 ( N_noxref_1_M0_noxref_d N_noxref_2_c_290_n ) capacitor c=0.00910163f \
 //x=-0.49 //y=0.905 //x2=0.1 //y2=0.53
cc_18 ( N_noxref_1_c_2_p N_noxref_2_c_293_n ) capacitor c=0.0010475f //x=0.585 \
 //y=1.655 //x2=1.07 //y2=0.53
cc_19 ( N_noxref_1_c_3_p N_noxref_2_c_293_n ) capacitor c=0.00431488f //x=0.67 \
 //y=1.13 //x2=1.07 //y2=0.53
cc_20 ( N_noxref_1_c_4_p N_noxref_2_c_293_n ) capacitor c=0.00128856f \
 //x=1.555 //y=1.655 //x2=1.07 //y2=0.53
cc_21 ( N_noxref_1_M1_noxref_d N_noxref_2_c_293_n ) capacitor c=0.00910163f \
 //x=0.48 //y=0.905 //x2=1.07 //y2=0.53
cc_22 ( N_noxref_1_c_4_p N_noxref_2_c_297_n ) capacitor c=0.00176314f \
 //x=1.555 //y=1.655 //x2=2.04 //y2=0.53
cc_23 ( N_noxref_1_c_5_p N_noxref_2_c_297_n ) capacitor c=0.00398909f //x=1.64 \
 //y=1.145 //x2=2.04 //y2=0.53
cc_24 ( N_noxref_1_c_6_p N_noxref_2_c_297_n ) capacitor c=0.00348283f \
 //x=2.135 //y=1.655 //x2=2.04 //y2=0.53
cc_25 ( N_noxref_1_M2_noxref_d N_noxref_2_c_297_n ) capacitor c=0.00910163f \
 //x=1.45 //y=0.905 //x2=2.04 //y2=0.53
cc_26 ( N_noxref_1_c_6_p N_noxref_2_c_301_n ) capacitor c=3.14462e-19 \
 //x=2.135 //y=1.655 //x2=3.16 //y2=0
cc_27 ( N_noxref_1_c_7_p N_noxref_2_c_301_n ) capacitor c=4.02988e-19 //x=2.22 \
 //y=3.49 //x2=3.16 //y2=0
cc_28 ( N_noxref_1_c_10_p N_noxref_2_c_303_n ) capacitor c=0.00114179f \
 //x=4.07 //y=2.085 //x2=4.355 //y2=0.535
cc_29 ( N_noxref_1_c_11_p N_noxref_2_c_303_n ) capacitor c=3.95714e-19 \
 //x=4.07 //y=2.085 //x2=4.355 //y2=0.535
cc_30 ( N_noxref_1_c_30_p N_noxref_2_c_303_n ) capacitor c=0.0125519f //x=4.18 \
 //y=0.91 //x2=4.355 //y2=0.535
cc_31 ( N_noxref_1_c_31_p N_noxref_2_c_303_n ) capacitor c=2.1838e-19 //x=4.07 \
 //y=2.085 //x2=4.355 //y2=0.535
cc_32 ( N_noxref_1_c_32_p N_noxref_2_c_307_n ) capacitor c=0.0134259f //x=4.71 \
 //y=0.91 //x2=4.845 //y2=0.535
cc_33 ( N_noxref_1_c_33_p N_noxref_2_c_308_n ) capacitor c=0.0025534f //x=1.64 \
 //y=1.57 //x2=3.33 //y2=0
cc_34 ( N_noxref_1_c_6_p N_noxref_2_c_308_n ) capacitor c=0.0222089f //x=2.135 \
 //y=1.655 //x2=3.33 //y2=0
cc_35 ( N_noxref_1_c_35_p N_noxref_2_c_308_n ) capacitor c=0.0111081f //x=4.07 \
 //y=3.175 //x2=3.33 //y2=0
cc_36 ( N_noxref_1_c_10_p N_noxref_2_c_308_n ) capacitor c=0.00717107f \
 //x=4.07 //y=2.085 //x2=3.33 //y2=0
cc_37 ( N_noxref_1_c_37_p N_noxref_2_c_308_n ) capacitor c=0.00560353f \
 //x=3.91 //y=3.335 //x2=3.33 //y2=0
cc_38 ( N_noxref_1_c_11_p N_noxref_2_c_308_n ) capacitor c=0.00733236f \
 //x=4.07 //y=2.085 //x2=3.33 //y2=0
cc_39 ( N_noxref_1_c_39_p N_noxref_2_c_308_n ) capacitor c=0.00570585f \
 //x=4.18 //y=1.92 //x2=3.33 //y2=0
cc_40 ( N_noxref_1_c_31_p N_noxref_2_c_308_n ) capacitor c=0.00786308f \
 //x=4.07 //y=2.085 //x2=3.33 //y2=0
cc_41 ( N_noxref_1_c_1_p N_noxref_2_c_316_n ) capacitor c=2.87802e-19 //x=-0.3 \
 //y=1.13 //x2=4.93 //y2=0
cc_42 ( N_noxref_1_c_3_p N_noxref_2_c_316_n ) capacitor c=2.87802e-19 //x=0.67 \
 //y=1.13 //x2=4.93 //y2=0
cc_43 ( N_noxref_1_c_5_p N_noxref_2_c_316_n ) capacitor c=2.87802e-19 //x=1.64 \
 //y=1.145 //x2=4.93 //y2=0
cc_44 ( N_noxref_1_c_11_p N_noxref_2_c_316_n ) capacitor c=0.0022444f //x=4.07 \
 //y=2.085 //x2=4.93 //y2=0
cc_45 ( N_noxref_1_c_31_p N_noxref_2_c_316_n ) capacitor c=2.63786e-19 \
 //x=4.07 //y=2.085 //x2=4.93 //y2=0
cc_46 ( N_noxref_1_c_1_p N_noxref_2_M0_noxref_s ) capacitor c=0.0106681f \
 //x=-0.3 //y=1.13 //x2=-0.92 //y2=0.365
cc_47 ( N_noxref_1_c_47_p N_noxref_2_M0_noxref_s ) capacitor c=0.0281176f \
 //x=-0.3 //y=1.57 //x2=-0.92 //y2=0.365
cc_48 ( N_noxref_1_c_2_p N_noxref_2_M0_noxref_s ) capacitor c=0.00856975f \
 //x=0.585 //y=1.655 //x2=-0.92 //y2=0.365
cc_49 ( N_noxref_1_c_3_p N_noxref_2_M0_noxref_s ) capacitor c=0.00695238f \
 //x=0.67 //y=1.13 //x2=-0.92 //y2=0.365
cc_50 ( N_noxref_1_c_50_p N_noxref_2_M0_noxref_s ) capacitor c=0.00901608f \
 //x=0.67 //y=1.57 //x2=-0.92 //y2=0.365
cc_51 ( N_noxref_1_c_4_p N_noxref_2_M0_noxref_s ) capacitor c=0.00884125f \
 //x=1.555 //y=1.655 //x2=-0.92 //y2=0.365
cc_52 ( N_noxref_1_c_5_p N_noxref_2_M0_noxref_s ) capacitor c=0.0101079f \
 //x=1.64 //y=1.145 //x2=-0.92 //y2=0.365
cc_53 ( N_noxref_1_c_33_p N_noxref_2_M0_noxref_s ) capacitor c=0.0103813f \
 //x=1.64 //y=1.57 //x2=-0.92 //y2=0.365
cc_54 ( N_noxref_1_c_6_p N_noxref_2_M0_noxref_s ) capacitor c=0.00860369f \
 //x=2.135 //y=1.655 //x2=-0.92 //y2=0.365
cc_55 ( N_noxref_1_c_9_p N_noxref_2_M0_noxref_s ) capacitor c=7.55412e-19 \
 //x=2.22 //y=3.33 //x2=-0.92 //y2=0.365
cc_56 ( N_noxref_1_M0_noxref_d N_noxref_2_M0_noxref_s ) capacitor c=0.0275007f \
 //x=-0.49 //y=0.905 //x2=-0.92 //y2=0.365
cc_57 ( N_noxref_1_M1_noxref_d N_noxref_2_M0_noxref_s ) capacitor c=0.0274981f \
 //x=0.48 //y=0.905 //x2=-0.92 //y2=0.365
cc_58 ( N_noxref_1_M2_noxref_d N_noxref_2_M0_noxref_s ) capacitor c=0.0274983f \
 //x=1.45 //y=0.905 //x2=-0.92 //y2=0.365
cc_59 ( N_noxref_1_c_8_p N_noxref_2_M3_noxref_s ) capacitor c=8.07067e-19 \
 //x=4.07 //y=3.495 //x2=3.825 //y2=0.37
cc_60 ( N_noxref_1_c_10_p N_noxref_2_M3_noxref_s ) capacitor c=0.00297844f \
 //x=4.07 //y=2.085 //x2=3.825 //y2=0.37
cc_61 ( N_noxref_1_c_11_p N_noxref_2_M3_noxref_s ) capacitor c=0.00651272f \
 //x=4.07 //y=2.085 //x2=3.825 //y2=0.37
cc_62 ( N_noxref_1_c_30_p N_noxref_2_M3_noxref_s ) capacitor c=0.030052f \
 //x=4.18 //y=0.91 //x2=3.825 //y2=0.37
cc_63 ( N_noxref_1_c_63_p N_noxref_2_M3_noxref_s ) capacitor c=0.002132f \
 //x=4.18 //y=1.565 //x2=3.825 //y2=0.37
cc_64 ( N_noxref_1_c_39_p N_noxref_2_M3_noxref_s ) capacitor c=0.00304786f \
 //x=4.18 //y=1.92 //x2=3.825 //y2=0.37
cc_65 ( N_noxref_1_c_65_p N_noxref_2_M3_noxref_s ) capacitor c=0.00517157f \
 //x=4.555 //y=0.755 //x2=3.825 //y2=0.37
cc_66 ( N_noxref_1_c_32_p N_noxref_2_M3_noxref_s ) capacitor c=0.0153553f \
 //x=4.71 //y=0.91 //x2=3.825 //y2=0.37
cc_67 ( N_noxref_1_c_67_p N_noxref_2_M3_noxref_s ) capacitor c=0.00629878f \
 //x=4.71 //y=1.255 //x2=3.825 //y2=0.37
cc_68 ( N_noxref_1_c_31_p N_noxref_2_M3_noxref_s ) capacitor c=0.00660494f \
 //x=4.07 //y=2.085 //x2=3.825 //y2=0.37
cc_69 ( N_noxref_1_c_1_p N_noxref_3_c_395_n ) capacitor c=2.38306e-19 //x=-0.3 \
 //y=1.13 //x2=0.075 //y2=5.21
cc_70 ( N_noxref_1_c_70_p N_noxref_3_c_395_n ) capacitor c=0.00265006f \
 //x=-0.215 //y=1.655 //x2=0.075 //y2=5.21
cc_71 ( N_noxref_1_c_2_p N_noxref_3_c_397_n ) capacitor c=0.00290517f \
 //x=0.585 //y=1.655 //x2=0.192 //y2=5.21
cc_72 ( N_noxref_1_c_72_p N_noxref_3_c_397_n ) capacitor c=0.00134451f \
 //x=2.22 //y=5.21 //x2=0.192 //y2=5.21
cc_73 ( N_noxref_1_c_73_p N_noxref_3_M7_noxref_d ) capacitor c=0.00395323f \
 //x=2.11 //y=5.72 //x2=0.925 //y2=5.025
cc_74 ( N_noxref_1_c_1_p N_noxref_4_c_491_n ) capacitor c=0.00147045f //x=-0.3 \
 //y=1.13 //x2=-0.37 //y2=2.245
cc_75 ( N_noxref_1_c_70_p N_noxref_4_c_491_n ) capacitor c=0.0171527f \
 //x=-0.215 //y=1.655 //x2=-0.37 //y2=2.245
cc_76 ( N_noxref_1_M0_noxref_d N_noxref_4_c_491_n ) capacitor c=0.00138074f \
 //x=-0.49 //y=0.905 //x2=-0.37 //y2=2.245
cc_77 ( N_noxref_1_c_1_p N_noxref_4_c_494_n ) capacitor c=7.07025e-19 //x=-0.3 \
 //y=1.13 //x2=-0.369 //y2=2.08
cc_78 ( N_noxref_1_c_70_p N_noxref_4_c_494_n ) capacitor c=0.00293491f \
 //x=-0.215 //y=1.655 //x2=-0.369 //y2=2.08
cc_79 ( N_noxref_1_M0_noxref_d N_noxref_4_c_494_n ) capacitor c=0.00150031f \
 //x=-0.49 //y=0.905 //x2=-0.369 //y2=2.08
cc_80 ( N_noxref_1_c_1_p N_noxref_4_c_497_n ) capacitor c=7.80351e-19 //x=-0.3 \
 //y=1.13 //x2=-0.565 //y2=0.905
cc_81 ( N_noxref_1_M0_noxref_d N_noxref_4_c_497_n ) capacitor c=8.46111e-19 \
 //x=-0.49 //y=0.905 //x2=-0.565 //y2=0.905
cc_82 ( N_noxref_1_c_1_p N_noxref_4_c_499_n ) capacitor c=0.00391325f //x=-0.3 \
 //y=1.13 //x2=-0.565 //y2=1.25
cc_83 ( N_noxref_1_c_47_p N_noxref_4_c_499_n ) capacitor c=0.00127432f \
 //x=-0.3 //y=1.57 //x2=-0.565 //y2=1.25
cc_84 ( N_noxref_1_M0_noxref_d N_noxref_4_c_499_n ) capacitor c=0.00237422f \
 //x=-0.49 //y=0.905 //x2=-0.565 //y2=1.25
cc_85 ( N_noxref_1_c_47_p N_noxref_4_c_502_n ) capacitor c=0.00350316f \
 //x=-0.3 //y=1.57 //x2=-0.565 //y2=1.56
cc_86 ( N_noxref_1_c_47_p N_noxref_4_c_503_n ) capacitor c=0.00379925f \
 //x=-0.3 //y=1.57 //x2=-0.565 //y2=1.915
cc_87 ( N_noxref_1_c_70_p N_noxref_4_c_503_n ) capacitor c=0.00113924f \
 //x=-0.215 //y=1.655 //x2=-0.565 //y2=1.915
cc_88 ( N_noxref_1_M0_noxref_d N_noxref_4_c_503_n ) capacitor c=4.64071e-19 \
 //x=-0.49 //y=0.905 //x2=-0.565 //y2=1.915
cc_89 ( N_noxref_1_c_1_p N_noxref_4_c_506_n ) capacitor c=5.34749e-19 //x=-0.3 \
 //y=1.13 //x2=-0.19 //y2=0.75
cc_90 ( N_noxref_1_M0_noxref_d N_noxref_4_c_506_n ) capacitor c=0.0020782f \
 //x=-0.49 //y=0.905 //x2=-0.19 //y2=0.75
cc_91 ( N_noxref_1_c_1_p N_noxref_4_c_508_n ) capacitor c=6.20502e-19 //x=-0.3 \
 //y=1.13 //x2=-0.19 //y2=1.405
cc_92 ( N_noxref_1_c_47_p N_noxref_4_c_508_n ) capacitor c=0.00702073f \
 //x=-0.3 //y=1.57 //x2=-0.19 //y2=1.405
cc_93 ( N_noxref_1_M0_noxref_d N_noxref_4_c_508_n ) capacitor c=0.00344131f \
 //x=-0.49 //y=0.905 //x2=-0.19 //y2=1.405
cc_94 ( N_noxref_1_c_1_p N_noxref_4_c_511_n ) capacitor c=9.60468e-19 //x=-0.3 \
 //y=1.13 //x2=-0.035 //y2=0.905
cc_95 ( N_noxref_1_M0_noxref_d N_noxref_4_c_511_n ) capacitor c=0.00139206f \
 //x=-0.49 //y=0.905 //x2=-0.035 //y2=0.905
cc_96 ( N_noxref_1_c_1_p N_noxref_4_c_513_n ) capacitor c=0.00221072f //x=-0.3 \
 //y=1.13 //x2=-0.035 //y2=1.25
cc_97 ( N_noxref_1_c_47_p N_noxref_4_c_513_n ) capacitor c=0.00253555f \
 //x=-0.3 //y=1.57 //x2=-0.035 //y2=1.25
cc_98 ( N_noxref_1_c_2_p N_noxref_4_c_513_n ) capacitor c=7.25274e-19 \
 //x=0.585 //y=1.655 //x2=-0.035 //y2=1.25
cc_99 ( N_noxref_1_c_50_p N_noxref_4_c_513_n ) capacitor c=6.29838e-19 \
 //x=0.67 //y=1.57 //x2=-0.035 //y2=1.25
cc_100 ( N_noxref_1_M0_noxref_d N_noxref_4_c_513_n ) capacitor c=0.00237422f \
 //x=-0.49 //y=0.905 //x2=-0.035 //y2=1.25
cc_101 ( N_noxref_1_c_8_p N_noxref_5_c_603_n ) capacitor c=2.5703e-19 //x=4.07 \
 //y=3.495 //x2=4.81 //y2=7.4
cc_102 ( N_noxref_1_c_102_p N_noxref_5_c_603_n ) capacitor c=5.72118e-19 \
 //x=4.07 //y=4.58 //x2=4.81 //y2=7.4
cc_103 ( N_noxref_1_c_103_p N_noxref_5_c_603_n ) capacitor c=3.40875e-19 \
 //x=4.07 //y=4.7 //x2=4.81 //y2=7.4
cc_104 ( N_noxref_1_c_73_p N_noxref_5_c_606_n ) capacitor c=0.00509179f \
 //x=2.11 //y=5.72 //x2=3.16 //y2=7.4
cc_105 ( N_noxref_1_c_102_p N_noxref_5_c_607_n ) capacitor c=5.4912e-19 \
 //x=4.07 //y=4.58 //x2=4.8 //y2=7.4
cc_106 ( N_noxref_1_M10_noxref_g N_noxref_5_c_607_n ) capacitor c=0.00748034f \
 //x=4.225 //y=6.02 //x2=4.8 //y2=7.4
cc_107 ( N_noxref_1_M11_noxref_g N_noxref_5_c_607_n ) capacitor c=0.00749619f \
 //x=4.665 //y=6.02 //x2=4.8 //y2=7.4
cc_108 ( N_noxref_1_c_108_p N_noxref_5_c_610_n ) capacitor c=0.00360403f \
 //x=2.11 //y=5.59 //x2=3.33 //y2=7.4
cc_109 ( N_noxref_1_c_109_p N_noxref_5_c_610_n ) capacitor c=0.0240178f \
 //x=2.22 //y=5.125 //x2=3.33 //y2=7.4
cc_110 ( N_noxref_1_c_102_p N_noxref_5_c_610_n ) capacitor c=0.0166244f \
 //x=4.07 //y=4.58 //x2=3.33 //y2=7.4
cc_111 ( N_noxref_1_c_37_p N_noxref_5_c_610_n ) capacitor c=0.00501351f \
 //x=3.91 //y=3.335 //x2=3.33 //y2=7.4
cc_112 ( N_noxref_1_c_73_p N_noxref_5_c_610_n ) capacitor c=0.0039206f \
 //x=2.11 //y=5.72 //x2=3.33 //y2=7.4
cc_113 ( N_noxref_1_c_103_p N_noxref_5_c_610_n ) capacitor c=0.00795384f \
 //x=4.07 //y=4.7 //x2=3.33 //y2=7.4
cc_114 ( N_noxref_1_M10_noxref_g N_noxref_5_c_610_n ) capacitor c=0.00873815f \
 //x=4.225 //y=6.02 //x2=3.33 //y2=7.4
cc_115 ( N_noxref_1_c_115_p N_noxref_5_c_610_n ) capacitor c=0.00799922f \
 //x=4.3 //y=4.79 //x2=3.33 //y2=7.4
cc_116 ( N_noxref_1_c_73_p N_noxref_5_c_618_n ) capacitor c=2.31538e-19 \
 //x=2.11 //y=5.72 //x2=4.81 //y2=7.4
cc_117 ( N_noxref_1_c_103_p N_noxref_5_c_618_n ) capacitor c=0.00241457f \
 //x=4.07 //y=4.7 //x2=4.81 //y2=7.4
cc_118 ( N_noxref_1_c_118_p N_noxref_5_c_618_n ) capacitor c=0.0174926f \
 //x=4.59 //y=4.79 //x2=4.81 //y2=7.4
cc_119 ( N_noxref_1_c_108_p N_noxref_5_M10_noxref_s ) capacitor c=0.00538961f \
 //x=2.11 //y=5.59 //x2=3.87 //y2=5.02
cc_120 ( N_noxref_1_c_8_p N_noxref_5_M10_noxref_s ) capacitor c=0.00120003f \
 //x=4.07 //y=3.495 //x2=3.87 //y2=5.02
cc_121 ( N_noxref_1_c_102_p N_noxref_5_M10_noxref_s ) capacitor c=0.0211604f \
 //x=4.07 //y=4.58 //x2=3.87 //y2=5.02
cc_122 ( N_noxref_1_c_72_p N_noxref_5_M10_noxref_s ) capacitor c=0.00235342f \
 //x=2.22 //y=5.21 //x2=3.87 //y2=5.02
cc_123 ( N_noxref_1_c_123_p N_noxref_5_M10_noxref_s ) capacitor c=4.26343e-19 \
 //x=4.07 //y=3.335 //x2=3.87 //y2=5.02
cc_124 ( N_noxref_1_c_37_p N_noxref_5_M10_noxref_s ) capacitor c=2.12313e-19 \
 //x=3.91 //y=3.335 //x2=3.87 //y2=5.02
cc_125 ( N_noxref_1_c_103_p N_noxref_5_M10_noxref_s ) capacitor c=0.00986151f \
 //x=4.07 //y=4.7 //x2=3.87 //y2=5.02
cc_126 ( N_noxref_1_M10_noxref_g N_noxref_5_M10_noxref_s ) capacitor \
 c=0.0573441f //x=4.225 //y=6.02 //x2=3.87 //y2=5.02
cc_127 ( N_noxref_1_c_115_p N_noxref_5_M10_noxref_s ) capacitor c=0.00524524f \
 //x=4.3 //y=4.79 //x2=3.87 //y2=5.02
cc_128 ( N_noxref_1_c_108_p N_noxref_5_M11_noxref_d ) capacitor c=5.58798e-19 \
 //x=2.11 //y=5.59 //x2=4.74 //y2=5.02
cc_129 ( N_noxref_1_M11_noxref_g N_noxref_5_M11_noxref_d ) capacitor \
 c=0.0572684f //x=4.665 //y=6.02 //x2=4.74 //y2=5.02
cc_130 ( N_noxref_1_c_2_p N_noxref_6_c_736_n ) capacitor c=0.0308091f \
 //x=0.585 //y=1.655 //x2=0.37 //y2=2.21
cc_131 ( N_noxref_1_c_131_p N_noxref_6_c_736_n ) capacitor c=3.05675e-19 \
 //x=2.22 //y=3.17 //x2=0.37 //y2=2.21
cc_132 ( N_noxref_1_c_2_p N_noxref_6_c_738_n ) capacitor c=3.68612e-19 \
 //x=0.585 //y=1.655 //x2=0.37 //y2=4.56
cc_133 ( N_noxref_1_c_131_p N_noxref_6_c_738_n ) capacitor c=0.00186546f \
 //x=2.22 //y=3.17 //x2=0.37 //y2=4.56
cc_134 ( N_noxref_1_c_109_p N_noxref_6_c_738_n ) capacitor c=0.00193455f \
 //x=2.22 //y=5.125 //x2=0.37 //y2=4.56
cc_135 ( N_noxref_1_c_2_p N_noxref_6_c_741_n ) capacitor c=0.00494853f \
 //x=0.585 //y=1.655 //x2=0.37 //y2=2.08
cc_136 ( N_noxref_1_c_3_p N_noxref_6_c_742_n ) capacitor c=8.454e-19 //x=0.67 \
 //y=1.13 //x2=0.405 //y2=0.905
cc_137 ( N_noxref_1_M1_noxref_d N_noxref_6_c_742_n ) capacitor c=8.51904e-19 \
 //x=0.48 //y=0.905 //x2=0.405 //y2=0.905
cc_138 ( N_noxref_1_c_3_p N_noxref_6_c_744_n ) capacitor c=0.00221072f \
 //x=0.67 //y=1.13 //x2=0.405 //y2=1.255
cc_139 ( N_noxref_1_c_50_p N_noxref_6_c_744_n ) capacitor c=7.7986e-19 \
 //x=0.67 //y=1.57 //x2=0.405 //y2=1.255
cc_140 ( N_noxref_1_M1_noxref_d N_noxref_6_c_744_n ) capacitor c=0.00237422f \
 //x=0.48 //y=0.905 //x2=0.405 //y2=1.255
cc_141 ( N_noxref_1_c_47_p N_noxref_6_c_747_n ) capacitor c=6.83023e-19 \
 //x=-0.3 //y=1.57 //x2=0.405 //y2=1.56
cc_142 ( N_noxref_1_c_50_p N_noxref_6_c_747_n ) capacitor c=0.00253868f \
 //x=0.67 //y=1.57 //x2=0.405 //y2=1.56
cc_143 ( N_noxref_1_c_3_p N_noxref_6_c_749_n ) capacitor c=5.42035e-19 \
 //x=0.67 //y=1.13 //x2=0.78 //y2=0.75
cc_144 ( N_noxref_1_M1_noxref_d N_noxref_6_c_749_n ) capacitor c=0.0020782f \
 //x=0.48 //y=0.905 //x2=0.78 //y2=0.75
cc_145 ( N_noxref_1_c_3_p N_noxref_6_c_751_n ) capacitor c=7.84428e-19 \
 //x=0.67 //y=1.13 //x2=0.78 //y2=1.405
cc_146 ( N_noxref_1_c_50_p N_noxref_6_c_751_n ) capacitor c=0.00845712f \
 //x=0.67 //y=1.57 //x2=0.78 //y2=1.405
cc_147 ( N_noxref_1_c_4_p N_noxref_6_c_751_n ) capacitor c=7.25274e-19 \
 //x=1.555 //y=1.655 //x2=0.78 //y2=1.405
cc_148 ( N_noxref_1_c_33_p N_noxref_6_c_751_n ) capacitor c=6.29838e-19 \
 //x=1.64 //y=1.57 //x2=0.78 //y2=1.405
cc_149 ( N_noxref_1_M1_noxref_d N_noxref_6_c_751_n ) capacitor c=0.00356097f \
 //x=0.48 //y=0.905 //x2=0.78 //y2=1.405
cc_150 ( N_noxref_1_c_3_p N_noxref_6_c_756_n ) capacitor c=7.61925e-19 \
 //x=0.67 //y=1.13 //x2=0.935 //y2=0.905
cc_151 ( N_noxref_1_M1_noxref_d N_noxref_6_c_756_n ) capacitor c=8.55887e-19 \
 //x=0.48 //y=0.905 //x2=0.935 //y2=0.905
cc_152 ( N_noxref_1_c_3_p N_noxref_6_c_758_n ) capacitor c=0.00220852f \
 //x=0.67 //y=1.13 //x2=0.935 //y2=1.255
cc_153 ( N_noxref_1_c_50_p N_noxref_6_c_758_n ) capacitor c=7.7986e-19 \
 //x=0.67 //y=1.57 //x2=0.935 //y2=1.255
cc_154 ( N_noxref_1_M1_noxref_d N_noxref_6_c_758_n ) capacitor c=0.00237422f \
 //x=0.48 //y=0.905 //x2=0.935 //y2=1.255
cc_155 ( N_noxref_1_c_2_p N_noxref_6_c_761_n ) capacitor c=0.00139093f \
 //x=0.585 //y=1.655 //x2=0.37 //y2=2.08
cc_156 ( N_noxref_1_c_2_p N_noxref_6_c_762_n ) capacitor c=0.00778097f \
 //x=0.585 //y=1.655 //x2=0.37 //y2=1.915
cc_157 ( N_noxref_1_c_4_p N_noxref_7_c_865_n ) capacitor c=0.0286668f \
 //x=1.555 //y=1.655 //x2=1.48 //y2=2.225
cc_158 ( N_noxref_1_c_131_p N_noxref_7_c_865_n ) capacitor c=0.0161611f \
 //x=2.22 //y=3.17 //x2=1.48 //y2=2.225
cc_159 ( N_noxref_1_c_159_p N_noxref_7_c_865_n ) capacitor c=0.00327478f \
 //x=1.64 //y=1.655 //x2=1.48 //y2=2.225
cc_160 ( N_noxref_1_M2_noxref_d N_noxref_7_c_865_n ) capacitor c=8.91766e-19 \
 //x=1.45 //y=0.905 //x2=1.48 //y2=2.225
cc_161 ( N_noxref_1_c_131_p N_noxref_7_c_869_n ) capacitor c=0.0435221f \
 //x=2.22 //y=3.17 //x2=1.48 //y2=4.585
cc_162 ( N_noxref_1_c_7_p N_noxref_7_c_869_n ) capacitor c=0.0148501f //x=2.22 \
 //y=3.49 //x2=1.48 //y2=4.585
cc_163 ( N_noxref_1_c_109_p N_noxref_7_c_869_n ) capacitor c=0.0668612f \
 //x=2.22 //y=5.125 //x2=1.48 //y2=4.585
cc_164 ( N_noxref_1_c_35_p N_noxref_7_c_869_n ) capacitor c=0.00210601f \
 //x=4.07 //y=3.175 //x2=1.48 //y2=4.585
cc_165 ( N_noxref_1_c_102_p N_noxref_7_c_869_n ) capacitor c=0.00211352f \
 //x=4.07 //y=4.58 //x2=1.48 //y2=4.585
cc_166 ( N_noxref_1_c_9_p N_noxref_7_c_869_n ) capacitor c=6.03895e-19 \
 //x=2.22 //y=3.33 //x2=1.48 //y2=4.585
cc_167 ( N_noxref_1_c_167_p N_noxref_7_c_869_n ) capacitor c=0.006875f \
 //x=2.38 //y=3.33 //x2=1.48 //y2=4.585
cc_168 ( N_noxref_1_c_4_p N_noxref_7_c_876_n ) capacitor c=0.00451548f \
 //x=1.555 //y=1.655 //x2=1.48 //y2=2.08
cc_169 ( N_noxref_1_c_5_p N_noxref_7_c_876_n ) capacitor c=2.35917e-19 \
 //x=1.64 //y=1.145 //x2=1.48 //y2=2.08
cc_170 ( N_noxref_1_c_131_p N_noxref_7_c_876_n ) capacitor c=0.00112301f \
 //x=2.22 //y=3.17 //x2=1.48 //y2=2.08
cc_171 ( N_noxref_1_c_159_p N_noxref_7_c_876_n ) capacitor c=0.00154812f \
 //x=1.64 //y=1.655 //x2=1.48 //y2=2.08
cc_172 ( N_noxref_1_M2_noxref_d N_noxref_7_c_876_n ) capacitor c=5.40451e-19 \
 //x=1.45 //y=0.905 //x2=1.48 //y2=2.08
cc_173 ( N_noxref_1_c_109_p N_noxref_7_c_881_n ) capacitor c=0.00154968f \
 //x=2.22 //y=5.125 //x2=1.48 //y2=4.705
cc_174 ( N_noxref_1_c_108_p N_noxref_7_M8_noxref_g ) capacitor c=0.00140876f \
 //x=2.11 //y=5.59 //x2=1.89 //y2=6.025
cc_175 ( N_noxref_1_c_109_p N_noxref_7_M8_noxref_g ) capacitor c=0.00478791f \
 //x=2.22 //y=5.125 //x2=1.89 //y2=6.025
cc_176 ( N_noxref_1_c_72_p N_noxref_7_M8_noxref_g ) capacitor c=0.00234737f \
 //x=2.22 //y=5.21 //x2=1.89 //y2=6.025
cc_177 ( N_noxref_1_c_73_p N_noxref_7_M8_noxref_g ) capacitor c=0.00896756f \
 //x=2.11 //y=5.72 //x2=1.89 //y2=6.025
cc_178 ( N_noxref_1_c_108_p N_noxref_7_M9_noxref_g ) capacitor c=0.00767663f \
 //x=2.11 //y=5.59 //x2=2.33 //y2=6.025
cc_179 ( N_noxref_1_c_109_p N_noxref_7_M9_noxref_g ) capacitor c=0.00397952f \
 //x=2.22 //y=5.125 //x2=2.33 //y2=6.025
cc_180 ( N_noxref_1_c_72_p N_noxref_7_M9_noxref_g ) capacitor c=0.00430799f \
 //x=2.22 //y=5.21 //x2=2.33 //y2=6.025
cc_181 ( N_noxref_1_c_73_p N_noxref_7_M9_noxref_g ) capacitor c=0.00896756f \
 //x=2.11 //y=5.72 //x2=2.33 //y2=6.025
cc_182 ( N_noxref_1_c_5_p N_noxref_7_c_890_n ) capacitor c=0.00114203f \
 //x=1.64 //y=1.145 //x2=1.375 //y2=0.905
cc_183 ( N_noxref_1_M2_noxref_d N_noxref_7_c_890_n ) capacitor c=0.00145956f \
 //x=1.45 //y=0.905 //x2=1.375 //y2=0.905
cc_184 ( N_noxref_1_c_5_p N_noxref_7_c_892_n ) capacitor c=0.00235402f \
 //x=1.64 //y=1.145 //x2=1.375 //y2=1.255
cc_185 ( N_noxref_1_c_33_p N_noxref_7_c_892_n ) capacitor c=7.7986e-19 \
 //x=1.64 //y=1.57 //x2=1.375 //y2=1.255
cc_186 ( N_noxref_1_M2_noxref_d N_noxref_7_c_892_n ) capacitor c=0.00237422f \
 //x=1.45 //y=0.905 //x2=1.375 //y2=1.255
cc_187 ( N_noxref_1_c_50_p N_noxref_7_c_895_n ) capacitor c=0.00120307f \
 //x=0.67 //y=1.57 //x2=1.375 //y2=1.56
cc_188 ( N_noxref_1_c_33_p N_noxref_7_c_895_n ) capacitor c=0.0030633f \
 //x=1.64 //y=1.57 //x2=1.375 //y2=1.56
cc_189 ( N_noxref_1_c_4_p N_noxref_7_c_897_n ) capacitor c=0.00915686f \
 //x=1.555 //y=1.655 //x2=1.375 //y2=1.915
cc_190 ( N_noxref_1_c_131_p N_noxref_7_c_897_n ) capacitor c=0.00300603f \
 //x=2.22 //y=3.17 //x2=1.375 //y2=1.915
cc_191 ( N_noxref_1_c_5_p N_noxref_7_c_899_n ) capacitor c=5.45609e-19 \
 //x=1.64 //y=1.145 //x2=1.75 //y2=0.75
cc_192 ( N_noxref_1_M2_noxref_d N_noxref_7_c_899_n ) capacitor c=0.0020782f \
 //x=1.45 //y=0.905 //x2=1.75 //y2=0.75
cc_193 ( N_noxref_1_c_5_p N_noxref_7_c_901_n ) capacitor c=4.1601e-19 //x=1.64 \
 //y=1.145 //x2=1.75 //y2=1.405
cc_194 ( N_noxref_1_c_33_p N_noxref_7_c_901_n ) capacitor c=0.00913324f \
 //x=1.64 //y=1.57 //x2=1.75 //y2=1.405
cc_195 ( N_noxref_1_c_6_p N_noxref_7_c_901_n ) capacitor c=0.0045388f \
 //x=2.135 //y=1.655 //x2=1.75 //y2=1.405
cc_196 ( N_noxref_1_M2_noxref_d N_noxref_7_c_901_n ) capacitor c=0.003549f \
 //x=1.45 //y=0.905 //x2=1.75 //y2=1.405
cc_197 ( N_noxref_1_c_5_p N_noxref_7_c_905_n ) capacitor c=9.74621e-19 \
 //x=1.64 //y=1.145 //x2=1.905 //y2=0.905
cc_198 ( N_noxref_1_M2_noxref_d N_noxref_7_c_905_n ) capacitor c=8.55887e-19 \
 //x=1.45 //y=0.905 //x2=1.905 //y2=0.905
cc_199 ( N_noxref_1_c_5_p N_noxref_7_c_907_n ) capacitor c=0.00376484f \
 //x=1.64 //y=1.145 //x2=1.905 //y2=1.255
cc_200 ( N_noxref_1_c_33_p N_noxref_7_c_907_n ) capacitor c=0.0012183f \
 //x=1.64 //y=1.57 //x2=1.905 //y2=1.255
cc_201 ( N_noxref_1_M2_noxref_d N_noxref_7_c_907_n ) capacitor c=0.00237422f \
 //x=1.45 //y=0.905 //x2=1.905 //y2=1.255
cc_202 ( N_noxref_1_c_109_p N_noxref_7_c_910_n ) capacitor c=0.00829075f \
 //x=2.22 //y=5.125 //x2=2.255 //y2=4.795
cc_203 ( N_noxref_1_c_72_p N_noxref_7_c_910_n ) capacitor c=0.00139519f \
 //x=2.22 //y=5.21 //x2=2.255 //y2=4.795
cc_204 ( N_noxref_1_c_73_p N_noxref_7_c_910_n ) capacitor c=0.00157916f \
 //x=2.11 //y=5.72 //x2=2.255 //y2=4.795
cc_205 ( N_noxref_1_c_4_p N_noxref_7_c_913_n ) capacitor c=0.00129562f \
 //x=1.555 //y=1.655 //x2=1.375 //y2=2.08
cc_206 ( N_noxref_1_c_131_p N_noxref_7_c_913_n ) capacitor c=0.00278769f \
 //x=2.22 //y=3.17 //x2=1.375 //y2=2.08
cc_207 ( N_noxref_1_c_109_p N_noxref_7_c_915_n ) capacitor c=0.00140919f \
 //x=2.22 //y=5.125 //x2=1.48 //y2=4.705
cc_208 ( N_noxref_1_c_3_p N_noxref_8_c_975_n ) capacitor c=2.03695e-19 \
 //x=0.67 //y=1.13 //x2=1.585 //y2=5.21
cc_209 ( N_noxref_1_c_4_p N_noxref_8_c_975_n ) capacitor c=0.00500529f \
 //x=1.555 //y=1.655 //x2=1.585 //y2=5.21
cc_210 ( N_noxref_1_c_72_p N_noxref_8_c_975_n ) capacitor c=0.0174982f \
 //x=2.22 //y=5.21 //x2=1.585 //y2=5.21
cc_211 ( N_noxref_1_c_6_p N_noxref_8_c_978_n ) capacitor c=3.49767e-19 \
 //x=2.135 //y=1.655 //x2=1.67 //y2=5.59
cc_212 ( N_noxref_1_c_108_p N_noxref_8_c_978_n ) capacitor c=0.0578031f \
 //x=2.11 //y=5.59 //x2=1.67 //y2=5.59
cc_213 ( N_noxref_1_c_73_p N_noxref_8_c_978_n ) capacitor c=0.00432732f \
 //x=2.11 //y=5.72 //x2=1.67 //y2=5.59
cc_214 ( N_noxref_1_c_108_p N_noxref_8_c_981_n ) capacitor c=0.00731192f \
 //x=2.11 //y=5.59 //x2=2.435 //y2=6.91
cc_215 ( N_noxref_1_c_7_p N_noxref_8_c_981_n ) capacitor c=5.02595e-19 \
 //x=2.22 //y=3.49 //x2=2.435 //y2=6.91
cc_216 ( N_noxref_1_c_72_p N_noxref_8_c_981_n ) capacitor c=0.00145412f \
 //x=2.22 //y=5.21 //x2=2.435 //y2=6.91
cc_217 ( N_noxref_1_c_73_p N_noxref_8_c_981_n ) capacitor c=0.00368853f \
 //x=2.11 //y=5.72 //x2=2.435 //y2=6.91
cc_218 ( N_noxref_1_c_2_p N_noxref_8_c_985_n ) capacitor c=0.00522451f \
 //x=0.585 //y=1.655 //x2=0.63 //y2=5.21
cc_219 ( N_noxref_1_c_3_p N_noxref_8_c_985_n ) capacitor c=2.29432e-19 \
 //x=0.67 //y=1.13 //x2=0.63 //y2=5.21
cc_220 ( N_noxref_1_c_108_p N_noxref_8_c_985_n ) capacitor c=0.00100155f \
 //x=2.11 //y=5.59 //x2=0.63 //y2=5.21
cc_221 ( N_noxref_1_c_73_p N_noxref_8_c_988_n ) capacitor c=8.19351e-19 \
 //x=2.11 //y=5.72 //x2=1.67 //y2=6.74
cc_222 ( N_noxref_1_c_7_p N_noxref_8_c_989_n ) capacitor c=2.85695e-19 \
 //x=2.22 //y=3.49 //x2=2.55 //y2=6.74
cc_223 ( N_noxref_1_c_73_p N_noxref_8_c_989_n ) capacitor c=8.19351e-19 \
 //x=2.11 //y=5.72 //x2=2.55 //y2=6.74
cc_224 ( N_noxref_1_c_108_p N_noxref_8_c_991_n ) capacitor c=0.00425215f \
 //x=2.11 //y=5.59 //x2=1.67 //y2=5.72
cc_225 ( N_noxref_1_c_73_p N_noxref_8_c_991_n ) capacitor c=0.0524362f \
 //x=2.11 //y=5.72 //x2=1.67 //y2=5.72
cc_226 ( N_noxref_1_c_108_p N_noxref_8_M9_noxref_d ) capacitor c=0.00783481f \
 //x=2.11 //y=5.59 //x2=2.405 //y2=5.025
cc_227 ( N_noxref_1_c_73_p N_noxref_8_M9_noxref_d ) capacitor c=0.0481518f \
 //x=2.11 //y=5.72 //x2=2.405 //y2=5.025
cc_228 ( N_noxref_1_c_50_p N_noxref_9_c_1063_n ) capacitor c=5.90929e-19 \
 //x=0.67 //y=1.57 //x2=4.44 //y2=1.755
cc_229 ( N_noxref_1_c_33_p N_noxref_9_c_1063_n ) capacitor c=0.00365555f \
 //x=1.64 //y=1.57 //x2=4.44 //y2=1.755
cc_230 ( N_noxref_1_c_6_p N_noxref_9_c_1063_n ) capacitor c=0.00276776f \
 //x=2.135 //y=1.655 //x2=4.44 //y2=1.755
cc_231 ( N_noxref_1_c_231_p N_noxref_9_c_1063_n ) capacitor c=0.00115244f \
 //x=4.18 //y=1.255 //x2=4.44 //y2=1.755
cc_232 ( N_noxref_1_c_63_p N_noxref_9_c_1063_n ) capacitor c=0.00537549f \
 //x=4.18 //y=1.565 //x2=4.44 //y2=1.755
cc_233 ( N_noxref_1_c_39_p N_noxref_9_c_1063_n ) capacitor c=0.00392604f \
 //x=4.18 //y=1.92 //x2=4.44 //y2=1.755
cc_234 ( N_noxref_1_c_234_p N_noxref_9_c_1063_n ) capacitor c=0.00946302f \
 //x=4.555 //y=1.41 //x2=4.44 //y2=1.755
cc_235 ( N_noxref_1_c_67_p N_noxref_9_c_1063_n ) capacitor c=0.00362207f \
 //x=4.71 //y=1.255 //x2=4.44 //y2=1.755
cc_236 ( N_noxref_1_c_108_p N_noxref_9_c_1071_n ) capacitor c=8.16881e-19 \
 //x=2.11 //y=5.59 //x2=4.445 //y2=5.24
cc_237 ( N_noxref_1_c_72_p N_noxref_9_c_1071_n ) capacitor c=0.00193209f \
 //x=2.22 //y=5.21 //x2=4.445 //y2=5.24
cc_238 ( N_noxref_1_M10_noxref_g N_noxref_9_c_1071_n ) capacitor c=0.00141266f \
 //x=4.225 //y=6.02 //x2=4.445 //y2=5.24
cc_239 ( N_noxref_1_M11_noxref_g N_noxref_9_c_1071_n ) capacitor c=0.00377331f \
 //x=4.665 //y=6.02 //x2=4.445 //y2=5.24
cc_240 ( N_noxref_1_c_234_p N_noxref_9_c_1075_n ) capacitor c=0.00180253f \
 //x=4.555 //y=1.41 //x2=4.725 //y2=1.84
cc_241 ( N_noxref_1_c_131_p N_noxref_9_c_1076_n ) capacitor c=0.00276776f \
 //x=2.22 //y=3.17 //x2=4.525 //y2=1.84
cc_242 ( N_noxref_1_c_31_p N_noxref_9_c_1076_n ) capacitor c=0.00392604f \
 //x=4.07 //y=2.085 //x2=4.525 //y2=1.84
cc_243 ( N_noxref_1_M11_noxref_g N_noxref_9_c_1078_n ) capacitor c=0.00966342f \
 //x=4.665 //y=6.02 //x2=4.725 //y2=4.96
cc_244 ( N_noxref_1_c_109_p N_noxref_9_c_1079_n ) capacitor c=0.00193209f \
 //x=2.22 //y=5.125 //x2=4.53 //y2=4.96
cc_245 ( N_noxref_1_M10_noxref_g N_noxref_9_c_1079_n ) capacitor c=0.0045573f \
 //x=4.225 //y=6.02 //x2=4.53 //y2=4.96
cc_246 ( N_noxref_1_c_118_p N_noxref_9_c_1079_n ) capacitor c=0.00262283f \
 //x=4.59 //y=4.79 //x2=4.53 //y2=4.96
cc_247 ( N_noxref_1_c_131_p N_noxref_9_c_1082_n ) capacitor c=0.00260832f \
 //x=2.22 //y=3.17 //x2=4.81 //y2=4.875
cc_248 ( N_noxref_1_c_109_p N_noxref_9_c_1082_n ) capacitor c=0.00267317f \
 //x=2.22 //y=5.125 //x2=4.81 //y2=4.875
cc_249 ( N_noxref_1_c_35_p N_noxref_9_c_1082_n ) capacitor c=0.0425276f \
 //x=4.07 //y=3.175 //x2=4.81 //y2=4.875
cc_250 ( N_noxref_1_c_8_p N_noxref_9_c_1082_n ) capacitor c=0.0149195f \
 //x=4.07 //y=3.495 //x2=4.81 //y2=4.875
cc_251 ( N_noxref_1_c_102_p N_noxref_9_c_1082_n ) capacitor c=0.0570666f \
 //x=4.07 //y=4.58 //x2=4.81 //y2=4.875
cc_252 ( N_noxref_1_c_252_p N_noxref_9_c_1082_n ) capacitor c=0.00541027f \
 //x=4.07 //y=3.33 //x2=4.81 //y2=4.875
cc_253 ( N_noxref_1_c_10_p N_noxref_9_c_1082_n ) capacitor c=0.00825076f \
 //x=4.07 //y=2.085 //x2=4.81 //y2=4.875
cc_254 ( N_noxref_1_c_123_p N_noxref_9_c_1082_n ) capacitor c=0.006875f \
 //x=4.07 //y=3.335 //x2=4.81 //y2=4.875
cc_255 ( N_noxref_1_c_11_p N_noxref_9_c_1082_n ) capacitor c=0.0023016f \
 //x=4.07 //y=2.085 //x2=4.81 //y2=4.875
cc_256 ( N_noxref_1_c_103_p N_noxref_9_c_1082_n ) capacitor c=0.00250262f \
 //x=4.07 //y=4.7 //x2=4.81 //y2=4.875
cc_257 ( N_noxref_1_c_118_p N_noxref_9_c_1082_n ) capacitor c=4.08297e-19 \
 //x=4.59 //y=4.79 //x2=4.81 //y2=4.875
cc_258 ( N_noxref_1_c_115_p N_noxref_9_c_1082_n ) capacitor c=0.00124564f \
 //x=4.3 //y=4.79 //x2=4.81 //y2=4.875
cc_259 ( N_noxref_1_c_31_p N_noxref_9_c_1082_n ) capacitor c=0.00112403f \
 //x=4.07 //y=2.085 //x2=4.81 //y2=4.875
cc_260 ( N_noxref_1_c_5_p N_noxref_9_c_1095_n ) capacitor c=0.00560743f \
 //x=1.64 //y=1.145 //x2=4.44 //y2=1.005
cc_261 ( N_noxref_1_c_30_p N_noxref_9_c_1095_n ) capacitor c=0.00179658f \
 //x=4.18 //y=0.91 //x2=4.44 //y2=1.005
cc_262 ( N_noxref_1_c_231_p N_noxref_9_c_1095_n ) capacitor c=0.00374613f \
 //x=4.18 //y=1.255 //x2=4.44 //y2=1.005
cc_263 ( N_noxref_1_c_65_p N_noxref_9_c_1095_n ) capacitor c=5.57924e-19 \
 //x=4.555 //y=0.755 //x2=4.44 //y2=1.005
cc_264 ( N_noxref_1_c_234_p N_noxref_9_c_1095_n ) capacitor c=5.75878e-19 \
 //x=4.555 //y=1.41 //x2=4.44 //y2=1.005
cc_265 ( N_noxref_1_c_32_p N_noxref_9_c_1095_n ) capacitor c=0.00160969f \
 //x=4.71 //y=0.91 //x2=4.44 //y2=1.005
cc_266 ( N_noxref_1_c_67_p N_noxref_9_c_1095_n ) capacitor c=0.00411132f \
 //x=4.71 //y=1.255 //x2=4.44 //y2=1.005
cc_267 ( N_noxref_1_M10_noxref_g N_noxref_9_c_1102_n ) capacitor c=0.0162066f \
 //x=4.225 //y=6.02 //x2=4.445 //y2=5.38
cc_268 ( N_noxref_1_M11_noxref_g N_noxref_9_c_1102_n ) capacitor c=0.0162066f \
 //x=4.665 //y=6.02 //x2=4.445 //y2=5.38
cc_269 ( N_noxref_1_c_118_p N_noxref_9_c_1102_n ) capacitor c=0.00290963f \
 //x=4.59 //y=4.79 //x2=4.445 //y2=5.38
cc_270 ( N_noxref_1_c_30_p N_noxref_9_M3_noxref_d ) capacitor c=0.00137914f \
 //x=4.18 //y=0.91 //x2=4.255 //y2=0.91
cc_271 ( N_noxref_1_c_231_p N_noxref_9_M3_noxref_d ) capacitor c=0.0023891f \
 //x=4.18 //y=1.255 //x2=4.255 //y2=0.91
cc_272 ( N_noxref_1_c_65_p N_noxref_9_M3_noxref_d ) capacitor c=0.0020782f \
 //x=4.555 //y=0.755 //x2=4.255 //y2=0.91
cc_273 ( N_noxref_1_c_234_p N_noxref_9_M3_noxref_d ) capacitor c=0.00356097f \
 //x=4.555 //y=1.41 //x2=4.255 //y2=0.91
cc_274 ( N_noxref_1_c_32_p N_noxref_9_M3_noxref_d ) capacitor c=0.00138452f \
 //x=4.71 //y=0.91 //x2=4.255 //y2=0.91
cc_275 ( N_noxref_1_c_67_p N_noxref_9_M3_noxref_d ) capacitor c=0.00235934f \
 //x=4.71 //y=1.255 //x2=4.255 //y2=0.91
cc_276 ( N_noxref_2_c_276_n N_noxref_4_c_491_n ) capacitor c=6.99281e-19 \
 //x=4.81 //y=0 //x2=-0.37 //y2=2.245
cc_277 ( N_noxref_2_c_290_n N_noxref_4_c_491_n ) capacitor c=9.81943e-19 \
 //x=0.1 //y=0.53 //x2=-0.37 //y2=2.245
cc_278 ( N_noxref_2_c_346_p N_noxref_4_c_491_n ) capacitor c=0.00920582f \
 //x=-0.739 //y=0 //x2=-0.37 //y2=2.245
cc_279 ( N_noxref_2_c_346_p N_noxref_4_c_521_n ) capacitor c=0.0119787f \
 //x=-0.739 //y=0 //x2=-0.37 //y2=4.585
cc_280 ( N_noxref_2_c_290_n N_noxref_4_c_494_n ) capacitor c=4.19546e-19 \
 //x=0.1 //y=0.53 //x2=-0.369 //y2=2.08
cc_281 ( N_noxref_2_c_346_p N_noxref_4_c_494_n ) capacitor c=0.00368165f \
 //x=-0.739 //y=0 //x2=-0.369 //y2=2.08
cc_282 ( N_noxref_2_c_290_n N_noxref_4_c_497_n ) capacitor c=0.0209625f \
 //x=0.1 //y=0.53 //x2=-0.565 //y2=0.905
cc_283 ( N_noxref_2_M0_noxref_s N_noxref_4_c_497_n ) capacitor c=0.033078f \
 //x=-0.92 //y=0.365 //x2=-0.565 //y2=0.905
cc_284 ( N_noxref_2_c_290_n N_noxref_4_c_503_n ) capacitor c=2.1838e-19 \
 //x=0.1 //y=0.53 //x2=-0.565 //y2=1.915
cc_285 ( N_noxref_2_c_346_p N_noxref_4_c_503_n ) capacitor c=0.0121558f \
 //x=-0.739 //y=0 //x2=-0.565 //y2=1.915
cc_286 ( N_noxref_2_c_290_n N_noxref_4_c_511_n ) capacitor c=0.00805599f \
 //x=0.1 //y=0.53 //x2=-0.035 //y2=0.905
cc_287 ( N_noxref_2_M0_noxref_s N_noxref_4_c_511_n ) capacitor c=0.00617417f \
 //x=-0.92 //y=0.365 //x2=-0.035 //y2=0.905
cc_288 ( N_noxref_2_M0_noxref_s N_noxref_4_c_513_n ) capacitor c=0.00120103f \
 //x=-0.92 //y=0.365 //x2=-0.035 //y2=1.25
cc_289 ( N_noxref_2_c_346_p N_noxref_5_c_632_n ) capacitor c=0.00989031f \
 //x=-0.739 //y=0 //x2=-0.739 //y2=7.4
cc_290 ( N_noxref_2_c_308_n N_noxref_5_c_610_n ) capacitor c=0.00912128f \
 //x=3.33 //y=0 //x2=3.33 //y2=7.4
cc_291 ( N_noxref_2_c_316_n N_noxref_5_c_618_n ) capacitor c=0.00989031f \
 //x=4.93 //y=0 //x2=4.81 //y2=7.4
cc_292 ( N_noxref_2_c_293_n N_noxref_6_c_736_n ) capacitor c=6.15173e-19 \
 //x=1.07 //y=0.53 //x2=0.37 //y2=2.21
cc_293 ( N_noxref_2_c_293_n N_noxref_6_c_741_n ) capacitor c=9.05712e-19 \
 //x=1.07 //y=0.53 //x2=0.37 //y2=2.08
cc_294 ( N_noxref_2_c_346_p N_noxref_6_c_741_n ) capacitor c=5.03552e-19 \
 //x=-0.739 //y=0 //x2=0.37 //y2=2.08
cc_295 ( N_noxref_2_c_308_n N_noxref_6_c_741_n ) capacitor c=2.74946e-19 \
 //x=3.33 //y=0 //x2=0.37 //y2=2.08
cc_296 ( N_noxref_2_c_293_n N_noxref_6_c_742_n ) capacitor c=0.0207598f \
 //x=1.07 //y=0.53 //x2=0.405 //y2=0.905
cc_297 ( N_noxref_2_M0_noxref_s N_noxref_6_c_742_n ) capacitor c=0.00732593f \
 //x=-0.92 //y=0.365 //x2=0.405 //y2=0.905
cc_298 ( N_noxref_2_M0_noxref_s N_noxref_6_c_751_n ) capacitor c=0.00120679f \
 //x=-0.92 //y=0.365 //x2=0.78 //y2=1.405
cc_299 ( N_noxref_2_c_293_n N_noxref_6_c_756_n ) capacitor c=0.00805599f \
 //x=1.07 //y=0.53 //x2=0.935 //y2=0.905
cc_300 ( N_noxref_2_M0_noxref_s N_noxref_6_c_756_n ) capacitor c=0.00617003f \
 //x=-0.92 //y=0.365 //x2=0.935 //y2=0.905
cc_301 ( N_noxref_2_c_293_n N_noxref_6_c_761_n ) capacitor c=2.1838e-19 \
 //x=1.07 //y=0.53 //x2=0.37 //y2=2.08
cc_302 ( N_noxref_2_M0_noxref_s N_noxref_6_c_761_n ) capacitor c=0.00118102f \
 //x=-0.92 //y=0.365 //x2=0.37 //y2=2.08
cc_303 ( N_noxref_2_c_297_n N_noxref_7_c_865_n ) capacitor c=7.66217e-19 \
 //x=2.04 //y=0.53 //x2=1.48 //y2=2.225
cc_304 ( N_noxref_2_c_297_n N_noxref_7_c_876_n ) capacitor c=0.00100208f \
 //x=2.04 //y=0.53 //x2=1.48 //y2=2.08
cc_305 ( N_noxref_2_c_308_n N_noxref_7_c_876_n ) capacitor c=0.00172597f \
 //x=3.33 //y=0 //x2=1.48 //y2=2.08
cc_306 ( N_noxref_2_c_297_n N_noxref_7_c_890_n ) capacitor c=0.0208435f \
 //x=2.04 //y=0.53 //x2=1.375 //y2=0.905
cc_307 ( N_noxref_2_M0_noxref_s N_noxref_7_c_890_n ) capacitor c=0.00732593f \
 //x=-0.92 //y=0.365 //x2=1.375 //y2=0.905
cc_308 ( N_noxref_2_M0_noxref_s N_noxref_7_c_901_n ) capacitor c=0.00271091f \
 //x=-0.92 //y=0.365 //x2=1.75 //y2=1.405
cc_309 ( N_noxref_2_c_297_n N_noxref_7_c_905_n ) capacitor c=0.00825432f \
 //x=2.04 //y=0.53 //x2=1.905 //y2=0.905
cc_310 ( N_noxref_2_M0_noxref_s N_noxref_7_c_905_n ) capacitor c=0.0143707f \
 //x=-0.92 //y=0.365 //x2=1.905 //y2=0.905
cc_311 ( N_noxref_2_c_297_n N_noxref_7_c_913_n ) capacitor c=2.1838e-19 \
 //x=2.04 //y=0.53 //x2=1.375 //y2=2.08
cc_312 ( N_noxref_2_c_308_n N_noxref_9_c_1063_n ) capacitor c=0.00364638f \
 //x=3.33 //y=0 //x2=4.44 //y2=1.755
cc_313 ( N_noxref_2_c_316_n N_noxref_9_c_1063_n ) capacitor c=0.00174147f \
 //x=4.93 //y=0 //x2=4.44 //y2=1.755
cc_314 ( N_noxref_2_M3_noxref_s N_noxref_9_c_1063_n ) capacitor c=0.033207f \
 //x=3.825 //y=0.37 //x2=4.44 //y2=1.755
cc_315 ( N_noxref_2_c_276_n N_noxref_9_c_1075_n ) capacitor c=0.00496359f \
 //x=4.81 //y=0 //x2=4.725 //y2=1.84
cc_316 ( N_noxref_2_c_307_n N_noxref_9_c_1075_n ) capacitor c=0.00321677f \
 //x=4.845 //y=0.535 //x2=4.725 //y2=1.84
cc_317 ( N_noxref_2_c_316_n N_noxref_9_c_1075_n ) capacitor c=0.030726f \
 //x=4.93 //y=0 //x2=4.725 //y2=1.84
cc_318 ( N_noxref_2_M3_noxref_s N_noxref_9_c_1075_n ) capacitor c=0.00565313f \
 //x=3.825 //y=0.37 //x2=4.725 //y2=1.84
cc_319 ( N_noxref_2_c_276_n N_noxref_9_c_1095_n ) capacitor c=0.00996824f \
 //x=4.81 //y=0 //x2=4.44 //y2=1.005
cc_320 ( N_noxref_2_c_303_n N_noxref_9_c_1095_n ) capacitor c=0.00124697f \
 //x=4.355 //y=0.535 //x2=4.44 //y2=1.005
cc_321 ( N_noxref_2_c_307_n N_noxref_9_c_1095_n ) capacitor c=0.00130436f \
 //x=4.845 //y=0.535 //x2=4.44 //y2=1.005
cc_322 ( N_noxref_2_c_316_n N_noxref_9_c_1095_n ) capacitor c=2.8029e-19 \
 //x=4.93 //y=0 //x2=4.44 //y2=1.005
cc_323 ( N_noxref_2_M3_noxref_s N_noxref_9_c_1095_n ) capacitor c=0.0160882f \
 //x=3.825 //y=0.37 //x2=4.44 //y2=1.005
cc_324 ( N_noxref_2_c_276_n N_noxref_9_M3_noxref_d ) capacitor c=0.00119583f \
 //x=4.81 //y=0 //x2=4.255 //y2=0.91
cc_325 ( N_noxref_2_c_316_n N_noxref_9_M3_noxref_d ) capacitor c=2.70835e-19 \
 //x=4.93 //y=0 //x2=4.255 //y2=0.91
cc_326 ( N_noxref_2_M3_noxref_s N_noxref_9_M3_noxref_d ) capacitor \
 c=0.0377604f //x=3.825 //y=0.37 //x2=4.255 //y2=0.91
cc_327 ( N_noxref_3_c_395_n N_noxref_4_c_491_n ) capacitor c=3.49728e-19 \
 //x=0.075 //y=5.21 //x2=-0.37 //y2=2.245
cc_328 ( N_noxref_3_c_395_n N_noxref_4_c_532_n ) capacitor c=0.00780885f \
 //x=0.075 //y=5.21 //x2=-0.524 //y2=4.705
cc_329 ( N_noxref_3_c_402_p N_noxref_4_c_532_n ) capacitor c=0.0239345f \
 //x=-0.687 //y=5.21 //x2=-0.524 //y2=4.705
cc_330 ( N_noxref_3_c_403_p N_noxref_4_c_532_n ) capacitor c=0.0022154f \
 //x=-0.689 //y=5.38 //x2=-0.524 //y2=4.705
cc_331 ( N_noxref_3_c_395_n N_noxref_4_c_535_n ) capacitor c=0.00104675f \
 //x=0.075 //y=5.21 //x2=-0.524 //y2=4.705
cc_332 ( N_noxref_3_c_402_p N_noxref_4_c_535_n ) capacitor c=0.00565893f \
 //x=-0.687 //y=5.21 //x2=-0.524 //y2=4.705
cc_333 ( N_noxref_3_c_403_p N_noxref_4_c_535_n ) capacitor c=0.00126834f \
 //x=-0.689 //y=5.38 //x2=-0.524 //y2=4.705
cc_334 ( N_noxref_3_c_395_n N_noxref_4_M4_noxref_g ) capacitor c=0.00997309f \
 //x=0.075 //y=5.21 //x2=-0.47 //y2=6.025
cc_335 ( N_noxref_3_c_402_p N_noxref_4_M4_noxref_g ) capacitor c=0.00429908f \
 //x=-0.687 //y=5.21 //x2=-0.47 //y2=6.025
cc_336 ( N_noxref_3_c_403_p N_noxref_4_M4_noxref_g ) capacitor c=0.0483843f \
 //x=-0.689 //y=5.38 //x2=-0.47 //y2=6.025
cc_337 ( N_noxref_3_M4_noxref_s N_noxref_4_M4_noxref_g ) capacitor \
 c=0.00370227f //x=-0.825 //y=5.025 //x2=-0.47 //y2=6.025
cc_338 ( N_noxref_3_c_395_n N_noxref_4_M5_noxref_g ) capacitor c=0.00967464f \
 //x=0.075 //y=5.21 //x2=-0.03 //y2=6.025
cc_339 ( N_noxref_3_c_397_n N_noxref_4_M5_noxref_g ) capacitor c=0.00182852f \
 //x=0.192 //y=5.21 //x2=-0.03 //y2=6.025
cc_340 ( N_noxref_3_c_413_p N_noxref_4_M5_noxref_g ) capacitor c=0.00175452f \
 //x=0.19 //y=6.74 //x2=-0.03 //y2=6.025
cc_341 ( N_noxref_3_c_414_p N_noxref_4_M5_noxref_g ) capacitor c=0.0170175f \
 //x=0.19 //y=5.38 //x2=-0.03 //y2=6.025
cc_342 ( N_noxref_3_c_395_n N_noxref_4_c_546_n ) capacitor c=0.00196455f \
 //x=0.075 //y=5.21 //x2=-0.105 //y2=4.795
cc_343 ( N_noxref_3_c_402_p N_noxref_4_c_547_n ) capacitor c=9.17057e-19 \
 //x=-0.687 //y=5.21 //x2=-0.524 //y2=4.705
cc_344 ( N_noxref_3_c_403_p N_noxref_4_c_547_n ) capacitor c=0.00297041f \
 //x=-0.689 //y=5.38 //x2=-0.524 //y2=4.705
cc_345 ( N_noxref_3_c_395_n N_noxref_5_c_635_n ) capacitor c=0.00186634f \
 //x=0.075 //y=5.21 //x2=-0.335 //y2=7.4
cc_346 ( N_noxref_3_c_402_p N_noxref_5_c_635_n ) capacitor c=3.01893e-19 \
 //x=-0.687 //y=5.21 //x2=-0.335 //y2=7.4
cc_347 ( N_noxref_3_c_403_p N_noxref_5_c_635_n ) capacitor c=0.00240599f \
 //x=-0.689 //y=5.38 //x2=-0.335 //y2=7.4
cc_348 ( N_noxref_3_M4_noxref_s N_noxref_5_c_635_n ) capacitor c=0.0245152f \
 //x=-0.825 //y=5.025 //x2=-0.335 //y2=7.4
cc_349 ( N_noxref_3_c_395_n N_noxref_5_c_639_n ) capacitor c=0.00495979f \
 //x=0.075 //y=5.21 //x2=-0.25 //y2=6.855
cc_350 ( N_noxref_3_c_413_p N_noxref_5_c_639_n ) capacitor c=0.0375632f \
 //x=0.19 //y=6.74 //x2=-0.25 //y2=6.855
cc_351 ( N_noxref_3_c_424_p N_noxref_5_c_639_n ) capacitor c=6.22236e-19 \
 //x=1.07 //y=6.74 //x2=-0.25 //y2=6.855
cc_352 ( N_noxref_3_c_403_p N_noxref_5_c_639_n ) capacitor c=0.00220362f \
 //x=-0.689 //y=5.38 //x2=-0.25 //y2=6.855
cc_353 ( N_noxref_3_c_414_p N_noxref_5_c_639_n ) capacitor c=0.00220362f \
 //x=0.19 //y=5.38 //x2=-0.25 //y2=6.855
cc_354 ( N_noxref_3_M4_noxref_s N_noxref_5_c_639_n ) capacitor c=0.0381427f \
 //x=-0.825 //y=5.025 //x2=-0.25 //y2=6.855
cc_355 ( N_noxref_3_c_413_p N_noxref_5_c_645_n ) capacitor c=0.0104314f \
 //x=0.19 //y=6.74 //x2=-0.25 //y2=7.23
cc_356 ( N_noxref_3_c_403_p N_noxref_5_c_645_n ) capacitor c=0.00158506f \
 //x=-0.689 //y=5.38 //x2=-0.25 //y2=7.23
cc_357 ( N_noxref_3_c_414_p N_noxref_5_c_645_n ) capacitor c=4.62894e-19 \
 //x=0.19 //y=5.38 //x2=-0.25 //y2=7.23
cc_358 ( N_noxref_3_M4_noxref_s N_noxref_5_c_645_n ) capacitor c=0.0121524f \
 //x=-0.825 //y=5.025 //x2=-0.25 //y2=7.23
cc_359 ( N_noxref_3_c_395_n N_noxref_5_c_603_n ) capacitor c=0.00198579f \
 //x=0.075 //y=5.21 //x2=4.81 //y2=7.4
cc_360 ( N_noxref_3_c_413_p N_noxref_5_c_603_n ) capacitor c=0.0973825f \
 //x=0.19 //y=6.74 //x2=4.81 //y2=7.4
cc_361 ( N_noxref_3_c_424_p N_noxref_5_c_603_n ) capacitor c=0.00214718f \
 //x=1.07 //y=6.74 //x2=4.81 //y2=7.4
cc_362 ( N_noxref_3_c_414_p N_noxref_5_c_603_n ) capacitor c=0.0020548f \
 //x=0.19 //y=5.38 //x2=4.81 //y2=7.4
cc_363 ( N_noxref_3_M7_noxref_d N_noxref_5_c_603_n ) capacitor c=0.00206634f \
 //x=0.925 //y=5.025 //x2=4.81 //y2=7.4
cc_364 ( N_noxref_3_c_395_n N_noxref_5_c_606_n ) capacitor c=0.00432797f \
 //x=0.075 //y=5.21 //x2=3.16 //y2=7.4
cc_365 ( N_noxref_3_c_402_p N_noxref_5_c_606_n ) capacitor c=2.30791e-19 \
 //x=-0.687 //y=5.21 //x2=3.16 //y2=7.4
cc_366 ( N_noxref_3_c_413_p N_noxref_5_c_606_n ) capacitor c=0.0204502f \
 //x=0.19 //y=6.74 //x2=3.16 //y2=7.4
cc_367 ( N_noxref_3_c_424_p N_noxref_5_c_606_n ) capacitor c=0.00105953f \
 //x=1.07 //y=6.74 //x2=3.16 //y2=7.4
cc_368 ( N_noxref_3_c_403_p N_noxref_5_c_606_n ) capacitor c=0.0126678f \
 //x=-0.689 //y=5.38 //x2=3.16 //y2=7.4
cc_369 ( N_noxref_3_c_414_p N_noxref_5_c_606_n ) capacitor c=0.00855842f \
 //x=0.19 //y=5.38 //x2=3.16 //y2=7.4
cc_370 ( N_noxref_3_M4_noxref_s N_noxref_5_c_606_n ) capacitor c=0.00292204f \
 //x=-0.825 //y=5.025 //x2=3.16 //y2=7.4
cc_371 ( N_noxref_3_M7_noxref_d N_noxref_5_c_606_n ) capacitor c=0.00858175f \
 //x=0.925 //y=5.025 //x2=3.16 //y2=7.4
cc_372 ( N_noxref_3_c_402_p N_noxref_5_c_632_n ) capacitor c=0.0100761f \
 //x=-0.687 //y=5.21 //x2=-0.739 //y2=7.4
cc_373 ( N_noxref_3_c_403_p N_noxref_5_c_632_n ) capacitor c=0.0554809f \
 //x=-0.689 //y=5.38 //x2=-0.739 //y2=7.4
cc_374 ( N_noxref_3_M4_noxref_s N_noxref_5_c_632_n ) capacitor c=0.00790985f \
 //x=-0.825 //y=5.025 //x2=-0.739 //y2=7.4
cc_375 ( N_noxref_3_c_448_p N_noxref_5_c_618_n ) capacitor c=0.00221878f \
 //x=0.955 //y=6.91 //x2=4.81 //y2=7.4
cc_376 ( N_noxref_3_c_413_p N_noxref_5_c_618_n ) capacitor c=0.00112916f \
 //x=0.19 //y=6.74 //x2=4.81 //y2=7.4
cc_377 ( N_noxref_3_c_424_p N_noxref_5_c_618_n ) capacitor c=0.00112713f \
 //x=1.07 //y=6.74 //x2=4.81 //y2=7.4
cc_378 ( N_noxref_3_c_403_p N_noxref_5_c_618_n ) capacitor c=0.00161681f \
 //x=-0.689 //y=5.38 //x2=4.81 //y2=7.4
cc_379 ( N_noxref_3_c_414_p N_noxref_5_c_618_n ) capacitor c=0.00100828f \
 //x=0.19 //y=5.38 //x2=4.81 //y2=7.4
cc_380 ( N_noxref_3_M4_noxref_s N_noxref_5_c_618_n ) capacitor c=0.00129282f \
 //x=-0.825 //y=5.025 //x2=4.81 //y2=7.4
cc_381 ( N_noxref_3_M7_noxref_d N_noxref_5_c_618_n ) capacitor c=0.00100487f \
 //x=0.925 //y=5.025 //x2=4.81 //y2=7.4
cc_382 ( N_noxref_3_c_395_n N_noxref_5_M4_noxref_d ) capacitor c=0.00667051f \
 //x=0.075 //y=5.21 //x2=-0.395 //y2=5.025
cc_383 ( N_noxref_3_c_413_p N_noxref_5_M4_noxref_d ) capacitor c=0.00466156f \
 //x=0.19 //y=6.74 //x2=-0.395 //y2=5.025
cc_384 ( N_noxref_3_c_403_p N_noxref_5_M4_noxref_d ) capacitor c=0.0736776f \
 //x=-0.689 //y=5.38 //x2=-0.395 //y2=5.025
cc_385 ( N_noxref_3_c_414_p N_noxref_5_M4_noxref_d ) capacitor c=0.0670838f \
 //x=0.19 //y=5.38 //x2=-0.395 //y2=5.025
cc_386 ( N_noxref_3_M4_noxref_s N_noxref_5_M4_noxref_d ) capacitor \
 c=0.00566948f //x=-0.825 //y=5.025 //x2=-0.395 //y2=5.025
cc_387 ( N_noxref_3_c_397_n N_noxref_6_c_736_n ) capacitor c=6.32666e-19 \
 //x=0.192 //y=5.21 //x2=0.37 //y2=2.21
cc_388 ( N_noxref_3_c_448_p N_noxref_6_c_738_n ) capacitor c=0.00230547f \
 //x=0.955 //y=6.91 //x2=0.37 //y2=4.56
cc_389 ( N_noxref_3_c_397_n N_noxref_6_c_738_n ) capacitor c=0.00148837f \
 //x=0.192 //y=5.21 //x2=0.37 //y2=4.56
cc_390 ( N_noxref_3_c_448_p N_noxref_6_c_777_n ) capacitor c=0.00233465f \
 //x=0.955 //y=6.91 //x2=0.405 //y2=4.705
cc_391 ( N_noxref_3_c_448_p N_noxref_6_M6_noxref_g ) capacitor c=0.00778083f \
 //x=0.955 //y=6.91 //x2=0.41 //y2=6.025
cc_392 ( N_noxref_3_c_397_n N_noxref_6_M6_noxref_g ) capacitor c=0.0018192f \
 //x=0.192 //y=5.21 //x2=0.41 //y2=6.025
cc_393 ( N_noxref_3_c_413_p N_noxref_6_M6_noxref_g ) capacitor c=0.0018046f \
 //x=0.19 //y=6.74 //x2=0.41 //y2=6.025
cc_394 ( N_noxref_3_c_414_p N_noxref_6_M6_noxref_g ) capacitor c=0.0170175f \
 //x=0.19 //y=5.38 //x2=0.41 //y2=6.025
cc_395 ( N_noxref_3_c_448_p N_noxref_6_M7_noxref_g ) capacitor c=0.00843033f \
 //x=0.955 //y=6.91 //x2=0.85 //y2=6.025
cc_396 ( N_noxref_3_c_424_p N_noxref_6_M7_noxref_g ) capacitor c=0.00272866f \
 //x=1.07 //y=6.74 //x2=0.85 //y2=6.025
cc_397 ( N_noxref_3_M7_noxref_d N_noxref_6_M7_noxref_g ) capacitor \
 c=0.0231499f //x=0.925 //y=5.025 //x2=0.85 //y2=6.025
cc_398 ( N_noxref_3_c_397_n N_noxref_6_c_785_n ) capacitor c=6.56606e-19 \
 //x=0.192 //y=5.21 //x2=0.405 //y2=4.705
cc_399 ( N_noxref_3_c_448_p N_noxref_8_c_975_n ) capacitor c=0.00321697f \
 //x=0.955 //y=6.91 //x2=1.585 //y2=5.21
cc_400 ( N_noxref_3_c_424_p N_noxref_8_c_975_n ) capacitor c=0.00503384f \
 //x=1.07 //y=6.74 //x2=1.585 //y2=5.21
cc_401 ( N_noxref_3_M7_noxref_d N_noxref_8_c_975_n ) capacitor c=0.00659996f \
 //x=0.925 //y=5.025 //x2=1.585 //y2=5.21
cc_402 ( N_noxref_3_c_397_n N_noxref_8_c_978_n ) capacitor c=8.51609e-19 \
 //x=0.192 //y=5.21 //x2=1.67 //y2=5.59
cc_403 ( N_noxref_3_M7_noxref_d N_noxref_8_c_978_n ) capacitor c=0.00726094f \
 //x=0.925 //y=5.025 //x2=1.67 //y2=5.59
cc_404 ( N_noxref_3_c_448_p N_noxref_8_c_985_n ) capacitor c=0.00515028f \
 //x=0.955 //y=6.91 //x2=0.63 //y2=5.21
cc_405 ( N_noxref_3_c_402_p N_noxref_8_c_985_n ) capacitor c=6.44186e-19 \
 //x=-0.687 //y=5.21 //x2=0.63 //y2=5.21
cc_406 ( N_noxref_3_c_397_n N_noxref_8_c_985_n ) capacitor c=0.0526233f \
 //x=0.192 //y=5.21 //x2=0.63 //y2=5.21
cc_407 ( N_noxref_3_c_414_p N_noxref_8_c_985_n ) capacitor c=0.00261162f \
 //x=0.19 //y=5.38 //x2=0.63 //y2=5.21
cc_408 ( N_noxref_3_c_413_p N_noxref_8_c_988_n ) capacitor c=4.26669e-19 \
 //x=0.19 //y=6.74 //x2=1.67 //y2=6.74
cc_409 ( N_noxref_3_c_424_p N_noxref_8_c_988_n ) capacitor c=0.036549f \
 //x=1.07 //y=6.74 //x2=1.67 //y2=6.74
cc_410 ( N_noxref_3_M7_noxref_d N_noxref_8_c_988_n ) capacitor c=0.00418103f \
 //x=0.925 //y=5.025 //x2=1.67 //y2=6.74
cc_411 ( N_noxref_3_c_424_p N_noxref_8_c_989_n ) capacitor c=4.2596e-19 \
 //x=1.07 //y=6.74 //x2=2.55 //y2=6.74
cc_412 ( N_noxref_3_c_448_p N_noxref_8_c_1008_n ) capacitor c=0.00406191f \
 //x=0.955 //y=6.91 //x2=0.63 //y2=5.38
cc_413 ( N_noxref_3_c_397_n N_noxref_8_c_1008_n ) capacitor c=0.00396335f \
 //x=0.192 //y=5.21 //x2=0.63 //y2=5.38
cc_414 ( N_noxref_3_c_414_p N_noxref_8_c_1008_n ) capacitor c=0.0679433f \
 //x=0.19 //y=5.38 //x2=0.63 //y2=5.38
cc_415 ( N_noxref_3_M7_noxref_d N_noxref_8_c_1008_n ) capacitor c=0.0468918f \
 //x=0.925 //y=5.025 //x2=0.63 //y2=5.38
cc_416 ( N_noxref_3_c_424_p N_noxref_8_c_991_n ) capacitor c=0.00161703f \
 //x=1.07 //y=6.74 //x2=1.67 //y2=5.72
cc_417 ( N_noxref_3_M7_noxref_d N_noxref_8_c_991_n ) capacitor c=0.0468546f \
 //x=0.925 //y=5.025 //x2=1.67 //y2=5.72
cc_418 ( N_noxref_4_M4_noxref_g N_noxref_5_c_639_n ) capacitor c=0.0012542f \
 //x=-0.47 //y=6.025 //x2=-0.25 //y2=6.855
cc_419 ( N_noxref_4_M5_noxref_g N_noxref_5_c_639_n ) capacitor c=0.0012542f \
 //x=-0.03 //y=6.025 //x2=-0.25 //y2=6.855
cc_420 ( N_noxref_4_M4_noxref_g N_noxref_5_c_645_n ) capacitor c=0.00205385f \
 //x=-0.47 //y=6.025 //x2=-0.25 //y2=7.23
cc_421 ( N_noxref_4_M5_noxref_g N_noxref_5_c_645_n ) capacitor c=0.00294739f \
 //x=-0.03 //y=6.025 //x2=-0.25 //y2=7.23
cc_422 ( N_noxref_4_M4_noxref_g N_noxref_5_c_606_n ) capacitor c=0.00715024f \
 //x=-0.47 //y=6.025 //x2=3.16 //y2=7.4
cc_423 ( N_noxref_4_M5_noxref_g N_noxref_5_c_606_n ) capacitor c=0.00754867f \
 //x=-0.03 //y=6.025 //x2=3.16 //y2=7.4
cc_424 ( N_noxref_4_c_521_n N_noxref_5_c_632_n ) capacitor c=0.0113632f \
 //x=-0.37 //y=4.585 //x2=-0.739 //y2=7.4
cc_425 ( N_noxref_4_c_532_n N_noxref_5_c_632_n ) capacitor c=0.00509436f \
 //x=-0.524 //y=4.705 //x2=-0.739 //y2=7.4
cc_426 ( N_noxref_4_c_535_n N_noxref_5_c_632_n ) capacitor c=0.00639333f \
 //x=-0.524 //y=4.705 //x2=-0.739 //y2=7.4
cc_427 ( N_noxref_4_M4_noxref_g N_noxref_5_c_632_n ) capacitor c=0.0165754f \
 //x=-0.47 //y=6.025 //x2=-0.739 //y2=7.4
cc_428 ( N_noxref_4_c_547_n N_noxref_5_c_632_n ) capacitor c=0.00542539f \
 //x=-0.524 //y=4.705 //x2=-0.739 //y2=7.4
cc_429 ( N_noxref_4_M4_noxref_g N_noxref_5_M4_noxref_d ) capacitor \
 c=0.0130453f //x=-0.47 //y=6.025 //x2=-0.395 //y2=5.025
cc_430 ( N_noxref_4_M5_noxref_g N_noxref_5_M4_noxref_d ) capacitor \
 c=0.0146888f //x=-0.03 //y=6.025 //x2=-0.395 //y2=5.025
cc_431 ( N_noxref_4_c_546_n N_noxref_5_M4_noxref_d ) capacitor c=0.00248632f \
 //x=-0.105 //y=4.795 //x2=-0.395 //y2=5.025
cc_432 ( N_noxref_4_c_491_n N_noxref_6_c_736_n ) capacitor c=0.0198635f \
 //x=-0.37 //y=2.245 //x2=0.37 //y2=2.21
cc_433 ( N_noxref_4_c_494_n N_noxref_6_c_736_n ) capacitor c=6.64673e-19 \
 //x=-0.369 //y=2.08 //x2=0.37 //y2=2.21
cc_434 ( N_noxref_4_c_503_n N_noxref_6_c_736_n ) capacitor c=0.00160374f \
 //x=-0.565 //y=1.915 //x2=0.37 //y2=2.21
cc_435 ( N_noxref_4_c_491_n N_noxref_6_c_738_n ) capacitor c=0.00271206f \
 //x=-0.37 //y=2.245 //x2=0.37 //y2=4.56
cc_436 ( N_noxref_4_c_521_n N_noxref_6_c_738_n ) capacitor c=0.119351f \
 //x=-0.37 //y=4.585 //x2=0.37 //y2=4.56
cc_437 ( N_noxref_4_c_532_n N_noxref_6_c_738_n ) capacitor c=0.00245109f \
 //x=-0.524 //y=4.705 //x2=0.37 //y2=4.56
cc_438 ( N_noxref_4_c_535_n N_noxref_6_c_738_n ) capacitor c=8.14108e-19 \
 //x=-0.524 //y=4.705 //x2=0.37 //y2=4.56
cc_439 ( N_noxref_4_c_546_n N_noxref_6_c_738_n ) capacitor c=7.4344e-19 \
 //x=-0.105 //y=4.795 //x2=0.37 //y2=4.56
cc_440 ( N_noxref_4_c_491_n N_noxref_6_c_741_n ) capacitor c=0.00412829f \
 //x=-0.37 //y=2.245 //x2=0.37 //y2=2.08
cc_441 ( N_noxref_4_c_494_n N_noxref_6_c_741_n ) capacitor c=0.00444996f \
 //x=-0.369 //y=2.08 //x2=0.37 //y2=2.08
cc_442 ( N_noxref_4_c_503_n N_noxref_6_c_741_n ) capacitor c=0.00284386f \
 //x=-0.565 //y=1.915 //x2=0.37 //y2=2.08
cc_443 ( N_noxref_4_c_521_n N_noxref_6_c_777_n ) capacitor c=0.0023775f \
 //x=-0.37 //y=4.585 //x2=0.405 //y2=4.705
cc_444 ( N_noxref_4_c_532_n N_noxref_6_c_777_n ) capacitor c=0.00153582f \
 //x=-0.524 //y=4.705 //x2=0.405 //y2=4.705
cc_445 ( N_noxref_4_c_535_n N_noxref_6_c_777_n ) capacitor c=0.00234902f \
 //x=-0.524 //y=4.705 //x2=0.405 //y2=4.705
cc_446 ( N_noxref_4_c_546_n N_noxref_6_c_777_n ) capacitor c=0.00112509f \
 //x=-0.105 //y=4.795 //x2=0.405 //y2=4.705
cc_447 ( N_noxref_4_c_547_n N_noxref_6_c_777_n ) capacitor c=0.00121814f \
 //x=-0.524 //y=4.705 //x2=0.405 //y2=4.705
cc_448 ( N_noxref_4_M4_noxref_g N_noxref_6_M6_noxref_g ) capacitor \
 c=0.0101077f //x=-0.47 //y=6.025 //x2=0.41 //y2=6.025
cc_449 ( N_noxref_4_M5_noxref_g N_noxref_6_M6_noxref_g ) capacitor c=0.109254f \
 //x=-0.03 //y=6.025 //x2=0.41 //y2=6.025
cc_450 ( N_noxref_4_M5_noxref_g N_noxref_6_M7_noxref_g ) capacitor \
 c=0.00945018f //x=-0.03 //y=6.025 //x2=0.85 //y2=6.025
cc_451 ( N_noxref_4_c_497_n N_noxref_6_c_742_n ) capacitor c=0.00128177f \
 //x=-0.565 //y=0.905 //x2=0.405 //y2=0.905
cc_452 ( N_noxref_4_c_511_n N_noxref_6_c_742_n ) capacitor c=0.0126654f \
 //x=-0.035 //y=0.905 //x2=0.405 //y2=0.905
cc_453 ( N_noxref_4_c_499_n N_noxref_6_c_744_n ) capacitor c=0.00149727f \
 //x=-0.565 //y=1.25 //x2=0.405 //y2=1.255
cc_454 ( N_noxref_4_c_502_n N_noxref_6_c_744_n ) capacitor c=0.00111802f \
 //x=-0.565 //y=1.56 //x2=0.405 //y2=1.255
cc_455 ( N_noxref_4_c_513_n N_noxref_6_c_744_n ) capacitor c=0.0126654f \
 //x=-0.035 //y=1.25 //x2=0.405 //y2=1.255
cc_456 ( N_noxref_4_c_502_n N_noxref_6_c_747_n ) capacitor c=0.00116305f \
 //x=-0.565 //y=1.56 //x2=0.405 //y2=1.56
cc_457 ( N_noxref_4_c_513_n N_noxref_6_c_747_n ) capacitor c=0.00938322f \
 //x=-0.035 //y=1.25 //x2=0.405 //y2=1.56
cc_458 ( N_noxref_4_c_513_n N_noxref_6_c_751_n ) capacitor c=0.00131492f \
 //x=-0.035 //y=1.25 //x2=0.78 //y2=1.405
cc_459 ( N_noxref_4_c_511_n N_noxref_6_c_756_n ) capacitor c=0.00135327f \
 //x=-0.035 //y=0.905 //x2=0.935 //y2=0.905
cc_460 ( N_noxref_4_c_513_n N_noxref_6_c_758_n ) capacitor c=0.00151998f \
 //x=-0.035 //y=1.25 //x2=0.935 //y2=1.255
cc_461 ( N_noxref_4_c_491_n N_noxref_6_c_761_n ) capacitor c=0.00184232f \
 //x=-0.37 //y=2.245 //x2=0.37 //y2=2.08
cc_462 ( N_noxref_4_c_494_n N_noxref_6_c_761_n ) capacitor c=0.00266357f \
 //x=-0.369 //y=2.08 //x2=0.37 //y2=2.08
cc_463 ( N_noxref_4_c_503_n N_noxref_6_c_761_n ) capacitor c=0.0177224f \
 //x=-0.565 //y=1.915 //x2=0.37 //y2=2.08
cc_464 ( N_noxref_4_c_503_n N_noxref_6_c_762_n ) capacitor c=0.00636965f \
 //x=-0.565 //y=1.915 //x2=0.37 //y2=1.915
cc_465 ( N_noxref_4_c_521_n N_noxref_6_c_785_n ) capacitor c=0.00117002f \
 //x=-0.37 //y=4.585 //x2=0.405 //y2=4.705
cc_466 ( N_noxref_4_c_532_n N_noxref_6_c_785_n ) capacitor c=4.66993e-19 \
 //x=-0.524 //y=4.705 //x2=0.405 //y2=4.705
cc_467 ( N_noxref_4_c_535_n N_noxref_6_c_785_n ) capacitor c=0.0022472f \
 //x=-0.524 //y=4.705 //x2=0.405 //y2=4.705
cc_468 ( N_noxref_4_c_546_n N_noxref_6_c_785_n ) capacitor c=0.019933f \
 //x=-0.105 //y=4.795 //x2=0.405 //y2=4.705
cc_469 ( N_noxref_4_c_547_n N_noxref_6_c_785_n ) capacitor c=0.00590438f \
 //x=-0.524 //y=4.705 //x2=0.405 //y2=4.705
cc_470 ( N_noxref_4_c_521_n N_noxref_7_c_869_n ) capacitor c=0.00474507f \
 //x=-0.37 //y=4.585 //x2=1.48 //y2=4.585
cc_471 ( N_noxref_4_c_535_n N_noxref_7_c_869_n ) capacitor c=2.52182e-19 \
 //x=-0.524 //y=4.705 //x2=1.48 //y2=4.585
cc_472 ( N_noxref_5_c_606_n N_noxref_6_M6_noxref_g ) capacitor c=0.00720241f \
 //x=3.16 //y=7.4 //x2=0.41 //y2=6.025
cc_473 ( N_noxref_5_c_606_n N_noxref_6_M7_noxref_g ) capacitor c=0.00776897f \
 //x=3.16 //y=7.4 //x2=0.85 //y2=6.025
cc_474 ( N_noxref_5_c_610_n N_noxref_7_c_881_n ) capacitor c=0.0018189f \
 //x=3.33 //y=7.4 //x2=1.48 //y2=4.705
cc_475 ( N_noxref_5_c_606_n N_noxref_7_M8_noxref_g ) capacitor c=0.00776897f \
 //x=3.16 //y=7.4 //x2=1.89 //y2=6.025
cc_476 ( N_noxref_5_c_606_n N_noxref_7_M9_noxref_g ) capacitor c=0.00776897f \
 //x=3.16 //y=7.4 //x2=2.33 //y2=6.025
cc_477 ( N_noxref_5_c_610_n N_noxref_7_c_910_n ) capacitor c=0.0210247f \
 //x=3.33 //y=7.4 //x2=2.255 //y2=4.795
cc_478 ( N_noxref_5_c_603_n N_noxref_8_c_975_n ) capacitor c=0.00445638f \
 //x=4.81 //y=7.4 //x2=1.585 //y2=5.21
cc_479 ( N_noxref_5_c_606_n N_noxref_8_c_975_n ) capacitor c=0.00365337f \
 //x=3.16 //y=7.4 //x2=1.585 //y2=5.21
cc_480 ( N_noxref_5_M10_noxref_s N_noxref_8_c_975_n ) capacitor c=0.001796f \
 //x=3.87 //y=5.02 //x2=1.585 //y2=5.21
cc_481 ( N_noxref_5_c_618_n N_noxref_8_c_981_n ) capacitor c=0.00221878f \
 //x=4.81 //y=7.4 //x2=2.435 //y2=6.91
cc_482 ( N_noxref_5_c_603_n N_noxref_8_c_988_n ) capacitor c=0.0975922f \
 //x=4.81 //y=7.4 //x2=1.67 //y2=6.74
cc_483 ( N_noxref_5_c_606_n N_noxref_8_c_988_n ) capacitor c=0.0222153f \
 //x=3.16 //y=7.4 //x2=1.67 //y2=6.74
cc_484 ( N_noxref_5_c_618_n N_noxref_8_c_988_n ) capacitor c=0.00113169f \
 //x=4.81 //y=7.4 //x2=1.67 //y2=6.74
cc_485 ( N_noxref_5_c_603_n N_noxref_8_c_989_n ) capacitor c=0.00187652f \
 //x=4.81 //y=7.4 //x2=2.55 //y2=6.74
cc_486 ( N_noxref_5_c_606_n N_noxref_8_c_989_n ) capacitor c=9.14097e-19 \
 //x=3.16 //y=7.4 //x2=2.55 //y2=6.74
cc_487 ( N_noxref_5_c_610_n N_noxref_8_c_989_n ) capacitor c=0.0128867f \
 //x=3.33 //y=7.4 //x2=2.55 //y2=6.74
cc_488 ( N_noxref_5_c_618_n N_noxref_8_c_989_n ) capacitor c=0.00112693f \
 //x=4.81 //y=7.4 //x2=2.55 //y2=6.74
cc_489 ( N_noxref_5_c_606_n N_noxref_8_c_1008_n ) capacitor c=0.00512314f \
 //x=3.16 //y=7.4 //x2=0.63 //y2=5.38
cc_490 ( N_noxref_5_c_610_n N_noxref_8_c_1008_n ) capacitor c=0.00127839f \
 //x=3.33 //y=7.4 //x2=0.63 //y2=5.38
cc_491 ( N_noxref_5_c_618_n N_noxref_8_c_1008_n ) capacitor c=2.32853e-19 \
 //x=4.81 //y=7.4 //x2=0.63 //y2=5.38
cc_492 ( N_noxref_5_M4_noxref_d N_noxref_8_c_1008_n ) capacitor c=0.00557191f \
 //x=-0.395 //y=5.025 //x2=0.63 //y2=5.38
cc_493 ( N_noxref_5_c_603_n N_noxref_8_c_991_n ) capacitor c=0.00206634f \
 //x=4.81 //y=7.4 //x2=1.67 //y2=5.72
cc_494 ( N_noxref_5_c_606_n N_noxref_8_c_991_n ) capacitor c=0.00858175f \
 //x=3.16 //y=7.4 //x2=1.67 //y2=5.72
cc_495 ( N_noxref_5_c_618_n N_noxref_8_c_991_n ) capacitor c=0.00100487f \
 //x=4.81 //y=7.4 //x2=1.67 //y2=5.72
cc_496 ( N_noxref_5_c_603_n N_noxref_8_M9_noxref_d ) capacitor c=0.00206634f \
 //x=4.81 //y=7.4 //x2=2.405 //y2=5.025
cc_497 ( N_noxref_5_c_606_n N_noxref_8_M9_noxref_d ) capacitor c=0.00858175f \
 //x=3.16 //y=7.4 //x2=2.405 //y2=5.025
cc_498 ( N_noxref_5_c_610_n N_noxref_8_M9_noxref_d ) capacitor c=0.0431966f \
 //x=3.33 //y=7.4 //x2=2.405 //y2=5.025
cc_499 ( N_noxref_5_c_618_n N_noxref_8_M9_noxref_d ) capacitor c=0.00100487f \
 //x=4.81 //y=7.4 //x2=2.405 //y2=5.025
cc_500 ( N_noxref_5_M10_noxref_s N_noxref_8_M9_noxref_d ) capacitor \
 c=0.00285201f //x=3.87 //y=5.02 //x2=2.405 //y2=5.025
cc_501 ( N_noxref_5_c_603_n N_noxref_9_c_1071_n ) capacitor c=0.00259275f \
 //x=4.81 //y=7.4 //x2=4.445 //y2=5.24
cc_502 ( N_noxref_5_c_607_n N_noxref_9_c_1071_n ) capacitor c=0.0010065f \
 //x=4.8 //y=7.4 //x2=4.445 //y2=5.24
cc_503 ( N_noxref_5_c_618_n N_noxref_9_c_1071_n ) capacitor c=0.00295945f \
 //x=4.81 //y=7.4 //x2=4.445 //y2=5.24
cc_504 ( N_noxref_5_M10_noxref_s N_noxref_9_c_1071_n ) capacitor c=0.0465774f \
 //x=3.87 //y=5.02 //x2=4.445 //y2=5.24
cc_505 ( N_noxref_5_M11_noxref_d N_noxref_9_c_1071_n ) capacitor c=0.0486749f \
 //x=4.74 //y=5.02 //x2=4.445 //y2=5.24
cc_506 ( N_noxref_5_c_603_n N_noxref_9_c_1078_n ) capacitor c=0.00199455f \
 //x=4.81 //y=7.4 //x2=4.725 //y2=4.96
cc_507 ( N_noxref_5_c_607_n N_noxref_9_c_1078_n ) capacitor c=0.00207359f \
 //x=4.8 //y=7.4 //x2=4.725 //y2=4.96
cc_508 ( N_noxref_5_M11_noxref_d N_noxref_9_c_1078_n ) capacitor c=0.0235605f \
 //x=4.74 //y=5.02 //x2=4.725 //y2=4.96
cc_509 ( N_noxref_5_c_610_n N_noxref_9_c_1079_n ) capacitor c=0.0049693f \
 //x=3.33 //y=7.4 //x2=4.53 //y2=4.96
cc_510 ( N_noxref_5_c_618_n N_noxref_9_c_1082_n ) capacitor c=0.0297606f \
 //x=4.81 //y=7.4 //x2=4.81 //y2=4.875
cc_511 ( N_noxref_5_c_603_n N_noxref_9_c_1102_n ) capacitor c=0.0024144f \
 //x=4.81 //y=7.4 //x2=4.445 //y2=5.38
cc_512 ( N_noxref_5_c_607_n N_noxref_9_c_1102_n ) capacitor c=0.0137788f \
 //x=4.8 //y=7.4 //x2=4.445 //y2=5.38
cc_513 ( N_noxref_5_c_610_n N_noxref_9_c_1102_n ) capacitor c=0.00817249f \
 //x=3.33 //y=7.4 //x2=4.445 //y2=5.38
cc_514 ( N_noxref_5_c_618_n N_noxref_9_c_1102_n ) capacitor c=0.00960351f \
 //x=4.81 //y=7.4 //x2=4.445 //y2=5.38
cc_515 ( N_noxref_5_M10_noxref_s N_noxref_9_c_1102_n ) capacitor c=0.0896047f \
 //x=3.87 //y=5.02 //x2=4.445 //y2=5.38
cc_516 ( N_noxref_5_M11_noxref_d N_noxref_9_c_1102_n ) capacitor c=0.0928151f \
 //x=4.74 //y=5.02 //x2=4.445 //y2=5.38
cc_517 ( N_noxref_6_c_736_n N_noxref_7_c_865_n ) capacitor c=0.0115855f \
 //x=0.37 //y=2.21 //x2=1.48 //y2=2.225
cc_518 ( N_noxref_6_c_738_n N_noxref_7_c_865_n ) capacitor c=6.43877e-19 \
 //x=0.37 //y=4.56 //x2=1.48 //y2=2.225
cc_519 ( N_noxref_6_c_741_n N_noxref_7_c_865_n ) capacitor c=5.84901e-19 \
 //x=0.37 //y=2.08 //x2=1.48 //y2=2.225
cc_520 ( N_noxref_6_c_738_n N_noxref_7_c_869_n ) capacitor c=0.0835776f \
 //x=0.37 //y=4.56 //x2=1.48 //y2=4.585
cc_521 ( N_noxref_6_c_777_n N_noxref_7_c_869_n ) capacitor c=9.78721e-19 \
 //x=0.405 //y=4.705 //x2=1.48 //y2=4.585
cc_522 ( N_noxref_6_c_736_n N_noxref_7_c_876_n ) capacitor c=4.43682e-19 \
 //x=0.37 //y=2.21 //x2=1.48 //y2=2.08
cc_523 ( N_noxref_6_c_741_n N_noxref_7_c_876_n ) capacitor c=0.00114266f \
 //x=0.37 //y=2.08 //x2=1.48 //y2=2.08
cc_524 ( N_noxref_6_c_761_n N_noxref_7_c_876_n ) capacitor c=3.80079e-19 \
 //x=0.37 //y=2.08 //x2=1.48 //y2=2.08
cc_525 ( N_noxref_6_c_738_n N_noxref_7_c_881_n ) capacitor c=8.51262e-19 \
 //x=0.37 //y=4.56 //x2=1.48 //y2=4.705
cc_526 ( N_noxref_6_c_777_n N_noxref_7_c_881_n ) capacitor c=0.00124702f \
 //x=0.405 //y=4.705 //x2=1.48 //y2=4.705
cc_527 ( N_noxref_6_c_785_n N_noxref_7_c_881_n ) capacitor c=4.01223e-19 \
 //x=0.405 //y=4.705 //x2=1.48 //y2=4.705
cc_528 ( N_noxref_6_M7_noxref_g N_noxref_7_M8_noxref_g ) capacitor \
 c=0.0359752f //x=0.85 //y=6.025 //x2=1.89 //y2=6.025
cc_529 ( N_noxref_6_c_742_n N_noxref_7_c_890_n ) capacitor c=0.00133966f \
 //x=0.405 //y=0.905 //x2=1.375 //y2=0.905
cc_530 ( N_noxref_6_c_756_n N_noxref_7_c_890_n ) capacitor c=0.00886682f \
 //x=0.935 //y=0.905 //x2=1.375 //y2=0.905
cc_531 ( N_noxref_6_c_744_n N_noxref_7_c_892_n ) capacitor c=0.0015172f \
 //x=0.405 //y=1.255 //x2=1.375 //y2=1.255
cc_532 ( N_noxref_6_c_758_n N_noxref_7_c_892_n ) capacitor c=0.00886682f \
 //x=0.935 //y=1.255 //x2=1.375 //y2=1.255
cc_533 ( N_noxref_6_c_747_n N_noxref_7_c_895_n ) capacitor c=0.00296957f \
 //x=0.405 //y=1.56 //x2=1.375 //y2=1.56
cc_534 ( N_noxref_6_c_751_n N_noxref_7_c_895_n ) capacitor c=0.0182761f \
 //x=0.78 //y=1.405 //x2=1.375 //y2=1.56
cc_535 ( N_noxref_6_c_762_n N_noxref_7_c_897_n ) capacitor c=0.00581071f \
 //x=0.37 //y=1.915 //x2=1.375 //y2=1.915
cc_536 ( N_noxref_6_c_751_n N_noxref_7_c_901_n ) capacitor c=0.00131492f \
 //x=0.78 //y=1.405 //x2=1.75 //y2=1.405
cc_537 ( N_noxref_6_c_756_n N_noxref_7_c_905_n ) capacitor c=0.00135327f \
 //x=0.935 //y=0.905 //x2=1.905 //y2=0.905
cc_538 ( N_noxref_6_c_758_n N_noxref_7_c_907_n ) capacitor c=0.0015172f \
 //x=0.935 //y=1.255 //x2=1.905 //y2=1.255
cc_539 ( N_noxref_6_c_736_n N_noxref_7_c_913_n ) capacitor c=0.00151737f \
 //x=0.37 //y=2.21 //x2=1.375 //y2=2.08
cc_540 ( N_noxref_6_c_741_n N_noxref_7_c_913_n ) capacitor c=0.0021413f \
 //x=0.37 //y=2.08 //x2=1.375 //y2=2.08
cc_541 ( N_noxref_6_c_761_n N_noxref_7_c_913_n ) capacitor c=0.00926648f \
 //x=0.37 //y=2.08 //x2=1.375 //y2=2.08
cc_542 ( N_noxref_6_c_738_n N_noxref_7_c_915_n ) capacitor c=0.00135035f \
 //x=0.37 //y=4.56 //x2=1.48 //y2=4.705
cc_543 ( N_noxref_6_c_777_n N_noxref_7_c_915_n ) capacitor c=0.00193614f \
 //x=0.405 //y=4.705 //x2=1.48 //y2=4.705
cc_544 ( N_noxref_6_c_853_p N_noxref_7_c_915_n ) capacitor c=0.0107159f \
 //x=0.775 //y=4.795 //x2=1.48 //y2=4.705
cc_545 ( N_noxref_6_c_785_n N_noxref_7_c_915_n ) capacitor c=0.0051116f \
 //x=0.405 //y=4.705 //x2=1.48 //y2=4.705
cc_546 ( N_noxref_6_M7_noxref_g N_noxref_8_c_975_n ) capacitor c=0.0108199f \
 //x=0.85 //y=6.025 //x2=1.585 //y2=5.21
cc_547 ( N_noxref_6_M7_noxref_g N_noxref_8_c_978_n ) capacitor c=0.00165119f \
 //x=0.85 //y=6.025 //x2=1.67 //y2=5.59
cc_548 ( N_noxref_6_c_738_n N_noxref_8_c_985_n ) capacitor c=9.00765e-19 \
 //x=0.37 //y=4.56 //x2=0.63 //y2=5.21
cc_549 ( N_noxref_6_M6_noxref_g N_noxref_8_c_985_n ) capacitor c=0.00186001f \
 //x=0.41 //y=6.025 //x2=0.63 //y2=5.21
cc_550 ( N_noxref_6_M7_noxref_g N_noxref_8_c_985_n ) capacitor c=0.00210236f \
 //x=0.85 //y=6.025 //x2=0.63 //y2=5.21
cc_551 ( N_noxref_6_c_853_p N_noxref_8_c_985_n ) capacitor c=0.00213157f \
 //x=0.775 //y=4.795 //x2=0.63 //y2=5.21
cc_552 ( N_noxref_6_M7_noxref_g N_noxref_8_c_988_n ) capacitor c=4.79118e-19 \
 //x=0.85 //y=6.025 //x2=1.67 //y2=6.74
cc_553 ( N_noxref_6_M6_noxref_g N_noxref_8_c_1008_n ) capacitor c=0.0120591f \
 //x=0.41 //y=6.025 //x2=0.63 //y2=5.38
cc_554 ( N_noxref_6_M7_noxref_g N_noxref_8_c_1008_n ) capacitor c=0.0159649f \
 //x=0.85 //y=6.025 //x2=0.63 //y2=5.38
cc_555 ( N_noxref_6_c_853_p N_noxref_8_c_1008_n ) capacitor c=0.00293135f \
 //x=0.775 //y=4.795 //x2=0.63 //y2=5.38
cc_556 ( N_noxref_7_c_865_n N_noxref_8_c_975_n ) capacitor c=3.89231e-19 \
 //x=1.48 //y=2.225 //x2=1.585 //y2=5.21
cc_557 ( N_noxref_7_c_869_n N_noxref_8_c_975_n ) capacitor c=0.02207f //x=1.48 \
 //y=4.585 //x2=1.585 //y2=5.21
cc_558 ( N_noxref_7_c_881_n N_noxref_8_c_975_n ) capacitor c=0.00449448f \
 //x=1.48 //y=4.705 //x2=1.585 //y2=5.21
cc_559 ( N_noxref_7_M8_noxref_g N_noxref_8_c_975_n ) capacitor c=0.00412344f \
 //x=1.89 //y=6.025 //x2=1.585 //y2=5.21
cc_560 ( N_noxref_7_c_915_n N_noxref_8_c_975_n ) capacitor c=0.00462848f \
 //x=1.48 //y=4.705 //x2=1.585 //y2=5.21
cc_561 ( N_noxref_7_M8_noxref_g N_noxref_8_c_978_n ) capacitor c=0.0025714f \
 //x=1.89 //y=6.025 //x2=1.67 //y2=5.59
cc_562 ( N_noxref_7_c_966_p N_noxref_8_c_978_n ) capacitor c=6.67396e-19 \
 //x=1.815 //y=4.795 //x2=1.67 //y2=5.59
cc_563 ( N_noxref_7_M8_noxref_g N_noxref_8_c_981_n ) capacitor c=0.00998354f \
 //x=1.89 //y=6.025 //x2=2.435 //y2=6.91
cc_564 ( N_noxref_7_M9_noxref_g N_noxref_8_c_981_n ) capacitor c=0.00971865f \
 //x=2.33 //y=6.025 //x2=2.435 //y2=6.91
cc_565 ( N_noxref_7_M8_noxref_g N_noxref_8_c_988_n ) capacitor c=0.00266045f \
 //x=1.89 //y=6.025 //x2=1.67 //y2=6.74
cc_566 ( N_noxref_7_M9_noxref_g N_noxref_8_c_989_n ) capacitor c=0.00394587f \
 //x=2.33 //y=6.025 //x2=2.55 //y2=6.74
cc_567 ( N_noxref_7_c_869_n N_noxref_8_c_991_n ) capacitor c=3.85234e-19 \
 //x=1.48 //y=4.585 //x2=1.67 //y2=5.72
cc_568 ( N_noxref_7_M8_noxref_g N_noxref_8_c_991_n ) capacitor c=0.0227892f \
 //x=1.89 //y=6.025 //x2=1.67 //y2=5.72
cc_569 ( N_noxref_7_c_915_n N_noxref_8_c_991_n ) capacitor c=0.00281079f \
 //x=1.48 //y=4.705 //x2=1.67 //y2=5.72
cc_570 ( N_noxref_7_M9_noxref_g N_noxref_8_M9_noxref_d ) capacitor \
 c=0.0365206f //x=2.33 //y=6.025 //x2=2.405 //y2=5.025
cc_571 ( N_noxref_8_c_975_n N_noxref_9_c_1071_n ) capacitor c=3.63983e-19 \
 //x=1.585 //y=5.21 //x2=4.445 //y2=5.24
