// File: and2x1_pcell.spi
// Created: Thu Jan 22 07:11:17 2026
// Program "Calibre xRC"
// Version "v2023.2_27.15"
//
simulator lang=spectre
include "/import/yukari1/lrburle/sky130RHBDlib/calibre/sky130_rhbd_output/spice/and2x1_pcell.pex.spice"
subckt and2x1_pcell (  )
//
M0_noxref ( N_noxref_4_M0_noxref_d N_noxref_3_M0_noxref_g \
 N_noxref_7_M0_noxref_s noxref_78 ) NMOS l=0.163119 w=2.35104 m=1
M1_noxref ( N_noxref_1_M1_noxref_d N_noxref_5_M1_noxref_g \
 N_noxref_7_M0_noxref_s noxref_78 ) NMOS l=0.163346 w=2.31104 m=1
M2_noxref ( N_noxref_6_M2_noxref_d N_noxref_1_M2_noxref_g \
 N_noxref_4_M2_noxref_s noxref_78 ) NMOS l=0.163346 w=2.31104 m=1
M3_noxref ( N_noxref_1_M3_noxref_d N_noxref_3_M3_noxref_g \
 N_noxref_2_M3_noxref_s noxref_76 ) PMOS l=0.15 w=2 ad=0.57 as=0.57 pd=2.57 \
 ps=2.57 nrd=0 nrs=0 m=1
M4_noxref ( N_noxref_2_M4_noxref_d N_noxref_3_M4_noxref_g \
 N_noxref_1_M3_noxref_d noxref_76 ) PMOS l=0.15 w=2 ad=0.58 as=0.58 pd=2.58 \
 ps=2.58 nrd=0 nrs=0 m=1
M5_noxref ( N_noxref_1_M5_noxref_d N_noxref_5_M5_noxref_g \
 N_noxref_2_M4_noxref_d noxref_76 ) PMOS l=0.15 w=2 ad=0.58 as=0.58 pd=2.58 \
 ps=2.58 nrd=0 nrs=0 m=1
M6_noxref ( N_noxref_2_M6_noxref_d N_noxref_5_M6_noxref_g \
 N_noxref_1_M5_noxref_d noxref_76 ) PMOS l=0.15 w=2 ad=0.56 as=0.56 pd=2.56 \
 ps=2.56 nrd=0 nrs=0 m=1
M7_noxref ( N_noxref_6_M7_noxref_d N_noxref_1_M7_noxref_g \
 N_noxref_2_M7_noxref_s noxref_76 ) PMOS l=0.15 w=2 ad=0.57 as=0.57 pd=2.57 \
 ps=2.57 nrd=0 nrs=0 m=1
M8_noxref ( N_noxref_2_M8_noxref_d N_noxref_1_M8_noxref_g \
 N_noxref_6_M7_noxref_d noxref_76 ) PMOS l=0.15 w=2 ad=0.56 as=0.56 pd=2.56 \
 ps=2.56 nrd=0 nrs=0 m=1
//
include "/import/yukari1/lrburle/sky130RHBDlib/calibre/sky130_rhbd_output/spice/and2x1_pcell.pxi.spice"
//
ends AND2X1_PCELL
//
//
