// File: TMRDFFRNQX1.spi.pex
// Created: Thu Jan 22 07:09:19 2026
// Program "Calibre xRC"
// Version "v2023.2_27.15"
// Nominal Temperature: 30C
// Circuit Temperature: 30C
//
simulator lang=spectre
subckt PM_TMRDFFRNQX1\%noxref_1 ( 1 2 3 4 5 7 10 11 13 14 15 16 18 19 20 22 23 \
 30 32 35 38 44 47 50 53 54 56 57 58 60 62 64 65 72 75 84 89 97 105 122 131 \
 135 136 137 138 139 140 144 145 146 151 153 156 157 158 159 160 161 165 167 \
 170 171 176 177 182 191 194 196 197 198 )
c440 ( 194 0 ) capacitor c=0.00885916f //x=8.695 //y=1.095
c441 ( 191 0 ) capacitor c=0.0682508f //x=11.22 //y=4.88
c442 ( 182 0 ) capacitor c=0.0710579f //x=3.82 //y=4.88
c443 ( 177 0 ) capacitor c=0.0278202f //x=3.82 //y=2.095
c444 ( 176 0 ) capacitor c=0.0479324f //x=3.82 //y=2.26
c445 ( 171 0 ) capacitor c=0.0318956f //x=11.555 //y=1.39
c446 ( 170 0 ) capacitor c=0.0186809f //x=11.555 //y=1.045
c447 ( 167 0 ) capacitor c=0.0141821f //x=11.4 //y=1.545
c448 ( 165 0 ) capacitor c=0.0158553f //x=11.4 //y=0.89
c449 ( 161 0 ) capacitor c=0.0854195f //x=11.025 //y=2.095
c450 ( 160 0 ) capacitor c=0.0229235f //x=11.025 //y=1.7
c451 ( 159 0 ) capacitor c=0.0234359f //x=11.025 //y=1.39
c452 ( 158 0 ) capacitor c=0.0198759f //x=11.025 //y=1.045
c453 ( 157 0 ) capacitor c=0.0443175f //x=4.34 //y=1.44
c454 ( 156 0 ) capacitor c=0.0199703f //x=4.34 //y=1.095
c455 ( 153 0 ) capacitor c=0.0162526f //x=4.185 //y=1.595
c456 ( 151 0 ) capacitor c=0.0157807f //x=4.185 //y=0.94
c457 ( 146 0 ) capacitor c=0.0220935f //x=3.81 //y=1.75
c458 ( 145 0 ) capacitor c=0.0207489f //x=3.81 //y=1.44
c459 ( 144 0 ) capacitor c=0.0194091f //x=3.81 //y=1.095
c460 ( 140 0 ) capacitor c=0.110369f //x=11.56 //y=6.2
c461 ( 139 0 ) capacitor c=0.154619f //x=11.12 //y=6.2
c462 ( 138 0 ) capacitor c=0.159671f //x=4 //y=6.2
c463 ( 137 0 ) capacitor c=0.110208f //x=3.56 //y=6.2
c464 ( 131 0 ) capacitor c=8.13425e-19 //x=11.22 //y=4.88
c465 ( 122 0 ) capacitor c=7.85889e-19 //x=11.22 //y=2.26
c466 ( 105 0 ) capacitor c=0.0292634f //x=8.59 //y=5.56
c467 ( 97 0 ) capacitor c=0.029137f //x=7.71 //y=5.56
c468 ( 89 0 ) capacitor c=0.0278099f //x=6.83 //y=5.56
c469 ( 84 0 ) capacitor c=7.7417e-19 //x=3.82 //y=4.88
c470 ( 75 0 ) capacitor c=0.00101179f //x=3.82 //y=2.26
c471 ( 72 0 ) capacitor c=5.33433e-19 //x=11.22 //y=3.51
c472 ( 65 0 ) capacitor c=0.0375158f //x=9.535 //y=3.51
c473 ( 64 0 ) capacitor c=0.0228332f //x=11.06 //y=3.51
c474 ( 62 0 ) capacitor c=0.00710937f //x=6.63 //y=3.495
c475 ( 60 0 ) capacitor c=0.0381161f //x=6.03 //y=3.51
c476 ( 58 0 ) capacitor c=0.0188644f //x=4.78 //y=3.5
c477 ( 57 0 ) capacitor c=0.00332161f //x=3.98 //y=3.51
c478 ( 56 0 ) capacitor c=0.00726184f //x=4.18 //y=3.51
c479 ( 54 0 ) capacitor c=0.0268056f //x=11.222 //y=4.74
c480 ( 53 0 ) capacitor c=0.00611114f //x=11.22 //y=4.88
c481 ( 50 0 ) capacitor c=0.00463527f //x=11.22 //y=2.26
c482 ( 47 0 ) capacitor c=0.0161834f //x=11.22 //y=3.51
c483 ( 44 0 ) capacitor c=0.0170515f //x=9.37 //y=3.51
c484 ( 38 0 ) capacitor c=0.00112339f //x=8.59 //y=5.335
c485 ( 35 0 ) capacitor c=0.00758336f //x=7.71 //y=5.335
c486 ( 32 0 ) capacitor c=0.0111234f //x=6.832 //y=5.335
c487 ( 30 0 ) capacitor c=0.0148558f //x=3.82 //y=3.51
c488 ( 23 0 ) capacitor c=0.013335f //x=11.22 //y=3.67
c489 ( 22 0 ) capacitor c=0.0276006f //x=11.22 //y=3.35
c490 ( 20 0 ) capacitor c=0.0423864f //x=9.37 //y=5.25
c491 ( 19 0 ) capacitor c=0.013011f //x=9.37 //y=3.67
c492 ( 18 0 ) capacitor c=0.0395103f //x=9.37 //y=3.35
c493 ( 16 0 ) capacitor c=0.00493487f //x=8.97 //y=1.845
c494 ( 15 0 ) capacitor c=0.012936f //x=9.285 //y=1.845
c495 ( 14 0 ) capacitor c=0.0136149f //x=8.885 //y=1.76
c496 ( 13 0 ) capacitor c=0.0112307f //x=8.885 //y=1.305
c497 ( 11 0 ) capacitor c=0.0238781f //x=9.285 //y=5.335
c498 ( 10 0 ) capacitor c=0.00906713f //x=8.59 //y=5.56
c499 ( 7 0 ) capacitor c=0.019596f //x=8.475 //y=5.335
c500 ( 5 0 ) capacitor c=0.0151757f //x=7.59 //y=5.335
c501 ( 4 0 ) capacitor c=0.0286235f //x=3.82 //y=4.75
c502 ( 3 0 ) capacitor c=0.0129216f //x=3.82 //y=3.67
c503 ( 2 0 ) capacitor c=0.0274817f //x=3.82 //y=3.35
c504 ( 1 0 ) capacitor c=0.00685053f //x=3.82 //y=2.375
r505 (  189 191 ) resistor r=20.6867 //w=0.233 //l=0.1 //layer=ply \
 //thickness=0.18 //x=11.12 //y=4.88 //x2=11.22 //y2=4.88
r506 (  176 177 ) resistor r=52.7279 //w=0.214 //l=0.165 //layer=ply \
 //thickness=0.18 //x=3.82 //y=2.26 //x2=3.82 //y2=2.095
r507 (  172 191 ) resistor r=70.3348 //w=0.233 //l=0.414367 //layer=ply \
 //thickness=0.18 //x=11.56 //y=5.045 //x2=11.22 //y2=4.88
r508 (  171 193 ) resistor r=45.1352 //w=0.168 //l=0.173853 //layer=ply \
 //thickness=0.18 //x=11.555 //y=1.39 //x2=11.515 //y2=1.545
r509 (  170 192 ) resistor r=45.1352 //w=0.168 //l=0.173853 //layer=ply \
 //thickness=0.18 //x=11.555 //y=1.045 //x2=11.515 //y2=0.89
r510 (  170 171 ) resistor r=176.904 //w=0.094 //l=0.345 //layer=ply \
 //thickness=0.18 //x=11.555 //y=1.045 //x2=11.555 //y2=1.39
r511 (  168 188 ) resistor r=10.701 //w=0.21 //l=0.115 //layer=ply \
 //thickness=0.18 //x=11.18 //y=1.545 //x2=11.065 //y2=1.545
r512 (  167 193 ) resistor r=5.52526 //w=0.168 //l=0.115 //layer=ply \
 //thickness=0.18 //x=11.4 //y=1.545 //x2=11.515 //y2=1.545
r513 (  166 187 ) resistor r=5.52526 //w=0.168 //l=0.115 //layer=ply \
 //thickness=0.18 //x=11.18 //y=0.89 //x2=11.065 //y2=0.89
r514 (  165 192 ) resistor r=5.52526 //w=0.168 //l=0.115 //layer=ply \
 //thickness=0.18 //x=11.4 //y=0.89 //x2=11.515 //y2=0.89
r515 (  165 166 ) resistor r=112.809 //w=0.094 //l=0.22 //layer=ply \
 //thickness=0.18 //x=11.4 //y=0.89 //x2=11.18 //y2=0.89
r516 (  162 189 ) resistor r=13.0941 //w=0.233 //l=0.165 //layer=ply \
 //thickness=0.18 //x=11.12 //y=5.045 //x2=11.12 //y2=4.88
r517 (  161 186 ) resistor r=34.8111 //w=0.27 //l=0.264953 //layer=ply \
 //thickness=0.18 //x=11.025 //y=2.095 //x2=11.22 //y2=2.26
r518 (  160 188 ) resistor r=39.5823 //w=0.21 //l=0.173853 //layer=ply \
 //thickness=0.18 //x=11.025 //y=1.7 //x2=11.065 //y2=1.545
r519 (  160 161 ) resistor r=202.543 //w=0.094 //l=0.395 //layer=ply \
 //thickness=0.18 //x=11.025 //y=1.7 //x2=11.025 //y2=2.095
r520 (  159 188 ) resistor r=39.5823 //w=0.21 //l=0.173853 //layer=ply \
 //thickness=0.18 //x=11.025 //y=1.39 //x2=11.065 //y2=1.545
r521 (  158 187 ) resistor r=45.1352 //w=0.168 //l=0.173853 //layer=ply \
 //thickness=0.18 //x=11.025 //y=1.045 //x2=11.065 //y2=0.89
r522 (  158 159 ) resistor r=176.904 //w=0.094 //l=0.345 //layer=ply \
 //thickness=0.18 //x=11.025 //y=1.045 //x2=11.025 //y2=1.39
r523 (  157 184 ) resistor r=45.1352 //w=0.168 //l=0.173853 //layer=ply \
 //thickness=0.18 //x=4.34 //y=1.44 //x2=4.3 //y2=1.595
r524 (  156 183 ) resistor r=45.1352 //w=0.168 //l=0.173853 //layer=ply \
 //thickness=0.18 //x=4.34 //y=1.095 //x2=4.3 //y2=0.94
r525 (  156 157 ) resistor r=176.904 //w=0.094 //l=0.345 //layer=ply \
 //thickness=0.18 //x=4.34 //y=1.095 //x2=4.34 //y2=1.44
r526 (  154 180 ) resistor r=10.701 //w=0.21 //l=0.115 //layer=ply \
 //thickness=0.18 //x=3.965 //y=1.595 //x2=3.85 //y2=1.595
r527 (  153 184 ) resistor r=5.52526 //w=0.168 //l=0.115 //layer=ply \
 //thickness=0.18 //x=4.185 //y=1.595 //x2=4.3 //y2=1.595
r528 (  152 179 ) resistor r=5.52526 //w=0.168 //l=0.115 //layer=ply \
 //thickness=0.18 //x=3.965 //y=0.94 //x2=3.85 //y2=0.94
r529 (  151 183 ) resistor r=5.52526 //w=0.168 //l=0.115 //layer=ply \
 //thickness=0.18 //x=4.185 //y=0.94 //x2=4.3 //y2=0.94
r530 (  151 152 ) resistor r=112.809 //w=0.094 //l=0.22 //layer=ply \
 //thickness=0.18 //x=4.185 //y=0.94 //x2=3.965 //y2=0.94
r531 (  148 182 ) resistor r=37.236 //w=0.233 //l=0.249199 //layer=ply \
 //thickness=0.18 //x=4 //y=5.045 //x2=3.82 //y2=4.88
r532 (  146 180 ) resistor r=39.5823 //w=0.21 //l=0.173853 //layer=ply \
 //thickness=0.18 //x=3.81 //y=1.75 //x2=3.85 //y2=1.595
r533 (  146 177 ) resistor r=176.904 //w=0.094 //l=0.345 //layer=ply \
 //thickness=0.18 //x=3.81 //y=1.75 //x2=3.81 //y2=2.095
r534 (  145 180 ) resistor r=39.5823 //w=0.21 //l=0.173853 //layer=ply \
 //thickness=0.18 //x=3.81 //y=1.44 //x2=3.85 //y2=1.595
r535 (  144 179 ) resistor r=45.1352 //w=0.168 //l=0.173853 //layer=ply \
 //thickness=0.18 //x=3.81 //y=1.095 //x2=3.85 //y2=0.94
r536 (  144 145 ) resistor r=176.904 //w=0.094 //l=0.345 //layer=ply \
 //thickness=0.18 //x=3.81 //y=1.095 //x2=3.81 //y2=1.44
r537 (  141 182 ) resistor r=53.7854 //w=0.233 //l=0.332415 //layer=ply \
 //thickness=0.18 //x=3.56 //y=5.045 //x2=3.82 //y2=4.88
r538 (  140 172 ) resistor r=592.245 //w=0.094 //l=1.155 //layer=ply \
 //thickness=0.18 //x=11.56 //y=6.2 //x2=11.56 //y2=5.045
r539 (  139 162 ) resistor r=592.245 //w=0.094 //l=1.155 //layer=ply \
 //thickness=0.18 //x=11.12 //y=6.2 //x2=11.12 //y2=5.045
r540 (  138 148 ) resistor r=592.245 //w=0.094 //l=1.155 //layer=ply \
 //thickness=0.18 //x=4 //y=6.2 //x2=4 //y2=5.045
r541 (  137 141 ) resistor r=592.245 //w=0.094 //l=1.155 //layer=ply \
 //thickness=0.18 //x=3.56 //y=6.2 //x2=3.56 //y2=5.045
r542 (  136 167 ) resistor r=56.4043 //w=0.094 //l=0.11 //layer=ply \
 //thickness=0.18 //x=11.29 //y=1.545 //x2=11.4 //y2=1.545
r543 (  136 168 ) resistor r=56.4043 //w=0.094 //l=0.11 //layer=ply \
 //thickness=0.18 //x=11.29 //y=1.545 //x2=11.18 //y2=1.545
r544 (  135 153 ) resistor r=56.4043 //w=0.094 //l=0.11 //layer=ply \
 //thickness=0.18 //x=4.075 //y=1.595 //x2=4.185 //y2=1.595
r545 (  135 154 ) resistor r=56.4043 //w=0.094 //l=0.11 //layer=ply \
 //thickness=0.18 //x=4.075 //y=1.595 //x2=3.965 //y2=1.595
r546 (  131 191 ) resistor r=152 //w=0.17 //l=0.17 //layer=licon //count=1 \
 //x=11.22 //y=4.88 //x2=11.22 //y2=4.88
r547 (  122 186 ) resistor r=152 //w=0.17 //l=0.17 //layer=licon //count=1 \
 //x=11.22 //y=2.26 //x2=11.22 //y2=2.26
r548 (  105 198 ) resistor r=23.615 //w=0.187 //l=0.345 //layer=li \
 //thickness=0.1 //x=8.59 //y=5.56 //x2=8.59 //y2=5.905
r549 (  97 197 ) resistor r=23.615 //w=0.187 //l=0.345 //layer=li \
 //thickness=0.1 //x=7.71 //y=5.56 //x2=7.71 //y2=5.905
r550 (  89 196 ) resistor r=23.615 //w=0.187 //l=0.345 //layer=li \
 //thickness=0.1 //x=6.83 //y=5.56 //x2=6.83 //y2=5.905
r551 (  84 182 ) resistor r=152 //w=0.17 //l=0.17 //layer=licon //count=1 \
 //x=3.82 //y=4.88 //x2=3.82 //y2=4.88
r552 (  75 176 ) resistor r=152 //w=0.17 //l=0.17 //layer=licon //count=1 \
 //x=3.82 //y=2.26 //x2=3.82 //y2=2.26
r553 (  65 70 ) resistor r=0.108234 //w=0.187 //l=0.16 //layer=m2 \
 //thickness=0.36 //x=9.535 //y=3.51 //x2=9.375 //y2=3.51
r554 (  64 72 ) resistor r=0.10734 //w=0.281 //l=0.16 //layer=m2 \
 //thickness=0.36 //x=11.06 //y=3.51 //x2=11.22 //y2=3.51
r555 (  64 65 ) resistor r=1.45515 //w=0.131 //l=1.525 //layer=m2 \
 //thickness=0.36 //x=11.06 //y=3.51 //x2=9.535 //y2=3.51
r556 (  62 70 ) resistor r=1.83617 //w=0.187 //l=2.75249 //layer=m2 \
 //thickness=0.36 //x=6.63 //y=3.495 //x2=9.375 //y2=3.51
r557 (  62 63 ) resistor r=0.410305 //w=0.131 //l=0.43 //layer=m2 \
 //thickness=0.36 //x=6.63 //y=3.495 //x2=6.2 //y2=3.495
r558 (  60 63 ) resistor r=0.125 //w=0.17 //l=0.177341 //layer=m2 \
 //thickness=0.36 //x=6.03 //y=3.51 //x2=6.2 //y2=3.495
r559 (  60 61 ) resistor r=0.949427 //w=0.131 //l=0.995 //layer=m2 \
 //thickness=0.36 //x=6.03 //y=3.51 //x2=5.035 //y2=3.51
r560 (  58 61 ) resistor r=0.1875 //w=0.17 //l=0.259952 //layer=m2 \
 //thickness=0.36 //x=4.78 //y=3.5 //x2=5.035 //y2=3.51
r561 (  58 59 ) resistor r=0.410305 //w=0.131 //l=0.43 //layer=m2 \
 //thickness=0.36 //x=4.78 //y=3.5 //x2=4.35 //y2=3.5
r562 (  57 67 ) resistor r=0.10734 //w=0.281 //l=0.16 //layer=m2 \
 //thickness=0.36 //x=3.98 //y=3.51 //x2=3.82 //y2=3.51
r563 (  56 59 ) resistor r=0.125 //w=0.17 //l=0.174929 //layer=m2 \
 //thickness=0.36 //x=4.18 //y=3.51 //x2=4.35 //y2=3.5
r564 (  56 57 ) resistor r=0.19084 //w=0.131 //l=0.2 //layer=m2 \
 //thickness=0.36 //x=4.18 //y=3.51 //x2=3.98 //y2=3.51
r565 (  53 131 ) resistor r=9.3 //w=0.17 //l=0.17 //layer=mcon //count=1 \
 //x=11.22 //y=4.88 //x2=11.22 //y2=4.88
r566 (  53 54 ) resistor r=0.103207 //w=0.196 //l=0.14 //layer=m1 \
 //thickness=0.36 //x=11.222 //y=4.88 //x2=11.222 //y2=4.74
r567 (  50 122 ) resistor r=9.3 //w=0.17 //l=0.17 //layer=mcon //count=1 \
 //x=11.22 //y=2.26 //x2=11.22 //y2=2.26
r568 (  47 72 ) resistor r=4.5 //w=0.15 //l=0.15 //layer=via1 //count=1 \
 //x=11.22 //y=3.51 //x2=11.22 //y2=3.51
r569 (  44 70 ) resistor r=4.5 //w=0.15 //l=0.15 //layer=via1 //count=1 \
 //x=9.375 //y=3.51 //x2=9.375 //y2=3.51
r570 (  42 194 ) resistor r=9.3 //w=0.17 //l=0.17 //layer=mcon //count=1 \
 //x=8.885 //y=1.19 //x2=8.885 //y2=1.19
r571 (  40 105 ) resistor r=9.3 //w=0.17 //l=0.17 //layer=mcon //count=1 \
 //x=8.59 //y=5.56 //x2=8.59 //y2=5.56
r572 (  37 97 ) resistor r=9.3 //w=0.17 //l=0.17 //layer=mcon //count=1 \
 //x=7.71 //y=5.56 //x2=7.71 //y2=5.56
r573 (  35 37 ) resistor r=0.121228 //w=0.232 //l=0.225 //layer=m1 \
 //thickness=0.36 //x=7.71 //y=5.335 //x2=7.71 //y2=5.56
r574 (  34 89 ) resistor r=9.3 //w=0.17 //l=0.17 //layer=mcon //count=1 \
 //x=6.83 //y=5.56 //x2=6.83 //y2=5.56
r575 (  32 34 ) resistor r=0.129608 //w=0.217 //l=0.225 //layer=m1 \
 //thickness=0.36 //x=6.832 //y=5.335 //x2=6.832 //y2=5.56
r576 (  30 67 ) resistor r=4.5 //w=0.15 //l=0.15 //layer=via1 //count=1 \
 //x=3.82 //y=3.51 //x2=3.82 //y2=3.51
r577 (  28 84 ) resistor r=9.3 //w=0.17 //l=0.17 //layer=mcon //count=1 \
 //x=3.82 //y=4.88 //x2=3.82 //y2=4.88
r578 (  26 75 ) resistor r=9.3 //w=0.17 //l=0.17 //layer=mcon //count=1 \
 //x=3.82 //y=2.26 //x2=3.82 //y2=2.26
r579 (  23 47 ) resistor r=0.0911593 //w=0.376 //l=0.184608 //layer=m1 \
 //thickness=0.36 //x=11.22 //y=3.67 //x2=11.167 //y2=3.51
r580 (  23 54 ) resistor r=1.02099 //w=0.131 //l=1.07 //layer=m1 \
 //thickness=0.36 //x=11.22 //y=3.67 //x2=11.22 //y2=4.74
r581 (  22 47 ) resistor r=0.0911593 //w=0.376 //l=0.184608 //layer=m1 \
 //thickness=0.36 //x=11.22 //y=3.35 //x2=11.167 //y2=3.51
r582 (  21 50 ) resistor r=0.0933015 //w=0.201 //l=0.125 //layer=m1 \
 //thickness=0.36 //x=11.22 //y=2.385 //x2=11.22 //y2=2.26
r583 (  21 22 ) resistor r=0.920802 //w=0.131 //l=0.965 //layer=m1 \
 //thickness=0.36 //x=11.22 //y=2.385 //x2=11.22 //y2=3.35
r584 (  19 44 ) resistor r=0.0910802 //w=0.374 //l=0.185472 //layer=m1 \
 //thickness=0.36 //x=9.37 //y=3.67 //x2=9.425 //y2=3.51
r585 (  19 20 ) resistor r=1.50763 //w=0.131 //l=1.58 //layer=m1 \
 //thickness=0.36 //x=9.37 //y=3.67 //x2=9.37 //y2=5.25
r586 (  18 44 ) resistor r=0.0910802 //w=0.374 //l=0.185472 //layer=m1 \
 //thickness=0.36 //x=9.37 //y=3.35 //x2=9.425 //y2=3.51
r587 (  17 18 ) resistor r=1.35496 //w=0.131 //l=1.42 //layer=m1 \
 //thickness=0.36 //x=9.37 //y=1.93 //x2=9.37 //y2=3.35
r588 (  15 17 ) resistor r=0.0698411 //w=0.17 //l=0.120208 //layer=m1 \
 //thickness=0.36 //x=9.285 //y=1.845 //x2=9.37 //y2=1.93
r589 (  15 16 ) resistor r=0.300573 //w=0.131 //l=0.315 //layer=m1 \
 //thickness=0.36 //x=9.285 //y=1.845 //x2=8.97 //y2=1.845
r590 (  14 16 ) resistor r=0.0698411 //w=0.17 //l=0.120208 //layer=m1 \
 //thickness=0.36 //x=8.885 //y=1.76 //x2=8.97 //y2=1.845
r591 (  13 42 ) resistor r=0.0717383 //w=0.224 //l=0.115 //layer=m1 \
 //thickness=0.36 //x=8.885 //y=1.305 //x2=8.885 //y2=1.19
r592 (  13 14 ) resistor r=0.43416 //w=0.131 //l=0.455 //layer=m1 \
 //thickness=0.36 //x=8.885 //y=1.305 //x2=8.885 //y2=1.76
r593 (  12 38 ) resistor r=0.0675342 //w=0.23 //l=0.115 //layer=m1 \
 //thickness=0.36 //x=8.705 //y=5.335 //x2=8.59 //y2=5.335
r594 (  11 20 ) resistor r=0.0698411 //w=0.17 //l=0.120208 //layer=m1 \
 //thickness=0.36 //x=9.285 //y=5.335 //x2=9.37 //y2=5.25
r595 (  11 12 ) resistor r=0.553435 //w=0.131 //l=0.58 //layer=m1 \
 //thickness=0.36 //x=9.285 //y=5.335 //x2=8.705 //y2=5.335
r596 (  10 40 ) resistor r=0.00118313 //w=0.23 //layer=m1 //thickness=0.36 \
 //x=8.59 //y=5.56 //x2=8.59 //y2=5.56
r597 (  9 38 ) resistor r=0.002872 //w=0.34 //l=0.085 //layer=m1 \
 //thickness=0.36 //x=8.59 //y=5.42 //x2=8.59 //y2=5.335
r598 (  9 10 ) resistor r=0.091623 //w=0.191 //l=0.14 //layer=m1 \
 //thickness=0.36 //x=8.59 //y=5.42 //x2=8.59 //y2=5.56
r599 (  8 35 ) resistor r=0.0262263 //w=0.232 //l=0.12 //layer=m1 \
 //thickness=0.36 //x=7.83 //y=5.335 //x2=7.71 //y2=5.335
r600 (  7 38 ) resistor r=0.0675342 //w=0.23 //l=0.115 //layer=m1 \
 //thickness=0.36 //x=8.475 //y=5.335 //x2=8.59 //y2=5.335
r601 (  7 8 ) resistor r=0.615458 //w=0.131 //l=0.645 //layer=m1 \
 //thickness=0.36 //x=8.475 //y=5.335 //x2=7.83 //y2=5.335
r602 (  6 32 ) resistor r=0.0222262 //w=0.217 //l=0.118 //layer=m1 \
 //thickness=0.36 //x=6.95 //y=5.335 //x2=6.832 //y2=5.335
r603 (  5 35 ) resistor r=0.0262263 //w=0.232 //l=0.12 //layer=m1 \
 //thickness=0.36 //x=7.59 //y=5.335 //x2=7.71 //y2=5.335
r604 (  5 6 ) resistor r=0.610687 //w=0.131 //l=0.64 //layer=m1 \
 //thickness=0.36 //x=7.59 //y=5.335 //x2=6.95 //y2=5.335
r605 (  4 28 ) resistor r=0.0801089 //w=0.224 //l=0.13 //layer=m1 \
 //thickness=0.36 //x=3.82 //y=4.75 //x2=3.82 //y2=4.88
r606 (  3 30 ) resistor r=0.0911593 //w=0.376 //l=0.184174 //layer=m1 \
 //thickness=0.36 //x=3.82 //y=3.67 //x2=3.872 //y2=3.51
r607 (  3 4 ) resistor r=1.03053 //w=0.131 //l=1.08 //layer=m1 \
 //thickness=0.36 //x=3.82 //y=3.67 //x2=3.82 //y2=4.75
r608 (  2 30 ) resistor r=0.0911593 //w=0.376 //l=0.184174 //layer=m1 \
 //thickness=0.36 //x=3.82 //y=3.35 //x2=3.872 //y2=3.51
r609 (  1 26 ) resistor r=0.0719237 //w=0.222 //l=0.115 //layer=m1 \
 //thickness=0.36 //x=3.82 //y=2.375 //x2=3.82 //y2=2.26
r610 (  1 2 ) resistor r=0.930344 //w=0.131 //l=0.975 //layer=m1 \
 //thickness=0.36 //x=3.82 //y=2.375 //x2=3.82 //y2=3.35
ends PM_TMRDFFRNQX1\%noxref_1

subckt PM_TMRDFFRNQX1\%noxref_2 ( 3 8 9 11 12 14 15 16 17 18 19 20 23 24 27 29 \
 32 36 48 50 51 54 62 79 88 92 93 94 95 96 97 98 99 101 107 108 109 110 122 \
 124 125 )
c277 ( 122 0 ) capacitor c=0.00878249f //x=12.07 //y=1.085
c278 ( 110 0 ) capacitor c=0.0612936f //x=14.825 //y=4.97
c279 ( 109 0 ) capacitor c=0.0376642f //x=15.115 //y=4.97
c280 ( 108 0 ) capacitor c=0.0346489f //x=14.78 //y=1.4
c281 ( 107 0 ) capacitor c=0.018692f //x=14.78 //y=1.055
c282 ( 101 0 ) capacitor c=0.0137077f //x=14.625 //y=1.555
c283 ( 99 0 ) capacitor c=0.0158585f //x=14.625 //y=0.9
c284 ( 98 0 ) capacitor c=0.101012f //x=14.25 //y=2.095
c285 ( 97 0 ) capacitor c=0.0229444f //x=14.25 //y=1.71
c286 ( 96 0 ) capacitor c=0.0234359f //x=14.25 //y=1.4
c287 ( 95 0 ) capacitor c=0.019815f //x=14.25 //y=1.055
c288 ( 94 0 ) capacitor c=0.110208f //x=15.19 //y=6.2
c289 ( 93 0 ) capacitor c=0.158957f //x=14.75 //y=6.2
c290 ( 88 0 ) capacitor c=0.0014751f //x=14.55 //y=4.88
c291 ( 79 0 ) capacitor c=0.0012618f //x=14.55 //y=2.26
c292 ( 62 0 ) capacitor c=0.0322017f //x=12.22 //y=5.56
c293 ( 54 0 ) capacitor c=0.0291938f //x=11.34 //y=5.56
c294 ( 51 0 ) capacitor c=0.0230934f //x=14.395 //y=3.515
c295 ( 50 0 ) capacitor c=5.6075e-19 //x=14.555 //y=3.515
c296 ( 48 0 ) capacitor c=8.37988e-19 //x=12.86 //y=3.515
c297 ( 36 0 ) capacitor c=0.0170693f //x=14.55 //y=3.51
c298 ( 32 0 ) capacitor c=0.016938f //x=12.7 //y=3.51
c299 ( 29 0 ) capacitor c=0.0112415f //x=12.26 //y=1.18
c300 ( 27 0 ) capacitor c=5.78613e-19 //x=12.22 //y=5.56
c301 ( 24 0 ) capacitor c=0.010659f //x=12.22 //y=5.38
c302 ( 23 0 ) capacitor c=0.00926978f //x=11.34 //y=5.56
c303 ( 20 0 ) capacitor c=0.0382053f //x=14.55 //y=4.755
c304 ( 19 0 ) capacitor c=0.0145929f //x=14.55 //y=3.675
c305 ( 18 0 ) capacitor c=0.0314186f //x=14.55 //y=3.355
c306 ( 17 0 ) capacitor c=0.00495287f //x=14.55 //y=2.375
c307 ( 16 0 ) capacitor c=0.0418029f //x=12.7 //y=5.295
c308 ( 15 0 ) capacitor c=0.0134337f //x=12.7 //y=3.675
c309 ( 14 0 ) capacitor c=0.0411601f //x=12.7 //y=3.355
c310 ( 12 0 ) capacitor c=0.00466468f //x=12.345 //y=1.835
c311 ( 11 0 ) capacitor c=0.0120653f //x=12.615 //y=1.835
c312 ( 9 0 ) capacitor c=0.0116495f //x=12.615 //y=5.38
c313 ( 8 0 ) capacitor c=0.0134844f //x=12.26 //y=1.75
c314 ( 3 0 ) capacitor c=0.013452f //x=12.105 //y=5.38
r315 (  109 111 ) resistor r=26.9307 //w=0.15 //l=0.106066 //layer=ply \
 //thickness=0.18 //x=15.115 //y=4.97 //x2=15.19 //y2=5.045
r316 (  109 110 ) resistor r=148.702 //w=0.094 //l=0.29 //layer=ply \
 //thickness=0.18 //x=15.115 //y=4.97 //x2=14.825 //y2=4.97
r317 (  108 121 ) resistor r=45.1352 //w=0.168 //l=0.173853 //layer=ply \
 //thickness=0.18 //x=14.78 //y=1.4 //x2=14.74 //y2=1.555
r318 (  107 120 ) resistor r=45.1352 //w=0.168 //l=0.173853 //layer=ply \
 //thickness=0.18 //x=14.78 //y=1.055 //x2=14.74 //y2=0.9
r319 (  107 108 ) resistor r=176.904 //w=0.094 //l=0.345 //layer=ply \
 //thickness=0.18 //x=14.78 //y=1.055 //x2=14.78 //y2=1.4
r320 (  104 110 ) resistor r=22.7971 //w=0.269 //l=0.106066 //layer=ply \
 //thickness=0.18 //x=14.75 //y=5.045 //x2=14.825 //y2=4.97
r321 (  104 119 ) resistor r=35.8364 //w=0.269 //l=0.270185 //layer=ply \
 //thickness=0.18 //x=14.75 //y=5.045 //x2=14.55 //y2=4.88
r322 (  102 115 ) resistor r=10.701 //w=0.21 //l=0.115 //layer=ply \
 //thickness=0.18 //x=14.405 //y=1.555 //x2=14.29 //y2=1.555
r323 (  101 121 ) resistor r=5.52526 //w=0.168 //l=0.115 //layer=ply \
 //thickness=0.18 //x=14.625 //y=1.555 //x2=14.74 //y2=1.555
r324 (  100 114 ) resistor r=5.52526 //w=0.168 //l=0.115 //layer=ply \
 //thickness=0.18 //x=14.405 //y=0.9 //x2=14.29 //y2=0.9
r325 (  99 120 ) resistor r=5.52526 //w=0.168 //l=0.115 //layer=ply \
 //thickness=0.18 //x=14.625 //y=0.9 //x2=14.74 //y2=0.9
r326 (  99 100 ) resistor r=112.809 //w=0.094 //l=0.22 //layer=ply \
 //thickness=0.18 //x=14.625 //y=0.9 //x2=14.405 //y2=0.9
r327 (  98 117 ) resistor r=58.7805 //w=0.246 //l=0.373497 //layer=ply \
 //thickness=0.18 //x=14.25 //y=2.095 //x2=14.55 //y2=2.26
r328 (  97 115 ) resistor r=39.5823 //w=0.21 //l=0.173853 //layer=ply \
 //thickness=0.18 //x=14.25 //y=1.71 //x2=14.29 //y2=1.555
r329 (  97 98 ) resistor r=197.415 //w=0.094 //l=0.385 //layer=ply \
 //thickness=0.18 //x=14.25 //y=1.71 //x2=14.25 //y2=2.095
r330 (  96 115 ) resistor r=39.5823 //w=0.21 //l=0.173853 //layer=ply \
 //thickness=0.18 //x=14.25 //y=1.4 //x2=14.29 //y2=1.555
r331 (  95 114 ) resistor r=45.1352 //w=0.168 //l=0.173853 //layer=ply \
 //thickness=0.18 //x=14.25 //y=1.055 //x2=14.29 //y2=0.9
r332 (  95 96 ) resistor r=176.904 //w=0.094 //l=0.345 //layer=ply \
 //thickness=0.18 //x=14.25 //y=1.055 //x2=14.25 //y2=1.4
r333 (  94 111 ) resistor r=592.245 //w=0.094 //l=1.155 //layer=ply \
 //thickness=0.18 //x=15.19 //y=6.2 //x2=15.19 //y2=5.045
r334 (  93 104 ) resistor r=592.245 //w=0.094 //l=1.155 //layer=ply \
 //thickness=0.18 //x=14.75 //y=6.2 //x2=14.75 //y2=5.045
r335 (  92 101 ) resistor r=56.4043 //w=0.094 //l=0.11 //layer=ply \
 //thickness=0.18 //x=14.515 //y=1.555 //x2=14.625 //y2=1.555
r336 (  92 102 ) resistor r=56.4043 //w=0.094 //l=0.11 //layer=ply \
 //thickness=0.18 //x=14.515 //y=1.555 //x2=14.405 //y2=1.555
r337 (  88 119 ) resistor r=152 //w=0.17 //l=0.17 //layer=licon //count=1 \
 //x=14.55 //y=4.88 //x2=14.55 //y2=4.88
r338 (  79 117 ) resistor r=152 //w=0.17 //l=0.17 //layer=licon //count=1 \
 //x=14.55 //y=2.26 //x2=14.55 //y2=2.26
r339 (  62 125 ) resistor r=23.615 //w=0.187 //l=0.345 //layer=li \
 //thickness=0.1 //x=12.22 //y=5.56 //x2=12.22 //y2=5.905
r340 (  54 124 ) resistor r=23.615 //w=0.187 //l=0.345 //layer=li \
 //thickness=0.1 //x=11.34 //y=5.56 //x2=11.34 //y2=5.905
r341 (  50 51 ) resistor r=0.10734 //w=0.281 //l=0.16 //layer=m2 \
 //thickness=0.36 //x=14.555 //y=3.515 //x2=14.395 //y2=3.515
r342 (  48 51 ) resistor r=1.46469 //w=0.131 //l=1.535 //layer=m2 \
 //thickness=0.36 //x=12.86 //y=3.51 //x2=14.395 //y2=3.51
r343 (  46 48 ) resistor r=0.10734 //w=0.281 //l=0.16 //layer=m2 \
 //thickness=0.36 //x=12.7 //y=3.515 //x2=12.86 //y2=3.515
r344 (  42 88 ) resistor r=9.3 //w=0.17 //l=0.17 //layer=mcon //count=1 \
 //x=14.55 //y=4.88 //x2=14.55 //y2=4.88
r345 (  40 79 ) resistor r=9.3 //w=0.17 //l=0.17 //layer=mcon //count=1 \
 //x=14.55 //y=2.26 //x2=14.55 //y2=2.26
r346 (  38 50 ) resistor r=4.5 //w=0.15 //l=0.15 //layer=via1 //count=1 \
 //x=14.555 //y=3.515 //x2=14.555 //y2=3.515
r347 (  36 38 ) resistor r=0.00164908 //w=0.379 //l=0.005 //layer=m1 \
 //thickness=0.36 //x=14.5 //y=3.51 //x2=14.5 //y2=3.515
r348 (  34 46 ) resistor r=4.5 //w=0.15 //l=0.15 //layer=via1 //count=1 \
 //x=12.7 //y=3.515 //x2=12.7 //y2=3.515
r349 (  32 34 ) resistor r=0.00166223 //w=0.376 //l=0.005 //layer=m1 \
 //thickness=0.36 //x=12.752 //y=3.51 //x2=12.752 //y2=3.515
r350 (  29 122 ) resistor r=9.3 //w=0.17 //l=0.17 //layer=mcon //count=1 \
 //x=12.26 //y=1.18 //x2=12.26 //y2=1.18
r351 (  27 62 ) resistor r=9.3 //w=0.17 //l=0.17 //layer=mcon //count=1 \
 //x=12.22 //y=5.56 //x2=12.22 //y2=5.56
r352 (  24 27 ) resistor r=0.117801 //w=0.191 //l=0.18 //layer=m1 \
 //thickness=0.36 //x=12.22 //y=5.38 //x2=12.22 //y2=5.56
r353 (  23 54 ) resistor r=9.3 //w=0.17 //l=0.17 //layer=mcon //count=1 \
 //x=11.34 //y=5.56 //x2=11.34 //y2=5.56
r354 (  21 23 ) resistor r=0.10274 //w=0.219 //l=0.18 //layer=m1 \
 //thickness=0.36 //x=11.34 //y=5.38 //x2=11.34 //y2=5.56
r355 (  20 42 ) resistor r=0.0760407 //w=0.238 //l=0.125 //layer=m1 \
 //thickness=0.36 //x=14.55 //y=4.755 //x2=14.55 //y2=4.88
r356 (  19 38 ) resistor r=0.0912814 //w=0.379 //l=0.183303 //layer=m1 \
 //thickness=0.36 //x=14.55 //y=3.675 //x2=14.5 //y2=3.515
r357 (  19 20 ) resistor r=1.03053 //w=0.131 //l=1.08 //layer=m1 \
 //thickness=0.36 //x=14.55 //y=3.675 //x2=14.55 //y2=4.755
r358 (  18 36 ) resistor r=0.0896323 //w=0.379 //l=0.178255 //layer=m1 \
 //thickness=0.36 //x=14.55 //y=3.355 //x2=14.5 //y2=3.51
r359 (  17 40 ) resistor r=0.0719237 //w=0.222 //l=0.115 //layer=m1 \
 //thickness=0.36 //x=14.55 //y=2.375 //x2=14.55 //y2=2.26
r360 (  17 18 ) resistor r=0.935115 //w=0.131 //l=0.98 //layer=m1 \
 //thickness=0.36 //x=14.55 //y=2.375 //x2=14.55 //y2=3.355
r361 (  15 34 ) resistor r=0.0911593 //w=0.376 //l=0.184174 //layer=m1 \
 //thickness=0.36 //x=12.7 //y=3.675 //x2=12.752 //y2=3.515
r362 (  15 16 ) resistor r=1.5458 //w=0.131 //l=1.62 //layer=m1 \
 //thickness=0.36 //x=12.7 //y=3.675 //x2=12.7 //y2=5.295
r363 (  14 32 ) resistor r=0.0894971 //w=0.376 //l=0.179123 //layer=m1 \
 //thickness=0.36 //x=12.7 //y=3.355 //x2=12.752 //y2=3.51
r364 (  13 14 ) resistor r=1.36927 //w=0.131 //l=1.435 //layer=m1 \
 //thickness=0.36 //x=12.7 //y=1.92 //x2=12.7 //y2=3.355
r365 (  11 13 ) resistor r=0.0698411 //w=0.17 //l=0.120208 //layer=m1 \
 //thickness=0.36 //x=12.615 //y=1.835 //x2=12.7 //y2=1.92
r366 (  11 12 ) resistor r=0.257634 //w=0.131 //l=0.27 //layer=m1 \
 //thickness=0.36 //x=12.615 //y=1.835 //x2=12.345 //y2=1.835
r367 (  10 24 ) resistor r=0.0257089 //w=0.23 //l=0.115 //layer=m1 \
 //thickness=0.36 //x=12.335 //y=5.38 //x2=12.22 //y2=5.38
r368 (  9 16 ) resistor r=0.0698411 //w=0.17 //l=0.120208 //layer=m1 \
 //thickness=0.36 //x=12.615 //y=5.38 //x2=12.7 //y2=5.295
r369 (  9 10 ) resistor r=0.267176 //w=0.131 //l=0.28 //layer=m1 \
 //thickness=0.36 //x=12.615 //y=5.38 //x2=12.335 //y2=5.38
r370 (  8 12 ) resistor r=0.0698411 //w=0.17 //l=0.120208 //layer=m1 \
 //thickness=0.36 //x=12.26 //y=1.75 //x2=12.345 //y2=1.835
r371 (  7 29 ) resistor r=0.0913624 //w=0.191 //l=0.12 //layer=m1 \
 //thickness=0.36 //x=12.26 //y=1.3 //x2=12.26 //y2=1.18
r372 (  7 8 ) resistor r=0.429389 //w=0.131 //l=0.45 //layer=m1 \
 //thickness=0.36 //x=12.26 //y=1.3 //x2=12.26 //y2=1.75
r373 (  4 21 ) resistor r=0.0227762 //w=0.219 //l=0.115 //layer=m1 \
 //thickness=0.36 //x=11.455 //y=5.38 //x2=11.34 //y2=5.38
r374 (  3 24 ) resistor r=0.0257089 //w=0.23 //l=0.115 //layer=m1 \
 //thickness=0.36 //x=12.105 //y=5.38 //x2=12.22 //y2=5.38
r375 (  3 4 ) resistor r=0.620229 //w=0.131 //l=0.65 //layer=m1 \
 //thickness=0.36 //x=12.105 //y=5.38 //x2=11.455 //y2=5.38
ends PM_TMRDFFRNQX1\%noxref_2

subckt PM_TMRDFFRNQX1\%noxref_3 ( 1 3 6 7 9 10 11 12 14 15 16 17 18 19 20 21 \
 22 23 24 25 28 31 37 45 48 54 56 57 58 60 62 64 66 68 70 72 77 83 91 99 116 \
 125 130 139 143 144 145 146 147 148 149 150 151 152 153 155 161 162 163 164 \
 168 169 170 171 172 174 180 181 182 183 203 205 206 207 )
c479 ( 203 0 ) capacitor c=0.00885916f //x=3.885 //y=1.095
c480 ( 183 0 ) capacitor c=0.0583399f //x=19.635 //y=4.97
c481 ( 182 0 ) capacitor c=0.0376642f //x=19.925 //y=4.97
c482 ( 181 0 ) capacitor c=0.0346489f //x=19.59 //y=1.4
c483 ( 180 0 ) capacitor c=0.018692f //x=19.59 //y=1.055
c484 ( 174 0 ) capacitor c=0.0137077f //x=19.435 //y=1.555
c485 ( 172 0 ) capacitor c=0.0158585f //x=19.435 //y=0.9
c486 ( 171 0 ) capacitor c=0.103534f //x=19.06 //y=2.095
c487 ( 170 0 ) capacitor c=0.0229444f //x=19.06 //y=1.71
c488 ( 169 0 ) capacitor c=0.0234359f //x=19.06 //y=1.4
c489 ( 168 0 ) capacitor c=0.019815f //x=19.06 //y=1.055
c490 ( 164 0 ) capacitor c=0.0564069f //x=6.685 //y=4.97
c491 ( 163 0 ) capacitor c=0.0376642f //x=6.975 //y=4.97
c492 ( 162 0 ) capacitor c=0.0346489f //x=6.64 //y=1.4
c493 ( 161 0 ) capacitor c=0.018692f //x=6.64 //y=1.055
c494 ( 155 0 ) capacitor c=0.0137077f //x=6.485 //y=1.555
c495 ( 153 0 ) capacitor c=0.0158585f //x=6.485 //y=0.9
c496 ( 152 0 ) capacitor c=0.103534f //x=6.11 //y=2.095
c497 ( 151 0 ) capacitor c=0.0229444f //x=6.11 //y=1.71
c498 ( 150 0 ) capacitor c=0.0234359f //x=6.11 //y=1.4
c499 ( 149 0 ) capacitor c=0.019815f //x=6.11 //y=1.055
c500 ( 148 0 ) capacitor c=0.110208f //x=20 //y=6.2
c501 ( 147 0 ) capacitor c=0.158957f //x=19.56 //y=6.2
c502 ( 146 0 ) capacitor c=0.110208f //x=7.05 //y=6.2
c503 ( 145 0 ) capacitor c=0.158957f //x=6.61 //y=6.2
c504 ( 139 0 ) capacitor c=0.0014751f //x=19.36 //y=4.88
c505 ( 130 0 ) capacitor c=0.0012618f //x=19.36 //y=2.26
c506 ( 125 0 ) capacitor c=0.0014751f //x=6.41 //y=4.88
c507 ( 116 0 ) capacitor c=0.0012618f //x=6.41 //y=2.26
c508 ( 99 0 ) capacitor c=0.0293561f //x=3.78 //y=5.56
c509 ( 91 0 ) capacitor c=0.029137f //x=2.9 //y=5.56
c510 ( 83 0 ) capacitor c=0.0278099f //x=2.02 //y=5.56
c511 ( 77 0 ) capacitor c=7.36606e-19 //x=4.725 //y=3.885
c512 ( 72 0 ) capacitor c=0.0323769f //x=17.73 //y=3.87
c513 ( 70 0 ) capacitor c=0.0302787f //x=17.13 //y=3.88
c514 ( 68 0 ) capacitor c=0.00490196f //x=14.77 //y=3.9
c515 ( 66 0 ) capacitor c=0.018225f //x=14.17 //y=3.88
c516 ( 64 0 ) capacitor c=0.00418082f //x=12.915 //y=3.9
c517 ( 62 0 ) capacitor c=0.00894521f //x=12.18 //y=3.865
c518 ( 60 0 ) capacitor c=0.00622316f //x=11.435 //y=3.895
c519 ( 58 0 ) capacitor c=0.0174986f //x=10.835 //y=3.88
c520 ( 57 0 ) capacitor c=0.0244189f //x=9.245 //y=3.895
c521 ( 56 0 ) capacitor c=0.00423161f //x=9.59 //y=3.895
c522 ( 54 0 ) capacitor c=0.0209003f //x=6.255 //y=3.88
c523 ( 48 0 ) capacitor c=0.0152841f //x=19.35 //y=3.88
c524 ( 45 0 ) capacitor c=0.0167936f //x=6.41 //y=3.88
c525 ( 37 0 ) capacitor c=0.0172565f //x=4.56 //y=3.88
c526 ( 31 0 ) capacitor c=9.55882e-19 //x=3.78 //y=5.335
c527 ( 28 0 ) capacitor c=0.00740623f //x=2.9 //y=5.335
c528 ( 25 0 ) capacitor c=0.0123281f //x=2.022 //y=5.335
c529 ( 24 0 ) capacitor c=0.024997f //x=19.36 //y=4.755
c530 ( 23 0 ) capacitor c=0.0136306f //x=19.36 //y=4.04
c531 ( 22 0 ) capacitor c=0.0448526f //x=19.36 //y=3.72
c532 ( 21 0 ) capacitor c=0.00489532f //x=19.36 //y=2.375
c533 ( 20 0 ) capacitor c=0.0266349f //x=6.41 //y=4.755
c534 ( 19 0 ) capacitor c=0.0127337f //x=6.41 //y=4.04
c535 ( 18 0 ) capacitor c=0.0420464f //x=6.41 //y=3.72
c536 ( 17 0 ) capacitor c=0.00670383f //x=6.41 //y=2.375
c537 ( 16 0 ) capacitor c=0.0325919f //x=4.56 //y=5.25
c538 ( 15 0 ) capacitor c=0.0131885f //x=4.56 //y=4.045
c539 ( 14 0 ) capacitor c=0.0524199f //x=4.56 //y=3.725
c540 ( 12 0 ) capacitor c=0.00686157f //x=4.16 //y=1.845
c541 ( 11 0 ) capacitor c=0.0163455f //x=4.475 //y=1.845
c542 ( 10 0 ) capacitor c=0.0167992f //x=4.075 //y=1.76
c543 ( 9 0 ) capacitor c=0.0113813f //x=4.075 //y=1.305
c544 ( 7 0 ) capacitor c=0.0229543f //x=4.475 //y=5.335
c545 ( 6 0 ) capacitor c=0.00933983f //x=3.78 //y=5.56
c546 ( 3 0 ) capacitor c=0.019444f //x=3.665 //y=5.335
c547 ( 1 0 ) capacitor c=0.0149475f //x=2.78 //y=5.335
r548 (  182 184 ) resistor r=26.9307 //w=0.15 //l=0.106066 //layer=ply \
 //thickness=0.18 //x=19.925 //y=4.97 //x2=20 //y2=5.045
r549 (  182 183 ) resistor r=148.702 //w=0.094 //l=0.29 //layer=ply \
 //thickness=0.18 //x=19.925 //y=4.97 //x2=19.635 //y2=4.97
r550 (  181 202 ) resistor r=45.1352 //w=0.168 //l=0.173853 //layer=ply \
 //thickness=0.18 //x=19.59 //y=1.4 //x2=19.55 //y2=1.555
r551 (  180 201 ) resistor r=45.1352 //w=0.168 //l=0.173853 //layer=ply \
 //thickness=0.18 //x=19.59 //y=1.055 //x2=19.55 //y2=0.9
r552 (  180 181 ) resistor r=176.904 //w=0.094 //l=0.345 //layer=ply \
 //thickness=0.18 //x=19.59 //y=1.055 //x2=19.59 //y2=1.4
r553 (  177 183 ) resistor r=22.7971 //w=0.269 //l=0.106066 //layer=ply \
 //thickness=0.18 //x=19.56 //y=5.045 //x2=19.635 //y2=4.97
r554 (  177 200 ) resistor r=35.8364 //w=0.269 //l=0.270185 //layer=ply \
 //thickness=0.18 //x=19.56 //y=5.045 //x2=19.36 //y2=4.88
r555 (  175 196 ) resistor r=10.701 //w=0.21 //l=0.115 //layer=ply \
 //thickness=0.18 //x=19.215 //y=1.555 //x2=19.1 //y2=1.555
r556 (  174 202 ) resistor r=5.52526 //w=0.168 //l=0.115 //layer=ply \
 //thickness=0.18 //x=19.435 //y=1.555 //x2=19.55 //y2=1.555
r557 (  173 195 ) resistor r=5.52526 //w=0.168 //l=0.115 //layer=ply \
 //thickness=0.18 //x=19.215 //y=0.9 //x2=19.1 //y2=0.9
r558 (  172 201 ) resistor r=5.52526 //w=0.168 //l=0.115 //layer=ply \
 //thickness=0.18 //x=19.435 //y=0.9 //x2=19.55 //y2=0.9
r559 (  172 173 ) resistor r=112.809 //w=0.094 //l=0.22 //layer=ply \
 //thickness=0.18 //x=19.435 //y=0.9 //x2=19.215 //y2=0.9
r560 (  171 198 ) resistor r=58.7805 //w=0.246 //l=0.373497 //layer=ply \
 //thickness=0.18 //x=19.06 //y=2.095 //x2=19.36 //y2=2.26
r561 (  170 196 ) resistor r=39.5823 //w=0.21 //l=0.173853 //layer=ply \
 //thickness=0.18 //x=19.06 //y=1.71 //x2=19.1 //y2=1.555
r562 (  170 171 ) resistor r=197.415 //w=0.094 //l=0.385 //layer=ply \
 //thickness=0.18 //x=19.06 //y=1.71 //x2=19.06 //y2=2.095
r563 (  169 196 ) resistor r=39.5823 //w=0.21 //l=0.173853 //layer=ply \
 //thickness=0.18 //x=19.06 //y=1.4 //x2=19.1 //y2=1.555
r564 (  168 195 ) resistor r=45.1352 //w=0.168 //l=0.173853 //layer=ply \
 //thickness=0.18 //x=19.06 //y=1.055 //x2=19.1 //y2=0.9
r565 (  168 169 ) resistor r=176.904 //w=0.094 //l=0.345 //layer=ply \
 //thickness=0.18 //x=19.06 //y=1.055 //x2=19.06 //y2=1.4
r566 (  163 165 ) resistor r=26.9307 //w=0.15 //l=0.106066 //layer=ply \
 //thickness=0.18 //x=6.975 //y=4.97 //x2=7.05 //y2=5.045
r567 (  163 164 ) resistor r=148.702 //w=0.094 //l=0.29 //layer=ply \
 //thickness=0.18 //x=6.975 //y=4.97 //x2=6.685 //y2=4.97
r568 (  162 194 ) resistor r=45.1352 //w=0.168 //l=0.173853 //layer=ply \
 //thickness=0.18 //x=6.64 //y=1.4 //x2=6.6 //y2=1.555
r569 (  161 193 ) resistor r=45.1352 //w=0.168 //l=0.173853 //layer=ply \
 //thickness=0.18 //x=6.64 //y=1.055 //x2=6.6 //y2=0.9
r570 (  161 162 ) resistor r=176.904 //w=0.094 //l=0.345 //layer=ply \
 //thickness=0.18 //x=6.64 //y=1.055 //x2=6.64 //y2=1.4
r571 (  158 164 ) resistor r=22.7971 //w=0.269 //l=0.106066 //layer=ply \
 //thickness=0.18 //x=6.61 //y=5.045 //x2=6.685 //y2=4.97
r572 (  158 192 ) resistor r=35.8364 //w=0.269 //l=0.270185 //layer=ply \
 //thickness=0.18 //x=6.61 //y=5.045 //x2=6.41 //y2=4.88
r573 (  156 188 ) resistor r=10.701 //w=0.21 //l=0.115 //layer=ply \
 //thickness=0.18 //x=6.265 //y=1.555 //x2=6.15 //y2=1.555
r574 (  155 194 ) resistor r=5.52526 //w=0.168 //l=0.115 //layer=ply \
 //thickness=0.18 //x=6.485 //y=1.555 //x2=6.6 //y2=1.555
r575 (  154 187 ) resistor r=5.52526 //w=0.168 //l=0.115 //layer=ply \
 //thickness=0.18 //x=6.265 //y=0.9 //x2=6.15 //y2=0.9
r576 (  153 193 ) resistor r=5.52526 //w=0.168 //l=0.115 //layer=ply \
 //thickness=0.18 //x=6.485 //y=0.9 //x2=6.6 //y2=0.9
r577 (  153 154 ) resistor r=112.809 //w=0.094 //l=0.22 //layer=ply \
 //thickness=0.18 //x=6.485 //y=0.9 //x2=6.265 //y2=0.9
r578 (  152 190 ) resistor r=58.7805 //w=0.246 //l=0.373497 //layer=ply \
 //thickness=0.18 //x=6.11 //y=2.095 //x2=6.41 //y2=2.26
r579 (  151 188 ) resistor r=39.5823 //w=0.21 //l=0.173853 //layer=ply \
 //thickness=0.18 //x=6.11 //y=1.71 //x2=6.15 //y2=1.555
r580 (  151 152 ) resistor r=197.415 //w=0.094 //l=0.385 //layer=ply \
 //thickness=0.18 //x=6.11 //y=1.71 //x2=6.11 //y2=2.095
r581 (  150 188 ) resistor r=39.5823 //w=0.21 //l=0.173853 //layer=ply \
 //thickness=0.18 //x=6.11 //y=1.4 //x2=6.15 //y2=1.555
r582 (  149 187 ) resistor r=45.1352 //w=0.168 //l=0.173853 //layer=ply \
 //thickness=0.18 //x=6.11 //y=1.055 //x2=6.15 //y2=0.9
r583 (  149 150 ) resistor r=176.904 //w=0.094 //l=0.345 //layer=ply \
 //thickness=0.18 //x=6.11 //y=1.055 //x2=6.11 //y2=1.4
r584 (  148 184 ) resistor r=592.245 //w=0.094 //l=1.155 //layer=ply \
 //thickness=0.18 //x=20 //y=6.2 //x2=20 //y2=5.045
r585 (  147 177 ) resistor r=592.245 //w=0.094 //l=1.155 //layer=ply \
 //thickness=0.18 //x=19.56 //y=6.2 //x2=19.56 //y2=5.045
r586 (  146 165 ) resistor r=592.245 //w=0.094 //l=1.155 //layer=ply \
 //thickness=0.18 //x=7.05 //y=6.2 //x2=7.05 //y2=5.045
r587 (  145 158 ) resistor r=592.245 //w=0.094 //l=1.155 //layer=ply \
 //thickness=0.18 //x=6.61 //y=6.2 //x2=6.61 //y2=5.045
r588 (  144 174 ) resistor r=56.4043 //w=0.094 //l=0.11 //layer=ply \
 //thickness=0.18 //x=19.325 //y=1.555 //x2=19.435 //y2=1.555
r589 (  144 175 ) resistor r=56.4043 //w=0.094 //l=0.11 //layer=ply \
 //thickness=0.18 //x=19.325 //y=1.555 //x2=19.215 //y2=1.555
r590 (  143 155 ) resistor r=56.4043 //w=0.094 //l=0.11 //layer=ply \
 //thickness=0.18 //x=6.375 //y=1.555 //x2=6.485 //y2=1.555
r591 (  143 156 ) resistor r=56.4043 //w=0.094 //l=0.11 //layer=ply \
 //thickness=0.18 //x=6.375 //y=1.555 //x2=6.265 //y2=1.555
r592 (  139 200 ) resistor r=152 //w=0.17 //l=0.17 //layer=licon //count=1 \
 //x=19.36 //y=4.88 //x2=19.36 //y2=4.88
r593 (  130 198 ) resistor r=152 //w=0.17 //l=0.17 //layer=licon //count=1 \
 //x=19.36 //y=2.26 //x2=19.36 //y2=2.26
r594 (  125 192 ) resistor r=152 //w=0.17 //l=0.17 //layer=licon //count=1 \
 //x=6.41 //y=4.88 //x2=6.41 //y2=4.88
r595 (  116 190 ) resistor r=152 //w=0.17 //l=0.17 //layer=licon //count=1 \
 //x=6.41 //y=2.26 //x2=6.41 //y2=2.26
r596 (  99 207 ) resistor r=23.615 //w=0.187 //l=0.345 //layer=li \
 //thickness=0.1 //x=3.78 //y=5.56 //x2=3.78 //y2=5.905
r597 (  91 206 ) resistor r=23.615 //w=0.187 //l=0.345 //layer=li \
 //thickness=0.1 //x=2.9 //y=5.56 //x2=2.9 //y2=5.905
r598 (  83 205 ) resistor r=23.615 //w=0.187 //l=0.345 //layer=li \
 //thickness=0.1 //x=2.02 //y=5.56 //x2=2.02 //y2=5.905
r599 (  75 77 ) resistor r=0.10734 //w=0.281 //l=0.16 //layer=m2 \
 //thickness=0.36 //x=4.565 //y=3.885 //x2=4.725 //y2=3.885
r600 (  72 81 ) resistor r=1.03061 //w=0.197 //l=1.62499 //layer=m2 \
 //thickness=0.36 //x=17.73 //y=3.87 //x2=19.35 //y2=3.88
r601 (  72 73 ) resistor r=0.410305 //w=0.131 //l=0.43 //layer=m2 \
 //thickness=0.36 //x=17.73 //y=3.87 //x2=17.3 //y2=3.87
r602 (  70 73 ) resistor r=0.125 //w=0.17 //l=0.174929 //layer=m2 \
 //thickness=0.36 //x=17.13 //y=3.88 //x2=17.3 //y2=3.87
r603 (  70 71 ) resistor r=2.08969 //w=0.131 //l=2.19 //layer=m2 \
 //thickness=0.36 //x=17.13 //y=3.88 //x2=14.94 //y2=3.88
r604 (  68 71 ) resistor r=0.125 //w=0.17 //l=0.179722 //layer=m2 \
 //thickness=0.36 //x=14.77 //y=3.9 //x2=14.94 //y2=3.88
r605 (  68 69 ) resistor r=0.329198 //w=0.131 //l=0.345 //layer=m2 \
 //thickness=0.36 //x=14.77 //y=3.9 //x2=14.425 //y2=3.9
r606 (  66 69 ) resistor r=0.1875 //w=0.17 //l=0.264811 //layer=m2 \
 //thickness=0.36 //x=14.17 //y=3.88 //x2=14.425 //y2=3.9
r607 (  66 67 ) resistor r=1.03531 //w=0.131 //l=1.085 //layer=m2 \
 //thickness=0.36 //x=14.17 //y=3.88 //x2=13.085 //y2=3.88
r608 (  64 67 ) resistor r=0.125 //w=0.17 //l=0.179722 //layer=m2 \
 //thickness=0.36 //x=12.915 //y=3.9 //x2=13.085 //y2=3.88
r609 (  64 65 ) resistor r=0.329198 //w=0.131 //l=0.345 //layer=m2 \
 //thickness=0.36 //x=12.915 //y=3.9 //x2=12.57 //y2=3.9
r610 (  62 65 ) resistor r=0.286765 //w=0.17 //l=0.407124 //layer=m2 \
 //thickness=0.36 //x=12.18 //y=3.865 //x2=12.57 //y2=3.9
r611 (  62 63 ) resistor r=0.410305 //w=0.131 //l=0.43 //layer=m2 \
 //thickness=0.36 //x=12.18 //y=3.865 //x2=11.75 //y2=3.865
r612 (  60 63 ) resistor r=0.231618 //w=0.17 //l=0.329659 //layer=m2 \
 //thickness=0.36 //x=11.435 //y=3.895 //x2=11.75 //y2=3.865
r613 (  60 61 ) resistor r=0.329198 //w=0.131 //l=0.345 //layer=m2 \
 //thickness=0.36 //x=11.435 //y=3.895 //x2=11.09 //y2=3.895
r614 (  58 61 ) resistor r=0.1875 //w=0.17 //l=0.262393 //layer=m2 \
 //thickness=0.36 //x=10.835 //y=3.88 //x2=11.09 //y2=3.895
r615 (  58 59 ) resistor r=1.02576 //w=0.131 //l=1.075 //layer=m2 \
 //thickness=0.36 //x=10.835 //y=3.88 //x2=9.76 //y2=3.88
r616 (  57 79 ) resistor r=1.89299 //w=0.187 //l=2.83749 //layer=m2 \
 //thickness=0.36 //x=9.245 //y=3.895 //x2=6.415 //y2=3.88
r617 (  56 59 ) resistor r=0.125 //w=0.17 //l=0.177341 //layer=m2 \
 //thickness=0.36 //x=9.59 //y=3.895 //x2=9.76 //y2=3.88
r618 (  56 57 ) resistor r=0.329198 //w=0.131 //l=0.345 //layer=m2 \
 //thickness=0.36 //x=9.59 //y=3.895 //x2=9.245 //y2=3.895
r619 (  54 79 ) resistor r=0.108234 //w=0.187 //l=0.16 //layer=m2 \
 //thickness=0.36 //x=6.255 //y=3.88 //x2=6.415 //y2=3.88
r620 (  54 77 ) resistor r=1.45992 //w=0.131 //l=1.53 //layer=m2 \
 //thickness=0.36 //x=6.255 //y=3.88 //x2=4.725 //y2=3.88
r621 (  53 139 ) resistor r=9.3 //w=0.17 //l=0.17 //layer=mcon //count=1 \
 //x=19.36 //y=4.88 //x2=19.36 //y2=4.88
r622 (  51 130 ) resistor r=9.3 //w=0.17 //l=0.17 //layer=mcon //count=1 \
 //x=19.36 //y=2.26 //x2=19.36 //y2=2.26
r623 (  48 81 ) resistor r=4.5 //w=0.15 //l=0.15 //layer=via1 //count=1 \
 //x=19.35 //y=3.88 //x2=19.35 //y2=3.88
r624 (  45 79 ) resistor r=4.5 //w=0.15 //l=0.15 //layer=via1 //count=1 \
 //x=6.415 //y=3.88 //x2=6.415 //y2=3.88
r625 (  43 125 ) resistor r=9.3 //w=0.17 //l=0.17 //layer=mcon //count=1 \
 //x=6.41 //y=4.88 //x2=6.41 //y2=4.88
r626 (  41 116 ) resistor r=9.3 //w=0.17 //l=0.17 //layer=mcon //count=1 \
 //x=6.41 //y=2.26 //x2=6.41 //y2=2.26
r627 (  39 75 ) resistor r=4.5 //w=0.15 //l=0.15 //layer=via1 //count=1 \
 //x=4.565 //y=3.885 //x2=4.565 //y2=3.885
r628 (  37 39 ) resistor r=0.00167112 //w=0.374 //l=0.005 //layer=m1 \
 //thickness=0.36 //x=4.615 //y=3.88 //x2=4.615 //y2=3.885
r629 (  35 203 ) resistor r=9.3 //w=0.17 //l=0.17 //layer=mcon //count=1 \
 //x=4.075 //y=1.19 //x2=4.075 //y2=1.19
r630 (  33 99 ) resistor r=9.3 //w=0.17 //l=0.17 //layer=mcon //count=1 \
 //x=3.78 //y=5.56 //x2=3.78 //y2=5.56
r631 (  30 91 ) resistor r=9.3 //w=0.17 //l=0.17 //layer=mcon //count=1 \
 //x=2.9 //y=5.56 //x2=2.9 //y2=5.56
r632 (  28 30 ) resistor r=0.121228 //w=0.232 //l=0.225 //layer=m1 \
 //thickness=0.36 //x=2.9 //y=5.335 //x2=2.9 //y2=5.56
r633 (  27 83 ) resistor r=9.3 //w=0.17 //l=0.17 //layer=mcon //count=1 \
 //x=2.02 //y=5.56 //x2=2.02 //y2=5.56
r634 (  25 27 ) resistor r=0.129608 //w=0.217 //l=0.225 //layer=m1 \
 //thickness=0.36 //x=2.022 //y=5.335 //x2=2.022 //y2=5.56
r635 (  24 53 ) resistor r=0.0760407 //w=0.238 //l=0.125 //layer=m1 \
 //thickness=0.36 //x=19.36 //y=4.755 //x2=19.36 //y2=4.88
r636 (  23 48 ) resistor r=0.0909648 //w=0.371 //l=0.186762 //layer=m1 \
 //thickness=0.36 //x=19.36 //y=4.04 //x2=19.302 //y2=3.88
r637 (  23 24 ) resistor r=0.682252 //w=0.131 //l=0.715 //layer=m1 \
 //thickness=0.36 //x=19.36 //y=4.04 //x2=19.36 //y2=4.755
r638 (  22 48 ) resistor r=0.0909648 //w=0.371 //l=0.186762 //layer=m1 \
 //thickness=0.36 //x=19.36 //y=3.72 //x2=19.302 //y2=3.88
r639 (  21 51 ) resistor r=0.0719237 //w=0.222 //l=0.115 //layer=m1 \
 //thickness=0.36 //x=19.36 //y=2.375 //x2=19.36 //y2=2.26
r640 (  21 22 ) resistor r=1.2834 //w=0.131 //l=1.345 //layer=m1 \
 //thickness=0.36 //x=19.36 //y=2.375 //x2=19.36 //y2=3.72
r641 (  20 43 ) resistor r=0.0760407 //w=0.238 //l=0.125 //layer=m1 \
 //thickness=0.36 //x=6.41 //y=4.755 //x2=6.41 //y2=4.88
r642 (  19 45 ) resistor r=0.0910802 //w=0.374 //l=0.185472 //layer=m1 \
 //thickness=0.36 //x=6.41 //y=4.04 //x2=6.465 //y2=3.88
r643 (  19 20 ) resistor r=0.682252 //w=0.131 //l=0.715 //layer=m1 \
 //thickness=0.36 //x=6.41 //y=4.04 //x2=6.41 //y2=4.755
r644 (  18 45 ) resistor r=0.0910802 //w=0.374 //l=0.185472 //layer=m1 \
 //thickness=0.36 //x=6.41 //y=3.72 //x2=6.465 //y2=3.88
r645 (  17 41 ) resistor r=0.0719237 //w=0.222 //l=0.115 //layer=m1 \
 //thickness=0.36 //x=6.41 //y=2.375 //x2=6.41 //y2=2.26
r646 (  17 18 ) resistor r=1.2834 //w=0.131 //l=1.345 //layer=m1 \
 //thickness=0.36 //x=6.41 //y=2.375 //x2=6.41 //y2=3.72
r647 (  15 39 ) resistor r=0.0910802 //w=0.374 //l=0.185472 //layer=m1 \
 //thickness=0.36 //x=4.56 //y=4.045 //x2=4.615 //y2=3.885
r648 (  15 16 ) resistor r=1.14981 //w=0.131 //l=1.205 //layer=m1 \
 //thickness=0.36 //x=4.56 //y=4.045 //x2=4.56 //y2=5.25
r649 (  14 37 ) resistor r=0.089409 //w=0.374 //l=0.180416 //layer=m1 \
 //thickness=0.36 //x=4.56 //y=3.725 //x2=4.615 //y2=3.88
r650 (  13 14 ) resistor r=1.71279 //w=0.131 //l=1.795 //layer=m1 \
 //thickness=0.36 //x=4.56 //y=1.93 //x2=4.56 //y2=3.725
r651 (  11 13 ) resistor r=0.0698411 //w=0.17 //l=0.120208 //layer=m1 \
 //thickness=0.36 //x=4.475 //y=1.845 //x2=4.56 //y2=1.93
r652 (  11 12 ) resistor r=0.300573 //w=0.131 //l=0.315 //layer=m1 \
 //thickness=0.36 //x=4.475 //y=1.845 //x2=4.16 //y2=1.845
r653 (  10 12 ) resistor r=0.0698411 //w=0.17 //l=0.120208 //layer=m1 \
 //thickness=0.36 //x=4.075 //y=1.76 //x2=4.16 //y2=1.845
r654 (  9 35 ) resistor r=0.0717383 //w=0.224 //l=0.115 //layer=m1 \
 //thickness=0.36 //x=4.075 //y=1.305 //x2=4.075 //y2=1.19
r655 (  9 10 ) resistor r=0.43416 //w=0.131 //l=0.455 //layer=m1 \
 //thickness=0.36 //x=4.075 //y=1.305 //x2=4.075 //y2=1.76
r656 (  8 31 ) resistor r=0.0675342 //w=0.23 //l=0.115 //layer=m1 \
 //thickness=0.36 //x=3.895 //y=5.335 //x2=3.78 //y2=5.335
r657 (  7 16 ) resistor r=0.0698411 //w=0.17 //l=0.120208 //layer=m1 \
 //thickness=0.36 //x=4.475 //y=5.335 //x2=4.56 //y2=5.25
r658 (  7 8 ) resistor r=0.553435 //w=0.131 //l=0.58 //layer=m1 \
 //thickness=0.36 //x=4.475 //y=5.335 //x2=3.895 //y2=5.335
r659 (  6 33 ) resistor r=0.00118313 //w=0.23 //layer=m1 //thickness=0.36 \
 //x=3.78 //y=5.56 //x2=3.78 //y2=5.56
r660 (  5 31 ) resistor r=0.002872 //w=0.34 //l=0.085 //layer=m1 \
 //thickness=0.36 //x=3.78 //y=5.42 //x2=3.78 //y2=5.335
r661 (  5 6 ) resistor r=0.091623 //w=0.191 //l=0.14 //layer=m1 \
 //thickness=0.36 //x=3.78 //y=5.42 //x2=3.78 //y2=5.56
r662 (  4 28 ) resistor r=0.0262263 //w=0.232 //l=0.12 //layer=m1 \
 //thickness=0.36 //x=3.02 //y=5.335 //x2=2.9 //y2=5.335
r663 (  3 31 ) resistor r=0.0675342 //w=0.23 //l=0.115 //layer=m1 \
 //thickness=0.36 //x=3.665 //y=5.335 //x2=3.78 //y2=5.335
r664 (  3 4 ) resistor r=0.615458 //w=0.131 //l=0.645 //layer=m1 \
 //thickness=0.36 //x=3.665 //y=5.335 //x2=3.02 //y2=5.335
r665 (  2 25 ) resistor r=0.0222262 //w=0.217 //l=0.118 //layer=m1 \
 //thickness=0.36 //x=2.14 //y=5.335 //x2=2.022 //y2=5.335
r666 (  1 28 ) resistor r=0.0262263 //w=0.232 //l=0.12 //layer=m1 \
 //thickness=0.36 //x=2.78 //y=5.335 //x2=2.9 //y2=5.335
r667 (  1 2 ) resistor r=0.610687 //w=0.131 //l=0.64 //layer=m1 \
 //thickness=0.36 //x=2.78 //y=5.335 //x2=2.14 //y2=5.335
ends PM_TMRDFFRNQX1\%noxref_3

subckt PM_TMRDFFRNQX1\%noxref_4 ( 1 2 3 4 6 7 8 9 11 14 15 17 18 19 20 22 23 \
 24 25 27 30 31 33 34 35 36 38 39 40 42 43 46 47 48 54 58 61 66 69 72 78 81 84 \
 87 95 99 101 104 105 108 112 117 119 121 123 125 126 127 128 130 136 145 146 \
 148 149 152 161 166 175 180 188 196 213 221 229 246 255 260 269 273 274 275 \
 276 277 278 279 280 281 282 283 284 285 286 287 288 289 291 297 298 299 300 \
 304 305 306 311 313 315 321 322 323 324 325 326 330 332 335 336 340 341 342 \
 347 349 351 357 358 368 369 372 386 390 391 394 402 403 406 407 408 409 410 \
 411 )
c823 ( 403 0 ) capacitor c=0.00885916f //x=21.645 //y=1.095
c824 ( 402 0 ) capacitor c=0.00885916f //x=16.835 //y=1.095
c825 ( 394 0 ) capacitor c=0.0366137f //x=24.94 //y=4.88
c826 ( 391 0 ) capacitor c=0.0297213f //x=24.91 //y=2.095
c827 ( 390 0 ) capacitor c=0.0488821f //x=24.91 //y=2.26
c828 ( 386 0 ) capacitor c=0.0642417f //x=24.17 //y=4.88
c829 ( 372 0 ) capacitor c=0.0354929f //x=11.99 //y=4.88
c830 ( 369 0 ) capacitor c=0.0284095f //x=11.96 //y=2.095
c831 ( 368 0 ) capacitor c=0.0476356f //x=11.96 //y=2.26
c832 ( 358 0 ) capacitor c=0.0441827f //x=25.475 //y=1.43
c833 ( 357 0 ) capacitor c=0.019833f //x=25.475 //y=1.085
c834 ( 351 0 ) capacitor c=0.0162526f //x=25.32 //y=1.585
c835 ( 349 0 ) capacitor c=0.0157807f //x=25.32 //y=0.93
c836 ( 347 0 ) capacitor c=0.0372668f //x=25.315 //y=4.97
c837 ( 342 0 ) capacitor c=0.0216374f //x=24.945 //y=1.74
c838 ( 341 0 ) capacitor c=0.0179909f //x=24.945 //y=1.43
c839 ( 340 0 ) capacitor c=0.0178631f //x=24.945 //y=1.085
c840 ( 336 0 ) capacitor c=0.0338883f //x=24.505 //y=1.39
c841 ( 335 0 ) capacitor c=0.0188688f //x=24.505 //y=1.045
c842 ( 332 0 ) capacitor c=0.0141821f //x=24.35 //y=1.545
c843 ( 330 0 ) capacitor c=0.0158553f //x=24.35 //y=0.89
c844 ( 326 0 ) capacitor c=0.0899055f //x=23.975 //y=2.095
c845 ( 325 0 ) capacitor c=0.0230625f //x=23.975 //y=1.7
c846 ( 324 0 ) capacitor c=0.0234359f //x=23.975 //y=1.39
c847 ( 323 0 ) capacitor c=0.0200755f //x=23.975 //y=1.045
c848 ( 322 0 ) capacitor c=0.0439708f //x=12.525 //y=1.43
c849 ( 321 0 ) capacitor c=0.0192582f //x=12.525 //y=1.085
c850 ( 315 0 ) capacitor c=0.0162526f //x=12.37 //y=1.585
c851 ( 313 0 ) capacitor c=0.0157807f //x=12.37 //y=0.93
c852 ( 311 0 ) capacitor c=0.0372668f //x=12.365 //y=4.97
c853 ( 306 0 ) capacitor c=0.0210762f //x=11.995 //y=1.74
c854 ( 305 0 ) capacitor c=0.0168511f //x=11.995 //y=1.43
c855 ( 304 0 ) capacitor c=0.0175485f //x=11.995 //y=1.085
c856 ( 300 0 ) capacitor c=0.0551642f //x=1.875 //y=4.97
c857 ( 299 0 ) capacitor c=0.0376642f //x=2.165 //y=4.97
c858 ( 298 0 ) capacitor c=0.0346489f //x=1.83 //y=1.4
c859 ( 297 0 ) capacitor c=0.018692f //x=1.83 //y=1.055
c860 ( 291 0 ) capacitor c=0.0137077f //x=1.675 //y=1.555
c861 ( 289 0 ) capacitor c=0.0158585f //x=1.675 //y=0.9
c862 ( 288 0 ) capacitor c=0.103534f //x=1.3 //y=2.095
c863 ( 287 0 ) capacitor c=0.0229444f //x=1.3 //y=1.71
c864 ( 286 0 ) capacitor c=0.0234359f //x=1.3 //y=1.4
c865 ( 285 0 ) capacitor c=0.019815f //x=1.3 //y=1.055
c866 ( 284 0 ) capacitor c=0.155269f //x=25.39 //y=6.2
c867 ( 283 0 ) capacitor c=0.116174f //x=24.95 //y=6.2
c868 ( 282 0 ) capacitor c=0.116167f //x=24.51 //y=6.2
c869 ( 281 0 ) capacitor c=0.154619f //x=24.07 //y=6.2
c870 ( 280 0 ) capacitor c=0.155269f //x=12.44 //y=6.2
c871 ( 279 0 ) capacitor c=0.110375f //x=12 //y=6.2
c872 ( 278 0 ) capacitor c=0.110208f //x=2.24 //y=6.2
c873 ( 277 0 ) capacitor c=0.158957f //x=1.8 //y=6.2
c874 ( 269 0 ) capacitor c=5.80994e-19 //x=24.94 //y=4.88
c875 ( 260 0 ) capacitor c=5.78095e-19 //x=24.91 //y=2.26
c876 ( 255 0 ) capacitor c=5.44848e-19 //x=24.17 //y=4.88
c877 ( 246 0 ) capacitor c=7.85889e-19 //x=24.17 //y=2.26
c878 ( 229 0 ) capacitor c=0.0292977f //x=21.54 //y=5.56
c879 ( 221 0 ) capacitor c=0.029137f //x=20.66 //y=5.56
c880 ( 213 0 ) capacitor c=0.0278099f //x=19.78 //y=5.56
c881 ( 196 0 ) capacitor c=0.0293124f //x=16.73 //y=5.56
c882 ( 188 0 ) capacitor c=0.029137f //x=15.85 //y=5.56
c883 ( 180 0 ) capacitor c=0.0277605f //x=14.97 //y=5.56
c884 ( 175 0 ) capacitor c=5.80994e-19 //x=11.99 //y=4.88
c885 ( 166 0 ) capacitor c=5.78095e-19 //x=11.96 //y=2.26
c886 ( 161 0 ) capacitor c=0.00120653f //x=1.6 //y=4.88
c887 ( 152 0 ) capacitor c=0.0012618f //x=1.6 //y=2.26
c888 ( 149 0 ) capacitor c=0.00473705f //x=24.74 //y=4.255
c889 ( 148 0 ) capacitor c=9.28285e-19 //x=24.9 //y=4.255
c890 ( 146 0 ) capacitor c=0.00101613f //x=24.335 //y=4.235
c891 ( 145 0 ) capacitor c=0.0246079f //x=24.015 //y=4.235
c892 ( 136 0 ) capacitor c=0.0109595f //x=1.76 //y=4.26
c893 ( 130 0 ) capacitor c=0.0377509f //x=22.49 //y=4.25
c894 ( 128 0 ) capacitor c=0.0202931f //x=19.22 //y=4.265
c895 ( 127 0 ) capacitor c=0.00207952f //x=19.565 //y=4.265
c896 ( 126 0 ) capacitor c=0.0480004f //x=12.125 //y=4.25
c897 ( 125 0 ) capacitor c=0.0489806f //x=17.355 //y=4.25
c898 ( 123 0 ) capacitor c=0.00158466f //x=6.63 //y=4.265
c899 ( 121 0 ) capacitor c=0.0162158f //x=6.03 //y=4.25
c900 ( 119 0 ) capacitor c=0.00487421f //x=4.815 //y=4.27
c901 ( 117 0 ) capacitor c=0.0681494f //x=4.175 //y=4.25
c902 ( 112 0 ) capacitor c=0.00504273f //x=24.91 //y=2.26
c903 ( 108 0 ) capacitor c=0.0135f //x=24.91 //y=4.25
c904 ( 105 0 ) capacitor c=0.00653918f //x=24.172 //y=4.74
c905 ( 104 0 ) capacitor c=0.0058774f //x=24.17 //y=4.88
c906 ( 101 0 ) capacitor c=0.00462953f //x=24.17 //y=2.26
c907 ( 99 0 ) capacitor c=0.0134849f //x=24.17 //y=4.25
c908 ( 95 0 ) capacitor c=0.016133f //x=22.32 //y=4.25
c909 ( 87 0 ) capacitor c=0.00101407f //x=21.54 //y=5.335
c910 ( 84 0 ) capacitor c=0.00809525f //x=20.66 //y=5.335
c911 ( 81 0 ) capacitor c=0.0109594f //x=19.782 //y=5.335
c912 ( 78 0 ) capacitor c=0.0151867f //x=17.51 //y=4.25
c913 ( 72 0 ) capacitor c=0.00112339f //x=16.73 //y=5.335
c914 ( 69 0 ) capacitor c=0.00744415f //x=15.85 //y=5.335
c915 ( 66 0 ) capacitor c=0.0112819f //x=14.972 //y=5.335
c916 ( 61 0 ) capacitor c=0.00504845f //x=11.96 //y=2.26
c917 ( 58 0 ) capacitor c=0.0141348f //x=11.96 //y=4.25
c918 ( 54 0 ) capacitor c=0.0160313f //x=1.6 //y=4.25
c919 ( 48 0 ) capacitor c=0.00890193f //x=24.91 //y=4.735
c920 ( 47 0 ) capacitor c=0.00923651f //x=24.91 //y=4.415
c921 ( 46 0 ) capacitor c=0.0371214f //x=24.91 //y=4.095
c922 ( 43 0 ) capacitor c=0.0117575f //x=24.17 //y=4.395
c923 ( 42 0 ) capacitor c=0.048579f //x=24.17 //y=4.075
c924 ( 40 0 ) capacitor c=0.0212366f //x=22.32 //y=5.25
c925 ( 39 0 ) capacitor c=0.0129353f //x=22.32 //y=4.395
c926 ( 38 0 ) capacitor c=0.0629501f //x=22.32 //y=4.075
c927 ( 36 0 ) capacitor c=0.0043645f //x=21.92 //y=1.845
c928 ( 35 0 ) capacitor c=0.0129971f //x=22.235 //y=1.845
c929 ( 34 0 ) capacitor c=0.0136149f //x=21.835 //y=1.76
c930 ( 33 0 ) capacitor c=0.0111648f //x=21.835 //y=1.305
c931 ( 31 0 ) capacitor c=0.0228869f //x=22.235 //y=5.335
c932 ( 30 0 ) capacitor c=0.00906713f //x=21.54 //y=5.56
c933 ( 27 0 ) capacitor c=0.019444f //x=21.425 //y=5.335
c934 ( 25 0 ) capacitor c=0.0151049f //x=20.54 //y=5.335
c935 ( 24 0 ) capacitor c=0.0222888f //x=17.51 //y=5.25
c936 ( 23 0 ) capacitor c=0.012762f //x=17.51 //y=4.415
c937 ( 22 0 ) capacitor c=0.0657923f //x=17.51 //y=4.095
c938 ( 20 0 ) capacitor c=0.00493487f //x=17.11 //y=1.845
c939 ( 19 0 ) capacitor c=0.0132593f //x=17.425 //y=1.845
c940 ( 18 0 ) capacitor c=0.0167333f //x=17.025 //y=1.76
c941 ( 17 0 ) capacitor c=0.0111392f //x=17.025 //y=1.305
c942 ( 15 0 ) capacitor c=0.0230009f //x=17.425 //y=5.335
c943 ( 14 0 ) capacitor c=0.00933983f //x=16.73 //y=5.56
c944 ( 11 0 ) capacitor c=0.019596f //x=16.615 //y=5.335
c945 ( 9 0 ) capacitor c=0.0147103f //x=15.73 //y=5.335
c946 ( 8 0 ) capacitor c=0.00917813f //x=11.96 //y=4.735
c947 ( 7 0 ) capacitor c=0.00994911f //x=11.96 //y=4.41
c948 ( 6 0 ) capacitor c=0.0355443f //x=11.96 //y=4.09
c949 ( 4 0 ) capacitor c=0.0226005f //x=1.6 //y=4.755
c950 ( 3 0 ) capacitor c=0.0130233f //x=1.6 //y=4.42
c951 ( 2 0 ) capacitor c=0.0864232f //x=1.6 //y=4.1
c952 ( 1 0 ) capacitor c=0.011342f //x=1.6 //y=2.375
r953 (  396 397 ) resistor r=32.4568 //w=0.214 //l=0.075 //layer=ply \
 //thickness=0.18 //x=24.94 //y=4.97 //x2=24.94 //y2=5.045
r954 (  394 396 ) resistor r=20.271 //w=0.214 //l=0.09 //layer=ply \
 //thickness=0.18 //x=24.94 //y=4.88 //x2=24.94 //y2=4.97
r955 (  390 391 ) resistor r=52.7279 //w=0.214 //l=0.165 //layer=ply \
 //thickness=0.18 //x=24.91 //y=2.26 //x2=24.91 //y2=2.095
r956 (  384 386 ) resistor r=20.6867 //w=0.233 //l=0.1 //layer=ply \
 //thickness=0.18 //x=24.07 //y=4.88 //x2=24.17 //y2=4.88
r957 (  374 375 ) resistor r=32.4568 //w=0.214 //l=0.075 //layer=ply \
 //thickness=0.18 //x=11.99 //y=4.97 //x2=11.99 //y2=5.045
r958 (  372 374 ) resistor r=20.271 //w=0.214 //l=0.09 //layer=ply \
 //thickness=0.18 //x=11.99 //y=4.88 //x2=11.99 //y2=4.97
r959 (  368 369 ) resistor r=52.7279 //w=0.214 //l=0.165 //layer=ply \
 //thickness=0.18 //x=11.96 //y=2.26 //x2=11.96 //y2=2.095
r960 (  358 401 ) resistor r=45.1352 //w=0.168 //l=0.173853 //layer=ply \
 //thickness=0.18 //x=25.475 //y=1.43 //x2=25.435 //y2=1.585
r961 (  357 400 ) resistor r=45.1352 //w=0.168 //l=0.173853 //layer=ply \
 //thickness=0.18 //x=25.475 //y=1.085 //x2=25.435 //y2=0.93
r962 (  357 358 ) resistor r=176.904 //w=0.094 //l=0.345 //layer=ply \
 //thickness=0.18 //x=25.475 //y=1.085 //x2=25.475 //y2=1.43
r963 (  352 399 ) resistor r=10.701 //w=0.21 //l=0.115 //layer=ply \
 //thickness=0.18 //x=25.1 //y=1.585 //x2=24.985 //y2=1.585
r964 (  351 401 ) resistor r=5.52526 //w=0.168 //l=0.115 //layer=ply \
 //thickness=0.18 //x=25.32 //y=1.585 //x2=25.435 //y2=1.585
r965 (  350 398 ) resistor r=5.52526 //w=0.168 //l=0.115 //layer=ply \
 //thickness=0.18 //x=25.1 //y=0.93 //x2=24.985 //y2=0.93
r966 (  349 400 ) resistor r=5.52526 //w=0.168 //l=0.115 //layer=ply \
 //thickness=0.18 //x=25.32 //y=0.93 //x2=25.435 //y2=0.93
r967 (  349 350 ) resistor r=112.809 //w=0.094 //l=0.22 //layer=ply \
 //thickness=0.18 //x=25.32 //y=0.93 //x2=25.1 //y2=0.93
r968 (  348 396 ) resistor r=16.5046 //w=0.27 //l=0.135 //layer=ply \
 //thickness=0.18 //x=25.075 //y=4.97 //x2=24.94 //y2=4.97
r969 (  347 354 ) resistor r=26.9307 //w=0.15 //l=0.106066 //layer=ply \
 //thickness=0.18 //x=25.315 //y=4.97 //x2=25.39 //y2=5.045
r970 (  347 348 ) resistor r=123.064 //w=0.094 //l=0.24 //layer=ply \
 //thickness=0.18 //x=25.315 //y=4.97 //x2=25.075 //y2=4.97
r971 (  342 399 ) resistor r=39.5823 //w=0.21 //l=0.173853 //layer=ply \
 //thickness=0.18 //x=24.945 //y=1.74 //x2=24.985 //y2=1.585
r972 (  342 391 ) resistor r=182.032 //w=0.094 //l=0.355 //layer=ply \
 //thickness=0.18 //x=24.945 //y=1.74 //x2=24.945 //y2=2.095
r973 (  341 399 ) resistor r=39.5823 //w=0.21 //l=0.173853 //layer=ply \
 //thickness=0.18 //x=24.945 //y=1.43 //x2=24.985 //y2=1.585
r974 (  340 398 ) resistor r=45.1352 //w=0.168 //l=0.173853 //layer=ply \
 //thickness=0.18 //x=24.945 //y=1.085 //x2=24.985 //y2=0.93
r975 (  340 341 ) resistor r=176.904 //w=0.094 //l=0.345 //layer=ply \
 //thickness=0.18 //x=24.945 //y=1.085 //x2=24.945 //y2=1.43
r976 (  337 386 ) resistor r=70.3348 //w=0.233 //l=0.414367 //layer=ply \
 //thickness=0.18 //x=24.51 //y=5.045 //x2=24.17 //y2=4.88
r977 (  336 388 ) resistor r=45.1352 //w=0.168 //l=0.173853 //layer=ply \
 //thickness=0.18 //x=24.505 //y=1.39 //x2=24.465 //y2=1.545
r978 (  335 387 ) resistor r=45.1352 //w=0.168 //l=0.173853 //layer=ply \
 //thickness=0.18 //x=24.505 //y=1.045 //x2=24.465 //y2=0.89
r979 (  335 336 ) resistor r=176.904 //w=0.094 //l=0.345 //layer=ply \
 //thickness=0.18 //x=24.505 //y=1.045 //x2=24.505 //y2=1.39
r980 (  333 383 ) resistor r=10.701 //w=0.21 //l=0.115 //layer=ply \
 //thickness=0.18 //x=24.13 //y=1.545 //x2=24.015 //y2=1.545
r981 (  332 388 ) resistor r=5.52526 //w=0.168 //l=0.115 //layer=ply \
 //thickness=0.18 //x=24.35 //y=1.545 //x2=24.465 //y2=1.545
r982 (  331 382 ) resistor r=5.52526 //w=0.168 //l=0.115 //layer=ply \
 //thickness=0.18 //x=24.13 //y=0.89 //x2=24.015 //y2=0.89
r983 (  330 387 ) resistor r=5.52526 //w=0.168 //l=0.115 //layer=ply \
 //thickness=0.18 //x=24.35 //y=0.89 //x2=24.465 //y2=0.89
r984 (  330 331 ) resistor r=112.809 //w=0.094 //l=0.22 //layer=ply \
 //thickness=0.18 //x=24.35 //y=0.89 //x2=24.13 //y2=0.89
r985 (  327 384 ) resistor r=13.0941 //w=0.233 //l=0.165 //layer=ply \
 //thickness=0.18 //x=24.07 //y=5.045 //x2=24.07 //y2=4.88
r986 (  326 381 ) resistor r=34.8111 //w=0.27 //l=0.264953 //layer=ply \
 //thickness=0.18 //x=23.975 //y=2.095 //x2=24.17 //y2=2.26
r987 (  325 383 ) resistor r=39.5823 //w=0.21 //l=0.173853 //layer=ply \
 //thickness=0.18 //x=23.975 //y=1.7 //x2=24.015 //y2=1.545
r988 (  325 326 ) resistor r=202.543 //w=0.094 //l=0.395 //layer=ply \
 //thickness=0.18 //x=23.975 //y=1.7 //x2=23.975 //y2=2.095
r989 (  324 383 ) resistor r=39.5823 //w=0.21 //l=0.173853 //layer=ply \
 //thickness=0.18 //x=23.975 //y=1.39 //x2=24.015 //y2=1.545
r990 (  323 382 ) resistor r=45.1352 //w=0.168 //l=0.173853 //layer=ply \
 //thickness=0.18 //x=23.975 //y=1.045 //x2=24.015 //y2=0.89
r991 (  323 324 ) resistor r=176.904 //w=0.094 //l=0.345 //layer=ply \
 //thickness=0.18 //x=23.975 //y=1.045 //x2=23.975 //y2=1.39
r992 (  322 379 ) resistor r=45.1352 //w=0.168 //l=0.173853 //layer=ply \
 //thickness=0.18 //x=12.525 //y=1.43 //x2=12.485 //y2=1.585
r993 (  321 378 ) resistor r=45.1352 //w=0.168 //l=0.173853 //layer=ply \
 //thickness=0.18 //x=12.525 //y=1.085 //x2=12.485 //y2=0.93
r994 (  321 322 ) resistor r=176.904 //w=0.094 //l=0.345 //layer=ply \
 //thickness=0.18 //x=12.525 //y=1.085 //x2=12.525 //y2=1.43
r995 (  316 377 ) resistor r=10.701 //w=0.21 //l=0.115 //layer=ply \
 //thickness=0.18 //x=12.15 //y=1.585 //x2=12.035 //y2=1.585
r996 (  315 379 ) resistor r=5.52526 //w=0.168 //l=0.115 //layer=ply \
 //thickness=0.18 //x=12.37 //y=1.585 //x2=12.485 //y2=1.585
r997 (  314 376 ) resistor r=5.52526 //w=0.168 //l=0.115 //layer=ply \
 //thickness=0.18 //x=12.15 //y=0.93 //x2=12.035 //y2=0.93
r998 (  313 378 ) resistor r=5.52526 //w=0.168 //l=0.115 //layer=ply \
 //thickness=0.18 //x=12.37 //y=0.93 //x2=12.485 //y2=0.93
r999 (  313 314 ) resistor r=112.809 //w=0.094 //l=0.22 //layer=ply \
 //thickness=0.18 //x=12.37 //y=0.93 //x2=12.15 //y2=0.93
r1000 (  312 374 ) resistor r=16.5046 //w=0.27 //l=0.135 //layer=ply \
 //thickness=0.18 //x=12.125 //y=4.97 //x2=11.99 //y2=4.97
r1001 (  311 318 ) resistor r=26.9307 //w=0.15 //l=0.106066 //layer=ply \
 //thickness=0.18 //x=12.365 //y=4.97 //x2=12.44 //y2=5.045
r1002 (  311 312 ) resistor r=123.064 //w=0.094 //l=0.24 //layer=ply \
 //thickness=0.18 //x=12.365 //y=4.97 //x2=12.125 //y2=4.97
r1003 (  306 377 ) resistor r=39.5823 //w=0.21 //l=0.173853 //layer=ply \
 //thickness=0.18 //x=11.995 //y=1.74 //x2=12.035 //y2=1.585
r1004 (  306 369 ) resistor r=182.032 //w=0.094 //l=0.355 //layer=ply \
 //thickness=0.18 //x=11.995 //y=1.74 //x2=11.995 //y2=2.095
r1005 (  305 377 ) resistor r=39.5823 //w=0.21 //l=0.173853 //layer=ply \
 //thickness=0.18 //x=11.995 //y=1.43 //x2=12.035 //y2=1.585
r1006 (  304 376 ) resistor r=45.1352 //w=0.168 //l=0.173853 //layer=ply \
 //thickness=0.18 //x=11.995 //y=1.085 //x2=12.035 //y2=0.93
r1007 (  304 305 ) resistor r=176.904 //w=0.094 //l=0.345 //layer=ply \
 //thickness=0.18 //x=11.995 //y=1.085 //x2=11.995 //y2=1.43
r1008 (  299 301 ) resistor r=26.9307 //w=0.15 //l=0.106066 //layer=ply \
 //thickness=0.18 //x=2.165 //y=4.97 //x2=2.24 //y2=5.045
r1009 (  299 300 ) resistor r=148.702 //w=0.094 //l=0.29 //layer=ply \
 //thickness=0.18 //x=2.165 //y=4.97 //x2=1.875 //y2=4.97
r1010 (  298 366 ) resistor r=45.1352 //w=0.168 //l=0.173853 //layer=ply \
 //thickness=0.18 //x=1.83 //y=1.4 //x2=1.79 //y2=1.555
r1011 (  297 365 ) resistor r=45.1352 //w=0.168 //l=0.173853 //layer=ply \
 //thickness=0.18 //x=1.83 //y=1.055 //x2=1.79 //y2=0.9
r1012 (  297 298 ) resistor r=176.904 //w=0.094 //l=0.345 //layer=ply \
 //thickness=0.18 //x=1.83 //y=1.055 //x2=1.83 //y2=1.4
r1013 (  294 300 ) resistor r=22.7971 //w=0.269 //l=0.106066 //layer=ply \
 //thickness=0.18 //x=1.8 //y=5.045 //x2=1.875 //y2=4.97
r1014 (  294 364 ) resistor r=35.8364 //w=0.269 //l=0.270185 //layer=ply \
 //thickness=0.18 //x=1.8 //y=5.045 //x2=1.6 //y2=4.88
r1015 (  292 360 ) resistor r=10.701 //w=0.21 //l=0.115 //layer=ply \
 //thickness=0.18 //x=1.455 //y=1.555 //x2=1.34 //y2=1.555
r1016 (  291 366 ) resistor r=5.52526 //w=0.168 //l=0.115 //layer=ply \
 //thickness=0.18 //x=1.675 //y=1.555 //x2=1.79 //y2=1.555
r1017 (  290 359 ) resistor r=5.52526 //w=0.168 //l=0.115 //layer=ply \
 //thickness=0.18 //x=1.455 //y=0.9 //x2=1.34 //y2=0.9
r1018 (  289 365 ) resistor r=5.52526 //w=0.168 //l=0.115 //layer=ply \
 //thickness=0.18 //x=1.675 //y=0.9 //x2=1.79 //y2=0.9
r1019 (  289 290 ) resistor r=112.809 //w=0.094 //l=0.22 //layer=ply \
 //thickness=0.18 //x=1.675 //y=0.9 //x2=1.455 //y2=0.9
r1020 (  288 362 ) resistor r=58.7805 //w=0.246 //l=0.373497 //layer=ply \
 //thickness=0.18 //x=1.3 //y=2.095 //x2=1.6 //y2=2.26
r1021 (  287 360 ) resistor r=39.5823 //w=0.21 //l=0.173853 //layer=ply \
 //thickness=0.18 //x=1.3 //y=1.71 //x2=1.34 //y2=1.555
r1022 (  287 288 ) resistor r=197.415 //w=0.094 //l=0.385 //layer=ply \
 //thickness=0.18 //x=1.3 //y=1.71 //x2=1.3 //y2=2.095
r1023 (  286 360 ) resistor r=39.5823 //w=0.21 //l=0.173853 //layer=ply \
 //thickness=0.18 //x=1.3 //y=1.4 //x2=1.34 //y2=1.555
r1024 (  285 359 ) resistor r=45.1352 //w=0.168 //l=0.173853 //layer=ply \
 //thickness=0.18 //x=1.3 //y=1.055 //x2=1.34 //y2=0.9
r1025 (  285 286 ) resistor r=176.904 //w=0.094 //l=0.345 //layer=ply \
 //thickness=0.18 //x=1.3 //y=1.055 //x2=1.3 //y2=1.4
r1026 (  284 354 ) resistor r=592.245 //w=0.094 //l=1.155 //layer=ply \
 //thickness=0.18 //x=25.39 //y=6.2 //x2=25.39 //y2=5.045
r1027 (  283 397 ) resistor r=592.245 //w=0.094 //l=1.155 //layer=ply \
 //thickness=0.18 //x=24.95 //y=6.2 //x2=24.95 //y2=5.045
r1028 (  282 337 ) resistor r=592.245 //w=0.094 //l=1.155 //layer=ply \
 //thickness=0.18 //x=24.51 //y=6.2 //x2=24.51 //y2=5.045
r1029 (  281 327 ) resistor r=592.245 //w=0.094 //l=1.155 //layer=ply \
 //thickness=0.18 //x=24.07 //y=6.2 //x2=24.07 //y2=5.045
r1030 (  280 318 ) resistor r=592.245 //w=0.094 //l=1.155 //layer=ply \
 //thickness=0.18 //x=12.44 //y=6.2 //x2=12.44 //y2=5.045
r1031 (  279 375 ) resistor r=592.245 //w=0.094 //l=1.155 //layer=ply \
 //thickness=0.18 //x=12 //y=6.2 //x2=12 //y2=5.045
r1032 (  278 301 ) resistor r=592.245 //w=0.094 //l=1.155 //layer=ply \
 //thickness=0.18 //x=2.24 //y=6.2 //x2=2.24 //y2=5.045
r1033 (  277 294 ) resistor r=592.245 //w=0.094 //l=1.155 //layer=ply \
 //thickness=0.18 //x=1.8 //y=6.2 //x2=1.8 //y2=5.045
r1034 (  276 351 ) resistor r=56.4043 //w=0.094 //l=0.11 //layer=ply \
 //thickness=0.18 //x=25.21 //y=1.585 //x2=25.32 //y2=1.585
r1035 (  276 352 ) resistor r=56.4043 //w=0.094 //l=0.11 //layer=ply \
 //thickness=0.18 //x=25.21 //y=1.585 //x2=25.1 //y2=1.585
r1036 (  275 332 ) resistor r=56.4043 //w=0.094 //l=0.11 //layer=ply \
 //thickness=0.18 //x=24.24 //y=1.545 //x2=24.35 //y2=1.545
r1037 (  275 333 ) resistor r=56.4043 //w=0.094 //l=0.11 //layer=ply \
 //thickness=0.18 //x=24.24 //y=1.545 //x2=24.13 //y2=1.545
r1038 (  274 315 ) resistor r=56.4043 //w=0.094 //l=0.11 //layer=ply \
 //thickness=0.18 //x=12.26 //y=1.585 //x2=12.37 //y2=1.585
r1039 (  274 316 ) resistor r=56.4043 //w=0.094 //l=0.11 //layer=ply \
 //thickness=0.18 //x=12.26 //y=1.585 //x2=12.15 //y2=1.585
r1040 (  273 291 ) resistor r=56.4043 //w=0.094 //l=0.11 //layer=ply \
 //thickness=0.18 //x=1.565 //y=1.555 //x2=1.675 //y2=1.555
r1041 (  273 292 ) resistor r=56.4043 //w=0.094 //l=0.11 //layer=ply \
 //thickness=0.18 //x=1.565 //y=1.555 //x2=1.455 //y2=1.555
r1042 (  269 394 ) resistor r=152 //w=0.17 //l=0.17 //layer=licon //count=1 \
 //x=24.94 //y=4.88 //x2=24.94 //y2=4.88
r1043 (  260 390 ) resistor r=152 //w=0.17 //l=0.17 //layer=licon //count=1 \
 //x=24.91 //y=2.26 //x2=24.91 //y2=2.26
r1044 (  255 386 ) resistor r=152 //w=0.17 //l=0.17 //layer=licon //count=1 \
 //x=24.17 //y=4.88 //x2=24.17 //y2=4.88
r1045 (  246 381 ) resistor r=152 //w=0.17 //l=0.17 //layer=licon //count=1 \
 //x=24.17 //y=2.26 //x2=24.17 //y2=2.26
r1046 (  229 411 ) resistor r=23.615 //w=0.187 //l=0.345 //layer=li \
 //thickness=0.1 //x=21.54 //y=5.56 //x2=21.54 //y2=5.905
r1047 (  221 410 ) resistor r=23.615 //w=0.187 //l=0.345 //layer=li \
 //thickness=0.1 //x=20.66 //y=5.56 //x2=20.66 //y2=5.905
r1048 (  213 409 ) resistor r=23.615 //w=0.187 //l=0.345 //layer=li \
 //thickness=0.1 //x=19.78 //y=5.56 //x2=19.78 //y2=5.905
r1049 (  196 408 ) resistor r=23.615 //w=0.187 //l=0.345 //layer=li \
 //thickness=0.1 //x=16.73 //y=5.56 //x2=16.73 //y2=5.905
r1050 (  188 407 ) resistor r=23.615 //w=0.187 //l=0.345 //layer=li \
 //thickness=0.1 //x=15.85 //y=5.56 //x2=15.85 //y2=5.905
r1051 (  180 406 ) resistor r=23.615 //w=0.187 //l=0.345 //layer=li \
 //thickness=0.1 //x=14.97 //y=5.56 //x2=14.97 //y2=5.905
r1052 (  175 372 ) resistor r=152 //w=0.17 //l=0.17 //layer=licon //count=1 \
 //x=11.99 //y=4.88 //x2=11.99 //y2=4.88
r1053 (  166 368 ) resistor r=152 //w=0.17 //l=0.17 //layer=licon //count=1 \
 //x=11.96 //y=2.26 //x2=11.96 //y2=2.26
r1054 (  161 364 ) resistor r=152 //w=0.17 //l=0.17 //layer=licon //count=1 \
 //x=1.6 //y=4.88 //x2=1.6 //y2=4.88
r1055 (  152 362 ) resistor r=152 //w=0.17 //l=0.17 //layer=licon //count=1 \
 //x=1.6 //y=2.26 //x2=1.6 //y2=2.26
r1056 (  148 149 ) resistor r=0.10734 //w=0.281 //l=0.16 //layer=m2 \
 //thickness=0.36 //x=24.9 //y=4.255 //x2=24.74 //y2=4.255
r1057 (  146 149 ) resistor r=0.38645 //w=0.131 //l=0.405 //layer=m2 \
 //thickness=0.36 //x=24.335 //y=4.25 //x2=24.74 //y2=4.25
r1058 (  144 146 ) resistor r=0.10734 //w=0.281 //l=0.16 //layer=m2 \
 //thickness=0.36 //x=24.175 //y=4.235 //x2=24.335 //y2=4.235
r1059 (  144 145 ) resistor r=0.10734 //w=0.281 //l=0.16 //layer=m2 \
 //thickness=0.36 //x=24.175 //y=4.235 //x2=24.015 //y2=4.235
r1060 (  134 136 ) resistor r=0.10734 //w=0.281 //l=0.16 //layer=m2 \
 //thickness=0.36 //x=1.6 //y=4.26 //x2=1.76 //y2=4.26
r1061 (  130 142 ) resistor r=0.108234 //w=0.187 //l=0.167332 //layer=m2 \
 //thickness=0.36 //x=22.49 //y=4.25 //x2=22.33 //y2=4.235
r1062 (  130 145 ) resistor r=1.45515 //w=0.131 //l=1.525 //layer=m2 \
 //thickness=0.36 //x=22.49 //y=4.25 //x2=24.015 //y2=4.25
r1063 (  128 140 ) resistor r=1.08991 //w=0.196 //l=1.70999 //layer=m2 \
 //thickness=0.36 //x=19.22 //y=4.265 //x2=17.515 //y2=4.255
r1064 (  127 142 ) resistor r=1.84954 //w=0.187 //l=2.77996 //layer=m2 \
 //thickness=0.36 //x=19.565 //y=4.265 //x2=22.33 //y2=4.235
r1065 (  127 128 ) resistor r=0.329198 //w=0.131 //l=0.345 //layer=m2 \
 //thickness=0.36 //x=19.565 //y=4.265 //x2=19.22 //y2=4.265
r1066 (  126 138 ) resistor r=0.112172 //w=0.179 //l=0.16 //layer=m2 \
 //thickness=0.36 //x=12.125 //y=4.25 //x2=11.965 //y2=4.25
r1067 (  125 140 ) resistor r=0.104578 //w=0.196 //l=0.162481 //layer=m2 \
 //thickness=0.36 //x=17.355 //y=4.25 //x2=17.515 //y2=4.255
r1068 (  125 126 ) resistor r=4.99046 //w=0.131 //l=5.23 //layer=m2 \
 //thickness=0.36 //x=17.355 //y=4.25 //x2=12.125 //y2=4.25
r1069 (  123 138 ) resistor r=3.726 //w=0.179 //l=5.34249 //layer=m2 \
 //thickness=0.36 //x=6.63 //y=4.265 //x2=11.965 //y2=4.25
r1070 (  123 124 ) resistor r=0.329198 //w=0.131 //l=0.345 //layer=m2 \
 //thickness=0.36 //x=6.63 //y=4.265 //x2=6.285 //y2=4.265
r1071 (  121 124 ) resistor r=0.1875 //w=0.17 //l=0.262393 //layer=m2 \
 //thickness=0.36 //x=6.03 //y=4.25 //x2=6.285 //y2=4.265
r1072 (  121 122 ) resistor r=0.997137 //w=0.131 //l=1.045 //layer=m2 \
 //thickness=0.36 //x=6.03 //y=4.25 //x2=4.985 //y2=4.25
r1073 (  119 122 ) resistor r=0.125 //w=0.17 //l=0.179722 //layer=m2 \
 //thickness=0.36 //x=4.815 //y=4.27 //x2=4.985 //y2=4.25
r1074 (  119 120 ) resistor r=0.367366 //w=0.131 //l=0.385 //layer=m2 \
 //thickness=0.36 //x=4.815 //y=4.27 //x2=4.43 //y2=4.27
r1075 (  117 120 ) resistor r=0.1875 //w=0.17 //l=0.264811 //layer=m2 \
 //thickness=0.36 //x=4.175 //y=4.25 //x2=4.43 //y2=4.27
r1076 (  117 136 ) resistor r=2.30439 //w=0.131 //l=2.415 //layer=m2 \
 //thickness=0.36 //x=4.175 //y=4.25 //x2=1.76 //y2=4.25
r1077 (  116 269 ) resistor r=9.3 //w=0.17 //l=0.17 //layer=mcon //count=1 \
 //x=24.94 //y=4.88 //x2=24.94 //y2=4.88
r1078 (  112 260 ) resistor r=9.3 //w=0.17 //l=0.17 //layer=mcon //count=1 \
 //x=24.91 //y=2.26 //x2=24.91 //y2=2.26
r1079 (  112 114 ) resistor r=0.0936408 //w=0.196 //l=0.125 //layer=m1 \
 //thickness=0.36 //x=24.912 //y=2.26 //x2=24.912 //y2=2.385
r1080 (  110 148 ) resistor r=4.5 //w=0.15 //l=0.15 //layer=via1 //count=1 \
 //x=24.9 //y=4.255 //x2=24.9 //y2=4.255
r1081 (  108 110 ) resistor r=0.00168464 //w=0.371 //l=0.005 //layer=m1 \
 //thickness=0.36 //x=24.852 //y=4.25 //x2=24.852 //y2=4.255
r1082 (  104 255 ) resistor r=9.3 //w=0.17 //l=0.17 //layer=mcon //count=1 \
 //x=24.17 //y=4.88 //x2=24.17 //y2=4.88
r1083 (  104 105 ) resistor r=0.103207 //w=0.196 //l=0.14 //layer=m1 \
 //thickness=0.36 //x=24.172 //y=4.88 //x2=24.172 //y2=4.74
r1084 (  101 246 ) resistor r=9.3 //w=0.17 //l=0.17 //layer=mcon //count=1 \
 //x=24.17 //y=2.26 //x2=24.17 //y2=2.26
r1085 (  97 144 ) resistor r=4.5 //w=0.15 //l=0.15 //layer=via1 //count=1 \
 //x=24.175 //y=4.235 //x2=24.175 //y2=4.235
r1086 (  97 99 ) resistor r=0.00494723 //w=0.379 //l=0.015 //layer=m1 \
 //thickness=0.36 //x=24.12 //y=4.235 //x2=24.12 //y2=4.25
r1087 (  93 142 ) resistor r=4.5 //w=0.15 //l=0.15 //layer=via1 //count=1 \
 //x=22.33 //y=4.235 //x2=22.33 //y2=4.235
r1088 (  93 95 ) resistor r=0.00505391 //w=0.371 //l=0.015 //layer=m1 \
 //thickness=0.36 //x=22.377 //y=4.235 //x2=22.377 //y2=4.25
r1089 (  91 403 ) resistor r=9.3 //w=0.17 //l=0.17 //layer=mcon //count=1 \
 //x=21.835 //y=1.19 //x2=21.835 //y2=1.19
r1090 (  89 229 ) resistor r=9.3 //w=0.17 //l=0.17 //layer=mcon //count=1 \
 //x=21.54 //y=5.56 //x2=21.54 //y2=5.56
r1091 (  86 221 ) resistor r=9.3 //w=0.17 //l=0.17 //layer=mcon //count=1 \
 //x=20.66 //y=5.56 //x2=20.66 //y2=5.56
r1092 (  84 86 ) resistor r=0.121228 //w=0.232 //l=0.225 //layer=m1 \
 //thickness=0.36 //x=20.66 //y=5.335 //x2=20.66 //y2=5.56
r1093 (  83 213 ) resistor r=9.3 //w=0.17 //l=0.17 //layer=mcon //count=1 \
 //x=19.78 //y=5.56 //x2=19.78 //y2=5.56
r1094 (  81 83 ) resistor r=0.129608 //w=0.217 //l=0.225 //layer=m1 \
 //thickness=0.36 //x=19.782 //y=5.335 //x2=19.782 //y2=5.56
r1095 (  80 140 ) resistor r=4.5 //w=0.15 //l=0.15 //layer=via1 //count=1 \
 //x=17.515 //y=4.255 //x2=17.515 //y2=4.255
r1096 (  78 80 ) resistor r=0.00164908 //w=0.379 //l=0.005 //layer=m1 \
 //thickness=0.36 //x=17.46 //y=4.25 //x2=17.46 //y2=4.255
r1097 (  76 402 ) resistor r=9.3 //w=0.17 //l=0.17 //layer=mcon //count=1 \
 //x=17.025 //y=1.19 //x2=17.025 //y2=1.19
r1098 (  74 196 ) resistor r=9.3 //w=0.17 //l=0.17 //layer=mcon //count=1 \
 //x=16.73 //y=5.56 //x2=16.73 //y2=5.56
r1099 (  71 188 ) resistor r=9.3 //w=0.17 //l=0.17 //layer=mcon //count=1 \
 //x=15.85 //y=5.56 //x2=15.85 //y2=5.56
r1100 (  69 71 ) resistor r=0.121228 //w=0.232 //l=0.225 //layer=m1 \
 //thickness=0.36 //x=15.85 //y=5.335 //x2=15.85 //y2=5.56
r1101 (  68 180 ) resistor r=9.3 //w=0.17 //l=0.17 //layer=mcon //count=1 \
 //x=14.97 //y=5.56 //x2=14.97 //y2=5.56
r1102 (  66 68 ) resistor r=0.129608 //w=0.217 //l=0.225 //layer=m1 \
 //thickness=0.36 //x=14.972 //y=5.335 //x2=14.972 //y2=5.56
r1103 (  65 175 ) resistor r=9.3 //w=0.17 //l=0.17 //layer=mcon //count=1 \
 //x=11.99 //y=4.88 //x2=11.99 //y2=4.88
r1104 (  61 166 ) resistor r=9.3 //w=0.17 //l=0.17 //layer=mcon //count=1 \
 //x=11.96 //y=2.26 //x2=11.96 //y2=2.26
r1105 (  61 63 ) resistor r=0.0936408 //w=0.196 //l=0.125 //layer=m1 \
 //thickness=0.36 //x=11.962 //y=2.26 //x2=11.962 //y2=2.385
r1106 (  58 138 ) resistor r=4.5 //w=0.15 //l=0.15 //layer=via1 //count=1 \
 //x=11.965 //y=4.25 //x2=11.965 //y2=4.25
r1107 (  56 134 ) resistor r=4.5 //w=0.15 //l=0.15 //layer=via1 //count=1 \
 //x=1.6 //y=4.26 //x2=1.6 //y2=4.26
r1108 (  54 56 ) resistor r=0.00332447 //w=0.376 //l=0.01 //layer=m1 \
 //thickness=0.36 //x=1.652 //y=4.25 //x2=1.652 //y2=4.26
r1109 (  52 161 ) resistor r=9.3 //w=0.17 //l=0.17 //layer=mcon //count=1 \
 //x=1.6 //y=4.88 //x2=1.6 //y2=4.88
r1110 (  50 152 ) resistor r=9.3 //w=0.17 //l=0.17 //layer=mcon //count=1 \
 //x=1.6 //y=2.26 //x2=1.6 //y2=2.26
r1111 (  48 116 ) resistor r=0.0878548 //w=0.228 //l=0.159295 //layer=m1 \
 //thickness=0.36 //x=24.91 //y=4.735 //x2=24.94 //y2=4.88
r1112 (  47 110 ) resistor r=0.0909648 //w=0.371 //l=0.186762 //layer=m1 \
 //thickness=0.36 //x=24.91 //y=4.415 //x2=24.852 //y2=4.255
r1113 (  47 48 ) resistor r=0.305344 //w=0.131 //l=0.32 //layer=m1 \
 //thickness=0.36 //x=24.91 //y=4.415 //x2=24.91 //y2=4.735
r1114 (  46 108 ) resistor r=0.0892801 //w=0.371 //l=0.1817 //layer=m1 \
 //thickness=0.36 //x=24.91 //y=4.095 //x2=24.852 //y2=4.25
r1115 (  46 114 ) resistor r=1.63168 //w=0.131 //l=1.71 //layer=m1 \
 //thickness=0.36 //x=24.91 //y=4.095 //x2=24.91 //y2=2.385
r1116 (  43 99 ) resistor r=0.0863342 //w=0.379 //l=0.168152 //layer=m1 \
 //thickness=0.36 //x=24.17 //y=4.395 //x2=24.12 //y2=4.25
r1117 (  43 105 ) resistor r=0.329198 //w=0.131 //l=0.345 //layer=m1 \
 //thickness=0.36 //x=24.17 //y=4.395 //x2=24.17 //y2=4.74
r1118 (  42 97 ) resistor r=0.0912814 //w=0.379 //l=0.183303 //layer=m1 \
 //thickness=0.36 //x=24.17 //y=4.075 //x2=24.12 //y2=4.235
r1119 (  41 101 ) resistor r=0.0933015 //w=0.201 //l=0.125 //layer=m1 \
 //thickness=0.36 //x=24.17 //y=2.385 //x2=24.17 //y2=2.26
r1120 (  41 42 ) resistor r=1.6126 //w=0.131 //l=1.69 //layer=m1 \
 //thickness=0.36 //x=24.17 //y=2.385 //x2=24.17 //y2=4.075
r1121 (  39 95 ) resistor r=0.0859108 //w=0.371 //l=0.171143 //layer=m1 \
 //thickness=0.36 //x=22.32 //y=4.395 //x2=22.377 //y2=4.25
r1122 (  39 40 ) resistor r=0.81584 //w=0.131 //l=0.855 //layer=m1 \
 //thickness=0.36 //x=22.32 //y=4.395 //x2=22.32 //y2=5.25
r1123 (  38 93 ) resistor r=0.0909648 //w=0.371 //l=0.186333 //layer=m1 \
 //thickness=0.36 //x=22.32 //y=4.075 //x2=22.377 //y2=4.235
r1124 (  37 38 ) resistor r=2.04676 //w=0.131 //l=2.145 //layer=m1 \
 //thickness=0.36 //x=22.32 //y=1.93 //x2=22.32 //y2=4.075
r1125 (  35 37 ) resistor r=0.0698411 //w=0.17 //l=0.120208 //layer=m1 \
 //thickness=0.36 //x=22.235 //y=1.845 //x2=22.32 //y2=1.93
r1126 (  35 36 ) resistor r=0.300573 //w=0.131 //l=0.315 //layer=m1 \
 //thickness=0.36 //x=22.235 //y=1.845 //x2=21.92 //y2=1.845
r1127 (  34 36 ) resistor r=0.0698411 //w=0.17 //l=0.120208 //layer=m1 \
 //thickness=0.36 //x=21.835 //y=1.76 //x2=21.92 //y2=1.845
r1128 (  33 91 ) resistor r=0.0717383 //w=0.224 //l=0.115 //layer=m1 \
 //thickness=0.36 //x=21.835 //y=1.305 //x2=21.835 //y2=1.19
r1129 (  33 34 ) resistor r=0.43416 //w=0.131 //l=0.455 //layer=m1 \
 //thickness=0.36 //x=21.835 //y=1.305 //x2=21.835 //y2=1.76
r1130 (  32 87 ) resistor r=0.0675342 //w=0.23 //l=0.115 //layer=m1 \
 //thickness=0.36 //x=21.655 //y=5.335 //x2=21.54 //y2=5.335
r1131 (  31 40 ) resistor r=0.0698411 //w=0.17 //l=0.120208 //layer=m1 \
 //thickness=0.36 //x=22.235 //y=5.335 //x2=22.32 //y2=5.25
r1132 (  31 32 ) resistor r=0.553435 //w=0.131 //l=0.58 //layer=m1 \
 //thickness=0.36 //x=22.235 //y=5.335 //x2=21.655 //y2=5.335
r1133 (  30 89 ) resistor r=0.00118313 //w=0.23 //layer=m1 //thickness=0.36 \
 //x=21.54 //y=5.56 //x2=21.54 //y2=5.56
r1134 (  29 87 ) resistor r=0.002872 //w=0.34 //l=0.085 //layer=m1 \
 //thickness=0.36 //x=21.54 //y=5.42 //x2=21.54 //y2=5.335
r1135 (  29 30 ) resistor r=0.091623 //w=0.191 //l=0.14 //layer=m1 \
 //thickness=0.36 //x=21.54 //y=5.42 //x2=21.54 //y2=5.56
r1136 (  28 84 ) resistor r=0.0262263 //w=0.232 //l=0.12 //layer=m1 \
 //thickness=0.36 //x=20.78 //y=5.335 //x2=20.66 //y2=5.335
r1137 (  27 87 ) resistor r=0.0675342 //w=0.23 //l=0.115 //layer=m1 \
 //thickness=0.36 //x=21.425 //y=5.335 //x2=21.54 //y2=5.335
r1138 (  27 28 ) resistor r=0.615458 //w=0.131 //l=0.645 //layer=m1 \
 //thickness=0.36 //x=21.425 //y=5.335 //x2=20.78 //y2=5.335
r1139 (  26 81 ) resistor r=0.0222262 //w=0.217 //l=0.118 //layer=m1 \
 //thickness=0.36 //x=19.9 //y=5.335 //x2=19.782 //y2=5.335
r1140 (  25 84 ) resistor r=0.0262263 //w=0.232 //l=0.12 //layer=m1 \
 //thickness=0.36 //x=20.54 //y=5.335 //x2=20.66 //y2=5.335
r1141 (  25 26 ) resistor r=0.610687 //w=0.131 //l=0.64 //layer=m1 \
 //thickness=0.36 //x=20.54 //y=5.335 //x2=19.9 //y2=5.335
r1142 (  23 80 ) resistor r=0.0912814 //w=0.379 //l=0.183303 //layer=m1 \
 //thickness=0.36 //x=17.51 //y=4.415 //x2=17.46 //y2=4.255
r1143 (  23 24 ) resistor r=0.796756 //w=0.131 //l=0.835 //layer=m1 \
 //thickness=0.36 //x=17.51 //y=4.415 //x2=17.51 //y2=5.25
r1144 (  22 78 ) resistor r=0.0896323 //w=0.379 //l=0.178255 //layer=m1 \
 //thickness=0.36 //x=17.51 //y=4.095 //x2=17.46 //y2=4.25
r1145 (  21 22 ) resistor r=2.06584 //w=0.131 //l=2.165 //layer=m1 \
 //thickness=0.36 //x=17.51 //y=1.93 //x2=17.51 //y2=4.095
r1146 (  19 21 ) resistor r=0.0698411 //w=0.17 //l=0.120208 //layer=m1 \
 //thickness=0.36 //x=17.425 //y=1.845 //x2=17.51 //y2=1.93
r1147 (  19 20 ) resistor r=0.300573 //w=0.131 //l=0.315 //layer=m1 \
 //thickness=0.36 //x=17.425 //y=1.845 //x2=17.11 //y2=1.845
r1148 (  18 20 ) resistor r=0.0698411 //w=0.17 //l=0.120208 //layer=m1 \
 //thickness=0.36 //x=17.025 //y=1.76 //x2=17.11 //y2=1.845
r1149 (  17 76 ) resistor r=0.0717383 //w=0.224 //l=0.115 //layer=m1 \
 //thickness=0.36 //x=17.025 //y=1.305 //x2=17.025 //y2=1.19
r1150 (  17 18 ) resistor r=0.43416 //w=0.131 //l=0.455 //layer=m1 \
 //thickness=0.36 //x=17.025 //y=1.305 //x2=17.025 //y2=1.76
r1151 (  16 72 ) resistor r=0.0675342 //w=0.23 //l=0.115 //layer=m1 \
 //thickness=0.36 //x=16.845 //y=5.335 //x2=16.73 //y2=5.335
r1152 (  15 24 ) resistor r=0.0698411 //w=0.17 //l=0.120208 //layer=m1 \
 //thickness=0.36 //x=17.425 //y=5.335 //x2=17.51 //y2=5.25
r1153 (  15 16 ) resistor r=0.553435 //w=0.131 //l=0.58 //layer=m1 \
 //thickness=0.36 //x=17.425 //y=5.335 //x2=16.845 //y2=5.335
r1154 (  14 74 ) resistor r=0.00118313 //w=0.23 //layer=m1 //thickness=0.36 \
 //x=16.73 //y=5.56 //x2=16.73 //y2=5.56
r1155 (  13 72 ) resistor r=0.002872 //w=0.34 //l=0.085 //layer=m1 \
 //thickness=0.36 //x=16.73 //y=5.42 //x2=16.73 //y2=5.335
r1156 (  13 14 ) resistor r=0.091623 //w=0.191 //l=0.14 //layer=m1 \
 //thickness=0.36 //x=16.73 //y=5.42 //x2=16.73 //y2=5.56
r1157 (  12 69 ) resistor r=0.0262263 //w=0.232 //l=0.12 //layer=m1 \
 //thickness=0.36 //x=15.97 //y=5.335 //x2=15.85 //y2=5.335
r1158 (  11 72 ) resistor r=0.0675342 //w=0.23 //l=0.115 //layer=m1 \
 //thickness=0.36 //x=16.615 //y=5.335 //x2=16.73 //y2=5.335
r1159 (  11 12 ) resistor r=0.615458 //w=0.131 //l=0.645 //layer=m1 \
 //thickness=0.36 //x=16.615 //y=5.335 //x2=15.97 //y2=5.335
r1160 (  10 66 ) resistor r=0.0222262 //w=0.217 //l=0.118 //layer=m1 \
 //thickness=0.36 //x=15.09 //y=5.335 //x2=14.972 //y2=5.335
r1161 (  9 69 ) resistor r=0.0262263 //w=0.232 //l=0.12 //layer=m1 \
 //thickness=0.36 //x=15.73 //y=5.335 //x2=15.85 //y2=5.335
r1162 (  9 10 ) resistor r=0.610687 //w=0.131 //l=0.64 //layer=m1 \
 //thickness=0.36 //x=15.73 //y=5.335 //x2=15.09 //y2=5.335
r1163 (  8 65 ) resistor r=0.0878548 //w=0.228 //l=0.159295 //layer=m1 \
 //thickness=0.36 //x=11.96 //y=4.735 //x2=11.99 //y2=4.88
r1164 (  7 58 ) resistor r=0.0912814 //w=0.379 //l=0.183303 //layer=m1 \
 //thickness=0.36 //x=11.96 //y=4.41 //x2=11.91 //y2=4.25
r1165 (  7 8 ) resistor r=0.310115 //w=0.131 //l=0.325 //layer=m1 \
 //thickness=0.36 //x=11.96 //y=4.41 //x2=11.96 //y2=4.735
r1166 (  6 58 ) resistor r=0.0912814 //w=0.379 //l=0.183303 //layer=m1 \
 //thickness=0.36 //x=11.96 //y=4.09 //x2=11.91 //y2=4.25
r1167 (  6 63 ) resistor r=1.62691 //w=0.131 //l=1.705 //layer=m1 \
 //thickness=0.36 //x=11.96 //y=4.09 //x2=11.96 //y2=2.385
r1168 (  4 52 ) resistor r=0.0760407 //w=0.238 //l=0.125 //layer=m1 \
 //thickness=0.36 //x=1.6 //y=4.755 //x2=1.6 //y2=4.88
r1169 (  3 56 ) resistor r=0.0911593 //w=0.376 //l=0.184174 //layer=m1 \
 //thickness=0.36 //x=1.6 //y=4.42 //x2=1.652 //y2=4.26
r1170 (  3 4 ) resistor r=0.319656 //w=0.131 //l=0.335 //layer=m1 \
 //thickness=0.36 //x=1.6 //y=4.42 //x2=1.6 //y2=4.755
r1171 (  2 54 ) resistor r=0.0878349 //w=0.376 //l=0.174069 //layer=m1 \
 //thickness=0.36 //x=1.6 //y=4.1 //x2=1.652 //y2=4.25
r1172 (  1 50 ) resistor r=0.0719237 //w=0.222 //l=0.115 //layer=m1 \
 //thickness=0.36 //x=1.6 //y=2.375 //x2=1.6 //y2=2.26
r1173 (  1 2 ) resistor r=1.64599 //w=0.131 //l=1.725 //layer=m1 \
 //thickness=0.36 //x=1.6 //y=2.375 //x2=1.6 //y2=4.1
ends PM_TMRDFFRNQX1\%noxref_4

subckt PM_TMRDFFRNQX1\%noxref_5 ( 1 2 3 4 5 7 10 11 13 14 15 16 18 19 20 22 23 \
 30 32 35 38 44 47 50 53 54 56 57 58 60 62 64 65 72 75 84 89 97 105 122 131 \
 135 136 137 138 139 140 144 145 146 151 153 156 157 158 159 160 161 165 167 \
 170 171 176 177 182 191 194 196 197 198 )
c449 ( 194 0 ) capacitor c=0.00885916f //x=34.595 //y=1.095
c450 ( 191 0 ) capacitor c=0.0682508f //x=37.12 //y=4.88
c451 ( 182 0 ) capacitor c=0.0710579f //x=29.72 //y=4.88
c452 ( 177 0 ) capacitor c=0.0278202f //x=29.72 //y=2.095
c453 ( 176 0 ) capacitor c=0.0479324f //x=29.72 //y=2.26
c454 ( 171 0 ) capacitor c=0.0318956f //x=37.455 //y=1.39
c455 ( 170 0 ) capacitor c=0.0186809f //x=37.455 //y=1.045
c456 ( 167 0 ) capacitor c=0.0141821f //x=37.3 //y=1.545
c457 ( 165 0 ) capacitor c=0.0158553f //x=37.3 //y=0.89
c458 ( 161 0 ) capacitor c=0.0854195f //x=36.925 //y=2.095
c459 ( 160 0 ) capacitor c=0.0229235f //x=36.925 //y=1.7
c460 ( 159 0 ) capacitor c=0.0234359f //x=36.925 //y=1.39
c461 ( 158 0 ) capacitor c=0.0198759f //x=36.925 //y=1.045
c462 ( 157 0 ) capacitor c=0.0443175f //x=30.24 //y=1.44
c463 ( 156 0 ) capacitor c=0.0199703f //x=30.24 //y=1.095
c464 ( 153 0 ) capacitor c=0.0162526f //x=30.085 //y=1.595
c465 ( 151 0 ) capacitor c=0.0157807f //x=30.085 //y=0.94
c466 ( 146 0 ) capacitor c=0.0220935f //x=29.71 //y=1.75
c467 ( 145 0 ) capacitor c=0.0207489f //x=29.71 //y=1.44
c468 ( 144 0 ) capacitor c=0.0194091f //x=29.71 //y=1.095
c469 ( 140 0 ) capacitor c=0.110369f //x=37.46 //y=6.2
c470 ( 139 0 ) capacitor c=0.154619f //x=37.02 //y=6.2
c471 ( 138 0 ) capacitor c=0.159671f //x=29.9 //y=6.2
c472 ( 137 0 ) capacitor c=0.110208f //x=29.46 //y=6.2
c473 ( 131 0 ) capacitor c=8.13425e-19 //x=37.12 //y=4.88
c474 ( 122 0 ) capacitor c=7.85889e-19 //x=37.12 //y=2.26
c475 ( 105 0 ) capacitor c=0.0292634f //x=34.49 //y=5.56
c476 ( 97 0 ) capacitor c=0.029137f //x=33.61 //y=5.56
c477 ( 89 0 ) capacitor c=0.0278099f //x=32.73 //y=5.56
c478 ( 84 0 ) capacitor c=7.7417e-19 //x=29.72 //y=4.88
c479 ( 75 0 ) capacitor c=0.00101179f //x=29.72 //y=2.26
c480 ( 72 0 ) capacitor c=4.64216e-19 //x=37.12 //y=3.51
c481 ( 65 0 ) capacitor c=0.0234115f //x=35.435 //y=3.51
c482 ( 64 0 ) capacitor c=0.0189392f //x=36.96 //y=3.51
c483 ( 62 0 ) capacitor c=0.00228713f //x=32.53 //y=3.495
c484 ( 60 0 ) capacitor c=0.0164618f //x=31.93 //y=3.51
c485 ( 58 0 ) capacitor c=0.00615936f //x=30.68 //y=3.5
c486 ( 57 0 ) capacitor c=6.16648e-19 //x=29.88 //y=3.51
c487 ( 56 0 ) capacitor c=0.00320294f //x=30.08 //y=3.51
c488 ( 54 0 ) capacitor c=0.0268056f //x=37.122 //y=4.74
c489 ( 53 0 ) capacitor c=0.00611114f //x=37.12 //y=4.88
c490 ( 50 0 ) capacitor c=0.00463527f //x=37.12 //y=2.26
c491 ( 47 0 ) capacitor c=0.0161834f //x=37.12 //y=3.51
c492 ( 44 0 ) capacitor c=0.0170515f //x=35.27 //y=3.51
c493 ( 38 0 ) capacitor c=0.00112339f //x=34.49 //y=5.335
c494 ( 35 0 ) capacitor c=0.00758329f //x=33.61 //y=5.335
c495 ( 32 0 ) capacitor c=0.0111234f //x=32.732 //y=5.335
c496 ( 30 0 ) capacitor c=0.0148558f //x=29.72 //y=3.51
c497 ( 23 0 ) capacitor c=0.013335f //x=37.12 //y=3.67
c498 ( 22 0 ) capacitor c=0.0249558f //x=37.12 //y=3.35
c499 ( 20 0 ) capacitor c=0.0423864f //x=35.27 //y=5.25
c500 ( 19 0 ) capacitor c=0.013011f //x=35.27 //y=3.67
c501 ( 18 0 ) capacitor c=0.0367834f //x=35.27 //y=3.35
c502 ( 16 0 ) capacitor c=0.00493487f //x=34.87 //y=1.845
c503 ( 15 0 ) capacitor c=0.012936f //x=35.185 //y=1.845
c504 ( 14 0 ) capacitor c=0.0136149f //x=34.785 //y=1.76
c505 ( 13 0 ) capacitor c=0.0112307f //x=34.785 //y=1.305
c506 ( 11 0 ) capacitor c=0.0238781f //x=35.185 //y=5.335
c507 ( 10 0 ) capacitor c=0.00906713f //x=34.49 //y=5.56
c508 ( 7 0 ) capacitor c=0.019596f //x=34.375 //y=5.335
c509 ( 5 0 ) capacitor c=0.0151947f //x=33.49 //y=5.335
c510 ( 4 0 ) capacitor c=0.0286235f //x=29.72 //y=4.75
c511 ( 3 0 ) capacitor c=0.0129098f //x=29.72 //y=3.67
c512 ( 2 0 ) capacitor c=0.0229166f //x=29.72 //y=3.35
c513 ( 1 0 ) capacitor c=0.00556102f //x=29.72 //y=2.375
r514 (  189 191 ) resistor r=20.6867 //w=0.233 //l=0.1 //layer=ply \
 //thickness=0.18 //x=37.02 //y=4.88 //x2=37.12 //y2=4.88
r515 (  176 177 ) resistor r=52.7279 //w=0.214 //l=0.165 //layer=ply \
 //thickness=0.18 //x=29.72 //y=2.26 //x2=29.72 //y2=2.095
r516 (  172 191 ) resistor r=70.3348 //w=0.233 //l=0.414367 //layer=ply \
 //thickness=0.18 //x=37.46 //y=5.045 //x2=37.12 //y2=4.88
r517 (  171 193 ) resistor r=45.1352 //w=0.168 //l=0.173853 //layer=ply \
 //thickness=0.18 //x=37.455 //y=1.39 //x2=37.415 //y2=1.545
r518 (  170 192 ) resistor r=45.1352 //w=0.168 //l=0.173853 //layer=ply \
 //thickness=0.18 //x=37.455 //y=1.045 //x2=37.415 //y2=0.89
r519 (  170 171 ) resistor r=176.904 //w=0.094 //l=0.345 //layer=ply \
 //thickness=0.18 //x=37.455 //y=1.045 //x2=37.455 //y2=1.39
r520 (  168 188 ) resistor r=10.701 //w=0.21 //l=0.115 //layer=ply \
 //thickness=0.18 //x=37.08 //y=1.545 //x2=36.965 //y2=1.545
r521 (  167 193 ) resistor r=5.52526 //w=0.168 //l=0.115 //layer=ply \
 //thickness=0.18 //x=37.3 //y=1.545 //x2=37.415 //y2=1.545
r522 (  166 187 ) resistor r=5.52526 //w=0.168 //l=0.115 //layer=ply \
 //thickness=0.18 //x=37.08 //y=0.89 //x2=36.965 //y2=0.89
r523 (  165 192 ) resistor r=5.52526 //w=0.168 //l=0.115 //layer=ply \
 //thickness=0.18 //x=37.3 //y=0.89 //x2=37.415 //y2=0.89
r524 (  165 166 ) resistor r=112.809 //w=0.094 //l=0.22 //layer=ply \
 //thickness=0.18 //x=37.3 //y=0.89 //x2=37.08 //y2=0.89
r525 (  162 189 ) resistor r=13.0941 //w=0.233 //l=0.165 //layer=ply \
 //thickness=0.18 //x=37.02 //y=5.045 //x2=37.02 //y2=4.88
r526 (  161 186 ) resistor r=34.8111 //w=0.27 //l=0.264953 //layer=ply \
 //thickness=0.18 //x=36.925 //y=2.095 //x2=37.12 //y2=2.26
r527 (  160 188 ) resistor r=39.5823 //w=0.21 //l=0.173853 //layer=ply \
 //thickness=0.18 //x=36.925 //y=1.7 //x2=36.965 //y2=1.545
r528 (  160 161 ) resistor r=202.543 //w=0.094 //l=0.395 //layer=ply \
 //thickness=0.18 //x=36.925 //y=1.7 //x2=36.925 //y2=2.095
r529 (  159 188 ) resistor r=39.5823 //w=0.21 //l=0.173853 //layer=ply \
 //thickness=0.18 //x=36.925 //y=1.39 //x2=36.965 //y2=1.545
r530 (  158 187 ) resistor r=45.1352 //w=0.168 //l=0.173853 //layer=ply \
 //thickness=0.18 //x=36.925 //y=1.045 //x2=36.965 //y2=0.89
r531 (  158 159 ) resistor r=176.904 //w=0.094 //l=0.345 //layer=ply \
 //thickness=0.18 //x=36.925 //y=1.045 //x2=36.925 //y2=1.39
r532 (  157 184 ) resistor r=45.1352 //w=0.168 //l=0.173853 //layer=ply \
 //thickness=0.18 //x=30.24 //y=1.44 //x2=30.2 //y2=1.595
r533 (  156 183 ) resistor r=45.1352 //w=0.168 //l=0.173853 //layer=ply \
 //thickness=0.18 //x=30.24 //y=1.095 //x2=30.2 //y2=0.94
r534 (  156 157 ) resistor r=176.904 //w=0.094 //l=0.345 //layer=ply \
 //thickness=0.18 //x=30.24 //y=1.095 //x2=30.24 //y2=1.44
r535 (  154 180 ) resistor r=10.701 //w=0.21 //l=0.115 //layer=ply \
 //thickness=0.18 //x=29.865 //y=1.595 //x2=29.75 //y2=1.595
r536 (  153 184 ) resistor r=5.52526 //w=0.168 //l=0.115 //layer=ply \
 //thickness=0.18 //x=30.085 //y=1.595 //x2=30.2 //y2=1.595
r537 (  152 179 ) resistor r=5.52526 //w=0.168 //l=0.115 //layer=ply \
 //thickness=0.18 //x=29.865 //y=0.94 //x2=29.75 //y2=0.94
r538 (  151 183 ) resistor r=5.52526 //w=0.168 //l=0.115 //layer=ply \
 //thickness=0.18 //x=30.085 //y=0.94 //x2=30.2 //y2=0.94
r539 (  151 152 ) resistor r=112.809 //w=0.094 //l=0.22 //layer=ply \
 //thickness=0.18 //x=30.085 //y=0.94 //x2=29.865 //y2=0.94
r540 (  148 182 ) resistor r=37.236 //w=0.233 //l=0.249199 //layer=ply \
 //thickness=0.18 //x=29.9 //y=5.045 //x2=29.72 //y2=4.88
r541 (  146 180 ) resistor r=39.5823 //w=0.21 //l=0.173853 //layer=ply \
 //thickness=0.18 //x=29.71 //y=1.75 //x2=29.75 //y2=1.595
r542 (  146 177 ) resistor r=176.904 //w=0.094 //l=0.345 //layer=ply \
 //thickness=0.18 //x=29.71 //y=1.75 //x2=29.71 //y2=2.095
r543 (  145 180 ) resistor r=39.5823 //w=0.21 //l=0.173853 //layer=ply \
 //thickness=0.18 //x=29.71 //y=1.44 //x2=29.75 //y2=1.595
r544 (  144 179 ) resistor r=45.1352 //w=0.168 //l=0.173853 //layer=ply \
 //thickness=0.18 //x=29.71 //y=1.095 //x2=29.75 //y2=0.94
r545 (  144 145 ) resistor r=176.904 //w=0.094 //l=0.345 //layer=ply \
 //thickness=0.18 //x=29.71 //y=1.095 //x2=29.71 //y2=1.44
r546 (  141 182 ) resistor r=53.7854 //w=0.233 //l=0.332415 //layer=ply \
 //thickness=0.18 //x=29.46 //y=5.045 //x2=29.72 //y2=4.88
r547 (  140 172 ) resistor r=592.245 //w=0.094 //l=1.155 //layer=ply \
 //thickness=0.18 //x=37.46 //y=6.2 //x2=37.46 //y2=5.045
r548 (  139 162 ) resistor r=592.245 //w=0.094 //l=1.155 //layer=ply \
 //thickness=0.18 //x=37.02 //y=6.2 //x2=37.02 //y2=5.045
r549 (  138 148 ) resistor r=592.245 //w=0.094 //l=1.155 //layer=ply \
 //thickness=0.18 //x=29.9 //y=6.2 //x2=29.9 //y2=5.045
r550 (  137 141 ) resistor r=592.245 //w=0.094 //l=1.155 //layer=ply \
 //thickness=0.18 //x=29.46 //y=6.2 //x2=29.46 //y2=5.045
r551 (  136 167 ) resistor r=56.4043 //w=0.094 //l=0.11 //layer=ply \
 //thickness=0.18 //x=37.19 //y=1.545 //x2=37.3 //y2=1.545
r552 (  136 168 ) resistor r=56.4043 //w=0.094 //l=0.11 //layer=ply \
 //thickness=0.18 //x=37.19 //y=1.545 //x2=37.08 //y2=1.545
r553 (  135 153 ) resistor r=56.4043 //w=0.094 //l=0.11 //layer=ply \
 //thickness=0.18 //x=29.975 //y=1.595 //x2=30.085 //y2=1.595
r554 (  135 154 ) resistor r=56.4043 //w=0.094 //l=0.11 //layer=ply \
 //thickness=0.18 //x=29.975 //y=1.595 //x2=29.865 //y2=1.595
r555 (  131 191 ) resistor r=152 //w=0.17 //l=0.17 //layer=licon //count=1 \
 //x=37.12 //y=4.88 //x2=37.12 //y2=4.88
r556 (  122 186 ) resistor r=152 //w=0.17 //l=0.17 //layer=licon //count=1 \
 //x=37.12 //y=2.26 //x2=37.12 //y2=2.26
r557 (  105 198 ) resistor r=23.615 //w=0.187 //l=0.345 //layer=li \
 //thickness=0.1 //x=34.49 //y=5.56 //x2=34.49 //y2=5.905
r558 (  97 197 ) resistor r=23.615 //w=0.187 //l=0.345 //layer=li \
 //thickness=0.1 //x=33.61 //y=5.56 //x2=33.61 //y2=5.905
r559 (  89 196 ) resistor r=23.615 //w=0.187 //l=0.345 //layer=li \
 //thickness=0.1 //x=32.73 //y=5.56 //x2=32.73 //y2=5.905
r560 (  84 182 ) resistor r=152 //w=0.17 //l=0.17 //layer=licon //count=1 \
 //x=29.72 //y=4.88 //x2=29.72 //y2=4.88
r561 (  75 176 ) resistor r=152 //w=0.17 //l=0.17 //layer=licon //count=1 \
 //x=29.72 //y=2.26 //x2=29.72 //y2=2.26
r562 (  65 70 ) resistor r=0.108234 //w=0.187 //l=0.16 //layer=m2 \
 //thickness=0.36 //x=35.435 //y=3.51 //x2=35.275 //y2=3.51
r563 (  64 72 ) resistor r=0.10734 //w=0.281 //l=0.16 //layer=m2 \
 //thickness=0.36 //x=36.96 //y=3.51 //x2=37.12 //y2=3.51
r564 (  64 65 ) resistor r=1.45515 //w=0.131 //l=1.525 //layer=m2 \
 //thickness=0.36 //x=36.96 //y=3.51 //x2=35.435 //y2=3.51
r565 (  62 70 ) resistor r=1.83617 //w=0.187 //l=2.75249 //layer=m2 \
 //thickness=0.36 //x=32.53 //y=3.495 //x2=35.275 //y2=3.51
r566 (  62 63 ) resistor r=0.410305 //w=0.131 //l=0.43 //layer=m2 \
 //thickness=0.36 //x=32.53 //y=3.495 //x2=32.1 //y2=3.495
r567 (  60 63 ) resistor r=0.125 //w=0.17 //l=0.177341 //layer=m2 \
 //thickness=0.36 //x=31.93 //y=3.51 //x2=32.1 //y2=3.495
r568 (  60 61 ) resistor r=0.949427 //w=0.131 //l=0.995 //layer=m2 \
 //thickness=0.36 //x=31.93 //y=3.51 //x2=30.935 //y2=3.51
r569 (  58 61 ) resistor r=0.1875 //w=0.17 //l=0.259952 //layer=m2 \
 //thickness=0.36 //x=30.68 //y=3.5 //x2=30.935 //y2=3.51
r570 (  58 59 ) resistor r=0.410305 //w=0.131 //l=0.43 //layer=m2 \
 //thickness=0.36 //x=30.68 //y=3.5 //x2=30.25 //y2=3.5
r571 (  57 67 ) resistor r=0.10734 //w=0.281 //l=0.16 //layer=m2 \
 //thickness=0.36 //x=29.88 //y=3.51 //x2=29.72 //y2=3.51
r572 (  56 59 ) resistor r=0.125 //w=0.17 //l=0.174929 //layer=m2 \
 //thickness=0.36 //x=30.08 //y=3.51 //x2=30.25 //y2=3.5
r573 (  56 57 ) resistor r=0.19084 //w=0.131 //l=0.2 //layer=m2 \
 //thickness=0.36 //x=30.08 //y=3.51 //x2=29.88 //y2=3.51
r574 (  53 131 ) resistor r=9.3 //w=0.17 //l=0.17 //layer=mcon //count=1 \
 //x=37.12 //y=4.88 //x2=37.12 //y2=4.88
r575 (  53 54 ) resistor r=0.103207 //w=0.196 //l=0.14 //layer=m1 \
 //thickness=0.36 //x=37.122 //y=4.88 //x2=37.122 //y2=4.74
r576 (  50 122 ) resistor r=9.3 //w=0.17 //l=0.17 //layer=mcon //count=1 \
 //x=37.12 //y=2.26 //x2=37.12 //y2=2.26
r577 (  47 72 ) resistor r=4.5 //w=0.15 //l=0.15 //layer=via1 //count=1 \
 //x=37.12 //y=3.51 //x2=37.12 //y2=3.51
r578 (  44 70 ) resistor r=4.5 //w=0.15 //l=0.15 //layer=via1 //count=1 \
 //x=35.275 //y=3.51 //x2=35.275 //y2=3.51
r579 (  42 194 ) resistor r=9.3 //w=0.17 //l=0.17 //layer=mcon //count=1 \
 //x=34.785 //y=1.19 //x2=34.785 //y2=1.19
r580 (  40 105 ) resistor r=9.3 //w=0.17 //l=0.17 //layer=mcon //count=1 \
 //x=34.49 //y=5.56 //x2=34.49 //y2=5.56
r581 (  37 97 ) resistor r=9.3 //w=0.17 //l=0.17 //layer=mcon //count=1 \
 //x=33.61 //y=5.56 //x2=33.61 //y2=5.56
r582 (  35 37 ) resistor r=0.121228 //w=0.232 //l=0.225 //layer=m1 \
 //thickness=0.36 //x=33.61 //y=5.335 //x2=33.61 //y2=5.56
r583 (  34 89 ) resistor r=9.3 //w=0.17 //l=0.17 //layer=mcon //count=1 \
 //x=32.73 //y=5.56 //x2=32.73 //y2=5.56
r584 (  32 34 ) resistor r=0.129608 //w=0.217 //l=0.225 //layer=m1 \
 //thickness=0.36 //x=32.732 //y=5.335 //x2=32.732 //y2=5.56
r585 (  30 67 ) resistor r=4.5 //w=0.15 //l=0.15 //layer=via1 //count=1 \
 //x=29.72 //y=3.51 //x2=29.72 //y2=3.51
r586 (  28 84 ) resistor r=9.3 //w=0.17 //l=0.17 //layer=mcon //count=1 \
 //x=29.72 //y=4.88 //x2=29.72 //y2=4.88
r587 (  26 75 ) resistor r=9.3 //w=0.17 //l=0.17 //layer=mcon //count=1 \
 //x=29.72 //y=2.26 //x2=29.72 //y2=2.26
r588 (  23 47 ) resistor r=0.0911593 //w=0.376 //l=0.184608 //layer=m1 \
 //thickness=0.36 //x=37.12 //y=3.67 //x2=37.067 //y2=3.51
r589 (  23 54 ) resistor r=1.02099 //w=0.131 //l=1.07 //layer=m1 \
 //thickness=0.36 //x=37.12 //y=3.67 //x2=37.12 //y2=4.74
r590 (  22 47 ) resistor r=0.0911593 //w=0.376 //l=0.184608 //layer=m1 \
 //thickness=0.36 //x=37.12 //y=3.35 //x2=37.067 //y2=3.51
r591 (  21 50 ) resistor r=0.0933015 //w=0.201 //l=0.125 //layer=m1 \
 //thickness=0.36 //x=37.12 //y=2.385 //x2=37.12 //y2=2.26
r592 (  21 22 ) resistor r=0.920802 //w=0.131 //l=0.965 //layer=m1 \
 //thickness=0.36 //x=37.12 //y=2.385 //x2=37.12 //y2=3.35
r593 (  19 44 ) resistor r=0.0910802 //w=0.374 //l=0.185472 //layer=m1 \
 //thickness=0.36 //x=35.27 //y=3.67 //x2=35.325 //y2=3.51
r594 (  19 20 ) resistor r=1.50763 //w=0.131 //l=1.58 //layer=m1 \
 //thickness=0.36 //x=35.27 //y=3.67 //x2=35.27 //y2=5.25
r595 (  18 44 ) resistor r=0.0910802 //w=0.374 //l=0.185472 //layer=m1 \
 //thickness=0.36 //x=35.27 //y=3.35 //x2=35.325 //y2=3.51
r596 (  17 18 ) resistor r=1.35496 //w=0.131 //l=1.42 //layer=m1 \
 //thickness=0.36 //x=35.27 //y=1.93 //x2=35.27 //y2=3.35
r597 (  15 17 ) resistor r=0.0698411 //w=0.17 //l=0.120208 //layer=m1 \
 //thickness=0.36 //x=35.185 //y=1.845 //x2=35.27 //y2=1.93
r598 (  15 16 ) resistor r=0.300573 //w=0.131 //l=0.315 //layer=m1 \
 //thickness=0.36 //x=35.185 //y=1.845 //x2=34.87 //y2=1.845
r599 (  14 16 ) resistor r=0.0698411 //w=0.17 //l=0.120208 //layer=m1 \
 //thickness=0.36 //x=34.785 //y=1.76 //x2=34.87 //y2=1.845
r600 (  13 42 ) resistor r=0.0717383 //w=0.224 //l=0.115 //layer=m1 \
 //thickness=0.36 //x=34.785 //y=1.305 //x2=34.785 //y2=1.19
r601 (  13 14 ) resistor r=0.43416 //w=0.131 //l=0.455 //layer=m1 \
 //thickness=0.36 //x=34.785 //y=1.305 //x2=34.785 //y2=1.76
r602 (  12 38 ) resistor r=0.0675342 //w=0.23 //l=0.115 //layer=m1 \
 //thickness=0.36 //x=34.605 //y=5.335 //x2=34.49 //y2=5.335
r603 (  11 20 ) resistor r=0.0698411 //w=0.17 //l=0.120208 //layer=m1 \
 //thickness=0.36 //x=35.185 //y=5.335 //x2=35.27 //y2=5.25
r604 (  11 12 ) resistor r=0.553435 //w=0.131 //l=0.58 //layer=m1 \
 //thickness=0.36 //x=35.185 //y=5.335 //x2=34.605 //y2=5.335
r605 (  10 40 ) resistor r=0.00118313 //w=0.23 //layer=m1 //thickness=0.36 \
 //x=34.49 //y=5.56 //x2=34.49 //y2=5.56
r606 (  9 38 ) resistor r=0.002872 //w=0.34 //l=0.085 //layer=m1 \
 //thickness=0.36 //x=34.49 //y=5.42 //x2=34.49 //y2=5.335
r607 (  9 10 ) resistor r=0.091623 //w=0.191 //l=0.14 //layer=m1 \
 //thickness=0.36 //x=34.49 //y=5.42 //x2=34.49 //y2=5.56
r608 (  8 35 ) resistor r=0.0262263 //w=0.232 //l=0.12 //layer=m1 \
 //thickness=0.36 //x=33.73 //y=5.335 //x2=33.61 //y2=5.335
r609 (  7 38 ) resistor r=0.0675342 //w=0.23 //l=0.115 //layer=m1 \
 //thickness=0.36 //x=34.375 //y=5.335 //x2=34.49 //y2=5.335
r610 (  7 8 ) resistor r=0.615458 //w=0.131 //l=0.645 //layer=m1 \
 //thickness=0.36 //x=34.375 //y=5.335 //x2=33.73 //y2=5.335
r611 (  6 32 ) resistor r=0.0222262 //w=0.217 //l=0.118 //layer=m1 \
 //thickness=0.36 //x=32.85 //y=5.335 //x2=32.732 //y2=5.335
r612 (  5 35 ) resistor r=0.0262263 //w=0.232 //l=0.12 //layer=m1 \
 //thickness=0.36 //x=33.49 //y=5.335 //x2=33.61 //y2=5.335
r613 (  5 6 ) resistor r=0.610687 //w=0.131 //l=0.64 //layer=m1 \
 //thickness=0.36 //x=33.49 //y=5.335 //x2=32.85 //y2=5.335
r614 (  4 28 ) resistor r=0.0801089 //w=0.224 //l=0.13 //layer=m1 \
 //thickness=0.36 //x=29.72 //y=4.75 //x2=29.72 //y2=4.88
r615 (  3 30 ) resistor r=0.0911593 //w=0.376 //l=0.184174 //layer=m1 \
 //thickness=0.36 //x=29.72 //y=3.67 //x2=29.772 //y2=3.51
r616 (  3 4 ) resistor r=1.03053 //w=0.131 //l=1.08 //layer=m1 \
 //thickness=0.36 //x=29.72 //y=3.67 //x2=29.72 //y2=4.75
r617 (  2 30 ) resistor r=0.0911593 //w=0.376 //l=0.184174 //layer=m1 \
 //thickness=0.36 //x=29.72 //y=3.35 //x2=29.772 //y2=3.51
r618 (  1 26 ) resistor r=0.0719237 //w=0.222 //l=0.115 //layer=m1 \
 //thickness=0.36 //x=29.72 //y=2.375 //x2=29.72 //y2=2.26
r619 (  1 2 ) resistor r=0.930344 //w=0.131 //l=0.975 //layer=m1 \
 //thickness=0.36 //x=29.72 //y=2.375 //x2=29.72 //y2=3.35
ends PM_TMRDFFRNQX1\%noxref_5

subckt PM_TMRDFFRNQX1\%noxref_6 ( 3 8 9 11 12 14 15 16 17 18 19 20 23 24 27 29 \
 32 36 48 50 51 54 62 79 88 92 93 94 95 96 97 98 99 101 107 108 109 110 122 \
 124 125 )
c282 ( 122 0 ) capacitor c=0.00878249f //x=37.97 //y=1.085
c283 ( 110 0 ) capacitor c=0.0612936f //x=40.725 //y=4.97
c284 ( 109 0 ) capacitor c=0.0376642f //x=41.015 //y=4.97
c285 ( 108 0 ) capacitor c=0.0346489f //x=40.68 //y=1.4
c286 ( 107 0 ) capacitor c=0.018692f //x=40.68 //y=1.055
c287 ( 101 0 ) capacitor c=0.0137077f //x=40.525 //y=1.555
c288 ( 99 0 ) capacitor c=0.0158585f //x=40.525 //y=0.9
c289 ( 98 0 ) capacitor c=0.101012f //x=40.15 //y=2.095
c290 ( 97 0 ) capacitor c=0.0229444f //x=40.15 //y=1.71
c291 ( 96 0 ) capacitor c=0.0234359f //x=40.15 //y=1.4
c292 ( 95 0 ) capacitor c=0.019815f //x=40.15 //y=1.055
c293 ( 94 0 ) capacitor c=0.110208f //x=41.09 //y=6.2
c294 ( 93 0 ) capacitor c=0.158957f //x=40.65 //y=6.2
c295 ( 88 0 ) capacitor c=0.0014751f //x=40.45 //y=4.88
c296 ( 79 0 ) capacitor c=0.0012618f //x=40.45 //y=2.26
c297 ( 62 0 ) capacitor c=0.0322017f //x=38.12 //y=5.56
c298 ( 54 0 ) capacitor c=0.0291938f //x=37.24 //y=5.56
c299 ( 51 0 ) capacitor c=0.0193753f //x=40.295 //y=3.515
c300 ( 50 0 ) capacitor c=4.92224e-19 //x=40.455 //y=3.515
c301 ( 48 0 ) capacitor c=6.92089e-19 //x=38.76 //y=3.515
c302 ( 36 0 ) capacitor c=0.0170693f //x=40.45 //y=3.51
c303 ( 32 0 ) capacitor c=0.016938f //x=38.6 //y=3.51
c304 ( 29 0 ) capacitor c=0.0112415f //x=38.16 //y=1.18
c305 ( 27 0 ) capacitor c=5.78613e-19 //x=38.12 //y=5.56
c306 ( 24 0 ) capacitor c=0.010659f //x=38.12 //y=5.38
c307 ( 23 0 ) capacitor c=0.00926978f //x=37.24 //y=5.56
c308 ( 20 0 ) capacitor c=0.0382053f //x=40.45 //y=4.755
c309 ( 19 0 ) capacitor c=0.0145929f //x=40.45 //y=3.675
c310 ( 18 0 ) capacitor c=0.0285052f //x=40.45 //y=3.355
c311 ( 17 0 ) capacitor c=0.00495287f //x=40.45 //y=2.375
c312 ( 16 0 ) capacitor c=0.0418029f //x=38.6 //y=5.295
c313 ( 15 0 ) capacitor c=0.0134337f //x=38.6 //y=3.675
c314 ( 14 0 ) capacitor c=0.0385195f //x=38.6 //y=3.355
c315 ( 12 0 ) capacitor c=0.00466468f //x=38.245 //y=1.835
c316 ( 11 0 ) capacitor c=0.0120653f //x=38.515 //y=1.835
c317 ( 9 0 ) capacitor c=0.0116495f //x=38.515 //y=5.38
c318 ( 8 0 ) capacitor c=0.0134844f //x=38.16 //y=1.75
c319 ( 3 0 ) capacitor c=0.013452f //x=38.005 //y=5.38
r320 (  109 111 ) resistor r=26.9307 //w=0.15 //l=0.106066 //layer=ply \
 //thickness=0.18 //x=41.015 //y=4.97 //x2=41.09 //y2=5.045
r321 (  109 110 ) resistor r=148.702 //w=0.094 //l=0.29 //layer=ply \
 //thickness=0.18 //x=41.015 //y=4.97 //x2=40.725 //y2=4.97
r322 (  108 121 ) resistor r=45.1352 //w=0.168 //l=0.173853 //layer=ply \
 //thickness=0.18 //x=40.68 //y=1.4 //x2=40.64 //y2=1.555
r323 (  107 120 ) resistor r=45.1352 //w=0.168 //l=0.173853 //layer=ply \
 //thickness=0.18 //x=40.68 //y=1.055 //x2=40.64 //y2=0.9
r324 (  107 108 ) resistor r=176.904 //w=0.094 //l=0.345 //layer=ply \
 //thickness=0.18 //x=40.68 //y=1.055 //x2=40.68 //y2=1.4
r325 (  104 110 ) resistor r=22.7971 //w=0.269 //l=0.106066 //layer=ply \
 //thickness=0.18 //x=40.65 //y=5.045 //x2=40.725 //y2=4.97
r326 (  104 119 ) resistor r=35.8364 //w=0.269 //l=0.270185 //layer=ply \
 //thickness=0.18 //x=40.65 //y=5.045 //x2=40.45 //y2=4.88
r327 (  102 115 ) resistor r=10.701 //w=0.21 //l=0.115 //layer=ply \
 //thickness=0.18 //x=40.305 //y=1.555 //x2=40.19 //y2=1.555
r328 (  101 121 ) resistor r=5.52526 //w=0.168 //l=0.115 //layer=ply \
 //thickness=0.18 //x=40.525 //y=1.555 //x2=40.64 //y2=1.555
r329 (  100 114 ) resistor r=5.52526 //w=0.168 //l=0.115 //layer=ply \
 //thickness=0.18 //x=40.305 //y=0.9 //x2=40.19 //y2=0.9
r330 (  99 120 ) resistor r=5.52526 //w=0.168 //l=0.115 //layer=ply \
 //thickness=0.18 //x=40.525 //y=0.9 //x2=40.64 //y2=0.9
r331 (  99 100 ) resistor r=112.809 //w=0.094 //l=0.22 //layer=ply \
 //thickness=0.18 //x=40.525 //y=0.9 //x2=40.305 //y2=0.9
r332 (  98 117 ) resistor r=58.7805 //w=0.246 //l=0.373497 //layer=ply \
 //thickness=0.18 //x=40.15 //y=2.095 //x2=40.45 //y2=2.26
r333 (  97 115 ) resistor r=39.5823 //w=0.21 //l=0.173853 //layer=ply \
 //thickness=0.18 //x=40.15 //y=1.71 //x2=40.19 //y2=1.555
r334 (  97 98 ) resistor r=197.415 //w=0.094 //l=0.385 //layer=ply \
 //thickness=0.18 //x=40.15 //y=1.71 //x2=40.15 //y2=2.095
r335 (  96 115 ) resistor r=39.5823 //w=0.21 //l=0.173853 //layer=ply \
 //thickness=0.18 //x=40.15 //y=1.4 //x2=40.19 //y2=1.555
r336 (  95 114 ) resistor r=45.1352 //w=0.168 //l=0.173853 //layer=ply \
 //thickness=0.18 //x=40.15 //y=1.055 //x2=40.19 //y2=0.9
r337 (  95 96 ) resistor r=176.904 //w=0.094 //l=0.345 //layer=ply \
 //thickness=0.18 //x=40.15 //y=1.055 //x2=40.15 //y2=1.4
r338 (  94 111 ) resistor r=592.245 //w=0.094 //l=1.155 //layer=ply \
 //thickness=0.18 //x=41.09 //y=6.2 //x2=41.09 //y2=5.045
r339 (  93 104 ) resistor r=592.245 //w=0.094 //l=1.155 //layer=ply \
 //thickness=0.18 //x=40.65 //y=6.2 //x2=40.65 //y2=5.045
r340 (  92 101 ) resistor r=56.4043 //w=0.094 //l=0.11 //layer=ply \
 //thickness=0.18 //x=40.415 //y=1.555 //x2=40.525 //y2=1.555
r341 (  92 102 ) resistor r=56.4043 //w=0.094 //l=0.11 //layer=ply \
 //thickness=0.18 //x=40.415 //y=1.555 //x2=40.305 //y2=1.555
r342 (  88 119 ) resistor r=152 //w=0.17 //l=0.17 //layer=licon //count=1 \
 //x=40.45 //y=4.88 //x2=40.45 //y2=4.88
r343 (  79 117 ) resistor r=152 //w=0.17 //l=0.17 //layer=licon //count=1 \
 //x=40.45 //y=2.26 //x2=40.45 //y2=2.26
r344 (  62 125 ) resistor r=23.615 //w=0.187 //l=0.345 //layer=li \
 //thickness=0.1 //x=38.12 //y=5.56 //x2=38.12 //y2=5.905
r345 (  54 124 ) resistor r=23.615 //w=0.187 //l=0.345 //layer=li \
 //thickness=0.1 //x=37.24 //y=5.56 //x2=37.24 //y2=5.905
r346 (  50 51 ) resistor r=0.10734 //w=0.281 //l=0.16 //layer=m2 \
 //thickness=0.36 //x=40.455 //y=3.515 //x2=40.295 //y2=3.515
r347 (  48 51 ) resistor r=1.46469 //w=0.131 //l=1.535 //layer=m2 \
 //thickness=0.36 //x=38.76 //y=3.51 //x2=40.295 //y2=3.51
r348 (  46 48 ) resistor r=0.10734 //w=0.281 //l=0.16 //layer=m2 \
 //thickness=0.36 //x=38.6 //y=3.515 //x2=38.76 //y2=3.515
r349 (  42 88 ) resistor r=9.3 //w=0.17 //l=0.17 //layer=mcon //count=1 \
 //x=40.45 //y=4.88 //x2=40.45 //y2=4.88
r350 (  40 79 ) resistor r=9.3 //w=0.17 //l=0.17 //layer=mcon //count=1 \
 //x=40.45 //y=2.26 //x2=40.45 //y2=2.26
r351 (  38 50 ) resistor r=4.5 //w=0.15 //l=0.15 //layer=via1 //count=1 \
 //x=40.455 //y=3.515 //x2=40.455 //y2=3.515
r352 (  36 38 ) resistor r=0.00164908 //w=0.379 //l=0.005 //layer=m1 \
 //thickness=0.36 //x=40.4 //y=3.51 //x2=40.4 //y2=3.515
r353 (  34 46 ) resistor r=4.5 //w=0.15 //l=0.15 //layer=via1 //count=1 \
 //x=38.6 //y=3.515 //x2=38.6 //y2=3.515
r354 (  32 34 ) resistor r=0.00166223 //w=0.376 //l=0.005 //layer=m1 \
 //thickness=0.36 //x=38.652 //y=3.51 //x2=38.652 //y2=3.515
r355 (  29 122 ) resistor r=9.3 //w=0.17 //l=0.17 //layer=mcon //count=1 \
 //x=38.16 //y=1.18 //x2=38.16 //y2=1.18
r356 (  27 62 ) resistor r=9.3 //w=0.17 //l=0.17 //layer=mcon //count=1 \
 //x=38.12 //y=5.56 //x2=38.12 //y2=5.56
r357 (  24 27 ) resistor r=0.117801 //w=0.191 //l=0.18 //layer=m1 \
 //thickness=0.36 //x=38.12 //y=5.38 //x2=38.12 //y2=5.56
r358 (  23 54 ) resistor r=9.3 //w=0.17 //l=0.17 //layer=mcon //count=1 \
 //x=37.24 //y=5.56 //x2=37.24 //y2=5.56
r359 (  21 23 ) resistor r=0.10274 //w=0.219 //l=0.18 //layer=m1 \
 //thickness=0.36 //x=37.24 //y=5.38 //x2=37.24 //y2=5.56
r360 (  20 42 ) resistor r=0.0760407 //w=0.238 //l=0.125 //layer=m1 \
 //thickness=0.36 //x=40.45 //y=4.755 //x2=40.45 //y2=4.88
r361 (  19 38 ) resistor r=0.0912814 //w=0.379 //l=0.183303 //layer=m1 \
 //thickness=0.36 //x=40.45 //y=3.675 //x2=40.4 //y2=3.515
r362 (  19 20 ) resistor r=1.03053 //w=0.131 //l=1.08 //layer=m1 \
 //thickness=0.36 //x=40.45 //y=3.675 //x2=40.45 //y2=4.755
r363 (  18 36 ) resistor r=0.0896323 //w=0.379 //l=0.178255 //layer=m1 \
 //thickness=0.36 //x=40.45 //y=3.355 //x2=40.4 //y2=3.51
r364 (  17 40 ) resistor r=0.0719237 //w=0.222 //l=0.115 //layer=m1 \
 //thickness=0.36 //x=40.45 //y=2.375 //x2=40.45 //y2=2.26
r365 (  17 18 ) resistor r=0.935115 //w=0.131 //l=0.98 //layer=m1 \
 //thickness=0.36 //x=40.45 //y=2.375 //x2=40.45 //y2=3.355
r366 (  15 34 ) resistor r=0.0911593 //w=0.376 //l=0.184174 //layer=m1 \
 //thickness=0.36 //x=38.6 //y=3.675 //x2=38.652 //y2=3.515
r367 (  15 16 ) resistor r=1.5458 //w=0.131 //l=1.62 //layer=m1 \
 //thickness=0.36 //x=38.6 //y=3.675 //x2=38.6 //y2=5.295
r368 (  14 32 ) resistor r=0.0894971 //w=0.376 //l=0.179123 //layer=m1 \
 //thickness=0.36 //x=38.6 //y=3.355 //x2=38.652 //y2=3.51
r369 (  13 14 ) resistor r=1.36927 //w=0.131 //l=1.435 //layer=m1 \
 //thickness=0.36 //x=38.6 //y=1.92 //x2=38.6 //y2=3.355
r370 (  11 13 ) resistor r=0.0698411 //w=0.17 //l=0.120208 //layer=m1 \
 //thickness=0.36 //x=38.515 //y=1.835 //x2=38.6 //y2=1.92
r371 (  11 12 ) resistor r=0.257634 //w=0.131 //l=0.27 //layer=m1 \
 //thickness=0.36 //x=38.515 //y=1.835 //x2=38.245 //y2=1.835
r372 (  10 24 ) resistor r=0.0257089 //w=0.23 //l=0.115 //layer=m1 \
 //thickness=0.36 //x=38.235 //y=5.38 //x2=38.12 //y2=5.38
r373 (  9 16 ) resistor r=0.0698411 //w=0.17 //l=0.120208 //layer=m1 \
 //thickness=0.36 //x=38.515 //y=5.38 //x2=38.6 //y2=5.295
r374 (  9 10 ) resistor r=0.267176 //w=0.131 //l=0.28 //layer=m1 \
 //thickness=0.36 //x=38.515 //y=5.38 //x2=38.235 //y2=5.38
r375 (  8 12 ) resistor r=0.0698411 //w=0.17 //l=0.120208 //layer=m1 \
 //thickness=0.36 //x=38.16 //y=1.75 //x2=38.245 //y2=1.835
r376 (  7 29 ) resistor r=0.0913624 //w=0.191 //l=0.12 //layer=m1 \
 //thickness=0.36 //x=38.16 //y=1.3 //x2=38.16 //y2=1.18
r377 (  7 8 ) resistor r=0.429389 //w=0.131 //l=0.45 //layer=m1 \
 //thickness=0.36 //x=38.16 //y=1.3 //x2=38.16 //y2=1.75
r378 (  4 21 ) resistor r=0.0227762 //w=0.219 //l=0.115 //layer=m1 \
 //thickness=0.36 //x=37.355 //y=5.38 //x2=37.24 //y2=5.38
r379 (  3 24 ) resistor r=0.0257089 //w=0.23 //l=0.115 //layer=m1 \
 //thickness=0.36 //x=38.005 //y=5.38 //x2=38.12 //y2=5.38
r380 (  3 4 ) resistor r=0.620229 //w=0.131 //l=0.65 //layer=m1 \
 //thickness=0.36 //x=38.005 //y=5.38 //x2=37.355 //y2=5.38
ends PM_TMRDFFRNQX1\%noxref_6

subckt PM_TMRDFFRNQX1\%noxref_7 ( 1 3 6 7 9 10 11 12 14 15 16 17 18 19 20 21 \
 22 23 24 25 28 31 37 45 48 54 56 57 58 60 62 64 66 68 70 72 77 83 91 99 116 \
 125 130 139 143 144 145 146 147 148 149 150 151 152 153 155 161 162 163 164 \
 168 169 170 171 172 174 180 181 182 183 203 205 206 207 )
c491 ( 203 0 ) capacitor c=0.00885916f //x=29.785 //y=1.095
c492 ( 183 0 ) capacitor c=0.0583399f //x=45.535 //y=4.97
c493 ( 182 0 ) capacitor c=0.0376642f //x=45.825 //y=4.97
c494 ( 181 0 ) capacitor c=0.0346489f //x=45.49 //y=1.4
c495 ( 180 0 ) capacitor c=0.018692f //x=45.49 //y=1.055
c496 ( 174 0 ) capacitor c=0.0137077f //x=45.335 //y=1.555
c497 ( 172 0 ) capacitor c=0.0158585f //x=45.335 //y=0.9
c498 ( 171 0 ) capacitor c=0.103534f //x=44.96 //y=2.095
c499 ( 170 0 ) capacitor c=0.0229444f //x=44.96 //y=1.71
c500 ( 169 0 ) capacitor c=0.0234359f //x=44.96 //y=1.4
c501 ( 168 0 ) capacitor c=0.019815f //x=44.96 //y=1.055
c502 ( 164 0 ) capacitor c=0.0564069f //x=32.585 //y=4.97
c503 ( 163 0 ) capacitor c=0.0376642f //x=32.875 //y=4.97
c504 ( 162 0 ) capacitor c=0.0346489f //x=32.54 //y=1.4
c505 ( 161 0 ) capacitor c=0.018692f //x=32.54 //y=1.055
c506 ( 155 0 ) capacitor c=0.0137077f //x=32.385 //y=1.555
c507 ( 153 0 ) capacitor c=0.0158585f //x=32.385 //y=0.9
c508 ( 152 0 ) capacitor c=0.103534f //x=32.01 //y=2.095
c509 ( 151 0 ) capacitor c=0.0229444f //x=32.01 //y=1.71
c510 ( 150 0 ) capacitor c=0.0234359f //x=32.01 //y=1.4
c511 ( 149 0 ) capacitor c=0.019815f //x=32.01 //y=1.055
c512 ( 148 0 ) capacitor c=0.110208f //x=45.9 //y=6.2
c513 ( 147 0 ) capacitor c=0.158957f //x=45.46 //y=6.2
c514 ( 146 0 ) capacitor c=0.110208f //x=32.95 //y=6.2
c515 ( 145 0 ) capacitor c=0.158957f //x=32.51 //y=6.2
c516 ( 139 0 ) capacitor c=0.0014751f //x=45.26 //y=4.88
c517 ( 130 0 ) capacitor c=0.0012618f //x=45.26 //y=2.26
c518 ( 125 0 ) capacitor c=0.0014751f //x=32.31 //y=4.88
c519 ( 116 0 ) capacitor c=0.0012618f //x=32.31 //y=2.26
c520 ( 99 0 ) capacitor c=0.0293561f //x=29.68 //y=5.56
c521 ( 91 0 ) capacitor c=0.029137f //x=28.8 //y=5.56
c522 ( 83 0 ) capacitor c=0.0277605f //x=27.92 //y=5.56
c523 ( 77 0 ) capacitor c=7.36606e-19 //x=30.625 //y=3.885
c524 ( 72 0 ) capacitor c=0.0285101f //x=43.63 //y=3.87
c525 ( 70 0 ) capacitor c=0.0261863f //x=43.03 //y=3.88
c526 ( 68 0 ) capacitor c=0.00448716f //x=40.67 //y=3.9
c527 ( 66 0 ) capacitor c=0.018225f //x=40.07 //y=3.88
c528 ( 64 0 ) capacitor c=0.00418082f //x=38.815 //y=3.9
c529 ( 62 0 ) capacitor c=0.00773337f //x=38.08 //y=3.865
c530 ( 60 0 ) capacitor c=0.00553701f //x=37.335 //y=3.895
c531 ( 58 0 ) capacitor c=0.0174986f //x=36.735 //y=3.88
c532 ( 57 0 ) capacitor c=0.0244293f //x=35.145 //y=3.895
c533 ( 56 0 ) capacitor c=0.00423161f //x=35.49 //y=3.895
c534 ( 54 0 ) capacitor c=0.0209003f //x=32.155 //y=3.88
c535 ( 48 0 ) capacitor c=0.0169558f //x=45.25 //y=3.88
c536 ( 45 0 ) capacitor c=0.0167936f //x=32.31 //y=3.88
c537 ( 37 0 ) capacitor c=0.0172565f //x=30.46 //y=3.88
c538 ( 31 0 ) capacitor c=9.55882e-19 //x=29.68 //y=5.335
c539 ( 28 0 ) capacitor c=0.00740623f //x=28.8 //y=5.335
c540 ( 25 0 ) capacitor c=0.0112819f //x=27.922 //y=5.335
c541 ( 24 0 ) capacitor c=0.0253859f //x=45.26 //y=4.755
c542 ( 23 0 ) capacitor c=0.0136301f //x=45.26 //y=4.04
c543 ( 22 0 ) capacitor c=0.0418984f //x=45.26 //y=3.72
c544 ( 21 0 ) capacitor c=0.00489532f //x=45.26 //y=2.375
c545 ( 20 0 ) capacitor c=0.0266349f //x=32.31 //y=4.755
c546 ( 19 0 ) capacitor c=0.0127018f //x=32.31 //y=4.04
c547 ( 18 0 ) capacitor c=0.0384264f //x=32.31 //y=3.72
c548 ( 17 0 ) capacitor c=0.00495287f //x=32.31 //y=2.375
c549 ( 16 0 ) capacitor c=0.0325919f //x=30.46 //y=5.25
c550 ( 15 0 ) capacitor c=0.0131885f //x=30.46 //y=4.045
c551 ( 14 0 ) capacitor c=0.0493256f //x=30.46 //y=3.725
c552 ( 12 0 ) capacitor c=0.0047266f //x=30.06 //y=1.845
c553 ( 11 0 ) capacitor c=0.0133232f //x=30.375 //y=1.845
c554 ( 10 0 ) capacitor c=0.0167333f //x=29.975 //y=1.76
c555 ( 9 0 ) capacitor c=0.0110969f //x=29.975 //y=1.305
c556 ( 7 0 ) capacitor c=0.0229543f //x=30.375 //y=5.335
c557 ( 6 0 ) capacitor c=0.00933983f //x=29.68 //y=5.56
c558 ( 3 0 ) capacitor c=0.019444f //x=29.565 //y=5.335
c559 ( 1 0 ) capacitor c=0.0146659f //x=28.68 //y=5.335
r560 (  182 184 ) resistor r=26.9307 //w=0.15 //l=0.106066 //layer=ply \
 //thickness=0.18 //x=45.825 //y=4.97 //x2=45.9 //y2=5.045
r561 (  182 183 ) resistor r=148.702 //w=0.094 //l=0.29 //layer=ply \
 //thickness=0.18 //x=45.825 //y=4.97 //x2=45.535 //y2=4.97
r562 (  181 202 ) resistor r=45.1352 //w=0.168 //l=0.173853 //layer=ply \
 //thickness=0.18 //x=45.49 //y=1.4 //x2=45.45 //y2=1.555
r563 (  180 201 ) resistor r=45.1352 //w=0.168 //l=0.173853 //layer=ply \
 //thickness=0.18 //x=45.49 //y=1.055 //x2=45.45 //y2=0.9
r564 (  180 181 ) resistor r=176.904 //w=0.094 //l=0.345 //layer=ply \
 //thickness=0.18 //x=45.49 //y=1.055 //x2=45.49 //y2=1.4
r565 (  177 183 ) resistor r=22.7971 //w=0.269 //l=0.106066 //layer=ply \
 //thickness=0.18 //x=45.46 //y=5.045 //x2=45.535 //y2=4.97
r566 (  177 200 ) resistor r=35.8364 //w=0.269 //l=0.270185 //layer=ply \
 //thickness=0.18 //x=45.46 //y=5.045 //x2=45.26 //y2=4.88
r567 (  175 196 ) resistor r=10.701 //w=0.21 //l=0.115 //layer=ply \
 //thickness=0.18 //x=45.115 //y=1.555 //x2=45 //y2=1.555
r568 (  174 202 ) resistor r=5.52526 //w=0.168 //l=0.115 //layer=ply \
 //thickness=0.18 //x=45.335 //y=1.555 //x2=45.45 //y2=1.555
r569 (  173 195 ) resistor r=5.52526 //w=0.168 //l=0.115 //layer=ply \
 //thickness=0.18 //x=45.115 //y=0.9 //x2=45 //y2=0.9
r570 (  172 201 ) resistor r=5.52526 //w=0.168 //l=0.115 //layer=ply \
 //thickness=0.18 //x=45.335 //y=0.9 //x2=45.45 //y2=0.9
r571 (  172 173 ) resistor r=112.809 //w=0.094 //l=0.22 //layer=ply \
 //thickness=0.18 //x=45.335 //y=0.9 //x2=45.115 //y2=0.9
r572 (  171 198 ) resistor r=58.7805 //w=0.246 //l=0.373497 //layer=ply \
 //thickness=0.18 //x=44.96 //y=2.095 //x2=45.26 //y2=2.26
r573 (  170 196 ) resistor r=39.5823 //w=0.21 //l=0.173853 //layer=ply \
 //thickness=0.18 //x=44.96 //y=1.71 //x2=45 //y2=1.555
r574 (  170 171 ) resistor r=197.415 //w=0.094 //l=0.385 //layer=ply \
 //thickness=0.18 //x=44.96 //y=1.71 //x2=44.96 //y2=2.095
r575 (  169 196 ) resistor r=39.5823 //w=0.21 //l=0.173853 //layer=ply \
 //thickness=0.18 //x=44.96 //y=1.4 //x2=45 //y2=1.555
r576 (  168 195 ) resistor r=45.1352 //w=0.168 //l=0.173853 //layer=ply \
 //thickness=0.18 //x=44.96 //y=1.055 //x2=45 //y2=0.9
r577 (  168 169 ) resistor r=176.904 //w=0.094 //l=0.345 //layer=ply \
 //thickness=0.18 //x=44.96 //y=1.055 //x2=44.96 //y2=1.4
r578 (  163 165 ) resistor r=26.9307 //w=0.15 //l=0.106066 //layer=ply \
 //thickness=0.18 //x=32.875 //y=4.97 //x2=32.95 //y2=5.045
r579 (  163 164 ) resistor r=148.702 //w=0.094 //l=0.29 //layer=ply \
 //thickness=0.18 //x=32.875 //y=4.97 //x2=32.585 //y2=4.97
r580 (  162 194 ) resistor r=45.1352 //w=0.168 //l=0.173853 //layer=ply \
 //thickness=0.18 //x=32.54 //y=1.4 //x2=32.5 //y2=1.555
r581 (  161 193 ) resistor r=45.1352 //w=0.168 //l=0.173853 //layer=ply \
 //thickness=0.18 //x=32.54 //y=1.055 //x2=32.5 //y2=0.9
r582 (  161 162 ) resistor r=176.904 //w=0.094 //l=0.345 //layer=ply \
 //thickness=0.18 //x=32.54 //y=1.055 //x2=32.54 //y2=1.4
r583 (  158 164 ) resistor r=22.7971 //w=0.269 //l=0.106066 //layer=ply \
 //thickness=0.18 //x=32.51 //y=5.045 //x2=32.585 //y2=4.97
r584 (  158 192 ) resistor r=35.8364 //w=0.269 //l=0.270185 //layer=ply \
 //thickness=0.18 //x=32.51 //y=5.045 //x2=32.31 //y2=4.88
r585 (  156 188 ) resistor r=10.701 //w=0.21 //l=0.115 //layer=ply \
 //thickness=0.18 //x=32.165 //y=1.555 //x2=32.05 //y2=1.555
r586 (  155 194 ) resistor r=5.52526 //w=0.168 //l=0.115 //layer=ply \
 //thickness=0.18 //x=32.385 //y=1.555 //x2=32.5 //y2=1.555
r587 (  154 187 ) resistor r=5.52526 //w=0.168 //l=0.115 //layer=ply \
 //thickness=0.18 //x=32.165 //y=0.9 //x2=32.05 //y2=0.9
r588 (  153 193 ) resistor r=5.52526 //w=0.168 //l=0.115 //layer=ply \
 //thickness=0.18 //x=32.385 //y=0.9 //x2=32.5 //y2=0.9
r589 (  153 154 ) resistor r=112.809 //w=0.094 //l=0.22 //layer=ply \
 //thickness=0.18 //x=32.385 //y=0.9 //x2=32.165 //y2=0.9
r590 (  152 190 ) resistor r=58.7805 //w=0.246 //l=0.373497 //layer=ply \
 //thickness=0.18 //x=32.01 //y=2.095 //x2=32.31 //y2=2.26
r591 (  151 188 ) resistor r=39.5823 //w=0.21 //l=0.173853 //layer=ply \
 //thickness=0.18 //x=32.01 //y=1.71 //x2=32.05 //y2=1.555
r592 (  151 152 ) resistor r=197.415 //w=0.094 //l=0.385 //layer=ply \
 //thickness=0.18 //x=32.01 //y=1.71 //x2=32.01 //y2=2.095
r593 (  150 188 ) resistor r=39.5823 //w=0.21 //l=0.173853 //layer=ply \
 //thickness=0.18 //x=32.01 //y=1.4 //x2=32.05 //y2=1.555
r594 (  149 187 ) resistor r=45.1352 //w=0.168 //l=0.173853 //layer=ply \
 //thickness=0.18 //x=32.01 //y=1.055 //x2=32.05 //y2=0.9
r595 (  149 150 ) resistor r=176.904 //w=0.094 //l=0.345 //layer=ply \
 //thickness=0.18 //x=32.01 //y=1.055 //x2=32.01 //y2=1.4
r596 (  148 184 ) resistor r=592.245 //w=0.094 //l=1.155 //layer=ply \
 //thickness=0.18 //x=45.9 //y=6.2 //x2=45.9 //y2=5.045
r597 (  147 177 ) resistor r=592.245 //w=0.094 //l=1.155 //layer=ply \
 //thickness=0.18 //x=45.46 //y=6.2 //x2=45.46 //y2=5.045
r598 (  146 165 ) resistor r=592.245 //w=0.094 //l=1.155 //layer=ply \
 //thickness=0.18 //x=32.95 //y=6.2 //x2=32.95 //y2=5.045
r599 (  145 158 ) resistor r=592.245 //w=0.094 //l=1.155 //layer=ply \
 //thickness=0.18 //x=32.51 //y=6.2 //x2=32.51 //y2=5.045
r600 (  144 174 ) resistor r=56.4043 //w=0.094 //l=0.11 //layer=ply \
 //thickness=0.18 //x=45.225 //y=1.555 //x2=45.335 //y2=1.555
r601 (  144 175 ) resistor r=56.4043 //w=0.094 //l=0.11 //layer=ply \
 //thickness=0.18 //x=45.225 //y=1.555 //x2=45.115 //y2=1.555
r602 (  143 155 ) resistor r=56.4043 //w=0.094 //l=0.11 //layer=ply \
 //thickness=0.18 //x=32.275 //y=1.555 //x2=32.385 //y2=1.555
r603 (  143 156 ) resistor r=56.4043 //w=0.094 //l=0.11 //layer=ply \
 //thickness=0.18 //x=32.275 //y=1.555 //x2=32.165 //y2=1.555
r604 (  139 200 ) resistor r=152 //w=0.17 //l=0.17 //layer=licon //count=1 \
 //x=45.26 //y=4.88 //x2=45.26 //y2=4.88
r605 (  130 198 ) resistor r=152 //w=0.17 //l=0.17 //layer=licon //count=1 \
 //x=45.26 //y=2.26 //x2=45.26 //y2=2.26
r606 (  125 192 ) resistor r=152 //w=0.17 //l=0.17 //layer=licon //count=1 \
 //x=32.31 //y=4.88 //x2=32.31 //y2=4.88
r607 (  116 190 ) resistor r=152 //w=0.17 //l=0.17 //layer=licon //count=1 \
 //x=32.31 //y=2.26 //x2=32.31 //y2=2.26
r608 (  99 207 ) resistor r=23.615 //w=0.187 //l=0.345 //layer=li \
 //thickness=0.1 //x=29.68 //y=5.56 //x2=29.68 //y2=5.905
r609 (  91 206 ) resistor r=23.615 //w=0.187 //l=0.345 //layer=li \
 //thickness=0.1 //x=28.8 //y=5.56 //x2=28.8 //y2=5.905
r610 (  83 205 ) resistor r=23.615 //w=0.187 //l=0.345 //layer=li \
 //thickness=0.1 //x=27.92 //y=5.56 //x2=27.92 //y2=5.905
r611 (  75 77 ) resistor r=0.10734 //w=0.281 //l=0.16 //layer=m2 \
 //thickness=0.36 //x=30.465 //y=3.885 //x2=30.625 //y2=3.885
r612 (  72 81 ) resistor r=1.03061 //w=0.197 //l=1.62499 //layer=m2 \
 //thickness=0.36 //x=43.63 //y=3.87 //x2=45.25 //y2=3.88
r613 (  72 73 ) resistor r=0.410305 //w=0.131 //l=0.43 //layer=m2 \
 //thickness=0.36 //x=43.63 //y=3.87 //x2=43.2 //y2=3.87
r614 (  70 73 ) resistor r=0.125 //w=0.17 //l=0.174929 //layer=m2 \
 //thickness=0.36 //x=43.03 //y=3.88 //x2=43.2 //y2=3.87
r615 (  70 71 ) resistor r=2.08969 //w=0.131 //l=2.19 //layer=m2 \
 //thickness=0.36 //x=43.03 //y=3.88 //x2=40.84 //y2=3.88
r616 (  68 71 ) resistor r=0.125 //w=0.17 //l=0.179722 //layer=m2 \
 //thickness=0.36 //x=40.67 //y=3.9 //x2=40.84 //y2=3.88
r617 (  68 69 ) resistor r=0.329198 //w=0.131 //l=0.345 //layer=m2 \
 //thickness=0.36 //x=40.67 //y=3.9 //x2=40.325 //y2=3.9
r618 (  66 69 ) resistor r=0.1875 //w=0.17 //l=0.264811 //layer=m2 \
 //thickness=0.36 //x=40.07 //y=3.88 //x2=40.325 //y2=3.9
r619 (  66 67 ) resistor r=1.03531 //w=0.131 //l=1.085 //layer=m2 \
 //thickness=0.36 //x=40.07 //y=3.88 //x2=38.985 //y2=3.88
r620 (  64 67 ) resistor r=0.125 //w=0.17 //l=0.179722 //layer=m2 \
 //thickness=0.36 //x=38.815 //y=3.9 //x2=38.985 //y2=3.88
r621 (  64 65 ) resistor r=0.329198 //w=0.131 //l=0.345 //layer=m2 \
 //thickness=0.36 //x=38.815 //y=3.9 //x2=38.47 //y2=3.9
r622 (  62 65 ) resistor r=0.286765 //w=0.17 //l=0.407124 //layer=m2 \
 //thickness=0.36 //x=38.08 //y=3.865 //x2=38.47 //y2=3.9
r623 (  62 63 ) resistor r=0.410305 //w=0.131 //l=0.43 //layer=m2 \
 //thickness=0.36 //x=38.08 //y=3.865 //x2=37.65 //y2=3.865
r624 (  60 63 ) resistor r=0.231618 //w=0.17 //l=0.329659 //layer=m2 \
 //thickness=0.36 //x=37.335 //y=3.895 //x2=37.65 //y2=3.865
r625 (  60 61 ) resistor r=0.329198 //w=0.131 //l=0.345 //layer=m2 \
 //thickness=0.36 //x=37.335 //y=3.895 //x2=36.99 //y2=3.895
r626 (  58 61 ) resistor r=0.1875 //w=0.17 //l=0.262393 //layer=m2 \
 //thickness=0.36 //x=36.735 //y=3.88 //x2=36.99 //y2=3.895
r627 (  58 59 ) resistor r=1.02576 //w=0.131 //l=1.075 //layer=m2 \
 //thickness=0.36 //x=36.735 //y=3.88 //x2=35.66 //y2=3.88
r628 (  57 79 ) resistor r=1.89299 //w=0.187 //l=2.83749 //layer=m2 \
 //thickness=0.36 //x=35.145 //y=3.895 //x2=32.315 //y2=3.88
r629 (  56 59 ) resistor r=0.125 //w=0.17 //l=0.177341 //layer=m2 \
 //thickness=0.36 //x=35.49 //y=3.895 //x2=35.66 //y2=3.88
r630 (  56 57 ) resistor r=0.329198 //w=0.131 //l=0.345 //layer=m2 \
 //thickness=0.36 //x=35.49 //y=3.895 //x2=35.145 //y2=3.895
r631 (  54 79 ) resistor r=0.108234 //w=0.187 //l=0.16 //layer=m2 \
 //thickness=0.36 //x=32.155 //y=3.88 //x2=32.315 //y2=3.88
r632 (  54 77 ) resistor r=1.45992 //w=0.131 //l=1.53 //layer=m2 \
 //thickness=0.36 //x=32.155 //y=3.88 //x2=30.625 //y2=3.88
r633 (  53 139 ) resistor r=9.3 //w=0.17 //l=0.17 //layer=mcon //count=1 \
 //x=45.26 //y=4.88 //x2=45.26 //y2=4.88
r634 (  51 130 ) resistor r=9.3 //w=0.17 //l=0.17 //layer=mcon //count=1 \
 //x=45.26 //y=2.26 //x2=45.26 //y2=2.26
r635 (  48 81 ) resistor r=4.5 //w=0.15 //l=0.15 //layer=via1 //count=1 \
 //x=45.25 //y=3.88 //x2=45.25 //y2=3.88
r636 (  45 79 ) resistor r=4.5 //w=0.15 //l=0.15 //layer=via1 //count=1 \
 //x=32.315 //y=3.88 //x2=32.315 //y2=3.88
r637 (  43 125 ) resistor r=9.3 //w=0.17 //l=0.17 //layer=mcon //count=1 \
 //x=32.31 //y=4.88 //x2=32.31 //y2=4.88
r638 (  41 116 ) resistor r=9.3 //w=0.17 //l=0.17 //layer=mcon //count=1 \
 //x=32.31 //y=2.26 //x2=32.31 //y2=2.26
r639 (  39 75 ) resistor r=4.5 //w=0.15 //l=0.15 //layer=via1 //count=1 \
 //x=30.465 //y=3.885 //x2=30.465 //y2=3.885
r640 (  37 39 ) resistor r=0.00167112 //w=0.374 //l=0.005 //layer=m1 \
 //thickness=0.36 //x=30.515 //y=3.88 //x2=30.515 //y2=3.885
r641 (  35 203 ) resistor r=9.3 //w=0.17 //l=0.17 //layer=mcon //count=1 \
 //x=29.975 //y=1.19 //x2=29.975 //y2=1.19
r642 (  33 99 ) resistor r=9.3 //w=0.17 //l=0.17 //layer=mcon //count=1 \
 //x=29.68 //y=5.56 //x2=29.68 //y2=5.56
r643 (  30 91 ) resistor r=9.3 //w=0.17 //l=0.17 //layer=mcon //count=1 \
 //x=28.8 //y=5.56 //x2=28.8 //y2=5.56
r644 (  28 30 ) resistor r=0.121228 //w=0.232 //l=0.225 //layer=m1 \
 //thickness=0.36 //x=28.8 //y=5.335 //x2=28.8 //y2=5.56
r645 (  27 83 ) resistor r=9.3 //w=0.17 //l=0.17 //layer=mcon //count=1 \
 //x=27.92 //y=5.56 //x2=27.92 //y2=5.56
r646 (  25 27 ) resistor r=0.129608 //w=0.217 //l=0.225 //layer=m1 \
 //thickness=0.36 //x=27.922 //y=5.335 //x2=27.922 //y2=5.56
r647 (  24 53 ) resistor r=0.0760407 //w=0.238 //l=0.125 //layer=m1 \
 //thickness=0.36 //x=45.26 //y=4.755 //x2=45.26 //y2=4.88
r648 (  23 48 ) resistor r=0.0909648 //w=0.371 //l=0.186762 //layer=m1 \
 //thickness=0.36 //x=45.26 //y=4.04 //x2=45.202 //y2=3.88
r649 (  23 24 ) resistor r=0.682252 //w=0.131 //l=0.715 //layer=m1 \
 //thickness=0.36 //x=45.26 //y=4.04 //x2=45.26 //y2=4.755
r650 (  22 48 ) resistor r=0.0909648 //w=0.371 //l=0.186762 //layer=m1 \
 //thickness=0.36 //x=45.26 //y=3.72 //x2=45.202 //y2=3.88
r651 (  21 51 ) resistor r=0.0719237 //w=0.222 //l=0.115 //layer=m1 \
 //thickness=0.36 //x=45.26 //y=2.375 //x2=45.26 //y2=2.26
r652 (  21 22 ) resistor r=1.2834 //w=0.131 //l=1.345 //layer=m1 \
 //thickness=0.36 //x=45.26 //y=2.375 //x2=45.26 //y2=3.72
r653 (  20 43 ) resistor r=0.0760407 //w=0.238 //l=0.125 //layer=m1 \
 //thickness=0.36 //x=32.31 //y=4.755 //x2=32.31 //y2=4.88
r654 (  19 45 ) resistor r=0.0910802 //w=0.374 //l=0.185472 //layer=m1 \
 //thickness=0.36 //x=32.31 //y=4.04 //x2=32.365 //y2=3.88
r655 (  19 20 ) resistor r=0.682252 //w=0.131 //l=0.715 //layer=m1 \
 //thickness=0.36 //x=32.31 //y=4.04 //x2=32.31 //y2=4.755
r656 (  18 45 ) resistor r=0.0910802 //w=0.374 //l=0.185472 //layer=m1 \
 //thickness=0.36 //x=32.31 //y=3.72 //x2=32.365 //y2=3.88
r657 (  17 41 ) resistor r=0.0719237 //w=0.222 //l=0.115 //layer=m1 \
 //thickness=0.36 //x=32.31 //y=2.375 //x2=32.31 //y2=2.26
r658 (  17 18 ) resistor r=1.2834 //w=0.131 //l=1.345 //layer=m1 \
 //thickness=0.36 //x=32.31 //y=2.375 //x2=32.31 //y2=3.72
r659 (  15 39 ) resistor r=0.0910802 //w=0.374 //l=0.185472 //layer=m1 \
 //thickness=0.36 //x=30.46 //y=4.045 //x2=30.515 //y2=3.885
r660 (  15 16 ) resistor r=1.14981 //w=0.131 //l=1.205 //layer=m1 \
 //thickness=0.36 //x=30.46 //y=4.045 //x2=30.46 //y2=5.25
r661 (  14 37 ) resistor r=0.089409 //w=0.374 //l=0.180416 //layer=m1 \
 //thickness=0.36 //x=30.46 //y=3.725 //x2=30.515 //y2=3.88
r662 (  13 14 ) resistor r=1.71279 //w=0.131 //l=1.795 //layer=m1 \
 //thickness=0.36 //x=30.46 //y=1.93 //x2=30.46 //y2=3.725
r663 (  11 13 ) resistor r=0.0698411 //w=0.17 //l=0.120208 //layer=m1 \
 //thickness=0.36 //x=30.375 //y=1.845 //x2=30.46 //y2=1.93
r664 (  11 12 ) resistor r=0.300573 //w=0.131 //l=0.315 //layer=m1 \
 //thickness=0.36 //x=30.375 //y=1.845 //x2=30.06 //y2=1.845
r665 (  10 12 ) resistor r=0.0698411 //w=0.17 //l=0.120208 //layer=m1 \
 //thickness=0.36 //x=29.975 //y=1.76 //x2=30.06 //y2=1.845
r666 (  9 35 ) resistor r=0.0717383 //w=0.224 //l=0.115 //layer=m1 \
 //thickness=0.36 //x=29.975 //y=1.305 //x2=29.975 //y2=1.19
r667 (  9 10 ) resistor r=0.43416 //w=0.131 //l=0.455 //layer=m1 \
 //thickness=0.36 //x=29.975 //y=1.305 //x2=29.975 //y2=1.76
r668 (  8 31 ) resistor r=0.0675342 //w=0.23 //l=0.115 //layer=m1 \
 //thickness=0.36 //x=29.795 //y=5.335 //x2=29.68 //y2=5.335
r669 (  7 16 ) resistor r=0.0698411 //w=0.17 //l=0.120208 //layer=m1 \
 //thickness=0.36 //x=30.375 //y=5.335 //x2=30.46 //y2=5.25
r670 (  7 8 ) resistor r=0.553435 //w=0.131 //l=0.58 //layer=m1 \
 //thickness=0.36 //x=30.375 //y=5.335 //x2=29.795 //y2=5.335
r671 (  6 33 ) resistor r=0.00118313 //w=0.23 //layer=m1 //thickness=0.36 \
 //x=29.68 //y=5.56 //x2=29.68 //y2=5.56
r672 (  5 31 ) resistor r=0.002872 //w=0.34 //l=0.085 //layer=m1 \
 //thickness=0.36 //x=29.68 //y=5.42 //x2=29.68 //y2=5.335
r673 (  5 6 ) resistor r=0.091623 //w=0.191 //l=0.14 //layer=m1 \
 //thickness=0.36 //x=29.68 //y=5.42 //x2=29.68 //y2=5.56
r674 (  4 28 ) resistor r=0.0262263 //w=0.232 //l=0.12 //layer=m1 \
 //thickness=0.36 //x=28.92 //y=5.335 //x2=28.8 //y2=5.335
r675 (  3 31 ) resistor r=0.0675342 //w=0.23 //l=0.115 //layer=m1 \
 //thickness=0.36 //x=29.565 //y=5.335 //x2=29.68 //y2=5.335
r676 (  3 4 ) resistor r=0.615458 //w=0.131 //l=0.645 //layer=m1 \
 //thickness=0.36 //x=29.565 //y=5.335 //x2=28.92 //y2=5.335
r677 (  2 25 ) resistor r=0.0222262 //w=0.217 //l=0.118 //layer=m1 \
 //thickness=0.36 //x=28.04 //y=5.335 //x2=27.922 //y2=5.335
r678 (  1 28 ) resistor r=0.0262263 //w=0.232 //l=0.12 //layer=m1 \
 //thickness=0.36 //x=28.68 //y=5.335 //x2=28.8 //y2=5.335
r679 (  1 2 ) resistor r=0.610687 //w=0.131 //l=0.64 //layer=m1 \
 //thickness=0.36 //x=28.68 //y=5.335 //x2=28.04 //y2=5.335
ends PM_TMRDFFRNQX1\%noxref_7

subckt PM_TMRDFFRNQX1\%noxref_8 ( 1 3 6 7 9 10 11 12 14 15 16 18 19 21 24 27 \
 35 39 41 44 45 52 54 55 58 66 74 91 100 104 105 106 107 108 109 110 114 116 \
 119 120 130 133 135 136 137 )
c294 ( 133 0 ) capacitor c=0.00885916f //x=47.545 //y=1.095
c295 ( 130 0 ) capacitor c=0.0646027f //x=50.07 //y=4.88
c296 ( 120 0 ) capacitor c=0.0318956f //x=50.405 //y=1.39
c297 ( 119 0 ) capacitor c=0.0186809f //x=50.405 //y=1.045
c298 ( 116 0 ) capacitor c=0.0141821f //x=50.25 //y=1.545
c299 ( 114 0 ) capacitor c=0.0158553f //x=50.25 //y=0.89
c300 ( 110 0 ) capacitor c=0.088055f //x=49.875 //y=2.095
c301 ( 109 0 ) capacitor c=0.0229235f //x=49.875 //y=1.7
c302 ( 108 0 ) capacitor c=0.0234359f //x=49.875 //y=1.39
c303 ( 107 0 ) capacitor c=0.0198759f //x=49.875 //y=1.045
c304 ( 106 0 ) capacitor c=0.110369f //x=50.41 //y=6.2
c305 ( 105 0 ) capacitor c=0.154619f //x=49.97 //y=6.2
c306 ( 100 0 ) capacitor c=8.13425e-19 //x=50.07 //y=4.88
c307 ( 91 0 ) capacitor c=7.85889e-19 //x=50.07 //y=2.26
c308 ( 74 0 ) capacitor c=0.0293075f //x=47.44 //y=5.56
c309 ( 66 0 ) capacitor c=0.029137f //x=46.56 //y=5.56
c310 ( 58 0 ) capacitor c=0.0278099f //x=45.68 //y=5.56
c311 ( 55 0 ) capacitor c=0.0192862f //x=49.905 //y=3.865
c312 ( 54 0 ) capacitor c=7.40619e-19 //x=50.065 //y=3.865
c313 ( 52 0 ) capacitor c=7.35495e-19 //x=48.385 //y=3.865
c314 ( 45 0 ) capacitor c=0.0159079f //x=50.072 //y=4.74
c315 ( 44 0 ) capacitor c=0.00598864f //x=50.07 //y=4.88
c316 ( 41 0 ) capacitor c=0.00462953f //x=50.07 //y=2.26
c317 ( 39 0 ) capacitor c=0.016592f //x=50.07 //y=3.88
c318 ( 35 0 ) capacitor c=0.0178849f //x=48.22 //y=3.88
c319 ( 27 0 ) capacitor c=9.53233e-19 //x=47.44 //y=5.335
c320 ( 24 0 ) capacitor c=0.00809525f //x=46.56 //y=5.335
c321 ( 21 0 ) capacitor c=0.0111234f //x=45.682 //y=5.335
c322 ( 19 0 ) capacitor c=0.0123168f //x=50.07 //y=4.025
c323 ( 18 0 ) capacitor c=0.0344812f //x=50.07 //y=3.705
c324 ( 16 0 ) capacitor c=0.0319031f //x=48.22 //y=5.25
c325 ( 15 0 ) capacitor c=0.0132077f //x=48.22 //y=4.025
c326 ( 14 0 ) capacitor c=0.0469424f //x=48.22 //y=3.705
c327 ( 12 0 ) capacitor c=0.0047266f //x=47.82 //y=1.845
c328 ( 11 0 ) capacitor c=0.0129855f //x=48.135 //y=1.845
c329 ( 10 0 ) capacitor c=0.0136149f //x=47.735 //y=1.76
c330 ( 9 0 ) capacitor c=0.0111883f //x=47.735 //y=1.305
c331 ( 7 0 ) capacitor c=0.0228415f //x=48.135 //y=5.335
c332 ( 6 0 ) capacitor c=0.00906713f //x=47.44 //y=5.56
c333 ( 3 0 ) capacitor c=0.019596f //x=47.325 //y=5.335
c334 ( 1 0 ) capacitor c=0.0151049f //x=46.44 //y=5.335
r335 (  128 130 ) resistor r=20.6867 //w=0.233 //l=0.1 //layer=ply \
 //thickness=0.18 //x=49.97 //y=4.88 //x2=50.07 //y2=4.88
r336 (  121 130 ) resistor r=70.3348 //w=0.233 //l=0.414367 //layer=ply \
 //thickness=0.18 //x=50.41 //y=5.045 //x2=50.07 //y2=4.88
r337 (  120 132 ) resistor r=45.1352 //w=0.168 //l=0.173853 //layer=ply \
 //thickness=0.18 //x=50.405 //y=1.39 //x2=50.365 //y2=1.545
r338 (  119 131 ) resistor r=45.1352 //w=0.168 //l=0.173853 //layer=ply \
 //thickness=0.18 //x=50.405 //y=1.045 //x2=50.365 //y2=0.89
r339 (  119 120 ) resistor r=176.904 //w=0.094 //l=0.345 //layer=ply \
 //thickness=0.18 //x=50.405 //y=1.045 //x2=50.405 //y2=1.39
r340 (  117 127 ) resistor r=10.701 //w=0.21 //l=0.115 //layer=ply \
 //thickness=0.18 //x=50.03 //y=1.545 //x2=49.915 //y2=1.545
r341 (  116 132 ) resistor r=5.52526 //w=0.168 //l=0.115 //layer=ply \
 //thickness=0.18 //x=50.25 //y=1.545 //x2=50.365 //y2=1.545
r342 (  115 126 ) resistor r=5.52526 //w=0.168 //l=0.115 //layer=ply \
 //thickness=0.18 //x=50.03 //y=0.89 //x2=49.915 //y2=0.89
r343 (  114 131 ) resistor r=5.52526 //w=0.168 //l=0.115 //layer=ply \
 //thickness=0.18 //x=50.25 //y=0.89 //x2=50.365 //y2=0.89
r344 (  114 115 ) resistor r=112.809 //w=0.094 //l=0.22 //layer=ply \
 //thickness=0.18 //x=50.25 //y=0.89 //x2=50.03 //y2=0.89
r345 (  111 128 ) resistor r=13.0941 //w=0.233 //l=0.165 //layer=ply \
 //thickness=0.18 //x=49.97 //y=5.045 //x2=49.97 //y2=4.88
r346 (  110 125 ) resistor r=34.8111 //w=0.27 //l=0.264953 //layer=ply \
 //thickness=0.18 //x=49.875 //y=2.095 //x2=50.07 //y2=2.26
r347 (  109 127 ) resistor r=39.5823 //w=0.21 //l=0.173853 //layer=ply \
 //thickness=0.18 //x=49.875 //y=1.7 //x2=49.915 //y2=1.545
r348 (  109 110 ) resistor r=202.543 //w=0.094 //l=0.395 //layer=ply \
 //thickness=0.18 //x=49.875 //y=1.7 //x2=49.875 //y2=2.095
r349 (  108 127 ) resistor r=39.5823 //w=0.21 //l=0.173853 //layer=ply \
 //thickness=0.18 //x=49.875 //y=1.39 //x2=49.915 //y2=1.545
r350 (  107 126 ) resistor r=45.1352 //w=0.168 //l=0.173853 //layer=ply \
 //thickness=0.18 //x=49.875 //y=1.045 //x2=49.915 //y2=0.89
r351 (  107 108 ) resistor r=176.904 //w=0.094 //l=0.345 //layer=ply \
 //thickness=0.18 //x=49.875 //y=1.045 //x2=49.875 //y2=1.39
r352 (  106 121 ) resistor r=592.245 //w=0.094 //l=1.155 //layer=ply \
 //thickness=0.18 //x=50.41 //y=6.2 //x2=50.41 //y2=5.045
r353 (  105 111 ) resistor r=592.245 //w=0.094 //l=1.155 //layer=ply \
 //thickness=0.18 //x=49.97 //y=6.2 //x2=49.97 //y2=5.045
r354 (  104 116 ) resistor r=56.4043 //w=0.094 //l=0.11 //layer=ply \
 //thickness=0.18 //x=50.14 //y=1.545 //x2=50.25 //y2=1.545
r355 (  104 117 ) resistor r=56.4043 //w=0.094 //l=0.11 //layer=ply \
 //thickness=0.18 //x=50.14 //y=1.545 //x2=50.03 //y2=1.545
r356 (  100 130 ) resistor r=152 //w=0.17 //l=0.17 //layer=licon //count=1 \
 //x=50.07 //y=4.88 //x2=50.07 //y2=4.88
r357 (  91 125 ) resistor r=152 //w=0.17 //l=0.17 //layer=licon //count=1 \
 //x=50.07 //y=2.26 //x2=50.07 //y2=2.26
r358 (  74 137 ) resistor r=23.615 //w=0.187 //l=0.345 //layer=li \
 //thickness=0.1 //x=47.44 //y=5.56 //x2=47.44 //y2=5.905
r359 (  66 136 ) resistor r=23.615 //w=0.187 //l=0.345 //layer=li \
 //thickness=0.1 //x=46.56 //y=5.56 //x2=46.56 //y2=5.905
r360 (  58 135 ) resistor r=23.615 //w=0.187 //l=0.345 //layer=li \
 //thickness=0.1 //x=45.68 //y=5.56 //x2=45.68 //y2=5.905
r361 (  54 55 ) resistor r=0.10734 //w=0.281 //l=0.16 //layer=m2 \
 //thickness=0.36 //x=50.065 //y=3.865 //x2=49.905 //y2=3.865
r362 (  52 55 ) resistor r=1.45038 //w=0.131 //l=1.52 //layer=m2 \
 //thickness=0.36 //x=48.385 //y=3.88 //x2=49.905 //y2=3.88
r363 (  50 52 ) resistor r=0.10734 //w=0.281 //l=0.16 //layer=m2 \
 //thickness=0.36 //x=48.225 //y=3.865 //x2=48.385 //y2=3.865
r364 (  44 100 ) resistor r=9.3 //w=0.17 //l=0.17 //layer=mcon //count=1 \
 //x=50.07 //y=4.88 //x2=50.07 //y2=4.88
r365 (  44 45 ) resistor r=0.103207 //w=0.196 //l=0.14 //layer=m1 \
 //thickness=0.36 //x=50.072 //y=4.88 //x2=50.072 //y2=4.74
r366 (  41 91 ) resistor r=9.3 //w=0.17 //l=0.17 //layer=mcon //count=1 \
 //x=50.07 //y=2.26 //x2=50.07 //y2=2.26
r367 (  37 54 ) resistor r=4.5 //w=0.15 //l=0.15 //layer=via1 //count=1 \
 //x=50.065 //y=3.865 //x2=50.065 //y2=3.865
r368 (  37 39 ) resistor r=0.00501337 //w=0.374 //l=0.015 //layer=m1 \
 //thickness=0.36 //x=50.015 //y=3.865 //x2=50.015 //y2=3.88
r369 (  33 50 ) resistor r=4.5 //w=0.15 //l=0.15 //layer=via1 //count=1 \
 //x=48.225 //y=3.865 //x2=48.225 //y2=3.865
r370 (  33 35 ) resistor r=0.00501337 //w=0.374 //l=0.015 //layer=m1 \
 //thickness=0.36 //x=48.275 //y=3.865 //x2=48.275 //y2=3.88
r371 (  31 133 ) resistor r=9.3 //w=0.17 //l=0.17 //layer=mcon //count=1 \
 //x=47.735 //y=1.19 //x2=47.735 //y2=1.19
r372 (  29 74 ) resistor r=9.3 //w=0.17 //l=0.17 //layer=mcon //count=1 \
 //x=47.44 //y=5.56 //x2=47.44 //y2=5.56
r373 (  26 66 ) resistor r=9.3 //w=0.17 //l=0.17 //layer=mcon //count=1 \
 //x=46.56 //y=5.56 //x2=46.56 //y2=5.56
r374 (  24 26 ) resistor r=0.121228 //w=0.232 //l=0.225 //layer=m1 \
 //thickness=0.36 //x=46.56 //y=5.335 //x2=46.56 //y2=5.56
r375 (  23 58 ) resistor r=9.3 //w=0.17 //l=0.17 //layer=mcon //count=1 \
 //x=45.68 //y=5.56 //x2=45.68 //y2=5.56
r376 (  21 23 ) resistor r=0.129608 //w=0.217 //l=0.225 //layer=m1 \
 //thickness=0.36 //x=45.682 //y=5.335 //x2=45.682 //y2=5.56
r377 (  19 39 ) resistor r=0.0860668 //w=0.374 //l=0.170294 //layer=m1 \
 //thickness=0.36 //x=50.07 //y=4.025 //x2=50.015 //y2=3.88
r378 (  19 45 ) resistor r=0.682252 //w=0.131 //l=0.715 //layer=m1 \
 //thickness=0.36 //x=50.07 //y=4.025 //x2=50.07 //y2=4.74
r379 (  18 37 ) resistor r=0.0910802 //w=0.374 //l=0.185472 //layer=m1 \
 //thickness=0.36 //x=50.07 //y=3.705 //x2=50.015 //y2=3.865
r380 (  17 41 ) resistor r=0.0933015 //w=0.201 //l=0.125 //layer=m1 \
 //thickness=0.36 //x=50.07 //y=2.385 //x2=50.07 //y2=2.26
r381 (  17 18 ) resistor r=1.25954 //w=0.131 //l=1.32 //layer=m1 \
 //thickness=0.36 //x=50.07 //y=2.385 //x2=50.07 //y2=3.705
r382 (  15 35 ) resistor r=0.0860668 //w=0.374 //l=0.170294 //layer=m1 \
 //thickness=0.36 //x=48.22 //y=4.025 //x2=48.275 //y2=3.88
r383 (  15 16 ) resistor r=1.16889 //w=0.131 //l=1.225 //layer=m1 \
 //thickness=0.36 //x=48.22 //y=4.025 //x2=48.22 //y2=5.25
r384 (  14 33 ) resistor r=0.0910802 //w=0.374 //l=0.185472 //layer=m1 \
 //thickness=0.36 //x=48.22 //y=3.705 //x2=48.275 //y2=3.865
r385 (  13 14 ) resistor r=1.6937 //w=0.131 //l=1.775 //layer=m1 \
 //thickness=0.36 //x=48.22 //y=1.93 //x2=48.22 //y2=3.705
r386 (  11 13 ) resistor r=0.0698411 //w=0.17 //l=0.120208 //layer=m1 \
 //thickness=0.36 //x=48.135 //y=1.845 //x2=48.22 //y2=1.93
r387 (  11 12 ) resistor r=0.300573 //w=0.131 //l=0.315 //layer=m1 \
 //thickness=0.36 //x=48.135 //y=1.845 //x2=47.82 //y2=1.845
r388 (  10 12 ) resistor r=0.0698411 //w=0.17 //l=0.120208 //layer=m1 \
 //thickness=0.36 //x=47.735 //y=1.76 //x2=47.82 //y2=1.845
r389 (  9 31 ) resistor r=0.0717383 //w=0.224 //l=0.115 //layer=m1 \
 //thickness=0.36 //x=47.735 //y=1.305 //x2=47.735 //y2=1.19
r390 (  9 10 ) resistor r=0.43416 //w=0.131 //l=0.455 //layer=m1 \
 //thickness=0.36 //x=47.735 //y=1.305 //x2=47.735 //y2=1.76
r391 (  8 27 ) resistor r=0.0675342 //w=0.23 //l=0.115 //layer=m1 \
 //thickness=0.36 //x=47.555 //y=5.335 //x2=47.44 //y2=5.335
r392 (  7 16 ) resistor r=0.0698411 //w=0.17 //l=0.120208 //layer=m1 \
 //thickness=0.36 //x=48.135 //y=5.335 //x2=48.22 //y2=5.25
r393 (  7 8 ) resistor r=0.553435 //w=0.131 //l=0.58 //layer=m1 \
 //thickness=0.36 //x=48.135 //y=5.335 //x2=47.555 //y2=5.335
r394 (  6 29 ) resistor r=0.00118313 //w=0.23 //layer=m1 //thickness=0.36 \
 //x=47.44 //y=5.56 //x2=47.44 //y2=5.56
r395 (  5 27 ) resistor r=0.002872 //w=0.34 //l=0.085 //layer=m1 \
 //thickness=0.36 //x=47.44 //y=5.42 //x2=47.44 //y2=5.335
r396 (  5 6 ) resistor r=0.091623 //w=0.191 //l=0.14 //layer=m1 \
 //thickness=0.36 //x=47.44 //y=5.42 //x2=47.44 //y2=5.56
r397 (  4 24 ) resistor r=0.0262263 //w=0.232 //l=0.12 //layer=m1 \
 //thickness=0.36 //x=46.68 //y=5.335 //x2=46.56 //y2=5.335
r398 (  3 27 ) resistor r=0.0675342 //w=0.23 //l=0.115 //layer=m1 \
 //thickness=0.36 //x=47.325 //y=5.335 //x2=47.44 //y2=5.335
r399 (  3 4 ) resistor r=0.615458 //w=0.131 //l=0.645 //layer=m1 \
 //thickness=0.36 //x=47.325 //y=5.335 //x2=46.68 //y2=5.335
r400 (  2 21 ) resistor r=0.0222262 //w=0.217 //l=0.118 //layer=m1 \
 //thickness=0.36 //x=45.8 //y=5.335 //x2=45.682 //y2=5.335
r401 (  1 24 ) resistor r=0.0262263 //w=0.232 //l=0.12 //layer=m1 \
 //thickness=0.36 //x=46.44 //y=5.335 //x2=46.56 //y2=5.335
r402 (  1 2 ) resistor r=0.610687 //w=0.131 //l=0.64 //layer=m1 \
 //thickness=0.36 //x=46.44 //y=5.335 //x2=45.8 //y2=5.335
ends PM_TMRDFFRNQX1\%noxref_8

subckt PM_TMRDFFRNQX1\%noxref_9 ( 1 2 3 4 6 7 8 9 11 14 15 17 18 19 20 22 23 \
 24 26 27 28 34 38 41 46 49 52 58 62 66 71 73 75 77 79 80 81 82 86 94 103 108 \
 117 122 130 138 155 164 168 169 170 171 172 173 174 175 176 177 178 179 180 \
 181 183 189 190 191 192 196 197 198 203 205 207 213 214 215 216 217 222 224 \
 226 232 233 243 244 247 256 257 260 268 270 271 272 )
c654 ( 268 0 ) capacitor c=0.00885916f //x=42.735 //y=1.095
c655 ( 260 0 ) capacitor c=0.0358148f //x=50.84 //y=4.88
c656 ( 257 0 ) capacitor c=0.0284095f //x=50.81 //y=2.095
c657 ( 256 0 ) capacitor c=0.0476356f //x=50.81 //y=2.26
c658 ( 247 0 ) capacitor c=0.0354929f //x=37.89 //y=4.88
c659 ( 244 0 ) capacitor c=0.0284095f //x=37.86 //y=2.095
c660 ( 243 0 ) capacitor c=0.0476356f //x=37.86 //y=2.26
c661 ( 233 0 ) capacitor c=0.0439708f //x=51.375 //y=1.43
c662 ( 232 0 ) capacitor c=0.0192582f //x=51.375 //y=1.085
c663 ( 226 0 ) capacitor c=0.0162526f //x=51.22 //y=1.585
c664 ( 224 0 ) capacitor c=0.0157807f //x=51.22 //y=0.93
c665 ( 222 0 ) capacitor c=0.0372668f //x=51.215 //y=4.97
c666 ( 217 0 ) capacitor c=0.0210762f //x=50.845 //y=1.74
c667 ( 216 0 ) capacitor c=0.0168511f //x=50.845 //y=1.43
c668 ( 215 0 ) capacitor c=0.0175485f //x=50.845 //y=1.085
c669 ( 214 0 ) capacitor c=0.0439708f //x=38.425 //y=1.43
c670 ( 213 0 ) capacitor c=0.0192582f //x=38.425 //y=1.085
c671 ( 207 0 ) capacitor c=0.0162526f //x=38.27 //y=1.585
c672 ( 205 0 ) capacitor c=0.0157807f //x=38.27 //y=0.93
c673 ( 203 0 ) capacitor c=0.0372668f //x=38.265 //y=4.97
c674 ( 198 0 ) capacitor c=0.0210762f //x=37.895 //y=1.74
c675 ( 197 0 ) capacitor c=0.0168511f //x=37.895 //y=1.43
c676 ( 196 0 ) capacitor c=0.0175485f //x=37.895 //y=1.085
c677 ( 192 0 ) capacitor c=0.0552068f //x=27.775 //y=4.97
c678 ( 191 0 ) capacitor c=0.0376642f //x=28.065 //y=4.97
c679 ( 190 0 ) capacitor c=0.0346489f //x=27.73 //y=1.4
c680 ( 189 0 ) capacitor c=0.018692f //x=27.73 //y=1.055
c681 ( 183 0 ) capacitor c=0.0137077f //x=27.575 //y=1.555
c682 ( 181 0 ) capacitor c=0.0158585f //x=27.575 //y=0.9
c683 ( 180 0 ) capacitor c=0.103534f //x=27.2 //y=2.095
c684 ( 179 0 ) capacitor c=0.0229444f //x=27.2 //y=1.71
c685 ( 178 0 ) capacitor c=0.0234359f //x=27.2 //y=1.4
c686 ( 177 0 ) capacitor c=0.019815f //x=27.2 //y=1.055
c687 ( 176 0 ) capacitor c=0.155269f //x=51.29 //y=6.2
c688 ( 175 0 ) capacitor c=0.110375f //x=50.85 //y=6.2
c689 ( 174 0 ) capacitor c=0.155269f //x=38.34 //y=6.2
c690 ( 173 0 ) capacitor c=0.110375f //x=37.9 //y=6.2
c691 ( 172 0 ) capacitor c=0.110208f //x=28.14 //y=6.2
c692 ( 171 0 ) capacitor c=0.158957f //x=27.7 //y=6.2
c693 ( 164 0 ) capacitor c=5.80994e-19 //x=50.84 //y=4.88
c694 ( 155 0 ) capacitor c=5.78095e-19 //x=50.81 //y=2.26
c695 ( 138 0 ) capacitor c=0.0293124f //x=42.63 //y=5.56
c696 ( 130 0 ) capacitor c=0.029137f //x=41.75 //y=5.56
c697 ( 122 0 ) capacitor c=0.0277605f //x=40.87 //y=5.56
c698 ( 117 0 ) capacitor c=5.80994e-19 //x=37.89 //y=4.88
c699 ( 108 0 ) capacitor c=5.78095e-19 //x=37.86 //y=2.26
c700 ( 103 0 ) capacitor c=0.00125338f //x=27.5 //y=4.88
c701 ( 94 0 ) capacitor c=0.0012618f //x=27.5 //y=2.26
c702 ( 86 0 ) capacitor c=0.00112715f //x=27.66 //y=4.26
c703 ( 82 0 ) capacitor c=0.0202931f //x=45.12 //y=4.265
c704 ( 81 0 ) capacitor c=0.0592498f //x=45.465 //y=4.265
c705 ( 80 0 ) capacitor c=0.0480089f //x=38.025 //y=4.25
c706 ( 79 0 ) capacitor c=0.0489806f //x=43.255 //y=4.25
c707 ( 77 0 ) capacitor c=0.00158466f //x=32.53 //y=4.265
c708 ( 75 0 ) capacitor c=0.0162158f //x=31.93 //y=4.25
c709 ( 73 0 ) capacitor c=0.00487421f //x=30.715 //y=4.27
c710 ( 71 0 ) capacitor c=0.0316949f //x=30.075 //y=4.25
c711 ( 66 0 ) capacitor c=0.00504273f //x=50.81 //y=2.26
c712 ( 62 0 ) capacitor c=0.0152943f //x=50.81 //y=4.25
c713 ( 58 0 ) capacitor c=0.0152032f //x=43.41 //y=4.25
c714 ( 52 0 ) capacitor c=0.00112339f //x=42.63 //y=5.335
c715 ( 49 0 ) capacitor c=0.00744415f //x=41.75 //y=5.335
c716 ( 46 0 ) capacitor c=0.0112819f //x=40.872 //y=5.335
c717 ( 41 0 ) capacitor c=0.00504845f //x=37.86 //y=2.26
c718 ( 38 0 ) capacitor c=0.0141348f //x=37.86 //y=4.25
c719 ( 34 0 ) capacitor c=0.0159682f //x=27.5 //y=4.25
c720 ( 28 0 ) capacitor c=0.00896518f //x=50.81 //y=4.735
c721 ( 27 0 ) capacitor c=0.00958631f //x=50.81 //y=4.415
c722 ( 26 0 ) capacitor c=0.0349751f //x=50.81 //y=4.095
c723 ( 24 0 ) capacitor c=0.0222888f //x=43.41 //y=5.25
c724 ( 23 0 ) capacitor c=0.012762f //x=43.41 //y=4.415
c725 ( 22 0 ) capacitor c=0.0630158f //x=43.41 //y=4.095
c726 ( 20 0 ) capacitor c=0.00493487f //x=43.01 //y=1.845
c727 ( 19 0 ) capacitor c=0.0134344f //x=43.325 //y=1.845
c728 ( 18 0 ) capacitor c=0.0167333f //x=42.925 //y=1.76
c729 ( 17 0 ) capacitor c=0.0111392f //x=42.925 //y=1.305
c730 ( 15 0 ) capacitor c=0.0231466f //x=43.325 //y=5.335
c731 ( 14 0 ) capacitor c=0.00933983f //x=42.63 //y=5.56
c732 ( 11 0 ) capacitor c=0.019596f //x=42.515 //y=5.335
c733 ( 9 0 ) capacitor c=0.0147103f //x=41.63 //y=5.335
c734 ( 8 0 ) capacitor c=0.00917813f //x=37.86 //y=4.735
c735 ( 7 0 ) capacitor c=0.00994911f //x=37.86 //y=4.41
c736 ( 6 0 ) capacitor c=0.0333568f //x=37.86 //y=4.09
c737 ( 4 0 ) capacitor c=0.0137415f //x=27.5 //y=4.755
c738 ( 3 0 ) capacitor c=0.0127139f //x=27.5 //y=4.42
c739 ( 2 0 ) capacitor c=0.0556467f //x=27.5 //y=4.1
c740 ( 1 0 ) capacitor c=0.00495287f //x=27.5 //y=2.375
r741 (  262 263 ) resistor r=32.4568 //w=0.214 //l=0.075 //layer=ply \
 //thickness=0.18 //x=50.84 //y=4.97 //x2=50.84 //y2=5.045
r742 (  260 262 ) resistor r=20.271 //w=0.214 //l=0.09 //layer=ply \
 //thickness=0.18 //x=50.84 //y=4.88 //x2=50.84 //y2=4.97
r743 (  256 257 ) resistor r=52.7279 //w=0.214 //l=0.165 //layer=ply \
 //thickness=0.18 //x=50.81 //y=2.26 //x2=50.81 //y2=2.095
r744 (  249 250 ) resistor r=32.4568 //w=0.214 //l=0.075 //layer=ply \
 //thickness=0.18 //x=37.89 //y=4.97 //x2=37.89 //y2=5.045
r745 (  247 249 ) resistor r=20.271 //w=0.214 //l=0.09 //layer=ply \
 //thickness=0.18 //x=37.89 //y=4.88 //x2=37.89 //y2=4.97
r746 (  243 244 ) resistor r=52.7279 //w=0.214 //l=0.165 //layer=ply \
 //thickness=0.18 //x=37.86 //y=2.26 //x2=37.86 //y2=2.095
r747 (  233 267 ) resistor r=45.1352 //w=0.168 //l=0.173853 //layer=ply \
 //thickness=0.18 //x=51.375 //y=1.43 //x2=51.335 //y2=1.585
r748 (  232 266 ) resistor r=45.1352 //w=0.168 //l=0.173853 //layer=ply \
 //thickness=0.18 //x=51.375 //y=1.085 //x2=51.335 //y2=0.93
r749 (  232 233 ) resistor r=176.904 //w=0.094 //l=0.345 //layer=ply \
 //thickness=0.18 //x=51.375 //y=1.085 //x2=51.375 //y2=1.43
r750 (  227 265 ) resistor r=10.701 //w=0.21 //l=0.115 //layer=ply \
 //thickness=0.18 //x=51 //y=1.585 //x2=50.885 //y2=1.585
r751 (  226 267 ) resistor r=5.52526 //w=0.168 //l=0.115 //layer=ply \
 //thickness=0.18 //x=51.22 //y=1.585 //x2=51.335 //y2=1.585
r752 (  225 264 ) resistor r=5.52526 //w=0.168 //l=0.115 //layer=ply \
 //thickness=0.18 //x=51 //y=0.93 //x2=50.885 //y2=0.93
r753 (  224 266 ) resistor r=5.52526 //w=0.168 //l=0.115 //layer=ply \
 //thickness=0.18 //x=51.22 //y=0.93 //x2=51.335 //y2=0.93
r754 (  224 225 ) resistor r=112.809 //w=0.094 //l=0.22 //layer=ply \
 //thickness=0.18 //x=51.22 //y=0.93 //x2=51 //y2=0.93
r755 (  223 262 ) resistor r=16.5046 //w=0.27 //l=0.135 //layer=ply \
 //thickness=0.18 //x=50.975 //y=4.97 //x2=50.84 //y2=4.97
r756 (  222 229 ) resistor r=26.9307 //w=0.15 //l=0.106066 //layer=ply \
 //thickness=0.18 //x=51.215 //y=4.97 //x2=51.29 //y2=5.045
r757 (  222 223 ) resistor r=123.064 //w=0.094 //l=0.24 //layer=ply \
 //thickness=0.18 //x=51.215 //y=4.97 //x2=50.975 //y2=4.97
r758 (  217 265 ) resistor r=39.5823 //w=0.21 //l=0.173853 //layer=ply \
 //thickness=0.18 //x=50.845 //y=1.74 //x2=50.885 //y2=1.585
r759 (  217 257 ) resistor r=182.032 //w=0.094 //l=0.355 //layer=ply \
 //thickness=0.18 //x=50.845 //y=1.74 //x2=50.845 //y2=2.095
r760 (  216 265 ) resistor r=39.5823 //w=0.21 //l=0.173853 //layer=ply \
 //thickness=0.18 //x=50.845 //y=1.43 //x2=50.885 //y2=1.585
r761 (  215 264 ) resistor r=45.1352 //w=0.168 //l=0.173853 //layer=ply \
 //thickness=0.18 //x=50.845 //y=1.085 //x2=50.885 //y2=0.93
r762 (  215 216 ) resistor r=176.904 //w=0.094 //l=0.345 //layer=ply \
 //thickness=0.18 //x=50.845 //y=1.085 //x2=50.845 //y2=1.43
r763 (  214 254 ) resistor r=45.1352 //w=0.168 //l=0.173853 //layer=ply \
 //thickness=0.18 //x=38.425 //y=1.43 //x2=38.385 //y2=1.585
r764 (  213 253 ) resistor r=45.1352 //w=0.168 //l=0.173853 //layer=ply \
 //thickness=0.18 //x=38.425 //y=1.085 //x2=38.385 //y2=0.93
r765 (  213 214 ) resistor r=176.904 //w=0.094 //l=0.345 //layer=ply \
 //thickness=0.18 //x=38.425 //y=1.085 //x2=38.425 //y2=1.43
r766 (  208 252 ) resistor r=10.701 //w=0.21 //l=0.115 //layer=ply \
 //thickness=0.18 //x=38.05 //y=1.585 //x2=37.935 //y2=1.585
r767 (  207 254 ) resistor r=5.52526 //w=0.168 //l=0.115 //layer=ply \
 //thickness=0.18 //x=38.27 //y=1.585 //x2=38.385 //y2=1.585
r768 (  206 251 ) resistor r=5.52526 //w=0.168 //l=0.115 //layer=ply \
 //thickness=0.18 //x=38.05 //y=0.93 //x2=37.935 //y2=0.93
r769 (  205 253 ) resistor r=5.52526 //w=0.168 //l=0.115 //layer=ply \
 //thickness=0.18 //x=38.27 //y=0.93 //x2=38.385 //y2=0.93
r770 (  205 206 ) resistor r=112.809 //w=0.094 //l=0.22 //layer=ply \
 //thickness=0.18 //x=38.27 //y=0.93 //x2=38.05 //y2=0.93
r771 (  204 249 ) resistor r=16.5046 //w=0.27 //l=0.135 //layer=ply \
 //thickness=0.18 //x=38.025 //y=4.97 //x2=37.89 //y2=4.97
r772 (  203 210 ) resistor r=26.9307 //w=0.15 //l=0.106066 //layer=ply \
 //thickness=0.18 //x=38.265 //y=4.97 //x2=38.34 //y2=5.045
r773 (  203 204 ) resistor r=123.064 //w=0.094 //l=0.24 //layer=ply \
 //thickness=0.18 //x=38.265 //y=4.97 //x2=38.025 //y2=4.97
r774 (  198 252 ) resistor r=39.5823 //w=0.21 //l=0.173853 //layer=ply \
 //thickness=0.18 //x=37.895 //y=1.74 //x2=37.935 //y2=1.585
r775 (  198 244 ) resistor r=182.032 //w=0.094 //l=0.355 //layer=ply \
 //thickness=0.18 //x=37.895 //y=1.74 //x2=37.895 //y2=2.095
r776 (  197 252 ) resistor r=39.5823 //w=0.21 //l=0.173853 //layer=ply \
 //thickness=0.18 //x=37.895 //y=1.43 //x2=37.935 //y2=1.585
r777 (  196 251 ) resistor r=45.1352 //w=0.168 //l=0.173853 //layer=ply \
 //thickness=0.18 //x=37.895 //y=1.085 //x2=37.935 //y2=0.93
r778 (  196 197 ) resistor r=176.904 //w=0.094 //l=0.345 //layer=ply \
 //thickness=0.18 //x=37.895 //y=1.085 //x2=37.895 //y2=1.43
r779 (  191 193 ) resistor r=26.9307 //w=0.15 //l=0.106066 //layer=ply \
 //thickness=0.18 //x=28.065 //y=4.97 //x2=28.14 //y2=5.045
r780 (  191 192 ) resistor r=148.702 //w=0.094 //l=0.29 //layer=ply \
 //thickness=0.18 //x=28.065 //y=4.97 //x2=27.775 //y2=4.97
r781 (  190 241 ) resistor r=45.1352 //w=0.168 //l=0.173853 //layer=ply \
 //thickness=0.18 //x=27.73 //y=1.4 //x2=27.69 //y2=1.555
r782 (  189 240 ) resistor r=45.1352 //w=0.168 //l=0.173853 //layer=ply \
 //thickness=0.18 //x=27.73 //y=1.055 //x2=27.69 //y2=0.9
r783 (  189 190 ) resistor r=176.904 //w=0.094 //l=0.345 //layer=ply \
 //thickness=0.18 //x=27.73 //y=1.055 //x2=27.73 //y2=1.4
r784 (  186 192 ) resistor r=22.7971 //w=0.269 //l=0.106066 //layer=ply \
 //thickness=0.18 //x=27.7 //y=5.045 //x2=27.775 //y2=4.97
r785 (  186 239 ) resistor r=35.8364 //w=0.269 //l=0.270185 //layer=ply \
 //thickness=0.18 //x=27.7 //y=5.045 //x2=27.5 //y2=4.88
r786 (  184 235 ) resistor r=10.701 //w=0.21 //l=0.115 //layer=ply \
 //thickness=0.18 //x=27.355 //y=1.555 //x2=27.24 //y2=1.555
r787 (  183 241 ) resistor r=5.52526 //w=0.168 //l=0.115 //layer=ply \
 //thickness=0.18 //x=27.575 //y=1.555 //x2=27.69 //y2=1.555
r788 (  182 234 ) resistor r=5.52526 //w=0.168 //l=0.115 //layer=ply \
 //thickness=0.18 //x=27.355 //y=0.9 //x2=27.24 //y2=0.9
r789 (  181 240 ) resistor r=5.52526 //w=0.168 //l=0.115 //layer=ply \
 //thickness=0.18 //x=27.575 //y=0.9 //x2=27.69 //y2=0.9
r790 (  181 182 ) resistor r=112.809 //w=0.094 //l=0.22 //layer=ply \
 //thickness=0.18 //x=27.575 //y=0.9 //x2=27.355 //y2=0.9
r791 (  180 237 ) resistor r=58.7805 //w=0.246 //l=0.373497 //layer=ply \
 //thickness=0.18 //x=27.2 //y=2.095 //x2=27.5 //y2=2.26
r792 (  179 235 ) resistor r=39.5823 //w=0.21 //l=0.173853 //layer=ply \
 //thickness=0.18 //x=27.2 //y=1.71 //x2=27.24 //y2=1.555
r793 (  179 180 ) resistor r=197.415 //w=0.094 //l=0.385 //layer=ply \
 //thickness=0.18 //x=27.2 //y=1.71 //x2=27.2 //y2=2.095
r794 (  178 235 ) resistor r=39.5823 //w=0.21 //l=0.173853 //layer=ply \
 //thickness=0.18 //x=27.2 //y=1.4 //x2=27.24 //y2=1.555
r795 (  177 234 ) resistor r=45.1352 //w=0.168 //l=0.173853 //layer=ply \
 //thickness=0.18 //x=27.2 //y=1.055 //x2=27.24 //y2=0.9
r796 (  177 178 ) resistor r=176.904 //w=0.094 //l=0.345 //layer=ply \
 //thickness=0.18 //x=27.2 //y=1.055 //x2=27.2 //y2=1.4
r797 (  176 229 ) resistor r=592.245 //w=0.094 //l=1.155 //layer=ply \
 //thickness=0.18 //x=51.29 //y=6.2 //x2=51.29 //y2=5.045
r798 (  175 263 ) resistor r=592.245 //w=0.094 //l=1.155 //layer=ply \
 //thickness=0.18 //x=50.85 //y=6.2 //x2=50.85 //y2=5.045
r799 (  174 210 ) resistor r=592.245 //w=0.094 //l=1.155 //layer=ply \
 //thickness=0.18 //x=38.34 //y=6.2 //x2=38.34 //y2=5.045
r800 (  173 250 ) resistor r=592.245 //w=0.094 //l=1.155 //layer=ply \
 //thickness=0.18 //x=37.9 //y=6.2 //x2=37.9 //y2=5.045
r801 (  172 193 ) resistor r=592.245 //w=0.094 //l=1.155 //layer=ply \
 //thickness=0.18 //x=28.14 //y=6.2 //x2=28.14 //y2=5.045
r802 (  171 186 ) resistor r=592.245 //w=0.094 //l=1.155 //layer=ply \
 //thickness=0.18 //x=27.7 //y=6.2 //x2=27.7 //y2=5.045
r803 (  170 226 ) resistor r=56.4043 //w=0.094 //l=0.11 //layer=ply \
 //thickness=0.18 //x=51.11 //y=1.585 //x2=51.22 //y2=1.585
r804 (  170 227 ) resistor r=56.4043 //w=0.094 //l=0.11 //layer=ply \
 //thickness=0.18 //x=51.11 //y=1.585 //x2=51 //y2=1.585
r805 (  169 207 ) resistor r=56.4043 //w=0.094 //l=0.11 //layer=ply \
 //thickness=0.18 //x=38.16 //y=1.585 //x2=38.27 //y2=1.585
r806 (  169 208 ) resistor r=56.4043 //w=0.094 //l=0.11 //layer=ply \
 //thickness=0.18 //x=38.16 //y=1.585 //x2=38.05 //y2=1.585
r807 (  168 183 ) resistor r=56.4043 //w=0.094 //l=0.11 //layer=ply \
 //thickness=0.18 //x=27.465 //y=1.555 //x2=27.575 //y2=1.555
r808 (  168 184 ) resistor r=56.4043 //w=0.094 //l=0.11 //layer=ply \
 //thickness=0.18 //x=27.465 //y=1.555 //x2=27.355 //y2=1.555
r809 (  164 260 ) resistor r=152 //w=0.17 //l=0.17 //layer=licon //count=1 \
 //x=50.84 //y=4.88 //x2=50.84 //y2=4.88
r810 (  155 256 ) resistor r=152 //w=0.17 //l=0.17 //layer=licon //count=1 \
 //x=50.81 //y=2.26 //x2=50.81 //y2=2.26
r811 (  138 272 ) resistor r=23.615 //w=0.187 //l=0.345 //layer=li \
 //thickness=0.1 //x=42.63 //y=5.56 //x2=42.63 //y2=5.905
r812 (  130 271 ) resistor r=23.615 //w=0.187 //l=0.345 //layer=li \
 //thickness=0.1 //x=41.75 //y=5.56 //x2=41.75 //y2=5.905
r813 (  122 270 ) resistor r=23.615 //w=0.187 //l=0.345 //layer=li \
 //thickness=0.1 //x=40.87 //y=5.56 //x2=40.87 //y2=5.905
r814 (  117 247 ) resistor r=152 //w=0.17 //l=0.17 //layer=licon //count=1 \
 //x=37.89 //y=4.88 //x2=37.89 //y2=4.88
r815 (  108 243 ) resistor r=152 //w=0.17 //l=0.17 //layer=licon //count=1 \
 //x=37.86 //y=2.26 //x2=37.86 //y2=2.26
r816 (  103 239 ) resistor r=152 //w=0.17 //l=0.17 //layer=licon //count=1 \
 //x=27.5 //y=4.88 //x2=27.5 //y2=4.88
r817 (  94 237 ) resistor r=152 //w=0.17 //l=0.17 //layer=licon //count=1 \
 //x=27.5 //y=2.26 //x2=27.5 //y2=2.26
r818 (  84 86 ) resistor r=0.10734 //w=0.281 //l=0.16 //layer=m2 \
 //thickness=0.36 //x=27.5 //y=4.26 //x2=27.66 //y2=4.26
r819 (  82 90 ) resistor r=1.08991 //w=0.196 //l=1.70999 //layer=m2 \
 //thickness=0.36 //x=45.12 //y=4.265 //x2=43.415 //y2=4.255
r820 (  81 92 ) resistor r=3.726 //w=0.179 //l=5.34 //layer=m2 \
 //thickness=0.36 //x=45.465 //y=4.265 //x2=50.8 //y2=4.255
r821 (  81 82 ) resistor r=0.329198 //w=0.131 //l=0.345 //layer=m2 \
 //thickness=0.36 //x=45.465 //y=4.265 //x2=45.12 //y2=4.265
r822 (  80 88 ) resistor r=0.112172 //w=0.179 //l=0.16 //layer=m2 \
 //thickness=0.36 //x=38.025 //y=4.25 //x2=37.865 //y2=4.25
r823 (  79 90 ) resistor r=0.104578 //w=0.196 //l=0.162481 //layer=m2 \
 //thickness=0.36 //x=43.255 //y=4.25 //x2=43.415 //y2=4.255
r824 (  79 80 ) resistor r=4.99046 //w=0.131 //l=5.23 //layer=m2 \
 //thickness=0.36 //x=43.255 //y=4.25 //x2=38.025 //y2=4.25
r825 (  77 88 ) resistor r=3.726 //w=0.179 //l=5.34249 //layer=m2 \
 //thickness=0.36 //x=32.53 //y=4.265 //x2=37.865 //y2=4.25
r826 (  77 78 ) resistor r=0.329198 //w=0.131 //l=0.345 //layer=m2 \
 //thickness=0.36 //x=32.53 //y=4.265 //x2=32.185 //y2=4.265
r827 (  75 78 ) resistor r=0.1875 //w=0.17 //l=0.262393 //layer=m2 \
 //thickness=0.36 //x=31.93 //y=4.25 //x2=32.185 //y2=4.265
r828 (  75 76 ) resistor r=0.997137 //w=0.131 //l=1.045 //layer=m2 \
 //thickness=0.36 //x=31.93 //y=4.25 //x2=30.885 //y2=4.25
r829 (  73 76 ) resistor r=0.125 //w=0.17 //l=0.179722 //layer=m2 \
 //thickness=0.36 //x=30.715 //y=4.27 //x2=30.885 //y2=4.25
r830 (  73 74 ) resistor r=0.367366 //w=0.131 //l=0.385 //layer=m2 \
 //thickness=0.36 //x=30.715 //y=4.27 //x2=30.33 //y2=4.27
r831 (  71 74 ) resistor r=0.1875 //w=0.17 //l=0.264811 //layer=m2 \
 //thickness=0.36 //x=30.075 //y=4.25 //x2=30.33 //y2=4.27
r832 (  71 86 ) resistor r=2.30439 //w=0.131 //l=2.415 //layer=m2 \
 //thickness=0.36 //x=30.075 //y=4.25 //x2=27.66 //y2=4.25
r833 (  70 164 ) resistor r=9.3 //w=0.17 //l=0.17 //layer=mcon //count=1 \
 //x=50.84 //y=4.88 //x2=50.84 //y2=4.88
r834 (  66 155 ) resistor r=9.3 //w=0.17 //l=0.17 //layer=mcon //count=1 \
 //x=50.81 //y=2.26 //x2=50.81 //y2=2.26
r835 (  66 68 ) resistor r=0.0936408 //w=0.196 //l=0.125 //layer=m1 \
 //thickness=0.36 //x=50.812 //y=2.26 //x2=50.812 //y2=2.385
r836 (  64 92 ) resistor r=4.5 //w=0.15 //l=0.15 //layer=via1 //count=1 \
 //x=50.8 //y=4.255 //x2=50.8 //y2=4.255
r837 (  62 64 ) resistor r=0.00168464 //w=0.371 //l=0.005 //layer=m1 \
 //thickness=0.36 //x=50.752 //y=4.25 //x2=50.752 //y2=4.255
r838 (  60 90 ) resistor r=4.5 //w=0.15 //l=0.15 //layer=via1 //count=1 \
 //x=43.415 //y=4.255 //x2=43.415 //y2=4.255
r839 (  58 60 ) resistor r=0.00164908 //w=0.379 //l=0.005 //layer=m1 \
 //thickness=0.36 //x=43.36 //y=4.25 //x2=43.36 //y2=4.255
r840 (  56 268 ) resistor r=9.3 //w=0.17 //l=0.17 //layer=mcon //count=1 \
 //x=42.925 //y=1.19 //x2=42.925 //y2=1.19
r841 (  54 138 ) resistor r=9.3 //w=0.17 //l=0.17 //layer=mcon //count=1 \
 //x=42.63 //y=5.56 //x2=42.63 //y2=5.56
r842 (  51 130 ) resistor r=9.3 //w=0.17 //l=0.17 //layer=mcon //count=1 \
 //x=41.75 //y=5.56 //x2=41.75 //y2=5.56
r843 (  49 51 ) resistor r=0.121228 //w=0.232 //l=0.225 //layer=m1 \
 //thickness=0.36 //x=41.75 //y=5.335 //x2=41.75 //y2=5.56
r844 (  48 122 ) resistor r=9.3 //w=0.17 //l=0.17 //layer=mcon //count=1 \
 //x=40.87 //y=5.56 //x2=40.87 //y2=5.56
r845 (  46 48 ) resistor r=0.129608 //w=0.217 //l=0.225 //layer=m1 \
 //thickness=0.36 //x=40.872 //y=5.335 //x2=40.872 //y2=5.56
r846 (  45 117 ) resistor r=9.3 //w=0.17 //l=0.17 //layer=mcon //count=1 \
 //x=37.89 //y=4.88 //x2=37.89 //y2=4.88
r847 (  41 108 ) resistor r=9.3 //w=0.17 //l=0.17 //layer=mcon //count=1 \
 //x=37.86 //y=2.26 //x2=37.86 //y2=2.26
r848 (  41 43 ) resistor r=0.0936408 //w=0.196 //l=0.125 //layer=m1 \
 //thickness=0.36 //x=37.862 //y=2.26 //x2=37.862 //y2=2.385
r849 (  38 88 ) resistor r=4.5 //w=0.15 //l=0.15 //layer=via1 //count=1 \
 //x=37.865 //y=4.25 //x2=37.865 //y2=4.25
r850 (  36 84 ) resistor r=4.5 //w=0.15 //l=0.15 //layer=via1 //count=1 \
 //x=27.5 //y=4.26 //x2=27.5 //y2=4.26
r851 (  34 36 ) resistor r=0.00332447 //w=0.376 //l=0.01 //layer=m1 \
 //thickness=0.36 //x=27.552 //y=4.25 //x2=27.552 //y2=4.26
r852 (  32 103 ) resistor r=9.3 //w=0.17 //l=0.17 //layer=mcon //count=1 \
 //x=27.5 //y=4.88 //x2=27.5 //y2=4.88
r853 (  30 94 ) resistor r=9.3 //w=0.17 //l=0.17 //layer=mcon //count=1 \
 //x=27.5 //y=2.26 //x2=27.5 //y2=2.26
r854 (  28 70 ) resistor r=0.0878548 //w=0.228 //l=0.159295 //layer=m1 \
 //thickness=0.36 //x=50.81 //y=4.735 //x2=50.84 //y2=4.88
r855 (  27 64 ) resistor r=0.0909648 //w=0.371 //l=0.186762 //layer=m1 \
 //thickness=0.36 //x=50.81 //y=4.415 //x2=50.752 //y2=4.255
r856 (  27 28 ) resistor r=0.305344 //w=0.131 //l=0.32 //layer=m1 \
 //thickness=0.36 //x=50.81 //y=4.415 //x2=50.81 //y2=4.735
r857 (  26 62 ) resistor r=0.0892801 //w=0.371 //l=0.1817 //layer=m1 \
 //thickness=0.36 //x=50.81 //y=4.095 //x2=50.752 //y2=4.25
r858 (  26 68 ) resistor r=1.63168 //w=0.131 //l=1.71 //layer=m1 \
 //thickness=0.36 //x=50.81 //y=4.095 //x2=50.81 //y2=2.385
r859 (  23 60 ) resistor r=0.0912814 //w=0.379 //l=0.183303 //layer=m1 \
 //thickness=0.36 //x=43.41 //y=4.415 //x2=43.36 //y2=4.255
r860 (  23 24 ) resistor r=0.796756 //w=0.131 //l=0.835 //layer=m1 \
 //thickness=0.36 //x=43.41 //y=4.415 //x2=43.41 //y2=5.25
r861 (  22 58 ) resistor r=0.0896323 //w=0.379 //l=0.178255 //layer=m1 \
 //thickness=0.36 //x=43.41 //y=4.095 //x2=43.36 //y2=4.25
r862 (  21 22 ) resistor r=2.06584 //w=0.131 //l=2.165 //layer=m1 \
 //thickness=0.36 //x=43.41 //y=1.93 //x2=43.41 //y2=4.095
r863 (  19 21 ) resistor r=0.0698411 //w=0.17 //l=0.120208 //layer=m1 \
 //thickness=0.36 //x=43.325 //y=1.845 //x2=43.41 //y2=1.93
r864 (  19 20 ) resistor r=0.300573 //w=0.131 //l=0.315 //layer=m1 \
 //thickness=0.36 //x=43.325 //y=1.845 //x2=43.01 //y2=1.845
r865 (  18 20 ) resistor r=0.0698411 //w=0.17 //l=0.120208 //layer=m1 \
 //thickness=0.36 //x=42.925 //y=1.76 //x2=43.01 //y2=1.845
r866 (  17 56 ) resistor r=0.0717383 //w=0.224 //l=0.115 //layer=m1 \
 //thickness=0.36 //x=42.925 //y=1.305 //x2=42.925 //y2=1.19
r867 (  17 18 ) resistor r=0.43416 //w=0.131 //l=0.455 //layer=m1 \
 //thickness=0.36 //x=42.925 //y=1.305 //x2=42.925 //y2=1.76
r868 (  16 52 ) resistor r=0.0675342 //w=0.23 //l=0.115 //layer=m1 \
 //thickness=0.36 //x=42.745 //y=5.335 //x2=42.63 //y2=5.335
r869 (  15 24 ) resistor r=0.0698411 //w=0.17 //l=0.120208 //layer=m1 \
 //thickness=0.36 //x=43.325 //y=5.335 //x2=43.41 //y2=5.25
r870 (  15 16 ) resistor r=0.553435 //w=0.131 //l=0.58 //layer=m1 \
 //thickness=0.36 //x=43.325 //y=5.335 //x2=42.745 //y2=5.335
r871 (  14 54 ) resistor r=0.00118313 //w=0.23 //layer=m1 //thickness=0.36 \
 //x=42.63 //y=5.56 //x2=42.63 //y2=5.56
r872 (  13 52 ) resistor r=0.002872 //w=0.34 //l=0.085 //layer=m1 \
 //thickness=0.36 //x=42.63 //y=5.42 //x2=42.63 //y2=5.335
r873 (  13 14 ) resistor r=0.091623 //w=0.191 //l=0.14 //layer=m1 \
 //thickness=0.36 //x=42.63 //y=5.42 //x2=42.63 //y2=5.56
r874 (  12 49 ) resistor r=0.0262263 //w=0.232 //l=0.12 //layer=m1 \
 //thickness=0.36 //x=41.87 //y=5.335 //x2=41.75 //y2=5.335
r875 (  11 52 ) resistor r=0.0675342 //w=0.23 //l=0.115 //layer=m1 \
 //thickness=0.36 //x=42.515 //y=5.335 //x2=42.63 //y2=5.335
r876 (  11 12 ) resistor r=0.615458 //w=0.131 //l=0.645 //layer=m1 \
 //thickness=0.36 //x=42.515 //y=5.335 //x2=41.87 //y2=5.335
r877 (  10 46 ) resistor r=0.0222262 //w=0.217 //l=0.118 //layer=m1 \
 //thickness=0.36 //x=40.99 //y=5.335 //x2=40.872 //y2=5.335
r878 (  9 49 ) resistor r=0.0262263 //w=0.232 //l=0.12 //layer=m1 \
 //thickness=0.36 //x=41.63 //y=5.335 //x2=41.75 //y2=5.335
r879 (  9 10 ) resistor r=0.610687 //w=0.131 //l=0.64 //layer=m1 \
 //thickness=0.36 //x=41.63 //y=5.335 //x2=40.99 //y2=5.335
r880 (  8 45 ) resistor r=0.0878548 //w=0.228 //l=0.159295 //layer=m1 \
 //thickness=0.36 //x=37.86 //y=4.735 //x2=37.89 //y2=4.88
r881 (  7 38 ) resistor r=0.0912814 //w=0.379 //l=0.183303 //layer=m1 \
 //thickness=0.36 //x=37.86 //y=4.41 //x2=37.81 //y2=4.25
r882 (  7 8 ) resistor r=0.310115 //w=0.131 //l=0.325 //layer=m1 \
 //thickness=0.36 //x=37.86 //y=4.41 //x2=37.86 //y2=4.735
r883 (  6 38 ) resistor r=0.0912814 //w=0.379 //l=0.183303 //layer=m1 \
 //thickness=0.36 //x=37.86 //y=4.09 //x2=37.81 //y2=4.25
r884 (  6 43 ) resistor r=1.62691 //w=0.131 //l=1.705 //layer=m1 \
 //thickness=0.36 //x=37.86 //y=4.09 //x2=37.86 //y2=2.385
r885 (  4 32 ) resistor r=0.0760407 //w=0.238 //l=0.125 //layer=m1 \
 //thickness=0.36 //x=27.5 //y=4.755 //x2=27.5 //y2=4.88
r886 (  3 36 ) resistor r=0.0911593 //w=0.376 //l=0.184174 //layer=m1 \
 //thickness=0.36 //x=27.5 //y=4.42 //x2=27.552 //y2=4.26
r887 (  3 4 ) resistor r=0.319656 //w=0.131 //l=0.335 //layer=m1 \
 //thickness=0.36 //x=27.5 //y=4.42 //x2=27.5 //y2=4.755
r888 (  2 34 ) resistor r=0.0878349 //w=0.376 //l=0.174069 //layer=m1 \
 //thickness=0.36 //x=27.5 //y=4.1 //x2=27.552 //y2=4.25
r889 (  1 30 ) resistor r=0.0719237 //w=0.222 //l=0.115 //layer=m1 \
 //thickness=0.36 //x=27.5 //y=2.375 //x2=27.5 //y2=2.26
r890 (  1 2 ) resistor r=1.64599 //w=0.131 //l=1.725 //layer=m1 \
 //thickness=0.36 //x=27.5 //y=2.375 //x2=27.5 //y2=4.1
ends PM_TMRDFFRNQX1\%noxref_9

subckt PM_TMRDFFRNQX1\%D ( 1 2 3 4 5 6 8 9 10 11 12 13 14 15 30 36 39 40 47 48 \
 50 53 62 67 76 81 90 94 95 96 97 98 99 100 101 102 103 104 105 107 113 114 \
 115 116 117 122 123 124 126 132 133 134 135 136 141 142 143 145 151 152 153 \
 154 155 163 174 185 )
c581 ( 185 0 ) capacitor c=0.0369044f //x=59.32 //y=4.88
c582 ( 174 0 ) capacitor c=0.0369044f //x=33.42 //y=4.88
c583 ( 163 0 ) capacitor c=0.0369044f //x=7.52 //y=4.88
c584 ( 155 0 ) capacitor c=0.0309248f //x=59.655 //y=4.97
c585 ( 154 0 ) capacitor c=0.0817369f //x=59.41 //y=2.095
c586 ( 153 0 ) capacitor c=0.0170266f //x=59.41 //y=1.63
c587 ( 152 0 ) capacitor c=0.018609f //x=59.41 //y=1.4
c588 ( 151 0 ) capacitor c=0.0186599f //x=59.41 //y=1.09
c589 ( 145 0 ) capacitor c=0.0146988f //x=59.255 //y=1.555
c590 ( 143 0 ) capacitor c=0.0148531f //x=59.255 //y=0.935
c591 ( 142 0 ) capacitor c=0.0334406f //x=58.885 //y=1.4
c592 ( 141 0 ) capacitor c=0.0173191f //x=58.885 //y=1.09
c593 ( 136 0 ) capacitor c=0.0309248f //x=33.755 //y=4.97
c594 ( 135 0 ) capacitor c=0.0817356f //x=33.51 //y=2.095
c595 ( 134 0 ) capacitor c=0.0170266f //x=33.51 //y=1.63
c596 ( 133 0 ) capacitor c=0.018609f //x=33.51 //y=1.4
c597 ( 132 0 ) capacitor c=0.0186599f //x=33.51 //y=1.09
c598 ( 126 0 ) capacitor c=0.0146988f //x=33.355 //y=1.555
c599 ( 124 0 ) capacitor c=0.0148531f //x=33.355 //y=0.935
c600 ( 123 0 ) capacitor c=0.0334406f //x=32.985 //y=1.4
c601 ( 122 0 ) capacitor c=0.0173191f //x=32.985 //y=1.09
c602 ( 117 0 ) capacitor c=0.0309248f //x=7.855 //y=4.97
c603 ( 116 0 ) capacitor c=0.0817382f //x=7.61 //y=2.095
c604 ( 115 0 ) capacitor c=0.0170266f //x=7.61 //y=1.63
c605 ( 114 0 ) capacitor c=0.018609f //x=7.61 //y=1.4
c606 ( 113 0 ) capacitor c=0.0186599f //x=7.61 //y=1.09
c607 ( 107 0 ) capacitor c=0.0146988f //x=7.455 //y=1.555
c608 ( 105 0 ) capacitor c=0.0148531f //x=7.455 //y=0.935
c609 ( 104 0 ) capacitor c=0.0334406f //x=7.085 //y=1.4
c610 ( 103 0 ) capacitor c=0.0173191f //x=7.085 //y=1.09
c611 ( 102 0 ) capacitor c=0.110208f //x=59.73 //y=6.2
c612 ( 101 0 ) capacitor c=0.110214f //x=59.29 //y=6.2
c613 ( 100 0 ) capacitor c=0.110208f //x=33.83 //y=6.2
c614 ( 99 0 ) capacitor c=0.110214f //x=33.39 //y=6.2
c615 ( 98 0 ) capacitor c=0.110208f //x=7.93 //y=6.2
c616 ( 97 0 ) capacitor c=0.110214f //x=7.49 //y=6.2
c617 ( 90 0 ) capacitor c=0.00129935f //x=59.32 //y=4.88
c618 ( 81 0 ) capacitor c=9.49278e-19 //x=59.32 //y=2.26
c619 ( 76 0 ) capacitor c=0.00129935f //x=33.42 //y=4.88
c620 ( 67 0 ) capacitor c=9.49278e-19 //x=33.42 //y=2.26
c621 ( 62 0 ) capacitor c=0.00129935f //x=7.52 //y=4.88
c622 ( 53 0 ) capacitor c=9.49278e-19 //x=7.52 //y=2.26
c623 ( 50 0 ) capacitor c=0.00503265f //x=59.335 //y=2.77
c624 ( 48 0 ) capacitor c=6.8999e-19 //x=33.585 //y=2.765
c625 ( 47 0 ) capacitor c=0.287256f //x=33.265 //y=2.765
c626 ( 40 0 ) capacitor c=0.230263f //x=59.175 //y=2.77
c627 ( 39 0 ) capacitor c=0.00268681f //x=7.68 //y=2.77
c628 ( 36 0 ) capacitor c=0.0159924f //x=59.32 //y=2.77
c629 ( 30 0 ) capacitor c=0.0162528f //x=33.42 //y=2.77
c630 ( 15 0 ) capacitor c=0.0537264f //x=59.32 //y=4.765
c631 ( 14 0 ) capacitor c=0.0128867f //x=59.32 //y=2.93
c632 ( 13 0 ) capacitor c=0.0041461f //x=59.32 //y=2.61
c633 ( 12 0 ) capacitor c=0.00359985f //x=59.32 //y=2.375
c634 ( 11 0 ) capacitor c=0.0539384f //x=33.42 //y=4.765
c635 ( 10 0 ) capacitor c=0.0121968f //x=33.42 //y=2.925
c636 ( 9 0 ) capacitor c=0.00410635f //x=33.42 //y=2.605
c637 ( 8 0 ) capacitor c=0.00352451f //x=33.42 //y=2.375
c638 ( 6 0 ) capacitor c=0.00495197f //x=7.52 //y=4.765
c639 ( 5 0 ) capacitor c=0.0122758f //x=7.52 //y=2.93
c640 ( 4 0 ) capacitor c=0.00514022f //x=7.52 //y=2.61
c641 ( 3 0 ) capacitor c=0.00503322f //x=7.52 //y=2.375
c642 ( 2 0 ) capacitor c=0.0159924f //x=7.52 //y=2.77
c643 ( 1 0 ) capacitor c=0.0515484f //x=7.52 //y=3.14
r644 (  187 188 ) resistor r=32.4568 //w=0.214 //l=0.075 //layer=ply \
 //thickness=0.18 //x=59.32 //y=4.97 //x2=59.32 //y2=5.045
r645 (  185 187 ) resistor r=20.271 //w=0.214 //l=0.09 //layer=ply \
 //thickness=0.18 //x=59.32 //y=4.88 //x2=59.32 //y2=4.97
r646 (  176 177 ) resistor r=32.4568 //w=0.214 //l=0.075 //layer=ply \
 //thickness=0.18 //x=33.42 //y=4.97 //x2=33.42 //y2=5.045
r647 (  174 176 ) resistor r=20.271 //w=0.214 //l=0.09 //layer=ply \
 //thickness=0.18 //x=33.42 //y=4.88 //x2=33.42 //y2=4.97
r648 (  165 166 ) resistor r=32.4568 //w=0.214 //l=0.075 //layer=ply \
 //thickness=0.18 //x=7.52 //y=4.97 //x2=7.52 //y2=5.045
r649 (  163 165 ) resistor r=20.271 //w=0.214 //l=0.09 //layer=ply \
 //thickness=0.18 //x=7.52 //y=4.88 //x2=7.52 //y2=4.97
r650 (  156 187 ) resistor r=16.5046 //w=0.27 //l=0.135 //layer=ply \
 //thickness=0.18 //x=59.455 //y=4.97 //x2=59.32 //y2=4.97
r651 (  155 157 ) resistor r=26.9307 //w=0.15 //l=0.106066 //layer=ply \
 //thickness=0.18 //x=59.655 //y=4.97 //x2=59.73 //y2=5.045
r652 (  155 156 ) resistor r=102.553 //w=0.094 //l=0.2 //layer=ply \
 //thickness=0.18 //x=59.655 //y=4.97 //x2=59.455 //y2=4.97
r653 (  154 192 ) resistor r=38.6777 //w=0.284 //l=0.198997 //layer=ply \
 //thickness=0.18 //x=59.41 //y=2.095 //x2=59.335 //y2=2.26
r654 (  153 190 ) resistor r=21.2976 //w=0.217 //l=0.0928709 //layer=ply \
 //thickness=0.18 //x=59.41 //y=1.63 //x2=59.37 //y2=1.555
r655 (  153 154 ) resistor r=238.436 //w=0.094 //l=0.465 //layer=ply \
 //thickness=0.18 //x=59.41 //y=1.63 //x2=59.41 //y2=2.095
r656 (  152 190 ) resistor r=39.0671 //w=0.217 //l=0.173853 //layer=ply \
 //thickness=0.18 //x=59.41 //y=1.4 //x2=59.37 //y2=1.555
r657 (  151 189 ) resistor r=45.1352 //w=0.168 //l=0.173853 //layer=ply \
 //thickness=0.18 //x=59.41 //y=1.09 //x2=59.37 //y2=0.935
r658 (  151 152 ) resistor r=158.957 //w=0.094 //l=0.31 //layer=ply \
 //thickness=0.18 //x=59.41 //y=1.09 //x2=59.41 //y2=1.4
r659 (  146 183 ) resistor r=5.52526 //w=0.168 //l=0.115 //layer=ply \
 //thickness=0.18 //x=59.04 //y=1.555 //x2=58.925 //y2=1.555
r660 (  145 190 ) resistor r=11.4558 //w=0.217 //l=0.115 //layer=ply \
 //thickness=0.18 //x=59.255 //y=1.555 //x2=59.37 //y2=1.555
r661 (  144 182 ) resistor r=5.52526 //w=0.168 //l=0.115 //layer=ply \
 //thickness=0.18 //x=59.04 //y=0.935 //x2=58.925 //y2=0.935
r662 (  143 189 ) resistor r=5.52526 //w=0.168 //l=0.115 //layer=ply \
 //thickness=0.18 //x=59.255 //y=0.935 //x2=59.37 //y2=0.935
r663 (  143 144 ) resistor r=110.245 //w=0.094 //l=0.215 //layer=ply \
 //thickness=0.18 //x=59.255 //y=0.935 //x2=59.04 //y2=0.935
r664 (  142 183 ) resistor r=45.1352 //w=0.168 //l=0.173853 //layer=ply \
 //thickness=0.18 //x=58.885 //y=1.4 //x2=58.925 //y2=1.555
r665 (  141 182 ) resistor r=45.1352 //w=0.168 //l=0.173853 //layer=ply \
 //thickness=0.18 //x=58.885 //y=1.09 //x2=58.925 //y2=0.935
r666 (  141 142 ) resistor r=158.957 //w=0.094 //l=0.31 //layer=ply \
 //thickness=0.18 //x=58.885 //y=1.09 //x2=58.885 //y2=1.4
r667 (  137 176 ) resistor r=16.5046 //w=0.27 //l=0.135 //layer=ply \
 //thickness=0.18 //x=33.555 //y=4.97 //x2=33.42 //y2=4.97
r668 (  136 138 ) resistor r=26.9307 //w=0.15 //l=0.106066 //layer=ply \
 //thickness=0.18 //x=33.755 //y=4.97 //x2=33.83 //y2=5.045
r669 (  136 137 ) resistor r=102.553 //w=0.094 //l=0.2 //layer=ply \
 //thickness=0.18 //x=33.755 //y=4.97 //x2=33.555 //y2=4.97
r670 (  135 181 ) resistor r=38.6777 //w=0.284 //l=0.198997 //layer=ply \
 //thickness=0.18 //x=33.51 //y=2.095 //x2=33.435 //y2=2.26
r671 (  134 179 ) resistor r=21.2976 //w=0.217 //l=0.0928709 //layer=ply \
 //thickness=0.18 //x=33.51 //y=1.63 //x2=33.47 //y2=1.555
r672 (  134 135 ) resistor r=238.436 //w=0.094 //l=0.465 //layer=ply \
 //thickness=0.18 //x=33.51 //y=1.63 //x2=33.51 //y2=2.095
r673 (  133 179 ) resistor r=39.0671 //w=0.217 //l=0.173853 //layer=ply \
 //thickness=0.18 //x=33.51 //y=1.4 //x2=33.47 //y2=1.555
r674 (  132 178 ) resistor r=45.1352 //w=0.168 //l=0.173853 //layer=ply \
 //thickness=0.18 //x=33.51 //y=1.09 //x2=33.47 //y2=0.935
r675 (  132 133 ) resistor r=158.957 //w=0.094 //l=0.31 //layer=ply \
 //thickness=0.18 //x=33.51 //y=1.09 //x2=33.51 //y2=1.4
r676 (  127 172 ) resistor r=5.52526 //w=0.168 //l=0.115 //layer=ply \
 //thickness=0.18 //x=33.14 //y=1.555 //x2=33.025 //y2=1.555
r677 (  126 179 ) resistor r=11.4558 //w=0.217 //l=0.115 //layer=ply \
 //thickness=0.18 //x=33.355 //y=1.555 //x2=33.47 //y2=1.555
r678 (  125 171 ) resistor r=5.52526 //w=0.168 //l=0.115 //layer=ply \
 //thickness=0.18 //x=33.14 //y=0.935 //x2=33.025 //y2=0.935
r679 (  124 178 ) resistor r=5.52526 //w=0.168 //l=0.115 //layer=ply \
 //thickness=0.18 //x=33.355 //y=0.935 //x2=33.47 //y2=0.935
r680 (  124 125 ) resistor r=110.245 //w=0.094 //l=0.215 //layer=ply \
 //thickness=0.18 //x=33.355 //y=0.935 //x2=33.14 //y2=0.935
r681 (  123 172 ) resistor r=45.1352 //w=0.168 //l=0.173853 //layer=ply \
 //thickness=0.18 //x=32.985 //y=1.4 //x2=33.025 //y2=1.555
r682 (  122 171 ) resistor r=45.1352 //w=0.168 //l=0.173853 //layer=ply \
 //thickness=0.18 //x=32.985 //y=1.09 //x2=33.025 //y2=0.935
r683 (  122 123 ) resistor r=158.957 //w=0.094 //l=0.31 //layer=ply \
 //thickness=0.18 //x=32.985 //y=1.09 //x2=32.985 //y2=1.4
r684 (  118 165 ) resistor r=16.5046 //w=0.27 //l=0.135 //layer=ply \
 //thickness=0.18 //x=7.655 //y=4.97 //x2=7.52 //y2=4.97
r685 (  117 119 ) resistor r=26.9307 //w=0.15 //l=0.106066 //layer=ply \
 //thickness=0.18 //x=7.855 //y=4.97 //x2=7.93 //y2=5.045
r686 (  117 118 ) resistor r=102.553 //w=0.094 //l=0.2 //layer=ply \
 //thickness=0.18 //x=7.855 //y=4.97 //x2=7.655 //y2=4.97
r687 (  116 170 ) resistor r=38.6777 //w=0.284 //l=0.198997 //layer=ply \
 //thickness=0.18 //x=7.61 //y=2.095 //x2=7.535 //y2=2.26
r688 (  115 168 ) resistor r=21.2976 //w=0.217 //l=0.0928709 //layer=ply \
 //thickness=0.18 //x=7.61 //y=1.63 //x2=7.57 //y2=1.555
r689 (  115 116 ) resistor r=238.436 //w=0.094 //l=0.465 //layer=ply \
 //thickness=0.18 //x=7.61 //y=1.63 //x2=7.61 //y2=2.095
r690 (  114 168 ) resistor r=39.0671 //w=0.217 //l=0.173853 //layer=ply \
 //thickness=0.18 //x=7.61 //y=1.4 //x2=7.57 //y2=1.555
r691 (  113 167 ) resistor r=45.1352 //w=0.168 //l=0.173853 //layer=ply \
 //thickness=0.18 //x=7.61 //y=1.09 //x2=7.57 //y2=0.935
r692 (  113 114 ) resistor r=158.957 //w=0.094 //l=0.31 //layer=ply \
 //thickness=0.18 //x=7.61 //y=1.09 //x2=7.61 //y2=1.4
r693 (  108 161 ) resistor r=5.52526 //w=0.168 //l=0.115 //layer=ply \
 //thickness=0.18 //x=7.24 //y=1.555 //x2=7.125 //y2=1.555
r694 (  107 168 ) resistor r=11.4558 //w=0.217 //l=0.115 //layer=ply \
 //thickness=0.18 //x=7.455 //y=1.555 //x2=7.57 //y2=1.555
r695 (  106 160 ) resistor r=5.52526 //w=0.168 //l=0.115 //layer=ply \
 //thickness=0.18 //x=7.24 //y=0.935 //x2=7.125 //y2=0.935
r696 (  105 167 ) resistor r=5.52526 //w=0.168 //l=0.115 //layer=ply \
 //thickness=0.18 //x=7.455 //y=0.935 //x2=7.57 //y2=0.935
r697 (  105 106 ) resistor r=110.245 //w=0.094 //l=0.215 //layer=ply \
 //thickness=0.18 //x=7.455 //y=0.935 //x2=7.24 //y2=0.935
r698 (  104 161 ) resistor r=45.1352 //w=0.168 //l=0.173853 //layer=ply \
 //thickness=0.18 //x=7.085 //y=1.4 //x2=7.125 //y2=1.555
r699 (  103 160 ) resistor r=45.1352 //w=0.168 //l=0.173853 //layer=ply \
 //thickness=0.18 //x=7.085 //y=1.09 //x2=7.125 //y2=0.935
r700 (  103 104 ) resistor r=158.957 //w=0.094 //l=0.31 //layer=ply \
 //thickness=0.18 //x=7.085 //y=1.09 //x2=7.085 //y2=1.4
r701 (  102 157 ) resistor r=592.245 //w=0.094 //l=1.155 //layer=ply \
 //thickness=0.18 //x=59.73 //y=6.2 //x2=59.73 //y2=5.045
r702 (  101 188 ) resistor r=592.245 //w=0.094 //l=1.155 //layer=ply \
 //thickness=0.18 //x=59.29 //y=6.2 //x2=59.29 //y2=5.045
r703 (  100 138 ) resistor r=592.245 //w=0.094 //l=1.155 //layer=ply \
 //thickness=0.18 //x=33.83 //y=6.2 //x2=33.83 //y2=5.045
r704 (  99 177 ) resistor r=592.245 //w=0.094 //l=1.155 //layer=ply \
 //thickness=0.18 //x=33.39 //y=6.2 //x2=33.39 //y2=5.045
r705 (  98 119 ) resistor r=592.245 //w=0.094 //l=1.155 //layer=ply \
 //thickness=0.18 //x=7.93 //y=6.2 //x2=7.93 //y2=5.045
r706 (  97 166 ) resistor r=592.245 //w=0.094 //l=1.155 //layer=ply \
 //thickness=0.18 //x=7.49 //y=6.2 //x2=7.49 //y2=5.045
r707 (  96 145 ) resistor r=55.3787 //w=0.094 //l=0.108 //layer=ply \
 //thickness=0.18 //x=59.147 //y=1.555 //x2=59.255 //y2=1.555
r708 (  96 146 ) resistor r=54.866 //w=0.094 //l=0.107 //layer=ply \
 //thickness=0.18 //x=59.147 //y=1.555 //x2=59.04 //y2=1.555
r709 (  95 126 ) resistor r=55.3787 //w=0.094 //l=0.108 //layer=ply \
 //thickness=0.18 //x=33.247 //y=1.555 //x2=33.355 //y2=1.555
r710 (  95 127 ) resistor r=54.866 //w=0.094 //l=0.107 //layer=ply \
 //thickness=0.18 //x=33.247 //y=1.555 //x2=33.14 //y2=1.555
r711 (  94 107 ) resistor r=55.3787 //w=0.094 //l=0.108 //layer=ply \
 //thickness=0.18 //x=7.347 //y=1.555 //x2=7.455 //y2=1.555
r712 (  94 108 ) resistor r=54.866 //w=0.094 //l=0.107 //layer=ply \
 //thickness=0.18 //x=7.347 //y=1.555 //x2=7.24 //y2=1.555
r713 (  90 185 ) resistor r=152 //w=0.17 //l=0.17 //layer=licon //count=1 \
 //x=59.32 //y=4.88 //x2=59.32 //y2=4.88
r714 (  81 192 ) resistor r=152 //w=0.17 //l=0.17 //layer=licon //count=1 \
 //x=59.32 //y=2.26 //x2=59.32 //y2=2.26
r715 (  76 174 ) resistor r=152 //w=0.17 //l=0.17 //layer=licon //count=1 \
 //x=33.42 //y=4.88 //x2=33.42 //y2=4.88
r716 (  67 181 ) resistor r=152 //w=0.17 //l=0.17 //layer=licon //count=1 \
 //x=33.42 //y=2.26 //x2=33.42 //y2=2.26
r717 (  62 163 ) resistor r=152 //w=0.17 //l=0.17 //layer=licon //count=1 \
 //x=7.52 //y=4.88 //x2=7.52 //y2=4.88
r718 (  53 170 ) resistor r=152 //w=0.17 //l=0.17 //layer=licon //count=1 \
 //x=7.52 //y=2.26 //x2=7.52 //y2=2.26
r719 (  46 48 ) resistor r=0.10734 //w=0.281 //l=0.16 //layer=m2 \
 //thickness=0.36 //x=33.425 //y=2.765 //x2=33.585 //y2=2.765
r720 (  46 47 ) resistor r=0.10734 //w=0.281 //l=0.16 //layer=m2 \
 //thickness=0.36 //x=33.425 //y=2.765 //x2=33.265 //y2=2.765
r721 (  40 50 ) resistor r=0.10734 //w=0.281 //l=0.16 //layer=m2 \
 //thickness=0.36 //x=59.175 //y=2.77 //x2=59.335 //y2=2.77
r722 (  40 48 ) resistor r=24.4179 //w=0.131 //l=25.59 //layer=m2 \
 //thickness=0.36 //x=59.175 //y=2.77 //x2=33.585 //y2=2.77
r723 (  39 43 ) resistor r=0.10734 //w=0.281 //l=0.16 //layer=m2 \
 //thickness=0.36 //x=7.68 //y=2.77 //x2=7.52 //y2=2.77
r724 (  39 47 ) resistor r=24.4132 //w=0.131 //l=25.585 //layer=m2 \
 //thickness=0.36 //x=7.68 //y=2.77 //x2=33.265 //y2=2.77
r725 (  36 50 ) resistor r=4.5 //w=0.15 //l=0.15 //layer=via1 //count=1 \
 //x=59.335 //y=2.77 //x2=59.335 //y2=2.77
r726 (  34 90 ) resistor r=9.3 //w=0.17 //l=0.17 //layer=mcon //count=1 \
 //x=59.32 //y=4.88 //x2=59.32 //y2=4.88
r727 (  32 81 ) resistor r=9.3 //w=0.17 //l=0.17 //layer=mcon //count=1 \
 //x=59.32 //y=2.26 //x2=59.32 //y2=2.26
r728 (  28 46 ) resistor r=4.5 //w=0.15 //l=0.15 //layer=via1 //count=1 \
 //x=33.425 //y=2.765 //x2=33.425 //y2=2.765
r729 (  28 30 ) resistor r=0.00167112 //w=0.374 //l=0.005 //layer=m1 \
 //thickness=0.36 //x=33.475 //y=2.765 //x2=33.475 //y2=2.77
r730 (  26 76 ) resistor r=9.3 //w=0.17 //l=0.17 //layer=mcon //count=1 \
 //x=33.42 //y=4.88 //x2=33.42 //y2=4.88
r731 (  24 67 ) resistor r=9.3 //w=0.17 //l=0.17 //layer=mcon //count=1 \
 //x=33.42 //y=2.26 //x2=33.42 //y2=2.26
r732 (  19 62 ) resistor r=9.3 //w=0.17 //l=0.17 //layer=mcon //count=1 \
 //x=7.52 //y=4.88 //x2=7.52 //y2=4.88
r733 (  17 53 ) resistor r=9.3 //w=0.17 //l=0.17 //layer=mcon //count=1 \
 //x=7.52 //y=2.26 //x2=7.52 //y2=2.26
r734 (  15 34 ) resistor r=0.0717383 //w=0.224 //l=0.115 //layer=m1 \
 //thickness=0.36 //x=59.32 //y=4.765 //x2=59.32 //y2=4.88
r735 (  14 36 ) resistor r=0.0908536 //w=0.368 //l=0.187617 //layer=m1 \
 //thickness=0.36 //x=59.32 //y=2.93 //x2=59.38 //y2=2.77
r736 (  14 15 ) resistor r=1.75095 //w=0.131 //l=1.835 //layer=m1 \
 //thickness=0.36 //x=59.32 //y=2.93 //x2=59.32 //y2=4.765
r737 (  13 36 ) resistor r=0.0908536 //w=0.368 //l=0.187617 //layer=m1 \
 //thickness=0.36 //x=59.32 //y=2.61 //x2=59.38 //y2=2.77
r738 (  12 32 ) resistor r=0.0715665 //w=0.226 //l=0.115996 //layer=m1 \
 //thickness=0.36 //x=59.32 //y=2.375 //x2=59.322 //y2=2.26
r739 (  12 13 ) resistor r=0.224237 //w=0.131 //l=0.235 //layer=m1 \
 //thickness=0.36 //x=59.32 //y=2.375 //x2=59.32 //y2=2.61
r740 (  11 26 ) resistor r=0.0717383 //w=0.224 //l=0.115 //layer=m1 \
 //thickness=0.36 //x=33.42 //y=4.765 //x2=33.42 //y2=4.88
r741 (  10 30 ) resistor r=0.089409 //w=0.374 //l=0.180416 //layer=m1 \
 //thickness=0.36 //x=33.42 //y=2.925 //x2=33.475 //y2=2.77
r742 (  10 11 ) resistor r=1.75573 //w=0.131 //l=1.84 //layer=m1 \
 //thickness=0.36 //x=33.42 //y=2.925 //x2=33.42 //y2=4.765
r743 (  9 28 ) resistor r=0.0910802 //w=0.374 //l=0.185472 //layer=m1 \
 //thickness=0.36 //x=33.42 //y=2.605 //x2=33.475 //y2=2.765
r744 (  8 24 ) resistor r=0.0715665 //w=0.226 //l=0.115996 //layer=m1 \
 //thickness=0.36 //x=33.42 //y=2.375 //x2=33.422 //y2=2.26
r745 (  8 9 ) resistor r=0.219466 //w=0.131 //l=0.23 //layer=m1 \
 //thickness=0.36 //x=33.42 //y=2.375 //x2=33.42 //y2=2.605
r746 (  6 19 ) resistor r=0.0717383 //w=0.224 //l=0.115 //layer=m1 \
 //thickness=0.36 //x=7.52 //y=4.765 //x2=7.52 //y2=4.88
r747 (  3 17 ) resistor r=0.0715665 //w=0.226 //l=0.115996 //layer=m1 \
 //thickness=0.36 //x=7.52 //y=2.375 //x2=7.522 //y2=2.26
r748 (  3 4 ) resistor r=0.224237 //w=0.131 //l=0.235 //layer=m1 \
 //thickness=0.36 //x=7.52 //y=2.375 //x2=7.52 //y2=2.61
r749 (  2 43 ) resistor r=4.5 //w=0.15 //l=0.15 //layer=via1 //count=1 \
 //x=7.52 //y=2.77 //x2=7.52 //y2=2.77
r750 (  2 5 ) resistor r=0.0911593 //w=0.376 //l=0.184174 //layer=m1 \
 //thickness=0.36 //x=7.572 //y=2.77 //x2=7.52 //y2=2.93
r751 (  2 4 ) resistor r=0.0911593 //w=0.376 //l=0.184174 //layer=m1 \
 //thickness=0.36 //x=7.572 //y=2.77 //x2=7.52 //y2=2.61
r752 (  1 6 ) resistor r=1.55057 //w=0.131 //l=1.625 //layer=m1 \
 //thickness=0.36 //x=7.52 //y=3.14 //x2=7.52 //y2=4.765
r753 (  1 5 ) resistor r=0.200382 //w=0.131 //l=0.21 //layer=m1 \
 //thickness=0.36 //x=7.52 //y=3.14 //x2=7.52 //y2=2.93
ends PM_TMRDFFRNQX1\%D

subckt PM_TMRDFFRNQX1\%CLK ( 1 2 3 4 5 6 7 8 9 10 11 12 13 14 15 16 17 24 28 \
 33 36 40 41 45 52 58 65 71 78 81 83 85 86 87 89 91 93 95 96 97 98 99 101 103 \
 105 107 108 109 123 128 133 138 143 148 153 158 163 168 173 178 182 183 184 \
 185 186 187 188 189 190 191 192 193 194 195 196 197 198 199 200 201 202 204 \
 210 211 212 213 214 219 220 221 223 229 230 231 232 233 238 239 240 242 248 \
 249 250 251 252 257 258 259 261 267 268 269 270 271 276 277 278 280 286 287 \
 288 289 290 295 296 297 299 305 306 307 308 309 317 328 339 350 361 372 )
c1037 ( 372 0 ) capacitor c=0.0356502f //x=67.46 //y=4.88
c1038 ( 361 0 ) capacitor c=0.0357436f //x=54.51 //y=4.88
c1039 ( 350 0 ) capacitor c=0.0356502f //x=41.56 //y=4.88
c1040 ( 339 0 ) capacitor c=0.0357436f //x=28.61 //y=4.88
c1041 ( 328 0 ) capacitor c=0.0356502f //x=15.66 //y=4.88
c1042 ( 317 0 ) capacitor c=0.0356344f //x=2.71 //y=4.88
c1043 ( 309 0 ) capacitor c=0.0306876f //x=67.795 //y=4.97
c1044 ( 308 0 ) capacitor c=0.0863671f //x=67.55 //y=2.095
c1045 ( 307 0 ) capacitor c=0.0170266f //x=67.55 //y=1.63
c1046 ( 306 0 ) capacitor c=0.018609f //x=67.55 //y=1.4
c1047 ( 305 0 ) capacitor c=0.0186599f //x=67.55 //y=1.09
c1048 ( 299 0 ) capacitor c=0.0146988f //x=67.395 //y=1.555
c1049 ( 297 0 ) capacitor c=0.0148531f //x=67.395 //y=0.935
c1050 ( 296 0 ) capacitor c=0.0334406f //x=67.025 //y=1.4
c1051 ( 295 0 ) capacitor c=0.0173191f //x=67.025 //y=1.09
c1052 ( 290 0 ) capacitor c=0.0306608f //x=54.845 //y=4.97
c1053 ( 289 0 ) capacitor c=0.0863671f //x=54.6 //y=2.095
c1054 ( 288 0 ) capacitor c=0.0170266f //x=54.6 //y=1.63
c1055 ( 287 0 ) capacitor c=0.018609f //x=54.6 //y=1.4
c1056 ( 286 0 ) capacitor c=0.0186599f //x=54.6 //y=1.09
c1057 ( 280 0 ) capacitor c=0.0146988f //x=54.445 //y=1.555
c1058 ( 278 0 ) capacitor c=0.0148531f //x=54.445 //y=0.935
c1059 ( 277 0 ) capacitor c=0.0334406f //x=54.075 //y=1.4
c1060 ( 276 0 ) capacitor c=0.0173191f //x=54.075 //y=1.09
c1061 ( 271 0 ) capacitor c=0.0306876f //x=41.895 //y=4.97
c1062 ( 270 0 ) capacitor c=0.0863671f //x=41.65 //y=2.095
c1063 ( 269 0 ) capacitor c=0.0170266f //x=41.65 //y=1.63
c1064 ( 268 0 ) capacitor c=0.018609f //x=41.65 //y=1.4
c1065 ( 267 0 ) capacitor c=0.0186599f //x=41.65 //y=1.09
c1066 ( 261 0 ) capacitor c=0.0146988f //x=41.495 //y=1.555
c1067 ( 259 0 ) capacitor c=0.0148531f //x=41.495 //y=0.935
c1068 ( 258 0 ) capacitor c=0.0334406f //x=41.125 //y=1.4
c1069 ( 257 0 ) capacitor c=0.0173191f //x=41.125 //y=1.09
c1070 ( 252 0 ) capacitor c=0.0306608f //x=28.945 //y=4.97
c1071 ( 251 0 ) capacitor c=0.0863671f //x=28.7 //y=2.095
c1072 ( 250 0 ) capacitor c=0.0170266f //x=28.7 //y=1.63
c1073 ( 249 0 ) capacitor c=0.018609f //x=28.7 //y=1.4
c1074 ( 248 0 ) capacitor c=0.0186599f //x=28.7 //y=1.09
c1075 ( 242 0 ) capacitor c=0.0146988f //x=28.545 //y=1.555
c1076 ( 240 0 ) capacitor c=0.0148531f //x=28.545 //y=0.935
c1077 ( 239 0 ) capacitor c=0.0334406f //x=28.175 //y=1.4
c1078 ( 238 0 ) capacitor c=0.0173191f //x=28.175 //y=1.09
c1079 ( 233 0 ) capacitor c=0.0306876f //x=15.995 //y=4.97
c1080 ( 232 0 ) capacitor c=0.0863671f //x=15.75 //y=2.095
c1081 ( 231 0 ) capacitor c=0.0170266f //x=15.75 //y=1.63
c1082 ( 230 0 ) capacitor c=0.018609f //x=15.75 //y=1.4
c1083 ( 229 0 ) capacitor c=0.0186599f //x=15.75 //y=1.09
c1084 ( 223 0 ) capacitor c=0.0146988f //x=15.595 //y=1.555
c1085 ( 221 0 ) capacitor c=0.0148531f //x=15.595 //y=0.935
c1086 ( 220 0 ) capacitor c=0.0334406f //x=15.225 //y=1.4
c1087 ( 219 0 ) capacitor c=0.0173191f //x=15.225 //y=1.09
c1088 ( 214 0 ) capacitor c=0.0306608f //x=3.045 //y=4.97
c1089 ( 213 0 ) capacitor c=0.0863671f //x=2.8 //y=2.095
c1090 ( 212 0 ) capacitor c=0.0170266f //x=2.8 //y=1.63
c1091 ( 211 0 ) capacitor c=0.018609f //x=2.8 //y=1.4
c1092 ( 210 0 ) capacitor c=0.0186599f //x=2.8 //y=1.09
c1093 ( 204 0 ) capacitor c=0.0146988f //x=2.645 //y=1.555
c1094 ( 202 0 ) capacitor c=0.0148531f //x=2.645 //y=0.935
c1095 ( 201 0 ) capacitor c=0.0334406f //x=2.275 //y=1.4
c1096 ( 200 0 ) capacitor c=0.0173191f //x=2.275 //y=1.09
c1097 ( 199 0 ) capacitor c=0.110208f //x=67.87 //y=6.2
c1098 ( 198 0 ) capacitor c=0.110214f //x=67.43 //y=6.2
c1099 ( 197 0 ) capacitor c=0.110208f //x=54.92 //y=6.2
c1100 ( 196 0 ) capacitor c=0.110214f //x=54.48 //y=6.2
c1101 ( 195 0 ) capacitor c=0.110208f //x=41.97 //y=6.2
c1102 ( 194 0 ) capacitor c=0.110214f //x=41.53 //y=6.2
c1103 ( 193 0 ) capacitor c=0.110208f //x=29.02 //y=6.2
c1104 ( 192 0 ) capacitor c=0.110214f //x=28.58 //y=6.2
c1105 ( 191 0 ) capacitor c=0.110208f //x=16.07 //y=6.2
c1106 ( 190 0 ) capacitor c=0.110214f //x=15.63 //y=6.2
c1107 ( 189 0 ) capacitor c=0.110208f //x=3.12 //y=6.2
c1108 ( 188 0 ) capacitor c=0.110214f //x=2.68 //y=6.2
c1109 ( 178 0 ) capacitor c=0.00129935f //x=67.46 //y=4.88
c1110 ( 173 0 ) capacitor c=0.00121786f //x=67.46 //y=2.26
c1111 ( 168 0 ) capacitor c=0.00129935f //x=54.51 //y=4.88
c1112 ( 163 0 ) capacitor c=0.00121786f //x=54.51 //y=2.26
c1113 ( 158 0 ) capacitor c=0.00129935f //x=41.56 //y=4.88
c1114 ( 153 0 ) capacitor c=0.00121786f //x=41.56 //y=2.26
c1115 ( 148 0 ) capacitor c=0.00129935f //x=28.61 //y=4.88
c1116 ( 143 0 ) capacitor c=0.00121786f //x=28.61 //y=2.26
c1117 ( 138 0 ) capacitor c=0.00129935f //x=15.66 //y=4.88
c1118 ( 133 0 ) capacitor c=0.00121786f //x=15.66 //y=2.26
c1119 ( 128 0 ) capacitor c=0.00129935f //x=2.71 //y=4.88
c1120 ( 123 0 ) capacitor c=0.00121786f //x=2.71 //y=2.26
c1121 ( 109 0 ) capacitor c=0.00444424f //x=2.705 //y=4.62
c1122 ( 108 0 ) capacitor c=0.240237f //x=63.635 //y=4.635
c1123 ( 107 0 ) capacitor c=0.0990677f //x=63.98 //y=4.635
c1124 ( 105 0 ) capacitor c=0.00751925f //x=53.615 //y=4.645
c1125 ( 103 0 ) capacitor c=0.0716877f //x=53.015 //y=4.62
c1126 ( 101 0 ) capacitor c=0.0100813f //x=51.015 //y=4.64
c1127 ( 99 0 ) capacitor c=0.170066f //x=50.415 //y=4.62
c1128 ( 98 0 ) capacitor c=0.12735f //x=43.285 //y=4.64
c1129 ( 97 0 ) capacitor c=0.0147164f //x=43.63 //y=4.64
c1130 ( 96 0 ) capacitor c=0.240211f //x=37.735 //y=4.635
c1131 ( 95 0 ) capacitor c=0.00466941f //x=38.08 //y=4.635
c1132 ( 93 0 ) capacitor c=0.00751925f //x=27.715 //y=4.645
c1133 ( 91 0 ) capacitor c=0.0755386f //x=27.115 //y=4.62
c1134 ( 89 0 ) capacitor c=0.0105682f //x=25.115 //y=4.64
c1135 ( 87 0 ) capacitor c=0.16915f //x=24.515 //y=4.62
c1136 ( 86 0 ) capacitor c=0.12735f //x=17.385 //y=4.64
c1137 ( 85 0 ) capacitor c=0.0147164f //x=17.73 //y=4.64
c1138 ( 83 0 ) capacitor c=0.00466941f //x=12.18 //y=4.635
c1139 ( 81 0 ) capacitor c=0.217676f //x=11.58 //y=4.62
c1140 ( 78 0 ) capacitor c=0.0115855f //x=67.455 //y=4.695
c1141 ( 71 0 ) capacitor c=0.00779217f //x=54.505 //y=4.835
c1142 ( 65 0 ) capacitor c=0.0115855f //x=41.555 //y=4.695
c1143 ( 58 0 ) capacitor c=0.00779217f //x=28.605 //y=4.835
c1144 ( 52 0 ) capacitor c=0.0115855f //x=15.655 //y=4.695
c1145 ( 45 0 ) capacitor c=0.00785249f //x=2.705 //y=4.835
c1146 ( 41 0 ) capacitor c=0.0600974f //x=67.46 //y=4.535
c1147 ( 40 0 ) capacitor c=0.00382585f //x=67.46 //y=2.375
c1148 ( 36 0 ) capacitor c=0.00380207f //x=54.51 //y=2.375
c1149 ( 33 0 ) capacitor c=0.00382585f //x=41.56 //y=2.375
c1150 ( 28 0 ) capacitor c=0.00380207f //x=28.61 //y=2.375
c1151 ( 24 0 ) capacitor c=0.00382585f //x=15.66 //y=2.375
c1152 ( 17 0 ) capacitor c=0.0056477f //x=2.71 //y=2.375
c1153 ( 12 0 ) capacitor c=0.0607593f //x=54.51 //y=3.88
c1154 ( 11 0 ) capacitor c=0.0595144f //x=41.56 //y=3.51
c1155 ( 8 0 ) capacitor c=0.0614609f //x=28.61 //y=3.51
c1156 ( 6 0 ) capacitor c=0.0620551f //x=15.66 //y=3.14
c1157 ( 1 0 ) capacitor c=0.0668824f //x=2.71 //y=2.77
r1158 (  374 375 ) resistor r=32.4568 //w=0.214 //l=0.075 //layer=ply \
 //thickness=0.18 //x=67.46 //y=4.97 //x2=67.46 //y2=5.045
r1159 (  372 374 ) resistor r=20.271 //w=0.214 //l=0.09 //layer=ply \
 //thickness=0.18 //x=67.46 //y=4.88 //x2=67.46 //y2=4.97
r1160 (  363 364 ) resistor r=32.4568 //w=0.214 //l=0.075 //layer=ply \
 //thickness=0.18 //x=54.51 //y=4.97 //x2=54.51 //y2=5.045
r1161 (  361 363 ) resistor r=20.271 //w=0.214 //l=0.09 //layer=ply \
 //thickness=0.18 //x=54.51 //y=4.88 //x2=54.51 //y2=4.97
r1162 (  352 353 ) resistor r=32.4568 //w=0.214 //l=0.075 //layer=ply \
 //thickness=0.18 //x=41.56 //y=4.97 //x2=41.56 //y2=5.045
r1163 (  350 352 ) resistor r=20.271 //w=0.214 //l=0.09 //layer=ply \
 //thickness=0.18 //x=41.56 //y=4.88 //x2=41.56 //y2=4.97
r1164 (  341 342 ) resistor r=32.4568 //w=0.214 //l=0.075 //layer=ply \
 //thickness=0.18 //x=28.61 //y=4.97 //x2=28.61 //y2=5.045
r1165 (  339 341 ) resistor r=20.271 //w=0.214 //l=0.09 //layer=ply \
 //thickness=0.18 //x=28.61 //y=4.88 //x2=28.61 //y2=4.97
r1166 (  330 331 ) resistor r=32.4568 //w=0.214 //l=0.075 //layer=ply \
 //thickness=0.18 //x=15.66 //y=4.97 //x2=15.66 //y2=5.045
r1167 (  328 330 ) resistor r=20.271 //w=0.214 //l=0.09 //layer=ply \
 //thickness=0.18 //x=15.66 //y=4.88 //x2=15.66 //y2=4.97
r1168 (  319 320 ) resistor r=32.4568 //w=0.214 //l=0.075 //layer=ply \
 //thickness=0.18 //x=2.71 //y=4.97 //x2=2.71 //y2=5.045
r1169 (  317 319 ) resistor r=20.271 //w=0.214 //l=0.09 //layer=ply \
 //thickness=0.18 //x=2.71 //y=4.88 //x2=2.71 //y2=4.97
r1170 (  310 374 ) resistor r=16.5046 //w=0.27 //l=0.135 //layer=ply \
 //thickness=0.18 //x=67.595 //y=4.97 //x2=67.46 //y2=4.97
r1171 (  309 311 ) resistor r=26.9307 //w=0.15 //l=0.106066 //layer=ply \
 //thickness=0.18 //x=67.795 //y=4.97 //x2=67.87 //y2=5.045
r1172 (  309 310 ) resistor r=102.553 //w=0.094 //l=0.2 //layer=ply \
 //thickness=0.18 //x=67.795 //y=4.97 //x2=67.595 //y2=4.97
r1173 (  308 379 ) resistor r=38.6777 //w=0.284 //l=0.198997 //layer=ply \
 //thickness=0.18 //x=67.55 //y=2.095 //x2=67.475 //y2=2.26
r1174 (  307 377 ) resistor r=21.2976 //w=0.217 //l=0.0928709 //layer=ply \
 //thickness=0.18 //x=67.55 //y=1.63 //x2=67.51 //y2=1.555
r1175 (  307 308 ) resistor r=238.436 //w=0.094 //l=0.465 //layer=ply \
 //thickness=0.18 //x=67.55 //y=1.63 //x2=67.55 //y2=2.095
r1176 (  306 377 ) resistor r=39.0671 //w=0.217 //l=0.173853 //layer=ply \
 //thickness=0.18 //x=67.55 //y=1.4 //x2=67.51 //y2=1.555
r1177 (  305 376 ) resistor r=45.1352 //w=0.168 //l=0.173853 //layer=ply \
 //thickness=0.18 //x=67.55 //y=1.09 //x2=67.51 //y2=0.935
r1178 (  305 306 ) resistor r=158.957 //w=0.094 //l=0.31 //layer=ply \
 //thickness=0.18 //x=67.55 //y=1.09 //x2=67.55 //y2=1.4
r1179 (  300 370 ) resistor r=5.52526 //w=0.168 //l=0.115 //layer=ply \
 //thickness=0.18 //x=67.18 //y=1.555 //x2=67.065 //y2=1.555
r1180 (  299 377 ) resistor r=11.4558 //w=0.217 //l=0.115 //layer=ply \
 //thickness=0.18 //x=67.395 //y=1.555 //x2=67.51 //y2=1.555
r1181 (  298 369 ) resistor r=5.52526 //w=0.168 //l=0.115 //layer=ply \
 //thickness=0.18 //x=67.18 //y=0.935 //x2=67.065 //y2=0.935
r1182 (  297 376 ) resistor r=5.52526 //w=0.168 //l=0.115 //layer=ply \
 //thickness=0.18 //x=67.395 //y=0.935 //x2=67.51 //y2=0.935
r1183 (  297 298 ) resistor r=110.245 //w=0.094 //l=0.215 //layer=ply \
 //thickness=0.18 //x=67.395 //y=0.935 //x2=67.18 //y2=0.935
r1184 (  296 370 ) resistor r=45.1352 //w=0.168 //l=0.173853 //layer=ply \
 //thickness=0.18 //x=67.025 //y=1.4 //x2=67.065 //y2=1.555
r1185 (  295 369 ) resistor r=45.1352 //w=0.168 //l=0.173853 //layer=ply \
 //thickness=0.18 //x=67.025 //y=1.09 //x2=67.065 //y2=0.935
r1186 (  295 296 ) resistor r=158.957 //w=0.094 //l=0.31 //layer=ply \
 //thickness=0.18 //x=67.025 //y=1.09 //x2=67.025 //y2=1.4
r1187 (  291 363 ) resistor r=16.5046 //w=0.27 //l=0.135 //layer=ply \
 //thickness=0.18 //x=54.645 //y=4.97 //x2=54.51 //y2=4.97
r1188 (  290 292 ) resistor r=26.9307 //w=0.15 //l=0.106066 //layer=ply \
 //thickness=0.18 //x=54.845 //y=4.97 //x2=54.92 //y2=5.045
r1189 (  290 291 ) resistor r=102.553 //w=0.094 //l=0.2 //layer=ply \
 //thickness=0.18 //x=54.845 //y=4.97 //x2=54.645 //y2=4.97
r1190 (  289 368 ) resistor r=38.6777 //w=0.284 //l=0.198997 //layer=ply \
 //thickness=0.18 //x=54.6 //y=2.095 //x2=54.525 //y2=2.26
r1191 (  288 366 ) resistor r=21.2976 //w=0.217 //l=0.0928709 //layer=ply \
 //thickness=0.18 //x=54.6 //y=1.63 //x2=54.56 //y2=1.555
r1192 (  288 289 ) resistor r=238.436 //w=0.094 //l=0.465 //layer=ply \
 //thickness=0.18 //x=54.6 //y=1.63 //x2=54.6 //y2=2.095
r1193 (  287 366 ) resistor r=39.0671 //w=0.217 //l=0.173853 //layer=ply \
 //thickness=0.18 //x=54.6 //y=1.4 //x2=54.56 //y2=1.555
r1194 (  286 365 ) resistor r=45.1352 //w=0.168 //l=0.173853 //layer=ply \
 //thickness=0.18 //x=54.6 //y=1.09 //x2=54.56 //y2=0.935
r1195 (  286 287 ) resistor r=158.957 //w=0.094 //l=0.31 //layer=ply \
 //thickness=0.18 //x=54.6 //y=1.09 //x2=54.6 //y2=1.4
r1196 (  281 359 ) resistor r=5.52526 //w=0.168 //l=0.115 //layer=ply \
 //thickness=0.18 //x=54.23 //y=1.555 //x2=54.115 //y2=1.555
r1197 (  280 366 ) resistor r=11.4558 //w=0.217 //l=0.115 //layer=ply \
 //thickness=0.18 //x=54.445 //y=1.555 //x2=54.56 //y2=1.555
r1198 (  279 358 ) resistor r=5.52526 //w=0.168 //l=0.115 //layer=ply \
 //thickness=0.18 //x=54.23 //y=0.935 //x2=54.115 //y2=0.935
r1199 (  278 365 ) resistor r=5.52526 //w=0.168 //l=0.115 //layer=ply \
 //thickness=0.18 //x=54.445 //y=0.935 //x2=54.56 //y2=0.935
r1200 (  278 279 ) resistor r=110.245 //w=0.094 //l=0.215 //layer=ply \
 //thickness=0.18 //x=54.445 //y=0.935 //x2=54.23 //y2=0.935
r1201 (  277 359 ) resistor r=45.1352 //w=0.168 //l=0.173853 //layer=ply \
 //thickness=0.18 //x=54.075 //y=1.4 //x2=54.115 //y2=1.555
r1202 (  276 358 ) resistor r=45.1352 //w=0.168 //l=0.173853 //layer=ply \
 //thickness=0.18 //x=54.075 //y=1.09 //x2=54.115 //y2=0.935
r1203 (  276 277 ) resistor r=158.957 //w=0.094 //l=0.31 //layer=ply \
 //thickness=0.18 //x=54.075 //y=1.09 //x2=54.075 //y2=1.4
r1204 (  272 352 ) resistor r=16.5046 //w=0.27 //l=0.135 //layer=ply \
 //thickness=0.18 //x=41.695 //y=4.97 //x2=41.56 //y2=4.97
r1205 (  271 273 ) resistor r=26.9307 //w=0.15 //l=0.106066 //layer=ply \
 //thickness=0.18 //x=41.895 //y=4.97 //x2=41.97 //y2=5.045
r1206 (  271 272 ) resistor r=102.553 //w=0.094 //l=0.2 //layer=ply \
 //thickness=0.18 //x=41.895 //y=4.97 //x2=41.695 //y2=4.97
r1207 (  270 357 ) resistor r=38.6777 //w=0.284 //l=0.198997 //layer=ply \
 //thickness=0.18 //x=41.65 //y=2.095 //x2=41.575 //y2=2.26
r1208 (  269 355 ) resistor r=21.2976 //w=0.217 //l=0.0928709 //layer=ply \
 //thickness=0.18 //x=41.65 //y=1.63 //x2=41.61 //y2=1.555
r1209 (  269 270 ) resistor r=238.436 //w=0.094 //l=0.465 //layer=ply \
 //thickness=0.18 //x=41.65 //y=1.63 //x2=41.65 //y2=2.095
r1210 (  268 355 ) resistor r=39.0671 //w=0.217 //l=0.173853 //layer=ply \
 //thickness=0.18 //x=41.65 //y=1.4 //x2=41.61 //y2=1.555
r1211 (  267 354 ) resistor r=45.1352 //w=0.168 //l=0.173853 //layer=ply \
 //thickness=0.18 //x=41.65 //y=1.09 //x2=41.61 //y2=0.935
r1212 (  267 268 ) resistor r=158.957 //w=0.094 //l=0.31 //layer=ply \
 //thickness=0.18 //x=41.65 //y=1.09 //x2=41.65 //y2=1.4
r1213 (  262 348 ) resistor r=5.52526 //w=0.168 //l=0.115 //layer=ply \
 //thickness=0.18 //x=41.28 //y=1.555 //x2=41.165 //y2=1.555
r1214 (  261 355 ) resistor r=11.4558 //w=0.217 //l=0.115 //layer=ply \
 //thickness=0.18 //x=41.495 //y=1.555 //x2=41.61 //y2=1.555
r1215 (  260 347 ) resistor r=5.52526 //w=0.168 //l=0.115 //layer=ply \
 //thickness=0.18 //x=41.28 //y=0.935 //x2=41.165 //y2=0.935
r1216 (  259 354 ) resistor r=5.52526 //w=0.168 //l=0.115 //layer=ply \
 //thickness=0.18 //x=41.495 //y=0.935 //x2=41.61 //y2=0.935
r1217 (  259 260 ) resistor r=110.245 //w=0.094 //l=0.215 //layer=ply \
 //thickness=0.18 //x=41.495 //y=0.935 //x2=41.28 //y2=0.935
r1218 (  258 348 ) resistor r=45.1352 //w=0.168 //l=0.173853 //layer=ply \
 //thickness=0.18 //x=41.125 //y=1.4 //x2=41.165 //y2=1.555
r1219 (  257 347 ) resistor r=45.1352 //w=0.168 //l=0.173853 //layer=ply \
 //thickness=0.18 //x=41.125 //y=1.09 //x2=41.165 //y2=0.935
r1220 (  257 258 ) resistor r=158.957 //w=0.094 //l=0.31 //layer=ply \
 //thickness=0.18 //x=41.125 //y=1.09 //x2=41.125 //y2=1.4
r1221 (  253 341 ) resistor r=16.5046 //w=0.27 //l=0.135 //layer=ply \
 //thickness=0.18 //x=28.745 //y=4.97 //x2=28.61 //y2=4.97
r1222 (  252 254 ) resistor r=26.9307 //w=0.15 //l=0.106066 //layer=ply \
 //thickness=0.18 //x=28.945 //y=4.97 //x2=29.02 //y2=5.045
r1223 (  252 253 ) resistor r=102.553 //w=0.094 //l=0.2 //layer=ply \
 //thickness=0.18 //x=28.945 //y=4.97 //x2=28.745 //y2=4.97
r1224 (  251 346 ) resistor r=38.6777 //w=0.284 //l=0.198997 //layer=ply \
 //thickness=0.18 //x=28.7 //y=2.095 //x2=28.625 //y2=2.26
r1225 (  250 344 ) resistor r=21.2976 //w=0.217 //l=0.0928709 //layer=ply \
 //thickness=0.18 //x=28.7 //y=1.63 //x2=28.66 //y2=1.555
r1226 (  250 251 ) resistor r=238.436 //w=0.094 //l=0.465 //layer=ply \
 //thickness=0.18 //x=28.7 //y=1.63 //x2=28.7 //y2=2.095
r1227 (  249 344 ) resistor r=39.0671 //w=0.217 //l=0.173853 //layer=ply \
 //thickness=0.18 //x=28.7 //y=1.4 //x2=28.66 //y2=1.555
r1228 (  248 343 ) resistor r=45.1352 //w=0.168 //l=0.173853 //layer=ply \
 //thickness=0.18 //x=28.7 //y=1.09 //x2=28.66 //y2=0.935
r1229 (  248 249 ) resistor r=158.957 //w=0.094 //l=0.31 //layer=ply \
 //thickness=0.18 //x=28.7 //y=1.09 //x2=28.7 //y2=1.4
r1230 (  243 337 ) resistor r=5.52526 //w=0.168 //l=0.115 //layer=ply \
 //thickness=0.18 //x=28.33 //y=1.555 //x2=28.215 //y2=1.555
r1231 (  242 344 ) resistor r=11.4558 //w=0.217 //l=0.115 //layer=ply \
 //thickness=0.18 //x=28.545 //y=1.555 //x2=28.66 //y2=1.555
r1232 (  241 336 ) resistor r=5.52526 //w=0.168 //l=0.115 //layer=ply \
 //thickness=0.18 //x=28.33 //y=0.935 //x2=28.215 //y2=0.935
r1233 (  240 343 ) resistor r=5.52526 //w=0.168 //l=0.115 //layer=ply \
 //thickness=0.18 //x=28.545 //y=0.935 //x2=28.66 //y2=0.935
r1234 (  240 241 ) resistor r=110.245 //w=0.094 //l=0.215 //layer=ply \
 //thickness=0.18 //x=28.545 //y=0.935 //x2=28.33 //y2=0.935
r1235 (  239 337 ) resistor r=45.1352 //w=0.168 //l=0.173853 //layer=ply \
 //thickness=0.18 //x=28.175 //y=1.4 //x2=28.215 //y2=1.555
r1236 (  238 336 ) resistor r=45.1352 //w=0.168 //l=0.173853 //layer=ply \
 //thickness=0.18 //x=28.175 //y=1.09 //x2=28.215 //y2=0.935
r1237 (  238 239 ) resistor r=158.957 //w=0.094 //l=0.31 //layer=ply \
 //thickness=0.18 //x=28.175 //y=1.09 //x2=28.175 //y2=1.4
r1238 (  234 330 ) resistor r=16.5046 //w=0.27 //l=0.135 //layer=ply \
 //thickness=0.18 //x=15.795 //y=4.97 //x2=15.66 //y2=4.97
r1239 (  233 235 ) resistor r=26.9307 //w=0.15 //l=0.106066 //layer=ply \
 //thickness=0.18 //x=15.995 //y=4.97 //x2=16.07 //y2=5.045
r1240 (  233 234 ) resistor r=102.553 //w=0.094 //l=0.2 //layer=ply \
 //thickness=0.18 //x=15.995 //y=4.97 //x2=15.795 //y2=4.97
r1241 (  232 335 ) resistor r=38.6777 //w=0.284 //l=0.198997 //layer=ply \
 //thickness=0.18 //x=15.75 //y=2.095 //x2=15.675 //y2=2.26
r1242 (  231 333 ) resistor r=21.2976 //w=0.217 //l=0.0928709 //layer=ply \
 //thickness=0.18 //x=15.75 //y=1.63 //x2=15.71 //y2=1.555
r1243 (  231 232 ) resistor r=238.436 //w=0.094 //l=0.465 //layer=ply \
 //thickness=0.18 //x=15.75 //y=1.63 //x2=15.75 //y2=2.095
r1244 (  230 333 ) resistor r=39.0671 //w=0.217 //l=0.173853 //layer=ply \
 //thickness=0.18 //x=15.75 //y=1.4 //x2=15.71 //y2=1.555
r1245 (  229 332 ) resistor r=45.1352 //w=0.168 //l=0.173853 //layer=ply \
 //thickness=0.18 //x=15.75 //y=1.09 //x2=15.71 //y2=0.935
r1246 (  229 230 ) resistor r=158.957 //w=0.094 //l=0.31 //layer=ply \
 //thickness=0.18 //x=15.75 //y=1.09 //x2=15.75 //y2=1.4
r1247 (  224 326 ) resistor r=5.52526 //w=0.168 //l=0.115 //layer=ply \
 //thickness=0.18 //x=15.38 //y=1.555 //x2=15.265 //y2=1.555
r1248 (  223 333 ) resistor r=11.4558 //w=0.217 //l=0.115 //layer=ply \
 //thickness=0.18 //x=15.595 //y=1.555 //x2=15.71 //y2=1.555
r1249 (  222 325 ) resistor r=5.52526 //w=0.168 //l=0.115 //layer=ply \
 //thickness=0.18 //x=15.38 //y=0.935 //x2=15.265 //y2=0.935
r1250 (  221 332 ) resistor r=5.52526 //w=0.168 //l=0.115 //layer=ply \
 //thickness=0.18 //x=15.595 //y=0.935 //x2=15.71 //y2=0.935
r1251 (  221 222 ) resistor r=110.245 //w=0.094 //l=0.215 //layer=ply \
 //thickness=0.18 //x=15.595 //y=0.935 //x2=15.38 //y2=0.935
r1252 (  220 326 ) resistor r=45.1352 //w=0.168 //l=0.173853 //layer=ply \
 //thickness=0.18 //x=15.225 //y=1.4 //x2=15.265 //y2=1.555
r1253 (  219 325 ) resistor r=45.1352 //w=0.168 //l=0.173853 //layer=ply \
 //thickness=0.18 //x=15.225 //y=1.09 //x2=15.265 //y2=0.935
r1254 (  219 220 ) resistor r=158.957 //w=0.094 //l=0.31 //layer=ply \
 //thickness=0.18 //x=15.225 //y=1.09 //x2=15.225 //y2=1.4
r1255 (  215 319 ) resistor r=16.5046 //w=0.27 //l=0.135 //layer=ply \
 //thickness=0.18 //x=2.845 //y=4.97 //x2=2.71 //y2=4.97
r1256 (  214 216 ) resistor r=26.9307 //w=0.15 //l=0.106066 //layer=ply \
 //thickness=0.18 //x=3.045 //y=4.97 //x2=3.12 //y2=5.045
r1257 (  214 215 ) resistor r=102.553 //w=0.094 //l=0.2 //layer=ply \
 //thickness=0.18 //x=3.045 //y=4.97 //x2=2.845 //y2=4.97
r1258 (  213 324 ) resistor r=38.6777 //w=0.284 //l=0.198997 //layer=ply \
 //thickness=0.18 //x=2.8 //y=2.095 //x2=2.725 //y2=2.26
r1259 (  212 322 ) resistor r=21.2976 //w=0.217 //l=0.0928709 //layer=ply \
 //thickness=0.18 //x=2.8 //y=1.63 //x2=2.76 //y2=1.555
r1260 (  212 213 ) resistor r=238.436 //w=0.094 //l=0.465 //layer=ply \
 //thickness=0.18 //x=2.8 //y=1.63 //x2=2.8 //y2=2.095
r1261 (  211 322 ) resistor r=39.0671 //w=0.217 //l=0.173853 //layer=ply \
 //thickness=0.18 //x=2.8 //y=1.4 //x2=2.76 //y2=1.555
r1262 (  210 321 ) resistor r=45.1352 //w=0.168 //l=0.173853 //layer=ply \
 //thickness=0.18 //x=2.8 //y=1.09 //x2=2.76 //y2=0.935
r1263 (  210 211 ) resistor r=158.957 //w=0.094 //l=0.31 //layer=ply \
 //thickness=0.18 //x=2.8 //y=1.09 //x2=2.8 //y2=1.4
r1264 (  205 315 ) resistor r=5.52526 //w=0.168 //l=0.115 //layer=ply \
 //thickness=0.18 //x=2.43 //y=1.555 //x2=2.315 //y2=1.555
r1265 (  204 322 ) resistor r=11.4558 //w=0.217 //l=0.115 //layer=ply \
 //thickness=0.18 //x=2.645 //y=1.555 //x2=2.76 //y2=1.555
r1266 (  203 314 ) resistor r=5.52526 //w=0.168 //l=0.115 //layer=ply \
 //thickness=0.18 //x=2.43 //y=0.935 //x2=2.315 //y2=0.935
r1267 (  202 321 ) resistor r=5.52526 //w=0.168 //l=0.115 //layer=ply \
 //thickness=0.18 //x=2.645 //y=0.935 //x2=2.76 //y2=0.935
r1268 (  202 203 ) resistor r=110.245 //w=0.094 //l=0.215 //layer=ply \
 //thickness=0.18 //x=2.645 //y=0.935 //x2=2.43 //y2=0.935
r1269 (  201 315 ) resistor r=45.1352 //w=0.168 //l=0.173853 //layer=ply \
 //thickness=0.18 //x=2.275 //y=1.4 //x2=2.315 //y2=1.555
r1270 (  200 314 ) resistor r=45.1352 //w=0.168 //l=0.173853 //layer=ply \
 //thickness=0.18 //x=2.275 //y=1.09 //x2=2.315 //y2=0.935
r1271 (  200 201 ) resistor r=158.957 //w=0.094 //l=0.31 //layer=ply \
 //thickness=0.18 //x=2.275 //y=1.09 //x2=2.275 //y2=1.4
r1272 (  199 311 ) resistor r=592.245 //w=0.094 //l=1.155 //layer=ply \
 //thickness=0.18 //x=67.87 //y=6.2 //x2=67.87 //y2=5.045
r1273 (  198 375 ) resistor r=592.245 //w=0.094 //l=1.155 //layer=ply \
 //thickness=0.18 //x=67.43 //y=6.2 //x2=67.43 //y2=5.045
r1274 (  197 292 ) resistor r=592.245 //w=0.094 //l=1.155 //layer=ply \
 //thickness=0.18 //x=54.92 //y=6.2 //x2=54.92 //y2=5.045
r1275 (  196 364 ) resistor r=592.245 //w=0.094 //l=1.155 //layer=ply \
 //thickness=0.18 //x=54.48 //y=6.2 //x2=54.48 //y2=5.045
r1276 (  195 273 ) resistor r=592.245 //w=0.094 //l=1.155 //layer=ply \
 //thickness=0.18 //x=41.97 //y=6.2 //x2=41.97 //y2=5.045
r1277 (  194 353 ) resistor r=592.245 //w=0.094 //l=1.155 //layer=ply \
 //thickness=0.18 //x=41.53 //y=6.2 //x2=41.53 //y2=5.045
r1278 (  193 254 ) resistor r=592.245 //w=0.094 //l=1.155 //layer=ply \
 //thickness=0.18 //x=29.02 //y=6.2 //x2=29.02 //y2=5.045
r1279 (  192 342 ) resistor r=592.245 //w=0.094 //l=1.155 //layer=ply \
 //thickness=0.18 //x=28.58 //y=6.2 //x2=28.58 //y2=5.045
r1280 (  191 235 ) resistor r=592.245 //w=0.094 //l=1.155 //layer=ply \
 //thickness=0.18 //x=16.07 //y=6.2 //x2=16.07 //y2=5.045
r1281 (  190 331 ) resistor r=592.245 //w=0.094 //l=1.155 //layer=ply \
 //thickness=0.18 //x=15.63 //y=6.2 //x2=15.63 //y2=5.045
r1282 (  189 216 ) resistor r=592.245 //w=0.094 //l=1.155 //layer=ply \
 //thickness=0.18 //x=3.12 //y=6.2 //x2=3.12 //y2=5.045
r1283 (  188 320 ) resistor r=592.245 //w=0.094 //l=1.155 //layer=ply \
 //thickness=0.18 //x=2.68 //y=6.2 //x2=2.68 //y2=5.045
r1284 (  187 299 ) resistor r=55.3787 //w=0.094 //l=0.108 //layer=ply \
 //thickness=0.18 //x=67.287 //y=1.555 //x2=67.395 //y2=1.555
r1285 (  187 300 ) resistor r=54.866 //w=0.094 //l=0.107 //layer=ply \
 //thickness=0.18 //x=67.287 //y=1.555 //x2=67.18 //y2=1.555
r1286 (  186 280 ) resistor r=55.3787 //w=0.094 //l=0.108 //layer=ply \
 //thickness=0.18 //x=54.337 //y=1.555 //x2=54.445 //y2=1.555
r1287 (  186 281 ) resistor r=54.866 //w=0.094 //l=0.107 //layer=ply \
 //thickness=0.18 //x=54.337 //y=1.555 //x2=54.23 //y2=1.555
r1288 (  185 261 ) resistor r=55.3787 //w=0.094 //l=0.108 //layer=ply \
 //thickness=0.18 //x=41.387 //y=1.555 //x2=41.495 //y2=1.555
r1289 (  185 262 ) resistor r=54.866 //w=0.094 //l=0.107 //layer=ply \
 //thickness=0.18 //x=41.387 //y=1.555 //x2=41.28 //y2=1.555
r1290 (  184 242 ) resistor r=55.3787 //w=0.094 //l=0.108 //layer=ply \
 //thickness=0.18 //x=28.437 //y=1.555 //x2=28.545 //y2=1.555
r1291 (  184 243 ) resistor r=54.866 //w=0.094 //l=0.107 //layer=ply \
 //thickness=0.18 //x=28.437 //y=1.555 //x2=28.33 //y2=1.555
r1292 (  183 223 ) resistor r=55.3787 //w=0.094 //l=0.108 //layer=ply \
 //thickness=0.18 //x=15.487 //y=1.555 //x2=15.595 //y2=1.555
r1293 (  183 224 ) resistor r=54.866 //w=0.094 //l=0.107 //layer=ply \
 //thickness=0.18 //x=15.487 //y=1.555 //x2=15.38 //y2=1.555
r1294 (  182 204 ) resistor r=55.3787 //w=0.094 //l=0.108 //layer=ply \
 //thickness=0.18 //x=2.537 //y=1.555 //x2=2.645 //y2=1.555
r1295 (  182 205 ) resistor r=54.866 //w=0.094 //l=0.107 //layer=ply \
 //thickness=0.18 //x=2.537 //y=1.555 //x2=2.43 //y2=1.555
r1296 (  178 372 ) resistor r=152 //w=0.17 //l=0.17 //layer=licon //count=1 \
 //x=67.46 //y=4.88 //x2=67.46 //y2=4.88
r1297 (  173 379 ) resistor r=152 //w=0.17 //l=0.17 //layer=licon //count=1 \
 //x=67.46 //y=2.26 //x2=67.46 //y2=2.26
r1298 (  168 361 ) resistor r=152 //w=0.17 //l=0.17 //layer=licon //count=1 \
 //x=54.51 //y=4.88 //x2=54.51 //y2=4.88
r1299 (  163 368 ) resistor r=152 //w=0.17 //l=0.17 //layer=licon //count=1 \
 //x=54.51 //y=2.26 //x2=54.51 //y2=2.26
r1300 (  158 350 ) resistor r=152 //w=0.17 //l=0.17 //layer=licon //count=1 \
 //x=41.56 //y=4.88 //x2=41.56 //y2=4.88
r1301 (  153 357 ) resistor r=152 //w=0.17 //l=0.17 //layer=licon //count=1 \
 //x=41.56 //y=2.26 //x2=41.56 //y2=2.26
r1302 (  148 339 ) resistor r=152 //w=0.17 //l=0.17 //layer=licon //count=1 \
 //x=28.61 //y=4.88 //x2=28.61 //y2=4.88
r1303 (  143 346 ) resistor r=152 //w=0.17 //l=0.17 //layer=licon //count=1 \
 //x=28.61 //y=2.26 //x2=28.61 //y2=2.26
r1304 (  138 328 ) resistor r=152 //w=0.17 //l=0.17 //layer=licon //count=1 \
 //x=15.66 //y=4.88 //x2=15.66 //y2=4.88
r1305 (  133 335 ) resistor r=152 //w=0.17 //l=0.17 //layer=licon //count=1 \
 //x=15.66 //y=2.26 //x2=15.66 //y2=2.26
r1306 (  128 317 ) resistor r=152 //w=0.17 //l=0.17 //layer=licon //count=1 \
 //x=2.71 //y=4.88 //x2=2.71 //y2=4.88
r1307 (  123 324 ) resistor r=152 //w=0.17 //l=0.17 //layer=licon //count=1 \
 //x=2.71 //y=2.26 //x2=2.71 //y2=2.26
r1308 (  109 111 ) resistor r=0.0904882 //w=0.297 //l=0.215 //layer=m2 \
 //thickness=0.36 //x=2.705 //y=4.62 //x2=2.705 //y2=4.835
r1309 (  108 119 ) resistor r=6.34081 //w=0.18 //l=9.16493 //layer=m2 \
 //thickness=0.36 //x=63.635 //y=4.635 //x2=54.505 //y2=4.705
r1310 (  107 121 ) resistor r=2.36166 //w=0.184 //l=3.50487 //layer=m2 \
 //thickness=0.36 //x=63.98 //y=4.635 //x2=67.455 //y2=4.695
r1311 (  107 108 ) resistor r=0.329198 //w=0.131 //l=0.345 //layer=m2 \
 //thickness=0.36 //x=63.98 //y=4.635 //x2=63.635 //y2=4.635
r1312 (  105 119 ) resistor r=0.618583 //w=0.18 //l=0.919511 //layer=m2 \
 //thickness=0.36 //x=53.615 //y=4.645 //x2=54.505 //y2=4.705
r1313 (  105 106 ) resistor r=0.329198 //w=0.131 //l=0.345 //layer=m2 \
 //thickness=0.36 //x=53.615 //y=4.645 //x2=53.27 //y2=4.645
r1314 (  103 106 ) resistor r=0.1875 //w=0.17 //l=0.267208 //layer=m2 \
 //thickness=0.36 //x=53.015 //y=4.62 //x2=53.27 //y2=4.645
r1315 (  103 104 ) resistor r=1.74618 //w=0.131 //l=1.83 //layer=m2 \
 //thickness=0.36 //x=53.015 //y=4.62 //x2=51.185 //y2=4.62
r1316 (  101 104 ) resistor r=0.125 //w=0.17 //l=0.179722 //layer=m2 \
 //thickness=0.36 //x=51.015 //y=4.64 //x2=51.185 //y2=4.62
r1317 (  101 102 ) resistor r=0.329198 //w=0.131 //l=0.345 //layer=m2 \
 //thickness=0.36 //x=51.015 //y=4.64 //x2=50.67 //y2=4.64
r1318 (  99 102 ) resistor r=0.1875 //w=0.17 //l=0.264811 //layer=m2 \
 //thickness=0.36 //x=50.415 //y=4.62 //x2=50.67 //y2=4.64
r1319 (  99 100 ) resistor r=6.31202 //w=0.131 //l=6.615 //layer=m2 \
 //thickness=0.36 //x=50.415 //y=4.62 //x2=43.8 //y2=4.62
r1320 (  98 117 ) resistor r=1.20192 //w=0.18 //l=1.75728 //layer=m2 \
 //thickness=0.36 //x=43.285 //y=4.64 //x2=41.555 //y2=4.695
r1321 (  97 100 ) resistor r=0.125 //w=0.17 //l=0.179722 //layer=m2 \
 //thickness=0.36 //x=43.63 //y=4.64 //x2=43.8 //y2=4.62
r1322 (  97 98 ) resistor r=0.329198 //w=0.131 //l=0.345 //layer=m2 \
 //thickness=0.36 //x=43.63 //y=4.64 //x2=43.285 //y2=4.64
r1323 (  96 115 ) resistor r=6.34081 //w=0.18 //l=9.16493 //layer=m2 \
 //thickness=0.36 //x=37.735 //y=4.635 //x2=28.605 //y2=4.705
r1324 (  95 117 ) resistor r=2.41372 //w=0.18 //l=3.50487 //layer=m2 \
 //thickness=0.36 //x=38.08 //y=4.635 //x2=41.555 //y2=4.695
r1325 (  95 96 ) resistor r=0.329198 //w=0.131 //l=0.345 //layer=m2 \
 //thickness=0.36 //x=38.08 //y=4.635 //x2=37.735 //y2=4.635
r1326 (  93 115 ) resistor r=0.618583 //w=0.18 //l=0.919511 //layer=m2 \
 //thickness=0.36 //x=27.715 //y=4.645 //x2=28.605 //y2=4.705
r1327 (  93 94 ) resistor r=0.329198 //w=0.131 //l=0.345 //layer=m2 \
 //thickness=0.36 //x=27.715 //y=4.645 //x2=27.37 //y2=4.645
r1328 (  91 94 ) resistor r=0.1875 //w=0.17 //l=0.267208 //layer=m2 \
 //thickness=0.36 //x=27.115 //y=4.62 //x2=27.37 //y2=4.645
r1329 (  91 92 ) resistor r=1.74618 //w=0.131 //l=1.83 //layer=m2 \
 //thickness=0.36 //x=27.115 //y=4.62 //x2=25.285 //y2=4.62
r1330 (  89 92 ) resistor r=0.125 //w=0.17 //l=0.179722 //layer=m2 \
 //thickness=0.36 //x=25.115 //y=4.64 //x2=25.285 //y2=4.62
r1331 (  89 90 ) resistor r=0.329198 //w=0.131 //l=0.345 //layer=m2 \
 //thickness=0.36 //x=25.115 //y=4.64 //x2=24.77 //y2=4.64
r1332 (  87 90 ) resistor r=0.1875 //w=0.17 //l=0.264811 //layer=m2 \
 //thickness=0.36 //x=24.515 //y=4.62 //x2=24.77 //y2=4.64
r1333 (  87 88 ) resistor r=6.31202 //w=0.131 //l=6.615 //layer=m2 \
 //thickness=0.36 //x=24.515 //y=4.62 //x2=17.9 //y2=4.62
r1334 (  86 113 ) resistor r=1.20192 //w=0.18 //l=1.75728 //layer=m2 \
 //thickness=0.36 //x=17.385 //y=4.64 //x2=15.655 //y2=4.695
r1335 (  85 88 ) resistor r=0.125 //w=0.17 //l=0.179722 //layer=m2 \
 //thickness=0.36 //x=17.73 //y=4.64 //x2=17.9 //y2=4.62
r1336 (  85 86 ) resistor r=0.329198 //w=0.131 //l=0.345 //layer=m2 \
 //thickness=0.36 //x=17.73 //y=4.64 //x2=17.385 //y2=4.64
r1337 (  83 113 ) resistor r=2.41372 //w=0.18 //l=3.50487 //layer=m2 \
 //thickness=0.36 //x=12.18 //y=4.635 //x2=15.655 //y2=4.695
r1338 (  83 84 ) resistor r=0.329198 //w=0.131 //l=0.345 //layer=m2 \
 //thickness=0.36 //x=12.18 //y=4.635 //x2=11.835 //y2=4.635
r1339 (  82 109 ) resistor r=0.0410036 //w=0.297 //l=0.16 //layer=m2 \
 //thickness=0.36 //x=2.865 //y=4.62 //x2=2.705 //y2=4.62
r1340 (  81 84 ) resistor r=0.1875 //w=0.17 //l=0.262393 //layer=m2 \
 //thickness=0.36 //x=11.58 //y=4.62 //x2=11.835 //y2=4.635
r1341 (  81 82 ) resistor r=8.31584 //w=0.131 //l=8.715 //layer=m2 \
 //thickness=0.36 //x=11.58 //y=4.62 //x2=2.865 //y2=4.62
r1342 (  80 178 ) resistor r=9.3 //w=0.17 //l=0.17 //layer=mcon //count=1 \
 //x=67.46 //y=4.88 //x2=67.46 //y2=4.88
r1343 (  78 121 ) resistor r=4.5 //w=0.15 //l=0.15 //layer=via1 //count=1 \
 //x=67.455 //y=4.695 //x2=67.455 //y2=4.695
r1344 (  78 80 ) resistor r=0.0808566 //w=0.286 //l=0.185 //layer=m1 \
 //thickness=0.36 //x=67.455 //y=4.695 //x2=67.455 //y2=4.88
r1345 (  75 173 ) resistor r=9.3 //w=0.17 //l=0.17 //layer=mcon //count=1 \
 //x=67.46 //y=2.26 //x2=67.46 //y2=2.26
r1346 (  73 168 ) resistor r=9.3 //w=0.17 //l=0.17 //layer=mcon //count=1 \
 //x=54.51 //y=4.88 //x2=54.51 //y2=4.88
r1347 (  71 119 ) resistor r=4.5 //w=0.15 //l=0.15 //layer=via1 //count=1 \
 //x=54.505 //y=4.835 //x2=54.505 //y2=4.835
r1348 (  71 73 ) resistor r=0.018263 //w=0.308 //l=0.045 //layer=m1 \
 //thickness=0.36 //x=54.505 //y=4.835 //x2=54.505 //y2=4.88
r1349 (  69 163 ) resistor r=9.3 //w=0.17 //l=0.17 //layer=mcon //count=1 \
 //x=54.51 //y=2.26 //x2=54.51 //y2=2.26
r1350 (  67 158 ) resistor r=9.3 //w=0.17 //l=0.17 //layer=mcon //count=1 \
 //x=41.56 //y=4.88 //x2=41.56 //y2=4.88
r1351 (  65 117 ) resistor r=4.5 //w=0.15 //l=0.15 //layer=via1 //count=1 \
 //x=41.555 //y=4.695 //x2=41.555 //y2=4.695
r1352 (  65 67 ) resistor r=0.0808566 //w=0.286 //l=0.185 //layer=m1 \
 //thickness=0.36 //x=41.555 //y=4.695 //x2=41.555 //y2=4.88
r1353 (  62 153 ) resistor r=9.3 //w=0.17 //l=0.17 //layer=mcon //count=1 \
 //x=41.56 //y=2.26 //x2=41.56 //y2=2.26
r1354 (  60 148 ) resistor r=9.3 //w=0.17 //l=0.17 //layer=mcon //count=1 \
 //x=28.61 //y=4.88 //x2=28.61 //y2=4.88
r1355 (  58 115 ) resistor r=4.5 //w=0.15 //l=0.15 //layer=via1 //count=1 \
 //x=28.605 //y=4.835 //x2=28.605 //y2=4.835
r1356 (  58 60 ) resistor r=0.018263 //w=0.308 //l=0.045 //layer=m1 \
 //thickness=0.36 //x=28.605 //y=4.835 //x2=28.605 //y2=4.88
r1357 (  56 143 ) resistor r=9.3 //w=0.17 //l=0.17 //layer=mcon //count=1 \
 //x=28.61 //y=2.26 //x2=28.61 //y2=2.26
r1358 (  54 138 ) resistor r=9.3 //w=0.17 //l=0.17 //layer=mcon //count=1 \
 //x=15.66 //y=4.88 //x2=15.66 //y2=4.88
r1359 (  52 113 ) resistor r=4.5 //w=0.15 //l=0.15 //layer=via1 //count=1 \
 //x=15.655 //y=4.695 //x2=15.655 //y2=4.695
r1360 (  52 54 ) resistor r=0.0808566 //w=0.286 //l=0.185 //layer=m1 \
 //thickness=0.36 //x=15.655 //y=4.695 //x2=15.655 //y2=4.88
r1361 (  49 133 ) resistor r=9.3 //w=0.17 //l=0.17 //layer=mcon //count=1 \
 //x=15.66 //y=2.26 //x2=15.66 //y2=2.26
r1362 (  47 128 ) resistor r=9.3 //w=0.17 //l=0.17 //layer=mcon //count=1 \
 //x=2.71 //y=4.88 //x2=2.71 //y2=4.88
r1363 (  45 111 ) resistor r=4.5 //w=0.15 //l=0.15 //layer=via1 //count=1 \
 //x=2.705 //y=4.835 //x2=2.705 //y2=4.835
r1364 (  45 47 ) resistor r=0.018263 //w=0.308 //l=0.045 //layer=m1 \
 //thickness=0.36 //x=2.705 //y=4.835 //x2=2.705 //y2=4.88
r1365 (  43 123 ) resistor r=9.3 //w=0.17 //l=0.17 //layer=mcon //count=1 \
 //x=2.71 //y=2.26 //x2=2.71 //y2=2.26
r1366 (  40 75 ) resistor r=0.0715665 //w=0.226 //l=0.115996 //layer=m1 \
 //thickness=0.36 //x=67.46 //y=2.375 //x2=67.462 //y2=2.26
r1367 (  40 41 ) resistor r=2.06107 //w=0.131 //l=2.16 //layer=m1 \
 //thickness=0.36 //x=67.46 //y=2.375 //x2=67.46 //y2=4.535
r1368 (  37 71 ) resistor r=0.0898396 //w=0.308 //l=0.162481 //layer=m1 \
 //thickness=0.36 //x=54.51 //y=4.675 //x2=54.505 //y2=4.835
r1369 (  36 69 ) resistor r=0.0715665 //w=0.226 //l=0.115996 //layer=m1 \
 //thickness=0.36 //x=54.51 //y=2.375 //x2=54.512 //y2=2.26
r1370 (  33 62 ) resistor r=0.0715665 //w=0.226 //l=0.115996 //layer=m1 \
 //thickness=0.36 //x=41.56 //y=2.375 //x2=41.562 //y2=2.26
r1371 (  29 58 ) resistor r=0.0898396 //w=0.308 //l=0.162481 //layer=m1 \
 //thickness=0.36 //x=28.61 //y=4.675 //x2=28.605 //y2=4.835
r1372 (  28 56 ) resistor r=0.0715665 //w=0.226 //l=0.115996 //layer=m1 \
 //thickness=0.36 //x=28.61 //y=2.375 //x2=28.612 //y2=2.26
r1373 (  24 49 ) resistor r=0.0715665 //w=0.226 //l=0.115996 //layer=m1 \
 //thickness=0.36 //x=15.66 //y=2.375 //x2=15.662 //y2=2.26
r1374 (  18 45 ) resistor r=0.0898396 //w=0.308 //l=0.162481 //layer=m1 \
 //thickness=0.36 //x=2.71 //y=4.675 //x2=2.705 //y2=4.835
r1375 (  17 43 ) resistor r=0.0715665 //w=0.226 //l=0.115996 //layer=m1 \
 //thickness=0.36 //x=2.71 //y=2.375 //x2=2.712 //y2=2.26
r1376 (  16 78 ) resistor r=0.0327797 //w=0.286 //l=0.075 //layer=m1 \
 //thickness=0.36 //x=67.455 //y=4.62 //x2=67.455 //y2=4.695
r1377 (  16 41 ) resistor r=0.0575483 //w=0.286 //l=0.0874643 //layer=m1 \
 //thickness=0.36 //x=67.455 //y=4.62 //x2=67.46 //y2=4.535
r1378 (  15 65 ) resistor r=0.0327797 //w=0.286 //l=0.075 //layer=m1 \
 //thickness=0.36 //x=41.555 //y=4.62 //x2=41.555 //y2=4.695
r1379 (  15 34 ) resistor r=0.0575483 //w=0.286 //l=0.0874643 //layer=m1 \
 //thickness=0.36 //x=41.555 //y=4.62 //x2=41.56 //y2=4.535
r1380 (  14 52 ) resistor r=0.0327797 //w=0.286 //l=0.075 //layer=m1 \
 //thickness=0.36 //x=15.655 //y=4.62 //x2=15.655 //y2=4.695
r1381 (  14 25 ) resistor r=0.0575483 //w=0.286 //l=0.0874643 //layer=m1 \
 //thickness=0.36 //x=15.655 //y=4.62 //x2=15.66 //y2=4.535
r1382 (  13 37 ) resistor r=0.0524809 //w=0.131 //l=0.055 //layer=m1 \
 //thickness=0.36 //x=54.51 //y=4.62 //x2=54.51 //y2=4.675
r1383 (  12 13 ) resistor r=0.706107 //w=0.131 //l=0.74 //layer=m1 \
 //thickness=0.36 //x=54.51 //y=3.88 //x2=54.51 //y2=4.62
r1384 (  12 36 ) resistor r=1.43607 //w=0.131 //l=1.505 //layer=m1 \
 //thickness=0.36 //x=54.51 //y=3.88 //x2=54.51 //y2=2.375
r1385 (  11 34 ) resistor r=0.978053 //w=0.131 //l=1.025 //layer=m1 \
 //thickness=0.36 //x=41.56 //y=3.51 //x2=41.56 //y2=4.535
r1386 (  11 33 ) resistor r=1.08302 //w=0.131 //l=1.135 //layer=m1 \
 //thickness=0.36 //x=41.56 //y=3.51 //x2=41.56 //y2=2.375
r1387 (  10 29 ) resistor r=0.0524809 //w=0.131 //l=0.055 //layer=m1 \
 //thickness=0.36 //x=28.61 //y=4.62 //x2=28.61 //y2=4.675
r1388 (  9 10 ) resistor r=0.706107 //w=0.131 //l=0.74 //layer=m1 \
 //thickness=0.36 //x=28.61 //y=3.88 //x2=28.61 //y2=4.62
r1389 (  8 9 ) resistor r=0.353053 //w=0.131 //l=0.37 //layer=m1 \
 //thickness=0.36 //x=28.61 //y=3.51 //x2=28.61 //y2=3.88
r1390 (  8 28 ) resistor r=1.08302 //w=0.131 //l=1.135 //layer=m1 \
 //thickness=0.36 //x=28.61 //y=3.51 //x2=28.61 //y2=2.375
r1391 (  7 25 ) resistor r=0.978053 //w=0.131 //l=1.025 //layer=m1 \
 //thickness=0.36 //x=15.66 //y=3.51 //x2=15.66 //y2=4.535
r1392 (  6 7 ) resistor r=0.353053 //w=0.131 //l=0.37 //layer=m1 \
 //thickness=0.36 //x=15.66 //y=3.14 //x2=15.66 //y2=3.51
r1393 (  6 24 ) resistor r=0.729962 //w=0.131 //l=0.765 //layer=m1 \
 //thickness=0.36 //x=15.66 //y=3.14 //x2=15.66 //y2=2.375
r1394 (  5 18 ) resistor r=0.0524809 //w=0.131 //l=0.055 //layer=m1 \
 //thickness=0.36 //x=2.71 //y=4.62 //x2=2.71 //y2=4.675
r1395 (  4 5 ) resistor r=0.706107 //w=0.131 //l=0.74 //layer=m1 \
 //thickness=0.36 //x=2.71 //y=3.88 //x2=2.71 //y2=4.62
r1396 (  3 4 ) resistor r=0.353053 //w=0.131 //l=0.37 //layer=m1 \
 //thickness=0.36 //x=2.71 //y=3.51 //x2=2.71 //y2=3.88
r1397 (  2 3 ) resistor r=0.353053 //w=0.131 //l=0.37 //layer=m1 \
 //thickness=0.36 //x=2.71 //y=3.14 //x2=2.71 //y2=3.51
r1398 (  1 2 ) resistor r=0.353053 //w=0.131 //l=0.37 //layer=m1 \
 //thickness=0.36 //x=2.71 //y=2.77 //x2=2.71 //y2=3.14
r1399 (  1 17 ) resistor r=0.376908 //w=0.131 //l=0.395 //layer=m1 \
 //thickness=0.36 //x=2.71 //y=2.77 //x2=2.71 //y2=2.375
ends PM_TMRDFFRNQX1\%CLK

subckt PM_TMRDFFRNQX1\%noxref_12 ( 1 3 6 7 9 10 11 12 14 15 16 17 18 19 20 21 \
 22 23 24 25 28 31 37 45 48 54 56 57 58 60 62 64 66 68 70 72 77 83 91 99 116 \
 125 130 139 143 144 145 146 147 148 149 150 151 152 153 155 161 162 163 164 \
 168 169 170 171 172 174 180 181 182 183 203 205 206 207 )
c491 ( 203 0 ) capacitor c=0.00885916f //x=55.685 //y=1.095
c492 ( 183 0 ) capacitor c=0.0583399f //x=71.435 //y=4.97
c493 ( 182 0 ) capacitor c=0.0376642f //x=71.725 //y=4.97
c494 ( 181 0 ) capacitor c=0.0346489f //x=71.39 //y=1.4
c495 ( 180 0 ) capacitor c=0.018692f //x=71.39 //y=1.055
c496 ( 174 0 ) capacitor c=0.0137077f //x=71.235 //y=1.555
c497 ( 172 0 ) capacitor c=0.0158585f //x=71.235 //y=0.9
c498 ( 171 0 ) capacitor c=0.103534f //x=70.86 //y=2.095
c499 ( 170 0 ) capacitor c=0.0229444f //x=70.86 //y=1.71
c500 ( 169 0 ) capacitor c=0.0234359f //x=70.86 //y=1.4
c501 ( 168 0 ) capacitor c=0.019815f //x=70.86 //y=1.055
c502 ( 164 0 ) capacitor c=0.0564069f //x=58.485 //y=4.97
c503 ( 163 0 ) capacitor c=0.0376642f //x=58.775 //y=4.97
c504 ( 162 0 ) capacitor c=0.0346489f //x=58.44 //y=1.4
c505 ( 161 0 ) capacitor c=0.018692f //x=58.44 //y=1.055
c506 ( 155 0 ) capacitor c=0.0137077f //x=58.285 //y=1.555
c507 ( 153 0 ) capacitor c=0.0158585f //x=58.285 //y=0.9
c508 ( 152 0 ) capacitor c=0.103534f //x=57.91 //y=2.095
c509 ( 151 0 ) capacitor c=0.0229444f //x=57.91 //y=1.71
c510 ( 150 0 ) capacitor c=0.0234359f //x=57.91 //y=1.4
c511 ( 149 0 ) capacitor c=0.019815f //x=57.91 //y=1.055
c512 ( 148 0 ) capacitor c=0.110208f //x=71.8 //y=6.2
c513 ( 147 0 ) capacitor c=0.158957f //x=71.36 //y=6.2
c514 ( 146 0 ) capacitor c=0.110208f //x=58.85 //y=6.2
c515 ( 145 0 ) capacitor c=0.158957f //x=58.41 //y=6.2
c516 ( 139 0 ) capacitor c=0.0014751f //x=71.16 //y=4.88
c517 ( 130 0 ) capacitor c=0.0012618f //x=71.16 //y=2.26
c518 ( 125 0 ) capacitor c=0.0014751f //x=58.21 //y=4.88
c519 ( 116 0 ) capacitor c=0.0012618f //x=58.21 //y=2.26
c520 ( 99 0 ) capacitor c=0.0293561f //x=55.58 //y=5.56
c521 ( 91 0 ) capacitor c=0.029137f //x=54.7 //y=5.56
c522 ( 83 0 ) capacitor c=0.0277605f //x=53.82 //y=5.56
c523 ( 77 0 ) capacitor c=7.36606e-19 //x=56.525 //y=3.885
c524 ( 72 0 ) capacitor c=0.0235722f //x=69.53 //y=3.87
c525 ( 70 0 ) capacitor c=0.0212796f //x=68.93 //y=3.88
c526 ( 68 0 ) capacitor c=0.00400338f //x=66.57 //y=3.9
c527 ( 66 0 ) capacitor c=0.018225f //x=65.97 //y=3.88
c528 ( 64 0 ) capacitor c=0.00418082f //x=64.715 //y=3.9
c529 ( 62 0 ) capacitor c=0.00628181f //x=63.98 //y=3.865
c530 ( 60 0 ) capacitor c=0.00473917f //x=63.235 //y=3.895
c531 ( 58 0 ) capacitor c=0.0174986f //x=62.635 //y=3.88
c532 ( 57 0 ) capacitor c=0.0244456f //x=61.045 //y=3.895
c533 ( 56 0 ) capacitor c=0.00423161f //x=61.39 //y=3.895
c534 ( 54 0 ) capacitor c=0.0209003f //x=58.055 //y=3.88
c535 ( 48 0 ) capacitor c=0.0168323f //x=71.15 //y=3.88
c536 ( 45 0 ) capacitor c=0.0167936f //x=58.21 //y=3.88
c537 ( 37 0 ) capacitor c=0.0172565f //x=56.36 //y=3.88
c538 ( 31 0 ) capacitor c=9.55882e-19 //x=55.58 //y=5.335
c539 ( 28 0 ) capacitor c=0.00740623f //x=54.7 //y=5.335
c540 ( 25 0 ) capacitor c=0.0112819f //x=53.822 //y=5.335
c541 ( 24 0 ) capacitor c=0.0263217f //x=71.16 //y=4.755
c542 ( 23 0 ) capacitor c=0.0136301f //x=71.16 //y=4.04
c543 ( 22 0 ) capacitor c=0.0420707f //x=71.16 //y=3.72
c544 ( 21 0 ) capacitor c=0.00489532f //x=71.16 //y=2.375
c545 ( 20 0 ) capacitor c=0.0266349f //x=58.21 //y=4.755
c546 ( 19 0 ) capacitor c=0.0127018f //x=58.21 //y=4.04
c547 ( 18 0 ) capacitor c=0.038409f //x=58.21 //y=3.72
c548 ( 17 0 ) capacitor c=0.00495287f //x=58.21 //y=2.375
c549 ( 16 0 ) capacitor c=0.0325919f //x=56.36 //y=5.25
c550 ( 15 0 ) capacitor c=0.0131885f //x=56.36 //y=4.045
c551 ( 14 0 ) capacitor c=0.04914f //x=56.36 //y=3.725
c552 ( 12 0 ) capacitor c=0.0047266f //x=55.96 //y=1.845
c553 ( 11 0 ) capacitor c=0.0133232f //x=56.275 //y=1.845
c554 ( 10 0 ) capacitor c=0.0167333f //x=55.875 //y=1.76
c555 ( 9 0 ) capacitor c=0.0110969f //x=55.875 //y=1.305
c556 ( 7 0 ) capacitor c=0.0229543f //x=56.275 //y=5.335
c557 ( 6 0 ) capacitor c=0.00933983f //x=55.58 //y=5.56
c558 ( 3 0 ) capacitor c=0.019444f //x=55.465 //y=5.335
c559 ( 1 0 ) capacitor c=0.0146659f //x=54.58 //y=5.335
r560 (  182 184 ) resistor r=26.9307 //w=0.15 //l=0.106066 //layer=ply \
 //thickness=0.18 //x=71.725 //y=4.97 //x2=71.8 //y2=5.045
r561 (  182 183 ) resistor r=148.702 //w=0.094 //l=0.29 //layer=ply \
 //thickness=0.18 //x=71.725 //y=4.97 //x2=71.435 //y2=4.97
r562 (  181 202 ) resistor r=45.1352 //w=0.168 //l=0.173853 //layer=ply \
 //thickness=0.18 //x=71.39 //y=1.4 //x2=71.35 //y2=1.555
r563 (  180 201 ) resistor r=45.1352 //w=0.168 //l=0.173853 //layer=ply \
 //thickness=0.18 //x=71.39 //y=1.055 //x2=71.35 //y2=0.9
r564 (  180 181 ) resistor r=176.904 //w=0.094 //l=0.345 //layer=ply \
 //thickness=0.18 //x=71.39 //y=1.055 //x2=71.39 //y2=1.4
r565 (  177 183 ) resistor r=22.7971 //w=0.269 //l=0.106066 //layer=ply \
 //thickness=0.18 //x=71.36 //y=5.045 //x2=71.435 //y2=4.97
r566 (  177 200 ) resistor r=35.8364 //w=0.269 //l=0.270185 //layer=ply \
 //thickness=0.18 //x=71.36 //y=5.045 //x2=71.16 //y2=4.88
r567 (  175 196 ) resistor r=10.701 //w=0.21 //l=0.115 //layer=ply \
 //thickness=0.18 //x=71.015 //y=1.555 //x2=70.9 //y2=1.555
r568 (  174 202 ) resistor r=5.52526 //w=0.168 //l=0.115 //layer=ply \
 //thickness=0.18 //x=71.235 //y=1.555 //x2=71.35 //y2=1.555
r569 (  173 195 ) resistor r=5.52526 //w=0.168 //l=0.115 //layer=ply \
 //thickness=0.18 //x=71.015 //y=0.9 //x2=70.9 //y2=0.9
r570 (  172 201 ) resistor r=5.52526 //w=0.168 //l=0.115 //layer=ply \
 //thickness=0.18 //x=71.235 //y=0.9 //x2=71.35 //y2=0.9
r571 (  172 173 ) resistor r=112.809 //w=0.094 //l=0.22 //layer=ply \
 //thickness=0.18 //x=71.235 //y=0.9 //x2=71.015 //y2=0.9
r572 (  171 198 ) resistor r=58.7805 //w=0.246 //l=0.373497 //layer=ply \
 //thickness=0.18 //x=70.86 //y=2.095 //x2=71.16 //y2=2.26
r573 (  170 196 ) resistor r=39.5823 //w=0.21 //l=0.173853 //layer=ply \
 //thickness=0.18 //x=70.86 //y=1.71 //x2=70.9 //y2=1.555
r574 (  170 171 ) resistor r=197.415 //w=0.094 //l=0.385 //layer=ply \
 //thickness=0.18 //x=70.86 //y=1.71 //x2=70.86 //y2=2.095
r575 (  169 196 ) resistor r=39.5823 //w=0.21 //l=0.173853 //layer=ply \
 //thickness=0.18 //x=70.86 //y=1.4 //x2=70.9 //y2=1.555
r576 (  168 195 ) resistor r=45.1352 //w=0.168 //l=0.173853 //layer=ply \
 //thickness=0.18 //x=70.86 //y=1.055 //x2=70.9 //y2=0.9
r577 (  168 169 ) resistor r=176.904 //w=0.094 //l=0.345 //layer=ply \
 //thickness=0.18 //x=70.86 //y=1.055 //x2=70.86 //y2=1.4
r578 (  163 165 ) resistor r=26.9307 //w=0.15 //l=0.106066 //layer=ply \
 //thickness=0.18 //x=58.775 //y=4.97 //x2=58.85 //y2=5.045
r579 (  163 164 ) resistor r=148.702 //w=0.094 //l=0.29 //layer=ply \
 //thickness=0.18 //x=58.775 //y=4.97 //x2=58.485 //y2=4.97
r580 (  162 194 ) resistor r=45.1352 //w=0.168 //l=0.173853 //layer=ply \
 //thickness=0.18 //x=58.44 //y=1.4 //x2=58.4 //y2=1.555
r581 (  161 193 ) resistor r=45.1352 //w=0.168 //l=0.173853 //layer=ply \
 //thickness=0.18 //x=58.44 //y=1.055 //x2=58.4 //y2=0.9
r582 (  161 162 ) resistor r=176.904 //w=0.094 //l=0.345 //layer=ply \
 //thickness=0.18 //x=58.44 //y=1.055 //x2=58.44 //y2=1.4
r583 (  158 164 ) resistor r=22.7971 //w=0.269 //l=0.106066 //layer=ply \
 //thickness=0.18 //x=58.41 //y=5.045 //x2=58.485 //y2=4.97
r584 (  158 192 ) resistor r=35.8364 //w=0.269 //l=0.270185 //layer=ply \
 //thickness=0.18 //x=58.41 //y=5.045 //x2=58.21 //y2=4.88
r585 (  156 188 ) resistor r=10.701 //w=0.21 //l=0.115 //layer=ply \
 //thickness=0.18 //x=58.065 //y=1.555 //x2=57.95 //y2=1.555
r586 (  155 194 ) resistor r=5.52526 //w=0.168 //l=0.115 //layer=ply \
 //thickness=0.18 //x=58.285 //y=1.555 //x2=58.4 //y2=1.555
r587 (  154 187 ) resistor r=5.52526 //w=0.168 //l=0.115 //layer=ply \
 //thickness=0.18 //x=58.065 //y=0.9 //x2=57.95 //y2=0.9
r588 (  153 193 ) resistor r=5.52526 //w=0.168 //l=0.115 //layer=ply \
 //thickness=0.18 //x=58.285 //y=0.9 //x2=58.4 //y2=0.9
r589 (  153 154 ) resistor r=112.809 //w=0.094 //l=0.22 //layer=ply \
 //thickness=0.18 //x=58.285 //y=0.9 //x2=58.065 //y2=0.9
r590 (  152 190 ) resistor r=58.7805 //w=0.246 //l=0.373497 //layer=ply \
 //thickness=0.18 //x=57.91 //y=2.095 //x2=58.21 //y2=2.26
r591 (  151 188 ) resistor r=39.5823 //w=0.21 //l=0.173853 //layer=ply \
 //thickness=0.18 //x=57.91 //y=1.71 //x2=57.95 //y2=1.555
r592 (  151 152 ) resistor r=197.415 //w=0.094 //l=0.385 //layer=ply \
 //thickness=0.18 //x=57.91 //y=1.71 //x2=57.91 //y2=2.095
r593 (  150 188 ) resistor r=39.5823 //w=0.21 //l=0.173853 //layer=ply \
 //thickness=0.18 //x=57.91 //y=1.4 //x2=57.95 //y2=1.555
r594 (  149 187 ) resistor r=45.1352 //w=0.168 //l=0.173853 //layer=ply \
 //thickness=0.18 //x=57.91 //y=1.055 //x2=57.95 //y2=0.9
r595 (  149 150 ) resistor r=176.904 //w=0.094 //l=0.345 //layer=ply \
 //thickness=0.18 //x=57.91 //y=1.055 //x2=57.91 //y2=1.4
r596 (  148 184 ) resistor r=592.245 //w=0.094 //l=1.155 //layer=ply \
 //thickness=0.18 //x=71.8 //y=6.2 //x2=71.8 //y2=5.045
r597 (  147 177 ) resistor r=592.245 //w=0.094 //l=1.155 //layer=ply \
 //thickness=0.18 //x=71.36 //y=6.2 //x2=71.36 //y2=5.045
r598 (  146 165 ) resistor r=592.245 //w=0.094 //l=1.155 //layer=ply \
 //thickness=0.18 //x=58.85 //y=6.2 //x2=58.85 //y2=5.045
r599 (  145 158 ) resistor r=592.245 //w=0.094 //l=1.155 //layer=ply \
 //thickness=0.18 //x=58.41 //y=6.2 //x2=58.41 //y2=5.045
r600 (  144 174 ) resistor r=56.4043 //w=0.094 //l=0.11 //layer=ply \
 //thickness=0.18 //x=71.125 //y=1.555 //x2=71.235 //y2=1.555
r601 (  144 175 ) resistor r=56.4043 //w=0.094 //l=0.11 //layer=ply \
 //thickness=0.18 //x=71.125 //y=1.555 //x2=71.015 //y2=1.555
r602 (  143 155 ) resistor r=56.4043 //w=0.094 //l=0.11 //layer=ply \
 //thickness=0.18 //x=58.175 //y=1.555 //x2=58.285 //y2=1.555
r603 (  143 156 ) resistor r=56.4043 //w=0.094 //l=0.11 //layer=ply \
 //thickness=0.18 //x=58.175 //y=1.555 //x2=58.065 //y2=1.555
r604 (  139 200 ) resistor r=152 //w=0.17 //l=0.17 //layer=licon //count=1 \
 //x=71.16 //y=4.88 //x2=71.16 //y2=4.88
r605 (  130 198 ) resistor r=152 //w=0.17 //l=0.17 //layer=licon //count=1 \
 //x=71.16 //y=2.26 //x2=71.16 //y2=2.26
r606 (  125 192 ) resistor r=152 //w=0.17 //l=0.17 //layer=licon //count=1 \
 //x=58.21 //y=4.88 //x2=58.21 //y2=4.88
r607 (  116 190 ) resistor r=152 //w=0.17 //l=0.17 //layer=licon //count=1 \
 //x=58.21 //y=2.26 //x2=58.21 //y2=2.26
r608 (  99 207 ) resistor r=23.615 //w=0.187 //l=0.345 //layer=li \
 //thickness=0.1 //x=55.58 //y=5.56 //x2=55.58 //y2=5.905
r609 (  91 206 ) resistor r=23.615 //w=0.187 //l=0.345 //layer=li \
 //thickness=0.1 //x=54.7 //y=5.56 //x2=54.7 //y2=5.905
r610 (  83 205 ) resistor r=23.615 //w=0.187 //l=0.345 //layer=li \
 //thickness=0.1 //x=53.82 //y=5.56 //x2=53.82 //y2=5.905
r611 (  75 77 ) resistor r=0.10734 //w=0.281 //l=0.16 //layer=m2 \
 //thickness=0.36 //x=56.365 //y=3.885 //x2=56.525 //y2=3.885
r612 (  72 81 ) resistor r=1.03061 //w=0.197 //l=1.62499 //layer=m2 \
 //thickness=0.36 //x=69.53 //y=3.87 //x2=71.15 //y2=3.88
r613 (  72 73 ) resistor r=0.410305 //w=0.131 //l=0.43 //layer=m2 \
 //thickness=0.36 //x=69.53 //y=3.87 //x2=69.1 //y2=3.87
r614 (  70 73 ) resistor r=0.125 //w=0.17 //l=0.174929 //layer=m2 \
 //thickness=0.36 //x=68.93 //y=3.88 //x2=69.1 //y2=3.87
r615 (  70 71 ) resistor r=2.08969 //w=0.131 //l=2.19 //layer=m2 \
 //thickness=0.36 //x=68.93 //y=3.88 //x2=66.74 //y2=3.88
r616 (  68 71 ) resistor r=0.125 //w=0.17 //l=0.179722 //layer=m2 \
 //thickness=0.36 //x=66.57 //y=3.9 //x2=66.74 //y2=3.88
r617 (  68 69 ) resistor r=0.329198 //w=0.131 //l=0.345 //layer=m2 \
 //thickness=0.36 //x=66.57 //y=3.9 //x2=66.225 //y2=3.9
r618 (  66 69 ) resistor r=0.1875 //w=0.17 //l=0.264811 //layer=m2 \
 //thickness=0.36 //x=65.97 //y=3.88 //x2=66.225 //y2=3.9
r619 (  66 67 ) resistor r=1.03531 //w=0.131 //l=1.085 //layer=m2 \
 //thickness=0.36 //x=65.97 //y=3.88 //x2=64.885 //y2=3.88
r620 (  64 67 ) resistor r=0.125 //w=0.17 //l=0.179722 //layer=m2 \
 //thickness=0.36 //x=64.715 //y=3.9 //x2=64.885 //y2=3.88
r621 (  64 65 ) resistor r=0.329198 //w=0.131 //l=0.345 //layer=m2 \
 //thickness=0.36 //x=64.715 //y=3.9 //x2=64.37 //y2=3.9
r622 (  62 65 ) resistor r=0.286765 //w=0.17 //l=0.407124 //layer=m2 \
 //thickness=0.36 //x=63.98 //y=3.865 //x2=64.37 //y2=3.9
r623 (  62 63 ) resistor r=0.410305 //w=0.131 //l=0.43 //layer=m2 \
 //thickness=0.36 //x=63.98 //y=3.865 //x2=63.55 //y2=3.865
r624 (  60 63 ) resistor r=0.231618 //w=0.17 //l=0.329659 //layer=m2 \
 //thickness=0.36 //x=63.235 //y=3.895 //x2=63.55 //y2=3.865
r625 (  60 61 ) resistor r=0.329198 //w=0.131 //l=0.345 //layer=m2 \
 //thickness=0.36 //x=63.235 //y=3.895 //x2=62.89 //y2=3.895
r626 (  58 61 ) resistor r=0.1875 //w=0.17 //l=0.262393 //layer=m2 \
 //thickness=0.36 //x=62.635 //y=3.88 //x2=62.89 //y2=3.895
r627 (  58 59 ) resistor r=1.02576 //w=0.131 //l=1.075 //layer=m2 \
 //thickness=0.36 //x=62.635 //y=3.88 //x2=61.56 //y2=3.88
r628 (  57 79 ) resistor r=1.89299 //w=0.187 //l=2.83749 //layer=m2 \
 //thickness=0.36 //x=61.045 //y=3.895 //x2=58.215 //y2=3.88
r629 (  56 59 ) resistor r=0.125 //w=0.17 //l=0.177341 //layer=m2 \
 //thickness=0.36 //x=61.39 //y=3.895 //x2=61.56 //y2=3.88
r630 (  56 57 ) resistor r=0.329198 //w=0.131 //l=0.345 //layer=m2 \
 //thickness=0.36 //x=61.39 //y=3.895 //x2=61.045 //y2=3.895
r631 (  54 79 ) resistor r=0.108234 //w=0.187 //l=0.16 //layer=m2 \
 //thickness=0.36 //x=58.055 //y=3.88 //x2=58.215 //y2=3.88
r632 (  54 77 ) resistor r=1.45992 //w=0.131 //l=1.53 //layer=m2 \
 //thickness=0.36 //x=58.055 //y=3.88 //x2=56.525 //y2=3.88
r633 (  53 139 ) resistor r=9.3 //w=0.17 //l=0.17 //layer=mcon //count=1 \
 //x=71.16 //y=4.88 //x2=71.16 //y2=4.88
r634 (  51 130 ) resistor r=9.3 //w=0.17 //l=0.17 //layer=mcon //count=1 \
 //x=71.16 //y=2.26 //x2=71.16 //y2=2.26
r635 (  48 81 ) resistor r=4.5 //w=0.15 //l=0.15 //layer=via1 //count=1 \
 //x=71.15 //y=3.88 //x2=71.15 //y2=3.88
r636 (  45 79 ) resistor r=4.5 //w=0.15 //l=0.15 //layer=via1 //count=1 \
 //x=58.215 //y=3.88 //x2=58.215 //y2=3.88
r637 (  43 125 ) resistor r=9.3 //w=0.17 //l=0.17 //layer=mcon //count=1 \
 //x=58.21 //y=4.88 //x2=58.21 //y2=4.88
r638 (  41 116 ) resistor r=9.3 //w=0.17 //l=0.17 //layer=mcon //count=1 \
 //x=58.21 //y=2.26 //x2=58.21 //y2=2.26
r639 (  39 75 ) resistor r=4.5 //w=0.15 //l=0.15 //layer=via1 //count=1 \
 //x=56.365 //y=3.885 //x2=56.365 //y2=3.885
r640 (  37 39 ) resistor r=0.00167112 //w=0.374 //l=0.005 //layer=m1 \
 //thickness=0.36 //x=56.415 //y=3.88 //x2=56.415 //y2=3.885
r641 (  35 203 ) resistor r=9.3 //w=0.17 //l=0.17 //layer=mcon //count=1 \
 //x=55.875 //y=1.19 //x2=55.875 //y2=1.19
r642 (  33 99 ) resistor r=9.3 //w=0.17 //l=0.17 //layer=mcon //count=1 \
 //x=55.58 //y=5.56 //x2=55.58 //y2=5.56
r643 (  30 91 ) resistor r=9.3 //w=0.17 //l=0.17 //layer=mcon //count=1 \
 //x=54.7 //y=5.56 //x2=54.7 //y2=5.56
r644 (  28 30 ) resistor r=0.121228 //w=0.232 //l=0.225 //layer=m1 \
 //thickness=0.36 //x=54.7 //y=5.335 //x2=54.7 //y2=5.56
r645 (  27 83 ) resistor r=9.3 //w=0.17 //l=0.17 //layer=mcon //count=1 \
 //x=53.82 //y=5.56 //x2=53.82 //y2=5.56
r646 (  25 27 ) resistor r=0.129608 //w=0.217 //l=0.225 //layer=m1 \
 //thickness=0.36 //x=53.822 //y=5.335 //x2=53.822 //y2=5.56
r647 (  24 53 ) resistor r=0.0760407 //w=0.238 //l=0.125 //layer=m1 \
 //thickness=0.36 //x=71.16 //y=4.755 //x2=71.16 //y2=4.88
r648 (  23 48 ) resistor r=0.0909648 //w=0.371 //l=0.186762 //layer=m1 \
 //thickness=0.36 //x=71.16 //y=4.04 //x2=71.102 //y2=3.88
r649 (  23 24 ) resistor r=0.682252 //w=0.131 //l=0.715 //layer=m1 \
 //thickness=0.36 //x=71.16 //y=4.04 //x2=71.16 //y2=4.755
r650 (  22 48 ) resistor r=0.0909648 //w=0.371 //l=0.186762 //layer=m1 \
 //thickness=0.36 //x=71.16 //y=3.72 //x2=71.102 //y2=3.88
r651 (  21 51 ) resistor r=0.0719237 //w=0.222 //l=0.115 //layer=m1 \
 //thickness=0.36 //x=71.16 //y=2.375 //x2=71.16 //y2=2.26
r652 (  21 22 ) resistor r=1.2834 //w=0.131 //l=1.345 //layer=m1 \
 //thickness=0.36 //x=71.16 //y=2.375 //x2=71.16 //y2=3.72
r653 (  20 43 ) resistor r=0.0760407 //w=0.238 //l=0.125 //layer=m1 \
 //thickness=0.36 //x=58.21 //y=4.755 //x2=58.21 //y2=4.88
r654 (  19 45 ) resistor r=0.0910802 //w=0.374 //l=0.185472 //layer=m1 \
 //thickness=0.36 //x=58.21 //y=4.04 //x2=58.265 //y2=3.88
r655 (  19 20 ) resistor r=0.682252 //w=0.131 //l=0.715 //layer=m1 \
 //thickness=0.36 //x=58.21 //y=4.04 //x2=58.21 //y2=4.755
r656 (  18 45 ) resistor r=0.0910802 //w=0.374 //l=0.185472 //layer=m1 \
 //thickness=0.36 //x=58.21 //y=3.72 //x2=58.265 //y2=3.88
r657 (  17 41 ) resistor r=0.0719237 //w=0.222 //l=0.115 //layer=m1 \
 //thickness=0.36 //x=58.21 //y=2.375 //x2=58.21 //y2=2.26
r658 (  17 18 ) resistor r=1.2834 //w=0.131 //l=1.345 //layer=m1 \
 //thickness=0.36 //x=58.21 //y=2.375 //x2=58.21 //y2=3.72
r659 (  15 39 ) resistor r=0.0910802 //w=0.374 //l=0.185472 //layer=m1 \
 //thickness=0.36 //x=56.36 //y=4.045 //x2=56.415 //y2=3.885
r660 (  15 16 ) resistor r=1.14981 //w=0.131 //l=1.205 //layer=m1 \
 //thickness=0.36 //x=56.36 //y=4.045 //x2=56.36 //y2=5.25
r661 (  14 37 ) resistor r=0.089409 //w=0.374 //l=0.180416 //layer=m1 \
 //thickness=0.36 //x=56.36 //y=3.725 //x2=56.415 //y2=3.88
r662 (  13 14 ) resistor r=1.71279 //w=0.131 //l=1.795 //layer=m1 \
 //thickness=0.36 //x=56.36 //y=1.93 //x2=56.36 //y2=3.725
r663 (  11 13 ) resistor r=0.0698411 //w=0.17 //l=0.120208 //layer=m1 \
 //thickness=0.36 //x=56.275 //y=1.845 //x2=56.36 //y2=1.93
r664 (  11 12 ) resistor r=0.300573 //w=0.131 //l=0.315 //layer=m1 \
 //thickness=0.36 //x=56.275 //y=1.845 //x2=55.96 //y2=1.845
r665 (  10 12 ) resistor r=0.0698411 //w=0.17 //l=0.120208 //layer=m1 \
 //thickness=0.36 //x=55.875 //y=1.76 //x2=55.96 //y2=1.845
r666 (  9 35 ) resistor r=0.0717383 //w=0.224 //l=0.115 //layer=m1 \
 //thickness=0.36 //x=55.875 //y=1.305 //x2=55.875 //y2=1.19
r667 (  9 10 ) resistor r=0.43416 //w=0.131 //l=0.455 //layer=m1 \
 //thickness=0.36 //x=55.875 //y=1.305 //x2=55.875 //y2=1.76
r668 (  8 31 ) resistor r=0.0675342 //w=0.23 //l=0.115 //layer=m1 \
 //thickness=0.36 //x=55.695 //y=5.335 //x2=55.58 //y2=5.335
r669 (  7 16 ) resistor r=0.0698411 //w=0.17 //l=0.120208 //layer=m1 \
 //thickness=0.36 //x=56.275 //y=5.335 //x2=56.36 //y2=5.25
r670 (  7 8 ) resistor r=0.553435 //w=0.131 //l=0.58 //layer=m1 \
 //thickness=0.36 //x=56.275 //y=5.335 //x2=55.695 //y2=5.335
r671 (  6 33 ) resistor r=0.00118313 //w=0.23 //layer=m1 //thickness=0.36 \
 //x=55.58 //y=5.56 //x2=55.58 //y2=5.56
r672 (  5 31 ) resistor r=0.002872 //w=0.34 //l=0.085 //layer=m1 \
 //thickness=0.36 //x=55.58 //y=5.42 //x2=55.58 //y2=5.335
r673 (  5 6 ) resistor r=0.091623 //w=0.191 //l=0.14 //layer=m1 \
 //thickness=0.36 //x=55.58 //y=5.42 //x2=55.58 //y2=5.56
r674 (  4 28 ) resistor r=0.0262263 //w=0.232 //l=0.12 //layer=m1 \
 //thickness=0.36 //x=54.82 //y=5.335 //x2=54.7 //y2=5.335
r675 (  3 31 ) resistor r=0.0675342 //w=0.23 //l=0.115 //layer=m1 \
 //thickness=0.36 //x=55.465 //y=5.335 //x2=55.58 //y2=5.335
r676 (  3 4 ) resistor r=0.615458 //w=0.131 //l=0.645 //layer=m1 \
 //thickness=0.36 //x=55.465 //y=5.335 //x2=54.82 //y2=5.335
r677 (  2 25 ) resistor r=0.0222262 //w=0.217 //l=0.118 //layer=m1 \
 //thickness=0.36 //x=53.94 //y=5.335 //x2=53.822 //y2=5.335
r678 (  1 28 ) resistor r=0.0262263 //w=0.232 //l=0.12 //layer=m1 \
 //thickness=0.36 //x=54.58 //y=5.335 //x2=54.7 //y2=5.335
r679 (  1 2 ) resistor r=0.610687 //w=0.131 //l=0.64 //layer=m1 \
 //thickness=0.36 //x=54.58 //y=5.335 //x2=53.94 //y2=5.335
ends PM_TMRDFFRNQX1\%noxref_12

subckt PM_TMRDFFRNQX1\%RN ( 1 2 3 4 5 6 7 8 9 10 12 14 15 18 19 22 23 24 25 27 \
 28 31 32 33 34 35 36 94 96 97 99 100 102 103 105 109 113 114 121 122 129 130 \
 132 133 136 141 146 151 156 161 166 171 176 181 186 191 196 201 206 211 216 \
 221 225 226 227 228 229 230 231 232 233 234 235 236 237 238 239 240 241 242 \
 243 244 245 246 247 248 249 250 251 255 256 257 262 264 267 268 272 273 274 \
 279 281 284 285 286 287 288 290 296 297 298 299 300 308 309 310 315 317 320 \
 321 325 326 327 332 334 337 338 339 340 341 343 349 350 351 352 353 361 362 \
 363 368 370 373 374 378 379 380 385 387 390 391 392 393 394 396 402 403 404 \
 405 406 412 413 418 422 423 428 434 443 444 449 453 454 459 465 474 475 480 \
 484 485 490 496 )
c1439 ( 496 0 ) capacitor c=0.0369044f //x=72.27 //y=4.88
c1440 ( 490 0 ) capacitor c=0.0710579f //x=68.57 //y=4.88
c1441 ( 485 0 ) capacitor c=0.0278202f //x=68.57 //y=2.095
c1442 ( 484 0 ) capacitor c=0.0490597f //x=68.57 //y=2.26
c1443 ( 480 0 ) capacitor c=0.0710579f //x=60.43 //y=4.88
c1444 ( 475 0 ) capacitor c=0.0278202f //x=60.43 //y=2.095
c1445 ( 474 0 ) capacitor c=0.0490597f //x=60.43 //y=2.26
c1446 ( 465 0 ) capacitor c=0.0369044f //x=46.37 //y=4.88
c1447 ( 459 0 ) capacitor c=0.0710579f //x=42.67 //y=4.88
c1448 ( 454 0 ) capacitor c=0.0278202f //x=42.67 //y=2.095
c1449 ( 453 0 ) capacitor c=0.0490597f //x=42.67 //y=2.26
c1450 ( 449 0 ) capacitor c=0.0710579f //x=34.53 //y=4.88
c1451 ( 444 0 ) capacitor c=0.0278202f //x=34.53 //y=2.095
c1452 ( 443 0 ) capacitor c=0.0490597f //x=34.53 //y=2.26
c1453 ( 434 0 ) capacitor c=0.0369044f //x=20.47 //y=4.88
c1454 ( 428 0 ) capacitor c=0.0710579f //x=16.77 //y=4.88
c1455 ( 423 0 ) capacitor c=0.0278202f //x=16.77 //y=2.095
c1456 ( 422 0 ) capacitor c=0.0490597f //x=16.77 //y=2.26
c1457 ( 418 0 ) capacitor c=0.0710579f //x=8.63 //y=4.88
c1458 ( 413 0 ) capacitor c=0.0278202f //x=8.63 //y=2.095
c1459 ( 412 0 ) capacitor c=0.0490597f //x=8.63 //y=2.26
c1460 ( 406 0 ) capacitor c=0.0309248f //x=72.605 //y=4.97
c1461 ( 405 0 ) capacitor c=0.0852528f //x=72.36 //y=2.095
c1462 ( 404 0 ) capacitor c=0.0170266f //x=72.36 //y=1.63
c1463 ( 403 0 ) capacitor c=0.018609f //x=72.36 //y=1.4
c1464 ( 402 0 ) capacitor c=0.0186599f //x=72.36 //y=1.09
c1465 ( 396 0 ) capacitor c=0.0146988f //x=72.205 //y=1.555
c1466 ( 394 0 ) capacitor c=0.0148531f //x=72.205 //y=0.935
c1467 ( 393 0 ) capacitor c=0.0334406f //x=71.835 //y=1.4
c1468 ( 392 0 ) capacitor c=0.0173191f //x=71.835 //y=1.09
c1469 ( 391 0 ) capacitor c=0.0443175f //x=69.09 //y=1.44
c1470 ( 390 0 ) capacitor c=0.0199703f //x=69.09 //y=1.095
c1471 ( 387 0 ) capacitor c=0.0160331f //x=68.935 //y=1.595
c1472 ( 385 0 ) capacitor c=0.0157807f //x=68.935 //y=0.94
c1473 ( 380 0 ) capacitor c=0.0219045f //x=68.56 //y=1.75
c1474 ( 379 0 ) capacitor c=0.0207489f //x=68.56 //y=1.44
c1475 ( 378 0 ) capacitor c=0.0194091f //x=68.56 //y=1.095
c1476 ( 374 0 ) capacitor c=0.0443175f //x=60.95 //y=1.44
c1477 ( 373 0 ) capacitor c=0.0199703f //x=60.95 //y=1.095
c1478 ( 370 0 ) capacitor c=0.0160331f //x=60.795 //y=1.595
c1479 ( 368 0 ) capacitor c=0.0157807f //x=60.795 //y=0.94
c1480 ( 363 0 ) capacitor c=0.0219045f //x=60.42 //y=1.75
c1481 ( 362 0 ) capacitor c=0.0207489f //x=60.42 //y=1.44
c1482 ( 361 0 ) capacitor c=0.0194091f //x=60.42 //y=1.095
c1483 ( 353 0 ) capacitor c=0.0309248f //x=46.705 //y=4.97
c1484 ( 352 0 ) capacitor c=0.0852528f //x=46.46 //y=2.095
c1485 ( 351 0 ) capacitor c=0.0170266f //x=46.46 //y=1.63
c1486 ( 350 0 ) capacitor c=0.018609f //x=46.46 //y=1.4
c1487 ( 349 0 ) capacitor c=0.0186599f //x=46.46 //y=1.09
c1488 ( 343 0 ) capacitor c=0.0146988f //x=46.305 //y=1.555
c1489 ( 341 0 ) capacitor c=0.0148531f //x=46.305 //y=0.935
c1490 ( 340 0 ) capacitor c=0.0334406f //x=45.935 //y=1.4
c1491 ( 339 0 ) capacitor c=0.0173191f //x=45.935 //y=1.09
c1492 ( 338 0 ) capacitor c=0.0443175f //x=43.19 //y=1.44
c1493 ( 337 0 ) capacitor c=0.0199703f //x=43.19 //y=1.095
c1494 ( 334 0 ) capacitor c=0.0160331f //x=43.035 //y=1.595
c1495 ( 332 0 ) capacitor c=0.0157807f //x=43.035 //y=0.94
c1496 ( 327 0 ) capacitor c=0.0219045f //x=42.66 //y=1.75
c1497 ( 326 0 ) capacitor c=0.0207489f //x=42.66 //y=1.44
c1498 ( 325 0 ) capacitor c=0.0194091f //x=42.66 //y=1.095
c1499 ( 321 0 ) capacitor c=0.0443175f //x=35.05 //y=1.44
c1500 ( 320 0 ) capacitor c=0.0199703f //x=35.05 //y=1.095
c1501 ( 317 0 ) capacitor c=0.0160331f //x=34.895 //y=1.595
c1502 ( 315 0 ) capacitor c=0.0157807f //x=34.895 //y=0.94
c1503 ( 310 0 ) capacitor c=0.0219045f //x=34.52 //y=1.75
c1504 ( 309 0 ) capacitor c=0.0207489f //x=34.52 //y=1.44
c1505 ( 308 0 ) capacitor c=0.0194091f //x=34.52 //y=1.095
c1506 ( 300 0 ) capacitor c=0.0309248f //x=20.805 //y=4.97
c1507 ( 299 0 ) capacitor c=0.0852528f //x=20.56 //y=2.095
c1508 ( 298 0 ) capacitor c=0.0170266f //x=20.56 //y=1.63
c1509 ( 297 0 ) capacitor c=0.018609f //x=20.56 //y=1.4
c1510 ( 296 0 ) capacitor c=0.0186599f //x=20.56 //y=1.09
c1511 ( 290 0 ) capacitor c=0.0146988f //x=20.405 //y=1.555
c1512 ( 288 0 ) capacitor c=0.0148531f //x=20.405 //y=0.935
c1513 ( 287 0 ) capacitor c=0.0334406f //x=20.035 //y=1.4
c1514 ( 286 0 ) capacitor c=0.0173191f //x=20.035 //y=1.09
c1515 ( 285 0 ) capacitor c=0.0443175f //x=17.29 //y=1.44
c1516 ( 284 0 ) capacitor c=0.0199703f //x=17.29 //y=1.095
c1517 ( 281 0 ) capacitor c=0.0160331f //x=17.135 //y=1.595
c1518 ( 279 0 ) capacitor c=0.0157807f //x=17.135 //y=0.94
c1519 ( 274 0 ) capacitor c=0.0219045f //x=16.76 //y=1.75
c1520 ( 273 0 ) capacitor c=0.0207489f //x=16.76 //y=1.44
c1521 ( 272 0 ) capacitor c=0.0194091f //x=16.76 //y=1.095
c1522 ( 268 0 ) capacitor c=0.0443175f //x=9.15 //y=1.44
c1523 ( 267 0 ) capacitor c=0.0199703f //x=9.15 //y=1.095
c1524 ( 264 0 ) capacitor c=0.0160331f //x=8.995 //y=1.595
c1525 ( 262 0 ) capacitor c=0.0157807f //x=8.995 //y=0.94
c1526 ( 257 0 ) capacitor c=0.0219045f //x=8.62 //y=1.75
c1527 ( 256 0 ) capacitor c=0.0207489f //x=8.62 //y=1.44
c1528 ( 255 0 ) capacitor c=0.0194091f //x=8.62 //y=1.095
c1529 ( 251 0 ) capacitor c=0.110208f //x=72.68 //y=6.2
c1530 ( 250 0 ) capacitor c=0.110214f //x=72.24 //y=6.2
c1531 ( 249 0 ) capacitor c=0.159671f //x=68.75 //y=6.2
c1532 ( 248 0 ) capacitor c=0.110208f //x=68.31 //y=6.2
c1533 ( 247 0 ) capacitor c=0.159671f //x=60.61 //y=6.2
c1534 ( 246 0 ) capacitor c=0.110208f //x=60.17 //y=6.2
c1535 ( 245 0 ) capacitor c=0.110208f //x=46.78 //y=6.2
c1536 ( 244 0 ) capacitor c=0.110214f //x=46.34 //y=6.2
c1537 ( 243 0 ) capacitor c=0.159671f //x=42.85 //y=6.2
c1538 ( 242 0 ) capacitor c=0.110208f //x=42.41 //y=6.2
c1539 ( 241 0 ) capacitor c=0.159671f //x=34.71 //y=6.2
c1540 ( 240 0 ) capacitor c=0.110208f //x=34.27 //y=6.2
c1541 ( 239 0 ) capacitor c=0.110208f //x=20.88 //y=6.2
c1542 ( 238 0 ) capacitor c=0.110214f //x=20.44 //y=6.2
c1543 ( 237 0 ) capacitor c=0.159671f //x=16.95 //y=6.2
c1544 ( 236 0 ) capacitor c=0.110208f //x=16.51 //y=6.2
c1545 ( 235 0 ) capacitor c=0.159671f //x=8.81 //y=6.2
c1546 ( 234 0 ) capacitor c=0.110208f //x=8.37 //y=6.2
c1547 ( 221 0 ) capacitor c=0.00129935f //x=72.27 //y=4.88
c1548 ( 216 0 ) capacitor c=0.00121786f //x=72.27 //y=2.26
c1549 ( 211 0 ) capacitor c=7.7417e-19 //x=68.57 //y=4.88
c1550 ( 206 0 ) capacitor c=0.00118671f //x=68.57 //y=2.26
c1551 ( 201 0 ) capacitor c=7.7417e-19 //x=60.43 //y=4.88
c1552 ( 196 0 ) capacitor c=0.00118671f //x=60.43 //y=2.26
c1553 ( 191 0 ) capacitor c=0.00129935f //x=46.37 //y=4.88
c1554 ( 186 0 ) capacitor c=0.00121786f //x=46.37 //y=2.26
c1555 ( 181 0 ) capacitor c=7.7417e-19 //x=42.67 //y=4.88
c1556 ( 176 0 ) capacitor c=0.00118671f //x=42.67 //y=2.26
c1557 ( 171 0 ) capacitor c=7.7417e-19 //x=34.53 //y=4.88
c1558 ( 166 0 ) capacitor c=0.00118671f //x=34.53 //y=2.26
c1559 ( 161 0 ) capacitor c=0.00129935f //x=20.47 //y=4.88
c1560 ( 156 0 ) capacitor c=0.00121786f //x=20.47 //y=2.26
c1561 ( 151 0 ) capacitor c=7.7417e-19 //x=16.77 //y=4.88
c1562 ( 146 0 ) capacitor c=0.00118671f //x=16.77 //y=2.26
c1563 ( 141 0 ) capacitor c=7.7417e-19 //x=8.63 //y=4.88
c1564 ( 136 0 ) capacitor c=0.00118671f //x=8.63 //y=2.26
c1565 ( 133 0 ) capacitor c=0.0848638f //x=72.065 //y=2.355
c1566 ( 132 0 ) capacitor c=0.00518283f //x=72.225 //y=2.355
c1567 ( 130 0 ) capacitor c=0.00830419f //x=68.735 //y=2.315
c1568 ( 129 0 ) capacitor c=0.19753f //x=68.415 //y=2.315
c1569 ( 122 0 ) capacitor c=0.00776587f //x=42.835 //y=2.315
c1570 ( 121 0 ) capacitor c=0.176703f //x=42.515 //y=2.315
c1571 ( 114 0 ) capacitor c=0.00776587f //x=16.935 //y=2.315
c1572 ( 113 0 ) capacitor c=0.176703f //x=16.615 //y=2.315
c1573 ( 109 0 ) capacitor c=0.00842516f //x=8.635 //y=2.305
c1574 ( 105 0 ) capacitor c=0.0293846f //x=60.595 //y=2.4
c1575 ( 103 0 ) capacitor c=0.291962f //x=59.12 //y=2.385
c1576 ( 102 0 ) capacitor c=0.00833922f //x=59.55 //y=2.385
c1577 ( 100 0 ) capacitor c=0.075506f //x=46.165 //y=2.4
c1578 ( 99 0 ) capacitor c=0.0262566f //x=34.695 //y=2.4
c1579 ( 97 0 ) capacitor c=0.291636f //x=33.21 //y=2.38
c1580 ( 96 0 ) capacitor c=0.00839706f //x=33.64 //y=2.38
c1581 ( 94 0 ) capacitor c=0.075506f //x=20.265 //y=2.4
c1582 ( 36 0 ) capacitor c=0.00506049f //x=72.27 //y=4.765
c1583 ( 35 0 ) capacitor c=0.00933959f //x=72.27 //y=2.515
c1584 ( 34 0 ) capacitor c=0.0607928f //x=68.57 //y=4.75
c1585 ( 33 0 ) capacitor c=0.0111478f //x=68.57 //y=2.465
c1586 ( 32 0 ) capacitor c=0.0579288f //x=60.43 //y=4.75
c1587 ( 31 0 ) capacitor c=0.0113376f //x=60.43 //y=2.465
c1588 ( 28 0 ) capacitor c=0.00506049f //x=46.37 //y=4.765
c1589 ( 27 0 ) capacitor c=0.00916777f //x=46.37 //y=2.515
c1590 ( 25 0 ) capacitor c=0.00449964f //x=42.67 //y=4.75
c1591 ( 24 0 ) capacitor c=0.0111214f //x=42.67 //y=2.465
c1592 ( 23 0 ) capacitor c=0.058355f //x=34.53 //y=4.75
c1593 ( 22 0 ) capacitor c=0.0111214f //x=34.53 //y=2.465
c1594 ( 19 0 ) capacitor c=0.00506049f //x=20.47 //y=4.765
c1595 ( 18 0 ) capacitor c=0.00916777f //x=20.47 //y=2.515
c1596 ( 15 0 ) capacitor c=0.00449964f //x=16.77 //y=4.75
c1597 ( 14 0 ) capacitor c=0.0111214f //x=16.77 //y=2.465
c1598 ( 12 0 ) capacitor c=0.00452448f //x=8.63 //y=4.75
c1599 ( 10 0 ) capacitor c=0.0111214f //x=8.63 //y=2.4
c1600 ( 9 0 ) capacitor c=0.0608892f //x=72.27 //y=3.88
c1601 ( 7 0 ) capacitor c=0.0594688f //x=46.37 //y=3.51
c1602 ( 6 0 ) capacitor c=0.0561443f //x=42.67 //y=3.51
c1603 ( 4 0 ) capacitor c=0.0635402f //x=20.47 //y=3.14
c1604 ( 2 0 ) capacitor c=0.0584568f //x=16.77 //y=3.14
c1605 ( 1 0 ) capacitor c=0.0562443f //x=8.63 //y=3.14
r1606 (  498 499 ) resistor r=32.4568 //w=0.214 //l=0.075 //layer=ply \
 //thickness=0.18 //x=72.27 //y=4.97 //x2=72.27 //y2=5.045
r1607 (  496 498 ) resistor r=20.271 //w=0.214 //l=0.09 //layer=ply \
 //thickness=0.18 //x=72.27 //y=4.88 //x2=72.27 //y2=4.97
r1608 (  484 485 ) resistor r=52.7279 //w=0.214 //l=0.165 //layer=ply \
 //thickness=0.18 //x=68.57 //y=2.26 //x2=68.57 //y2=2.095
r1609 (  474 475 ) resistor r=52.7279 //w=0.214 //l=0.165 //layer=ply \
 //thickness=0.18 //x=60.43 //y=2.26 //x2=60.43 //y2=2.095
r1610 (  467 468 ) resistor r=32.4568 //w=0.214 //l=0.075 //layer=ply \
 //thickness=0.18 //x=46.37 //y=4.97 //x2=46.37 //y2=5.045
r1611 (  465 467 ) resistor r=20.271 //w=0.214 //l=0.09 //layer=ply \
 //thickness=0.18 //x=46.37 //y=4.88 //x2=46.37 //y2=4.97
r1612 (  453 454 ) resistor r=52.7279 //w=0.214 //l=0.165 //layer=ply \
 //thickness=0.18 //x=42.67 //y=2.26 //x2=42.67 //y2=2.095
r1613 (  443 444 ) resistor r=52.7279 //w=0.214 //l=0.165 //layer=ply \
 //thickness=0.18 //x=34.53 //y=2.26 //x2=34.53 //y2=2.095
r1614 (  436 437 ) resistor r=32.4568 //w=0.214 //l=0.075 //layer=ply \
 //thickness=0.18 //x=20.47 //y=4.97 //x2=20.47 //y2=5.045
r1615 (  434 436 ) resistor r=20.271 //w=0.214 //l=0.09 //layer=ply \
 //thickness=0.18 //x=20.47 //y=4.88 //x2=20.47 //y2=4.97
r1616 (  422 423 ) resistor r=52.7279 //w=0.214 //l=0.165 //layer=ply \
 //thickness=0.18 //x=16.77 //y=2.26 //x2=16.77 //y2=2.095
r1617 (  412 413 ) resistor r=52.7279 //w=0.214 //l=0.165 //layer=ply \
 //thickness=0.18 //x=8.63 //y=2.26 //x2=8.63 //y2=2.095
r1618 (  407 498 ) resistor r=16.5046 //w=0.27 //l=0.135 //layer=ply \
 //thickness=0.18 //x=72.405 //y=4.97 //x2=72.27 //y2=4.97
r1619 (  406 408 ) resistor r=26.9307 //w=0.15 //l=0.106066 //layer=ply \
 //thickness=0.18 //x=72.605 //y=4.97 //x2=72.68 //y2=5.045
r1620 (  406 407 ) resistor r=102.553 //w=0.094 //l=0.2 //layer=ply \
 //thickness=0.18 //x=72.605 //y=4.97 //x2=72.405 //y2=4.97
r1621 (  405 503 ) resistor r=38.6777 //w=0.284 //l=0.198997 //layer=ply \
 //thickness=0.18 //x=72.36 //y=2.095 //x2=72.285 //y2=2.26
r1622 (  404 501 ) resistor r=21.2976 //w=0.217 //l=0.0928709 //layer=ply \
 //thickness=0.18 //x=72.36 //y=1.63 //x2=72.32 //y2=1.555
r1623 (  404 405 ) resistor r=238.436 //w=0.094 //l=0.465 //layer=ply \
 //thickness=0.18 //x=72.36 //y=1.63 //x2=72.36 //y2=2.095
r1624 (  403 501 ) resistor r=39.0671 //w=0.217 //l=0.173853 //layer=ply \
 //thickness=0.18 //x=72.36 //y=1.4 //x2=72.32 //y2=1.555
r1625 (  402 500 ) resistor r=45.1352 //w=0.168 //l=0.173853 //layer=ply \
 //thickness=0.18 //x=72.36 //y=1.09 //x2=72.32 //y2=0.935
r1626 (  402 403 ) resistor r=158.957 //w=0.094 //l=0.31 //layer=ply \
 //thickness=0.18 //x=72.36 //y=1.09 //x2=72.36 //y2=1.4
r1627 (  397 494 ) resistor r=5.52526 //w=0.168 //l=0.115 //layer=ply \
 //thickness=0.18 //x=71.99 //y=1.555 //x2=71.875 //y2=1.555
r1628 (  396 501 ) resistor r=11.4558 //w=0.217 //l=0.115 //layer=ply \
 //thickness=0.18 //x=72.205 //y=1.555 //x2=72.32 //y2=1.555
r1629 (  395 493 ) resistor r=5.52526 //w=0.168 //l=0.115 //layer=ply \
 //thickness=0.18 //x=71.99 //y=0.935 //x2=71.875 //y2=0.935
r1630 (  394 500 ) resistor r=5.52526 //w=0.168 //l=0.115 //layer=ply \
 //thickness=0.18 //x=72.205 //y=0.935 //x2=72.32 //y2=0.935
r1631 (  394 395 ) resistor r=110.245 //w=0.094 //l=0.215 //layer=ply \
 //thickness=0.18 //x=72.205 //y=0.935 //x2=71.99 //y2=0.935
r1632 (  393 494 ) resistor r=45.1352 //w=0.168 //l=0.173853 //layer=ply \
 //thickness=0.18 //x=71.835 //y=1.4 //x2=71.875 //y2=1.555
r1633 (  392 493 ) resistor r=45.1352 //w=0.168 //l=0.173853 //layer=ply \
 //thickness=0.18 //x=71.835 //y=1.09 //x2=71.875 //y2=0.935
r1634 (  392 393 ) resistor r=158.957 //w=0.094 //l=0.31 //layer=ply \
 //thickness=0.18 //x=71.835 //y=1.09 //x2=71.835 //y2=1.4
r1635 (  391 492 ) resistor r=45.1352 //w=0.168 //l=0.173853 //layer=ply \
 //thickness=0.18 //x=69.09 //y=1.44 //x2=69.05 //y2=1.595
r1636 (  390 491 ) resistor r=45.1352 //w=0.168 //l=0.173853 //layer=ply \
 //thickness=0.18 //x=69.09 //y=1.095 //x2=69.05 //y2=0.94
r1637 (  390 391 ) resistor r=176.904 //w=0.094 //l=0.345 //layer=ply \
 //thickness=0.18 //x=69.09 //y=1.095 //x2=69.09 //y2=1.44
r1638 (  388 488 ) resistor r=10.701 //w=0.21 //l=0.115 //layer=ply \
 //thickness=0.18 //x=68.715 //y=1.595 //x2=68.6 //y2=1.595
r1639 (  387 492 ) resistor r=5.52526 //w=0.168 //l=0.115 //layer=ply \
 //thickness=0.18 //x=68.935 //y=1.595 //x2=69.05 //y2=1.595
r1640 (  386 487 ) resistor r=5.52526 //w=0.168 //l=0.115 //layer=ply \
 //thickness=0.18 //x=68.715 //y=0.94 //x2=68.6 //y2=0.94
r1641 (  385 491 ) resistor r=5.52526 //w=0.168 //l=0.115 //layer=ply \
 //thickness=0.18 //x=68.935 //y=0.94 //x2=69.05 //y2=0.94
r1642 (  385 386 ) resistor r=112.809 //w=0.094 //l=0.22 //layer=ply \
 //thickness=0.18 //x=68.935 //y=0.94 //x2=68.715 //y2=0.94
r1643 (  382 490 ) resistor r=37.236 //w=0.233 //l=0.249199 //layer=ply \
 //thickness=0.18 //x=68.75 //y=5.045 //x2=68.57 //y2=4.88
r1644 (  380 488 ) resistor r=39.5823 //w=0.21 //l=0.173853 //layer=ply \
 //thickness=0.18 //x=68.56 //y=1.75 //x2=68.6 //y2=1.595
r1645 (  380 485 ) resistor r=176.904 //w=0.094 //l=0.345 //layer=ply \
 //thickness=0.18 //x=68.56 //y=1.75 //x2=68.56 //y2=2.095
r1646 (  379 488 ) resistor r=39.5823 //w=0.21 //l=0.173853 //layer=ply \
 //thickness=0.18 //x=68.56 //y=1.44 //x2=68.6 //y2=1.595
r1647 (  378 487 ) resistor r=45.1352 //w=0.168 //l=0.173853 //layer=ply \
 //thickness=0.18 //x=68.56 //y=1.095 //x2=68.6 //y2=0.94
r1648 (  378 379 ) resistor r=176.904 //w=0.094 //l=0.345 //layer=ply \
 //thickness=0.18 //x=68.56 //y=1.095 //x2=68.56 //y2=1.44
r1649 (  375 490 ) resistor r=53.7854 //w=0.233 //l=0.332415 //layer=ply \
 //thickness=0.18 //x=68.31 //y=5.045 //x2=68.57 //y2=4.88
r1650 (  374 482 ) resistor r=45.1352 //w=0.168 //l=0.173853 //layer=ply \
 //thickness=0.18 //x=60.95 //y=1.44 //x2=60.91 //y2=1.595
r1651 (  373 481 ) resistor r=45.1352 //w=0.168 //l=0.173853 //layer=ply \
 //thickness=0.18 //x=60.95 //y=1.095 //x2=60.91 //y2=0.94
r1652 (  373 374 ) resistor r=176.904 //w=0.094 //l=0.345 //layer=ply \
 //thickness=0.18 //x=60.95 //y=1.095 //x2=60.95 //y2=1.44
r1653 (  371 478 ) resistor r=10.701 //w=0.21 //l=0.115 //layer=ply \
 //thickness=0.18 //x=60.575 //y=1.595 //x2=60.46 //y2=1.595
r1654 (  370 482 ) resistor r=5.52526 //w=0.168 //l=0.115 //layer=ply \
 //thickness=0.18 //x=60.795 //y=1.595 //x2=60.91 //y2=1.595
r1655 (  369 477 ) resistor r=5.52526 //w=0.168 //l=0.115 //layer=ply \
 //thickness=0.18 //x=60.575 //y=0.94 //x2=60.46 //y2=0.94
r1656 (  368 481 ) resistor r=5.52526 //w=0.168 //l=0.115 //layer=ply \
 //thickness=0.18 //x=60.795 //y=0.94 //x2=60.91 //y2=0.94
r1657 (  368 369 ) resistor r=112.809 //w=0.094 //l=0.22 //layer=ply \
 //thickness=0.18 //x=60.795 //y=0.94 //x2=60.575 //y2=0.94
r1658 (  365 480 ) resistor r=37.236 //w=0.233 //l=0.249199 //layer=ply \
 //thickness=0.18 //x=60.61 //y=5.045 //x2=60.43 //y2=4.88
r1659 (  363 478 ) resistor r=39.5823 //w=0.21 //l=0.173853 //layer=ply \
 //thickness=0.18 //x=60.42 //y=1.75 //x2=60.46 //y2=1.595
r1660 (  363 475 ) resistor r=176.904 //w=0.094 //l=0.345 //layer=ply \
 //thickness=0.18 //x=60.42 //y=1.75 //x2=60.42 //y2=2.095
r1661 (  362 478 ) resistor r=39.5823 //w=0.21 //l=0.173853 //layer=ply \
 //thickness=0.18 //x=60.42 //y=1.44 //x2=60.46 //y2=1.595
r1662 (  361 477 ) resistor r=45.1352 //w=0.168 //l=0.173853 //layer=ply \
 //thickness=0.18 //x=60.42 //y=1.095 //x2=60.46 //y2=0.94
r1663 (  361 362 ) resistor r=176.904 //w=0.094 //l=0.345 //layer=ply \
 //thickness=0.18 //x=60.42 //y=1.095 //x2=60.42 //y2=1.44
r1664 (  358 480 ) resistor r=53.7854 //w=0.233 //l=0.332415 //layer=ply \
 //thickness=0.18 //x=60.17 //y=5.045 //x2=60.43 //y2=4.88
r1665 (  354 467 ) resistor r=16.5046 //w=0.27 //l=0.135 //layer=ply \
 //thickness=0.18 //x=46.505 //y=4.97 //x2=46.37 //y2=4.97
r1666 (  353 355 ) resistor r=26.9307 //w=0.15 //l=0.106066 //layer=ply \
 //thickness=0.18 //x=46.705 //y=4.97 //x2=46.78 //y2=5.045
r1667 (  353 354 ) resistor r=102.553 //w=0.094 //l=0.2 //layer=ply \
 //thickness=0.18 //x=46.705 //y=4.97 //x2=46.505 //y2=4.97
r1668 (  352 472 ) resistor r=38.6777 //w=0.284 //l=0.198997 //layer=ply \
 //thickness=0.18 //x=46.46 //y=2.095 //x2=46.385 //y2=2.26
r1669 (  351 470 ) resistor r=21.2976 //w=0.217 //l=0.0928709 //layer=ply \
 //thickness=0.18 //x=46.46 //y=1.63 //x2=46.42 //y2=1.555
r1670 (  351 352 ) resistor r=238.436 //w=0.094 //l=0.465 //layer=ply \
 //thickness=0.18 //x=46.46 //y=1.63 //x2=46.46 //y2=2.095
r1671 (  350 470 ) resistor r=39.0671 //w=0.217 //l=0.173853 //layer=ply \
 //thickness=0.18 //x=46.46 //y=1.4 //x2=46.42 //y2=1.555
r1672 (  349 469 ) resistor r=45.1352 //w=0.168 //l=0.173853 //layer=ply \
 //thickness=0.18 //x=46.46 //y=1.09 //x2=46.42 //y2=0.935
r1673 (  349 350 ) resistor r=158.957 //w=0.094 //l=0.31 //layer=ply \
 //thickness=0.18 //x=46.46 //y=1.09 //x2=46.46 //y2=1.4
r1674 (  344 463 ) resistor r=5.52526 //w=0.168 //l=0.115 //layer=ply \
 //thickness=0.18 //x=46.09 //y=1.555 //x2=45.975 //y2=1.555
r1675 (  343 470 ) resistor r=11.4558 //w=0.217 //l=0.115 //layer=ply \
 //thickness=0.18 //x=46.305 //y=1.555 //x2=46.42 //y2=1.555
r1676 (  342 462 ) resistor r=5.52526 //w=0.168 //l=0.115 //layer=ply \
 //thickness=0.18 //x=46.09 //y=0.935 //x2=45.975 //y2=0.935
r1677 (  341 469 ) resistor r=5.52526 //w=0.168 //l=0.115 //layer=ply \
 //thickness=0.18 //x=46.305 //y=0.935 //x2=46.42 //y2=0.935
r1678 (  341 342 ) resistor r=110.245 //w=0.094 //l=0.215 //layer=ply \
 //thickness=0.18 //x=46.305 //y=0.935 //x2=46.09 //y2=0.935
r1679 (  340 463 ) resistor r=45.1352 //w=0.168 //l=0.173853 //layer=ply \
 //thickness=0.18 //x=45.935 //y=1.4 //x2=45.975 //y2=1.555
r1680 (  339 462 ) resistor r=45.1352 //w=0.168 //l=0.173853 //layer=ply \
 //thickness=0.18 //x=45.935 //y=1.09 //x2=45.975 //y2=0.935
r1681 (  339 340 ) resistor r=158.957 //w=0.094 //l=0.31 //layer=ply \
 //thickness=0.18 //x=45.935 //y=1.09 //x2=45.935 //y2=1.4
r1682 (  338 461 ) resistor r=45.1352 //w=0.168 //l=0.173853 //layer=ply \
 //thickness=0.18 //x=43.19 //y=1.44 //x2=43.15 //y2=1.595
r1683 (  337 460 ) resistor r=45.1352 //w=0.168 //l=0.173853 //layer=ply \
 //thickness=0.18 //x=43.19 //y=1.095 //x2=43.15 //y2=0.94
r1684 (  337 338 ) resistor r=176.904 //w=0.094 //l=0.345 //layer=ply \
 //thickness=0.18 //x=43.19 //y=1.095 //x2=43.19 //y2=1.44
r1685 (  335 457 ) resistor r=10.701 //w=0.21 //l=0.115 //layer=ply \
 //thickness=0.18 //x=42.815 //y=1.595 //x2=42.7 //y2=1.595
r1686 (  334 461 ) resistor r=5.52526 //w=0.168 //l=0.115 //layer=ply \
 //thickness=0.18 //x=43.035 //y=1.595 //x2=43.15 //y2=1.595
r1687 (  333 456 ) resistor r=5.52526 //w=0.168 //l=0.115 //layer=ply \
 //thickness=0.18 //x=42.815 //y=0.94 //x2=42.7 //y2=0.94
r1688 (  332 460 ) resistor r=5.52526 //w=0.168 //l=0.115 //layer=ply \
 //thickness=0.18 //x=43.035 //y=0.94 //x2=43.15 //y2=0.94
r1689 (  332 333 ) resistor r=112.809 //w=0.094 //l=0.22 //layer=ply \
 //thickness=0.18 //x=43.035 //y=0.94 //x2=42.815 //y2=0.94
r1690 (  329 459 ) resistor r=37.236 //w=0.233 //l=0.249199 //layer=ply \
 //thickness=0.18 //x=42.85 //y=5.045 //x2=42.67 //y2=4.88
r1691 (  327 457 ) resistor r=39.5823 //w=0.21 //l=0.173853 //layer=ply \
 //thickness=0.18 //x=42.66 //y=1.75 //x2=42.7 //y2=1.595
r1692 (  327 454 ) resistor r=176.904 //w=0.094 //l=0.345 //layer=ply \
 //thickness=0.18 //x=42.66 //y=1.75 //x2=42.66 //y2=2.095
r1693 (  326 457 ) resistor r=39.5823 //w=0.21 //l=0.173853 //layer=ply \
 //thickness=0.18 //x=42.66 //y=1.44 //x2=42.7 //y2=1.595
r1694 (  325 456 ) resistor r=45.1352 //w=0.168 //l=0.173853 //layer=ply \
 //thickness=0.18 //x=42.66 //y=1.095 //x2=42.7 //y2=0.94
r1695 (  325 326 ) resistor r=176.904 //w=0.094 //l=0.345 //layer=ply \
 //thickness=0.18 //x=42.66 //y=1.095 //x2=42.66 //y2=1.44
r1696 (  322 459 ) resistor r=53.7854 //w=0.233 //l=0.332415 //layer=ply \
 //thickness=0.18 //x=42.41 //y=5.045 //x2=42.67 //y2=4.88
r1697 (  321 451 ) resistor r=45.1352 //w=0.168 //l=0.173853 //layer=ply \
 //thickness=0.18 //x=35.05 //y=1.44 //x2=35.01 //y2=1.595
r1698 (  320 450 ) resistor r=45.1352 //w=0.168 //l=0.173853 //layer=ply \
 //thickness=0.18 //x=35.05 //y=1.095 //x2=35.01 //y2=0.94
r1699 (  320 321 ) resistor r=176.904 //w=0.094 //l=0.345 //layer=ply \
 //thickness=0.18 //x=35.05 //y=1.095 //x2=35.05 //y2=1.44
r1700 (  318 447 ) resistor r=10.701 //w=0.21 //l=0.115 //layer=ply \
 //thickness=0.18 //x=34.675 //y=1.595 //x2=34.56 //y2=1.595
r1701 (  317 451 ) resistor r=5.52526 //w=0.168 //l=0.115 //layer=ply \
 //thickness=0.18 //x=34.895 //y=1.595 //x2=35.01 //y2=1.595
r1702 (  316 446 ) resistor r=5.52526 //w=0.168 //l=0.115 //layer=ply \
 //thickness=0.18 //x=34.675 //y=0.94 //x2=34.56 //y2=0.94
r1703 (  315 450 ) resistor r=5.52526 //w=0.168 //l=0.115 //layer=ply \
 //thickness=0.18 //x=34.895 //y=0.94 //x2=35.01 //y2=0.94
r1704 (  315 316 ) resistor r=112.809 //w=0.094 //l=0.22 //layer=ply \
 //thickness=0.18 //x=34.895 //y=0.94 //x2=34.675 //y2=0.94
r1705 (  312 449 ) resistor r=37.236 //w=0.233 //l=0.249199 //layer=ply \
 //thickness=0.18 //x=34.71 //y=5.045 //x2=34.53 //y2=4.88
r1706 (  310 447 ) resistor r=39.5823 //w=0.21 //l=0.173853 //layer=ply \
 //thickness=0.18 //x=34.52 //y=1.75 //x2=34.56 //y2=1.595
r1707 (  310 444 ) resistor r=176.904 //w=0.094 //l=0.345 //layer=ply \
 //thickness=0.18 //x=34.52 //y=1.75 //x2=34.52 //y2=2.095
r1708 (  309 447 ) resistor r=39.5823 //w=0.21 //l=0.173853 //layer=ply \
 //thickness=0.18 //x=34.52 //y=1.44 //x2=34.56 //y2=1.595
r1709 (  308 446 ) resistor r=45.1352 //w=0.168 //l=0.173853 //layer=ply \
 //thickness=0.18 //x=34.52 //y=1.095 //x2=34.56 //y2=0.94
r1710 (  308 309 ) resistor r=176.904 //w=0.094 //l=0.345 //layer=ply \
 //thickness=0.18 //x=34.52 //y=1.095 //x2=34.52 //y2=1.44
r1711 (  305 449 ) resistor r=53.7854 //w=0.233 //l=0.332415 //layer=ply \
 //thickness=0.18 //x=34.27 //y=5.045 //x2=34.53 //y2=4.88
r1712 (  301 436 ) resistor r=16.5046 //w=0.27 //l=0.135 //layer=ply \
 //thickness=0.18 //x=20.605 //y=4.97 //x2=20.47 //y2=4.97
r1713 (  300 302 ) resistor r=26.9307 //w=0.15 //l=0.106066 //layer=ply \
 //thickness=0.18 //x=20.805 //y=4.97 //x2=20.88 //y2=5.045
r1714 (  300 301 ) resistor r=102.553 //w=0.094 //l=0.2 //layer=ply \
 //thickness=0.18 //x=20.805 //y=4.97 //x2=20.605 //y2=4.97
r1715 (  299 441 ) resistor r=38.6777 //w=0.284 //l=0.198997 //layer=ply \
 //thickness=0.18 //x=20.56 //y=2.095 //x2=20.485 //y2=2.26
r1716 (  298 439 ) resistor r=21.2976 //w=0.217 //l=0.0928709 //layer=ply \
 //thickness=0.18 //x=20.56 //y=1.63 //x2=20.52 //y2=1.555
r1717 (  298 299 ) resistor r=238.436 //w=0.094 //l=0.465 //layer=ply \
 //thickness=0.18 //x=20.56 //y=1.63 //x2=20.56 //y2=2.095
r1718 (  297 439 ) resistor r=39.0671 //w=0.217 //l=0.173853 //layer=ply \
 //thickness=0.18 //x=20.56 //y=1.4 //x2=20.52 //y2=1.555
r1719 (  296 438 ) resistor r=45.1352 //w=0.168 //l=0.173853 //layer=ply \
 //thickness=0.18 //x=20.56 //y=1.09 //x2=20.52 //y2=0.935
r1720 (  296 297 ) resistor r=158.957 //w=0.094 //l=0.31 //layer=ply \
 //thickness=0.18 //x=20.56 //y=1.09 //x2=20.56 //y2=1.4
r1721 (  291 432 ) resistor r=5.52526 //w=0.168 //l=0.115 //layer=ply \
 //thickness=0.18 //x=20.19 //y=1.555 //x2=20.075 //y2=1.555
r1722 (  290 439 ) resistor r=11.4558 //w=0.217 //l=0.115 //layer=ply \
 //thickness=0.18 //x=20.405 //y=1.555 //x2=20.52 //y2=1.555
r1723 (  289 431 ) resistor r=5.52526 //w=0.168 //l=0.115 //layer=ply \
 //thickness=0.18 //x=20.19 //y=0.935 //x2=20.075 //y2=0.935
r1724 (  288 438 ) resistor r=5.52526 //w=0.168 //l=0.115 //layer=ply \
 //thickness=0.18 //x=20.405 //y=0.935 //x2=20.52 //y2=0.935
r1725 (  288 289 ) resistor r=110.245 //w=0.094 //l=0.215 //layer=ply \
 //thickness=0.18 //x=20.405 //y=0.935 //x2=20.19 //y2=0.935
r1726 (  287 432 ) resistor r=45.1352 //w=0.168 //l=0.173853 //layer=ply \
 //thickness=0.18 //x=20.035 //y=1.4 //x2=20.075 //y2=1.555
r1727 (  286 431 ) resistor r=45.1352 //w=0.168 //l=0.173853 //layer=ply \
 //thickness=0.18 //x=20.035 //y=1.09 //x2=20.075 //y2=0.935
r1728 (  286 287 ) resistor r=158.957 //w=0.094 //l=0.31 //layer=ply \
 //thickness=0.18 //x=20.035 //y=1.09 //x2=20.035 //y2=1.4
r1729 (  285 430 ) resistor r=45.1352 //w=0.168 //l=0.173853 //layer=ply \
 //thickness=0.18 //x=17.29 //y=1.44 //x2=17.25 //y2=1.595
r1730 (  284 429 ) resistor r=45.1352 //w=0.168 //l=0.173853 //layer=ply \
 //thickness=0.18 //x=17.29 //y=1.095 //x2=17.25 //y2=0.94
r1731 (  284 285 ) resistor r=176.904 //w=0.094 //l=0.345 //layer=ply \
 //thickness=0.18 //x=17.29 //y=1.095 //x2=17.29 //y2=1.44
r1732 (  282 426 ) resistor r=10.701 //w=0.21 //l=0.115 //layer=ply \
 //thickness=0.18 //x=16.915 //y=1.595 //x2=16.8 //y2=1.595
r1733 (  281 430 ) resistor r=5.52526 //w=0.168 //l=0.115 //layer=ply \
 //thickness=0.18 //x=17.135 //y=1.595 //x2=17.25 //y2=1.595
r1734 (  280 425 ) resistor r=5.52526 //w=0.168 //l=0.115 //layer=ply \
 //thickness=0.18 //x=16.915 //y=0.94 //x2=16.8 //y2=0.94
r1735 (  279 429 ) resistor r=5.52526 //w=0.168 //l=0.115 //layer=ply \
 //thickness=0.18 //x=17.135 //y=0.94 //x2=17.25 //y2=0.94
r1736 (  279 280 ) resistor r=112.809 //w=0.094 //l=0.22 //layer=ply \
 //thickness=0.18 //x=17.135 //y=0.94 //x2=16.915 //y2=0.94
r1737 (  276 428 ) resistor r=37.236 //w=0.233 //l=0.249199 //layer=ply \
 //thickness=0.18 //x=16.95 //y=5.045 //x2=16.77 //y2=4.88
r1738 (  274 426 ) resistor r=39.5823 //w=0.21 //l=0.173853 //layer=ply \
 //thickness=0.18 //x=16.76 //y=1.75 //x2=16.8 //y2=1.595
r1739 (  274 423 ) resistor r=176.904 //w=0.094 //l=0.345 //layer=ply \
 //thickness=0.18 //x=16.76 //y=1.75 //x2=16.76 //y2=2.095
r1740 (  273 426 ) resistor r=39.5823 //w=0.21 //l=0.173853 //layer=ply \
 //thickness=0.18 //x=16.76 //y=1.44 //x2=16.8 //y2=1.595
r1741 (  272 425 ) resistor r=45.1352 //w=0.168 //l=0.173853 //layer=ply \
 //thickness=0.18 //x=16.76 //y=1.095 //x2=16.8 //y2=0.94
r1742 (  272 273 ) resistor r=176.904 //w=0.094 //l=0.345 //layer=ply \
 //thickness=0.18 //x=16.76 //y=1.095 //x2=16.76 //y2=1.44
r1743 (  269 428 ) resistor r=53.7854 //w=0.233 //l=0.332415 //layer=ply \
 //thickness=0.18 //x=16.51 //y=5.045 //x2=16.77 //y2=4.88
r1744 (  268 420 ) resistor r=45.1352 //w=0.168 //l=0.173853 //layer=ply \
 //thickness=0.18 //x=9.15 //y=1.44 //x2=9.11 //y2=1.595
r1745 (  267 419 ) resistor r=45.1352 //w=0.168 //l=0.173853 //layer=ply \
 //thickness=0.18 //x=9.15 //y=1.095 //x2=9.11 //y2=0.94
r1746 (  267 268 ) resistor r=176.904 //w=0.094 //l=0.345 //layer=ply \
 //thickness=0.18 //x=9.15 //y=1.095 //x2=9.15 //y2=1.44
r1747 (  265 416 ) resistor r=10.701 //w=0.21 //l=0.115 //layer=ply \
 //thickness=0.18 //x=8.775 //y=1.595 //x2=8.66 //y2=1.595
r1748 (  264 420 ) resistor r=5.52526 //w=0.168 //l=0.115 //layer=ply \
 //thickness=0.18 //x=8.995 //y=1.595 //x2=9.11 //y2=1.595
r1749 (  263 415 ) resistor r=5.52526 //w=0.168 //l=0.115 //layer=ply \
 //thickness=0.18 //x=8.775 //y=0.94 //x2=8.66 //y2=0.94
r1750 (  262 419 ) resistor r=5.52526 //w=0.168 //l=0.115 //layer=ply \
 //thickness=0.18 //x=8.995 //y=0.94 //x2=9.11 //y2=0.94
r1751 (  262 263 ) resistor r=112.809 //w=0.094 //l=0.22 //layer=ply \
 //thickness=0.18 //x=8.995 //y=0.94 //x2=8.775 //y2=0.94
r1752 (  259 418 ) resistor r=37.236 //w=0.233 //l=0.249199 //layer=ply \
 //thickness=0.18 //x=8.81 //y=5.045 //x2=8.63 //y2=4.88
r1753 (  257 416 ) resistor r=39.5823 //w=0.21 //l=0.173853 //layer=ply \
 //thickness=0.18 //x=8.62 //y=1.75 //x2=8.66 //y2=1.595
r1754 (  257 413 ) resistor r=176.904 //w=0.094 //l=0.345 //layer=ply \
 //thickness=0.18 //x=8.62 //y=1.75 //x2=8.62 //y2=2.095
r1755 (  256 416 ) resistor r=39.5823 //w=0.21 //l=0.173853 //layer=ply \
 //thickness=0.18 //x=8.62 //y=1.44 //x2=8.66 //y2=1.595
r1756 (  255 415 ) resistor r=45.1352 //w=0.168 //l=0.173853 //layer=ply \
 //thickness=0.18 //x=8.62 //y=1.095 //x2=8.66 //y2=0.94
r1757 (  255 256 ) resistor r=176.904 //w=0.094 //l=0.345 //layer=ply \
 //thickness=0.18 //x=8.62 //y=1.095 //x2=8.62 //y2=1.44
r1758 (  252 418 ) resistor r=53.7854 //w=0.233 //l=0.332415 //layer=ply \
 //thickness=0.18 //x=8.37 //y=5.045 //x2=8.63 //y2=4.88
r1759 (  251 408 ) resistor r=592.245 //w=0.094 //l=1.155 //layer=ply \
 //thickness=0.18 //x=72.68 //y=6.2 //x2=72.68 //y2=5.045
r1760 (  250 499 ) resistor r=592.245 //w=0.094 //l=1.155 //layer=ply \
 //thickness=0.18 //x=72.24 //y=6.2 //x2=72.24 //y2=5.045
r1761 (  249 382 ) resistor r=592.245 //w=0.094 //l=1.155 //layer=ply \
 //thickness=0.18 //x=68.75 //y=6.2 //x2=68.75 //y2=5.045
r1762 (  248 375 ) resistor r=592.245 //w=0.094 //l=1.155 //layer=ply \
 //thickness=0.18 //x=68.31 //y=6.2 //x2=68.31 //y2=5.045
r1763 (  247 365 ) resistor r=592.245 //w=0.094 //l=1.155 //layer=ply \
 //thickness=0.18 //x=60.61 //y=6.2 //x2=60.61 //y2=5.045
r1764 (  246 358 ) resistor r=592.245 //w=0.094 //l=1.155 //layer=ply \
 //thickness=0.18 //x=60.17 //y=6.2 //x2=60.17 //y2=5.045
r1765 (  245 355 ) resistor r=592.245 //w=0.094 //l=1.155 //layer=ply \
 //thickness=0.18 //x=46.78 //y=6.2 //x2=46.78 //y2=5.045
r1766 (  244 468 ) resistor r=592.245 //w=0.094 //l=1.155 //layer=ply \
 //thickness=0.18 //x=46.34 //y=6.2 //x2=46.34 //y2=5.045
r1767 (  243 329 ) resistor r=592.245 //w=0.094 //l=1.155 //layer=ply \
 //thickness=0.18 //x=42.85 //y=6.2 //x2=42.85 //y2=5.045
r1768 (  242 322 ) resistor r=592.245 //w=0.094 //l=1.155 //layer=ply \
 //thickness=0.18 //x=42.41 //y=6.2 //x2=42.41 //y2=5.045
r1769 (  241 312 ) resistor r=592.245 //w=0.094 //l=1.155 //layer=ply \
 //thickness=0.18 //x=34.71 //y=6.2 //x2=34.71 //y2=5.045
r1770 (  240 305 ) resistor r=592.245 //w=0.094 //l=1.155 //layer=ply \
 //thickness=0.18 //x=34.27 //y=6.2 //x2=34.27 //y2=5.045
r1771 (  239 302 ) resistor r=592.245 //w=0.094 //l=1.155 //layer=ply \
 //thickness=0.18 //x=20.88 //y=6.2 //x2=20.88 //y2=5.045
r1772 (  238 437 ) resistor r=592.245 //w=0.094 //l=1.155 //layer=ply \
 //thickness=0.18 //x=20.44 //y=6.2 //x2=20.44 //y2=5.045
r1773 (  237 276 ) resistor r=592.245 //w=0.094 //l=1.155 //layer=ply \
 //thickness=0.18 //x=16.95 //y=6.2 //x2=16.95 //y2=5.045
r1774 (  236 269 ) resistor r=592.245 //w=0.094 //l=1.155 //layer=ply \
 //thickness=0.18 //x=16.51 //y=6.2 //x2=16.51 //y2=5.045
r1775 (  235 259 ) resistor r=592.245 //w=0.094 //l=1.155 //layer=ply \
 //thickness=0.18 //x=8.81 //y=6.2 //x2=8.81 //y2=5.045
r1776 (  234 252 ) resistor r=592.245 //w=0.094 //l=1.155 //layer=ply \
 //thickness=0.18 //x=8.37 //y=6.2 //x2=8.37 //y2=5.045
r1777 (  233 396 ) resistor r=55.3787 //w=0.094 //l=0.108 //layer=ply \
 //thickness=0.18 //x=72.097 //y=1.555 //x2=72.205 //y2=1.555
r1778 (  233 397 ) resistor r=54.866 //w=0.094 //l=0.107 //layer=ply \
 //thickness=0.18 //x=72.097 //y=1.555 //x2=71.99 //y2=1.555
r1779 (  232 387 ) resistor r=56.4043 //w=0.094 //l=0.11 //layer=ply \
 //thickness=0.18 //x=68.825 //y=1.595 //x2=68.935 //y2=1.595
r1780 (  232 388 ) resistor r=56.4043 //w=0.094 //l=0.11 //layer=ply \
 //thickness=0.18 //x=68.825 //y=1.595 //x2=68.715 //y2=1.595
r1781 (  231 370 ) resistor r=56.4043 //w=0.094 //l=0.11 //layer=ply \
 //thickness=0.18 //x=60.685 //y=1.595 //x2=60.795 //y2=1.595
r1782 (  231 371 ) resistor r=56.4043 //w=0.094 //l=0.11 //layer=ply \
 //thickness=0.18 //x=60.685 //y=1.595 //x2=60.575 //y2=1.595
r1783 (  230 343 ) resistor r=55.3787 //w=0.094 //l=0.108 //layer=ply \
 //thickness=0.18 //x=46.197 //y=1.555 //x2=46.305 //y2=1.555
r1784 (  230 344 ) resistor r=54.866 //w=0.094 //l=0.107 //layer=ply \
 //thickness=0.18 //x=46.197 //y=1.555 //x2=46.09 //y2=1.555
r1785 (  229 334 ) resistor r=56.4043 //w=0.094 //l=0.11 //layer=ply \
 //thickness=0.18 //x=42.925 //y=1.595 //x2=43.035 //y2=1.595
r1786 (  229 335 ) resistor r=56.4043 //w=0.094 //l=0.11 //layer=ply \
 //thickness=0.18 //x=42.925 //y=1.595 //x2=42.815 //y2=1.595
r1787 (  228 317 ) resistor r=56.4043 //w=0.094 //l=0.11 //layer=ply \
 //thickness=0.18 //x=34.785 //y=1.595 //x2=34.895 //y2=1.595
r1788 (  228 318 ) resistor r=56.4043 //w=0.094 //l=0.11 //layer=ply \
 //thickness=0.18 //x=34.785 //y=1.595 //x2=34.675 //y2=1.595
r1789 (  227 290 ) resistor r=55.3787 //w=0.094 //l=0.108 //layer=ply \
 //thickness=0.18 //x=20.297 //y=1.555 //x2=20.405 //y2=1.555
r1790 (  227 291 ) resistor r=54.866 //w=0.094 //l=0.107 //layer=ply \
 //thickness=0.18 //x=20.297 //y=1.555 //x2=20.19 //y2=1.555
r1791 (  226 281 ) resistor r=56.4043 //w=0.094 //l=0.11 //layer=ply \
 //thickness=0.18 //x=17.025 //y=1.595 //x2=17.135 //y2=1.595
r1792 (  226 282 ) resistor r=56.4043 //w=0.094 //l=0.11 //layer=ply \
 //thickness=0.18 //x=17.025 //y=1.595 //x2=16.915 //y2=1.595
r1793 (  225 264 ) resistor r=56.4043 //w=0.094 //l=0.11 //layer=ply \
 //thickness=0.18 //x=8.885 //y=1.595 //x2=8.995 //y2=1.595
r1794 (  225 265 ) resistor r=56.4043 //w=0.094 //l=0.11 //layer=ply \
 //thickness=0.18 //x=8.885 //y=1.595 //x2=8.775 //y2=1.595
r1795 (  221 496 ) resistor r=152 //w=0.17 //l=0.17 //layer=licon //count=1 \
 //x=72.27 //y=4.88 //x2=72.27 //y2=4.88
r1796 (  216 503 ) resistor r=152 //w=0.17 //l=0.17 //layer=licon //count=1 \
 //x=72.27 //y=2.26 //x2=72.27 //y2=2.26
r1797 (  211 490 ) resistor r=152 //w=0.17 //l=0.17 //layer=licon //count=1 \
 //x=68.57 //y=4.88 //x2=68.57 //y2=4.88
r1798 (  206 484 ) resistor r=152 //w=0.17 //l=0.17 //layer=licon //count=1 \
 //x=68.57 //y=2.26 //x2=68.57 //y2=2.26
r1799 (  201 480 ) resistor r=152 //w=0.17 //l=0.17 //layer=licon //count=1 \
 //x=60.43 //y=4.88 //x2=60.43 //y2=4.88
r1800 (  196 474 ) resistor r=152 //w=0.17 //l=0.17 //layer=licon //count=1 \
 //x=60.43 //y=2.26 //x2=60.43 //y2=2.26
r1801 (  191 465 ) resistor r=152 //w=0.17 //l=0.17 //layer=licon //count=1 \
 //x=46.37 //y=4.88 //x2=46.37 //y2=4.88
r1802 (  186 472 ) resistor r=152 //w=0.17 //l=0.17 //layer=licon //count=1 \
 //x=46.37 //y=2.26 //x2=46.37 //y2=2.26
r1803 (  181 459 ) resistor r=152 //w=0.17 //l=0.17 //layer=licon //count=1 \
 //x=42.67 //y=4.88 //x2=42.67 //y2=4.88
r1804 (  176 453 ) resistor r=152 //w=0.17 //l=0.17 //layer=licon //count=1 \
 //x=42.67 //y=2.26 //x2=42.67 //y2=2.26
r1805 (  171 449 ) resistor r=152 //w=0.17 //l=0.17 //layer=licon //count=1 \
 //x=34.53 //y=4.88 //x2=34.53 //y2=4.88
r1806 (  166 443 ) resistor r=152 //w=0.17 //l=0.17 //layer=licon //count=1 \
 //x=34.53 //y=2.26 //x2=34.53 //y2=2.26
r1807 (  161 434 ) resistor r=152 //w=0.17 //l=0.17 //layer=licon //count=1 \
 //x=20.47 //y=4.88 //x2=20.47 //y2=4.88
r1808 (  156 441 ) resistor r=152 //w=0.17 //l=0.17 //layer=licon //count=1 \
 //x=20.47 //y=2.26 //x2=20.47 //y2=2.26
r1809 (  151 428 ) resistor r=152 //w=0.17 //l=0.17 //layer=licon //count=1 \
 //x=16.77 //y=4.88 //x2=16.77 //y2=4.88
r1810 (  146 422 ) resistor r=152 //w=0.17 //l=0.17 //layer=licon //count=1 \
 //x=16.77 //y=2.26 //x2=16.77 //y2=2.26
r1811 (  141 418 ) resistor r=152 //w=0.17 //l=0.17 //layer=licon //count=1 \
 //x=8.63 //y=4.88 //x2=8.63 //y2=4.88
r1812 (  136 412 ) resistor r=152 //w=0.17 //l=0.17 //layer=licon //count=1 \
 //x=8.63 //y=2.26 //x2=8.63 //y2=2.26
r1813 (  132 133 ) resistor r=0.10734 //w=0.281 //l=0.16 //layer=m2 \
 //thickness=0.36 //x=72.225 //y=2.355 //x2=72.065 //y2=2.355
r1814 (  130 133 ) resistor r=3.17748 //w=0.131 //l=3.33 //layer=m2 \
 //thickness=0.36 //x=68.735 //y=2.4 //x2=72.065 //y2=2.4
r1815 (  128 130 ) resistor r=0.107331 //w=0.301 //l=0.16 //layer=m2 \
 //thickness=0.36 //x=68.575 //y=2.315 //x2=68.735 //y2=2.315
r1816 (  128 129 ) resistor r=0.107331 //w=0.301 //l=0.16 //layer=m2 \
 //thickness=0.36 //x=68.575 //y=2.315 //x2=68.415 //y2=2.315
r1817 (  120 122 ) resistor r=0.107331 //w=0.301 //l=0.16 //layer=m2 \
 //thickness=0.36 //x=42.675 //y=2.315 //x2=42.835 //y2=2.315
r1818 (  120 121 ) resistor r=0.107331 //w=0.301 //l=0.16 //layer=m2 \
 //thickness=0.36 //x=42.675 //y=2.315 //x2=42.515 //y2=2.315
r1819 (  112 114 ) resistor r=0.107331 //w=0.301 //l=0.16 //layer=m2 \
 //thickness=0.36 //x=16.775 //y=2.315 //x2=16.935 //y2=2.315
r1820 (  112 113 ) resistor r=0.107331 //w=0.301 //l=0.16 //layer=m2 \
 //thickness=0.36 //x=16.775 //y=2.315 //x2=16.615 //y2=2.315
r1821 (  109 110 ) resistor r=0.0373428 //w=0.318 //l=0.095 //layer=m2 \
 //thickness=0.36 //x=8.635 //y=2.305 //x2=8.635 //y2=2.4
r1822 (  105 126 ) resistor r=0.0970535 //w=0.223 //l=0.19799 //layer=m2 \
 //thickness=0.36 //x=60.595 //y=2.4 //x2=60.435 //y2=2.315
r1823 (  105 129 ) resistor r=7.46183 //w=0.131 //l=7.82 //layer=m2 \
 //thickness=0.36 //x=60.595 //y=2.4 //x2=68.415 //y2=2.4
r1824 (  103 124 ) resistor r=9.19181 //w=0.174 //l=12.81 //layer=m2 \
 //thickness=0.36 //x=59.12 //y=2.385 //x2=46.325 //y2=2.355
r1825 (  102 126 ) resistor r=0.503444 //w=0.223 //l=0.919334 //layer=m2 \
 //thickness=0.36 //x=59.55 //y=2.385 //x2=60.435 //y2=2.315
r1826 (  102 103 ) resistor r=0.410305 //w=0.131 //l=0.43 //layer=m2 \
 //thickness=0.36 //x=59.55 //y=2.385 //x2=59.12 //y2=2.385
r1827 (  100 124 ) resistor r=0.114943 //w=0.174 //l=0.181108 //layer=m2 \
 //thickness=0.36 //x=46.165 //y=2.4 //x2=46.325 //y2=2.355
r1828 (  100 122 ) resistor r=3.17748 //w=0.131 //l=3.33 //layer=m2 \
 //thickness=0.36 //x=46.165 //y=2.4 //x2=42.835 //y2=2.4
r1829 (  99 118 ) resistor r=0.0972615 //w=0.222 //l=0.19799 //layer=m2 \
 //thickness=0.36 //x=34.695 //y=2.4 //x2=34.535 //y2=2.315
r1830 (  99 121 ) resistor r=7.46183 //w=0.131 //l=7.82 //layer=m2 \
 //thickness=0.36 //x=34.695 //y=2.4 //x2=42.515 //y2=2.4
r1831 (  97 116 ) resistor r=9.18463 //w=0.174 //l=12.7975 //layer=m2 \
 //thickness=0.36 //x=33.21 //y=2.38 //x2=20.425 //y2=2.355
r1832 (  96 118 ) resistor r=0.511113 //w=0.222 //l=0.92693 //layer=m2 \
 //thickness=0.36 //x=33.64 //y=2.38 //x2=34.535 //y2=2.315
r1833 (  96 97 ) resistor r=0.410305 //w=0.131 //l=0.43 //layer=m2 \
 //thickness=0.36 //x=33.64 //y=2.38 //x2=33.21 //y2=2.38
r1834 (  94 116 ) resistor r=0.114943 //w=0.174 //l=0.181108 //layer=m2 \
 //thickness=0.36 //x=20.265 //y=2.4 //x2=20.425 //y2=2.355
r1835 (  94 114 ) resistor r=3.17748 //w=0.131 //l=3.33 //layer=m2 \
 //thickness=0.36 //x=20.265 //y=2.4 //x2=16.935 //y2=2.4
r1836 (  93 110 ) resistor r=0.0451273 //w=0.318 //l=0.16 //layer=m2 \
 //thickness=0.36 //x=8.795 //y=2.4 //x2=8.635 //y2=2.4
r1837 (  93 113 ) resistor r=7.46183 //w=0.131 //l=7.82 //layer=m2 \
 //thickness=0.36 //x=8.795 //y=2.4 //x2=16.615 //y2=2.4
r1838 (  91 132 ) resistor r=4.5 //w=0.15 //l=0.15 //layer=via1 //count=1 \
 //x=72.225 //y=2.355 //x2=72.225 //y2=2.355
r1839 (  89 216 ) resistor r=9.3 //w=0.17 //l=0.17 //layer=mcon //count=1 \
 //x=72.27 //y=2.26 //x2=72.27 //y2=2.26
r1840 (  89 91 ) resistor r=0.0401182 //w=0.296 //l=0.095 //layer=m1 \
 //thickness=0.36 //x=72.227 //y=2.26 //x2=72.227 //y2=2.355
r1841 (  87 221 ) resistor r=9.3 //w=0.17 //l=0.17 //layer=mcon //count=1 \
 //x=72.27 //y=4.88 //x2=72.27 //y2=4.88
r1842 (  85 128 ) resistor r=4.5 //w=0.15 //l=0.15 //layer=via1 //count=1 \
 //x=68.575 //y=2.305 //x2=68.575 //y2=2.305
r1843 (  83 206 ) resistor r=9.3 //w=0.17 //l=0.17 //layer=mcon //count=1 \
 //x=68.57 //y=2.26 //x2=68.57 //y2=2.26
r1844 (  83 85 ) resistor r=0.0186258 //w=0.302 //l=0.045 //layer=m1 \
 //thickness=0.36 //x=68.575 //y=2.26 //x2=68.575 //y2=2.305
r1845 (  81 211 ) resistor r=9.3 //w=0.17 //l=0.17 //layer=mcon //count=1 \
 //x=68.57 //y=4.88 //x2=68.57 //y2=4.88
r1846 (  79 126 ) resistor r=4.5 //w=0.15 //l=0.15 //layer=via1 //count=1 \
 //x=60.435 //y=2.305 //x2=60.435 //y2=2.305
r1847 (  77 196 ) resistor r=9.3 //w=0.17 //l=0.17 //layer=mcon //count=1 \
 //x=60.43 //y=2.26 //x2=60.43 //y2=2.26
r1848 (  77 79 ) resistor r=0.0186258 //w=0.302 //l=0.045 //layer=m1 \
 //thickness=0.36 //x=60.435 //y=2.26 //x2=60.435 //y2=2.305
r1849 (  75 201 ) resistor r=9.3 //w=0.17 //l=0.17 //layer=mcon //count=1 \
 //x=60.43 //y=4.88 //x2=60.43 //y2=4.88
r1850 (  73 124 ) resistor r=4.5 //w=0.15 //l=0.15 //layer=via1 //count=1 \
 //x=46.325 //y=2.355 //x2=46.325 //y2=2.355
r1851 (  71 186 ) resistor r=9.3 //w=0.17 //l=0.17 //layer=mcon //count=1 \
 //x=46.37 //y=2.26 //x2=46.37 //y2=2.26
r1852 (  71 73 ) resistor r=0.0401182 //w=0.296 //l=0.095 //layer=m1 \
 //thickness=0.36 //x=46.327 //y=2.26 //x2=46.327 //y2=2.355
r1853 (  69 191 ) resistor r=9.3 //w=0.17 //l=0.17 //layer=mcon //count=1 \
 //x=46.37 //y=4.88 //x2=46.37 //y2=4.88
r1854 (  67 120 ) resistor r=4.5 //w=0.15 //l=0.15 //layer=via1 //count=1 \
 //x=42.675 //y=2.305 //x2=42.675 //y2=2.305
r1855 (  65 176 ) resistor r=9.3 //w=0.17 //l=0.17 //layer=mcon //count=1 \
 //x=42.67 //y=2.26 //x2=42.67 //y2=2.26
r1856 (  65 67 ) resistor r=0.0186258 //w=0.302 //l=0.045 //layer=m1 \
 //thickness=0.36 //x=42.675 //y=2.26 //x2=42.675 //y2=2.305
r1857 (  63 181 ) resistor r=9.3 //w=0.17 //l=0.17 //layer=mcon //count=1 \
 //x=42.67 //y=4.88 //x2=42.67 //y2=4.88
r1858 (  61 118 ) resistor r=4.5 //w=0.15 //l=0.15 //layer=via1 //count=1 \
 //x=34.535 //y=2.305 //x2=34.535 //y2=2.305
r1859 (  59 166 ) resistor r=9.3 //w=0.17 //l=0.17 //layer=mcon //count=1 \
 //x=34.53 //y=2.26 //x2=34.53 //y2=2.26
r1860 (  59 61 ) resistor r=0.0186258 //w=0.302 //l=0.045 //layer=m1 \
 //thickness=0.36 //x=34.535 //y=2.26 //x2=34.535 //y2=2.305
r1861 (  57 171 ) resistor r=9.3 //w=0.17 //l=0.17 //layer=mcon //count=1 \
 //x=34.53 //y=4.88 //x2=34.53 //y2=4.88
r1862 (  55 116 ) resistor r=4.5 //w=0.15 //l=0.15 //layer=via1 //count=1 \
 //x=20.425 //y=2.355 //x2=20.425 //y2=2.355
r1863 (  53 156 ) resistor r=9.3 //w=0.17 //l=0.17 //layer=mcon //count=1 \
 //x=20.47 //y=2.26 //x2=20.47 //y2=2.26
r1864 (  53 55 ) resistor r=0.0401182 //w=0.296 //l=0.095 //layer=m1 \
 //thickness=0.36 //x=20.427 //y=2.26 //x2=20.427 //y2=2.355
r1865 (  51 161 ) resistor r=9.3 //w=0.17 //l=0.17 //layer=mcon //count=1 \
 //x=20.47 //y=4.88 //x2=20.47 //y2=4.88
r1866 (  49 112 ) resistor r=4.5 //w=0.15 //l=0.15 //layer=via1 //count=1 \
 //x=16.775 //y=2.305 //x2=16.775 //y2=2.305
r1867 (  47 146 ) resistor r=9.3 //w=0.17 //l=0.17 //layer=mcon //count=1 \
 //x=16.77 //y=2.26 //x2=16.77 //y2=2.26
r1868 (  47 49 ) resistor r=0.0186258 //w=0.302 //l=0.045 //layer=m1 \
 //thickness=0.36 //x=16.775 //y=2.26 //x2=16.775 //y2=2.305
r1869 (  45 151 ) resistor r=9.3 //w=0.17 //l=0.17 //layer=mcon //count=1 \
 //x=16.77 //y=4.88 //x2=16.77 //y2=4.88
r1870 (  43 109 ) resistor r=4.5 //w=0.15 //l=0.15 //layer=via1 //count=1 \
 //x=8.635 //y=2.305 //x2=8.635 //y2=2.305
r1871 (  39 141 ) resistor r=9.3 //w=0.17 //l=0.17 //layer=mcon //count=1 \
 //x=8.63 //y=4.88 //x2=8.63 //y2=4.88
r1872 (  36 87 ) resistor r=0.0717383 //w=0.224 //l=0.115 //layer=m1 \
 //thickness=0.36 //x=72.27 //y=4.765 //x2=72.27 //y2=4.88
r1873 (  35 91 ) resistor r=0.0900276 //w=0.296 //l=0.180222 //layer=m1 \
 //thickness=0.36 //x=72.27 //y=2.515 //x2=72.227 //y2=2.355
r1874 (  34 81 ) resistor r=0.0801089 //w=0.224 //l=0.13 //layer=m1 \
 //thickness=0.36 //x=68.57 //y=4.75 //x2=68.57 //y2=4.88
r1875 (  33 85 ) resistor r=0.0899119 //w=0.302 //l=0.162481 //layer=m1 \
 //thickness=0.36 //x=68.57 //y=2.465 //x2=68.575 //y2=2.305
r1876 (  33 34 ) resistor r=2.18034 //w=0.131 //l=2.285 //layer=m1 \
 //thickness=0.36 //x=68.57 //y=2.465 //x2=68.57 //y2=4.75
r1877 (  32 75 ) resistor r=0.0801089 //w=0.224 //l=0.13 //layer=m1 \
 //thickness=0.36 //x=60.43 //y=4.75 //x2=60.43 //y2=4.88
r1878 (  31 79 ) resistor r=0.0899119 //w=0.302 //l=0.162481 //layer=m1 \
 //thickness=0.36 //x=60.43 //y=2.465 //x2=60.435 //y2=2.305
r1879 (  31 32 ) resistor r=2.18034 //w=0.131 //l=2.285 //layer=m1 \
 //thickness=0.36 //x=60.43 //y=2.465 //x2=60.43 //y2=4.75
r1880 (  28 69 ) resistor r=0.0717383 //w=0.224 //l=0.115 //layer=m1 \
 //thickness=0.36 //x=46.37 //y=4.765 //x2=46.37 //y2=4.88
r1881 (  27 73 ) resistor r=0.0900276 //w=0.296 //l=0.180222 //layer=m1 \
 //thickness=0.36 //x=46.37 //y=2.515 //x2=46.327 //y2=2.355
r1882 (  25 63 ) resistor r=0.0801089 //w=0.224 //l=0.13 //layer=m1 \
 //thickness=0.36 //x=42.67 //y=4.75 //x2=42.67 //y2=4.88
r1883 (  24 67 ) resistor r=0.0899119 //w=0.302 //l=0.162481 //layer=m1 \
 //thickness=0.36 //x=42.67 //y=2.465 //x2=42.675 //y2=2.305
r1884 (  23 57 ) resistor r=0.0801089 //w=0.224 //l=0.13 //layer=m1 \
 //thickness=0.36 //x=34.53 //y=4.75 //x2=34.53 //y2=4.88
r1885 (  22 61 ) resistor r=0.0899119 //w=0.302 //l=0.162481 //layer=m1 \
 //thickness=0.36 //x=34.53 //y=2.465 //x2=34.535 //y2=2.305
r1886 (  22 23 ) resistor r=2.18034 //w=0.131 //l=2.285 //layer=m1 \
 //thickness=0.36 //x=34.53 //y=2.465 //x2=34.53 //y2=4.75
r1887 (  19 51 ) resistor r=0.0717383 //w=0.224 //l=0.115 //layer=m1 \
 //thickness=0.36 //x=20.47 //y=4.765 //x2=20.47 //y2=4.88
r1888 (  18 55 ) resistor r=0.0900276 //w=0.296 //l=0.180222 //layer=m1 \
 //thickness=0.36 //x=20.47 //y=2.515 //x2=20.427 //y2=2.355
r1889 (  15 45 ) resistor r=0.0801089 //w=0.224 //l=0.13 //layer=m1 \
 //thickness=0.36 //x=16.77 //y=4.75 //x2=16.77 //y2=4.88
r1890 (  14 49 ) resistor r=0.0899119 //w=0.302 //l=0.162481 //layer=m1 \
 //thickness=0.36 //x=16.77 //y=2.465 //x2=16.775 //y2=2.305
r1891 (  12 39 ) resistor r=0.0801089 //w=0.224 //l=0.13 //layer=m1 \
 //thickness=0.36 //x=8.63 //y=4.75 //x2=8.63 //y2=4.88
r1892 (  10 136 ) resistor r=9.3 //w=0.17 //l=0.17 //layer=mcon //count=1 \
 //x=8.63 //y=2.26 //x2=8.63 //y2=2.26
r1893 (  10 43 ) resistor r=0.00179083 //w=0.349 //l=0.005 //layer=m1 \
 //thickness=0.36 //x=8.63 //y=2.28 //x2=8.635 //y2=2.28
r1894 (  10 11 ) resistor r=0.050788 //w=0.349 //l=0.185 //layer=m1 \
 //thickness=0.36 //x=8.63 //y=2.28 //x2=8.63 //y2=2.465
r1895 (  9 36 ) resistor r=0.844466 //w=0.131 //l=0.885 //layer=m1 \
 //thickness=0.36 //x=72.27 //y=3.88 //x2=72.27 //y2=4.765
r1896 (  9 35 ) resistor r=1.30248 //w=0.131 //l=1.365 //layer=m1 \
 //thickness=0.36 //x=72.27 //y=3.88 //x2=72.27 //y2=2.515
r1897 (  8 28 ) resistor r=0.844466 //w=0.131 //l=0.885 //layer=m1 \
 //thickness=0.36 //x=46.37 //y=3.88 //x2=46.37 //y2=4.765
r1898 (  7 8 ) resistor r=0.353053 //w=0.131 //l=0.37 //layer=m1 \
 //thickness=0.36 //x=46.37 //y=3.51 //x2=46.37 //y2=3.88
r1899 (  7 27 ) resistor r=0.949427 //w=0.131 //l=0.995 //layer=m1 \
 //thickness=0.36 //x=46.37 //y=3.51 //x2=46.37 //y2=2.515
r1900 (  6 25 ) resistor r=1.18321 //w=0.131 //l=1.24 //layer=m1 \
 //thickness=0.36 //x=42.67 //y=3.51 //x2=42.67 //y2=4.75
r1901 (  6 24 ) resistor r=0.997137 //w=0.131 //l=1.045 //layer=m1 \
 //thickness=0.36 //x=42.67 //y=3.51 //x2=42.67 //y2=2.465
r1902 (  5 19 ) resistor r=1.19752 //w=0.131 //l=1.255 //layer=m1 \
 //thickness=0.36 //x=20.47 //y=3.51 //x2=20.47 //y2=4.765
r1903 (  4 5 ) resistor r=0.353053 //w=0.131 //l=0.37 //layer=m1 \
 //thickness=0.36 //x=20.47 //y=3.14 //x2=20.47 //y2=3.51
r1904 (  4 18 ) resistor r=0.596374 //w=0.131 //l=0.625 //layer=m1 \
 //thickness=0.36 //x=20.47 //y=3.14 //x2=20.47 //y2=2.515
r1905 (  3 15 ) resistor r=1.18321 //w=0.131 //l=1.24 //layer=m1 \
 //thickness=0.36 //x=16.77 //y=3.51 //x2=16.77 //y2=4.75
r1906 (  2 3 ) resistor r=0.353053 //w=0.131 //l=0.37 //layer=m1 \
 //thickness=0.36 //x=16.77 //y=3.14 //x2=16.77 //y2=3.51
r1907 (  2 14 ) resistor r=0.644084 //w=0.131 //l=0.675 //layer=m1 \
 //thickness=0.36 //x=16.77 //y=3.14 //x2=16.77 //y2=2.465
r1908 (  1 12 ) resistor r=1.53626 //w=0.131 //l=1.61 //layer=m1 \
 //thickness=0.36 //x=8.63 //y=3.14 //x2=8.63 //y2=4.75
r1909 (  1 11 ) resistor r=0.644084 //w=0.131 //l=0.675 //layer=m1 \
 //thickness=0.36 //x=8.63 //y=3.14 //x2=8.63 //y2=2.465
ends PM_TMRDFFRNQX1\%RN

subckt PM_TMRDFFRNQX1\%noxref_14 ( 1 2 3 4 6 7 8 9 11 14 15 17 18 19 20 22 23 \
 24 25 27 30 31 33 34 35 36 38 39 40 42 43 46 47 48 54 58 61 66 69 72 78 81 84 \
 87 93 97 101 104 105 108 112 117 119 121 123 125 126 127 128 130 136 145 146 \
 148 149 152 161 166 175 180 188 196 213 221 229 246 255 260 269 273 274 275 \
 276 277 278 279 280 281 282 283 284 285 286 287 288 289 291 297 298 299 300 \
 304 305 306 311 313 315 321 322 323 324 325 326 330 332 335 336 340 341 342 \
 347 349 351 357 358 368 369 372 386 390 391 394 402 403 406 407 408 409 410 \
 411 )
c825 ( 403 0 ) capacitor c=0.00885916f //x=73.445 //y=1.095
c826 ( 402 0 ) capacitor c=0.00885916f //x=68.635 //y=1.095
c827 ( 394 0 ) capacitor c=0.0366137f //x=76.74 //y=4.88
c828 ( 391 0 ) capacitor c=0.0297213f //x=76.71 //y=2.095
c829 ( 390 0 ) capacitor c=0.0488821f //x=76.71 //y=2.26
c830 ( 386 0 ) capacitor c=0.064448f //x=75.97 //y=4.88
c831 ( 372 0 ) capacitor c=0.0354929f //x=63.79 //y=4.88
c832 ( 369 0 ) capacitor c=0.0284095f //x=63.76 //y=2.095
c833 ( 368 0 ) capacitor c=0.0476356f //x=63.76 //y=2.26
c834 ( 358 0 ) capacitor c=0.0441827f //x=77.275 //y=1.43
c835 ( 357 0 ) capacitor c=0.019833f //x=77.275 //y=1.085
c836 ( 351 0 ) capacitor c=0.0162526f //x=77.12 //y=1.585
c837 ( 349 0 ) capacitor c=0.0157807f //x=77.12 //y=0.93
c838 ( 347 0 ) capacitor c=0.0360083f //x=77.115 //y=4.97
c839 ( 342 0 ) capacitor c=0.0216374f //x=76.745 //y=1.74
c840 ( 341 0 ) capacitor c=0.0179909f //x=76.745 //y=1.43
c841 ( 340 0 ) capacitor c=0.0178631f //x=76.745 //y=1.085
c842 ( 336 0 ) capacitor c=0.0338883f //x=76.305 //y=1.39
c843 ( 335 0 ) capacitor c=0.0188688f //x=76.305 //y=1.045
c844 ( 332 0 ) capacitor c=0.0141821f //x=76.15 //y=1.545
c845 ( 330 0 ) capacitor c=0.0158553f //x=76.15 //y=0.89
c846 ( 326 0 ) capacitor c=0.0899055f //x=75.775 //y=2.095
c847 ( 325 0 ) capacitor c=0.0230625f //x=75.775 //y=1.7
c848 ( 324 0 ) capacitor c=0.0234359f //x=75.775 //y=1.39
c849 ( 323 0 ) capacitor c=0.0200755f //x=75.775 //y=1.045
c850 ( 322 0 ) capacitor c=0.0439708f //x=64.325 //y=1.43
c851 ( 321 0 ) capacitor c=0.0192582f //x=64.325 //y=1.085
c852 ( 315 0 ) capacitor c=0.0162526f //x=64.17 //y=1.585
c853 ( 313 0 ) capacitor c=0.0157807f //x=64.17 //y=0.93
c854 ( 311 0 ) capacitor c=0.0372668f //x=64.165 //y=4.97
c855 ( 306 0 ) capacitor c=0.0210762f //x=63.795 //y=1.74
c856 ( 305 0 ) capacitor c=0.0168511f //x=63.795 //y=1.43
c857 ( 304 0 ) capacitor c=0.0175485f //x=63.795 //y=1.085
c858 ( 300 0 ) capacitor c=0.0552068f //x=53.675 //y=4.97
c859 ( 299 0 ) capacitor c=0.0376642f //x=53.965 //y=4.97
c860 ( 298 0 ) capacitor c=0.0346489f //x=53.63 //y=1.4
c861 ( 297 0 ) capacitor c=0.018692f //x=53.63 //y=1.055
c862 ( 291 0 ) capacitor c=0.0137077f //x=53.475 //y=1.555
c863 ( 289 0 ) capacitor c=0.0158585f //x=53.475 //y=0.9
c864 ( 288 0 ) capacitor c=0.103534f //x=53.1 //y=2.095
c865 ( 287 0 ) capacitor c=0.0229444f //x=53.1 //y=1.71
c866 ( 286 0 ) capacitor c=0.0234359f //x=53.1 //y=1.4
c867 ( 285 0 ) capacitor c=0.019815f //x=53.1 //y=1.055
c868 ( 284 0 ) capacitor c=0.155269f //x=77.19 //y=6.2
c869 ( 283 0 ) capacitor c=0.116174f //x=76.75 //y=6.2
c870 ( 282 0 ) capacitor c=0.116167f //x=76.31 //y=6.2
c871 ( 281 0 ) capacitor c=0.154619f //x=75.87 //y=6.2
c872 ( 280 0 ) capacitor c=0.155269f //x=64.24 //y=6.2
c873 ( 279 0 ) capacitor c=0.110375f //x=63.8 //y=6.2
c874 ( 278 0 ) capacitor c=0.110208f //x=54.04 //y=6.2
c875 ( 277 0 ) capacitor c=0.158957f //x=53.6 //y=6.2
c876 ( 269 0 ) capacitor c=5.80994e-19 //x=76.74 //y=4.88
c877 ( 260 0 ) capacitor c=5.78095e-19 //x=76.71 //y=2.26
c878 ( 255 0 ) capacitor c=5.44848e-19 //x=75.97 //y=4.88
c879 ( 246 0 ) capacitor c=7.85889e-19 //x=75.97 //y=2.26
c880 ( 229 0 ) capacitor c=0.0293219f //x=73.34 //y=5.56
c881 ( 221 0 ) capacitor c=0.029137f //x=72.46 //y=5.56
c882 ( 213 0 ) capacitor c=0.0278099f //x=71.58 //y=5.56
c883 ( 196 0 ) capacitor c=0.0293124f //x=68.53 //y=5.56
c884 ( 188 0 ) capacitor c=0.029137f //x=67.65 //y=5.56
c885 ( 180 0 ) capacitor c=0.0277605f //x=66.77 //y=5.56
c886 ( 175 0 ) capacitor c=5.80994e-19 //x=63.79 //y=4.88
c887 ( 166 0 ) capacitor c=5.78095e-19 //x=63.76 //y=2.26
c888 ( 161 0 ) capacitor c=0.00125338f //x=53.4 //y=4.88
c889 ( 152 0 ) capacitor c=0.0012618f //x=53.4 //y=2.26
c890 ( 149 0 ) capacitor c=0.00768948f //x=76.54 //y=4.255
c891 ( 148 0 ) capacitor c=0.00244809f //x=76.7 //y=4.255
c892 ( 146 0 ) capacitor c=0.0036891f //x=76.115 //y=4.275
c893 ( 145 0 ) capacitor c=0.0424994f //x=75.795 //y=4.275
c894 ( 136 0 ) capacitor c=9.9247e-19 //x=53.56 //y=4.26
c895 ( 130 0 ) capacitor c=0.0639374f //x=74.28 //y=4.25
c896 ( 128 0 ) capacitor c=0.0541447f //x=71.02 //y=4.265
c897 ( 127 0 ) capacitor c=0.00660693f //x=71.365 //y=4.265
c898 ( 126 0 ) capacitor c=0.0480221f //x=63.925 //y=4.25
c899 ( 125 0 ) capacitor c=0.0667107f //x=69.155 //y=4.25
c900 ( 123 0 ) capacitor c=0.00158466f //x=58.43 //y=4.265
c901 ( 121 0 ) capacitor c=0.0162158f //x=57.83 //y=4.25
c902 ( 119 0 ) capacitor c=0.00487421f //x=56.615 //y=4.27
c903 ( 117 0 ) capacitor c=0.0280256f //x=55.975 //y=4.25
c904 ( 112 0 ) capacitor c=0.00661943f //x=76.71 //y=2.26
c905 ( 108 0 ) capacitor c=0.0139f //x=76.71 //y=4.25
c906 ( 105 0 ) capacitor c=0.00656908f //x=75.972 //y=4.74
c907 ( 104 0 ) capacitor c=0.00586902f //x=75.97 //y=4.88
c908 ( 101 0 ) capacitor c=0.00667671f //x=75.97 //y=2.26
c909 ( 97 0 ) capacitor c=0.0134828f //x=75.97 //y=4.25
c910 ( 93 0 ) capacitor c=0.016125f //x=74.12 //y=4.25
c911 ( 87 0 ) capacitor c=9.35422e-19 //x=73.34 //y=5.335
c912 ( 84 0 ) capacitor c=0.00825613f //x=72.46 //y=5.335
c913 ( 81 0 ) capacitor c=0.0111859f //x=71.582 //y=5.335
c914 ( 78 0 ) capacitor c=0.0151867f //x=69.31 //y=4.25
c915 ( 72 0 ) capacitor c=0.00118259f //x=68.53 //y=5.335
c916 ( 69 0 ) capacitor c=0.00758117f //x=67.65 //y=5.335
c917 ( 66 0 ) capacitor c=0.0112819f //x=66.772 //y=5.335
c918 ( 61 0 ) capacitor c=0.00504845f //x=63.76 //y=2.26
c919 ( 58 0 ) capacitor c=0.0141348f //x=63.76 //y=4.25
c920 ( 54 0 ) capacitor c=0.0159682f //x=53.4 //y=4.25
c921 ( 48 0 ) capacitor c=0.0092073f //x=76.71 //y=4.735
c922 ( 47 0 ) capacitor c=0.00913643f //x=76.71 //y=4.415
c923 ( 46 0 ) capacitor c=0.0338939f //x=76.71 //y=4.095
c924 ( 43 0 ) capacitor c=0.0109318f //x=75.97 //y=4.435
c925 ( 42 0 ) capacitor c=0.0463902f //x=75.97 //y=4.115
c926 ( 40 0 ) capacitor c=0.0215199f //x=74.12 //y=5.25
c927 ( 39 0 ) capacitor c=0.0129289f //x=74.12 //y=4.425
c928 ( 38 0 ) capacitor c=0.059071f //x=74.12 //y=4.105
c929 ( 36 0 ) capacitor c=0.00551674f //x=73.72 //y=1.845
c930 ( 35 0 ) capacitor c=0.0156131f //x=74.035 //y=1.845
c931 ( 34 0 ) capacitor c=0.0136149f //x=73.635 //y=1.76
c932 ( 33 0 ) capacitor c=0.0112322f //x=73.635 //y=1.305
c933 ( 31 0 ) capacitor c=0.0238688f //x=74.035 //y=5.335
c934 ( 30 0 ) capacitor c=0.00906713f //x=73.34 //y=5.56
c935 ( 27 0 ) capacitor c=0.0200404f //x=73.225 //y=5.335
c936 ( 25 0 ) capacitor c=0.0154206f //x=72.34 //y=5.335
c937 ( 24 0 ) capacitor c=0.0221841f //x=69.31 //y=5.25
c938 ( 23 0 ) capacitor c=0.0126978f //x=69.31 //y=4.415
c939 ( 22 0 ) capacitor c=0.0610795f //x=69.31 //y=4.095
c940 ( 20 0 ) capacitor c=0.00493487f //x=68.91 //y=1.845
c941 ( 19 0 ) capacitor c=0.0132593f //x=69.225 //y=1.845
c942 ( 18 0 ) capacitor c=0.0167333f //x=68.825 //y=1.76
c943 ( 17 0 ) capacitor c=0.0111392f //x=68.825 //y=1.305
c944 ( 15 0 ) capacitor c=0.0239047f //x=69.225 //y=5.335
c945 ( 14 0 ) capacitor c=0.00933983f //x=68.53 //y=5.56
c946 ( 11 0 ) capacitor c=0.0200404f //x=68.415 //y=5.335
c947 ( 9 0 ) capacitor c=0.0147103f //x=67.53 //y=5.335
c948 ( 8 0 ) capacitor c=0.00917813f //x=63.76 //y=4.735
c949 ( 7 0 ) capacitor c=0.00994911f //x=63.76 //y=4.41
c950 ( 6 0 ) capacitor c=0.0349592f //x=63.76 //y=4.09
c951 ( 4 0 ) capacitor c=0.0137415f //x=53.4 //y=4.755
c952 ( 3 0 ) capacitor c=0.0127134f //x=53.4 //y=4.42
c953 ( 2 0 ) capacitor c=0.0531107f //x=53.4 //y=4.1
c954 ( 1 0 ) capacitor c=0.00495287f //x=53.4 //y=2.375
r955 (  396 397 ) resistor r=32.4568 //w=0.214 //l=0.075 //layer=ply \
 //thickness=0.18 //x=76.74 //y=4.97 //x2=76.74 //y2=5.045
r956 (  394 396 ) resistor r=20.271 //w=0.214 //l=0.09 //layer=ply \
 //thickness=0.18 //x=76.74 //y=4.88 //x2=76.74 //y2=4.97
r957 (  390 391 ) resistor r=52.7279 //w=0.214 //l=0.165 //layer=ply \
 //thickness=0.18 //x=76.71 //y=2.26 //x2=76.71 //y2=2.095
r958 (  384 386 ) resistor r=20.6867 //w=0.233 //l=0.1 //layer=ply \
 //thickness=0.18 //x=75.87 //y=4.88 //x2=75.97 //y2=4.88
r959 (  374 375 ) resistor r=32.4568 //w=0.214 //l=0.075 //layer=ply \
 //thickness=0.18 //x=63.79 //y=4.97 //x2=63.79 //y2=5.045
r960 (  372 374 ) resistor r=20.271 //w=0.214 //l=0.09 //layer=ply \
 //thickness=0.18 //x=63.79 //y=4.88 //x2=63.79 //y2=4.97
r961 (  368 369 ) resistor r=52.7279 //w=0.214 //l=0.165 //layer=ply \
 //thickness=0.18 //x=63.76 //y=2.26 //x2=63.76 //y2=2.095
r962 (  358 401 ) resistor r=45.1352 //w=0.168 //l=0.173853 //layer=ply \
 //thickness=0.18 //x=77.275 //y=1.43 //x2=77.235 //y2=1.585
r963 (  357 400 ) resistor r=45.1352 //w=0.168 //l=0.173853 //layer=ply \
 //thickness=0.18 //x=77.275 //y=1.085 //x2=77.235 //y2=0.93
r964 (  357 358 ) resistor r=176.904 //w=0.094 //l=0.345 //layer=ply \
 //thickness=0.18 //x=77.275 //y=1.085 //x2=77.275 //y2=1.43
r965 (  352 399 ) resistor r=10.701 //w=0.21 //l=0.115 //layer=ply \
 //thickness=0.18 //x=76.9 //y=1.585 //x2=76.785 //y2=1.585
r966 (  351 401 ) resistor r=5.52526 //w=0.168 //l=0.115 //layer=ply \
 //thickness=0.18 //x=77.12 //y=1.585 //x2=77.235 //y2=1.585
r967 (  350 398 ) resistor r=5.52526 //w=0.168 //l=0.115 //layer=ply \
 //thickness=0.18 //x=76.9 //y=0.93 //x2=76.785 //y2=0.93
r968 (  349 400 ) resistor r=5.52526 //w=0.168 //l=0.115 //layer=ply \
 //thickness=0.18 //x=77.12 //y=0.93 //x2=77.235 //y2=0.93
r969 (  349 350 ) resistor r=112.809 //w=0.094 //l=0.22 //layer=ply \
 //thickness=0.18 //x=77.12 //y=0.93 //x2=76.9 //y2=0.93
r970 (  348 396 ) resistor r=16.5046 //w=0.27 //l=0.135 //layer=ply \
 //thickness=0.18 //x=76.875 //y=4.97 //x2=76.74 //y2=4.97
r971 (  347 354 ) resistor r=26.9307 //w=0.15 //l=0.106066 //layer=ply \
 //thickness=0.18 //x=77.115 //y=4.97 //x2=77.19 //y2=5.045
r972 (  347 348 ) resistor r=123.064 //w=0.094 //l=0.24 //layer=ply \
 //thickness=0.18 //x=77.115 //y=4.97 //x2=76.875 //y2=4.97
r973 (  342 399 ) resistor r=39.5823 //w=0.21 //l=0.173853 //layer=ply \
 //thickness=0.18 //x=76.745 //y=1.74 //x2=76.785 //y2=1.585
r974 (  342 391 ) resistor r=182.032 //w=0.094 //l=0.355 //layer=ply \
 //thickness=0.18 //x=76.745 //y=1.74 //x2=76.745 //y2=2.095
r975 (  341 399 ) resistor r=39.5823 //w=0.21 //l=0.173853 //layer=ply \
 //thickness=0.18 //x=76.745 //y=1.43 //x2=76.785 //y2=1.585
r976 (  340 398 ) resistor r=45.1352 //w=0.168 //l=0.173853 //layer=ply \
 //thickness=0.18 //x=76.745 //y=1.085 //x2=76.785 //y2=0.93
r977 (  340 341 ) resistor r=176.904 //w=0.094 //l=0.345 //layer=ply \
 //thickness=0.18 //x=76.745 //y=1.085 //x2=76.745 //y2=1.43
r978 (  337 386 ) resistor r=70.3348 //w=0.233 //l=0.414367 //layer=ply \
 //thickness=0.18 //x=76.31 //y=5.045 //x2=75.97 //y2=4.88
r979 (  336 388 ) resistor r=45.1352 //w=0.168 //l=0.173853 //layer=ply \
 //thickness=0.18 //x=76.305 //y=1.39 //x2=76.265 //y2=1.545
r980 (  335 387 ) resistor r=45.1352 //w=0.168 //l=0.173853 //layer=ply \
 //thickness=0.18 //x=76.305 //y=1.045 //x2=76.265 //y2=0.89
r981 (  335 336 ) resistor r=176.904 //w=0.094 //l=0.345 //layer=ply \
 //thickness=0.18 //x=76.305 //y=1.045 //x2=76.305 //y2=1.39
r982 (  333 383 ) resistor r=10.701 //w=0.21 //l=0.115 //layer=ply \
 //thickness=0.18 //x=75.93 //y=1.545 //x2=75.815 //y2=1.545
r983 (  332 388 ) resistor r=5.52526 //w=0.168 //l=0.115 //layer=ply \
 //thickness=0.18 //x=76.15 //y=1.545 //x2=76.265 //y2=1.545
r984 (  331 382 ) resistor r=5.52526 //w=0.168 //l=0.115 //layer=ply \
 //thickness=0.18 //x=75.93 //y=0.89 //x2=75.815 //y2=0.89
r985 (  330 387 ) resistor r=5.52526 //w=0.168 //l=0.115 //layer=ply \
 //thickness=0.18 //x=76.15 //y=0.89 //x2=76.265 //y2=0.89
r986 (  330 331 ) resistor r=112.809 //w=0.094 //l=0.22 //layer=ply \
 //thickness=0.18 //x=76.15 //y=0.89 //x2=75.93 //y2=0.89
r987 (  327 384 ) resistor r=13.0941 //w=0.233 //l=0.165 //layer=ply \
 //thickness=0.18 //x=75.87 //y=5.045 //x2=75.87 //y2=4.88
r988 (  326 381 ) resistor r=34.8111 //w=0.27 //l=0.264953 //layer=ply \
 //thickness=0.18 //x=75.775 //y=2.095 //x2=75.97 //y2=2.26
r989 (  325 383 ) resistor r=39.5823 //w=0.21 //l=0.173853 //layer=ply \
 //thickness=0.18 //x=75.775 //y=1.7 //x2=75.815 //y2=1.545
r990 (  325 326 ) resistor r=202.543 //w=0.094 //l=0.395 //layer=ply \
 //thickness=0.18 //x=75.775 //y=1.7 //x2=75.775 //y2=2.095
r991 (  324 383 ) resistor r=39.5823 //w=0.21 //l=0.173853 //layer=ply \
 //thickness=0.18 //x=75.775 //y=1.39 //x2=75.815 //y2=1.545
r992 (  323 382 ) resistor r=45.1352 //w=0.168 //l=0.173853 //layer=ply \
 //thickness=0.18 //x=75.775 //y=1.045 //x2=75.815 //y2=0.89
r993 (  323 324 ) resistor r=176.904 //w=0.094 //l=0.345 //layer=ply \
 //thickness=0.18 //x=75.775 //y=1.045 //x2=75.775 //y2=1.39
r994 (  322 379 ) resistor r=45.1352 //w=0.168 //l=0.173853 //layer=ply \
 //thickness=0.18 //x=64.325 //y=1.43 //x2=64.285 //y2=1.585
r995 (  321 378 ) resistor r=45.1352 //w=0.168 //l=0.173853 //layer=ply \
 //thickness=0.18 //x=64.325 //y=1.085 //x2=64.285 //y2=0.93
r996 (  321 322 ) resistor r=176.904 //w=0.094 //l=0.345 //layer=ply \
 //thickness=0.18 //x=64.325 //y=1.085 //x2=64.325 //y2=1.43
r997 (  316 377 ) resistor r=10.701 //w=0.21 //l=0.115 //layer=ply \
 //thickness=0.18 //x=63.95 //y=1.585 //x2=63.835 //y2=1.585
r998 (  315 379 ) resistor r=5.52526 //w=0.168 //l=0.115 //layer=ply \
 //thickness=0.18 //x=64.17 //y=1.585 //x2=64.285 //y2=1.585
r999 (  314 376 ) resistor r=5.52526 //w=0.168 //l=0.115 //layer=ply \
 //thickness=0.18 //x=63.95 //y=0.93 //x2=63.835 //y2=0.93
r1000 (  313 378 ) resistor r=5.52526 //w=0.168 //l=0.115 //layer=ply \
 //thickness=0.18 //x=64.17 //y=0.93 //x2=64.285 //y2=0.93
r1001 (  313 314 ) resistor r=112.809 //w=0.094 //l=0.22 //layer=ply \
 //thickness=0.18 //x=64.17 //y=0.93 //x2=63.95 //y2=0.93
r1002 (  312 374 ) resistor r=16.5046 //w=0.27 //l=0.135 //layer=ply \
 //thickness=0.18 //x=63.925 //y=4.97 //x2=63.79 //y2=4.97
r1003 (  311 318 ) resistor r=26.9307 //w=0.15 //l=0.106066 //layer=ply \
 //thickness=0.18 //x=64.165 //y=4.97 //x2=64.24 //y2=5.045
r1004 (  311 312 ) resistor r=123.064 //w=0.094 //l=0.24 //layer=ply \
 //thickness=0.18 //x=64.165 //y=4.97 //x2=63.925 //y2=4.97
r1005 (  306 377 ) resistor r=39.5823 //w=0.21 //l=0.173853 //layer=ply \
 //thickness=0.18 //x=63.795 //y=1.74 //x2=63.835 //y2=1.585
r1006 (  306 369 ) resistor r=182.032 //w=0.094 //l=0.355 //layer=ply \
 //thickness=0.18 //x=63.795 //y=1.74 //x2=63.795 //y2=2.095
r1007 (  305 377 ) resistor r=39.5823 //w=0.21 //l=0.173853 //layer=ply \
 //thickness=0.18 //x=63.795 //y=1.43 //x2=63.835 //y2=1.585
r1008 (  304 376 ) resistor r=45.1352 //w=0.168 //l=0.173853 //layer=ply \
 //thickness=0.18 //x=63.795 //y=1.085 //x2=63.835 //y2=0.93
r1009 (  304 305 ) resistor r=176.904 //w=0.094 //l=0.345 //layer=ply \
 //thickness=0.18 //x=63.795 //y=1.085 //x2=63.795 //y2=1.43
r1010 (  299 301 ) resistor r=26.9307 //w=0.15 //l=0.106066 //layer=ply \
 //thickness=0.18 //x=53.965 //y=4.97 //x2=54.04 //y2=5.045
r1011 (  299 300 ) resistor r=148.702 //w=0.094 //l=0.29 //layer=ply \
 //thickness=0.18 //x=53.965 //y=4.97 //x2=53.675 //y2=4.97
r1012 (  298 366 ) resistor r=45.1352 //w=0.168 //l=0.173853 //layer=ply \
 //thickness=0.18 //x=53.63 //y=1.4 //x2=53.59 //y2=1.555
r1013 (  297 365 ) resistor r=45.1352 //w=0.168 //l=0.173853 //layer=ply \
 //thickness=0.18 //x=53.63 //y=1.055 //x2=53.59 //y2=0.9
r1014 (  297 298 ) resistor r=176.904 //w=0.094 //l=0.345 //layer=ply \
 //thickness=0.18 //x=53.63 //y=1.055 //x2=53.63 //y2=1.4
r1015 (  294 300 ) resistor r=22.7971 //w=0.269 //l=0.106066 //layer=ply \
 //thickness=0.18 //x=53.6 //y=5.045 //x2=53.675 //y2=4.97
r1016 (  294 364 ) resistor r=35.8364 //w=0.269 //l=0.270185 //layer=ply \
 //thickness=0.18 //x=53.6 //y=5.045 //x2=53.4 //y2=4.88
r1017 (  292 360 ) resistor r=10.701 //w=0.21 //l=0.115 //layer=ply \
 //thickness=0.18 //x=53.255 //y=1.555 //x2=53.14 //y2=1.555
r1018 (  291 366 ) resistor r=5.52526 //w=0.168 //l=0.115 //layer=ply \
 //thickness=0.18 //x=53.475 //y=1.555 //x2=53.59 //y2=1.555
r1019 (  290 359 ) resistor r=5.52526 //w=0.168 //l=0.115 //layer=ply \
 //thickness=0.18 //x=53.255 //y=0.9 //x2=53.14 //y2=0.9
r1020 (  289 365 ) resistor r=5.52526 //w=0.168 //l=0.115 //layer=ply \
 //thickness=0.18 //x=53.475 //y=0.9 //x2=53.59 //y2=0.9
r1021 (  289 290 ) resistor r=112.809 //w=0.094 //l=0.22 //layer=ply \
 //thickness=0.18 //x=53.475 //y=0.9 //x2=53.255 //y2=0.9
r1022 (  288 362 ) resistor r=58.7805 //w=0.246 //l=0.373497 //layer=ply \
 //thickness=0.18 //x=53.1 //y=2.095 //x2=53.4 //y2=2.26
r1023 (  287 360 ) resistor r=39.5823 //w=0.21 //l=0.173853 //layer=ply \
 //thickness=0.18 //x=53.1 //y=1.71 //x2=53.14 //y2=1.555
r1024 (  287 288 ) resistor r=197.415 //w=0.094 //l=0.385 //layer=ply \
 //thickness=0.18 //x=53.1 //y=1.71 //x2=53.1 //y2=2.095
r1025 (  286 360 ) resistor r=39.5823 //w=0.21 //l=0.173853 //layer=ply \
 //thickness=0.18 //x=53.1 //y=1.4 //x2=53.14 //y2=1.555
r1026 (  285 359 ) resistor r=45.1352 //w=0.168 //l=0.173853 //layer=ply \
 //thickness=0.18 //x=53.1 //y=1.055 //x2=53.14 //y2=0.9
r1027 (  285 286 ) resistor r=176.904 //w=0.094 //l=0.345 //layer=ply \
 //thickness=0.18 //x=53.1 //y=1.055 //x2=53.1 //y2=1.4
r1028 (  284 354 ) resistor r=592.245 //w=0.094 //l=1.155 //layer=ply \
 //thickness=0.18 //x=77.19 //y=6.2 //x2=77.19 //y2=5.045
r1029 (  283 397 ) resistor r=592.245 //w=0.094 //l=1.155 //layer=ply \
 //thickness=0.18 //x=76.75 //y=6.2 //x2=76.75 //y2=5.045
r1030 (  282 337 ) resistor r=592.245 //w=0.094 //l=1.155 //layer=ply \
 //thickness=0.18 //x=76.31 //y=6.2 //x2=76.31 //y2=5.045
r1031 (  281 327 ) resistor r=592.245 //w=0.094 //l=1.155 //layer=ply \
 //thickness=0.18 //x=75.87 //y=6.2 //x2=75.87 //y2=5.045
r1032 (  280 318 ) resistor r=592.245 //w=0.094 //l=1.155 //layer=ply \
 //thickness=0.18 //x=64.24 //y=6.2 //x2=64.24 //y2=5.045
r1033 (  279 375 ) resistor r=592.245 //w=0.094 //l=1.155 //layer=ply \
 //thickness=0.18 //x=63.8 //y=6.2 //x2=63.8 //y2=5.045
r1034 (  278 301 ) resistor r=592.245 //w=0.094 //l=1.155 //layer=ply \
 //thickness=0.18 //x=54.04 //y=6.2 //x2=54.04 //y2=5.045
r1035 (  277 294 ) resistor r=592.245 //w=0.094 //l=1.155 //layer=ply \
 //thickness=0.18 //x=53.6 //y=6.2 //x2=53.6 //y2=5.045
r1036 (  276 351 ) resistor r=56.4043 //w=0.094 //l=0.11 //layer=ply \
 //thickness=0.18 //x=77.01 //y=1.585 //x2=77.12 //y2=1.585
r1037 (  276 352 ) resistor r=56.4043 //w=0.094 //l=0.11 //layer=ply \
 //thickness=0.18 //x=77.01 //y=1.585 //x2=76.9 //y2=1.585
r1038 (  275 332 ) resistor r=56.4043 //w=0.094 //l=0.11 //layer=ply \
 //thickness=0.18 //x=76.04 //y=1.545 //x2=76.15 //y2=1.545
r1039 (  275 333 ) resistor r=56.4043 //w=0.094 //l=0.11 //layer=ply \
 //thickness=0.18 //x=76.04 //y=1.545 //x2=75.93 //y2=1.545
r1040 (  274 315 ) resistor r=56.4043 //w=0.094 //l=0.11 //layer=ply \
 //thickness=0.18 //x=64.06 //y=1.585 //x2=64.17 //y2=1.585
r1041 (  274 316 ) resistor r=56.4043 //w=0.094 //l=0.11 //layer=ply \
 //thickness=0.18 //x=64.06 //y=1.585 //x2=63.95 //y2=1.585
r1042 (  273 291 ) resistor r=56.4043 //w=0.094 //l=0.11 //layer=ply \
 //thickness=0.18 //x=53.365 //y=1.555 //x2=53.475 //y2=1.555
r1043 (  273 292 ) resistor r=56.4043 //w=0.094 //l=0.11 //layer=ply \
 //thickness=0.18 //x=53.365 //y=1.555 //x2=53.255 //y2=1.555
r1044 (  269 394 ) resistor r=152 //w=0.17 //l=0.17 //layer=licon //count=1 \
 //x=76.74 //y=4.88 //x2=76.74 //y2=4.88
r1045 (  260 390 ) resistor r=152 //w=0.17 //l=0.17 //layer=licon //count=1 \
 //x=76.71 //y=2.26 //x2=76.71 //y2=2.26
r1046 (  255 386 ) resistor r=152 //w=0.17 //l=0.17 //layer=licon //count=1 \
 //x=75.97 //y=4.88 //x2=75.97 //y2=4.88
r1047 (  246 381 ) resistor r=152 //w=0.17 //l=0.17 //layer=licon //count=1 \
 //x=75.97 //y=2.26 //x2=75.97 //y2=2.26
r1048 (  229 411 ) resistor r=23.615 //w=0.187 //l=0.345 //layer=li \
 //thickness=0.1 //x=73.34 //y=5.56 //x2=73.34 //y2=5.905
r1049 (  221 410 ) resistor r=23.615 //w=0.187 //l=0.345 //layer=li \
 //thickness=0.1 //x=72.46 //y=5.56 //x2=72.46 //y2=5.905
r1050 (  213 409 ) resistor r=23.615 //w=0.187 //l=0.345 //layer=li \
 //thickness=0.1 //x=71.58 //y=5.56 //x2=71.58 //y2=5.905
r1051 (  196 408 ) resistor r=23.615 //w=0.187 //l=0.345 //layer=li \
 //thickness=0.1 //x=68.53 //y=5.56 //x2=68.53 //y2=5.905
r1052 (  188 407 ) resistor r=23.615 //w=0.187 //l=0.345 //layer=li \
 //thickness=0.1 //x=67.65 //y=5.56 //x2=67.65 //y2=5.905
r1053 (  180 406 ) resistor r=23.615 //w=0.187 //l=0.345 //layer=li \
 //thickness=0.1 //x=66.77 //y=5.56 //x2=66.77 //y2=5.905
r1054 (  175 372 ) resistor r=152 //w=0.17 //l=0.17 //layer=licon //count=1 \
 //x=63.79 //y=4.88 //x2=63.79 //y2=4.88
r1055 (  166 368 ) resistor r=152 //w=0.17 //l=0.17 //layer=licon //count=1 \
 //x=63.76 //y=2.26 //x2=63.76 //y2=2.26
r1056 (  161 364 ) resistor r=152 //w=0.17 //l=0.17 //layer=licon //count=1 \
 //x=53.4 //y=4.88 //x2=53.4 //y2=4.88
r1057 (  152 362 ) resistor r=152 //w=0.17 //l=0.17 //layer=licon //count=1 \
 //x=53.4 //y=2.26 //x2=53.4 //y2=2.26
r1058 (  148 149 ) resistor r=0.10734 //w=0.281 //l=0.16 //layer=m2 \
 //thickness=0.36 //x=76.7 //y=4.255 //x2=76.54 //y2=4.255
r1059 (  146 149 ) resistor r=0.405534 //w=0.131 //l=0.425 //layer=m2 \
 //thickness=0.36 //x=76.115 //y=4.25 //x2=76.54 //y2=4.25
r1060 (  144 146 ) resistor r=0.10734 //w=0.281 //l=0.16 //layer=m2 \
 //thickness=0.36 //x=75.955 //y=4.275 //x2=76.115 //y2=4.275
r1061 (  144 145 ) resistor r=0.10734 //w=0.281 //l=0.16 //layer=m2 \
 //thickness=0.36 //x=75.955 //y=4.275 //x2=75.795 //y2=4.275
r1062 (  134 136 ) resistor r=0.10734 //w=0.281 //l=0.16 //layer=m2 \
 //thickness=0.36 //x=53.4 //y=4.26 //x2=53.56 //y2=4.26
r1063 (  130 142 ) resistor r=0.108234 //w=0.187 //l=0.167332 //layer=m2 \
 //thickness=0.36 //x=74.28 //y=4.25 //x2=74.12 //y2=4.265
r1064 (  130 145 ) resistor r=1.44561 //w=0.131 //l=1.515 //layer=m2 \
 //thickness=0.36 //x=74.28 //y=4.25 //x2=75.795 //y2=4.25
r1065 (  128 140 ) resistor r=1.08991 //w=0.196 //l=1.70999 //layer=m2 \
 //thickness=0.36 //x=71.02 //y=4.265 //x2=69.315 //y2=4.255
r1066 (  127 142 ) resistor r=1.84286 //w=0.187 //l=2.755 //layer=m2 \
 //thickness=0.36 //x=71.365 //y=4.265 //x2=74.12 //y2=4.265
r1067 (  127 128 ) resistor r=0.329198 //w=0.131 //l=0.345 //layer=m2 \
 //thickness=0.36 //x=71.365 //y=4.265 //x2=71.02 //y2=4.265
r1068 (  126 138 ) resistor r=0.112172 //w=0.179 //l=0.16 //layer=m2 \
 //thickness=0.36 //x=63.925 //y=4.25 //x2=63.765 //y2=4.25
r1069 (  125 140 ) resistor r=0.104578 //w=0.196 //l=0.162481 //layer=m2 \
 //thickness=0.36 //x=69.155 //y=4.25 //x2=69.315 //y2=4.255
r1070 (  125 126 ) resistor r=4.99046 //w=0.131 //l=5.23 //layer=m2 \
 //thickness=0.36 //x=69.155 //y=4.25 //x2=63.925 //y2=4.25
r1071 (  123 138 ) resistor r=3.726 //w=0.179 //l=5.34249 //layer=m2 \
 //thickness=0.36 //x=58.43 //y=4.265 //x2=63.765 //y2=4.25
r1072 (  123 124 ) resistor r=0.329198 //w=0.131 //l=0.345 //layer=m2 \
 //thickness=0.36 //x=58.43 //y=4.265 //x2=58.085 //y2=4.265
r1073 (  121 124 ) resistor r=0.1875 //w=0.17 //l=0.262393 //layer=m2 \
 //thickness=0.36 //x=57.83 //y=4.25 //x2=58.085 //y2=4.265
r1074 (  121 122 ) resistor r=0.997137 //w=0.131 //l=1.045 //layer=m2 \
 //thickness=0.36 //x=57.83 //y=4.25 //x2=56.785 //y2=4.25
r1075 (  119 122 ) resistor r=0.125 //w=0.17 //l=0.179722 //layer=m2 \
 //thickness=0.36 //x=56.615 //y=4.27 //x2=56.785 //y2=4.25
r1076 (  119 120 ) resistor r=0.367366 //w=0.131 //l=0.385 //layer=m2 \
 //thickness=0.36 //x=56.615 //y=4.27 //x2=56.23 //y2=4.27
r1077 (  117 120 ) resistor r=0.1875 //w=0.17 //l=0.264811 //layer=m2 \
 //thickness=0.36 //x=55.975 //y=4.25 //x2=56.23 //y2=4.27
r1078 (  117 136 ) resistor r=2.30439 //w=0.131 //l=2.415 //layer=m2 \
 //thickness=0.36 //x=55.975 //y=4.25 //x2=53.56 //y2=4.25
r1079 (  116 269 ) resistor r=9.3 //w=0.17 //l=0.17 //layer=mcon //count=1 \
 //x=76.74 //y=4.88 //x2=76.74 //y2=4.88
r1080 (  112 260 ) resistor r=9.3 //w=0.17 //l=0.17 //layer=mcon //count=1 \
 //x=76.71 //y=2.26 //x2=76.71 //y2=2.26
r1081 (  112 114 ) resistor r=0.0936408 //w=0.196 //l=0.125 //layer=m1 \
 //thickness=0.36 //x=76.712 //y=2.26 //x2=76.712 //y2=2.385
r1082 (  110 148 ) resistor r=4.5 //w=0.15 //l=0.15 //layer=via1 //count=1 \
 //x=76.7 //y=4.255 //x2=76.7 //y2=4.255
r1083 (  108 110 ) resistor r=0.00168464 //w=0.371 //l=0.005 //layer=m1 \
 //thickness=0.36 //x=76.652 //y=4.25 //x2=76.652 //y2=4.255
r1084 (  104 255 ) resistor r=9.3 //w=0.17 //l=0.17 //layer=mcon //count=1 \
 //x=75.97 //y=4.88 //x2=75.97 //y2=4.88
r1085 (  104 105 ) resistor r=0.103207 //w=0.196 //l=0.14 //layer=m1 \
 //thickness=0.36 //x=75.972 //y=4.88 //x2=75.972 //y2=4.74
r1086 (  101 246 ) resistor r=9.3 //w=0.17 //l=0.17 //layer=mcon //count=1 \
 //x=75.97 //y=2.26 //x2=75.97 //y2=2.26
r1087 (  99 144 ) resistor r=4.5 //w=0.15 //l=0.15 //layer=via1 //count=1 \
 //x=75.955 //y=4.275 //x2=75.955 //y2=4.275
r1088 (  97 99 ) resistor r=0.00849185 //w=0.368 //l=0.025 //layer=m1 \
 //thickness=0.36 //x=75.91 //y=4.25 //x2=75.91 //y2=4.275
r1089 (  95 142 ) resistor r=4.5 //w=0.15 //l=0.15 //layer=via1 //count=1 \
 //x=74.12 //y=4.265 //x2=74.12 //y2=4.265
r1090 (  93 95 ) resistor r=0.0049867 //w=0.376 //l=0.015 //layer=m1 \
 //thickness=0.36 //x=74.172 //y=4.25 //x2=74.172 //y2=4.265
r1091 (  91 403 ) resistor r=9.3 //w=0.17 //l=0.17 //layer=mcon //count=1 \
 //x=73.635 //y=1.19 //x2=73.635 //y2=1.19
r1092 (  89 229 ) resistor r=9.3 //w=0.17 //l=0.17 //layer=mcon //count=1 \
 //x=73.34 //y=5.56 //x2=73.34 //y2=5.56
r1093 (  86 221 ) resistor r=9.3 //w=0.17 //l=0.17 //layer=mcon //count=1 \
 //x=72.46 //y=5.56 //x2=72.46 //y2=5.56
r1094 (  84 86 ) resistor r=0.121228 //w=0.232 //l=0.225 //layer=m1 \
 //thickness=0.36 //x=72.46 //y=5.335 //x2=72.46 //y2=5.56
r1095 (  83 213 ) resistor r=9.3 //w=0.17 //l=0.17 //layer=mcon //count=1 \
 //x=71.58 //y=5.56 //x2=71.58 //y2=5.56
r1096 (  81 83 ) resistor r=0.129608 //w=0.217 //l=0.225 //layer=m1 \
 //thickness=0.36 //x=71.582 //y=5.335 //x2=71.582 //y2=5.56
r1097 (  80 140 ) resistor r=4.5 //w=0.15 //l=0.15 //layer=via1 //count=1 \
 //x=69.315 //y=4.255 //x2=69.315 //y2=4.255
r1098 (  78 80 ) resistor r=0.00164908 //w=0.379 //l=0.005 //layer=m1 \
 //thickness=0.36 //x=69.26 //y=4.25 //x2=69.26 //y2=4.255
r1099 (  76 402 ) resistor r=9.3 //w=0.17 //l=0.17 //layer=mcon //count=1 \
 //x=68.825 //y=1.19 //x2=68.825 //y2=1.19
r1100 (  74 196 ) resistor r=9.3 //w=0.17 //l=0.17 //layer=mcon //count=1 \
 //x=68.53 //y=5.56 //x2=68.53 //y2=5.56
r1101 (  71 188 ) resistor r=9.3 //w=0.17 //l=0.17 //layer=mcon //count=1 \
 //x=67.65 //y=5.56 //x2=67.65 //y2=5.56
r1102 (  69 71 ) resistor r=0.121228 //w=0.232 //l=0.225 //layer=m1 \
 //thickness=0.36 //x=67.65 //y=5.335 //x2=67.65 //y2=5.56
r1103 (  68 180 ) resistor r=9.3 //w=0.17 //l=0.17 //layer=mcon //count=1 \
 //x=66.77 //y=5.56 //x2=66.77 //y2=5.56
r1104 (  66 68 ) resistor r=0.129608 //w=0.217 //l=0.225 //layer=m1 \
 //thickness=0.36 //x=66.772 //y=5.335 //x2=66.772 //y2=5.56
r1105 (  65 175 ) resistor r=9.3 //w=0.17 //l=0.17 //layer=mcon //count=1 \
 //x=63.79 //y=4.88 //x2=63.79 //y2=4.88
r1106 (  61 166 ) resistor r=9.3 //w=0.17 //l=0.17 //layer=mcon //count=1 \
 //x=63.76 //y=2.26 //x2=63.76 //y2=2.26
r1107 (  61 63 ) resistor r=0.0936408 //w=0.196 //l=0.125 //layer=m1 \
 //thickness=0.36 //x=63.762 //y=2.26 //x2=63.762 //y2=2.385
r1108 (  58 138 ) resistor r=4.5 //w=0.15 //l=0.15 //layer=via1 //count=1 \
 //x=63.765 //y=4.25 //x2=63.765 //y2=4.25
r1109 (  56 134 ) resistor r=4.5 //w=0.15 //l=0.15 //layer=via1 //count=1 \
 //x=53.4 //y=4.26 //x2=53.4 //y2=4.26
r1110 (  54 56 ) resistor r=0.00332447 //w=0.376 //l=0.01 //layer=m1 \
 //thickness=0.36 //x=53.452 //y=4.25 //x2=53.452 //y2=4.26
r1111 (  52 161 ) resistor r=9.3 //w=0.17 //l=0.17 //layer=mcon //count=1 \
 //x=53.4 //y=4.88 //x2=53.4 //y2=4.88
r1112 (  50 152 ) resistor r=9.3 //w=0.17 //l=0.17 //layer=mcon //count=1 \
 //x=53.4 //y=2.26 //x2=53.4 //y2=2.26
r1113 (  48 116 ) resistor r=0.0878548 //w=0.228 //l=0.159295 //layer=m1 \
 //thickness=0.36 //x=76.71 //y=4.735 //x2=76.74 //y2=4.88
r1114 (  47 110 ) resistor r=0.0909648 //w=0.371 //l=0.186762 //layer=m1 \
 //thickness=0.36 //x=76.71 //y=4.415 //x2=76.652 //y2=4.255
r1115 (  47 48 ) resistor r=0.305344 //w=0.131 //l=0.32 //layer=m1 \
 //thickness=0.36 //x=76.71 //y=4.415 //x2=76.71 //y2=4.735
r1116 (  46 108 ) resistor r=0.0892801 //w=0.371 //l=0.1817 //layer=m1 \
 //thickness=0.36 //x=76.71 //y=4.095 //x2=76.652 //y2=4.25
r1117 (  46 114 ) resistor r=1.63168 //w=0.131 //l=1.71 //layer=m1 \
 //thickness=0.36 //x=76.71 //y=4.095 //x2=76.71 //y2=2.385
r1118 (  43 99 ) resistor r=0.0908536 //w=0.368 //l=0.187617 //layer=m1 \
 //thickness=0.36 //x=75.97 //y=4.435 //x2=75.91 //y2=4.275
r1119 (  43 105 ) resistor r=0.291031 //w=0.131 //l=0.305 //layer=m1 \
 //thickness=0.36 //x=75.97 //y=4.435 //x2=75.97 //y2=4.74
r1120 (  42 97 ) resistor r=0.0823617 //w=0.368 //l=0.16225 //layer=m1 \
 //thickness=0.36 //x=75.97 //y=4.115 //x2=75.91 //y2=4.25
r1121 (  41 101 ) resistor r=0.0933015 //w=0.201 //l=0.125 //layer=m1 \
 //thickness=0.36 //x=75.97 //y=2.385 //x2=75.97 //y2=2.26
r1122 (  41 42 ) resistor r=1.65076 //w=0.131 //l=1.73 //layer=m1 \
 //thickness=0.36 //x=75.97 //y=2.385 //x2=75.97 //y2=4.115
r1123 (  39 95 ) resistor r=0.0911593 //w=0.376 //l=0.184174 //layer=m1 \
 //thickness=0.36 //x=74.12 //y=4.425 //x2=74.172 //y2=4.265
r1124 (  39 40 ) resistor r=0.787214 //w=0.131 //l=0.825 //layer=m1 \
 //thickness=0.36 //x=74.12 //y=4.425 //x2=74.12 //y2=5.25
r1125 (  38 93 ) resistor r=0.0861726 //w=0.376 //l=0.169012 //layer=m1 \
 //thickness=0.36 //x=74.12 //y=4.105 //x2=74.172 //y2=4.25
r1126 (  37 38 ) resistor r=2.07538 //w=0.131 //l=2.175 //layer=m1 \
 //thickness=0.36 //x=74.12 //y=1.93 //x2=74.12 //y2=4.105
r1127 (  35 37 ) resistor r=0.0698411 //w=0.17 //l=0.120208 //layer=m1 \
 //thickness=0.36 //x=74.035 //y=1.845 //x2=74.12 //y2=1.93
r1128 (  35 36 ) resistor r=0.300573 //w=0.131 //l=0.315 //layer=m1 \
 //thickness=0.36 //x=74.035 //y=1.845 //x2=73.72 //y2=1.845
r1129 (  34 36 ) resistor r=0.0698411 //w=0.17 //l=0.120208 //layer=m1 \
 //thickness=0.36 //x=73.635 //y=1.76 //x2=73.72 //y2=1.845
r1130 (  33 91 ) resistor r=0.0717383 //w=0.224 //l=0.115 //layer=m1 \
 //thickness=0.36 //x=73.635 //y=1.305 //x2=73.635 //y2=1.19
r1131 (  33 34 ) resistor r=0.43416 //w=0.131 //l=0.455 //layer=m1 \
 //thickness=0.36 //x=73.635 //y=1.305 //x2=73.635 //y2=1.76
r1132 (  32 87 ) resistor r=0.0675342 //w=0.23 //l=0.115 //layer=m1 \
 //thickness=0.36 //x=73.455 //y=5.335 //x2=73.34 //y2=5.335
r1133 (  31 40 ) resistor r=0.0698411 //w=0.17 //l=0.120208 //layer=m1 \
 //thickness=0.36 //x=74.035 //y=5.335 //x2=74.12 //y2=5.25
r1134 (  31 32 ) resistor r=0.553435 //w=0.131 //l=0.58 //layer=m1 \
 //thickness=0.36 //x=74.035 //y=5.335 //x2=73.455 //y2=5.335
r1135 (  30 89 ) resistor r=0.00118313 //w=0.23 //layer=m1 //thickness=0.36 \
 //x=73.34 //y=5.56 //x2=73.34 //y2=5.56
r1136 (  29 87 ) resistor r=0.002872 //w=0.34 //l=0.085 //layer=m1 \
 //thickness=0.36 //x=73.34 //y=5.42 //x2=73.34 //y2=5.335
r1137 (  29 30 ) resistor r=0.091623 //w=0.191 //l=0.14 //layer=m1 \
 //thickness=0.36 //x=73.34 //y=5.42 //x2=73.34 //y2=5.56
r1138 (  28 84 ) resistor r=0.0262263 //w=0.232 //l=0.12 //layer=m1 \
 //thickness=0.36 //x=72.58 //y=5.335 //x2=72.46 //y2=5.335
r1139 (  27 87 ) resistor r=0.0675342 //w=0.23 //l=0.115 //layer=m1 \
 //thickness=0.36 //x=73.225 //y=5.335 //x2=73.34 //y2=5.335
r1140 (  27 28 ) resistor r=0.615458 //w=0.131 //l=0.645 //layer=m1 \
 //thickness=0.36 //x=73.225 //y=5.335 //x2=72.58 //y2=5.335
r1141 (  26 81 ) resistor r=0.0222262 //w=0.217 //l=0.118 //layer=m1 \
 //thickness=0.36 //x=71.7 //y=5.335 //x2=71.582 //y2=5.335
r1142 (  25 84 ) resistor r=0.0262263 //w=0.232 //l=0.12 //layer=m1 \
 //thickness=0.36 //x=72.34 //y=5.335 //x2=72.46 //y2=5.335
r1143 (  25 26 ) resistor r=0.610687 //w=0.131 //l=0.64 //layer=m1 \
 //thickness=0.36 //x=72.34 //y=5.335 //x2=71.7 //y2=5.335
r1144 (  23 80 ) resistor r=0.0912814 //w=0.379 //l=0.183303 //layer=m1 \
 //thickness=0.36 //x=69.31 //y=4.415 //x2=69.26 //y2=4.255
r1145 (  23 24 ) resistor r=0.796756 //w=0.131 //l=0.835 //layer=m1 \
 //thickness=0.36 //x=69.31 //y=4.415 //x2=69.31 //y2=5.25
r1146 (  22 78 ) resistor r=0.0896323 //w=0.379 //l=0.178255 //layer=m1 \
 //thickness=0.36 //x=69.31 //y=4.095 //x2=69.26 //y2=4.25
r1147 (  21 22 ) resistor r=2.06584 //w=0.131 //l=2.165 //layer=m1 \
 //thickness=0.36 //x=69.31 //y=1.93 //x2=69.31 //y2=4.095
r1148 (  19 21 ) resistor r=0.0698411 //w=0.17 //l=0.120208 //layer=m1 \
 //thickness=0.36 //x=69.225 //y=1.845 //x2=69.31 //y2=1.93
r1149 (  19 20 ) resistor r=0.300573 //w=0.131 //l=0.315 //layer=m1 \
 //thickness=0.36 //x=69.225 //y=1.845 //x2=68.91 //y2=1.845
r1150 (  18 20 ) resistor r=0.0698411 //w=0.17 //l=0.120208 //layer=m1 \
 //thickness=0.36 //x=68.825 //y=1.76 //x2=68.91 //y2=1.845
r1151 (  17 76 ) resistor r=0.0717383 //w=0.224 //l=0.115 //layer=m1 \
 //thickness=0.36 //x=68.825 //y=1.305 //x2=68.825 //y2=1.19
r1152 (  17 18 ) resistor r=0.43416 //w=0.131 //l=0.455 //layer=m1 \
 //thickness=0.36 //x=68.825 //y=1.305 //x2=68.825 //y2=1.76
r1153 (  16 72 ) resistor r=0.0675342 //w=0.23 //l=0.115 //layer=m1 \
 //thickness=0.36 //x=68.645 //y=5.335 //x2=68.53 //y2=5.335
r1154 (  15 24 ) resistor r=0.0698411 //w=0.17 //l=0.120208 //layer=m1 \
 //thickness=0.36 //x=69.225 //y=5.335 //x2=69.31 //y2=5.25
r1155 (  15 16 ) resistor r=0.553435 //w=0.131 //l=0.58 //layer=m1 \
 //thickness=0.36 //x=69.225 //y=5.335 //x2=68.645 //y2=5.335
r1156 (  14 74 ) resistor r=0.00118313 //w=0.23 //layer=m1 //thickness=0.36 \
 //x=68.53 //y=5.56 //x2=68.53 //y2=5.56
r1157 (  13 72 ) resistor r=0.002872 //w=0.34 //l=0.085 //layer=m1 \
 //thickness=0.36 //x=68.53 //y=5.42 //x2=68.53 //y2=5.335
r1158 (  13 14 ) resistor r=0.091623 //w=0.191 //l=0.14 //layer=m1 \
 //thickness=0.36 //x=68.53 //y=5.42 //x2=68.53 //y2=5.56
r1159 (  12 69 ) resistor r=0.0262263 //w=0.232 //l=0.12 //layer=m1 \
 //thickness=0.36 //x=67.77 //y=5.335 //x2=67.65 //y2=5.335
r1160 (  11 72 ) resistor r=0.0675342 //w=0.23 //l=0.115 //layer=m1 \
 //thickness=0.36 //x=68.415 //y=5.335 //x2=68.53 //y2=5.335
r1161 (  11 12 ) resistor r=0.615458 //w=0.131 //l=0.645 //layer=m1 \
 //thickness=0.36 //x=68.415 //y=5.335 //x2=67.77 //y2=5.335
r1162 (  10 66 ) resistor r=0.0222262 //w=0.217 //l=0.118 //layer=m1 \
 //thickness=0.36 //x=66.89 //y=5.335 //x2=66.772 //y2=5.335
r1163 (  9 69 ) resistor r=0.0262263 //w=0.232 //l=0.12 //layer=m1 \
 //thickness=0.36 //x=67.53 //y=5.335 //x2=67.65 //y2=5.335
r1164 (  9 10 ) resistor r=0.610687 //w=0.131 //l=0.64 //layer=m1 \
 //thickness=0.36 //x=67.53 //y=5.335 //x2=66.89 //y2=5.335
r1165 (  8 65 ) resistor r=0.0878548 //w=0.228 //l=0.159295 //layer=m1 \
 //thickness=0.36 //x=63.76 //y=4.735 //x2=63.79 //y2=4.88
r1166 (  7 58 ) resistor r=0.0912814 //w=0.379 //l=0.183303 //layer=m1 \
 //thickness=0.36 //x=63.76 //y=4.41 //x2=63.71 //y2=4.25
r1167 (  7 8 ) resistor r=0.310115 //w=0.131 //l=0.325 //layer=m1 \
 //thickness=0.36 //x=63.76 //y=4.41 //x2=63.76 //y2=4.735
r1168 (  6 58 ) resistor r=0.0912814 //w=0.379 //l=0.183303 //layer=m1 \
 //thickness=0.36 //x=63.76 //y=4.09 //x2=63.71 //y2=4.25
r1169 (  6 63 ) resistor r=1.62691 //w=0.131 //l=1.705 //layer=m1 \
 //thickness=0.36 //x=63.76 //y=4.09 //x2=63.76 //y2=2.385
r1170 (  4 52 ) resistor r=0.0760407 //w=0.238 //l=0.125 //layer=m1 \
 //thickness=0.36 //x=53.4 //y=4.755 //x2=53.4 //y2=4.88
r1171 (  3 56 ) resistor r=0.0911593 //w=0.376 //l=0.184174 //layer=m1 \
 //thickness=0.36 //x=53.4 //y=4.42 //x2=53.452 //y2=4.26
r1172 (  3 4 ) resistor r=0.319656 //w=0.131 //l=0.335 //layer=m1 \
 //thickness=0.36 //x=53.4 //y=4.42 //x2=53.4 //y2=4.755
r1173 (  2 54 ) resistor r=0.0878349 //w=0.376 //l=0.174069 //layer=m1 \
 //thickness=0.36 //x=53.4 //y=4.1 //x2=53.452 //y2=4.25
r1174 (  1 50 ) resistor r=0.0719237 //w=0.222 //l=0.115 //layer=m1 \
 //thickness=0.36 //x=53.4 //y=2.375 //x2=53.4 //y2=2.26
r1175 (  1 2 ) resistor r=1.64599 //w=0.131 //l=1.725 //layer=m1 \
 //thickness=0.36 //x=53.4 //y=2.375 //x2=53.4 //y2=4.1
ends PM_TMRDFFRNQX1\%noxref_14

subckt PM_TMRDFFRNQX1\%noxref_15 ( 1 2 3 4 7 12 13 15 16 18 19 20 21 22 23 24 \
 25 27 30 31 33 34 35 36 38 39 40 42 43 47 52 53 55 56 58 59 60 61 62 63 64 65 \
 66 67 68 69 70 76 81 82 85 87 90 98 100 103 106 112 115 118 121 122 126 127 \
 130 132 135 139 147 152 155 160 162 164 166 168 169 170 171 172 174 176 177 \
 179 180 182 183 184 186 189 193 204 205 214 215 218 227 232 240 257 266 271 \
 279 287 304 313 318 326 343 352 357 366 372 377 382 383 384 385 386 387 388 \
 389 390 391 392 393 394 395 396 397 398 399 403 404 405 410 412 415 416 420 \
 421 422 427 429 432 433 434 435 436 437 441 443 446 447 451 452 453 454 455 \
 457 463 464 465 466 470 471 472 473 477 479 482 483 484 485 489 490 491 492 \
 496 498 504 505 507 508 513 517 518 523 532 544 557 560 561 562 566 567 568 \
 569 570 571 572 )
c1309 ( 562 0 ) capacitor c=0.00878249f //x=63.87 //y=1.085
c1310 ( 561 0 ) capacitor c=0.00885916f //x=60.495 //y=1.095
c1311 ( 560 0 ) capacitor c=0.00878249f //x=50.92 //y=1.085
c1312 ( 557 0 ) capacitor c=0.0692896f //x=82.63 //y=4.885
c1313 ( 544 0 ) capacitor c=0.0575534f //x=78.93 //y=2.26
c1314 ( 532 0 ) capacitor c=0.0682508f //x=63.02 //y=4.88
c1315 ( 523 0 ) capacitor c=0.0710579f //x=55.62 //y=4.88
c1316 ( 518 0 ) capacitor c=0.0278202f //x=55.62 //y=2.095
c1317 ( 517 0 ) capacitor c=0.0479324f //x=55.62 //y=2.26
c1318 ( 513 0 ) capacitor c=0.0710579f //x=47.48 //y=4.88
c1319 ( 508 0 ) capacitor c=0.0278202f //x=47.48 //y=2.095
c1320 ( 507 0 ) capacitor c=0.0479125f //x=47.48 //y=2.26
c1321 ( 505 0 ) capacitor c=0.0344584f //x=82.965 //y=1.39
c1322 ( 504 0 ) capacitor c=0.0188421f //x=82.965 //y=1.045
c1323 ( 498 0 ) capacitor c=0.0141798f //x=82.81 //y=1.545
c1324 ( 496 0 ) capacitor c=0.0160622f //x=82.81 //y=0.89
c1325 ( 492 0 ) capacitor c=0.103881f //x=82.435 //y=2.095
c1326 ( 491 0 ) capacitor c=0.0227978f //x=82.435 //y=1.7
c1327 ( 490 0 ) capacitor c=0.0234352f //x=82.435 //y=1.39
c1328 ( 489 0 ) capacitor c=0.0200371f //x=82.435 //y=1.045
c1329 ( 485 0 ) capacitor c=0.0318956f //x=79.635 //y=1.39
c1330 ( 484 0 ) capacitor c=0.0186809f //x=79.635 //y=1.045
c1331 ( 483 0 ) capacitor c=0.0625156f //x=79.275 //y=4.975
c1332 ( 482 0 ) capacitor c=0.0375163f //x=79.565 //y=4.975
c1333 ( 479 0 ) capacitor c=0.0157936f //x=79.48 //y=1.545
c1334 ( 477 0 ) capacitor c=0.0158553f //x=79.48 //y=0.89
c1335 ( 473 0 ) capacitor c=0.0302441f //x=79.105 //y=2.095
c1336 ( 472 0 ) capacitor c=0.0238107f //x=79.105 //y=1.7
c1337 ( 471 0 ) capacitor c=0.0234359f //x=79.105 //y=1.39
c1338 ( 470 0 ) capacitor c=0.0199332f //x=79.105 //y=1.045
c1339 ( 466 0 ) capacitor c=0.0612936f //x=66.625 //y=4.97
c1340 ( 465 0 ) capacitor c=0.0376642f //x=66.915 //y=4.97
c1341 ( 464 0 ) capacitor c=0.0346489f //x=66.58 //y=1.4
c1342 ( 463 0 ) capacitor c=0.018692f //x=66.58 //y=1.055
c1343 ( 457 0 ) capacitor c=0.0137077f //x=66.425 //y=1.555
c1344 ( 455 0 ) capacitor c=0.0158585f //x=66.425 //y=0.9
c1345 ( 454 0 ) capacitor c=0.101012f //x=66.05 //y=2.095
c1346 ( 453 0 ) capacitor c=0.0229444f //x=66.05 //y=1.71
c1347 ( 452 0 ) capacitor c=0.0234359f //x=66.05 //y=1.4
c1348 ( 451 0 ) capacitor c=0.019815f //x=66.05 //y=1.055
c1349 ( 447 0 ) capacitor c=0.0318956f //x=63.355 //y=1.39
c1350 ( 446 0 ) capacitor c=0.0186809f //x=63.355 //y=1.045
c1351 ( 443 0 ) capacitor c=0.0141821f //x=63.2 //y=1.545
c1352 ( 441 0 ) capacitor c=0.0158553f //x=63.2 //y=0.89
c1353 ( 437 0 ) capacitor c=0.0854195f //x=62.825 //y=2.095
c1354 ( 436 0 ) capacitor c=0.0229235f //x=62.825 //y=1.7
c1355 ( 435 0 ) capacitor c=0.0234359f //x=62.825 //y=1.39
c1356 ( 434 0 ) capacitor c=0.0198759f //x=62.825 //y=1.045
c1357 ( 433 0 ) capacitor c=0.0443175f //x=56.14 //y=1.44
c1358 ( 432 0 ) capacitor c=0.0199703f //x=56.14 //y=1.095
c1359 ( 429 0 ) capacitor c=0.0162526f //x=55.985 //y=1.595
c1360 ( 427 0 ) capacitor c=0.0157807f //x=55.985 //y=0.94
c1361 ( 422 0 ) capacitor c=0.0220935f //x=55.61 //y=1.75
c1362 ( 421 0 ) capacitor c=0.0207489f //x=55.61 //y=1.44
c1363 ( 420 0 ) capacitor c=0.0194091f //x=55.61 //y=1.095
c1364 ( 416 0 ) capacitor c=0.0443175f //x=48 //y=1.44
c1365 ( 415 0 ) capacitor c=0.0199703f //x=48 //y=1.095
c1366 ( 412 0 ) capacitor c=0.0162526f //x=47.845 //y=1.595
c1367 ( 410 0 ) capacitor c=0.0157807f //x=47.845 //y=0.94
c1368 ( 405 0 ) capacitor c=0.0220935f //x=47.47 //y=1.75
c1369 ( 404 0 ) capacitor c=0.0207489f //x=47.47 //y=1.44
c1370 ( 403 0 ) capacitor c=0.0194091f //x=47.47 //y=1.095
c1371 ( 399 0 ) capacitor c=0.111167f //x=82.96 //y=6.205
c1372 ( 398 0 ) capacitor c=0.154978f //x=82.52 //y=6.205
c1373 ( 397 0 ) capacitor c=0.110282f //x=79.64 //y=6.205
c1374 ( 396 0 ) capacitor c=0.155219f //x=79.2 //y=6.205
c1375 ( 395 0 ) capacitor c=0.110208f //x=66.99 //y=6.2
c1376 ( 394 0 ) capacitor c=0.158957f //x=66.55 //y=6.2
c1377 ( 393 0 ) capacitor c=0.110369f //x=63.36 //y=6.2
c1378 ( 392 0 ) capacitor c=0.154619f //x=62.92 //y=6.2
c1379 ( 391 0 ) capacitor c=0.159671f //x=55.8 //y=6.2
c1380 ( 390 0 ) capacitor c=0.110208f //x=55.36 //y=6.2
c1381 ( 389 0 ) capacitor c=0.159671f //x=47.66 //y=6.2
c1382 ( 388 0 ) capacitor c=0.110208f //x=47.22 //y=6.2
c1383 ( 377 0 ) capacitor c=0.0156727f //x=82.63 //y=4.62
c1384 ( 372 0 ) capacitor c=0.00133484f //x=82.63 //y=2.26
c1385 ( 366 0 ) capacitor c=0.0126258f //x=78.93 //y=4.62
c1386 ( 357 0 ) capacitor c=8.37642e-19 //x=78.93 //y=2.26
c1387 ( 352 0 ) capacitor c=0.0014751f //x=66.35 //y=4.88
c1388 ( 343 0 ) capacitor c=0.0012618f //x=66.35 //y=2.26
c1389 ( 326 0 ) capacitor c=0.0322017f //x=64.02 //y=5.56
c1390 ( 318 0 ) capacitor c=0.0290143f //x=63.14 //y=5.56
c1391 ( 313 0 ) capacitor c=8.13425e-19 //x=63.02 //y=4.88
c1392 ( 304 0 ) capacitor c=7.85889e-19 //x=63.02 //y=2.26
c1393 ( 287 0 ) capacitor c=0.0292634f //x=60.39 //y=5.56
c1394 ( 279 0 ) capacitor c=0.029137f //x=59.51 //y=5.56
c1395 ( 271 0 ) capacitor c=0.0278099f //x=58.63 //y=5.56
c1396 ( 266 0 ) capacitor c=7.7417e-19 //x=55.62 //y=4.88
c1397 ( 257 0 ) capacitor c=0.00101179f //x=55.62 //y=2.26
c1398 ( 240 0 ) capacitor c=0.0322017f //x=51.07 //y=5.56
c1399 ( 232 0 ) capacitor c=0.0290186f //x=50.19 //y=5.56
c1400 ( 227 0 ) capacitor c=7.7417e-19 //x=47.48 //y=4.88
c1401 ( 218 0 ) capacitor c=0.00101179f //x=47.48 //y=2.26
c1402 ( 215 0 ) capacitor c=0.071029f //x=82.475 //y=4.64
c1403 ( 214 0 ) capacitor c=0.00642399f //x=82.635 //y=4.64
c1404 ( 205 0 ) capacitor c=6.92089e-19 //x=64.66 //y=3.515
c1405 ( 204 0 ) capacitor c=0.00937613f //x=64.34 //y=3.515
c1406 ( 193 0 ) capacitor c=6.30469e-19 //x=47.645 //y=3.525
c1407 ( 189 0 ) capacitor c=0.00526197f //x=79.095 //y=4.62
c1408 ( 186 0 ) capacitor c=0.0560706f //x=73.6 //y=3.48
c1409 ( 184 0 ) capacitor c=0.0176351f //x=73 //y=3.51
c1410 ( 183 0 ) capacitor c=0.0467586f //x=70.935 //y=3.495
c1411 ( 182 0 ) capacitor c=0.00605681f //x=71.365 //y=3.495
c1412 ( 180 0 ) capacitor c=0.0193753f //x=66.195 //y=3.51
c1413 ( 179 0 ) capacitor c=4.64216e-19 //x=63.18 //y=3.51
c1414 ( 177 0 ) capacitor c=0.0234213f //x=61.335 //y=3.51
c1415 ( 176 0 ) capacitor c=0.0189392f //x=62.86 //y=3.51
c1416 ( 174 0 ) capacitor c=0.00228713f //x=58.43 //y=3.495
c1417 ( 172 0 ) capacitor c=0.0164618f //x=57.83 //y=3.51
c1418 ( 171 0 ) capacitor c=0.00364857f //x=56.15 //y=3.5
c1419 ( 170 0 ) capacitor c=0.00615936f //x=56.58 //y=3.5
c1420 ( 169 0 ) capacitor c=0.0110197f //x=51.71 //y=3.51
c1421 ( 168 0 ) capacitor c=0.0537541f //x=55.46 //y=3.51
c1422 ( 166 0 ) capacitor c=0.00216906f //x=50.28 //y=3.48
c1423 ( 164 0 ) capacitor c=0.0156036f //x=49.68 //y=3.51
c1424 ( 162 0 ) capacitor c=0.00631297f //x=48.44 //y=3.48
c1425 ( 160 0 ) capacitor c=0.00303676f //x=47.84 //y=3.51
c1426 ( 155 0 ) capacitor c=0.0127073f //x=82.63 //y=4.62
c1427 ( 152 0 ) capacitor c=0.013034f //x=78.93 //y=4.62
c1428 ( 147 0 ) capacitor c=0.015329f //x=78.93 //y=3.51
c1429 ( 139 0 ) capacitor c=0.0170693f //x=66.35 //y=3.51
c1430 ( 135 0 ) capacitor c=0.016938f //x=64.5 //y=3.51
c1431 ( 132 0 ) capacitor c=0.0108728f //x=64.06 //y=1.18
c1432 ( 130 0 ) capacitor c=5.78613e-19 //x=64.02 //y=5.56
c1433 ( 127 0 ) capacitor c=0.010659f //x=64.02 //y=5.38
c1434 ( 126 0 ) capacitor c=0.00837128f //x=63.14 //y=5.56
c1435 ( 122 0 ) capacitor c=0.0268056f //x=63.022 //y=4.74
c1436 ( 121 0 ) capacitor c=0.00611114f //x=63.02 //y=4.88
c1437 ( 118 0 ) capacitor c=0.00463527f //x=63.02 //y=2.26
c1438 ( 115 0 ) capacitor c=0.0161834f //x=63.02 //y=3.51
c1439 ( 112 0 ) capacitor c=0.0170515f //x=61.17 //y=3.51
c1440 ( 106 0 ) capacitor c=0.00112339f //x=60.39 //y=5.335
c1441 ( 103 0 ) capacitor c=0.00758139f //x=59.51 //y=5.335
c1442 ( 100 0 ) capacitor c=0.0111234f //x=58.632 //y=5.335
c1443 ( 98 0 ) capacitor c=0.0148558f //x=55.62 //y=3.51
c1444 ( 90 0 ) capacitor c=0.0158241f //x=51.55 //y=3.51
c1445 ( 87 0 ) capacitor c=0.0112415f //x=51.11 //y=1.18
c1446 ( 85 0 ) capacitor c=5.78613e-19 //x=51.07 //y=5.56
c1447 ( 82 0 ) capacitor c=0.0108004f //x=51.07 //y=5.38
c1448 ( 81 0 ) capacitor c=0.00923159f //x=50.19 //y=5.56
c1449 ( 76 0 ) capacitor c=0.0150828f //x=47.48 //y=3.51
c1450 ( 70 0 ) capacitor c=0.0782518f //x=82.63 //y=4.475
c1451 ( 69 0 ) capacitor c=0.00894425f //x=82.63 //y=2.385
c1452 ( 68 0 ) capacitor c=0.0180081f //x=78.93 //y=4.46
c1453 ( 67 0 ) capacitor c=0.013759f //x=78.93 //y=3.67
c1454 ( 66 0 ) capacitor c=0.0264415f //x=78.93 //y=3.35
c1455 ( 65 0 ) capacitor c=0.00530172f //x=78.93 //y=2.375
c1456 ( 64 0 ) capacitor c=0.0382053f //x=66.35 //y=4.755
c1457 ( 63 0 ) capacitor c=0.0145929f //x=66.35 //y=3.675
c1458 ( 62 0 ) capacitor c=0.0298948f //x=66.35 //y=3.355
c1459 ( 61 0 ) capacitor c=0.00495287f //x=66.35 //y=2.375
c1460 ( 60 0 ) capacitor c=0.0419718f //x=64.5 //y=5.295
c1461 ( 59 0 ) capacitor c=0.0134337f //x=64.5 //y=3.675
c1462 ( 58 0 ) capacitor c=0.0388571f //x=64.5 //y=3.355
c1463 ( 56 0 ) capacitor c=0.00458458f //x=64.145 //y=1.835
c1464 ( 55 0 ) capacitor c=0.0120653f //x=64.415 //y=1.835
c1465 ( 53 0 ) capacitor c=0.0116495f //x=64.415 //y=5.38
c1466 ( 52 0 ) capacitor c=0.0134247f //x=64.06 //y=1.75
c1467 ( 47 0 ) capacitor c=0.013452f //x=63.905 //y=5.38
c1468 ( 43 0 ) capacitor c=0.0131563f //x=63.02 //y=3.67
c1469 ( 42 0 ) capacitor c=0.02559f //x=63.02 //y=3.35
c1470 ( 40 0 ) capacitor c=0.0424466f //x=61.17 //y=5.25
c1471 ( 39 0 ) capacitor c=0.013011f //x=61.17 //y=3.67
c1472 ( 38 0 ) capacitor c=0.0363667f //x=61.17 //y=3.35
c1473 ( 36 0 ) capacitor c=0.00493487f //x=60.77 //y=1.845
c1474 ( 35 0 ) capacitor c=0.0128695f //x=61.085 //y=1.845
c1475 ( 34 0 ) capacitor c=0.0136833f //x=60.685 //y=1.76
c1476 ( 33 0 ) capacitor c=0.0107052f //x=60.685 //y=1.305
c1477 ( 31 0 ) capacitor c=0.0237967f //x=61.085 //y=5.335
c1478 ( 30 0 ) capacitor c=0.00906713f //x=60.39 //y=5.56
c1479 ( 27 0 ) capacitor c=0.019444f //x=60.275 //y=5.335
c1480 ( 25 0 ) capacitor c=0.0152313f //x=59.39 //y=5.335
c1481 ( 24 0 ) capacitor c=0.0286235f //x=55.62 //y=4.75
c1482 ( 23 0 ) capacitor c=0.0129401f //x=55.62 //y=3.67
c1483 ( 22 0 ) capacitor c=0.0229166f //x=55.62 //y=3.35
c1484 ( 21 0 ) capacitor c=0.00556102f //x=55.62 //y=2.375
c1485 ( 20 0 ) capacitor c=0.0404678f //x=51.55 //y=5.295
c1486 ( 19 0 ) capacitor c=0.0138107f //x=51.55 //y=3.685
c1487 ( 18 0 ) capacitor c=0.0389638f //x=51.55 //y=3.365
c1488 ( 16 0 ) capacitor c=0.00466468f //x=51.195 //y=1.835
c1489 ( 15 0 ) capacitor c=0.0120832f //x=51.465 //y=1.835
c1490 ( 13 0 ) capacitor c=0.0112162f //x=51.465 //y=5.38
c1491 ( 12 0 ) capacitor c=0.0134844f //x=51.11 //y=1.75
c1492 ( 7 0 ) capacitor c=0.0134407f //x=50.955 //y=5.38
c1493 ( 4 0 ) capacitor c=0.0268989f //x=47.48 //y=4.75
c1494 ( 3 0 ) capacitor c=0.0128618f //x=47.48 //y=3.685
c1495 ( 2 0 ) capacitor c=0.0232096f //x=47.48 //y=3.365
c1496 ( 1 0 ) capacitor c=0.00550278f //x=47.48 //y=2.375
r1497 (  555 557 ) resistor r=22.7554 //w=0.233 //l=0.11 //layer=ply \
 //thickness=0.18 //x=82.52 //y=4.885 //x2=82.63 //y2=4.885
r1498 (  530 532 ) resistor r=20.6867 //w=0.233 //l=0.1 //layer=ply \
 //thickness=0.18 //x=62.92 //y=4.88 //x2=63.02 //y2=4.88
r1499 (  517 518 ) resistor r=52.7279 //w=0.214 //l=0.165 //layer=ply \
 //thickness=0.18 //x=55.62 //y=2.26 //x2=55.62 //y2=2.095
r1500 (  507 508 ) resistor r=52.7279 //w=0.214 //l=0.165 //layer=ply \
 //thickness=0.18 //x=47.48 //y=2.26 //x2=47.48 //y2=2.095
r1501 (  505 559 ) resistor r=45.1352 //w=0.168 //l=0.173853 //layer=ply \
 //thickness=0.18 //x=82.965 //y=1.39 //x2=82.925 //y2=1.545
r1502 (  504 558 ) resistor r=45.1352 //w=0.168 //l=0.173853 //layer=ply \
 //thickness=0.18 //x=82.965 //y=1.045 //x2=82.925 //y2=0.89
r1503 (  504 505 ) resistor r=176.904 //w=0.094 //l=0.345 //layer=ply \
 //thickness=0.18 //x=82.965 //y=1.045 //x2=82.965 //y2=1.39
r1504 (  501 557 ) resistor r=68.2661 //w=0.233 //l=0.404166 //layer=ply \
 //thickness=0.18 //x=82.96 //y=5.05 //x2=82.63 //y2=4.885
r1505 (  499 554 ) resistor r=10.701 //w=0.21 //l=0.115 //layer=ply \
 //thickness=0.18 //x=82.59 //y=1.545 //x2=82.475 //y2=1.545
r1506 (  498 559 ) resistor r=5.52526 //w=0.168 //l=0.115 //layer=ply \
 //thickness=0.18 //x=82.81 //y=1.545 //x2=82.925 //y2=1.545
r1507 (  497 553 ) resistor r=5.52526 //w=0.168 //l=0.115 //layer=ply \
 //thickness=0.18 //x=82.59 //y=0.89 //x2=82.475 //y2=0.89
r1508 (  496 558 ) resistor r=5.52526 //w=0.168 //l=0.115 //layer=ply \
 //thickness=0.18 //x=82.81 //y=0.89 //x2=82.925 //y2=0.89
r1509 (  496 497 ) resistor r=112.809 //w=0.094 //l=0.22 //layer=ply \
 //thickness=0.18 //x=82.81 //y=0.89 //x2=82.59 //y2=0.89
r1510 (  493 555 ) resistor r=13.0941 //w=0.233 //l=0.165 //layer=ply \
 //thickness=0.18 //x=82.52 //y=5.05 //x2=82.52 //y2=4.885
r1511 (  492 552 ) resistor r=34.8111 //w=0.27 //l=0.264953 //layer=ply \
 //thickness=0.18 //x=82.435 //y=2.095 //x2=82.63 //y2=2.26
r1512 (  491 554 ) resistor r=39.5823 //w=0.21 //l=0.173853 //layer=ply \
 //thickness=0.18 //x=82.435 //y=1.7 //x2=82.475 //y2=1.545
r1513 (  491 492 ) resistor r=202.543 //w=0.094 //l=0.395 //layer=ply \
 //thickness=0.18 //x=82.435 //y=1.7 //x2=82.435 //y2=2.095
r1514 (  490 554 ) resistor r=39.5823 //w=0.21 //l=0.173853 //layer=ply \
 //thickness=0.18 //x=82.435 //y=1.39 //x2=82.475 //y2=1.545
r1515 (  489 553 ) resistor r=45.1352 //w=0.168 //l=0.173853 //layer=ply \
 //thickness=0.18 //x=82.435 //y=1.045 //x2=82.475 //y2=0.89
r1516 (  489 490 ) resistor r=176.904 //w=0.094 //l=0.345 //layer=ply \
 //thickness=0.18 //x=82.435 //y=1.045 //x2=82.435 //y2=1.39
r1517 (  485 550 ) resistor r=45.1352 //w=0.168 //l=0.173853 //layer=ply \
 //thickness=0.18 //x=79.635 //y=1.39 //x2=79.595 //y2=1.545
r1518 (  484 549 ) resistor r=45.1352 //w=0.168 //l=0.173853 //layer=ply \
 //thickness=0.18 //x=79.635 //y=1.045 //x2=79.595 //y2=0.89
r1519 (  484 485 ) resistor r=176.904 //w=0.094 //l=0.345 //layer=ply \
 //thickness=0.18 //x=79.635 //y=1.045 //x2=79.635 //y2=1.39
r1520 (  482 486 ) resistor r=26.9307 //w=0.15 //l=0.106066 //layer=ply \
 //thickness=0.18 //x=79.565 //y=4.975 //x2=79.64 //y2=5.05
r1521 (  482 483 ) resistor r=148.702 //w=0.094 //l=0.29 //layer=ply \
 //thickness=0.18 //x=79.565 //y=4.975 //x2=79.275 //y2=4.975
r1522 (  480 548 ) resistor r=10.701 //w=0.21 //l=0.115 //layer=ply \
 //thickness=0.18 //x=79.26 //y=1.545 //x2=79.145 //y2=1.545
r1523 (  479 550 ) resistor r=5.52526 //w=0.168 //l=0.115 //layer=ply \
 //thickness=0.18 //x=79.48 //y=1.545 //x2=79.595 //y2=1.545
r1524 (  478 547 ) resistor r=5.52526 //w=0.168 //l=0.115 //layer=ply \
 //thickness=0.18 //x=79.26 //y=0.89 //x2=79.145 //y2=0.89
r1525 (  477 549 ) resistor r=5.52526 //w=0.168 //l=0.115 //layer=ply \
 //thickness=0.18 //x=79.48 //y=0.89 //x2=79.595 //y2=0.89
r1526 (  477 478 ) resistor r=112.809 //w=0.094 //l=0.22 //layer=ply \
 //thickness=0.18 //x=79.48 //y=0.89 //x2=79.26 //y2=0.89
r1527 (  474 483 ) resistor r=22.1787 //w=0.252 //l=0.106066 //layer=ply \
 //thickness=0.18 //x=79.2 //y=5.05 //x2=79.275 //y2=4.975
r1528 (  474 546 ) resistor r=51.6429 //w=0.252 //l=0.34271 //layer=ply \
 //thickness=0.18 //x=79.2 //y=5.05 //x2=78.93 //y2=4.885
r1529 (  473 544 ) resistor r=30.4513 //w=0.277 //l=0.243926 //layer=ply \
 //thickness=0.18 //x=79.105 //y=2.095 //x2=78.93 //y2=2.26
r1530 (  472 548 ) resistor r=39.5823 //w=0.21 //l=0.173853 //layer=ply \
 //thickness=0.18 //x=79.105 //y=1.7 //x2=79.145 //y2=1.545
r1531 (  472 473 ) resistor r=202.543 //w=0.094 //l=0.395 //layer=ply \
 //thickness=0.18 //x=79.105 //y=1.7 //x2=79.105 //y2=2.095
r1532 (  471 548 ) resistor r=39.5823 //w=0.21 //l=0.173853 //layer=ply \
 //thickness=0.18 //x=79.105 //y=1.39 //x2=79.145 //y2=1.545
r1533 (  470 547 ) resistor r=45.1352 //w=0.168 //l=0.173853 //layer=ply \
 //thickness=0.18 //x=79.105 //y=1.045 //x2=79.145 //y2=0.89
r1534 (  470 471 ) resistor r=176.904 //w=0.094 //l=0.345 //layer=ply \
 //thickness=0.18 //x=79.105 //y=1.045 //x2=79.105 //y2=1.39
r1535 (  465 467 ) resistor r=26.9307 //w=0.15 //l=0.106066 //layer=ply \
 //thickness=0.18 //x=66.915 //y=4.97 //x2=66.99 //y2=5.045
r1536 (  465 466 ) resistor r=148.702 //w=0.094 //l=0.29 //layer=ply \
 //thickness=0.18 //x=66.915 //y=4.97 //x2=66.625 //y2=4.97
r1537 (  464 542 ) resistor r=45.1352 //w=0.168 //l=0.173853 //layer=ply \
 //thickness=0.18 //x=66.58 //y=1.4 //x2=66.54 //y2=1.555
r1538 (  463 541 ) resistor r=45.1352 //w=0.168 //l=0.173853 //layer=ply \
 //thickness=0.18 //x=66.58 //y=1.055 //x2=66.54 //y2=0.9
r1539 (  463 464 ) resistor r=176.904 //w=0.094 //l=0.345 //layer=ply \
 //thickness=0.18 //x=66.58 //y=1.055 //x2=66.58 //y2=1.4
r1540 (  460 466 ) resistor r=22.7971 //w=0.269 //l=0.106066 //layer=ply \
 //thickness=0.18 //x=66.55 //y=5.045 //x2=66.625 //y2=4.97
r1541 (  460 540 ) resistor r=35.8364 //w=0.269 //l=0.270185 //layer=ply \
 //thickness=0.18 //x=66.55 //y=5.045 //x2=66.35 //y2=4.88
r1542 (  458 536 ) resistor r=10.701 //w=0.21 //l=0.115 //layer=ply \
 //thickness=0.18 //x=66.205 //y=1.555 //x2=66.09 //y2=1.555
r1543 (  457 542 ) resistor r=5.52526 //w=0.168 //l=0.115 //layer=ply \
 //thickness=0.18 //x=66.425 //y=1.555 //x2=66.54 //y2=1.555
r1544 (  456 535 ) resistor r=5.52526 //w=0.168 //l=0.115 //layer=ply \
 //thickness=0.18 //x=66.205 //y=0.9 //x2=66.09 //y2=0.9
r1545 (  455 541 ) resistor r=5.52526 //w=0.168 //l=0.115 //layer=ply \
 //thickness=0.18 //x=66.425 //y=0.9 //x2=66.54 //y2=0.9
r1546 (  455 456 ) resistor r=112.809 //w=0.094 //l=0.22 //layer=ply \
 //thickness=0.18 //x=66.425 //y=0.9 //x2=66.205 //y2=0.9
r1547 (  454 538 ) resistor r=58.7805 //w=0.246 //l=0.373497 //layer=ply \
 //thickness=0.18 //x=66.05 //y=2.095 //x2=66.35 //y2=2.26
r1548 (  453 536 ) resistor r=39.5823 //w=0.21 //l=0.173853 //layer=ply \
 //thickness=0.18 //x=66.05 //y=1.71 //x2=66.09 //y2=1.555
r1549 (  453 454 ) resistor r=197.415 //w=0.094 //l=0.385 //layer=ply \
 //thickness=0.18 //x=66.05 //y=1.71 //x2=66.05 //y2=2.095
r1550 (  452 536 ) resistor r=39.5823 //w=0.21 //l=0.173853 //layer=ply \
 //thickness=0.18 //x=66.05 //y=1.4 //x2=66.09 //y2=1.555
r1551 (  451 535 ) resistor r=45.1352 //w=0.168 //l=0.173853 //layer=ply \
 //thickness=0.18 //x=66.05 //y=1.055 //x2=66.09 //y2=0.9
r1552 (  451 452 ) resistor r=176.904 //w=0.094 //l=0.345 //layer=ply \
 //thickness=0.18 //x=66.05 //y=1.055 //x2=66.05 //y2=1.4
r1553 (  448 532 ) resistor r=70.3348 //w=0.233 //l=0.414367 //layer=ply \
 //thickness=0.18 //x=63.36 //y=5.045 //x2=63.02 //y2=4.88
r1554 (  447 534 ) resistor r=45.1352 //w=0.168 //l=0.173853 //layer=ply \
 //thickness=0.18 //x=63.355 //y=1.39 //x2=63.315 //y2=1.545
r1555 (  446 533 ) resistor r=45.1352 //w=0.168 //l=0.173853 //layer=ply \
 //thickness=0.18 //x=63.355 //y=1.045 //x2=63.315 //y2=0.89
r1556 (  446 447 ) resistor r=176.904 //w=0.094 //l=0.345 //layer=ply \
 //thickness=0.18 //x=63.355 //y=1.045 //x2=63.355 //y2=1.39
r1557 (  444 529 ) resistor r=10.701 //w=0.21 //l=0.115 //layer=ply \
 //thickness=0.18 //x=62.98 //y=1.545 //x2=62.865 //y2=1.545
r1558 (  443 534 ) resistor r=5.52526 //w=0.168 //l=0.115 //layer=ply \
 //thickness=0.18 //x=63.2 //y=1.545 //x2=63.315 //y2=1.545
r1559 (  442 528 ) resistor r=5.52526 //w=0.168 //l=0.115 //layer=ply \
 //thickness=0.18 //x=62.98 //y=0.89 //x2=62.865 //y2=0.89
r1560 (  441 533 ) resistor r=5.52526 //w=0.168 //l=0.115 //layer=ply \
 //thickness=0.18 //x=63.2 //y=0.89 //x2=63.315 //y2=0.89
r1561 (  441 442 ) resistor r=112.809 //w=0.094 //l=0.22 //layer=ply \
 //thickness=0.18 //x=63.2 //y=0.89 //x2=62.98 //y2=0.89
r1562 (  438 530 ) resistor r=13.0941 //w=0.233 //l=0.165 //layer=ply \
 //thickness=0.18 //x=62.92 //y=5.045 //x2=62.92 //y2=4.88
r1563 (  437 527 ) resistor r=34.8111 //w=0.27 //l=0.264953 //layer=ply \
 //thickness=0.18 //x=62.825 //y=2.095 //x2=63.02 //y2=2.26
r1564 (  436 529 ) resistor r=39.5823 //w=0.21 //l=0.173853 //layer=ply \
 //thickness=0.18 //x=62.825 //y=1.7 //x2=62.865 //y2=1.545
r1565 (  436 437 ) resistor r=202.543 //w=0.094 //l=0.395 //layer=ply \
 //thickness=0.18 //x=62.825 //y=1.7 //x2=62.825 //y2=2.095
r1566 (  435 529 ) resistor r=39.5823 //w=0.21 //l=0.173853 //layer=ply \
 //thickness=0.18 //x=62.825 //y=1.39 //x2=62.865 //y2=1.545
r1567 (  434 528 ) resistor r=45.1352 //w=0.168 //l=0.173853 //layer=ply \
 //thickness=0.18 //x=62.825 //y=1.045 //x2=62.865 //y2=0.89
r1568 (  434 435 ) resistor r=176.904 //w=0.094 //l=0.345 //layer=ply \
 //thickness=0.18 //x=62.825 //y=1.045 //x2=62.825 //y2=1.39
r1569 (  433 525 ) resistor r=45.1352 //w=0.168 //l=0.173853 //layer=ply \
 //thickness=0.18 //x=56.14 //y=1.44 //x2=56.1 //y2=1.595
r1570 (  432 524 ) resistor r=45.1352 //w=0.168 //l=0.173853 //layer=ply \
 //thickness=0.18 //x=56.14 //y=1.095 //x2=56.1 //y2=0.94
r1571 (  432 433 ) resistor r=176.904 //w=0.094 //l=0.345 //layer=ply \
 //thickness=0.18 //x=56.14 //y=1.095 //x2=56.14 //y2=1.44
r1572 (  430 521 ) resistor r=10.701 //w=0.21 //l=0.115 //layer=ply \
 //thickness=0.18 //x=55.765 //y=1.595 //x2=55.65 //y2=1.595
r1573 (  429 525 ) resistor r=5.52526 //w=0.168 //l=0.115 //layer=ply \
 //thickness=0.18 //x=55.985 //y=1.595 //x2=56.1 //y2=1.595
r1574 (  428 520 ) resistor r=5.52526 //w=0.168 //l=0.115 //layer=ply \
 //thickness=0.18 //x=55.765 //y=0.94 //x2=55.65 //y2=0.94
r1575 (  427 524 ) resistor r=5.52526 //w=0.168 //l=0.115 //layer=ply \
 //thickness=0.18 //x=55.985 //y=0.94 //x2=56.1 //y2=0.94
r1576 (  427 428 ) resistor r=112.809 //w=0.094 //l=0.22 //layer=ply \
 //thickness=0.18 //x=55.985 //y=0.94 //x2=55.765 //y2=0.94
r1577 (  424 523 ) resistor r=37.236 //w=0.233 //l=0.249199 //layer=ply \
 //thickness=0.18 //x=55.8 //y=5.045 //x2=55.62 //y2=4.88
r1578 (  422 521 ) resistor r=39.5823 //w=0.21 //l=0.173853 //layer=ply \
 //thickness=0.18 //x=55.61 //y=1.75 //x2=55.65 //y2=1.595
r1579 (  422 518 ) resistor r=176.904 //w=0.094 //l=0.345 //layer=ply \
 //thickness=0.18 //x=55.61 //y=1.75 //x2=55.61 //y2=2.095
r1580 (  421 521 ) resistor r=39.5823 //w=0.21 //l=0.173853 //layer=ply \
 //thickness=0.18 //x=55.61 //y=1.44 //x2=55.65 //y2=1.595
r1581 (  420 520 ) resistor r=45.1352 //w=0.168 //l=0.173853 //layer=ply \
 //thickness=0.18 //x=55.61 //y=1.095 //x2=55.65 //y2=0.94
r1582 (  420 421 ) resistor r=176.904 //w=0.094 //l=0.345 //layer=ply \
 //thickness=0.18 //x=55.61 //y=1.095 //x2=55.61 //y2=1.44
r1583 (  417 523 ) resistor r=53.7854 //w=0.233 //l=0.332415 //layer=ply \
 //thickness=0.18 //x=55.36 //y=5.045 //x2=55.62 //y2=4.88
r1584 (  416 515 ) resistor r=45.1352 //w=0.168 //l=0.173853 //layer=ply \
 //thickness=0.18 //x=48 //y=1.44 //x2=47.96 //y2=1.595
r1585 (  415 514 ) resistor r=45.1352 //w=0.168 //l=0.173853 //layer=ply \
 //thickness=0.18 //x=48 //y=1.095 //x2=47.96 //y2=0.94
r1586 (  415 416 ) resistor r=176.904 //w=0.094 //l=0.345 //layer=ply \
 //thickness=0.18 //x=48 //y=1.095 //x2=48 //y2=1.44
r1587 (  413 511 ) resistor r=10.701 //w=0.21 //l=0.115 //layer=ply \
 //thickness=0.18 //x=47.625 //y=1.595 //x2=47.51 //y2=1.595
r1588 (  412 515 ) resistor r=5.52526 //w=0.168 //l=0.115 //layer=ply \
 //thickness=0.18 //x=47.845 //y=1.595 //x2=47.96 //y2=1.595
r1589 (  411 510 ) resistor r=5.52526 //w=0.168 //l=0.115 //layer=ply \
 //thickness=0.18 //x=47.625 //y=0.94 //x2=47.51 //y2=0.94
r1590 (  410 514 ) resistor r=5.52526 //w=0.168 //l=0.115 //layer=ply \
 //thickness=0.18 //x=47.845 //y=0.94 //x2=47.96 //y2=0.94
r1591 (  410 411 ) resistor r=112.809 //w=0.094 //l=0.22 //layer=ply \
 //thickness=0.18 //x=47.845 //y=0.94 //x2=47.625 //y2=0.94
r1592 (  407 513 ) resistor r=37.236 //w=0.233 //l=0.249199 //layer=ply \
 //thickness=0.18 //x=47.66 //y=5.045 //x2=47.48 //y2=4.88
r1593 (  405 511 ) resistor r=39.5823 //w=0.21 //l=0.173853 //layer=ply \
 //thickness=0.18 //x=47.47 //y=1.75 //x2=47.51 //y2=1.595
r1594 (  405 508 ) resistor r=176.904 //w=0.094 //l=0.345 //layer=ply \
 //thickness=0.18 //x=47.47 //y=1.75 //x2=47.47 //y2=2.095
r1595 (  404 511 ) resistor r=39.5823 //w=0.21 //l=0.173853 //layer=ply \
 //thickness=0.18 //x=47.47 //y=1.44 //x2=47.51 //y2=1.595
r1596 (  403 510 ) resistor r=45.1352 //w=0.168 //l=0.173853 //layer=ply \
 //thickness=0.18 //x=47.47 //y=1.095 //x2=47.51 //y2=0.94
r1597 (  403 404 ) resistor r=176.904 //w=0.094 //l=0.345 //layer=ply \
 //thickness=0.18 //x=47.47 //y=1.095 //x2=47.47 //y2=1.44
r1598 (  400 513 ) resistor r=53.7854 //w=0.233 //l=0.332415 //layer=ply \
 //thickness=0.18 //x=47.22 //y=5.045 //x2=47.48 //y2=4.88
r1599 (  399 501 ) resistor r=592.245 //w=0.094 //l=1.155 //layer=ply \
 //thickness=0.18 //x=82.96 //y=6.205 //x2=82.96 //y2=5.05
r1600 (  398 493 ) resistor r=592.245 //w=0.094 //l=1.155 //layer=ply \
 //thickness=0.18 //x=82.52 //y=6.205 //x2=82.52 //y2=5.05
r1601 (  397 486 ) resistor r=592.245 //w=0.094 //l=1.155 //layer=ply \
 //thickness=0.18 //x=79.64 //y=6.205 //x2=79.64 //y2=5.05
r1602 (  396 474 ) resistor r=592.245 //w=0.094 //l=1.155 //layer=ply \
 //thickness=0.18 //x=79.2 //y=6.205 //x2=79.2 //y2=5.05
r1603 (  395 467 ) resistor r=592.245 //w=0.094 //l=1.155 //layer=ply \
 //thickness=0.18 //x=66.99 //y=6.2 //x2=66.99 //y2=5.045
r1604 (  394 460 ) resistor r=592.245 //w=0.094 //l=1.155 //layer=ply \
 //thickness=0.18 //x=66.55 //y=6.2 //x2=66.55 //y2=5.045
r1605 (  393 448 ) resistor r=592.245 //w=0.094 //l=1.155 //layer=ply \
 //thickness=0.18 //x=63.36 //y=6.2 //x2=63.36 //y2=5.045
r1606 (  392 438 ) resistor r=592.245 //w=0.094 //l=1.155 //layer=ply \
 //thickness=0.18 //x=62.92 //y=6.2 //x2=62.92 //y2=5.045
r1607 (  391 424 ) resistor r=592.245 //w=0.094 //l=1.155 //layer=ply \
 //thickness=0.18 //x=55.8 //y=6.2 //x2=55.8 //y2=5.045
r1608 (  390 417 ) resistor r=592.245 //w=0.094 //l=1.155 //layer=ply \
 //thickness=0.18 //x=55.36 //y=6.2 //x2=55.36 //y2=5.045
r1609 (  389 407 ) resistor r=592.245 //w=0.094 //l=1.155 //layer=ply \
 //thickness=0.18 //x=47.66 //y=6.2 //x2=47.66 //y2=5.045
r1610 (  388 400 ) resistor r=592.245 //w=0.094 //l=1.155 //layer=ply \
 //thickness=0.18 //x=47.22 //y=6.2 //x2=47.22 //y2=5.045
r1611 (  387 498 ) resistor r=56.4043 //w=0.094 //l=0.11 //layer=ply \
 //thickness=0.18 //x=82.7 //y=1.545 //x2=82.81 //y2=1.545
r1612 (  387 499 ) resistor r=56.4043 //w=0.094 //l=0.11 //layer=ply \
 //thickness=0.18 //x=82.7 //y=1.545 //x2=82.59 //y2=1.545
r1613 (  386 479 ) resistor r=56.4043 //w=0.094 //l=0.11 //layer=ply \
 //thickness=0.18 //x=79.37 //y=1.545 //x2=79.48 //y2=1.545
r1614 (  386 480 ) resistor r=56.4043 //w=0.094 //l=0.11 //layer=ply \
 //thickness=0.18 //x=79.37 //y=1.545 //x2=79.26 //y2=1.545
r1615 (  385 457 ) resistor r=56.4043 //w=0.094 //l=0.11 //layer=ply \
 //thickness=0.18 //x=66.315 //y=1.555 //x2=66.425 //y2=1.555
r1616 (  385 458 ) resistor r=56.4043 //w=0.094 //l=0.11 //layer=ply \
 //thickness=0.18 //x=66.315 //y=1.555 //x2=66.205 //y2=1.555
r1617 (  384 443 ) resistor r=56.4043 //w=0.094 //l=0.11 //layer=ply \
 //thickness=0.18 //x=63.09 //y=1.545 //x2=63.2 //y2=1.545
r1618 (  384 444 ) resistor r=56.4043 //w=0.094 //l=0.11 //layer=ply \
 //thickness=0.18 //x=63.09 //y=1.545 //x2=62.98 //y2=1.545
r1619 (  383 429 ) resistor r=56.4043 //w=0.094 //l=0.11 //layer=ply \
 //thickness=0.18 //x=55.875 //y=1.595 //x2=55.985 //y2=1.595
r1620 (  383 430 ) resistor r=56.4043 //w=0.094 //l=0.11 //layer=ply \
 //thickness=0.18 //x=55.875 //y=1.595 //x2=55.765 //y2=1.595
r1621 (  382 412 ) resistor r=56.4043 //w=0.094 //l=0.11 //layer=ply \
 //thickness=0.18 //x=47.735 //y=1.595 //x2=47.845 //y2=1.595
r1622 (  382 413 ) resistor r=56.4043 //w=0.094 //l=0.11 //layer=ply \
 //thickness=0.18 //x=47.735 //y=1.595 //x2=47.625 //y2=1.595
r1623 (  380 557 ) resistor r=152 //w=0.17 //l=0.17 //layer=licon //count=1 \
 //x=82.63 //y=4.885 //x2=82.63 //y2=4.885
r1624 (  377 380 ) resistor r=18.139 //w=0.187 //l=0.265 //layer=li \
 //thickness=0.1 //x=82.63 //y=4.62 //x2=82.63 //y2=4.885
r1625 (  372 552 ) resistor r=152 //w=0.17 //l=0.17 //layer=licon //count=1 \
 //x=82.63 //y=2.26 //x2=82.63 //y2=2.26
r1626 (  369 546 ) resistor r=152 //w=0.17 //l=0.17 //layer=licon //count=1 \
 //x=78.93 //y=4.885 //x2=78.93 //y2=4.885
r1627 (  366 369 ) resistor r=18.139 //w=0.187 //l=0.265 //layer=li \
 //thickness=0.1 //x=78.93 //y=4.62 //x2=78.93 //y2=4.885
r1628 (  357 544 ) resistor r=152 //w=0.17 //l=0.17 //layer=licon //count=1 \
 //x=78.93 //y=2.26 //x2=78.93 //y2=2.26
r1629 (  352 540 ) resistor r=152 //w=0.17 //l=0.17 //layer=licon //count=1 \
 //x=66.35 //y=4.88 //x2=66.35 //y2=4.88
r1630 (  343 538 ) resistor r=152 //w=0.17 //l=0.17 //layer=licon //count=1 \
 //x=66.35 //y=2.26 //x2=66.35 //y2=2.26
r1631 (  326 572 ) resistor r=23.615 //w=0.187 //l=0.345 //layer=li \
 //thickness=0.1 //x=64.02 //y=5.56 //x2=64.02 //y2=5.905
r1632 (  318 571 ) resistor r=23.615 //w=0.187 //l=0.345 //layer=li \
 //thickness=0.1 //x=63.14 //y=5.56 //x2=63.14 //y2=5.905
r1633 (  313 532 ) resistor r=152 //w=0.17 //l=0.17 //layer=licon //count=1 \
 //x=63.02 //y=4.88 //x2=63.02 //y2=4.88
r1634 (  304 527 ) resistor r=152 //w=0.17 //l=0.17 //layer=licon //count=1 \
 //x=63.02 //y=2.26 //x2=63.02 //y2=2.26
r1635 (  287 570 ) resistor r=23.615 //w=0.187 //l=0.345 //layer=li \
 //thickness=0.1 //x=60.39 //y=5.56 //x2=60.39 //y2=5.905
r1636 (  279 569 ) resistor r=23.615 //w=0.187 //l=0.345 //layer=li \
 //thickness=0.1 //x=59.51 //y=5.56 //x2=59.51 //y2=5.905
r1637 (  271 568 ) resistor r=23.615 //w=0.187 //l=0.345 //layer=li \
 //thickness=0.1 //x=58.63 //y=5.56 //x2=58.63 //y2=5.905
r1638 (  266 523 ) resistor r=152 //w=0.17 //l=0.17 //layer=licon //count=1 \
 //x=55.62 //y=4.88 //x2=55.62 //y2=4.88
r1639 (  257 517 ) resistor r=152 //w=0.17 //l=0.17 //layer=licon //count=1 \
 //x=55.62 //y=2.26 //x2=55.62 //y2=2.26
r1640 (  240 567 ) resistor r=23.615 //w=0.187 //l=0.345 //layer=li \
 //thickness=0.1 //x=51.07 //y=5.56 //x2=51.07 //y2=5.905
r1641 (  232 566 ) resistor r=23.615 //w=0.187 //l=0.345 //layer=li \
 //thickness=0.1 //x=50.19 //y=5.56 //x2=50.19 //y2=5.905
r1642 (  227 513 ) resistor r=152 //w=0.17 //l=0.17 //layer=licon //count=1 \
 //x=47.48 //y=4.88 //x2=47.48 //y2=4.88
r1643 (  218 507 ) resistor r=152 //w=0.17 //l=0.17 //layer=licon //count=1 \
 //x=47.48 //y=2.26 //x2=47.48 //y2=2.26
r1644 (  214 215 ) resistor r=0.10734 //w=0.281 //l=0.16 //layer=m2 \
 //thickness=0.36 //x=82.635 //y=4.64 //x2=82.475 //y2=4.64
r1645 (  203 205 ) resistor r=0.10734 //w=0.281 //l=0.16 //layer=m2 \
 //thickness=0.36 //x=64.5 //y=3.515 //x2=64.66 //y2=3.515
r1646 (  203 204 ) resistor r=0.10734 //w=0.281 //l=0.16 //layer=m2 \
 //thickness=0.36 //x=64.5 //y=3.515 //x2=64.34 //y2=3.515
r1647 (  191 193 ) resistor r=0.10734 //w=0.281 //l=0.16 //layer=m2 \
 //thickness=0.36 //x=47.485 //y=3.525 //x2=47.645 //y2=3.525
r1648 (  189 211 ) resistor r=0.10734 //w=0.281 //l=0.16 //layer=m2 \
 //thickness=0.36 //x=79.095 //y=4.62 //x2=78.935 //y2=4.62
r1649 (  189 215 ) resistor r=3.22519 //w=0.131 //l=3.38 //layer=m2 \
 //thickness=0.36 //x=79.095 //y=4.62 //x2=82.475 //y2=4.62
r1650 (  186 209 ) resistor r=3.72251 //w=0.179 //l=5.34498 //layer=m2 \
 //thickness=0.36 //x=73.6 //y=3.48 //x2=78.93 //y2=3.51
r1651 (  186 187 ) resistor r=0.410305 //w=0.131 //l=0.43 //layer=m2 \
 //thickness=0.36 //x=73.6 //y=3.48 //x2=73.17 //y2=3.48
r1652 (  184 187 ) resistor r=0.125 //w=0.17 //l=0.184391 //layer=m2 \
 //thickness=0.36 //x=73 //y=3.51 //x2=73.17 //y2=3.48
r1653 (  184 185 ) resistor r=1.31679 //w=0.131 //l=1.38 //layer=m2 \
 //thickness=0.36 //x=73 //y=3.51 //x2=71.62 //y2=3.51
r1654 (  183 207 ) resistor r=3.1636 //w=0.181 //l=4.58999 //layer=m2 \
 //thickness=0.36 //x=70.935 //y=3.495 //x2=66.355 //y2=3.515
r1655 (  182 185 ) resistor r=0.1875 //w=0.17 //l=0.262393 //layer=m2 \
 //thickness=0.36 //x=71.365 //y=3.495 //x2=71.62 //y2=3.51
r1656 (  182 183 ) resistor r=0.410305 //w=0.131 //l=0.43 //layer=m2 \
 //thickness=0.36 //x=71.365 //y=3.495 //x2=70.935 //y2=3.495
r1657 (  180 207 ) resistor r=0.111117 //w=0.181 //l=0.162481 //layer=m2 \
 //thickness=0.36 //x=66.195 //y=3.51 //x2=66.355 //y2=3.515
r1658 (  180 205 ) resistor r=1.46469 //w=0.131 //l=1.535 //layer=m2 \
 //thickness=0.36 //x=66.195 //y=3.51 //x2=64.66 //y2=3.51
r1659 (  179 201 ) resistor r=0.10734 //w=0.281 //l=0.16 //layer=m2 \
 //thickness=0.36 //x=63.18 //y=3.51 //x2=63.02 //y2=3.51
r1660 (  179 204 ) resistor r=1.10687 //w=0.131 //l=1.16 //layer=m2 \
 //thickness=0.36 //x=63.18 //y=3.51 //x2=64.34 //y2=3.51
r1661 (  177 199 ) resistor r=0.108234 //w=0.187 //l=0.16 //layer=m2 \
 //thickness=0.36 //x=61.335 //y=3.51 //x2=61.175 //y2=3.51
r1662 (  176 201 ) resistor r=0.10734 //w=0.281 //l=0.16 //layer=m2 \
 //thickness=0.36 //x=62.86 //y=3.51 //x2=63.02 //y2=3.51
r1663 (  176 177 ) resistor r=1.45515 //w=0.131 //l=1.525 //layer=m2 \
 //thickness=0.36 //x=62.86 //y=3.51 //x2=61.335 //y2=3.51
r1664 (  174 199 ) resistor r=1.83617 //w=0.187 //l=2.75249 //layer=m2 \
 //thickness=0.36 //x=58.43 //y=3.495 //x2=61.175 //y2=3.51
r1665 (  174 175 ) resistor r=0.410305 //w=0.131 //l=0.43 //layer=m2 \
 //thickness=0.36 //x=58.43 //y=3.495 //x2=58 //y2=3.495
r1666 (  172 175 ) resistor r=0.125 //w=0.17 //l=0.177341 //layer=m2 \
 //thickness=0.36 //x=57.83 //y=3.51 //x2=58 //y2=3.495
r1667 (  172 173 ) resistor r=0.949427 //w=0.131 //l=0.995 //layer=m2 \
 //thickness=0.36 //x=57.83 //y=3.51 //x2=56.835 //y2=3.51
r1668 (  171 197 ) resistor r=0.286843 //w=0.24 //l=0.534977 //layer=m2 \
 //thickness=0.36 //x=56.15 //y=3.5 //x2=55.62 //y2=3.51
r1669 (  170 173 ) resistor r=0.1875 //w=0.17 //l=0.259952 //layer=m2 \
 //thickness=0.36 //x=56.58 //y=3.5 //x2=56.835 //y2=3.51
r1670 (  170 171 ) resistor r=0.410305 //w=0.131 //l=0.43 //layer=m2 \
 //thickness=0.36 //x=56.58 //y=3.5 //x2=56.15 //y2=3.5
r1671 (  169 195 ) resistor r=0.10188 //w=0.204 //l=0.167332 //layer=m2 \
 //thickness=0.36 //x=51.71 //y=3.51 //x2=51.55 //y2=3.525
r1672 (  168 197 ) resistor r=0.0941343 //w=0.24 //l=0.16 //layer=m2 \
 //thickness=0.36 //x=55.46 //y=3.51 //x2=55.62 //y2=3.51
r1673 (  168 169 ) resistor r=3.57824 //w=0.131 //l=3.75 //layer=m2 \
 //thickness=0.36 //x=55.46 //y=3.51 //x2=51.71 //y2=3.51
r1674 (  166 195 ) resistor r=0.782027 //w=0.204 //l=1.2923 //layer=m2 \
 //thickness=0.36 //x=50.28 //y=3.48 //x2=51.55 //y2=3.525
r1675 (  166 167 ) resistor r=0.410305 //w=0.131 //l=0.43 //layer=m2 \
 //thickness=0.36 //x=50.28 //y=3.48 //x2=49.85 //y2=3.48
r1676 (  164 167 ) resistor r=0.125 //w=0.17 //l=0.184391 //layer=m2 \
 //thickness=0.36 //x=49.68 //y=3.51 //x2=49.85 //y2=3.48
r1677 (  164 165 ) resistor r=0.939885 //w=0.131 //l=0.985 //layer=m2 \
 //thickness=0.36 //x=49.68 //y=3.51 //x2=48.695 //y2=3.51
r1678 (  162 165 ) resistor r=0.1875 //w=0.17 //l=0.269583 //layer=m2 \
 //thickness=0.36 //x=48.44 //y=3.48 //x2=48.695 //y2=3.51
r1679 (  162 163 ) resistor r=0.410305 //w=0.131 //l=0.43 //layer=m2 \
 //thickness=0.36 //x=48.44 //y=3.48 //x2=48.01 //y2=3.48
r1680 (  160 163 ) resistor r=0.125 //w=0.17 //l=0.184391 //layer=m2 \
 //thickness=0.36 //x=47.84 //y=3.51 //x2=48.01 //y2=3.48
r1681 (  160 193 ) resistor r=0.186069 //w=0.131 //l=0.195 //layer=m2 \
 //thickness=0.36 //x=47.84 //y=3.51 //x2=47.645 //y2=3.51
r1682 (  159 372 ) resistor r=9.3 //w=0.17 //l=0.17 //layer=mcon //count=1 \
 //x=82.63 //y=2.26 //x2=82.63 //y2=2.26
r1683 (  157 214 ) resistor r=4.5 //w=0.15 //l=0.15 //layer=via1 //count=1 \
 //x=82.635 //y=4.64 //x2=82.635 //y2=4.64
r1684 (  155 377 ) resistor r=9.3 //w=0.17 //l=0.17 //layer=mcon //count=1 \
 //x=82.63 //y=4.62 //x2=82.63 //y2=4.62
r1685 (  155 157 ) resistor r=0.00659631 //w=0.379 //l=0.02 //layer=m1 \
 //thickness=0.36 //x=82.58 //y=4.62 //x2=82.58 //y2=4.64
r1686 (  152 366 ) resistor r=9.3 //w=0.17 //l=0.17 //layer=mcon //count=1 \
 //x=78.93 //y=4.62 //x2=78.93 //y2=4.62
r1687 (  152 211 ) resistor r=4.5 //w=0.15 //l=0.15 //layer=via1 //count=1 \
 //x=78.935 //y=4.62 //x2=78.935 //y2=4.62
r1688 (  150 357 ) resistor r=9.3 //w=0.17 //l=0.17 //layer=mcon //count=1 \
 //x=78.93 //y=2.26 //x2=78.93 //y2=2.26
r1689 (  147 209 ) resistor r=4.5 //w=0.15 //l=0.15 //layer=via1 //count=1 \
 //x=78.93 //y=3.51 //x2=78.93 //y2=3.51
r1690 (  145 352 ) resistor r=9.3 //w=0.17 //l=0.17 //layer=mcon //count=1 \
 //x=66.35 //y=4.88 //x2=66.35 //y2=4.88
r1691 (  143 343 ) resistor r=9.3 //w=0.17 //l=0.17 //layer=mcon //count=1 \
 //x=66.35 //y=2.26 //x2=66.35 //y2=2.26
r1692 (  141 207 ) resistor r=4.5 //w=0.15 //l=0.15 //layer=via1 //count=1 \
 //x=66.355 //y=3.515 //x2=66.355 //y2=3.515
r1693 (  139 141 ) resistor r=0.00164908 //w=0.379 //l=0.005 //layer=m1 \
 //thickness=0.36 //x=66.3 //y=3.51 //x2=66.3 //y2=3.515
r1694 (  137 203 ) resistor r=4.5 //w=0.15 //l=0.15 //layer=via1 //count=1 \
 //x=64.5 //y=3.515 //x2=64.5 //y2=3.515
r1695 (  135 137 ) resistor r=0.00166223 //w=0.376 //l=0.005 //layer=m1 \
 //thickness=0.36 //x=64.552 //y=3.51 //x2=64.552 //y2=3.515
r1696 (  132 562 ) resistor r=9.3 //w=0.17 //l=0.17 //layer=mcon //count=1 \
 //x=64.06 //y=1.18 //x2=64.06 //y2=1.18
r1697 (  130 326 ) resistor r=9.3 //w=0.17 //l=0.17 //layer=mcon //count=1 \
 //x=64.02 //y=5.56 //x2=64.02 //y2=5.56
r1698 (  127 130 ) resistor r=0.117801 //w=0.191 //l=0.18 //layer=m1 \
 //thickness=0.36 //x=64.02 //y=5.38 //x2=64.02 //y2=5.56
r1699 (  126 318 ) resistor r=9.3 //w=0.17 //l=0.17 //layer=mcon //count=1 \
 //x=63.14 //y=5.56 //x2=63.14 //y2=5.56
r1700 (  124 126 ) resistor r=0.10274 //w=0.219 //l=0.18 //layer=m1 \
 //thickness=0.36 //x=63.14 //y=5.38 //x2=63.14 //y2=5.56
r1701 (  121 313 ) resistor r=9.3 //w=0.17 //l=0.17 //layer=mcon //count=1 \
 //x=63.02 //y=4.88 //x2=63.02 //y2=4.88
r1702 (  121 122 ) resistor r=0.103207 //w=0.196 //l=0.14 //layer=m1 \
 //thickness=0.36 //x=63.022 //y=4.88 //x2=63.022 //y2=4.74
r1703 (  118 304 ) resistor r=9.3 //w=0.17 //l=0.17 //layer=mcon //count=1 \
 //x=63.02 //y=2.26 //x2=63.02 //y2=2.26
r1704 (  115 201 ) resistor r=4.5 //w=0.15 //l=0.15 //layer=via1 //count=1 \
 //x=63.02 //y=3.51 //x2=63.02 //y2=3.51
r1705 (  112 199 ) resistor r=4.5 //w=0.15 //l=0.15 //layer=via1 //count=1 \
 //x=61.175 //y=3.51 //x2=61.175 //y2=3.51
r1706 (  110 561 ) resistor r=9.3 //w=0.17 //l=0.17 //layer=mcon //count=1 \
 //x=60.685 //y=1.19 //x2=60.685 //y2=1.19
r1707 (  108 287 ) resistor r=9.3 //w=0.17 //l=0.17 //layer=mcon //count=1 \
 //x=60.39 //y=5.56 //x2=60.39 //y2=5.56
r1708 (  105 279 ) resistor r=9.3 //w=0.17 //l=0.17 //layer=mcon //count=1 \
 //x=59.51 //y=5.56 //x2=59.51 //y2=5.56
r1709 (  103 105 ) resistor r=0.121228 //w=0.232 //l=0.225 //layer=m1 \
 //thickness=0.36 //x=59.51 //y=5.335 //x2=59.51 //y2=5.56
r1710 (  102 271 ) resistor r=9.3 //w=0.17 //l=0.17 //layer=mcon //count=1 \
 //x=58.63 //y=5.56 //x2=58.63 //y2=5.56
r1711 (  100 102 ) resistor r=0.129608 //w=0.217 //l=0.225 //layer=m1 \
 //thickness=0.36 //x=58.632 //y=5.335 //x2=58.632 //y2=5.56
r1712 (  98 197 ) resistor r=4.5 //w=0.15 //l=0.15 //layer=via1 //count=1 \
 //x=55.62 //y=3.51 //x2=55.62 //y2=3.51
r1713 (  96 266 ) resistor r=9.3 //w=0.17 //l=0.17 //layer=mcon //count=1 \
 //x=55.62 //y=4.88 //x2=55.62 //y2=4.88
r1714 (  94 257 ) resistor r=9.3 //w=0.17 //l=0.17 //layer=mcon //count=1 \
 //x=55.62 //y=2.26 //x2=55.62 //y2=2.26
r1715 (  92 195 ) resistor r=4.5 //w=0.15 //l=0.15 //layer=via1 //count=1 \
 //x=51.55 //y=3.525 //x2=51.55 //y2=3.525
r1716 (  90 92 ) resistor r=0.0049867 //w=0.376 //l=0.015 //layer=m1 \
 //thickness=0.36 //x=51.497 //y=3.51 //x2=51.497 //y2=3.525
r1717 (  87 560 ) resistor r=9.3 //w=0.17 //l=0.17 //layer=mcon //count=1 \
 //x=51.11 //y=1.18 //x2=51.11 //y2=1.18
r1718 (  85 240 ) resistor r=9.3 //w=0.17 //l=0.17 //layer=mcon //count=1 \
 //x=51.07 //y=5.56 //x2=51.07 //y2=5.56
r1719 (  82 85 ) resistor r=0.117801 //w=0.191 //l=0.18 //layer=m1 \
 //thickness=0.36 //x=51.07 //y=5.38 //x2=51.07 //y2=5.56
r1720 (  81 232 ) resistor r=9.3 //w=0.17 //l=0.17 //layer=mcon //count=1 \
 //x=50.19 //y=5.56 //x2=50.19 //y2=5.56
r1721 (  79 81 ) resistor r=0.10274 //w=0.219 //l=0.18 //layer=m1 \
 //thickness=0.36 //x=50.19 //y=5.38 //x2=50.19 //y2=5.56
r1722 (  78 191 ) resistor r=4.5 //w=0.15 //l=0.15 //layer=via1 //count=1 \
 //x=47.485 //y=3.525 //x2=47.485 //y2=3.525
r1723 (  76 78 ) resistor r=0.00501337 //w=0.374 //l=0.015 //layer=m1 \
 //thickness=0.36 //x=47.535 //y=3.51 //x2=47.535 //y2=3.525
r1724 (  74 227 ) resistor r=9.3 //w=0.17 //l=0.17 //layer=mcon //count=1 \
 //x=47.48 //y=4.88 //x2=47.48 //y2=4.88
r1725 (  72 218 ) resistor r=9.3 //w=0.17 //l=0.17 //layer=mcon //count=1 \
 //x=47.48 //y=2.26 //x2=47.48 //y2=2.26
r1726 (  70 155 ) resistor r=0.0863342 //w=0.379 //l=0.168152 //layer=m1 \
 //thickness=0.36 //x=82.63 //y=4.475 //x2=82.58 //y2=4.62
r1727 (  69 159 ) resistor r=0.0761125 //w=0.237 //l=0.126491 //layer=m1 \
 //thickness=0.36 //x=82.63 //y=2.385 //x2=82.627 //y2=2.26
r1728 (  69 70 ) resistor r=1.99427 //w=0.131 //l=2.09 //layer=m1 \
 //thickness=0.36 //x=82.63 //y=2.385 //x2=82.63 //y2=4.475
r1729 (  68 152 ) resistor r=0.0898201 //w=0.322 //l=0.185472 //layer=m1 \
 //thickness=0.36 //x=78.93 //y=4.46 //x2=78.985 //y2=4.62
r1730 (  67 147 ) resistor r=0.0911593 //w=0.376 //l=0.184608 //layer=m1 \
 //thickness=0.36 //x=78.93 //y=3.67 //x2=78.877 //y2=3.51
r1731 (  67 68 ) resistor r=0.753817 //w=0.131 //l=0.79 //layer=m1 \
 //thickness=0.36 //x=78.93 //y=3.67 //x2=78.93 //y2=4.46
r1732 (  66 147 ) resistor r=0.0911593 //w=0.376 //l=0.184608 //layer=m1 \
 //thickness=0.36 //x=78.93 //y=3.35 //x2=78.877 //y2=3.51
r1733 (  65 150 ) resistor r=0.0717383 //w=0.224 //l=0.115 //layer=m1 \
 //thickness=0.36 //x=78.93 //y=2.375 //x2=78.93 //y2=2.26
r1734 (  65 66 ) resistor r=0.930344 //w=0.131 //l=0.975 //layer=m1 \
 //thickness=0.36 //x=78.93 //y=2.375 //x2=78.93 //y2=3.35
r1735 (  64 145 ) resistor r=0.0760407 //w=0.238 //l=0.125 //layer=m1 \
 //thickness=0.36 //x=66.35 //y=4.755 //x2=66.35 //y2=4.88
r1736 (  63 141 ) resistor r=0.0912814 //w=0.379 //l=0.183303 //layer=m1 \
 //thickness=0.36 //x=66.35 //y=3.675 //x2=66.3 //y2=3.515
r1737 (  63 64 ) resistor r=1.03053 //w=0.131 //l=1.08 //layer=m1 \
 //thickness=0.36 //x=66.35 //y=3.675 //x2=66.35 //y2=4.755
r1738 (  62 139 ) resistor r=0.0896323 //w=0.379 //l=0.178255 //layer=m1 \
 //thickness=0.36 //x=66.35 //y=3.355 //x2=66.3 //y2=3.51
r1739 (  61 143 ) resistor r=0.0719237 //w=0.222 //l=0.115 //layer=m1 \
 //thickness=0.36 //x=66.35 //y=2.375 //x2=66.35 //y2=2.26
r1740 (  61 62 ) resistor r=0.935115 //w=0.131 //l=0.98 //layer=m1 \
 //thickness=0.36 //x=66.35 //y=2.375 //x2=66.35 //y2=3.355
r1741 (  59 137 ) resistor r=0.0911593 //w=0.376 //l=0.184174 //layer=m1 \
 //thickness=0.36 //x=64.5 //y=3.675 //x2=64.552 //y2=3.515
r1742 (  59 60 ) resistor r=1.5458 //w=0.131 //l=1.62 //layer=m1 \
 //thickness=0.36 //x=64.5 //y=3.675 //x2=64.5 //y2=5.295
r1743 (  58 135 ) resistor r=0.0894971 //w=0.376 //l=0.179123 //layer=m1 \
 //thickness=0.36 //x=64.5 //y=3.355 //x2=64.552 //y2=3.51
r1744 (  57 58 ) resistor r=1.36927 //w=0.131 //l=1.435 //layer=m1 \
 //thickness=0.36 //x=64.5 //y=1.92 //x2=64.5 //y2=3.355
r1745 (  55 57 ) resistor r=0.0698411 //w=0.17 //l=0.120208 //layer=m1 \
 //thickness=0.36 //x=64.415 //y=1.835 //x2=64.5 //y2=1.92
r1746 (  55 56 ) resistor r=0.257634 //w=0.131 //l=0.27 //layer=m1 \
 //thickness=0.36 //x=64.415 //y=1.835 //x2=64.145 //y2=1.835
r1747 (  54 127 ) resistor r=0.0257089 //w=0.23 //l=0.115 //layer=m1 \
 //thickness=0.36 //x=64.135 //y=5.38 //x2=64.02 //y2=5.38
r1748 (  53 60 ) resistor r=0.0698411 //w=0.17 //l=0.120208 //layer=m1 \
 //thickness=0.36 //x=64.415 //y=5.38 //x2=64.5 //y2=5.295
r1749 (  53 54 ) resistor r=0.267176 //w=0.131 //l=0.28 //layer=m1 \
 //thickness=0.36 //x=64.415 //y=5.38 //x2=64.135 //y2=5.38
r1750 (  52 56 ) resistor r=0.0698411 //w=0.17 //l=0.120208 //layer=m1 \
 //thickness=0.36 //x=64.06 //y=1.75 //x2=64.145 //y2=1.835
r1751 (  51 132 ) resistor r=0.0913624 //w=0.191 //l=0.12 //layer=m1 \
 //thickness=0.36 //x=64.06 //y=1.3 //x2=64.06 //y2=1.18
r1752 (  51 52 ) resistor r=0.429389 //w=0.131 //l=0.45 //layer=m1 \
 //thickness=0.36 //x=64.06 //y=1.3 //x2=64.06 //y2=1.75
r1753 (  48 124 ) resistor r=0.0227762 //w=0.219 //l=0.115 //layer=m1 \
 //thickness=0.36 //x=63.255 //y=5.38 //x2=63.14 //y2=5.38
r1754 (  47 127 ) resistor r=0.0257089 //w=0.23 //l=0.115 //layer=m1 \
 //thickness=0.36 //x=63.905 //y=5.38 //x2=64.02 //y2=5.38
r1755 (  47 48 ) resistor r=0.620229 //w=0.131 //l=0.65 //layer=m1 \
 //thickness=0.36 //x=63.905 //y=5.38 //x2=63.255 //y2=5.38
r1756 (  43 115 ) resistor r=0.0911593 //w=0.376 //l=0.184608 //layer=m1 \
 //thickness=0.36 //x=63.02 //y=3.67 //x2=62.967 //y2=3.51
r1757 (  43 122 ) resistor r=1.02099 //w=0.131 //l=1.07 //layer=m1 \
 //thickness=0.36 //x=63.02 //y=3.67 //x2=63.02 //y2=4.74
r1758 (  42 115 ) resistor r=0.0911593 //w=0.376 //l=0.184608 //layer=m1 \
 //thickness=0.36 //x=63.02 //y=3.35 //x2=62.967 //y2=3.51
r1759 (  41 118 ) resistor r=0.0933015 //w=0.201 //l=0.125 //layer=m1 \
 //thickness=0.36 //x=63.02 //y=2.385 //x2=63.02 //y2=2.26
r1760 (  41 42 ) resistor r=0.920802 //w=0.131 //l=0.965 //layer=m1 \
 //thickness=0.36 //x=63.02 //y=2.385 //x2=63.02 //y2=3.35
r1761 (  39 112 ) resistor r=0.0910802 //w=0.374 //l=0.185472 //layer=m1 \
 //thickness=0.36 //x=61.17 //y=3.67 //x2=61.225 //y2=3.51
r1762 (  39 40 ) resistor r=1.50763 //w=0.131 //l=1.58 //layer=m1 \
 //thickness=0.36 //x=61.17 //y=3.67 //x2=61.17 //y2=5.25
r1763 (  38 112 ) resistor r=0.0910802 //w=0.374 //l=0.185472 //layer=m1 \
 //thickness=0.36 //x=61.17 //y=3.35 //x2=61.225 //y2=3.51
r1764 (  37 38 ) resistor r=1.35496 //w=0.131 //l=1.42 //layer=m1 \
 //thickness=0.36 //x=61.17 //y=1.93 //x2=61.17 //y2=3.35
r1765 (  35 37 ) resistor r=0.0698411 //w=0.17 //l=0.120208 //layer=m1 \
 //thickness=0.36 //x=61.085 //y=1.845 //x2=61.17 //y2=1.93
r1766 (  35 36 ) resistor r=0.300573 //w=0.131 //l=0.315 //layer=m1 \
 //thickness=0.36 //x=61.085 //y=1.845 //x2=60.77 //y2=1.845
r1767 (  34 36 ) resistor r=0.0698411 //w=0.17 //l=0.120208 //layer=m1 \
 //thickness=0.36 //x=60.685 //y=1.76 //x2=60.77 //y2=1.845
r1768 (  33 110 ) resistor r=0.0717383 //w=0.224 //l=0.115 //layer=m1 \
 //thickness=0.36 //x=60.685 //y=1.305 //x2=60.685 //y2=1.19
r1769 (  33 34 ) resistor r=0.43416 //w=0.131 //l=0.455 //layer=m1 \
 //thickness=0.36 //x=60.685 //y=1.305 //x2=60.685 //y2=1.76
r1770 (  32 106 ) resistor r=0.0675342 //w=0.23 //l=0.115 //layer=m1 \
 //thickness=0.36 //x=60.505 //y=5.335 //x2=60.39 //y2=5.335
r1771 (  31 40 ) resistor r=0.0698411 //w=0.17 //l=0.120208 //layer=m1 \
 //thickness=0.36 //x=61.085 //y=5.335 //x2=61.17 //y2=5.25
r1772 (  31 32 ) resistor r=0.553435 //w=0.131 //l=0.58 //layer=m1 \
 //thickness=0.36 //x=61.085 //y=5.335 //x2=60.505 //y2=5.335
r1773 (  30 108 ) resistor r=0.00118313 //w=0.23 //layer=m1 //thickness=0.36 \
 //x=60.39 //y=5.56 //x2=60.39 //y2=5.56
r1774 (  29 106 ) resistor r=0.002872 //w=0.34 //l=0.085 //layer=m1 \
 //thickness=0.36 //x=60.39 //y=5.42 //x2=60.39 //y2=5.335
r1775 (  29 30 ) resistor r=0.091623 //w=0.191 //l=0.14 //layer=m1 \
 //thickness=0.36 //x=60.39 //y=5.42 //x2=60.39 //y2=5.56
r1776 (  28 103 ) resistor r=0.0262263 //w=0.232 //l=0.12 //layer=m1 \
 //thickness=0.36 //x=59.63 //y=5.335 //x2=59.51 //y2=5.335
r1777 (  27 106 ) resistor r=0.0675342 //w=0.23 //l=0.115 //layer=m1 \
 //thickness=0.36 //x=60.275 //y=5.335 //x2=60.39 //y2=5.335
r1778 (  27 28 ) resistor r=0.615458 //w=0.131 //l=0.645 //layer=m1 \
 //thickness=0.36 //x=60.275 //y=5.335 //x2=59.63 //y2=5.335
r1779 (  26 100 ) resistor r=0.0222262 //w=0.217 //l=0.118 //layer=m1 \
 //thickness=0.36 //x=58.75 //y=5.335 //x2=58.632 //y2=5.335
r1780 (  25 103 ) resistor r=0.0262263 //w=0.232 //l=0.12 //layer=m1 \
 //thickness=0.36 //x=59.39 //y=5.335 //x2=59.51 //y2=5.335
r1781 (  25 26 ) resistor r=0.610687 //w=0.131 //l=0.64 //layer=m1 \
 //thickness=0.36 //x=59.39 //y=5.335 //x2=58.75 //y2=5.335
r1782 (  24 96 ) resistor r=0.0801089 //w=0.224 //l=0.13 //layer=m1 \
 //thickness=0.36 //x=55.62 //y=4.75 //x2=55.62 //y2=4.88
r1783 (  23 98 ) resistor r=0.0911593 //w=0.376 //l=0.184174 //layer=m1 \
 //thickness=0.36 //x=55.62 //y=3.67 //x2=55.672 //y2=3.51
r1784 (  23 24 ) resistor r=1.03053 //w=0.131 //l=1.08 //layer=m1 \
 //thickness=0.36 //x=55.62 //y=3.67 //x2=55.62 //y2=4.75
r1785 (  22 98 ) resistor r=0.0911593 //w=0.376 //l=0.184174 //layer=m1 \
 //thickness=0.36 //x=55.62 //y=3.35 //x2=55.672 //y2=3.51
r1786 (  21 94 ) resistor r=0.0719237 //w=0.222 //l=0.115 //layer=m1 \
 //thickness=0.36 //x=55.62 //y=2.375 //x2=55.62 //y2=2.26
r1787 (  21 22 ) resistor r=0.930344 //w=0.131 //l=0.975 //layer=m1 \
 //thickness=0.36 //x=55.62 //y=2.375 //x2=55.62 //y2=3.35
r1788 (  19 92 ) resistor r=0.0911593 //w=0.376 //l=0.184608 //layer=m1 \
 //thickness=0.36 //x=51.55 //y=3.685 //x2=51.497 //y2=3.525
r1789 (  19 20 ) resistor r=1.53626 //w=0.131 //l=1.61 //layer=m1 \
 //thickness=0.36 //x=51.55 //y=3.685 //x2=51.55 //y2=5.295
r1790 (  18 90 ) resistor r=0.0861726 //w=0.376 //l=0.16944 //layer=m1 \
 //thickness=0.36 //x=51.55 //y=3.365 //x2=51.497 //y2=3.51
r1791 (  17 18 ) resistor r=1.37882 //w=0.131 //l=1.445 //layer=m1 \
 //thickness=0.36 //x=51.55 //y=1.92 //x2=51.55 //y2=3.365
r1792 (  15 17 ) resistor r=0.0698411 //w=0.17 //l=0.120208 //layer=m1 \
 //thickness=0.36 //x=51.465 //y=1.835 //x2=51.55 //y2=1.92
r1793 (  15 16 ) resistor r=0.257634 //w=0.131 //l=0.27 //layer=m1 \
 //thickness=0.36 //x=51.465 //y=1.835 //x2=51.195 //y2=1.835
r1794 (  14 82 ) resistor r=0.0257089 //w=0.23 //l=0.115 //layer=m1 \
 //thickness=0.36 //x=51.185 //y=5.38 //x2=51.07 //y2=5.38
r1795 (  13 20 ) resistor r=0.0698411 //w=0.17 //l=0.120208 //layer=m1 \
 //thickness=0.36 //x=51.465 //y=5.38 //x2=51.55 //y2=5.295
r1796 (  13 14 ) resistor r=0.267176 //w=0.131 //l=0.28 //layer=m1 \
 //thickness=0.36 //x=51.465 //y=5.38 //x2=51.185 //y2=5.38
r1797 (  12 16 ) resistor r=0.0698411 //w=0.17 //l=0.120208 //layer=m1 \
 //thickness=0.36 //x=51.11 //y=1.75 //x2=51.195 //y2=1.835
r1798 (  11 87 ) resistor r=0.0913624 //w=0.191 //l=0.12 //layer=m1 \
 //thickness=0.36 //x=51.11 //y=1.3 //x2=51.11 //y2=1.18
r1799 (  11 12 ) resistor r=0.429389 //w=0.131 //l=0.45 //layer=m1 \
 //thickness=0.36 //x=51.11 //y=1.3 //x2=51.11 //y2=1.75
r1800 (  8 79 ) resistor r=0.0227762 //w=0.219 //l=0.115 //layer=m1 \
 //thickness=0.36 //x=50.305 //y=5.38 //x2=50.19 //y2=5.38
r1801 (  7 82 ) resistor r=0.0257089 //w=0.23 //l=0.115 //layer=m1 \
 //thickness=0.36 //x=50.955 //y=5.38 //x2=51.07 //y2=5.38
r1802 (  7 8 ) resistor r=0.620229 //w=0.131 //l=0.65 //layer=m1 \
 //thickness=0.36 //x=50.955 //y=5.38 //x2=50.305 //y2=5.38
r1803 (  4 74 ) resistor r=0.0801089 //w=0.224 //l=0.13 //layer=m1 \
 //thickness=0.36 //x=47.48 //y=4.75 //x2=47.48 //y2=4.88
r1804 (  3 78 ) resistor r=0.0910802 //w=0.374 //l=0.185472 //layer=m1 \
 //thickness=0.36 //x=47.48 //y=3.685 //x2=47.535 //y2=3.525
r1805 (  3 4 ) resistor r=1.01622 //w=0.131 //l=1.065 //layer=m1 \
 //thickness=0.36 //x=47.48 //y=3.685 //x2=47.48 //y2=4.75
r1806 (  2 76 ) resistor r=0.0860668 //w=0.374 //l=0.170294 //layer=m1 \
 //thickness=0.36 //x=47.48 //y=3.365 //x2=47.535 //y2=3.51
r1807 (  1 72 ) resistor r=0.0719237 //w=0.222 //l=0.115 //layer=m1 \
 //thickness=0.36 //x=47.48 //y=2.375 //x2=47.48 //y2=2.26
r1808 (  1 2 ) resistor r=0.944656 //w=0.131 //l=0.99 //layer=m1 \
 //thickness=0.36 //x=47.48 //y=2.375 //x2=47.48 //y2=3.365
ends PM_TMRDFFRNQX1\%noxref_15

subckt PM_TMRDFFRNQX1\%noxref_16 ( 1 2 3 4 7 12 13 15 16 18 19 20 21 22 23 24 \
 25 26 32 37 38 41 43 46 50 64 66 67 68 70 72 74 76 78 80 82 84 86 88 90 92 94 \
 96 98 100 102 104 106 108 110 112 114 121 129 131 132 135 144 149 157 174 183 \
 188 193 197 198 199 200 201 202 203 204 205 209 210 211 216 218 221 222 226 \
 227 228 229 230 232 235 238 239 240 241 242 243 244 245 249 251 254 255 256 \
 257 262 263 268 280 287 289 290 )
c813 ( 287 0 ) capacitor c=0.00878249f //x=25.02 //y=1.085
c814 ( 280 0 ) capacitor c=0.0586737f //x=85.59 //y=2.26
c815 ( 268 0 ) capacitor c=0.0710579f //x=21.58 //y=4.88
c816 ( 263 0 ) capacitor c=0.0278202f //x=21.58 //y=2.095
c817 ( 262 0 ) capacitor c=0.0468631f //x=21.58 //y=2.26
c818 ( 257 0 ) capacitor c=0.0318956f //x=86.295 //y=1.39
c819 ( 256 0 ) capacitor c=0.0186809f //x=86.295 //y=1.045
c820 ( 255 0 ) capacitor c=0.0659968f //x=85.935 //y=4.975
c821 ( 254 0 ) capacitor c=0.0373387f //x=86.225 //y=4.975
c822 ( 251 0 ) capacitor c=0.0157936f //x=86.14 //y=1.545
c823 ( 249 0 ) capacitor c=0.0158553f //x=86.14 //y=0.89
c824 ( 245 0 ) capacitor c=0.0302441f //x=85.765 //y=2.095
c825 ( 244 0 ) capacitor c=0.0238107f //x=85.765 //y=1.7
c826 ( 243 0 ) capacitor c=0.0234359f //x=85.765 //y=1.39
c827 ( 242 0 ) capacitor c=0.0199332f //x=85.765 //y=1.045
c828 ( 241 0 ) capacitor c=0.0927643f //x=83.935 //y=2.095
c829 ( 240 0 ) capacitor c=0.0251353f //x=83.935 //y=1.74
c830 ( 239 0 ) capacitor c=0.0234318f //x=83.935 //y=1.43
c831 ( 238 0 ) capacitor c=0.0192547f //x=83.935 //y=1.085
c832 ( 235 0 ) capacitor c=0.0714656f //x=83.84 //y=5.05
c833 ( 232 0 ) capacitor c=0.0186579f //x=83.78 //y=1.585
c834 ( 230 0 ) capacitor c=0.0157803f //x=83.78 //y=0.93
c835 ( 229 0 ) capacitor c=0.0134011f //x=83.475 //y=4.975
c836 ( 228 0 ) capacitor c=0.0243282f //x=83.765 //y=4.975
c837 ( 227 0 ) capacitor c=0.0364928f //x=83.405 //y=1.43
c838 ( 226 0 ) capacitor c=0.0174823f //x=83.405 //y=1.085
c839 ( 222 0 ) capacitor c=0.0443175f //x=22.1 //y=1.44
c840 ( 221 0 ) capacitor c=0.0199703f //x=22.1 //y=1.095
c841 ( 218 0 ) capacitor c=0.0162526f //x=21.945 //y=1.595
c842 ( 216 0 ) capacitor c=0.0157807f //x=21.945 //y=0.94
c843 ( 211 0 ) capacitor c=0.0220935f //x=21.57 //y=1.75
c844 ( 210 0 ) capacitor c=0.0207489f //x=21.57 //y=1.44
c845 ( 209 0 ) capacitor c=0.0194091f //x=21.57 //y=1.095
c846 ( 205 0 ) capacitor c=0.11081f //x=86.3 //y=6.205
c847 ( 204 0 ) capacitor c=0.154997f //x=85.86 //y=6.205
c848 ( 203 0 ) capacitor c=0.155934f //x=83.84 //y=6.205
c849 ( 202 0 ) capacitor c=0.110594f //x=83.4 //y=6.205
c850 ( 201 0 ) capacitor c=0.159671f //x=21.76 //y=6.2
c851 ( 200 0 ) capacitor c=0.110208f //x=21.32 //y=6.2
c852 ( 193 0 ) capacitor c=7.7962e-19 //x=85.59 //y=4.885
c853 ( 188 0 ) capacitor c=7.89145e-19 //x=85.59 //y=2.26
c854 ( 183 0 ) capacitor c=7.79163e-19 //x=84.11 //y=4.885
c855 ( 174 0 ) capacitor c=4.74639e-19 //x=84.11 //y=2.26
c856 ( 157 0 ) capacitor c=0.0322017f //x=25.17 //y=5.56
c857 ( 149 0 ) capacitor c=0.0290435f //x=24.29 //y=5.56
c858 ( 144 0 ) capacitor c=7.7417e-19 //x=21.58 //y=4.88
c859 ( 135 0 ) capacitor c=7.43216e-19 //x=21.58 //y=2.26
c860 ( 132 0 ) capacitor c=0.0208859f //x=85.425 //y=2.27
c861 ( 131 0 ) capacitor c=0.00247225f //x=85.585 //y=2.27
c862 ( 129 0 ) capacitor c=0.00130247f //x=84.275 //y=2.27
c863 ( 121 0 ) capacitor c=5.98389e-19 //x=21.74 //y=3.155
c864 ( 114 0 ) capacitor c=0.116128f //x=79.145 //y=3.125
c865 ( 112 0 ) capacitor c=0.232755f //x=78.545 //y=3.14
c866 ( 110 0 ) capacitor c=0.00602915f //x=66.57 //y=3.13
c867 ( 108 0 ) capacitor c=0.0185118f //x=65.97 //y=3.14
c868 ( 106 0 ) capacitor c=0.0075058f //x=64.715 //y=3.13
c869 ( 104 0 ) capacitor c=0.00690874f //x=64.115 //y=3.14
c870 ( 102 0 ) capacitor c=0.0056712f //x=63.235 //y=3.125
c871 ( 100 0 ) capacitor c=0.0185731f //x=62.635 //y=3.14
c872 ( 98 0 ) capacitor c=0.00790392f //x=61.39 //y=3.125
c873 ( 96 0 ) capacitor c=0.0132354f //x=60.79 //y=3.14
c874 ( 94 0 ) capacitor c=0.00360584f //x=59.55 //y=3.155
c875 ( 92 0 ) capacitor c=0.0340843f //x=58.95 //y=3.14
c876 ( 90 0 ) capacitor c=0.00454802f //x=55.835 //y=3.125
c877 ( 88 0 ) capacitor c=0.160489f //x=55.235 //y=3.14
c878 ( 86 0 ) capacitor c=0.00594697f //x=40.67 //y=3.13
c879 ( 84 0 ) capacitor c=0.0156828f //x=40.07 //y=3.14
c880 ( 82 0 ) capacitor c=0.00598602f //x=38.815 //y=3.13
c881 ( 80 0 ) capacitor c=0.00692108f //x=38.215 //y=3.14
c882 ( 78 0 ) capacitor c=0.0053442f //x=37.335 //y=3.125
c883 ( 76 0 ) capacitor c=0.0155657f //x=36.735 //y=3.14
c884 ( 74 0 ) capacitor c=0.00616696f //x=35.49 //y=3.125
c885 ( 72 0 ) capacitor c=0.0109271f //x=34.89 //y=3.14
c886 ( 70 0 ) capacitor c=0.0032089f //x=33.64 //y=3.15
c887 ( 68 0 ) capacitor c=0.0338694f //x=33.04 //y=3.14
c888 ( 67 0 ) capacitor c=0.0611852f //x=29.505 //y=3.125
c889 ( 66 0 ) capacitor c=0.00475936f //x=29.935 //y=3.125
c890 ( 64 0 ) capacitor c=0.0503135f //x=25.49 //y=3.14
c891 ( 50 0 ) capacitor c=0.0148135f //x=84.105 //y=3.14
c892 ( 46 0 ) capacitor c=0.0158166f //x=25.65 //y=3.14
c893 ( 43 0 ) capacitor c=0.0112415f //x=25.21 //y=1.18
c894 ( 41 0 ) capacitor c=5.78613e-19 //x=25.17 //y=5.56
c895 ( 38 0 ) capacitor c=0.0108004f //x=25.17 //y=5.38
c896 ( 37 0 ) capacitor c=0.00895634f //x=24.29 //y=5.56
c897 ( 32 0 ) capacitor c=0.0145644f //x=21.58 //y=3.14
c898 ( 26 0 ) capacitor c=0.0767052f //x=85.59 //y=4.755
c899 ( 25 0 ) capacitor c=0.00995077f //x=85.59 //y=2.43
c900 ( 24 0 ) capacitor c=0.0562407f //x=84.11 //y=4.76
c901 ( 23 0 ) capacitor c=0.0138761f //x=84.11 //y=3.3
c902 ( 22 0 ) capacitor c=0.0154555f //x=84.11 //y=2.98
c903 ( 21 0 ) capacitor c=0.0100761f //x=84.11 //y=2.43
c904 ( 20 0 ) capacitor c=0.0571725f //x=25.65 //y=5.295
c905 ( 19 0 ) capacitor c=0.0138106f //x=25.65 //y=3.315
c906 ( 18 0 ) capacitor c=0.0273346f //x=25.65 //y=2.995
c907 ( 16 0 ) capacitor c=0.00466468f //x=25.295 //y=1.835
c908 ( 15 0 ) capacitor c=0.0118312f //x=25.565 //y=1.835
c909 ( 13 0 ) capacitor c=0.0114168f //x=25.565 //y=5.38
c910 ( 12 0 ) capacitor c=0.0134844f //x=25.21 //y=1.75
c911 ( 7 0 ) capacitor c=0.0134407f //x=25.055 //y=5.38
c912 ( 4 0 ) capacitor c=0.0415703f //x=21.58 //y=4.75
c913 ( 3 0 ) capacitor c=0.0126106f //x=21.58 //y=3.315
c914 ( 2 0 ) capacitor c=0.0129767f //x=21.58 //y=2.995
c915 ( 1 0 ) capacitor c=0.00550278f //x=21.58 //y=2.375
r916 (  262 263 ) resistor r=52.7279 //w=0.214 //l=0.165 //layer=ply \
 //thickness=0.18 //x=21.58 //y=2.26 //x2=21.58 //y2=2.095
r917 (  257 286 ) resistor r=45.1352 //w=0.168 //l=0.173853 //layer=ply \
 //thickness=0.18 //x=86.295 //y=1.39 //x2=86.255 //y2=1.545
r918 (  256 285 ) resistor r=45.1352 //w=0.168 //l=0.173853 //layer=ply \
 //thickness=0.18 //x=86.295 //y=1.045 //x2=86.255 //y2=0.89
r919 (  256 257 ) resistor r=176.904 //w=0.094 //l=0.345 //layer=ply \
 //thickness=0.18 //x=86.295 //y=1.045 //x2=86.295 //y2=1.39
r920 (  254 258 ) resistor r=26.9307 //w=0.15 //l=0.106066 //layer=ply \
 //thickness=0.18 //x=86.225 //y=4.975 //x2=86.3 //y2=5.05
r921 (  254 255 ) resistor r=148.702 //w=0.094 //l=0.29 //layer=ply \
 //thickness=0.18 //x=86.225 //y=4.975 //x2=85.935 //y2=4.975
r922 (  252 284 ) resistor r=10.701 //w=0.21 //l=0.115 //layer=ply \
 //thickness=0.18 //x=85.92 //y=1.545 //x2=85.805 //y2=1.545
r923 (  251 286 ) resistor r=5.52526 //w=0.168 //l=0.115 //layer=ply \
 //thickness=0.18 //x=86.14 //y=1.545 //x2=86.255 //y2=1.545
r924 (  250 283 ) resistor r=5.52526 //w=0.168 //l=0.115 //layer=ply \
 //thickness=0.18 //x=85.92 //y=0.89 //x2=85.805 //y2=0.89
r925 (  249 285 ) resistor r=5.52526 //w=0.168 //l=0.115 //layer=ply \
 //thickness=0.18 //x=86.14 //y=0.89 //x2=86.255 //y2=0.89
r926 (  249 250 ) resistor r=112.809 //w=0.094 //l=0.22 //layer=ply \
 //thickness=0.18 //x=86.14 //y=0.89 //x2=85.92 //y2=0.89
r927 (  246 255 ) resistor r=22.1787 //w=0.252 //l=0.106066 //layer=ply \
 //thickness=0.18 //x=85.86 //y=5.05 //x2=85.935 //y2=4.975
r928 (  246 282 ) resistor r=51.6429 //w=0.252 //l=0.34271 //layer=ply \
 //thickness=0.18 //x=85.86 //y=5.05 //x2=85.59 //y2=4.885
r929 (  245 280 ) resistor r=30.4513 //w=0.277 //l=0.243926 //layer=ply \
 //thickness=0.18 //x=85.765 //y=2.095 //x2=85.59 //y2=2.26
r930 (  244 284 ) resistor r=39.5823 //w=0.21 //l=0.173853 //layer=ply \
 //thickness=0.18 //x=85.765 //y=1.7 //x2=85.805 //y2=1.545
r931 (  244 245 ) resistor r=202.543 //w=0.094 //l=0.395 //layer=ply \
 //thickness=0.18 //x=85.765 //y=1.7 //x2=85.765 //y2=2.095
r932 (  243 284 ) resistor r=39.5823 //w=0.21 //l=0.173853 //layer=ply \
 //thickness=0.18 //x=85.765 //y=1.39 //x2=85.805 //y2=1.545
r933 (  242 283 ) resistor r=45.1352 //w=0.168 //l=0.173853 //layer=ply \
 //thickness=0.18 //x=85.765 //y=1.045 //x2=85.805 //y2=0.89
r934 (  242 243 ) resistor r=176.904 //w=0.094 //l=0.345 //layer=ply \
 //thickness=0.18 //x=85.765 //y=1.045 //x2=85.765 //y2=1.39
r935 (  241 276 ) resistor r=30.4513 //w=0.277 //l=0.243926 //layer=ply \
 //thickness=0.18 //x=83.935 //y=2.095 //x2=84.11 //y2=2.26
r936 (  240 274 ) resistor r=39.5823 //w=0.21 //l=0.173853 //layer=ply \
 //thickness=0.18 //x=83.935 //y=1.74 //x2=83.895 //y2=1.585
r937 (  240 241 ) resistor r=182.032 //w=0.094 //l=0.355 //layer=ply \
 //thickness=0.18 //x=83.935 //y=1.74 //x2=83.935 //y2=2.095
r938 (  239 274 ) resistor r=39.5823 //w=0.21 //l=0.173853 //layer=ply \
 //thickness=0.18 //x=83.935 //y=1.43 //x2=83.895 //y2=1.585
r939 (  238 273 ) resistor r=45.1352 //w=0.168 //l=0.173853 //layer=ply \
 //thickness=0.18 //x=83.935 //y=1.085 //x2=83.895 //y2=0.93
r940 (  238 239 ) resistor r=176.904 //w=0.094 //l=0.345 //layer=ply \
 //thickness=0.18 //x=83.935 //y=1.085 //x2=83.935 //y2=1.43
r941 (  235 278 ) resistor r=51.6429 //w=0.252 //l=0.34271 //layer=ply \
 //thickness=0.18 //x=83.84 //y=5.05 //x2=84.11 //y2=4.885
r942 (  233 272 ) resistor r=5.52526 //w=0.168 //l=0.115 //layer=ply \
 //thickness=0.18 //x=83.56 //y=1.585 //x2=83.445 //y2=1.585
r943 (  232 274 ) resistor r=10.701 //w=0.21 //l=0.115 //layer=ply \
 //thickness=0.18 //x=83.78 //y=1.585 //x2=83.895 //y2=1.585
r944 (  231 271 ) resistor r=5.52526 //w=0.168 //l=0.115 //layer=ply \
 //thickness=0.18 //x=83.56 //y=0.93 //x2=83.445 //y2=0.93
r945 (  230 273 ) resistor r=5.52526 //w=0.168 //l=0.115 //layer=ply \
 //thickness=0.18 //x=83.78 //y=0.93 //x2=83.895 //y2=0.93
r946 (  230 231 ) resistor r=112.809 //w=0.094 //l=0.22 //layer=ply \
 //thickness=0.18 //x=83.78 //y=0.93 //x2=83.56 //y2=0.93
r947 (  228 235 ) resistor r=22.1787 //w=0.252 //l=0.106066 //layer=ply \
 //thickness=0.18 //x=83.765 //y=4.975 //x2=83.84 //y2=5.05
r948 (  228 229 ) resistor r=148.702 //w=0.094 //l=0.29 //layer=ply \
 //thickness=0.18 //x=83.765 //y=4.975 //x2=83.475 //y2=4.975
r949 (  227 272 ) resistor r=45.1352 //w=0.168 //l=0.173853 //layer=ply \
 //thickness=0.18 //x=83.405 //y=1.43 //x2=83.445 //y2=1.585
r950 (  226 271 ) resistor r=45.1352 //w=0.168 //l=0.173853 //layer=ply \
 //thickness=0.18 //x=83.405 //y=1.085 //x2=83.445 //y2=0.93
r951 (  226 227 ) resistor r=176.904 //w=0.094 //l=0.345 //layer=ply \
 //thickness=0.18 //x=83.405 //y=1.085 //x2=83.405 //y2=1.43
r952 (  223 229 ) resistor r=26.9307 //w=0.15 //l=0.106066 //layer=ply \
 //thickness=0.18 //x=83.4 //y=5.05 //x2=83.475 //y2=4.975
r953 (  222 270 ) resistor r=45.1352 //w=0.168 //l=0.173853 //layer=ply \
 //thickness=0.18 //x=22.1 //y=1.44 //x2=22.06 //y2=1.595
r954 (  221 269 ) resistor r=45.1352 //w=0.168 //l=0.173853 //layer=ply \
 //thickness=0.18 //x=22.1 //y=1.095 //x2=22.06 //y2=0.94
r955 (  221 222 ) resistor r=176.904 //w=0.094 //l=0.345 //layer=ply \
 //thickness=0.18 //x=22.1 //y=1.095 //x2=22.1 //y2=1.44
r956 (  219 266 ) resistor r=10.701 //w=0.21 //l=0.115 //layer=ply \
 //thickness=0.18 //x=21.725 //y=1.595 //x2=21.61 //y2=1.595
r957 (  218 270 ) resistor r=5.52526 //w=0.168 //l=0.115 //layer=ply \
 //thickness=0.18 //x=21.945 //y=1.595 //x2=22.06 //y2=1.595
r958 (  217 265 ) resistor r=5.52526 //w=0.168 //l=0.115 //layer=ply \
 //thickness=0.18 //x=21.725 //y=0.94 //x2=21.61 //y2=0.94
r959 (  216 269 ) resistor r=5.52526 //w=0.168 //l=0.115 //layer=ply \
 //thickness=0.18 //x=21.945 //y=0.94 //x2=22.06 //y2=0.94
r960 (  216 217 ) resistor r=112.809 //w=0.094 //l=0.22 //layer=ply \
 //thickness=0.18 //x=21.945 //y=0.94 //x2=21.725 //y2=0.94
r961 (  213 268 ) resistor r=37.236 //w=0.233 //l=0.249199 //layer=ply \
 //thickness=0.18 //x=21.76 //y=5.045 //x2=21.58 //y2=4.88
r962 (  211 266 ) resistor r=39.5823 //w=0.21 //l=0.173853 //layer=ply \
 //thickness=0.18 //x=21.57 //y=1.75 //x2=21.61 //y2=1.595
r963 (  211 263 ) resistor r=176.904 //w=0.094 //l=0.345 //layer=ply \
 //thickness=0.18 //x=21.57 //y=1.75 //x2=21.57 //y2=2.095
r964 (  210 266 ) resistor r=39.5823 //w=0.21 //l=0.173853 //layer=ply \
 //thickness=0.18 //x=21.57 //y=1.44 //x2=21.61 //y2=1.595
r965 (  209 265 ) resistor r=45.1352 //w=0.168 //l=0.173853 //layer=ply \
 //thickness=0.18 //x=21.57 //y=1.095 //x2=21.61 //y2=0.94
r966 (  209 210 ) resistor r=176.904 //w=0.094 //l=0.345 //layer=ply \
 //thickness=0.18 //x=21.57 //y=1.095 //x2=21.57 //y2=1.44
r967 (  206 268 ) resistor r=53.7854 //w=0.233 //l=0.332415 //layer=ply \
 //thickness=0.18 //x=21.32 //y=5.045 //x2=21.58 //y2=4.88
r968 (  205 258 ) resistor r=592.245 //w=0.094 //l=1.155 //layer=ply \
 //thickness=0.18 //x=86.3 //y=6.205 //x2=86.3 //y2=5.05
r969 (  204 246 ) resistor r=592.245 //w=0.094 //l=1.155 //layer=ply \
 //thickness=0.18 //x=85.86 //y=6.205 //x2=85.86 //y2=5.05
r970 (  203 235 ) resistor r=592.245 //w=0.094 //l=1.155 //layer=ply \
 //thickness=0.18 //x=83.84 //y=6.205 //x2=83.84 //y2=5.05
r971 (  202 223 ) resistor r=592.245 //w=0.094 //l=1.155 //layer=ply \
 //thickness=0.18 //x=83.4 //y=6.205 //x2=83.4 //y2=5.05
r972 (  201 213 ) resistor r=592.245 //w=0.094 //l=1.155 //layer=ply \
 //thickness=0.18 //x=21.76 //y=6.2 //x2=21.76 //y2=5.045
r973 (  200 206 ) resistor r=592.245 //w=0.094 //l=1.155 //layer=ply \
 //thickness=0.18 //x=21.32 //y=6.2 //x2=21.32 //y2=5.045
r974 (  199 251 ) resistor r=56.4043 //w=0.094 //l=0.11 //layer=ply \
 //thickness=0.18 //x=86.03 //y=1.545 //x2=86.14 //y2=1.545
r975 (  199 252 ) resistor r=56.4043 //w=0.094 //l=0.11 //layer=ply \
 //thickness=0.18 //x=86.03 //y=1.545 //x2=85.92 //y2=1.545
r976 (  198 232 ) resistor r=56.4043 //w=0.094 //l=0.11 //layer=ply \
 //thickness=0.18 //x=83.67 //y=1.585 //x2=83.78 //y2=1.585
r977 (  198 233 ) resistor r=56.4043 //w=0.094 //l=0.11 //layer=ply \
 //thickness=0.18 //x=83.67 //y=1.585 //x2=83.56 //y2=1.585
r978 (  197 218 ) resistor r=56.4043 //w=0.094 //l=0.11 //layer=ply \
 //thickness=0.18 //x=21.835 //y=1.595 //x2=21.945 //y2=1.595
r979 (  197 219 ) resistor r=56.4043 //w=0.094 //l=0.11 //layer=ply \
 //thickness=0.18 //x=21.835 //y=1.595 //x2=21.725 //y2=1.595
r980 (  193 282 ) resistor r=152 //w=0.17 //l=0.17 //layer=licon //count=1 \
 //x=85.59 //y=4.885 //x2=85.59 //y2=4.885
r981 (  188 280 ) resistor r=152 //w=0.17 //l=0.17 //layer=licon //count=1 \
 //x=85.59 //y=2.26 //x2=85.59 //y2=2.26
r982 (  183 278 ) resistor r=152 //w=0.17 //l=0.17 //layer=licon //count=1 \
 //x=84.11 //y=4.885 //x2=84.11 //y2=4.885
r983 (  174 276 ) resistor r=152 //w=0.17 //l=0.17 //layer=licon //count=1 \
 //x=84.11 //y=2.26 //x2=84.11 //y2=2.26
r984 (  157 290 ) resistor r=23.615 //w=0.187 //l=0.345 //layer=li \
 //thickness=0.1 //x=25.17 //y=5.56 //x2=25.17 //y2=5.905
r985 (  149 289 ) resistor r=23.615 //w=0.187 //l=0.345 //layer=li \
 //thickness=0.1 //x=24.29 //y=5.56 //x2=24.29 //y2=5.905
r986 (  144 268 ) resistor r=152 //w=0.17 //l=0.17 //layer=licon //count=1 \
 //x=21.58 //y=4.88 //x2=21.58 //y2=4.88
r987 (  135 262 ) resistor r=152 //w=0.17 //l=0.17 //layer=licon //count=1 \
 //x=21.58 //y=2.26 //x2=21.58 //y2=2.26
r988 (  131 132 ) resistor r=0.10734 //w=0.281 //l=0.16 //layer=m2 \
 //thickness=0.36 //x=85.585 //y=2.27 //x2=85.425 //y2=2.27
r989 (  129 132 ) resistor r=1.09733 //w=0.131 //l=1.15 //layer=m2 \
 //thickness=0.36 //x=84.275 //y=2.26 //x2=85.425 //y2=2.26
r990 (  127 129 ) resistor r=0.10734 //w=0.281 //l=0.16 //layer=m2 \
 //thickness=0.36 //x=84.115 //y=2.27 //x2=84.275 //y2=2.27
r991 (  119 121 ) resistor r=0.10734 //w=0.281 //l=0.16 //layer=m2 \
 //thickness=0.36 //x=21.58 //y=3.155 //x2=21.74 //y2=3.155
r992 (  114 125 ) resistor r=3.44497 //w=0.18 //l=4.96749 //layer=m2 \
 //thickness=0.36 //x=79.145 //y=3.125 //x2=84.105 //y2=3.14
r993 (  114 115 ) resistor r=0.410305 //w=0.131 //l=0.43 //layer=m2 \
 //thickness=0.36 //x=79.145 //y=3.125 //x2=78.715 //y2=3.125
r994 (  112 115 ) resistor r=0.125 //w=0.17 //l=0.177341 //layer=m2 \
 //thickness=0.36 //x=78.545 //y=3.14 //x2=78.715 //y2=3.125
r995 (  112 113 ) resistor r=11.1832 //w=0.131 //l=11.72 //layer=m2 \
 //thickness=0.36 //x=78.545 //y=3.14 //x2=66.825 //y2=3.14
r996 (  110 113 ) resistor r=0.1875 //w=0.17 //l=0.259952 //layer=m2 \
 //thickness=0.36 //x=66.57 //y=3.13 //x2=66.825 //y2=3.14
r997 (  110 111 ) resistor r=0.410305 //w=0.131 //l=0.43 //layer=m2 \
 //thickness=0.36 //x=66.57 //y=3.13 //x2=66.14 //y2=3.13
r998 (  108 111 ) resistor r=0.125 //w=0.17 //l=0.174929 //layer=m2 \
 //thickness=0.36 //x=65.97 //y=3.14 //x2=66.14 //y2=3.13
r999 (  108 109 ) resistor r=0.954198 //w=0.131 //l=1 //layer=m2 \
 //thickness=0.36 //x=65.97 //y=3.14 //x2=64.97 //y2=3.14
r1000 (  106 109 ) resistor r=0.1875 //w=0.17 //l=0.259952 //layer=m2 \
 //thickness=0.36 //x=64.715 //y=3.13 //x2=64.97 //y2=3.14
r1001 (  106 107 ) resistor r=0.410305 //w=0.131 //l=0.43 //layer=m2 \
 //thickness=0.36 //x=64.715 //y=3.13 //x2=64.285 //y2=3.13
r1002 (  104 107 ) resistor r=0.125 //w=0.17 //l=0.174929 //layer=m2 \
 //thickness=0.36 //x=64.115 //y=3.14 //x2=64.285 //y2=3.13
r1003 (  104 105 ) resistor r=0.596374 //w=0.131 //l=0.625 //layer=m2 \
 //thickness=0.36 //x=64.115 //y=3.14 //x2=63.49 //y2=3.14
r1004 (  102 105 ) resistor r=0.1875 //w=0.17 //l=0.262393 //layer=m2 \
 //thickness=0.36 //x=63.235 //y=3.125 //x2=63.49 //y2=3.14
r1005 (  102 103 ) resistor r=0.410305 //w=0.131 //l=0.43 //layer=m2 \
 //thickness=0.36 //x=63.235 //y=3.125 //x2=62.805 //y2=3.125
r1006 (  100 103 ) resistor r=0.125 //w=0.17 //l=0.177341 //layer=m2 \
 //thickness=0.36 //x=62.635 //y=3.14 //x2=62.805 //y2=3.125
r1007 (  100 101 ) resistor r=0.944656 //w=0.131 //l=0.99 //layer=m2 \
 //thickness=0.36 //x=62.635 //y=3.14 //x2=61.645 //y2=3.14
r1008 (  98 101 ) resistor r=0.1875 //w=0.17 //l=0.262393 //layer=m2 \
 //thickness=0.36 //x=61.39 //y=3.125 //x2=61.645 //y2=3.14
r1009 (  98 99 ) resistor r=0.410305 //w=0.131 //l=0.43 //layer=m2 \
 //thickness=0.36 //x=61.39 //y=3.125 //x2=60.96 //y2=3.125
r1010 (  96 99 ) resistor r=0.125 //w=0.17 //l=0.177341 //layer=m2 \
 //thickness=0.36 //x=60.79 //y=3.14 //x2=60.96 //y2=3.125
r1011 (  96 97 ) resistor r=1.02099 //w=0.131 //l=1.07 //layer=m2 \
 //thickness=0.36 //x=60.79 //y=3.14 //x2=59.72 //y2=3.14
r1012 (  94 97 ) resistor r=0.125 //w=0.17 //l=0.177341 //layer=m2 \
 //thickness=0.36 //x=59.55 //y=3.155 //x2=59.72 //y2=3.14
r1013 (  94 95 ) resistor r=0.329198 //w=0.131 //l=0.345 //layer=m2 \
 //thickness=0.36 //x=59.55 //y=3.155 //x2=59.205 //y2=3.155
r1014 (  92 95 ) resistor r=0.1875 //w=0.17 //l=0.262393 //layer=m2 \
 //thickness=0.36 //x=58.95 //y=3.14 //x2=59.205 //y2=3.155
r1015 (  92 93 ) resistor r=2.72901 //w=0.131 //l=2.86 //layer=m2 \
 //thickness=0.36 //x=58.95 //y=3.14 //x2=56.09 //y2=3.14
r1016 (  90 93 ) resistor r=0.1875 //w=0.17 //l=0.262393 //layer=m2 \
 //thickness=0.36 //x=55.835 //y=3.125 //x2=56.09 //y2=3.14
r1017 (  90 91 ) resistor r=0.410305 //w=0.131 //l=0.43 //layer=m2 \
 //thickness=0.36 //x=55.835 //y=3.125 //x2=55.405 //y2=3.125
r1018 (  88 91 ) resistor r=0.125 //w=0.17 //l=0.177341 //layer=m2 \
 //thickness=0.36 //x=55.235 //y=3.14 //x2=55.405 //y2=3.125
r1019 (  88 89 ) resistor r=13.6546 //w=0.131 //l=14.31 //layer=m2 \
 //thickness=0.36 //x=55.235 //y=3.14 //x2=40.925 //y2=3.14
r1020 (  86 89 ) resistor r=0.1875 //w=0.17 //l=0.259952 //layer=m2 \
 //thickness=0.36 //x=40.67 //y=3.13 //x2=40.925 //y2=3.14
r1021 (  86 87 ) resistor r=0.410305 //w=0.131 //l=0.43 //layer=m2 \
 //thickness=0.36 //x=40.67 //y=3.13 //x2=40.24 //y2=3.13
r1022 (  84 87 ) resistor r=0.125 //w=0.17 //l=0.174929 //layer=m2 \
 //thickness=0.36 //x=40.07 //y=3.14 //x2=40.24 //y2=3.13
r1023 (  84 85 ) resistor r=0.954198 //w=0.131 //l=1 //layer=m2 \
 //thickness=0.36 //x=40.07 //y=3.14 //x2=39.07 //y2=3.14
r1024 (  82 85 ) resistor r=0.1875 //w=0.17 //l=0.259952 //layer=m2 \
 //thickness=0.36 //x=38.815 //y=3.13 //x2=39.07 //y2=3.14
r1025 (  82 83 ) resistor r=0.410305 //w=0.131 //l=0.43 //layer=m2 \
 //thickness=0.36 //x=38.815 //y=3.13 //x2=38.385 //y2=3.13
r1026 (  80 83 ) resistor r=0.125 //w=0.17 //l=0.174929 //layer=m2 \
 //thickness=0.36 //x=38.215 //y=3.14 //x2=38.385 //y2=3.13
r1027 (  80 81 ) resistor r=0.596374 //w=0.131 //l=0.625 //layer=m2 \
 //thickness=0.36 //x=38.215 //y=3.14 //x2=37.59 //y2=3.14
r1028 (  78 81 ) resistor r=0.1875 //w=0.17 //l=0.262393 //layer=m2 \
 //thickness=0.36 //x=37.335 //y=3.125 //x2=37.59 //y2=3.14
r1029 (  78 79 ) resistor r=0.410305 //w=0.131 //l=0.43 //layer=m2 \
 //thickness=0.36 //x=37.335 //y=3.125 //x2=36.905 //y2=3.125
r1030 (  76 79 ) resistor r=0.125 //w=0.17 //l=0.177341 //layer=m2 \
 //thickness=0.36 //x=36.735 //y=3.14 //x2=36.905 //y2=3.125
r1031 (  76 77 ) resistor r=0.944656 //w=0.131 //l=0.99 //layer=m2 \
 //thickness=0.36 //x=36.735 //y=3.14 //x2=35.745 //y2=3.14
r1032 (  74 77 ) resistor r=0.1875 //w=0.17 //l=0.262393 //layer=m2 \
 //thickness=0.36 //x=35.49 //y=3.125 //x2=35.745 //y2=3.14
r1033 (  74 75 ) resistor r=0.410305 //w=0.131 //l=0.43 //layer=m2 \
 //thickness=0.36 //x=35.49 //y=3.125 //x2=35.06 //y2=3.125
r1034 (  72 75 ) resistor r=0.125 //w=0.17 //l=0.177341 //layer=m2 \
 //thickness=0.36 //x=34.89 //y=3.14 //x2=35.06 //y2=3.125
r1035 (  72 73 ) resistor r=1.03053 //w=0.131 //l=1.08 //layer=m2 \
 //thickness=0.36 //x=34.89 //y=3.14 //x2=33.81 //y2=3.14
r1036 (  70 73 ) resistor r=0.125 //w=0.17 //l=0.174929 //layer=m2 \
 //thickness=0.36 //x=33.64 //y=3.15 //x2=33.81 //y2=3.14
r1037 (  70 71 ) resistor r=0.329198 //w=0.131 //l=0.345 //layer=m2 \
 //thickness=0.36 //x=33.64 //y=3.15 //x2=33.295 //y2=3.15
r1038 (  68 71 ) resistor r=0.1875 //w=0.17 //l=0.259952 //layer=m2 \
 //thickness=0.36 //x=33.04 //y=3.14 //x2=33.295 //y2=3.15
r1039 (  68 69 ) resistor r=2.71947 //w=0.131 //l=2.85 //layer=m2 \
 //thickness=0.36 //x=33.04 //y=3.14 //x2=30.19 //y2=3.14
r1040 (  67 123 ) resistor r=2.64838 //w=0.182 //l=3.86997 //layer=m2 \
 //thickness=0.36 //x=29.505 //y=3.125 //x2=25.65 //y2=3.155
r1041 (  66 69 ) resistor r=0.1875 //w=0.17 //l=0.262393 //layer=m2 \
 //thickness=0.36 //x=29.935 //y=3.125 //x2=30.19 //y2=3.14
r1042 (  66 67 ) resistor r=0.410305 //w=0.131 //l=0.43 //layer=m2 \
 //thickness=0.36 //x=29.935 //y=3.125 //x2=29.505 //y2=3.125
r1043 (  64 123 ) resistor r=0.110608 //w=0.182 //l=0.167332 //layer=m2 \
 //thickness=0.36 //x=25.49 //y=3.14 //x2=25.65 //y2=3.155
r1044 (  64 121 ) resistor r=3.57824 //w=0.131 //l=3.75 //layer=m2 \
 //thickness=0.36 //x=25.49 //y=3.14 //x2=21.74 //y2=3.14
r1045 (  63 193 ) resistor r=9.3 //w=0.17 //l=0.17 //layer=mcon //count=1 \
 //x=85.59 //y=4.885 //x2=85.59 //y2=4.885
r1046 (  61 131 ) resistor r=4.5 //w=0.15 //l=0.15 //layer=via1 //count=1 \
 //x=85.585 //y=2.27 //x2=85.585 //y2=2.27
r1047 (  59 188 ) resistor r=9.3 //w=0.17 //l=0.17 //layer=mcon //count=1 \
 //x=85.59 //y=2.26 //x2=85.59 //y2=2.26
r1048 (  59 61 ) resistor r=0.00334225 //w=0.374 //l=0.01 //layer=m1 \
 //thickness=0.36 //x=85.535 //y=2.26 //x2=85.535 //y2=2.27
r1049 (  57 127 ) resistor r=4.5 //w=0.15 //l=0.15 //layer=via1 //count=1 \
 //x=84.115 //y=2.27 //x2=84.115 //y2=2.27
r1050 (  55 174 ) resistor r=9.3 //w=0.17 //l=0.17 //layer=mcon //count=1 \
 //x=84.11 //y=2.26 //x2=84.11 //y2=2.26
r1051 (  55 57 ) resistor r=0.00334225 //w=0.374 //l=0.01 //layer=m1 \
 //thickness=0.36 //x=84.165 //y=2.26 //x2=84.165 //y2=2.27
r1052 (  53 183 ) resistor r=9.3 //w=0.17 //l=0.17 //layer=mcon //count=1 \
 //x=84.11 //y=4.885 //x2=84.11 //y2=4.885
r1053 (  50 125 ) resistor r=4.5 //w=0.15 //l=0.15 //layer=via1 //count=1 \
 //x=84.105 //y=3.14 //x2=84.105 //y2=3.14
r1054 (  48 123 ) resistor r=4.5 //w=0.15 //l=0.15 //layer=via1 //count=1 \
 //x=25.65 //y=3.155 //x2=25.65 //y2=3.155
r1055 (  46 48 ) resistor r=0.0049867 //w=0.376 //l=0.015 //layer=m1 \
 //thickness=0.36 //x=25.597 //y=3.14 //x2=25.597 //y2=3.155
r1056 (  43 287 ) resistor r=9.3 //w=0.17 //l=0.17 //layer=mcon //count=1 \
 //x=25.21 //y=1.18 //x2=25.21 //y2=1.18
r1057 (  41 157 ) resistor r=9.3 //w=0.17 //l=0.17 //layer=mcon //count=1 \
 //x=25.17 //y=5.56 //x2=25.17 //y2=5.56
r1058 (  38 41 ) resistor r=0.117801 //w=0.191 //l=0.18 //layer=m1 \
 //thickness=0.36 //x=25.17 //y=5.38 //x2=25.17 //y2=5.56
r1059 (  37 149 ) resistor r=9.3 //w=0.17 //l=0.17 //layer=mcon //count=1 \
 //x=24.29 //y=5.56 //x2=24.29 //y2=5.56
r1060 (  35 37 ) resistor r=0.10274 //w=0.219 //l=0.18 //layer=m1 \
 //thickness=0.36 //x=24.29 //y=5.38 //x2=24.29 //y2=5.56
r1061 (  34 119 ) resistor r=4.5 //w=0.15 //l=0.15 //layer=via1 //count=1 \
 //x=21.58 //y=3.155 //x2=21.58 //y2=3.155
r1062 (  32 34 ) resistor r=0.0049867 //w=0.376 //l=0.015 //layer=m1 \
 //thickness=0.36 //x=21.632 //y=3.14 //x2=21.632 //y2=3.155
r1063 (  30 144 ) resistor r=9.3 //w=0.17 //l=0.17 //layer=mcon //count=1 \
 //x=21.58 //y=4.88 //x2=21.58 //y2=4.88
r1064 (  28 135 ) resistor r=9.3 //w=0.17 //l=0.17 //layer=mcon //count=1 \
 //x=21.58 //y=2.26 //x2=21.58 //y2=2.26
r1065 (  26 63 ) resistor r=0.0777782 //w=0.252 //l=0.131491 //layer=m1 \
 //thickness=0.36 //x=85.59 //y=4.755 //x2=85.587 //y2=4.885
r1066 (  25 61 ) resistor r=0.0910802 //w=0.374 //l=0.185472 //layer=m1 \
 //thickness=0.36 //x=85.59 //y=2.43 //x2=85.535 //y2=2.27
r1067 (  25 26 ) resistor r=2.21851 //w=0.131 //l=2.325 //layer=m1 \
 //thickness=0.36 //x=85.59 //y=2.43 //x2=85.59 //y2=4.755
r1068 (  24 53 ) resistor r=0.075298 //w=0.252 //l=0.125 //layer=m1 \
 //thickness=0.36 //x=84.11 //y=4.76 //x2=84.11 //y2=4.885
r1069 (  23 50 ) resistor r=0.0910802 //w=0.374 //l=0.185472 //layer=m1 \
 //thickness=0.36 //x=84.11 //y=3.3 //x2=84.055 //y2=3.14
r1070 (  23 24 ) resistor r=1.39313 //w=0.131 //l=1.46 //layer=m1 \
 //thickness=0.36 //x=84.11 //y=3.3 //x2=84.11 //y2=4.76
r1071 (  22 50 ) resistor r=0.0910802 //w=0.374 //l=0.185472 //layer=m1 \
 //thickness=0.36 //x=84.11 //y=2.98 //x2=84.055 //y2=3.14
r1072 (  21 57 ) resistor r=0.0910802 //w=0.374 //l=0.185472 //layer=m1 \
 //thickness=0.36 //x=84.11 //y=2.43 //x2=84.165 //y2=2.27
r1073 (  21 22 ) resistor r=0.524809 //w=0.131 //l=0.55 //layer=m1 \
 //thickness=0.36 //x=84.11 //y=2.43 //x2=84.11 //y2=2.98
r1074 (  19 48 ) resistor r=0.0911593 //w=0.376 //l=0.184608 //layer=m1 \
 //thickness=0.36 //x=25.65 //y=3.315 //x2=25.597 //y2=3.155
r1075 (  19 20 ) resistor r=1.88931 //w=0.131 //l=1.98 //layer=m1 \
 //thickness=0.36 //x=25.65 //y=3.315 //x2=25.65 //y2=5.295
r1076 (  18 46 ) resistor r=0.0861726 //w=0.376 //l=0.16944 //layer=m1 \
 //thickness=0.36 //x=25.65 //y=2.995 //x2=25.597 //y2=3.14
r1077 (  17 18 ) resistor r=1.02576 //w=0.131 //l=1.075 //layer=m1 \
 //thickness=0.36 //x=25.65 //y=1.92 //x2=25.65 //y2=2.995
r1078 (  15 17 ) resistor r=0.0698411 //w=0.17 //l=0.120208 //layer=m1 \
 //thickness=0.36 //x=25.565 //y=1.835 //x2=25.65 //y2=1.92
r1079 (  15 16 ) resistor r=0.257634 //w=0.131 //l=0.27 //layer=m1 \
 //thickness=0.36 //x=25.565 //y=1.835 //x2=25.295 //y2=1.835
r1080 (  14 38 ) resistor r=0.0257089 //w=0.23 //l=0.115 //layer=m1 \
 //thickness=0.36 //x=25.285 //y=5.38 //x2=25.17 //y2=5.38
r1081 (  13 20 ) resistor r=0.0698411 //w=0.17 //l=0.120208 //layer=m1 \
 //thickness=0.36 //x=25.565 //y=5.38 //x2=25.65 //y2=5.295
r1082 (  13 14 ) resistor r=0.267176 //w=0.131 //l=0.28 //layer=m1 \
 //thickness=0.36 //x=25.565 //y=5.38 //x2=25.285 //y2=5.38
r1083 (  12 16 ) resistor r=0.0698411 //w=0.17 //l=0.120208 //layer=m1 \
 //thickness=0.36 //x=25.21 //y=1.75 //x2=25.295 //y2=1.835
r1084 (  11 43 ) resistor r=0.0913624 //w=0.191 //l=0.12 //layer=m1 \
 //thickness=0.36 //x=25.21 //y=1.3 //x2=25.21 //y2=1.18
r1085 (  11 12 ) resistor r=0.429389 //w=0.131 //l=0.45 //layer=m1 \
 //thickness=0.36 //x=25.21 //y=1.3 //x2=25.21 //y2=1.75
r1086 (  8 35 ) resistor r=0.0227762 //w=0.219 //l=0.115 //layer=m1 \
 //thickness=0.36 //x=24.405 //y=5.38 //x2=24.29 //y2=5.38
r1087 (  7 38 ) resistor r=0.0257089 //w=0.23 //l=0.115 //layer=m1 \
 //thickness=0.36 //x=25.055 //y=5.38 //x2=25.17 //y2=5.38
r1088 (  7 8 ) resistor r=0.620229 //w=0.131 //l=0.65 //layer=m1 \
 //thickness=0.36 //x=25.055 //y=5.38 //x2=24.405 //y2=5.38
r1089 (  4 30 ) resistor r=0.0801089 //w=0.224 //l=0.13 //layer=m1 \
 //thickness=0.36 //x=21.58 //y=4.75 //x2=21.58 //y2=4.88
r1090 (  3 34 ) resistor r=0.0911593 //w=0.376 //l=0.184174 //layer=m1 \
 //thickness=0.36 //x=21.58 //y=3.315 //x2=21.632 //y2=3.155
r1091 (  3 4 ) resistor r=1.36927 //w=0.131 //l=1.435 //layer=m1 \
 //thickness=0.36 //x=21.58 //y=3.315 //x2=21.58 //y2=4.75
r1092 (  2 32 ) resistor r=0.0861726 //w=0.376 //l=0.169012 //layer=m1 \
 //thickness=0.36 //x=21.58 //y=2.995 //x2=21.632 //y2=3.14
r1093 (  1 28 ) resistor r=0.0719237 //w=0.222 //l=0.115 //layer=m1 \
 //thickness=0.36 //x=21.58 //y=2.375 //x2=21.58 //y2=2.26
r1094 (  1 2 ) resistor r=0.591603 //w=0.131 //l=0.62 //layer=m1 \
 //thickness=0.36 //x=21.58 //y=2.375 //x2=21.58 //y2=2.995
ends PM_TMRDFFRNQX1\%noxref_16

subckt PM_TMRDFFRNQX1\%noxref_17 ( 1 2 3 4 7 12 13 15 16 18 19 20 21 22 23 24 \
 25 26 27 28 36 39 40 43 45 48 58 62 67 69 71 72 74 78 84 85 88 97 102 110 127 \
 136 141 150 154 155 156 157 158 159 160 161 162 166 167 168 173 175 178 179 \
 180 181 182 187 189 191 197 198 199 200 201 206 208 210 216 217 219 220 225 \
 229 230 233 241 242 245 253 255 256 )
c593 ( 253 0 ) capacitor c=0.00878249f //x=76.82 //y=1.085
c594 ( 245 0 ) capacitor c=0.0370698f //x=86.72 //y=4.885
c595 ( 242 0 ) capacitor c=0.028421f //x=86.7 //y=2.095
c596 ( 241 0 ) capacitor c=0.0512002f //x=86.7 //y=2.26
c597 ( 233 0 ) capacitor c=0.0387879f //x=80.08 //y=4.885
c598 ( 230 0 ) capacitor c=0.0300885f //x=80.04 //y=2.095
c599 ( 229 0 ) capacitor c=0.0554483f //x=80.04 //y=2.26
c600 ( 225 0 ) capacitor c=0.0654765f //x=73.38 //y=4.88
c601 ( 220 0 ) capacitor c=0.0278202f //x=73.38 //y=2.095
c602 ( 219 0 ) capacitor c=0.0502771f //x=73.38 //y=2.26
c603 ( 217 0 ) capacitor c=0.0237734f //x=87.265 //y=1.435
c604 ( 216 0 ) capacitor c=0.0191782f //x=87.265 //y=1.085
c605 ( 210 0 ) capacitor c=0.0361171f //x=87.11 //y=1.585
c606 ( 208 0 ) capacitor c=0.0157803f //x=87.11 //y=0.93
c607 ( 206 0 ) capacitor c=0.0377178f //x=87.105 //y=4.975
c608 ( 201 0 ) capacitor c=0.020493f //x=86.735 //y=1.74
c609 ( 200 0 ) capacitor c=0.0167049f //x=86.735 //y=1.435
c610 ( 199 0 ) capacitor c=0.0174993f //x=86.735 //y=1.085
c611 ( 198 0 ) capacitor c=0.0443648f //x=80.605 //y=1.43
c612 ( 197 0 ) capacitor c=0.0192211f //x=80.605 //y=1.085
c613 ( 191 0 ) capacitor c=0.0186579f //x=80.45 //y=1.585
c614 ( 189 0 ) capacitor c=0.0157795f //x=80.45 //y=0.93
c615 ( 187 0 ) capacitor c=0.0351351f //x=80.445 //y=4.975
c616 ( 182 0 ) capacitor c=0.0209124f //x=80.075 //y=1.74
c617 ( 181 0 ) capacitor c=0.016848f //x=80.075 //y=1.43
c618 ( 180 0 ) capacitor c=0.0174777f //x=80.075 //y=1.085
c619 ( 179 0 ) capacitor c=0.0443175f //x=73.9 //y=1.44
c620 ( 178 0 ) capacitor c=0.0199703f //x=73.9 //y=1.095
c621 ( 175 0 ) capacitor c=0.0162526f //x=73.745 //y=1.595
c622 ( 173 0 ) capacitor c=0.0157807f //x=73.745 //y=0.94
c623 ( 168 0 ) capacitor c=0.0220935f //x=73.37 //y=1.75
c624 ( 167 0 ) capacitor c=0.0207489f //x=73.37 //y=1.44
c625 ( 166 0 ) capacitor c=0.0194091f //x=73.37 //y=1.095
c626 ( 162 0 ) capacitor c=0.155887f //x=87.18 //y=6.205
c627 ( 161 0 ) capacitor c=0.1106f //x=86.74 //y=6.205
c628 ( 160 0 ) capacitor c=0.154859f //x=80.52 //y=6.205
c629 ( 159 0 ) capacitor c=0.110573f //x=80.08 //y=6.205
c630 ( 158 0 ) capacitor c=0.159671f //x=73.56 //y=6.2
c631 ( 157 0 ) capacitor c=0.110208f //x=73.12 //y=6.2
c632 ( 150 0 ) capacitor c=8.10734e-19 //x=86.72 //y=4.885
c633 ( 141 0 ) capacitor c=0.00105273f //x=86.7 //y=2.26
c634 ( 136 0 ) capacitor c=0.00173056f //x=80.08 //y=4.885
c635 ( 127 0 ) capacitor c=0.00152737f //x=80.04 //y=2.26
c636 ( 110 0 ) capacitor c=0.0320929f //x=76.97 //y=5.56
c637 ( 102 0 ) capacitor c=0.0289929f //x=76.09 //y=5.56
c638 ( 97 0 ) capacitor c=7.7417e-19 //x=73.38 //y=4.88
c639 ( 88 0 ) capacitor c=0.00101179f //x=73.38 //y=2.26
c640 ( 85 0 ) capacitor c=0.147351f //x=86.555 //y=4.21
c641 ( 84 0 ) capacitor c=0.00479868f //x=86.715 //y=4.21
c642 ( 78 0 ) capacitor c=6.13673e-19 //x=73.545 //y=3.865
c643 ( 74 0 ) capacitor c=0.0215252f //x=80.2 //y=4.252
c644 ( 72 0 ) capacitor c=0.0511849f //x=78.8 //y=3.895
c645 ( 71 0 ) capacitor c=0.0016674f //x=79.145 //y=3.895
c646 ( 69 0 ) capacitor c=0.00315672f //x=76.915 //y=3.87
c647 ( 67 0 ) capacitor c=0.0290928f //x=76.315 //y=3.88
c648 ( 62 0 ) capacitor c=0.0138506f //x=86.7 //y=4.25
c649 ( 58 0 ) capacitor c=0.0166522f //x=80.04 //y=4.25
c650 ( 48 0 ) capacitor c=0.0156971f //x=77.45 //y=3.88
c651 ( 45 0 ) capacitor c=0.0114156f //x=77.01 //y=1.18
c652 ( 43 0 ) capacitor c=5.78613e-19 //x=76.97 //y=5.56
c653 ( 40 0 ) capacitor c=0.0116708f //x=76.97 //y=5.38
c654 ( 39 0 ) capacitor c=0.00933044f //x=76.09 //y=5.56
c655 ( 36 0 ) capacitor c=0.0165507f //x=73.38 //y=3.88
c656 ( 28 0 ) capacitor c=0.0124358f //x=86.7 //y=4.74
c657 ( 27 0 ) capacitor c=0.0108569f //x=86.7 //y=4.37
c658 ( 26 0 ) capacitor c=0.0479887f //x=86.7 //y=4.05
c659 ( 25 0 ) capacitor c=0.00651439f //x=86.7 //y=2.38
c660 ( 24 0 ) capacitor c=0.0169891f //x=80.04 //y=4.71
c661 ( 23 0 ) capacitor c=0.0130793f //x=80.04 //y=4.365
c662 ( 22 0 ) capacitor c=0.0559926f //x=80.04 //y=4.045
c663 ( 21 0 ) capacitor c=0.00920415f //x=80.04 //y=2.375
c664 ( 20 0 ) capacitor c=0.0279819f //x=77.45 //y=5.295
c665 ( 19 0 ) capacitor c=0.0124785f //x=77.45 //y=4.055
c666 ( 18 0 ) capacitor c=0.0467232f //x=77.45 //y=3.735
c667 ( 16 0 ) capacitor c=0.00619787f //x=77.095 //y=1.835
c668 ( 15 0 ) capacitor c=0.0147414f //x=77.365 //y=1.835
c669 ( 13 0 ) capacitor c=0.0108239f //x=77.365 //y=5.38
c670 ( 12 0 ) capacitor c=0.0116169f //x=77.01 //y=1.75
c671 ( 7 0 ) capacitor c=0.0136546f //x=76.855 //y=5.38
c672 ( 4 0 ) capacitor c=0.0203648f //x=73.38 //y=4.75
c673 ( 3 0 ) capacitor c=0.0111255f //x=73.38 //y=4.025
c674 ( 2 0 ) capacitor c=0.0342845f //x=73.38 //y=3.705
c675 ( 1 0 ) capacitor c=0.00690423f //x=73.38 //y=2.375
r676 (  247 248 ) resistor r=32.4568 //w=0.214 //l=0.075 //layer=ply \
 //thickness=0.18 //x=86.72 //y=4.975 //x2=86.72 //y2=5.05
r677 (  245 247 ) resistor r=20.271 //w=0.214 //l=0.09 //layer=ply \
 //thickness=0.18 //x=86.72 //y=4.885 //x2=86.72 //y2=4.975
r678 (  241 242 ) resistor r=52.7279 //w=0.214 //l=0.165 //layer=ply \
 //thickness=0.18 //x=86.7 //y=2.26 //x2=86.7 //y2=2.095
r679 (  233 235 ) resistor r=20.271 //w=0.214 //l=0.09 //layer=ply \
 //thickness=0.18 //x=80.08 //y=4.885 //x2=80.08 //y2=4.975
r680 (  229 230 ) resistor r=52.7279 //w=0.214 //l=0.165 //layer=ply \
 //thickness=0.18 //x=80.04 //y=2.26 //x2=80.04 //y2=2.095
r681 (  219 220 ) resistor r=52.7279 //w=0.214 //l=0.165 //layer=ply \
 //thickness=0.18 //x=73.38 //y=2.26 //x2=73.38 //y2=2.095
r682 (  217 252 ) resistor r=4.95774 //w=0.164 //l=0.112 //layer=ply \
 //thickness=0.18 //x=87.265 //y=1.435 //x2=87.265 //y2=1.547
r683 (  216 251 ) resistor r=45.1352 //w=0.168 //l=0.173853 //layer=ply \
 //thickness=0.18 //x=87.265 //y=1.085 //x2=87.225 //y2=0.93
r684 (  216 217 ) resistor r=179.468 //w=0.094 //l=0.35 //layer=ply \
 //thickness=0.18 //x=87.265 //y=1.085 //x2=87.265 //y2=1.435
r685 (  211 250 ) resistor r=10.8103 //w=0.211 //l=0.115 //layer=ply \
 //thickness=0.18 //x=86.89 //y=1.585 //x2=86.775 //y2=1.585
r686 (  210 252 ) resistor r=45.9962 //w=0.164 //l=0.17296 //layer=ply \
 //thickness=0.18 //x=87.11 //y=1.585 //x2=87.265 //y2=1.547
r687 (  209 249 ) resistor r=5.52526 //w=0.168 //l=0.115 //layer=ply \
 //thickness=0.18 //x=86.89 //y=0.93 //x2=86.775 //y2=0.93
r688 (  208 251 ) resistor r=5.52526 //w=0.168 //l=0.115 //layer=ply \
 //thickness=0.18 //x=87.11 //y=0.93 //x2=87.225 //y2=0.93
r689 (  208 209 ) resistor r=112.809 //w=0.094 //l=0.22 //layer=ply \
 //thickness=0.18 //x=87.11 //y=0.93 //x2=86.89 //y2=0.93
r690 (  207 247 ) resistor r=16.5046 //w=0.27 //l=0.135 //layer=ply \
 //thickness=0.18 //x=86.855 //y=4.975 //x2=86.72 //y2=4.975
r691 (  206 213 ) resistor r=26.9307 //w=0.15 //l=0.106066 //layer=ply \
 //thickness=0.18 //x=87.105 //y=4.975 //x2=87.18 //y2=5.05
r692 (  206 207 ) resistor r=128.191 //w=0.094 //l=0.25 //layer=ply \
 //thickness=0.18 //x=87.105 //y=4.975 //x2=86.855 //y2=4.975
r693 (  201 250 ) resistor r=39.5036 //w=0.211 //l=0.173853 //layer=ply \
 //thickness=0.18 //x=86.735 //y=1.74 //x2=86.775 //y2=1.585
r694 (  201 242 ) resistor r=182.032 //w=0.094 //l=0.355 //layer=ply \
 //thickness=0.18 //x=86.735 //y=1.74 //x2=86.735 //y2=2.095
r695 (  200 250 ) resistor r=38.3614 //w=0.211 //l=0.168819 //layer=ply \
 //thickness=0.18 //x=86.735 //y=1.435 //x2=86.775 //y2=1.585
r696 (  199 249 ) resistor r=45.1352 //w=0.168 //l=0.173853 //layer=ply \
 //thickness=0.18 //x=86.735 //y=1.085 //x2=86.775 //y2=0.93
r697 (  199 200 ) resistor r=179.468 //w=0.094 //l=0.35 //layer=ply \
 //thickness=0.18 //x=86.735 //y=1.085 //x2=86.735 //y2=1.435
r698 (  198 239 ) resistor r=45.1352 //w=0.168 //l=0.173853 //layer=ply \
 //thickness=0.18 //x=80.605 //y=1.43 //x2=80.565 //y2=1.585
r699 (  197 238 ) resistor r=45.1352 //w=0.168 //l=0.173853 //layer=ply \
 //thickness=0.18 //x=80.605 //y=1.085 //x2=80.565 //y2=0.93
r700 (  197 198 ) resistor r=176.904 //w=0.094 //l=0.345 //layer=ply \
 //thickness=0.18 //x=80.605 //y=1.085 //x2=80.605 //y2=1.43
r701 (  192 237 ) resistor r=10.701 //w=0.21 //l=0.115 //layer=ply \
 //thickness=0.18 //x=80.23 //y=1.585 //x2=80.115 //y2=1.585
r702 (  191 239 ) resistor r=5.52526 //w=0.168 //l=0.115 //layer=ply \
 //thickness=0.18 //x=80.45 //y=1.585 //x2=80.565 //y2=1.585
r703 (  190 236 ) resistor r=5.52526 //w=0.168 //l=0.115 //layer=ply \
 //thickness=0.18 //x=80.23 //y=0.93 //x2=80.115 //y2=0.93
r704 (  189 238 ) resistor r=5.52526 //w=0.168 //l=0.115 //layer=ply \
 //thickness=0.18 //x=80.45 //y=0.93 //x2=80.565 //y2=0.93
r705 (  189 190 ) resistor r=112.809 //w=0.094 //l=0.22 //layer=ply \
 //thickness=0.18 //x=80.45 //y=0.93 //x2=80.23 //y2=0.93
r706 (  188 235 ) resistor r=16.5046 //w=0.27 //l=0.135 //layer=ply \
 //thickness=0.18 //x=80.215 //y=4.975 //x2=80.08 //y2=4.975
r707 (  187 194 ) resistor r=26.9307 //w=0.15 //l=0.106066 //layer=ply \
 //thickness=0.18 //x=80.445 //y=4.975 //x2=80.52 //y2=5.05
r708 (  187 188 ) resistor r=117.936 //w=0.094 //l=0.23 //layer=ply \
 //thickness=0.18 //x=80.445 //y=4.975 //x2=80.215 //y2=4.975
r709 (  184 235 ) resistor r=32.4568 //w=0.214 //l=0.075 //layer=ply \
 //thickness=0.18 //x=80.08 //y=5.05 //x2=80.08 //y2=4.975
r710 (  182 237 ) resistor r=39.5823 //w=0.21 //l=0.173853 //layer=ply \
 //thickness=0.18 //x=80.075 //y=1.74 //x2=80.115 //y2=1.585
r711 (  182 230 ) resistor r=182.032 //w=0.094 //l=0.355 //layer=ply \
 //thickness=0.18 //x=80.075 //y=1.74 //x2=80.075 //y2=2.095
r712 (  181 237 ) resistor r=39.5823 //w=0.21 //l=0.173853 //layer=ply \
 //thickness=0.18 //x=80.075 //y=1.43 //x2=80.115 //y2=1.585
r713 (  180 236 ) resistor r=45.1352 //w=0.168 //l=0.173853 //layer=ply \
 //thickness=0.18 //x=80.075 //y=1.085 //x2=80.115 //y2=0.93
r714 (  180 181 ) resistor r=176.904 //w=0.094 //l=0.345 //layer=ply \
 //thickness=0.18 //x=80.075 //y=1.085 //x2=80.075 //y2=1.43
r715 (  179 227 ) resistor r=45.1352 //w=0.168 //l=0.173853 //layer=ply \
 //thickness=0.18 //x=73.9 //y=1.44 //x2=73.86 //y2=1.595
r716 (  178 226 ) resistor r=45.1352 //w=0.168 //l=0.173853 //layer=ply \
 //thickness=0.18 //x=73.9 //y=1.095 //x2=73.86 //y2=0.94
r717 (  178 179 ) resistor r=176.904 //w=0.094 //l=0.345 //layer=ply \
 //thickness=0.18 //x=73.9 //y=1.095 //x2=73.9 //y2=1.44
r718 (  176 223 ) resistor r=10.701 //w=0.21 //l=0.115 //layer=ply \
 //thickness=0.18 //x=73.525 //y=1.595 //x2=73.41 //y2=1.595
r719 (  175 227 ) resistor r=5.52526 //w=0.168 //l=0.115 //layer=ply \
 //thickness=0.18 //x=73.745 //y=1.595 //x2=73.86 //y2=1.595
r720 (  174 222 ) resistor r=5.52526 //w=0.168 //l=0.115 //layer=ply \
 //thickness=0.18 //x=73.525 //y=0.94 //x2=73.41 //y2=0.94
r721 (  173 226 ) resistor r=5.52526 //w=0.168 //l=0.115 //layer=ply \
 //thickness=0.18 //x=73.745 //y=0.94 //x2=73.86 //y2=0.94
r722 (  173 174 ) resistor r=112.809 //w=0.094 //l=0.22 //layer=ply \
 //thickness=0.18 //x=73.745 //y=0.94 //x2=73.525 //y2=0.94
r723 (  170 225 ) resistor r=37.236 //w=0.233 //l=0.249199 //layer=ply \
 //thickness=0.18 //x=73.56 //y=5.045 //x2=73.38 //y2=4.88
r724 (  168 223 ) resistor r=39.5823 //w=0.21 //l=0.173853 //layer=ply \
 //thickness=0.18 //x=73.37 //y=1.75 //x2=73.41 //y2=1.595
r725 (  168 220 ) resistor r=176.904 //w=0.094 //l=0.345 //layer=ply \
 //thickness=0.18 //x=73.37 //y=1.75 //x2=73.37 //y2=2.095
r726 (  167 223 ) resistor r=39.5823 //w=0.21 //l=0.173853 //layer=ply \
 //thickness=0.18 //x=73.37 //y=1.44 //x2=73.41 //y2=1.595
r727 (  166 222 ) resistor r=45.1352 //w=0.168 //l=0.173853 //layer=ply \
 //thickness=0.18 //x=73.37 //y=1.095 //x2=73.41 //y2=0.94
r728 (  166 167 ) resistor r=176.904 //w=0.094 //l=0.345 //layer=ply \
 //thickness=0.18 //x=73.37 //y=1.095 //x2=73.37 //y2=1.44
r729 (  163 225 ) resistor r=53.7854 //w=0.233 //l=0.332415 //layer=ply \
 //thickness=0.18 //x=73.12 //y=5.045 //x2=73.38 //y2=4.88
r730 (  162 213 ) resistor r=592.245 //w=0.094 //l=1.155 //layer=ply \
 //thickness=0.18 //x=87.18 //y=6.205 //x2=87.18 //y2=5.05
r731 (  161 248 ) resistor r=592.245 //w=0.094 //l=1.155 //layer=ply \
 //thickness=0.18 //x=86.74 //y=6.205 //x2=86.74 //y2=5.05
r732 (  160 194 ) resistor r=592.245 //w=0.094 //l=1.155 //layer=ply \
 //thickness=0.18 //x=80.52 //y=6.205 //x2=80.52 //y2=5.05
r733 (  159 184 ) resistor r=592.245 //w=0.094 //l=1.155 //layer=ply \
 //thickness=0.18 //x=80.08 //y=6.205 //x2=80.08 //y2=5.05
r734 (  158 170 ) resistor r=592.245 //w=0.094 //l=1.155 //layer=ply \
 //thickness=0.18 //x=73.56 //y=6.2 //x2=73.56 //y2=5.045
r735 (  157 163 ) resistor r=592.245 //w=0.094 //l=1.155 //layer=ply \
 //thickness=0.18 //x=73.12 //y=6.2 //x2=73.12 //y2=5.045
r736 (  156 210 ) resistor r=56.4043 //w=0.094 //l=0.11 //layer=ply \
 //thickness=0.18 //x=87 //y=1.585 //x2=87.11 //y2=1.585
r737 (  156 211 ) resistor r=56.4043 //w=0.094 //l=0.11 //layer=ply \
 //thickness=0.18 //x=87 //y=1.585 //x2=86.89 //y2=1.585
r738 (  155 191 ) resistor r=56.4043 //w=0.094 //l=0.11 //layer=ply \
 //thickness=0.18 //x=80.34 //y=1.585 //x2=80.45 //y2=1.585
r739 (  155 192 ) resistor r=56.4043 //w=0.094 //l=0.11 //layer=ply \
 //thickness=0.18 //x=80.34 //y=1.585 //x2=80.23 //y2=1.585
r740 (  154 175 ) resistor r=56.4043 //w=0.094 //l=0.11 //layer=ply \
 //thickness=0.18 //x=73.635 //y=1.595 //x2=73.745 //y2=1.595
r741 (  154 176 ) resistor r=56.4043 //w=0.094 //l=0.11 //layer=ply \
 //thickness=0.18 //x=73.635 //y=1.595 //x2=73.525 //y2=1.595
r742 (  150 245 ) resistor r=152 //w=0.17 //l=0.17 //layer=licon //count=1 \
 //x=86.72 //y=4.885 //x2=86.72 //y2=4.885
r743 (  141 241 ) resistor r=152 //w=0.17 //l=0.17 //layer=licon //count=1 \
 //x=86.7 //y=2.26 //x2=86.7 //y2=2.26
r744 (  136 233 ) resistor r=152 //w=0.17 //l=0.17 //layer=licon //count=1 \
 //x=80.08 //y=4.885 //x2=80.08 //y2=4.885
r745 (  127 229 ) resistor r=152 //w=0.17 //l=0.17 //layer=licon //count=1 \
 //x=80.04 //y=2.26 //x2=80.04 //y2=2.26
r746 (  110 256 ) resistor r=23.615 //w=0.187 //l=0.345 //layer=li \
 //thickness=0.1 //x=76.97 //y=5.56 //x2=76.97 //y2=5.905
r747 (  102 255 ) resistor r=23.615 //w=0.187 //l=0.345 //layer=li \
 //thickness=0.1 //x=76.09 //y=5.56 //x2=76.09 //y2=5.905
r748 (  97 225 ) resistor r=152 //w=0.17 //l=0.17 //layer=licon //count=1 \
 //x=73.38 //y=4.88 //x2=73.38 //y2=4.88
r749 (  88 219 ) resistor r=152 //w=0.17 //l=0.17 //layer=licon //count=1 \
 //x=73.38 //y=2.26 //x2=73.38 //y2=2.26
r750 (  84 85 ) resistor r=0.104807 //w=0.281 //l=0.16 //layer=m2 \
 //thickness=0.36 //x=86.715 //y=4.21 //x2=86.555 //y2=4.21
r751 (  76 78 ) resistor r=0.10734 //w=0.281 //l=0.16 //layer=m2 \
 //thickness=0.36 //x=73.385 //y=3.865 //x2=73.545 //y2=3.865
r752 (  74 82 ) resistor r=0.0892547 //w=0.274 //l=0.358175 //layer=m2 \
 //thickness=0.36 //x=80.2 //y=4.252 //x2=80.04 //y2=3.965
r753 (  74 85 ) resistor r=5.84099 //w=0.136 //l=6.355 //layer=m2 \
 //thickness=0.36 //x=80.2 //y=4.252 //x2=86.555 //y2=4.252
r754 (  72 80 ) resistor r=0.869884 //w=0.196 //l=1.36 //layer=m2 \
 //thickness=0.36 //x=78.8 //y=3.895 //x2=77.44 //y2=3.895
r755 (  71 82 ) resistor r=0.426203 //w=0.274 //l=0.929341 //layer=m2 \
 //thickness=0.36 //x=79.145 //y=3.895 //x2=80.04 //y2=3.965
r756 (  71 72 ) resistor r=0.329198 //w=0.131 //l=0.345 //layer=m2 \
 //thickness=0.36 //x=79.145 //y=3.895 //x2=78.8 //y2=3.895
r757 (  69 80 ) resistor r=0.337359 //w=0.196 //l=0.537355 //layer=m2 \
 //thickness=0.36 //x=76.915 //y=3.87 //x2=77.44 //y2=3.895
r758 (  69 70 ) resistor r=0.410305 //w=0.131 //l=0.43 //layer=m2 \
 //thickness=0.36 //x=76.915 //y=3.87 //x2=76.485 //y2=3.87
r759 (  67 70 ) resistor r=0.125 //w=0.17 //l=0.174929 //layer=m2 \
 //thickness=0.36 //x=76.315 //y=3.88 //x2=76.485 //y2=3.87
r760 (  67 78 ) resistor r=2.64313 //w=0.131 //l=2.77 //layer=m2 \
 //thickness=0.36 //x=76.315 //y=3.88 //x2=73.545 //y2=3.88
r761 (  66 150 ) resistor r=9.3 //w=0.17 //l=0.17 //layer=mcon //count=1 \
 //x=86.72 //y=4.885 //x2=86.72 //y2=4.885
r762 (  64 141 ) resistor r=9.3 //w=0.17 //l=0.17 //layer=mcon //count=1 \
 //x=86.7 //y=2.26 //x2=86.7 //y2=2.26
r763 (  60 84 ) resistor r=4.5 //w=0.15 //l=0.15 //layer=via1 //count=1 \
 //x=86.715 //y=4.21 //x2=86.715 //y2=4.21
r764 (  60 62 ) resistor r=0.0130208 //w=0.384 //l=0.04 //layer=m1 \
 //thickness=0.36 //x=86.655 //y=4.21 //x2=86.655 //y2=4.25
r765 (  56 82 ) resistor r=4.5 //w=0.15 //l=0.15 //layer=via1 //count=1 \
 //x=80.04 //y=4.205 //x2=80.04 //y2=4.205
r766 (  56 58 ) resistor r=0.0149601 //w=0.376 //l=0.045 //layer=m1 \
 //thickness=0.36 //x=80.092 //y=4.205 //x2=80.092 //y2=4.25
r767 (  54 136 ) resistor r=9.3 //w=0.17 //l=0.17 //layer=mcon //count=1 \
 //x=80.08 //y=4.885 //x2=80.08 //y2=4.885
r768 (  52 127 ) resistor r=9.3 //w=0.17 //l=0.17 //layer=mcon //count=1 \
 //x=80.04 //y=2.26 //x2=80.04 //y2=2.26
r769 (  50 80 ) resistor r=4.5 //w=0.15 //l=0.15 //layer=via1 //count=1 \
 //x=77.44 //y=3.895 //x2=77.44 //y2=3.895
r770 (  48 50 ) resistor r=0.00505391 //w=0.371 //l=0.015 //layer=m1 \
 //thickness=0.36 //x=77.392 //y=3.88 //x2=77.392 //y2=3.895
r771 (  45 253 ) resistor r=9.3 //w=0.17 //l=0.17 //layer=mcon //count=1 \
 //x=77.01 //y=1.18 //x2=77.01 //y2=1.18
r772 (  43 110 ) resistor r=9.3 //w=0.17 //l=0.17 //layer=mcon //count=1 \
 //x=76.97 //y=5.56 //x2=76.97 //y2=5.56
r773 (  40 43 ) resistor r=0.117801 //w=0.191 //l=0.18 //layer=m1 \
 //thickness=0.36 //x=76.97 //y=5.38 //x2=76.97 //y2=5.56
r774 (  39 102 ) resistor r=9.3 //w=0.17 //l=0.17 //layer=mcon //count=1 \
 //x=76.09 //y=5.56 //x2=76.09 //y2=5.56
r775 (  37 39 ) resistor r=0.10274 //w=0.219 //l=0.18 //layer=m1 \
 //thickness=0.36 //x=76.09 //y=5.38 //x2=76.09 //y2=5.56
r776 (  34 76 ) resistor r=4.5 //w=0.15 //l=0.15 //layer=via1 //count=1 \
 //x=73.385 //y=3.865 //x2=73.385 //y2=3.865
r777 (  34 36 ) resistor r=0.00501337 //w=0.374 //l=0.015 //layer=m1 \
 //thickness=0.36 //x=73.435 //y=3.865 //x2=73.435 //y2=3.88
r778 (  32 97 ) resistor r=9.3 //w=0.17 //l=0.17 //layer=mcon //count=1 \
 //x=73.38 //y=4.88 //x2=73.38 //y2=4.88
r779 (  30 88 ) resistor r=9.3 //w=0.17 //l=0.17 //layer=mcon //count=1 \
 //x=73.38 //y=2.26 //x2=73.38 //y2=2.26
r780 (  28 66 ) resistor r=0.0893515 //w=0.219 //l=0.154677 //layer=m1 \
 //thickness=0.36 //x=86.7 //y=4.74 //x2=86.72 //y2=4.885
r781 (  27 62 ) resistor r=0.0784723 //w=0.384 //l=0.140712 //layer=m1 \
 //thickness=0.36 //x=86.7 //y=4.37 //x2=86.655 //y2=4.25
r782 (  27 28 ) resistor r=0.353053 //w=0.131 //l=0.37 //layer=m1 \
 //thickness=0.36 //x=86.7 //y=4.37 //x2=86.7 //y2=4.74
r783 (  26 60 ) resistor r=0.0914932 //w=0.384 //l=0.181108 //layer=m1 \
 //thickness=0.36 //x=86.7 //y=4.05 //x2=86.655 //y2=4.21
r784 (  25 64 ) resistor r=0.0744285 //w=0.225 //l=0.12 //layer=m1 \
 //thickness=0.36 //x=86.7 //y=2.38 //x2=86.7 //y2=2.26
r785 (  25 26 ) resistor r=1.59351 //w=0.131 //l=1.67 //layer=m1 \
 //thickness=0.36 //x=86.7 //y=2.38 //x2=86.7 //y2=4.05
r786 (  24 54 ) resistor r=0.100665 //w=0.248 //l=0.193972 //layer=m1 \
 //thickness=0.36 //x=80.04 //y=4.71 //x2=80.08 //y2=4.885
r787 (  23 58 ) resistor r=0.0761992 //w=0.376 //l=0.138582 //layer=m1 \
 //thickness=0.36 //x=80.04 //y=4.365 //x2=80.092 //y2=4.25
r788 (  23 24 ) resistor r=0.329198 //w=0.131 //l=0.345 //layer=m1 \
 //thickness=0.36 //x=80.04 //y=4.365 //x2=80.04 //y2=4.71
r789 (  22 56 ) resistor r=0.0911593 //w=0.376 //l=0.184174 //layer=m1 \
 //thickness=0.36 //x=80.04 //y=4.045 //x2=80.092 //y2=4.205
r790 (  21 52 ) resistor r=0.0717383 //w=0.224 //l=0.115 //layer=m1 \
 //thickness=0.36 //x=80.04 //y=2.375 //x2=80.04 //y2=2.26
r791 (  21 22 ) resistor r=1.59351 //w=0.131 //l=1.67 //layer=m1 \
 //thickness=0.36 //x=80.04 //y=2.375 //x2=80.04 //y2=4.045
r792 (  19 50 ) resistor r=0.0909648 //w=0.371 //l=0.186762 //layer=m1 \
 //thickness=0.36 //x=77.45 //y=4.055 //x2=77.392 //y2=3.895
r793 (  19 20 ) resistor r=1.18321 //w=0.131 //l=1.24 //layer=m1 \
 //thickness=0.36 //x=77.45 //y=4.055 //x2=77.45 //y2=5.295
r794 (  18 48 ) resistor r=0.0859108 //w=0.371 //l=0.171566 //layer=m1 \
 //thickness=0.36 //x=77.45 //y=3.735 //x2=77.392 //y2=3.88
r795 (  17 18 ) resistor r=1.73187 //w=0.131 //l=1.815 //layer=m1 \
 //thickness=0.36 //x=77.45 //y=1.92 //x2=77.45 //y2=3.735
r796 (  15 17 ) resistor r=0.0698411 //w=0.17 //l=0.120208 //layer=m1 \
 //thickness=0.36 //x=77.365 //y=1.835 //x2=77.45 //y2=1.92
r797 (  15 16 ) resistor r=0.257634 //w=0.131 //l=0.27 //layer=m1 \
 //thickness=0.36 //x=77.365 //y=1.835 //x2=77.095 //y2=1.835
r798 (  14 40 ) resistor r=0.0257089 //w=0.23 //l=0.115 //layer=m1 \
 //thickness=0.36 //x=77.085 //y=5.38 //x2=76.97 //y2=5.38
r799 (  13 20 ) resistor r=0.0698411 //w=0.17 //l=0.120208 //layer=m1 \
 //thickness=0.36 //x=77.365 //y=5.38 //x2=77.45 //y2=5.295
r800 (  13 14 ) resistor r=0.267176 //w=0.131 //l=0.28 //layer=m1 \
 //thickness=0.36 //x=77.365 //y=5.38 //x2=77.085 //y2=5.38
r801 (  12 16 ) resistor r=0.0698411 //w=0.17 //l=0.120208 //layer=m1 \
 //thickness=0.36 //x=77.01 //y=1.75 //x2=77.095 //y2=1.835
r802 (  11 45 ) resistor r=0.0913624 //w=0.191 //l=0.12 //layer=m1 \
 //thickness=0.36 //x=77.01 //y=1.3 //x2=77.01 //y2=1.18
r803 (  11 12 ) resistor r=0.429389 //w=0.131 //l=0.45 //layer=m1 \
 //thickness=0.36 //x=77.01 //y=1.3 //x2=77.01 //y2=1.75
r804 (  8 37 ) resistor r=0.0227762 //w=0.219 //l=0.115 //layer=m1 \
 //thickness=0.36 //x=76.205 //y=5.38 //x2=76.09 //y2=5.38
r805 (  7 40 ) resistor r=0.0257089 //w=0.23 //l=0.115 //layer=m1 \
 //thickness=0.36 //x=76.855 //y=5.38 //x2=76.97 //y2=5.38
r806 (  7 8 ) resistor r=0.620229 //w=0.131 //l=0.65 //layer=m1 \
 //thickness=0.36 //x=76.855 //y=5.38 //x2=76.205 //y2=5.38
r807 (  4 32 ) resistor r=0.0801089 //w=0.224 //l=0.13 //layer=m1 \
 //thickness=0.36 //x=73.38 //y=4.75 //x2=73.38 //y2=4.88
r808 (  3 36 ) resistor r=0.0860668 //w=0.374 //l=0.170294 //layer=m1 \
 //thickness=0.36 //x=73.38 //y=4.025 //x2=73.435 //y2=3.88
r809 (  3 4 ) resistor r=0.691794 //w=0.131 //l=0.725 //layer=m1 \
 //thickness=0.36 //x=73.38 //y=4.025 //x2=73.38 //y2=4.75
r810 (  2 34 ) resistor r=0.0910802 //w=0.374 //l=0.185472 //layer=m1 \
 //thickness=0.36 //x=73.38 //y=3.705 //x2=73.435 //y2=3.865
r811 (  1 30 ) resistor r=0.0719237 //w=0.222 //l=0.115 //layer=m1 \
 //thickness=0.36 //x=73.38 //y=2.375 //x2=73.38 //y2=2.26
r812 (  1 2 ) resistor r=1.26908 //w=0.131 //l=1.33 //layer=m1 \
 //thickness=0.36 //x=73.38 //y=2.375 //x2=73.38 //y2=3.705
ends PM_TMRDFFRNQX1\%noxref_17

subckt PM_TMRDFFRNQX1\%noxref_18 ( 1 3 4 5 7 8 10 11 12 14 15 16 18 22 25 28 \
 36 40 44 57 60 61 63 64 69 71 72 81 89 107 116 124 125 126 127 128 129 130 \
 134 135 136 138 144 145 147 155 156 157 161 162 )
c337 ( 157 0 ) capacitor c=0.00985497f //x=86.81 //y=1.085
c338 ( 156 0 ) capacitor c=0.0110388f //x=83.48 //y=1.085
c339 ( 155 0 ) capacitor c=0.0110842f //x=80.15 //y=1.085
c340 ( 147 0 ) capacitor c=0.0588117f //x=88.92 //y=2.265
c341 ( 145 0 ) capacitor c=0.0439576f //x=89.56 //y=1.435
c342 ( 144 0 ) capacitor c=0.0201087f //x=89.56 //y=1.09
c343 ( 138 0 ) capacitor c=0.0161986f //x=89.405 //y=1.59
c344 ( 136 0 ) capacitor c=0.0157807f //x=89.405 //y=0.935
c345 ( 135 0 ) capacitor c=0.051364f //x=89.15 //y=4.97
c346 ( 134 0 ) capacitor c=0.0406047f //x=89.44 //y=4.97
c347 ( 130 0 ) capacitor c=0.0301471f //x=89.03 //y=2.1
c348 ( 129 0 ) capacitor c=0.0255349f //x=89.03 //y=1.745
c349 ( 128 0 ) capacitor c=0.0234346f //x=89.03 //y=1.435
c350 ( 127 0 ) capacitor c=0.02013f //x=89.03 //y=1.09
c351 ( 126 0 ) capacitor c=0.153839f //x=89.515 //y=6.2
c352 ( 125 0 ) capacitor c=0.15434f //x=89.075 //y=6.2
c353 ( 116 0 ) capacitor c=6.76693e-19 //x=88.92 //y=4.88
c354 ( 107 0 ) capacitor c=9.11699e-19 //x=88.92 //y=2.265
c355 ( 89 0 ) capacitor c=0.0265472f //x=86.96 //y=5.56
c356 ( 81 0 ) capacitor c=0.0232072f //x=86.08 //y=5.56
c357 ( 72 0 ) capacitor c=0.0554023f //x=88.76 //y=4.255
c358 ( 71 0 ) capacitor c=0.00507699f //x=88.92 //y=4.255
c359 ( 69 0 ) capacitor c=0.00713729f //x=87.6 //y=4.255
c360 ( 64 0 ) capacitor c=0.0846636f //x=86.835 //y=1.405
c361 ( 63 0 ) capacitor c=0.0257508f //x=86.995 //y=1.405
c362 ( 61 0 ) capacitor c=0.00731967f //x=83.8 //y=1.405
c363 ( 60 0 ) capacitor c=0.0847663f //x=83.54 //y=1.405
c364 ( 57 0 ) capacitor c=0.0031611f //x=80.505 //y=1.405
c365 ( 44 0 ) capacitor c=0.0116317f //x=88.92 //y=2.265
c366 ( 40 0 ) capacitor c=0.0139687f //x=88.92 //y=4.25
c367 ( 36 0 ) capacitor c=0.0138558f //x=87.44 //y=4.25
c368 ( 28 0 ) capacitor c=0.0125078f //x=86.957 //y=5.39
c369 ( 25 0 ) capacitor c=0.0156957f //x=86.08 //y=5.39
c370 ( 22 0 ) capacitor c=0.00890301f //x=83.67 //y=1.36
c371 ( 18 0 ) capacitor c=0.00591007f //x=80.34 //y=1.36
c372 ( 16 0 ) capacitor c=0.010406f //x=88.92 //y=4.76
c373 ( 15 0 ) capacitor c=0.0112315f //x=88.92 //y=4.415
c374 ( 14 0 ) capacitor c=0.0499188f //x=88.92 //y=4.095
c375 ( 12 0 ) capacitor c=0.0203608f //x=87.44 //y=5.305
c376 ( 11 0 ) capacitor c=0.0114995f //x=87.44 //y=4.415
c377 ( 10 0 ) capacitor c=0.0630549f //x=87.44 //y=4.095
c378 ( 8 0 ) capacitor c=0.00834076f //x=87.085 //y=1.825
c379 ( 7 0 ) capacitor c=0.014154f //x=87.355 //y=1.825
c380 ( 5 0 ) capacitor c=0.00996583f //x=87.355 //y=5.39
c381 ( 4 0 ) capacitor c=0.00638645f //x=87 //y=1.74
c382 ( 3 0 ) capacitor c=0.00623208f //x=87 //y=1.535
c383 ( 1 0 ) capacitor c=0.0116295f //x=86.835 //y=5.39
r384 (  147 148 ) resistor r=17.5563 //w=0.302 //l=0.11 //layer=ply \
 //thickness=0.18 //x=88.92 //y=2.265 //x2=89.03 //y2=2.265
r385 (  145 154 ) resistor r=45.1352 //w=0.168 //l=0.173853 //layer=ply \
 //thickness=0.18 //x=89.56 //y=1.435 //x2=89.52 //y2=1.59
r386 (  144 153 ) resistor r=45.1352 //w=0.168 //l=0.173853 //layer=ply \
 //thickness=0.18 //x=89.56 //y=1.09 //x2=89.52 //y2=0.935
r387 (  144 145 ) resistor r=176.904 //w=0.094 //l=0.345 //layer=ply \
 //thickness=0.18 //x=89.56 //y=1.09 //x2=89.56 //y2=1.435
r388 (  139 152 ) resistor r=10.701 //w=0.21 //l=0.115 //layer=ply \
 //thickness=0.18 //x=89.185 //y=1.59 //x2=89.07 //y2=1.59
r389 (  138 154 ) resistor r=5.52526 //w=0.168 //l=0.115 //layer=ply \
 //thickness=0.18 //x=89.405 //y=1.59 //x2=89.52 //y2=1.59
r390 (  137 151 ) resistor r=5.52526 //w=0.168 //l=0.115 //layer=ply \
 //thickness=0.18 //x=89.185 //y=0.935 //x2=89.07 //y2=0.935
r391 (  136 153 ) resistor r=5.52526 //w=0.168 //l=0.115 //layer=ply \
 //thickness=0.18 //x=89.405 //y=0.935 //x2=89.52 //y2=0.935
r392 (  136 137 ) resistor r=112.809 //w=0.094 //l=0.22 //layer=ply \
 //thickness=0.18 //x=89.405 //y=0.935 //x2=89.185 //y2=0.935
r393 (  134 141 ) resistor r=26.9307 //w=0.15 //l=0.106066 //layer=ply \
 //thickness=0.18 //x=89.44 //y=4.97 //x2=89.515 //y2=5.045
r394 (  134 135 ) resistor r=148.702 //w=0.094 //l=0.29 //layer=ply \
 //thickness=0.18 //x=89.44 //y=4.97 //x2=89.15 //y2=4.97
r395 (  131 135 ) resistor r=23.403 //w=0.284 //l=0.106066 //layer=ply \
 //thickness=0.18 //x=89.075 //y=5.045 //x2=89.15 //y2=4.97
r396 (  131 150 ) resistor r=26.3063 //w=0.284 //l=0.229783 //layer=ply \
 //thickness=0.18 //x=89.075 //y=5.045 //x2=88.92 //y2=4.88
r397 (  130 148 ) resistor r=19.1248 //w=0.302 //l=0.165 //layer=ply \
 //thickness=0.18 //x=89.03 //y=2.1 //x2=89.03 //y2=2.265
r398 (  129 152 ) resistor r=39.5823 //w=0.21 //l=0.173853 //layer=ply \
 //thickness=0.18 //x=89.03 //y=1.745 //x2=89.07 //y2=1.59
r399 (  129 130 ) resistor r=182.032 //w=0.094 //l=0.355 //layer=ply \
 //thickness=0.18 //x=89.03 //y=1.745 //x2=89.03 //y2=2.1
r400 (  128 152 ) resistor r=39.5823 //w=0.21 //l=0.173853 //layer=ply \
 //thickness=0.18 //x=89.03 //y=1.435 //x2=89.07 //y2=1.59
r401 (  127 151 ) resistor r=45.1352 //w=0.168 //l=0.173853 //layer=ply \
 //thickness=0.18 //x=89.03 //y=1.09 //x2=89.07 //y2=0.935
r402 (  127 128 ) resistor r=176.904 //w=0.094 //l=0.345 //layer=ply \
 //thickness=0.18 //x=89.03 //y=1.09 //x2=89.03 //y2=1.435
r403 (  126 141 ) resistor r=592.245 //w=0.094 //l=1.155 //layer=ply \
 //thickness=0.18 //x=89.515 //y=6.2 //x2=89.515 //y2=5.045
r404 (  125 131 ) resistor r=592.245 //w=0.094 //l=1.155 //layer=ply \
 //thickness=0.18 //x=89.075 //y=6.2 //x2=89.075 //y2=5.045
r405 (  124 138 ) resistor r=56.4043 //w=0.094 //l=0.11 //layer=ply \
 //thickness=0.18 //x=89.295 //y=1.59 //x2=89.405 //y2=1.59
r406 (  124 139 ) resistor r=56.4043 //w=0.094 //l=0.11 //layer=ply \
 //thickness=0.18 //x=89.295 //y=1.59 //x2=89.185 //y2=1.59
r407 (  123 155 ) resistor r=13.3953 //w=0.172 //l=0.18 //layer=li \
 //thickness=0.1 //x=80.337 //y=1.36 //x2=80.337 //y2=1.18
r408 (  116 150 ) resistor r=152 //w=0.17 //l=0.17 //layer=licon //count=1 \
 //x=88.92 //y=4.88 //x2=88.92 //y2=4.88
r409 (  107 147 ) resistor r=152 //w=0.17 //l=0.17 //layer=licon //count=1 \
 //x=88.92 //y=2.265 //x2=88.92 //y2=2.265
r410 (  100 157 ) resistor r=12.3209 //w=0.187 //l=0.18 //layer=li \
 //thickness=0.1 //x=87 //y=1.36 //x2=87 //y2=1.18
r411 (  89 162 ) resistor r=23.2727 //w=0.187 //l=0.34 //layer=li \
 //thickness=0.1 //x=86.96 //y=5.56 //x2=86.96 //y2=5.9
r412 (  81 161 ) resistor r=23.2727 //w=0.187 //l=0.34 //layer=li \
 //thickness=0.1 //x=86.08 //y=5.56 //x2=86.08 //y2=5.9
r413 (  78 156 ) resistor r=12.3209 //w=0.187 //l=0.18 //layer=li \
 //thickness=0.1 //x=83.67 //y=1.36 //x2=83.67 //y2=1.18
r414 (  71 72 ) resistor r=0.10734 //w=0.281 //l=0.16 //layer=m2 \
 //thickness=0.36 //x=88.92 //y=4.255 //x2=88.76 //y2=4.255
r415 (  69 72 ) resistor r=1.10687 //w=0.131 //l=1.16 //layer=m2 \
 //thickness=0.36 //x=87.6 //y=4.25 //x2=88.76 //y2=4.25
r416 (  67 69 ) resistor r=0.10734 //w=0.281 //l=0.16 //layer=m2 \
 //thickness=0.36 //x=87.44 //y=4.255 //x2=87.6 //y2=4.255
r417 (  63 64 ) resistor r=0.10734 //w=0.281 //l=0.16 //layer=m2 \
 //thickness=0.36 //x=86.995 //y=1.405 //x2=86.835 //y2=1.405
r418 (  61 64 ) resistor r=2.89599 //w=0.131 //l=3.035 //layer=m2 \
 //thickness=0.36 //x=83.8 //y=1.36 //x2=86.835 //y2=1.36
r419 (  59 61 ) resistor r=0.0942778 //w=0.221 //l=0.13 //layer=m2 \
 //thickness=0.36 //x=83.67 //y=1.405 //x2=83.8 //y2=1.405
r420 (  59 60 ) resistor r=0.0942778 //w=0.221 //l=0.13 //layer=m2 \
 //thickness=0.36 //x=83.67 //y=1.405 //x2=83.54 //y2=1.405
r421 (  57 60 ) resistor r=2.89599 //w=0.131 //l=3.035 //layer=m2 \
 //thickness=0.36 //x=80.505 //y=1.36 //x2=83.54 //y2=1.36
r422 (  55 57 ) resistor r=0.10734 //w=0.281 //l=0.16 //layer=m2 \
 //thickness=0.36 //x=80.345 //y=1.405 //x2=80.505 //y2=1.405
r423 (  47 116 ) resistor r=9.3 //w=0.17 //l=0.17 //layer=mcon //count=1 \
 //x=88.92 //y=4.88 //x2=88.92 //y2=4.88
r424 (  44 107 ) resistor r=9.3 //w=0.17 //l=0.17 //layer=mcon //count=1 \
 //x=88.92 //y=2.265 //x2=88.92 //y2=2.265
r425 (  42 71 ) resistor r=4.5 //w=0.15 //l=0.15 //layer=via1 //count=1 \
 //x=88.92 //y=4.255 //x2=88.92 //y2=4.255
r426 (  40 42 ) resistor r=0.00166223 //w=0.376 //l=0.005 //layer=m1 \
 //thickness=0.36 //x=88.867 //y=4.25 //x2=88.867 //y2=4.255
r427 (  38 67 ) resistor r=4.5 //w=0.15 //l=0.15 //layer=via1 //count=1 \
 //x=87.44 //y=4.255 //x2=87.44 //y2=4.255
r428 (  36 38 ) resistor r=0.00166223 //w=0.376 //l=0.005 //layer=m1 \
 //thickness=0.36 //x=87.492 //y=4.25 //x2=87.492 //y2=4.255
r429 (  34 63 ) resistor r=4.5 //w=0.15 //l=0.15 //layer=via1 //count=1 \
 //x=86.995 //y=1.405 //x2=86.995 //y2=1.405
r430 (  32 100 ) resistor r=9.3 //w=0.17 //l=0.17 //layer=mcon //count=1 \
 //x=87 //y=1.36 //x2=87 //y2=1.36
r431 (  32 34 ) resistor r=0.0163043 //w=0.345 //l=0.045 //layer=m1 \
 //thickness=0.36 //x=86.94 //y=1.36 //x2=86.94 //y2=1.405
r432 (  30 89 ) resistor r=9.3 //w=0.17 //l=0.17 //layer=mcon //count=1 \
 //x=86.96 //y=5.56 //x2=86.96 //y2=5.56
r433 (  28 30 ) resistor r=0.0944444 //w=0.225 //l=0.17 //layer=m1 \
 //thickness=0.36 //x=86.957 //y=5.39 //x2=86.957 //y2=5.56
r434 (  27 81 ) resistor r=9.3 //w=0.17 //l=0.17 //layer=mcon //count=1 \
 //x=86.08 //y=5.56 //x2=86.08 //y2=5.56
r435 (  25 27 ) resistor r=0.0936123 //w=0.227 //l=0.17 //layer=m1 \
 //thickness=0.36 //x=86.08 //y=5.39 //x2=86.08 //y2=5.56
r436 (  24 59 ) resistor r=4.5 //w=0.15 //l=0.15 //layer=via1 //count=1 \
 //x=83.67 //y=1.405 //x2=83.67 //y2=1.405
r437 (  22 78 ) resistor r=9.3 //w=0.17 //l=0.17 //layer=mcon //count=1 \
 //x=83.67 //y=1.36 //x2=83.67 //y2=1.36
r438 (  22 24 ) resistor r=0.0163043 //w=0.345 //l=0.045 //layer=m1 \
 //thickness=0.36 //x=83.61 //y=1.36 //x2=83.61 //y2=1.405
r439 (  20 55 ) resistor r=4.5 //w=0.15 //l=0.15 //layer=via1 //count=1 \
 //x=80.345 //y=1.405 //x2=80.345 //y2=1.405
r440 (  18 123 ) resistor r=9.3 //w=0.17 //l=0.17 //layer=mcon //count=1 \
 //x=80.34 //y=1.36 //x2=80.34 //y2=1.36
r441 (  18 20 ) resistor r=0.0150401 //w=0.374 //l=0.045 //layer=m1 \
 //thickness=0.36 //x=80.395 //y=1.36 //x2=80.395 //y2=1.405
r442 (  16 47 ) resistor r=0.0732479 //w=0.241 //l=0.122474 //layer=m1 \
 //thickness=0.36 //x=88.92 //y=4.76 //x2=88.925 //y2=4.88
r443 (  15 42 ) resistor r=0.0911593 //w=0.376 //l=0.184608 //layer=m1 \
 //thickness=0.36 //x=88.92 //y=4.415 //x2=88.867 //y2=4.255
r444 (  15 16 ) resistor r=0.329198 //w=0.131 //l=0.345 //layer=m1 \
 //thickness=0.36 //x=88.92 //y=4.415 //x2=88.92 //y2=4.76
r445 (  14 40 ) resistor r=0.0894971 //w=0.376 //l=0.179555 //layer=m1 \
 //thickness=0.36 //x=88.92 //y=4.095 //x2=88.867 //y2=4.25
r446 (  13 44 ) resistor r=0.116051 //w=0.211 //l=0.165 //layer=m1 \
 //thickness=0.36 //x=88.92 //y=2.43 //x2=88.92 //y2=2.265
r447 (  13 14 ) resistor r=1.58874 //w=0.131 //l=1.665 //layer=m1 \
 //thickness=0.36 //x=88.92 //y=2.43 //x2=88.92 //y2=4.095
r448 (  11 38 ) resistor r=0.0911593 //w=0.376 //l=0.184174 //layer=m1 \
 //thickness=0.36 //x=87.44 //y=4.415 //x2=87.492 //y2=4.255
r449 (  11 12 ) resistor r=0.849237 //w=0.131 //l=0.89 //layer=m1 \
 //thickness=0.36 //x=87.44 //y=4.415 //x2=87.44 //y2=5.305
r450 (  10 36 ) resistor r=0.0894971 //w=0.376 //l=0.179123 //layer=m1 \
 //thickness=0.36 //x=87.44 //y=4.095 //x2=87.492 //y2=4.25
r451 (  9 10 ) resistor r=2.08492 //w=0.131 //l=2.185 //layer=m1 \
 //thickness=0.36 //x=87.44 //y=1.91 //x2=87.44 //y2=4.095
r452 (  7 9 ) resistor r=0.0698411 //w=0.17 //l=0.120208 //layer=m1 \
 //thickness=0.36 //x=87.355 //y=1.825 //x2=87.44 //y2=1.91
r453 (  7 8 ) resistor r=0.257634 //w=0.131 //l=0.27 //layer=m1 \
 //thickness=0.36 //x=87.355 //y=1.825 //x2=87.085 //y2=1.825
r454 (  6 28 ) resistor r=0.0243946 //w=0.225 //l=0.123 //layer=m1 \
 //thickness=0.36 //x=87.08 //y=5.39 //x2=86.957 //y2=5.39
r455 (  5 12 ) resistor r=0.0698411 //w=0.17 //l=0.120208 //layer=m1 \
 //thickness=0.36 //x=87.355 //y=5.39 //x2=87.44 //y2=5.305
r456 (  5 6 ) resistor r=0.262405 //w=0.131 //l=0.275 //layer=m1 \
 //thickness=0.36 //x=87.355 //y=5.39 //x2=87.08 //y2=5.39
r457 (  4 8 ) resistor r=0.0698411 //w=0.17 //l=0.120208 //layer=m1 \
 //thickness=0.36 //x=87 //y=1.74 //x2=87.085 //y2=1.825
r458 (  3 34 ) resistor r=0.0792909 //w=0.345 //l=0.157162 //layer=m1 \
 //thickness=0.36 //x=87 //y=1.535 //x2=86.94 //y2=1.405
r459 (  3 4 ) resistor r=0.195611 //w=0.131 //l=0.205 //layer=m1 \
 //thickness=0.36 //x=87 //y=1.535 //x2=87 //y2=1.74
r460 (  2 25 ) resistor r=0.0249239 //w=0.227 //l=0.125 //layer=m1 \
 //thickness=0.36 //x=86.205 //y=5.39 //x2=86.08 //y2=5.39
r461 (  1 28 ) resistor r=0.0243946 //w=0.225 //l=0.122 //layer=m1 \
 //thickness=0.36 //x=86.835 //y=5.39 //x2=86.957 //y2=5.39
r462 (  1 2 ) resistor r=0.601145 //w=0.131 //l=0.63 //layer=m1 \
 //thickness=0.36 //x=86.835 //y=5.39 //x2=86.205 //y2=5.39
ends PM_TMRDFFRNQX1\%noxref_18

subckt PM_TMRDFFRNQX1\%VDD ( 1 2 133 134 135 137 138 139 143 144 161 220 229 \
 239 247 257 275 285 293 303 319 327 353 361 371 381 397 405 415 425 441 451 \
 477 487 497 505 521 531 541 549 565 575 599 609 617 627 645 655 663 673 689 \
 697 723 731 741 751 767 775 785 795 811 821 847 857 867 875 891 901 911 919 \
 935 945 957 992 1000 1020 1038 1043 1048 1054 1060 1064 1070 1076 1081 1086 \
 1091 1096 1102 1108 1112 1118 1124 1129 1130 1131 1132 1136 1137 1138 1139 \
 1140 1141 1142 1143 1144 1145 1146 1147 1148 1149 1150 1151 1152 1153 1154 \
 1155 1156 1157 1158 1159 1160 1161 1162 1163 1164 1165 1166 1167 1168 1169 \
 1170 1171 1172 1173 1174 1175 1176 1177 1178 1179 1180 1181 1182 1183 1184 \
 1185 1186 1187 1188 1189 1190 1191 1192 1193 1194 1195 1196 1197 1198 1199 \
 1200 1201 1202 1203 1204 1205 1206 1207 )
c1455 ( 1207 0 ) capacitor c=0.0632648f //x=89.59 //y=5.2
c1456 ( 1206 0 ) capacitor c=0.0575062f //x=88.72 //y=5.2
c1457 ( 1205 0 ) capacitor c=0.0424825f //x=80.595 //y=5.205
c1458 ( 1204 0 ) capacitor c=0.0223606f //x=79.715 //y=5.205
c1459 ( 1203 0 ) capacitor c=0.050992f //x=78.845 //y=5.205
c1460 ( 1202 0 ) capacitor c=0.0393089f //x=77.265 //y=5.2
c1461 ( 1201 0 ) capacitor c=0.0247431f //x=76.385 //y=5.2
c1462 ( 1200 0 ) capacitor c=0.062629f //x=75.515 //y=5.2
c1463 ( 1199 0 ) capacitor c=0.0466891f //x=73.635 //y=5.2
c1464 ( 1198 0 ) capacitor c=0.0255836f //x=72.755 //y=5.2
c1465 ( 1197 0 ) capacitor c=0.0256114f //x=71.875 //y=5.2
c1466 ( 1196 0 ) capacitor c=0.0675934f //x=71.005 //y=5.2
c1467 ( 1195 0 ) capacitor c=0.0466891f //x=68.825 //y=5.2
c1468 ( 1194 0 ) capacitor c=0.025617f //x=67.945 //y=5.2
c1469 ( 1193 0 ) capacitor c=0.0255777f //x=67.065 //y=5.2
c1470 ( 1192 0 ) capacitor c=0.0675298f //x=66.195 //y=5.2
c1471 ( 1191 0 ) capacitor c=0.039544f //x=64.315 //y=5.2
c1472 ( 1190 0 ) capacitor c=0.0248174f //x=63.435 //y=5.2
c1473 ( 1189 0 ) capacitor c=0.0628113f //x=62.565 //y=5.2
c1474 ( 1188 0 ) capacitor c=0.0466891f //x=60.685 //y=5.2
c1475 ( 1187 0 ) capacitor c=0.0255836f //x=59.805 //y=5.2
c1476 ( 1186 0 ) capacitor c=0.0256114f //x=58.925 //y=5.2
c1477 ( 1185 0 ) capacitor c=0.0676343f //x=58.055 //y=5.2
c1478 ( 1184 0 ) capacitor c=0.0466891f //x=55.875 //y=5.2
c1479 ( 1183 0 ) capacitor c=0.025617f //x=54.995 //y=5.2
c1480 ( 1182 0 ) capacitor c=0.0255777f //x=54.115 //y=5.2
c1481 ( 1181 0 ) capacitor c=0.067436f //x=53.245 //y=5.2
c1482 ( 1180 0 ) capacitor c=0.039544f //x=51.365 //y=5.2
c1483 ( 1179 0 ) capacitor c=0.0248174f //x=50.485 //y=5.2
c1484 ( 1178 0 ) capacitor c=0.0627254f //x=49.615 //y=5.2
c1485 ( 1177 0 ) capacitor c=0.0466891f //x=47.735 //y=5.2
c1486 ( 1176 0 ) capacitor c=0.0255836f //x=46.855 //y=5.2
c1487 ( 1175 0 ) capacitor c=0.0256114f //x=45.975 //y=5.2
c1488 ( 1174 0 ) capacitor c=0.0675744f //x=45.105 //y=5.2
c1489 ( 1173 0 ) capacitor c=0.0466891f //x=42.925 //y=5.2
c1490 ( 1172 0 ) capacitor c=0.025617f //x=42.045 //y=5.2
c1491 ( 1171 0 ) capacitor c=0.0255777f //x=41.165 //y=5.2
c1492 ( 1170 0 ) capacitor c=0.0675298f //x=40.295 //y=5.2
c1493 ( 1169 0 ) capacitor c=0.039544f //x=38.415 //y=5.2
c1494 ( 1168 0 ) capacitor c=0.0248174f //x=37.535 //y=5.2
c1495 ( 1167 0 ) capacitor c=0.0628113f //x=36.665 //y=5.2
c1496 ( 1166 0 ) capacitor c=0.0466891f //x=34.785 //y=5.2
c1497 ( 1165 0 ) capacitor c=0.0255836f //x=33.905 //y=5.2
c1498 ( 1164 0 ) capacitor c=0.0256114f //x=33.025 //y=5.2
c1499 ( 1163 0 ) capacitor c=0.0676343f //x=32.155 //y=5.2
c1500 ( 1162 0 ) capacitor c=0.0466891f //x=29.975 //y=5.2
c1501 ( 1161 0 ) capacitor c=0.025617f //x=29.095 //y=5.2
c1502 ( 1160 0 ) capacitor c=0.0255777f //x=28.215 //y=5.2
c1503 ( 1159 0 ) capacitor c=0.067436f //x=27.345 //y=5.2
c1504 ( 1158 0 ) capacitor c=0.0397412f //x=25.465 //y=5.2
c1505 ( 1157 0 ) capacitor c=0.0248174f //x=24.585 //y=5.2
c1506 ( 1156 0 ) capacitor c=0.062426f //x=23.715 //y=5.2
c1507 ( 1155 0 ) capacitor c=0.0466891f //x=21.835 //y=5.2
c1508 ( 1154 0 ) capacitor c=0.0255836f //x=20.955 //y=5.2
c1509 ( 1153 0 ) capacitor c=0.0256114f //x=20.075 //y=5.2
c1510 ( 1152 0 ) capacitor c=0.0675744f //x=19.205 //y=5.2
c1511 ( 1151 0 ) capacitor c=0.0466891f //x=17.025 //y=5.2
c1512 ( 1150 0 ) capacitor c=0.025617f //x=16.145 //y=5.2
c1513 ( 1149 0 ) capacitor c=0.0255777f //x=15.265 //y=5.2
c1514 ( 1148 0 ) capacitor c=0.0674699f //x=14.395 //y=5.2
c1515 ( 1147 0 ) capacitor c=0.039544f //x=12.515 //y=5.2
c1516 ( 1146 0 ) capacitor c=0.0248174f //x=11.635 //y=5.2
c1517 ( 1145 0 ) capacitor c=0.0628113f //x=10.765 //y=5.2
c1518 ( 1144 0 ) capacitor c=0.0466891f //x=8.885 //y=5.2
c1519 ( 1143 0 ) capacitor c=0.0255836f //x=8.005 //y=5.2
c1520 ( 1142 0 ) capacitor c=0.0256114f //x=7.125 //y=5.2
c1521 ( 1141 0 ) capacitor c=0.0676346f //x=6.255 //y=5.2
c1522 ( 1140 0 ) capacitor c=0.0466891f //x=4.075 //y=5.2
c1523 ( 1139 0 ) capacitor c=0.025617f //x=3.195 //y=5.2
c1524 ( 1138 0 ) capacitor c=0.0256114f //x=2.315 //y=5.2
c1525 ( 1137 0 ) capacitor c=0.0693233f //x=1.445 //y=5.2
c1526 ( 1136 0 ) capacitor c=0.258867f //x=89.66 //y=7.58
c1527 ( 1134 0 ) capacitor c=0.00597439f //x=88.92 //y=7.58
c1528 ( 1132 0 ) capacitor c=0.117824f //x=88.18 //y=7.585
c1529 ( 1131 0 ) capacitor c=0.121201f //x=84.85 //y=7.585
c1530 ( 1130 0 ) capacitor c=0.125864f //x=81.52 //y=7.585
c1531 ( 1129 0 ) capacitor c=0.123835f //x=78.19 //y=7.585
c1532 ( 1128 0 ) capacitor c=0.00597439f //x=77.45 //y=7.58
c1533 ( 1126 0 ) capacitor c=0.00597439f //x=76.53 //y=7.585
c1534 ( 1125 0 ) capacitor c=0.00597439f //x=75.65 //y=7.585
c1535 ( 1124 0 ) capacitor c=0.144126f //x=74.86 //y=7.585
c1536 ( 1123 0 ) capacitor c=0.00597439f //x=73.75 //y=7.58
c1537 ( 1121 0 ) capacitor c=0.00597439f //x=72.9 //y=7.585
c1538 ( 1120 0 ) capacitor c=0.00597439f //x=72.02 //y=7.585
c1539 ( 1119 0 ) capacitor c=0.00597439f //x=71.14 //y=7.585
c1540 ( 1118 0 ) capacitor c=0.16206f //x=70.05 //y=7.585
c1541 ( 1117 0 ) capacitor c=0.00597439f //x=68.94 //y=7.58
c1542 ( 1115 0 ) capacitor c=0.00597439f //x=68.09 //y=7.585
c1543 ( 1114 0 ) capacitor c=0.00597439f //x=67.21 //y=7.585
c1544 ( 1113 0 ) capacitor c=0.00597439f //x=66.33 //y=7.585
c1545 ( 1112 0 ) capacitor c=0.144432f //x=65.24 //y=7.585
c1546 ( 1111 0 ) capacitor c=0.00597439f //x=64.46 //y=7.585
c1547 ( 1110 0 ) capacitor c=0.00597439f //x=63.58 //y=7.585
c1548 ( 1109 0 ) capacitor c=0.00597439f //x=62.7 //y=7.585
c1549 ( 1108 0 ) capacitor c=0.145153f //x=61.91 //y=7.585
c1550 ( 1107 0 ) capacitor c=0.00597439f //x=60.83 //y=7.585
c1551 ( 1106 0 ) capacitor c=0.00597439f //x=59.95 //y=7.585
c1552 ( 1105 0 ) capacitor c=0.00597439f //x=59.07 //y=7.585
c1553 ( 1104 0 ) capacitor c=0.00597439f //x=58.21 //y=7.58
c1554 ( 1102 0 ) capacitor c=0.163341f //x=57.1 //y=7.585
c1555 ( 1101 0 ) capacitor c=0.00597439f //x=56.02 //y=7.585
c1556 ( 1100 0 ) capacitor c=0.00597439f //x=55.14 //y=7.585
c1557 ( 1099 0 ) capacitor c=0.00597439f //x=54.26 //y=7.585
c1558 ( 1098 0 ) capacitor c=0.00597439f //x=53.4 //y=7.58
c1559 ( 1096 0 ) capacitor c=0.145506f //x=52.29 //y=7.585
c1560 ( 1095 0 ) capacitor c=0.00597439f //x=51.51 //y=7.585
c1561 ( 1094 0 ) capacitor c=0.00597439f //x=50.63 //y=7.585
c1562 ( 1093 0 ) capacitor c=0.00597439f //x=49.7 //y=7.58
c1563 ( 1091 0 ) capacitor c=0.145153f //x=48.96 //y=7.585
c1564 ( 1090 0 ) capacitor c=0.00597439f //x=47.88 //y=7.585
c1565 ( 1089 0 ) capacitor c=0.00597439f //x=47 //y=7.585
c1566 ( 1088 0 ) capacitor c=0.00597439f //x=46.12 //y=7.585
c1567 ( 1087 0 ) capacitor c=0.00597439f //x=45.24 //y=7.585
c1568 ( 1086 0 ) capacitor c=0.16219f //x=44.15 //y=7.585
c1569 ( 1085 0 ) capacitor c=0.00597439f //x=43.07 //y=7.585
c1570 ( 1084 0 ) capacitor c=0.00597439f //x=42.19 //y=7.585
c1571 ( 1083 0 ) capacitor c=0.00597439f //x=41.31 //y=7.585
c1572 ( 1082 0 ) capacitor c=0.00597439f //x=40.43 //y=7.585
c1573 ( 1081 0 ) capacitor c=0.144432f //x=39.34 //y=7.585
c1574 ( 1080 0 ) capacitor c=0.00597439f //x=38.6 //y=7.58
c1575 ( 1078 0 ) capacitor c=0.00597439f //x=37.68 //y=7.585
c1576 ( 1077 0 ) capacitor c=0.00597439f //x=36.8 //y=7.585
c1577 ( 1076 0 ) capacitor c=0.145153f //x=36.01 //y=7.585
c1578 ( 1075 0 ) capacitor c=0.00597439f //x=34.9 //y=7.58
c1579 ( 1073 0 ) capacitor c=0.00597439f //x=34.05 //y=7.585
c1580 ( 1072 0 ) capacitor c=0.00597439f //x=33.17 //y=7.585
c1581 ( 1071 0 ) capacitor c=0.00597439f //x=32.29 //y=7.585
c1582 ( 1070 0 ) capacitor c=0.163341f //x=31.2 //y=7.585
c1583 ( 1069 0 ) capacitor c=0.00597439f //x=30.09 //y=7.58
c1584 ( 1067 0 ) capacitor c=0.00597439f //x=29.24 //y=7.585
c1585 ( 1066 0 ) capacitor c=0.00597439f //x=28.36 //y=7.585
c1586 ( 1065 0 ) capacitor c=0.00597439f //x=27.48 //y=7.585
c1587 ( 1064 0 ) capacitor c=0.145755f //x=26.39 //y=7.585
c1588 ( 1063 0 ) capacitor c=0.00597439f //x=25.61 //y=7.585
c1589 ( 1062 0 ) capacitor c=0.00597439f //x=24.73 //y=7.585
c1590 ( 1061 0 ) capacitor c=0.00597439f //x=23.85 //y=7.585
c1591 ( 1060 0 ) capacitor c=0.143485f //x=23.06 //y=7.585
c1592 ( 1059 0 ) capacitor c=0.00597439f //x=21.98 //y=7.585
c1593 ( 1058 0 ) capacitor c=0.00597439f //x=21.1 //y=7.585
c1594 ( 1057 0 ) capacitor c=0.00597439f //x=20.22 //y=7.585
c1595 ( 1056 0 ) capacitor c=0.00597439f //x=19.36 //y=7.58
c1596 ( 1054 0 ) capacitor c=0.16219f //x=18.25 //y=7.585
c1597 ( 1053 0 ) capacitor c=0.00597439f //x=17.17 //y=7.585
c1598 ( 1052 0 ) capacitor c=0.00597439f //x=16.29 //y=7.585
c1599 ( 1051 0 ) capacitor c=0.00597439f //x=15.41 //y=7.585
c1600 ( 1050 0 ) capacitor c=0.00597439f //x=14.55 //y=7.58
c1601 ( 1048 0 ) capacitor c=0.144432f //x=13.44 //y=7.585
c1602 ( 1047 0 ) capacitor c=0.00597439f //x=12.66 //y=7.585
c1603 ( 1046 0 ) capacitor c=0.00597439f //x=11.78 //y=7.585
c1604 ( 1045 0 ) capacitor c=0.00597439f //x=10.85 //y=7.58
c1605 ( 1043 0 ) capacitor c=0.145153f //x=10.11 //y=7.585
c1606 ( 1042 0 ) capacitor c=0.00597439f //x=9.03 //y=7.585
c1607 ( 1041 0 ) capacitor c=0.00597439f //x=8.15 //y=7.585
c1608 ( 1040 0 ) capacitor c=0.00597439f //x=7.27 //y=7.585
c1609 ( 1039 0 ) capacitor c=0.00597439f //x=6.39 //y=7.585
c1610 ( 1038 0 ) capacitor c=0.163341f //x=5.3 //y=7.585
c1611 ( 1037 0 ) capacitor c=0.00597439f //x=4.22 //y=7.585
c1612 ( 1036 0 ) capacitor c=0.00597439f //x=3.34 //y=7.585
c1613 ( 1035 0 ) capacitor c=0.00597439f //x=2.46 //y=7.585
c1614 ( 1034 0 ) capacitor c=0.00597439f //x=1.58 //y=7.585
c1615 ( 1020 0 ) capacitor c=0.0290604f //x=89.65 //y=7.585
c1616 ( 1010 0 ) capacitor c=0.021306f //x=88.77 //y=7.585
c1617 ( 1000 0 ) capacitor c=0.134506f //x=88.01 //y=7.585
c1618 ( 992 0 ) capacitor c=0.131873f //x=84.68 //y=7.585
c1619 ( 957 0 ) capacitor c=0.133054f //x=81.35 //y=7.585
c1620 ( 953 0 ) capacitor c=0.0277785f //x=78.02 //y=7.585
c1621 ( 945 0 ) capacitor c=0.0287376f //x=77.325 //y=7.585
c1622 ( 935 0 ) capacitor c=0.0291745f //x=76.445 //y=7.585
c1623 ( 923 0 ) capacitor c=0.0283511f //x=75.565 //y=7.585
c1624 ( 919 0 ) capacitor c=0.0416617f //x=74.69 //y=7.585
c1625 ( 911 0 ) capacitor c=0.0288858f //x=73.695 //y=7.585
c1626 ( 901 0 ) capacitor c=0.0289326f //x=72.815 //y=7.585
c1627 ( 891 0 ) capacitor c=0.0290299f //x=71.935 //y=7.585
c1628 ( 879 0 ) capacitor c=0.0455283f //x=71.055 //y=7.585
c1629 ( 875 0 ) capacitor c=0.0427734f //x=69.88 //y=7.585
c1630 ( 867 0 ) capacitor c=0.0288858f //x=68.885 //y=7.585
c1631 ( 857 0 ) capacitor c=0.0289326f //x=68.005 //y=7.585
c1632 ( 847 0 ) capacitor c=0.0290299f //x=67.125 //y=7.585
c1633 ( 835 0 ) capacitor c=0.0455283f //x=66.245 //y=7.585
c1634 ( 831 0 ) capacitor c=0.0277785f //x=65.07 //y=7.585
c1635 ( 821 0 ) capacitor c=0.0287376f //x=64.375 //y=7.585
c1636 ( 811 0 ) capacitor c=0.0291078f //x=63.495 //y=7.585
c1637 ( 801 0 ) capacitor c=0.0283511f //x=62.615 //y=7.585
c1638 ( 795 0 ) capacitor c=0.042257f //x=61.74 //y=7.585
c1639 ( 785 0 ) capacitor c=0.0288858f //x=60.745 //y=7.585
c1640 ( 775 0 ) capacitor c=0.0289326f //x=59.865 //y=7.585
c1641 ( 767 0 ) capacitor c=0.0290299f //x=58.985 //y=7.585
c1642 ( 757 0 ) capacitor c=0.0455283f //x=58.105 //y=7.585
c1643 ( 751 0 ) capacitor c=0.042257f //x=56.93 //y=7.585
c1644 ( 741 0 ) capacitor c=0.0288858f //x=55.935 //y=7.585
c1645 ( 731 0 ) capacitor c=0.0289326f //x=55.055 //y=7.585
c1646 ( 723 0 ) capacitor c=0.0289834f //x=54.175 //y=7.585
c1647 ( 713 0 ) capacitor c=0.0454931f //x=53.295 //y=7.585
c1648 ( 707 0 ) capacitor c=0.0277785f //x=52.12 //y=7.585
c1649 ( 697 0 ) capacitor c=0.0287376f //x=51.425 //y=7.585
c1650 ( 689 0 ) capacitor c=0.0291078f //x=50.545 //y=7.585
c1651 ( 679 0 ) capacitor c=0.0283511f //x=49.665 //y=7.585
c1652 ( 673 0 ) capacitor c=0.042257f //x=48.79 //y=7.585
c1653 ( 663 0 ) capacitor c=0.0288858f //x=47.795 //y=7.585
c1654 ( 655 0 ) capacitor c=0.0289326f //x=46.915 //y=7.585
c1655 ( 645 0 ) capacitor c=0.0290299f //x=46.035 //y=7.585
c1656 ( 633 0 ) capacitor c=0.0455283f //x=45.155 //y=7.585
c1657 ( 627 0 ) capacitor c=0.0427734f //x=43.98 //y=7.585
c1658 ( 617 0 ) capacitor c=0.0288858f //x=42.985 //y=7.585
c1659 ( 609 0 ) capacitor c=0.0289326f //x=42.105 //y=7.585
c1660 ( 599 0 ) capacitor c=0.0290299f //x=41.225 //y=7.585
c1661 ( 587 0 ) capacitor c=0.0455283f //x=40.345 //y=7.585
c1662 ( 583 0 ) capacitor c=0.0277785f //x=39.17 //y=7.585
c1663 ( 575 0 ) capacitor c=0.0287376f //x=38.475 //y=7.585
c1664 ( 565 0 ) capacitor c=0.0291078f //x=37.595 //y=7.585
c1665 ( 553 0 ) capacitor c=0.0283511f //x=36.715 //y=7.585
c1666 ( 549 0 ) capacitor c=0.042257f //x=35.84 //y=7.585
c1667 ( 541 0 ) capacitor c=0.0288858f //x=34.845 //y=7.585
c1668 ( 531 0 ) capacitor c=0.0289326f //x=33.965 //y=7.585
c1669 ( 521 0 ) capacitor c=0.0290299f //x=33.085 //y=7.585
c1670 ( 509 0 ) capacitor c=0.0455283f //x=32.205 //y=7.585
c1671 ( 505 0 ) capacitor c=0.042257f //x=31.03 //y=7.585
c1672 ( 497 0 ) capacitor c=0.0288858f //x=30.035 //y=7.585
c1673 ( 487 0 ) capacitor c=0.0289326f //x=29.155 //y=7.585
c1674 ( 477 0 ) capacitor c=0.0289834f //x=28.275 //y=7.585
c1675 ( 465 0 ) capacitor c=0.0454931f //x=27.395 //y=7.585
c1676 ( 461 0 ) capacitor c=0.0277785f //x=26.22 //y=7.585
c1677 ( 451 0 ) capacitor c=0.0287376f //x=25.525 //y=7.585
c1678 ( 441 0 ) capacitor c=0.029171f //x=24.645 //y=7.585
c1679 ( 431 0 ) capacitor c=0.0283511f //x=23.765 //y=7.585
c1680 ( 425 0 ) capacitor c=0.0416617f //x=22.89 //y=7.585
c1681 ( 415 0 ) capacitor c=0.0288858f //x=21.895 //y=7.585
c1682 ( 405 0 ) capacitor c=0.0289326f //x=21.015 //y=7.585
c1683 ( 397 0 ) capacitor c=0.0290299f //x=20.135 //y=7.585
c1684 ( 387 0 ) capacitor c=0.0455283f //x=19.255 //y=7.585
c1685 ( 381 0 ) capacitor c=0.0427734f //x=18.08 //y=7.585
c1686 ( 371 0 ) capacitor c=0.0288858f //x=17.085 //y=7.585
c1687 ( 361 0 ) capacitor c=0.0289326f //x=16.205 //y=7.585
c1688 ( 353 0 ) capacitor c=0.0290299f //x=15.325 //y=7.585
c1689 ( 343 0 ) capacitor c=0.0455283f //x=14.445 //y=7.585
c1690 ( 337 0 ) capacitor c=0.0277785f //x=13.27 //y=7.585
c1691 ( 327 0 ) capacitor c=0.0287376f //x=12.575 //y=7.585
c1692 ( 319 0 ) capacitor c=0.0291078f //x=11.695 //y=7.585
c1693 ( 309 0 ) capacitor c=0.0283511f //x=10.815 //y=7.585
c1694 ( 303 0 ) capacitor c=0.042257f //x=9.94 //y=7.585
c1695 ( 293 0 ) capacitor c=0.0288858f //x=8.945 //y=7.585
c1696 ( 285 0 ) capacitor c=0.0289326f //x=8.065 //y=7.585
c1697 ( 275 0 ) capacitor c=0.0290299f //x=7.185 //y=7.585
c1698 ( 263 0 ) capacitor c=0.0455283f //x=6.305 //y=7.585
c1699 ( 257 0 ) capacitor c=0.042257f //x=5.13 //y=7.585
c1700 ( 247 0 ) capacitor c=0.0288858f //x=4.135 //y=7.585
c1701 ( 239 0 ) capacitor c=0.0289326f //x=3.255 //y=7.585
c1702 ( 229 0 ) capacitor c=0.0289834f //x=2.375 //y=7.585
c1703 ( 220 0 ) capacitor c=0.253533f //x=1.23 //y=7.58
c1704 ( 217 0 ) capacitor c=0.0454931f //x=1.495 //y=7.585
c1705 ( 208 0 ) capacitor c=0.00499323f //x=80.74 //y=7.585
c1706 ( 205 0 ) capacitor c=0.00499323f //x=79.86 //y=7.585
c1707 ( 200 0 ) capacitor c=0.00499323f //x=78.93 //y=7.58
c1708 ( 161 0 ) capacitor c=0.348083f //x=89.66 //y=7.58
c1709 ( 144 0 ) capacitor c=0.00657976f //x=80.74 //y=7.41
c1710 ( 143 0 ) capacitor c=0.00827249f //x=80.74 //y=7.035
c1711 ( 139 0 ) capacitor c=0.0220779f //x=80.655 //y=7.585
c1712 ( 138 0 ) capacitor c=0.00369726f //x=79.86 //y=7.41
c1713 ( 137 0 ) capacitor c=0.00650208f //x=79.86 //y=7.035
c1714 ( 135 0 ) capacitor c=0.02242f //x=79.775 //y=7.585
c1715 ( 134 0 ) capacitor c=0.0090067f //x=78.98 //y=7.41
c1716 ( 133 0 ) capacitor c=0.0125184f //x=78.98 //y=7.035
c1717 ( 2 0 ) capacitor c=2.80686f //x=78.895 //y=7.585
r1718 (  1022 1136 ) resistor r=4.23183 //w=0.7 //l=0.175 //layer=li \
 //thickness=0.1 //x=89.735 //y=7.41 //x2=89.735 //y2=7.585
r1719 (  1022 1207 ) resistor r=56.4706 //w=0.187 //l=0.825 //layer=li \
 //thickness=0.1 //x=89.735 //y=7.41 //x2=89.735 //y2=6.585
r1720 (  1021 1134 ) resistor r=2.87058 //w=0.35 //l=0.085 //layer=li \
 //thickness=0.1 //x=88.94 //y=7.585 //x2=88.855 //y2=7.585
r1721 (  1020 1136 ) resistor r=2.87058 //w=0.35 //l=0.085 //layer=li \
 //thickness=0.1 //x=89.65 //y=7.585 //x2=89.735 //y2=7.585
r1722 (  1020 1021 ) resistor r=24.7629 //w=0.367 //l=0.71 //layer=li \
 //thickness=0.1 //x=89.65 //y=7.585 //x2=88.94 //y2=7.585
r1723 (  1012 1134 ) resistor r=4.23183 //w=0.7 //l=0.175 //layer=li \
 //thickness=0.1 //x=88.855 //y=7.41 //x2=88.855 //y2=7.585
r1724 (  1012 1206 ) resistor r=56.4706 //w=0.187 //l=0.825 //layer=li \
 //thickness=0.1 //x=88.855 //y=7.41 //x2=88.855 //y2=6.585
r1725 (  1011 1132 ) resistor r=5.29055 //w=0.35 //l=0.17 //layer=li \
 //thickness=0.1 //x=88.35 //y=7.585 //x2=88.18 //y2=7.585
r1726 (  1010 1134 ) resistor r=2.87058 //w=0.35 //l=0.085 //layer=li \
 //thickness=0.1 //x=88.77 //y=7.585 //x2=88.855 //y2=7.585
r1727 (  1010 1011 ) resistor r=14.6485 //w=0.367 //l=0.42 //layer=li \
 //thickness=0.1 //x=88.77 //y=7.585 //x2=88.35 //y2=7.585
r1728 (  1005 1007 ) resistor r=38.7139 //w=0.367 //l=1.11 //layer=li \
 //thickness=0.1 //x=86.33 //y=7.585 //x2=87.44 //y2=7.585
r1729 (  1003 1005 ) resistor r=38.7139 //w=0.367 //l=1.11 //layer=li \
 //thickness=0.1 //x=85.22 //y=7.585 //x2=86.33 //y2=7.585
r1730 (  1001 1131 ) resistor r=5.29055 //w=0.35 //l=0.17 //layer=li \
 //thickness=0.1 //x=85.02 //y=7.585 //x2=84.85 //y2=7.585
r1731 (  1001 1003 ) resistor r=6.97548 //w=0.367 //l=0.2 //layer=li \
 //thickness=0.1 //x=85.02 //y=7.585 //x2=85.22 //y2=7.585
r1732 (  1000 1132 ) resistor r=5.29055 //w=0.35 //l=0.17 //layer=li \
 //thickness=0.1 //x=88.01 //y=7.585 //x2=88.18 //y2=7.585
r1733 (  1000 1007 ) resistor r=19.8801 //w=0.367 //l=0.57 //layer=li \
 //thickness=0.1 //x=88.01 //y=7.585 //x2=87.44 //y2=7.585
r1734 (  995 997 ) resistor r=38.7139 //w=0.367 //l=1.11 //layer=li \
 //thickness=0.1 //x=82.63 //y=7.585 //x2=83.74 //y2=7.585
r1735 (  993 1130 ) resistor r=5.29055 //w=0.35 //l=0.17 //layer=li \
 //thickness=0.1 //x=81.69 //y=7.585 //x2=81.52 //y2=7.585
r1736 (  993 995 ) resistor r=32.7847 //w=0.367 //l=0.94 //layer=li \
 //thickness=0.1 //x=81.69 //y=7.585 //x2=82.63 //y2=7.585
r1737 (  992 1131 ) resistor r=5.29055 //w=0.35 //l=0.17 //layer=li \
 //thickness=0.1 //x=84.68 //y=7.585 //x2=84.85 //y2=7.585
r1738 (  992 997 ) resistor r=32.7847 //w=0.367 //l=0.94 //layer=li \
 //thickness=0.1 //x=84.68 //y=7.585 //x2=83.74 //y2=7.585
r1739 (  988 1205 ) resistor r=23.2727 //w=0.187 //l=0.34 //layer=li \
 //thickness=0.1 //x=80.74 //y=6.92 //x2=80.74 //y2=6.58
r1740 (  973 1203 ) resistor r=23.2727 //w=0.187 //l=0.34 //layer=li \
 //thickness=0.1 //x=78.98 //y=6.92 //x2=78.98 //y2=6.58
r1741 (  962 964 ) resistor r=38.7139 //w=0.367 //l=1.11 //layer=li \
 //thickness=0.1 //x=80.04 //y=7.585 //x2=81.15 //y2=7.585
r1742 (  960 962 ) resistor r=38.7139 //w=0.367 //l=1.11 //layer=li \
 //thickness=0.1 //x=78.93 //y=7.585 //x2=80.04 //y2=7.585
r1743 (  958 1129 ) resistor r=5.29055 //w=0.35 //l=0.17 //layer=li \
 //thickness=0.1 //x=78.36 //y=7.585 //x2=78.19 //y2=7.585
r1744 (  958 960 ) resistor r=19.8801 //w=0.367 //l=0.57 //layer=li \
 //thickness=0.1 //x=78.36 //y=7.585 //x2=78.93 //y2=7.585
r1745 (  957 1130 ) resistor r=5.29055 //w=0.35 //l=0.17 //layer=li \
 //thickness=0.1 //x=81.35 //y=7.585 //x2=81.52 //y2=7.585
r1746 (  957 964 ) resistor r=6.97548 //w=0.367 //l=0.2 //layer=li \
 //thickness=0.1 //x=81.35 //y=7.585 //x2=81.15 //y2=7.585
r1747 (  954 1128 ) resistor r=2.87058 //w=0.35 //l=0.085 //layer=li \
 //thickness=0.1 //x=77.495 //y=7.585 //x2=77.41 //y2=7.585
r1748 (  953 1129 ) resistor r=5.29055 //w=0.35 //l=0.17 //layer=li \
 //thickness=0.1 //x=78.02 //y=7.585 //x2=78.19 //y2=7.585
r1749 (  953 954 ) resistor r=18.3106 //w=0.367 //l=0.525 //layer=li \
 //thickness=0.1 //x=78.02 //y=7.585 //x2=77.495 //y2=7.585
r1750 (  947 1128 ) resistor r=4.23183 //w=0.7 //l=0.175 //layer=li \
 //thickness=0.1 //x=77.41 //y=7.41 //x2=77.41 //y2=7.585
r1751 (  947 1202 ) resistor r=33.1979 //w=0.187 //l=0.485 //layer=li \
 //thickness=0.1 //x=77.41 //y=7.41 //x2=77.41 //y2=6.925
r1752 (  946 1126 ) resistor r=2.87058 //w=0.35 //l=0.085 //layer=li \
 //thickness=0.1 //x=76.615 //y=7.585 //x2=76.53 //y2=7.585
r1753 (  945 1128 ) resistor r=2.87058 //w=0.35 //l=0.085 //layer=li \
 //thickness=0.1 //x=77.325 //y=7.585 //x2=77.41 //y2=7.585
r1754 (  945 946 ) resistor r=24.7629 //w=0.367 //l=0.71 //layer=li \
 //thickness=0.1 //x=77.325 //y=7.585 //x2=76.615 //y2=7.585
r1755 (  939 1126 ) resistor r=4.23183 //w=0.7 //l=0.175 //layer=li \
 //thickness=0.1 //x=76.53 //y=7.41 //x2=76.53 //y2=7.585
r1756 (  939 1201 ) resistor r=33.1979 //w=0.187 //l=0.485 //layer=li \
 //thickness=0.1 //x=76.53 //y=7.41 //x2=76.53 //y2=6.925
r1757 (  936 1125 ) resistor r=2.87058 //w=0.35 //l=0.085 //layer=li \
 //thickness=0.1 //x=75.735 //y=7.585 //x2=75.65 //y2=7.585
r1758 (  936 938 ) resistor r=21.1008 //w=0.367 //l=0.605 //layer=li \
 //thickness=0.1 //x=75.735 //y=7.585 //x2=76.34 //y2=7.585
r1759 (  935 1126 ) resistor r=2.87058 //w=0.35 //l=0.085 //layer=li \
 //thickness=0.1 //x=76.445 //y=7.585 //x2=76.53 //y2=7.585
r1760 (  935 938 ) resistor r=3.66213 //w=0.367 //l=0.105 //layer=li \
 //thickness=0.1 //x=76.445 //y=7.585 //x2=76.34 //y2=7.585
r1761 (  927 1125 ) resistor r=4.23183 //w=0.7 //l=0.175 //layer=li \
 //thickness=0.1 //x=75.65 //y=7.41 //x2=75.65 //y2=7.585
r1762 (  927 1200 ) resistor r=56.4706 //w=0.187 //l=0.825 //layer=li \
 //thickness=0.1 //x=75.65 //y=7.41 //x2=75.65 //y2=6.585
r1763 (  924 1124 ) resistor r=5.29055 //w=0.35 //l=0.17 //layer=li \
 //thickness=0.1 //x=75.03 //y=7.585 //x2=74.86 //y2=7.585
r1764 (  924 926 ) resistor r=6.97548 //w=0.367 //l=0.2 //layer=li \
 //thickness=0.1 //x=75.03 //y=7.585 //x2=75.23 //y2=7.585
r1765 (  923 1125 ) resistor r=2.87058 //w=0.35 //l=0.085 //layer=li \
 //thickness=0.1 //x=75.565 //y=7.585 //x2=75.65 //y2=7.585
r1766 (  923 926 ) resistor r=11.6839 //w=0.367 //l=0.335 //layer=li \
 //thickness=0.1 //x=75.565 //y=7.585 //x2=75.23 //y2=7.585
r1767 (  920 1123 ) resistor r=2.87058 //w=0.35 //l=0.085 //layer=li \
 //thickness=0.1 //x=73.865 //y=7.585 //x2=73.78 //y2=7.585
r1768 (  919 1124 ) resistor r=5.29055 //w=0.35 //l=0.17 //layer=li \
 //thickness=0.1 //x=74.69 //y=7.585 //x2=74.86 //y2=7.585
r1769 (  919 920 ) resistor r=28.7738 //w=0.367 //l=0.825 //layer=li \
 //thickness=0.1 //x=74.69 //y=7.585 //x2=73.865 //y2=7.585
r1770 (  913 1123 ) resistor r=4.23183 //w=0.7 //l=0.175 //layer=li \
 //thickness=0.1 //x=73.78 //y=7.41 //x2=73.78 //y2=7.585
r1771 (  913 1199 ) resistor r=33.1979 //w=0.187 //l=0.485 //layer=li \
 //thickness=0.1 //x=73.78 //y=7.41 //x2=73.78 //y2=6.925
r1772 (  912 1121 ) resistor r=2.87058 //w=0.35 //l=0.085 //layer=li \
 //thickness=0.1 //x=72.985 //y=7.585 //x2=72.9 //y2=7.585
r1773 (  911 1123 ) resistor r=2.87058 //w=0.35 //l=0.085 //layer=li \
 //thickness=0.1 //x=73.695 //y=7.585 //x2=73.78 //y2=7.585
r1774 (  911 912 ) resistor r=24.7629 //w=0.367 //l=0.71 //layer=li \
 //thickness=0.1 //x=73.695 //y=7.585 //x2=72.985 //y2=7.585
r1775 (  905 1121 ) resistor r=4.23183 //w=0.7 //l=0.175 //layer=li \
 //thickness=0.1 //x=72.9 //y=7.41 //x2=72.9 //y2=7.585
r1776 (  905 1198 ) resistor r=33.1979 //w=0.187 //l=0.485 //layer=li \
 //thickness=0.1 //x=72.9 //y=7.41 //x2=72.9 //y2=6.925
r1777 (  902 1120 ) resistor r=2.87058 //w=0.35 //l=0.085 //layer=li \
 //thickness=0.1 //x=72.105 //y=7.585 //x2=72.02 //y2=7.585
r1778 (  902 904 ) resistor r=18.6594 //w=0.367 //l=0.535 //layer=li \
 //thickness=0.1 //x=72.105 //y=7.585 //x2=72.64 //y2=7.585
r1779 (  901 1121 ) resistor r=2.87058 //w=0.35 //l=0.085 //layer=li \
 //thickness=0.1 //x=72.815 //y=7.585 //x2=72.9 //y2=7.585
r1780 (  901 904 ) resistor r=6.10354 //w=0.367 //l=0.175 //layer=li \
 //thickness=0.1 //x=72.815 //y=7.585 //x2=72.64 //y2=7.585
r1781 (  895 1120 ) resistor r=4.23183 //w=0.7 //l=0.175 //layer=li \
 //thickness=0.1 //x=72.02 //y=7.41 //x2=72.02 //y2=7.585
r1782 (  895 1197 ) resistor r=33.1979 //w=0.187 //l=0.485 //layer=li \
 //thickness=0.1 //x=72.02 //y=7.41 //x2=72.02 //y2=6.925
r1783 (  892 1119 ) resistor r=2.87058 //w=0.35 //l=0.085 //layer=li \
 //thickness=0.1 //x=71.225 //y=7.585 //x2=71.14 //y2=7.585
r1784 (  892 894 ) resistor r=10.6376 //w=0.367 //l=0.305 //layer=li \
 //thickness=0.1 //x=71.225 //y=7.585 //x2=71.53 //y2=7.585
r1785 (  891 1120 ) resistor r=2.87058 //w=0.35 //l=0.085 //layer=li \
 //thickness=0.1 //x=71.935 //y=7.585 //x2=72.02 //y2=7.585
r1786 (  891 894 ) resistor r=14.1253 //w=0.367 //l=0.405 //layer=li \
 //thickness=0.1 //x=71.935 //y=7.585 //x2=71.53 //y2=7.585
r1787 (  883 1119 ) resistor r=4.23183 //w=0.7 //l=0.175 //layer=li \
 //thickness=0.1 //x=71.14 //y=7.41 //x2=71.14 //y2=7.585
r1788 (  883 1196 ) resistor r=56.4706 //w=0.187 //l=0.825 //layer=li \
 //thickness=0.1 //x=71.14 //y=7.41 //x2=71.14 //y2=6.585
r1789 (  880 1118 ) resistor r=5.29055 //w=0.35 //l=0.17 //layer=li \
 //thickness=0.1 //x=70.22 //y=7.585 //x2=70.05 //y2=7.585
r1790 (  880 882 ) resistor r=6.97548 //w=0.367 //l=0.2 //layer=li \
 //thickness=0.1 //x=70.22 //y=7.585 //x2=70.42 //y2=7.585
r1791 (  879 1119 ) resistor r=2.87058 //w=0.35 //l=0.085 //layer=li \
 //thickness=0.1 //x=71.055 //y=7.585 //x2=71.14 //y2=7.585
r1792 (  879 882 ) resistor r=22.1471 //w=0.367 //l=0.635 //layer=li \
 //thickness=0.1 //x=71.055 //y=7.585 //x2=70.42 //y2=7.585
r1793 (  876 1117 ) resistor r=2.87058 //w=0.35 //l=0.085 //layer=li \
 //thickness=0.1 //x=69.055 //y=7.585 //x2=68.97 //y2=7.585
r1794 (  875 1118 ) resistor r=5.29055 //w=0.35 //l=0.17 //layer=li \
 //thickness=0.1 //x=69.88 //y=7.585 //x2=70.05 //y2=7.585
r1795 (  875 876 ) resistor r=28.7738 //w=0.367 //l=0.825 //layer=li \
 //thickness=0.1 //x=69.88 //y=7.585 //x2=69.055 //y2=7.585
r1796 (  869 1117 ) resistor r=4.23183 //w=0.7 //l=0.175 //layer=li \
 //thickness=0.1 //x=68.97 //y=7.41 //x2=68.97 //y2=7.585
r1797 (  869 1195 ) resistor r=33.1979 //w=0.187 //l=0.485 //layer=li \
 //thickness=0.1 //x=68.97 //y=7.41 //x2=68.97 //y2=6.925
r1798 (  868 1115 ) resistor r=2.87058 //w=0.35 //l=0.085 //layer=li \
 //thickness=0.1 //x=68.175 //y=7.585 //x2=68.09 //y2=7.585
r1799 (  867 1117 ) resistor r=2.87058 //w=0.35 //l=0.085 //layer=li \
 //thickness=0.1 //x=68.885 //y=7.585 //x2=68.97 //y2=7.585
r1800 (  867 868 ) resistor r=24.7629 //w=0.367 //l=0.71 //layer=li \
 //thickness=0.1 //x=68.885 //y=7.585 //x2=68.175 //y2=7.585
r1801 (  861 1115 ) resistor r=4.23183 //w=0.7 //l=0.175 //layer=li \
 //thickness=0.1 //x=68.09 //y=7.41 //x2=68.09 //y2=7.585
r1802 (  861 1194 ) resistor r=33.1979 //w=0.187 //l=0.485 //layer=li \
 //thickness=0.1 //x=68.09 //y=7.41 //x2=68.09 //y2=6.925
r1803 (  858 1114 ) resistor r=2.87058 //w=0.35 //l=0.085 //layer=li \
 //thickness=0.1 //x=67.295 //y=7.585 //x2=67.21 //y2=7.585
r1804 (  858 860 ) resistor r=18.6594 //w=0.367 //l=0.535 //layer=li \
 //thickness=0.1 //x=67.295 //y=7.585 //x2=67.83 //y2=7.585
r1805 (  857 1115 ) resistor r=2.87058 //w=0.35 //l=0.085 //layer=li \
 //thickness=0.1 //x=68.005 //y=7.585 //x2=68.09 //y2=7.585
r1806 (  857 860 ) resistor r=6.10354 //w=0.367 //l=0.175 //layer=li \
 //thickness=0.1 //x=68.005 //y=7.585 //x2=67.83 //y2=7.585
r1807 (  851 1114 ) resistor r=4.23183 //w=0.7 //l=0.175 //layer=li \
 //thickness=0.1 //x=67.21 //y=7.41 //x2=67.21 //y2=7.585
r1808 (  851 1193 ) resistor r=33.1979 //w=0.187 //l=0.485 //layer=li \
 //thickness=0.1 //x=67.21 //y=7.41 //x2=67.21 //y2=6.925
r1809 (  848 1113 ) resistor r=2.87058 //w=0.35 //l=0.085 //layer=li \
 //thickness=0.1 //x=66.415 //y=7.585 //x2=66.33 //y2=7.585
r1810 (  848 850 ) resistor r=10.6376 //w=0.367 //l=0.305 //layer=li \
 //thickness=0.1 //x=66.415 //y=7.585 //x2=66.72 //y2=7.585
r1811 (  847 1114 ) resistor r=2.87058 //w=0.35 //l=0.085 //layer=li \
 //thickness=0.1 //x=67.125 //y=7.585 //x2=67.21 //y2=7.585
r1812 (  847 850 ) resistor r=14.1253 //w=0.367 //l=0.405 //layer=li \
 //thickness=0.1 //x=67.125 //y=7.585 //x2=66.72 //y2=7.585
r1813 (  839 1113 ) resistor r=4.23183 //w=0.7 //l=0.175 //layer=li \
 //thickness=0.1 //x=66.33 //y=7.41 //x2=66.33 //y2=7.585
r1814 (  839 1192 ) resistor r=56.4706 //w=0.187 //l=0.825 //layer=li \
 //thickness=0.1 //x=66.33 //y=7.41 //x2=66.33 //y2=6.585
r1815 (  836 1112 ) resistor r=5.29055 //w=0.35 //l=0.17 //layer=li \
 //thickness=0.1 //x=65.41 //y=7.585 //x2=65.24 //y2=7.585
r1816 (  836 838 ) resistor r=6.97548 //w=0.367 //l=0.2 //layer=li \
 //thickness=0.1 //x=65.41 //y=7.585 //x2=65.61 //y2=7.585
r1817 (  835 1113 ) resistor r=2.87058 //w=0.35 //l=0.085 //layer=li \
 //thickness=0.1 //x=66.245 //y=7.585 //x2=66.33 //y2=7.585
r1818 (  835 838 ) resistor r=22.1471 //w=0.367 //l=0.635 //layer=li \
 //thickness=0.1 //x=66.245 //y=7.585 //x2=65.61 //y2=7.585
r1819 (  832 1111 ) resistor r=2.87058 //w=0.35 //l=0.085 //layer=li \
 //thickness=0.1 //x=64.545 //y=7.585 //x2=64.46 //y2=7.585
r1820 (  831 1112 ) resistor r=5.29055 //w=0.35 //l=0.17 //layer=li \
 //thickness=0.1 //x=65.07 //y=7.585 //x2=65.24 //y2=7.585
r1821 (  831 832 ) resistor r=18.3106 //w=0.367 //l=0.525 //layer=li \
 //thickness=0.1 //x=65.07 //y=7.585 //x2=64.545 //y2=7.585
r1822 (  825 1111 ) resistor r=4.23183 //w=0.7 //l=0.175 //layer=li \
 //thickness=0.1 //x=64.46 //y=7.41 //x2=64.46 //y2=7.585
r1823 (  825 1191 ) resistor r=33.1979 //w=0.187 //l=0.485 //layer=li \
 //thickness=0.1 //x=64.46 //y=7.41 //x2=64.46 //y2=6.925
r1824 (  822 1110 ) resistor r=2.87058 //w=0.35 //l=0.085 //layer=li \
 //thickness=0.1 //x=63.665 //y=7.585 //x2=63.58 //y2=7.585
r1825 (  822 824 ) resistor r=16.218 //w=0.367 //l=0.465 //layer=li \
 //thickness=0.1 //x=63.665 //y=7.585 //x2=64.13 //y2=7.585
r1826 (  821 1111 ) resistor r=2.87058 //w=0.35 //l=0.085 //layer=li \
 //thickness=0.1 //x=64.375 //y=7.585 //x2=64.46 //y2=7.585
r1827 (  821 824 ) resistor r=8.54496 //w=0.367 //l=0.245 //layer=li \
 //thickness=0.1 //x=64.375 //y=7.585 //x2=64.13 //y2=7.585
r1828 (  815 1110 ) resistor r=4.23183 //w=0.7 //l=0.175 //layer=li \
 //thickness=0.1 //x=63.58 //y=7.41 //x2=63.58 //y2=7.585
r1829 (  815 1190 ) resistor r=33.1979 //w=0.187 //l=0.485 //layer=li \
 //thickness=0.1 //x=63.58 //y=7.41 //x2=63.58 //y2=6.925
r1830 (  812 1109 ) resistor r=2.87058 //w=0.35 //l=0.085 //layer=li \
 //thickness=0.1 //x=62.785 //y=7.585 //x2=62.7 //y2=7.585
r1831 (  812 814 ) resistor r=8.19619 //w=0.367 //l=0.235 //layer=li \
 //thickness=0.1 //x=62.785 //y=7.585 //x2=63.02 //y2=7.585
r1832 (  811 1110 ) resistor r=2.87058 //w=0.35 //l=0.085 //layer=li \
 //thickness=0.1 //x=63.495 //y=7.585 //x2=63.58 //y2=7.585
r1833 (  811 814 ) resistor r=16.5668 //w=0.367 //l=0.475 //layer=li \
 //thickness=0.1 //x=63.495 //y=7.585 //x2=63.02 //y2=7.585
r1834 (  803 1109 ) resistor r=4.23183 //w=0.7 //l=0.175 //layer=li \
 //thickness=0.1 //x=62.7 //y=7.41 //x2=62.7 //y2=7.585
r1835 (  803 1189 ) resistor r=56.4706 //w=0.187 //l=0.825 //layer=li \
 //thickness=0.1 //x=62.7 //y=7.41 //x2=62.7 //y2=6.585
r1836 (  802 1108 ) resistor r=5.29055 //w=0.35 //l=0.17 //layer=li \
 //thickness=0.1 //x=62.08 //y=7.585 //x2=61.91 //y2=7.585
r1837 (  801 1109 ) resistor r=2.87058 //w=0.35 //l=0.085 //layer=li \
 //thickness=0.1 //x=62.615 //y=7.585 //x2=62.7 //y2=7.585
r1838 (  801 802 ) resistor r=18.6594 //w=0.367 //l=0.535 //layer=li \
 //thickness=0.1 //x=62.615 //y=7.585 //x2=62.08 //y2=7.585
r1839 (  796 1107 ) resistor r=2.87058 //w=0.35 //l=0.085 //layer=li \
 //thickness=0.1 //x=60.915 //y=7.585 //x2=60.83 //y2=7.585
r1840 (  796 798 ) resistor r=21.7984 //w=0.367 //l=0.625 //layer=li \
 //thickness=0.1 //x=60.915 //y=7.585 //x2=61.54 //y2=7.585
r1841 (  795 1108 ) resistor r=5.29055 //w=0.35 //l=0.17 //layer=li \
 //thickness=0.1 //x=61.74 //y=7.585 //x2=61.91 //y2=7.585
r1842 (  795 798 ) resistor r=6.97548 //w=0.367 //l=0.2 //layer=li \
 //thickness=0.1 //x=61.74 //y=7.585 //x2=61.54 //y2=7.585
r1843 (  789 1107 ) resistor r=4.23183 //w=0.7 //l=0.175 //layer=li \
 //thickness=0.1 //x=60.83 //y=7.41 //x2=60.83 //y2=7.585
r1844 (  789 1188 ) resistor r=33.1979 //w=0.187 //l=0.485 //layer=li \
 //thickness=0.1 //x=60.83 //y=7.41 //x2=60.83 //y2=6.925
r1845 (  786 1106 ) resistor r=2.87058 //w=0.35 //l=0.085 //layer=li \
 //thickness=0.1 //x=60.035 //y=7.585 //x2=59.95 //y2=7.585
r1846 (  786 788 ) resistor r=13.7766 //w=0.367 //l=0.395 //layer=li \
 //thickness=0.1 //x=60.035 //y=7.585 //x2=60.43 //y2=7.585
r1847 (  785 1107 ) resistor r=2.87058 //w=0.35 //l=0.085 //layer=li \
 //thickness=0.1 //x=60.745 //y=7.585 //x2=60.83 //y2=7.585
r1848 (  785 788 ) resistor r=10.9864 //w=0.367 //l=0.315 //layer=li \
 //thickness=0.1 //x=60.745 //y=7.585 //x2=60.43 //y2=7.585
r1849 (  779 1106 ) resistor r=4.23183 //w=0.7 //l=0.175 //layer=li \
 //thickness=0.1 //x=59.95 //y=7.41 //x2=59.95 //y2=7.585
r1850 (  779 1187 ) resistor r=33.1979 //w=0.187 //l=0.485 //layer=li \
 //thickness=0.1 //x=59.95 //y=7.41 //x2=59.95 //y2=6.925
r1851 (  776 1105 ) resistor r=2.87058 //w=0.35 //l=0.085 //layer=li \
 //thickness=0.1 //x=59.155 //y=7.585 //x2=59.07 //y2=7.585
r1852 (  776 778 ) resistor r=5.75477 //w=0.367 //l=0.165 //layer=li \
 //thickness=0.1 //x=59.155 //y=7.585 //x2=59.32 //y2=7.585
r1853 (  775 1106 ) resistor r=2.87058 //w=0.35 //l=0.085 //layer=li \
 //thickness=0.1 //x=59.865 //y=7.585 //x2=59.95 //y2=7.585
r1854 (  775 778 ) resistor r=19.0082 //w=0.367 //l=0.545 //layer=li \
 //thickness=0.1 //x=59.865 //y=7.585 //x2=59.32 //y2=7.585
r1855 (  769 1105 ) resistor r=4.23183 //w=0.7 //l=0.175 //layer=li \
 //thickness=0.1 //x=59.07 //y=7.41 //x2=59.07 //y2=7.585
r1856 (  769 1186 ) resistor r=33.1979 //w=0.187 //l=0.485 //layer=li \
 //thickness=0.1 //x=59.07 //y=7.41 //x2=59.07 //y2=6.925
r1857 (  768 1104 ) resistor r=2.87058 //w=0.35 //l=0.085 //layer=li \
 //thickness=0.1 //x=58.275 //y=7.585 //x2=58.19 //y2=7.585
r1858 (  767 1105 ) resistor r=2.87058 //w=0.35 //l=0.085 //layer=li \
 //thickness=0.1 //x=58.985 //y=7.585 //x2=59.07 //y2=7.585
r1859 (  767 768 ) resistor r=24.7629 //w=0.367 //l=0.71 //layer=li \
 //thickness=0.1 //x=58.985 //y=7.585 //x2=58.275 //y2=7.585
r1860 (  759 1104 ) resistor r=4.23183 //w=0.7 //l=0.175 //layer=li \
 //thickness=0.1 //x=58.19 //y=7.41 //x2=58.19 //y2=7.585
r1861 (  759 1185 ) resistor r=56.4706 //w=0.187 //l=0.825 //layer=li \
 //thickness=0.1 //x=58.19 //y=7.41 //x2=58.19 //y2=6.585
r1862 (  758 1102 ) resistor r=5.29055 //w=0.35 //l=0.17 //layer=li \
 //thickness=0.1 //x=57.27 //y=7.585 //x2=57.1 //y2=7.585
r1863 (  757 1104 ) resistor r=2.87058 //w=0.35 //l=0.085 //layer=li \
 //thickness=0.1 //x=58.105 //y=7.585 //x2=58.19 //y2=7.585
r1864 (  757 758 ) resistor r=29.1226 //w=0.367 //l=0.835 //layer=li \
 //thickness=0.1 //x=58.105 //y=7.585 //x2=57.27 //y2=7.585
r1865 (  752 1101 ) resistor r=2.87058 //w=0.35 //l=0.085 //layer=li \
 //thickness=0.1 //x=56.105 //y=7.585 //x2=56.02 //y2=7.585
r1866 (  752 754 ) resistor r=21.7984 //w=0.367 //l=0.625 //layer=li \
 //thickness=0.1 //x=56.105 //y=7.585 //x2=56.73 //y2=7.585
r1867 (  751 1102 ) resistor r=5.29055 //w=0.35 //l=0.17 //layer=li \
 //thickness=0.1 //x=56.93 //y=7.585 //x2=57.1 //y2=7.585
r1868 (  751 754 ) resistor r=6.97548 //w=0.367 //l=0.2 //layer=li \
 //thickness=0.1 //x=56.93 //y=7.585 //x2=56.73 //y2=7.585
r1869 (  745 1101 ) resistor r=4.23183 //w=0.7 //l=0.175 //layer=li \
 //thickness=0.1 //x=56.02 //y=7.41 //x2=56.02 //y2=7.585
r1870 (  745 1184 ) resistor r=33.1979 //w=0.187 //l=0.485 //layer=li \
 //thickness=0.1 //x=56.02 //y=7.41 //x2=56.02 //y2=6.925
r1871 (  742 1100 ) resistor r=2.87058 //w=0.35 //l=0.085 //layer=li \
 //thickness=0.1 //x=55.225 //y=7.585 //x2=55.14 //y2=7.585
r1872 (  742 744 ) resistor r=13.7766 //w=0.367 //l=0.395 //layer=li \
 //thickness=0.1 //x=55.225 //y=7.585 //x2=55.62 //y2=7.585
r1873 (  741 1101 ) resistor r=2.87058 //w=0.35 //l=0.085 //layer=li \
 //thickness=0.1 //x=55.935 //y=7.585 //x2=56.02 //y2=7.585
r1874 (  741 744 ) resistor r=10.9864 //w=0.367 //l=0.315 //layer=li \
 //thickness=0.1 //x=55.935 //y=7.585 //x2=55.62 //y2=7.585
r1875 (  735 1100 ) resistor r=4.23183 //w=0.7 //l=0.175 //layer=li \
 //thickness=0.1 //x=55.14 //y=7.41 //x2=55.14 //y2=7.585
r1876 (  735 1183 ) resistor r=33.1979 //w=0.187 //l=0.485 //layer=li \
 //thickness=0.1 //x=55.14 //y=7.41 //x2=55.14 //y2=6.925
r1877 (  732 1099 ) resistor r=2.87058 //w=0.35 //l=0.085 //layer=li \
 //thickness=0.1 //x=54.345 //y=7.585 //x2=54.26 //y2=7.585
r1878 (  732 734 ) resistor r=5.75477 //w=0.367 //l=0.165 //layer=li \
 //thickness=0.1 //x=54.345 //y=7.585 //x2=54.51 //y2=7.585
r1879 (  731 1100 ) resistor r=2.87058 //w=0.35 //l=0.085 //layer=li \
 //thickness=0.1 //x=55.055 //y=7.585 //x2=55.14 //y2=7.585
r1880 (  731 734 ) resistor r=19.0082 //w=0.367 //l=0.545 //layer=li \
 //thickness=0.1 //x=55.055 //y=7.585 //x2=54.51 //y2=7.585
r1881 (  725 1099 ) resistor r=4.23183 //w=0.7 //l=0.175 //layer=li \
 //thickness=0.1 //x=54.26 //y=7.41 //x2=54.26 //y2=7.585
r1882 (  725 1182 ) resistor r=33.1979 //w=0.187 //l=0.485 //layer=li \
 //thickness=0.1 //x=54.26 //y=7.41 //x2=54.26 //y2=6.925
r1883 (  724 1098 ) resistor r=2.87058 //w=0.35 //l=0.085 //layer=li \
 //thickness=0.1 //x=53.465 //y=7.585 //x2=53.38 //y2=7.585
r1884 (  723 1099 ) resistor r=2.87058 //w=0.35 //l=0.085 //layer=li \
 //thickness=0.1 //x=54.175 //y=7.585 //x2=54.26 //y2=7.585
r1885 (  723 724 ) resistor r=24.7629 //w=0.367 //l=0.71 //layer=li \
 //thickness=0.1 //x=54.175 //y=7.585 //x2=53.465 //y2=7.585
r1886 (  715 1098 ) resistor r=4.23183 //w=0.7 //l=0.175 //layer=li \
 //thickness=0.1 //x=53.38 //y=7.41 //x2=53.38 //y2=7.585
r1887 (  715 1181 ) resistor r=56.4706 //w=0.187 //l=0.825 //layer=li \
 //thickness=0.1 //x=53.38 //y=7.41 //x2=53.38 //y2=6.585
r1888 (  714 1096 ) resistor r=5.29055 //w=0.35 //l=0.17 //layer=li \
 //thickness=0.1 //x=52.46 //y=7.585 //x2=52.29 //y2=7.585
r1889 (  713 1098 ) resistor r=2.87058 //w=0.35 //l=0.085 //layer=li \
 //thickness=0.1 //x=53.295 //y=7.585 //x2=53.38 //y2=7.585
r1890 (  713 714 ) resistor r=29.1226 //w=0.367 //l=0.835 //layer=li \
 //thickness=0.1 //x=53.295 //y=7.585 //x2=52.46 //y2=7.585
r1891 (  708 1095 ) resistor r=2.87058 //w=0.35 //l=0.085 //layer=li \
 //thickness=0.1 //x=51.595 //y=7.585 //x2=51.51 //y2=7.585
r1892 (  708 710 ) resistor r=11.3351 //w=0.367 //l=0.325 //layer=li \
 //thickness=0.1 //x=51.595 //y=7.585 //x2=51.92 //y2=7.585
r1893 (  707 1096 ) resistor r=5.29055 //w=0.35 //l=0.17 //layer=li \
 //thickness=0.1 //x=52.12 //y=7.585 //x2=52.29 //y2=7.585
r1894 (  707 710 ) resistor r=6.97548 //w=0.367 //l=0.2 //layer=li \
 //thickness=0.1 //x=52.12 //y=7.585 //x2=51.92 //y2=7.585
r1895 (  701 1095 ) resistor r=4.23183 //w=0.7 //l=0.175 //layer=li \
 //thickness=0.1 //x=51.51 //y=7.41 //x2=51.51 //y2=7.585
r1896 (  701 1180 ) resistor r=33.1979 //w=0.187 //l=0.485 //layer=li \
 //thickness=0.1 //x=51.51 //y=7.41 //x2=51.51 //y2=6.925
r1897 (  698 1094 ) resistor r=2.87058 //w=0.35 //l=0.085 //layer=li \
 //thickness=0.1 //x=50.715 //y=7.585 //x2=50.63 //y2=7.585
r1898 (  698 700 ) resistor r=3.31335 //w=0.367 //l=0.095 //layer=li \
 //thickness=0.1 //x=50.715 //y=7.585 //x2=50.81 //y2=7.585
r1899 (  697 1095 ) resistor r=2.87058 //w=0.35 //l=0.085 //layer=li \
 //thickness=0.1 //x=51.425 //y=7.585 //x2=51.51 //y2=7.585
r1900 (  697 700 ) resistor r=21.4496 //w=0.367 //l=0.615 //layer=li \
 //thickness=0.1 //x=51.425 //y=7.585 //x2=50.81 //y2=7.585
r1901 (  691 1094 ) resistor r=4.23183 //w=0.7 //l=0.175 //layer=li \
 //thickness=0.1 //x=50.63 //y=7.41 //x2=50.63 //y2=7.585
r1902 (  691 1179 ) resistor r=33.1979 //w=0.187 //l=0.485 //layer=li \
 //thickness=0.1 //x=50.63 //y=7.41 //x2=50.63 //y2=6.925
r1903 (  690 1093 ) resistor r=2.87058 //w=0.35 //l=0.085 //layer=li \
 //thickness=0.1 //x=49.835 //y=7.585 //x2=49.75 //y2=7.585
r1904 (  689 1094 ) resistor r=2.87058 //w=0.35 //l=0.085 //layer=li \
 //thickness=0.1 //x=50.545 //y=7.585 //x2=50.63 //y2=7.585
r1905 (  689 690 ) resistor r=24.7629 //w=0.367 //l=0.71 //layer=li \
 //thickness=0.1 //x=50.545 //y=7.585 //x2=49.835 //y2=7.585
r1906 (  681 1093 ) resistor r=4.23183 //w=0.7 //l=0.175 //layer=li \
 //thickness=0.1 //x=49.75 //y=7.41 //x2=49.75 //y2=7.585
r1907 (  681 1178 ) resistor r=56.4706 //w=0.187 //l=0.825 //layer=li \
 //thickness=0.1 //x=49.75 //y=7.41 //x2=49.75 //y2=6.585
r1908 (  680 1091 ) resistor r=5.29055 //w=0.35 //l=0.17 //layer=li \
 //thickness=0.1 //x=49.13 //y=7.585 //x2=48.96 //y2=7.585
r1909 (  679 1093 ) resistor r=2.87058 //w=0.35 //l=0.085 //layer=li \
 //thickness=0.1 //x=49.665 //y=7.585 //x2=49.75 //y2=7.585
r1910 (  679 680 ) resistor r=18.6594 //w=0.367 //l=0.535 //layer=li \
 //thickness=0.1 //x=49.665 //y=7.585 //x2=49.13 //y2=7.585
r1911 (  674 1090 ) resistor r=2.87058 //w=0.35 //l=0.085 //layer=li \
 //thickness=0.1 //x=47.965 //y=7.585 //x2=47.88 //y2=7.585
r1912 (  674 676 ) resistor r=8.89373 //w=0.367 //l=0.255 //layer=li \
 //thickness=0.1 //x=47.965 //y=7.585 //x2=48.22 //y2=7.585
r1913 (  673 1091 ) resistor r=5.29055 //w=0.35 //l=0.17 //layer=li \
 //thickness=0.1 //x=48.79 //y=7.585 //x2=48.96 //y2=7.585
r1914 (  673 676 ) resistor r=19.8801 //w=0.367 //l=0.57 //layer=li \
 //thickness=0.1 //x=48.79 //y=7.585 //x2=48.22 //y2=7.585
r1915 (  667 1090 ) resistor r=4.23183 //w=0.7 //l=0.175 //layer=li \
 //thickness=0.1 //x=47.88 //y=7.41 //x2=47.88 //y2=7.585
r1916 (  667 1177 ) resistor r=33.1979 //w=0.187 //l=0.485 //layer=li \
 //thickness=0.1 //x=47.88 //y=7.41 //x2=47.88 //y2=6.925
r1917 (  664 1089 ) resistor r=2.87058 //w=0.35 //l=0.085 //layer=li \
 //thickness=0.1 //x=47.085 //y=7.585 //x2=47 //y2=7.585
r1918 (  664 666 ) resistor r=0.871935 //w=0.367 //l=0.025 //layer=li \
 //thickness=0.1 //x=47.085 //y=7.585 //x2=47.11 //y2=7.585
r1919 (  663 1090 ) resistor r=2.87058 //w=0.35 //l=0.085 //layer=li \
 //thickness=0.1 //x=47.795 //y=7.585 //x2=47.88 //y2=7.585
r1920 (  663 666 ) resistor r=23.891 //w=0.367 //l=0.685 //layer=li \
 //thickness=0.1 //x=47.795 //y=7.585 //x2=47.11 //y2=7.585
r1921 (  657 1089 ) resistor r=4.23183 //w=0.7 //l=0.175 //layer=li \
 //thickness=0.1 //x=47 //y=7.41 //x2=47 //y2=7.585
r1922 (  657 1176 ) resistor r=33.1979 //w=0.187 //l=0.485 //layer=li \
 //thickness=0.1 //x=47 //y=7.41 //x2=47 //y2=6.925
r1923 (  656 1088 ) resistor r=2.87058 //w=0.35 //l=0.085 //layer=li \
 //thickness=0.1 //x=46.205 //y=7.585 //x2=46.12 //y2=7.585
r1924 (  655 1089 ) resistor r=2.87058 //w=0.35 //l=0.085 //layer=li \
 //thickness=0.1 //x=46.915 //y=7.585 //x2=47 //y2=7.585
r1925 (  655 656 ) resistor r=24.7629 //w=0.367 //l=0.71 //layer=li \
 //thickness=0.1 //x=46.915 //y=7.585 //x2=46.205 //y2=7.585
r1926 (  649 1088 ) resistor r=4.23183 //w=0.7 //l=0.175 //layer=li \
 //thickness=0.1 //x=46.12 //y=7.41 //x2=46.12 //y2=7.585
r1927 (  649 1175 ) resistor r=33.1979 //w=0.187 //l=0.485 //layer=li \
 //thickness=0.1 //x=46.12 //y=7.41 //x2=46.12 //y2=6.925
r1928 (  646 1087 ) resistor r=2.87058 //w=0.35 //l=0.085 //layer=li \
 //thickness=0.1 //x=45.325 //y=7.585 //x2=45.24 //y2=7.585
r1929 (  646 648 ) resistor r=23.5422 //w=0.367 //l=0.675 //layer=li \
 //thickness=0.1 //x=45.325 //y=7.585 //x2=46 //y2=7.585
r1930 (  645 1088 ) resistor r=2.87058 //w=0.35 //l=0.085 //layer=li \
 //thickness=0.1 //x=46.035 //y=7.585 //x2=46.12 //y2=7.585
r1931 (  645 648 ) resistor r=1.22071 //w=0.367 //l=0.035 //layer=li \
 //thickness=0.1 //x=46.035 //y=7.585 //x2=46 //y2=7.585
r1932 (  637 1087 ) resistor r=4.23183 //w=0.7 //l=0.175 //layer=li \
 //thickness=0.1 //x=45.24 //y=7.41 //x2=45.24 //y2=7.585
r1933 (  637 1174 ) resistor r=56.4706 //w=0.187 //l=0.825 //layer=li \
 //thickness=0.1 //x=45.24 //y=7.41 //x2=45.24 //y2=6.585
r1934 (  634 1086 ) resistor r=5.29055 //w=0.35 //l=0.17 //layer=li \
 //thickness=0.1 //x=44.32 //y=7.585 //x2=44.15 //y2=7.585
r1935 (  634 636 ) resistor r=19.8801 //w=0.367 //l=0.57 //layer=li \
 //thickness=0.1 //x=44.32 //y=7.585 //x2=44.89 //y2=7.585
r1936 (  633 1087 ) resistor r=2.87058 //w=0.35 //l=0.085 //layer=li \
 //thickness=0.1 //x=45.155 //y=7.585 //x2=45.24 //y2=7.585
r1937 (  633 636 ) resistor r=9.24251 //w=0.367 //l=0.265 //layer=li \
 //thickness=0.1 //x=45.155 //y=7.585 //x2=44.89 //y2=7.585
r1938 (  628 1085 ) resistor r=2.87058 //w=0.35 //l=0.085 //layer=li \
 //thickness=0.1 //x=43.155 //y=7.585 //x2=43.07 //y2=7.585
r1939 (  628 630 ) resistor r=8.89373 //w=0.367 //l=0.255 //layer=li \
 //thickness=0.1 //x=43.155 //y=7.585 //x2=43.41 //y2=7.585
r1940 (  627 1086 ) resistor r=5.29055 //w=0.35 //l=0.17 //layer=li \
 //thickness=0.1 //x=43.98 //y=7.585 //x2=44.15 //y2=7.585
r1941 (  627 630 ) resistor r=19.8801 //w=0.367 //l=0.57 //layer=li \
 //thickness=0.1 //x=43.98 //y=7.585 //x2=43.41 //y2=7.585
r1942 (  621 1085 ) resistor r=4.23183 //w=0.7 //l=0.175 //layer=li \
 //thickness=0.1 //x=43.07 //y=7.41 //x2=43.07 //y2=7.585
r1943 (  621 1173 ) resistor r=33.1979 //w=0.187 //l=0.485 //layer=li \
 //thickness=0.1 //x=43.07 //y=7.41 //x2=43.07 //y2=6.925
r1944 (  618 1084 ) resistor r=2.87058 //w=0.35 //l=0.085 //layer=li \
 //thickness=0.1 //x=42.275 //y=7.585 //x2=42.19 //y2=7.585
r1945 (  618 620 ) resistor r=0.871935 //w=0.367 //l=0.025 //layer=li \
 //thickness=0.1 //x=42.275 //y=7.585 //x2=42.3 //y2=7.585
r1946 (  617 1085 ) resistor r=2.87058 //w=0.35 //l=0.085 //layer=li \
 //thickness=0.1 //x=42.985 //y=7.585 //x2=43.07 //y2=7.585
r1947 (  617 620 ) resistor r=23.891 //w=0.367 //l=0.685 //layer=li \
 //thickness=0.1 //x=42.985 //y=7.585 //x2=42.3 //y2=7.585
r1948 (  611 1084 ) resistor r=4.23183 //w=0.7 //l=0.175 //layer=li \
 //thickness=0.1 //x=42.19 //y=7.41 //x2=42.19 //y2=7.585
r1949 (  611 1172 ) resistor r=33.1979 //w=0.187 //l=0.485 //layer=li \
 //thickness=0.1 //x=42.19 //y=7.41 //x2=42.19 //y2=6.925
r1950 (  610 1083 ) resistor r=2.87058 //w=0.35 //l=0.085 //layer=li \
 //thickness=0.1 //x=41.395 //y=7.585 //x2=41.31 //y2=7.585
r1951 (  609 1084 ) resistor r=2.87058 //w=0.35 //l=0.085 //layer=li \
 //thickness=0.1 //x=42.105 //y=7.585 //x2=42.19 //y2=7.585
r1952 (  609 610 ) resistor r=24.7629 //w=0.367 //l=0.71 //layer=li \
 //thickness=0.1 //x=42.105 //y=7.585 //x2=41.395 //y2=7.585
r1953 (  603 1083 ) resistor r=4.23183 //w=0.7 //l=0.175 //layer=li \
 //thickness=0.1 //x=41.31 //y=7.41 //x2=41.31 //y2=7.585
r1954 (  603 1171 ) resistor r=33.1979 //w=0.187 //l=0.485 //layer=li \
 //thickness=0.1 //x=41.31 //y=7.41 //x2=41.31 //y2=6.925
r1955 (  600 1082 ) resistor r=2.87058 //w=0.35 //l=0.085 //layer=li \
 //thickness=0.1 //x=40.515 //y=7.585 //x2=40.43 //y2=7.585
r1956 (  600 602 ) resistor r=23.5422 //w=0.367 //l=0.675 //layer=li \
 //thickness=0.1 //x=40.515 //y=7.585 //x2=41.19 //y2=7.585
r1957 (  599 1083 ) resistor r=2.87058 //w=0.35 //l=0.085 //layer=li \
 //thickness=0.1 //x=41.225 //y=7.585 //x2=41.31 //y2=7.585
r1958 (  599 602 ) resistor r=1.22071 //w=0.367 //l=0.035 //layer=li \
 //thickness=0.1 //x=41.225 //y=7.585 //x2=41.19 //y2=7.585
r1959 (  591 1082 ) resistor r=4.23183 //w=0.7 //l=0.175 //layer=li \
 //thickness=0.1 //x=40.43 //y=7.41 //x2=40.43 //y2=7.585
r1960 (  591 1170 ) resistor r=56.4706 //w=0.187 //l=0.825 //layer=li \
 //thickness=0.1 //x=40.43 //y=7.41 //x2=40.43 //y2=6.585
r1961 (  588 1081 ) resistor r=5.29055 //w=0.35 //l=0.17 //layer=li \
 //thickness=0.1 //x=39.51 //y=7.585 //x2=39.34 //y2=7.585
r1962 (  588 590 ) resistor r=19.8801 //w=0.367 //l=0.57 //layer=li \
 //thickness=0.1 //x=39.51 //y=7.585 //x2=40.08 //y2=7.585
r1963 (  587 1082 ) resistor r=2.87058 //w=0.35 //l=0.085 //layer=li \
 //thickness=0.1 //x=40.345 //y=7.585 //x2=40.43 //y2=7.585
r1964 (  587 590 ) resistor r=9.24251 //w=0.367 //l=0.265 //layer=li \
 //thickness=0.1 //x=40.345 //y=7.585 //x2=40.08 //y2=7.585
r1965 (  584 1080 ) resistor r=2.87058 //w=0.35 //l=0.085 //layer=li \
 //thickness=0.1 //x=38.645 //y=7.585 //x2=38.56 //y2=7.585
r1966 (  583 1081 ) resistor r=5.29055 //w=0.35 //l=0.17 //layer=li \
 //thickness=0.1 //x=39.17 //y=7.585 //x2=39.34 //y2=7.585
r1967 (  583 584 ) resistor r=18.3106 //w=0.367 //l=0.525 //layer=li \
 //thickness=0.1 //x=39.17 //y=7.585 //x2=38.645 //y2=7.585
r1968 (  577 1080 ) resistor r=4.23183 //w=0.7 //l=0.175 //layer=li \
 //thickness=0.1 //x=38.56 //y=7.41 //x2=38.56 //y2=7.585
r1969 (  577 1169 ) resistor r=33.1979 //w=0.187 //l=0.485 //layer=li \
 //thickness=0.1 //x=38.56 //y=7.41 //x2=38.56 //y2=6.925
r1970 (  576 1078 ) resistor r=2.87058 //w=0.35 //l=0.085 //layer=li \
 //thickness=0.1 //x=37.765 //y=7.585 //x2=37.68 //y2=7.585
r1971 (  575 1080 ) resistor r=2.87058 //w=0.35 //l=0.085 //layer=li \
 //thickness=0.1 //x=38.475 //y=7.585 //x2=38.56 //y2=7.585
r1972 (  575 576 ) resistor r=24.7629 //w=0.367 //l=0.71 //layer=li \
 //thickness=0.1 //x=38.475 //y=7.585 //x2=37.765 //y2=7.585
r1973 (  569 1078 ) resistor r=4.23183 //w=0.7 //l=0.175 //layer=li \
 //thickness=0.1 //x=37.68 //y=7.41 //x2=37.68 //y2=7.585
r1974 (  569 1168 ) resistor r=33.1979 //w=0.187 //l=0.485 //layer=li \
 //thickness=0.1 //x=37.68 //y=7.41 //x2=37.68 //y2=6.925
r1975 (  566 1077 ) resistor r=2.87058 //w=0.35 //l=0.085 //layer=li \
 //thickness=0.1 //x=36.885 //y=7.585 //x2=36.8 //y2=7.585
r1976 (  566 568 ) resistor r=21.1008 //w=0.367 //l=0.605 //layer=li \
 //thickness=0.1 //x=36.885 //y=7.585 //x2=37.49 //y2=7.585
r1977 (  565 1078 ) resistor r=2.87058 //w=0.35 //l=0.085 //layer=li \
 //thickness=0.1 //x=37.595 //y=7.585 //x2=37.68 //y2=7.585
r1978 (  565 568 ) resistor r=3.66213 //w=0.367 //l=0.105 //layer=li \
 //thickness=0.1 //x=37.595 //y=7.585 //x2=37.49 //y2=7.585
r1979 (  557 1077 ) resistor r=4.23183 //w=0.7 //l=0.175 //layer=li \
 //thickness=0.1 //x=36.8 //y=7.41 //x2=36.8 //y2=7.585
r1980 (  557 1167 ) resistor r=56.4706 //w=0.187 //l=0.825 //layer=li \
 //thickness=0.1 //x=36.8 //y=7.41 //x2=36.8 //y2=6.585
r1981 (  554 1076 ) resistor r=5.29055 //w=0.35 //l=0.17 //layer=li \
 //thickness=0.1 //x=36.18 //y=7.585 //x2=36.01 //y2=7.585
r1982 (  554 556 ) resistor r=6.97548 //w=0.367 //l=0.2 //layer=li \
 //thickness=0.1 //x=36.18 //y=7.585 //x2=36.38 //y2=7.585
r1983 (  553 1077 ) resistor r=2.87058 //w=0.35 //l=0.085 //layer=li \
 //thickness=0.1 //x=36.715 //y=7.585 //x2=36.8 //y2=7.585
r1984 (  553 556 ) resistor r=11.6839 //w=0.367 //l=0.335 //layer=li \
 //thickness=0.1 //x=36.715 //y=7.585 //x2=36.38 //y2=7.585
r1985 (  550 1075 ) resistor r=2.87058 //w=0.35 //l=0.085 //layer=li \
 //thickness=0.1 //x=35.015 //y=7.585 //x2=34.93 //y2=7.585
r1986 (  549 1076 ) resistor r=5.29055 //w=0.35 //l=0.17 //layer=li \
 //thickness=0.1 //x=35.84 //y=7.585 //x2=36.01 //y2=7.585
r1987 (  549 550 ) resistor r=28.7738 //w=0.367 //l=0.825 //layer=li \
 //thickness=0.1 //x=35.84 //y=7.585 //x2=35.015 //y2=7.585
r1988 (  543 1075 ) resistor r=4.23183 //w=0.7 //l=0.175 //layer=li \
 //thickness=0.1 //x=34.93 //y=7.41 //x2=34.93 //y2=7.585
r1989 (  543 1166 ) resistor r=33.1979 //w=0.187 //l=0.485 //layer=li \
 //thickness=0.1 //x=34.93 //y=7.41 //x2=34.93 //y2=6.925
r1990 (  542 1073 ) resistor r=2.87058 //w=0.35 //l=0.085 //layer=li \
 //thickness=0.1 //x=34.135 //y=7.585 //x2=34.05 //y2=7.585
r1991 (  541 1075 ) resistor r=2.87058 //w=0.35 //l=0.085 //layer=li \
 //thickness=0.1 //x=34.845 //y=7.585 //x2=34.93 //y2=7.585
r1992 (  541 542 ) resistor r=24.7629 //w=0.367 //l=0.71 //layer=li \
 //thickness=0.1 //x=34.845 //y=7.585 //x2=34.135 //y2=7.585
r1993 (  535 1073 ) resistor r=4.23183 //w=0.7 //l=0.175 //layer=li \
 //thickness=0.1 //x=34.05 //y=7.41 //x2=34.05 //y2=7.585
r1994 (  535 1165 ) resistor r=33.1979 //w=0.187 //l=0.485 //layer=li \
 //thickness=0.1 //x=34.05 //y=7.41 //x2=34.05 //y2=6.925
r1995 (  532 1072 ) resistor r=2.87058 //w=0.35 //l=0.085 //layer=li \
 //thickness=0.1 //x=33.255 //y=7.585 //x2=33.17 //y2=7.585
r1996 (  532 534 ) resistor r=18.6594 //w=0.367 //l=0.535 //layer=li \
 //thickness=0.1 //x=33.255 //y=7.585 //x2=33.79 //y2=7.585
r1997 (  531 1073 ) resistor r=2.87058 //w=0.35 //l=0.085 //layer=li \
 //thickness=0.1 //x=33.965 //y=7.585 //x2=34.05 //y2=7.585
r1998 (  531 534 ) resistor r=6.10354 //w=0.367 //l=0.175 //layer=li \
 //thickness=0.1 //x=33.965 //y=7.585 //x2=33.79 //y2=7.585
r1999 (  525 1072 ) resistor r=4.23183 //w=0.7 //l=0.175 //layer=li \
 //thickness=0.1 //x=33.17 //y=7.41 //x2=33.17 //y2=7.585
r2000 (  525 1164 ) resistor r=33.1979 //w=0.187 //l=0.485 //layer=li \
 //thickness=0.1 //x=33.17 //y=7.41 //x2=33.17 //y2=6.925
r2001 (  522 1071 ) resistor r=2.87058 //w=0.35 //l=0.085 //layer=li \
 //thickness=0.1 //x=32.375 //y=7.585 //x2=32.29 //y2=7.585
r2002 (  522 524 ) resistor r=10.6376 //w=0.367 //l=0.305 //layer=li \
 //thickness=0.1 //x=32.375 //y=7.585 //x2=32.68 //y2=7.585
r2003 (  521 1072 ) resistor r=2.87058 //w=0.35 //l=0.085 //layer=li \
 //thickness=0.1 //x=33.085 //y=7.585 //x2=33.17 //y2=7.585
r2004 (  521 524 ) resistor r=14.1253 //w=0.367 //l=0.405 //layer=li \
 //thickness=0.1 //x=33.085 //y=7.585 //x2=32.68 //y2=7.585
r2005 (  513 1071 ) resistor r=4.23183 //w=0.7 //l=0.175 //layer=li \
 //thickness=0.1 //x=32.29 //y=7.41 //x2=32.29 //y2=7.585
r2006 (  513 1163 ) resistor r=56.4706 //w=0.187 //l=0.825 //layer=li \
 //thickness=0.1 //x=32.29 //y=7.41 //x2=32.29 //y2=6.585
r2007 (  510 1070 ) resistor r=5.29055 //w=0.35 //l=0.17 //layer=li \
 //thickness=0.1 //x=31.37 //y=7.585 //x2=31.2 //y2=7.585
r2008 (  510 512 ) resistor r=6.97548 //w=0.367 //l=0.2 //layer=li \
 //thickness=0.1 //x=31.37 //y=7.585 //x2=31.57 //y2=7.585
r2009 (  509 1071 ) resistor r=2.87058 //w=0.35 //l=0.085 //layer=li \
 //thickness=0.1 //x=32.205 //y=7.585 //x2=32.29 //y2=7.585
r2010 (  509 512 ) resistor r=22.1471 //w=0.367 //l=0.635 //layer=li \
 //thickness=0.1 //x=32.205 //y=7.585 //x2=31.57 //y2=7.585
r2011 (  506 1069 ) resistor r=2.87058 //w=0.35 //l=0.085 //layer=li \
 //thickness=0.1 //x=30.205 //y=7.585 //x2=30.12 //y2=7.585
r2012 (  505 1070 ) resistor r=5.29055 //w=0.35 //l=0.17 //layer=li \
 //thickness=0.1 //x=31.03 //y=7.585 //x2=31.2 //y2=7.585
r2013 (  505 506 ) resistor r=28.7738 //w=0.367 //l=0.825 //layer=li \
 //thickness=0.1 //x=31.03 //y=7.585 //x2=30.205 //y2=7.585
r2014 (  499 1069 ) resistor r=4.23183 //w=0.7 //l=0.175 //layer=li \
 //thickness=0.1 //x=30.12 //y=7.41 //x2=30.12 //y2=7.585
r2015 (  499 1162 ) resistor r=33.1979 //w=0.187 //l=0.485 //layer=li \
 //thickness=0.1 //x=30.12 //y=7.41 //x2=30.12 //y2=6.925
r2016 (  498 1067 ) resistor r=2.87058 //w=0.35 //l=0.085 //layer=li \
 //thickness=0.1 //x=29.325 //y=7.585 //x2=29.24 //y2=7.585
r2017 (  497 1069 ) resistor r=2.87058 //w=0.35 //l=0.085 //layer=li \
 //thickness=0.1 //x=30.035 //y=7.585 //x2=30.12 //y2=7.585
r2018 (  497 498 ) resistor r=24.7629 //w=0.367 //l=0.71 //layer=li \
 //thickness=0.1 //x=30.035 //y=7.585 //x2=29.325 //y2=7.585
r2019 (  491 1067 ) resistor r=4.23183 //w=0.7 //l=0.175 //layer=li \
 //thickness=0.1 //x=29.24 //y=7.41 //x2=29.24 //y2=7.585
r2020 (  491 1161 ) resistor r=33.1979 //w=0.187 //l=0.485 //layer=li \
 //thickness=0.1 //x=29.24 //y=7.41 //x2=29.24 //y2=6.925
r2021 (  488 1066 ) resistor r=2.87058 //w=0.35 //l=0.085 //layer=li \
 //thickness=0.1 //x=28.445 //y=7.585 //x2=28.36 //y2=7.585
r2022 (  488 490 ) resistor r=18.6594 //w=0.367 //l=0.535 //layer=li \
 //thickness=0.1 //x=28.445 //y=7.585 //x2=28.98 //y2=7.585
r2023 (  487 1067 ) resistor r=2.87058 //w=0.35 //l=0.085 //layer=li \
 //thickness=0.1 //x=29.155 //y=7.585 //x2=29.24 //y2=7.585
r2024 (  487 490 ) resistor r=6.10354 //w=0.367 //l=0.175 //layer=li \
 //thickness=0.1 //x=29.155 //y=7.585 //x2=28.98 //y2=7.585
r2025 (  481 1066 ) resistor r=4.23183 //w=0.7 //l=0.175 //layer=li \
 //thickness=0.1 //x=28.36 //y=7.41 //x2=28.36 //y2=7.585
r2026 (  481 1160 ) resistor r=33.1979 //w=0.187 //l=0.485 //layer=li \
 //thickness=0.1 //x=28.36 //y=7.41 //x2=28.36 //y2=6.925
r2027 (  478 1065 ) resistor r=2.87058 //w=0.35 //l=0.085 //layer=li \
 //thickness=0.1 //x=27.565 //y=7.585 //x2=27.48 //y2=7.585
r2028 (  478 480 ) resistor r=10.6376 //w=0.367 //l=0.305 //layer=li \
 //thickness=0.1 //x=27.565 //y=7.585 //x2=27.87 //y2=7.585
r2029 (  477 1066 ) resistor r=2.87058 //w=0.35 //l=0.085 //layer=li \
 //thickness=0.1 //x=28.275 //y=7.585 //x2=28.36 //y2=7.585
r2030 (  477 480 ) resistor r=14.1253 //w=0.367 //l=0.405 //layer=li \
 //thickness=0.1 //x=28.275 //y=7.585 //x2=27.87 //y2=7.585
r2031 (  469 1065 ) resistor r=4.23183 //w=0.7 //l=0.175 //layer=li \
 //thickness=0.1 //x=27.48 //y=7.41 //x2=27.48 //y2=7.585
r2032 (  469 1159 ) resistor r=56.4706 //w=0.187 //l=0.825 //layer=li \
 //thickness=0.1 //x=27.48 //y=7.41 //x2=27.48 //y2=6.585
r2033 (  466 1064 ) resistor r=5.29055 //w=0.35 //l=0.17 //layer=li \
 //thickness=0.1 //x=26.56 //y=7.585 //x2=26.39 //y2=7.585
r2034 (  466 468 ) resistor r=6.97548 //w=0.367 //l=0.2 //layer=li \
 //thickness=0.1 //x=26.56 //y=7.585 //x2=26.76 //y2=7.585
r2035 (  465 1065 ) resistor r=2.87058 //w=0.35 //l=0.085 //layer=li \
 //thickness=0.1 //x=27.395 //y=7.585 //x2=27.48 //y2=7.585
r2036 (  465 468 ) resistor r=22.1471 //w=0.367 //l=0.635 //layer=li \
 //thickness=0.1 //x=27.395 //y=7.585 //x2=26.76 //y2=7.585
r2037 (  462 1063 ) resistor r=2.87058 //w=0.35 //l=0.085 //layer=li \
 //thickness=0.1 //x=25.695 //y=7.585 //x2=25.61 //y2=7.585
r2038 (  461 1064 ) resistor r=5.29055 //w=0.35 //l=0.17 //layer=li \
 //thickness=0.1 //x=26.22 //y=7.585 //x2=26.39 //y2=7.585
r2039 (  461 462 ) resistor r=18.3106 //w=0.367 //l=0.525 //layer=li \
 //thickness=0.1 //x=26.22 //y=7.585 //x2=25.695 //y2=7.585
r2040 (  455 1063 ) resistor r=4.23183 //w=0.7 //l=0.175 //layer=li \
 //thickness=0.1 //x=25.61 //y=7.41 //x2=25.61 //y2=7.585
r2041 (  455 1158 ) resistor r=33.1979 //w=0.187 //l=0.485 //layer=li \
 //thickness=0.1 //x=25.61 //y=7.41 //x2=25.61 //y2=6.925
r2042 (  452 1062 ) resistor r=2.87058 //w=0.35 //l=0.085 //layer=li \
 //thickness=0.1 //x=24.815 //y=7.585 //x2=24.73 //y2=7.585
r2043 (  452 454 ) resistor r=16.218 //w=0.367 //l=0.465 //layer=li \
 //thickness=0.1 //x=24.815 //y=7.585 //x2=25.28 //y2=7.585
r2044 (  451 1063 ) resistor r=2.87058 //w=0.35 //l=0.085 //layer=li \
 //thickness=0.1 //x=25.525 //y=7.585 //x2=25.61 //y2=7.585
r2045 (  451 454 ) resistor r=8.54496 //w=0.367 //l=0.245 //layer=li \
 //thickness=0.1 //x=25.525 //y=7.585 //x2=25.28 //y2=7.585
r2046 (  445 1062 ) resistor r=4.23183 //w=0.7 //l=0.175 //layer=li \
 //thickness=0.1 //x=24.73 //y=7.41 //x2=24.73 //y2=7.585
r2047 (  445 1157 ) resistor r=33.1979 //w=0.187 //l=0.485 //layer=li \
 //thickness=0.1 //x=24.73 //y=7.41 //x2=24.73 //y2=6.925
r2048 (  442 1061 ) resistor r=2.87058 //w=0.35 //l=0.085 //layer=li \
 //thickness=0.1 //x=23.935 //y=7.585 //x2=23.85 //y2=7.585
r2049 (  442 444 ) resistor r=8.19619 //w=0.367 //l=0.235 //layer=li \
 //thickness=0.1 //x=23.935 //y=7.585 //x2=24.17 //y2=7.585
r2050 (  441 1062 ) resistor r=2.87058 //w=0.35 //l=0.085 //layer=li \
 //thickness=0.1 //x=24.645 //y=7.585 //x2=24.73 //y2=7.585
r2051 (  441 444 ) resistor r=16.5668 //w=0.367 //l=0.475 //layer=li \
 //thickness=0.1 //x=24.645 //y=7.585 //x2=24.17 //y2=7.585
r2052 (  433 1061 ) resistor r=4.23183 //w=0.7 //l=0.175 //layer=li \
 //thickness=0.1 //x=23.85 //y=7.41 //x2=23.85 //y2=7.585
r2053 (  433 1156 ) resistor r=56.4706 //w=0.187 //l=0.825 //layer=li \
 //thickness=0.1 //x=23.85 //y=7.41 //x2=23.85 //y2=6.585
r2054 (  432 1060 ) resistor r=5.29055 //w=0.35 //l=0.17 //layer=li \
 //thickness=0.1 //x=23.23 //y=7.585 //x2=23.06 //y2=7.585
r2055 (  431 1061 ) resistor r=2.87058 //w=0.35 //l=0.085 //layer=li \
 //thickness=0.1 //x=23.765 //y=7.585 //x2=23.85 //y2=7.585
r2056 (  431 432 ) resistor r=18.6594 //w=0.367 //l=0.535 //layer=li \
 //thickness=0.1 //x=23.765 //y=7.585 //x2=23.23 //y2=7.585
r2057 (  426 1059 ) resistor r=2.87058 //w=0.35 //l=0.085 //layer=li \
 //thickness=0.1 //x=22.065 //y=7.585 //x2=21.98 //y2=7.585
r2058 (  426 428 ) resistor r=21.7984 //w=0.367 //l=0.625 //layer=li \
 //thickness=0.1 //x=22.065 //y=7.585 //x2=22.69 //y2=7.585
r2059 (  425 1060 ) resistor r=5.29055 //w=0.35 //l=0.17 //layer=li \
 //thickness=0.1 //x=22.89 //y=7.585 //x2=23.06 //y2=7.585
r2060 (  425 428 ) resistor r=6.97548 //w=0.367 //l=0.2 //layer=li \
 //thickness=0.1 //x=22.89 //y=7.585 //x2=22.69 //y2=7.585
r2061 (  419 1059 ) resistor r=4.23183 //w=0.7 //l=0.175 //layer=li \
 //thickness=0.1 //x=21.98 //y=7.41 //x2=21.98 //y2=7.585
r2062 (  419 1155 ) resistor r=33.1979 //w=0.187 //l=0.485 //layer=li \
 //thickness=0.1 //x=21.98 //y=7.41 //x2=21.98 //y2=6.925
r2063 (  416 1058 ) resistor r=2.87058 //w=0.35 //l=0.085 //layer=li \
 //thickness=0.1 //x=21.185 //y=7.585 //x2=21.1 //y2=7.585
r2064 (  416 418 ) resistor r=13.7766 //w=0.367 //l=0.395 //layer=li \
 //thickness=0.1 //x=21.185 //y=7.585 //x2=21.58 //y2=7.585
r2065 (  415 1059 ) resistor r=2.87058 //w=0.35 //l=0.085 //layer=li \
 //thickness=0.1 //x=21.895 //y=7.585 //x2=21.98 //y2=7.585
r2066 (  415 418 ) resistor r=10.9864 //w=0.367 //l=0.315 //layer=li \
 //thickness=0.1 //x=21.895 //y=7.585 //x2=21.58 //y2=7.585
r2067 (  409 1058 ) resistor r=4.23183 //w=0.7 //l=0.175 //layer=li \
 //thickness=0.1 //x=21.1 //y=7.41 //x2=21.1 //y2=7.585
r2068 (  409 1154 ) resistor r=33.1979 //w=0.187 //l=0.485 //layer=li \
 //thickness=0.1 //x=21.1 //y=7.41 //x2=21.1 //y2=6.925
r2069 (  406 1057 ) resistor r=2.87058 //w=0.35 //l=0.085 //layer=li \
 //thickness=0.1 //x=20.305 //y=7.585 //x2=20.22 //y2=7.585
r2070 (  406 408 ) resistor r=5.75477 //w=0.367 //l=0.165 //layer=li \
 //thickness=0.1 //x=20.305 //y=7.585 //x2=20.47 //y2=7.585
r2071 (  405 1058 ) resistor r=2.87058 //w=0.35 //l=0.085 //layer=li \
 //thickness=0.1 //x=21.015 //y=7.585 //x2=21.1 //y2=7.585
r2072 (  405 408 ) resistor r=19.0082 //w=0.367 //l=0.545 //layer=li \
 //thickness=0.1 //x=21.015 //y=7.585 //x2=20.47 //y2=7.585
r2073 (  399 1057 ) resistor r=4.23183 //w=0.7 //l=0.175 //layer=li \
 //thickness=0.1 //x=20.22 //y=7.41 //x2=20.22 //y2=7.585
r2074 (  399 1153 ) resistor r=33.1979 //w=0.187 //l=0.485 //layer=li \
 //thickness=0.1 //x=20.22 //y=7.41 //x2=20.22 //y2=6.925
r2075 (  398 1056 ) resistor r=2.87058 //w=0.35 //l=0.085 //layer=li \
 //thickness=0.1 //x=19.425 //y=7.585 //x2=19.34 //y2=7.585
r2076 (  397 1057 ) resistor r=2.87058 //w=0.35 //l=0.085 //layer=li \
 //thickness=0.1 //x=20.135 //y=7.585 //x2=20.22 //y2=7.585
r2077 (  397 398 ) resistor r=24.7629 //w=0.367 //l=0.71 //layer=li \
 //thickness=0.1 //x=20.135 //y=7.585 //x2=19.425 //y2=7.585
r2078 (  389 1056 ) resistor r=4.23183 //w=0.7 //l=0.175 //layer=li \
 //thickness=0.1 //x=19.34 //y=7.41 //x2=19.34 //y2=7.585
r2079 (  389 1152 ) resistor r=56.4706 //w=0.187 //l=0.825 //layer=li \
 //thickness=0.1 //x=19.34 //y=7.41 //x2=19.34 //y2=6.585
r2080 (  388 1054 ) resistor r=5.29055 //w=0.35 //l=0.17 //layer=li \
 //thickness=0.1 //x=18.42 //y=7.585 //x2=18.25 //y2=7.585
r2081 (  387 1056 ) resistor r=2.87058 //w=0.35 //l=0.085 //layer=li \
 //thickness=0.1 //x=19.255 //y=7.585 //x2=19.34 //y2=7.585
r2082 (  387 388 ) resistor r=29.1226 //w=0.367 //l=0.835 //layer=li \
 //thickness=0.1 //x=19.255 //y=7.585 //x2=18.42 //y2=7.585
r2083 (  382 1053 ) resistor r=2.87058 //w=0.35 //l=0.085 //layer=li \
 //thickness=0.1 //x=17.255 //y=7.585 //x2=17.17 //y2=7.585
r2084 (  382 384 ) resistor r=21.7984 //w=0.367 //l=0.625 //layer=li \
 //thickness=0.1 //x=17.255 //y=7.585 //x2=17.88 //y2=7.585
r2085 (  381 1054 ) resistor r=5.29055 //w=0.35 //l=0.17 //layer=li \
 //thickness=0.1 //x=18.08 //y=7.585 //x2=18.25 //y2=7.585
r2086 (  381 384 ) resistor r=6.97548 //w=0.367 //l=0.2 //layer=li \
 //thickness=0.1 //x=18.08 //y=7.585 //x2=17.88 //y2=7.585
r2087 (  375 1053 ) resistor r=4.23183 //w=0.7 //l=0.175 //layer=li \
 //thickness=0.1 //x=17.17 //y=7.41 //x2=17.17 //y2=7.585
r2088 (  375 1151 ) resistor r=33.1979 //w=0.187 //l=0.485 //layer=li \
 //thickness=0.1 //x=17.17 //y=7.41 //x2=17.17 //y2=6.925
r2089 (  372 1052 ) resistor r=2.87058 //w=0.35 //l=0.085 //layer=li \
 //thickness=0.1 //x=16.375 //y=7.585 //x2=16.29 //y2=7.585
r2090 (  372 374 ) resistor r=13.7766 //w=0.367 //l=0.395 //layer=li \
 //thickness=0.1 //x=16.375 //y=7.585 //x2=16.77 //y2=7.585
r2091 (  371 1053 ) resistor r=2.87058 //w=0.35 //l=0.085 //layer=li \
 //thickness=0.1 //x=17.085 //y=7.585 //x2=17.17 //y2=7.585
r2092 (  371 374 ) resistor r=10.9864 //w=0.367 //l=0.315 //layer=li \
 //thickness=0.1 //x=17.085 //y=7.585 //x2=16.77 //y2=7.585
r2093 (  365 1052 ) resistor r=4.23183 //w=0.7 //l=0.175 //layer=li \
 //thickness=0.1 //x=16.29 //y=7.41 //x2=16.29 //y2=7.585
r2094 (  365 1150 ) resistor r=33.1979 //w=0.187 //l=0.485 //layer=li \
 //thickness=0.1 //x=16.29 //y=7.41 //x2=16.29 //y2=6.925
r2095 (  362 1051 ) resistor r=2.87058 //w=0.35 //l=0.085 //layer=li \
 //thickness=0.1 //x=15.495 //y=7.585 //x2=15.41 //y2=7.585
r2096 (  362 364 ) resistor r=5.75477 //w=0.367 //l=0.165 //layer=li \
 //thickness=0.1 //x=15.495 //y=7.585 //x2=15.66 //y2=7.585
r2097 (  361 1052 ) resistor r=2.87058 //w=0.35 //l=0.085 //layer=li \
 //thickness=0.1 //x=16.205 //y=7.585 //x2=16.29 //y2=7.585
r2098 (  361 364 ) resistor r=19.0082 //w=0.367 //l=0.545 //layer=li \
 //thickness=0.1 //x=16.205 //y=7.585 //x2=15.66 //y2=7.585
r2099 (  355 1051 ) resistor r=4.23183 //w=0.7 //l=0.175 //layer=li \
 //thickness=0.1 //x=15.41 //y=7.41 //x2=15.41 //y2=7.585
r2100 (  355 1149 ) resistor r=33.1979 //w=0.187 //l=0.485 //layer=li \
 //thickness=0.1 //x=15.41 //y=7.41 //x2=15.41 //y2=6.925
r2101 (  354 1050 ) resistor r=2.87058 //w=0.35 //l=0.085 //layer=li \
 //thickness=0.1 //x=14.615 //y=7.585 //x2=14.53 //y2=7.585
r2102 (  353 1051 ) resistor r=2.87058 //w=0.35 //l=0.085 //layer=li \
 //thickness=0.1 //x=15.325 //y=7.585 //x2=15.41 //y2=7.585
r2103 (  353 354 ) resistor r=24.7629 //w=0.367 //l=0.71 //layer=li \
 //thickness=0.1 //x=15.325 //y=7.585 //x2=14.615 //y2=7.585
r2104 (  345 1050 ) resistor r=4.23183 //w=0.7 //l=0.175 //layer=li \
 //thickness=0.1 //x=14.53 //y=7.41 //x2=14.53 //y2=7.585
r2105 (  345 1148 ) resistor r=56.4706 //w=0.187 //l=0.825 //layer=li \
 //thickness=0.1 //x=14.53 //y=7.41 //x2=14.53 //y2=6.585
r2106 (  344 1048 ) resistor r=5.29055 //w=0.35 //l=0.17 //layer=li \
 //thickness=0.1 //x=13.61 //y=7.585 //x2=13.44 //y2=7.585
r2107 (  343 1050 ) resistor r=2.87058 //w=0.35 //l=0.085 //layer=li \
 //thickness=0.1 //x=14.445 //y=7.585 //x2=14.53 //y2=7.585
r2108 (  343 344 ) resistor r=29.1226 //w=0.367 //l=0.835 //layer=li \
 //thickness=0.1 //x=14.445 //y=7.585 //x2=13.61 //y2=7.585
r2109 (  338 1047 ) resistor r=2.87058 //w=0.35 //l=0.085 //layer=li \
 //thickness=0.1 //x=12.745 //y=7.585 //x2=12.66 //y2=7.585
r2110 (  338 340 ) resistor r=11.3351 //w=0.367 //l=0.325 //layer=li \
 //thickness=0.1 //x=12.745 //y=7.585 //x2=13.07 //y2=7.585
r2111 (  337 1048 ) resistor r=5.29055 //w=0.35 //l=0.17 //layer=li \
 //thickness=0.1 //x=13.27 //y=7.585 //x2=13.44 //y2=7.585
r2112 (  337 340 ) resistor r=6.97548 //w=0.367 //l=0.2 //layer=li \
 //thickness=0.1 //x=13.27 //y=7.585 //x2=13.07 //y2=7.585
r2113 (  331 1047 ) resistor r=4.23183 //w=0.7 //l=0.175 //layer=li \
 //thickness=0.1 //x=12.66 //y=7.41 //x2=12.66 //y2=7.585
r2114 (  331 1147 ) resistor r=33.1979 //w=0.187 //l=0.485 //layer=li \
 //thickness=0.1 //x=12.66 //y=7.41 //x2=12.66 //y2=6.925
r2115 (  328 1046 ) resistor r=2.87058 //w=0.35 //l=0.085 //layer=li \
 //thickness=0.1 //x=11.865 //y=7.585 //x2=11.78 //y2=7.585
r2116 (  328 330 ) resistor r=3.31335 //w=0.367 //l=0.095 //layer=li \
 //thickness=0.1 //x=11.865 //y=7.585 //x2=11.96 //y2=7.585
r2117 (  327 1047 ) resistor r=2.87058 //w=0.35 //l=0.085 //layer=li \
 //thickness=0.1 //x=12.575 //y=7.585 //x2=12.66 //y2=7.585
r2118 (  327 330 ) resistor r=21.4496 //w=0.367 //l=0.615 //layer=li \
 //thickness=0.1 //x=12.575 //y=7.585 //x2=11.96 //y2=7.585
r2119 (  321 1046 ) resistor r=4.23183 //w=0.7 //l=0.175 //layer=li \
 //thickness=0.1 //x=11.78 //y=7.41 //x2=11.78 //y2=7.585
r2120 (  321 1146 ) resistor r=33.1979 //w=0.187 //l=0.485 //layer=li \
 //thickness=0.1 //x=11.78 //y=7.41 //x2=11.78 //y2=6.925
r2121 (  320 1045 ) resistor r=2.87058 //w=0.35 //l=0.085 //layer=li \
 //thickness=0.1 //x=10.985 //y=7.585 //x2=10.9 //y2=7.585
r2122 (  319 1046 ) resistor r=2.87058 //w=0.35 //l=0.085 //layer=li \
 //thickness=0.1 //x=11.695 //y=7.585 //x2=11.78 //y2=7.585
r2123 (  319 320 ) resistor r=24.7629 //w=0.367 //l=0.71 //layer=li \
 //thickness=0.1 //x=11.695 //y=7.585 //x2=10.985 //y2=7.585
r2124 (  311 1045 ) resistor r=4.23183 //w=0.7 //l=0.175 //layer=li \
 //thickness=0.1 //x=10.9 //y=7.41 //x2=10.9 //y2=7.585
r2125 (  311 1145 ) resistor r=56.4706 //w=0.187 //l=0.825 //layer=li \
 //thickness=0.1 //x=10.9 //y=7.41 //x2=10.9 //y2=6.585
r2126 (  310 1043 ) resistor r=5.29055 //w=0.35 //l=0.17 //layer=li \
 //thickness=0.1 //x=10.28 //y=7.585 //x2=10.11 //y2=7.585
r2127 (  309 1045 ) resistor r=2.87058 //w=0.35 //l=0.085 //layer=li \
 //thickness=0.1 //x=10.815 //y=7.585 //x2=10.9 //y2=7.585
r2128 (  309 310 ) resistor r=18.6594 //w=0.367 //l=0.535 //layer=li \
 //thickness=0.1 //x=10.815 //y=7.585 //x2=10.28 //y2=7.585
r2129 (  304 1042 ) resistor r=2.87058 //w=0.35 //l=0.085 //layer=li \
 //thickness=0.1 //x=9.115 //y=7.585 //x2=9.03 //y2=7.585
r2130 (  304 306 ) resistor r=8.89373 //w=0.367 //l=0.255 //layer=li \
 //thickness=0.1 //x=9.115 //y=7.585 //x2=9.37 //y2=7.585
r2131 (  303 1043 ) resistor r=5.29055 //w=0.35 //l=0.17 //layer=li \
 //thickness=0.1 //x=9.94 //y=7.585 //x2=10.11 //y2=7.585
r2132 (  303 306 ) resistor r=19.8801 //w=0.367 //l=0.57 //layer=li \
 //thickness=0.1 //x=9.94 //y=7.585 //x2=9.37 //y2=7.585
r2133 (  297 1042 ) resistor r=4.23183 //w=0.7 //l=0.175 //layer=li \
 //thickness=0.1 //x=9.03 //y=7.41 //x2=9.03 //y2=7.585
r2134 (  297 1144 ) resistor r=33.1979 //w=0.187 //l=0.485 //layer=li \
 //thickness=0.1 //x=9.03 //y=7.41 //x2=9.03 //y2=6.925
r2135 (  294 1041 ) resistor r=2.87058 //w=0.35 //l=0.085 //layer=li \
 //thickness=0.1 //x=8.235 //y=7.585 //x2=8.15 //y2=7.585
r2136 (  294 296 ) resistor r=0.871935 //w=0.367 //l=0.025 //layer=li \
 //thickness=0.1 //x=8.235 //y=7.585 //x2=8.26 //y2=7.585
r2137 (  293 1042 ) resistor r=2.87058 //w=0.35 //l=0.085 //layer=li \
 //thickness=0.1 //x=8.945 //y=7.585 //x2=9.03 //y2=7.585
r2138 (  293 296 ) resistor r=23.891 //w=0.367 //l=0.685 //layer=li \
 //thickness=0.1 //x=8.945 //y=7.585 //x2=8.26 //y2=7.585
r2139 (  287 1041 ) resistor r=4.23183 //w=0.7 //l=0.175 //layer=li \
 //thickness=0.1 //x=8.15 //y=7.41 //x2=8.15 //y2=7.585
r2140 (  287 1143 ) resistor r=33.1979 //w=0.187 //l=0.485 //layer=li \
 //thickness=0.1 //x=8.15 //y=7.41 //x2=8.15 //y2=6.925
r2141 (  286 1040 ) resistor r=2.87058 //w=0.35 //l=0.085 //layer=li \
 //thickness=0.1 //x=7.355 //y=7.585 //x2=7.27 //y2=7.585
r2142 (  285 1041 ) resistor r=2.87058 //w=0.35 //l=0.085 //layer=li \
 //thickness=0.1 //x=8.065 //y=7.585 //x2=8.15 //y2=7.585
r2143 (  285 286 ) resistor r=24.7629 //w=0.367 //l=0.71 //layer=li \
 //thickness=0.1 //x=8.065 //y=7.585 //x2=7.355 //y2=7.585
r2144 (  279 1040 ) resistor r=4.23183 //w=0.7 //l=0.175 //layer=li \
 //thickness=0.1 //x=7.27 //y=7.41 //x2=7.27 //y2=7.585
r2145 (  279 1142 ) resistor r=33.1979 //w=0.187 //l=0.485 //layer=li \
 //thickness=0.1 //x=7.27 //y=7.41 //x2=7.27 //y2=6.925
r2146 (  276 1039 ) resistor r=2.87058 //w=0.35 //l=0.085 //layer=li \
 //thickness=0.1 //x=6.475 //y=7.585 //x2=6.39 //y2=7.585
r2147 (  276 278 ) resistor r=23.5422 //w=0.367 //l=0.675 //layer=li \
 //thickness=0.1 //x=6.475 //y=7.585 //x2=7.15 //y2=7.585
r2148 (  275 1040 ) resistor r=2.87058 //w=0.35 //l=0.085 //layer=li \
 //thickness=0.1 //x=7.185 //y=7.585 //x2=7.27 //y2=7.585
r2149 (  275 278 ) resistor r=1.22071 //w=0.367 //l=0.035 //layer=li \
 //thickness=0.1 //x=7.185 //y=7.585 //x2=7.15 //y2=7.585
r2150 (  267 1039 ) resistor r=4.23183 //w=0.7 //l=0.175 //layer=li \
 //thickness=0.1 //x=6.39 //y=7.41 //x2=6.39 //y2=7.585
r2151 (  267 1141 ) resistor r=56.4706 //w=0.187 //l=0.825 //layer=li \
 //thickness=0.1 //x=6.39 //y=7.41 //x2=6.39 //y2=6.585
r2152 (  264 1038 ) resistor r=5.29055 //w=0.35 //l=0.17 //layer=li \
 //thickness=0.1 //x=5.47 //y=7.585 //x2=5.3 //y2=7.585
r2153 (  264 266 ) resistor r=19.8801 //w=0.367 //l=0.57 //layer=li \
 //thickness=0.1 //x=5.47 //y=7.585 //x2=6.04 //y2=7.585
r2154 (  263 1039 ) resistor r=2.87058 //w=0.35 //l=0.085 //layer=li \
 //thickness=0.1 //x=6.305 //y=7.585 //x2=6.39 //y2=7.585
r2155 (  263 266 ) resistor r=9.24251 //w=0.367 //l=0.265 //layer=li \
 //thickness=0.1 //x=6.305 //y=7.585 //x2=6.04 //y2=7.585
r2156 (  258 1037 ) resistor r=2.87058 //w=0.35 //l=0.085 //layer=li \
 //thickness=0.1 //x=4.305 //y=7.585 //x2=4.22 //y2=7.585
r2157 (  258 260 ) resistor r=8.89373 //w=0.367 //l=0.255 //layer=li \
 //thickness=0.1 //x=4.305 //y=7.585 //x2=4.56 //y2=7.585
r2158 (  257 1038 ) resistor r=5.29055 //w=0.35 //l=0.17 //layer=li \
 //thickness=0.1 //x=5.13 //y=7.585 //x2=5.3 //y2=7.585
r2159 (  257 260 ) resistor r=19.8801 //w=0.367 //l=0.57 //layer=li \
 //thickness=0.1 //x=5.13 //y=7.585 //x2=4.56 //y2=7.585
r2160 (  251 1037 ) resistor r=4.23183 //w=0.7 //l=0.175 //layer=li \
 //thickness=0.1 //x=4.22 //y=7.41 //x2=4.22 //y2=7.585
r2161 (  251 1140 ) resistor r=33.1979 //w=0.187 //l=0.485 //layer=li \
 //thickness=0.1 //x=4.22 //y=7.41 //x2=4.22 //y2=6.925
r2162 (  248 1036 ) resistor r=2.87058 //w=0.35 //l=0.085 //layer=li \
 //thickness=0.1 //x=3.425 //y=7.585 //x2=3.34 //y2=7.585
r2163 (  248 250 ) resistor r=0.871935 //w=0.367 //l=0.025 //layer=li \
 //thickness=0.1 //x=3.425 //y=7.585 //x2=3.45 //y2=7.585
r2164 (  247 1037 ) resistor r=2.87058 //w=0.35 //l=0.085 //layer=li \
 //thickness=0.1 //x=4.135 //y=7.585 //x2=4.22 //y2=7.585
r2165 (  247 250 ) resistor r=23.891 //w=0.367 //l=0.685 //layer=li \
 //thickness=0.1 //x=4.135 //y=7.585 //x2=3.45 //y2=7.585
r2166 (  241 1036 ) resistor r=4.23183 //w=0.7 //l=0.175 //layer=li \
 //thickness=0.1 //x=3.34 //y=7.41 //x2=3.34 //y2=7.585
r2167 (  241 1139 ) resistor r=33.1979 //w=0.187 //l=0.485 //layer=li \
 //thickness=0.1 //x=3.34 //y=7.41 //x2=3.34 //y2=6.925
r2168 (  240 1035 ) resistor r=2.87058 //w=0.35 //l=0.085 //layer=li \
 //thickness=0.1 //x=2.545 //y=7.585 //x2=2.46 //y2=7.585
r2169 (  239 1036 ) resistor r=2.87058 //w=0.35 //l=0.085 //layer=li \
 //thickness=0.1 //x=3.255 //y=7.585 //x2=3.34 //y2=7.585
r2170 (  239 240 ) resistor r=24.7629 //w=0.367 //l=0.71 //layer=li \
 //thickness=0.1 //x=3.255 //y=7.585 //x2=2.545 //y2=7.585
r2171 (  233 1035 ) resistor r=4.23183 //w=0.7 //l=0.175 //layer=li \
 //thickness=0.1 //x=2.46 //y=7.41 //x2=2.46 //y2=7.585
r2172 (  233 1138 ) resistor r=33.1979 //w=0.187 //l=0.485 //layer=li \
 //thickness=0.1 //x=2.46 //y=7.41 //x2=2.46 //y2=6.925
r2173 (  230 1034 ) resistor r=2.87058 //w=0.35 //l=0.085 //layer=li \
 //thickness=0.1 //x=1.665 //y=7.585 //x2=1.58 //y2=7.585
r2174 (  230 232 ) resistor r=23.5422 //w=0.367 //l=0.675 //layer=li \
 //thickness=0.1 //x=1.665 //y=7.585 //x2=2.34 //y2=7.585
r2175 (  229 1035 ) resistor r=2.87058 //w=0.35 //l=0.085 //layer=li \
 //thickness=0.1 //x=2.375 //y=7.585 //x2=2.46 //y2=7.585
r2176 (  229 232 ) resistor r=1.22071 //w=0.367 //l=0.035 //layer=li \
 //thickness=0.1 //x=2.375 //y=7.585 //x2=2.34 //y2=7.585
r2177 (  221 1034 ) resistor r=4.23183 //w=0.7 //l=0.175 //layer=li \
 //thickness=0.1 //x=1.58 //y=7.41 //x2=1.58 //y2=7.585
r2178 (  221 1137 ) resistor r=56.4706 //w=0.187 //l=0.825 //layer=li \
 //thickness=0.1 //x=1.58 //y=7.41 //x2=1.58 //y2=6.585
r2179 (  217 1034 ) resistor r=2.87058 //w=0.35 //l=0.085 //layer=li \
 //thickness=0.1 //x=1.495 //y=7.585 //x2=1.58 //y2=7.585
r2180 (  217 220 ) resistor r=9.24251 //w=0.367 //l=0.265 //layer=li \
 //thickness=0.1 //x=1.495 //y=7.585 //x2=1.23 //y2=7.585
r2181 (  210 988 ) resistor r=9.3 //w=0.17 //l=0.17 //layer=mcon //count=1 \
 //x=80.74 //y=6.92 //x2=80.74 //y2=6.92
r2182 (  207 1204 ) resistor r=9.3 //w=0.17 //l=0.17 //layer=mcon //count=1 \
 //x=79.86 //y=6.92 //x2=79.86 //y2=6.92
r2183 (  204 973 ) resistor r=9.3 //w=0.17 //l=0.17 //layer=mcon //count=1 \
 //x=78.98 //y=6.92 //x2=78.98 //y2=6.92
r2184 (  200 960 ) resistor r=3.1 //w=0.17 //l=0.51 //layer=mcon //count=3 \
 //x=78.93 //y=7.58 //x2=78.93 //y2=7.58
r2185 (  161 1136 ) resistor r=4.65 //w=0.17 //l=0.34 //layer=mcon //count=2 \
 //x=89.66 //y=7.58 //x2=89.66 //y2=7.58
r2186 (  159 1134 ) resistor r=3.1 //w=0.17 //l=0.51 //layer=mcon //count=3 \
 //x=88.92 //y=7.58 //x2=88.92 //y2=7.58
r2187 (  159 161 ) resistor r=0.297428 //w=0.311 //l=0.74 //layer=m1 \
 //thickness=0.36 //x=88.92 //y=7.585 //x2=89.66 //y2=7.585
r2188 (  157 1007 ) resistor r=3.1 //w=0.17 //l=0.51 //layer=mcon //count=3 \
 //x=87.44 //y=7.58 //x2=87.44 //y2=7.58
r2189 (  157 159 ) resistor r=0.594855 //w=0.311 //l=1.48 //layer=m1 \
 //thickness=0.36 //x=87.44 //y=7.585 //x2=88.92 //y2=7.585
r2190 (  155 1005 ) resistor r=3.1 //w=0.17 //l=0.51 //layer=mcon //count=3 \
 //x=86.33 //y=7.58 //x2=86.33 //y2=7.58
r2191 (  155 157 ) resistor r=0.446141 //w=0.311 //l=1.11 //layer=m1 \
 //thickness=0.36 //x=86.33 //y=7.585 //x2=87.44 //y2=7.585
r2192 (  153 1003 ) resistor r=3.1 //w=0.17 //l=0.51 //layer=mcon //count=3 \
 //x=85.22 //y=7.58 //x2=85.22 //y2=7.58
r2193 (  153 155 ) resistor r=0.446141 //w=0.311 //l=1.11 //layer=m1 \
 //thickness=0.36 //x=85.22 //y=7.585 //x2=86.33 //y2=7.585
r2194 (  151 997 ) resistor r=3.1 //w=0.17 //l=0.51 //layer=mcon //count=3 \
 //x=83.74 //y=7.58 //x2=83.74 //y2=7.58
r2195 (  151 153 ) resistor r=0.594855 //w=0.311 //l=1.48 //layer=m1 \
 //thickness=0.36 //x=83.74 //y=7.585 //x2=85.22 //y2=7.585
r2196 (  149 995 ) resistor r=3.1 //w=0.17 //l=0.51 //layer=mcon //count=3 \
 //x=82.63 //y=7.58 //x2=82.63 //y2=7.58
r2197 (  149 151 ) resistor r=0.446141 //w=0.311 //l=1.11 //layer=m1 \
 //thickness=0.36 //x=82.63 //y=7.585 //x2=83.74 //y2=7.585
r2198 (  147 964 ) resistor r=3.1 //w=0.17 //l=0.51 //layer=mcon //count=3 \
 //x=81.15 //y=7.58 //x2=81.15 //y2=7.58
r2199 (  147 149 ) resistor r=0.594855 //w=0.311 //l=1.48 //layer=m1 \
 //thickness=0.36 //x=81.15 //y=7.585 //x2=82.63 //y2=7.585
r2200 (  145 208 ) resistor r=0.028033 //w=0.35 //l=0.085 //layer=m1 \
 //thickness=0.36 //x=80.825 //y=7.585 //x2=80.74 //y2=7.585
r2201 (  145 147 ) resistor r=0.130627 //w=0.311 //l=0.325 //layer=m1 \
 //thickness=0.36 //x=80.825 //y=7.585 //x2=81.15 //y2=7.585
r2202 (  144 208 ) resistor r=0.0413265 //w=0.7 //l=0.175 //layer=m1 \
 //thickness=0.36 //x=80.74 //y=7.41 //x2=80.74 //y2=7.585
r2203 (  143 210 ) resistor r=0.0715665 //w=0.226 //l=0.115 //layer=m1 \
 //thickness=0.36 //x=80.74 //y=7.035 //x2=80.74 //y2=6.92
r2204 (  143 144 ) resistor r=0.357824 //w=0.131 //l=0.375 //layer=m1 \
 //thickness=0.36 //x=80.74 //y=7.035 //x2=80.74 //y2=7.41
r2205 (  142 962 ) resistor r=3.1 //w=0.17 //l=0.51 //layer=mcon //count=3 \
 //x=80.04 //y=7.58 //x2=80.04 //y2=7.58
r2206 (  140 205 ) resistor r=0.028033 //w=0.35 //l=0.085 //layer=m1 \
 //thickness=0.36 //x=79.945 //y=7.585 //x2=79.86 //y2=7.585
r2207 (  140 142 ) resistor r=0.0381833 //w=0.311 //l=0.095 //layer=m1 \
 //thickness=0.36 //x=79.945 //y=7.585 //x2=80.04 //y2=7.585
r2208 (  139 208 ) resistor r=0.028033 //w=0.35 //l=0.085 //layer=m1 \
 //thickness=0.36 //x=80.655 //y=7.585 //x2=80.74 //y2=7.585
r2209 (  139 142 ) resistor r=0.247186 //w=0.311 //l=0.615 //layer=m1 \
 //thickness=0.36 //x=80.655 //y=7.585 //x2=80.04 //y2=7.585
r2210 (  138 205 ) resistor r=0.0413265 //w=0.7 //l=0.175 //layer=m1 \
 //thickness=0.36 //x=79.86 //y=7.41 //x2=79.86 //y2=7.585
r2211 (  137 207 ) resistor r=0.0715665 //w=0.226 //l=0.117473 //layer=m1 \
 //thickness=0.36 //x=79.86 //y=7.035 //x2=79.865 //y2=6.92
r2212 (  137 138 ) resistor r=0.357824 //w=0.131 //l=0.375 //layer=m1 \
 //thickness=0.36 //x=79.86 //y=7.035 //x2=79.86 //y2=7.41
r2213 (  136 200 ) resistor r=0.028033 //w=0.35 //l=0.085 //layer=m1 \
 //thickness=0.36 //x=79.065 //y=7.585 //x2=78.98 //y2=7.585
r2214 (  135 205 ) resistor r=0.028033 //w=0.35 //l=0.085 //layer=m1 \
 //thickness=0.36 //x=79.775 //y=7.585 //x2=79.86 //y2=7.585
r2215 (  135 136 ) resistor r=0.28537 //w=0.311 //l=0.71 //layer=m1 \
 //thickness=0.36 //x=79.775 //y=7.585 //x2=79.065 //y2=7.585
r2216 (  134 200 ) resistor r=0.0413265 //w=0.7 //l=0.175 //layer=m1 \
 //thickness=0.36 //x=78.98 //y=7.41 //x2=78.98 //y2=7.585
r2217 (  133 204 ) resistor r=0.0712609 //w=0.23 //l=0.11649 //layer=m1 \
 //thickness=0.36 //x=78.98 //y=7.035 //x2=78.977 //y2=6.92
r2218 (  133 134 ) resistor r=0.357824 //w=0.131 //l=0.375 //layer=m1 \
 //thickness=0.36 //x=78.98 //y=7.035 //x2=78.98 //y2=7.41
r2219 (  132 1128 ) resistor r=3.1 //w=0.17 //l=0.51 //layer=mcon //count=3 \
 //x=77.45 //y=7.58 //x2=77.45 //y2=7.58
r2220 (  130 938 ) resistor r=3.1 //w=0.17 //l=0.51 //layer=mcon //count=3 \
 //x=76.34 //y=7.58 //x2=76.34 //y2=7.58
r2221 (  130 132 ) resistor r=0.446141 //w=0.311 //l=1.11 //layer=m1 \
 //thickness=0.36 //x=76.34 //y=7.585 //x2=77.45 //y2=7.585
r2222 (  128 926 ) resistor r=3.1 //w=0.17 //l=0.51 //layer=mcon //count=3 \
 //x=75.23 //y=7.58 //x2=75.23 //y2=7.58
r2223 (  128 130 ) resistor r=0.446141 //w=0.311 //l=1.11 //layer=m1 \
 //thickness=0.36 //x=75.23 //y=7.585 //x2=76.34 //y2=7.585
r2224 (  126 1123 ) resistor r=3.1 //w=0.17 //l=0.51 //layer=mcon //count=3 \
 //x=73.75 //y=7.58 //x2=73.75 //y2=7.58
r2225 (  126 128 ) resistor r=0.594855 //w=0.311 //l=1.48 //layer=m1 \
 //thickness=0.36 //x=73.75 //y=7.585 //x2=75.23 //y2=7.585
r2226 (  124 904 ) resistor r=3.1 //w=0.17 //l=0.51 //layer=mcon //count=3 \
 //x=72.64 //y=7.58 //x2=72.64 //y2=7.58
r2227 (  124 126 ) resistor r=0.446141 //w=0.311 //l=1.11 //layer=m1 \
 //thickness=0.36 //x=72.64 //y=7.585 //x2=73.75 //y2=7.585
r2228 (  122 894 ) resistor r=3.1 //w=0.17 //l=0.51 //layer=mcon //count=3 \
 //x=71.53 //y=7.58 //x2=71.53 //y2=7.58
r2229 (  122 124 ) resistor r=0.446141 //w=0.311 //l=1.11 //layer=m1 \
 //thickness=0.36 //x=71.53 //y=7.585 //x2=72.64 //y2=7.585
r2230 (  120 882 ) resistor r=3.1 //w=0.17 //l=0.51 //layer=mcon //count=3 \
 //x=70.42 //y=7.58 //x2=70.42 //y2=7.58
r2231 (  120 122 ) resistor r=0.446141 //w=0.311 //l=1.11 //layer=m1 \
 //thickness=0.36 //x=70.42 //y=7.585 //x2=71.53 //y2=7.585
r2232 (  118 1117 ) resistor r=3.1 //w=0.17 //l=0.51 //layer=mcon //count=3 \
 //x=68.94 //y=7.58 //x2=68.94 //y2=7.58
r2233 (  118 120 ) resistor r=0.594855 //w=0.311 //l=1.48 //layer=m1 \
 //thickness=0.36 //x=68.94 //y=7.585 //x2=70.42 //y2=7.585
r2234 (  116 860 ) resistor r=3.1 //w=0.17 //l=0.51 //layer=mcon //count=3 \
 //x=67.83 //y=7.58 //x2=67.83 //y2=7.58
r2235 (  116 118 ) resistor r=0.446141 //w=0.311 //l=1.11 //layer=m1 \
 //thickness=0.36 //x=67.83 //y=7.585 //x2=68.94 //y2=7.585
r2236 (  114 850 ) resistor r=3.1 //w=0.17 //l=0.51 //layer=mcon //count=3 \
 //x=66.72 //y=7.58 //x2=66.72 //y2=7.58
r2237 (  114 116 ) resistor r=0.446141 //w=0.311 //l=1.11 //layer=m1 \
 //thickness=0.36 //x=66.72 //y=7.585 //x2=67.83 //y2=7.585
r2238 (  112 838 ) resistor r=3.1 //w=0.17 //l=0.51 //layer=mcon //count=3 \
 //x=65.61 //y=7.58 //x2=65.61 //y2=7.58
r2239 (  112 114 ) resistor r=0.446141 //w=0.311 //l=1.11 //layer=m1 \
 //thickness=0.36 //x=65.61 //y=7.585 //x2=66.72 //y2=7.585
r2240 (  110 824 ) resistor r=3.1 //w=0.17 //l=0.51 //layer=mcon //count=3 \
 //x=64.13 //y=7.58 //x2=64.13 //y2=7.58
r2241 (  110 112 ) resistor r=0.594855 //w=0.311 //l=1.48 //layer=m1 \
 //thickness=0.36 //x=64.13 //y=7.585 //x2=65.61 //y2=7.585
r2242 (  108 814 ) resistor r=3.1 //w=0.17 //l=0.51 //layer=mcon //count=3 \
 //x=63.02 //y=7.58 //x2=63.02 //y2=7.58
r2243 (  108 110 ) resistor r=0.446141 //w=0.311 //l=1.11 //layer=m1 \
 //thickness=0.36 //x=63.02 //y=7.585 //x2=64.13 //y2=7.585
r2244 (  106 798 ) resistor r=3.1 //w=0.17 //l=0.51 //layer=mcon //count=3 \
 //x=61.54 //y=7.58 //x2=61.54 //y2=7.58
r2245 (  106 108 ) resistor r=0.594855 //w=0.311 //l=1.48 //layer=m1 \
 //thickness=0.36 //x=61.54 //y=7.585 //x2=63.02 //y2=7.585
r2246 (  104 788 ) resistor r=3.1 //w=0.17 //l=0.51 //layer=mcon //count=3 \
 //x=60.43 //y=7.58 //x2=60.43 //y2=7.58
r2247 (  104 106 ) resistor r=0.446141 //w=0.311 //l=1.11 //layer=m1 \
 //thickness=0.36 //x=60.43 //y=7.585 //x2=61.54 //y2=7.585
r2248 (  102 778 ) resistor r=3.1 //w=0.17 //l=0.51 //layer=mcon //count=3 \
 //x=59.32 //y=7.58 //x2=59.32 //y2=7.58
r2249 (  102 104 ) resistor r=0.446141 //w=0.311 //l=1.11 //layer=m1 \
 //thickness=0.36 //x=59.32 //y=7.585 //x2=60.43 //y2=7.585
r2250 (  100 1104 ) resistor r=3.1 //w=0.17 //l=0.51 //layer=mcon //count=3 \
 //x=58.21 //y=7.58 //x2=58.21 //y2=7.58
r2251 (  100 102 ) resistor r=0.446141 //w=0.311 //l=1.11 //layer=m1 \
 //thickness=0.36 //x=58.21 //y=7.585 //x2=59.32 //y2=7.585
r2252 (  98 754 ) resistor r=3.1 //w=0.17 //l=0.51 //layer=mcon //count=3 \
 //x=56.73 //y=7.58 //x2=56.73 //y2=7.58
r2253 (  98 100 ) resistor r=0.594855 //w=0.311 //l=1.48 //layer=m1 \
 //thickness=0.36 //x=56.73 //y=7.585 //x2=58.21 //y2=7.585
r2254 (  96 744 ) resistor r=3.1 //w=0.17 //l=0.51 //layer=mcon //count=3 \
 //x=55.62 //y=7.58 //x2=55.62 //y2=7.58
r2255 (  96 98 ) resistor r=0.446141 //w=0.311 //l=1.11 //layer=m1 \
 //thickness=0.36 //x=55.62 //y=7.585 //x2=56.73 //y2=7.585
r2256 (  94 734 ) resistor r=3.1 //w=0.17 //l=0.51 //layer=mcon //count=3 \
 //x=54.51 //y=7.58 //x2=54.51 //y2=7.58
r2257 (  94 96 ) resistor r=0.446141 //w=0.311 //l=1.11 //layer=m1 \
 //thickness=0.36 //x=54.51 //y=7.585 //x2=55.62 //y2=7.585
r2258 (  92 1098 ) resistor r=3.1 //w=0.17 //l=0.51 //layer=mcon //count=3 \
 //x=53.4 //y=7.58 //x2=53.4 //y2=7.58
r2259 (  92 94 ) resistor r=0.446141 //w=0.311 //l=1.11 //layer=m1 \
 //thickness=0.36 //x=53.4 //y=7.585 //x2=54.51 //y2=7.585
r2260 (  90 710 ) resistor r=3.1 //w=0.17 //l=0.51 //layer=mcon //count=3 \
 //x=51.92 //y=7.58 //x2=51.92 //y2=7.58
r2261 (  90 92 ) resistor r=0.594855 //w=0.311 //l=1.48 //layer=m1 \
 //thickness=0.36 //x=51.92 //y=7.585 //x2=53.4 //y2=7.585
r2262 (  88 700 ) resistor r=3.1 //w=0.17 //l=0.51 //layer=mcon //count=3 \
 //x=50.81 //y=7.58 //x2=50.81 //y2=7.58
r2263 (  88 90 ) resistor r=0.446141 //w=0.311 //l=1.11 //layer=m1 \
 //thickness=0.36 //x=50.81 //y=7.585 //x2=51.92 //y2=7.585
r2264 (  86 1093 ) resistor r=3.1 //w=0.17 //l=0.51 //layer=mcon //count=3 \
 //x=49.7 //y=7.58 //x2=49.7 //y2=7.58
r2265 (  86 88 ) resistor r=0.446141 //w=0.311 //l=1.11 //layer=m1 \
 //thickness=0.36 //x=49.7 //y=7.585 //x2=50.81 //y2=7.585
r2266 (  84 676 ) resistor r=3.1 //w=0.17 //l=0.51 //layer=mcon //count=3 \
 //x=48.22 //y=7.58 //x2=48.22 //y2=7.58
r2267 (  84 86 ) resistor r=0.594855 //w=0.311 //l=1.48 //layer=m1 \
 //thickness=0.36 //x=48.22 //y=7.585 //x2=49.7 //y2=7.585
r2268 (  82 666 ) resistor r=3.1 //w=0.17 //l=0.51 //layer=mcon //count=3 \
 //x=47.11 //y=7.58 //x2=47.11 //y2=7.58
r2269 (  82 84 ) resistor r=0.446141 //w=0.311 //l=1.11 //layer=m1 \
 //thickness=0.36 //x=47.11 //y=7.585 //x2=48.22 //y2=7.585
r2270 (  80 648 ) resistor r=3.1 //w=0.17 //l=0.51 //layer=mcon //count=3 \
 //x=46 //y=7.58 //x2=46 //y2=7.58
r2271 (  80 82 ) resistor r=0.446141 //w=0.311 //l=1.11 //layer=m1 \
 //thickness=0.36 //x=46 //y=7.585 //x2=47.11 //y2=7.585
r2272 (  77 636 ) resistor r=3.1 //w=0.17 //l=0.51 //layer=mcon //count=3 \
 //x=44.89 //y=7.58 //x2=44.89 //y2=7.58
r2273 (  75 630 ) resistor r=3.1 //w=0.17 //l=0.51 //layer=mcon //count=3 \
 //x=43.41 //y=7.58 //x2=43.41 //y2=7.58
r2274 (  75 77 ) resistor r=0.594855 //w=0.311 //l=1.48 //layer=m1 \
 //thickness=0.36 //x=43.41 //y=7.585 //x2=44.89 //y2=7.585
r2275 (  73 620 ) resistor r=3.1 //w=0.17 //l=0.51 //layer=mcon //count=3 \
 //x=42.3 //y=7.58 //x2=42.3 //y2=7.58
r2276 (  73 75 ) resistor r=0.446141 //w=0.311 //l=1.11 //layer=m1 \
 //thickness=0.36 //x=42.3 //y=7.585 //x2=43.41 //y2=7.585
r2277 (  71 602 ) resistor r=3.1 //w=0.17 //l=0.51 //layer=mcon //count=3 \
 //x=41.19 //y=7.58 //x2=41.19 //y2=7.58
r2278 (  71 73 ) resistor r=0.446141 //w=0.311 //l=1.11 //layer=m1 \
 //thickness=0.36 //x=41.19 //y=7.585 //x2=42.3 //y2=7.585
r2279 (  69 590 ) resistor r=3.1 //w=0.17 //l=0.51 //layer=mcon //count=3 \
 //x=40.08 //y=7.58 //x2=40.08 //y2=7.58
r2280 (  69 71 ) resistor r=0.446141 //w=0.311 //l=1.11 //layer=m1 \
 //thickness=0.36 //x=40.08 //y=7.585 //x2=41.19 //y2=7.585
r2281 (  67 1080 ) resistor r=3.1 //w=0.17 //l=0.51 //layer=mcon //count=3 \
 //x=38.6 //y=7.58 //x2=38.6 //y2=7.58
r2282 (  67 69 ) resistor r=0.594855 //w=0.311 //l=1.48 //layer=m1 \
 //thickness=0.36 //x=38.6 //y=7.585 //x2=40.08 //y2=7.585
r2283 (  65 568 ) resistor r=3.1 //w=0.17 //l=0.51 //layer=mcon //count=3 \
 //x=37.49 //y=7.58 //x2=37.49 //y2=7.58
r2284 (  65 67 ) resistor r=0.446141 //w=0.311 //l=1.11 //layer=m1 \
 //thickness=0.36 //x=37.49 //y=7.585 //x2=38.6 //y2=7.585
r2285 (  63 556 ) resistor r=3.1 //w=0.17 //l=0.51 //layer=mcon //count=3 \
 //x=36.38 //y=7.58 //x2=36.38 //y2=7.58
r2286 (  63 65 ) resistor r=0.446141 //w=0.311 //l=1.11 //layer=m1 \
 //thickness=0.36 //x=36.38 //y=7.585 //x2=37.49 //y2=7.585
r2287 (  61 1075 ) resistor r=3.1 //w=0.17 //l=0.51 //layer=mcon //count=3 \
 //x=34.9 //y=7.58 //x2=34.9 //y2=7.58
r2288 (  61 63 ) resistor r=0.594855 //w=0.311 //l=1.48 //layer=m1 \
 //thickness=0.36 //x=34.9 //y=7.585 //x2=36.38 //y2=7.585
r2289 (  59 534 ) resistor r=3.1 //w=0.17 //l=0.51 //layer=mcon //count=3 \
 //x=33.79 //y=7.58 //x2=33.79 //y2=7.58
r2290 (  59 61 ) resistor r=0.446141 //w=0.311 //l=1.11 //layer=m1 \
 //thickness=0.36 //x=33.79 //y=7.585 //x2=34.9 //y2=7.585
r2291 (  57 524 ) resistor r=3.1 //w=0.17 //l=0.51 //layer=mcon //count=3 \
 //x=32.68 //y=7.58 //x2=32.68 //y2=7.58
r2292 (  57 59 ) resistor r=0.446141 //w=0.311 //l=1.11 //layer=m1 \
 //thickness=0.36 //x=32.68 //y=7.585 //x2=33.79 //y2=7.585
r2293 (  55 512 ) resistor r=3.1 //w=0.17 //l=0.51 //layer=mcon //count=3 \
 //x=31.57 //y=7.58 //x2=31.57 //y2=7.58
r2294 (  55 57 ) resistor r=0.446141 //w=0.311 //l=1.11 //layer=m1 \
 //thickness=0.36 //x=31.57 //y=7.585 //x2=32.68 //y2=7.585
r2295 (  53 1069 ) resistor r=3.1 //w=0.17 //l=0.51 //layer=mcon //count=3 \
 //x=30.09 //y=7.58 //x2=30.09 //y2=7.58
r2296 (  53 55 ) resistor r=0.594855 //w=0.311 //l=1.48 //layer=m1 \
 //thickness=0.36 //x=30.09 //y=7.585 //x2=31.57 //y2=7.585
r2297 (  51 490 ) resistor r=3.1 //w=0.17 //l=0.51 //layer=mcon //count=3 \
 //x=28.98 //y=7.58 //x2=28.98 //y2=7.58
r2298 (  51 53 ) resistor r=0.446141 //w=0.311 //l=1.11 //layer=m1 \
 //thickness=0.36 //x=28.98 //y=7.585 //x2=30.09 //y2=7.585
r2299 (  49 480 ) resistor r=3.1 //w=0.17 //l=0.51 //layer=mcon //count=3 \
 //x=27.87 //y=7.58 //x2=27.87 //y2=7.58
r2300 (  49 51 ) resistor r=0.446141 //w=0.311 //l=1.11 //layer=m1 \
 //thickness=0.36 //x=27.87 //y=7.585 //x2=28.98 //y2=7.585
r2301 (  47 468 ) resistor r=3.1 //w=0.17 //l=0.51 //layer=mcon //count=3 \
 //x=26.76 //y=7.58 //x2=26.76 //y2=7.58
r2302 (  47 49 ) resistor r=0.446141 //w=0.311 //l=1.11 //layer=m1 \
 //thickness=0.36 //x=26.76 //y=7.585 //x2=27.87 //y2=7.585
r2303 (  45 454 ) resistor r=3.1 //w=0.17 //l=0.51 //layer=mcon //count=3 \
 //x=25.28 //y=7.58 //x2=25.28 //y2=7.58
r2304 (  45 47 ) resistor r=0.594855 //w=0.311 //l=1.48 //layer=m1 \
 //thickness=0.36 //x=25.28 //y=7.585 //x2=26.76 //y2=7.585
r2305 (  43 444 ) resistor r=3.1 //w=0.17 //l=0.51 //layer=mcon //count=3 \
 //x=24.17 //y=7.58 //x2=24.17 //y2=7.58
r2306 (  43 45 ) resistor r=0.446141 //w=0.311 //l=1.11 //layer=m1 \
 //thickness=0.36 //x=24.17 //y=7.585 //x2=25.28 //y2=7.585
r2307 (  41 428 ) resistor r=3.1 //w=0.17 //l=0.51 //layer=mcon //count=3 \
 //x=22.69 //y=7.58 //x2=22.69 //y2=7.58
r2308 (  41 43 ) resistor r=0.594855 //w=0.311 //l=1.48 //layer=m1 \
 //thickness=0.36 //x=22.69 //y=7.585 //x2=24.17 //y2=7.585
r2309 (  39 418 ) resistor r=3.1 //w=0.17 //l=0.51 //layer=mcon //count=3 \
 //x=21.58 //y=7.58 //x2=21.58 //y2=7.58
r2310 (  39 41 ) resistor r=0.446141 //w=0.311 //l=1.11 //layer=m1 \
 //thickness=0.36 //x=21.58 //y=7.585 //x2=22.69 //y2=7.585
r2311 (  37 408 ) resistor r=3.1 //w=0.17 //l=0.51 //layer=mcon //count=3 \
 //x=20.47 //y=7.58 //x2=20.47 //y2=7.58
r2312 (  37 39 ) resistor r=0.446141 //w=0.311 //l=1.11 //layer=m1 \
 //thickness=0.36 //x=20.47 //y=7.585 //x2=21.58 //y2=7.585
r2313 (  35 1056 ) resistor r=3.1 //w=0.17 //l=0.51 //layer=mcon //count=3 \
 //x=19.36 //y=7.58 //x2=19.36 //y2=7.58
r2314 (  35 37 ) resistor r=0.446141 //w=0.311 //l=1.11 //layer=m1 \
 //thickness=0.36 //x=19.36 //y=7.585 //x2=20.47 //y2=7.585
r2315 (  33 384 ) resistor r=3.1 //w=0.17 //l=0.51 //layer=mcon //count=3 \
 //x=17.88 //y=7.58 //x2=17.88 //y2=7.58
r2316 (  33 35 ) resistor r=0.594855 //w=0.311 //l=1.48 //layer=m1 \
 //thickness=0.36 //x=17.88 //y=7.585 //x2=19.36 //y2=7.585
r2317 (  31 374 ) resistor r=3.1 //w=0.17 //l=0.51 //layer=mcon //count=3 \
 //x=16.77 //y=7.58 //x2=16.77 //y2=7.58
r2318 (  31 33 ) resistor r=0.446141 //w=0.311 //l=1.11 //layer=m1 \
 //thickness=0.36 //x=16.77 //y=7.585 //x2=17.88 //y2=7.585
r2319 (  29 364 ) resistor r=3.1 //w=0.17 //l=0.51 //layer=mcon //count=3 \
 //x=15.66 //y=7.58 //x2=15.66 //y2=7.58
r2320 (  29 31 ) resistor r=0.446141 //w=0.311 //l=1.11 //layer=m1 \
 //thickness=0.36 //x=15.66 //y=7.585 //x2=16.77 //y2=7.585
r2321 (  27 1050 ) resistor r=3.1 //w=0.17 //l=0.51 //layer=mcon //count=3 \
 //x=14.55 //y=7.58 //x2=14.55 //y2=7.58
r2322 (  27 29 ) resistor r=0.446141 //w=0.311 //l=1.11 //layer=m1 \
 //thickness=0.36 //x=14.55 //y=7.585 //x2=15.66 //y2=7.585
r2323 (  25 340 ) resistor r=3.1 //w=0.17 //l=0.51 //layer=mcon //count=3 \
 //x=13.07 //y=7.58 //x2=13.07 //y2=7.58
r2324 (  25 27 ) resistor r=0.594855 //w=0.311 //l=1.48 //layer=m1 \
 //thickness=0.36 //x=13.07 //y=7.585 //x2=14.55 //y2=7.585
r2325 (  23 330 ) resistor r=3.1 //w=0.17 //l=0.51 //layer=mcon //count=3 \
 //x=11.96 //y=7.58 //x2=11.96 //y2=7.58
r2326 (  23 25 ) resistor r=0.446141 //w=0.311 //l=1.11 //layer=m1 \
 //thickness=0.36 //x=11.96 //y=7.585 //x2=13.07 //y2=7.585
r2327 (  21 1045 ) resistor r=3.1 //w=0.17 //l=0.51 //layer=mcon //count=3 \
 //x=10.85 //y=7.58 //x2=10.85 //y2=7.58
r2328 (  21 23 ) resistor r=0.446141 //w=0.311 //l=1.11 //layer=m1 \
 //thickness=0.36 //x=10.85 //y=7.585 //x2=11.96 //y2=7.585
r2329 (  19 306 ) resistor r=3.1 //w=0.17 //l=0.51 //layer=mcon //count=3 \
 //x=9.37 //y=7.58 //x2=9.37 //y2=7.58
r2330 (  19 21 ) resistor r=0.594855 //w=0.311 //l=1.48 //layer=m1 \
 //thickness=0.36 //x=9.37 //y=7.585 //x2=10.85 //y2=7.585
r2331 (  17 296 ) resistor r=3.1 //w=0.17 //l=0.51 //layer=mcon //count=3 \
 //x=8.26 //y=7.58 //x2=8.26 //y2=7.58
r2332 (  17 19 ) resistor r=0.446141 //w=0.311 //l=1.11 //layer=m1 \
 //thickness=0.36 //x=8.26 //y=7.585 //x2=9.37 //y2=7.585
r2333 (  15 278 ) resistor r=3.1 //w=0.17 //l=0.51 //layer=mcon //count=3 \
 //x=7.15 //y=7.58 //x2=7.15 //y2=7.58
r2334 (  15 17 ) resistor r=0.446141 //w=0.311 //l=1.11 //layer=m1 \
 //thickness=0.36 //x=7.15 //y=7.585 //x2=8.26 //y2=7.585
r2335 (  13 266 ) resistor r=3.1 //w=0.17 //l=0.51 //layer=mcon //count=3 \
 //x=6.04 //y=7.58 //x2=6.04 //y2=7.58
r2336 (  13 15 ) resistor r=0.446141 //w=0.311 //l=1.11 //layer=m1 \
 //thickness=0.36 //x=6.04 //y=7.585 //x2=7.15 //y2=7.585
r2337 (  11 260 ) resistor r=3.1 //w=0.17 //l=0.51 //layer=mcon //count=3 \
 //x=4.56 //y=7.58 //x2=4.56 //y2=7.58
r2338 (  11 13 ) resistor r=0.594855 //w=0.311 //l=1.48 //layer=m1 \
 //thickness=0.36 //x=4.56 //y=7.585 //x2=6.04 //y2=7.585
r2339 (  9 250 ) resistor r=3.1 //w=0.17 //l=0.51 //layer=mcon //count=3 \
 //x=3.45 //y=7.58 //x2=3.45 //y2=7.58
r2340 (  9 11 ) resistor r=0.446141 //w=0.311 //l=1.11 //layer=m1 \
 //thickness=0.36 //x=3.45 //y=7.585 //x2=4.56 //y2=7.585
r2341 (  7 232 ) resistor r=3.1 //w=0.17 //l=0.51 //layer=mcon //count=3 \
 //x=2.34 //y=7.58 //x2=2.34 //y2=7.58
r2342 (  7 9 ) resistor r=0.446141 //w=0.311 //l=1.11 //layer=m1 \
 //thickness=0.36 //x=2.34 //y=7.585 //x2=3.45 //y2=7.585
r2343 (  4 220 ) resistor r=3.1 //w=0.17 //l=0.51 //layer=mcon //count=3 \
 //x=1.23 //y=7.58 //x2=1.23 //y2=7.58
r2344 (  4 7 ) resistor r=0.446141 //w=0.311 //l=1.11 //layer=m1 \
 //thickness=0.36 //x=1.23 //y=7.585 //x2=2.34 //y2=7.585
r2345 (  2 200 ) resistor r=0.028033 //w=0.35 //l=0.085 //layer=m1 \
 //thickness=0.36 //x=78.895 //y=7.585 //x2=78.98 //y2=7.585
r2346 (  2 132 ) resistor r=0.580788 //w=0.311 //l=1.445 //layer=m1 \
 //thickness=0.36 //x=78.895 //y=7.585 //x2=77.45 //y2=7.585
r2347 (  1 80 ) resistor r=0.223071 //w=0.311 //l=0.555 //layer=m1 \
 //thickness=0.36 //x=45.445 //y=7.585 //x2=46 //y2=7.585
r2348 (  1 77 ) resistor r=0.223071 //w=0.311 //l=0.555 //layer=m1 \
 //thickness=0.36 //x=45.445 //y=7.585 //x2=44.89 //y2=7.585
ends PM_TMRDFFRNQX1\%VDD

subckt PM_TMRDFFRNQX1\%noxref_20 ( 5 7 15 19 30 33 34 )
c63 ( 34 0 ) capacitor c=0.0464972f //x=3.455 //y=0.555
c64 ( 33 0 ) capacitor c=0.0198861f //x=2.35 //y=1.09
c65 ( 30 0 ) capacitor c=0.00141302f //x=3.59 //y=1.175
c66 ( 19 0 ) capacitor c=0.00692795f //x=4.56 //y=0.805
c67 ( 15 0 ) capacitor c=0.0154966f //x=4.475 //y=0.72
c68 ( 7 0 ) capacitor c=0.00689459f //x=3.59 //y=0.805
c69 ( 5 0 ) capacitor c=0.0288646f //x=3.505 //y=1.175
r70 (  19 34 ) resistor r=3.57586 //w=0.17 //l=0.125 //layer=li \
 //thickness=0.1 //x=4.56 //y=0.805 //x2=4.56 //y2=0.68
r71 (  19 34 ) resistor r=18.139 //w=0.187 //l=0.265 //layer=li \
 //thickness=0.1 //x=4.56 //y=0.805 //x2=4.56 //y2=1.07
r72 (  16 34 ) resistor r=3.57586 //w=0.17 //l=0.103078 //layer=li \
 //thickness=0.1 //x=3.675 //y=0.72 //x2=3.59 //y2=0.68
r73 (  16 34 ) resistor r=27.3797 //w=0.187 //l=0.4 //layer=li //thickness=0.1 \
 //x=3.675 //y=0.72 //x2=4.075 //y2=0.72
r74 (  15 34 ) resistor r=3.57586 //w=0.17 //l=0.103078 //layer=li \
 //thickness=0.1 //x=4.475 //y=0.72 //x2=4.56 //y2=0.68
r75 (  15 34 ) resistor r=27.3797 //w=0.187 //l=0.4 //layer=li //thickness=0.1 \
 //x=4.475 //y=0.72 //x2=4.075 //y2=0.72
r76 (  11 30 ) resistor r=5.4201 //w=0.17 //l=0.085 //layer=li //thickness=0.1 \
 //x=3.59 //y=1.26 //x2=3.59 //y2=1.175
r77 (  11 34 ) resistor r=10.2674 //w=0.187 //l=0.15 //layer=li \
 //thickness=0.1 //x=3.59 //y=1.26 //x2=3.59 //y2=1.41
r78 (  8 30 ) resistor r=5.4201 //w=0.17 //l=0.085 //layer=li //thickness=0.1 \
 //x=3.59 //y=1.09 //x2=3.59 //y2=1.175
r79 (  8 34 ) resistor r=1.36898 //w=0.187 //l=0.02 //layer=li //thickness=0.1 \
 //x=3.59 //y=1.09 //x2=3.59 //y2=1.07
r80 (  7 34 ) resistor r=3.57586 //w=0.17 //l=0.125 //layer=li //thickness=0.1 \
 //x=3.59 //y=0.805 //x2=3.59 //y2=0.68
r81 (  7 34 ) resistor r=18.139 //w=0.187 //l=0.265 //layer=li //thickness=0.1 \
 //x=3.59 //y=0.805 //x2=3.59 //y2=1.07
r82 (  6 33 ) resistor r=0.751729 //w=0.17 //l=0.085 //layer=li \
 //thickness=0.1 //x=2.625 //y=1.175 //x2=2.54 //y2=1.175
r83 (  5 30 ) resistor r=1.40859 //w=0.34 //l=0.085 //layer=li //thickness=0.1 \
 //x=3.505 //y=1.175 //x2=3.59 //y2=1.175
r84 (  5 6 ) resistor r=60.2353 //w=0.187 //l=0.88 //layer=li //thickness=0.1 \
 //x=3.505 //y=1.175 //x2=2.625 //y2=1.175
ends PM_TMRDFFRNQX1\%noxref_20

subckt PM_TMRDFFRNQX1\%noxref_21 ( 5 7 15 19 30 33 34 )
c69 ( 34 0 ) capacitor c=0.0450634f //x=8.265 //y=0.555
c70 ( 33 0 ) capacitor c=0.019304f //x=7.16 //y=1.09
c71 ( 30 0 ) capacitor c=0.00141302f //x=8.4 //y=1.175
c72 ( 19 0 ) capacitor c=0.00695768f //x=9.37 //y=0.805
c73 ( 15 0 ) capacitor c=0.0153419f //x=9.285 //y=0.72
c74 ( 7 0 ) capacitor c=0.00689476f //x=8.4 //y=0.805
c75 ( 5 0 ) capacitor c=0.0241574f //x=8.315 //y=1.175
r76 (  19 34 ) resistor r=3.57586 //w=0.17 //l=0.125 //layer=li \
 //thickness=0.1 //x=9.37 //y=0.805 //x2=9.37 //y2=0.68
r77 (  19 34 ) resistor r=18.139 //w=0.187 //l=0.265 //layer=li \
 //thickness=0.1 //x=9.37 //y=0.805 //x2=9.37 //y2=1.07
r78 (  16 34 ) resistor r=3.57586 //w=0.17 //l=0.103078 //layer=li \
 //thickness=0.1 //x=8.485 //y=0.72 //x2=8.4 //y2=0.68
r79 (  16 34 ) resistor r=27.3797 //w=0.187 //l=0.4 //layer=li //thickness=0.1 \
 //x=8.485 //y=0.72 //x2=8.885 //y2=0.72
r80 (  15 34 ) resistor r=3.57586 //w=0.17 //l=0.103078 //layer=li \
 //thickness=0.1 //x=9.285 //y=0.72 //x2=9.37 //y2=0.68
r81 (  15 34 ) resistor r=27.3797 //w=0.187 //l=0.4 //layer=li //thickness=0.1 \
 //x=9.285 //y=0.72 //x2=8.885 //y2=0.72
r82 (  11 30 ) resistor r=5.4201 //w=0.17 //l=0.085 //layer=li //thickness=0.1 \
 //x=8.4 //y=1.26 //x2=8.4 //y2=1.175
r83 (  11 34 ) resistor r=10.2674 //w=0.187 //l=0.15 //layer=li \
 //thickness=0.1 //x=8.4 //y=1.26 //x2=8.4 //y2=1.41
r84 (  8 30 ) resistor r=5.4201 //w=0.17 //l=0.085 //layer=li //thickness=0.1 \
 //x=8.4 //y=1.09 //x2=8.4 //y2=1.175
r85 (  8 34 ) resistor r=1.36898 //w=0.187 //l=0.02 //layer=li //thickness=0.1 \
 //x=8.4 //y=1.09 //x2=8.4 //y2=1.07
r86 (  7 34 ) resistor r=3.57586 //w=0.17 //l=0.125 //layer=li //thickness=0.1 \
 //x=8.4 //y=0.805 //x2=8.4 //y2=0.68
r87 (  7 34 ) resistor r=18.139 //w=0.187 //l=0.265 //layer=li //thickness=0.1 \
 //x=8.4 //y=0.805 //x2=8.4 //y2=1.07
r88 (  6 33 ) resistor r=0.751729 //w=0.17 //l=0.085 //layer=li \
 //thickness=0.1 //x=7.435 //y=1.175 //x2=7.35 //y2=1.175
r89 (  5 30 ) resistor r=1.40859 //w=0.34 //l=0.085 //layer=li //thickness=0.1 \
 //x=8.315 //y=1.175 //x2=8.4 //y2=1.175
r90 (  5 6 ) resistor r=60.2353 //w=0.187 //l=0.88 //layer=li //thickness=0.1 \
 //x=8.315 //y=1.175 //x2=7.435 //y2=1.175
ends PM_TMRDFFRNQX1\%noxref_21

subckt PM_TMRDFFRNQX1\%noxref_22 ( 5 7 15 19 30 33 34 )
c67 ( 34 0 ) capacitor c=0.0455032f //x=16.405 //y=0.555
c68 ( 33 0 ) capacitor c=0.019478f //x=15.3 //y=1.09
c69 ( 30 0 ) capacitor c=0.00141302f //x=16.54 //y=1.175
c70 ( 19 0 ) capacitor c=0.00692795f //x=17.51 //y=0.805
c71 ( 15 0 ) capacitor c=0.0153419f //x=17.425 //y=0.72
c72 ( 7 0 ) capacitor c=0.00689459f //x=16.54 //y=0.805
c73 ( 5 0 ) capacitor c=0.0235962f //x=16.455 //y=1.175
r74 (  19 34 ) resistor r=3.57586 //w=0.17 //l=0.125 //layer=li \
 //thickness=0.1 //x=17.51 //y=0.805 //x2=17.51 //y2=0.68
r75 (  19 34 ) resistor r=18.139 //w=0.187 //l=0.265 //layer=li \
 //thickness=0.1 //x=17.51 //y=0.805 //x2=17.51 //y2=1.07
r76 (  16 34 ) resistor r=3.57586 //w=0.17 //l=0.103078 //layer=li \
 //thickness=0.1 //x=16.625 //y=0.72 //x2=16.54 //y2=0.68
r77 (  16 34 ) resistor r=27.3797 //w=0.187 //l=0.4 //layer=li //thickness=0.1 \
 //x=16.625 //y=0.72 //x2=17.025 //y2=0.72
r78 (  15 34 ) resistor r=3.57586 //w=0.17 //l=0.103078 //layer=li \
 //thickness=0.1 //x=17.425 //y=0.72 //x2=17.51 //y2=0.68
r79 (  15 34 ) resistor r=27.3797 //w=0.187 //l=0.4 //layer=li //thickness=0.1 \
 //x=17.425 //y=0.72 //x2=17.025 //y2=0.72
r80 (  11 30 ) resistor r=5.4201 //w=0.17 //l=0.085 //layer=li //thickness=0.1 \
 //x=16.54 //y=1.26 //x2=16.54 //y2=1.175
r81 (  11 34 ) resistor r=10.2674 //w=0.187 //l=0.15 //layer=li \
 //thickness=0.1 //x=16.54 //y=1.26 //x2=16.54 //y2=1.41
r82 (  8 30 ) resistor r=5.4201 //w=0.17 //l=0.085 //layer=li //thickness=0.1 \
 //x=16.54 //y=1.09 //x2=16.54 //y2=1.175
r83 (  8 34 ) resistor r=1.36898 //w=0.187 //l=0.02 //layer=li //thickness=0.1 \
 //x=16.54 //y=1.09 //x2=16.54 //y2=1.07
r84 (  7 34 ) resistor r=3.57586 //w=0.17 //l=0.125 //layer=li //thickness=0.1 \
 //x=16.54 //y=0.805 //x2=16.54 //y2=0.68
r85 (  7 34 ) resistor r=18.139 //w=0.187 //l=0.265 //layer=li //thickness=0.1 \
 //x=16.54 //y=0.805 //x2=16.54 //y2=1.07
r86 (  6 33 ) resistor r=0.751729 //w=0.17 //l=0.085 //layer=li \
 //thickness=0.1 //x=15.575 //y=1.175 //x2=15.49 //y2=1.175
r87 (  5 30 ) resistor r=1.40859 //w=0.34 //l=0.085 //layer=li //thickness=0.1 \
 //x=16.455 //y=1.175 //x2=16.54 //y2=1.175
r88 (  5 6 ) resistor r=60.2353 //w=0.187 //l=0.88 //layer=li //thickness=0.1 \
 //x=16.455 //y=1.175 //x2=15.575 //y2=1.175
ends PM_TMRDFFRNQX1\%noxref_22

subckt PM_TMRDFFRNQX1\%noxref_23 ( 5 7 15 19 30 33 34 )
c69 ( 34 0 ) capacitor c=0.0454561f //x=21.215 //y=0.555
c70 ( 33 0 ) capacitor c=0.0186047f //x=20.11 //y=1.09
c71 ( 30 0 ) capacitor c=0.00141302f //x=21.35 //y=1.175
c72 ( 19 0 ) capacitor c=0.00695768f //x=22.32 //y=0.805
c73 ( 15 0 ) capacitor c=0.0155355f //x=22.235 //y=0.72
c74 ( 7 0 ) capacitor c=0.00689476f //x=21.35 //y=0.805
c75 ( 5 0 ) capacitor c=0.0235962f //x=21.265 //y=1.175
r76 (  19 34 ) resistor r=3.57586 //w=0.17 //l=0.125 //layer=li \
 //thickness=0.1 //x=22.32 //y=0.805 //x2=22.32 //y2=0.68
r77 (  19 34 ) resistor r=18.139 //w=0.187 //l=0.265 //layer=li \
 //thickness=0.1 //x=22.32 //y=0.805 //x2=22.32 //y2=1.07
r78 (  16 34 ) resistor r=3.57586 //w=0.17 //l=0.103078 //layer=li \
 //thickness=0.1 //x=21.435 //y=0.72 //x2=21.35 //y2=0.68
r79 (  16 34 ) resistor r=27.3797 //w=0.187 //l=0.4 //layer=li //thickness=0.1 \
 //x=21.435 //y=0.72 //x2=21.835 //y2=0.72
r80 (  15 34 ) resistor r=3.57586 //w=0.17 //l=0.103078 //layer=li \
 //thickness=0.1 //x=22.235 //y=0.72 //x2=22.32 //y2=0.68
r81 (  15 34 ) resistor r=27.3797 //w=0.187 //l=0.4 //layer=li //thickness=0.1 \
 //x=22.235 //y=0.72 //x2=21.835 //y2=0.72
r82 (  11 30 ) resistor r=5.4201 //w=0.17 //l=0.085 //layer=li //thickness=0.1 \
 //x=21.35 //y=1.26 //x2=21.35 //y2=1.175
r83 (  11 34 ) resistor r=10.2674 //w=0.187 //l=0.15 //layer=li \
 //thickness=0.1 //x=21.35 //y=1.26 //x2=21.35 //y2=1.41
r84 (  8 30 ) resistor r=5.4201 //w=0.17 //l=0.085 //layer=li //thickness=0.1 \
 //x=21.35 //y=1.09 //x2=21.35 //y2=1.175
r85 (  8 34 ) resistor r=1.36898 //w=0.187 //l=0.02 //layer=li //thickness=0.1 \
 //x=21.35 //y=1.09 //x2=21.35 //y2=1.07
r86 (  7 34 ) resistor r=3.57586 //w=0.17 //l=0.125 //layer=li //thickness=0.1 \
 //x=21.35 //y=0.805 //x2=21.35 //y2=0.68
r87 (  7 34 ) resistor r=18.139 //w=0.187 //l=0.265 //layer=li //thickness=0.1 \
 //x=21.35 //y=0.805 //x2=21.35 //y2=1.07
r88 (  6 33 ) resistor r=0.751729 //w=0.17 //l=0.085 //layer=li \
 //thickness=0.1 //x=20.385 //y=1.175 //x2=20.3 //y2=1.175
r89 (  5 30 ) resistor r=1.40859 //w=0.34 //l=0.085 //layer=li //thickness=0.1 \
 //x=21.265 //y=1.175 //x2=21.35 //y2=1.175
r90 (  5 6 ) resistor r=60.2353 //w=0.187 //l=0.88 //layer=li //thickness=0.1 \
 //x=21.265 //y=1.175 //x2=20.385 //y2=1.175
ends PM_TMRDFFRNQX1\%noxref_23

subckt PM_TMRDFFRNQX1\%noxref_24 ( 5 7 15 19 30 33 34 )
c67 ( 34 0 ) capacitor c=0.0455026f //x=29.355 //y=0.555
c68 ( 33 0 ) capacitor c=0.0194934f //x=28.25 //y=1.09
c69 ( 30 0 ) capacitor c=0.00141302f //x=29.49 //y=1.175
c70 ( 19 0 ) capacitor c=0.00692795f //x=30.46 //y=0.805
c71 ( 15 0 ) capacitor c=0.0155081f //x=30.375 //y=0.72
c72 ( 7 0 ) capacitor c=0.00689459f //x=29.49 //y=0.805
c73 ( 5 0 ) capacitor c=0.0235962f //x=29.405 //y=1.175
r74 (  19 34 ) resistor r=3.57586 //w=0.17 //l=0.125 //layer=li \
 //thickness=0.1 //x=30.46 //y=0.805 //x2=30.46 //y2=0.68
r75 (  19 34 ) resistor r=18.139 //w=0.187 //l=0.265 //layer=li \
 //thickness=0.1 //x=30.46 //y=0.805 //x2=30.46 //y2=1.07
r76 (  16 34 ) resistor r=3.57586 //w=0.17 //l=0.103078 //layer=li \
 //thickness=0.1 //x=29.575 //y=0.72 //x2=29.49 //y2=0.68
r77 (  16 34 ) resistor r=27.3797 //w=0.187 //l=0.4 //layer=li //thickness=0.1 \
 //x=29.575 //y=0.72 //x2=29.975 //y2=0.72
r78 (  15 34 ) resistor r=3.57586 //w=0.17 //l=0.103078 //layer=li \
 //thickness=0.1 //x=30.375 //y=0.72 //x2=30.46 //y2=0.68
r79 (  15 34 ) resistor r=27.3797 //w=0.187 //l=0.4 //layer=li //thickness=0.1 \
 //x=30.375 //y=0.72 //x2=29.975 //y2=0.72
r80 (  11 30 ) resistor r=5.4201 //w=0.17 //l=0.085 //layer=li //thickness=0.1 \
 //x=29.49 //y=1.26 //x2=29.49 //y2=1.175
r81 (  11 34 ) resistor r=10.2674 //w=0.187 //l=0.15 //layer=li \
 //thickness=0.1 //x=29.49 //y=1.26 //x2=29.49 //y2=1.41
r82 (  8 30 ) resistor r=5.4201 //w=0.17 //l=0.085 //layer=li //thickness=0.1 \
 //x=29.49 //y=1.09 //x2=29.49 //y2=1.175
r83 (  8 34 ) resistor r=1.36898 //w=0.187 //l=0.02 //layer=li //thickness=0.1 \
 //x=29.49 //y=1.09 //x2=29.49 //y2=1.07
r84 (  7 34 ) resistor r=3.57586 //w=0.17 //l=0.125 //layer=li //thickness=0.1 \
 //x=29.49 //y=0.805 //x2=29.49 //y2=0.68
r85 (  7 34 ) resistor r=18.139 //w=0.187 //l=0.265 //layer=li //thickness=0.1 \
 //x=29.49 //y=0.805 //x2=29.49 //y2=1.07
r86 (  6 33 ) resistor r=0.751729 //w=0.17 //l=0.085 //layer=li \
 //thickness=0.1 //x=28.525 //y=1.175 //x2=28.44 //y2=1.175
r87 (  5 30 ) resistor r=1.40859 //w=0.34 //l=0.085 //layer=li //thickness=0.1 \
 //x=29.405 //y=1.175 //x2=29.49 //y2=1.175
r88 (  5 6 ) resistor r=60.2353 //w=0.187 //l=0.88 //layer=li //thickness=0.1 \
 //x=29.405 //y=1.175 //x2=28.525 //y2=1.175
ends PM_TMRDFFRNQX1\%noxref_24

subckt PM_TMRDFFRNQX1\%noxref_25 ( 5 7 15 19 30 33 34 )
c68 ( 34 0 ) capacitor c=0.0449068f //x=34.165 //y=0.555
c69 ( 33 0 ) capacitor c=0.01927f //x=33.06 //y=1.09
c70 ( 30 0 ) capacitor c=0.00141302f //x=34.3 //y=1.175
c71 ( 19 0 ) capacitor c=0.00695768f //x=35.27 //y=0.805
c72 ( 15 0 ) capacitor c=0.0153419f //x=35.185 //y=0.72
c73 ( 7 0 ) capacitor c=0.00689476f //x=34.3 //y=0.805
c74 ( 5 0 ) capacitor c=0.0235935f //x=34.215 //y=1.175
r75 (  19 34 ) resistor r=3.57586 //w=0.17 //l=0.125 //layer=li \
 //thickness=0.1 //x=35.27 //y=0.805 //x2=35.27 //y2=0.68
r76 (  19 34 ) resistor r=18.139 //w=0.187 //l=0.265 //layer=li \
 //thickness=0.1 //x=35.27 //y=0.805 //x2=35.27 //y2=1.07
r77 (  16 34 ) resistor r=3.57586 //w=0.17 //l=0.103078 //layer=li \
 //thickness=0.1 //x=34.385 //y=0.72 //x2=34.3 //y2=0.68
r78 (  16 34 ) resistor r=27.3797 //w=0.187 //l=0.4 //layer=li //thickness=0.1 \
 //x=34.385 //y=0.72 //x2=34.785 //y2=0.72
r79 (  15 34 ) resistor r=3.57586 //w=0.17 //l=0.103078 //layer=li \
 //thickness=0.1 //x=35.185 //y=0.72 //x2=35.27 //y2=0.68
r80 (  15 34 ) resistor r=27.3797 //w=0.187 //l=0.4 //layer=li //thickness=0.1 \
 //x=35.185 //y=0.72 //x2=34.785 //y2=0.72
r81 (  11 30 ) resistor r=5.4201 //w=0.17 //l=0.085 //layer=li //thickness=0.1 \
 //x=34.3 //y=1.26 //x2=34.3 //y2=1.175
r82 (  11 34 ) resistor r=10.2674 //w=0.187 //l=0.15 //layer=li \
 //thickness=0.1 //x=34.3 //y=1.26 //x2=34.3 //y2=1.41
r83 (  8 30 ) resistor r=5.4201 //w=0.17 //l=0.085 //layer=li //thickness=0.1 \
 //x=34.3 //y=1.09 //x2=34.3 //y2=1.175
r84 (  8 34 ) resistor r=1.36898 //w=0.187 //l=0.02 //layer=li //thickness=0.1 \
 //x=34.3 //y=1.09 //x2=34.3 //y2=1.07
r85 (  7 34 ) resistor r=3.57586 //w=0.17 //l=0.125 //layer=li //thickness=0.1 \
 //x=34.3 //y=0.805 //x2=34.3 //y2=0.68
r86 (  7 34 ) resistor r=18.139 //w=0.187 //l=0.265 //layer=li //thickness=0.1 \
 //x=34.3 //y=0.805 //x2=34.3 //y2=1.07
r87 (  6 33 ) resistor r=0.751729 //w=0.17 //l=0.085 //layer=li \
 //thickness=0.1 //x=33.335 //y=1.175 //x2=33.25 //y2=1.175
r88 (  5 30 ) resistor r=1.40859 //w=0.34 //l=0.085 //layer=li //thickness=0.1 \
 //x=34.215 //y=1.175 //x2=34.3 //y2=1.175
r89 (  5 6 ) resistor r=60.2353 //w=0.187 //l=0.88 //layer=li //thickness=0.1 \
 //x=34.215 //y=1.175 //x2=33.335 //y2=1.175
ends PM_TMRDFFRNQX1\%noxref_25

subckt PM_TMRDFFRNQX1\%noxref_26 ( 5 7 15 19 30 33 34 )
c67 ( 34 0 ) capacitor c=0.0455032f //x=42.305 //y=0.555
c68 ( 33 0 ) capacitor c=0.019478f //x=41.2 //y=1.09
c69 ( 30 0 ) capacitor c=0.00141302f //x=42.44 //y=1.175
c70 ( 19 0 ) capacitor c=0.00692795f //x=43.41 //y=0.805
c71 ( 15 0 ) capacitor c=0.0153419f //x=43.325 //y=0.72
c72 ( 7 0 ) capacitor c=0.00689459f //x=42.44 //y=0.805
c73 ( 5 0 ) capacitor c=0.0235962f //x=42.355 //y=1.175
r74 (  19 34 ) resistor r=3.57586 //w=0.17 //l=0.125 //layer=li \
 //thickness=0.1 //x=43.41 //y=0.805 //x2=43.41 //y2=0.68
r75 (  19 34 ) resistor r=18.139 //w=0.187 //l=0.265 //layer=li \
 //thickness=0.1 //x=43.41 //y=0.805 //x2=43.41 //y2=1.07
r76 (  16 34 ) resistor r=3.57586 //w=0.17 //l=0.103078 //layer=li \
 //thickness=0.1 //x=42.525 //y=0.72 //x2=42.44 //y2=0.68
r77 (  16 34 ) resistor r=27.3797 //w=0.187 //l=0.4 //layer=li //thickness=0.1 \
 //x=42.525 //y=0.72 //x2=42.925 //y2=0.72
r78 (  15 34 ) resistor r=3.57586 //w=0.17 //l=0.103078 //layer=li \
 //thickness=0.1 //x=43.325 //y=0.72 //x2=43.41 //y2=0.68
r79 (  15 34 ) resistor r=27.3797 //w=0.187 //l=0.4 //layer=li //thickness=0.1 \
 //x=43.325 //y=0.72 //x2=42.925 //y2=0.72
r80 (  11 30 ) resistor r=5.4201 //w=0.17 //l=0.085 //layer=li //thickness=0.1 \
 //x=42.44 //y=1.26 //x2=42.44 //y2=1.175
r81 (  11 34 ) resistor r=10.2674 //w=0.187 //l=0.15 //layer=li \
 //thickness=0.1 //x=42.44 //y=1.26 //x2=42.44 //y2=1.41
r82 (  8 30 ) resistor r=5.4201 //w=0.17 //l=0.085 //layer=li //thickness=0.1 \
 //x=42.44 //y=1.09 //x2=42.44 //y2=1.175
r83 (  8 34 ) resistor r=1.36898 //w=0.187 //l=0.02 //layer=li //thickness=0.1 \
 //x=42.44 //y=1.09 //x2=42.44 //y2=1.07
r84 (  7 34 ) resistor r=3.57586 //w=0.17 //l=0.125 //layer=li //thickness=0.1 \
 //x=42.44 //y=0.805 //x2=42.44 //y2=0.68
r85 (  7 34 ) resistor r=18.139 //w=0.187 //l=0.265 //layer=li //thickness=0.1 \
 //x=42.44 //y=0.805 //x2=42.44 //y2=1.07
r86 (  6 33 ) resistor r=0.751729 //w=0.17 //l=0.085 //layer=li \
 //thickness=0.1 //x=41.475 //y=1.175 //x2=41.39 //y2=1.175
r87 (  5 30 ) resistor r=1.40859 //w=0.34 //l=0.085 //layer=li //thickness=0.1 \
 //x=42.355 //y=1.175 //x2=42.44 //y2=1.175
r88 (  5 6 ) resistor r=60.2353 //w=0.187 //l=0.88 //layer=li //thickness=0.1 \
 //x=42.355 //y=1.175 //x2=41.475 //y2=1.175
ends PM_TMRDFFRNQX1\%noxref_26

subckt PM_TMRDFFRNQX1\%noxref_27 ( 5 7 15 19 30 33 34 )
c68 ( 34 0 ) capacitor c=0.0453511f //x=47.115 //y=0.555
c69 ( 33 0 ) capacitor c=0.0186047f //x=46.01 //y=1.09
c70 ( 30 0 ) capacitor c=0.00141302f //x=47.25 //y=1.175
c71 ( 19 0 ) capacitor c=0.00695768f //x=48.22 //y=0.805
c72 ( 15 0 ) capacitor c=0.0155072f //x=48.135 //y=0.72
c73 ( 7 0 ) capacitor c=0.00689476f //x=47.25 //y=0.805
c74 ( 5 0 ) capacitor c=0.0235962f //x=47.165 //y=1.175
r75 (  19 34 ) resistor r=3.57586 //w=0.17 //l=0.125 //layer=li \
 //thickness=0.1 //x=48.22 //y=0.805 //x2=48.22 //y2=0.68
r76 (  19 34 ) resistor r=18.139 //w=0.187 //l=0.265 //layer=li \
 //thickness=0.1 //x=48.22 //y=0.805 //x2=48.22 //y2=1.07
r77 (  16 34 ) resistor r=3.57586 //w=0.17 //l=0.103078 //layer=li \
 //thickness=0.1 //x=47.335 //y=0.72 //x2=47.25 //y2=0.68
r78 (  16 34 ) resistor r=27.3797 //w=0.187 //l=0.4 //layer=li //thickness=0.1 \
 //x=47.335 //y=0.72 //x2=47.735 //y2=0.72
r79 (  15 34 ) resistor r=3.57586 //w=0.17 //l=0.103078 //layer=li \
 //thickness=0.1 //x=48.135 //y=0.72 //x2=48.22 //y2=0.68
r80 (  15 34 ) resistor r=27.3797 //w=0.187 //l=0.4 //layer=li //thickness=0.1 \
 //x=48.135 //y=0.72 //x2=47.735 //y2=0.72
r81 (  11 30 ) resistor r=5.4201 //w=0.17 //l=0.085 //layer=li //thickness=0.1 \
 //x=47.25 //y=1.26 //x2=47.25 //y2=1.175
r82 (  11 34 ) resistor r=10.2674 //w=0.187 //l=0.15 //layer=li \
 //thickness=0.1 //x=47.25 //y=1.26 //x2=47.25 //y2=1.41
r83 (  8 30 ) resistor r=5.4201 //w=0.17 //l=0.085 //layer=li //thickness=0.1 \
 //x=47.25 //y=1.09 //x2=47.25 //y2=1.175
r84 (  8 34 ) resistor r=1.36898 //w=0.187 //l=0.02 //layer=li //thickness=0.1 \
 //x=47.25 //y=1.09 //x2=47.25 //y2=1.07
r85 (  7 34 ) resistor r=3.57586 //w=0.17 //l=0.125 //layer=li //thickness=0.1 \
 //x=47.25 //y=0.805 //x2=47.25 //y2=0.68
r86 (  7 34 ) resistor r=18.139 //w=0.187 //l=0.265 //layer=li //thickness=0.1 \
 //x=47.25 //y=0.805 //x2=47.25 //y2=1.07
r87 (  6 33 ) resistor r=0.751729 //w=0.17 //l=0.085 //layer=li \
 //thickness=0.1 //x=46.285 //y=1.175 //x2=46.2 //y2=1.175
r88 (  5 30 ) resistor r=1.40859 //w=0.34 //l=0.085 //layer=li //thickness=0.1 \
 //x=47.165 //y=1.175 //x2=47.25 //y2=1.175
r89 (  5 6 ) resistor r=60.2353 //w=0.187 //l=0.88 //layer=li //thickness=0.1 \
 //x=47.165 //y=1.175 //x2=46.285 //y2=1.175
ends PM_TMRDFFRNQX1\%noxref_27

subckt PM_TMRDFFRNQX1\%noxref_28 ( 5 7 15 19 30 33 34 )
c67 ( 34 0 ) capacitor c=0.0455026f //x=55.255 //y=0.555
c68 ( 33 0 ) capacitor c=0.0194934f //x=54.15 //y=1.09
c69 ( 30 0 ) capacitor c=0.00141302f //x=55.39 //y=1.175
c70 ( 19 0 ) capacitor c=0.00692795f //x=56.36 //y=0.805
c71 ( 15 0 ) capacitor c=0.0155081f //x=56.275 //y=0.72
c72 ( 7 0 ) capacitor c=0.00689459f //x=55.39 //y=0.805
c73 ( 5 0 ) capacitor c=0.0235962f //x=55.305 //y=1.175
r74 (  19 34 ) resistor r=3.57586 //w=0.17 //l=0.125 //layer=li \
 //thickness=0.1 //x=56.36 //y=0.805 //x2=56.36 //y2=0.68
r75 (  19 34 ) resistor r=18.139 //w=0.187 //l=0.265 //layer=li \
 //thickness=0.1 //x=56.36 //y=0.805 //x2=56.36 //y2=1.07
r76 (  16 34 ) resistor r=3.57586 //w=0.17 //l=0.103078 //layer=li \
 //thickness=0.1 //x=55.475 //y=0.72 //x2=55.39 //y2=0.68
r77 (  16 34 ) resistor r=27.3797 //w=0.187 //l=0.4 //layer=li //thickness=0.1 \
 //x=55.475 //y=0.72 //x2=55.875 //y2=0.72
r78 (  15 34 ) resistor r=3.57586 //w=0.17 //l=0.103078 //layer=li \
 //thickness=0.1 //x=56.275 //y=0.72 //x2=56.36 //y2=0.68
r79 (  15 34 ) resistor r=27.3797 //w=0.187 //l=0.4 //layer=li //thickness=0.1 \
 //x=56.275 //y=0.72 //x2=55.875 //y2=0.72
r80 (  11 30 ) resistor r=5.4201 //w=0.17 //l=0.085 //layer=li //thickness=0.1 \
 //x=55.39 //y=1.26 //x2=55.39 //y2=1.175
r81 (  11 34 ) resistor r=10.2674 //w=0.187 //l=0.15 //layer=li \
 //thickness=0.1 //x=55.39 //y=1.26 //x2=55.39 //y2=1.41
r82 (  8 30 ) resistor r=5.4201 //w=0.17 //l=0.085 //layer=li //thickness=0.1 \
 //x=55.39 //y=1.09 //x2=55.39 //y2=1.175
r83 (  8 34 ) resistor r=1.36898 //w=0.187 //l=0.02 //layer=li //thickness=0.1 \
 //x=55.39 //y=1.09 //x2=55.39 //y2=1.07
r84 (  7 34 ) resistor r=3.57586 //w=0.17 //l=0.125 //layer=li //thickness=0.1 \
 //x=55.39 //y=0.805 //x2=55.39 //y2=0.68
r85 (  7 34 ) resistor r=18.139 //w=0.187 //l=0.265 //layer=li //thickness=0.1 \
 //x=55.39 //y=0.805 //x2=55.39 //y2=1.07
r86 (  6 33 ) resistor r=0.751729 //w=0.17 //l=0.085 //layer=li \
 //thickness=0.1 //x=54.425 //y=1.175 //x2=54.34 //y2=1.175
r87 (  5 30 ) resistor r=1.40859 //w=0.34 //l=0.085 //layer=li //thickness=0.1 \
 //x=55.305 //y=1.175 //x2=55.39 //y2=1.175
r88 (  5 6 ) resistor r=60.2353 //w=0.187 //l=0.88 //layer=li //thickness=0.1 \
 //x=55.305 //y=1.175 //x2=54.425 //y2=1.175
ends PM_TMRDFFRNQX1\%noxref_28

subckt PM_TMRDFFRNQX1\%noxref_29 ( 5 7 15 19 30 33 34 )
c67 ( 34 0 ) capacitor c=0.0449068f //x=60.065 //y=0.555
c68 ( 33 0 ) capacitor c=0.0195237f //x=58.96 //y=1.09
c69 ( 30 0 ) capacitor c=0.00141302f //x=60.2 //y=1.175
c70 ( 19 0 ) capacitor c=0.00695768f //x=61.17 //y=0.805
c71 ( 15 0 ) capacitor c=0.0153419f //x=61.085 //y=0.72
c72 ( 7 0 ) capacitor c=0.00689476f //x=60.2 //y=0.805
c73 ( 5 0 ) capacitor c=0.0235936f //x=60.115 //y=1.175
r74 (  19 34 ) resistor r=3.57586 //w=0.17 //l=0.125 //layer=li \
 //thickness=0.1 //x=61.17 //y=0.805 //x2=61.17 //y2=0.68
r75 (  19 34 ) resistor r=18.139 //w=0.187 //l=0.265 //layer=li \
 //thickness=0.1 //x=61.17 //y=0.805 //x2=61.17 //y2=1.07
r76 (  16 34 ) resistor r=3.57586 //w=0.17 //l=0.103078 //layer=li \
 //thickness=0.1 //x=60.285 //y=0.72 //x2=60.2 //y2=0.68
r77 (  16 34 ) resistor r=27.3797 //w=0.187 //l=0.4 //layer=li //thickness=0.1 \
 //x=60.285 //y=0.72 //x2=60.685 //y2=0.72
r78 (  15 34 ) resistor r=3.57586 //w=0.17 //l=0.103078 //layer=li \
 //thickness=0.1 //x=61.085 //y=0.72 //x2=61.17 //y2=0.68
r79 (  15 34 ) resistor r=27.3797 //w=0.187 //l=0.4 //layer=li //thickness=0.1 \
 //x=61.085 //y=0.72 //x2=60.685 //y2=0.72
r80 (  11 30 ) resistor r=5.4201 //w=0.17 //l=0.085 //layer=li //thickness=0.1 \
 //x=60.2 //y=1.26 //x2=60.2 //y2=1.175
r81 (  11 34 ) resistor r=10.2674 //w=0.187 //l=0.15 //layer=li \
 //thickness=0.1 //x=60.2 //y=1.26 //x2=60.2 //y2=1.41
r82 (  8 30 ) resistor r=5.4201 //w=0.17 //l=0.085 //layer=li //thickness=0.1 \
 //x=60.2 //y=1.09 //x2=60.2 //y2=1.175
r83 (  8 34 ) resistor r=1.36898 //w=0.187 //l=0.02 //layer=li //thickness=0.1 \
 //x=60.2 //y=1.09 //x2=60.2 //y2=1.07
r84 (  7 34 ) resistor r=3.57586 //w=0.17 //l=0.125 //layer=li //thickness=0.1 \
 //x=60.2 //y=0.805 //x2=60.2 //y2=0.68
r85 (  7 34 ) resistor r=18.139 //w=0.187 //l=0.265 //layer=li //thickness=0.1 \
 //x=60.2 //y=0.805 //x2=60.2 //y2=1.07
r86 (  6 33 ) resistor r=0.751729 //w=0.17 //l=0.085 //layer=li \
 //thickness=0.1 //x=59.235 //y=1.175 //x2=59.15 //y2=1.175
r87 (  5 30 ) resistor r=1.40859 //w=0.34 //l=0.085 //layer=li //thickness=0.1 \
 //x=60.115 //y=1.175 //x2=60.2 //y2=1.175
r88 (  5 6 ) resistor r=60.2353 //w=0.187 //l=0.88 //layer=li //thickness=0.1 \
 //x=60.115 //y=1.175 //x2=59.235 //y2=1.175
ends PM_TMRDFFRNQX1\%noxref_29

subckt PM_TMRDFFRNQX1\%noxref_30 ( 5 7 15 19 30 33 34 )
c67 ( 34 0 ) capacitor c=0.0455032f //x=68.205 //y=0.555
c68 ( 33 0 ) capacitor c=0.019478f //x=67.1 //y=1.09
c69 ( 30 0 ) capacitor c=0.00141302f //x=68.34 //y=1.175
c70 ( 19 0 ) capacitor c=0.00692795f //x=69.31 //y=0.805
c71 ( 15 0 ) capacitor c=0.0153419f //x=69.225 //y=0.72
c72 ( 7 0 ) capacitor c=0.00689459f //x=68.34 //y=0.805
c73 ( 5 0 ) capacitor c=0.0235962f //x=68.255 //y=1.175
r74 (  19 34 ) resistor r=3.57586 //w=0.17 //l=0.125 //layer=li \
 //thickness=0.1 //x=69.31 //y=0.805 //x2=69.31 //y2=0.68
r75 (  19 34 ) resistor r=18.139 //w=0.187 //l=0.265 //layer=li \
 //thickness=0.1 //x=69.31 //y=0.805 //x2=69.31 //y2=1.07
r76 (  16 34 ) resistor r=3.57586 //w=0.17 //l=0.103078 //layer=li \
 //thickness=0.1 //x=68.425 //y=0.72 //x2=68.34 //y2=0.68
r77 (  16 34 ) resistor r=27.3797 //w=0.187 //l=0.4 //layer=li //thickness=0.1 \
 //x=68.425 //y=0.72 //x2=68.825 //y2=0.72
r78 (  15 34 ) resistor r=3.57586 //w=0.17 //l=0.103078 //layer=li \
 //thickness=0.1 //x=69.225 //y=0.72 //x2=69.31 //y2=0.68
r79 (  15 34 ) resistor r=27.3797 //w=0.187 //l=0.4 //layer=li //thickness=0.1 \
 //x=69.225 //y=0.72 //x2=68.825 //y2=0.72
r80 (  11 30 ) resistor r=5.4201 //w=0.17 //l=0.085 //layer=li //thickness=0.1 \
 //x=68.34 //y=1.26 //x2=68.34 //y2=1.175
r81 (  11 34 ) resistor r=10.2674 //w=0.187 //l=0.15 //layer=li \
 //thickness=0.1 //x=68.34 //y=1.26 //x2=68.34 //y2=1.41
r82 (  8 30 ) resistor r=5.4201 //w=0.17 //l=0.085 //layer=li //thickness=0.1 \
 //x=68.34 //y=1.09 //x2=68.34 //y2=1.175
r83 (  8 34 ) resistor r=1.36898 //w=0.187 //l=0.02 //layer=li //thickness=0.1 \
 //x=68.34 //y=1.09 //x2=68.34 //y2=1.07
r84 (  7 34 ) resistor r=3.57586 //w=0.17 //l=0.125 //layer=li //thickness=0.1 \
 //x=68.34 //y=0.805 //x2=68.34 //y2=0.68
r85 (  7 34 ) resistor r=18.139 //w=0.187 //l=0.265 //layer=li //thickness=0.1 \
 //x=68.34 //y=0.805 //x2=68.34 //y2=1.07
r86 (  6 33 ) resistor r=0.751729 //w=0.17 //l=0.085 //layer=li \
 //thickness=0.1 //x=67.375 //y=1.175 //x2=67.29 //y2=1.175
r87 (  5 30 ) resistor r=1.40859 //w=0.34 //l=0.085 //layer=li //thickness=0.1 \
 //x=68.255 //y=1.175 //x2=68.34 //y2=1.175
r88 (  5 6 ) resistor r=60.2353 //w=0.187 //l=0.88 //layer=li //thickness=0.1 \
 //x=68.255 //y=1.175 //x2=67.375 //y2=1.175
ends PM_TMRDFFRNQX1\%noxref_30

subckt PM_TMRDFFRNQX1\%noxref_31 ( 5 7 15 19 30 33 34 )
c68 ( 34 0 ) capacitor c=0.0459345f //x=73.015 //y=0.555
c69 ( 33 0 ) capacitor c=0.0186047f //x=71.91 //y=1.09
c70 ( 30 0 ) capacitor c=0.00141302f //x=73.15 //y=1.175
c71 ( 19 0 ) capacitor c=0.00695768f //x=74.12 //y=0.805
c72 ( 15 0 ) capacitor c=0.0155081f //x=74.035 //y=0.72
c73 ( 7 0 ) capacitor c=0.00689476f //x=73.15 //y=0.805
c74 ( 5 0 ) capacitor c=0.0247635f //x=73.065 //y=1.175
r75 (  19 34 ) resistor r=3.57586 //w=0.17 //l=0.125 //layer=li \
 //thickness=0.1 //x=74.12 //y=0.805 //x2=74.12 //y2=0.68
r76 (  19 34 ) resistor r=18.139 //w=0.187 //l=0.265 //layer=li \
 //thickness=0.1 //x=74.12 //y=0.805 //x2=74.12 //y2=1.07
r77 (  16 34 ) resistor r=3.57586 //w=0.17 //l=0.103078 //layer=li \
 //thickness=0.1 //x=73.235 //y=0.72 //x2=73.15 //y2=0.68
r78 (  16 34 ) resistor r=27.3797 //w=0.187 //l=0.4 //layer=li //thickness=0.1 \
 //x=73.235 //y=0.72 //x2=73.635 //y2=0.72
r79 (  15 34 ) resistor r=3.57586 //w=0.17 //l=0.103078 //layer=li \
 //thickness=0.1 //x=74.035 //y=0.72 //x2=74.12 //y2=0.68
r80 (  15 34 ) resistor r=27.3797 //w=0.187 //l=0.4 //layer=li //thickness=0.1 \
 //x=74.035 //y=0.72 //x2=73.635 //y2=0.72
r81 (  11 30 ) resistor r=5.4201 //w=0.17 //l=0.085 //layer=li //thickness=0.1 \
 //x=73.15 //y=1.26 //x2=73.15 //y2=1.175
r82 (  11 34 ) resistor r=10.2674 //w=0.187 //l=0.15 //layer=li \
 //thickness=0.1 //x=73.15 //y=1.26 //x2=73.15 //y2=1.41
r83 (  8 30 ) resistor r=5.4201 //w=0.17 //l=0.085 //layer=li //thickness=0.1 \
 //x=73.15 //y=1.09 //x2=73.15 //y2=1.175
r84 (  8 34 ) resistor r=1.36898 //w=0.187 //l=0.02 //layer=li //thickness=0.1 \
 //x=73.15 //y=1.09 //x2=73.15 //y2=1.07
r85 (  7 34 ) resistor r=3.57586 //w=0.17 //l=0.125 //layer=li //thickness=0.1 \
 //x=73.15 //y=0.805 //x2=73.15 //y2=0.68
r86 (  7 34 ) resistor r=18.139 //w=0.187 //l=0.265 //layer=li //thickness=0.1 \
 //x=73.15 //y=0.805 //x2=73.15 //y2=1.07
r87 (  6 33 ) resistor r=0.751729 //w=0.17 //l=0.085 //layer=li \
 //thickness=0.1 //x=72.185 //y=1.175 //x2=72.1 //y2=1.175
r88 (  5 30 ) resistor r=1.40859 //w=0.34 //l=0.085 //layer=li //thickness=0.1 \
 //x=73.065 //y=1.175 //x2=73.15 //y2=1.175
r89 (  5 6 ) resistor r=60.2353 //w=0.187 //l=0.88 //layer=li //thickness=0.1 \
 //x=73.065 //y=1.175 //x2=72.185 //y2=1.175
ends PM_TMRDFFRNQX1\%noxref_31

subckt PM_TMRDFFRNQX1\%noxref_32 ( 1 3 4 5 7 9 19 25 27 30 40 49 71 72 73 74 \
 75 )
c161 ( 75 0 ) capacitor c=0.0354016f //x=83.915 //y=5.205
c162 ( 74 0 ) capacitor c=0.0241107f //x=83.035 //y=5.205
c163 ( 72 0 ) capacitor c=0.00544792f //x=80.155 //y=5.205
c164 ( 71 0 ) capacitor c=0.00516996f //x=79.275 //y=5.205
c165 ( 49 0 ) capacitor c=0.0508454f //x=82.3 //y=5.39
c166 ( 40 0 ) capacitor c=0.0362911f //x=80.3 //y=5.39
c167 ( 30 0 ) capacitor c=0.0293961f //x=79.42 //y=5.56
c168 ( 27 0 ) capacitor c=0.00984489f //x=84.06 //y=6.92
c169 ( 25 0 ) capacitor c=0.0059844f //x=83.177 //y=7.09
c170 ( 19 0 ) capacitor c=0.00975753f //x=82.3 //y=6.92
c171 ( 9 0 ) capacitor c=0.014892f //x=79.422 //y=5.39
c172 ( 7 0 ) capacitor c=0.00787288f //x=83.945 //y=7.09
c173 ( 5 0 ) capacitor c=0.00659042f //x=83.06 //y=7.09
c174 ( 4 0 ) capacitor c=0.00558326f //x=80.415 //y=5.39
c175 ( 3 0 ) capacitor c=0.0636102f //x=82.185 //y=5.39
c176 ( 1 0 ) capacitor c=0.0145996f //x=80.185 //y=5.39
r177 (  49 73 ) resistor r=58.1818 //w=0.187 //l=0.85 //layer=li \
 //thickness=0.1 //x=82.3 //y=5.39 //x2=82.3 //y2=6.24
r178 (  40 72 ) resistor r=58.1818 //w=0.187 //l=0.85 //layer=li \
 //thickness=0.1 //x=80.3 //y=5.39 //x2=80.3 //y2=6.24
r179 (  30 71 ) resistor r=23.2727 //w=0.187 //l=0.34 //layer=li \
 //thickness=0.1 //x=79.42 //y=5.56 //x2=79.42 //y2=5.9
r180 (  27 75 ) resistor r=9.3 //w=0.17 //l=0.17 //layer=mcon //count=1 \
 //x=84.06 //y=6.92 //x2=84.06 //y2=6.92
r181 (  27 28 ) resistor r=0.0988372 //w=0.215 //l=0.17 //layer=m1 \
 //thickness=0.36 //x=84.062 //y=6.92 //x2=84.062 //y2=7.09
r182 (  24 74 ) resistor r=9.3 //w=0.17 //l=0.17 //layer=mcon //count=1 \
 //x=83.18 //y=6.92 //x2=83.18 //y2=6.92
r183 (  24 25 ) resistor r=0.0940266 //w=0.226 //l=0.17 //layer=m1 \
 //thickness=0.36 //x=83.177 //y=6.92 //x2=83.177 //y2=7.09
r184 (  22 49 ) resistor r=9.3 //w=0.17 //l=0.17 //layer=mcon //count=1 \
 //x=82.3 //y=5.39 //x2=82.3 //y2=5.39
r185 (  19 73 ) resistor r=9.3 //w=0.17 //l=0.17 //layer=mcon //count=1 \
 //x=82.3 //y=6.92 //x2=82.3 //y2=6.92
r186 (  19 20 ) resistor r=0.0979263 //w=0.217 //l=0.17 //layer=m1 \
 //thickness=0.36 //x=82.302 //y=6.92 //x2=82.302 //y2=7.09
r187 (  15 40 ) resistor r=9.3 //w=0.17 //l=0.17 //layer=mcon //count=1 \
 //x=80.3 //y=5.39 //x2=80.3 //y2=5.39
r188 (  11 30 ) resistor r=9.3 //w=0.17 //l=0.17 //layer=mcon //count=1 \
 //x=79.42 //y=5.56 //x2=79.42 //y2=5.56
r189 (  9 11 ) resistor r=0.0944444 //w=0.225 //l=0.17 //layer=m1 \
 //thickness=0.36 //x=79.422 //y=5.39 //x2=79.422 //y2=5.56
r190 (  8 25 ) resistor r=0.0246599 //w=0.226 //l=0.118 //layer=m1 \
 //thickness=0.36 //x=83.295 //y=7.09 //x2=83.177 //y2=7.09
r191 (  7 28 ) resistor r=0.0216707 //w=0.215 //l=0.117 //layer=m1 \
 //thickness=0.36 //x=83.945 //y=7.09 //x2=84.062 //y2=7.09
r192 (  7 8 ) resistor r=0.620229 //w=0.131 //l=0.65 //layer=m1 \
 //thickness=0.36 //x=83.945 //y=7.09 //x2=83.295 //y2=7.09
r193 (  6 20 ) resistor r=0.0222262 //w=0.217 //l=0.118 //layer=m1 \
 //thickness=0.36 //x=82.42 //y=7.09 //x2=82.302 //y2=7.09
r194 (  5 25 ) resistor r=0.0246599 //w=0.226 //l=0.117 //layer=m1 \
 //thickness=0.36 //x=83.06 //y=7.09 //x2=83.177 //y2=7.09
r195 (  5 6 ) resistor r=0.610687 //w=0.131 //l=0.64 //layer=m1 \
 //thickness=0.36 //x=83.06 //y=7.09 //x2=82.42 //y2=7.09
r196 (  4 15 ) resistor r=0.0880901 //w=0.191 //l=0.115 //layer=m1 \
 //thickness=0.36 //x=80.415 //y=5.39 //x2=80.3 //y2=5.39
r197 (  3 22 ) resistor r=0.0717383 //w=0.224 //l=0.115 //layer=m1 \
 //thickness=0.36 //x=82.185 //y=5.39 //x2=82.3 //y2=5.39
r198 (  3 4 ) resistor r=1.68893 //w=0.131 //l=1.77 //layer=m1 \
 //thickness=0.36 //x=82.185 //y=5.39 //x2=80.415 //y2=5.39
r199 (  2 9 ) resistor r=0.0243946 //w=0.225 //l=0.123 //layer=m1 \
 //thickness=0.36 //x=79.545 //y=5.39 //x2=79.422 //y2=5.39
r200 (  1 15 ) resistor r=0.0880901 //w=0.191 //l=0.115 //layer=m1 \
 //thickness=0.36 //x=80.185 //y=5.39 //x2=80.3 //y2=5.39
r201 (  1 2 ) resistor r=0.610687 //w=0.131 //l=0.64 //layer=m1 \
 //thickness=0.36 //x=80.185 //y=5.39 //x2=79.545 //y2=5.39
ends PM_TMRDFFRNQX1\%noxref_32

subckt PM_TMRDFFRNQX1\%noxref_33 ( 1 3 4 5 7 9 13 15 21 23 26 38 60 61 62 63 )
c132 ( 63 0 ) capacitor c=0.0343252f //x=87.255 //y=5.205
c133 ( 62 0 ) capacitor c=0.0239063f //x=86.375 //y=5.205
c134 ( 38 0 ) capacitor c=0.0496553f //x=85.64 //y=5.39
c135 ( 26 0 ) capacitor c=0.0229521f //x=82.74 //y=5.56
c136 ( 23 0 ) capacitor c=0.0155899f //x=87.4 //y=6.92
c137 ( 21 0 ) capacitor c=0.00566376f //x=86.52 //y=7.09
c138 ( 15 0 ) capacitor c=0.00945187f //x=85.64 //y=6.92
c139 ( 13 0 ) capacitor c=0.0163615f //x=83.62 //y=5.39
c140 ( 9 0 ) capacitor c=0.0150333f //x=82.74 //y=5.39
c141 ( 7 0 ) capacitor c=0.0068287f //x=87.27 //y=7.09
c142 ( 5 0 ) capacitor c=0.00878908f //x=86.405 //y=7.09
c143 ( 4 0 ) capacitor c=0.00826388f //x=83.735 //y=5.39
c144 ( 3 0 ) capacitor c=0.0560142f //x=85.525 //y=5.39
c145 ( 1 0 ) capacitor c=0.0183136f //x=83.505 //y=5.39
r146 (  38 61 ) resistor r=58.1818 //w=0.187 //l=0.85 //layer=li \
 //thickness=0.1 //x=85.64 //y=5.39 //x2=85.64 //y2=6.24
r147 (  26 60 ) resistor r=23.2727 //w=0.187 //l=0.34 //layer=li \
 //thickness=0.1 //x=82.74 //y=5.56 //x2=82.74 //y2=5.9
r148 (  23 63 ) resistor r=9.3 //w=0.17 //l=0.17 //layer=mcon //count=1 \
 //x=87.4 //y=6.92 //x2=87.4 //y2=6.92
r149 (  23 24 ) resistor r=0.0923913 //w=0.23 //l=0.17 //layer=m1 \
 //thickness=0.36 //x=87.395 //y=6.92 //x2=87.395 //y2=7.09
r150 (  20 62 ) resistor r=9.3 //w=0.17 //l=0.17 //layer=mcon //count=1 \
 //x=86.52 //y=6.92 //x2=86.52 //y2=6.92
r151 (  20 21 ) resistor r=0.0957207 //w=0.222 //l=0.17 //layer=m1 \
 //thickness=0.36 //x=86.52 //y=6.92 //x2=86.52 //y2=7.09
r152 (  18 38 ) resistor r=9.3 //w=0.17 //l=0.17 //layer=mcon //count=1 \
 //x=85.64 //y=5.39 //x2=85.64 //y2=5.39
r153 (  15 61 ) resistor r=9.3 //w=0.17 //l=0.17 //layer=mcon //count=1 \
 //x=85.64 //y=6.92 //x2=85.64 //y2=6.92
r154 (  15 16 ) resistor r=0.100236 //w=0.212 //l=0.17 //layer=m1 \
 //thickness=0.36 //x=85.64 //y=6.92 //x2=85.64 //y2=7.09
r155 (  11 26 ) resistor r=9.3 //w=0.17 //l=0.17 //layer=mcon //count=1 \
 //x=82.74 //y=5.56 //x2=82.74 //y2=5.56
r156 (  9 11 ) resistor r=0.100236 //w=0.212 //l=0.17 //layer=m1 \
 //thickness=0.36 //x=82.74 //y=5.39 //x2=82.74 //y2=5.56
r157 (  8 21 ) resistor r=0.0235912 //w=0.222 //l=0.115 //layer=m1 \
 //thickness=0.36 //x=86.635 //y=7.09 //x2=86.52 //y2=7.09
r158 (  7 24 ) resistor r=0.0257089 //w=0.23 //l=0.125 //layer=m1 \
 //thickness=0.36 //x=87.27 //y=7.09 //x2=87.395 //y2=7.09
r159 (  7 8 ) resistor r=0.605916 //w=0.131 //l=0.635 //layer=m1 \
 //thickness=0.36 //x=87.27 //y=7.09 //x2=86.635 //y2=7.09
r160 (  6 16 ) resistor r=0.0208269 //w=0.212 //l=0.115 //layer=m1 \
 //thickness=0.36 //x=85.755 //y=7.09 //x2=85.64 //y2=7.09
r161 (  5 21 ) resistor r=0.0235912 //w=0.222 //l=0.115 //layer=m1 \
 //thickness=0.36 //x=86.405 //y=7.09 //x2=86.52 //y2=7.09
r162 (  5 6 ) resistor r=0.620229 //w=0.131 //l=0.65 //layer=m1 \
 //thickness=0.36 //x=86.405 //y=7.09 //x2=85.755 //y2=7.09
r163 (  4 13 ) resistor r=0.0880901 //w=0.191 //l=0.115 //layer=m1 \
 //thickness=0.36 //x=83.735 //y=5.39 //x2=83.62 //y2=5.39
r164 (  3 18 ) resistor r=0.0717383 //w=0.224 //l=0.115 //layer=m1 \
 //thickness=0.36 //x=85.525 //y=5.39 //x2=85.64 //y2=5.39
r165 (  3 4 ) resistor r=1.70802 //w=0.131 //l=1.79 //layer=m1 \
 //thickness=0.36 //x=85.525 //y=5.39 //x2=83.735 //y2=5.39
r166 (  2 9 ) resistor r=0.0208269 //w=0.212 //l=0.115 //layer=m1 \
 //thickness=0.36 //x=82.855 //y=5.39 //x2=82.74 //y2=5.39
r167 (  1 13 ) resistor r=0.0880901 //w=0.191 //l=0.115 //layer=m1 \
 //thickness=0.36 //x=83.505 //y=5.39 //x2=83.62 //y2=5.39
r168 (  1 2 ) resistor r=0.620229 //w=0.131 //l=0.65 //layer=m1 \
 //thickness=0.36 //x=83.505 //y=5.39 //x2=82.855 //y2=5.39
ends PM_TMRDFFRNQX1\%noxref_33

subckt PM_TMRDFFRNQX1\%GND ( 1 2 6 7 18 19 31 38 39 48 49 59 66 67 78 79 91 \
 100 101 112 113 126 133 134 143 144 154 161 162 173 174 186 195 196 204 211 \
 220 223 227 231 232 236 241 246 247 252 256 260 261 265 269 273 274 278 283 \
 288 289 294 298 302 303 310 316 319 333 350 365 382 399 412 429 446 461 478 \
 495 510 527 544 557 574 591 606 621 629 647 652 656 668 669 670 671 672 673 \
 674 675 676 677 678 679 680 681 682 683 684 685 686 687 688 695 702 703 704 \
 705 706 707 708 709 710 711 712 713 714 715 716 717 718 719 720 721 722 )
c1615 ( 722 0 ) capacitor c=0.0654471f //x=88.675 //y=0.55
c1616 ( 721 0 ) capacitor c=0.00828027f //x=85.84 //y=1.045
c1617 ( 720 0 ) capacitor c=0.0083251f //x=79.18 //y=1.045
c1618 ( 719 0 ) capacitor c=0.00843555f //x=75.85 //y=1.045
c1619 ( 718 0 ) capacitor c=0.00840423f //x=70.935 //y=1.055
c1620 ( 717 0 ) capacitor c=0.00840423f //x=66.125 //y=1.055
c1621 ( 716 0 ) capacitor c=0.00843555f //x=62.9 //y=1.045
c1622 ( 715 0 ) capacitor c=0.00840423f //x=57.985 //y=1.055
c1623 ( 714 0 ) capacitor c=0.00840423f //x=53.175 //y=1.055
c1624 ( 713 0 ) capacitor c=0.00843555f //x=49.95 //y=1.045
c1625 ( 712 0 ) capacitor c=0.00840423f //x=45.035 //y=1.055
c1626 ( 711 0 ) capacitor c=0.00840423f //x=40.225 //y=1.055
c1627 ( 710 0 ) capacitor c=0.00843555f //x=37 //y=1.045
c1628 ( 709 0 ) capacitor c=0.00840423f //x=32.085 //y=1.055
c1629 ( 708 0 ) capacitor c=0.00840423f //x=27.275 //y=1.055
c1630 ( 707 0 ) capacitor c=0.00843555f //x=24.05 //y=1.045
c1631 ( 706 0 ) capacitor c=0.00840423f //x=19.135 //y=1.055
c1632 ( 705 0 ) capacitor c=0.00840423f //x=14.325 //y=1.055
c1633 ( 704 0 ) capacitor c=0.00843555f //x=11.1 //y=1.045
c1634 ( 703 0 ) capacitor c=0.00840423f //x=6.185 //y=1.055
c1635 ( 702 0 ) capacitor c=0.00840423f //x=1.375 //y=1.055
c1636 ( 695 0 ) capacitor c=0.260496f //x=89.78 //y=0.175
c1637 ( 688 0 ) capacitor c=0.11347f //x=88.18 //y=0.175
c1638 ( 687 0 ) capacitor c=0.110371f //x=84.85 //y=0.175
c1639 ( 686 0 ) capacitor c=0.123957f //x=81.52 //y=0.175
c1640 ( 685 0 ) capacitor c=0.114503f //x=78.19 //y=0.175
c1641 ( 684 0 ) capacitor c=0.118684f //x=74.86 //y=0.175
c1642 ( 683 0 ) capacitor c=0.114177f //x=70.05 //y=0.175
c1643 ( 682 0 ) capacitor c=0.112855f //x=65.24 //y=0.175
c1644 ( 681 0 ) capacitor c=0.11997f //x=61.91 //y=0.175
c1645 ( 680 0 ) capacitor c=0.114256f //x=57.1 //y=0.175
c1646 ( 679 0 ) capacitor c=0.112554f //x=52.29 //y=0.175
c1647 ( 678 0 ) capacitor c=0.118197f //x=48.96 //y=0.175
c1648 ( 677 0 ) capacitor c=0.114306f //x=44.15 //y=0.175
c1649 ( 676 0 ) capacitor c=0.112554f //x=39.34 //y=0.175
c1650 ( 675 0 ) capacitor c=0.118478f //x=36.01 //y=0.175
c1651 ( 674 0 ) capacitor c=0.114256f //x=31.2 //y=0.175
c1652 ( 673 0 ) capacitor c=0.112554f //x=26.39 //y=0.175
c1653 ( 672 0 ) capacitor c=0.118197f //x=23.06 //y=0.175
c1654 ( 671 0 ) capacitor c=0.1147f //x=18.25 //y=0.175
c1655 ( 670 0 ) capacitor c=0.112709f //x=13.44 //y=0.175
c1656 ( 669 0 ) capacitor c=0.118632f //x=10.11 //y=0.175
c1657 ( 668 0 ) capacitor c=0.114221f //x=5.3 //y=0.175
c1658 ( 659 0 ) capacitor c=0.00585268f //x=89.78 //y=0.63
c1659 ( 656 0 ) capacitor c=0.00625302f //x=89.695 //y=0.715
c1660 ( 655 0 ) capacitor c=0.00479851f //x=89.29 //y=0.63
c1661 ( 652 0 ) capacitor c=0.00645299f //x=89.205 //y=0.715
c1662 ( 647 0 ) capacitor c=0.00586769f //x=88.81 //y=0.63
c1663 ( 644 0 ) capacitor c=0.0191899f //x=88.725 //y=0.175
c1664 ( 629 0 ) capacitor c=0.122563f //x=88.01 //y=0.175
c1665 ( 621 0 ) capacitor c=0.118825f //x=84.68 //y=0.175
c1666 ( 606 0 ) capacitor c=0.121639f //x=81.35 //y=0.175
c1667 ( 591 0 ) capacitor c=0.126434f //x=78.02 //y=0.175
c1668 ( 574 0 ) capacitor c=0.178514f //x=74.69 //y=0.175
c1669 ( 557 0 ) capacitor c=0.176416f //x=69.88 //y=0.175
c1670 ( 544 0 ) capacitor c=0.118875f //x=65.07 //y=0.175
c1671 ( 527 0 ) capacitor c=0.176416f //x=61.74 //y=0.175
c1672 ( 510 0 ) capacitor c=0.176415f //x=56.93 //y=0.175
c1673 ( 495 0 ) capacitor c=0.11901f //x=52.12 //y=0.175
c1674 ( 478 0 ) capacitor c=0.176412f //x=48.79 //y=0.175
c1675 ( 461 0 ) capacitor c=0.176416f //x=43.98 //y=0.175
c1676 ( 446 0 ) capacitor c=0.118875f //x=39.17 //y=0.175
c1677 ( 429 0 ) capacitor c=0.176416f //x=35.84 //y=0.175
c1678 ( 412 0 ) capacitor c=0.176415f //x=31.03 //y=0.175
c1679 ( 399 0 ) capacitor c=0.119029f //x=26.22 //y=0.175
c1680 ( 382 0 ) capacitor c=0.176421f //x=22.89 //y=0.175
c1681 ( 365 0 ) capacitor c=0.176416f //x=18.08 //y=0.175
c1682 ( 350 0 ) capacitor c=0.118875f //x=13.27 //y=0.175
c1683 ( 333 0 ) capacitor c=0.179332f //x=9.94 //y=0.175
c1684 ( 319 0 ) capacitor c=0.197064f //x=1.23 //y=0.18
c1685 ( 316 0 ) capacitor c=0.181456f //x=5.13 //y=0.175
c1686 ( 311 0 ) capacitor c=0.00509083f //x=86.03 //y=0.175
c1687 ( 310 0 ) capacitor c=0.0256262f //x=82.63 //y=0.18
c1688 ( 306 0 ) capacitor c=0.00509083f //x=79.37 //y=0.175
c1689 ( 305 0 ) capacitor c=0.00509083f //x=76.04 //y=0.175
c1690 ( 303 0 ) capacitor c=0.0235363f //x=76.037 //y=1.005
c1691 ( 302 0 ) capacitor c=0.0135545f //x=76.04 //y=1.135
c1692 ( 300 0 ) capacitor c=0.00509414f //x=71.125 //y=0.175
c1693 ( 298 0 ) capacitor c=0.0140345f //x=71.125 //y=1.145
c1694 ( 296 0 ) capacitor c=0.00509414f //x=66.315 //y=0.175
c1695 ( 294 0 ) capacitor c=0.0131639f //x=66.315 //y=1.145
c1696 ( 292 0 ) capacitor c=0.00509083f //x=63.02 //y=0.18
c1697 ( 289 0 ) capacitor c=0.0234055f //x=63.087 //y=1.005
c1698 ( 288 0 ) capacitor c=0.01353f //x=63.09 //y=1.135
c1699 ( 286 0 ) capacitor c=0.00509414f //x=58.21 //y=0.18
c1700 ( 283 0 ) capacitor c=0.014142f //x=58.175 //y=1.145
c1701 ( 281 0 ) capacitor c=0.00509414f //x=53.4 //y=0.18
c1702 ( 278 0 ) capacitor c=0.0131758f //x=53.365 //y=1.145
c1703 ( 276 0 ) capacitor c=0.00509083f //x=50.14 //y=0.175
c1704 ( 274 0 ) capacitor c=0.0234055f //x=50.137 //y=1.005
c1705 ( 273 0 ) capacitor c=0.0135212f //x=50.14 //y=1.135
c1706 ( 271 0 ) capacitor c=0.00509414f //x=45.225 //y=0.175
c1707 ( 269 0 ) capacitor c=0.0140335f //x=45.225 //y=1.145
c1708 ( 267 0 ) capacitor c=0.00509414f //x=40.415 //y=0.175
c1709 ( 265 0 ) capacitor c=0.0131639f //x=40.415 //y=1.145
c1710 ( 263 0 ) capacitor c=0.00509083f //x=37.19 //y=0.175
c1711 ( 261 0 ) capacitor c=0.0234055f //x=37.187 //y=1.005
c1712 ( 260 0 ) capacitor c=0.01353f //x=37.19 //y=1.135
c1713 ( 258 0 ) capacitor c=0.00509414f //x=32.275 //y=0.175
c1714 ( 256 0 ) capacitor c=0.014142f //x=32.275 //y=1.145
c1715 ( 254 0 ) capacitor c=0.00509414f //x=27.465 //y=0.175
c1716 ( 252 0 ) capacitor c=0.0131758f //x=27.465 //y=1.145
c1717 ( 250 0 ) capacitor c=0.00509083f //x=24.17 //y=0.18
c1718 ( 247 0 ) capacitor c=0.0234055f //x=24.237 //y=1.005
c1719 ( 246 0 ) capacitor c=0.0136246f //x=24.24 //y=1.135
c1720 ( 244 0 ) capacitor c=0.00509414f //x=19.36 //y=0.18
c1721 ( 241 0 ) capacitor c=0.0140335f //x=19.325 //y=1.145
c1722 ( 239 0 ) capacitor c=0.00509414f //x=14.55 //y=0.18
c1723 ( 236 0 ) capacitor c=0.013104f //x=14.515 //y=1.145
c1724 ( 234 0 ) capacitor c=0.00509083f //x=11.29 //y=0.175
c1725 ( 232 0 ) capacitor c=0.0234055f //x=11.287 //y=1.005
c1726 ( 231 0 ) capacitor c=0.01353f //x=11.29 //y=1.135
c1727 ( 229 0 ) capacitor c=0.00509414f //x=6.375 //y=0.175
c1728 ( 227 0 ) capacitor c=0.014205f //x=6.375 //y=1.145
c1729 ( 225 0 ) capacitor c=0.00509414f //x=1.565 //y=0.175
c1730 ( 223 0 ) capacitor c=0.0170404f //x=1.565 //y=1.145
c1731 ( 220 0 ) capacitor c=0.179237f //x=89.66 //y=0.18
c1732 ( 211 0 ) capacitor c=0.0414658f //x=86.03 //y=1.02
c1733 ( 204 0 ) capacitor c=0.107614f //x=85.945 //y=0.175
c1734 ( 196 0 ) capacitor c=0.112566f //x=82.615 //y=0.175
c1735 ( 195 0 ) capacitor c=0.0359644f //x=79.37 //y=1.015
c1736 ( 186 0 ) capacitor c=0.10994f //x=79.285 //y=0.175
c1737 ( 174 0 ) capacitor c=0.154898f //x=75.955 //y=0.175
c1738 ( 173 0 ) capacitor c=0.0302305f //x=71.125 //y=1.015
c1739 ( 162 0 ) capacitor c=0.150267f //x=71.04 //y=0.175
c1740 ( 161 0 ) capacitor c=0.0253397f //x=66.315 //y=1.015
c1741 ( 154 0 ) capacitor c=0.105424f //x=66.23 //y=0.175
c1742 ( 144 0 ) capacitor c=0.15436f //x=63.005 //y=0.175
c1743 ( 143 0 ) capacitor c=0.0302305f //x=58.175 //y=1.015
c1744 ( 134 0 ) capacitor c=0.149273f //x=58.09 //y=0.175
c1745 ( 133 0 ) capacitor c=0.0253397f //x=53.365 //y=1.015
c1746 ( 126 0 ) capacitor c=0.106799f //x=53.28 //y=0.175
c1747 ( 113 0 ) capacitor c=0.15464f //x=50.055 //y=0.175
c1748 ( 112 0 ) capacitor c=0.0302305f //x=45.225 //y=1.015
c1749 ( 101 0 ) capacitor c=0.150267f //x=45.14 //y=0.175
c1750 ( 100 0 ) capacitor c=0.0253397f //x=40.415 //y=1.015
c1751 ( 91 0 ) capacitor c=0.105424f //x=40.33 //y=0.175
c1752 ( 79 0 ) capacitor c=0.15436f //x=37.105 //y=0.175
c1753 ( 78 0 ) capacitor c=0.0302305f //x=32.275 //y=1.015
c1754 ( 67 0 ) capacitor c=0.149273f //x=32.19 //y=0.175
c1755 ( 66 0 ) capacitor c=0.0253397f //x=27.465 //y=1.015
c1756 ( 59 0 ) capacitor c=0.106786f //x=27.38 //y=0.175
c1757 ( 49 0 ) capacitor c=0.154817f //x=24.155 //y=0.175
c1758 ( 48 0 ) capacitor c=0.0302305f //x=19.325 //y=1.015
c1759 ( 39 0 ) capacitor c=0.150267f //x=19.24 //y=0.175
c1760 ( 38 0 ) capacitor c=0.0253397f //x=14.515 //y=1.015
c1761 ( 31 0 ) capacitor c=0.105424f //x=14.43 //y=0.175
c1762 ( 19 0 ) capacitor c=0.154392f //x=11.205 //y=0.175
c1763 ( 18 0 ) capacitor c=0.0302305f //x=6.375 //y=1.015
c1764 ( 7 0 ) capacitor c=0.149367f //x=6.29 //y=0.175
c1765 ( 6 0 ) capacitor c=0.0302305f //x=1.565 //y=1.015
c1766 ( 2 0 ) capacitor c=0.0710427f //x=1.48 //y=0.175
r1767 (  694 695 ) resistor r=4.18529 //w=0.367 //l=0.12 //layer=li \
 //thickness=0.1 //x=89.66 //y=0.175 //x2=89.78 //y2=0.175
r1768 (  692 694 ) resistor r=12.9046 //w=0.367 //l=0.37 //layer=li \
 //thickness=0.1 //x=89.29 //y=0.175 //x2=89.66 //y2=0.175
r1769 (  691 692 ) resistor r=12.9046 //w=0.367 //l=0.37 //layer=li \
 //thickness=0.1 //x=88.92 //y=0.175 //x2=89.29 //y2=0.175
r1770 (  689 691 ) resistor r=3.83651 //w=0.367 //l=0.11 //layer=li \
 //thickness=0.1 //x=88.81 //y=0.175 //x2=88.92 //y2=0.175
r1771 (  660 722 ) resistor r=5.4201 //w=0.17 //l=0.085 //layer=li \
 //thickness=0.1 //x=89.78 //y=0.8 //x2=89.78 //y2=0.715
r1772 (  660 722 ) resistor r=41.4118 //w=0.187 //l=0.605 //layer=li \
 //thickness=0.1 //x=89.78 //y=0.8 //x2=89.78 //y2=1.405
r1773 (  659 722 ) resistor r=5.4201 //w=0.17 //l=0.085 //layer=li \
 //thickness=0.1 //x=89.78 //y=0.63 //x2=89.78 //y2=0.715
r1774 (  658 695 ) resistor r=5.21862 //w=0.35 //l=0.175 //layer=li \
 //thickness=0.1 //x=89.78 //y=0.35 //x2=89.78 //y2=0.175
r1775 (  658 659 ) resistor r=19.1658 //w=0.187 //l=0.28 //layer=li \
 //thickness=0.1 //x=89.78 //y=0.35 //x2=89.78 //y2=0.63
r1776 (  657 722 ) resistor r=5.4201 //w=0.17 //l=0.085 //layer=li \
 //thickness=0.1 //x=89.375 //y=0.715 //x2=89.29 //y2=0.715
r1777 (  656 722 ) resistor r=1.40859 //w=0.34 //l=0.085 //layer=li \
 //thickness=0.1 //x=89.695 //y=0.715 //x2=89.78 //y2=0.715
r1778 (  656 657 ) resistor r=21.9037 //w=0.187 //l=0.32 //layer=li \
 //thickness=0.1 //x=89.695 //y=0.715 //x2=89.375 //y2=0.715
r1779 (  655 722 ) resistor r=1.40859 //w=0.34 //l=0.085 //layer=li \
 //thickness=0.1 //x=89.29 //y=0.63 //x2=89.29 //y2=0.715
r1780 (  654 692 ) resistor r=5.21862 //w=0.35 //l=0.175 //layer=li \
 //thickness=0.1 //x=89.29 //y=0.35 //x2=89.29 //y2=0.175
r1781 (  654 655 ) resistor r=19.1658 //w=0.187 //l=0.28 //layer=li \
 //thickness=0.1 //x=89.29 //y=0.35 //x2=89.29 //y2=0.63
r1782 (  653 722 ) resistor r=1.40859 //w=0.34 //l=0.085 //layer=li \
 //thickness=0.1 //x=88.895 //y=0.715 //x2=88.81 //y2=0.715
r1783 (  652 722 ) resistor r=5.4201 //w=0.17 //l=0.085 //layer=li \
 //thickness=0.1 //x=89.205 //y=0.715 //x2=89.29 //y2=0.715
r1784 (  652 653 ) resistor r=21.2193 //w=0.187 //l=0.31 //layer=li \
 //thickness=0.1 //x=89.205 //y=0.715 //x2=88.895 //y2=0.715
r1785 (  648 722 ) resistor r=5.4201 //w=0.17 //l=0.085 //layer=li \
 //thickness=0.1 //x=88.81 //y=0.8 //x2=88.81 //y2=0.715
r1786 (  648 722 ) resistor r=41.4118 //w=0.187 //l=0.605 //layer=li \
 //thickness=0.1 //x=88.81 //y=0.8 //x2=88.81 //y2=1.405
r1787 (  647 722 ) resistor r=5.4201 //w=0.17 //l=0.085 //layer=li \
 //thickness=0.1 //x=88.81 //y=0.63 //x2=88.81 //y2=0.715
r1788 (  646 689 ) resistor r=5.21862 //w=0.35 //l=0.175 //layer=li \
 //thickness=0.1 //x=88.81 //y=0.35 //x2=88.81 //y2=0.175
r1789 (  646 647 ) resistor r=19.1658 //w=0.187 //l=0.28 //layer=li \
 //thickness=0.1 //x=88.81 //y=0.35 //x2=88.81 //y2=0.63
r1790 (  645 688 ) resistor r=5.29055 //w=0.35 //l=0.17 //layer=li \
 //thickness=0.1 //x=88.35 //y=0.175 //x2=88.18 //y2=0.175
r1791 (  644 689 ) resistor r=2.96458 //w=0.367 //l=0.085 //layer=li \
 //thickness=0.1 //x=88.725 //y=0.175 //x2=88.81 //y2=0.175
r1792 (  644 645 ) resistor r=13.079 //w=0.367 //l=0.375 //layer=li \
 //thickness=0.1 //x=88.725 //y=0.175 //x2=88.35 //y2=0.175
r1793 (  634 636 ) resistor r=38.7139 //w=0.367 //l=1.11 //layer=li \
 //thickness=0.1 //x=86.33 //y=0.175 //x2=87.44 //y2=0.175
r1794 (  632 634 ) resistor r=38.7139 //w=0.367 //l=1.11 //layer=li \
 //thickness=0.1 //x=85.22 //y=0.175 //x2=86.33 //y2=0.175
r1795 (  630 687 ) resistor r=5.29055 //w=0.35 //l=0.17 //layer=li \
 //thickness=0.1 //x=85.02 //y=0.175 //x2=84.85 //y2=0.175
r1796 (  630 632 ) resistor r=6.97548 //w=0.367 //l=0.2 //layer=li \
 //thickness=0.1 //x=85.02 //y=0.175 //x2=85.22 //y2=0.175
r1797 (  629 688 ) resistor r=5.29055 //w=0.35 //l=0.17 //layer=li \
 //thickness=0.1 //x=88.01 //y=0.175 //x2=88.18 //y2=0.175
r1798 (  629 636 ) resistor r=19.8801 //w=0.367 //l=0.57 //layer=li \
 //thickness=0.1 //x=88.01 //y=0.175 //x2=87.44 //y2=0.175
r1799 (  624 626 ) resistor r=38.7139 //w=0.367 //l=1.11 //layer=li \
 //thickness=0.1 //x=82.63 //y=0.175 //x2=83.74 //y2=0.175
r1800 (  622 686 ) resistor r=5.29055 //w=0.35 //l=0.17 //layer=li \
 //thickness=0.1 //x=81.69 //y=0.175 //x2=81.52 //y2=0.175
r1801 (  622 624 ) resistor r=32.7847 //w=0.367 //l=0.94 //layer=li \
 //thickness=0.1 //x=81.69 //y=0.175 //x2=82.63 //y2=0.175
r1802 (  621 687 ) resistor r=5.29055 //w=0.35 //l=0.17 //layer=li \
 //thickness=0.1 //x=84.68 //y=0.175 //x2=84.85 //y2=0.175
r1803 (  621 626 ) resistor r=32.7847 //w=0.367 //l=0.94 //layer=li \
 //thickness=0.1 //x=84.68 //y=0.175 //x2=83.74 //y2=0.175
r1804 (  611 613 ) resistor r=38.7139 //w=0.367 //l=1.11 //layer=li \
 //thickness=0.1 //x=80.04 //y=0.175 //x2=81.15 //y2=0.175
r1805 (  609 611 ) resistor r=38.7139 //w=0.367 //l=1.11 //layer=li \
 //thickness=0.1 //x=78.93 //y=0.175 //x2=80.04 //y2=0.175
r1806 (  607 685 ) resistor r=5.29055 //w=0.35 //l=0.17 //layer=li \
 //thickness=0.1 //x=78.36 //y=0.175 //x2=78.19 //y2=0.175
r1807 (  607 609 ) resistor r=19.8801 //w=0.367 //l=0.57 //layer=li \
 //thickness=0.1 //x=78.36 //y=0.175 //x2=78.93 //y2=0.175
r1808 (  606 686 ) resistor r=5.29055 //w=0.35 //l=0.17 //layer=li \
 //thickness=0.1 //x=81.35 //y=0.175 //x2=81.52 //y2=0.175
r1809 (  606 613 ) resistor r=6.97548 //w=0.367 //l=0.2 //layer=li \
 //thickness=0.1 //x=81.35 //y=0.175 //x2=81.15 //y2=0.175
r1810 (  596 598 ) resistor r=38.7139 //w=0.367 //l=1.11 //layer=li \
 //thickness=0.1 //x=76.34 //y=0.175 //x2=77.45 //y2=0.175
r1811 (  594 596 ) resistor r=38.7139 //w=0.367 //l=1.11 //layer=li \
 //thickness=0.1 //x=75.23 //y=0.175 //x2=76.34 //y2=0.175
r1812 (  592 684 ) resistor r=5.29055 //w=0.35 //l=0.17 //layer=li \
 //thickness=0.1 //x=75.03 //y=0.175 //x2=74.86 //y2=0.175
r1813 (  592 594 ) resistor r=6.97548 //w=0.367 //l=0.2 //layer=li \
 //thickness=0.1 //x=75.03 //y=0.175 //x2=75.23 //y2=0.175
r1814 (  591 685 ) resistor r=5.29055 //w=0.35 //l=0.17 //layer=li \
 //thickness=0.1 //x=78.02 //y=0.175 //x2=78.19 //y2=0.175
r1815 (  591 598 ) resistor r=19.8801 //w=0.367 //l=0.57 //layer=li \
 //thickness=0.1 //x=78.02 //y=0.175 //x2=77.45 //y2=0.175
r1816 (  581 583 ) resistor r=38.7139 //w=0.367 //l=1.11 //layer=li \
 //thickness=0.1 //x=72.64 //y=0.175 //x2=73.75 //y2=0.175
r1817 (  579 581 ) resistor r=38.7139 //w=0.367 //l=1.11 //layer=li \
 //thickness=0.1 //x=71.53 //y=0.175 //x2=72.64 //y2=0.175
r1818 (  577 579 ) resistor r=38.7139 //w=0.367 //l=1.11 //layer=li \
 //thickness=0.1 //x=70.42 //y=0.175 //x2=71.53 //y2=0.175
r1819 (  575 683 ) resistor r=5.29055 //w=0.35 //l=0.17 //layer=li \
 //thickness=0.1 //x=70.22 //y=0.175 //x2=70.05 //y2=0.175
r1820 (  575 577 ) resistor r=6.97548 //w=0.367 //l=0.2 //layer=li \
 //thickness=0.1 //x=70.22 //y=0.175 //x2=70.42 //y2=0.175
r1821 (  574 684 ) resistor r=5.29055 //w=0.35 //l=0.17 //layer=li \
 //thickness=0.1 //x=74.69 //y=0.175 //x2=74.86 //y2=0.175
r1822 (  574 583 ) resistor r=32.7847 //w=0.367 //l=0.94 //layer=li \
 //thickness=0.1 //x=74.69 //y=0.175 //x2=73.75 //y2=0.175
r1823 (  564 566 ) resistor r=38.7139 //w=0.367 //l=1.11 //layer=li \
 //thickness=0.1 //x=67.83 //y=0.175 //x2=68.94 //y2=0.175
r1824 (  562 564 ) resistor r=38.7139 //w=0.367 //l=1.11 //layer=li \
 //thickness=0.1 //x=66.72 //y=0.175 //x2=67.83 //y2=0.175
r1825 (  560 562 ) resistor r=38.7139 //w=0.367 //l=1.11 //layer=li \
 //thickness=0.1 //x=65.61 //y=0.175 //x2=66.72 //y2=0.175
r1826 (  558 682 ) resistor r=5.29055 //w=0.35 //l=0.17 //layer=li \
 //thickness=0.1 //x=65.41 //y=0.175 //x2=65.24 //y2=0.175
r1827 (  558 560 ) resistor r=6.97548 //w=0.367 //l=0.2 //layer=li \
 //thickness=0.1 //x=65.41 //y=0.175 //x2=65.61 //y2=0.175
r1828 (  557 683 ) resistor r=5.29055 //w=0.35 //l=0.17 //layer=li \
 //thickness=0.1 //x=69.88 //y=0.175 //x2=70.05 //y2=0.175
r1829 (  557 566 ) resistor r=32.7847 //w=0.367 //l=0.94 //layer=li \
 //thickness=0.1 //x=69.88 //y=0.175 //x2=68.94 //y2=0.175
r1830 (  547 549 ) resistor r=38.7139 //w=0.367 //l=1.11 //layer=li \
 //thickness=0.1 //x=63.02 //y=0.175 //x2=64.13 //y2=0.175
r1831 (  545 681 ) resistor r=5.29055 //w=0.35 //l=0.17 //layer=li \
 //thickness=0.1 //x=62.08 //y=0.175 //x2=61.91 //y2=0.175
r1832 (  545 547 ) resistor r=32.7847 //w=0.367 //l=0.94 //layer=li \
 //thickness=0.1 //x=62.08 //y=0.175 //x2=63.02 //y2=0.175
r1833 (  544 682 ) resistor r=5.29055 //w=0.35 //l=0.17 //layer=li \
 //thickness=0.1 //x=65.07 //y=0.175 //x2=65.24 //y2=0.175
r1834 (  544 549 ) resistor r=32.7847 //w=0.367 //l=0.94 //layer=li \
 //thickness=0.1 //x=65.07 //y=0.175 //x2=64.13 //y2=0.175
r1835 (  534 536 ) resistor r=38.7139 //w=0.367 //l=1.11 //layer=li \
 //thickness=0.1 //x=60.43 //y=0.175 //x2=61.54 //y2=0.175
r1836 (  532 534 ) resistor r=38.7139 //w=0.367 //l=1.11 //layer=li \
 //thickness=0.1 //x=59.32 //y=0.175 //x2=60.43 //y2=0.175
r1837 (  530 532 ) resistor r=38.7139 //w=0.367 //l=1.11 //layer=li \
 //thickness=0.1 //x=58.21 //y=0.175 //x2=59.32 //y2=0.175
r1838 (  528 680 ) resistor r=5.29055 //w=0.35 //l=0.17 //layer=li \
 //thickness=0.1 //x=57.27 //y=0.175 //x2=57.1 //y2=0.175
r1839 (  528 530 ) resistor r=32.7847 //w=0.367 //l=0.94 //layer=li \
 //thickness=0.1 //x=57.27 //y=0.175 //x2=58.21 //y2=0.175
r1840 (  527 681 ) resistor r=5.29055 //w=0.35 //l=0.17 //layer=li \
 //thickness=0.1 //x=61.74 //y=0.175 //x2=61.91 //y2=0.175
r1841 (  527 536 ) resistor r=6.97548 //w=0.367 //l=0.2 //layer=li \
 //thickness=0.1 //x=61.74 //y=0.175 //x2=61.54 //y2=0.175
r1842 (  517 519 ) resistor r=38.7139 //w=0.367 //l=1.11 //layer=li \
 //thickness=0.1 //x=55.62 //y=0.175 //x2=56.73 //y2=0.175
r1843 (  515 517 ) resistor r=38.7139 //w=0.367 //l=1.11 //layer=li \
 //thickness=0.1 //x=54.51 //y=0.175 //x2=55.62 //y2=0.175
r1844 (  513 515 ) resistor r=38.7139 //w=0.367 //l=1.11 //layer=li \
 //thickness=0.1 //x=53.4 //y=0.175 //x2=54.51 //y2=0.175
r1845 (  511 679 ) resistor r=5.29055 //w=0.35 //l=0.17 //layer=li \
 //thickness=0.1 //x=52.46 //y=0.175 //x2=52.29 //y2=0.175
r1846 (  511 513 ) resistor r=32.7847 //w=0.367 //l=0.94 //layer=li \
 //thickness=0.1 //x=52.46 //y=0.175 //x2=53.4 //y2=0.175
r1847 (  510 680 ) resistor r=5.29055 //w=0.35 //l=0.17 //layer=li \
 //thickness=0.1 //x=56.93 //y=0.175 //x2=57.1 //y2=0.175
r1848 (  510 519 ) resistor r=6.97548 //w=0.367 //l=0.2 //layer=li \
 //thickness=0.1 //x=56.93 //y=0.175 //x2=56.73 //y2=0.175
r1849 (  500 502 ) resistor r=38.7139 //w=0.367 //l=1.11 //layer=li \
 //thickness=0.1 //x=50.81 //y=0.175 //x2=51.92 //y2=0.175
r1850 (  498 500 ) resistor r=38.7139 //w=0.367 //l=1.11 //layer=li \
 //thickness=0.1 //x=49.7 //y=0.175 //x2=50.81 //y2=0.175
r1851 (  496 678 ) resistor r=5.29055 //w=0.35 //l=0.17 //layer=li \
 //thickness=0.1 //x=49.13 //y=0.175 //x2=48.96 //y2=0.175
r1852 (  496 498 ) resistor r=19.8801 //w=0.367 //l=0.57 //layer=li \
 //thickness=0.1 //x=49.13 //y=0.175 //x2=49.7 //y2=0.175
r1853 (  495 679 ) resistor r=5.29055 //w=0.35 //l=0.17 //layer=li \
 //thickness=0.1 //x=52.12 //y=0.175 //x2=52.29 //y2=0.175
r1854 (  495 502 ) resistor r=6.97548 //w=0.367 //l=0.2 //layer=li \
 //thickness=0.1 //x=52.12 //y=0.175 //x2=51.92 //y2=0.175
r1855 (  485 487 ) resistor r=38.7139 //w=0.367 //l=1.11 //layer=li \
 //thickness=0.1 //x=47.11 //y=0.175 //x2=48.22 //y2=0.175
r1856 (  483 485 ) resistor r=38.7139 //w=0.367 //l=1.11 //layer=li \
 //thickness=0.1 //x=46 //y=0.175 //x2=47.11 //y2=0.175
r1857 (  481 483 ) resistor r=38.7139 //w=0.367 //l=1.11 //layer=li \
 //thickness=0.1 //x=44.89 //y=0.175 //x2=46 //y2=0.175
r1858 (  479 677 ) resistor r=5.29055 //w=0.35 //l=0.17 //layer=li \
 //thickness=0.1 //x=44.32 //y=0.175 //x2=44.15 //y2=0.175
r1859 (  479 481 ) resistor r=19.8801 //w=0.367 //l=0.57 //layer=li \
 //thickness=0.1 //x=44.32 //y=0.175 //x2=44.89 //y2=0.175
r1860 (  478 678 ) resistor r=5.29055 //w=0.35 //l=0.17 //layer=li \
 //thickness=0.1 //x=48.79 //y=0.175 //x2=48.96 //y2=0.175
r1861 (  478 487 ) resistor r=19.8801 //w=0.367 //l=0.57 //layer=li \
 //thickness=0.1 //x=48.79 //y=0.175 //x2=48.22 //y2=0.175
r1862 (  468 470 ) resistor r=38.7139 //w=0.367 //l=1.11 //layer=li \
 //thickness=0.1 //x=42.3 //y=0.175 //x2=43.41 //y2=0.175
r1863 (  466 468 ) resistor r=38.7139 //w=0.367 //l=1.11 //layer=li \
 //thickness=0.1 //x=41.19 //y=0.175 //x2=42.3 //y2=0.175
r1864 (  464 466 ) resistor r=38.7139 //w=0.367 //l=1.11 //layer=li \
 //thickness=0.1 //x=40.08 //y=0.175 //x2=41.19 //y2=0.175
r1865 (  462 676 ) resistor r=5.29055 //w=0.35 //l=0.17 //layer=li \
 //thickness=0.1 //x=39.51 //y=0.175 //x2=39.34 //y2=0.175
r1866 (  462 464 ) resistor r=19.8801 //w=0.367 //l=0.57 //layer=li \
 //thickness=0.1 //x=39.51 //y=0.175 //x2=40.08 //y2=0.175
r1867 (  461 677 ) resistor r=5.29055 //w=0.35 //l=0.17 //layer=li \
 //thickness=0.1 //x=43.98 //y=0.175 //x2=44.15 //y2=0.175
r1868 (  461 470 ) resistor r=19.8801 //w=0.367 //l=0.57 //layer=li \
 //thickness=0.1 //x=43.98 //y=0.175 //x2=43.41 //y2=0.175
r1869 (  451 453 ) resistor r=38.7139 //w=0.367 //l=1.11 //layer=li \
 //thickness=0.1 //x=37.49 //y=0.175 //x2=38.6 //y2=0.175
r1870 (  449 451 ) resistor r=38.7139 //w=0.367 //l=1.11 //layer=li \
 //thickness=0.1 //x=36.38 //y=0.175 //x2=37.49 //y2=0.175
r1871 (  447 675 ) resistor r=5.29055 //w=0.35 //l=0.17 //layer=li \
 //thickness=0.1 //x=36.18 //y=0.175 //x2=36.01 //y2=0.175
r1872 (  447 449 ) resistor r=6.97548 //w=0.367 //l=0.2 //layer=li \
 //thickness=0.1 //x=36.18 //y=0.175 //x2=36.38 //y2=0.175
r1873 (  446 676 ) resistor r=5.29055 //w=0.35 //l=0.17 //layer=li \
 //thickness=0.1 //x=39.17 //y=0.175 //x2=39.34 //y2=0.175
r1874 (  446 453 ) resistor r=19.8801 //w=0.367 //l=0.57 //layer=li \
 //thickness=0.1 //x=39.17 //y=0.175 //x2=38.6 //y2=0.175
r1875 (  436 438 ) resistor r=38.7139 //w=0.367 //l=1.11 //layer=li \
 //thickness=0.1 //x=33.79 //y=0.175 //x2=34.9 //y2=0.175
r1876 (  434 436 ) resistor r=38.7139 //w=0.367 //l=1.11 //layer=li \
 //thickness=0.1 //x=32.68 //y=0.175 //x2=33.79 //y2=0.175
r1877 (  432 434 ) resistor r=38.7139 //w=0.367 //l=1.11 //layer=li \
 //thickness=0.1 //x=31.57 //y=0.175 //x2=32.68 //y2=0.175
r1878 (  430 674 ) resistor r=5.29055 //w=0.35 //l=0.17 //layer=li \
 //thickness=0.1 //x=31.37 //y=0.175 //x2=31.2 //y2=0.175
r1879 (  430 432 ) resistor r=6.97548 //w=0.367 //l=0.2 //layer=li \
 //thickness=0.1 //x=31.37 //y=0.175 //x2=31.57 //y2=0.175
r1880 (  429 675 ) resistor r=5.29055 //w=0.35 //l=0.17 //layer=li \
 //thickness=0.1 //x=35.84 //y=0.175 //x2=36.01 //y2=0.175
r1881 (  429 438 ) resistor r=32.7847 //w=0.367 //l=0.94 //layer=li \
 //thickness=0.1 //x=35.84 //y=0.175 //x2=34.9 //y2=0.175
r1882 (  419 421 ) resistor r=38.7139 //w=0.367 //l=1.11 //layer=li \
 //thickness=0.1 //x=28.98 //y=0.175 //x2=30.09 //y2=0.175
r1883 (  417 419 ) resistor r=38.7139 //w=0.367 //l=1.11 //layer=li \
 //thickness=0.1 //x=27.87 //y=0.175 //x2=28.98 //y2=0.175
r1884 (  415 417 ) resistor r=38.7139 //w=0.367 //l=1.11 //layer=li \
 //thickness=0.1 //x=26.76 //y=0.175 //x2=27.87 //y2=0.175
r1885 (  413 673 ) resistor r=5.29055 //w=0.35 //l=0.17 //layer=li \
 //thickness=0.1 //x=26.56 //y=0.175 //x2=26.39 //y2=0.175
r1886 (  413 415 ) resistor r=6.97548 //w=0.367 //l=0.2 //layer=li \
 //thickness=0.1 //x=26.56 //y=0.175 //x2=26.76 //y2=0.175
r1887 (  412 674 ) resistor r=5.29055 //w=0.35 //l=0.17 //layer=li \
 //thickness=0.1 //x=31.03 //y=0.175 //x2=31.2 //y2=0.175
r1888 (  412 421 ) resistor r=32.7847 //w=0.367 //l=0.94 //layer=li \
 //thickness=0.1 //x=31.03 //y=0.175 //x2=30.09 //y2=0.175
r1889 (  402 404 ) resistor r=38.7139 //w=0.367 //l=1.11 //layer=li \
 //thickness=0.1 //x=24.17 //y=0.175 //x2=25.28 //y2=0.175
r1890 (  400 672 ) resistor r=5.29055 //w=0.35 //l=0.17 //layer=li \
 //thickness=0.1 //x=23.23 //y=0.175 //x2=23.06 //y2=0.175
r1891 (  400 402 ) resistor r=32.7847 //w=0.367 //l=0.94 //layer=li \
 //thickness=0.1 //x=23.23 //y=0.175 //x2=24.17 //y2=0.175
r1892 (  399 673 ) resistor r=5.29055 //w=0.35 //l=0.17 //layer=li \
 //thickness=0.1 //x=26.22 //y=0.175 //x2=26.39 //y2=0.175
r1893 (  399 404 ) resistor r=32.7847 //w=0.367 //l=0.94 //layer=li \
 //thickness=0.1 //x=26.22 //y=0.175 //x2=25.28 //y2=0.175
r1894 (  389 391 ) resistor r=38.7139 //w=0.367 //l=1.11 //layer=li \
 //thickness=0.1 //x=21.58 //y=0.175 //x2=22.69 //y2=0.175
r1895 (  387 389 ) resistor r=38.7139 //w=0.367 //l=1.11 //layer=li \
 //thickness=0.1 //x=20.47 //y=0.175 //x2=21.58 //y2=0.175
r1896 (  385 387 ) resistor r=38.7139 //w=0.367 //l=1.11 //layer=li \
 //thickness=0.1 //x=19.36 //y=0.175 //x2=20.47 //y2=0.175
r1897 (  383 671 ) resistor r=5.29055 //w=0.35 //l=0.17 //layer=li \
 //thickness=0.1 //x=18.42 //y=0.175 //x2=18.25 //y2=0.175
r1898 (  383 385 ) resistor r=32.7847 //w=0.367 //l=0.94 //layer=li \
 //thickness=0.1 //x=18.42 //y=0.175 //x2=19.36 //y2=0.175
r1899 (  382 672 ) resistor r=5.29055 //w=0.35 //l=0.17 //layer=li \
 //thickness=0.1 //x=22.89 //y=0.175 //x2=23.06 //y2=0.175
r1900 (  382 391 ) resistor r=6.97548 //w=0.367 //l=0.2 //layer=li \
 //thickness=0.1 //x=22.89 //y=0.175 //x2=22.69 //y2=0.175
r1901 (  372 374 ) resistor r=38.7139 //w=0.367 //l=1.11 //layer=li \
 //thickness=0.1 //x=16.77 //y=0.175 //x2=17.88 //y2=0.175
r1902 (  370 372 ) resistor r=38.7139 //w=0.367 //l=1.11 //layer=li \
 //thickness=0.1 //x=15.66 //y=0.175 //x2=16.77 //y2=0.175
r1903 (  368 370 ) resistor r=38.7139 //w=0.367 //l=1.11 //layer=li \
 //thickness=0.1 //x=14.55 //y=0.175 //x2=15.66 //y2=0.175
r1904 (  366 670 ) resistor r=5.29055 //w=0.35 //l=0.17 //layer=li \
 //thickness=0.1 //x=13.61 //y=0.175 //x2=13.44 //y2=0.175
r1905 (  366 368 ) resistor r=32.7847 //w=0.367 //l=0.94 //layer=li \
 //thickness=0.1 //x=13.61 //y=0.175 //x2=14.55 //y2=0.175
r1906 (  365 671 ) resistor r=5.29055 //w=0.35 //l=0.17 //layer=li \
 //thickness=0.1 //x=18.08 //y=0.175 //x2=18.25 //y2=0.175
r1907 (  365 374 ) resistor r=6.97548 //w=0.367 //l=0.2 //layer=li \
 //thickness=0.1 //x=18.08 //y=0.175 //x2=17.88 //y2=0.175
r1908 (  355 357 ) resistor r=38.7139 //w=0.367 //l=1.11 //layer=li \
 //thickness=0.1 //x=11.96 //y=0.175 //x2=13.07 //y2=0.175
r1909 (  353 355 ) resistor r=38.7139 //w=0.367 //l=1.11 //layer=li \
 //thickness=0.1 //x=10.85 //y=0.175 //x2=11.96 //y2=0.175
r1910 (  351 669 ) resistor r=5.29055 //w=0.35 //l=0.17 //layer=li \
 //thickness=0.1 //x=10.28 //y=0.175 //x2=10.11 //y2=0.175
r1911 (  351 353 ) resistor r=19.8801 //w=0.367 //l=0.57 //layer=li \
 //thickness=0.1 //x=10.28 //y=0.175 //x2=10.85 //y2=0.175
r1912 (  350 670 ) resistor r=5.29055 //w=0.35 //l=0.17 //layer=li \
 //thickness=0.1 //x=13.27 //y=0.175 //x2=13.44 //y2=0.175
r1913 (  350 357 ) resistor r=6.97548 //w=0.367 //l=0.2 //layer=li \
 //thickness=0.1 //x=13.27 //y=0.175 //x2=13.07 //y2=0.175
r1914 (  340 342 ) resistor r=38.7139 //w=0.367 //l=1.11 //layer=li \
 //thickness=0.1 //x=8.26 //y=0.175 //x2=9.37 //y2=0.175
r1915 (  338 340 ) resistor r=38.7139 //w=0.367 //l=1.11 //layer=li \
 //thickness=0.1 //x=7.15 //y=0.175 //x2=8.26 //y2=0.175
r1916 (  336 338 ) resistor r=38.7139 //w=0.367 //l=1.11 //layer=li \
 //thickness=0.1 //x=6.04 //y=0.175 //x2=7.15 //y2=0.175
r1917 (  334 668 ) resistor r=5.29055 //w=0.35 //l=0.17 //layer=li \
 //thickness=0.1 //x=5.47 //y=0.175 //x2=5.3 //y2=0.175
r1918 (  334 336 ) resistor r=19.8801 //w=0.367 //l=0.57 //layer=li \
 //thickness=0.1 //x=5.47 //y=0.175 //x2=6.04 //y2=0.175
r1919 (  333 669 ) resistor r=5.29055 //w=0.35 //l=0.17 //layer=li \
 //thickness=0.1 //x=9.94 //y=0.175 //x2=10.11 //y2=0.175
r1920 (  333 342 ) resistor r=19.8801 //w=0.367 //l=0.57 //layer=li \
 //thickness=0.1 //x=9.94 //y=0.175 //x2=9.37 //y2=0.175
r1921 (  323 325 ) resistor r=38.7139 //w=0.367 //l=1.11 //layer=li \
 //thickness=0.1 //x=3.45 //y=0.175 //x2=4.56 //y2=0.175
r1922 (  321 323 ) resistor r=38.7139 //w=0.367 //l=1.11 //layer=li \
 //thickness=0.1 //x=2.34 //y=0.175 //x2=3.45 //y2=0.175
r1923 (  319 321 ) resistor r=38.7139 //w=0.367 //l=1.11 //layer=li \
 //thickness=0.1 //x=1.23 //y=0.175 //x2=2.34 //y2=0.175
r1924 (  316 668 ) resistor r=5.29055 //w=0.35 //l=0.17 //layer=li \
 //thickness=0.1 //x=5.13 //y=0.175 //x2=5.3 //y2=0.175
r1925 (  316 325 ) resistor r=19.8801 //w=0.367 //l=0.57 //layer=li \
 //thickness=0.1 //x=5.13 //y=0.175 //x2=4.56 //y2=0.175
r1926 (  313 721 ) resistor r=9.3 //w=0.17 //l=0.17 //layer=mcon //count=1 \
 //x=86.03 //y=1.135 //x2=86.03 //y2=1.135
r1927 (  310 624 ) resistor r=3.1 //w=0.17 //l=0.51 //layer=mcon //count=3 \
 //x=82.63 //y=0.18 //x2=82.63 //y2=0.18
r1928 (  308 720 ) resistor r=9.3 //w=0.17 //l=0.17 //layer=mcon //count=1 \
 //x=79.37 //y=1.135 //x2=79.37 //y2=1.135
r1929 (  302 719 ) resistor r=9.3 //w=0.17 //l=0.17 //layer=mcon //count=1 \
 //x=76.04 //y=1.135 //x2=76.04 //y2=1.135
r1930 (  302 303 ) resistor r=0.0939994 //w=0.226 //l=0.13 //layer=m1 \
 //thickness=0.36 //x=76.037 //y=1.135 //x2=76.037 //y2=1.005
r1931 (  298 718 ) resistor r=9.3 //w=0.17 //l=0.17 //layer=mcon //count=1 \
 //x=71.125 //y=1.145 //x2=71.125 //y2=1.145
r1932 (  294 717 ) resistor r=9.3 //w=0.17 //l=0.17 //layer=mcon //count=1 \
 //x=66.315 //y=1.145 //x2=66.315 //y2=1.145
r1933 (  292 547 ) resistor r=3.1 //w=0.17 //l=0.51 //layer=mcon //count=3 \
 //x=63.02 //y=0.18 //x2=63.02 //y2=0.18
r1934 (  288 716 ) resistor r=9.3 //w=0.17 //l=0.17 //layer=mcon //count=1 \
 //x=63.09 //y=1.135 //x2=63.09 //y2=1.135
r1935 (  288 289 ) resistor r=0.0939994 //w=0.226 //l=0.13 //layer=m1 \
 //thickness=0.36 //x=63.087 //y=1.135 //x2=63.087 //y2=1.005
r1936 (  286 530 ) resistor r=3.1 //w=0.17 //l=0.51 //layer=mcon //count=3 \
 //x=58.21 //y=0.18 //x2=58.21 //y2=0.18
r1937 (  283 715 ) resistor r=9.3 //w=0.17 //l=0.17 //layer=mcon //count=1 \
 //x=58.175 //y=1.145 //x2=58.175 //y2=1.145
r1938 (  281 513 ) resistor r=3.1 //w=0.17 //l=0.51 //layer=mcon //count=3 \
 //x=53.4 //y=0.18 //x2=53.4 //y2=0.18
r1939 (  278 714 ) resistor r=9.3 //w=0.17 //l=0.17 //layer=mcon //count=1 \
 //x=53.365 //y=1.145 //x2=53.365 //y2=1.145
r1940 (  273 713 ) resistor r=9.3 //w=0.17 //l=0.17 //layer=mcon //count=1 \
 //x=50.14 //y=1.135 //x2=50.14 //y2=1.135
r1941 (  273 274 ) resistor r=0.0939994 //w=0.226 //l=0.13 //layer=m1 \
 //thickness=0.36 //x=50.137 //y=1.135 //x2=50.137 //y2=1.005
r1942 (  269 712 ) resistor r=9.3 //w=0.17 //l=0.17 //layer=mcon //count=1 \
 //x=45.225 //y=1.145 //x2=45.225 //y2=1.145
r1943 (  265 711 ) resistor r=9.3 //w=0.17 //l=0.17 //layer=mcon //count=1 \
 //x=40.415 //y=1.145 //x2=40.415 //y2=1.145
r1944 (  260 710 ) resistor r=9.3 //w=0.17 //l=0.17 //layer=mcon //count=1 \
 //x=37.19 //y=1.135 //x2=37.19 //y2=1.135
r1945 (  260 261 ) resistor r=0.0939994 //w=0.226 //l=0.13 //layer=m1 \
 //thickness=0.36 //x=37.187 //y=1.135 //x2=37.187 //y2=1.005
r1946 (  256 709 ) resistor r=9.3 //w=0.17 //l=0.17 //layer=mcon //count=1 \
 //x=32.275 //y=1.145 //x2=32.275 //y2=1.145
r1947 (  252 708 ) resistor r=9.3 //w=0.17 //l=0.17 //layer=mcon //count=1 \
 //x=27.465 //y=1.145 //x2=27.465 //y2=1.145
r1948 (  250 402 ) resistor r=3.1 //w=0.17 //l=0.51 //layer=mcon //count=3 \
 //x=24.17 //y=0.18 //x2=24.17 //y2=0.18
r1949 (  246 707 ) resistor r=9.3 //w=0.17 //l=0.17 //layer=mcon //count=1 \
 //x=24.24 //y=1.135 //x2=24.24 //y2=1.135
r1950 (  246 247 ) resistor r=0.0939994 //w=0.226 //l=0.13 //layer=m1 \
 //thickness=0.36 //x=24.237 //y=1.135 //x2=24.237 //y2=1.005
r1951 (  244 385 ) resistor r=3.1 //w=0.17 //l=0.51 //layer=mcon //count=3 \
 //x=19.36 //y=0.18 //x2=19.36 //y2=0.18
r1952 (  241 706 ) resistor r=9.3 //w=0.17 //l=0.17 //layer=mcon //count=1 \
 //x=19.325 //y=1.145 //x2=19.325 //y2=1.145
r1953 (  239 368 ) resistor r=3.1 //w=0.17 //l=0.51 //layer=mcon //count=3 \
 //x=14.55 //y=0.18 //x2=14.55 //y2=0.18
r1954 (  236 705 ) resistor r=9.3 //w=0.17 //l=0.17 //layer=mcon //count=1 \
 //x=14.515 //y=1.145 //x2=14.515 //y2=1.145
r1955 (  231 704 ) resistor r=9.3 //w=0.17 //l=0.17 //layer=mcon //count=1 \
 //x=11.29 //y=1.135 //x2=11.29 //y2=1.135
r1956 (  231 232 ) resistor r=0.0939994 //w=0.226 //l=0.13 //layer=m1 \
 //thickness=0.36 //x=11.287 //y=1.135 //x2=11.287 //y2=1.005
r1957 (  227 703 ) resistor r=9.3 //w=0.17 //l=0.17 //layer=mcon //count=1 \
 //x=6.375 //y=1.145 //x2=6.375 //y2=1.145
r1958 (  223 702 ) resistor r=9.3 //w=0.17 //l=0.17 //layer=mcon //count=1 \
 //x=1.565 //y=1.145 //x2=1.565 //y2=1.145
r1959 (  220 694 ) resistor r=4.65 //w=0.17 //l=0.34 //layer=mcon //count=2 \
 //x=89.66 //y=0.18 //x2=89.66 //y2=0.18
r1960 (  218 691 ) resistor r=3.1 //w=0.17 //l=0.51 //layer=mcon //count=3 \
 //x=88.92 //y=0.18 //x2=88.92 //y2=0.18
r1961 (  218 220 ) resistor r=0.297428 //w=0.311 //l=0.74 //layer=m1 \
 //thickness=0.36 //x=88.92 //y=0.175 //x2=89.66 //y2=0.175
r1962 (  216 636 ) resistor r=3.1 //w=0.17 //l=0.51 //layer=mcon //count=3 \
 //x=87.44 //y=0.18 //x2=87.44 //y2=0.18
r1963 (  216 218 ) resistor r=0.594855 //w=0.311 //l=1.48 //layer=m1 \
 //thickness=0.36 //x=87.44 //y=0.175 //x2=88.92 //y2=0.175
r1964 (  214 634 ) resistor r=3.1 //w=0.17 //l=0.51 //layer=mcon //count=3 \
 //x=86.33 //y=0.18 //x2=86.33 //y2=0.18
r1965 (  214 216 ) resistor r=0.446141 //w=0.311 //l=1.11 //layer=m1 \
 //thickness=0.36 //x=86.33 //y=0.175 //x2=87.44 //y2=0.175
r1966 (  212 311 ) resistor r=0.028033 //w=0.35 //l=0.085 //layer=m1 \
 //thickness=0.36 //x=86.115 //y=0.175 //x2=86.03 //y2=0.175
r1967 (  212 214 ) resistor r=0.0864148 //w=0.311 //l=0.215 //layer=m1 \
 //thickness=0.36 //x=86.115 //y=0.175 //x2=86.33 //y2=0.175
r1968 (  211 313 ) resistor r=0.0703067 //w=0.254 //l=0.11649 //layer=m1 \
 //thickness=0.36 //x=86.03 //y=1.02 //x2=86.027 //y2=1.135
r1969 (  210 311 ) resistor r=0.0413265 //w=0.7 //l=0.175 //layer=m1 \
 //thickness=0.36 //x=86.03 //y=0.35 //x2=86.03 //y2=0.175
r1970 (  210 211 ) resistor r=0.639313 //w=0.131 //l=0.67 //layer=m1 \
 //thickness=0.36 //x=86.03 //y=0.35 //x2=86.03 //y2=1.02
r1971 (  209 632 ) resistor r=3.1 //w=0.17 //l=0.51 //layer=mcon //count=3 \
 //x=85.22 //y=0.18 //x2=85.22 //y2=0.18
r1972 (  207 626 ) resistor r=3.1 //w=0.17 //l=0.51 //layer=mcon //count=3 \
 //x=83.74 //y=0.18 //x2=83.74 //y2=0.18
r1973 (  207 209 ) resistor r=0.594855 //w=0.311 //l=1.48 //layer=m1 \
 //thickness=0.36 //x=83.74 //y=0.175 //x2=85.22 //y2=0.175
r1974 (  205 310 ) resistor r=0.028033 //w=0.35 //l=0.085 //layer=m1 \
 //thickness=0.36 //x=82.785 //y=0.175 //x2=82.7 //y2=0.175
r1975 (  205 207 ) resistor r=0.383842 //w=0.311 //l=0.955 //layer=m1 \
 //thickness=0.36 //x=82.785 //y=0.175 //x2=83.74 //y2=0.175
r1976 (  204 311 ) resistor r=0.028033 //w=0.35 //l=0.085 //layer=m1 \
 //thickness=0.36 //x=85.945 //y=0.175 //x2=86.03 //y2=0.175
r1977 (  204 209 ) resistor r=0.291399 //w=0.311 //l=0.725 //layer=m1 \
 //thickness=0.36 //x=85.945 //y=0.175 //x2=85.22 //y2=0.175
r1978 (  201 613 ) resistor r=3.1 //w=0.17 //l=0.51 //layer=mcon //count=3 \
 //x=81.15 //y=0.18 //x2=81.15 //y2=0.18
r1979 (  199 611 ) resistor r=3.1 //w=0.17 //l=0.51 //layer=mcon //count=3 \
 //x=80.04 //y=0.18 //x2=80.04 //y2=0.18
r1980 (  199 201 ) resistor r=0.446141 //w=0.311 //l=1.11 //layer=m1 \
 //thickness=0.36 //x=80.04 //y=0.175 //x2=81.15 //y2=0.175
r1981 (  197 306 ) resistor r=0.028033 //w=0.35 //l=0.085 //layer=m1 \
 //thickness=0.36 //x=79.455 //y=0.175 //x2=79.37 //y2=0.175
r1982 (  197 199 ) resistor r=0.235129 //w=0.311 //l=0.585 //layer=m1 \
 //thickness=0.36 //x=79.455 //y=0.175 //x2=80.04 //y2=0.175
r1983 (  196 310 ) resistor r=0.028033 //w=0.35 //l=0.085 //layer=m1 \
 //thickness=0.36 //x=82.615 //y=0.175 //x2=82.7 //y2=0.175
r1984 (  196 201 ) resistor r=0.588826 //w=0.311 //l=1.465 //layer=m1 \
 //thickness=0.36 //x=82.615 //y=0.175 //x2=81.15 //y2=0.175
r1985 (  195 308 ) resistor r=0.0729089 //w=0.249 //l=0.120996 //layer=m1 \
 //thickness=0.36 //x=79.37 //y=1.015 //x2=79.372 //y2=1.135
r1986 (  194 306 ) resistor r=0.0413265 //w=0.7 //l=0.175 //layer=m1 \
 //thickness=0.36 //x=79.37 //y=0.35 //x2=79.37 //y2=0.175
r1987 (  194 195 ) resistor r=0.634542 //w=0.131 //l=0.665 //layer=m1 \
 //thickness=0.36 //x=79.37 //y=0.35 //x2=79.37 //y2=1.015
r1988 (  193 609 ) resistor r=3.1 //w=0.17 //l=0.51 //layer=mcon //count=3 \
 //x=78.93 //y=0.18 //x2=78.93 //y2=0.18
r1989 (  191 598 ) resistor r=3.1 //w=0.17 //l=0.51 //layer=mcon //count=3 \
 //x=77.45 //y=0.18 //x2=77.45 //y2=0.18
r1990 (  191 193 ) resistor r=0.594855 //w=0.311 //l=1.48 //layer=m1 \
 //thickness=0.36 //x=77.45 //y=0.175 //x2=78.93 //y2=0.175
r1991 (  189 596 ) resistor r=3.1 //w=0.17 //l=0.51 //layer=mcon //count=3 \
 //x=76.34 //y=0.18 //x2=76.34 //y2=0.18
r1992 (  189 191 ) resistor r=0.446141 //w=0.311 //l=1.11 //layer=m1 \
 //thickness=0.36 //x=76.34 //y=0.175 //x2=77.45 //y2=0.175
r1993 (  187 305 ) resistor r=0.028033 //w=0.35 //l=0.085 //layer=m1 \
 //thickness=0.36 //x=76.125 //y=0.175 //x2=76.04 //y2=0.175
r1994 (  187 189 ) resistor r=0.0864148 //w=0.311 //l=0.215 //layer=m1 \
 //thickness=0.36 //x=76.125 //y=0.175 //x2=76.34 //y2=0.175
r1995 (  186 306 ) resistor r=0.028033 //w=0.35 //l=0.085 //layer=m1 \
 //thickness=0.36 //x=79.285 //y=0.175 //x2=79.37 //y2=0.175
r1996 (  186 193 ) resistor r=0.142685 //w=0.311 //l=0.355 //layer=m1 \
 //thickness=0.36 //x=79.285 //y=0.175 //x2=78.93 //y2=0.175
r1997 (  184 305 ) resistor r=0.0413265 //w=0.7 //l=0.175 //layer=m1 \
 //thickness=0.36 //x=76.04 //y=0.35 //x2=76.04 //y2=0.175
r1998 (  184 303 ) resistor r=0.625 //w=0.131 //l=0.655 //layer=m1 \
 //thickness=0.36 //x=76.04 //y=0.35 //x2=76.04 //y2=1.005
r1999 (  183 594 ) resistor r=3.1 //w=0.17 //l=0.51 //layer=mcon //count=3 \
 //x=75.23 //y=0.18 //x2=75.23 //y2=0.18
r2000 (  181 583 ) resistor r=3.1 //w=0.17 //l=0.51 //layer=mcon //count=3 \
 //x=73.75 //y=0.18 //x2=73.75 //y2=0.18
r2001 (  181 183 ) resistor r=0.594855 //w=0.311 //l=1.48 //layer=m1 \
 //thickness=0.36 //x=73.75 //y=0.175 //x2=75.23 //y2=0.175
r2002 (  179 581 ) resistor r=3.1 //w=0.17 //l=0.51 //layer=mcon //count=3 \
 //x=72.64 //y=0.18 //x2=72.64 //y2=0.18
r2003 (  179 181 ) resistor r=0.446141 //w=0.311 //l=1.11 //layer=m1 \
 //thickness=0.36 //x=72.64 //y=0.175 //x2=73.75 //y2=0.175
r2004 (  177 579 ) resistor r=3.1 //w=0.17 //l=0.51 //layer=mcon //count=3 \
 //x=71.53 //y=0.18 //x2=71.53 //y2=0.18
r2005 (  177 179 ) resistor r=0.446141 //w=0.311 //l=1.11 //layer=m1 \
 //thickness=0.36 //x=71.53 //y=0.175 //x2=72.64 //y2=0.175
r2006 (  175 300 ) resistor r=0.028033 //w=0.35 //l=0.085 //layer=m1 \
 //thickness=0.36 //x=71.21 //y=0.175 //x2=71.125 //y2=0.175
r2007 (  175 177 ) resistor r=0.128617 //w=0.311 //l=0.32 //layer=m1 \
 //thickness=0.36 //x=71.21 //y=0.175 //x2=71.53 //y2=0.175
r2008 (  174 305 ) resistor r=0.028033 //w=0.35 //l=0.085 //layer=m1 \
 //thickness=0.36 //x=75.955 //y=0.175 //x2=76.04 //y2=0.175
r2009 (  174 183 ) resistor r=0.291399 //w=0.311 //l=0.725 //layer=m1 \
 //thickness=0.36 //x=75.955 //y=0.175 //x2=75.23 //y2=0.175
r2010 (  173 298 ) resistor r=0.0942778 //w=0.221 //l=0.13 //layer=m1 \
 //thickness=0.36 //x=71.125 //y=1.015 //x2=71.125 //y2=1.145
r2011 (  172 300 ) resistor r=0.0413265 //w=0.7 //l=0.175 //layer=m1 \
 //thickness=0.36 //x=71.125 //y=0.35 //x2=71.125 //y2=0.175
r2012 (  172 173 ) resistor r=0.634542 //w=0.131 //l=0.665 //layer=m1 \
 //thickness=0.36 //x=71.125 //y=0.35 //x2=71.125 //y2=1.015
r2013 (  171 577 ) resistor r=3.1 //w=0.17 //l=0.51 //layer=mcon //count=3 \
 //x=70.42 //y=0.18 //x2=70.42 //y2=0.18
r2014 (  169 566 ) resistor r=3.1 //w=0.17 //l=0.51 //layer=mcon //count=3 \
 //x=68.94 //y=0.18 //x2=68.94 //y2=0.18
r2015 (  169 171 ) resistor r=0.594855 //w=0.311 //l=1.48 //layer=m1 \
 //thickness=0.36 //x=68.94 //y=0.175 //x2=70.42 //y2=0.175
r2016 (  167 564 ) resistor r=3.1 //w=0.17 //l=0.51 //layer=mcon //count=3 \
 //x=67.83 //y=0.18 //x2=67.83 //y2=0.18
r2017 (  167 169 ) resistor r=0.446141 //w=0.311 //l=1.11 //layer=m1 \
 //thickness=0.36 //x=67.83 //y=0.175 //x2=68.94 //y2=0.175
r2018 (  165 562 ) resistor r=3.1 //w=0.17 //l=0.51 //layer=mcon //count=3 \
 //x=66.72 //y=0.18 //x2=66.72 //y2=0.18
r2019 (  165 167 ) resistor r=0.446141 //w=0.311 //l=1.11 //layer=m1 \
 //thickness=0.36 //x=66.72 //y=0.175 //x2=67.83 //y2=0.175
r2020 (  163 296 ) resistor r=0.028033 //w=0.35 //l=0.085 //layer=m1 \
 //thickness=0.36 //x=66.4 //y=0.175 //x2=66.315 //y2=0.175
r2021 (  163 165 ) resistor r=0.128617 //w=0.311 //l=0.32 //layer=m1 \
 //thickness=0.36 //x=66.4 //y=0.175 //x2=66.72 //y2=0.175
r2022 (  162 300 ) resistor r=0.028033 //w=0.35 //l=0.085 //layer=m1 \
 //thickness=0.36 //x=71.04 //y=0.175 //x2=71.125 //y2=0.175
r2023 (  162 171 ) resistor r=0.249196 //w=0.311 //l=0.62 //layer=m1 \
 //thickness=0.36 //x=71.04 //y=0.175 //x2=70.42 //y2=0.175
r2024 (  161 294 ) resistor r=0.0942778 //w=0.221 //l=0.13 //layer=m1 \
 //thickness=0.36 //x=66.315 //y=1.015 //x2=66.315 //y2=1.145
r2025 (  160 296 ) resistor r=0.0413265 //w=0.7 //l=0.175 //layer=m1 \
 //thickness=0.36 //x=66.315 //y=0.35 //x2=66.315 //y2=0.175
r2026 (  160 161 ) resistor r=0.634542 //w=0.131 //l=0.665 //layer=m1 \
 //thickness=0.36 //x=66.315 //y=0.35 //x2=66.315 //y2=1.015
r2027 (  159 560 ) resistor r=3.1 //w=0.17 //l=0.51 //layer=mcon //count=3 \
 //x=65.61 //y=0.18 //x2=65.61 //y2=0.18
r2028 (  157 549 ) resistor r=3.1 //w=0.17 //l=0.51 //layer=mcon //count=3 \
 //x=64.13 //y=0.18 //x2=64.13 //y2=0.18
r2029 (  157 159 ) resistor r=0.594855 //w=0.311 //l=1.48 //layer=m1 \
 //thickness=0.36 //x=64.13 //y=0.175 //x2=65.61 //y2=0.175
r2030 (  155 292 ) resistor r=0.028033 //w=0.35 //l=0.085 //layer=m1 \
 //thickness=0.36 //x=63.175 //y=0.175 //x2=63.09 //y2=0.175
r2031 (  155 157 ) resistor r=0.383842 //w=0.311 //l=0.955 //layer=m1 \
 //thickness=0.36 //x=63.175 //y=0.175 //x2=64.13 //y2=0.175
r2032 (  154 296 ) resistor r=0.028033 //w=0.35 //l=0.085 //layer=m1 \
 //thickness=0.36 //x=66.23 //y=0.175 //x2=66.315 //y2=0.175
r2033 (  154 159 ) resistor r=0.249196 //w=0.311 //l=0.62 //layer=m1 \
 //thickness=0.36 //x=66.23 //y=0.175 //x2=65.61 //y2=0.175
r2034 (  152 292 ) resistor r=0.0413265 //w=0.7 //l=0.175 //layer=m1 \
 //thickness=0.36 //x=63.09 //y=0.35 //x2=63.09 //y2=0.175
r2035 (  152 289 ) resistor r=0.625 //w=0.131 //l=0.655 //layer=m1 \
 //thickness=0.36 //x=63.09 //y=0.35 //x2=63.09 //y2=1.005
r2036 (  151 536 ) resistor r=3.1 //w=0.17 //l=0.51 //layer=mcon //count=3 \
 //x=61.54 //y=0.18 //x2=61.54 //y2=0.18
r2037 (  149 534 ) resistor r=3.1 //w=0.17 //l=0.51 //layer=mcon //count=3 \
 //x=60.43 //y=0.18 //x2=60.43 //y2=0.18
r2038 (  149 151 ) resistor r=0.446141 //w=0.311 //l=1.11 //layer=m1 \
 //thickness=0.36 //x=60.43 //y=0.175 //x2=61.54 //y2=0.175
r2039 (  147 532 ) resistor r=3.1 //w=0.17 //l=0.51 //layer=mcon //count=3 \
 //x=59.32 //y=0.18 //x2=59.32 //y2=0.18
r2040 (  147 149 ) resistor r=0.446141 //w=0.311 //l=1.11 //layer=m1 \
 //thickness=0.36 //x=59.32 //y=0.175 //x2=60.43 //y2=0.175
r2041 (  145 286 ) resistor r=0.028033 //w=0.35 //l=0.085 //layer=m1 \
 //thickness=0.36 //x=58.26 //y=0.175 //x2=58.175 //y2=0.175
r2042 (  145 147 ) resistor r=0.426045 //w=0.311 //l=1.06 //layer=m1 \
 //thickness=0.36 //x=58.26 //y=0.175 //x2=59.32 //y2=0.175
r2043 (  144 292 ) resistor r=0.028033 //w=0.35 //l=0.085 //layer=m1 \
 //thickness=0.36 //x=63.005 //y=0.175 //x2=63.09 //y2=0.175
r2044 (  144 151 ) resistor r=0.588826 //w=0.311 //l=1.465 //layer=m1 \
 //thickness=0.36 //x=63.005 //y=0.175 //x2=61.54 //y2=0.175
r2045 (  143 283 ) resistor r=0.0942778 //w=0.221 //l=0.13 //layer=m1 \
 //thickness=0.36 //x=58.175 //y=1.015 //x2=58.175 //y2=1.145
r2046 (  142 286 ) resistor r=0.0413265 //w=0.7 //l=0.175 //layer=m1 \
 //thickness=0.36 //x=58.175 //y=0.35 //x2=58.175 //y2=0.175
r2047 (  142 143 ) resistor r=0.634542 //w=0.131 //l=0.665 //layer=m1 \
 //thickness=0.36 //x=58.175 //y=0.35 //x2=58.175 //y2=1.015
r2048 (  141 519 ) resistor r=3.1 //w=0.17 //l=0.51 //layer=mcon //count=3 \
 //x=56.73 //y=0.18 //x2=56.73 //y2=0.18
r2049 (  139 517 ) resistor r=3.1 //w=0.17 //l=0.51 //layer=mcon //count=3 \
 //x=55.62 //y=0.18 //x2=55.62 //y2=0.18
r2050 (  139 141 ) resistor r=0.446141 //w=0.311 //l=1.11 //layer=m1 \
 //thickness=0.36 //x=55.62 //y=0.175 //x2=56.73 //y2=0.175
r2051 (  137 515 ) resistor r=3.1 //w=0.17 //l=0.51 //layer=mcon //count=3 \
 //x=54.51 //y=0.18 //x2=54.51 //y2=0.18
r2052 (  137 139 ) resistor r=0.446141 //w=0.311 //l=1.11 //layer=m1 \
 //thickness=0.36 //x=54.51 //y=0.175 //x2=55.62 //y2=0.175
r2053 (  135 281 ) resistor r=0.028033 //w=0.35 //l=0.085 //layer=m1 \
 //thickness=0.36 //x=53.45 //y=0.175 //x2=53.365 //y2=0.175
r2054 (  135 137 ) resistor r=0.426045 //w=0.311 //l=1.06 //layer=m1 \
 //thickness=0.36 //x=53.45 //y=0.175 //x2=54.51 //y2=0.175
r2055 (  134 286 ) resistor r=0.028033 //w=0.35 //l=0.085 //layer=m1 \
 //thickness=0.36 //x=58.09 //y=0.175 //x2=58.175 //y2=0.175
r2056 (  134 141 ) resistor r=0.546624 //w=0.311 //l=1.36 //layer=m1 \
 //thickness=0.36 //x=58.09 //y=0.175 //x2=56.73 //y2=0.175
r2057 (  133 278 ) resistor r=0.0942778 //w=0.221 //l=0.13 //layer=m1 \
 //thickness=0.36 //x=53.365 //y=1.015 //x2=53.365 //y2=1.145
r2058 (  132 281 ) resistor r=0.0413265 //w=0.7 //l=0.175 //layer=m1 \
 //thickness=0.36 //x=53.365 //y=0.35 //x2=53.365 //y2=0.175
r2059 (  132 133 ) resistor r=0.634542 //w=0.131 //l=0.665 //layer=m1 \
 //thickness=0.36 //x=53.365 //y=0.35 //x2=53.365 //y2=1.015
r2060 (  131 502 ) resistor r=3.1 //w=0.17 //l=0.51 //layer=mcon //count=3 \
 //x=51.92 //y=0.18 //x2=51.92 //y2=0.18
r2061 (  129 500 ) resistor r=3.1 //w=0.17 //l=0.51 //layer=mcon //count=3 \
 //x=50.81 //y=0.18 //x2=50.81 //y2=0.18
r2062 (  129 131 ) resistor r=0.446141 //w=0.311 //l=1.11 //layer=m1 \
 //thickness=0.36 //x=50.81 //y=0.175 //x2=51.92 //y2=0.175
r2063 (  127 276 ) resistor r=0.028033 //w=0.35 //l=0.085 //layer=m1 \
 //thickness=0.36 //x=50.225 //y=0.175 //x2=50.14 //y2=0.175
r2064 (  127 129 ) resistor r=0.235129 //w=0.311 //l=0.585 //layer=m1 \
 //thickness=0.36 //x=50.225 //y=0.175 //x2=50.81 //y2=0.175
r2065 (  126 281 ) resistor r=0.028033 //w=0.35 //l=0.085 //layer=m1 \
 //thickness=0.36 //x=53.28 //y=0.175 //x2=53.365 //y2=0.175
r2066 (  126 131 ) resistor r=0.546624 //w=0.311 //l=1.36 //layer=m1 \
 //thickness=0.36 //x=53.28 //y=0.175 //x2=51.92 //y2=0.175
r2067 (  124 276 ) resistor r=0.0413265 //w=0.7 //l=0.175 //layer=m1 \
 //thickness=0.36 //x=50.14 //y=0.35 //x2=50.14 //y2=0.175
r2068 (  124 274 ) resistor r=0.625 //w=0.131 //l=0.655 //layer=m1 \
 //thickness=0.36 //x=50.14 //y=0.35 //x2=50.14 //y2=1.005
r2069 (  123 498 ) resistor r=3.1 //w=0.17 //l=0.51 //layer=mcon //count=3 \
 //x=49.7 //y=0.18 //x2=49.7 //y2=0.18
r2070 (  121 487 ) resistor r=3.1 //w=0.17 //l=0.51 //layer=mcon //count=3 \
 //x=48.22 //y=0.18 //x2=48.22 //y2=0.18
r2071 (  121 123 ) resistor r=0.594855 //w=0.311 //l=1.48 //layer=m1 \
 //thickness=0.36 //x=48.22 //y=0.175 //x2=49.7 //y2=0.175
r2072 (  119 485 ) resistor r=3.1 //w=0.17 //l=0.51 //layer=mcon //count=3 \
 //x=47.11 //y=0.18 //x2=47.11 //y2=0.18
r2073 (  119 121 ) resistor r=0.446141 //w=0.311 //l=1.11 //layer=m1 \
 //thickness=0.36 //x=47.11 //y=0.175 //x2=48.22 //y2=0.175
r2074 (  117 483 ) resistor r=3.1 //w=0.17 //l=0.51 //layer=mcon //count=3 \
 //x=46 //y=0.18 //x2=46 //y2=0.18
r2075 (  117 119 ) resistor r=0.446141 //w=0.311 //l=1.11 //layer=m1 \
 //thickness=0.36 //x=46 //y=0.175 //x2=47.11 //y2=0.175
r2076 (  114 271 ) resistor r=0.028033 //w=0.35 //l=0.085 //layer=m1 \
 //thickness=0.36 //x=45.31 //y=0.175 //x2=45.225 //y2=0.175
r2077 (  113 276 ) resistor r=0.028033 //w=0.35 //l=0.085 //layer=m1 \
 //thickness=0.36 //x=50.055 //y=0.175 //x2=50.14 //y2=0.175
r2078 (  113 123 ) resistor r=0.142685 //w=0.311 //l=0.355 //layer=m1 \
 //thickness=0.36 //x=50.055 //y=0.175 //x2=49.7 //y2=0.175
r2079 (  112 269 ) resistor r=0.0942778 //w=0.221 //l=0.13 //layer=m1 \
 //thickness=0.36 //x=45.225 //y=1.015 //x2=45.225 //y2=1.145
r2080 (  111 271 ) resistor r=0.0413265 //w=0.7 //l=0.175 //layer=m1 \
 //thickness=0.36 //x=45.225 //y=0.35 //x2=45.225 //y2=0.175
r2081 (  111 112 ) resistor r=0.634542 //w=0.131 //l=0.665 //layer=m1 \
 //thickness=0.36 //x=45.225 //y=0.35 //x2=45.225 //y2=1.015
r2082 (  110 481 ) resistor r=3.1 //w=0.17 //l=0.51 //layer=mcon //count=3 \
 //x=44.89 //y=0.18 //x2=44.89 //y2=0.18
r2083 (  108 470 ) resistor r=3.1 //w=0.17 //l=0.51 //layer=mcon //count=3 \
 //x=43.41 //y=0.18 //x2=43.41 //y2=0.18
r2084 (  108 110 ) resistor r=0.594855 //w=0.311 //l=1.48 //layer=m1 \
 //thickness=0.36 //x=43.41 //y=0.175 //x2=44.89 //y2=0.175
r2085 (  106 468 ) resistor r=3.1 //w=0.17 //l=0.51 //layer=mcon //count=3 \
 //x=42.3 //y=0.18 //x2=42.3 //y2=0.18
r2086 (  106 108 ) resistor r=0.446141 //w=0.311 //l=1.11 //layer=m1 \
 //thickness=0.36 //x=42.3 //y=0.175 //x2=43.41 //y2=0.175
r2087 (  104 466 ) resistor r=3.1 //w=0.17 //l=0.51 //layer=mcon //count=3 \
 //x=41.19 //y=0.18 //x2=41.19 //y2=0.18
r2088 (  104 106 ) resistor r=0.446141 //w=0.311 //l=1.11 //layer=m1 \
 //thickness=0.36 //x=41.19 //y=0.175 //x2=42.3 //y2=0.175
r2089 (  102 267 ) resistor r=0.028033 //w=0.35 //l=0.085 //layer=m1 \
 //thickness=0.36 //x=40.5 //y=0.175 //x2=40.415 //y2=0.175
r2090 (  102 104 ) resistor r=0.277331 //w=0.311 //l=0.69 //layer=m1 \
 //thickness=0.36 //x=40.5 //y=0.175 //x2=41.19 //y2=0.175
r2091 (  101 271 ) resistor r=0.028033 //w=0.35 //l=0.085 //layer=m1 \
 //thickness=0.36 //x=45.14 //y=0.175 //x2=45.225 //y2=0.175
r2092 (  101 110 ) resistor r=0.100482 //w=0.311 //l=0.25 //layer=m1 \
 //thickness=0.36 //x=45.14 //y=0.175 //x2=44.89 //y2=0.175
r2093 (  100 265 ) resistor r=0.0942778 //w=0.221 //l=0.13 //layer=m1 \
 //thickness=0.36 //x=40.415 //y=1.015 //x2=40.415 //y2=1.145
r2094 (  99 267 ) resistor r=0.0413265 //w=0.7 //l=0.175 //layer=m1 \
 //thickness=0.36 //x=40.415 //y=0.35 //x2=40.415 //y2=0.175
r2095 (  99 100 ) resistor r=0.634542 //w=0.131 //l=0.665 //layer=m1 \
 //thickness=0.36 //x=40.415 //y=0.35 //x2=40.415 //y2=1.015
r2096 (  98 464 ) resistor r=3.1 //w=0.17 //l=0.51 //layer=mcon //count=3 \
 //x=40.08 //y=0.18 //x2=40.08 //y2=0.18
r2097 (  96 453 ) resistor r=3.1 //w=0.17 //l=0.51 //layer=mcon //count=3 \
 //x=38.6 //y=0.18 //x2=38.6 //y2=0.18
r2098 (  96 98 ) resistor r=0.594855 //w=0.311 //l=1.48 //layer=m1 \
 //thickness=0.36 //x=38.6 //y=0.175 //x2=40.08 //y2=0.175
r2099 (  94 451 ) resistor r=3.1 //w=0.17 //l=0.51 //layer=mcon //count=3 \
 //x=37.49 //y=0.18 //x2=37.49 //y2=0.18
r2100 (  94 96 ) resistor r=0.446141 //w=0.311 //l=1.11 //layer=m1 \
 //thickness=0.36 //x=37.49 //y=0.175 //x2=38.6 //y2=0.175
r2101 (  92 263 ) resistor r=0.028033 //w=0.35 //l=0.085 //layer=m1 \
 //thickness=0.36 //x=37.275 //y=0.175 //x2=37.19 //y2=0.175
r2102 (  92 94 ) resistor r=0.0864148 //w=0.311 //l=0.215 //layer=m1 \
 //thickness=0.36 //x=37.275 //y=0.175 //x2=37.49 //y2=0.175
r2103 (  91 267 ) resistor r=0.028033 //w=0.35 //l=0.085 //layer=m1 \
 //thickness=0.36 //x=40.33 //y=0.175 //x2=40.415 //y2=0.175
r2104 (  91 98 ) resistor r=0.100482 //w=0.311 //l=0.25 //layer=m1 \
 //thickness=0.36 //x=40.33 //y=0.175 //x2=40.08 //y2=0.175
r2105 (  89 263 ) resistor r=0.0413265 //w=0.7 //l=0.175 //layer=m1 \
 //thickness=0.36 //x=37.19 //y=0.35 //x2=37.19 //y2=0.175
r2106 (  89 261 ) resistor r=0.625 //w=0.131 //l=0.655 //layer=m1 \
 //thickness=0.36 //x=37.19 //y=0.35 //x2=37.19 //y2=1.005
r2107 (  88 449 ) resistor r=3.1 //w=0.17 //l=0.51 //layer=mcon //count=3 \
 //x=36.38 //y=0.18 //x2=36.38 //y2=0.18
r2108 (  86 438 ) resistor r=3.1 //w=0.17 //l=0.51 //layer=mcon //count=3 \
 //x=34.9 //y=0.18 //x2=34.9 //y2=0.18
r2109 (  86 88 ) resistor r=0.594855 //w=0.311 //l=1.48 //layer=m1 \
 //thickness=0.36 //x=34.9 //y=0.175 //x2=36.38 //y2=0.175
r2110 (  84 436 ) resistor r=3.1 //w=0.17 //l=0.51 //layer=mcon //count=3 \
 //x=33.79 //y=0.18 //x2=33.79 //y2=0.18
r2111 (  84 86 ) resistor r=0.446141 //w=0.311 //l=1.11 //layer=m1 \
 //thickness=0.36 //x=33.79 //y=0.175 //x2=34.9 //y2=0.175
r2112 (  82 434 ) resistor r=3.1 //w=0.17 //l=0.51 //layer=mcon //count=3 \
 //x=32.68 //y=0.18 //x2=32.68 //y2=0.18
r2113 (  82 84 ) resistor r=0.446141 //w=0.311 //l=1.11 //layer=m1 \
 //thickness=0.36 //x=32.68 //y=0.175 //x2=33.79 //y2=0.175
r2114 (  80 258 ) resistor r=0.028033 //w=0.35 //l=0.085 //layer=m1 \
 //thickness=0.36 //x=32.36 //y=0.175 //x2=32.275 //y2=0.175
r2115 (  80 82 ) resistor r=0.128617 //w=0.311 //l=0.32 //layer=m1 \
 //thickness=0.36 //x=32.36 //y=0.175 //x2=32.68 //y2=0.175
r2116 (  79 263 ) resistor r=0.028033 //w=0.35 //l=0.085 //layer=m1 \
 //thickness=0.36 //x=37.105 //y=0.175 //x2=37.19 //y2=0.175
r2117 (  79 88 ) resistor r=0.291399 //w=0.311 //l=0.725 //layer=m1 \
 //thickness=0.36 //x=37.105 //y=0.175 //x2=36.38 //y2=0.175
r2118 (  78 256 ) resistor r=0.0942778 //w=0.221 //l=0.13 //layer=m1 \
 //thickness=0.36 //x=32.275 //y=1.015 //x2=32.275 //y2=1.145
r2119 (  77 258 ) resistor r=0.0413265 //w=0.7 //l=0.175 //layer=m1 \
 //thickness=0.36 //x=32.275 //y=0.35 //x2=32.275 //y2=0.175
r2120 (  77 78 ) resistor r=0.634542 //w=0.131 //l=0.665 //layer=m1 \
 //thickness=0.36 //x=32.275 //y=0.35 //x2=32.275 //y2=1.015
r2121 (  76 432 ) resistor r=3.1 //w=0.17 //l=0.51 //layer=mcon //count=3 \
 //x=31.57 //y=0.18 //x2=31.57 //y2=0.18
r2122 (  74 421 ) resistor r=3.1 //w=0.17 //l=0.51 //layer=mcon //count=3 \
 //x=30.09 //y=0.18 //x2=30.09 //y2=0.18
r2123 (  74 76 ) resistor r=0.594855 //w=0.311 //l=1.48 //layer=m1 \
 //thickness=0.36 //x=30.09 //y=0.175 //x2=31.57 //y2=0.175
r2124 (  72 419 ) resistor r=3.1 //w=0.17 //l=0.51 //layer=mcon //count=3 \
 //x=28.98 //y=0.18 //x2=28.98 //y2=0.18
r2125 (  72 74 ) resistor r=0.446141 //w=0.311 //l=1.11 //layer=m1 \
 //thickness=0.36 //x=28.98 //y=0.175 //x2=30.09 //y2=0.175
r2126 (  70 417 ) resistor r=3.1 //w=0.17 //l=0.51 //layer=mcon //count=3 \
 //x=27.87 //y=0.18 //x2=27.87 //y2=0.18
r2127 (  70 72 ) resistor r=0.446141 //w=0.311 //l=1.11 //layer=m1 \
 //thickness=0.36 //x=27.87 //y=0.175 //x2=28.98 //y2=0.175
r2128 (  68 254 ) resistor r=0.028033 //w=0.35 //l=0.085 //layer=m1 \
 //thickness=0.36 //x=27.55 //y=0.175 //x2=27.465 //y2=0.175
r2129 (  68 70 ) resistor r=0.128617 //w=0.311 //l=0.32 //layer=m1 \
 //thickness=0.36 //x=27.55 //y=0.175 //x2=27.87 //y2=0.175
r2130 (  67 258 ) resistor r=0.028033 //w=0.35 //l=0.085 //layer=m1 \
 //thickness=0.36 //x=32.19 //y=0.175 //x2=32.275 //y2=0.175
r2131 (  67 76 ) resistor r=0.249196 //w=0.311 //l=0.62 //layer=m1 \
 //thickness=0.36 //x=32.19 //y=0.175 //x2=31.57 //y2=0.175
r2132 (  66 252 ) resistor r=0.0942778 //w=0.221 //l=0.13 //layer=m1 \
 //thickness=0.36 //x=27.465 //y=1.015 //x2=27.465 //y2=1.145
r2133 (  65 254 ) resistor r=0.0413265 //w=0.7 //l=0.175 //layer=m1 \
 //thickness=0.36 //x=27.465 //y=0.35 //x2=27.465 //y2=0.175
r2134 (  65 66 ) resistor r=0.634542 //w=0.131 //l=0.665 //layer=m1 \
 //thickness=0.36 //x=27.465 //y=0.35 //x2=27.465 //y2=1.015
r2135 (  64 415 ) resistor r=3.1 //w=0.17 //l=0.51 //layer=mcon //count=3 \
 //x=26.76 //y=0.18 //x2=26.76 //y2=0.18
r2136 (  62 404 ) resistor r=3.1 //w=0.17 //l=0.51 //layer=mcon //count=3 \
 //x=25.28 //y=0.18 //x2=25.28 //y2=0.18
r2137 (  62 64 ) resistor r=0.594855 //w=0.311 //l=1.48 //layer=m1 \
 //thickness=0.36 //x=25.28 //y=0.175 //x2=26.76 //y2=0.175
r2138 (  60 250 ) resistor r=0.028033 //w=0.35 //l=0.085 //layer=m1 \
 //thickness=0.36 //x=24.325 //y=0.175 //x2=24.24 //y2=0.175
r2139 (  60 62 ) resistor r=0.383842 //w=0.311 //l=0.955 //layer=m1 \
 //thickness=0.36 //x=24.325 //y=0.175 //x2=25.28 //y2=0.175
r2140 (  59 254 ) resistor r=0.028033 //w=0.35 //l=0.085 //layer=m1 \
 //thickness=0.36 //x=27.38 //y=0.175 //x2=27.465 //y2=0.175
r2141 (  59 64 ) resistor r=0.249196 //w=0.311 //l=0.62 //layer=m1 \
 //thickness=0.36 //x=27.38 //y=0.175 //x2=26.76 //y2=0.175
r2142 (  57 250 ) resistor r=0.0413265 //w=0.7 //l=0.175 //layer=m1 \
 //thickness=0.36 //x=24.24 //y=0.35 //x2=24.24 //y2=0.175
r2143 (  57 247 ) resistor r=0.625 //w=0.131 //l=0.655 //layer=m1 \
 //thickness=0.36 //x=24.24 //y=0.35 //x2=24.24 //y2=1.005
r2144 (  56 391 ) resistor r=3.1 //w=0.17 //l=0.51 //layer=mcon //count=3 \
 //x=22.69 //y=0.18 //x2=22.69 //y2=0.18
r2145 (  54 389 ) resistor r=3.1 //w=0.17 //l=0.51 //layer=mcon //count=3 \
 //x=21.58 //y=0.18 //x2=21.58 //y2=0.18
r2146 (  54 56 ) resistor r=0.446141 //w=0.311 //l=1.11 //layer=m1 \
 //thickness=0.36 //x=21.58 //y=0.175 //x2=22.69 //y2=0.175
r2147 (  52 387 ) resistor r=3.1 //w=0.17 //l=0.51 //layer=mcon //count=3 \
 //x=20.47 //y=0.18 //x2=20.47 //y2=0.18
r2148 (  52 54 ) resistor r=0.446141 //w=0.311 //l=1.11 //layer=m1 \
 //thickness=0.36 //x=20.47 //y=0.175 //x2=21.58 //y2=0.175
r2149 (  50 244 ) resistor r=0.028033 //w=0.35 //l=0.085 //layer=m1 \
 //thickness=0.36 //x=19.41 //y=0.175 //x2=19.325 //y2=0.175
r2150 (  50 52 ) resistor r=0.426045 //w=0.311 //l=1.06 //layer=m1 \
 //thickness=0.36 //x=19.41 //y=0.175 //x2=20.47 //y2=0.175
r2151 (  49 250 ) resistor r=0.028033 //w=0.35 //l=0.085 //layer=m1 \
 //thickness=0.36 //x=24.155 //y=0.175 //x2=24.24 //y2=0.175
r2152 (  49 56 ) resistor r=0.588826 //w=0.311 //l=1.465 //layer=m1 \
 //thickness=0.36 //x=24.155 //y=0.175 //x2=22.69 //y2=0.175
r2153 (  48 241 ) resistor r=0.0942778 //w=0.221 //l=0.13 //layer=m1 \
 //thickness=0.36 //x=19.325 //y=1.015 //x2=19.325 //y2=1.145
r2154 (  47 244 ) resistor r=0.0413265 //w=0.7 //l=0.175 //layer=m1 \
 //thickness=0.36 //x=19.325 //y=0.35 //x2=19.325 //y2=0.175
r2155 (  47 48 ) resistor r=0.634542 //w=0.131 //l=0.665 //layer=m1 \
 //thickness=0.36 //x=19.325 //y=0.35 //x2=19.325 //y2=1.015
r2156 (  46 374 ) resistor r=3.1 //w=0.17 //l=0.51 //layer=mcon //count=3 \
 //x=17.88 //y=0.18 //x2=17.88 //y2=0.18
r2157 (  44 372 ) resistor r=3.1 //w=0.17 //l=0.51 //layer=mcon //count=3 \
 //x=16.77 //y=0.18 //x2=16.77 //y2=0.18
r2158 (  44 46 ) resistor r=0.446141 //w=0.311 //l=1.11 //layer=m1 \
 //thickness=0.36 //x=16.77 //y=0.175 //x2=17.88 //y2=0.175
r2159 (  42 370 ) resistor r=3.1 //w=0.17 //l=0.51 //layer=mcon //count=3 \
 //x=15.66 //y=0.18 //x2=15.66 //y2=0.18
r2160 (  42 44 ) resistor r=0.446141 //w=0.311 //l=1.11 //layer=m1 \
 //thickness=0.36 //x=15.66 //y=0.175 //x2=16.77 //y2=0.175
r2161 (  40 239 ) resistor r=0.028033 //w=0.35 //l=0.085 //layer=m1 \
 //thickness=0.36 //x=14.6 //y=0.175 //x2=14.515 //y2=0.175
r2162 (  40 42 ) resistor r=0.426045 //w=0.311 //l=1.06 //layer=m1 \
 //thickness=0.36 //x=14.6 //y=0.175 //x2=15.66 //y2=0.175
r2163 (  39 244 ) resistor r=0.028033 //w=0.35 //l=0.085 //layer=m1 \
 //thickness=0.36 //x=19.24 //y=0.175 //x2=19.325 //y2=0.175
r2164 (  39 46 ) resistor r=0.546624 //w=0.311 //l=1.36 //layer=m1 \
 //thickness=0.36 //x=19.24 //y=0.175 //x2=17.88 //y2=0.175
r2165 (  38 236 ) resistor r=0.0942778 //w=0.221 //l=0.13 //layer=m1 \
 //thickness=0.36 //x=14.515 //y=1.015 //x2=14.515 //y2=1.145
r2166 (  37 239 ) resistor r=0.0413265 //w=0.7 //l=0.175 //layer=m1 \
 //thickness=0.36 //x=14.515 //y=0.35 //x2=14.515 //y2=0.175
r2167 (  37 38 ) resistor r=0.634542 //w=0.131 //l=0.665 //layer=m1 \
 //thickness=0.36 //x=14.515 //y=0.35 //x2=14.515 //y2=1.015
r2168 (  36 357 ) resistor r=3.1 //w=0.17 //l=0.51 //layer=mcon //count=3 \
 //x=13.07 //y=0.18 //x2=13.07 //y2=0.18
r2169 (  34 355 ) resistor r=3.1 //w=0.17 //l=0.51 //layer=mcon //count=3 \
 //x=11.96 //y=0.18 //x2=11.96 //y2=0.18
r2170 (  34 36 ) resistor r=0.446141 //w=0.311 //l=1.11 //layer=m1 \
 //thickness=0.36 //x=11.96 //y=0.175 //x2=13.07 //y2=0.175
r2171 (  32 234 ) resistor r=0.028033 //w=0.35 //l=0.085 //layer=m1 \
 //thickness=0.36 //x=11.375 //y=0.175 //x2=11.29 //y2=0.175
r2172 (  32 34 ) resistor r=0.235129 //w=0.311 //l=0.585 //layer=m1 \
 //thickness=0.36 //x=11.375 //y=0.175 //x2=11.96 //y2=0.175
r2173 (  31 239 ) resistor r=0.028033 //w=0.35 //l=0.085 //layer=m1 \
 //thickness=0.36 //x=14.43 //y=0.175 //x2=14.515 //y2=0.175
r2174 (  31 36 ) resistor r=0.546624 //w=0.311 //l=1.36 //layer=m1 \
 //thickness=0.36 //x=14.43 //y=0.175 //x2=13.07 //y2=0.175
r2175 (  29 234 ) resistor r=0.0413265 //w=0.7 //l=0.175 //layer=m1 \
 //thickness=0.36 //x=11.29 //y=0.35 //x2=11.29 //y2=0.175
r2176 (  29 232 ) resistor r=0.625 //w=0.131 //l=0.655 //layer=m1 \
 //thickness=0.36 //x=11.29 //y=0.35 //x2=11.29 //y2=1.005
r2177 (  28 353 ) resistor r=3.1 //w=0.17 //l=0.51 //layer=mcon //count=3 \
 //x=10.85 //y=0.18 //x2=10.85 //y2=0.18
r2178 (  26 342 ) resistor r=3.1 //w=0.17 //l=0.51 //layer=mcon //count=3 \
 //x=9.37 //y=0.18 //x2=9.37 //y2=0.18
r2179 (  26 28 ) resistor r=0.594855 //w=0.311 //l=1.48 //layer=m1 \
 //thickness=0.36 //x=9.37 //y=0.175 //x2=10.85 //y2=0.175
r2180 (  24 340 ) resistor r=3.1 //w=0.17 //l=0.51 //layer=mcon //count=3 \
 //x=8.26 //y=0.18 //x2=8.26 //y2=0.18
r2181 (  24 26 ) resistor r=0.446141 //w=0.311 //l=1.11 //layer=m1 \
 //thickness=0.36 //x=8.26 //y=0.175 //x2=9.37 //y2=0.175
r2182 (  22 338 ) resistor r=3.1 //w=0.17 //l=0.51 //layer=mcon //count=3 \
 //x=7.15 //y=0.18 //x2=7.15 //y2=0.18
r2183 (  22 24 ) resistor r=0.446141 //w=0.311 //l=1.11 //layer=m1 \
 //thickness=0.36 //x=7.15 //y=0.175 //x2=8.26 //y2=0.175
r2184 (  20 229 ) resistor r=0.028033 //w=0.35 //l=0.085 //layer=m1 \
 //thickness=0.36 //x=6.46 //y=0.175 //x2=6.375 //y2=0.175
r2185 (  20 22 ) resistor r=0.277331 //w=0.311 //l=0.69 //layer=m1 \
 //thickness=0.36 //x=6.46 //y=0.175 //x2=7.15 //y2=0.175
r2186 (  19 234 ) resistor r=0.028033 //w=0.35 //l=0.085 //layer=m1 \
 //thickness=0.36 //x=11.205 //y=0.175 //x2=11.29 //y2=0.175
r2187 (  19 28 ) resistor r=0.142685 //w=0.311 //l=0.355 //layer=m1 \
 //thickness=0.36 //x=11.205 //y=0.175 //x2=10.85 //y2=0.175
r2188 (  18 227 ) resistor r=0.0942778 //w=0.221 //l=0.13 //layer=m1 \
 //thickness=0.36 //x=6.375 //y=1.015 //x2=6.375 //y2=1.145
r2189 (  17 229 ) resistor r=0.0413265 //w=0.7 //l=0.175 //layer=m1 \
 //thickness=0.36 //x=6.375 //y=0.35 //x2=6.375 //y2=0.175
r2190 (  17 18 ) resistor r=0.634542 //w=0.131 //l=0.665 //layer=m1 \
 //thickness=0.36 //x=6.375 //y=0.35 //x2=6.375 //y2=1.015
r2191 (  16 336 ) resistor r=3.1 //w=0.17 //l=0.51 //layer=mcon //count=3 \
 //x=6.04 //y=0.18 //x2=6.04 //y2=0.18
r2192 (  14 325 ) resistor r=3.1 //w=0.17 //l=0.51 //layer=mcon //count=3 \
 //x=4.56 //y=0.18 //x2=4.56 //y2=0.18
r2193 (  14 16 ) resistor r=0.594855 //w=0.311 //l=1.48 //layer=m1 \
 //thickness=0.36 //x=4.56 //y=0.175 //x2=6.04 //y2=0.175
r2194 (  12 323 ) resistor r=3.1 //w=0.17 //l=0.51 //layer=mcon //count=3 \
 //x=3.45 //y=0.18 //x2=3.45 //y2=0.18
r2195 (  12 14 ) resistor r=0.446141 //w=0.311 //l=1.11 //layer=m1 \
 //thickness=0.36 //x=3.45 //y=0.175 //x2=4.56 //y2=0.175
r2196 (  10 321 ) resistor r=3.1 //w=0.17 //l=0.51 //layer=mcon //count=3 \
 //x=2.34 //y=0.18 //x2=2.34 //y2=0.18
r2197 (  10 12 ) resistor r=0.446141 //w=0.311 //l=1.11 //layer=m1 \
 //thickness=0.36 //x=2.34 //y=0.175 //x2=3.45 //y2=0.175
r2198 (  8 225 ) resistor r=0.028033 //w=0.35 //l=0.085 //layer=m1 \
 //thickness=0.36 //x=1.65 //y=0.175 //x2=1.565 //y2=0.175
r2199 (  8 10 ) resistor r=0.277331 //w=0.311 //l=0.69 //layer=m1 \
 //thickness=0.36 //x=1.65 //y=0.175 //x2=2.34 //y2=0.175
r2200 (  7 229 ) resistor r=0.028033 //w=0.35 //l=0.085 //layer=m1 \
 //thickness=0.36 //x=6.29 //y=0.175 //x2=6.375 //y2=0.175
r2201 (  7 16 ) resistor r=0.100482 //w=0.311 //l=0.25 //layer=m1 \
 //thickness=0.36 //x=6.29 //y=0.175 //x2=6.04 //y2=0.175
r2202 (  6 223 ) resistor r=0.0942778 //w=0.221 //l=0.13 //layer=m1 \
 //thickness=0.36 //x=1.565 //y=1.015 //x2=1.565 //y2=1.145
r2203 (  5 225 ) resistor r=0.0413265 //w=0.7 //l=0.175 //layer=m1 \
 //thickness=0.36 //x=1.565 //y=0.35 //x2=1.565 //y2=0.175
r2204 (  5 6 ) resistor r=0.634542 //w=0.131 //l=0.665 //layer=m1 \
 //thickness=0.36 //x=1.565 //y=0.35 //x2=1.565 //y2=1.015
r2205 (  4 319 ) resistor r=3.1 //w=0.17 //l=0.51 //layer=mcon //count=3 \
 //x=1.23 //y=0.18 //x2=1.23 //y2=0.18
r2206 (  2 225 ) resistor r=0.028033 //w=0.35 //l=0.085 //layer=m1 \
 //thickness=0.36 //x=1.48 //y=0.175 //x2=1.565 //y2=0.175
r2207 (  2 4 ) resistor r=0.0892857 //w=0.35 //l=0.25 //layer=m1 \
 //thickness=0.36 //x=1.48 //y=0.175 //x2=1.23 //y2=0.175
r2208 (  1 117 ) resistor r=0.223071 //w=0.311 //l=0.555 //layer=m1 \
 //thickness=0.36 //x=45.445 //y=0.175 //x2=46 //y2=0.175
r2209 (  1 114 ) resistor r=0.0542605 //w=0.311 //l=0.135 //layer=m1 \
 //thickness=0.36 //x=45.445 //y=0.175 //x2=45.31 //y2=0.175
ends PM_TMRDFFRNQX1\%GND

subckt PM_TMRDFFRNQX1\%Q ( 1 2 3 4 5 6 7 9 11 12 13 14 15 26 36 43 45 )
c80 ( 43 0 ) capacitor c=0.00875839f //x=89.105 //y=1.09
c81 ( 36 0 ) capacitor c=0.0261871f //x=89.295 //y=5.56
c82 ( 26 0 ) capacitor c=0.0196817f //x=89.29 //y=1.185
c83 ( 15 0 ) capacitor c=0.00557311f //x=89.38 //y=5.14
c84 ( 14 0 ) capacitor c=0.00944012f //x=89.575 //y=5.14
c85 ( 13 0 ) capacitor c=0.00724565f //x=89.375 //y=2.02
c86 ( 12 0 ) capacitor c=0.0145753f //x=89.575 //y=2.02
c87 ( 11 0 ) capacitor c=0.0117946f //x=89.295 //y=5.42
c88 ( 9 0 ) capacitor c=0.0166561f //x=89.29 //y=1.935
c89 ( 1 0 ) capacitor c=0.116158f //x=89.66 //y=2.4
r90 (  36 45 ) resistor r=23.615 //w=0.187 //l=0.345 //layer=li \
 //thickness=0.1 //x=89.295 //y=5.56 //x2=89.295 //y2=5.905
r91 (  29 36 ) resistor r=9.3 //w=0.17 //l=0.17 //layer=mcon //count=1 \
 //x=89.295 //y=5.56 //x2=89.295 //y2=5.56
r92 (  26 43 ) resistor r=9.3 //w=0.17 //l=0.17 //layer=mcon //count=1 \
 //x=89.29 //y=1.185 //x2=89.29 //y2=1.185
r93 (  14 17 ) resistor r=0.0698411 //w=0.17 //l=0.120208 //layer=m1 \
 //thickness=0.36 //x=89.575 //y=5.14 //x2=89.66 //y2=5.055
r94 (  14 15 ) resistor r=0.186069 //w=0.131 //l=0.195 //layer=m1 \
 //thickness=0.36 //x=89.575 //y=5.14 //x2=89.38 //y2=5.14
r95 (  12 16 ) resistor r=0.0698411 //w=0.17 //l=0.120208 //layer=m1 \
 //thickness=0.36 //x=89.575 //y=2.02 //x2=89.66 //y2=2.105
r96 (  12 13 ) resistor r=0.19084 //w=0.131 //l=0.2 //layer=m1 \
 //thickness=0.36 //x=89.575 //y=2.02 //x2=89.375 //y2=2.02
r97 (  11 29 ) resistor r=0.086672 //w=0.218 //l=0.14 //layer=m1 \
 //thickness=0.36 //x=89.295 //y=5.42 //x2=89.295 //y2=5.56
r98 (  10 15 ) resistor r=0.0698411 //w=0.17 //l=0.120208 //layer=m1 \
 //thickness=0.36 //x=89.295 //y=5.225 //x2=89.38 //y2=5.14
r99 (  10 11 ) resistor r=0.186069 //w=0.131 //l=0.195 //layer=m1 \
 //thickness=0.36 //x=89.295 //y=5.225 //x2=89.295 //y2=5.42
r100 (  9 13 ) resistor r=0.0698411 //w=0.17 //l=0.120208 //layer=m1 \
 //thickness=0.36 //x=89.29 //y=1.935 //x2=89.375 //y2=2.02
r101 (  8 26 ) resistor r=0.105739 //w=0.201 //l=0.145 //layer=m1 \
 //thickness=0.36 //x=89.29 //y=1.33 //x2=89.29 //y2=1.185
r102 (  8 9 ) resistor r=0.57729 //w=0.131 //l=0.605 //layer=m1 \
 //thickness=0.36 //x=89.29 //y=1.33 //x2=89.29 //y2=1.935
r103 (  7 17 ) resistor r=0.415076 //w=0.131 //l=0.435 //layer=m1 \
 //thickness=0.36 //x=89.66 //y=4.62 //x2=89.66 //y2=5.055
r104 (  6 7 ) resistor r=0.353053 //w=0.131 //l=0.37 //layer=m1 \
 //thickness=0.36 //x=89.66 //y=4.25 //x2=89.66 //y2=4.62
r105 (  5 6 ) resistor r=0.353053 //w=0.131 //l=0.37 //layer=m1 \
 //thickness=0.36 //x=89.66 //y=3.88 //x2=89.66 //y2=4.25
r106 (  4 5 ) resistor r=0.353053 //w=0.131 //l=0.37 //layer=m1 \
 //thickness=0.36 //x=89.66 //y=3.51 //x2=89.66 //y2=3.88
r107 (  3 4 ) resistor r=0.353053 //w=0.131 //l=0.37 //layer=m1 \
 //thickness=0.36 //x=89.66 //y=3.14 //x2=89.66 //y2=3.51
r108 (  2 3 ) resistor r=0.353053 //w=0.131 //l=0.37 //layer=m1 \
 //thickness=0.36 //x=89.66 //y=2.77 //x2=89.66 //y2=3.14
r109 (  1 2 ) resistor r=0.353053 //w=0.131 //l=0.37 //layer=m1 \
 //thickness=0.36 //x=89.66 //y=2.4 //x2=89.66 //y2=2.77
r110 (  1 16 ) resistor r=0.281489 //w=0.131 //l=0.295 //layer=m1 \
 //thickness=0.36 //x=89.66 //y=2.4 //x2=89.66 //y2=2.105
ends PM_TMRDFFRNQX1\%Q

subckt PM_TMRDFFRNQX1\%noxref_36 ( 1 5 9 13 17 35 )
c54 ( 35 0 ) capacitor c=0.0720943f //x=0.945 //y=0.555
c55 ( 17 0 ) capacitor c=0.0221074f //x=2.935 //y=1.77
c56 ( 13 0 ) capacitor c=0.0153941f //x=2.935 //y=0.72
c57 ( 9 0 ) capacitor c=0.00772076f //x=2.05 //y=0.805
c58 ( 5 0 ) capacitor c=0.0198385f //x=1.965 //y=1.77
c59 ( 1 0 ) capacitor c=0.0109947f //x=1.08 //y=1.685
r60 (  18 35 ) resistor r=5.4201 //w=0.17 //l=0.103078 //layer=li \
 //thickness=0.1 //x=2.135 //y=1.77 //x2=2.05 //y2=1.81
r61 (  18 35 ) resistor r=27.3797 //w=0.187 //l=0.4 //layer=li //thickness=0.1 \
 //x=2.135 //y=1.77 //x2=2.535 //y2=1.77
r62 (  17 35 ) resistor r=0.751729 //w=0.17 //l=0.085 //layer=li \
 //thickness=0.1 //x=2.935 //y=1.77 //x2=3.02 //y2=1.77
r63 (  17 35 ) resistor r=27.3797 //w=0.187 //l=0.4 //layer=li //thickness=0.1 \
 //x=2.935 //y=1.77 //x2=2.535 //y2=1.77
r64 (  14 35 ) resistor r=3.57586 //w=0.17 //l=0.103078 //layer=li \
 //thickness=0.1 //x=2.135 //y=0.72 //x2=2.05 //y2=0.68
r65 (  14 35 ) resistor r=27.3797 //w=0.187 //l=0.4 //layer=li //thickness=0.1 \
 //x=2.135 //y=0.72 //x2=2.535 //y2=0.72
r66 (  13 35 ) resistor r=0.751729 //w=0.17 //l=0.085 //layer=li \
 //thickness=0.1 //x=2.935 //y=0.72 //x2=3.02 //y2=0.72
r67 (  13 35 ) resistor r=27.3797 //w=0.187 //l=0.4 //layer=li //thickness=0.1 \
 //x=2.935 //y=0.72 //x2=2.535 //y2=0.72
r68 (  10 35 ) resistor r=1.40859 //w=0.34 //l=0.125 //layer=li \
 //thickness=0.1 //x=2.05 //y=1.685 //x2=2.05 //y2=1.81
r69 (  10 35 ) resistor r=42.0963 //w=0.187 //l=0.615 //layer=li \
 //thickness=0.1 //x=2.05 //y=1.685 //x2=2.05 //y2=1.07
r70 (  9 35 ) resistor r=3.57586 //w=0.17 //l=0.125 //layer=li //thickness=0.1 \
 //x=2.05 //y=0.805 //x2=2.05 //y2=0.68
r71 (  9 35 ) resistor r=18.139 //w=0.187 //l=0.265 //layer=li //thickness=0.1 \
 //x=2.05 //y=0.805 //x2=2.05 //y2=1.07
r72 (  6 35 ) resistor r=3.57586 //w=0.17 //l=0.103078 //layer=li \
 //thickness=0.1 //x=1.165 //y=1.77 //x2=1.08 //y2=1.81
r73 (  6 35 ) resistor r=27.3797 //w=0.187 //l=0.4 //layer=li //thickness=0.1 \
 //x=1.165 //y=1.77 //x2=1.565 //y2=1.77
r74 (  5 35 ) resistor r=5.4201 //w=0.17 //l=0.103078 //layer=li \
 //thickness=0.1 //x=1.965 //y=1.77 //x2=2.05 //y2=1.81
r75 (  5 35 ) resistor r=27.3797 //w=0.187 //l=0.4 //layer=li //thickness=0.1 \
 //x=1.965 //y=1.77 //x2=1.565 //y2=1.77
r76 (  1 35 ) resistor r=3.57586 //w=0.17 //l=0.125 //layer=li //thickness=0.1 \
 //x=1.08 //y=1.685 //x2=1.08 //y2=1.81
r77 (  1 35 ) resistor r=42.0963 //w=0.187 //l=0.615 //layer=li \
 //thickness=0.1 //x=1.08 //y=1.685 //x2=1.08 //y2=1.07
ends PM_TMRDFFRNQX1\%noxref_36

subckt PM_TMRDFFRNQX1\%noxref_37 ( 1 5 9 13 17 35 )
c60 ( 35 0 ) capacitor c=0.0698511f //x=5.755 //y=0.555
c61 ( 17 0 ) capacitor c=0.0204478f //x=7.745 //y=1.77
c62 ( 13 0 ) capacitor c=0.0153311f //x=7.745 //y=0.72
c63 ( 9 0 ) capacitor c=0.00772076f //x=6.86 //y=0.805
c64 ( 5 0 ) capacitor c=0.0180187f //x=6.775 //y=1.77
c65 ( 1 0 ) capacitor c=0.00771772f //x=5.89 //y=1.685
r66 (  18 35 ) resistor r=5.4201 //w=0.17 //l=0.103078 //layer=li \
 //thickness=0.1 //x=6.945 //y=1.77 //x2=6.86 //y2=1.81
r67 (  18 35 ) resistor r=27.3797 //w=0.187 //l=0.4 //layer=li //thickness=0.1 \
 //x=6.945 //y=1.77 //x2=7.345 //y2=1.77
r68 (  17 35 ) resistor r=0.751729 //w=0.17 //l=0.085 //layer=li \
 //thickness=0.1 //x=7.745 //y=1.77 //x2=7.83 //y2=1.77
r69 (  17 35 ) resistor r=27.3797 //w=0.187 //l=0.4 //layer=li //thickness=0.1 \
 //x=7.745 //y=1.77 //x2=7.345 //y2=1.77
r70 (  14 35 ) resistor r=3.57586 //w=0.17 //l=0.103078 //layer=li \
 //thickness=0.1 //x=6.945 //y=0.72 //x2=6.86 //y2=0.68
r71 (  14 35 ) resistor r=27.3797 //w=0.187 //l=0.4 //layer=li //thickness=0.1 \
 //x=6.945 //y=0.72 //x2=7.345 //y2=0.72
r72 (  13 35 ) resistor r=0.751729 //w=0.17 //l=0.085 //layer=li \
 //thickness=0.1 //x=7.745 //y=0.72 //x2=7.83 //y2=0.72
r73 (  13 35 ) resistor r=27.3797 //w=0.187 //l=0.4 //layer=li //thickness=0.1 \
 //x=7.745 //y=0.72 //x2=7.345 //y2=0.72
r74 (  10 35 ) resistor r=1.40859 //w=0.34 //l=0.125 //layer=li \
 //thickness=0.1 //x=6.86 //y=1.685 //x2=6.86 //y2=1.81
r75 (  10 35 ) resistor r=42.0963 //w=0.187 //l=0.615 //layer=li \
 //thickness=0.1 //x=6.86 //y=1.685 //x2=6.86 //y2=1.07
r76 (  9 35 ) resistor r=3.57586 //w=0.17 //l=0.125 //layer=li //thickness=0.1 \
 //x=6.86 //y=0.805 //x2=6.86 //y2=0.68
r77 (  9 35 ) resistor r=18.139 //w=0.187 //l=0.265 //layer=li //thickness=0.1 \
 //x=6.86 //y=0.805 //x2=6.86 //y2=1.07
r78 (  6 35 ) resistor r=3.57586 //w=0.17 //l=0.103078 //layer=li \
 //thickness=0.1 //x=5.975 //y=1.77 //x2=5.89 //y2=1.81
r79 (  6 35 ) resistor r=27.3797 //w=0.187 //l=0.4 //layer=li //thickness=0.1 \
 //x=5.975 //y=1.77 //x2=6.375 //y2=1.77
r80 (  5 35 ) resistor r=5.4201 //w=0.17 //l=0.103078 //layer=li \
 //thickness=0.1 //x=6.775 //y=1.77 //x2=6.86 //y2=1.81
r81 (  5 35 ) resistor r=27.3797 //w=0.187 //l=0.4 //layer=li //thickness=0.1 \
 //x=6.775 //y=1.77 //x2=6.375 //y2=1.77
r82 (  1 35 ) resistor r=3.57586 //w=0.17 //l=0.125 //layer=li //thickness=0.1 \
 //x=5.89 //y=1.685 //x2=5.89 //y2=1.81
r83 (  1 35 ) resistor r=42.0963 //w=0.187 //l=0.615 //layer=li \
 //thickness=0.1 //x=5.89 //y=1.685 //x2=5.89 //y2=1.07
ends PM_TMRDFFRNQX1\%noxref_37

subckt PM_TMRDFFRNQX1\%noxref_38 ( 1 5 9 10 13 17 29 )
c67 ( 29 0 ) capacitor c=0.067062f //x=10.67 //y=0.545
c68 ( 17 0 ) capacitor c=0.00675704f //x=12.745 //y=0.795
c69 ( 13 0 ) capacitor c=0.0156329f //x=12.66 //y=0.71
c70 ( 10 0 ) capacitor c=0.00673372f //x=11.775 //y=1.675
c71 ( 9 0 ) capacitor c=0.00770028f //x=11.775 //y=0.795
c72 ( 5 0 ) capacitor c=0.0179513f //x=11.69 //y=1.76
c73 ( 1 0 ) capacitor c=0.00761099f //x=10.805 //y=1.675
r74 (  17 29 ) resistor r=3.57586 //w=0.17 //l=0.125 //layer=li \
 //thickness=0.1 //x=12.745 //y=0.795 //x2=12.745 //y2=0.67
r75 (  17 29 ) resistor r=18.139 //w=0.187 //l=0.265 //layer=li \
 //thickness=0.1 //x=12.745 //y=0.795 //x2=12.745 //y2=1.06
r76 (  14 29 ) resistor r=3.57586 //w=0.17 //l=0.103078 //layer=li \
 //thickness=0.1 //x=11.86 //y=0.71 //x2=11.775 //y2=0.67
r77 (  14 29 ) resistor r=27.3797 //w=0.187 //l=0.4 //layer=li //thickness=0.1 \
 //x=11.86 //y=0.71 //x2=12.26 //y2=0.71
r78 (  13 29 ) resistor r=3.57586 //w=0.17 //l=0.103078 //layer=li \
 //thickness=0.1 //x=12.66 //y=0.71 //x2=12.745 //y2=0.67
r79 (  13 29 ) resistor r=27.3797 //w=0.187 //l=0.4 //layer=li //thickness=0.1 \
 //x=12.66 //y=0.71 //x2=12.26 //y2=0.71
r80 (  10 29 ) resistor r=3.57586 //w=0.17 //l=0.125 //layer=li \
 //thickness=0.1 //x=11.775 //y=1.675 //x2=11.775 //y2=1.8
r81 (  10 29 ) resistor r=42.0963 //w=0.187 //l=0.615 //layer=li \
 //thickness=0.1 //x=11.775 //y=1.675 //x2=11.775 //y2=1.06
r82 (  9 29 ) resistor r=3.57586 //w=0.17 //l=0.125 //layer=li //thickness=0.1 \
 //x=11.775 //y=0.795 //x2=11.775 //y2=0.67
r83 (  9 29 ) resistor r=18.139 //w=0.187 //l=0.265 //layer=li //thickness=0.1 \
 //x=11.775 //y=0.795 //x2=11.775 //y2=1.06
r84 (  6 29 ) resistor r=3.57586 //w=0.17 //l=0.103078 //layer=li \
 //thickness=0.1 //x=10.89 //y=1.76 //x2=10.805 //y2=1.8
r85 (  6 29 ) resistor r=27.3797 //w=0.187 //l=0.4 //layer=li //thickness=0.1 \
 //x=10.89 //y=1.76 //x2=11.29 //y2=1.76
r86 (  5 29 ) resistor r=3.57586 //w=0.17 //l=0.103078 //layer=li \
 //thickness=0.1 //x=11.69 //y=1.76 //x2=11.775 //y2=1.8
r87 (  5 29 ) resistor r=27.3797 //w=0.187 //l=0.4 //layer=li //thickness=0.1 \
 //x=11.69 //y=1.76 //x2=11.29 //y2=1.76
r88 (  1 29 ) resistor r=3.57586 //w=0.17 //l=0.125 //layer=li //thickness=0.1 \
 //x=10.805 //y=1.675 //x2=10.805 //y2=1.8
r89 (  1 29 ) resistor r=42.0963 //w=0.187 //l=0.615 //layer=li \
 //thickness=0.1 //x=10.805 //y=1.675 //x2=10.805 //y2=1.06
ends PM_TMRDFFRNQX1\%noxref_38

subckt PM_TMRDFFRNQX1\%noxref_39 ( 1 5 9 13 17 35 )
c58 ( 35 0 ) capacitor c=0.068832f //x=13.895 //y=0.555
c59 ( 17 0 ) capacitor c=0.0190725f //x=15.885 //y=1.77
c60 ( 13 0 ) capacitor c=0.015325f //x=15.885 //y=0.72
c61 ( 9 0 ) capacitor c=0.00772076f //x=15 //y=0.805
c62 ( 5 0 ) capacitor c=0.0168501f //x=14.915 //y=1.77
c63 ( 1 0 ) capacitor c=0.00709556f //x=14.03 //y=1.685
r64 (  18 35 ) resistor r=5.4201 //w=0.17 //l=0.103078 //layer=li \
 //thickness=0.1 //x=15.085 //y=1.77 //x2=15 //y2=1.81
r65 (  18 35 ) resistor r=27.3797 //w=0.187 //l=0.4 //layer=li //thickness=0.1 \
 //x=15.085 //y=1.77 //x2=15.485 //y2=1.77
r66 (  17 35 ) resistor r=0.751729 //w=0.17 //l=0.085 //layer=li \
 //thickness=0.1 //x=15.885 //y=1.77 //x2=15.97 //y2=1.77
r67 (  17 35 ) resistor r=27.3797 //w=0.187 //l=0.4 //layer=li //thickness=0.1 \
 //x=15.885 //y=1.77 //x2=15.485 //y2=1.77
r68 (  14 35 ) resistor r=3.57586 //w=0.17 //l=0.103078 //layer=li \
 //thickness=0.1 //x=15.085 //y=0.72 //x2=15 //y2=0.68
r69 (  14 35 ) resistor r=27.3797 //w=0.187 //l=0.4 //layer=li //thickness=0.1 \
 //x=15.085 //y=0.72 //x2=15.485 //y2=0.72
r70 (  13 35 ) resistor r=0.751729 //w=0.17 //l=0.085 //layer=li \
 //thickness=0.1 //x=15.885 //y=0.72 //x2=15.97 //y2=0.72
r71 (  13 35 ) resistor r=27.3797 //w=0.187 //l=0.4 //layer=li //thickness=0.1 \
 //x=15.885 //y=0.72 //x2=15.485 //y2=0.72
r72 (  10 35 ) resistor r=1.40859 //w=0.34 //l=0.125 //layer=li \
 //thickness=0.1 //x=15 //y=1.685 //x2=15 //y2=1.81
r73 (  10 35 ) resistor r=42.0963 //w=0.187 //l=0.615 //layer=li \
 //thickness=0.1 //x=15 //y=1.685 //x2=15 //y2=1.07
r74 (  9 35 ) resistor r=3.57586 //w=0.17 //l=0.125 //layer=li //thickness=0.1 \
 //x=15 //y=0.805 //x2=15 //y2=0.68
r75 (  9 35 ) resistor r=18.139 //w=0.187 //l=0.265 //layer=li //thickness=0.1 \
 //x=15 //y=0.805 //x2=15 //y2=1.07
r76 (  6 35 ) resistor r=3.57586 //w=0.17 //l=0.103078 //layer=li \
 //thickness=0.1 //x=14.115 //y=1.77 //x2=14.03 //y2=1.81
r77 (  6 35 ) resistor r=27.3797 //w=0.187 //l=0.4 //layer=li //thickness=0.1 \
 //x=14.115 //y=1.77 //x2=14.515 //y2=1.77
r78 (  5 35 ) resistor r=5.4201 //w=0.17 //l=0.103078 //layer=li \
 //thickness=0.1 //x=14.915 //y=1.77 //x2=15 //y2=1.81
r79 (  5 35 ) resistor r=27.3797 //w=0.187 //l=0.4 //layer=li //thickness=0.1 \
 //x=14.915 //y=1.77 //x2=14.515 //y2=1.77
r80 (  1 35 ) resistor r=3.57586 //w=0.17 //l=0.125 //layer=li //thickness=0.1 \
 //x=14.03 //y=1.685 //x2=14.03 //y2=1.81
r81 (  1 35 ) resistor r=42.0963 //w=0.187 //l=0.615 //layer=li \
 //thickness=0.1 //x=14.03 //y=1.685 //x2=14.03 //y2=1.07
ends PM_TMRDFFRNQX1\%noxref_39

subckt PM_TMRDFFRNQX1\%noxref_40 ( 1 5 9 13 17 35 )
c58 ( 35 0 ) capacitor c=0.0691304f //x=18.705 //y=0.555
c59 ( 17 0 ) capacitor c=0.0188157f //x=20.695 //y=1.77
c60 ( 13 0 ) capacitor c=0.015325f //x=20.695 //y=0.72
c61 ( 9 0 ) capacitor c=0.00772076f //x=19.81 //y=0.805
c62 ( 5 0 ) capacitor c=0.0168501f //x=19.725 //y=1.77
c63 ( 1 0 ) capacitor c=0.00710458f //x=18.84 //y=1.685
r64 (  18 35 ) resistor r=5.4201 //w=0.17 //l=0.103078 //layer=li \
 //thickness=0.1 //x=19.895 //y=1.77 //x2=19.81 //y2=1.81
r65 (  18 35 ) resistor r=27.3797 //w=0.187 //l=0.4 //layer=li //thickness=0.1 \
 //x=19.895 //y=1.77 //x2=20.295 //y2=1.77
r66 (  17 35 ) resistor r=0.751729 //w=0.17 //l=0.085 //layer=li \
 //thickness=0.1 //x=20.695 //y=1.77 //x2=20.78 //y2=1.77
r67 (  17 35 ) resistor r=27.3797 //w=0.187 //l=0.4 //layer=li //thickness=0.1 \
 //x=20.695 //y=1.77 //x2=20.295 //y2=1.77
r68 (  14 35 ) resistor r=3.57586 //w=0.17 //l=0.103078 //layer=li \
 //thickness=0.1 //x=19.895 //y=0.72 //x2=19.81 //y2=0.68
r69 (  14 35 ) resistor r=27.3797 //w=0.187 //l=0.4 //layer=li //thickness=0.1 \
 //x=19.895 //y=0.72 //x2=20.295 //y2=0.72
r70 (  13 35 ) resistor r=0.751729 //w=0.17 //l=0.085 //layer=li \
 //thickness=0.1 //x=20.695 //y=0.72 //x2=20.78 //y2=0.72
r71 (  13 35 ) resistor r=27.3797 //w=0.187 //l=0.4 //layer=li //thickness=0.1 \
 //x=20.695 //y=0.72 //x2=20.295 //y2=0.72
r72 (  10 35 ) resistor r=1.40859 //w=0.34 //l=0.125 //layer=li \
 //thickness=0.1 //x=19.81 //y=1.685 //x2=19.81 //y2=1.81
r73 (  10 35 ) resistor r=42.0963 //w=0.187 //l=0.615 //layer=li \
 //thickness=0.1 //x=19.81 //y=1.685 //x2=19.81 //y2=1.07
r74 (  9 35 ) resistor r=3.57586 //w=0.17 //l=0.125 //layer=li //thickness=0.1 \
 //x=19.81 //y=0.805 //x2=19.81 //y2=0.68
r75 (  9 35 ) resistor r=18.139 //w=0.187 //l=0.265 //layer=li //thickness=0.1 \
 //x=19.81 //y=0.805 //x2=19.81 //y2=1.07
r76 (  6 35 ) resistor r=3.57586 //w=0.17 //l=0.103078 //layer=li \
 //thickness=0.1 //x=18.925 //y=1.77 //x2=18.84 //y2=1.81
r77 (  6 35 ) resistor r=27.3797 //w=0.187 //l=0.4 //layer=li //thickness=0.1 \
 //x=18.925 //y=1.77 //x2=19.325 //y2=1.77
r78 (  5 35 ) resistor r=5.4201 //w=0.17 //l=0.103078 //layer=li \
 //thickness=0.1 //x=19.725 //y=1.77 //x2=19.81 //y2=1.81
r79 (  5 35 ) resistor r=27.3797 //w=0.187 //l=0.4 //layer=li //thickness=0.1 \
 //x=19.725 //y=1.77 //x2=19.325 //y2=1.77
r80 (  1 35 ) resistor r=3.57586 //w=0.17 //l=0.125 //layer=li //thickness=0.1 \
 //x=18.84 //y=1.685 //x2=18.84 //y2=1.81
r81 (  1 35 ) resistor r=42.0963 //w=0.187 //l=0.615 //layer=li \
 //thickness=0.1 //x=18.84 //y=1.685 //x2=18.84 //y2=1.07
ends PM_TMRDFFRNQX1\%noxref_40

subckt PM_TMRDFFRNQX1\%noxref_41 ( 1 5 9 10 13 17 29 )
c67 ( 29 0 ) capacitor c=0.0668165f //x=23.62 //y=0.545
c68 ( 17 0 ) capacitor c=0.00675704f //x=25.695 //y=0.795
c69 ( 13 0 ) capacitor c=0.0155876f //x=25.61 //y=0.71
c70 ( 10 0 ) capacitor c=0.00673372f //x=24.725 //y=1.675
c71 ( 9 0 ) capacitor c=0.00770028f //x=24.725 //y=0.795
c72 ( 5 0 ) capacitor c=0.0179513f //x=24.64 //y=1.76
c73 ( 1 0 ) capacitor c=0.00761099f //x=23.755 //y=1.675
r74 (  17 29 ) resistor r=3.57586 //w=0.17 //l=0.125 //layer=li \
 //thickness=0.1 //x=25.695 //y=0.795 //x2=25.695 //y2=0.67
r75 (  17 29 ) resistor r=18.139 //w=0.187 //l=0.265 //layer=li \
 //thickness=0.1 //x=25.695 //y=0.795 //x2=25.695 //y2=1.06
r76 (  14 29 ) resistor r=3.57586 //w=0.17 //l=0.103078 //layer=li \
 //thickness=0.1 //x=24.81 //y=0.71 //x2=24.725 //y2=0.67
r77 (  14 29 ) resistor r=27.3797 //w=0.187 //l=0.4 //layer=li //thickness=0.1 \
 //x=24.81 //y=0.71 //x2=25.21 //y2=0.71
r78 (  13 29 ) resistor r=3.57586 //w=0.17 //l=0.103078 //layer=li \
 //thickness=0.1 //x=25.61 //y=0.71 //x2=25.695 //y2=0.67
r79 (  13 29 ) resistor r=27.3797 //w=0.187 //l=0.4 //layer=li //thickness=0.1 \
 //x=25.61 //y=0.71 //x2=25.21 //y2=0.71
r80 (  10 29 ) resistor r=3.57586 //w=0.17 //l=0.125 //layer=li \
 //thickness=0.1 //x=24.725 //y=1.675 //x2=24.725 //y2=1.8
r81 (  10 29 ) resistor r=42.0963 //w=0.187 //l=0.615 //layer=li \
 //thickness=0.1 //x=24.725 //y=1.675 //x2=24.725 //y2=1.06
r82 (  9 29 ) resistor r=3.57586 //w=0.17 //l=0.125 //layer=li //thickness=0.1 \
 //x=24.725 //y=0.795 //x2=24.725 //y2=0.67
r83 (  9 29 ) resistor r=18.139 //w=0.187 //l=0.265 //layer=li //thickness=0.1 \
 //x=24.725 //y=0.795 //x2=24.725 //y2=1.06
r84 (  6 29 ) resistor r=3.57586 //w=0.17 //l=0.103078 //layer=li \
 //thickness=0.1 //x=23.84 //y=1.76 //x2=23.755 //y2=1.8
r85 (  6 29 ) resistor r=27.3797 //w=0.187 //l=0.4 //layer=li //thickness=0.1 \
 //x=23.84 //y=1.76 //x2=24.24 //y2=1.76
r86 (  5 29 ) resistor r=3.57586 //w=0.17 //l=0.103078 //layer=li \
 //thickness=0.1 //x=24.64 //y=1.76 //x2=24.725 //y2=1.8
r87 (  5 29 ) resistor r=27.3797 //w=0.187 //l=0.4 //layer=li //thickness=0.1 \
 //x=24.64 //y=1.76 //x2=24.24 //y2=1.76
r88 (  1 29 ) resistor r=3.57586 //w=0.17 //l=0.125 //layer=li //thickness=0.1 \
 //x=23.755 //y=1.675 //x2=23.755 //y2=1.8
r89 (  1 29 ) resistor r=42.0963 //w=0.187 //l=0.615 //layer=li \
 //thickness=0.1 //x=23.755 //y=1.675 //x2=23.755 //y2=1.06
ends PM_TMRDFFRNQX1\%noxref_41

subckt PM_TMRDFFRNQX1\%noxref_42 ( 1 5 9 13 17 35 )
c58 ( 35 0 ) capacitor c=0.068832f //x=26.845 //y=0.555
c59 ( 17 0 ) capacitor c=0.0190725f //x=28.835 //y=1.77
c60 ( 13 0 ) capacitor c=0.015325f //x=28.835 //y=0.72
c61 ( 9 0 ) capacitor c=0.00772076f //x=27.95 //y=0.805
c62 ( 5 0 ) capacitor c=0.0168501f //x=27.865 //y=1.77
c63 ( 1 0 ) capacitor c=0.00709556f //x=26.98 //y=1.685
r64 (  18 35 ) resistor r=5.4201 //w=0.17 //l=0.103078 //layer=li \
 //thickness=0.1 //x=28.035 //y=1.77 //x2=27.95 //y2=1.81
r65 (  18 35 ) resistor r=27.3797 //w=0.187 //l=0.4 //layer=li //thickness=0.1 \
 //x=28.035 //y=1.77 //x2=28.435 //y2=1.77
r66 (  17 35 ) resistor r=0.751729 //w=0.17 //l=0.085 //layer=li \
 //thickness=0.1 //x=28.835 //y=1.77 //x2=28.92 //y2=1.77
r67 (  17 35 ) resistor r=27.3797 //w=0.187 //l=0.4 //layer=li //thickness=0.1 \
 //x=28.835 //y=1.77 //x2=28.435 //y2=1.77
r68 (  14 35 ) resistor r=3.57586 //w=0.17 //l=0.103078 //layer=li \
 //thickness=0.1 //x=28.035 //y=0.72 //x2=27.95 //y2=0.68
r69 (  14 35 ) resistor r=27.3797 //w=0.187 //l=0.4 //layer=li //thickness=0.1 \
 //x=28.035 //y=0.72 //x2=28.435 //y2=0.72
r70 (  13 35 ) resistor r=0.751729 //w=0.17 //l=0.085 //layer=li \
 //thickness=0.1 //x=28.835 //y=0.72 //x2=28.92 //y2=0.72
r71 (  13 35 ) resistor r=27.3797 //w=0.187 //l=0.4 //layer=li //thickness=0.1 \
 //x=28.835 //y=0.72 //x2=28.435 //y2=0.72
r72 (  10 35 ) resistor r=1.40859 //w=0.34 //l=0.125 //layer=li \
 //thickness=0.1 //x=27.95 //y=1.685 //x2=27.95 //y2=1.81
r73 (  10 35 ) resistor r=42.0963 //w=0.187 //l=0.615 //layer=li \
 //thickness=0.1 //x=27.95 //y=1.685 //x2=27.95 //y2=1.07
r74 (  9 35 ) resistor r=3.57586 //w=0.17 //l=0.125 //layer=li //thickness=0.1 \
 //x=27.95 //y=0.805 //x2=27.95 //y2=0.68
r75 (  9 35 ) resistor r=18.139 //w=0.187 //l=0.265 //layer=li //thickness=0.1 \
 //x=27.95 //y=0.805 //x2=27.95 //y2=1.07
r76 (  6 35 ) resistor r=3.57586 //w=0.17 //l=0.103078 //layer=li \
 //thickness=0.1 //x=27.065 //y=1.77 //x2=26.98 //y2=1.81
r77 (  6 35 ) resistor r=27.3797 //w=0.187 //l=0.4 //layer=li //thickness=0.1 \
 //x=27.065 //y=1.77 //x2=27.465 //y2=1.77
r78 (  5 35 ) resistor r=5.4201 //w=0.17 //l=0.103078 //layer=li \
 //thickness=0.1 //x=27.865 //y=1.77 //x2=27.95 //y2=1.81
r79 (  5 35 ) resistor r=27.3797 //w=0.187 //l=0.4 //layer=li //thickness=0.1 \
 //x=27.865 //y=1.77 //x2=27.465 //y2=1.77
r80 (  1 35 ) resistor r=3.57586 //w=0.17 //l=0.125 //layer=li //thickness=0.1 \
 //x=26.98 //y=1.685 //x2=26.98 //y2=1.81
r81 (  1 35 ) resistor r=42.0963 //w=0.187 //l=0.615 //layer=li \
 //thickness=0.1 //x=26.98 //y=1.685 //x2=26.98 //y2=1.07
ends PM_TMRDFFRNQX1\%noxref_42

subckt PM_TMRDFFRNQX1\%noxref_43 ( 1 5 9 13 17 35 )
c60 ( 35 0 ) capacitor c=0.0690801f //x=31.655 //y=0.555
c61 ( 17 0 ) capacitor c=0.0189754f //x=33.645 //y=1.77
c62 ( 13 0 ) capacitor c=0.015324f //x=33.645 //y=0.72
c63 ( 9 0 ) capacitor c=0.00772076f //x=32.76 //y=0.805
c64 ( 5 0 ) capacitor c=0.0168501f //x=32.675 //y=1.77
c65 ( 1 0 ) capacitor c=0.00710458f //x=31.79 //y=1.685
r66 (  18 35 ) resistor r=5.4201 //w=0.17 //l=0.103078 //layer=li \
 //thickness=0.1 //x=32.845 //y=1.77 //x2=32.76 //y2=1.81
r67 (  18 35 ) resistor r=27.3797 //w=0.187 //l=0.4 //layer=li //thickness=0.1 \
 //x=32.845 //y=1.77 //x2=33.245 //y2=1.77
r68 (  17 35 ) resistor r=0.751729 //w=0.17 //l=0.085 //layer=li \
 //thickness=0.1 //x=33.645 //y=1.77 //x2=33.73 //y2=1.77
r69 (  17 35 ) resistor r=27.3797 //w=0.187 //l=0.4 //layer=li //thickness=0.1 \
 //x=33.645 //y=1.77 //x2=33.245 //y2=1.77
r70 (  14 35 ) resistor r=3.57586 //w=0.17 //l=0.103078 //layer=li \
 //thickness=0.1 //x=32.845 //y=0.72 //x2=32.76 //y2=0.68
r71 (  14 35 ) resistor r=27.3797 //w=0.187 //l=0.4 //layer=li //thickness=0.1 \
 //x=32.845 //y=0.72 //x2=33.245 //y2=0.72
r72 (  13 35 ) resistor r=0.751729 //w=0.17 //l=0.085 //layer=li \
 //thickness=0.1 //x=33.645 //y=0.72 //x2=33.73 //y2=0.72
r73 (  13 35 ) resistor r=27.3797 //w=0.187 //l=0.4 //layer=li //thickness=0.1 \
 //x=33.645 //y=0.72 //x2=33.245 //y2=0.72
r74 (  10 35 ) resistor r=1.40859 //w=0.34 //l=0.125 //layer=li \
 //thickness=0.1 //x=32.76 //y=1.685 //x2=32.76 //y2=1.81
r75 (  10 35 ) resistor r=42.0963 //w=0.187 //l=0.615 //layer=li \
 //thickness=0.1 //x=32.76 //y=1.685 //x2=32.76 //y2=1.07
r76 (  9 35 ) resistor r=3.57586 //w=0.17 //l=0.125 //layer=li //thickness=0.1 \
 //x=32.76 //y=0.805 //x2=32.76 //y2=0.68
r77 (  9 35 ) resistor r=18.139 //w=0.187 //l=0.265 //layer=li //thickness=0.1 \
 //x=32.76 //y=0.805 //x2=32.76 //y2=1.07
r78 (  6 35 ) resistor r=3.57586 //w=0.17 //l=0.103078 //layer=li \
 //thickness=0.1 //x=31.875 //y=1.77 //x2=31.79 //y2=1.81
r79 (  6 35 ) resistor r=27.3797 //w=0.187 //l=0.4 //layer=li //thickness=0.1 \
 //x=31.875 //y=1.77 //x2=32.275 //y2=1.77
r80 (  5 35 ) resistor r=5.4201 //w=0.17 //l=0.103078 //layer=li \
 //thickness=0.1 //x=32.675 //y=1.77 //x2=32.76 //y2=1.81
r81 (  5 35 ) resistor r=27.3797 //w=0.187 //l=0.4 //layer=li //thickness=0.1 \
 //x=32.675 //y=1.77 //x2=32.275 //y2=1.77
r82 (  1 35 ) resistor r=3.57586 //w=0.17 //l=0.125 //layer=li //thickness=0.1 \
 //x=31.79 //y=1.685 //x2=31.79 //y2=1.81
r83 (  1 35 ) resistor r=42.0963 //w=0.187 //l=0.615 //layer=li \
 //thickness=0.1 //x=31.79 //y=1.685 //x2=31.79 //y2=1.07
ends PM_TMRDFFRNQX1\%noxref_43

subckt PM_TMRDFFRNQX1\%noxref_44 ( 1 5 9 10 13 17 29 )
c67 ( 29 0 ) capacitor c=0.067062f //x=36.57 //y=0.545
c68 ( 17 0 ) capacitor c=0.00675704f //x=38.645 //y=0.795
c69 ( 13 0 ) capacitor c=0.0156329f //x=38.56 //y=0.71
c70 ( 10 0 ) capacitor c=0.00673372f //x=37.675 //y=1.675
c71 ( 9 0 ) capacitor c=0.00770028f //x=37.675 //y=0.795
c72 ( 5 0 ) capacitor c=0.0179513f //x=37.59 //y=1.76
c73 ( 1 0 ) capacitor c=0.00761099f //x=36.705 //y=1.675
r74 (  17 29 ) resistor r=3.57586 //w=0.17 //l=0.125 //layer=li \
 //thickness=0.1 //x=38.645 //y=0.795 //x2=38.645 //y2=0.67
r75 (  17 29 ) resistor r=18.139 //w=0.187 //l=0.265 //layer=li \
 //thickness=0.1 //x=38.645 //y=0.795 //x2=38.645 //y2=1.06
r76 (  14 29 ) resistor r=3.57586 //w=0.17 //l=0.103078 //layer=li \
 //thickness=0.1 //x=37.76 //y=0.71 //x2=37.675 //y2=0.67
r77 (  14 29 ) resistor r=27.3797 //w=0.187 //l=0.4 //layer=li //thickness=0.1 \
 //x=37.76 //y=0.71 //x2=38.16 //y2=0.71
r78 (  13 29 ) resistor r=3.57586 //w=0.17 //l=0.103078 //layer=li \
 //thickness=0.1 //x=38.56 //y=0.71 //x2=38.645 //y2=0.67
r79 (  13 29 ) resistor r=27.3797 //w=0.187 //l=0.4 //layer=li //thickness=0.1 \
 //x=38.56 //y=0.71 //x2=38.16 //y2=0.71
r80 (  10 29 ) resistor r=3.57586 //w=0.17 //l=0.125 //layer=li \
 //thickness=0.1 //x=37.675 //y=1.675 //x2=37.675 //y2=1.8
r81 (  10 29 ) resistor r=42.0963 //w=0.187 //l=0.615 //layer=li \
 //thickness=0.1 //x=37.675 //y=1.675 //x2=37.675 //y2=1.06
r82 (  9 29 ) resistor r=3.57586 //w=0.17 //l=0.125 //layer=li //thickness=0.1 \
 //x=37.675 //y=0.795 //x2=37.675 //y2=0.67
r83 (  9 29 ) resistor r=18.139 //w=0.187 //l=0.265 //layer=li //thickness=0.1 \
 //x=37.675 //y=0.795 //x2=37.675 //y2=1.06
r84 (  6 29 ) resistor r=3.57586 //w=0.17 //l=0.103078 //layer=li \
 //thickness=0.1 //x=36.79 //y=1.76 //x2=36.705 //y2=1.8
r85 (  6 29 ) resistor r=27.3797 //w=0.187 //l=0.4 //layer=li //thickness=0.1 \
 //x=36.79 //y=1.76 //x2=37.19 //y2=1.76
r86 (  5 29 ) resistor r=3.57586 //w=0.17 //l=0.103078 //layer=li \
 //thickness=0.1 //x=37.59 //y=1.76 //x2=37.675 //y2=1.8
r87 (  5 29 ) resistor r=27.3797 //w=0.187 //l=0.4 //layer=li //thickness=0.1 \
 //x=37.59 //y=1.76 //x2=37.19 //y2=1.76
r88 (  1 29 ) resistor r=3.57586 //w=0.17 //l=0.125 //layer=li //thickness=0.1 \
 //x=36.705 //y=1.675 //x2=36.705 //y2=1.8
r89 (  1 29 ) resistor r=42.0963 //w=0.187 //l=0.615 //layer=li \
 //thickness=0.1 //x=36.705 //y=1.675 //x2=36.705 //y2=1.06
ends PM_TMRDFFRNQX1\%noxref_44

subckt PM_TMRDFFRNQX1\%noxref_45 ( 1 5 9 13 17 35 )
c58 ( 35 0 ) capacitor c=0.068832f //x=39.795 //y=0.555
c59 ( 17 0 ) capacitor c=0.0190725f //x=41.785 //y=1.77
c60 ( 13 0 ) capacitor c=0.015325f //x=41.785 //y=0.72
c61 ( 9 0 ) capacitor c=0.00772076f //x=40.9 //y=0.805
c62 ( 5 0 ) capacitor c=0.0168501f //x=40.815 //y=1.77
c63 ( 1 0 ) capacitor c=0.00709556f //x=39.93 //y=1.685
r64 (  18 35 ) resistor r=5.4201 //w=0.17 //l=0.103078 //layer=li \
 //thickness=0.1 //x=40.985 //y=1.77 //x2=40.9 //y2=1.81
r65 (  18 35 ) resistor r=27.3797 //w=0.187 //l=0.4 //layer=li //thickness=0.1 \
 //x=40.985 //y=1.77 //x2=41.385 //y2=1.77
r66 (  17 35 ) resistor r=0.751729 //w=0.17 //l=0.085 //layer=li \
 //thickness=0.1 //x=41.785 //y=1.77 //x2=41.87 //y2=1.77
r67 (  17 35 ) resistor r=27.3797 //w=0.187 //l=0.4 //layer=li //thickness=0.1 \
 //x=41.785 //y=1.77 //x2=41.385 //y2=1.77
r68 (  14 35 ) resistor r=3.57586 //w=0.17 //l=0.103078 //layer=li \
 //thickness=0.1 //x=40.985 //y=0.72 //x2=40.9 //y2=0.68
r69 (  14 35 ) resistor r=27.3797 //w=0.187 //l=0.4 //layer=li //thickness=0.1 \
 //x=40.985 //y=0.72 //x2=41.385 //y2=0.72
r70 (  13 35 ) resistor r=0.751729 //w=0.17 //l=0.085 //layer=li \
 //thickness=0.1 //x=41.785 //y=0.72 //x2=41.87 //y2=0.72
r71 (  13 35 ) resistor r=27.3797 //w=0.187 //l=0.4 //layer=li //thickness=0.1 \
 //x=41.785 //y=0.72 //x2=41.385 //y2=0.72
r72 (  10 35 ) resistor r=1.40859 //w=0.34 //l=0.125 //layer=li \
 //thickness=0.1 //x=40.9 //y=1.685 //x2=40.9 //y2=1.81
r73 (  10 35 ) resistor r=42.0963 //w=0.187 //l=0.615 //layer=li \
 //thickness=0.1 //x=40.9 //y=1.685 //x2=40.9 //y2=1.07
r74 (  9 35 ) resistor r=3.57586 //w=0.17 //l=0.125 //layer=li //thickness=0.1 \
 //x=40.9 //y=0.805 //x2=40.9 //y2=0.68
r75 (  9 35 ) resistor r=18.139 //w=0.187 //l=0.265 //layer=li //thickness=0.1 \
 //x=40.9 //y=0.805 //x2=40.9 //y2=1.07
r76 (  6 35 ) resistor r=3.57586 //w=0.17 //l=0.103078 //layer=li \
 //thickness=0.1 //x=40.015 //y=1.77 //x2=39.93 //y2=1.81
r77 (  6 35 ) resistor r=27.3797 //w=0.187 //l=0.4 //layer=li //thickness=0.1 \
 //x=40.015 //y=1.77 //x2=40.415 //y2=1.77
r78 (  5 35 ) resistor r=5.4201 //w=0.17 //l=0.103078 //layer=li \
 //thickness=0.1 //x=40.815 //y=1.77 //x2=40.9 //y2=1.81
r79 (  5 35 ) resistor r=27.3797 //w=0.187 //l=0.4 //layer=li //thickness=0.1 \
 //x=40.815 //y=1.77 //x2=40.415 //y2=1.77
r80 (  1 35 ) resistor r=3.57586 //w=0.17 //l=0.125 //layer=li //thickness=0.1 \
 //x=39.93 //y=1.685 //x2=39.93 //y2=1.81
r81 (  1 35 ) resistor r=42.0963 //w=0.187 //l=0.615 //layer=li \
 //thickness=0.1 //x=39.93 //y=1.685 //x2=39.93 //y2=1.07
ends PM_TMRDFFRNQX1\%noxref_45

subckt PM_TMRDFFRNQX1\%noxref_46 ( 1 5 9 13 17 35 )
c58 ( 35 0 ) capacitor c=0.0691304f //x=44.605 //y=0.555
c59 ( 17 0 ) capacitor c=0.0188157f //x=46.595 //y=1.77
c60 ( 13 0 ) capacitor c=0.015325f //x=46.595 //y=0.72
c61 ( 9 0 ) capacitor c=0.00772076f //x=45.71 //y=0.805
c62 ( 5 0 ) capacitor c=0.0168501f //x=45.625 //y=1.77
c63 ( 1 0 ) capacitor c=0.00710458f //x=44.74 //y=1.685
r64 (  18 35 ) resistor r=5.4201 //w=0.17 //l=0.103078 //layer=li \
 //thickness=0.1 //x=45.795 //y=1.77 //x2=45.71 //y2=1.81
r65 (  18 35 ) resistor r=27.3797 //w=0.187 //l=0.4 //layer=li //thickness=0.1 \
 //x=45.795 //y=1.77 //x2=46.195 //y2=1.77
r66 (  17 35 ) resistor r=0.751729 //w=0.17 //l=0.085 //layer=li \
 //thickness=0.1 //x=46.595 //y=1.77 //x2=46.68 //y2=1.77
r67 (  17 35 ) resistor r=27.3797 //w=0.187 //l=0.4 //layer=li //thickness=0.1 \
 //x=46.595 //y=1.77 //x2=46.195 //y2=1.77
r68 (  14 35 ) resistor r=3.57586 //w=0.17 //l=0.103078 //layer=li \
 //thickness=0.1 //x=45.795 //y=0.72 //x2=45.71 //y2=0.68
r69 (  14 35 ) resistor r=27.3797 //w=0.187 //l=0.4 //layer=li //thickness=0.1 \
 //x=45.795 //y=0.72 //x2=46.195 //y2=0.72
r70 (  13 35 ) resistor r=0.751729 //w=0.17 //l=0.085 //layer=li \
 //thickness=0.1 //x=46.595 //y=0.72 //x2=46.68 //y2=0.72
r71 (  13 35 ) resistor r=27.3797 //w=0.187 //l=0.4 //layer=li //thickness=0.1 \
 //x=46.595 //y=0.72 //x2=46.195 //y2=0.72
r72 (  10 35 ) resistor r=1.40859 //w=0.34 //l=0.125 //layer=li \
 //thickness=0.1 //x=45.71 //y=1.685 //x2=45.71 //y2=1.81
r73 (  10 35 ) resistor r=42.0963 //w=0.187 //l=0.615 //layer=li \
 //thickness=0.1 //x=45.71 //y=1.685 //x2=45.71 //y2=1.07
r74 (  9 35 ) resistor r=3.57586 //w=0.17 //l=0.125 //layer=li //thickness=0.1 \
 //x=45.71 //y=0.805 //x2=45.71 //y2=0.68
r75 (  9 35 ) resistor r=18.139 //w=0.187 //l=0.265 //layer=li //thickness=0.1 \
 //x=45.71 //y=0.805 //x2=45.71 //y2=1.07
r76 (  6 35 ) resistor r=3.57586 //w=0.17 //l=0.103078 //layer=li \
 //thickness=0.1 //x=44.825 //y=1.77 //x2=44.74 //y2=1.81
r77 (  6 35 ) resistor r=27.3797 //w=0.187 //l=0.4 //layer=li //thickness=0.1 \
 //x=44.825 //y=1.77 //x2=45.225 //y2=1.77
r78 (  5 35 ) resistor r=5.4201 //w=0.17 //l=0.103078 //layer=li \
 //thickness=0.1 //x=45.625 //y=1.77 //x2=45.71 //y2=1.81
r79 (  5 35 ) resistor r=27.3797 //w=0.187 //l=0.4 //layer=li //thickness=0.1 \
 //x=45.625 //y=1.77 //x2=45.225 //y2=1.77
r80 (  1 35 ) resistor r=3.57586 //w=0.17 //l=0.125 //layer=li //thickness=0.1 \
 //x=44.74 //y=1.685 //x2=44.74 //y2=1.81
r81 (  1 35 ) resistor r=42.0963 //w=0.187 //l=0.615 //layer=li \
 //thickness=0.1 //x=44.74 //y=1.685 //x2=44.74 //y2=1.07
ends PM_TMRDFFRNQX1\%noxref_46

subckt PM_TMRDFFRNQX1\%noxref_47 ( 1 5 9 10 13 17 29 )
c67 ( 29 0 ) capacitor c=0.067062f //x=49.52 //y=0.545
c68 ( 17 0 ) capacitor c=0.00675704f //x=51.595 //y=0.795
c69 ( 13 0 ) capacitor c=0.0155876f //x=51.51 //y=0.71
c70 ( 10 0 ) capacitor c=0.00673372f //x=50.625 //y=1.675
c71 ( 9 0 ) capacitor c=0.00770028f //x=50.625 //y=0.795
c72 ( 5 0 ) capacitor c=0.0179513f //x=50.54 //y=1.76
c73 ( 1 0 ) capacitor c=0.00761099f //x=49.655 //y=1.675
r74 (  17 29 ) resistor r=3.57586 //w=0.17 //l=0.125 //layer=li \
 //thickness=0.1 //x=51.595 //y=0.795 //x2=51.595 //y2=0.67
r75 (  17 29 ) resistor r=18.139 //w=0.187 //l=0.265 //layer=li \
 //thickness=0.1 //x=51.595 //y=0.795 //x2=51.595 //y2=1.06
r76 (  14 29 ) resistor r=3.57586 //w=0.17 //l=0.103078 //layer=li \
 //thickness=0.1 //x=50.71 //y=0.71 //x2=50.625 //y2=0.67
r77 (  14 29 ) resistor r=27.3797 //w=0.187 //l=0.4 //layer=li //thickness=0.1 \
 //x=50.71 //y=0.71 //x2=51.11 //y2=0.71
r78 (  13 29 ) resistor r=3.57586 //w=0.17 //l=0.103078 //layer=li \
 //thickness=0.1 //x=51.51 //y=0.71 //x2=51.595 //y2=0.67
r79 (  13 29 ) resistor r=27.3797 //w=0.187 //l=0.4 //layer=li //thickness=0.1 \
 //x=51.51 //y=0.71 //x2=51.11 //y2=0.71
r80 (  10 29 ) resistor r=3.57586 //w=0.17 //l=0.125 //layer=li \
 //thickness=0.1 //x=50.625 //y=1.675 //x2=50.625 //y2=1.8
r81 (  10 29 ) resistor r=42.0963 //w=0.187 //l=0.615 //layer=li \
 //thickness=0.1 //x=50.625 //y=1.675 //x2=50.625 //y2=1.06
r82 (  9 29 ) resistor r=3.57586 //w=0.17 //l=0.125 //layer=li //thickness=0.1 \
 //x=50.625 //y=0.795 //x2=50.625 //y2=0.67
r83 (  9 29 ) resistor r=18.139 //w=0.187 //l=0.265 //layer=li //thickness=0.1 \
 //x=50.625 //y=0.795 //x2=50.625 //y2=1.06
r84 (  6 29 ) resistor r=3.57586 //w=0.17 //l=0.103078 //layer=li \
 //thickness=0.1 //x=49.74 //y=1.76 //x2=49.655 //y2=1.8
r85 (  6 29 ) resistor r=27.3797 //w=0.187 //l=0.4 //layer=li //thickness=0.1 \
 //x=49.74 //y=1.76 //x2=50.14 //y2=1.76
r86 (  5 29 ) resistor r=3.57586 //w=0.17 //l=0.103078 //layer=li \
 //thickness=0.1 //x=50.54 //y=1.76 //x2=50.625 //y2=1.8
r87 (  5 29 ) resistor r=27.3797 //w=0.187 //l=0.4 //layer=li //thickness=0.1 \
 //x=50.54 //y=1.76 //x2=50.14 //y2=1.76
r88 (  1 29 ) resistor r=3.57586 //w=0.17 //l=0.125 //layer=li //thickness=0.1 \
 //x=49.655 //y=1.675 //x2=49.655 //y2=1.8
r89 (  1 29 ) resistor r=42.0963 //w=0.187 //l=0.615 //layer=li \
 //thickness=0.1 //x=49.655 //y=1.675 //x2=49.655 //y2=1.06
ends PM_TMRDFFRNQX1\%noxref_47

subckt PM_TMRDFFRNQX1\%noxref_48 ( 1 5 9 13 17 35 )
c58 ( 35 0 ) capacitor c=0.068832f //x=52.745 //y=0.555
c59 ( 17 0 ) capacitor c=0.0190725f //x=54.735 //y=1.77
c60 ( 13 0 ) capacitor c=0.015325f //x=54.735 //y=0.72
c61 ( 9 0 ) capacitor c=0.00772076f //x=53.85 //y=0.805
c62 ( 5 0 ) capacitor c=0.0168501f //x=53.765 //y=1.77
c63 ( 1 0 ) capacitor c=0.00709556f //x=52.88 //y=1.685
r64 (  18 35 ) resistor r=5.4201 //w=0.17 //l=0.103078 //layer=li \
 //thickness=0.1 //x=53.935 //y=1.77 //x2=53.85 //y2=1.81
r65 (  18 35 ) resistor r=27.3797 //w=0.187 //l=0.4 //layer=li //thickness=0.1 \
 //x=53.935 //y=1.77 //x2=54.335 //y2=1.77
r66 (  17 35 ) resistor r=0.751729 //w=0.17 //l=0.085 //layer=li \
 //thickness=0.1 //x=54.735 //y=1.77 //x2=54.82 //y2=1.77
r67 (  17 35 ) resistor r=27.3797 //w=0.187 //l=0.4 //layer=li //thickness=0.1 \
 //x=54.735 //y=1.77 //x2=54.335 //y2=1.77
r68 (  14 35 ) resistor r=3.57586 //w=0.17 //l=0.103078 //layer=li \
 //thickness=0.1 //x=53.935 //y=0.72 //x2=53.85 //y2=0.68
r69 (  14 35 ) resistor r=27.3797 //w=0.187 //l=0.4 //layer=li //thickness=0.1 \
 //x=53.935 //y=0.72 //x2=54.335 //y2=0.72
r70 (  13 35 ) resistor r=0.751729 //w=0.17 //l=0.085 //layer=li \
 //thickness=0.1 //x=54.735 //y=0.72 //x2=54.82 //y2=0.72
r71 (  13 35 ) resistor r=27.3797 //w=0.187 //l=0.4 //layer=li //thickness=0.1 \
 //x=54.735 //y=0.72 //x2=54.335 //y2=0.72
r72 (  10 35 ) resistor r=1.40859 //w=0.34 //l=0.125 //layer=li \
 //thickness=0.1 //x=53.85 //y=1.685 //x2=53.85 //y2=1.81
r73 (  10 35 ) resistor r=42.0963 //w=0.187 //l=0.615 //layer=li \
 //thickness=0.1 //x=53.85 //y=1.685 //x2=53.85 //y2=1.07
r74 (  9 35 ) resistor r=3.57586 //w=0.17 //l=0.125 //layer=li //thickness=0.1 \
 //x=53.85 //y=0.805 //x2=53.85 //y2=0.68
r75 (  9 35 ) resistor r=18.139 //w=0.187 //l=0.265 //layer=li //thickness=0.1 \
 //x=53.85 //y=0.805 //x2=53.85 //y2=1.07
r76 (  6 35 ) resistor r=3.57586 //w=0.17 //l=0.103078 //layer=li \
 //thickness=0.1 //x=52.965 //y=1.77 //x2=52.88 //y2=1.81
r77 (  6 35 ) resistor r=27.3797 //w=0.187 //l=0.4 //layer=li //thickness=0.1 \
 //x=52.965 //y=1.77 //x2=53.365 //y2=1.77
r78 (  5 35 ) resistor r=5.4201 //w=0.17 //l=0.103078 //layer=li \
 //thickness=0.1 //x=53.765 //y=1.77 //x2=53.85 //y2=1.81
r79 (  5 35 ) resistor r=27.3797 //w=0.187 //l=0.4 //layer=li //thickness=0.1 \
 //x=53.765 //y=1.77 //x2=53.365 //y2=1.77
r80 (  1 35 ) resistor r=3.57586 //w=0.17 //l=0.125 //layer=li //thickness=0.1 \
 //x=52.88 //y=1.685 //x2=52.88 //y2=1.81
r81 (  1 35 ) resistor r=42.0963 //w=0.187 //l=0.615 //layer=li \
 //thickness=0.1 //x=52.88 //y=1.685 //x2=52.88 //y2=1.07
ends PM_TMRDFFRNQX1\%noxref_48

subckt PM_TMRDFFRNQX1\%noxref_49 ( 1 5 9 13 17 35 )
c61 ( 35 0 ) capacitor c=0.0690804f //x=57.555 //y=0.555
c62 ( 17 0 ) capacitor c=0.0189869f //x=59.545 //y=1.77
c63 ( 13 0 ) capacitor c=0.0153243f //x=59.545 //y=0.72
c64 ( 9 0 ) capacitor c=0.00772076f //x=58.66 //y=0.805
c65 ( 5 0 ) capacitor c=0.0168501f //x=58.575 //y=1.77
c66 ( 1 0 ) capacitor c=0.00710458f //x=57.69 //y=1.685
r67 (  18 35 ) resistor r=5.4201 //w=0.17 //l=0.103078 //layer=li \
 //thickness=0.1 //x=58.745 //y=1.77 //x2=58.66 //y2=1.81
r68 (  18 35 ) resistor r=27.3797 //w=0.187 //l=0.4 //layer=li //thickness=0.1 \
 //x=58.745 //y=1.77 //x2=59.145 //y2=1.77
r69 (  17 35 ) resistor r=0.751729 //w=0.17 //l=0.085 //layer=li \
 //thickness=0.1 //x=59.545 //y=1.77 //x2=59.63 //y2=1.77
r70 (  17 35 ) resistor r=27.3797 //w=0.187 //l=0.4 //layer=li //thickness=0.1 \
 //x=59.545 //y=1.77 //x2=59.145 //y2=1.77
r71 (  14 35 ) resistor r=3.57586 //w=0.17 //l=0.103078 //layer=li \
 //thickness=0.1 //x=58.745 //y=0.72 //x2=58.66 //y2=0.68
r72 (  14 35 ) resistor r=27.3797 //w=0.187 //l=0.4 //layer=li //thickness=0.1 \
 //x=58.745 //y=0.72 //x2=59.145 //y2=0.72
r73 (  13 35 ) resistor r=0.751729 //w=0.17 //l=0.085 //layer=li \
 //thickness=0.1 //x=59.545 //y=0.72 //x2=59.63 //y2=0.72
r74 (  13 35 ) resistor r=27.3797 //w=0.187 //l=0.4 //layer=li //thickness=0.1 \
 //x=59.545 //y=0.72 //x2=59.145 //y2=0.72
r75 (  10 35 ) resistor r=1.40859 //w=0.34 //l=0.125 //layer=li \
 //thickness=0.1 //x=58.66 //y=1.685 //x2=58.66 //y2=1.81
r76 (  10 35 ) resistor r=42.0963 //w=0.187 //l=0.615 //layer=li \
 //thickness=0.1 //x=58.66 //y=1.685 //x2=58.66 //y2=1.07
r77 (  9 35 ) resistor r=3.57586 //w=0.17 //l=0.125 //layer=li //thickness=0.1 \
 //x=58.66 //y=0.805 //x2=58.66 //y2=0.68
r78 (  9 35 ) resistor r=18.139 //w=0.187 //l=0.265 //layer=li //thickness=0.1 \
 //x=58.66 //y=0.805 //x2=58.66 //y2=1.07
r79 (  6 35 ) resistor r=3.57586 //w=0.17 //l=0.103078 //layer=li \
 //thickness=0.1 //x=57.775 //y=1.77 //x2=57.69 //y2=1.81
r80 (  6 35 ) resistor r=27.3797 //w=0.187 //l=0.4 //layer=li //thickness=0.1 \
 //x=57.775 //y=1.77 //x2=58.175 //y2=1.77
r81 (  5 35 ) resistor r=5.4201 //w=0.17 //l=0.103078 //layer=li \
 //thickness=0.1 //x=58.575 //y=1.77 //x2=58.66 //y2=1.81
r82 (  5 35 ) resistor r=27.3797 //w=0.187 //l=0.4 //layer=li //thickness=0.1 \
 //x=58.575 //y=1.77 //x2=58.175 //y2=1.77
r83 (  1 35 ) resistor r=3.57586 //w=0.17 //l=0.125 //layer=li //thickness=0.1 \
 //x=57.69 //y=1.685 //x2=57.69 //y2=1.81
r84 (  1 35 ) resistor r=42.0963 //w=0.187 //l=0.615 //layer=li \
 //thickness=0.1 //x=57.69 //y=1.685 //x2=57.69 //y2=1.07
ends PM_TMRDFFRNQX1\%noxref_49

subckt PM_TMRDFFRNQX1\%noxref_50 ( 1 5 9 10 13 17 29 )
c67 ( 29 0 ) capacitor c=0.067062f //x=62.47 //y=0.545
c68 ( 17 0 ) capacitor c=0.00675704f //x=64.545 //y=0.795
c69 ( 13 0 ) capacitor c=0.0156329f //x=64.46 //y=0.71
c70 ( 10 0 ) capacitor c=0.00673372f //x=63.575 //y=1.675
c71 ( 9 0 ) capacitor c=0.00770028f //x=63.575 //y=0.795
c72 ( 5 0 ) capacitor c=0.0179513f //x=63.49 //y=1.76
c73 ( 1 0 ) capacitor c=0.00761099f //x=62.605 //y=1.675
r74 (  17 29 ) resistor r=3.57586 //w=0.17 //l=0.125 //layer=li \
 //thickness=0.1 //x=64.545 //y=0.795 //x2=64.545 //y2=0.67
r75 (  17 29 ) resistor r=18.139 //w=0.187 //l=0.265 //layer=li \
 //thickness=0.1 //x=64.545 //y=0.795 //x2=64.545 //y2=1.06
r76 (  14 29 ) resistor r=3.57586 //w=0.17 //l=0.103078 //layer=li \
 //thickness=0.1 //x=63.66 //y=0.71 //x2=63.575 //y2=0.67
r77 (  14 29 ) resistor r=27.3797 //w=0.187 //l=0.4 //layer=li //thickness=0.1 \
 //x=63.66 //y=0.71 //x2=64.06 //y2=0.71
r78 (  13 29 ) resistor r=3.57586 //w=0.17 //l=0.103078 //layer=li \
 //thickness=0.1 //x=64.46 //y=0.71 //x2=64.545 //y2=0.67
r79 (  13 29 ) resistor r=27.3797 //w=0.187 //l=0.4 //layer=li //thickness=0.1 \
 //x=64.46 //y=0.71 //x2=64.06 //y2=0.71
r80 (  10 29 ) resistor r=3.57586 //w=0.17 //l=0.125 //layer=li \
 //thickness=0.1 //x=63.575 //y=1.675 //x2=63.575 //y2=1.8
r81 (  10 29 ) resistor r=42.0963 //w=0.187 //l=0.615 //layer=li \
 //thickness=0.1 //x=63.575 //y=1.675 //x2=63.575 //y2=1.06
r82 (  9 29 ) resistor r=3.57586 //w=0.17 //l=0.125 //layer=li //thickness=0.1 \
 //x=63.575 //y=0.795 //x2=63.575 //y2=0.67
r83 (  9 29 ) resistor r=18.139 //w=0.187 //l=0.265 //layer=li //thickness=0.1 \
 //x=63.575 //y=0.795 //x2=63.575 //y2=1.06
r84 (  6 29 ) resistor r=3.57586 //w=0.17 //l=0.103078 //layer=li \
 //thickness=0.1 //x=62.69 //y=1.76 //x2=62.605 //y2=1.8
r85 (  6 29 ) resistor r=27.3797 //w=0.187 //l=0.4 //layer=li //thickness=0.1 \
 //x=62.69 //y=1.76 //x2=63.09 //y2=1.76
r86 (  5 29 ) resistor r=3.57586 //w=0.17 //l=0.103078 //layer=li \
 //thickness=0.1 //x=63.49 //y=1.76 //x2=63.575 //y2=1.8
r87 (  5 29 ) resistor r=27.3797 //w=0.187 //l=0.4 //layer=li //thickness=0.1 \
 //x=63.49 //y=1.76 //x2=63.09 //y2=1.76
r88 (  1 29 ) resistor r=3.57586 //w=0.17 //l=0.125 //layer=li //thickness=0.1 \
 //x=62.605 //y=1.675 //x2=62.605 //y2=1.8
r89 (  1 29 ) resistor r=42.0963 //w=0.187 //l=0.615 //layer=li \
 //thickness=0.1 //x=62.605 //y=1.675 //x2=62.605 //y2=1.06
ends PM_TMRDFFRNQX1\%noxref_50

subckt PM_TMRDFFRNQX1\%noxref_51 ( 1 5 9 13 17 35 )
c58 ( 35 0 ) capacitor c=0.068832f //x=65.695 //y=0.555
c59 ( 17 0 ) capacitor c=0.0190725f //x=67.685 //y=1.77
c60 ( 13 0 ) capacitor c=0.015325f //x=67.685 //y=0.72
c61 ( 9 0 ) capacitor c=0.00772076f //x=66.8 //y=0.805
c62 ( 5 0 ) capacitor c=0.0168501f //x=66.715 //y=1.77
c63 ( 1 0 ) capacitor c=0.00709556f //x=65.83 //y=1.685
r64 (  18 35 ) resistor r=5.4201 //w=0.17 //l=0.103078 //layer=li \
 //thickness=0.1 //x=66.885 //y=1.77 //x2=66.8 //y2=1.81
r65 (  18 35 ) resistor r=27.3797 //w=0.187 //l=0.4 //layer=li //thickness=0.1 \
 //x=66.885 //y=1.77 //x2=67.285 //y2=1.77
r66 (  17 35 ) resistor r=0.751729 //w=0.17 //l=0.085 //layer=li \
 //thickness=0.1 //x=67.685 //y=1.77 //x2=67.77 //y2=1.77
r67 (  17 35 ) resistor r=27.3797 //w=0.187 //l=0.4 //layer=li //thickness=0.1 \
 //x=67.685 //y=1.77 //x2=67.285 //y2=1.77
r68 (  14 35 ) resistor r=3.57586 //w=0.17 //l=0.103078 //layer=li \
 //thickness=0.1 //x=66.885 //y=0.72 //x2=66.8 //y2=0.68
r69 (  14 35 ) resistor r=27.3797 //w=0.187 //l=0.4 //layer=li //thickness=0.1 \
 //x=66.885 //y=0.72 //x2=67.285 //y2=0.72
r70 (  13 35 ) resistor r=0.751729 //w=0.17 //l=0.085 //layer=li \
 //thickness=0.1 //x=67.685 //y=0.72 //x2=67.77 //y2=0.72
r71 (  13 35 ) resistor r=27.3797 //w=0.187 //l=0.4 //layer=li //thickness=0.1 \
 //x=67.685 //y=0.72 //x2=67.285 //y2=0.72
r72 (  10 35 ) resistor r=1.40859 //w=0.34 //l=0.125 //layer=li \
 //thickness=0.1 //x=66.8 //y=1.685 //x2=66.8 //y2=1.81
r73 (  10 35 ) resistor r=42.0963 //w=0.187 //l=0.615 //layer=li \
 //thickness=0.1 //x=66.8 //y=1.685 //x2=66.8 //y2=1.07
r74 (  9 35 ) resistor r=3.57586 //w=0.17 //l=0.125 //layer=li //thickness=0.1 \
 //x=66.8 //y=0.805 //x2=66.8 //y2=0.68
r75 (  9 35 ) resistor r=18.139 //w=0.187 //l=0.265 //layer=li //thickness=0.1 \
 //x=66.8 //y=0.805 //x2=66.8 //y2=1.07
r76 (  6 35 ) resistor r=3.57586 //w=0.17 //l=0.103078 //layer=li \
 //thickness=0.1 //x=65.915 //y=1.77 //x2=65.83 //y2=1.81
r77 (  6 35 ) resistor r=27.3797 //w=0.187 //l=0.4 //layer=li //thickness=0.1 \
 //x=65.915 //y=1.77 //x2=66.315 //y2=1.77
r78 (  5 35 ) resistor r=5.4201 //w=0.17 //l=0.103078 //layer=li \
 //thickness=0.1 //x=66.715 //y=1.77 //x2=66.8 //y2=1.81
r79 (  5 35 ) resistor r=27.3797 //w=0.187 //l=0.4 //layer=li //thickness=0.1 \
 //x=66.715 //y=1.77 //x2=66.315 //y2=1.77
r80 (  1 35 ) resistor r=3.57586 //w=0.17 //l=0.125 //layer=li //thickness=0.1 \
 //x=65.83 //y=1.685 //x2=65.83 //y2=1.81
r81 (  1 35 ) resistor r=42.0963 //w=0.187 //l=0.615 //layer=li \
 //thickness=0.1 //x=65.83 //y=1.685 //x2=65.83 //y2=1.07
ends PM_TMRDFFRNQX1\%noxref_51

subckt PM_TMRDFFRNQX1\%noxref_52 ( 1 5 9 13 17 35 )
c58 ( 35 0 ) capacitor c=0.0695682f //x=70.505 //y=0.555
c59 ( 17 0 ) capacitor c=0.018949f //x=72.495 //y=1.77
c60 ( 13 0 ) capacitor c=0.0153552f //x=72.495 //y=0.72
c61 ( 9 0 ) capacitor c=0.00772076f //x=71.61 //y=0.805
c62 ( 5 0 ) capacitor c=0.0168501f //x=71.525 //y=1.77
c63 ( 1 0 ) capacitor c=0.00710458f //x=70.64 //y=1.685
r64 (  18 35 ) resistor r=5.4201 //w=0.17 //l=0.103078 //layer=li \
 //thickness=0.1 //x=71.695 //y=1.77 //x2=71.61 //y2=1.81
r65 (  18 35 ) resistor r=27.3797 //w=0.187 //l=0.4 //layer=li //thickness=0.1 \
 //x=71.695 //y=1.77 //x2=72.095 //y2=1.77
r66 (  17 35 ) resistor r=0.751729 //w=0.17 //l=0.085 //layer=li \
 //thickness=0.1 //x=72.495 //y=1.77 //x2=72.58 //y2=1.77
r67 (  17 35 ) resistor r=27.3797 //w=0.187 //l=0.4 //layer=li //thickness=0.1 \
 //x=72.495 //y=1.77 //x2=72.095 //y2=1.77
r68 (  14 35 ) resistor r=3.57586 //w=0.17 //l=0.103078 //layer=li \
 //thickness=0.1 //x=71.695 //y=0.72 //x2=71.61 //y2=0.68
r69 (  14 35 ) resistor r=27.3797 //w=0.187 //l=0.4 //layer=li //thickness=0.1 \
 //x=71.695 //y=0.72 //x2=72.095 //y2=0.72
r70 (  13 35 ) resistor r=0.751729 //w=0.17 //l=0.085 //layer=li \
 //thickness=0.1 //x=72.495 //y=0.72 //x2=72.58 //y2=0.72
r71 (  13 35 ) resistor r=27.3797 //w=0.187 //l=0.4 //layer=li //thickness=0.1 \
 //x=72.495 //y=0.72 //x2=72.095 //y2=0.72
r72 (  10 35 ) resistor r=1.40859 //w=0.34 //l=0.125 //layer=li \
 //thickness=0.1 //x=71.61 //y=1.685 //x2=71.61 //y2=1.81
r73 (  10 35 ) resistor r=42.0963 //w=0.187 //l=0.615 //layer=li \
 //thickness=0.1 //x=71.61 //y=1.685 //x2=71.61 //y2=1.07
r74 (  9 35 ) resistor r=3.57586 //w=0.17 //l=0.125 //layer=li //thickness=0.1 \
 //x=71.61 //y=0.805 //x2=71.61 //y2=0.68
r75 (  9 35 ) resistor r=18.139 //w=0.187 //l=0.265 //layer=li //thickness=0.1 \
 //x=71.61 //y=0.805 //x2=71.61 //y2=1.07
r76 (  6 35 ) resistor r=3.57586 //w=0.17 //l=0.103078 //layer=li \
 //thickness=0.1 //x=70.725 //y=1.77 //x2=70.64 //y2=1.81
r77 (  6 35 ) resistor r=27.3797 //w=0.187 //l=0.4 //layer=li //thickness=0.1 \
 //x=70.725 //y=1.77 //x2=71.125 //y2=1.77
r78 (  5 35 ) resistor r=5.4201 //w=0.17 //l=0.103078 //layer=li \
 //thickness=0.1 //x=71.525 //y=1.77 //x2=71.61 //y2=1.81
r79 (  5 35 ) resistor r=27.3797 //w=0.187 //l=0.4 //layer=li //thickness=0.1 \
 //x=71.525 //y=1.77 //x2=71.125 //y2=1.77
r80 (  1 35 ) resistor r=3.57586 //w=0.17 //l=0.125 //layer=li //thickness=0.1 \
 //x=70.64 //y=1.685 //x2=70.64 //y2=1.81
r81 (  1 35 ) resistor r=42.0963 //w=0.187 //l=0.615 //layer=li \
 //thickness=0.1 //x=70.64 //y=1.685 //x2=70.64 //y2=1.07
ends PM_TMRDFFRNQX1\%noxref_52

subckt PM_TMRDFFRNQX1\%noxref_53 ( 1 5 9 10 13 17 29 )
c67 ( 29 0 ) capacitor c=0.0672999f //x=75.42 //y=0.545
c68 ( 17 0 ) capacitor c=0.0067865f //x=77.495 //y=0.795
c69 ( 13 0 ) capacitor c=0.0156392f //x=77.41 //y=0.71
c70 ( 10 0 ) capacitor c=0.00705387f //x=76.525 //y=1.675
c71 ( 9 0 ) capacitor c=0.00770028f //x=76.525 //y=0.795
c72 ( 5 0 ) capacitor c=0.0188733f //x=76.44 //y=1.76
c73 ( 1 0 ) capacitor c=0.00799611f //x=75.555 //y=1.675
r74 (  17 29 ) resistor r=3.57586 //w=0.17 //l=0.125 //layer=li \
 //thickness=0.1 //x=77.495 //y=0.795 //x2=77.495 //y2=0.67
r75 (  17 29 ) resistor r=18.139 //w=0.187 //l=0.265 //layer=li \
 //thickness=0.1 //x=77.495 //y=0.795 //x2=77.495 //y2=1.06
r76 (  14 29 ) resistor r=3.57586 //w=0.17 //l=0.103078 //layer=li \
 //thickness=0.1 //x=76.61 //y=0.71 //x2=76.525 //y2=0.67
r77 (  14 29 ) resistor r=27.3797 //w=0.187 //l=0.4 //layer=li //thickness=0.1 \
 //x=76.61 //y=0.71 //x2=77.01 //y2=0.71
r78 (  13 29 ) resistor r=3.57586 //w=0.17 //l=0.103078 //layer=li \
 //thickness=0.1 //x=77.41 //y=0.71 //x2=77.495 //y2=0.67
r79 (  13 29 ) resistor r=27.3797 //w=0.187 //l=0.4 //layer=li //thickness=0.1 \
 //x=77.41 //y=0.71 //x2=77.01 //y2=0.71
r80 (  10 29 ) resistor r=3.57586 //w=0.17 //l=0.125 //layer=li \
 //thickness=0.1 //x=76.525 //y=1.675 //x2=76.525 //y2=1.8
r81 (  10 29 ) resistor r=42.0963 //w=0.187 //l=0.615 //layer=li \
 //thickness=0.1 //x=76.525 //y=1.675 //x2=76.525 //y2=1.06
r82 (  9 29 ) resistor r=3.57586 //w=0.17 //l=0.125 //layer=li //thickness=0.1 \
 //x=76.525 //y=0.795 //x2=76.525 //y2=0.67
r83 (  9 29 ) resistor r=18.139 //w=0.187 //l=0.265 //layer=li //thickness=0.1 \
 //x=76.525 //y=0.795 //x2=76.525 //y2=1.06
r84 (  6 29 ) resistor r=3.57586 //w=0.17 //l=0.103078 //layer=li \
 //thickness=0.1 //x=75.64 //y=1.76 //x2=75.555 //y2=1.8
r85 (  6 29 ) resistor r=27.3797 //w=0.187 //l=0.4 //layer=li //thickness=0.1 \
 //x=75.64 //y=1.76 //x2=76.04 //y2=1.76
r86 (  5 29 ) resistor r=3.57586 //w=0.17 //l=0.103078 //layer=li \
 //thickness=0.1 //x=76.44 //y=1.76 //x2=76.525 //y2=1.8
r87 (  5 29 ) resistor r=27.3797 //w=0.187 //l=0.4 //layer=li //thickness=0.1 \
 //x=76.44 //y=1.76 //x2=76.04 //y2=1.76
r88 (  1 29 ) resistor r=3.57586 //w=0.17 //l=0.125 //layer=li //thickness=0.1 \
 //x=75.555 //y=1.675 //x2=75.555 //y2=1.8
r89 (  1 29 ) resistor r=42.0963 //w=0.187 //l=0.615 //layer=li \
 //thickness=0.1 //x=75.555 //y=1.675 //x2=75.555 //y2=1.06
ends PM_TMRDFFRNQX1\%noxref_53

subckt PM_TMRDFFRNQX1\%noxref_54 ( 1 5 9 10 13 17 29 )
c69 ( 29 0 ) capacitor c=0.0769028f //x=78.75 //y=0.545
c70 ( 17 0 ) capacitor c=0.00678917f //x=80.825 //y=0.795
c71 ( 13 0 ) capacitor c=0.0154285f //x=80.74 //y=0.71
c72 ( 10 0 ) capacitor c=0.00780084f //x=79.855 //y=1.675
c73 ( 9 0 ) capacitor c=0.00770028f //x=79.855 //y=0.795
c74 ( 5 0 ) capacitor c=0.0216718f //x=79.77 //y=1.76
c75 ( 1 0 ) capacitor c=0.00464525f //x=78.885 //y=1.675
r76 (  17 29 ) resistor r=3.57586 //w=0.17 //l=0.125 //layer=li \
 //thickness=0.1 //x=80.825 //y=0.795 //x2=80.825 //y2=0.67
r77 (  17 29 ) resistor r=41.4118 //w=0.187 //l=0.605 //layer=li \
 //thickness=0.1 //x=80.825 //y=0.795 //x2=80.825 //y2=1.4
r78 (  14 29 ) resistor r=3.57586 //w=0.17 //l=0.103078 //layer=li \
 //thickness=0.1 //x=79.94 //y=0.71 //x2=79.855 //y2=0.67
r79 (  14 29 ) resistor r=27.0374 //w=0.187 //l=0.395 //layer=li \
 //thickness=0.1 //x=79.94 //y=0.71 //x2=80.335 //y2=0.71
r80 (  13 29 ) resistor r=3.57586 //w=0.17 //l=0.103078 //layer=li \
 //thickness=0.1 //x=80.74 //y=0.71 //x2=80.825 //y2=0.67
r81 (  13 29 ) resistor r=27.7219 //w=0.187 //l=0.405 //layer=li \
 //thickness=0.1 //x=80.74 //y=0.71 //x2=80.335 //y2=0.71
r82 (  10 29 ) resistor r=3.57586 //w=0.17 //l=0.125 //layer=li \
 //thickness=0.1 //x=79.855 //y=1.675 //x2=79.855 //y2=1.8
r83 (  10 29 ) resistor r=42.0963 //w=0.187 //l=0.615 //layer=li \
 //thickness=0.1 //x=79.855 //y=1.675 //x2=79.855 //y2=1.06
r84 (  9 29 ) resistor r=3.57586 //w=0.17 //l=0.125 //layer=li //thickness=0.1 \
 //x=79.855 //y=0.795 //x2=79.855 //y2=0.67
r85 (  9 29 ) resistor r=18.139 //w=0.187 //l=0.265 //layer=li //thickness=0.1 \
 //x=79.855 //y=0.795 //x2=79.855 //y2=1.06
r86 (  6 29 ) resistor r=3.57586 //w=0.17 //l=0.103078 //layer=li \
 //thickness=0.1 //x=78.97 //y=1.76 //x2=78.885 //y2=1.8
r87 (  6 29 ) resistor r=27.3797 //w=0.187 //l=0.4 //layer=li //thickness=0.1 \
 //x=78.97 //y=1.76 //x2=79.37 //y2=1.76
r88 (  5 29 ) resistor r=3.57586 //w=0.17 //l=0.103078 //layer=li \
 //thickness=0.1 //x=79.77 //y=1.76 //x2=79.855 //y2=1.8
r89 (  5 29 ) resistor r=27.3797 //w=0.187 //l=0.4 //layer=li //thickness=0.1 \
 //x=79.77 //y=1.76 //x2=79.37 //y2=1.76
r90 (  1 29 ) resistor r=3.57586 //w=0.17 //l=0.125 //layer=li //thickness=0.1 \
 //x=78.885 //y=1.675 //x2=78.885 //y2=1.8
r91 (  1 29 ) resistor r=42.0963 //w=0.187 //l=0.615 //layer=li \
 //thickness=0.1 //x=78.885 //y=1.675 //x2=78.885 //y2=1.06
ends PM_TMRDFFRNQX1\%noxref_54

subckt PM_TMRDFFRNQX1\%noxref_57 ( 1 5 9 10 13 17 29 )
c63 ( 29 0 ) capacitor c=0.0746046f //x=82.08 //y=0.545
c64 ( 17 0 ) capacitor c=0.00678917f //x=84.155 //y=0.795
c65 ( 13 0 ) capacitor c=0.0158009f //x=84.07 //y=0.71
c66 ( 10 0 ) capacitor c=0.00903204f //x=83.185 //y=1.675
c67 ( 9 0 ) capacitor c=0.00770028f //x=83.185 //y=0.795
c68 ( 5 0 ) capacitor c=0.0187096f //x=83.1 //y=1.76
c69 ( 1 0 ) capacitor c=0.00881929f //x=82.215 //y=1.675
r70 (  17 29 ) resistor r=3.57586 //w=0.17 //l=0.125 //layer=li \
 //thickness=0.1 //x=84.155 //y=0.795 //x2=84.155 //y2=0.67
r71 (  17 29 ) resistor r=41.4118 //w=0.187 //l=0.605 //layer=li \
 //thickness=0.1 //x=84.155 //y=0.795 //x2=84.155 //y2=1.4
r72 (  14 29 ) resistor r=3.57586 //w=0.17 //l=0.103078 //layer=li \
 //thickness=0.1 //x=83.27 //y=0.71 //x2=83.185 //y2=0.67
r73 (  14 29 ) resistor r=27.3797 //w=0.187 //l=0.4 //layer=li //thickness=0.1 \
 //x=83.27 //y=0.71 //x2=83.67 //y2=0.71
r74 (  13 29 ) resistor r=3.57586 //w=0.17 //l=0.103078 //layer=li \
 //thickness=0.1 //x=84.07 //y=0.71 //x2=84.155 //y2=0.67
r75 (  13 29 ) resistor r=27.3797 //w=0.187 //l=0.4 //layer=li //thickness=0.1 \
 //x=84.07 //y=0.71 //x2=83.67 //y2=0.71
r76 (  10 29 ) resistor r=3.57586 //w=0.17 //l=0.125 //layer=li \
 //thickness=0.1 //x=83.185 //y=1.675 //x2=83.185 //y2=1.8
r77 (  10 29 ) resistor r=42.0963 //w=0.187 //l=0.615 //layer=li \
 //thickness=0.1 //x=83.185 //y=1.675 //x2=83.185 //y2=1.06
r78 (  9 29 ) resistor r=3.57586 //w=0.17 //l=0.125 //layer=li //thickness=0.1 \
 //x=83.185 //y=0.795 //x2=83.185 //y2=0.67
r79 (  9 29 ) resistor r=18.139 //w=0.187 //l=0.265 //layer=li //thickness=0.1 \
 //x=83.185 //y=0.795 //x2=83.185 //y2=1.06
r80 (  6 29 ) resistor r=3.57586 //w=0.17 //l=0.103078 //layer=li \
 //thickness=0.1 //x=82.3 //y=1.76 //x2=82.215 //y2=1.8
r81 (  6 29 ) resistor r=27.3797 //w=0.187 //l=0.4 //layer=li //thickness=0.1 \
 //x=82.3 //y=1.76 //x2=82.7 //y2=1.76
r82 (  5 29 ) resistor r=3.57586 //w=0.17 //l=0.103078 //layer=li \
 //thickness=0.1 //x=83.1 //y=1.76 //x2=83.185 //y2=1.8
r83 (  5 29 ) resistor r=27.3797 //w=0.187 //l=0.4 //layer=li //thickness=0.1 \
 //x=83.1 //y=1.76 //x2=82.7 //y2=1.76
r84 (  1 29 ) resistor r=3.57586 //w=0.17 //l=0.125 //layer=li //thickness=0.1 \
 //x=82.215 //y=1.675 //x2=82.215 //y2=1.8
r85 (  1 29 ) resistor r=42.0963 //w=0.187 //l=0.615 //layer=li \
 //thickness=0.1 //x=82.215 //y=1.675 //x2=82.215 //y2=1.06
ends PM_TMRDFFRNQX1\%noxref_57

subckt PM_TMRDFFRNQX1\%noxref_58 ( 1 5 9 10 13 17 29 )
c69 ( 29 0 ) capacitor c=0.0678679f //x=85.41 //y=0.545
c70 ( 17 0 ) capacitor c=0.00709795f //x=87.485 //y=0.795
c71 ( 13 0 ) capacitor c=0.0152565f //x=87.4 //y=0.71
c72 ( 10 0 ) capacitor c=0.00749806f //x=86.515 //y=1.675
c73 ( 9 0 ) capacitor c=0.00770028f //x=86.515 //y=0.795
c74 ( 5 0 ) capacitor c=0.0236235f //x=86.43 //y=1.76
c75 ( 1 0 ) capacitor c=0.00498238f //x=85.545 //y=1.675
r76 (  17 29 ) resistor r=3.57586 //w=0.17 //l=0.125 //layer=li \
 //thickness=0.1 //x=87.485 //y=0.795 //x2=87.485 //y2=0.67
r77 (  17 29 ) resistor r=18.139 //w=0.187 //l=0.265 //layer=li \
 //thickness=0.1 //x=87.485 //y=0.795 //x2=87.485 //y2=1.06
r78 (  14 29 ) resistor r=3.57586 //w=0.17 //l=0.103078 //layer=li \
 //thickness=0.1 //x=86.6 //y=0.71 //x2=86.515 //y2=0.67
r79 (  14 29 ) resistor r=27.3797 //w=0.187 //l=0.4 //layer=li //thickness=0.1 \
 //x=86.6 //y=0.71 //x2=87 //y2=0.71
r80 (  13 29 ) resistor r=3.57586 //w=0.17 //l=0.103078 //layer=li \
 //thickness=0.1 //x=87.4 //y=0.71 //x2=87.485 //y2=0.67
r81 (  13 29 ) resistor r=27.3797 //w=0.187 //l=0.4 //layer=li //thickness=0.1 \
 //x=87.4 //y=0.71 //x2=87 //y2=0.71
r82 (  10 29 ) resistor r=3.57586 //w=0.17 //l=0.125 //layer=li \
 //thickness=0.1 //x=86.515 //y=1.675 //x2=86.515 //y2=1.8
r83 (  10 29 ) resistor r=42.0963 //w=0.187 //l=0.615 //layer=li \
 //thickness=0.1 //x=86.515 //y=1.675 //x2=86.515 //y2=1.06
r84 (  9 29 ) resistor r=3.57586 //w=0.17 //l=0.125 //layer=li //thickness=0.1 \
 //x=86.515 //y=0.795 //x2=86.515 //y2=0.67
r85 (  9 29 ) resistor r=18.139 //w=0.187 //l=0.265 //layer=li //thickness=0.1 \
 //x=86.515 //y=0.795 //x2=86.515 //y2=1.06
r86 (  6 29 ) resistor r=3.57586 //w=0.17 //l=0.103078 //layer=li \
 //thickness=0.1 //x=85.63 //y=1.76 //x2=85.545 //y2=1.8
r87 (  6 29 ) resistor r=27.3797 //w=0.187 //l=0.4 //layer=li //thickness=0.1 \
 //x=85.63 //y=1.76 //x2=86.03 //y2=1.76
r88 (  5 29 ) resistor r=3.57586 //w=0.17 //l=0.103078 //layer=li \
 //thickness=0.1 //x=86.43 //y=1.76 //x2=86.515 //y2=1.8
r89 (  5 29 ) resistor r=27.3797 //w=0.187 //l=0.4 //layer=li //thickness=0.1 \
 //x=86.43 //y=1.76 //x2=86.03 //y2=1.76
r90 (  1 29 ) resistor r=3.57586 //w=0.17 //l=0.125 //layer=li //thickness=0.1 \
 //x=85.545 //y=1.675 //x2=85.545 //y2=1.8
r91 (  1 29 ) resistor r=42.0963 //w=0.187 //l=0.615 //layer=li \
 //thickness=0.1 //x=85.545 //y=1.675 //x2=85.545 //y2=1.06
ends PM_TMRDFFRNQX1\%noxref_58
