// File: TMRDFFRNQX1.spi.pex
// Created: Tue Apr 29 10:45:32 2025
// Program "Calibre xRC"
// Version "v2023.2_27.15"
// Nominal Temperature: 30C
// Circuit Temperature: 30C
//
simulator lang=spectre
subckt PM_TMRDFFRNQX1\%GND ( 1 151 155 158 163 173 181 191 199 207 213 223 229 \
 239 245 251 259 269 277 287 295 303 311 321 329 339 347 355 361 371 377 387 \
 393 399 407 417 425 435 443 451 459 467 473 479 487 498 503 507 520 522 524 \
 527 530 533 535 537 539 541 543 545 548 551 554 556 558 560 562 565 567 574 \
 581 582 583 584 585 586 587 588 589 590 591 592 593 594 595 596 597 598 599 \
 600 601 602 )
c1025 ( 602 0 ) capacitor c=0.0604394f //x=88.675 //y=0.55
c1026 ( 601 0 ) capacitor c=0.0215013f //x=85.84 //y=1.045
c1027 ( 600 0 ) capacitor c=0.0215013f //x=82.51 //y=1.045
c1028 ( 599 0 ) capacitor c=0.0207525f //x=79.18 //y=1.045
c1029 ( 598 0 ) capacitor c=0.0207874f //x=75.85 //y=1.045
c1030 ( 597 0 ) capacitor c=0.0225954f //x=70.935 //y=1.055
c1031 ( 596 0 ) capacitor c=0.0226075f //x=66.125 //y=1.055
c1032 ( 595 0 ) capacitor c=0.0207408f //x=62.9 //y=1.045
c1033 ( 594 0 ) capacitor c=0.0225954f //x=57.985 //y=1.055
c1034 ( 593 0 ) capacitor c=0.0226075f //x=53.175 //y=1.055
c1035 ( 592 0 ) capacitor c=0.0207408f //x=49.95 //y=1.045
c1036 ( 591 0 ) capacitor c=0.0225954f //x=45.035 //y=1.055
c1037 ( 590 0 ) capacitor c=0.0226075f //x=40.225 //y=1.055
c1038 ( 589 0 ) capacitor c=0.0207408f //x=37 //y=1.045
c1039 ( 588 0 ) capacitor c=0.0225954f //x=32.085 //y=1.055
c1040 ( 587 0 ) capacitor c=0.0226075f //x=27.275 //y=1.055
c1041 ( 586 0 ) capacitor c=0.0207408f //x=24.05 //y=1.045
c1042 ( 585 0 ) capacitor c=0.0225954f //x=19.135 //y=1.055
c1043 ( 584 0 ) capacitor c=0.0226075f //x=14.325 //y=1.055
c1044 ( 583 0 ) capacitor c=0.0207408f //x=11.1 //y=1.045
c1045 ( 582 0 ) capacitor c=0.0226571f //x=6.185 //y=1.055
c1046 ( 581 0 ) capacitor c=0.022675f //x=1.375 //y=1.055
c1047 ( 574 0 ) capacitor c=0.253772f //x=89.78 //y=0.175
c1048 ( 567 0 ) capacitor c=0.102069f //x=88.18 //y=0.175
c1049 ( 566 0 ) capacitor c=0.00446416f //x=86.03 //y=0.175
c1050 ( 565 0 ) capacitor c=0.101602f //x=84.85 //y=0.175
c1051 ( 564 0 ) capacitor c=0.00446416f //x=82.63 //y=0.18
c1052 ( 562 0 ) capacitor c=0.1166f //x=81.52 //y=0.175
c1053 ( 561 0 ) capacitor c=0.00446416f //x=79.37 //y=0.175
c1054 ( 560 0 ) capacitor c=0.1042f //x=78.19 //y=0.175
c1055 ( 559 0 ) capacitor c=0.00446416f //x=76.04 //y=0.175
c1056 ( 558 0 ) capacitor c=0.109421f //x=74.86 //y=0.175
c1057 ( 557 0 ) capacitor c=0.00446464f //x=71.125 //y=0.175
c1058 ( 556 0 ) capacitor c=0.107029f //x=70.05 //y=0.175
c1059 ( 555 0 ) capacitor c=0.00446464f //x=66.315 //y=0.175
c1060 ( 554 0 ) capacitor c=0.104256f //x=65.24 //y=0.175
c1061 ( 553 0 ) capacitor c=0.00446416f //x=63.02 //y=0.18
c1062 ( 551 0 ) capacitor c=0.108115f //x=61.91 //y=0.175
c1063 ( 550 0 ) capacitor c=0.00446464f //x=58.21 //y=0.18
c1064 ( 548 0 ) capacitor c=0.107529f //x=57.1 //y=0.175
c1065 ( 547 0 ) capacitor c=0.00446464f //x=53.4 //y=0.18
c1066 ( 545 0 ) capacitor c=0.104705f //x=52.29 //y=0.175
c1067 ( 544 0 ) capacitor c=0.00446416f //x=50.14 //y=0.175
c1068 ( 543 0 ) capacitor c=0.108811f //x=48.96 //y=0.175
c1069 ( 542 0 ) capacitor c=0.00446464f //x=45.225 //y=0.175
c1070 ( 541 0 ) capacitor c=0.107455f //x=44.15 //y=0.175
c1071 ( 540 0 ) capacitor c=0.00446464f //x=40.415 //y=0.175
c1072 ( 539 0 ) capacitor c=0.104681f //x=39.34 //y=0.175
c1073 ( 538 0 ) capacitor c=0.00446416f //x=37.19 //y=0.175
c1074 ( 537 0 ) capacitor c=0.10869f //x=36.01 //y=0.175
c1075 ( 536 0 ) capacitor c=0.00446464f //x=32.275 //y=0.175
c1076 ( 535 0 ) capacitor c=0.107529f //x=31.2 //y=0.175
c1077 ( 534 0 ) capacitor c=0.00446464f //x=27.465 //y=0.175
c1078 ( 533 0 ) capacitor c=0.104705f //x=26.39 //y=0.175
c1079 ( 532 0 ) capacitor c=0.00446416f //x=24.17 //y=0.18
c1080 ( 530 0 ) capacitor c=0.108811f //x=23.06 //y=0.175
c1081 ( 529 0 ) capacitor c=0.00446464f //x=19.36 //y=0.18
c1082 ( 527 0 ) capacitor c=0.107455f //x=18.25 //y=0.175
c1083 ( 526 0 ) capacitor c=0.00446464f //x=14.55 //y=0.18
c1084 ( 524 0 ) capacitor c=0.104681f //x=13.44 //y=0.175
c1085 ( 523 0 ) capacitor c=0.00446416f //x=11.29 //y=0.175
c1086 ( 522 0 ) capacitor c=0.10869f //x=10.11 //y=0.175
c1087 ( 521 0 ) capacitor c=0.00446464f //x=6.375 //y=0.175
c1088 ( 520 0 ) capacitor c=0.108483f //x=5.3 //y=0.175
c1089 ( 519 0 ) capacitor c=0.00446464f //x=1.565 //y=0.175
c1090 ( 510 0 ) capacitor c=0.00583665f //x=89.78 //y=0.63
c1091 ( 507 0 ) capacitor c=0.00542565f //x=89.695 //y=0.715
c1092 ( 506 0 ) capacitor c=0.00479856f //x=89.295 //y=0.63
c1093 ( 503 0 ) capacitor c=0.00707849f //x=89.21 //y=0.715
c1094 ( 498 0 ) capacitor c=0.00588377f //x=88.81 //y=0.63
c1095 ( 495 0 ) capacitor c=0.0191899f //x=88.725 //y=0.175
c1096 ( 487 0 ) capacitor c=0.0758845f //x=88.01 //y=0.175
c1097 ( 479 0 ) capacitor c=0.0393378f //x=85.945 //y=0.175
c1098 ( 473 0 ) capacitor c=0.0725462f //x=84.68 //y=0.175
c1099 ( 467 0 ) capacitor c=0.0391794f //x=82.615 //y=0.175
c1100 ( 459 0 ) capacitor c=0.0726698f //x=81.35 //y=0.175
c1101 ( 451 0 ) capacitor c=0.0394931f //x=79.285 //y=0.175
c1102 ( 443 0 ) capacitor c=0.0727797f //x=78.02 //y=0.175
c1103 ( 435 0 ) capacitor c=0.0392687f //x=75.955 //y=0.175
c1104 ( 425 0 ) capacitor c=0.13531f //x=74.69 //y=0.175
c1105 ( 417 0 ) capacitor c=0.0342713f //x=71.04 //y=0.175
c1106 ( 407 0 ) capacitor c=0.135264f //x=69.88 //y=0.175
c1107 ( 399 0 ) capacitor c=0.0342713f //x=66.23 //y=0.175
c1108 ( 393 0 ) capacitor c=0.0727058f //x=65.07 //y=0.175
c1109 ( 387 0 ) capacitor c=0.0392405f //x=63.005 //y=0.175
c1110 ( 377 0 ) capacitor c=0.135264f //x=61.74 //y=0.175
c1111 ( 371 0 ) capacitor c=0.0342713f //x=58.09 //y=0.175
c1112 ( 361 0 ) capacitor c=0.135066f //x=56.93 //y=0.175
c1113 ( 355 0 ) capacitor c=0.0342713f //x=53.28 //y=0.175
c1114 ( 347 0 ) capacitor c=0.0727058f //x=52.12 //y=0.175
c1115 ( 339 0 ) capacitor c=0.0392405f //x=50.055 //y=0.175
c1116 ( 329 0 ) capacitor c=0.135066f //x=48.79 //y=0.175
c1117 ( 321 0 ) capacitor c=0.0342713f //x=45.14 //y=0.175
c1118 ( 311 0 ) capacitor c=0.135264f //x=43.98 //y=0.175
c1119 ( 303 0 ) capacitor c=0.0342713f //x=40.33 //y=0.175
c1120 ( 295 0 ) capacitor c=0.0727058f //x=39.17 //y=0.175
c1121 ( 287 0 ) capacitor c=0.0392405f //x=37.105 //y=0.175
c1122 ( 277 0 ) capacitor c=0.135264f //x=35.84 //y=0.175
c1123 ( 269 0 ) capacitor c=0.0342713f //x=32.19 //y=0.175
c1124 ( 259 0 ) capacitor c=0.135066f //x=31.03 //y=0.175
c1125 ( 251 0 ) capacitor c=0.0342713f //x=27.38 //y=0.175
c1126 ( 245 0 ) capacitor c=0.0727058f //x=26.22 //y=0.175
c1127 ( 239 0 ) capacitor c=0.0392405f //x=24.155 //y=0.175
c1128 ( 229 0 ) capacitor c=0.135066f //x=22.89 //y=0.175
c1129 ( 223 0 ) capacitor c=0.0342713f //x=19.24 //y=0.175
c1130 ( 213 0 ) capacitor c=0.135264f //x=18.08 //y=0.175
c1131 ( 207 0 ) capacitor c=0.0342713f //x=14.43 //y=0.175
c1132 ( 199 0 ) capacitor c=0.0727058f //x=13.27 //y=0.175
c1133 ( 191 0 ) capacitor c=0.0392405f //x=11.205 //y=0.175
c1134 ( 181 0 ) capacitor c=0.13523f //x=9.94 //y=0.175
c1135 ( 173 0 ) capacitor c=0.0343125f //x=6.29 //y=0.175
c1136 ( 163 0 ) capacitor c=0.133468f //x=5.13 //y=0.175
c1137 ( 158 0 ) capacitor c=0.196955f //x=1.23 //y=0.18
c1138 ( 155 0 ) capacitor c=0.0370791f //x=1.48 //y=0.175
c1139 ( 151 0 ) capacitor c=2.75189f //x=89.66 //y=0.18
r1140 (  573 574 ) resistor r=4.18529 //w=0.367 //l=0.12 //layer=li \
 //thickness=0.1 //x=89.66 //y=0.175 //x2=89.78 //y2=0.175
r1141 (  571 573 ) resistor r=12.7302 //w=0.367 //l=0.365 //layer=li \
 //thickness=0.1 //x=89.295 //y=0.175 //x2=89.66 //y2=0.175
r1142 (  570 571 ) resistor r=13.079 //w=0.367 //l=0.375 //layer=li \
 //thickness=0.1 //x=88.92 //y=0.175 //x2=89.295 //y2=0.175
r1143 (  568 570 ) resistor r=3.83651 //w=0.367 //l=0.11 //layer=li \
 //thickness=0.1 //x=88.81 //y=0.175 //x2=88.92 //y2=0.175
r1144 (  511 602 ) resistor r=5.4201 //w=0.17 //l=0.085 //layer=li \
 //thickness=0.1 //x=89.78 //y=0.8 //x2=89.78 //y2=0.715
r1145 (  511 602 ) resistor r=41.4118 //w=0.187 //l=0.605 //layer=li \
 //thickness=0.1 //x=89.78 //y=0.8 //x2=89.78 //y2=1.405
r1146 (  510 602 ) resistor r=5.4201 //w=0.17 //l=0.085 //layer=li \
 //thickness=0.1 //x=89.78 //y=0.63 //x2=89.78 //y2=0.715
r1147 (  509 574 ) resistor r=5.21862 //w=0.35 //l=0.175 //layer=li \
 //thickness=0.1 //x=89.78 //y=0.35 //x2=89.78 //y2=0.175
r1148 (  509 510 ) resistor r=19.1658 //w=0.187 //l=0.28 //layer=li \
 //thickness=0.1 //x=89.78 //y=0.35 //x2=89.78 //y2=0.63
r1149 (  508 602 ) resistor r=5.4201 //w=0.17 //l=0.085 //layer=li \
 //thickness=0.1 //x=89.38 //y=0.715 //x2=89.295 //y2=0.715
r1150 (  507 602 ) resistor r=1.40859 //w=0.34 //l=0.085 //layer=li \
 //thickness=0.1 //x=89.695 //y=0.715 //x2=89.78 //y2=0.715
r1151 (  507 508 ) resistor r=21.5615 //w=0.187 //l=0.315 //layer=li \
 //thickness=0.1 //x=89.695 //y=0.715 //x2=89.38 //y2=0.715
r1152 (  506 602 ) resistor r=1.40859 //w=0.34 //l=0.085 //layer=li \
 //thickness=0.1 //x=89.295 //y=0.63 //x2=89.295 //y2=0.715
r1153 (  505 571 ) resistor r=5.21862 //w=0.35 //l=0.175 //layer=li \
 //thickness=0.1 //x=89.295 //y=0.35 //x2=89.295 //y2=0.175
r1154 (  505 506 ) resistor r=19.1658 //w=0.187 //l=0.28 //layer=li \
 //thickness=0.1 //x=89.295 //y=0.35 //x2=89.295 //y2=0.63
r1155 (  504 602 ) resistor r=1.40859 //w=0.34 //l=0.085 //layer=li \
 //thickness=0.1 //x=88.895 //y=0.715 //x2=88.81 //y2=0.715
r1156 (  503 602 ) resistor r=5.4201 //w=0.17 //l=0.085 //layer=li \
 //thickness=0.1 //x=89.21 //y=0.715 //x2=89.295 //y2=0.715
r1157 (  503 504 ) resistor r=21.5615 //w=0.187 //l=0.315 //layer=li \
 //thickness=0.1 //x=89.21 //y=0.715 //x2=88.895 //y2=0.715
r1158 (  499 602 ) resistor r=5.4201 //w=0.17 //l=0.085 //layer=li \
 //thickness=0.1 //x=88.81 //y=0.8 //x2=88.81 //y2=0.715
r1159 (  499 602 ) resistor r=41.4118 //w=0.187 //l=0.605 //layer=li \
 //thickness=0.1 //x=88.81 //y=0.8 //x2=88.81 //y2=1.405
r1160 (  498 602 ) resistor r=5.4201 //w=0.17 //l=0.085 //layer=li \
 //thickness=0.1 //x=88.81 //y=0.63 //x2=88.81 //y2=0.715
r1161 (  497 568 ) resistor r=5.21862 //w=0.35 //l=0.175 //layer=li \
 //thickness=0.1 //x=88.81 //y=0.35 //x2=88.81 //y2=0.175
r1162 (  497 498 ) resistor r=19.1658 //w=0.187 //l=0.28 //layer=li \
 //thickness=0.1 //x=88.81 //y=0.35 //x2=88.81 //y2=0.63
r1163 (  496 567 ) resistor r=5.29055 //w=0.35 //l=0.17 //layer=li \
 //thickness=0.1 //x=88.35 //y=0.175 //x2=88.18 //y2=0.175
r1164 (  495 568 ) resistor r=2.96458 //w=0.367 //l=0.085 //layer=li \
 //thickness=0.1 //x=88.725 //y=0.175 //x2=88.81 //y2=0.175
r1165 (  495 496 ) resistor r=13.079 //w=0.367 //l=0.375 //layer=li \
 //thickness=0.1 //x=88.725 //y=0.175 //x2=88.35 //y2=0.175
r1166 (  490 492 ) resistor r=38.7139 //w=0.367 //l=1.11 //layer=li \
 //thickness=0.1 //x=86.33 //y=0.175 //x2=87.44 //y2=0.175
r1167 (  488 566 ) resistor r=2.87058 //w=0.35 //l=0.085 //layer=li \
 //thickness=0.1 //x=86.115 //y=0.175 //x2=86.03 //y2=0.175
r1168 (  488 490 ) resistor r=7.49864 //w=0.367 //l=0.215 //layer=li \
 //thickness=0.1 //x=86.115 //y=0.175 //x2=86.33 //y2=0.175
r1169 (  487 567 ) resistor r=5.29055 //w=0.35 //l=0.17 //layer=li \
 //thickness=0.1 //x=88.01 //y=0.175 //x2=88.18 //y2=0.175
r1170 (  487 492 ) resistor r=19.8801 //w=0.367 //l=0.57 //layer=li \
 //thickness=0.1 //x=88.01 //y=0.175 //x2=87.44 //y2=0.175
r1171 (  483 566 ) resistor r=4.23183 //w=0.7 //l=0.175 //layer=li \
 //thickness=0.1 //x=86.03 //y=0.35 //x2=86.03 //y2=0.175
r1172 (  483 601 ) resistor r=53.7326 //w=0.187 //l=0.785 //layer=li \
 //thickness=0.1 //x=86.03 //y=0.35 //x2=86.03 //y2=1.135
r1173 (  480 565 ) resistor r=5.29055 //w=0.35 //l=0.17 //layer=li \
 //thickness=0.1 //x=85.02 //y=0.175 //x2=84.85 //y2=0.175
r1174 (  480 482 ) resistor r=6.97548 //w=0.367 //l=0.2 //layer=li \
 //thickness=0.1 //x=85.02 //y=0.175 //x2=85.22 //y2=0.175
r1175 (  479 566 ) resistor r=2.87058 //w=0.35 //l=0.085 //layer=li \
 //thickness=0.1 //x=85.945 //y=0.175 //x2=86.03 //y2=0.175
r1176 (  479 482 ) resistor r=25.2861 //w=0.367 //l=0.725 //layer=li \
 //thickness=0.1 //x=85.945 //y=0.175 //x2=85.22 //y2=0.175
r1177 (  474 564 ) resistor r=2.87058 //w=0.35 //l=0.085 //layer=li \
 //thickness=0.1 //x=82.785 //y=0.175 //x2=82.7 //y2=0.175
r1178 (  474 476 ) resistor r=33.3079 //w=0.367 //l=0.955 //layer=li \
 //thickness=0.1 //x=82.785 //y=0.175 //x2=83.74 //y2=0.175
r1179 (  473 565 ) resistor r=5.29055 //w=0.35 //l=0.17 //layer=li \
 //thickness=0.1 //x=84.68 //y=0.175 //x2=84.85 //y2=0.175
r1180 (  473 476 ) resistor r=32.7847 //w=0.367 //l=0.94 //layer=li \
 //thickness=0.1 //x=84.68 //y=0.175 //x2=83.74 //y2=0.175
r1181 (  469 564 ) resistor r=4.23183 //w=0.7 //l=0.175 //layer=li \
 //thickness=0.1 //x=82.7 //y=0.35 //x2=82.7 //y2=0.175
r1182 (  469 600 ) resistor r=53.7326 //w=0.187 //l=0.785 //layer=li \
 //thickness=0.1 //x=82.7 //y=0.35 //x2=82.7 //y2=1.135
r1183 (  468 562 ) resistor r=5.29055 //w=0.35 //l=0.17 //layer=li \
 //thickness=0.1 //x=81.69 //y=0.175 //x2=81.52 //y2=0.175
r1184 (  467 564 ) resistor r=2.87058 //w=0.35 //l=0.085 //layer=li \
 //thickness=0.1 //x=82.615 //y=0.175 //x2=82.7 //y2=0.175
r1185 (  467 468 ) resistor r=32.2616 //w=0.367 //l=0.925 //layer=li \
 //thickness=0.1 //x=82.615 //y=0.175 //x2=81.69 //y2=0.175
r1186 (  462 464 ) resistor r=38.7139 //w=0.367 //l=1.11 //layer=li \
 //thickness=0.1 //x=80.04 //y=0.175 //x2=81.15 //y2=0.175
r1187 (  460 561 ) resistor r=2.87058 //w=0.35 //l=0.085 //layer=li \
 //thickness=0.1 //x=79.455 //y=0.175 //x2=79.37 //y2=0.175
r1188 (  460 462 ) resistor r=20.4033 //w=0.367 //l=0.585 //layer=li \
 //thickness=0.1 //x=79.455 //y=0.175 //x2=80.04 //y2=0.175
r1189 (  459 562 ) resistor r=5.29055 //w=0.35 //l=0.17 //layer=li \
 //thickness=0.1 //x=81.35 //y=0.175 //x2=81.52 //y2=0.175
r1190 (  459 464 ) resistor r=6.97548 //w=0.367 //l=0.2 //layer=li \
 //thickness=0.1 //x=81.35 //y=0.175 //x2=81.15 //y2=0.175
r1191 (  455 561 ) resistor r=4.23183 //w=0.7 //l=0.175 //layer=li \
 //thickness=0.1 //x=79.37 //y=0.35 //x2=79.37 //y2=0.175
r1192 (  455 599 ) resistor r=53.7326 //w=0.187 //l=0.785 //layer=li \
 //thickness=0.1 //x=79.37 //y=0.35 //x2=79.37 //y2=1.135
r1193 (  452 560 ) resistor r=5.29055 //w=0.35 //l=0.17 //layer=li \
 //thickness=0.1 //x=78.36 //y=0.175 //x2=78.19 //y2=0.175
r1194 (  452 454 ) resistor r=19.8801 //w=0.367 //l=0.57 //layer=li \
 //thickness=0.1 //x=78.36 //y=0.175 //x2=78.93 //y2=0.175
r1195 (  451 561 ) resistor r=2.87058 //w=0.35 //l=0.085 //layer=li \
 //thickness=0.1 //x=79.285 //y=0.175 //x2=79.37 //y2=0.175
r1196 (  451 454 ) resistor r=12.3815 //w=0.367 //l=0.355 //layer=li \
 //thickness=0.1 //x=79.285 //y=0.175 //x2=78.93 //y2=0.175
r1197 (  446 448 ) resistor r=38.7139 //w=0.367 //l=1.11 //layer=li \
 //thickness=0.1 //x=76.34 //y=0.175 //x2=77.45 //y2=0.175
r1198 (  444 559 ) resistor r=2.87058 //w=0.35 //l=0.085 //layer=li \
 //thickness=0.1 //x=76.125 //y=0.175 //x2=76.04 //y2=0.175
r1199 (  444 446 ) resistor r=7.49864 //w=0.367 //l=0.215 //layer=li \
 //thickness=0.1 //x=76.125 //y=0.175 //x2=76.34 //y2=0.175
r1200 (  443 560 ) resistor r=5.29055 //w=0.35 //l=0.17 //layer=li \
 //thickness=0.1 //x=78.02 //y=0.175 //x2=78.19 //y2=0.175
r1201 (  443 448 ) resistor r=19.8801 //w=0.367 //l=0.57 //layer=li \
 //thickness=0.1 //x=78.02 //y=0.175 //x2=77.45 //y2=0.175
r1202 (  439 559 ) resistor r=4.23183 //w=0.7 //l=0.175 //layer=li \
 //thickness=0.1 //x=76.04 //y=0.35 //x2=76.04 //y2=0.175
r1203 (  439 598 ) resistor r=53.7326 //w=0.187 //l=0.785 //layer=li \
 //thickness=0.1 //x=76.04 //y=0.35 //x2=76.04 //y2=1.135
r1204 (  436 558 ) resistor r=5.29055 //w=0.35 //l=0.17 //layer=li \
 //thickness=0.1 //x=75.03 //y=0.175 //x2=74.86 //y2=0.175
r1205 (  436 438 ) resistor r=6.97548 //w=0.367 //l=0.2 //layer=li \
 //thickness=0.1 //x=75.03 //y=0.175 //x2=75.23 //y2=0.175
r1206 (  435 559 ) resistor r=2.87058 //w=0.35 //l=0.085 //layer=li \
 //thickness=0.1 //x=75.955 //y=0.175 //x2=76.04 //y2=0.175
r1207 (  435 438 ) resistor r=25.2861 //w=0.367 //l=0.725 //layer=li \
 //thickness=0.1 //x=75.955 //y=0.175 //x2=75.23 //y2=0.175
r1208 (  430 432 ) resistor r=38.7139 //w=0.367 //l=1.11 //layer=li \
 //thickness=0.1 //x=72.64 //y=0.175 //x2=73.75 //y2=0.175
r1209 (  428 430 ) resistor r=38.7139 //w=0.367 //l=1.11 //layer=li \
 //thickness=0.1 //x=71.53 //y=0.175 //x2=72.64 //y2=0.175
r1210 (  426 557 ) resistor r=2.87058 //w=0.35 //l=0.085 //layer=li \
 //thickness=0.1 //x=71.21 //y=0.175 //x2=71.125 //y2=0.175
r1211 (  426 428 ) resistor r=11.1608 //w=0.367 //l=0.32 //layer=li \
 //thickness=0.1 //x=71.21 //y=0.175 //x2=71.53 //y2=0.175
r1212 (  425 558 ) resistor r=5.29055 //w=0.35 //l=0.17 //layer=li \
 //thickness=0.1 //x=74.69 //y=0.175 //x2=74.86 //y2=0.175
r1213 (  425 432 ) resistor r=32.7847 //w=0.367 //l=0.94 //layer=li \
 //thickness=0.1 //x=74.69 //y=0.175 //x2=73.75 //y2=0.175
r1214 (  421 557 ) resistor r=4.23183 //w=0.7 //l=0.175 //layer=li \
 //thickness=0.1 //x=71.125 //y=0.35 //x2=71.125 //y2=0.175
r1215 (  421 597 ) resistor r=54.4171 //w=0.187 //l=0.795 //layer=li \
 //thickness=0.1 //x=71.125 //y=0.35 //x2=71.125 //y2=1.145
r1216 (  418 556 ) resistor r=5.29055 //w=0.35 //l=0.17 //layer=li \
 //thickness=0.1 //x=70.22 //y=0.175 //x2=70.05 //y2=0.175
r1217 (  418 420 ) resistor r=6.97548 //w=0.367 //l=0.2 //layer=li \
 //thickness=0.1 //x=70.22 //y=0.175 //x2=70.42 //y2=0.175
r1218 (  417 557 ) resistor r=2.87058 //w=0.35 //l=0.085 //layer=li \
 //thickness=0.1 //x=71.04 //y=0.175 //x2=71.125 //y2=0.175
r1219 (  417 420 ) resistor r=21.624 //w=0.367 //l=0.62 //layer=li \
 //thickness=0.1 //x=71.04 //y=0.175 //x2=70.42 //y2=0.175
r1220 (  412 414 ) resistor r=38.7139 //w=0.367 //l=1.11 //layer=li \
 //thickness=0.1 //x=67.83 //y=0.175 //x2=68.94 //y2=0.175
r1221 (  410 412 ) resistor r=38.7139 //w=0.367 //l=1.11 //layer=li \
 //thickness=0.1 //x=66.72 //y=0.175 //x2=67.83 //y2=0.175
r1222 (  408 555 ) resistor r=2.87058 //w=0.35 //l=0.085 //layer=li \
 //thickness=0.1 //x=66.4 //y=0.175 //x2=66.315 //y2=0.175
r1223 (  408 410 ) resistor r=11.1608 //w=0.367 //l=0.32 //layer=li \
 //thickness=0.1 //x=66.4 //y=0.175 //x2=66.72 //y2=0.175
r1224 (  407 556 ) resistor r=5.29055 //w=0.35 //l=0.17 //layer=li \
 //thickness=0.1 //x=69.88 //y=0.175 //x2=70.05 //y2=0.175
r1225 (  407 414 ) resistor r=32.7847 //w=0.367 //l=0.94 //layer=li \
 //thickness=0.1 //x=69.88 //y=0.175 //x2=68.94 //y2=0.175
r1226 (  403 555 ) resistor r=4.23183 //w=0.7 //l=0.175 //layer=li \
 //thickness=0.1 //x=66.315 //y=0.35 //x2=66.315 //y2=0.175
r1227 (  403 596 ) resistor r=54.4171 //w=0.187 //l=0.795 //layer=li \
 //thickness=0.1 //x=66.315 //y=0.35 //x2=66.315 //y2=1.145
r1228 (  400 554 ) resistor r=5.29055 //w=0.35 //l=0.17 //layer=li \
 //thickness=0.1 //x=65.41 //y=0.175 //x2=65.24 //y2=0.175
r1229 (  400 402 ) resistor r=6.97548 //w=0.367 //l=0.2 //layer=li \
 //thickness=0.1 //x=65.41 //y=0.175 //x2=65.61 //y2=0.175
r1230 (  399 555 ) resistor r=2.87058 //w=0.35 //l=0.085 //layer=li \
 //thickness=0.1 //x=66.23 //y=0.175 //x2=66.315 //y2=0.175
r1231 (  399 402 ) resistor r=21.624 //w=0.367 //l=0.62 //layer=li \
 //thickness=0.1 //x=66.23 //y=0.175 //x2=65.61 //y2=0.175
r1232 (  394 553 ) resistor r=2.87058 //w=0.35 //l=0.085 //layer=li \
 //thickness=0.1 //x=63.175 //y=0.175 //x2=63.09 //y2=0.175
r1233 (  394 396 ) resistor r=33.3079 //w=0.367 //l=0.955 //layer=li \
 //thickness=0.1 //x=63.175 //y=0.175 //x2=64.13 //y2=0.175
r1234 (  393 554 ) resistor r=5.29055 //w=0.35 //l=0.17 //layer=li \
 //thickness=0.1 //x=65.07 //y=0.175 //x2=65.24 //y2=0.175
r1235 (  393 396 ) resistor r=32.7847 //w=0.367 //l=0.94 //layer=li \
 //thickness=0.1 //x=65.07 //y=0.175 //x2=64.13 //y2=0.175
r1236 (  389 553 ) resistor r=4.23183 //w=0.7 //l=0.175 //layer=li \
 //thickness=0.1 //x=63.09 //y=0.35 //x2=63.09 //y2=0.175
r1237 (  389 595 ) resistor r=53.7326 //w=0.187 //l=0.785 //layer=li \
 //thickness=0.1 //x=63.09 //y=0.35 //x2=63.09 //y2=1.135
r1238 (  388 551 ) resistor r=5.29055 //w=0.35 //l=0.17 //layer=li \
 //thickness=0.1 //x=62.08 //y=0.175 //x2=61.91 //y2=0.175
r1239 (  387 553 ) resistor r=2.87058 //w=0.35 //l=0.085 //layer=li \
 //thickness=0.1 //x=63.005 //y=0.175 //x2=63.09 //y2=0.175
r1240 (  387 388 ) resistor r=32.2616 //w=0.367 //l=0.925 //layer=li \
 //thickness=0.1 //x=63.005 //y=0.175 //x2=62.08 //y2=0.175
r1241 (  382 384 ) resistor r=38.7139 //w=0.367 //l=1.11 //layer=li \
 //thickness=0.1 //x=60.43 //y=0.175 //x2=61.54 //y2=0.175
r1242 (  380 382 ) resistor r=38.7139 //w=0.367 //l=1.11 //layer=li \
 //thickness=0.1 //x=59.32 //y=0.175 //x2=60.43 //y2=0.175
r1243 (  378 550 ) resistor r=2.87058 //w=0.35 //l=0.085 //layer=li \
 //thickness=0.1 //x=58.26 //y=0.175 //x2=58.175 //y2=0.175
r1244 (  378 380 ) resistor r=36.97 //w=0.367 //l=1.06 //layer=li \
 //thickness=0.1 //x=58.26 //y=0.175 //x2=59.32 //y2=0.175
r1245 (  377 551 ) resistor r=5.29055 //w=0.35 //l=0.17 //layer=li \
 //thickness=0.1 //x=61.74 //y=0.175 //x2=61.91 //y2=0.175
r1246 (  377 384 ) resistor r=6.97548 //w=0.367 //l=0.2 //layer=li \
 //thickness=0.1 //x=61.74 //y=0.175 //x2=61.54 //y2=0.175
r1247 (  373 550 ) resistor r=4.23183 //w=0.7 //l=0.175 //layer=li \
 //thickness=0.1 //x=58.175 //y=0.35 //x2=58.175 //y2=0.175
r1248 (  373 594 ) resistor r=54.4171 //w=0.187 //l=0.795 //layer=li \
 //thickness=0.1 //x=58.175 //y=0.35 //x2=58.175 //y2=1.145
r1249 (  372 548 ) resistor r=5.29055 //w=0.35 //l=0.17 //layer=li \
 //thickness=0.1 //x=57.27 //y=0.175 //x2=57.1 //y2=0.175
r1250 (  371 550 ) resistor r=2.87058 //w=0.35 //l=0.085 //layer=li \
 //thickness=0.1 //x=58.09 //y=0.175 //x2=58.175 //y2=0.175
r1251 (  371 372 ) resistor r=28.5995 //w=0.367 //l=0.82 //layer=li \
 //thickness=0.1 //x=58.09 //y=0.175 //x2=57.27 //y2=0.175
r1252 (  366 368 ) resistor r=38.7139 //w=0.367 //l=1.11 //layer=li \
 //thickness=0.1 //x=55.62 //y=0.175 //x2=56.73 //y2=0.175
r1253 (  364 366 ) resistor r=38.7139 //w=0.367 //l=1.11 //layer=li \
 //thickness=0.1 //x=54.51 //y=0.175 //x2=55.62 //y2=0.175
r1254 (  362 547 ) resistor r=2.87058 //w=0.35 //l=0.085 //layer=li \
 //thickness=0.1 //x=53.45 //y=0.175 //x2=53.365 //y2=0.175
r1255 (  362 364 ) resistor r=36.97 //w=0.367 //l=1.06 //layer=li \
 //thickness=0.1 //x=53.45 //y=0.175 //x2=54.51 //y2=0.175
r1256 (  361 548 ) resistor r=5.29055 //w=0.35 //l=0.17 //layer=li \
 //thickness=0.1 //x=56.93 //y=0.175 //x2=57.1 //y2=0.175
r1257 (  361 368 ) resistor r=6.97548 //w=0.367 //l=0.2 //layer=li \
 //thickness=0.1 //x=56.93 //y=0.175 //x2=56.73 //y2=0.175
r1258 (  357 547 ) resistor r=4.23183 //w=0.7 //l=0.175 //layer=li \
 //thickness=0.1 //x=53.365 //y=0.35 //x2=53.365 //y2=0.175
r1259 (  357 593 ) resistor r=54.4171 //w=0.187 //l=0.795 //layer=li \
 //thickness=0.1 //x=53.365 //y=0.35 //x2=53.365 //y2=1.145
r1260 (  356 545 ) resistor r=5.29055 //w=0.35 //l=0.17 //layer=li \
 //thickness=0.1 //x=52.46 //y=0.175 //x2=52.29 //y2=0.175
r1261 (  355 547 ) resistor r=2.87058 //w=0.35 //l=0.085 //layer=li \
 //thickness=0.1 //x=53.28 //y=0.175 //x2=53.365 //y2=0.175
r1262 (  355 356 ) resistor r=28.5995 //w=0.367 //l=0.82 //layer=li \
 //thickness=0.1 //x=53.28 //y=0.175 //x2=52.46 //y2=0.175
r1263 (  350 352 ) resistor r=38.7139 //w=0.367 //l=1.11 //layer=li \
 //thickness=0.1 //x=50.81 //y=0.175 //x2=51.92 //y2=0.175
r1264 (  348 544 ) resistor r=2.87058 //w=0.35 //l=0.085 //layer=li \
 //thickness=0.1 //x=50.225 //y=0.175 //x2=50.14 //y2=0.175
r1265 (  348 350 ) resistor r=20.4033 //w=0.367 //l=0.585 //layer=li \
 //thickness=0.1 //x=50.225 //y=0.175 //x2=50.81 //y2=0.175
r1266 (  347 545 ) resistor r=5.29055 //w=0.35 //l=0.17 //layer=li \
 //thickness=0.1 //x=52.12 //y=0.175 //x2=52.29 //y2=0.175
r1267 (  347 352 ) resistor r=6.97548 //w=0.367 //l=0.2 //layer=li \
 //thickness=0.1 //x=52.12 //y=0.175 //x2=51.92 //y2=0.175
r1268 (  343 544 ) resistor r=4.23183 //w=0.7 //l=0.175 //layer=li \
 //thickness=0.1 //x=50.14 //y=0.35 //x2=50.14 //y2=0.175
r1269 (  343 592 ) resistor r=53.7326 //w=0.187 //l=0.785 //layer=li \
 //thickness=0.1 //x=50.14 //y=0.35 //x2=50.14 //y2=1.135
r1270 (  340 543 ) resistor r=5.29055 //w=0.35 //l=0.17 //layer=li \
 //thickness=0.1 //x=49.13 //y=0.175 //x2=48.96 //y2=0.175
r1271 (  340 342 ) resistor r=19.8801 //w=0.367 //l=0.57 //layer=li \
 //thickness=0.1 //x=49.13 //y=0.175 //x2=49.7 //y2=0.175
r1272 (  339 544 ) resistor r=2.87058 //w=0.35 //l=0.085 //layer=li \
 //thickness=0.1 //x=50.055 //y=0.175 //x2=50.14 //y2=0.175
r1273 (  339 342 ) resistor r=12.3815 //w=0.367 //l=0.355 //layer=li \
 //thickness=0.1 //x=50.055 //y=0.175 //x2=49.7 //y2=0.175
r1274 (  334 336 ) resistor r=38.7139 //w=0.367 //l=1.11 //layer=li \
 //thickness=0.1 //x=47.11 //y=0.175 //x2=48.22 //y2=0.175
r1275 (  332 334 ) resistor r=38.7139 //w=0.367 //l=1.11 //layer=li \
 //thickness=0.1 //x=46 //y=0.175 //x2=47.11 //y2=0.175
r1276 (  330 542 ) resistor r=2.87058 //w=0.35 //l=0.085 //layer=li \
 //thickness=0.1 //x=45.31 //y=0.175 //x2=45.225 //y2=0.175
r1277 (  330 332 ) resistor r=24.0654 //w=0.367 //l=0.69 //layer=li \
 //thickness=0.1 //x=45.31 //y=0.175 //x2=46 //y2=0.175
r1278 (  329 543 ) resistor r=5.29055 //w=0.35 //l=0.17 //layer=li \
 //thickness=0.1 //x=48.79 //y=0.175 //x2=48.96 //y2=0.175
r1279 (  329 336 ) resistor r=19.8801 //w=0.367 //l=0.57 //layer=li \
 //thickness=0.1 //x=48.79 //y=0.175 //x2=48.22 //y2=0.175
r1280 (  325 542 ) resistor r=4.23183 //w=0.7 //l=0.175 //layer=li \
 //thickness=0.1 //x=45.225 //y=0.35 //x2=45.225 //y2=0.175
r1281 (  325 591 ) resistor r=54.4171 //w=0.187 //l=0.795 //layer=li \
 //thickness=0.1 //x=45.225 //y=0.35 //x2=45.225 //y2=1.145
r1282 (  322 541 ) resistor r=5.29055 //w=0.35 //l=0.17 //layer=li \
 //thickness=0.1 //x=44.32 //y=0.175 //x2=44.15 //y2=0.175
r1283 (  322 324 ) resistor r=19.8801 //w=0.367 //l=0.57 //layer=li \
 //thickness=0.1 //x=44.32 //y=0.175 //x2=44.89 //y2=0.175
r1284 (  321 542 ) resistor r=2.87058 //w=0.35 //l=0.085 //layer=li \
 //thickness=0.1 //x=45.14 //y=0.175 //x2=45.225 //y2=0.175
r1285 (  321 324 ) resistor r=8.71935 //w=0.367 //l=0.25 //layer=li \
 //thickness=0.1 //x=45.14 //y=0.175 //x2=44.89 //y2=0.175
r1286 (  316 318 ) resistor r=38.7139 //w=0.367 //l=1.11 //layer=li \
 //thickness=0.1 //x=42.3 //y=0.175 //x2=43.41 //y2=0.175
r1287 (  314 316 ) resistor r=38.7139 //w=0.367 //l=1.11 //layer=li \
 //thickness=0.1 //x=41.19 //y=0.175 //x2=42.3 //y2=0.175
r1288 (  312 540 ) resistor r=2.87058 //w=0.35 //l=0.085 //layer=li \
 //thickness=0.1 //x=40.5 //y=0.175 //x2=40.415 //y2=0.175
r1289 (  312 314 ) resistor r=24.0654 //w=0.367 //l=0.69 //layer=li \
 //thickness=0.1 //x=40.5 //y=0.175 //x2=41.19 //y2=0.175
r1290 (  311 541 ) resistor r=5.29055 //w=0.35 //l=0.17 //layer=li \
 //thickness=0.1 //x=43.98 //y=0.175 //x2=44.15 //y2=0.175
r1291 (  311 318 ) resistor r=19.8801 //w=0.367 //l=0.57 //layer=li \
 //thickness=0.1 //x=43.98 //y=0.175 //x2=43.41 //y2=0.175
r1292 (  307 540 ) resistor r=4.23183 //w=0.7 //l=0.175 //layer=li \
 //thickness=0.1 //x=40.415 //y=0.35 //x2=40.415 //y2=0.175
r1293 (  307 590 ) resistor r=54.4171 //w=0.187 //l=0.795 //layer=li \
 //thickness=0.1 //x=40.415 //y=0.35 //x2=40.415 //y2=1.145
r1294 (  304 539 ) resistor r=5.29055 //w=0.35 //l=0.17 //layer=li \
 //thickness=0.1 //x=39.51 //y=0.175 //x2=39.34 //y2=0.175
r1295 (  304 306 ) resistor r=19.8801 //w=0.367 //l=0.57 //layer=li \
 //thickness=0.1 //x=39.51 //y=0.175 //x2=40.08 //y2=0.175
r1296 (  303 540 ) resistor r=2.87058 //w=0.35 //l=0.085 //layer=li \
 //thickness=0.1 //x=40.33 //y=0.175 //x2=40.415 //y2=0.175
r1297 (  303 306 ) resistor r=8.71935 //w=0.367 //l=0.25 //layer=li \
 //thickness=0.1 //x=40.33 //y=0.175 //x2=40.08 //y2=0.175
r1298 (  298 300 ) resistor r=38.7139 //w=0.367 //l=1.11 //layer=li \
 //thickness=0.1 //x=37.49 //y=0.175 //x2=38.6 //y2=0.175
r1299 (  296 538 ) resistor r=2.87058 //w=0.35 //l=0.085 //layer=li \
 //thickness=0.1 //x=37.275 //y=0.175 //x2=37.19 //y2=0.175
r1300 (  296 298 ) resistor r=7.49864 //w=0.367 //l=0.215 //layer=li \
 //thickness=0.1 //x=37.275 //y=0.175 //x2=37.49 //y2=0.175
r1301 (  295 539 ) resistor r=5.29055 //w=0.35 //l=0.17 //layer=li \
 //thickness=0.1 //x=39.17 //y=0.175 //x2=39.34 //y2=0.175
r1302 (  295 300 ) resistor r=19.8801 //w=0.367 //l=0.57 //layer=li \
 //thickness=0.1 //x=39.17 //y=0.175 //x2=38.6 //y2=0.175
r1303 (  291 538 ) resistor r=4.23183 //w=0.7 //l=0.175 //layer=li \
 //thickness=0.1 //x=37.19 //y=0.35 //x2=37.19 //y2=0.175
r1304 (  291 589 ) resistor r=53.7326 //w=0.187 //l=0.785 //layer=li \
 //thickness=0.1 //x=37.19 //y=0.35 //x2=37.19 //y2=1.135
r1305 (  288 537 ) resistor r=5.29055 //w=0.35 //l=0.17 //layer=li \
 //thickness=0.1 //x=36.18 //y=0.175 //x2=36.01 //y2=0.175
r1306 (  288 290 ) resistor r=6.97548 //w=0.367 //l=0.2 //layer=li \
 //thickness=0.1 //x=36.18 //y=0.175 //x2=36.38 //y2=0.175
r1307 (  287 538 ) resistor r=2.87058 //w=0.35 //l=0.085 //layer=li \
 //thickness=0.1 //x=37.105 //y=0.175 //x2=37.19 //y2=0.175
r1308 (  287 290 ) resistor r=25.2861 //w=0.367 //l=0.725 //layer=li \
 //thickness=0.1 //x=37.105 //y=0.175 //x2=36.38 //y2=0.175
r1309 (  282 284 ) resistor r=38.7139 //w=0.367 //l=1.11 //layer=li \
 //thickness=0.1 //x=33.79 //y=0.175 //x2=34.9 //y2=0.175
r1310 (  280 282 ) resistor r=38.7139 //w=0.367 //l=1.11 //layer=li \
 //thickness=0.1 //x=32.68 //y=0.175 //x2=33.79 //y2=0.175
r1311 (  278 536 ) resistor r=2.87058 //w=0.35 //l=0.085 //layer=li \
 //thickness=0.1 //x=32.36 //y=0.175 //x2=32.275 //y2=0.175
r1312 (  278 280 ) resistor r=11.1608 //w=0.367 //l=0.32 //layer=li \
 //thickness=0.1 //x=32.36 //y=0.175 //x2=32.68 //y2=0.175
r1313 (  277 537 ) resistor r=5.29055 //w=0.35 //l=0.17 //layer=li \
 //thickness=0.1 //x=35.84 //y=0.175 //x2=36.01 //y2=0.175
r1314 (  277 284 ) resistor r=32.7847 //w=0.367 //l=0.94 //layer=li \
 //thickness=0.1 //x=35.84 //y=0.175 //x2=34.9 //y2=0.175
r1315 (  273 536 ) resistor r=4.23183 //w=0.7 //l=0.175 //layer=li \
 //thickness=0.1 //x=32.275 //y=0.35 //x2=32.275 //y2=0.175
r1316 (  273 588 ) resistor r=54.4171 //w=0.187 //l=0.795 //layer=li \
 //thickness=0.1 //x=32.275 //y=0.35 //x2=32.275 //y2=1.145
r1317 (  270 535 ) resistor r=5.29055 //w=0.35 //l=0.17 //layer=li \
 //thickness=0.1 //x=31.37 //y=0.175 //x2=31.2 //y2=0.175
r1318 (  270 272 ) resistor r=6.97548 //w=0.367 //l=0.2 //layer=li \
 //thickness=0.1 //x=31.37 //y=0.175 //x2=31.57 //y2=0.175
r1319 (  269 536 ) resistor r=2.87058 //w=0.35 //l=0.085 //layer=li \
 //thickness=0.1 //x=32.19 //y=0.175 //x2=32.275 //y2=0.175
r1320 (  269 272 ) resistor r=21.624 //w=0.367 //l=0.62 //layer=li \
 //thickness=0.1 //x=32.19 //y=0.175 //x2=31.57 //y2=0.175
r1321 (  264 266 ) resistor r=38.7139 //w=0.367 //l=1.11 //layer=li \
 //thickness=0.1 //x=28.98 //y=0.175 //x2=30.09 //y2=0.175
r1322 (  262 264 ) resistor r=38.7139 //w=0.367 //l=1.11 //layer=li \
 //thickness=0.1 //x=27.87 //y=0.175 //x2=28.98 //y2=0.175
r1323 (  260 534 ) resistor r=2.87058 //w=0.35 //l=0.085 //layer=li \
 //thickness=0.1 //x=27.55 //y=0.175 //x2=27.465 //y2=0.175
r1324 (  260 262 ) resistor r=11.1608 //w=0.367 //l=0.32 //layer=li \
 //thickness=0.1 //x=27.55 //y=0.175 //x2=27.87 //y2=0.175
r1325 (  259 535 ) resistor r=5.29055 //w=0.35 //l=0.17 //layer=li \
 //thickness=0.1 //x=31.03 //y=0.175 //x2=31.2 //y2=0.175
r1326 (  259 266 ) resistor r=32.7847 //w=0.367 //l=0.94 //layer=li \
 //thickness=0.1 //x=31.03 //y=0.175 //x2=30.09 //y2=0.175
r1327 (  255 534 ) resistor r=4.23183 //w=0.7 //l=0.175 //layer=li \
 //thickness=0.1 //x=27.465 //y=0.35 //x2=27.465 //y2=0.175
r1328 (  255 587 ) resistor r=54.4171 //w=0.187 //l=0.795 //layer=li \
 //thickness=0.1 //x=27.465 //y=0.35 //x2=27.465 //y2=1.145
r1329 (  252 533 ) resistor r=5.29055 //w=0.35 //l=0.17 //layer=li \
 //thickness=0.1 //x=26.56 //y=0.175 //x2=26.39 //y2=0.175
r1330 (  252 254 ) resistor r=6.97548 //w=0.367 //l=0.2 //layer=li \
 //thickness=0.1 //x=26.56 //y=0.175 //x2=26.76 //y2=0.175
r1331 (  251 534 ) resistor r=2.87058 //w=0.35 //l=0.085 //layer=li \
 //thickness=0.1 //x=27.38 //y=0.175 //x2=27.465 //y2=0.175
r1332 (  251 254 ) resistor r=21.624 //w=0.367 //l=0.62 //layer=li \
 //thickness=0.1 //x=27.38 //y=0.175 //x2=26.76 //y2=0.175
r1333 (  246 532 ) resistor r=2.87058 //w=0.35 //l=0.085 //layer=li \
 //thickness=0.1 //x=24.325 //y=0.175 //x2=24.24 //y2=0.175
r1334 (  246 248 ) resistor r=33.3079 //w=0.367 //l=0.955 //layer=li \
 //thickness=0.1 //x=24.325 //y=0.175 //x2=25.28 //y2=0.175
r1335 (  245 533 ) resistor r=5.29055 //w=0.35 //l=0.17 //layer=li \
 //thickness=0.1 //x=26.22 //y=0.175 //x2=26.39 //y2=0.175
r1336 (  245 248 ) resistor r=32.7847 //w=0.367 //l=0.94 //layer=li \
 //thickness=0.1 //x=26.22 //y=0.175 //x2=25.28 //y2=0.175
r1337 (  241 532 ) resistor r=4.23183 //w=0.7 //l=0.175 //layer=li \
 //thickness=0.1 //x=24.24 //y=0.35 //x2=24.24 //y2=0.175
r1338 (  241 586 ) resistor r=53.7326 //w=0.187 //l=0.785 //layer=li \
 //thickness=0.1 //x=24.24 //y=0.35 //x2=24.24 //y2=1.135
r1339 (  240 530 ) resistor r=5.29055 //w=0.35 //l=0.17 //layer=li \
 //thickness=0.1 //x=23.23 //y=0.175 //x2=23.06 //y2=0.175
r1340 (  239 532 ) resistor r=2.87058 //w=0.35 //l=0.085 //layer=li \
 //thickness=0.1 //x=24.155 //y=0.175 //x2=24.24 //y2=0.175
r1341 (  239 240 ) resistor r=32.2616 //w=0.367 //l=0.925 //layer=li \
 //thickness=0.1 //x=24.155 //y=0.175 //x2=23.23 //y2=0.175
r1342 (  234 236 ) resistor r=38.7139 //w=0.367 //l=1.11 //layer=li \
 //thickness=0.1 //x=21.58 //y=0.175 //x2=22.69 //y2=0.175
r1343 (  232 234 ) resistor r=38.7139 //w=0.367 //l=1.11 //layer=li \
 //thickness=0.1 //x=20.47 //y=0.175 //x2=21.58 //y2=0.175
r1344 (  230 529 ) resistor r=2.87058 //w=0.35 //l=0.085 //layer=li \
 //thickness=0.1 //x=19.41 //y=0.175 //x2=19.325 //y2=0.175
r1345 (  230 232 ) resistor r=36.97 //w=0.367 //l=1.06 //layer=li \
 //thickness=0.1 //x=19.41 //y=0.175 //x2=20.47 //y2=0.175
r1346 (  229 530 ) resistor r=5.29055 //w=0.35 //l=0.17 //layer=li \
 //thickness=0.1 //x=22.89 //y=0.175 //x2=23.06 //y2=0.175
r1347 (  229 236 ) resistor r=6.97548 //w=0.367 //l=0.2 //layer=li \
 //thickness=0.1 //x=22.89 //y=0.175 //x2=22.69 //y2=0.175
r1348 (  225 529 ) resistor r=4.23183 //w=0.7 //l=0.175 //layer=li \
 //thickness=0.1 //x=19.325 //y=0.35 //x2=19.325 //y2=0.175
r1349 (  225 585 ) resistor r=54.4171 //w=0.187 //l=0.795 //layer=li \
 //thickness=0.1 //x=19.325 //y=0.35 //x2=19.325 //y2=1.145
r1350 (  224 527 ) resistor r=5.29055 //w=0.35 //l=0.17 //layer=li \
 //thickness=0.1 //x=18.42 //y=0.175 //x2=18.25 //y2=0.175
r1351 (  223 529 ) resistor r=2.87058 //w=0.35 //l=0.085 //layer=li \
 //thickness=0.1 //x=19.24 //y=0.175 //x2=19.325 //y2=0.175
r1352 (  223 224 ) resistor r=28.5995 //w=0.367 //l=0.82 //layer=li \
 //thickness=0.1 //x=19.24 //y=0.175 //x2=18.42 //y2=0.175
r1353 (  218 220 ) resistor r=38.7139 //w=0.367 //l=1.11 //layer=li \
 //thickness=0.1 //x=16.77 //y=0.175 //x2=17.88 //y2=0.175
r1354 (  216 218 ) resistor r=38.7139 //w=0.367 //l=1.11 //layer=li \
 //thickness=0.1 //x=15.66 //y=0.175 //x2=16.77 //y2=0.175
r1355 (  214 526 ) resistor r=2.87058 //w=0.35 //l=0.085 //layer=li \
 //thickness=0.1 //x=14.6 //y=0.175 //x2=14.515 //y2=0.175
r1356 (  214 216 ) resistor r=36.97 //w=0.367 //l=1.06 //layer=li \
 //thickness=0.1 //x=14.6 //y=0.175 //x2=15.66 //y2=0.175
r1357 (  213 527 ) resistor r=5.29055 //w=0.35 //l=0.17 //layer=li \
 //thickness=0.1 //x=18.08 //y=0.175 //x2=18.25 //y2=0.175
r1358 (  213 220 ) resistor r=6.97548 //w=0.367 //l=0.2 //layer=li \
 //thickness=0.1 //x=18.08 //y=0.175 //x2=17.88 //y2=0.175
r1359 (  209 526 ) resistor r=4.23183 //w=0.7 //l=0.175 //layer=li \
 //thickness=0.1 //x=14.515 //y=0.35 //x2=14.515 //y2=0.175
r1360 (  209 584 ) resistor r=54.4171 //w=0.187 //l=0.795 //layer=li \
 //thickness=0.1 //x=14.515 //y=0.35 //x2=14.515 //y2=1.145
r1361 (  208 524 ) resistor r=5.29055 //w=0.35 //l=0.17 //layer=li \
 //thickness=0.1 //x=13.61 //y=0.175 //x2=13.44 //y2=0.175
r1362 (  207 526 ) resistor r=2.87058 //w=0.35 //l=0.085 //layer=li \
 //thickness=0.1 //x=14.43 //y=0.175 //x2=14.515 //y2=0.175
r1363 (  207 208 ) resistor r=28.5995 //w=0.367 //l=0.82 //layer=li \
 //thickness=0.1 //x=14.43 //y=0.175 //x2=13.61 //y2=0.175
r1364 (  202 204 ) resistor r=38.7139 //w=0.367 //l=1.11 //layer=li \
 //thickness=0.1 //x=11.96 //y=0.175 //x2=13.07 //y2=0.175
r1365 (  200 523 ) resistor r=2.87058 //w=0.35 //l=0.085 //layer=li \
 //thickness=0.1 //x=11.375 //y=0.175 //x2=11.29 //y2=0.175
r1366 (  200 202 ) resistor r=20.4033 //w=0.367 //l=0.585 //layer=li \
 //thickness=0.1 //x=11.375 //y=0.175 //x2=11.96 //y2=0.175
r1367 (  199 524 ) resistor r=5.29055 //w=0.35 //l=0.17 //layer=li \
 //thickness=0.1 //x=13.27 //y=0.175 //x2=13.44 //y2=0.175
r1368 (  199 204 ) resistor r=6.97548 //w=0.367 //l=0.2 //layer=li \
 //thickness=0.1 //x=13.27 //y=0.175 //x2=13.07 //y2=0.175
r1369 (  195 523 ) resistor r=4.23183 //w=0.7 //l=0.175 //layer=li \
 //thickness=0.1 //x=11.29 //y=0.35 //x2=11.29 //y2=0.175
r1370 (  195 583 ) resistor r=53.7326 //w=0.187 //l=0.785 //layer=li \
 //thickness=0.1 //x=11.29 //y=0.35 //x2=11.29 //y2=1.135
r1371 (  192 522 ) resistor r=5.29055 //w=0.35 //l=0.17 //layer=li \
 //thickness=0.1 //x=10.28 //y=0.175 //x2=10.11 //y2=0.175
r1372 (  192 194 ) resistor r=19.8801 //w=0.367 //l=0.57 //layer=li \
 //thickness=0.1 //x=10.28 //y=0.175 //x2=10.85 //y2=0.175
r1373 (  191 523 ) resistor r=2.87058 //w=0.35 //l=0.085 //layer=li \
 //thickness=0.1 //x=11.205 //y=0.175 //x2=11.29 //y2=0.175
r1374 (  191 194 ) resistor r=12.3815 //w=0.367 //l=0.355 //layer=li \
 //thickness=0.1 //x=11.205 //y=0.175 //x2=10.85 //y2=0.175
r1375 (  186 188 ) resistor r=38.7139 //w=0.367 //l=1.11 //layer=li \
 //thickness=0.1 //x=8.26 //y=0.175 //x2=9.37 //y2=0.175
r1376 (  184 186 ) resistor r=38.7139 //w=0.367 //l=1.11 //layer=li \
 //thickness=0.1 //x=7.15 //y=0.175 //x2=8.26 //y2=0.175
r1377 (  182 521 ) resistor r=2.87058 //w=0.35 //l=0.085 //layer=li \
 //thickness=0.1 //x=6.46 //y=0.175 //x2=6.375 //y2=0.175
r1378 (  182 184 ) resistor r=24.0654 //w=0.367 //l=0.69 //layer=li \
 //thickness=0.1 //x=6.46 //y=0.175 //x2=7.15 //y2=0.175
r1379 (  181 522 ) resistor r=5.29055 //w=0.35 //l=0.17 //layer=li \
 //thickness=0.1 //x=9.94 //y=0.175 //x2=10.11 //y2=0.175
r1380 (  181 188 ) resistor r=19.8801 //w=0.367 //l=0.57 //layer=li \
 //thickness=0.1 //x=9.94 //y=0.175 //x2=9.37 //y2=0.175
r1381 (  177 521 ) resistor r=4.23183 //w=0.7 //l=0.175 //layer=li \
 //thickness=0.1 //x=6.375 //y=0.35 //x2=6.375 //y2=0.175
r1382 (  177 582 ) resistor r=54.4171 //w=0.187 //l=0.795 //layer=li \
 //thickness=0.1 //x=6.375 //y=0.35 //x2=6.375 //y2=1.145
r1383 (  174 520 ) resistor r=5.29055 //w=0.35 //l=0.17 //layer=li \
 //thickness=0.1 //x=5.47 //y=0.175 //x2=5.3 //y2=0.175
r1384 (  174 176 ) resistor r=19.8801 //w=0.367 //l=0.57 //layer=li \
 //thickness=0.1 //x=5.47 //y=0.175 //x2=6.04 //y2=0.175
r1385 (  173 521 ) resistor r=2.87058 //w=0.35 //l=0.085 //layer=li \
 //thickness=0.1 //x=6.29 //y=0.175 //x2=6.375 //y2=0.175
r1386 (  173 176 ) resistor r=8.71935 //w=0.367 //l=0.25 //layer=li \
 //thickness=0.1 //x=6.29 //y=0.175 //x2=6.04 //y2=0.175
r1387 (  168 170 ) resistor r=38.7139 //w=0.367 //l=1.11 //layer=li \
 //thickness=0.1 //x=3.45 //y=0.175 //x2=4.56 //y2=0.175
r1388 (  166 168 ) resistor r=38.7139 //w=0.367 //l=1.11 //layer=li \
 //thickness=0.1 //x=2.34 //y=0.175 //x2=3.45 //y2=0.175
r1389 (  164 519 ) resistor r=2.87058 //w=0.35 //l=0.085 //layer=li \
 //thickness=0.1 //x=1.65 //y=0.175 //x2=1.565 //y2=0.175
r1390 (  164 166 ) resistor r=24.0654 //w=0.367 //l=0.69 //layer=li \
 //thickness=0.1 //x=1.65 //y=0.175 //x2=2.34 //y2=0.175
r1391 (  163 520 ) resistor r=5.29055 //w=0.35 //l=0.17 //layer=li \
 //thickness=0.1 //x=5.13 //y=0.175 //x2=5.3 //y2=0.175
r1392 (  163 170 ) resistor r=19.8801 //w=0.367 //l=0.57 //layer=li \
 //thickness=0.1 //x=5.13 //y=0.175 //x2=4.56 //y2=0.175
r1393 (  159 519 ) resistor r=4.23183 //w=0.7 //l=0.175 //layer=li \
 //thickness=0.1 //x=1.565 //y=0.35 //x2=1.565 //y2=0.175
r1394 (  159 581 ) resistor r=54.4171 //w=0.187 //l=0.795 //layer=li \
 //thickness=0.1 //x=1.565 //y=0.35 //x2=1.565 //y2=1.145
r1395 (  155 519 ) resistor r=2.87058 //w=0.35 //l=0.085 //layer=li \
 //thickness=0.1 //x=1.48 //y=0.175 //x2=1.565 //y2=0.175
r1396 (  155 158 ) resistor r=8.71935 //w=0.367 //l=0.25 //layer=li \
 //thickness=0.1 //x=1.48 //y=0.175 //x2=1.23 //y2=0.175
r1397 (  151 573 ) resistor r=4.65 //w=0.17 //l=0.34 //layer=mcon //count=2 \
 //x=89.66 //y=0.18 //x2=89.66 //y2=0.18
r1398 (  149 570 ) resistor r=3.1 //w=0.17 //l=0.51 //layer=mcon //count=3 \
 //x=88.92 //y=0.18 //x2=88.92 //y2=0.18
r1399 (  149 151 ) resistor r=0.297428 //w=0.311 //l=0.74 //layer=m1 \
 //thickness=0.36 //x=88.92 //y=0.175 //x2=89.66 //y2=0.175
r1400 (  147 492 ) resistor r=3.1 //w=0.17 //l=0.51 //layer=mcon //count=3 \
 //x=87.44 //y=0.18 //x2=87.44 //y2=0.18
r1401 (  147 149 ) resistor r=0.594855 //w=0.311 //l=1.48 //layer=m1 \
 //thickness=0.36 //x=87.44 //y=0.175 //x2=88.92 //y2=0.175
r1402 (  145 490 ) resistor r=3.1 //w=0.17 //l=0.51 //layer=mcon //count=3 \
 //x=86.33 //y=0.18 //x2=86.33 //y2=0.18
r1403 (  145 147 ) resistor r=0.446141 //w=0.311 //l=1.11 //layer=m1 \
 //thickness=0.36 //x=86.33 //y=0.175 //x2=87.44 //y2=0.175
r1404 (  143 482 ) resistor r=3.1 //w=0.17 //l=0.51 //layer=mcon //count=3 \
 //x=85.22 //y=0.18 //x2=85.22 //y2=0.18
r1405 (  143 145 ) resistor r=0.446141 //w=0.311 //l=1.11 //layer=m1 \
 //thickness=0.36 //x=85.22 //y=0.175 //x2=86.33 //y2=0.175
r1406 (  141 476 ) resistor r=3.1 //w=0.17 //l=0.51 //layer=mcon //count=3 \
 //x=83.74 //y=0.18 //x2=83.74 //y2=0.18
r1407 (  141 143 ) resistor r=0.594855 //w=0.311 //l=1.48 //layer=m1 \
 //thickness=0.36 //x=83.74 //y=0.175 //x2=85.22 //y2=0.175
r1408 (  139 564 ) resistor r=3.1 //w=0.17 //l=0.51 //layer=mcon //count=3 \
 //x=82.63 //y=0.18 //x2=82.63 //y2=0.18
r1409 (  139 141 ) resistor r=0.446141 //w=0.311 //l=1.11 //layer=m1 \
 //thickness=0.36 //x=82.63 //y=0.175 //x2=83.74 //y2=0.175
r1410 (  137 464 ) resistor r=3.1 //w=0.17 //l=0.51 //layer=mcon //count=3 \
 //x=81.15 //y=0.18 //x2=81.15 //y2=0.18
r1411 (  137 139 ) resistor r=0.594855 //w=0.311 //l=1.48 //layer=m1 \
 //thickness=0.36 //x=81.15 //y=0.175 //x2=82.63 //y2=0.175
r1412 (  135 462 ) resistor r=3.1 //w=0.17 //l=0.51 //layer=mcon //count=3 \
 //x=80.04 //y=0.18 //x2=80.04 //y2=0.18
r1413 (  135 137 ) resistor r=0.446141 //w=0.311 //l=1.11 //layer=m1 \
 //thickness=0.36 //x=80.04 //y=0.175 //x2=81.15 //y2=0.175
r1414 (  133 454 ) resistor r=3.1 //w=0.17 //l=0.51 //layer=mcon //count=3 \
 //x=78.93 //y=0.18 //x2=78.93 //y2=0.18
r1415 (  133 135 ) resistor r=0.446141 //w=0.311 //l=1.11 //layer=m1 \
 //thickness=0.36 //x=78.93 //y=0.175 //x2=80.04 //y2=0.175
r1416 (  131 448 ) resistor r=3.1 //w=0.17 //l=0.51 //layer=mcon //count=3 \
 //x=77.45 //y=0.18 //x2=77.45 //y2=0.18
r1417 (  131 133 ) resistor r=0.594855 //w=0.311 //l=1.48 //layer=m1 \
 //thickness=0.36 //x=77.45 //y=0.175 //x2=78.93 //y2=0.175
r1418 (  129 446 ) resistor r=3.1 //w=0.17 //l=0.51 //layer=mcon //count=3 \
 //x=76.34 //y=0.18 //x2=76.34 //y2=0.18
r1419 (  129 131 ) resistor r=0.446141 //w=0.311 //l=1.11 //layer=m1 \
 //thickness=0.36 //x=76.34 //y=0.175 //x2=77.45 //y2=0.175
r1420 (  127 438 ) resistor r=3.1 //w=0.17 //l=0.51 //layer=mcon //count=3 \
 //x=75.23 //y=0.18 //x2=75.23 //y2=0.18
r1421 (  127 129 ) resistor r=0.446141 //w=0.311 //l=1.11 //layer=m1 \
 //thickness=0.36 //x=75.23 //y=0.175 //x2=76.34 //y2=0.175
r1422 (  125 432 ) resistor r=3.1 //w=0.17 //l=0.51 //layer=mcon //count=3 \
 //x=73.75 //y=0.18 //x2=73.75 //y2=0.18
r1423 (  125 127 ) resistor r=0.594855 //w=0.311 //l=1.48 //layer=m1 \
 //thickness=0.36 //x=73.75 //y=0.175 //x2=75.23 //y2=0.175
r1424 (  123 430 ) resistor r=3.1 //w=0.17 //l=0.51 //layer=mcon //count=3 \
 //x=72.64 //y=0.18 //x2=72.64 //y2=0.18
r1425 (  123 125 ) resistor r=0.446141 //w=0.311 //l=1.11 //layer=m1 \
 //thickness=0.36 //x=72.64 //y=0.175 //x2=73.75 //y2=0.175
r1426 (  121 428 ) resistor r=3.1 //w=0.17 //l=0.51 //layer=mcon //count=3 \
 //x=71.53 //y=0.18 //x2=71.53 //y2=0.18
r1427 (  121 123 ) resistor r=0.446141 //w=0.311 //l=1.11 //layer=m1 \
 //thickness=0.36 //x=71.53 //y=0.175 //x2=72.64 //y2=0.175
r1428 (  119 420 ) resistor r=3.1 //w=0.17 //l=0.51 //layer=mcon //count=3 \
 //x=70.42 //y=0.18 //x2=70.42 //y2=0.18
r1429 (  119 121 ) resistor r=0.446141 //w=0.311 //l=1.11 //layer=m1 \
 //thickness=0.36 //x=70.42 //y=0.175 //x2=71.53 //y2=0.175
r1430 (  117 414 ) resistor r=3.1 //w=0.17 //l=0.51 //layer=mcon //count=3 \
 //x=68.94 //y=0.18 //x2=68.94 //y2=0.18
r1431 (  117 119 ) resistor r=0.594855 //w=0.311 //l=1.48 //layer=m1 \
 //thickness=0.36 //x=68.94 //y=0.175 //x2=70.42 //y2=0.175
r1432 (  115 412 ) resistor r=3.1 //w=0.17 //l=0.51 //layer=mcon //count=3 \
 //x=67.83 //y=0.18 //x2=67.83 //y2=0.18
r1433 (  115 117 ) resistor r=0.446141 //w=0.311 //l=1.11 //layer=m1 \
 //thickness=0.36 //x=67.83 //y=0.175 //x2=68.94 //y2=0.175
r1434 (  113 410 ) resistor r=3.1 //w=0.17 //l=0.51 //layer=mcon //count=3 \
 //x=66.72 //y=0.18 //x2=66.72 //y2=0.18
r1435 (  113 115 ) resistor r=0.446141 //w=0.311 //l=1.11 //layer=m1 \
 //thickness=0.36 //x=66.72 //y=0.175 //x2=67.83 //y2=0.175
r1436 (  111 402 ) resistor r=3.1 //w=0.17 //l=0.51 //layer=mcon //count=3 \
 //x=65.61 //y=0.18 //x2=65.61 //y2=0.18
r1437 (  111 113 ) resistor r=0.446141 //w=0.311 //l=1.11 //layer=m1 \
 //thickness=0.36 //x=65.61 //y=0.175 //x2=66.72 //y2=0.175
r1438 (  109 396 ) resistor r=3.1 //w=0.17 //l=0.51 //layer=mcon //count=3 \
 //x=64.13 //y=0.18 //x2=64.13 //y2=0.18
r1439 (  109 111 ) resistor r=0.594855 //w=0.311 //l=1.48 //layer=m1 \
 //thickness=0.36 //x=64.13 //y=0.175 //x2=65.61 //y2=0.175
r1440 (  107 553 ) resistor r=3.1 //w=0.17 //l=0.51 //layer=mcon //count=3 \
 //x=63.02 //y=0.18 //x2=63.02 //y2=0.18
r1441 (  107 109 ) resistor r=0.446141 //w=0.311 //l=1.11 //layer=m1 \
 //thickness=0.36 //x=63.02 //y=0.175 //x2=64.13 //y2=0.175
r1442 (  105 384 ) resistor r=3.1 //w=0.17 //l=0.51 //layer=mcon //count=3 \
 //x=61.54 //y=0.18 //x2=61.54 //y2=0.18
r1443 (  105 107 ) resistor r=0.594855 //w=0.311 //l=1.48 //layer=m1 \
 //thickness=0.36 //x=61.54 //y=0.175 //x2=63.02 //y2=0.175
r1444 (  103 382 ) resistor r=3.1 //w=0.17 //l=0.51 //layer=mcon //count=3 \
 //x=60.43 //y=0.18 //x2=60.43 //y2=0.18
r1445 (  103 105 ) resistor r=0.446141 //w=0.311 //l=1.11 //layer=m1 \
 //thickness=0.36 //x=60.43 //y=0.175 //x2=61.54 //y2=0.175
r1446 (  101 380 ) resistor r=3.1 //w=0.17 //l=0.51 //layer=mcon //count=3 \
 //x=59.32 //y=0.18 //x2=59.32 //y2=0.18
r1447 (  101 103 ) resistor r=0.446141 //w=0.311 //l=1.11 //layer=m1 \
 //thickness=0.36 //x=59.32 //y=0.175 //x2=60.43 //y2=0.175
r1448 (  99 550 ) resistor r=3.1 //w=0.17 //l=0.51 //layer=mcon //count=3 \
 //x=58.21 //y=0.18 //x2=58.21 //y2=0.18
r1449 (  99 101 ) resistor r=0.446141 //w=0.311 //l=1.11 //layer=m1 \
 //thickness=0.36 //x=58.21 //y=0.175 //x2=59.32 //y2=0.175
r1450 (  97 368 ) resistor r=3.1 //w=0.17 //l=0.51 //layer=mcon //count=3 \
 //x=56.73 //y=0.18 //x2=56.73 //y2=0.18
r1451 (  97 99 ) resistor r=0.594855 //w=0.311 //l=1.48 //layer=m1 \
 //thickness=0.36 //x=56.73 //y=0.175 //x2=58.21 //y2=0.175
r1452 (  95 366 ) resistor r=3.1 //w=0.17 //l=0.51 //layer=mcon //count=3 \
 //x=55.62 //y=0.18 //x2=55.62 //y2=0.18
r1453 (  95 97 ) resistor r=0.446141 //w=0.311 //l=1.11 //layer=m1 \
 //thickness=0.36 //x=55.62 //y=0.175 //x2=56.73 //y2=0.175
r1454 (  93 364 ) resistor r=3.1 //w=0.17 //l=0.51 //layer=mcon //count=3 \
 //x=54.51 //y=0.18 //x2=54.51 //y2=0.18
r1455 (  93 95 ) resistor r=0.446141 //w=0.311 //l=1.11 //layer=m1 \
 //thickness=0.36 //x=54.51 //y=0.175 //x2=55.62 //y2=0.175
r1456 (  91 547 ) resistor r=3.1 //w=0.17 //l=0.51 //layer=mcon //count=3 \
 //x=53.4 //y=0.18 //x2=53.4 //y2=0.18
r1457 (  91 93 ) resistor r=0.446141 //w=0.311 //l=1.11 //layer=m1 \
 //thickness=0.36 //x=53.4 //y=0.175 //x2=54.51 //y2=0.175
r1458 (  89 352 ) resistor r=3.1 //w=0.17 //l=0.51 //layer=mcon //count=3 \
 //x=51.92 //y=0.18 //x2=51.92 //y2=0.18
r1459 (  89 91 ) resistor r=0.594855 //w=0.311 //l=1.48 //layer=m1 \
 //thickness=0.36 //x=51.92 //y=0.175 //x2=53.4 //y2=0.175
r1460 (  87 350 ) resistor r=3.1 //w=0.17 //l=0.51 //layer=mcon //count=3 \
 //x=50.81 //y=0.18 //x2=50.81 //y2=0.18
r1461 (  87 89 ) resistor r=0.446141 //w=0.311 //l=1.11 //layer=m1 \
 //thickness=0.36 //x=50.81 //y=0.175 //x2=51.92 //y2=0.175
r1462 (  85 342 ) resistor r=3.1 //w=0.17 //l=0.51 //layer=mcon //count=3 \
 //x=49.7 //y=0.18 //x2=49.7 //y2=0.18
r1463 (  85 87 ) resistor r=0.446141 //w=0.311 //l=1.11 //layer=m1 \
 //thickness=0.36 //x=49.7 //y=0.175 //x2=50.81 //y2=0.175
r1464 (  83 336 ) resistor r=3.1 //w=0.17 //l=0.51 //layer=mcon //count=3 \
 //x=48.22 //y=0.18 //x2=48.22 //y2=0.18
r1465 (  83 85 ) resistor r=0.594855 //w=0.311 //l=1.48 //layer=m1 \
 //thickness=0.36 //x=48.22 //y=0.175 //x2=49.7 //y2=0.175
r1466 (  81 334 ) resistor r=3.1 //w=0.17 //l=0.51 //layer=mcon //count=3 \
 //x=47.11 //y=0.18 //x2=47.11 //y2=0.18
r1467 (  81 83 ) resistor r=0.446141 //w=0.311 //l=1.11 //layer=m1 \
 //thickness=0.36 //x=47.11 //y=0.175 //x2=48.22 //y2=0.175
r1468 (  79 332 ) resistor r=3.1 //w=0.17 //l=0.51 //layer=mcon //count=3 \
 //x=46 //y=0.18 //x2=46 //y2=0.18
r1469 (  79 81 ) resistor r=0.446141 //w=0.311 //l=1.11 //layer=m1 \
 //thickness=0.36 //x=46 //y=0.175 //x2=47.11 //y2=0.175
r1470 (  76 324 ) resistor r=3.1 //w=0.17 //l=0.51 //layer=mcon //count=3 \
 //x=44.89 //y=0.18 //x2=44.89 //y2=0.18
r1471 (  74 318 ) resistor r=3.1 //w=0.17 //l=0.51 //layer=mcon //count=3 \
 //x=43.41 //y=0.18 //x2=43.41 //y2=0.18
r1472 (  74 76 ) resistor r=0.594855 //w=0.311 //l=1.48 //layer=m1 \
 //thickness=0.36 //x=43.41 //y=0.175 //x2=44.89 //y2=0.175
r1473 (  72 316 ) resistor r=3.1 //w=0.17 //l=0.51 //layer=mcon //count=3 \
 //x=42.3 //y=0.18 //x2=42.3 //y2=0.18
r1474 (  72 74 ) resistor r=0.446141 //w=0.311 //l=1.11 //layer=m1 \
 //thickness=0.36 //x=42.3 //y=0.175 //x2=43.41 //y2=0.175
r1475 (  70 314 ) resistor r=3.1 //w=0.17 //l=0.51 //layer=mcon //count=3 \
 //x=41.19 //y=0.18 //x2=41.19 //y2=0.18
r1476 (  70 72 ) resistor r=0.446141 //w=0.311 //l=1.11 //layer=m1 \
 //thickness=0.36 //x=41.19 //y=0.175 //x2=42.3 //y2=0.175
r1477 (  68 306 ) resistor r=3.1 //w=0.17 //l=0.51 //layer=mcon //count=3 \
 //x=40.08 //y=0.18 //x2=40.08 //y2=0.18
r1478 (  68 70 ) resistor r=0.446141 //w=0.311 //l=1.11 //layer=m1 \
 //thickness=0.36 //x=40.08 //y=0.175 //x2=41.19 //y2=0.175
r1479 (  66 300 ) resistor r=3.1 //w=0.17 //l=0.51 //layer=mcon //count=3 \
 //x=38.6 //y=0.18 //x2=38.6 //y2=0.18
r1480 (  66 68 ) resistor r=0.594855 //w=0.311 //l=1.48 //layer=m1 \
 //thickness=0.36 //x=38.6 //y=0.175 //x2=40.08 //y2=0.175
r1481 (  64 298 ) resistor r=3.1 //w=0.17 //l=0.51 //layer=mcon //count=3 \
 //x=37.49 //y=0.18 //x2=37.49 //y2=0.18
r1482 (  64 66 ) resistor r=0.446141 //w=0.311 //l=1.11 //layer=m1 \
 //thickness=0.36 //x=37.49 //y=0.175 //x2=38.6 //y2=0.175
r1483 (  62 290 ) resistor r=3.1 //w=0.17 //l=0.51 //layer=mcon //count=3 \
 //x=36.38 //y=0.18 //x2=36.38 //y2=0.18
r1484 (  62 64 ) resistor r=0.446141 //w=0.311 //l=1.11 //layer=m1 \
 //thickness=0.36 //x=36.38 //y=0.175 //x2=37.49 //y2=0.175
r1485 (  60 284 ) resistor r=3.1 //w=0.17 //l=0.51 //layer=mcon //count=3 \
 //x=34.9 //y=0.18 //x2=34.9 //y2=0.18
r1486 (  60 62 ) resistor r=0.594855 //w=0.311 //l=1.48 //layer=m1 \
 //thickness=0.36 //x=34.9 //y=0.175 //x2=36.38 //y2=0.175
r1487 (  58 282 ) resistor r=3.1 //w=0.17 //l=0.51 //layer=mcon //count=3 \
 //x=33.79 //y=0.18 //x2=33.79 //y2=0.18
r1488 (  58 60 ) resistor r=0.446141 //w=0.311 //l=1.11 //layer=m1 \
 //thickness=0.36 //x=33.79 //y=0.175 //x2=34.9 //y2=0.175
r1489 (  56 280 ) resistor r=3.1 //w=0.17 //l=0.51 //layer=mcon //count=3 \
 //x=32.68 //y=0.18 //x2=32.68 //y2=0.18
r1490 (  56 58 ) resistor r=0.446141 //w=0.311 //l=1.11 //layer=m1 \
 //thickness=0.36 //x=32.68 //y=0.175 //x2=33.79 //y2=0.175
r1491 (  54 272 ) resistor r=3.1 //w=0.17 //l=0.51 //layer=mcon //count=3 \
 //x=31.57 //y=0.18 //x2=31.57 //y2=0.18
r1492 (  54 56 ) resistor r=0.446141 //w=0.311 //l=1.11 //layer=m1 \
 //thickness=0.36 //x=31.57 //y=0.175 //x2=32.68 //y2=0.175
r1493 (  52 266 ) resistor r=3.1 //w=0.17 //l=0.51 //layer=mcon //count=3 \
 //x=30.09 //y=0.18 //x2=30.09 //y2=0.18
r1494 (  52 54 ) resistor r=0.594855 //w=0.311 //l=1.48 //layer=m1 \
 //thickness=0.36 //x=30.09 //y=0.175 //x2=31.57 //y2=0.175
r1495 (  50 264 ) resistor r=3.1 //w=0.17 //l=0.51 //layer=mcon //count=3 \
 //x=28.98 //y=0.18 //x2=28.98 //y2=0.18
r1496 (  50 52 ) resistor r=0.446141 //w=0.311 //l=1.11 //layer=m1 \
 //thickness=0.36 //x=28.98 //y=0.175 //x2=30.09 //y2=0.175
r1497 (  48 262 ) resistor r=3.1 //w=0.17 //l=0.51 //layer=mcon //count=3 \
 //x=27.87 //y=0.18 //x2=27.87 //y2=0.18
r1498 (  48 50 ) resistor r=0.446141 //w=0.311 //l=1.11 //layer=m1 \
 //thickness=0.36 //x=27.87 //y=0.175 //x2=28.98 //y2=0.175
r1499 (  46 254 ) resistor r=3.1 //w=0.17 //l=0.51 //layer=mcon //count=3 \
 //x=26.76 //y=0.18 //x2=26.76 //y2=0.18
r1500 (  46 48 ) resistor r=0.446141 //w=0.311 //l=1.11 //layer=m1 \
 //thickness=0.36 //x=26.76 //y=0.175 //x2=27.87 //y2=0.175
r1501 (  44 248 ) resistor r=3.1 //w=0.17 //l=0.51 //layer=mcon //count=3 \
 //x=25.28 //y=0.18 //x2=25.28 //y2=0.18
r1502 (  44 46 ) resistor r=0.594855 //w=0.311 //l=1.48 //layer=m1 \
 //thickness=0.36 //x=25.28 //y=0.175 //x2=26.76 //y2=0.175
r1503 (  42 532 ) resistor r=3.1 //w=0.17 //l=0.51 //layer=mcon //count=3 \
 //x=24.17 //y=0.18 //x2=24.17 //y2=0.18
r1504 (  42 44 ) resistor r=0.446141 //w=0.311 //l=1.11 //layer=m1 \
 //thickness=0.36 //x=24.17 //y=0.175 //x2=25.28 //y2=0.175
r1505 (  40 236 ) resistor r=3.1 //w=0.17 //l=0.51 //layer=mcon //count=3 \
 //x=22.69 //y=0.18 //x2=22.69 //y2=0.18
r1506 (  40 42 ) resistor r=0.594855 //w=0.311 //l=1.48 //layer=m1 \
 //thickness=0.36 //x=22.69 //y=0.175 //x2=24.17 //y2=0.175
r1507 (  38 234 ) resistor r=3.1 //w=0.17 //l=0.51 //layer=mcon //count=3 \
 //x=21.58 //y=0.18 //x2=21.58 //y2=0.18
r1508 (  38 40 ) resistor r=0.446141 //w=0.311 //l=1.11 //layer=m1 \
 //thickness=0.36 //x=21.58 //y=0.175 //x2=22.69 //y2=0.175
r1509 (  36 232 ) resistor r=3.1 //w=0.17 //l=0.51 //layer=mcon //count=3 \
 //x=20.47 //y=0.18 //x2=20.47 //y2=0.18
r1510 (  36 38 ) resistor r=0.446141 //w=0.311 //l=1.11 //layer=m1 \
 //thickness=0.36 //x=20.47 //y=0.175 //x2=21.58 //y2=0.175
r1511 (  34 529 ) resistor r=3.1 //w=0.17 //l=0.51 //layer=mcon //count=3 \
 //x=19.36 //y=0.18 //x2=19.36 //y2=0.18
r1512 (  34 36 ) resistor r=0.446141 //w=0.311 //l=1.11 //layer=m1 \
 //thickness=0.36 //x=19.36 //y=0.175 //x2=20.47 //y2=0.175
r1513 (  32 220 ) resistor r=3.1 //w=0.17 //l=0.51 //layer=mcon //count=3 \
 //x=17.88 //y=0.18 //x2=17.88 //y2=0.18
r1514 (  32 34 ) resistor r=0.594855 //w=0.311 //l=1.48 //layer=m1 \
 //thickness=0.36 //x=17.88 //y=0.175 //x2=19.36 //y2=0.175
r1515 (  30 218 ) resistor r=3.1 //w=0.17 //l=0.51 //layer=mcon //count=3 \
 //x=16.77 //y=0.18 //x2=16.77 //y2=0.18
r1516 (  30 32 ) resistor r=0.446141 //w=0.311 //l=1.11 //layer=m1 \
 //thickness=0.36 //x=16.77 //y=0.175 //x2=17.88 //y2=0.175
r1517 (  28 216 ) resistor r=3.1 //w=0.17 //l=0.51 //layer=mcon //count=3 \
 //x=15.66 //y=0.18 //x2=15.66 //y2=0.18
r1518 (  28 30 ) resistor r=0.446141 //w=0.311 //l=1.11 //layer=m1 \
 //thickness=0.36 //x=15.66 //y=0.175 //x2=16.77 //y2=0.175
r1519 (  26 526 ) resistor r=3.1 //w=0.17 //l=0.51 //layer=mcon //count=3 \
 //x=14.55 //y=0.18 //x2=14.55 //y2=0.18
r1520 (  26 28 ) resistor r=0.446141 //w=0.311 //l=1.11 //layer=m1 \
 //thickness=0.36 //x=14.55 //y=0.175 //x2=15.66 //y2=0.175
r1521 (  24 204 ) resistor r=3.1 //w=0.17 //l=0.51 //layer=mcon //count=3 \
 //x=13.07 //y=0.18 //x2=13.07 //y2=0.18
r1522 (  24 26 ) resistor r=0.594855 //w=0.311 //l=1.48 //layer=m1 \
 //thickness=0.36 //x=13.07 //y=0.175 //x2=14.55 //y2=0.175
r1523 (  22 202 ) resistor r=3.1 //w=0.17 //l=0.51 //layer=mcon //count=3 \
 //x=11.96 //y=0.18 //x2=11.96 //y2=0.18
r1524 (  22 24 ) resistor r=0.446141 //w=0.311 //l=1.11 //layer=m1 \
 //thickness=0.36 //x=11.96 //y=0.175 //x2=13.07 //y2=0.175
r1525 (  20 194 ) resistor r=3.1 //w=0.17 //l=0.51 //layer=mcon //count=3 \
 //x=10.85 //y=0.18 //x2=10.85 //y2=0.18
r1526 (  20 22 ) resistor r=0.446141 //w=0.311 //l=1.11 //layer=m1 \
 //thickness=0.36 //x=10.85 //y=0.175 //x2=11.96 //y2=0.175
r1527 (  18 188 ) resistor r=3.1 //w=0.17 //l=0.51 //layer=mcon //count=3 \
 //x=9.37 //y=0.18 //x2=9.37 //y2=0.18
r1528 (  18 20 ) resistor r=0.594855 //w=0.311 //l=1.48 //layer=m1 \
 //thickness=0.36 //x=9.37 //y=0.175 //x2=10.85 //y2=0.175
r1529 (  16 186 ) resistor r=3.1 //w=0.17 //l=0.51 //layer=mcon //count=3 \
 //x=8.26 //y=0.18 //x2=8.26 //y2=0.18
r1530 (  16 18 ) resistor r=0.446141 //w=0.311 //l=1.11 //layer=m1 \
 //thickness=0.36 //x=8.26 //y=0.175 //x2=9.37 //y2=0.175
r1531 (  14 184 ) resistor r=3.1 //w=0.17 //l=0.51 //layer=mcon //count=3 \
 //x=7.15 //y=0.18 //x2=7.15 //y2=0.18
r1532 (  14 16 ) resistor r=0.446141 //w=0.311 //l=1.11 //layer=m1 \
 //thickness=0.36 //x=7.15 //y=0.175 //x2=8.26 //y2=0.175
r1533 (  12 176 ) resistor r=3.1 //w=0.17 //l=0.51 //layer=mcon //count=3 \
 //x=6.04 //y=0.18 //x2=6.04 //y2=0.18
r1534 (  12 14 ) resistor r=0.446141 //w=0.311 //l=1.11 //layer=m1 \
 //thickness=0.36 //x=6.04 //y=0.175 //x2=7.15 //y2=0.175
r1535 (  10 170 ) resistor r=3.1 //w=0.17 //l=0.51 //layer=mcon //count=3 \
 //x=4.56 //y=0.18 //x2=4.56 //y2=0.18
r1536 (  10 12 ) resistor r=0.594855 //w=0.311 //l=1.48 //layer=m1 \
 //thickness=0.36 //x=4.56 //y=0.175 //x2=6.04 //y2=0.175
r1537 (  8 168 ) resistor r=3.1 //w=0.17 //l=0.51 //layer=mcon //count=3 \
 //x=3.45 //y=0.18 //x2=3.45 //y2=0.18
r1538 (  8 10 ) resistor r=0.446141 //w=0.311 //l=1.11 //layer=m1 \
 //thickness=0.36 //x=3.45 //y=0.175 //x2=4.56 //y2=0.175
r1539 (  6 166 ) resistor r=3.1 //w=0.17 //l=0.51 //layer=mcon //count=3 \
 //x=2.34 //y=0.18 //x2=2.34 //y2=0.18
r1540 (  6 8 ) resistor r=0.446141 //w=0.311 //l=1.11 //layer=m1 \
 //thickness=0.36 //x=2.34 //y=0.175 //x2=3.45 //y2=0.175
r1541 (  3 158 ) resistor r=3.1 //w=0.17 //l=0.51 //layer=mcon //count=3 \
 //x=1.23 //y=0.18 //x2=1.23 //y2=0.18
r1542 (  3 6 ) resistor r=0.446141 //w=0.311 //l=1.11 //layer=m1 \
 //thickness=0.36 //x=1.23 //y=0.175 //x2=2.34 //y2=0.175
r1543 (  1 79 ) resistor r=0.223071 //w=0.311 //l=0.555 //layer=m1 \
 //thickness=0.36 //x=45.445 //y=0.175 //x2=46 //y2=0.175
r1544 (  1 76 ) resistor r=0.223071 //w=0.311 //l=0.555 //layer=m1 \
 //thickness=0.36 //x=45.445 //y=0.175 //x2=44.89 //y2=0.175
ends PM_TMRDFFRNQX1\%GND

subckt PM_TMRDFFRNQX1\%VDD ( 1 151 158 165 175 183 193 199 209 219 227 237 243 \
 251 259 269 275 283 291 301 311 317 325 333 343 353 359 367 377 387 391 401 \
 411 421 429 433 443 453 463 471 475 485 495 503 507 517 527 535 545 551 561 \
 571 579 589 595 603 611 621 627 635 643 653 663 669 677 685 695 705 711 719 \
 729 739 743 753 763 773 781 785 795 805 815 823 827 837 847 859 867 875 885 \
 891 899 909 917 933 938 943 949 955 959 965 971 976 981 986 991 997 1003 1007 \
 1013 1019 1024 1029 1030 1031 1035 1036 1037 1038 1039 1040 1041 1042 1043 \
 1044 1045 1046 1047 1048 1049 1050 1051 1052 1053 1054 1055 1056 1057 1058 \
 1059 1060 1061 1062 1063 1064 1065 1066 1067 1068 1069 1070 1071 1072 1073 \
 1074 1075 1076 1077 1078 1079 1080 1081 1082 1083 1084 1085 1086 1087 1088 \
 1089 1090 1091 1092 1093 1094 1095 1096 1097 1098 1099 1100 1101 1102 1103 \
 1104 1105 1106 )
c1138 ( 1106 0 ) capacitor c=0.0451938f //x=89.59 //y=5.2
c1139 ( 1105 0 ) capacitor c=0.0420334f //x=88.72 //y=5.2
c1140 ( 1104 0 ) capacitor c=0.0476809f //x=80.595 //y=5.205
c1141 ( 1103 0 ) capacitor c=0.0241715f //x=79.715 //y=5.205
c1142 ( 1102 0 ) capacitor c=0.0467094f //x=78.845 //y=5.205
c1143 ( 1101 0 ) capacitor c=0.0382077f //x=77.265 //y=5.2
c1144 ( 1100 0 ) capacitor c=0.0240874f //x=76.385 //y=5.2
c1145 ( 1099 0 ) capacitor c=0.0495447f //x=75.515 //y=5.2
c1146 ( 1098 0 ) capacitor c=0.045306f //x=73.635 //y=5.2
c1147 ( 1097 0 ) capacitor c=0.0242401f //x=72.755 //y=5.2
c1148 ( 1096 0 ) capacitor c=0.0242401f //x=71.875 //y=5.2
c1149 ( 1095 0 ) capacitor c=0.0531794f //x=71.005 //y=5.2
c1150 ( 1094 0 ) capacitor c=0.045306f //x=68.825 //y=5.2
c1151 ( 1093 0 ) capacitor c=0.0242401f //x=67.945 //y=5.2
c1152 ( 1092 0 ) capacitor c=0.0241521f //x=67.065 //y=5.2
c1153 ( 1091 0 ) capacitor c=0.0531894f //x=66.195 //y=5.2
c1154 ( 1090 0 ) capacitor c=0.038068f //x=64.315 //y=5.2
c1155 ( 1089 0 ) capacitor c=0.0240081f //x=63.435 //y=5.2
c1156 ( 1088 0 ) capacitor c=0.0492093f //x=62.565 //y=5.2
c1157 ( 1087 0 ) capacitor c=0.045218f //x=60.685 //y=5.2
c1158 ( 1086 0 ) capacitor c=0.0241521f //x=59.805 //y=5.2
c1159 ( 1085 0 ) capacitor c=0.0241521f //x=58.925 //y=5.2
c1160 ( 1084 0 ) capacitor c=0.053132f //x=58.055 //y=5.2
c1161 ( 1083 0 ) capacitor c=0.045218f //x=55.875 //y=5.2
c1162 ( 1082 0 ) capacitor c=0.0241521f //x=54.995 //y=5.2
c1163 ( 1081 0 ) capacitor c=0.0241521f //x=54.115 //y=5.2
c1164 ( 1080 0 ) capacitor c=0.0531894f //x=53.245 //y=5.2
c1165 ( 1079 0 ) capacitor c=0.038068f //x=51.365 //y=5.2
c1166 ( 1078 0 ) capacitor c=0.0240081f //x=50.485 //y=5.2
c1167 ( 1077 0 ) capacitor c=0.0492093f //x=49.615 //y=5.2
c1168 ( 1076 0 ) capacitor c=0.045218f //x=47.735 //y=5.2
c1169 ( 1075 0 ) capacitor c=0.0241521f //x=46.855 //y=5.2
c1170 ( 1074 0 ) capacitor c=0.0241521f //x=45.975 //y=5.2
c1171 ( 1073 0 ) capacitor c=0.053132f //x=45.105 //y=5.2
c1172 ( 1072 0 ) capacitor c=0.045218f //x=42.925 //y=5.2
c1173 ( 1071 0 ) capacitor c=0.0241521f //x=42.045 //y=5.2
c1174 ( 1070 0 ) capacitor c=0.0241521f //x=41.165 //y=5.2
c1175 ( 1069 0 ) capacitor c=0.0531894f //x=40.295 //y=5.2
c1176 ( 1068 0 ) capacitor c=0.038068f //x=38.415 //y=5.2
c1177 ( 1067 0 ) capacitor c=0.0240081f //x=37.535 //y=5.2
c1178 ( 1066 0 ) capacitor c=0.0492093f //x=36.665 //y=5.2
c1179 ( 1065 0 ) capacitor c=0.045218f //x=34.785 //y=5.2
c1180 ( 1064 0 ) capacitor c=0.0241521f //x=33.905 //y=5.2
c1181 ( 1063 0 ) capacitor c=0.0241521f //x=33.025 //y=5.2
c1182 ( 1062 0 ) capacitor c=0.053132f //x=32.155 //y=5.2
c1183 ( 1061 0 ) capacitor c=0.045218f //x=29.975 //y=5.2
c1184 ( 1060 0 ) capacitor c=0.0241521f //x=29.095 //y=5.2
c1185 ( 1059 0 ) capacitor c=0.0241521f //x=28.215 //y=5.2
c1186 ( 1058 0 ) capacitor c=0.0531894f //x=27.345 //y=5.2
c1187 ( 1057 0 ) capacitor c=0.038068f //x=25.465 //y=5.2
c1188 ( 1056 0 ) capacitor c=0.0240081f //x=24.585 //y=5.2
c1189 ( 1055 0 ) capacitor c=0.0492093f //x=23.715 //y=5.2
c1190 ( 1054 0 ) capacitor c=0.045218f //x=21.835 //y=5.2
c1191 ( 1053 0 ) capacitor c=0.0241521f //x=20.955 //y=5.2
c1192 ( 1052 0 ) capacitor c=0.0241521f //x=20.075 //y=5.2
c1193 ( 1051 0 ) capacitor c=0.053132f //x=19.205 //y=5.2
c1194 ( 1050 0 ) capacitor c=0.045218f //x=17.025 //y=5.2
c1195 ( 1049 0 ) capacitor c=0.0241521f //x=16.145 //y=5.2
c1196 ( 1048 0 ) capacitor c=0.0241521f //x=15.265 //y=5.2
c1197 ( 1047 0 ) capacitor c=0.0531894f //x=14.395 //y=5.2
c1198 ( 1046 0 ) capacitor c=0.038068f //x=12.515 //y=5.2
c1199 ( 1045 0 ) capacitor c=0.0240081f //x=11.635 //y=5.2
c1200 ( 1044 0 ) capacitor c=0.0492093f //x=10.765 //y=5.2
c1201 ( 1043 0 ) capacitor c=0.045218f //x=8.885 //y=5.2
c1202 ( 1042 0 ) capacitor c=0.0241521f //x=8.005 //y=5.2
c1203 ( 1041 0 ) capacitor c=0.0241521f //x=7.125 //y=5.2
c1204 ( 1040 0 ) capacitor c=0.053132f //x=6.255 //y=5.2
c1205 ( 1039 0 ) capacitor c=0.045218f //x=4.075 //y=5.2
c1206 ( 1038 0 ) capacitor c=0.0241521f //x=3.195 //y=5.2
c1207 ( 1037 0 ) capacitor c=0.0242401f //x=2.315 //y=5.2
c1208 ( 1036 0 ) capacitor c=0.0531407f //x=1.445 //y=5.2
c1209 ( 1035 0 ) capacitor c=0.253514f //x=89.66 //y=7.58
c1210 ( 1033 0 ) capacitor c=0.00597439f //x=88.92 //y=7.58
c1211 ( 1031 0 ) capacitor c=0.107782f //x=88.18 //y=7.585
c1212 ( 1030 0 ) capacitor c=0.113453f //x=84.85 //y=7.585
c1213 ( 1029 0 ) capacitor c=0.121322f //x=81.52 //y=7.585
c1214 ( 1028 0 ) capacitor c=0.00597439f //x=80.74 //y=7.585
c1215 ( 1027 0 ) capacitor c=0.00597439f //x=79.86 //y=7.585
c1216 ( 1026 0 ) capacitor c=0.00597439f //x=78.93 //y=7.58
c1217 ( 1024 0 ) capacitor c=0.115632f //x=78.19 //y=7.585
c1218 ( 1023 0 ) capacitor c=0.00597439f //x=77.45 //y=7.58
c1219 ( 1021 0 ) capacitor c=0.00597439f //x=76.53 //y=7.585
c1220 ( 1020 0 ) capacitor c=0.00597439f //x=75.65 //y=7.585
c1221 ( 1019 0 ) capacitor c=0.136715f //x=74.86 //y=7.585
c1222 ( 1018 0 ) capacitor c=0.00597439f //x=73.75 //y=7.58
c1223 ( 1016 0 ) capacitor c=0.00597439f //x=72.9 //y=7.585
c1224 ( 1015 0 ) capacitor c=0.00597439f //x=72.02 //y=7.585
c1225 ( 1014 0 ) capacitor c=0.00597439f //x=71.14 //y=7.585
c1226 ( 1013 0 ) capacitor c=0.157263f //x=70.05 //y=7.585
c1227 ( 1012 0 ) capacitor c=0.00597439f //x=68.94 //y=7.58
c1228 ( 1010 0 ) capacitor c=0.00597439f //x=68.09 //y=7.585
c1229 ( 1009 0 ) capacitor c=0.00597439f //x=67.21 //y=7.585
c1230 ( 1008 0 ) capacitor c=0.00597439f //x=66.33 //y=7.585
c1231 ( 1007 0 ) capacitor c=0.135162f //x=65.24 //y=7.585
c1232 ( 1006 0 ) capacitor c=0.00597439f //x=64.46 //y=7.585
c1233 ( 1005 0 ) capacitor c=0.00597439f //x=63.58 //y=7.585
c1234 ( 1004 0 ) capacitor c=0.00597439f //x=62.7 //y=7.585
c1235 ( 1003 0 ) capacitor c=0.134682f //x=61.91 //y=7.585
c1236 ( 1002 0 ) capacitor c=0.00597439f //x=60.83 //y=7.585
c1237 ( 1001 0 ) capacitor c=0.00597439f //x=59.95 //y=7.585
c1238 ( 1000 0 ) capacitor c=0.00597439f //x=59.07 //y=7.585
c1239 ( 999 0 ) capacitor c=0.00597439f //x=58.21 //y=7.58
c1240 ( 997 0 ) capacitor c=0.155314f //x=57.1 //y=7.585
c1241 ( 996 0 ) capacitor c=0.00597439f //x=56.02 //y=7.585
c1242 ( 995 0 ) capacitor c=0.00597439f //x=55.14 //y=7.585
c1243 ( 994 0 ) capacitor c=0.00597439f //x=54.26 //y=7.585
c1244 ( 993 0 ) capacitor c=0.00597439f //x=53.4 //y=7.58
c1245 ( 991 0 ) capacitor c=0.139349f //x=52.29 //y=7.585
c1246 ( 990 0 ) capacitor c=0.00597439f //x=51.51 //y=7.585
c1247 ( 989 0 ) capacitor c=0.00597439f //x=50.63 //y=7.585
c1248 ( 988 0 ) capacitor c=0.00597439f //x=49.7 //y=7.58
c1249 ( 986 0 ) capacitor c=0.134682f //x=48.96 //y=7.585
c1250 ( 985 0 ) capacitor c=0.00597439f //x=47.88 //y=7.585
c1251 ( 984 0 ) capacitor c=0.00597439f //x=47 //y=7.585
c1252 ( 983 0 ) capacitor c=0.00597439f //x=46.12 //y=7.585
c1253 ( 982 0 ) capacitor c=0.00597439f //x=45.24 //y=7.585
c1254 ( 981 0 ) capacitor c=0.155205f //x=44.15 //y=7.585
c1255 ( 980 0 ) capacitor c=0.00597439f //x=43.07 //y=7.585
c1256 ( 979 0 ) capacitor c=0.00597439f //x=42.19 //y=7.585
c1257 ( 978 0 ) capacitor c=0.00597439f //x=41.31 //y=7.585
c1258 ( 977 0 ) capacitor c=0.00597439f //x=40.43 //y=7.585
c1259 ( 976 0 ) capacitor c=0.135162f //x=39.34 //y=7.585
c1260 ( 975 0 ) capacitor c=0.00597439f //x=38.6 //y=7.58
c1261 ( 973 0 ) capacitor c=0.00597439f //x=37.68 //y=7.585
c1262 ( 972 0 ) capacitor c=0.00597439f //x=36.8 //y=7.585
c1263 ( 971 0 ) capacitor c=0.134682f //x=36.01 //y=7.585
c1264 ( 970 0 ) capacitor c=0.00597439f //x=34.9 //y=7.58
c1265 ( 968 0 ) capacitor c=0.00597439f //x=34.05 //y=7.585
c1266 ( 967 0 ) capacitor c=0.00597439f //x=33.17 //y=7.585
c1267 ( 966 0 ) capacitor c=0.00597439f //x=32.29 //y=7.585
c1268 ( 965 0 ) capacitor c=0.155314f //x=31.2 //y=7.585
c1269 ( 964 0 ) capacitor c=0.00597439f //x=30.09 //y=7.58
c1270 ( 962 0 ) capacitor c=0.00597439f //x=29.24 //y=7.585
c1271 ( 961 0 ) capacitor c=0.00597439f //x=28.36 //y=7.585
c1272 ( 960 0 ) capacitor c=0.00597439f //x=27.48 //y=7.585
c1273 ( 959 0 ) capacitor c=0.139349f //x=26.39 //y=7.585
c1274 ( 958 0 ) capacitor c=0.00597439f //x=25.61 //y=7.585
c1275 ( 957 0 ) capacitor c=0.00597439f //x=24.73 //y=7.585
c1276 ( 956 0 ) capacitor c=0.00597439f //x=23.85 //y=7.585
c1277 ( 955 0 ) capacitor c=0.134836f //x=23.06 //y=7.585
c1278 ( 954 0 ) capacitor c=0.00597439f //x=21.98 //y=7.585
c1279 ( 953 0 ) capacitor c=0.00597439f //x=21.1 //y=7.585
c1280 ( 952 0 ) capacitor c=0.00597439f //x=20.22 //y=7.585
c1281 ( 951 0 ) capacitor c=0.00597439f //x=19.36 //y=7.58
c1282 ( 949 0 ) capacitor c=0.155205f //x=18.25 //y=7.585
c1283 ( 948 0 ) capacitor c=0.00597439f //x=17.17 //y=7.585
c1284 ( 947 0 ) capacitor c=0.00597439f //x=16.29 //y=7.585
c1285 ( 946 0 ) capacitor c=0.00597439f //x=15.41 //y=7.585
c1286 ( 945 0 ) capacitor c=0.00597439f //x=14.55 //y=7.58
c1287 ( 943 0 ) capacitor c=0.135162f //x=13.44 //y=7.585
c1288 ( 942 0 ) capacitor c=0.00597439f //x=12.66 //y=7.585
c1289 ( 941 0 ) capacitor c=0.00597439f //x=11.78 //y=7.585
c1290 ( 940 0 ) capacitor c=0.00597439f //x=10.85 //y=7.58
c1291 ( 938 0 ) capacitor c=0.134682f //x=10.11 //y=7.585
c1292 ( 937 0 ) capacitor c=0.00597439f //x=9.03 //y=7.585
c1293 ( 936 0 ) capacitor c=0.00597439f //x=8.15 //y=7.585
c1294 ( 935 0 ) capacitor c=0.00597439f //x=7.27 //y=7.585
c1295 ( 934 0 ) capacitor c=0.00597439f //x=6.39 //y=7.585
c1296 ( 933 0 ) capacitor c=0.155314f //x=5.3 //y=7.585
c1297 ( 932 0 ) capacitor c=0.00597439f //x=4.22 //y=7.585
c1298 ( 931 0 ) capacitor c=0.00597439f //x=3.34 //y=7.585
c1299 ( 930 0 ) capacitor c=0.00597439f //x=2.46 //y=7.585
c1300 ( 929 0 ) capacitor c=0.00597439f //x=1.58 //y=7.585
c1301 ( 917 0 ) capacitor c=0.0290557f //x=89.65 //y=7.585
c1302 ( 909 0 ) capacitor c=0.0187886f //x=88.77 //y=7.585
c1303 ( 899 0 ) capacitor c=0.122205f //x=88.01 //y=7.585
c1304 ( 891 0 ) capacitor c=0.122102f //x=84.68 //y=7.585
c1305 ( 885 0 ) capacitor c=0.0238235f //x=81.35 //y=7.585
c1306 ( 875 0 ) capacitor c=0.0288071f //x=80.655 //y=7.585
c1307 ( 867 0 ) capacitor c=0.0287754f //x=79.775 //y=7.585
c1308 ( 859 0 ) capacitor c=0.0277927f //x=78.895 //y=7.585
c1309 ( 855 0 ) capacitor c=0.0277785f //x=78.02 //y=7.585
c1310 ( 847 0 ) capacitor c=0.028702f //x=77.325 //y=7.585
c1311 ( 837 0 ) capacitor c=0.0291278f //x=76.445 //y=7.585
c1312 ( 827 0 ) capacitor c=0.024303f //x=75.565 //y=7.585
c1313 ( 823 0 ) capacitor c=0.0398272f //x=74.69 //y=7.585
c1314 ( 815 0 ) capacitor c=0.0291418f //x=73.695 //y=7.585
c1315 ( 805 0 ) capacitor c=0.0290414f //x=72.815 //y=7.585
c1316 ( 795 0 ) capacitor c=0.0287792f //x=71.935 //y=7.585
c1317 ( 785 0 ) capacitor c=0.0386886f //x=71.055 //y=7.585
c1318 ( 781 0 ) capacitor c=0.0398272f //x=69.88 //y=7.585
c1319 ( 773 0 ) capacitor c=0.0291418f //x=68.885 //y=7.585
c1320 ( 763 0 ) capacitor c=0.0290281f //x=68.005 //y=7.585
c1321 ( 753 0 ) capacitor c=0.0287649f //x=67.125 //y=7.585
c1322 ( 743 0 ) capacitor c=0.0386886f //x=66.245 //y=7.585
c1323 ( 739 0 ) capacitor c=0.0238235f //x=65.07 //y=7.585
c1324 ( 729 0 ) capacitor c=0.0291008f //x=64.375 //y=7.585
c1325 ( 719 0 ) capacitor c=0.0291028f //x=63.495 //y=7.585
c1326 ( 711 0 ) capacitor c=0.024303f //x=62.615 //y=7.585
c1327 ( 705 0 ) capacitor c=0.0397734f //x=61.74 //y=7.585
c1328 ( 695 0 ) capacitor c=0.0291138f //x=60.745 //y=7.585
c1329 ( 685 0 ) capacitor c=0.0290172f //x=59.865 //y=7.585
c1330 ( 677 0 ) capacitor c=0.0287649f //x=58.985 //y=7.585
c1331 ( 669 0 ) capacitor c=0.0386886f //x=58.105 //y=7.585
c1332 ( 663 0 ) capacitor c=0.0397734f //x=56.93 //y=7.585
c1333 ( 653 0 ) capacitor c=0.0291138f //x=55.935 //y=7.585
c1334 ( 643 0 ) capacitor c=0.0290163f //x=55.055 //y=7.585
c1335 ( 635 0 ) capacitor c=0.0287649f //x=54.175 //y=7.585
c1336 ( 627 0 ) capacitor c=0.0386886f //x=53.295 //y=7.585
c1337 ( 621 0 ) capacitor c=0.0238235f //x=52.12 //y=7.585
c1338 ( 611 0 ) capacitor c=0.0291008f //x=51.425 //y=7.585
c1339 ( 603 0 ) capacitor c=0.0291028f //x=50.545 //y=7.585
c1340 ( 595 0 ) capacitor c=0.024303f //x=49.665 //y=7.585
c1341 ( 589 0 ) capacitor c=0.0397734f //x=48.79 //y=7.585
c1342 ( 579 0 ) capacitor c=0.0291138f //x=47.795 //y=7.585
c1343 ( 571 0 ) capacitor c=0.0290172f //x=46.915 //y=7.585
c1344 ( 561 0 ) capacitor c=0.0287649f //x=46.035 //y=7.585
c1345 ( 551 0 ) capacitor c=0.0386886f //x=45.155 //y=7.585
c1346 ( 545 0 ) capacitor c=0.0397734f //x=43.98 //y=7.585
c1347 ( 535 0 ) capacitor c=0.0291138f //x=42.985 //y=7.585
c1348 ( 527 0 ) capacitor c=0.0290163f //x=42.105 //y=7.585
c1349 ( 517 0 ) capacitor c=0.0287649f //x=41.225 //y=7.585
c1350 ( 507 0 ) capacitor c=0.0386886f //x=40.345 //y=7.585
c1351 ( 503 0 ) capacitor c=0.0238235f //x=39.17 //y=7.585
c1352 ( 495 0 ) capacitor c=0.0291008f //x=38.475 //y=7.585
c1353 ( 485 0 ) capacitor c=0.0291028f //x=37.595 //y=7.585
c1354 ( 475 0 ) capacitor c=0.024303f //x=36.715 //y=7.585
c1355 ( 471 0 ) capacitor c=0.0397734f //x=35.84 //y=7.585
c1356 ( 463 0 ) capacitor c=0.0291138f //x=34.845 //y=7.585
c1357 ( 453 0 ) capacitor c=0.0290172f //x=33.965 //y=7.585
c1358 ( 443 0 ) capacitor c=0.0287649f //x=33.085 //y=7.585
c1359 ( 433 0 ) capacitor c=0.0386886f //x=32.205 //y=7.585
c1360 ( 429 0 ) capacitor c=0.0397734f //x=31.03 //y=7.585
c1361 ( 421 0 ) capacitor c=0.0291138f //x=30.035 //y=7.585
c1362 ( 411 0 ) capacitor c=0.0290163f //x=29.155 //y=7.585
c1363 ( 401 0 ) capacitor c=0.0287649f //x=28.275 //y=7.585
c1364 ( 391 0 ) capacitor c=0.0386886f //x=27.395 //y=7.585
c1365 ( 387 0 ) capacitor c=0.0238235f //x=26.22 //y=7.585
c1366 ( 377 0 ) capacitor c=0.0291008f //x=25.525 //y=7.585
c1367 ( 367 0 ) capacitor c=0.0291028f //x=24.645 //y=7.585
c1368 ( 359 0 ) capacitor c=0.024303f //x=23.765 //y=7.585
c1369 ( 353 0 ) capacitor c=0.0397734f //x=22.89 //y=7.585
c1370 ( 343 0 ) capacitor c=0.0291138f //x=21.895 //y=7.585
c1371 ( 333 0 ) capacitor c=0.0290172f //x=21.015 //y=7.585
c1372 ( 325 0 ) capacitor c=0.0287649f //x=20.135 //y=7.585
c1373 ( 317 0 ) capacitor c=0.0386886f //x=19.255 //y=7.585
c1374 ( 311 0 ) capacitor c=0.0397734f //x=18.08 //y=7.585
c1375 ( 301 0 ) capacitor c=0.0291138f //x=17.085 //y=7.585
c1376 ( 291 0 ) capacitor c=0.0290163f //x=16.205 //y=7.585
c1377 ( 283 0 ) capacitor c=0.0287649f //x=15.325 //y=7.585
c1378 ( 275 0 ) capacitor c=0.0386886f //x=14.445 //y=7.585
c1379 ( 269 0 ) capacitor c=0.0238235f //x=13.27 //y=7.585
c1380 ( 259 0 ) capacitor c=0.0291008f //x=12.575 //y=7.585
c1381 ( 251 0 ) capacitor c=0.0291028f //x=11.695 //y=7.585
c1382 ( 243 0 ) capacitor c=0.024303f //x=10.815 //y=7.585
c1383 ( 237 0 ) capacitor c=0.0397734f //x=9.94 //y=7.585
c1384 ( 227 0 ) capacitor c=0.0291138f //x=8.945 //y=7.585
c1385 ( 219 0 ) capacitor c=0.0290172f //x=8.065 //y=7.585
c1386 ( 209 0 ) capacitor c=0.0287649f //x=7.185 //y=7.585
c1387 ( 199 0 ) capacitor c=0.0386886f //x=6.305 //y=7.585
c1388 ( 193 0 ) capacitor c=0.0397734f //x=5.13 //y=7.585
c1389 ( 183 0 ) capacitor c=0.0291138f //x=4.135 //y=7.585
c1390 ( 175 0 ) capacitor c=0.0290163f //x=3.255 //y=7.585
c1391 ( 165 0 ) capacitor c=0.0287792f //x=2.375 //y=7.585
c1392 ( 158 0 ) capacitor c=0.253096f //x=1.23 //y=7.58
c1393 ( 155 0 ) capacitor c=0.0455283f //x=1.495 //y=7.585
c1394 ( 151 0 ) capacitor c=3.01935f //x=89.66 //y=7.58
r1395 (  919 1035 ) resistor r=4.23183 //w=0.7 //l=0.175 //layer=li \
 //thickness=0.1 //x=89.735 //y=7.41 //x2=89.735 //y2=7.585
r1396 (  919 1106 ) resistor r=56.4706 //w=0.187 //l=0.825 //layer=li \
 //thickness=0.1 //x=89.735 //y=7.41 //x2=89.735 //y2=6.585
r1397 (  918 1033 ) resistor r=2.87058 //w=0.35 //l=0.085 //layer=li \
 //thickness=0.1 //x=88.94 //y=7.585 //x2=88.855 //y2=7.585
r1398 (  917 1035 ) resistor r=2.87058 //w=0.35 //l=0.085 //layer=li \
 //thickness=0.1 //x=89.65 //y=7.585 //x2=89.735 //y2=7.585
r1399 (  917 918 ) resistor r=24.7629 //w=0.367 //l=0.71 //layer=li \
 //thickness=0.1 //x=89.65 //y=7.585 //x2=88.94 //y2=7.585
r1400 (  911 1033 ) resistor r=4.23183 //w=0.7 //l=0.175 //layer=li \
 //thickness=0.1 //x=88.855 //y=7.41 //x2=88.855 //y2=7.585
r1401 (  911 1105 ) resistor r=56.4706 //w=0.187 //l=0.825 //layer=li \
 //thickness=0.1 //x=88.855 //y=7.41 //x2=88.855 //y2=6.585
r1402 (  910 1031 ) resistor r=5.29055 //w=0.35 //l=0.17 //layer=li \
 //thickness=0.1 //x=88.35 //y=7.585 //x2=88.18 //y2=7.585
r1403 (  909 1033 ) resistor r=2.87058 //w=0.35 //l=0.085 //layer=li \
 //thickness=0.1 //x=88.77 //y=7.585 //x2=88.855 //y2=7.585
r1404 (  909 910 ) resistor r=14.6485 //w=0.367 //l=0.42 //layer=li \
 //thickness=0.1 //x=88.77 //y=7.585 //x2=88.35 //y2=7.585
r1405 (  904 906 ) resistor r=38.7139 //w=0.367 //l=1.11 //layer=li \
 //thickness=0.1 //x=86.33 //y=7.585 //x2=87.44 //y2=7.585
r1406 (  902 904 ) resistor r=38.7139 //w=0.367 //l=1.11 //layer=li \
 //thickness=0.1 //x=85.22 //y=7.585 //x2=86.33 //y2=7.585
r1407 (  900 1030 ) resistor r=5.29055 //w=0.35 //l=0.17 //layer=li \
 //thickness=0.1 //x=85.02 //y=7.585 //x2=84.85 //y2=7.585
r1408 (  900 902 ) resistor r=6.97548 //w=0.367 //l=0.2 //layer=li \
 //thickness=0.1 //x=85.02 //y=7.585 //x2=85.22 //y2=7.585
r1409 (  899 1031 ) resistor r=5.29055 //w=0.35 //l=0.17 //layer=li \
 //thickness=0.1 //x=88.01 //y=7.585 //x2=88.18 //y2=7.585
r1410 (  899 906 ) resistor r=19.8801 //w=0.367 //l=0.57 //layer=li \
 //thickness=0.1 //x=88.01 //y=7.585 //x2=87.44 //y2=7.585
r1411 (  894 896 ) resistor r=38.7139 //w=0.367 //l=1.11 //layer=li \
 //thickness=0.1 //x=82.63 //y=7.585 //x2=83.74 //y2=7.585
r1412 (  892 1029 ) resistor r=5.29055 //w=0.35 //l=0.17 //layer=li \
 //thickness=0.1 //x=81.69 //y=7.585 //x2=81.52 //y2=7.585
r1413 (  892 894 ) resistor r=32.7847 //w=0.367 //l=0.94 //layer=li \
 //thickness=0.1 //x=81.69 //y=7.585 //x2=82.63 //y2=7.585
r1414 (  891 1030 ) resistor r=5.29055 //w=0.35 //l=0.17 //layer=li \
 //thickness=0.1 //x=84.68 //y=7.585 //x2=84.85 //y2=7.585
r1415 (  891 896 ) resistor r=32.7847 //w=0.367 //l=0.94 //layer=li \
 //thickness=0.1 //x=84.68 //y=7.585 //x2=83.74 //y2=7.585
r1416 (  886 1028 ) resistor r=2.87058 //w=0.35 //l=0.085 //layer=li \
 //thickness=0.1 //x=80.825 //y=7.585 //x2=80.74 //y2=7.585
r1417 (  886 888 ) resistor r=11.3351 //w=0.367 //l=0.325 //layer=li \
 //thickness=0.1 //x=80.825 //y=7.585 //x2=81.15 //y2=7.585
r1418 (  885 1029 ) resistor r=5.29055 //w=0.35 //l=0.17 //layer=li \
 //thickness=0.1 //x=81.35 //y=7.585 //x2=81.52 //y2=7.585
r1419 (  885 888 ) resistor r=6.97548 //w=0.367 //l=0.2 //layer=li \
 //thickness=0.1 //x=81.35 //y=7.585 //x2=81.15 //y2=7.585
r1420 (  879 1028 ) resistor r=4.23183 //w=0.7 //l=0.175 //layer=li \
 //thickness=0.1 //x=80.74 //y=7.41 //x2=80.74 //y2=7.585
r1421 (  879 1104 ) resistor r=56.8128 //w=0.187 //l=0.83 //layer=li \
 //thickness=0.1 //x=80.74 //y=7.41 //x2=80.74 //y2=6.58
r1422 (  876 1027 ) resistor r=2.87058 //w=0.35 //l=0.085 //layer=li \
 //thickness=0.1 //x=79.945 //y=7.585 //x2=79.86 //y2=7.585
r1423 (  876 878 ) resistor r=3.31335 //w=0.367 //l=0.095 //layer=li \
 //thickness=0.1 //x=79.945 //y=7.585 //x2=80.04 //y2=7.585
r1424 (  875 1028 ) resistor r=2.87058 //w=0.35 //l=0.085 //layer=li \
 //thickness=0.1 //x=80.655 //y=7.585 //x2=80.74 //y2=7.585
r1425 (  875 878 ) resistor r=21.4496 //w=0.367 //l=0.615 //layer=li \
 //thickness=0.1 //x=80.655 //y=7.585 //x2=80.04 //y2=7.585
r1426 (  869 1027 ) resistor r=4.23183 //w=0.7 //l=0.175 //layer=li \
 //thickness=0.1 //x=79.86 //y=7.41 //x2=79.86 //y2=7.585
r1427 (  869 1103 ) resistor r=33.5401 //w=0.187 //l=0.49 //layer=li \
 //thickness=0.1 //x=79.86 //y=7.41 //x2=79.86 //y2=6.92
r1428 (  868 1026 ) resistor r=2.87058 //w=0.35 //l=0.085 //layer=li \
 //thickness=0.1 //x=79.065 //y=7.585 //x2=78.98 //y2=7.585
r1429 (  867 1027 ) resistor r=2.87058 //w=0.35 //l=0.085 //layer=li \
 //thickness=0.1 //x=79.775 //y=7.585 //x2=79.86 //y2=7.585
r1430 (  867 868 ) resistor r=24.7629 //w=0.367 //l=0.71 //layer=li \
 //thickness=0.1 //x=79.775 //y=7.585 //x2=79.065 //y2=7.585
r1431 (  861 1026 ) resistor r=4.23183 //w=0.7 //l=0.175 //layer=li \
 //thickness=0.1 //x=78.98 //y=7.41 //x2=78.98 //y2=7.585
r1432 (  861 1102 ) resistor r=56.8128 //w=0.187 //l=0.83 //layer=li \
 //thickness=0.1 //x=78.98 //y=7.41 //x2=78.98 //y2=6.58
r1433 (  860 1024 ) resistor r=5.29055 //w=0.35 //l=0.17 //layer=li \
 //thickness=0.1 //x=78.36 //y=7.585 //x2=78.19 //y2=7.585
r1434 (  859 1026 ) resistor r=2.87058 //w=0.35 //l=0.085 //layer=li \
 //thickness=0.1 //x=78.895 //y=7.585 //x2=78.98 //y2=7.585
r1435 (  859 860 ) resistor r=18.6594 //w=0.367 //l=0.535 //layer=li \
 //thickness=0.1 //x=78.895 //y=7.585 //x2=78.36 //y2=7.585
r1436 (  856 1023 ) resistor r=2.87058 //w=0.35 //l=0.085 //layer=li \
 //thickness=0.1 //x=77.495 //y=7.585 //x2=77.41 //y2=7.585
r1437 (  855 1024 ) resistor r=5.29055 //w=0.35 //l=0.17 //layer=li \
 //thickness=0.1 //x=78.02 //y=7.585 //x2=78.19 //y2=7.585
r1438 (  855 856 ) resistor r=18.3106 //w=0.367 //l=0.525 //layer=li \
 //thickness=0.1 //x=78.02 //y=7.585 //x2=77.495 //y2=7.585
r1439 (  849 1023 ) resistor r=4.23183 //w=0.7 //l=0.175 //layer=li \
 //thickness=0.1 //x=77.41 //y=7.41 //x2=77.41 //y2=7.585
r1440 (  849 1101 ) resistor r=33.1979 //w=0.187 //l=0.485 //layer=li \
 //thickness=0.1 //x=77.41 //y=7.41 //x2=77.41 //y2=6.925
r1441 (  848 1021 ) resistor r=2.87058 //w=0.35 //l=0.085 //layer=li \
 //thickness=0.1 //x=76.615 //y=7.585 //x2=76.53 //y2=7.585
r1442 (  847 1023 ) resistor r=2.87058 //w=0.35 //l=0.085 //layer=li \
 //thickness=0.1 //x=77.325 //y=7.585 //x2=77.41 //y2=7.585
r1443 (  847 848 ) resistor r=24.7629 //w=0.367 //l=0.71 //layer=li \
 //thickness=0.1 //x=77.325 //y=7.585 //x2=76.615 //y2=7.585
r1444 (  841 1021 ) resistor r=4.23183 //w=0.7 //l=0.175 //layer=li \
 //thickness=0.1 //x=76.53 //y=7.41 //x2=76.53 //y2=7.585
r1445 (  841 1100 ) resistor r=33.1979 //w=0.187 //l=0.485 //layer=li \
 //thickness=0.1 //x=76.53 //y=7.41 //x2=76.53 //y2=6.925
r1446 (  838 1020 ) resistor r=2.87058 //w=0.35 //l=0.085 //layer=li \
 //thickness=0.1 //x=75.735 //y=7.585 //x2=75.65 //y2=7.585
r1447 (  838 840 ) resistor r=21.1008 //w=0.367 //l=0.605 //layer=li \
 //thickness=0.1 //x=75.735 //y=7.585 //x2=76.34 //y2=7.585
r1448 (  837 1021 ) resistor r=2.87058 //w=0.35 //l=0.085 //layer=li \
 //thickness=0.1 //x=76.445 //y=7.585 //x2=76.53 //y2=7.585
r1449 (  837 840 ) resistor r=3.66213 //w=0.367 //l=0.105 //layer=li \
 //thickness=0.1 //x=76.445 //y=7.585 //x2=76.34 //y2=7.585
r1450 (  831 1020 ) resistor r=4.23183 //w=0.7 //l=0.175 //layer=li \
 //thickness=0.1 //x=75.65 //y=7.41 //x2=75.65 //y2=7.585
r1451 (  831 1099 ) resistor r=56.4706 //w=0.187 //l=0.825 //layer=li \
 //thickness=0.1 //x=75.65 //y=7.41 //x2=75.65 //y2=6.585
r1452 (  828 1019 ) resistor r=5.29055 //w=0.35 //l=0.17 //layer=li \
 //thickness=0.1 //x=75.03 //y=7.585 //x2=74.86 //y2=7.585
r1453 (  828 830 ) resistor r=6.97548 //w=0.367 //l=0.2 //layer=li \
 //thickness=0.1 //x=75.03 //y=7.585 //x2=75.23 //y2=7.585
r1454 (  827 1020 ) resistor r=2.87058 //w=0.35 //l=0.085 //layer=li \
 //thickness=0.1 //x=75.565 //y=7.585 //x2=75.65 //y2=7.585
r1455 (  827 830 ) resistor r=11.6839 //w=0.367 //l=0.335 //layer=li \
 //thickness=0.1 //x=75.565 //y=7.585 //x2=75.23 //y2=7.585
r1456 (  824 1018 ) resistor r=2.87058 //w=0.35 //l=0.085 //layer=li \
 //thickness=0.1 //x=73.865 //y=7.585 //x2=73.78 //y2=7.585
r1457 (  823 1019 ) resistor r=5.29055 //w=0.35 //l=0.17 //layer=li \
 //thickness=0.1 //x=74.69 //y=7.585 //x2=74.86 //y2=7.585
r1458 (  823 824 ) resistor r=28.7738 //w=0.367 //l=0.825 //layer=li \
 //thickness=0.1 //x=74.69 //y=7.585 //x2=73.865 //y2=7.585
r1459 (  817 1018 ) resistor r=4.23183 //w=0.7 //l=0.175 //layer=li \
 //thickness=0.1 //x=73.78 //y=7.41 //x2=73.78 //y2=7.585
r1460 (  817 1098 ) resistor r=33.1979 //w=0.187 //l=0.485 //layer=li \
 //thickness=0.1 //x=73.78 //y=7.41 //x2=73.78 //y2=6.925
r1461 (  816 1016 ) resistor r=2.87058 //w=0.35 //l=0.085 //layer=li \
 //thickness=0.1 //x=72.985 //y=7.585 //x2=72.9 //y2=7.585
r1462 (  815 1018 ) resistor r=2.87058 //w=0.35 //l=0.085 //layer=li \
 //thickness=0.1 //x=73.695 //y=7.585 //x2=73.78 //y2=7.585
r1463 (  815 816 ) resistor r=24.7629 //w=0.367 //l=0.71 //layer=li \
 //thickness=0.1 //x=73.695 //y=7.585 //x2=72.985 //y2=7.585
r1464 (  809 1016 ) resistor r=4.23183 //w=0.7 //l=0.175 //layer=li \
 //thickness=0.1 //x=72.9 //y=7.41 //x2=72.9 //y2=7.585
r1465 (  809 1097 ) resistor r=33.1979 //w=0.187 //l=0.485 //layer=li \
 //thickness=0.1 //x=72.9 //y=7.41 //x2=72.9 //y2=6.925
r1466 (  806 1015 ) resistor r=2.87058 //w=0.35 //l=0.085 //layer=li \
 //thickness=0.1 //x=72.105 //y=7.585 //x2=72.02 //y2=7.585
r1467 (  806 808 ) resistor r=18.6594 //w=0.367 //l=0.535 //layer=li \
 //thickness=0.1 //x=72.105 //y=7.585 //x2=72.64 //y2=7.585
r1468 (  805 1016 ) resistor r=2.87058 //w=0.35 //l=0.085 //layer=li \
 //thickness=0.1 //x=72.815 //y=7.585 //x2=72.9 //y2=7.585
r1469 (  805 808 ) resistor r=6.10354 //w=0.367 //l=0.175 //layer=li \
 //thickness=0.1 //x=72.815 //y=7.585 //x2=72.64 //y2=7.585
r1470 (  799 1015 ) resistor r=4.23183 //w=0.7 //l=0.175 //layer=li \
 //thickness=0.1 //x=72.02 //y=7.41 //x2=72.02 //y2=7.585
r1471 (  799 1096 ) resistor r=33.1979 //w=0.187 //l=0.485 //layer=li \
 //thickness=0.1 //x=72.02 //y=7.41 //x2=72.02 //y2=6.925
r1472 (  796 1014 ) resistor r=2.87058 //w=0.35 //l=0.085 //layer=li \
 //thickness=0.1 //x=71.225 //y=7.585 //x2=71.14 //y2=7.585
r1473 (  796 798 ) resistor r=10.6376 //w=0.367 //l=0.305 //layer=li \
 //thickness=0.1 //x=71.225 //y=7.585 //x2=71.53 //y2=7.585
r1474 (  795 1015 ) resistor r=2.87058 //w=0.35 //l=0.085 //layer=li \
 //thickness=0.1 //x=71.935 //y=7.585 //x2=72.02 //y2=7.585
r1475 (  795 798 ) resistor r=14.1253 //w=0.367 //l=0.405 //layer=li \
 //thickness=0.1 //x=71.935 //y=7.585 //x2=71.53 //y2=7.585
r1476 (  789 1014 ) resistor r=4.23183 //w=0.7 //l=0.175 //layer=li \
 //thickness=0.1 //x=71.14 //y=7.41 //x2=71.14 //y2=7.585
r1477 (  789 1095 ) resistor r=56.4706 //w=0.187 //l=0.825 //layer=li \
 //thickness=0.1 //x=71.14 //y=7.41 //x2=71.14 //y2=6.585
r1478 (  786 1013 ) resistor r=5.29055 //w=0.35 //l=0.17 //layer=li \
 //thickness=0.1 //x=70.22 //y=7.585 //x2=70.05 //y2=7.585
r1479 (  786 788 ) resistor r=6.97548 //w=0.367 //l=0.2 //layer=li \
 //thickness=0.1 //x=70.22 //y=7.585 //x2=70.42 //y2=7.585
r1480 (  785 1014 ) resistor r=2.87058 //w=0.35 //l=0.085 //layer=li \
 //thickness=0.1 //x=71.055 //y=7.585 //x2=71.14 //y2=7.585
r1481 (  785 788 ) resistor r=22.1471 //w=0.367 //l=0.635 //layer=li \
 //thickness=0.1 //x=71.055 //y=7.585 //x2=70.42 //y2=7.585
r1482 (  782 1012 ) resistor r=2.87058 //w=0.35 //l=0.085 //layer=li \
 //thickness=0.1 //x=69.055 //y=7.585 //x2=68.97 //y2=7.585
r1483 (  781 1013 ) resistor r=5.29055 //w=0.35 //l=0.17 //layer=li \
 //thickness=0.1 //x=69.88 //y=7.585 //x2=70.05 //y2=7.585
r1484 (  781 782 ) resistor r=28.7738 //w=0.367 //l=0.825 //layer=li \
 //thickness=0.1 //x=69.88 //y=7.585 //x2=69.055 //y2=7.585
r1485 (  775 1012 ) resistor r=4.23183 //w=0.7 //l=0.175 //layer=li \
 //thickness=0.1 //x=68.97 //y=7.41 //x2=68.97 //y2=7.585
r1486 (  775 1094 ) resistor r=33.1979 //w=0.187 //l=0.485 //layer=li \
 //thickness=0.1 //x=68.97 //y=7.41 //x2=68.97 //y2=6.925
r1487 (  774 1010 ) resistor r=2.87058 //w=0.35 //l=0.085 //layer=li \
 //thickness=0.1 //x=68.175 //y=7.585 //x2=68.09 //y2=7.585
r1488 (  773 1012 ) resistor r=2.87058 //w=0.35 //l=0.085 //layer=li \
 //thickness=0.1 //x=68.885 //y=7.585 //x2=68.97 //y2=7.585
r1489 (  773 774 ) resistor r=24.7629 //w=0.367 //l=0.71 //layer=li \
 //thickness=0.1 //x=68.885 //y=7.585 //x2=68.175 //y2=7.585
r1490 (  767 1010 ) resistor r=4.23183 //w=0.7 //l=0.175 //layer=li \
 //thickness=0.1 //x=68.09 //y=7.41 //x2=68.09 //y2=7.585
r1491 (  767 1093 ) resistor r=33.1979 //w=0.187 //l=0.485 //layer=li \
 //thickness=0.1 //x=68.09 //y=7.41 //x2=68.09 //y2=6.925
r1492 (  764 1009 ) resistor r=2.87058 //w=0.35 //l=0.085 //layer=li \
 //thickness=0.1 //x=67.295 //y=7.585 //x2=67.21 //y2=7.585
r1493 (  764 766 ) resistor r=18.6594 //w=0.367 //l=0.535 //layer=li \
 //thickness=0.1 //x=67.295 //y=7.585 //x2=67.83 //y2=7.585
r1494 (  763 1010 ) resistor r=2.87058 //w=0.35 //l=0.085 //layer=li \
 //thickness=0.1 //x=68.005 //y=7.585 //x2=68.09 //y2=7.585
r1495 (  763 766 ) resistor r=6.10354 //w=0.367 //l=0.175 //layer=li \
 //thickness=0.1 //x=68.005 //y=7.585 //x2=67.83 //y2=7.585
r1496 (  757 1009 ) resistor r=4.23183 //w=0.7 //l=0.175 //layer=li \
 //thickness=0.1 //x=67.21 //y=7.41 //x2=67.21 //y2=7.585
r1497 (  757 1092 ) resistor r=33.1979 //w=0.187 //l=0.485 //layer=li \
 //thickness=0.1 //x=67.21 //y=7.41 //x2=67.21 //y2=6.925
r1498 (  754 1008 ) resistor r=2.87058 //w=0.35 //l=0.085 //layer=li \
 //thickness=0.1 //x=66.415 //y=7.585 //x2=66.33 //y2=7.585
r1499 (  754 756 ) resistor r=10.6376 //w=0.367 //l=0.305 //layer=li \
 //thickness=0.1 //x=66.415 //y=7.585 //x2=66.72 //y2=7.585
r1500 (  753 1009 ) resistor r=2.87058 //w=0.35 //l=0.085 //layer=li \
 //thickness=0.1 //x=67.125 //y=7.585 //x2=67.21 //y2=7.585
r1501 (  753 756 ) resistor r=14.1253 //w=0.367 //l=0.405 //layer=li \
 //thickness=0.1 //x=67.125 //y=7.585 //x2=66.72 //y2=7.585
r1502 (  747 1008 ) resistor r=4.23183 //w=0.7 //l=0.175 //layer=li \
 //thickness=0.1 //x=66.33 //y=7.41 //x2=66.33 //y2=7.585
r1503 (  747 1091 ) resistor r=56.4706 //w=0.187 //l=0.825 //layer=li \
 //thickness=0.1 //x=66.33 //y=7.41 //x2=66.33 //y2=6.585
r1504 (  744 1007 ) resistor r=5.29055 //w=0.35 //l=0.17 //layer=li \
 //thickness=0.1 //x=65.41 //y=7.585 //x2=65.24 //y2=7.585
r1505 (  744 746 ) resistor r=6.97548 //w=0.367 //l=0.2 //layer=li \
 //thickness=0.1 //x=65.41 //y=7.585 //x2=65.61 //y2=7.585
r1506 (  743 1008 ) resistor r=2.87058 //w=0.35 //l=0.085 //layer=li \
 //thickness=0.1 //x=66.245 //y=7.585 //x2=66.33 //y2=7.585
r1507 (  743 746 ) resistor r=22.1471 //w=0.367 //l=0.635 //layer=li \
 //thickness=0.1 //x=66.245 //y=7.585 //x2=65.61 //y2=7.585
r1508 (  740 1006 ) resistor r=2.87058 //w=0.35 //l=0.085 //layer=li \
 //thickness=0.1 //x=64.545 //y=7.585 //x2=64.46 //y2=7.585
r1509 (  739 1007 ) resistor r=5.29055 //w=0.35 //l=0.17 //layer=li \
 //thickness=0.1 //x=65.07 //y=7.585 //x2=65.24 //y2=7.585
r1510 (  739 740 ) resistor r=18.3106 //w=0.367 //l=0.525 //layer=li \
 //thickness=0.1 //x=65.07 //y=7.585 //x2=64.545 //y2=7.585
r1511 (  733 1006 ) resistor r=4.23183 //w=0.7 //l=0.175 //layer=li \
 //thickness=0.1 //x=64.46 //y=7.41 //x2=64.46 //y2=7.585
r1512 (  733 1090 ) resistor r=33.1979 //w=0.187 //l=0.485 //layer=li \
 //thickness=0.1 //x=64.46 //y=7.41 //x2=64.46 //y2=6.925
r1513 (  730 1005 ) resistor r=2.87058 //w=0.35 //l=0.085 //layer=li \
 //thickness=0.1 //x=63.665 //y=7.585 //x2=63.58 //y2=7.585
r1514 (  730 732 ) resistor r=16.218 //w=0.367 //l=0.465 //layer=li \
 //thickness=0.1 //x=63.665 //y=7.585 //x2=64.13 //y2=7.585
r1515 (  729 1006 ) resistor r=2.87058 //w=0.35 //l=0.085 //layer=li \
 //thickness=0.1 //x=64.375 //y=7.585 //x2=64.46 //y2=7.585
r1516 (  729 732 ) resistor r=8.54496 //w=0.367 //l=0.245 //layer=li \
 //thickness=0.1 //x=64.375 //y=7.585 //x2=64.13 //y2=7.585
r1517 (  723 1005 ) resistor r=4.23183 //w=0.7 //l=0.175 //layer=li \
 //thickness=0.1 //x=63.58 //y=7.41 //x2=63.58 //y2=7.585
r1518 (  723 1089 ) resistor r=33.1979 //w=0.187 //l=0.485 //layer=li \
 //thickness=0.1 //x=63.58 //y=7.41 //x2=63.58 //y2=6.925
r1519 (  720 1004 ) resistor r=2.87058 //w=0.35 //l=0.085 //layer=li \
 //thickness=0.1 //x=62.785 //y=7.585 //x2=62.7 //y2=7.585
r1520 (  720 722 ) resistor r=8.19619 //w=0.367 //l=0.235 //layer=li \
 //thickness=0.1 //x=62.785 //y=7.585 //x2=63.02 //y2=7.585
r1521 (  719 1005 ) resistor r=2.87058 //w=0.35 //l=0.085 //layer=li \
 //thickness=0.1 //x=63.495 //y=7.585 //x2=63.58 //y2=7.585
r1522 (  719 722 ) resistor r=16.5668 //w=0.367 //l=0.475 //layer=li \
 //thickness=0.1 //x=63.495 //y=7.585 //x2=63.02 //y2=7.585
r1523 (  713 1004 ) resistor r=4.23183 //w=0.7 //l=0.175 //layer=li \
 //thickness=0.1 //x=62.7 //y=7.41 //x2=62.7 //y2=7.585
r1524 (  713 1088 ) resistor r=56.4706 //w=0.187 //l=0.825 //layer=li \
 //thickness=0.1 //x=62.7 //y=7.41 //x2=62.7 //y2=6.585
r1525 (  712 1003 ) resistor r=5.29055 //w=0.35 //l=0.17 //layer=li \
 //thickness=0.1 //x=62.08 //y=7.585 //x2=61.91 //y2=7.585
r1526 (  711 1004 ) resistor r=2.87058 //w=0.35 //l=0.085 //layer=li \
 //thickness=0.1 //x=62.615 //y=7.585 //x2=62.7 //y2=7.585
r1527 (  711 712 ) resistor r=18.6594 //w=0.367 //l=0.535 //layer=li \
 //thickness=0.1 //x=62.615 //y=7.585 //x2=62.08 //y2=7.585
r1528 (  706 1002 ) resistor r=2.87058 //w=0.35 //l=0.085 //layer=li \
 //thickness=0.1 //x=60.915 //y=7.585 //x2=60.83 //y2=7.585
r1529 (  706 708 ) resistor r=21.7984 //w=0.367 //l=0.625 //layer=li \
 //thickness=0.1 //x=60.915 //y=7.585 //x2=61.54 //y2=7.585
r1530 (  705 1003 ) resistor r=5.29055 //w=0.35 //l=0.17 //layer=li \
 //thickness=0.1 //x=61.74 //y=7.585 //x2=61.91 //y2=7.585
r1531 (  705 708 ) resistor r=6.97548 //w=0.367 //l=0.2 //layer=li \
 //thickness=0.1 //x=61.74 //y=7.585 //x2=61.54 //y2=7.585
r1532 (  699 1002 ) resistor r=4.23183 //w=0.7 //l=0.175 //layer=li \
 //thickness=0.1 //x=60.83 //y=7.41 //x2=60.83 //y2=7.585
r1533 (  699 1087 ) resistor r=33.1979 //w=0.187 //l=0.485 //layer=li \
 //thickness=0.1 //x=60.83 //y=7.41 //x2=60.83 //y2=6.925
r1534 (  696 1001 ) resistor r=2.87058 //w=0.35 //l=0.085 //layer=li \
 //thickness=0.1 //x=60.035 //y=7.585 //x2=59.95 //y2=7.585
r1535 (  696 698 ) resistor r=13.7766 //w=0.367 //l=0.395 //layer=li \
 //thickness=0.1 //x=60.035 //y=7.585 //x2=60.43 //y2=7.585
r1536 (  695 1002 ) resistor r=2.87058 //w=0.35 //l=0.085 //layer=li \
 //thickness=0.1 //x=60.745 //y=7.585 //x2=60.83 //y2=7.585
r1537 (  695 698 ) resistor r=10.9864 //w=0.367 //l=0.315 //layer=li \
 //thickness=0.1 //x=60.745 //y=7.585 //x2=60.43 //y2=7.585
r1538 (  689 1001 ) resistor r=4.23183 //w=0.7 //l=0.175 //layer=li \
 //thickness=0.1 //x=59.95 //y=7.41 //x2=59.95 //y2=7.585
r1539 (  689 1086 ) resistor r=33.1979 //w=0.187 //l=0.485 //layer=li \
 //thickness=0.1 //x=59.95 //y=7.41 //x2=59.95 //y2=6.925
r1540 (  686 1000 ) resistor r=2.87058 //w=0.35 //l=0.085 //layer=li \
 //thickness=0.1 //x=59.155 //y=7.585 //x2=59.07 //y2=7.585
r1541 (  686 688 ) resistor r=5.75477 //w=0.367 //l=0.165 //layer=li \
 //thickness=0.1 //x=59.155 //y=7.585 //x2=59.32 //y2=7.585
r1542 (  685 1001 ) resistor r=2.87058 //w=0.35 //l=0.085 //layer=li \
 //thickness=0.1 //x=59.865 //y=7.585 //x2=59.95 //y2=7.585
r1543 (  685 688 ) resistor r=19.0082 //w=0.367 //l=0.545 //layer=li \
 //thickness=0.1 //x=59.865 //y=7.585 //x2=59.32 //y2=7.585
r1544 (  679 1000 ) resistor r=4.23183 //w=0.7 //l=0.175 //layer=li \
 //thickness=0.1 //x=59.07 //y=7.41 //x2=59.07 //y2=7.585
r1545 (  679 1085 ) resistor r=33.1979 //w=0.187 //l=0.485 //layer=li \
 //thickness=0.1 //x=59.07 //y=7.41 //x2=59.07 //y2=6.925
r1546 (  678 999 ) resistor r=2.87058 //w=0.35 //l=0.085 //layer=li \
 //thickness=0.1 //x=58.275 //y=7.585 //x2=58.19 //y2=7.585
r1547 (  677 1000 ) resistor r=2.87058 //w=0.35 //l=0.085 //layer=li \
 //thickness=0.1 //x=58.985 //y=7.585 //x2=59.07 //y2=7.585
r1548 (  677 678 ) resistor r=24.7629 //w=0.367 //l=0.71 //layer=li \
 //thickness=0.1 //x=58.985 //y=7.585 //x2=58.275 //y2=7.585
r1549 (  671 999 ) resistor r=4.23183 //w=0.7 //l=0.175 //layer=li \
 //thickness=0.1 //x=58.19 //y=7.41 //x2=58.19 //y2=7.585
r1550 (  671 1084 ) resistor r=56.4706 //w=0.187 //l=0.825 //layer=li \
 //thickness=0.1 //x=58.19 //y=7.41 //x2=58.19 //y2=6.585
r1551 (  670 997 ) resistor r=5.29055 //w=0.35 //l=0.17 //layer=li \
 //thickness=0.1 //x=57.27 //y=7.585 //x2=57.1 //y2=7.585
r1552 (  669 999 ) resistor r=2.87058 //w=0.35 //l=0.085 //layer=li \
 //thickness=0.1 //x=58.105 //y=7.585 //x2=58.19 //y2=7.585
r1553 (  669 670 ) resistor r=29.1226 //w=0.367 //l=0.835 //layer=li \
 //thickness=0.1 //x=58.105 //y=7.585 //x2=57.27 //y2=7.585
r1554 (  664 996 ) resistor r=2.87058 //w=0.35 //l=0.085 //layer=li \
 //thickness=0.1 //x=56.105 //y=7.585 //x2=56.02 //y2=7.585
r1555 (  664 666 ) resistor r=21.7984 //w=0.367 //l=0.625 //layer=li \
 //thickness=0.1 //x=56.105 //y=7.585 //x2=56.73 //y2=7.585
r1556 (  663 997 ) resistor r=5.29055 //w=0.35 //l=0.17 //layer=li \
 //thickness=0.1 //x=56.93 //y=7.585 //x2=57.1 //y2=7.585
r1557 (  663 666 ) resistor r=6.97548 //w=0.367 //l=0.2 //layer=li \
 //thickness=0.1 //x=56.93 //y=7.585 //x2=56.73 //y2=7.585
r1558 (  657 996 ) resistor r=4.23183 //w=0.7 //l=0.175 //layer=li \
 //thickness=0.1 //x=56.02 //y=7.41 //x2=56.02 //y2=7.585
r1559 (  657 1083 ) resistor r=33.1979 //w=0.187 //l=0.485 //layer=li \
 //thickness=0.1 //x=56.02 //y=7.41 //x2=56.02 //y2=6.925
r1560 (  654 995 ) resistor r=2.87058 //w=0.35 //l=0.085 //layer=li \
 //thickness=0.1 //x=55.225 //y=7.585 //x2=55.14 //y2=7.585
r1561 (  654 656 ) resistor r=13.7766 //w=0.367 //l=0.395 //layer=li \
 //thickness=0.1 //x=55.225 //y=7.585 //x2=55.62 //y2=7.585
r1562 (  653 996 ) resistor r=2.87058 //w=0.35 //l=0.085 //layer=li \
 //thickness=0.1 //x=55.935 //y=7.585 //x2=56.02 //y2=7.585
r1563 (  653 656 ) resistor r=10.9864 //w=0.367 //l=0.315 //layer=li \
 //thickness=0.1 //x=55.935 //y=7.585 //x2=55.62 //y2=7.585
r1564 (  647 995 ) resistor r=4.23183 //w=0.7 //l=0.175 //layer=li \
 //thickness=0.1 //x=55.14 //y=7.41 //x2=55.14 //y2=7.585
r1565 (  647 1082 ) resistor r=33.1979 //w=0.187 //l=0.485 //layer=li \
 //thickness=0.1 //x=55.14 //y=7.41 //x2=55.14 //y2=6.925
r1566 (  644 994 ) resistor r=2.87058 //w=0.35 //l=0.085 //layer=li \
 //thickness=0.1 //x=54.345 //y=7.585 //x2=54.26 //y2=7.585
r1567 (  644 646 ) resistor r=5.75477 //w=0.367 //l=0.165 //layer=li \
 //thickness=0.1 //x=54.345 //y=7.585 //x2=54.51 //y2=7.585
r1568 (  643 995 ) resistor r=2.87058 //w=0.35 //l=0.085 //layer=li \
 //thickness=0.1 //x=55.055 //y=7.585 //x2=55.14 //y2=7.585
r1569 (  643 646 ) resistor r=19.0082 //w=0.367 //l=0.545 //layer=li \
 //thickness=0.1 //x=55.055 //y=7.585 //x2=54.51 //y2=7.585
r1570 (  637 994 ) resistor r=4.23183 //w=0.7 //l=0.175 //layer=li \
 //thickness=0.1 //x=54.26 //y=7.41 //x2=54.26 //y2=7.585
r1571 (  637 1081 ) resistor r=33.1979 //w=0.187 //l=0.485 //layer=li \
 //thickness=0.1 //x=54.26 //y=7.41 //x2=54.26 //y2=6.925
r1572 (  636 993 ) resistor r=2.87058 //w=0.35 //l=0.085 //layer=li \
 //thickness=0.1 //x=53.465 //y=7.585 //x2=53.38 //y2=7.585
r1573 (  635 994 ) resistor r=2.87058 //w=0.35 //l=0.085 //layer=li \
 //thickness=0.1 //x=54.175 //y=7.585 //x2=54.26 //y2=7.585
r1574 (  635 636 ) resistor r=24.7629 //w=0.367 //l=0.71 //layer=li \
 //thickness=0.1 //x=54.175 //y=7.585 //x2=53.465 //y2=7.585
r1575 (  629 993 ) resistor r=4.23183 //w=0.7 //l=0.175 //layer=li \
 //thickness=0.1 //x=53.38 //y=7.41 //x2=53.38 //y2=7.585
r1576 (  629 1080 ) resistor r=56.4706 //w=0.187 //l=0.825 //layer=li \
 //thickness=0.1 //x=53.38 //y=7.41 //x2=53.38 //y2=6.585
r1577 (  628 991 ) resistor r=5.29055 //w=0.35 //l=0.17 //layer=li \
 //thickness=0.1 //x=52.46 //y=7.585 //x2=52.29 //y2=7.585
r1578 (  627 993 ) resistor r=2.87058 //w=0.35 //l=0.085 //layer=li \
 //thickness=0.1 //x=53.295 //y=7.585 //x2=53.38 //y2=7.585
r1579 (  627 628 ) resistor r=29.1226 //w=0.367 //l=0.835 //layer=li \
 //thickness=0.1 //x=53.295 //y=7.585 //x2=52.46 //y2=7.585
r1580 (  622 990 ) resistor r=2.87058 //w=0.35 //l=0.085 //layer=li \
 //thickness=0.1 //x=51.595 //y=7.585 //x2=51.51 //y2=7.585
r1581 (  622 624 ) resistor r=11.3351 //w=0.367 //l=0.325 //layer=li \
 //thickness=0.1 //x=51.595 //y=7.585 //x2=51.92 //y2=7.585
r1582 (  621 991 ) resistor r=5.29055 //w=0.35 //l=0.17 //layer=li \
 //thickness=0.1 //x=52.12 //y=7.585 //x2=52.29 //y2=7.585
r1583 (  621 624 ) resistor r=6.97548 //w=0.367 //l=0.2 //layer=li \
 //thickness=0.1 //x=52.12 //y=7.585 //x2=51.92 //y2=7.585
r1584 (  615 990 ) resistor r=4.23183 //w=0.7 //l=0.175 //layer=li \
 //thickness=0.1 //x=51.51 //y=7.41 //x2=51.51 //y2=7.585
r1585 (  615 1079 ) resistor r=33.1979 //w=0.187 //l=0.485 //layer=li \
 //thickness=0.1 //x=51.51 //y=7.41 //x2=51.51 //y2=6.925
r1586 (  612 989 ) resistor r=2.87058 //w=0.35 //l=0.085 //layer=li \
 //thickness=0.1 //x=50.715 //y=7.585 //x2=50.63 //y2=7.585
r1587 (  612 614 ) resistor r=3.31335 //w=0.367 //l=0.095 //layer=li \
 //thickness=0.1 //x=50.715 //y=7.585 //x2=50.81 //y2=7.585
r1588 (  611 990 ) resistor r=2.87058 //w=0.35 //l=0.085 //layer=li \
 //thickness=0.1 //x=51.425 //y=7.585 //x2=51.51 //y2=7.585
r1589 (  611 614 ) resistor r=21.4496 //w=0.367 //l=0.615 //layer=li \
 //thickness=0.1 //x=51.425 //y=7.585 //x2=50.81 //y2=7.585
r1590 (  605 989 ) resistor r=4.23183 //w=0.7 //l=0.175 //layer=li \
 //thickness=0.1 //x=50.63 //y=7.41 //x2=50.63 //y2=7.585
r1591 (  605 1078 ) resistor r=33.1979 //w=0.187 //l=0.485 //layer=li \
 //thickness=0.1 //x=50.63 //y=7.41 //x2=50.63 //y2=6.925
r1592 (  604 988 ) resistor r=2.87058 //w=0.35 //l=0.085 //layer=li \
 //thickness=0.1 //x=49.835 //y=7.585 //x2=49.75 //y2=7.585
r1593 (  603 989 ) resistor r=2.87058 //w=0.35 //l=0.085 //layer=li \
 //thickness=0.1 //x=50.545 //y=7.585 //x2=50.63 //y2=7.585
r1594 (  603 604 ) resistor r=24.7629 //w=0.367 //l=0.71 //layer=li \
 //thickness=0.1 //x=50.545 //y=7.585 //x2=49.835 //y2=7.585
r1595 (  597 988 ) resistor r=4.23183 //w=0.7 //l=0.175 //layer=li \
 //thickness=0.1 //x=49.75 //y=7.41 //x2=49.75 //y2=7.585
r1596 (  597 1077 ) resistor r=56.4706 //w=0.187 //l=0.825 //layer=li \
 //thickness=0.1 //x=49.75 //y=7.41 //x2=49.75 //y2=6.585
r1597 (  596 986 ) resistor r=5.29055 //w=0.35 //l=0.17 //layer=li \
 //thickness=0.1 //x=49.13 //y=7.585 //x2=48.96 //y2=7.585
r1598 (  595 988 ) resistor r=2.87058 //w=0.35 //l=0.085 //layer=li \
 //thickness=0.1 //x=49.665 //y=7.585 //x2=49.75 //y2=7.585
r1599 (  595 596 ) resistor r=18.6594 //w=0.367 //l=0.535 //layer=li \
 //thickness=0.1 //x=49.665 //y=7.585 //x2=49.13 //y2=7.585
r1600 (  590 985 ) resistor r=2.87058 //w=0.35 //l=0.085 //layer=li \
 //thickness=0.1 //x=47.965 //y=7.585 //x2=47.88 //y2=7.585
r1601 (  590 592 ) resistor r=8.89373 //w=0.367 //l=0.255 //layer=li \
 //thickness=0.1 //x=47.965 //y=7.585 //x2=48.22 //y2=7.585
r1602 (  589 986 ) resistor r=5.29055 //w=0.35 //l=0.17 //layer=li \
 //thickness=0.1 //x=48.79 //y=7.585 //x2=48.96 //y2=7.585
r1603 (  589 592 ) resistor r=19.8801 //w=0.367 //l=0.57 //layer=li \
 //thickness=0.1 //x=48.79 //y=7.585 //x2=48.22 //y2=7.585
r1604 (  583 985 ) resistor r=4.23183 //w=0.7 //l=0.175 //layer=li \
 //thickness=0.1 //x=47.88 //y=7.41 //x2=47.88 //y2=7.585
r1605 (  583 1076 ) resistor r=33.1979 //w=0.187 //l=0.485 //layer=li \
 //thickness=0.1 //x=47.88 //y=7.41 //x2=47.88 //y2=6.925
r1606 (  580 984 ) resistor r=2.87058 //w=0.35 //l=0.085 //layer=li \
 //thickness=0.1 //x=47.085 //y=7.585 //x2=47 //y2=7.585
r1607 (  580 582 ) resistor r=0.871935 //w=0.367 //l=0.025 //layer=li \
 //thickness=0.1 //x=47.085 //y=7.585 //x2=47.11 //y2=7.585
r1608 (  579 985 ) resistor r=2.87058 //w=0.35 //l=0.085 //layer=li \
 //thickness=0.1 //x=47.795 //y=7.585 //x2=47.88 //y2=7.585
r1609 (  579 582 ) resistor r=23.891 //w=0.367 //l=0.685 //layer=li \
 //thickness=0.1 //x=47.795 //y=7.585 //x2=47.11 //y2=7.585
r1610 (  573 984 ) resistor r=4.23183 //w=0.7 //l=0.175 //layer=li \
 //thickness=0.1 //x=47 //y=7.41 //x2=47 //y2=7.585
r1611 (  573 1075 ) resistor r=33.1979 //w=0.187 //l=0.485 //layer=li \
 //thickness=0.1 //x=47 //y=7.41 //x2=47 //y2=6.925
r1612 (  572 983 ) resistor r=2.87058 //w=0.35 //l=0.085 //layer=li \
 //thickness=0.1 //x=46.205 //y=7.585 //x2=46.12 //y2=7.585
r1613 (  571 984 ) resistor r=2.87058 //w=0.35 //l=0.085 //layer=li \
 //thickness=0.1 //x=46.915 //y=7.585 //x2=47 //y2=7.585
r1614 (  571 572 ) resistor r=24.7629 //w=0.367 //l=0.71 //layer=li \
 //thickness=0.1 //x=46.915 //y=7.585 //x2=46.205 //y2=7.585
r1615 (  565 983 ) resistor r=4.23183 //w=0.7 //l=0.175 //layer=li \
 //thickness=0.1 //x=46.12 //y=7.41 //x2=46.12 //y2=7.585
r1616 (  565 1074 ) resistor r=33.1979 //w=0.187 //l=0.485 //layer=li \
 //thickness=0.1 //x=46.12 //y=7.41 //x2=46.12 //y2=6.925
r1617 (  562 982 ) resistor r=2.87058 //w=0.35 //l=0.085 //layer=li \
 //thickness=0.1 //x=45.325 //y=7.585 //x2=45.24 //y2=7.585
r1618 (  562 564 ) resistor r=23.5422 //w=0.367 //l=0.675 //layer=li \
 //thickness=0.1 //x=45.325 //y=7.585 //x2=46 //y2=7.585
r1619 (  561 983 ) resistor r=2.87058 //w=0.35 //l=0.085 //layer=li \
 //thickness=0.1 //x=46.035 //y=7.585 //x2=46.12 //y2=7.585
r1620 (  561 564 ) resistor r=1.22071 //w=0.367 //l=0.035 //layer=li \
 //thickness=0.1 //x=46.035 //y=7.585 //x2=46 //y2=7.585
r1621 (  555 982 ) resistor r=4.23183 //w=0.7 //l=0.175 //layer=li \
 //thickness=0.1 //x=45.24 //y=7.41 //x2=45.24 //y2=7.585
r1622 (  555 1073 ) resistor r=56.4706 //w=0.187 //l=0.825 //layer=li \
 //thickness=0.1 //x=45.24 //y=7.41 //x2=45.24 //y2=6.585
r1623 (  552 981 ) resistor r=5.29055 //w=0.35 //l=0.17 //layer=li \
 //thickness=0.1 //x=44.32 //y=7.585 //x2=44.15 //y2=7.585
r1624 (  552 554 ) resistor r=19.8801 //w=0.367 //l=0.57 //layer=li \
 //thickness=0.1 //x=44.32 //y=7.585 //x2=44.89 //y2=7.585
r1625 (  551 982 ) resistor r=2.87058 //w=0.35 //l=0.085 //layer=li \
 //thickness=0.1 //x=45.155 //y=7.585 //x2=45.24 //y2=7.585
r1626 (  551 554 ) resistor r=9.24251 //w=0.367 //l=0.265 //layer=li \
 //thickness=0.1 //x=45.155 //y=7.585 //x2=44.89 //y2=7.585
r1627 (  546 980 ) resistor r=2.87058 //w=0.35 //l=0.085 //layer=li \
 //thickness=0.1 //x=43.155 //y=7.585 //x2=43.07 //y2=7.585
r1628 (  546 548 ) resistor r=8.89373 //w=0.367 //l=0.255 //layer=li \
 //thickness=0.1 //x=43.155 //y=7.585 //x2=43.41 //y2=7.585
r1629 (  545 981 ) resistor r=5.29055 //w=0.35 //l=0.17 //layer=li \
 //thickness=0.1 //x=43.98 //y=7.585 //x2=44.15 //y2=7.585
r1630 (  545 548 ) resistor r=19.8801 //w=0.367 //l=0.57 //layer=li \
 //thickness=0.1 //x=43.98 //y=7.585 //x2=43.41 //y2=7.585
r1631 (  539 980 ) resistor r=4.23183 //w=0.7 //l=0.175 //layer=li \
 //thickness=0.1 //x=43.07 //y=7.41 //x2=43.07 //y2=7.585
r1632 (  539 1072 ) resistor r=33.1979 //w=0.187 //l=0.485 //layer=li \
 //thickness=0.1 //x=43.07 //y=7.41 //x2=43.07 //y2=6.925
r1633 (  536 979 ) resistor r=2.87058 //w=0.35 //l=0.085 //layer=li \
 //thickness=0.1 //x=42.275 //y=7.585 //x2=42.19 //y2=7.585
r1634 (  536 538 ) resistor r=0.871935 //w=0.367 //l=0.025 //layer=li \
 //thickness=0.1 //x=42.275 //y=7.585 //x2=42.3 //y2=7.585
r1635 (  535 980 ) resistor r=2.87058 //w=0.35 //l=0.085 //layer=li \
 //thickness=0.1 //x=42.985 //y=7.585 //x2=43.07 //y2=7.585
r1636 (  535 538 ) resistor r=23.891 //w=0.367 //l=0.685 //layer=li \
 //thickness=0.1 //x=42.985 //y=7.585 //x2=42.3 //y2=7.585
r1637 (  529 979 ) resistor r=4.23183 //w=0.7 //l=0.175 //layer=li \
 //thickness=0.1 //x=42.19 //y=7.41 //x2=42.19 //y2=7.585
r1638 (  529 1071 ) resistor r=33.1979 //w=0.187 //l=0.485 //layer=li \
 //thickness=0.1 //x=42.19 //y=7.41 //x2=42.19 //y2=6.925
r1639 (  528 978 ) resistor r=2.87058 //w=0.35 //l=0.085 //layer=li \
 //thickness=0.1 //x=41.395 //y=7.585 //x2=41.31 //y2=7.585
r1640 (  527 979 ) resistor r=2.87058 //w=0.35 //l=0.085 //layer=li \
 //thickness=0.1 //x=42.105 //y=7.585 //x2=42.19 //y2=7.585
r1641 (  527 528 ) resistor r=24.7629 //w=0.367 //l=0.71 //layer=li \
 //thickness=0.1 //x=42.105 //y=7.585 //x2=41.395 //y2=7.585
r1642 (  521 978 ) resistor r=4.23183 //w=0.7 //l=0.175 //layer=li \
 //thickness=0.1 //x=41.31 //y=7.41 //x2=41.31 //y2=7.585
r1643 (  521 1070 ) resistor r=33.1979 //w=0.187 //l=0.485 //layer=li \
 //thickness=0.1 //x=41.31 //y=7.41 //x2=41.31 //y2=6.925
r1644 (  518 977 ) resistor r=2.87058 //w=0.35 //l=0.085 //layer=li \
 //thickness=0.1 //x=40.515 //y=7.585 //x2=40.43 //y2=7.585
r1645 (  518 520 ) resistor r=23.5422 //w=0.367 //l=0.675 //layer=li \
 //thickness=0.1 //x=40.515 //y=7.585 //x2=41.19 //y2=7.585
r1646 (  517 978 ) resistor r=2.87058 //w=0.35 //l=0.085 //layer=li \
 //thickness=0.1 //x=41.225 //y=7.585 //x2=41.31 //y2=7.585
r1647 (  517 520 ) resistor r=1.22071 //w=0.367 //l=0.035 //layer=li \
 //thickness=0.1 //x=41.225 //y=7.585 //x2=41.19 //y2=7.585
r1648 (  511 977 ) resistor r=4.23183 //w=0.7 //l=0.175 //layer=li \
 //thickness=0.1 //x=40.43 //y=7.41 //x2=40.43 //y2=7.585
r1649 (  511 1069 ) resistor r=56.4706 //w=0.187 //l=0.825 //layer=li \
 //thickness=0.1 //x=40.43 //y=7.41 //x2=40.43 //y2=6.585
r1650 (  508 976 ) resistor r=5.29055 //w=0.35 //l=0.17 //layer=li \
 //thickness=0.1 //x=39.51 //y=7.585 //x2=39.34 //y2=7.585
r1651 (  508 510 ) resistor r=19.8801 //w=0.367 //l=0.57 //layer=li \
 //thickness=0.1 //x=39.51 //y=7.585 //x2=40.08 //y2=7.585
r1652 (  507 977 ) resistor r=2.87058 //w=0.35 //l=0.085 //layer=li \
 //thickness=0.1 //x=40.345 //y=7.585 //x2=40.43 //y2=7.585
r1653 (  507 510 ) resistor r=9.24251 //w=0.367 //l=0.265 //layer=li \
 //thickness=0.1 //x=40.345 //y=7.585 //x2=40.08 //y2=7.585
r1654 (  504 975 ) resistor r=2.87058 //w=0.35 //l=0.085 //layer=li \
 //thickness=0.1 //x=38.645 //y=7.585 //x2=38.56 //y2=7.585
r1655 (  503 976 ) resistor r=5.29055 //w=0.35 //l=0.17 //layer=li \
 //thickness=0.1 //x=39.17 //y=7.585 //x2=39.34 //y2=7.585
r1656 (  503 504 ) resistor r=18.3106 //w=0.367 //l=0.525 //layer=li \
 //thickness=0.1 //x=39.17 //y=7.585 //x2=38.645 //y2=7.585
r1657 (  497 975 ) resistor r=4.23183 //w=0.7 //l=0.175 //layer=li \
 //thickness=0.1 //x=38.56 //y=7.41 //x2=38.56 //y2=7.585
r1658 (  497 1068 ) resistor r=33.1979 //w=0.187 //l=0.485 //layer=li \
 //thickness=0.1 //x=38.56 //y=7.41 //x2=38.56 //y2=6.925
r1659 (  496 973 ) resistor r=2.87058 //w=0.35 //l=0.085 //layer=li \
 //thickness=0.1 //x=37.765 //y=7.585 //x2=37.68 //y2=7.585
r1660 (  495 975 ) resistor r=2.87058 //w=0.35 //l=0.085 //layer=li \
 //thickness=0.1 //x=38.475 //y=7.585 //x2=38.56 //y2=7.585
r1661 (  495 496 ) resistor r=24.7629 //w=0.367 //l=0.71 //layer=li \
 //thickness=0.1 //x=38.475 //y=7.585 //x2=37.765 //y2=7.585
r1662 (  489 973 ) resistor r=4.23183 //w=0.7 //l=0.175 //layer=li \
 //thickness=0.1 //x=37.68 //y=7.41 //x2=37.68 //y2=7.585
r1663 (  489 1067 ) resistor r=33.1979 //w=0.187 //l=0.485 //layer=li \
 //thickness=0.1 //x=37.68 //y=7.41 //x2=37.68 //y2=6.925
r1664 (  486 972 ) resistor r=2.87058 //w=0.35 //l=0.085 //layer=li \
 //thickness=0.1 //x=36.885 //y=7.585 //x2=36.8 //y2=7.585
r1665 (  486 488 ) resistor r=21.1008 //w=0.367 //l=0.605 //layer=li \
 //thickness=0.1 //x=36.885 //y=7.585 //x2=37.49 //y2=7.585
r1666 (  485 973 ) resistor r=2.87058 //w=0.35 //l=0.085 //layer=li \
 //thickness=0.1 //x=37.595 //y=7.585 //x2=37.68 //y2=7.585
r1667 (  485 488 ) resistor r=3.66213 //w=0.367 //l=0.105 //layer=li \
 //thickness=0.1 //x=37.595 //y=7.585 //x2=37.49 //y2=7.585
r1668 (  479 972 ) resistor r=4.23183 //w=0.7 //l=0.175 //layer=li \
 //thickness=0.1 //x=36.8 //y=7.41 //x2=36.8 //y2=7.585
r1669 (  479 1066 ) resistor r=56.4706 //w=0.187 //l=0.825 //layer=li \
 //thickness=0.1 //x=36.8 //y=7.41 //x2=36.8 //y2=6.585
r1670 (  476 971 ) resistor r=5.29055 //w=0.35 //l=0.17 //layer=li \
 //thickness=0.1 //x=36.18 //y=7.585 //x2=36.01 //y2=7.585
r1671 (  476 478 ) resistor r=6.97548 //w=0.367 //l=0.2 //layer=li \
 //thickness=0.1 //x=36.18 //y=7.585 //x2=36.38 //y2=7.585
r1672 (  475 972 ) resistor r=2.87058 //w=0.35 //l=0.085 //layer=li \
 //thickness=0.1 //x=36.715 //y=7.585 //x2=36.8 //y2=7.585
r1673 (  475 478 ) resistor r=11.6839 //w=0.367 //l=0.335 //layer=li \
 //thickness=0.1 //x=36.715 //y=7.585 //x2=36.38 //y2=7.585
r1674 (  472 970 ) resistor r=2.87058 //w=0.35 //l=0.085 //layer=li \
 //thickness=0.1 //x=35.015 //y=7.585 //x2=34.93 //y2=7.585
r1675 (  471 971 ) resistor r=5.29055 //w=0.35 //l=0.17 //layer=li \
 //thickness=0.1 //x=35.84 //y=7.585 //x2=36.01 //y2=7.585
r1676 (  471 472 ) resistor r=28.7738 //w=0.367 //l=0.825 //layer=li \
 //thickness=0.1 //x=35.84 //y=7.585 //x2=35.015 //y2=7.585
r1677 (  465 970 ) resistor r=4.23183 //w=0.7 //l=0.175 //layer=li \
 //thickness=0.1 //x=34.93 //y=7.41 //x2=34.93 //y2=7.585
r1678 (  465 1065 ) resistor r=33.1979 //w=0.187 //l=0.485 //layer=li \
 //thickness=0.1 //x=34.93 //y=7.41 //x2=34.93 //y2=6.925
r1679 (  464 968 ) resistor r=2.87058 //w=0.35 //l=0.085 //layer=li \
 //thickness=0.1 //x=34.135 //y=7.585 //x2=34.05 //y2=7.585
r1680 (  463 970 ) resistor r=2.87058 //w=0.35 //l=0.085 //layer=li \
 //thickness=0.1 //x=34.845 //y=7.585 //x2=34.93 //y2=7.585
r1681 (  463 464 ) resistor r=24.7629 //w=0.367 //l=0.71 //layer=li \
 //thickness=0.1 //x=34.845 //y=7.585 //x2=34.135 //y2=7.585
r1682 (  457 968 ) resistor r=4.23183 //w=0.7 //l=0.175 //layer=li \
 //thickness=0.1 //x=34.05 //y=7.41 //x2=34.05 //y2=7.585
r1683 (  457 1064 ) resistor r=33.1979 //w=0.187 //l=0.485 //layer=li \
 //thickness=0.1 //x=34.05 //y=7.41 //x2=34.05 //y2=6.925
r1684 (  454 967 ) resistor r=2.87058 //w=0.35 //l=0.085 //layer=li \
 //thickness=0.1 //x=33.255 //y=7.585 //x2=33.17 //y2=7.585
r1685 (  454 456 ) resistor r=18.6594 //w=0.367 //l=0.535 //layer=li \
 //thickness=0.1 //x=33.255 //y=7.585 //x2=33.79 //y2=7.585
r1686 (  453 968 ) resistor r=2.87058 //w=0.35 //l=0.085 //layer=li \
 //thickness=0.1 //x=33.965 //y=7.585 //x2=34.05 //y2=7.585
r1687 (  453 456 ) resistor r=6.10354 //w=0.367 //l=0.175 //layer=li \
 //thickness=0.1 //x=33.965 //y=7.585 //x2=33.79 //y2=7.585
r1688 (  447 967 ) resistor r=4.23183 //w=0.7 //l=0.175 //layer=li \
 //thickness=0.1 //x=33.17 //y=7.41 //x2=33.17 //y2=7.585
r1689 (  447 1063 ) resistor r=33.1979 //w=0.187 //l=0.485 //layer=li \
 //thickness=0.1 //x=33.17 //y=7.41 //x2=33.17 //y2=6.925
r1690 (  444 966 ) resistor r=2.87058 //w=0.35 //l=0.085 //layer=li \
 //thickness=0.1 //x=32.375 //y=7.585 //x2=32.29 //y2=7.585
r1691 (  444 446 ) resistor r=10.6376 //w=0.367 //l=0.305 //layer=li \
 //thickness=0.1 //x=32.375 //y=7.585 //x2=32.68 //y2=7.585
r1692 (  443 967 ) resistor r=2.87058 //w=0.35 //l=0.085 //layer=li \
 //thickness=0.1 //x=33.085 //y=7.585 //x2=33.17 //y2=7.585
r1693 (  443 446 ) resistor r=14.1253 //w=0.367 //l=0.405 //layer=li \
 //thickness=0.1 //x=33.085 //y=7.585 //x2=32.68 //y2=7.585
r1694 (  437 966 ) resistor r=4.23183 //w=0.7 //l=0.175 //layer=li \
 //thickness=0.1 //x=32.29 //y=7.41 //x2=32.29 //y2=7.585
r1695 (  437 1062 ) resistor r=56.4706 //w=0.187 //l=0.825 //layer=li \
 //thickness=0.1 //x=32.29 //y=7.41 //x2=32.29 //y2=6.585
r1696 (  434 965 ) resistor r=5.29055 //w=0.35 //l=0.17 //layer=li \
 //thickness=0.1 //x=31.37 //y=7.585 //x2=31.2 //y2=7.585
r1697 (  434 436 ) resistor r=6.97548 //w=0.367 //l=0.2 //layer=li \
 //thickness=0.1 //x=31.37 //y=7.585 //x2=31.57 //y2=7.585
r1698 (  433 966 ) resistor r=2.87058 //w=0.35 //l=0.085 //layer=li \
 //thickness=0.1 //x=32.205 //y=7.585 //x2=32.29 //y2=7.585
r1699 (  433 436 ) resistor r=22.1471 //w=0.367 //l=0.635 //layer=li \
 //thickness=0.1 //x=32.205 //y=7.585 //x2=31.57 //y2=7.585
r1700 (  430 964 ) resistor r=2.87058 //w=0.35 //l=0.085 //layer=li \
 //thickness=0.1 //x=30.205 //y=7.585 //x2=30.12 //y2=7.585
r1701 (  429 965 ) resistor r=5.29055 //w=0.35 //l=0.17 //layer=li \
 //thickness=0.1 //x=31.03 //y=7.585 //x2=31.2 //y2=7.585
r1702 (  429 430 ) resistor r=28.7738 //w=0.367 //l=0.825 //layer=li \
 //thickness=0.1 //x=31.03 //y=7.585 //x2=30.205 //y2=7.585
r1703 (  423 964 ) resistor r=4.23183 //w=0.7 //l=0.175 //layer=li \
 //thickness=0.1 //x=30.12 //y=7.41 //x2=30.12 //y2=7.585
r1704 (  423 1061 ) resistor r=33.1979 //w=0.187 //l=0.485 //layer=li \
 //thickness=0.1 //x=30.12 //y=7.41 //x2=30.12 //y2=6.925
r1705 (  422 962 ) resistor r=2.87058 //w=0.35 //l=0.085 //layer=li \
 //thickness=0.1 //x=29.325 //y=7.585 //x2=29.24 //y2=7.585
r1706 (  421 964 ) resistor r=2.87058 //w=0.35 //l=0.085 //layer=li \
 //thickness=0.1 //x=30.035 //y=7.585 //x2=30.12 //y2=7.585
r1707 (  421 422 ) resistor r=24.7629 //w=0.367 //l=0.71 //layer=li \
 //thickness=0.1 //x=30.035 //y=7.585 //x2=29.325 //y2=7.585
r1708 (  415 962 ) resistor r=4.23183 //w=0.7 //l=0.175 //layer=li \
 //thickness=0.1 //x=29.24 //y=7.41 //x2=29.24 //y2=7.585
r1709 (  415 1060 ) resistor r=33.1979 //w=0.187 //l=0.485 //layer=li \
 //thickness=0.1 //x=29.24 //y=7.41 //x2=29.24 //y2=6.925
r1710 (  412 961 ) resistor r=2.87058 //w=0.35 //l=0.085 //layer=li \
 //thickness=0.1 //x=28.445 //y=7.585 //x2=28.36 //y2=7.585
r1711 (  412 414 ) resistor r=18.6594 //w=0.367 //l=0.535 //layer=li \
 //thickness=0.1 //x=28.445 //y=7.585 //x2=28.98 //y2=7.585
r1712 (  411 962 ) resistor r=2.87058 //w=0.35 //l=0.085 //layer=li \
 //thickness=0.1 //x=29.155 //y=7.585 //x2=29.24 //y2=7.585
r1713 (  411 414 ) resistor r=6.10354 //w=0.367 //l=0.175 //layer=li \
 //thickness=0.1 //x=29.155 //y=7.585 //x2=28.98 //y2=7.585
r1714 (  405 961 ) resistor r=4.23183 //w=0.7 //l=0.175 //layer=li \
 //thickness=0.1 //x=28.36 //y=7.41 //x2=28.36 //y2=7.585
r1715 (  405 1059 ) resistor r=33.1979 //w=0.187 //l=0.485 //layer=li \
 //thickness=0.1 //x=28.36 //y=7.41 //x2=28.36 //y2=6.925
r1716 (  402 960 ) resistor r=2.87058 //w=0.35 //l=0.085 //layer=li \
 //thickness=0.1 //x=27.565 //y=7.585 //x2=27.48 //y2=7.585
r1717 (  402 404 ) resistor r=10.6376 //w=0.367 //l=0.305 //layer=li \
 //thickness=0.1 //x=27.565 //y=7.585 //x2=27.87 //y2=7.585
r1718 (  401 961 ) resistor r=2.87058 //w=0.35 //l=0.085 //layer=li \
 //thickness=0.1 //x=28.275 //y=7.585 //x2=28.36 //y2=7.585
r1719 (  401 404 ) resistor r=14.1253 //w=0.367 //l=0.405 //layer=li \
 //thickness=0.1 //x=28.275 //y=7.585 //x2=27.87 //y2=7.585
r1720 (  395 960 ) resistor r=4.23183 //w=0.7 //l=0.175 //layer=li \
 //thickness=0.1 //x=27.48 //y=7.41 //x2=27.48 //y2=7.585
r1721 (  395 1058 ) resistor r=56.4706 //w=0.187 //l=0.825 //layer=li \
 //thickness=0.1 //x=27.48 //y=7.41 //x2=27.48 //y2=6.585
r1722 (  392 959 ) resistor r=5.29055 //w=0.35 //l=0.17 //layer=li \
 //thickness=0.1 //x=26.56 //y=7.585 //x2=26.39 //y2=7.585
r1723 (  392 394 ) resistor r=6.97548 //w=0.367 //l=0.2 //layer=li \
 //thickness=0.1 //x=26.56 //y=7.585 //x2=26.76 //y2=7.585
r1724 (  391 960 ) resistor r=2.87058 //w=0.35 //l=0.085 //layer=li \
 //thickness=0.1 //x=27.395 //y=7.585 //x2=27.48 //y2=7.585
r1725 (  391 394 ) resistor r=22.1471 //w=0.367 //l=0.635 //layer=li \
 //thickness=0.1 //x=27.395 //y=7.585 //x2=26.76 //y2=7.585
r1726 (  388 958 ) resistor r=2.87058 //w=0.35 //l=0.085 //layer=li \
 //thickness=0.1 //x=25.695 //y=7.585 //x2=25.61 //y2=7.585
r1727 (  387 959 ) resistor r=5.29055 //w=0.35 //l=0.17 //layer=li \
 //thickness=0.1 //x=26.22 //y=7.585 //x2=26.39 //y2=7.585
r1728 (  387 388 ) resistor r=18.3106 //w=0.367 //l=0.525 //layer=li \
 //thickness=0.1 //x=26.22 //y=7.585 //x2=25.695 //y2=7.585
r1729 (  381 958 ) resistor r=4.23183 //w=0.7 //l=0.175 //layer=li \
 //thickness=0.1 //x=25.61 //y=7.41 //x2=25.61 //y2=7.585
r1730 (  381 1057 ) resistor r=33.1979 //w=0.187 //l=0.485 //layer=li \
 //thickness=0.1 //x=25.61 //y=7.41 //x2=25.61 //y2=6.925
r1731 (  378 957 ) resistor r=2.87058 //w=0.35 //l=0.085 //layer=li \
 //thickness=0.1 //x=24.815 //y=7.585 //x2=24.73 //y2=7.585
r1732 (  378 380 ) resistor r=16.218 //w=0.367 //l=0.465 //layer=li \
 //thickness=0.1 //x=24.815 //y=7.585 //x2=25.28 //y2=7.585
r1733 (  377 958 ) resistor r=2.87058 //w=0.35 //l=0.085 //layer=li \
 //thickness=0.1 //x=25.525 //y=7.585 //x2=25.61 //y2=7.585
r1734 (  377 380 ) resistor r=8.54496 //w=0.367 //l=0.245 //layer=li \
 //thickness=0.1 //x=25.525 //y=7.585 //x2=25.28 //y2=7.585
r1735 (  371 957 ) resistor r=4.23183 //w=0.7 //l=0.175 //layer=li \
 //thickness=0.1 //x=24.73 //y=7.41 //x2=24.73 //y2=7.585
r1736 (  371 1056 ) resistor r=33.1979 //w=0.187 //l=0.485 //layer=li \
 //thickness=0.1 //x=24.73 //y=7.41 //x2=24.73 //y2=6.925
r1737 (  368 956 ) resistor r=2.87058 //w=0.35 //l=0.085 //layer=li \
 //thickness=0.1 //x=23.935 //y=7.585 //x2=23.85 //y2=7.585
r1738 (  368 370 ) resistor r=8.19619 //w=0.367 //l=0.235 //layer=li \
 //thickness=0.1 //x=23.935 //y=7.585 //x2=24.17 //y2=7.585
r1739 (  367 957 ) resistor r=2.87058 //w=0.35 //l=0.085 //layer=li \
 //thickness=0.1 //x=24.645 //y=7.585 //x2=24.73 //y2=7.585
r1740 (  367 370 ) resistor r=16.5668 //w=0.367 //l=0.475 //layer=li \
 //thickness=0.1 //x=24.645 //y=7.585 //x2=24.17 //y2=7.585
r1741 (  361 956 ) resistor r=4.23183 //w=0.7 //l=0.175 //layer=li \
 //thickness=0.1 //x=23.85 //y=7.41 //x2=23.85 //y2=7.585
r1742 (  361 1055 ) resistor r=56.4706 //w=0.187 //l=0.825 //layer=li \
 //thickness=0.1 //x=23.85 //y=7.41 //x2=23.85 //y2=6.585
r1743 (  360 955 ) resistor r=5.29055 //w=0.35 //l=0.17 //layer=li \
 //thickness=0.1 //x=23.23 //y=7.585 //x2=23.06 //y2=7.585
r1744 (  359 956 ) resistor r=2.87058 //w=0.35 //l=0.085 //layer=li \
 //thickness=0.1 //x=23.765 //y=7.585 //x2=23.85 //y2=7.585
r1745 (  359 360 ) resistor r=18.6594 //w=0.367 //l=0.535 //layer=li \
 //thickness=0.1 //x=23.765 //y=7.585 //x2=23.23 //y2=7.585
r1746 (  354 954 ) resistor r=2.87058 //w=0.35 //l=0.085 //layer=li \
 //thickness=0.1 //x=22.065 //y=7.585 //x2=21.98 //y2=7.585
r1747 (  354 356 ) resistor r=21.7984 //w=0.367 //l=0.625 //layer=li \
 //thickness=0.1 //x=22.065 //y=7.585 //x2=22.69 //y2=7.585
r1748 (  353 955 ) resistor r=5.29055 //w=0.35 //l=0.17 //layer=li \
 //thickness=0.1 //x=22.89 //y=7.585 //x2=23.06 //y2=7.585
r1749 (  353 356 ) resistor r=6.97548 //w=0.367 //l=0.2 //layer=li \
 //thickness=0.1 //x=22.89 //y=7.585 //x2=22.69 //y2=7.585
r1750 (  347 954 ) resistor r=4.23183 //w=0.7 //l=0.175 //layer=li \
 //thickness=0.1 //x=21.98 //y=7.41 //x2=21.98 //y2=7.585
r1751 (  347 1054 ) resistor r=33.1979 //w=0.187 //l=0.485 //layer=li \
 //thickness=0.1 //x=21.98 //y=7.41 //x2=21.98 //y2=6.925
r1752 (  344 953 ) resistor r=2.87058 //w=0.35 //l=0.085 //layer=li \
 //thickness=0.1 //x=21.185 //y=7.585 //x2=21.1 //y2=7.585
r1753 (  344 346 ) resistor r=13.7766 //w=0.367 //l=0.395 //layer=li \
 //thickness=0.1 //x=21.185 //y=7.585 //x2=21.58 //y2=7.585
r1754 (  343 954 ) resistor r=2.87058 //w=0.35 //l=0.085 //layer=li \
 //thickness=0.1 //x=21.895 //y=7.585 //x2=21.98 //y2=7.585
r1755 (  343 346 ) resistor r=10.9864 //w=0.367 //l=0.315 //layer=li \
 //thickness=0.1 //x=21.895 //y=7.585 //x2=21.58 //y2=7.585
r1756 (  337 953 ) resistor r=4.23183 //w=0.7 //l=0.175 //layer=li \
 //thickness=0.1 //x=21.1 //y=7.41 //x2=21.1 //y2=7.585
r1757 (  337 1053 ) resistor r=33.1979 //w=0.187 //l=0.485 //layer=li \
 //thickness=0.1 //x=21.1 //y=7.41 //x2=21.1 //y2=6.925
r1758 (  334 952 ) resistor r=2.87058 //w=0.35 //l=0.085 //layer=li \
 //thickness=0.1 //x=20.305 //y=7.585 //x2=20.22 //y2=7.585
r1759 (  334 336 ) resistor r=5.75477 //w=0.367 //l=0.165 //layer=li \
 //thickness=0.1 //x=20.305 //y=7.585 //x2=20.47 //y2=7.585
r1760 (  333 953 ) resistor r=2.87058 //w=0.35 //l=0.085 //layer=li \
 //thickness=0.1 //x=21.015 //y=7.585 //x2=21.1 //y2=7.585
r1761 (  333 336 ) resistor r=19.0082 //w=0.367 //l=0.545 //layer=li \
 //thickness=0.1 //x=21.015 //y=7.585 //x2=20.47 //y2=7.585
r1762 (  327 952 ) resistor r=4.23183 //w=0.7 //l=0.175 //layer=li \
 //thickness=0.1 //x=20.22 //y=7.41 //x2=20.22 //y2=7.585
r1763 (  327 1052 ) resistor r=33.1979 //w=0.187 //l=0.485 //layer=li \
 //thickness=0.1 //x=20.22 //y=7.41 //x2=20.22 //y2=6.925
r1764 (  326 951 ) resistor r=2.87058 //w=0.35 //l=0.085 //layer=li \
 //thickness=0.1 //x=19.425 //y=7.585 //x2=19.34 //y2=7.585
r1765 (  325 952 ) resistor r=2.87058 //w=0.35 //l=0.085 //layer=li \
 //thickness=0.1 //x=20.135 //y=7.585 //x2=20.22 //y2=7.585
r1766 (  325 326 ) resistor r=24.7629 //w=0.367 //l=0.71 //layer=li \
 //thickness=0.1 //x=20.135 //y=7.585 //x2=19.425 //y2=7.585
r1767 (  319 951 ) resistor r=4.23183 //w=0.7 //l=0.175 //layer=li \
 //thickness=0.1 //x=19.34 //y=7.41 //x2=19.34 //y2=7.585
r1768 (  319 1051 ) resistor r=56.4706 //w=0.187 //l=0.825 //layer=li \
 //thickness=0.1 //x=19.34 //y=7.41 //x2=19.34 //y2=6.585
r1769 (  318 949 ) resistor r=5.29055 //w=0.35 //l=0.17 //layer=li \
 //thickness=0.1 //x=18.42 //y=7.585 //x2=18.25 //y2=7.585
r1770 (  317 951 ) resistor r=2.87058 //w=0.35 //l=0.085 //layer=li \
 //thickness=0.1 //x=19.255 //y=7.585 //x2=19.34 //y2=7.585
r1771 (  317 318 ) resistor r=29.1226 //w=0.367 //l=0.835 //layer=li \
 //thickness=0.1 //x=19.255 //y=7.585 //x2=18.42 //y2=7.585
r1772 (  312 948 ) resistor r=2.87058 //w=0.35 //l=0.085 //layer=li \
 //thickness=0.1 //x=17.255 //y=7.585 //x2=17.17 //y2=7.585
r1773 (  312 314 ) resistor r=21.7984 //w=0.367 //l=0.625 //layer=li \
 //thickness=0.1 //x=17.255 //y=7.585 //x2=17.88 //y2=7.585
r1774 (  311 949 ) resistor r=5.29055 //w=0.35 //l=0.17 //layer=li \
 //thickness=0.1 //x=18.08 //y=7.585 //x2=18.25 //y2=7.585
r1775 (  311 314 ) resistor r=6.97548 //w=0.367 //l=0.2 //layer=li \
 //thickness=0.1 //x=18.08 //y=7.585 //x2=17.88 //y2=7.585
r1776 (  305 948 ) resistor r=4.23183 //w=0.7 //l=0.175 //layer=li \
 //thickness=0.1 //x=17.17 //y=7.41 //x2=17.17 //y2=7.585
r1777 (  305 1050 ) resistor r=33.1979 //w=0.187 //l=0.485 //layer=li \
 //thickness=0.1 //x=17.17 //y=7.41 //x2=17.17 //y2=6.925
r1778 (  302 947 ) resistor r=2.87058 //w=0.35 //l=0.085 //layer=li \
 //thickness=0.1 //x=16.375 //y=7.585 //x2=16.29 //y2=7.585
r1779 (  302 304 ) resistor r=13.7766 //w=0.367 //l=0.395 //layer=li \
 //thickness=0.1 //x=16.375 //y=7.585 //x2=16.77 //y2=7.585
r1780 (  301 948 ) resistor r=2.87058 //w=0.35 //l=0.085 //layer=li \
 //thickness=0.1 //x=17.085 //y=7.585 //x2=17.17 //y2=7.585
r1781 (  301 304 ) resistor r=10.9864 //w=0.367 //l=0.315 //layer=li \
 //thickness=0.1 //x=17.085 //y=7.585 //x2=16.77 //y2=7.585
r1782 (  295 947 ) resistor r=4.23183 //w=0.7 //l=0.175 //layer=li \
 //thickness=0.1 //x=16.29 //y=7.41 //x2=16.29 //y2=7.585
r1783 (  295 1049 ) resistor r=33.1979 //w=0.187 //l=0.485 //layer=li \
 //thickness=0.1 //x=16.29 //y=7.41 //x2=16.29 //y2=6.925
r1784 (  292 946 ) resistor r=2.87058 //w=0.35 //l=0.085 //layer=li \
 //thickness=0.1 //x=15.495 //y=7.585 //x2=15.41 //y2=7.585
r1785 (  292 294 ) resistor r=5.75477 //w=0.367 //l=0.165 //layer=li \
 //thickness=0.1 //x=15.495 //y=7.585 //x2=15.66 //y2=7.585
r1786 (  291 947 ) resistor r=2.87058 //w=0.35 //l=0.085 //layer=li \
 //thickness=0.1 //x=16.205 //y=7.585 //x2=16.29 //y2=7.585
r1787 (  291 294 ) resistor r=19.0082 //w=0.367 //l=0.545 //layer=li \
 //thickness=0.1 //x=16.205 //y=7.585 //x2=15.66 //y2=7.585
r1788 (  285 946 ) resistor r=4.23183 //w=0.7 //l=0.175 //layer=li \
 //thickness=0.1 //x=15.41 //y=7.41 //x2=15.41 //y2=7.585
r1789 (  285 1048 ) resistor r=33.1979 //w=0.187 //l=0.485 //layer=li \
 //thickness=0.1 //x=15.41 //y=7.41 //x2=15.41 //y2=6.925
r1790 (  284 945 ) resistor r=2.87058 //w=0.35 //l=0.085 //layer=li \
 //thickness=0.1 //x=14.615 //y=7.585 //x2=14.53 //y2=7.585
r1791 (  283 946 ) resistor r=2.87058 //w=0.35 //l=0.085 //layer=li \
 //thickness=0.1 //x=15.325 //y=7.585 //x2=15.41 //y2=7.585
r1792 (  283 284 ) resistor r=24.7629 //w=0.367 //l=0.71 //layer=li \
 //thickness=0.1 //x=15.325 //y=7.585 //x2=14.615 //y2=7.585
r1793 (  277 945 ) resistor r=4.23183 //w=0.7 //l=0.175 //layer=li \
 //thickness=0.1 //x=14.53 //y=7.41 //x2=14.53 //y2=7.585
r1794 (  277 1047 ) resistor r=56.4706 //w=0.187 //l=0.825 //layer=li \
 //thickness=0.1 //x=14.53 //y=7.41 //x2=14.53 //y2=6.585
r1795 (  276 943 ) resistor r=5.29055 //w=0.35 //l=0.17 //layer=li \
 //thickness=0.1 //x=13.61 //y=7.585 //x2=13.44 //y2=7.585
r1796 (  275 945 ) resistor r=2.87058 //w=0.35 //l=0.085 //layer=li \
 //thickness=0.1 //x=14.445 //y=7.585 //x2=14.53 //y2=7.585
r1797 (  275 276 ) resistor r=29.1226 //w=0.367 //l=0.835 //layer=li \
 //thickness=0.1 //x=14.445 //y=7.585 //x2=13.61 //y2=7.585
r1798 (  270 942 ) resistor r=2.87058 //w=0.35 //l=0.085 //layer=li \
 //thickness=0.1 //x=12.745 //y=7.585 //x2=12.66 //y2=7.585
r1799 (  270 272 ) resistor r=11.3351 //w=0.367 //l=0.325 //layer=li \
 //thickness=0.1 //x=12.745 //y=7.585 //x2=13.07 //y2=7.585
r1800 (  269 943 ) resistor r=5.29055 //w=0.35 //l=0.17 //layer=li \
 //thickness=0.1 //x=13.27 //y=7.585 //x2=13.44 //y2=7.585
r1801 (  269 272 ) resistor r=6.97548 //w=0.367 //l=0.2 //layer=li \
 //thickness=0.1 //x=13.27 //y=7.585 //x2=13.07 //y2=7.585
r1802 (  263 942 ) resistor r=4.23183 //w=0.7 //l=0.175 //layer=li \
 //thickness=0.1 //x=12.66 //y=7.41 //x2=12.66 //y2=7.585
r1803 (  263 1046 ) resistor r=33.1979 //w=0.187 //l=0.485 //layer=li \
 //thickness=0.1 //x=12.66 //y=7.41 //x2=12.66 //y2=6.925
r1804 (  260 941 ) resistor r=2.87058 //w=0.35 //l=0.085 //layer=li \
 //thickness=0.1 //x=11.865 //y=7.585 //x2=11.78 //y2=7.585
r1805 (  260 262 ) resistor r=3.31335 //w=0.367 //l=0.095 //layer=li \
 //thickness=0.1 //x=11.865 //y=7.585 //x2=11.96 //y2=7.585
r1806 (  259 942 ) resistor r=2.87058 //w=0.35 //l=0.085 //layer=li \
 //thickness=0.1 //x=12.575 //y=7.585 //x2=12.66 //y2=7.585
r1807 (  259 262 ) resistor r=21.4496 //w=0.367 //l=0.615 //layer=li \
 //thickness=0.1 //x=12.575 //y=7.585 //x2=11.96 //y2=7.585
r1808 (  253 941 ) resistor r=4.23183 //w=0.7 //l=0.175 //layer=li \
 //thickness=0.1 //x=11.78 //y=7.41 //x2=11.78 //y2=7.585
r1809 (  253 1045 ) resistor r=33.1979 //w=0.187 //l=0.485 //layer=li \
 //thickness=0.1 //x=11.78 //y=7.41 //x2=11.78 //y2=6.925
r1810 (  252 940 ) resistor r=2.87058 //w=0.35 //l=0.085 //layer=li \
 //thickness=0.1 //x=10.985 //y=7.585 //x2=10.9 //y2=7.585
r1811 (  251 941 ) resistor r=2.87058 //w=0.35 //l=0.085 //layer=li \
 //thickness=0.1 //x=11.695 //y=7.585 //x2=11.78 //y2=7.585
r1812 (  251 252 ) resistor r=24.7629 //w=0.367 //l=0.71 //layer=li \
 //thickness=0.1 //x=11.695 //y=7.585 //x2=10.985 //y2=7.585
r1813 (  245 940 ) resistor r=4.23183 //w=0.7 //l=0.175 //layer=li \
 //thickness=0.1 //x=10.9 //y=7.41 //x2=10.9 //y2=7.585
r1814 (  245 1044 ) resistor r=56.4706 //w=0.187 //l=0.825 //layer=li \
 //thickness=0.1 //x=10.9 //y=7.41 //x2=10.9 //y2=6.585
r1815 (  244 938 ) resistor r=5.29055 //w=0.35 //l=0.17 //layer=li \
 //thickness=0.1 //x=10.28 //y=7.585 //x2=10.11 //y2=7.585
r1816 (  243 940 ) resistor r=2.87058 //w=0.35 //l=0.085 //layer=li \
 //thickness=0.1 //x=10.815 //y=7.585 //x2=10.9 //y2=7.585
r1817 (  243 244 ) resistor r=18.6594 //w=0.367 //l=0.535 //layer=li \
 //thickness=0.1 //x=10.815 //y=7.585 //x2=10.28 //y2=7.585
r1818 (  238 937 ) resistor r=2.87058 //w=0.35 //l=0.085 //layer=li \
 //thickness=0.1 //x=9.115 //y=7.585 //x2=9.03 //y2=7.585
r1819 (  238 240 ) resistor r=8.89373 //w=0.367 //l=0.255 //layer=li \
 //thickness=0.1 //x=9.115 //y=7.585 //x2=9.37 //y2=7.585
r1820 (  237 938 ) resistor r=5.29055 //w=0.35 //l=0.17 //layer=li \
 //thickness=0.1 //x=9.94 //y=7.585 //x2=10.11 //y2=7.585
r1821 (  237 240 ) resistor r=19.8801 //w=0.367 //l=0.57 //layer=li \
 //thickness=0.1 //x=9.94 //y=7.585 //x2=9.37 //y2=7.585
r1822 (  231 937 ) resistor r=4.23183 //w=0.7 //l=0.175 //layer=li \
 //thickness=0.1 //x=9.03 //y=7.41 //x2=9.03 //y2=7.585
r1823 (  231 1043 ) resistor r=33.1979 //w=0.187 //l=0.485 //layer=li \
 //thickness=0.1 //x=9.03 //y=7.41 //x2=9.03 //y2=6.925
r1824 (  228 936 ) resistor r=2.87058 //w=0.35 //l=0.085 //layer=li \
 //thickness=0.1 //x=8.235 //y=7.585 //x2=8.15 //y2=7.585
r1825 (  228 230 ) resistor r=0.871935 //w=0.367 //l=0.025 //layer=li \
 //thickness=0.1 //x=8.235 //y=7.585 //x2=8.26 //y2=7.585
r1826 (  227 937 ) resistor r=2.87058 //w=0.35 //l=0.085 //layer=li \
 //thickness=0.1 //x=8.945 //y=7.585 //x2=9.03 //y2=7.585
r1827 (  227 230 ) resistor r=23.891 //w=0.367 //l=0.685 //layer=li \
 //thickness=0.1 //x=8.945 //y=7.585 //x2=8.26 //y2=7.585
r1828 (  221 936 ) resistor r=4.23183 //w=0.7 //l=0.175 //layer=li \
 //thickness=0.1 //x=8.15 //y=7.41 //x2=8.15 //y2=7.585
r1829 (  221 1042 ) resistor r=33.1979 //w=0.187 //l=0.485 //layer=li \
 //thickness=0.1 //x=8.15 //y=7.41 //x2=8.15 //y2=6.925
r1830 (  220 935 ) resistor r=2.87058 //w=0.35 //l=0.085 //layer=li \
 //thickness=0.1 //x=7.355 //y=7.585 //x2=7.27 //y2=7.585
r1831 (  219 936 ) resistor r=2.87058 //w=0.35 //l=0.085 //layer=li \
 //thickness=0.1 //x=8.065 //y=7.585 //x2=8.15 //y2=7.585
r1832 (  219 220 ) resistor r=24.7629 //w=0.367 //l=0.71 //layer=li \
 //thickness=0.1 //x=8.065 //y=7.585 //x2=7.355 //y2=7.585
r1833 (  213 935 ) resistor r=4.23183 //w=0.7 //l=0.175 //layer=li \
 //thickness=0.1 //x=7.27 //y=7.41 //x2=7.27 //y2=7.585
r1834 (  213 1041 ) resistor r=33.1979 //w=0.187 //l=0.485 //layer=li \
 //thickness=0.1 //x=7.27 //y=7.41 //x2=7.27 //y2=6.925
r1835 (  210 934 ) resistor r=2.87058 //w=0.35 //l=0.085 //layer=li \
 //thickness=0.1 //x=6.475 //y=7.585 //x2=6.39 //y2=7.585
r1836 (  210 212 ) resistor r=23.5422 //w=0.367 //l=0.675 //layer=li \
 //thickness=0.1 //x=6.475 //y=7.585 //x2=7.15 //y2=7.585
r1837 (  209 935 ) resistor r=2.87058 //w=0.35 //l=0.085 //layer=li \
 //thickness=0.1 //x=7.185 //y=7.585 //x2=7.27 //y2=7.585
r1838 (  209 212 ) resistor r=1.22071 //w=0.367 //l=0.035 //layer=li \
 //thickness=0.1 //x=7.185 //y=7.585 //x2=7.15 //y2=7.585
r1839 (  203 934 ) resistor r=4.23183 //w=0.7 //l=0.175 //layer=li \
 //thickness=0.1 //x=6.39 //y=7.41 //x2=6.39 //y2=7.585
r1840 (  203 1040 ) resistor r=56.4706 //w=0.187 //l=0.825 //layer=li \
 //thickness=0.1 //x=6.39 //y=7.41 //x2=6.39 //y2=6.585
r1841 (  200 933 ) resistor r=5.29055 //w=0.35 //l=0.17 //layer=li \
 //thickness=0.1 //x=5.47 //y=7.585 //x2=5.3 //y2=7.585
r1842 (  200 202 ) resistor r=19.8801 //w=0.367 //l=0.57 //layer=li \
 //thickness=0.1 //x=5.47 //y=7.585 //x2=6.04 //y2=7.585
r1843 (  199 934 ) resistor r=2.87058 //w=0.35 //l=0.085 //layer=li \
 //thickness=0.1 //x=6.305 //y=7.585 //x2=6.39 //y2=7.585
r1844 (  199 202 ) resistor r=9.24251 //w=0.367 //l=0.265 //layer=li \
 //thickness=0.1 //x=6.305 //y=7.585 //x2=6.04 //y2=7.585
r1845 (  194 932 ) resistor r=2.87058 //w=0.35 //l=0.085 //layer=li \
 //thickness=0.1 //x=4.305 //y=7.585 //x2=4.22 //y2=7.585
r1846 (  194 196 ) resistor r=8.89373 //w=0.367 //l=0.255 //layer=li \
 //thickness=0.1 //x=4.305 //y=7.585 //x2=4.56 //y2=7.585
r1847 (  193 933 ) resistor r=5.29055 //w=0.35 //l=0.17 //layer=li \
 //thickness=0.1 //x=5.13 //y=7.585 //x2=5.3 //y2=7.585
r1848 (  193 196 ) resistor r=19.8801 //w=0.367 //l=0.57 //layer=li \
 //thickness=0.1 //x=5.13 //y=7.585 //x2=4.56 //y2=7.585
r1849 (  187 932 ) resistor r=4.23183 //w=0.7 //l=0.175 //layer=li \
 //thickness=0.1 //x=4.22 //y=7.41 //x2=4.22 //y2=7.585
r1850 (  187 1039 ) resistor r=33.1979 //w=0.187 //l=0.485 //layer=li \
 //thickness=0.1 //x=4.22 //y=7.41 //x2=4.22 //y2=6.925
r1851 (  184 931 ) resistor r=2.87058 //w=0.35 //l=0.085 //layer=li \
 //thickness=0.1 //x=3.425 //y=7.585 //x2=3.34 //y2=7.585
r1852 (  184 186 ) resistor r=0.871935 //w=0.367 //l=0.025 //layer=li \
 //thickness=0.1 //x=3.425 //y=7.585 //x2=3.45 //y2=7.585
r1853 (  183 932 ) resistor r=2.87058 //w=0.35 //l=0.085 //layer=li \
 //thickness=0.1 //x=4.135 //y=7.585 //x2=4.22 //y2=7.585
r1854 (  183 186 ) resistor r=23.891 //w=0.367 //l=0.685 //layer=li \
 //thickness=0.1 //x=4.135 //y=7.585 //x2=3.45 //y2=7.585
r1855 (  177 931 ) resistor r=4.23183 //w=0.7 //l=0.175 //layer=li \
 //thickness=0.1 //x=3.34 //y=7.41 //x2=3.34 //y2=7.585
r1856 (  177 1038 ) resistor r=33.1979 //w=0.187 //l=0.485 //layer=li \
 //thickness=0.1 //x=3.34 //y=7.41 //x2=3.34 //y2=6.925
r1857 (  176 930 ) resistor r=2.87058 //w=0.35 //l=0.085 //layer=li \
 //thickness=0.1 //x=2.545 //y=7.585 //x2=2.46 //y2=7.585
r1858 (  175 931 ) resistor r=2.87058 //w=0.35 //l=0.085 //layer=li \
 //thickness=0.1 //x=3.255 //y=7.585 //x2=3.34 //y2=7.585
r1859 (  175 176 ) resistor r=24.7629 //w=0.367 //l=0.71 //layer=li \
 //thickness=0.1 //x=3.255 //y=7.585 //x2=2.545 //y2=7.585
r1860 (  169 930 ) resistor r=4.23183 //w=0.7 //l=0.175 //layer=li \
 //thickness=0.1 //x=2.46 //y=7.41 //x2=2.46 //y2=7.585
r1861 (  169 1037 ) resistor r=33.1979 //w=0.187 //l=0.485 //layer=li \
 //thickness=0.1 //x=2.46 //y=7.41 //x2=2.46 //y2=6.925
r1862 (  166 929 ) resistor r=2.87058 //w=0.35 //l=0.085 //layer=li \
 //thickness=0.1 //x=1.665 //y=7.585 //x2=1.58 //y2=7.585
r1863 (  166 168 ) resistor r=23.5422 //w=0.367 //l=0.675 //layer=li \
 //thickness=0.1 //x=1.665 //y=7.585 //x2=2.34 //y2=7.585
r1864 (  165 930 ) resistor r=2.87058 //w=0.35 //l=0.085 //layer=li \
 //thickness=0.1 //x=2.375 //y=7.585 //x2=2.46 //y2=7.585
r1865 (  165 168 ) resistor r=1.22071 //w=0.367 //l=0.035 //layer=li \
 //thickness=0.1 //x=2.375 //y=7.585 //x2=2.34 //y2=7.585
r1866 (  159 929 ) resistor r=4.23183 //w=0.7 //l=0.175 //layer=li \
 //thickness=0.1 //x=1.58 //y=7.41 //x2=1.58 //y2=7.585
r1867 (  159 1036 ) resistor r=56.4706 //w=0.187 //l=0.825 //layer=li \
 //thickness=0.1 //x=1.58 //y=7.41 //x2=1.58 //y2=6.585
r1868 (  155 929 ) resistor r=2.87058 //w=0.35 //l=0.085 //layer=li \
 //thickness=0.1 //x=1.495 //y=7.585 //x2=1.58 //y2=7.585
r1869 (  155 158 ) resistor r=9.24251 //w=0.367 //l=0.265 //layer=li \
 //thickness=0.1 //x=1.495 //y=7.585 //x2=1.23 //y2=7.585
r1870 (  151 1035 ) resistor r=4.65 //w=0.17 //l=0.34 //layer=mcon //count=2 \
 //x=89.66 //y=7.58 //x2=89.66 //y2=7.58
r1871 (  149 1033 ) resistor r=3.1 //w=0.17 //l=0.51 //layer=mcon //count=3 \
 //x=88.92 //y=7.58 //x2=88.92 //y2=7.58
r1872 (  149 151 ) resistor r=0.297428 //w=0.311 //l=0.74 //layer=m1 \
 //thickness=0.36 //x=88.92 //y=7.585 //x2=89.66 //y2=7.585
r1873 (  147 906 ) resistor r=3.1 //w=0.17 //l=0.51 //layer=mcon //count=3 \
 //x=87.44 //y=7.58 //x2=87.44 //y2=7.58
r1874 (  147 149 ) resistor r=0.594855 //w=0.311 //l=1.48 //layer=m1 \
 //thickness=0.36 //x=87.44 //y=7.585 //x2=88.92 //y2=7.585
r1875 (  145 904 ) resistor r=3.1 //w=0.17 //l=0.51 //layer=mcon //count=3 \
 //x=86.33 //y=7.58 //x2=86.33 //y2=7.58
r1876 (  145 147 ) resistor r=0.446141 //w=0.311 //l=1.11 //layer=m1 \
 //thickness=0.36 //x=86.33 //y=7.585 //x2=87.44 //y2=7.585
r1877 (  143 902 ) resistor r=3.1 //w=0.17 //l=0.51 //layer=mcon //count=3 \
 //x=85.22 //y=7.58 //x2=85.22 //y2=7.58
r1878 (  143 145 ) resistor r=0.446141 //w=0.311 //l=1.11 //layer=m1 \
 //thickness=0.36 //x=85.22 //y=7.585 //x2=86.33 //y2=7.585
r1879 (  141 896 ) resistor r=3.1 //w=0.17 //l=0.51 //layer=mcon //count=3 \
 //x=83.74 //y=7.58 //x2=83.74 //y2=7.58
r1880 (  141 143 ) resistor r=0.594855 //w=0.311 //l=1.48 //layer=m1 \
 //thickness=0.36 //x=83.74 //y=7.585 //x2=85.22 //y2=7.585
r1881 (  139 894 ) resistor r=3.1 //w=0.17 //l=0.51 //layer=mcon //count=3 \
 //x=82.63 //y=7.58 //x2=82.63 //y2=7.58
r1882 (  139 141 ) resistor r=0.446141 //w=0.311 //l=1.11 //layer=m1 \
 //thickness=0.36 //x=82.63 //y=7.585 //x2=83.74 //y2=7.585
r1883 (  137 888 ) resistor r=3.1 //w=0.17 //l=0.51 //layer=mcon //count=3 \
 //x=81.15 //y=7.58 //x2=81.15 //y2=7.58
r1884 (  137 139 ) resistor r=0.594855 //w=0.311 //l=1.48 //layer=m1 \
 //thickness=0.36 //x=81.15 //y=7.585 //x2=82.63 //y2=7.585
r1885 (  135 878 ) resistor r=3.1 //w=0.17 //l=0.51 //layer=mcon //count=3 \
 //x=80.04 //y=7.58 //x2=80.04 //y2=7.58
r1886 (  135 137 ) resistor r=0.446141 //w=0.311 //l=1.11 //layer=m1 \
 //thickness=0.36 //x=80.04 //y=7.585 //x2=81.15 //y2=7.585
r1887 (  133 1026 ) resistor r=3.1 //w=0.17 //l=0.51 //layer=mcon //count=3 \
 //x=78.93 //y=7.58 //x2=78.93 //y2=7.58
r1888 (  133 135 ) resistor r=0.446141 //w=0.311 //l=1.11 //layer=m1 \
 //thickness=0.36 //x=78.93 //y=7.585 //x2=80.04 //y2=7.585
r1889 (  131 1023 ) resistor r=3.1 //w=0.17 //l=0.51 //layer=mcon //count=3 \
 //x=77.45 //y=7.58 //x2=77.45 //y2=7.58
r1890 (  131 133 ) resistor r=0.594855 //w=0.311 //l=1.48 //layer=m1 \
 //thickness=0.36 //x=77.45 //y=7.585 //x2=78.93 //y2=7.585
r1891 (  129 840 ) resistor r=3.1 //w=0.17 //l=0.51 //layer=mcon //count=3 \
 //x=76.34 //y=7.58 //x2=76.34 //y2=7.58
r1892 (  129 131 ) resistor r=0.446141 //w=0.311 //l=1.11 //layer=m1 \
 //thickness=0.36 //x=76.34 //y=7.585 //x2=77.45 //y2=7.585
r1893 (  127 830 ) resistor r=3.1 //w=0.17 //l=0.51 //layer=mcon //count=3 \
 //x=75.23 //y=7.58 //x2=75.23 //y2=7.58
r1894 (  127 129 ) resistor r=0.446141 //w=0.311 //l=1.11 //layer=m1 \
 //thickness=0.36 //x=75.23 //y=7.585 //x2=76.34 //y2=7.585
r1895 (  125 1018 ) resistor r=3.1 //w=0.17 //l=0.51 //layer=mcon //count=3 \
 //x=73.75 //y=7.58 //x2=73.75 //y2=7.58
r1896 (  125 127 ) resistor r=0.594855 //w=0.311 //l=1.48 //layer=m1 \
 //thickness=0.36 //x=73.75 //y=7.585 //x2=75.23 //y2=7.585
r1897 (  123 808 ) resistor r=3.1 //w=0.17 //l=0.51 //layer=mcon //count=3 \
 //x=72.64 //y=7.58 //x2=72.64 //y2=7.58
r1898 (  123 125 ) resistor r=0.446141 //w=0.311 //l=1.11 //layer=m1 \
 //thickness=0.36 //x=72.64 //y=7.585 //x2=73.75 //y2=7.585
r1899 (  121 798 ) resistor r=3.1 //w=0.17 //l=0.51 //layer=mcon //count=3 \
 //x=71.53 //y=7.58 //x2=71.53 //y2=7.58
r1900 (  121 123 ) resistor r=0.446141 //w=0.311 //l=1.11 //layer=m1 \
 //thickness=0.36 //x=71.53 //y=7.585 //x2=72.64 //y2=7.585
r1901 (  119 788 ) resistor r=3.1 //w=0.17 //l=0.51 //layer=mcon //count=3 \
 //x=70.42 //y=7.58 //x2=70.42 //y2=7.58
r1902 (  119 121 ) resistor r=0.446141 //w=0.311 //l=1.11 //layer=m1 \
 //thickness=0.36 //x=70.42 //y=7.585 //x2=71.53 //y2=7.585
r1903 (  117 1012 ) resistor r=3.1 //w=0.17 //l=0.51 //layer=mcon //count=3 \
 //x=68.94 //y=7.58 //x2=68.94 //y2=7.58
r1904 (  117 119 ) resistor r=0.594855 //w=0.311 //l=1.48 //layer=m1 \
 //thickness=0.36 //x=68.94 //y=7.585 //x2=70.42 //y2=7.585
r1905 (  115 766 ) resistor r=3.1 //w=0.17 //l=0.51 //layer=mcon //count=3 \
 //x=67.83 //y=7.58 //x2=67.83 //y2=7.58
r1906 (  115 117 ) resistor r=0.446141 //w=0.311 //l=1.11 //layer=m1 \
 //thickness=0.36 //x=67.83 //y=7.585 //x2=68.94 //y2=7.585
r1907 (  113 756 ) resistor r=3.1 //w=0.17 //l=0.51 //layer=mcon //count=3 \
 //x=66.72 //y=7.58 //x2=66.72 //y2=7.58
r1908 (  113 115 ) resistor r=0.446141 //w=0.311 //l=1.11 //layer=m1 \
 //thickness=0.36 //x=66.72 //y=7.585 //x2=67.83 //y2=7.585
r1909 (  111 746 ) resistor r=3.1 //w=0.17 //l=0.51 //layer=mcon //count=3 \
 //x=65.61 //y=7.58 //x2=65.61 //y2=7.58
r1910 (  111 113 ) resistor r=0.446141 //w=0.311 //l=1.11 //layer=m1 \
 //thickness=0.36 //x=65.61 //y=7.585 //x2=66.72 //y2=7.585
r1911 (  109 732 ) resistor r=3.1 //w=0.17 //l=0.51 //layer=mcon //count=3 \
 //x=64.13 //y=7.58 //x2=64.13 //y2=7.58
r1912 (  109 111 ) resistor r=0.594855 //w=0.311 //l=1.48 //layer=m1 \
 //thickness=0.36 //x=64.13 //y=7.585 //x2=65.61 //y2=7.585
r1913 (  107 722 ) resistor r=3.1 //w=0.17 //l=0.51 //layer=mcon //count=3 \
 //x=63.02 //y=7.58 //x2=63.02 //y2=7.58
r1914 (  107 109 ) resistor r=0.446141 //w=0.311 //l=1.11 //layer=m1 \
 //thickness=0.36 //x=63.02 //y=7.585 //x2=64.13 //y2=7.585
r1915 (  105 708 ) resistor r=3.1 //w=0.17 //l=0.51 //layer=mcon //count=3 \
 //x=61.54 //y=7.58 //x2=61.54 //y2=7.58
r1916 (  105 107 ) resistor r=0.594855 //w=0.311 //l=1.48 //layer=m1 \
 //thickness=0.36 //x=61.54 //y=7.585 //x2=63.02 //y2=7.585
r1917 (  103 698 ) resistor r=3.1 //w=0.17 //l=0.51 //layer=mcon //count=3 \
 //x=60.43 //y=7.58 //x2=60.43 //y2=7.58
r1918 (  103 105 ) resistor r=0.446141 //w=0.311 //l=1.11 //layer=m1 \
 //thickness=0.36 //x=60.43 //y=7.585 //x2=61.54 //y2=7.585
r1919 (  101 688 ) resistor r=3.1 //w=0.17 //l=0.51 //layer=mcon //count=3 \
 //x=59.32 //y=7.58 //x2=59.32 //y2=7.58
r1920 (  101 103 ) resistor r=0.446141 //w=0.311 //l=1.11 //layer=m1 \
 //thickness=0.36 //x=59.32 //y=7.585 //x2=60.43 //y2=7.585
r1921 (  99 999 ) resistor r=3.1 //w=0.17 //l=0.51 //layer=mcon //count=3 \
 //x=58.21 //y=7.58 //x2=58.21 //y2=7.58
r1922 (  99 101 ) resistor r=0.446141 //w=0.311 //l=1.11 //layer=m1 \
 //thickness=0.36 //x=58.21 //y=7.585 //x2=59.32 //y2=7.585
r1923 (  97 666 ) resistor r=3.1 //w=0.17 //l=0.51 //layer=mcon //count=3 \
 //x=56.73 //y=7.58 //x2=56.73 //y2=7.58
r1924 (  97 99 ) resistor r=0.594855 //w=0.311 //l=1.48 //layer=m1 \
 //thickness=0.36 //x=56.73 //y=7.585 //x2=58.21 //y2=7.585
r1925 (  95 656 ) resistor r=3.1 //w=0.17 //l=0.51 //layer=mcon //count=3 \
 //x=55.62 //y=7.58 //x2=55.62 //y2=7.58
r1926 (  95 97 ) resistor r=0.446141 //w=0.311 //l=1.11 //layer=m1 \
 //thickness=0.36 //x=55.62 //y=7.585 //x2=56.73 //y2=7.585
r1927 (  93 646 ) resistor r=3.1 //w=0.17 //l=0.51 //layer=mcon //count=3 \
 //x=54.51 //y=7.58 //x2=54.51 //y2=7.58
r1928 (  93 95 ) resistor r=0.446141 //w=0.311 //l=1.11 //layer=m1 \
 //thickness=0.36 //x=54.51 //y=7.585 //x2=55.62 //y2=7.585
r1929 (  91 993 ) resistor r=3.1 //w=0.17 //l=0.51 //layer=mcon //count=3 \
 //x=53.4 //y=7.58 //x2=53.4 //y2=7.58
r1930 (  91 93 ) resistor r=0.446141 //w=0.311 //l=1.11 //layer=m1 \
 //thickness=0.36 //x=53.4 //y=7.585 //x2=54.51 //y2=7.585
r1931 (  89 624 ) resistor r=3.1 //w=0.17 //l=0.51 //layer=mcon //count=3 \
 //x=51.92 //y=7.58 //x2=51.92 //y2=7.58
r1932 (  89 91 ) resistor r=0.594855 //w=0.311 //l=1.48 //layer=m1 \
 //thickness=0.36 //x=51.92 //y=7.585 //x2=53.4 //y2=7.585
r1933 (  87 614 ) resistor r=3.1 //w=0.17 //l=0.51 //layer=mcon //count=3 \
 //x=50.81 //y=7.58 //x2=50.81 //y2=7.58
r1934 (  87 89 ) resistor r=0.446141 //w=0.311 //l=1.11 //layer=m1 \
 //thickness=0.36 //x=50.81 //y=7.585 //x2=51.92 //y2=7.585
r1935 (  85 988 ) resistor r=3.1 //w=0.17 //l=0.51 //layer=mcon //count=3 \
 //x=49.7 //y=7.58 //x2=49.7 //y2=7.58
r1936 (  85 87 ) resistor r=0.446141 //w=0.311 //l=1.11 //layer=m1 \
 //thickness=0.36 //x=49.7 //y=7.585 //x2=50.81 //y2=7.585
r1937 (  83 592 ) resistor r=3.1 //w=0.17 //l=0.51 //layer=mcon //count=3 \
 //x=48.22 //y=7.58 //x2=48.22 //y2=7.58
r1938 (  83 85 ) resistor r=0.594855 //w=0.311 //l=1.48 //layer=m1 \
 //thickness=0.36 //x=48.22 //y=7.585 //x2=49.7 //y2=7.585
r1939 (  81 582 ) resistor r=3.1 //w=0.17 //l=0.51 //layer=mcon //count=3 \
 //x=47.11 //y=7.58 //x2=47.11 //y2=7.58
r1940 (  81 83 ) resistor r=0.446141 //w=0.311 //l=1.11 //layer=m1 \
 //thickness=0.36 //x=47.11 //y=7.585 //x2=48.22 //y2=7.585
r1941 (  79 564 ) resistor r=3.1 //w=0.17 //l=0.51 //layer=mcon //count=3 \
 //x=46 //y=7.58 //x2=46 //y2=7.58
r1942 (  79 81 ) resistor r=0.446141 //w=0.311 //l=1.11 //layer=m1 \
 //thickness=0.36 //x=46 //y=7.585 //x2=47.11 //y2=7.585
r1943 (  76 554 ) resistor r=3.1 //w=0.17 //l=0.51 //layer=mcon //count=3 \
 //x=44.89 //y=7.58 //x2=44.89 //y2=7.58
r1944 (  74 548 ) resistor r=3.1 //w=0.17 //l=0.51 //layer=mcon //count=3 \
 //x=43.41 //y=7.58 //x2=43.41 //y2=7.58
r1945 (  74 76 ) resistor r=0.594855 //w=0.311 //l=1.48 //layer=m1 \
 //thickness=0.36 //x=43.41 //y=7.585 //x2=44.89 //y2=7.585
r1946 (  72 538 ) resistor r=3.1 //w=0.17 //l=0.51 //layer=mcon //count=3 \
 //x=42.3 //y=7.58 //x2=42.3 //y2=7.58
r1947 (  72 74 ) resistor r=0.446141 //w=0.311 //l=1.11 //layer=m1 \
 //thickness=0.36 //x=42.3 //y=7.585 //x2=43.41 //y2=7.585
r1948 (  70 520 ) resistor r=3.1 //w=0.17 //l=0.51 //layer=mcon //count=3 \
 //x=41.19 //y=7.58 //x2=41.19 //y2=7.58
r1949 (  70 72 ) resistor r=0.446141 //w=0.311 //l=1.11 //layer=m1 \
 //thickness=0.36 //x=41.19 //y=7.585 //x2=42.3 //y2=7.585
r1950 (  68 510 ) resistor r=3.1 //w=0.17 //l=0.51 //layer=mcon //count=3 \
 //x=40.08 //y=7.58 //x2=40.08 //y2=7.58
r1951 (  68 70 ) resistor r=0.446141 //w=0.311 //l=1.11 //layer=m1 \
 //thickness=0.36 //x=40.08 //y=7.585 //x2=41.19 //y2=7.585
r1952 (  66 975 ) resistor r=3.1 //w=0.17 //l=0.51 //layer=mcon //count=3 \
 //x=38.6 //y=7.58 //x2=38.6 //y2=7.58
r1953 (  66 68 ) resistor r=0.594855 //w=0.311 //l=1.48 //layer=m1 \
 //thickness=0.36 //x=38.6 //y=7.585 //x2=40.08 //y2=7.585
r1954 (  64 488 ) resistor r=3.1 //w=0.17 //l=0.51 //layer=mcon //count=3 \
 //x=37.49 //y=7.58 //x2=37.49 //y2=7.58
r1955 (  64 66 ) resistor r=0.446141 //w=0.311 //l=1.11 //layer=m1 \
 //thickness=0.36 //x=37.49 //y=7.585 //x2=38.6 //y2=7.585
r1956 (  62 478 ) resistor r=3.1 //w=0.17 //l=0.51 //layer=mcon //count=3 \
 //x=36.38 //y=7.58 //x2=36.38 //y2=7.58
r1957 (  62 64 ) resistor r=0.446141 //w=0.311 //l=1.11 //layer=m1 \
 //thickness=0.36 //x=36.38 //y=7.585 //x2=37.49 //y2=7.585
r1958 (  60 970 ) resistor r=3.1 //w=0.17 //l=0.51 //layer=mcon //count=3 \
 //x=34.9 //y=7.58 //x2=34.9 //y2=7.58
r1959 (  60 62 ) resistor r=0.594855 //w=0.311 //l=1.48 //layer=m1 \
 //thickness=0.36 //x=34.9 //y=7.585 //x2=36.38 //y2=7.585
r1960 (  58 456 ) resistor r=3.1 //w=0.17 //l=0.51 //layer=mcon //count=3 \
 //x=33.79 //y=7.58 //x2=33.79 //y2=7.58
r1961 (  58 60 ) resistor r=0.446141 //w=0.311 //l=1.11 //layer=m1 \
 //thickness=0.36 //x=33.79 //y=7.585 //x2=34.9 //y2=7.585
r1962 (  56 446 ) resistor r=3.1 //w=0.17 //l=0.51 //layer=mcon //count=3 \
 //x=32.68 //y=7.58 //x2=32.68 //y2=7.58
r1963 (  56 58 ) resistor r=0.446141 //w=0.311 //l=1.11 //layer=m1 \
 //thickness=0.36 //x=32.68 //y=7.585 //x2=33.79 //y2=7.585
r1964 (  54 436 ) resistor r=3.1 //w=0.17 //l=0.51 //layer=mcon //count=3 \
 //x=31.57 //y=7.58 //x2=31.57 //y2=7.58
r1965 (  54 56 ) resistor r=0.446141 //w=0.311 //l=1.11 //layer=m1 \
 //thickness=0.36 //x=31.57 //y=7.585 //x2=32.68 //y2=7.585
r1966 (  52 964 ) resistor r=3.1 //w=0.17 //l=0.51 //layer=mcon //count=3 \
 //x=30.09 //y=7.58 //x2=30.09 //y2=7.58
r1967 (  52 54 ) resistor r=0.594855 //w=0.311 //l=1.48 //layer=m1 \
 //thickness=0.36 //x=30.09 //y=7.585 //x2=31.57 //y2=7.585
r1968 (  50 414 ) resistor r=3.1 //w=0.17 //l=0.51 //layer=mcon //count=3 \
 //x=28.98 //y=7.58 //x2=28.98 //y2=7.58
r1969 (  50 52 ) resistor r=0.446141 //w=0.311 //l=1.11 //layer=m1 \
 //thickness=0.36 //x=28.98 //y=7.585 //x2=30.09 //y2=7.585
r1970 (  48 404 ) resistor r=3.1 //w=0.17 //l=0.51 //layer=mcon //count=3 \
 //x=27.87 //y=7.58 //x2=27.87 //y2=7.58
r1971 (  48 50 ) resistor r=0.446141 //w=0.311 //l=1.11 //layer=m1 \
 //thickness=0.36 //x=27.87 //y=7.585 //x2=28.98 //y2=7.585
r1972 (  46 394 ) resistor r=3.1 //w=0.17 //l=0.51 //layer=mcon //count=3 \
 //x=26.76 //y=7.58 //x2=26.76 //y2=7.58
r1973 (  46 48 ) resistor r=0.446141 //w=0.311 //l=1.11 //layer=m1 \
 //thickness=0.36 //x=26.76 //y=7.585 //x2=27.87 //y2=7.585
r1974 (  44 380 ) resistor r=3.1 //w=0.17 //l=0.51 //layer=mcon //count=3 \
 //x=25.28 //y=7.58 //x2=25.28 //y2=7.58
r1975 (  44 46 ) resistor r=0.594855 //w=0.311 //l=1.48 //layer=m1 \
 //thickness=0.36 //x=25.28 //y=7.585 //x2=26.76 //y2=7.585
r1976 (  42 370 ) resistor r=3.1 //w=0.17 //l=0.51 //layer=mcon //count=3 \
 //x=24.17 //y=7.58 //x2=24.17 //y2=7.58
r1977 (  42 44 ) resistor r=0.446141 //w=0.311 //l=1.11 //layer=m1 \
 //thickness=0.36 //x=24.17 //y=7.585 //x2=25.28 //y2=7.585
r1978 (  40 356 ) resistor r=3.1 //w=0.17 //l=0.51 //layer=mcon //count=3 \
 //x=22.69 //y=7.58 //x2=22.69 //y2=7.58
r1979 (  40 42 ) resistor r=0.594855 //w=0.311 //l=1.48 //layer=m1 \
 //thickness=0.36 //x=22.69 //y=7.585 //x2=24.17 //y2=7.585
r1980 (  38 346 ) resistor r=3.1 //w=0.17 //l=0.51 //layer=mcon //count=3 \
 //x=21.58 //y=7.58 //x2=21.58 //y2=7.58
r1981 (  38 40 ) resistor r=0.446141 //w=0.311 //l=1.11 //layer=m1 \
 //thickness=0.36 //x=21.58 //y=7.585 //x2=22.69 //y2=7.585
r1982 (  36 336 ) resistor r=3.1 //w=0.17 //l=0.51 //layer=mcon //count=3 \
 //x=20.47 //y=7.58 //x2=20.47 //y2=7.58
r1983 (  36 38 ) resistor r=0.446141 //w=0.311 //l=1.11 //layer=m1 \
 //thickness=0.36 //x=20.47 //y=7.585 //x2=21.58 //y2=7.585
r1984 (  34 951 ) resistor r=3.1 //w=0.17 //l=0.51 //layer=mcon //count=3 \
 //x=19.36 //y=7.58 //x2=19.36 //y2=7.58
r1985 (  34 36 ) resistor r=0.446141 //w=0.311 //l=1.11 //layer=m1 \
 //thickness=0.36 //x=19.36 //y=7.585 //x2=20.47 //y2=7.585
r1986 (  32 314 ) resistor r=3.1 //w=0.17 //l=0.51 //layer=mcon //count=3 \
 //x=17.88 //y=7.58 //x2=17.88 //y2=7.58
r1987 (  32 34 ) resistor r=0.594855 //w=0.311 //l=1.48 //layer=m1 \
 //thickness=0.36 //x=17.88 //y=7.585 //x2=19.36 //y2=7.585
r1988 (  30 304 ) resistor r=3.1 //w=0.17 //l=0.51 //layer=mcon //count=3 \
 //x=16.77 //y=7.58 //x2=16.77 //y2=7.58
r1989 (  30 32 ) resistor r=0.446141 //w=0.311 //l=1.11 //layer=m1 \
 //thickness=0.36 //x=16.77 //y=7.585 //x2=17.88 //y2=7.585
r1990 (  28 294 ) resistor r=3.1 //w=0.17 //l=0.51 //layer=mcon //count=3 \
 //x=15.66 //y=7.58 //x2=15.66 //y2=7.58
r1991 (  28 30 ) resistor r=0.446141 //w=0.311 //l=1.11 //layer=m1 \
 //thickness=0.36 //x=15.66 //y=7.585 //x2=16.77 //y2=7.585
r1992 (  26 945 ) resistor r=3.1 //w=0.17 //l=0.51 //layer=mcon //count=3 \
 //x=14.55 //y=7.58 //x2=14.55 //y2=7.58
r1993 (  26 28 ) resistor r=0.446141 //w=0.311 //l=1.11 //layer=m1 \
 //thickness=0.36 //x=14.55 //y=7.585 //x2=15.66 //y2=7.585
r1994 (  24 272 ) resistor r=3.1 //w=0.17 //l=0.51 //layer=mcon //count=3 \
 //x=13.07 //y=7.58 //x2=13.07 //y2=7.58
r1995 (  24 26 ) resistor r=0.594855 //w=0.311 //l=1.48 //layer=m1 \
 //thickness=0.36 //x=13.07 //y=7.585 //x2=14.55 //y2=7.585
r1996 (  22 262 ) resistor r=3.1 //w=0.17 //l=0.51 //layer=mcon //count=3 \
 //x=11.96 //y=7.58 //x2=11.96 //y2=7.58
r1997 (  22 24 ) resistor r=0.446141 //w=0.311 //l=1.11 //layer=m1 \
 //thickness=0.36 //x=11.96 //y=7.585 //x2=13.07 //y2=7.585
r1998 (  20 940 ) resistor r=3.1 //w=0.17 //l=0.51 //layer=mcon //count=3 \
 //x=10.85 //y=7.58 //x2=10.85 //y2=7.58
r1999 (  20 22 ) resistor r=0.446141 //w=0.311 //l=1.11 //layer=m1 \
 //thickness=0.36 //x=10.85 //y=7.585 //x2=11.96 //y2=7.585
r2000 (  18 240 ) resistor r=3.1 //w=0.17 //l=0.51 //layer=mcon //count=3 \
 //x=9.37 //y=7.58 //x2=9.37 //y2=7.58
r2001 (  18 20 ) resistor r=0.594855 //w=0.311 //l=1.48 //layer=m1 \
 //thickness=0.36 //x=9.37 //y=7.585 //x2=10.85 //y2=7.585
r2002 (  16 230 ) resistor r=3.1 //w=0.17 //l=0.51 //layer=mcon //count=3 \
 //x=8.26 //y=7.58 //x2=8.26 //y2=7.58
r2003 (  16 18 ) resistor r=0.446141 //w=0.311 //l=1.11 //layer=m1 \
 //thickness=0.36 //x=8.26 //y=7.585 //x2=9.37 //y2=7.585
r2004 (  14 212 ) resistor r=3.1 //w=0.17 //l=0.51 //layer=mcon //count=3 \
 //x=7.15 //y=7.58 //x2=7.15 //y2=7.58
r2005 (  14 16 ) resistor r=0.446141 //w=0.311 //l=1.11 //layer=m1 \
 //thickness=0.36 //x=7.15 //y=7.585 //x2=8.26 //y2=7.585
r2006 (  12 202 ) resistor r=3.1 //w=0.17 //l=0.51 //layer=mcon //count=3 \
 //x=6.04 //y=7.58 //x2=6.04 //y2=7.58
r2007 (  12 14 ) resistor r=0.446141 //w=0.311 //l=1.11 //layer=m1 \
 //thickness=0.36 //x=6.04 //y=7.585 //x2=7.15 //y2=7.585
r2008 (  10 196 ) resistor r=3.1 //w=0.17 //l=0.51 //layer=mcon //count=3 \
 //x=4.56 //y=7.58 //x2=4.56 //y2=7.58
r2009 (  10 12 ) resistor r=0.594855 //w=0.311 //l=1.48 //layer=m1 \
 //thickness=0.36 //x=4.56 //y=7.585 //x2=6.04 //y2=7.585
r2010 (  8 186 ) resistor r=3.1 //w=0.17 //l=0.51 //layer=mcon //count=3 \
 //x=3.45 //y=7.58 //x2=3.45 //y2=7.58
r2011 (  8 10 ) resistor r=0.446141 //w=0.311 //l=1.11 //layer=m1 \
 //thickness=0.36 //x=3.45 //y=7.585 //x2=4.56 //y2=7.585
r2012 (  6 168 ) resistor r=3.1 //w=0.17 //l=0.51 //layer=mcon //count=3 \
 //x=2.34 //y=7.58 //x2=2.34 //y2=7.58
r2013 (  6 8 ) resistor r=0.446141 //w=0.311 //l=1.11 //layer=m1 \
 //thickness=0.36 //x=2.34 //y=7.585 //x2=3.45 //y2=7.585
r2014 (  3 158 ) resistor r=3.1 //w=0.17 //l=0.51 //layer=mcon //count=3 \
 //x=1.23 //y=7.58 //x2=1.23 //y2=7.58
r2015 (  3 6 ) resistor r=0.446141 //w=0.311 //l=1.11 //layer=m1 \
 //thickness=0.36 //x=1.23 //y=7.585 //x2=2.34 //y2=7.585
r2016 (  1 79 ) resistor r=0.223071 //w=0.311 //l=0.555 //layer=m1 \
 //thickness=0.36 //x=45.445 //y=7.585 //x2=46 //y2=7.585
r2017 (  1 76 ) resistor r=0.223071 //w=0.311 //l=0.555 //layer=m1 \
 //thickness=0.36 //x=45.445 //y=7.585 //x2=44.89 //y2=7.585
ends PM_TMRDFFRNQX1\%VDD

subckt PM_TMRDFFRNQX1\%noxref_3 ( 1 2 3 4 12 25 26 33 41 47 48 52 54 61 62 63 \
 64 65 66 67 68 72 73 74 79 81 84 85 86 87 88 89 93 95 98 99 104 105 110 119 \
 122 124 125 126 )
c250 ( 126 0 ) capacitor c=0.023087f //x=8.445 //y=5.2
c251 ( 125 0 ) capacitor c=0.023519f //x=7.565 //y=5.2
c252 ( 124 0 ) capacitor c=0.0224735f //x=6.685 //y=5.2
c253 ( 122 0 ) capacitor c=0.00872971f //x=8.695 //y=1.095
c254 ( 119 0 ) capacitor c=0.0588816f //x=11.22 //y=4.88
c255 ( 110 0 ) capacitor c=0.058931f //x=3.82 //y=4.88
c256 ( 105 0 ) capacitor c=0.0273931f //x=3.82 //y=2.095
c257 ( 104 0 ) capacitor c=0.0464411f //x=3.82 //y=2.26
c258 ( 99 0 ) capacitor c=0.0318948f //x=11.555 //y=1.39
c259 ( 98 0 ) capacitor c=0.0187384f //x=11.555 //y=1.045
c260 ( 95 0 ) capacitor c=0.0141798f //x=11.4 //y=1.545
c261 ( 93 0 ) capacitor c=0.0149844f //x=11.4 //y=0.89
c262 ( 89 0 ) capacitor c=0.0813322f //x=11.025 //y=2.095
c263 ( 88 0 ) capacitor c=0.0229267f //x=11.025 //y=1.7
c264 ( 87 0 ) capacitor c=0.0234352f //x=11.025 //y=1.39
c265 ( 86 0 ) capacitor c=0.0199343f //x=11.025 //y=1.045
c266 ( 85 0 ) capacitor c=0.0432517f //x=4.34 //y=1.44
c267 ( 84 0 ) capacitor c=0.0200379f //x=4.34 //y=1.095
c268 ( 81 0 ) capacitor c=0.0158629f //x=4.185 //y=1.595
c269 ( 79 0 ) capacitor c=0.0157803f //x=4.185 //y=0.94
c270 ( 74 0 ) capacitor c=0.0218028f //x=3.81 //y=1.75
c271 ( 73 0 ) capacitor c=0.0207459f //x=3.81 //y=1.44
c272 ( 72 0 ) capacitor c=0.0194308f //x=3.81 //y=1.095
c273 ( 68 0 ) capacitor c=0.110275f //x=11.56 //y=6.2
c274 ( 67 0 ) capacitor c=0.154305f //x=11.12 //y=6.2
c275 ( 66 0 ) capacitor c=0.158794f //x=4 //y=6.2
c276 ( 65 0 ) capacitor c=0.110114f //x=3.56 //y=6.2
c277 ( 62 0 ) capacitor c=0.00106608f //x=8.59 //y=5.335
c278 ( 61 0 ) capacitor c=0.00207319f //x=7.71 //y=5.335
c279 ( 54 0 ) capacitor c=0.0872487f //x=11.22 //y=2.26
c280 ( 52 0 ) capacitor c=0.10679f //x=9.37 //y=3.51
c281 ( 48 0 ) capacitor c=0.00398962f //x=8.97 //y=1.845
c282 ( 47 0 ) capacitor c=0.0137288f //x=9.285 //y=1.845
c283 ( 41 0 ) capacitor c=0.0284988f //x=9.285 //y=5.335
c284 ( 33 0 ) capacitor c=0.0176454f //x=8.505 //y=5.335
c285 ( 26 0 ) capacitor c=0.00332903f //x=6.915 //y=5.335
c286 ( 25 0 ) capacitor c=0.0148427f //x=7.625 //y=5.335
c287 ( 12 0 ) capacitor c=0.0883349f //x=3.82 //y=2.26
c288 ( 4 0 ) capacitor c=0.00455264f //x=9.485 //y=3.51
c289 ( 3 0 ) capacitor c=0.0402401f //x=11.105 //y=3.51
c290 ( 2 0 ) capacitor c=0.0164246f //x=3.935 //y=3.51
c291 ( 1 0 ) capacitor c=0.130412f //x=9.255 //y=3.51
r292 (  117 119 ) resistor r=20.6867 //w=0.233 //l=0.1 //layer=ply \
 //thickness=0.18 //x=11.12 //y=4.88 //x2=11.22 //y2=4.88
r293 (  104 105 ) resistor r=52.7279 //w=0.214 //l=0.165 //layer=ply \
 //thickness=0.18 //x=3.82 //y=2.26 //x2=3.82 //y2=2.095
r294 (  100 119 ) resistor r=70.3348 //w=0.233 //l=0.414367 //layer=ply \
 //thickness=0.18 //x=11.56 //y=5.045 //x2=11.22 //y2=4.88
r295 (  99 121 ) resistor r=45.1352 //w=0.168 //l=0.173853 //layer=ply \
 //thickness=0.18 //x=11.555 //y=1.39 //x2=11.515 //y2=1.545
r296 (  98 120 ) resistor r=45.1352 //w=0.168 //l=0.173853 //layer=ply \
 //thickness=0.18 //x=11.555 //y=1.045 //x2=11.515 //y2=0.89
r297 (  98 99 ) resistor r=176.904 //w=0.094 //l=0.345 //layer=ply \
 //thickness=0.18 //x=11.555 //y=1.045 //x2=11.555 //y2=1.39
r298 (  96 116 ) resistor r=10.701 //w=0.21 //l=0.115 //layer=ply \
 //thickness=0.18 //x=11.18 //y=1.545 //x2=11.065 //y2=1.545
r299 (  95 121 ) resistor r=5.52526 //w=0.168 //l=0.115 //layer=ply \
 //thickness=0.18 //x=11.4 //y=1.545 //x2=11.515 //y2=1.545
r300 (  94 115 ) resistor r=5.52526 //w=0.168 //l=0.115 //layer=ply \
 //thickness=0.18 //x=11.18 //y=0.89 //x2=11.065 //y2=0.89
r301 (  93 120 ) resistor r=5.52526 //w=0.168 //l=0.115 //layer=ply \
 //thickness=0.18 //x=11.4 //y=0.89 //x2=11.515 //y2=0.89
r302 (  93 94 ) resistor r=112.809 //w=0.094 //l=0.22 //layer=ply \
 //thickness=0.18 //x=11.4 //y=0.89 //x2=11.18 //y2=0.89
r303 (  90 117 ) resistor r=13.0941 //w=0.233 //l=0.165 //layer=ply \
 //thickness=0.18 //x=11.12 //y=5.045 //x2=11.12 //y2=4.88
r304 (  89 114 ) resistor r=34.8111 //w=0.27 //l=0.264953 //layer=ply \
 //thickness=0.18 //x=11.025 //y=2.095 //x2=11.22 //y2=2.26
r305 (  88 116 ) resistor r=39.5823 //w=0.21 //l=0.173853 //layer=ply \
 //thickness=0.18 //x=11.025 //y=1.7 //x2=11.065 //y2=1.545
r306 (  88 89 ) resistor r=202.543 //w=0.094 //l=0.395 //layer=ply \
 //thickness=0.18 //x=11.025 //y=1.7 //x2=11.025 //y2=2.095
r307 (  87 116 ) resistor r=39.5823 //w=0.21 //l=0.173853 //layer=ply \
 //thickness=0.18 //x=11.025 //y=1.39 //x2=11.065 //y2=1.545
r308 (  86 115 ) resistor r=45.1352 //w=0.168 //l=0.173853 //layer=ply \
 //thickness=0.18 //x=11.025 //y=1.045 //x2=11.065 //y2=0.89
r309 (  86 87 ) resistor r=176.904 //w=0.094 //l=0.345 //layer=ply \
 //thickness=0.18 //x=11.025 //y=1.045 //x2=11.025 //y2=1.39
r310 (  85 112 ) resistor r=45.1352 //w=0.168 //l=0.173853 //layer=ply \
 //thickness=0.18 //x=4.34 //y=1.44 //x2=4.3 //y2=1.595
r311 (  84 111 ) resistor r=45.1352 //w=0.168 //l=0.173853 //layer=ply \
 //thickness=0.18 //x=4.34 //y=1.095 //x2=4.3 //y2=0.94
r312 (  84 85 ) resistor r=176.904 //w=0.094 //l=0.345 //layer=ply \
 //thickness=0.18 //x=4.34 //y=1.095 //x2=4.34 //y2=1.44
r313 (  82 108 ) resistor r=10.701 //w=0.21 //l=0.115 //layer=ply \
 //thickness=0.18 //x=3.965 //y=1.595 //x2=3.85 //y2=1.595
r314 (  81 112 ) resistor r=5.52526 //w=0.168 //l=0.115 //layer=ply \
 //thickness=0.18 //x=4.185 //y=1.595 //x2=4.3 //y2=1.595
r315 (  80 107 ) resistor r=5.52526 //w=0.168 //l=0.115 //layer=ply \
 //thickness=0.18 //x=3.965 //y=0.94 //x2=3.85 //y2=0.94
r316 (  79 111 ) resistor r=5.52526 //w=0.168 //l=0.115 //layer=ply \
 //thickness=0.18 //x=4.185 //y=0.94 //x2=4.3 //y2=0.94
r317 (  79 80 ) resistor r=112.809 //w=0.094 //l=0.22 //layer=ply \
 //thickness=0.18 //x=4.185 //y=0.94 //x2=3.965 //y2=0.94
r318 (  76 110 ) resistor r=37.236 //w=0.233 //l=0.249199 //layer=ply \
 //thickness=0.18 //x=4 //y=5.045 //x2=3.82 //y2=4.88
r319 (  74 108 ) resistor r=39.5823 //w=0.21 //l=0.173853 //layer=ply \
 //thickness=0.18 //x=3.81 //y=1.75 //x2=3.85 //y2=1.595
r320 (  74 105 ) resistor r=176.904 //w=0.094 //l=0.345 //layer=ply \
 //thickness=0.18 //x=3.81 //y=1.75 //x2=3.81 //y2=2.095
r321 (  73 108 ) resistor r=39.5823 //w=0.21 //l=0.173853 //layer=ply \
 //thickness=0.18 //x=3.81 //y=1.44 //x2=3.85 //y2=1.595
r322 (  72 107 ) resistor r=45.1352 //w=0.168 //l=0.173853 //layer=ply \
 //thickness=0.18 //x=3.81 //y=1.095 //x2=3.85 //y2=0.94
r323 (  72 73 ) resistor r=176.904 //w=0.094 //l=0.345 //layer=ply \
 //thickness=0.18 //x=3.81 //y=1.095 //x2=3.81 //y2=1.44
r324 (  69 110 ) resistor r=53.7854 //w=0.233 //l=0.332415 //layer=ply \
 //thickness=0.18 //x=3.56 //y=5.045 //x2=3.82 //y2=4.88
r325 (  68 100 ) resistor r=592.245 //w=0.094 //l=1.155 //layer=ply \
 //thickness=0.18 //x=11.56 //y=6.2 //x2=11.56 //y2=5.045
r326 (  67 90 ) resistor r=592.245 //w=0.094 //l=1.155 //layer=ply \
 //thickness=0.18 //x=11.12 //y=6.2 //x2=11.12 //y2=5.045
r327 (  66 76 ) resistor r=592.245 //w=0.094 //l=1.155 //layer=ply \
 //thickness=0.18 //x=4 //y=6.2 //x2=4 //y2=5.045
r328 (  65 69 ) resistor r=592.245 //w=0.094 //l=1.155 //layer=ply \
 //thickness=0.18 //x=3.56 //y=6.2 //x2=3.56 //y2=5.045
r329 (  64 95 ) resistor r=56.4043 //w=0.094 //l=0.11 //layer=ply \
 //thickness=0.18 //x=11.29 //y=1.545 //x2=11.4 //y2=1.545
r330 (  64 96 ) resistor r=56.4043 //w=0.094 //l=0.11 //layer=ply \
 //thickness=0.18 //x=11.29 //y=1.545 //x2=11.18 //y2=1.545
r331 (  63 81 ) resistor r=56.4043 //w=0.094 //l=0.11 //layer=ply \
 //thickness=0.18 //x=4.075 //y=1.595 //x2=4.185 //y2=1.595
r332 (  63 82 ) resistor r=56.4043 //w=0.094 //l=0.11 //layer=ply \
 //thickness=0.18 //x=4.075 //y=1.595 //x2=3.965 //y2=1.595
r333 (  59 119 ) resistor r=152 //w=0.17 //l=0.17 //layer=licon //count=1 \
 //x=11.22 //y=4.88 //x2=11.22 //y2=4.88
r334 (  57 59 ) resistor r=93.7754 //w=0.187 //l=1.37 //layer=li \
 //thickness=0.1 //x=11.22 //y=3.51 //x2=11.22 //y2=4.88
r335 (  54 114 ) resistor r=152 //w=0.17 //l=0.17 //layer=licon //count=1 \
 //x=11.22 //y=2.26 //x2=11.22 //y2=2.26
r336 (  54 57 ) resistor r=85.5615 //w=0.187 //l=1.25 //layer=li \
 //thickness=0.1 //x=11.22 //y=2.26 //x2=11.22 //y2=3.51
r337 (  50 52 ) resistor r=119.102 //w=0.187 //l=1.74 //layer=li \
 //thickness=0.1 //x=9.37 //y=5.25 //x2=9.37 //y2=3.51
r338 (  49 52 ) resistor r=108.15 //w=0.187 //l=1.58 //layer=li \
 //thickness=0.1 //x=9.37 //y=1.93 //x2=9.37 //y2=3.51
r339 (  47 49 ) resistor r=7.15173 //w=0.17 //l=0.120208 //layer=li \
 //thickness=0.1 //x=9.285 //y=1.845 //x2=9.37 //y2=1.93
r340 (  47 48 ) resistor r=21.5615 //w=0.187 //l=0.315 //layer=li \
 //thickness=0.1 //x=9.285 //y=1.845 //x2=8.97 //y2=1.845
r341 (  43 48 ) resistor r=7.15173 //w=0.17 //l=0.120208 //layer=li \
 //thickness=0.1 //x=8.885 //y=1.76 //x2=8.97 //y2=1.845
r342 (  43 122 ) resistor r=39.016 //w=0.187 //l=0.57 //layer=li \
 //thickness=0.1 //x=8.885 //y=1.76 //x2=8.885 //y2=1.19
r343 (  42 62 ) resistor r=5.4201 //w=0.17 //l=0.085 //layer=li \
 //thickness=0.1 //x=8.675 //y=5.335 //x2=8.59 //y2=5.335
r344 (  41 50 ) resistor r=7.15173 //w=0.17 //l=0.120208 //layer=li \
 //thickness=0.1 //x=9.285 //y=5.335 //x2=9.37 //y2=5.25
r345 (  41 42 ) resistor r=41.754 //w=0.187 //l=0.61 //layer=li \
 //thickness=0.1 //x=9.285 //y=5.335 //x2=8.675 //y2=5.335
r346 (  35 62 ) resistor r=1.40859 //w=0.34 //l=0.085 //layer=li \
 //thickness=0.1 //x=8.59 //y=5.42 //x2=8.59 //y2=5.335
r347 (  35 126 ) resistor r=33.1979 //w=0.187 //l=0.485 //layer=li \
 //thickness=0.1 //x=8.59 //y=5.42 //x2=8.59 //y2=5.905
r348 (  34 61 ) resistor r=5.4201 //w=0.17 //l=0.085 //layer=li \
 //thickness=0.1 //x=7.795 //y=5.335 //x2=7.71 //y2=5.335
r349 (  33 62 ) resistor r=5.4201 //w=0.17 //l=0.085 //layer=li \
 //thickness=0.1 //x=8.505 //y=5.335 //x2=8.59 //y2=5.335
r350 (  33 34 ) resistor r=48.5989 //w=0.187 //l=0.71 //layer=li \
 //thickness=0.1 //x=8.505 //y=5.335 //x2=7.795 //y2=5.335
r351 (  27 61 ) resistor r=1.40859 //w=0.34 //l=0.085 //layer=li \
 //thickness=0.1 //x=7.71 //y=5.42 //x2=7.71 //y2=5.335
r352 (  27 125 ) resistor r=33.1979 //w=0.187 //l=0.485 //layer=li \
 //thickness=0.1 //x=7.71 //y=5.42 //x2=7.71 //y2=5.905
r353 (  25 61 ) resistor r=5.4201 //w=0.17 //l=0.085 //layer=li \
 //thickness=0.1 //x=7.625 //y=5.335 //x2=7.71 //y2=5.335
r354 (  25 26 ) resistor r=48.5989 //w=0.187 //l=0.71 //layer=li \
 //thickness=0.1 //x=7.625 //y=5.335 //x2=6.915 //y2=5.335
r355 (  19 26 ) resistor r=7.15173 //w=0.17 //l=0.120208 //layer=li \
 //thickness=0.1 //x=6.83 //y=5.42 //x2=6.915 //y2=5.335
r356 (  19 124 ) resistor r=33.1979 //w=0.187 //l=0.485 //layer=li \
 //thickness=0.1 //x=6.83 //y=5.42 //x2=6.83 //y2=5.905
r357 (  17 110 ) resistor r=152 //w=0.17 //l=0.17 //layer=licon //count=1 \
 //x=3.82 //y=4.88 //x2=3.82 //y2=4.88
r358 (  15 17 ) resistor r=93.7754 //w=0.187 //l=1.37 //layer=li \
 //thickness=0.1 //x=3.82 //y=3.51 //x2=3.82 //y2=4.88
r359 (  12 104 ) resistor r=152 //w=0.17 //l=0.17 //layer=licon //count=1 \
 //x=3.82 //y=2.26 //x2=3.82 //y2=2.26
r360 (  12 15 ) resistor r=85.5615 //w=0.187 //l=1.25 //layer=li \
 //thickness=0.1 //x=3.82 //y=2.26 //x2=3.82 //y2=3.51
r361 (  10 57 ) resistor r=9.3 //w=0.17 //l=0.17 //layer=mcon //count=1 \
 //x=11.22 //y=3.51 //x2=11.22 //y2=3.51
r362 (  8 52 ) resistor r=9.3 //w=0.17 //l=0.17 //layer=mcon //count=1 \
 //x=9.37 //y=3.51 //x2=9.37 //y2=3.51
r363 (  6 15 ) resistor r=9.3 //w=0.17 //l=0.17 //layer=mcon //count=1 \
 //x=3.82 //y=3.51 //x2=3.82 //y2=3.51
r364 (  4 8 ) resistor r=0.0880901 //w=0.191 //l=0.115 //layer=m1 \
 //thickness=0.36 //x=9.485 //y=3.51 //x2=9.37 //y2=3.51
r365 (  3 10 ) resistor r=0.0717383 //w=0.224 //l=0.115 //layer=m1 \
 //thickness=0.36 //x=11.105 //y=3.51 //x2=11.22 //y2=3.51
r366 (  3 4 ) resistor r=1.5458 //w=0.131 //l=1.62 //layer=m1 //thickness=0.36 \
 //x=11.105 //y=3.51 //x2=9.485 //y2=3.51
r367 (  2 6 ) resistor r=0.0717383 //w=0.224 //l=0.115 //layer=m1 \
 //thickness=0.36 //x=3.935 //y=3.51 //x2=3.82 //y2=3.51
r368 (  1 8 ) resistor r=0.0880901 //w=0.191 //l=0.115 //layer=m1 \
 //thickness=0.36 //x=9.255 //y=3.51 //x2=9.37 //y2=3.51
r369 (  1 2 ) resistor r=5.07634 //w=0.131 //l=5.32 //layer=m1 \
 //thickness=0.36 //x=9.255 //y=3.51 //x2=3.935 //y2=3.51
ends PM_TMRDFFRNQX1\%noxref_3

subckt PM_TMRDFFRNQX1\%noxref_4 ( 1 2 13 14 25 27 28 32 34 41 42 43 44 45 46 \
 47 48 49 51 57 58 59 60 72 74 75 )
c152 ( 75 0 ) capacitor c=0.0220291f //x=12.075 //y=5.2
c153 ( 74 0 ) capacitor c=0.0217503f //x=11.195 //y=5.2
c154 ( 72 0 ) capacitor c=0.0084702f //x=12.07 //y=1.085
c155 ( 60 0 ) capacitor c=0.0557698f //x=14.825 //y=4.97
c156 ( 59 0 ) capacitor c=0.0293157f //x=15.115 //y=4.97
c157 ( 58 0 ) capacitor c=0.0347816f //x=14.78 //y=1.4
c158 ( 57 0 ) capacitor c=0.0187487f //x=14.78 //y=1.055
c159 ( 51 0 ) capacitor c=0.0137055f //x=14.625 //y=1.555
c160 ( 49 0 ) capacitor c=0.0149861f //x=14.625 //y=0.9
c161 ( 48 0 ) capacitor c=0.096037f //x=14.25 //y=2.095
c162 ( 47 0 ) capacitor c=0.0228993f //x=14.25 //y=1.71
c163 ( 46 0 ) capacitor c=0.0234352f //x=14.25 //y=1.4
c164 ( 45 0 ) capacitor c=0.0198724f //x=14.25 //y=1.055
c165 ( 44 0 ) capacitor c=0.110114f //x=15.19 //y=6.2
c166 ( 43 0 ) capacitor c=0.158956f //x=14.75 //y=6.2
c167 ( 41 0 ) capacitor c=0.00211606f //x=12.22 //y=5.38
c168 ( 34 0 ) capacitor c=0.0970289f //x=14.55 //y=2.26
c169 ( 32 0 ) capacitor c=0.105815f //x=12.7 //y=3.51
c170 ( 28 0 ) capacitor c=0.00404073f //x=12.345 //y=1.835
c171 ( 27 0 ) capacitor c=0.0122201f //x=12.615 //y=1.835
c172 ( 25 0 ) capacitor c=0.0137995f //x=12.615 //y=5.38
c173 ( 14 0 ) capacitor c=0.00251635f //x=11.425 //y=5.38
c174 ( 13 0 ) capacitor c=0.0143649f //x=12.135 //y=5.38
c175 ( 2 0 ) capacitor c=0.00703116f //x=12.815 //y=3.51
c176 ( 1 0 ) capacitor c=0.0456992f //x=14.435 //y=3.51
r177 (  59 61 ) resistor r=26.9307 //w=0.15 //l=0.106066 //layer=ply \
 //thickness=0.18 //x=15.115 //y=4.97 //x2=15.19 //y2=5.045
r178 (  59 60 ) resistor r=148.702 //w=0.094 //l=0.29 //layer=ply \
 //thickness=0.18 //x=15.115 //y=4.97 //x2=14.825 //y2=4.97
r179 (  58 71 ) resistor r=45.1352 //w=0.168 //l=0.173853 //layer=ply \
 //thickness=0.18 //x=14.78 //y=1.4 //x2=14.74 //y2=1.555
r180 (  57 70 ) resistor r=45.1352 //w=0.168 //l=0.173853 //layer=ply \
 //thickness=0.18 //x=14.78 //y=1.055 //x2=14.74 //y2=0.9
r181 (  57 58 ) resistor r=176.904 //w=0.094 //l=0.345 //layer=ply \
 //thickness=0.18 //x=14.78 //y=1.055 //x2=14.78 //y2=1.4
r182 (  54 60 ) resistor r=22.7971 //w=0.269 //l=0.106066 //layer=ply \
 //thickness=0.18 //x=14.75 //y=5.045 //x2=14.825 //y2=4.97
r183 (  54 69 ) resistor r=35.8364 //w=0.269 //l=0.270185 //layer=ply \
 //thickness=0.18 //x=14.75 //y=5.045 //x2=14.55 //y2=4.88
r184 (  52 65 ) resistor r=10.701 //w=0.21 //l=0.115 //layer=ply \
 //thickness=0.18 //x=14.405 //y=1.555 //x2=14.29 //y2=1.555
r185 (  51 71 ) resistor r=5.52526 //w=0.168 //l=0.115 //layer=ply \
 //thickness=0.18 //x=14.625 //y=1.555 //x2=14.74 //y2=1.555
r186 (  50 64 ) resistor r=5.52526 //w=0.168 //l=0.115 //layer=ply \
 //thickness=0.18 //x=14.405 //y=0.9 //x2=14.29 //y2=0.9
r187 (  49 70 ) resistor r=5.52526 //w=0.168 //l=0.115 //layer=ply \
 //thickness=0.18 //x=14.625 //y=0.9 //x2=14.74 //y2=0.9
r188 (  49 50 ) resistor r=112.809 //w=0.094 //l=0.22 //layer=ply \
 //thickness=0.18 //x=14.625 //y=0.9 //x2=14.405 //y2=0.9
r189 (  48 67 ) resistor r=58.7805 //w=0.246 //l=0.373497 //layer=ply \
 //thickness=0.18 //x=14.25 //y=2.095 //x2=14.55 //y2=2.26
r190 (  47 65 ) resistor r=39.5823 //w=0.21 //l=0.173853 //layer=ply \
 //thickness=0.18 //x=14.25 //y=1.71 //x2=14.29 //y2=1.555
r191 (  47 48 ) resistor r=197.415 //w=0.094 //l=0.385 //layer=ply \
 //thickness=0.18 //x=14.25 //y=1.71 //x2=14.25 //y2=2.095
r192 (  46 65 ) resistor r=39.5823 //w=0.21 //l=0.173853 //layer=ply \
 //thickness=0.18 //x=14.25 //y=1.4 //x2=14.29 //y2=1.555
r193 (  45 64 ) resistor r=45.1352 //w=0.168 //l=0.173853 //layer=ply \
 //thickness=0.18 //x=14.25 //y=1.055 //x2=14.29 //y2=0.9
r194 (  45 46 ) resistor r=176.904 //w=0.094 //l=0.345 //layer=ply \
 //thickness=0.18 //x=14.25 //y=1.055 //x2=14.25 //y2=1.4
r195 (  44 61 ) resistor r=592.245 //w=0.094 //l=1.155 //layer=ply \
 //thickness=0.18 //x=15.19 //y=6.2 //x2=15.19 //y2=5.045
r196 (  43 54 ) resistor r=592.245 //w=0.094 //l=1.155 //layer=ply \
 //thickness=0.18 //x=14.75 //y=6.2 //x2=14.75 //y2=5.045
r197 (  42 51 ) resistor r=56.4043 //w=0.094 //l=0.11 //layer=ply \
 //thickness=0.18 //x=14.515 //y=1.555 //x2=14.625 //y2=1.555
r198 (  42 52 ) resistor r=56.4043 //w=0.094 //l=0.11 //layer=ply \
 //thickness=0.18 //x=14.515 //y=1.555 //x2=14.405 //y2=1.555
r199 (  39 69 ) resistor r=152 //w=0.17 //l=0.17 //layer=licon //count=1 \
 //x=14.55 //y=4.88 //x2=14.55 //y2=4.88
r200 (  37 39 ) resistor r=93.7754 //w=0.187 //l=1.37 //layer=li \
 //thickness=0.1 //x=14.55 //y=3.51 //x2=14.55 //y2=4.88
r201 (  34 67 ) resistor r=152 //w=0.17 //l=0.17 //layer=licon //count=1 \
 //x=14.55 //y=2.26 //x2=14.55 //y2=2.26
r202 (  34 37 ) resistor r=85.5615 //w=0.187 //l=1.25 //layer=li \
 //thickness=0.1 //x=14.55 //y=2.26 //x2=14.55 //y2=3.51
r203 (  30 32 ) resistor r=122.182 //w=0.187 //l=1.785 //layer=li \
 //thickness=0.1 //x=12.7 //y=5.295 //x2=12.7 //y2=3.51
r204 (  29 32 ) resistor r=108.834 //w=0.187 //l=1.59 //layer=li \
 //thickness=0.1 //x=12.7 //y=1.92 //x2=12.7 //y2=3.51
r205 (  27 29 ) resistor r=7.15173 //w=0.17 //l=0.120208 //layer=li \
 //thickness=0.1 //x=12.615 //y=1.835 //x2=12.7 //y2=1.92
r206 (  27 28 ) resistor r=18.4813 //w=0.187 //l=0.27 //layer=li \
 //thickness=0.1 //x=12.615 //y=1.835 //x2=12.345 //y2=1.835
r207 (  26 41 ) resistor r=5.4201 //w=0.17 //l=0.085 //layer=li \
 //thickness=0.1 //x=12.305 //y=5.38 //x2=12.22 //y2=5.38
r208 (  25 30 ) resistor r=7.15173 //w=0.17 //l=0.120208 //layer=li \
 //thickness=0.1 //x=12.615 //y=5.38 //x2=12.7 //y2=5.295
r209 (  25 26 ) resistor r=21.2193 //w=0.187 //l=0.31 //layer=li \
 //thickness=0.1 //x=12.615 //y=5.38 //x2=12.305 //y2=5.38
r210 (  21 28 ) resistor r=7.15173 //w=0.17 //l=0.120208 //layer=li \
 //thickness=0.1 //x=12.26 //y=1.75 //x2=12.345 //y2=1.835
r211 (  21 72 ) resistor r=39.016 //w=0.187 //l=0.57 //layer=li \
 //thickness=0.1 //x=12.26 //y=1.75 //x2=12.26 //y2=1.18
r212 (  15 41 ) resistor r=1.40859 //w=0.34 //l=0.085 //layer=li \
 //thickness=0.1 //x=12.22 //y=5.465 //x2=12.22 //y2=5.38
r213 (  15 75 ) resistor r=30.1176 //w=0.187 //l=0.44 //layer=li \
 //thickness=0.1 //x=12.22 //y=5.465 //x2=12.22 //y2=5.905
r214 (  13 41 ) resistor r=5.4201 //w=0.17 //l=0.085 //layer=li \
 //thickness=0.1 //x=12.135 //y=5.38 //x2=12.22 //y2=5.38
r215 (  13 14 ) resistor r=48.5989 //w=0.187 //l=0.71 //layer=li \
 //thickness=0.1 //x=12.135 //y=5.38 //x2=11.425 //y2=5.38
r216 (  7 14 ) resistor r=7.15173 //w=0.17 //l=0.120208 //layer=li \
 //thickness=0.1 //x=11.34 //y=5.465 //x2=11.425 //y2=5.38
r217 (  7 74 ) resistor r=30.1176 //w=0.187 //l=0.44 //layer=li \
 //thickness=0.1 //x=11.34 //y=5.465 //x2=11.34 //y2=5.905
r218 (  6 37 ) resistor r=9.3 //w=0.17 //l=0.17 //layer=mcon //count=1 \
 //x=14.55 //y=3.51 //x2=14.55 //y2=3.51
r219 (  4 32 ) resistor r=9.3 //w=0.17 //l=0.17 //layer=mcon //count=1 \
 //x=12.7 //y=3.51 //x2=12.7 //y2=3.51
r220 (  2 4 ) resistor r=0.0717383 //w=0.224 //l=0.115 //layer=m1 \
 //thickness=0.36 //x=12.815 //y=3.51 //x2=12.7 //y2=3.51
r221 (  1 6 ) resistor r=0.0717383 //w=0.224 //l=0.115 //layer=m1 \
 //thickness=0.36 //x=14.435 //y=3.51 //x2=14.55 //y2=3.51
r222 (  1 2 ) resistor r=1.5458 //w=0.131 //l=1.62 //layer=m1 //thickness=0.36 \
 //x=14.435 //y=3.51 //x2=12.815 //y2=3.51
ends PM_TMRDFFRNQX1\%noxref_4

subckt PM_TMRDFFRNQX1\%noxref_5 ( 1 2 3 4 17 18 25 33 39 40 44 46 54 61 62 63 \
 64 65 66 67 68 69 70 71 72 73 75 81 82 83 84 88 89 90 91 92 94 100 101 102 \
 103 123 125 126 127 )
c253 ( 127 0 ) capacitor c=0.023087f //x=3.635 //y=5.2
c254 ( 126 0 ) capacitor c=0.023519f //x=2.755 //y=5.2
c255 ( 125 0 ) capacitor c=0.0224735f //x=1.875 //y=5.2
c256 ( 123 0 ) capacitor c=0.00853354f //x=3.885 //y=1.095
c257 ( 103 0 ) capacitor c=0.0556143f //x=19.635 //y=4.97
c258 ( 102 0 ) capacitor c=0.0293157f //x=19.925 //y=4.97
c259 ( 101 0 ) capacitor c=0.0347816f //x=19.59 //y=1.4
c260 ( 100 0 ) capacitor c=0.0187487f //x=19.59 //y=1.055
c261 ( 94 0 ) capacitor c=0.0137055f //x=19.435 //y=1.555
c262 ( 92 0 ) capacitor c=0.0149861f //x=19.435 //y=0.9
c263 ( 91 0 ) capacitor c=0.096037f //x=19.06 //y=2.095
c264 ( 90 0 ) capacitor c=0.0228993f //x=19.06 //y=1.71
c265 ( 89 0 ) capacitor c=0.0234352f //x=19.06 //y=1.4
c266 ( 88 0 ) capacitor c=0.0198724f //x=19.06 //y=1.055
c267 ( 84 0 ) capacitor c=0.0556143f //x=6.685 //y=4.97
c268 ( 83 0 ) capacitor c=0.0293157f //x=6.975 //y=4.97
c269 ( 82 0 ) capacitor c=0.0347816f //x=6.64 //y=1.4
c270 ( 81 0 ) capacitor c=0.0187487f //x=6.64 //y=1.055
c271 ( 75 0 ) capacitor c=0.0137055f //x=6.485 //y=1.555
c272 ( 73 0 ) capacitor c=0.0149861f //x=6.485 //y=0.9
c273 ( 72 0 ) capacitor c=0.102158f //x=6.11 //y=2.095
c274 ( 71 0 ) capacitor c=0.0229444f //x=6.11 //y=1.71
c275 ( 70 0 ) capacitor c=0.0234352f //x=6.11 //y=1.4
c276 ( 69 0 ) capacitor c=0.0198724f //x=6.11 //y=1.055
c277 ( 68 0 ) capacitor c=0.110114f //x=20 //y=6.2
c278 ( 67 0 ) capacitor c=0.158956f //x=19.56 //y=6.2
c279 ( 66 0 ) capacitor c=0.110114f //x=7.05 //y=6.2
c280 ( 65 0 ) capacitor c=0.158956f //x=6.61 //y=6.2
c281 ( 62 0 ) capacitor c=0.00106608f //x=3.78 //y=5.335
c282 ( 61 0 ) capacitor c=0.00207162f //x=2.9 //y=5.335
c283 ( 54 0 ) capacitor c=0.100095f //x=19.36 //y=2.26
c284 ( 46 0 ) capacitor c=0.101432f //x=6.41 //y=2.26
c285 ( 44 0 ) capacitor c=0.109588f //x=4.56 //y=3.88
c286 ( 40 0 ) capacitor c=0.00493499f //x=4.16 //y=1.845
c287 ( 39 0 ) capacitor c=0.0154052f //x=4.475 //y=1.845
c288 ( 33 0 ) capacitor c=0.0283082f //x=4.475 //y=5.335
c289 ( 25 0 ) capacitor c=0.0176454f //x=3.695 //y=5.335
c290 ( 18 0 ) capacitor c=0.00351598f //x=2.105 //y=5.335
c291 ( 17 0 ) capacitor c=0.0154196f //x=2.815 //y=5.335
c292 ( 4 0 ) capacitor c=0.00424246f //x=6.525 //y=3.88
c293 ( 3 0 ) capacitor c=0.229463f //x=19.245 //y=3.88
c294 ( 2 0 ) capacitor c=0.0125346f //x=4.675 //y=3.88
c295 ( 1 0 ) capacitor c=0.0288301f //x=6.295 //y=3.88
r296 (  102 104 ) resistor r=26.9307 //w=0.15 //l=0.106066 //layer=ply \
 //thickness=0.18 //x=19.925 //y=4.97 //x2=20 //y2=5.045
r297 (  102 103 ) resistor r=148.702 //w=0.094 //l=0.29 //layer=ply \
 //thickness=0.18 //x=19.925 //y=4.97 //x2=19.635 //y2=4.97
r298 (  101 122 ) resistor r=45.1352 //w=0.168 //l=0.173853 //layer=ply \
 //thickness=0.18 //x=19.59 //y=1.4 //x2=19.55 //y2=1.555
r299 (  100 121 ) resistor r=45.1352 //w=0.168 //l=0.173853 //layer=ply \
 //thickness=0.18 //x=19.59 //y=1.055 //x2=19.55 //y2=0.9
r300 (  100 101 ) resistor r=176.904 //w=0.094 //l=0.345 //layer=ply \
 //thickness=0.18 //x=19.59 //y=1.055 //x2=19.59 //y2=1.4
r301 (  97 103 ) resistor r=22.7971 //w=0.269 //l=0.106066 //layer=ply \
 //thickness=0.18 //x=19.56 //y=5.045 //x2=19.635 //y2=4.97
r302 (  97 120 ) resistor r=35.8364 //w=0.269 //l=0.270185 //layer=ply \
 //thickness=0.18 //x=19.56 //y=5.045 //x2=19.36 //y2=4.88
r303 (  95 116 ) resistor r=10.701 //w=0.21 //l=0.115 //layer=ply \
 //thickness=0.18 //x=19.215 //y=1.555 //x2=19.1 //y2=1.555
r304 (  94 122 ) resistor r=5.52526 //w=0.168 //l=0.115 //layer=ply \
 //thickness=0.18 //x=19.435 //y=1.555 //x2=19.55 //y2=1.555
r305 (  93 115 ) resistor r=5.52526 //w=0.168 //l=0.115 //layer=ply \
 //thickness=0.18 //x=19.215 //y=0.9 //x2=19.1 //y2=0.9
r306 (  92 121 ) resistor r=5.52526 //w=0.168 //l=0.115 //layer=ply \
 //thickness=0.18 //x=19.435 //y=0.9 //x2=19.55 //y2=0.9
r307 (  92 93 ) resistor r=112.809 //w=0.094 //l=0.22 //layer=ply \
 //thickness=0.18 //x=19.435 //y=0.9 //x2=19.215 //y2=0.9
r308 (  91 118 ) resistor r=58.7805 //w=0.246 //l=0.373497 //layer=ply \
 //thickness=0.18 //x=19.06 //y=2.095 //x2=19.36 //y2=2.26
r309 (  90 116 ) resistor r=39.5823 //w=0.21 //l=0.173853 //layer=ply \
 //thickness=0.18 //x=19.06 //y=1.71 //x2=19.1 //y2=1.555
r310 (  90 91 ) resistor r=197.415 //w=0.094 //l=0.385 //layer=ply \
 //thickness=0.18 //x=19.06 //y=1.71 //x2=19.06 //y2=2.095
r311 (  89 116 ) resistor r=39.5823 //w=0.21 //l=0.173853 //layer=ply \
 //thickness=0.18 //x=19.06 //y=1.4 //x2=19.1 //y2=1.555
r312 (  88 115 ) resistor r=45.1352 //w=0.168 //l=0.173853 //layer=ply \
 //thickness=0.18 //x=19.06 //y=1.055 //x2=19.1 //y2=0.9
r313 (  88 89 ) resistor r=176.904 //w=0.094 //l=0.345 //layer=ply \
 //thickness=0.18 //x=19.06 //y=1.055 //x2=19.06 //y2=1.4
r314 (  83 85 ) resistor r=26.9307 //w=0.15 //l=0.106066 //layer=ply \
 //thickness=0.18 //x=6.975 //y=4.97 //x2=7.05 //y2=5.045
r315 (  83 84 ) resistor r=148.702 //w=0.094 //l=0.29 //layer=ply \
 //thickness=0.18 //x=6.975 //y=4.97 //x2=6.685 //y2=4.97
r316 (  82 114 ) resistor r=45.1352 //w=0.168 //l=0.173853 //layer=ply \
 //thickness=0.18 //x=6.64 //y=1.4 //x2=6.6 //y2=1.555
r317 (  81 113 ) resistor r=45.1352 //w=0.168 //l=0.173853 //layer=ply \
 //thickness=0.18 //x=6.64 //y=1.055 //x2=6.6 //y2=0.9
r318 (  81 82 ) resistor r=176.904 //w=0.094 //l=0.345 //layer=ply \
 //thickness=0.18 //x=6.64 //y=1.055 //x2=6.64 //y2=1.4
r319 (  78 84 ) resistor r=22.7971 //w=0.269 //l=0.106066 //layer=ply \
 //thickness=0.18 //x=6.61 //y=5.045 //x2=6.685 //y2=4.97
r320 (  78 112 ) resistor r=35.8364 //w=0.269 //l=0.270185 //layer=ply \
 //thickness=0.18 //x=6.61 //y=5.045 //x2=6.41 //y2=4.88
r321 (  76 108 ) resistor r=10.701 //w=0.21 //l=0.115 //layer=ply \
 //thickness=0.18 //x=6.265 //y=1.555 //x2=6.15 //y2=1.555
r322 (  75 114 ) resistor r=5.52526 //w=0.168 //l=0.115 //layer=ply \
 //thickness=0.18 //x=6.485 //y=1.555 //x2=6.6 //y2=1.555
r323 (  74 107 ) resistor r=5.52526 //w=0.168 //l=0.115 //layer=ply \
 //thickness=0.18 //x=6.265 //y=0.9 //x2=6.15 //y2=0.9
r324 (  73 113 ) resistor r=5.52526 //w=0.168 //l=0.115 //layer=ply \
 //thickness=0.18 //x=6.485 //y=0.9 //x2=6.6 //y2=0.9
r325 (  73 74 ) resistor r=112.809 //w=0.094 //l=0.22 //layer=ply \
 //thickness=0.18 //x=6.485 //y=0.9 //x2=6.265 //y2=0.9
r326 (  72 110 ) resistor r=58.7805 //w=0.246 //l=0.373497 //layer=ply \
 //thickness=0.18 //x=6.11 //y=2.095 //x2=6.41 //y2=2.26
r327 (  71 108 ) resistor r=39.5823 //w=0.21 //l=0.173853 //layer=ply \
 //thickness=0.18 //x=6.11 //y=1.71 //x2=6.15 //y2=1.555
r328 (  71 72 ) resistor r=197.415 //w=0.094 //l=0.385 //layer=ply \
 //thickness=0.18 //x=6.11 //y=1.71 //x2=6.11 //y2=2.095
r329 (  70 108 ) resistor r=39.5823 //w=0.21 //l=0.173853 //layer=ply \
 //thickness=0.18 //x=6.11 //y=1.4 //x2=6.15 //y2=1.555
r330 (  69 107 ) resistor r=45.1352 //w=0.168 //l=0.173853 //layer=ply \
 //thickness=0.18 //x=6.11 //y=1.055 //x2=6.15 //y2=0.9
r331 (  69 70 ) resistor r=176.904 //w=0.094 //l=0.345 //layer=ply \
 //thickness=0.18 //x=6.11 //y=1.055 //x2=6.11 //y2=1.4
r332 (  68 104 ) resistor r=592.245 //w=0.094 //l=1.155 //layer=ply \
 //thickness=0.18 //x=20 //y=6.2 //x2=20 //y2=5.045
r333 (  67 97 ) resistor r=592.245 //w=0.094 //l=1.155 //layer=ply \
 //thickness=0.18 //x=19.56 //y=6.2 //x2=19.56 //y2=5.045
r334 (  66 85 ) resistor r=592.245 //w=0.094 //l=1.155 //layer=ply \
 //thickness=0.18 //x=7.05 //y=6.2 //x2=7.05 //y2=5.045
r335 (  65 78 ) resistor r=592.245 //w=0.094 //l=1.155 //layer=ply \
 //thickness=0.18 //x=6.61 //y=6.2 //x2=6.61 //y2=5.045
r336 (  64 94 ) resistor r=56.4043 //w=0.094 //l=0.11 //layer=ply \
 //thickness=0.18 //x=19.325 //y=1.555 //x2=19.435 //y2=1.555
r337 (  64 95 ) resistor r=56.4043 //w=0.094 //l=0.11 //layer=ply \
 //thickness=0.18 //x=19.325 //y=1.555 //x2=19.215 //y2=1.555
r338 (  63 75 ) resistor r=56.4043 //w=0.094 //l=0.11 //layer=ply \
 //thickness=0.18 //x=6.375 //y=1.555 //x2=6.485 //y2=1.555
r339 (  63 76 ) resistor r=56.4043 //w=0.094 //l=0.11 //layer=ply \
 //thickness=0.18 //x=6.375 //y=1.555 //x2=6.265 //y2=1.555
r340 (  59 120 ) resistor r=152 //w=0.17 //l=0.17 //layer=licon //count=1 \
 //x=19.36 //y=4.88 //x2=19.36 //y2=4.88
r341 (  57 59 ) resistor r=68.4492 //w=0.187 //l=1 //layer=li //thickness=0.1 \
 //x=19.36 //y=3.88 //x2=19.36 //y2=4.88
r342 (  54 118 ) resistor r=152 //w=0.17 //l=0.17 //layer=licon //count=1 \
 //x=19.36 //y=2.26 //x2=19.36 //y2=2.26
r343 (  54 57 ) resistor r=110.888 //w=0.187 //l=1.62 //layer=li \
 //thickness=0.1 //x=19.36 //y=2.26 //x2=19.36 //y2=3.88
r344 (  51 112 ) resistor r=152 //w=0.17 //l=0.17 //layer=licon //count=1 \
 //x=6.41 //y=4.88 //x2=6.41 //y2=4.88
r345 (  49 51 ) resistor r=68.4492 //w=0.187 //l=1 //layer=li //thickness=0.1 \
 //x=6.41 //y=3.88 //x2=6.41 //y2=4.88
r346 (  46 110 ) resistor r=152 //w=0.17 //l=0.17 //layer=licon //count=1 \
 //x=6.41 //y=2.26 //x2=6.41 //y2=2.26
r347 (  46 49 ) resistor r=110.888 //w=0.187 //l=1.62 //layer=li \
 //thickness=0.1 //x=6.41 //y=2.26 //x2=6.41 //y2=3.88
r348 (  42 44 ) resistor r=93.7754 //w=0.187 //l=1.37 //layer=li \
 //thickness=0.1 //x=4.56 //y=5.25 //x2=4.56 //y2=3.88
r349 (  41 44 ) resistor r=133.476 //w=0.187 //l=1.95 //layer=li \
 //thickness=0.1 //x=4.56 //y=1.93 //x2=4.56 //y2=3.88
r350 (  39 41 ) resistor r=7.15173 //w=0.17 //l=0.120208 //layer=li \
 //thickness=0.1 //x=4.475 //y=1.845 //x2=4.56 //y2=1.93
r351 (  39 40 ) resistor r=21.5615 //w=0.187 //l=0.315 //layer=li \
 //thickness=0.1 //x=4.475 //y=1.845 //x2=4.16 //y2=1.845
r352 (  35 40 ) resistor r=7.15173 //w=0.17 //l=0.120208 //layer=li \
 //thickness=0.1 //x=4.075 //y=1.76 //x2=4.16 //y2=1.845
r353 (  35 123 ) resistor r=39.016 //w=0.187 //l=0.57 //layer=li \
 //thickness=0.1 //x=4.075 //y=1.76 //x2=4.075 //y2=1.19
r354 (  34 62 ) resistor r=5.4201 //w=0.17 //l=0.085 //layer=li \
 //thickness=0.1 //x=3.865 //y=5.335 //x2=3.78 //y2=5.335
r355 (  33 42 ) resistor r=7.15173 //w=0.17 //l=0.120208 //layer=li \
 //thickness=0.1 //x=4.475 //y=5.335 //x2=4.56 //y2=5.25
r356 (  33 34 ) resistor r=41.754 //w=0.187 //l=0.61 //layer=li \
 //thickness=0.1 //x=4.475 //y=5.335 //x2=3.865 //y2=5.335
r357 (  27 62 ) resistor r=1.40859 //w=0.34 //l=0.085 //layer=li \
 //thickness=0.1 //x=3.78 //y=5.42 //x2=3.78 //y2=5.335
r358 (  27 127 ) resistor r=33.1979 //w=0.187 //l=0.485 //layer=li \
 //thickness=0.1 //x=3.78 //y=5.42 //x2=3.78 //y2=5.905
r359 (  26 61 ) resistor r=5.4201 //w=0.17 //l=0.085 //layer=li \
 //thickness=0.1 //x=2.985 //y=5.335 //x2=2.9 //y2=5.335
r360 (  25 62 ) resistor r=5.4201 //w=0.17 //l=0.085 //layer=li \
 //thickness=0.1 //x=3.695 //y=5.335 //x2=3.78 //y2=5.335
r361 (  25 26 ) resistor r=48.5989 //w=0.187 //l=0.71 //layer=li \
 //thickness=0.1 //x=3.695 //y=5.335 //x2=2.985 //y2=5.335
r362 (  19 61 ) resistor r=1.40859 //w=0.34 //l=0.085 //layer=li \
 //thickness=0.1 //x=2.9 //y=5.42 //x2=2.9 //y2=5.335
r363 (  19 126 ) resistor r=33.1979 //w=0.187 //l=0.485 //layer=li \
 //thickness=0.1 //x=2.9 //y=5.42 //x2=2.9 //y2=5.905
r364 (  17 61 ) resistor r=5.4201 //w=0.17 //l=0.085 //layer=li \
 //thickness=0.1 //x=2.815 //y=5.335 //x2=2.9 //y2=5.335
r365 (  17 18 ) resistor r=48.5989 //w=0.187 //l=0.71 //layer=li \
 //thickness=0.1 //x=2.815 //y=5.335 //x2=2.105 //y2=5.335
r366 (  11 18 ) resistor r=7.15173 //w=0.17 //l=0.120208 //layer=li \
 //thickness=0.1 //x=2.02 //y=5.42 //x2=2.105 //y2=5.335
r367 (  11 125 ) resistor r=33.1979 //w=0.187 //l=0.485 //layer=li \
 //thickness=0.1 //x=2.02 //y=5.42 //x2=2.02 //y2=5.905
r368 (  10 57 ) resistor r=9.3 //w=0.17 //l=0.17 //layer=mcon //count=1 \
 //x=19.36 //y=3.88 //x2=19.36 //y2=3.88
r369 (  8 49 ) resistor r=9.3 //w=0.17 //l=0.17 //layer=mcon //count=1 \
 //x=6.41 //y=3.88 //x2=6.41 //y2=3.88
r370 (  6 44 ) resistor r=9.3 //w=0.17 //l=0.17 //layer=mcon //count=1 \
 //x=4.56 //y=3.88 //x2=4.56 //y2=3.88
r371 (  4 8 ) resistor r=0.0880901 //w=0.191 //l=0.115 //layer=m1 \
 //thickness=0.36 //x=6.525 //y=3.88 //x2=6.41 //y2=3.88
r372 (  3 10 ) resistor r=0.0717383 //w=0.224 //l=0.115 //layer=m1 \
 //thickness=0.36 //x=19.245 //y=3.88 //x2=19.36 //y2=3.88
r373 (  3 4 ) resistor r=12.1374 //w=0.131 //l=12.72 //layer=m1 \
 //thickness=0.36 //x=19.245 //y=3.88 //x2=6.525 //y2=3.88
r374 (  2 6 ) resistor r=0.0717383 //w=0.224 //l=0.115 //layer=m1 \
 //thickness=0.36 //x=4.675 //y=3.88 //x2=4.56 //y2=3.88
r375 (  1 8 ) resistor r=0.0880901 //w=0.191 //l=0.115 //layer=m1 \
 //thickness=0.36 //x=6.295 //y=3.88 //x2=6.41 //y2=3.88
r376 (  1 2 ) resistor r=1.5458 //w=0.131 //l=1.62 //layer=m1 //thickness=0.36 \
 //x=6.295 //y=3.88 //x2=4.675 //y2=3.88
ends PM_TMRDFFRNQX1\%noxref_5

subckt PM_TMRDFFRNQX1\%noxref_6 ( 1 2 3 4 5 6 7 8 9 10 24 31 33 43 44 51 59 65 \
 66 70 77 78 85 93 99 100 104 106 113 115 121 122 123 124 127 128 129 130 131 \
 132 133 134 135 136 137 138 139 140 141 142 143 145 151 152 153 154 158 159 \
 160 165 167 169 175 176 177 178 179 180 184 186 189 190 194 195 196 201 203 \
 205 211 212 222 223 226 240 244 245 248 256 257 260 261 262 263 264 265 )
c485 ( 265 0 ) capacitor c=0.023087f //x=21.395 //y=5.2
c486 ( 264 0 ) capacitor c=0.023519f //x=20.515 //y=5.2
c487 ( 263 0 ) capacitor c=0.0224735f //x=19.635 //y=5.2
c488 ( 262 0 ) capacitor c=0.023087f //x=16.585 //y=5.2
c489 ( 261 0 ) capacitor c=0.023519f //x=15.705 //y=5.2
c490 ( 260 0 ) capacitor c=0.0224735f //x=14.825 //y=5.2
c491 ( 257 0 ) capacitor c=0.00872971f //x=21.645 //y=1.095
c492 ( 256 0 ) capacitor c=0.00853354f //x=16.835 //y=1.095
c493 ( 248 0 ) capacitor c=0.0339723f //x=24.94 //y=4.88
c494 ( 245 0 ) capacitor c=0.0292616f //x=24.91 //y=2.095
c495 ( 244 0 ) capacitor c=0.0430486f //x=24.91 //y=2.26
c496 ( 240 0 ) capacitor c=0.0598414f //x=24.17 //y=4.88
c497 ( 226 0 ) capacitor c=0.0331095f //x=11.99 //y=4.88
c498 ( 223 0 ) capacitor c=0.0279499f //x=11.96 //y=2.095
c499 ( 222 0 ) capacitor c=0.0421676f //x=11.96 //y=2.26
c500 ( 212 0 ) capacitor c=0.0431781f //x=25.475 //y=1.43
c501 ( 211 0 ) capacitor c=0.0197948f //x=25.475 //y=1.085
c502 ( 205 0 ) capacitor c=0.0148884f //x=25.32 //y=1.585
c503 ( 203 0 ) capacitor c=0.0157803f //x=25.32 //y=0.93
c504 ( 201 0 ) capacitor c=0.0295235f //x=25.315 //y=4.97
c505 ( 196 0 ) capacitor c=0.02098f //x=24.945 //y=1.74
c506 ( 195 0 ) capacitor c=0.0179879f //x=24.945 //y=1.43
c507 ( 194 0 ) capacitor c=0.0177928f //x=24.945 //y=1.085
c508 ( 190 0 ) capacitor c=0.0338875f //x=24.505 //y=1.39
c509 ( 189 0 ) capacitor c=0.0189263f //x=24.505 //y=1.045
c510 ( 186 0 ) capacitor c=0.0141798f //x=24.35 //y=1.545
c511 ( 184 0 ) capacitor c=0.0149844f //x=24.35 //y=0.89
c512 ( 180 0 ) capacitor c=0.0828193f //x=23.975 //y=2.095
c513 ( 179 0 ) capacitor c=0.0230657f //x=23.975 //y=1.7
c514 ( 178 0 ) capacitor c=0.0234352f //x=23.975 //y=1.39
c515 ( 177 0 ) capacitor c=0.0201338f //x=23.975 //y=1.045
c516 ( 176 0 ) capacitor c=0.0429696f //x=12.525 //y=1.43
c517 ( 175 0 ) capacitor c=0.0192208f //x=12.525 //y=1.085
c518 ( 169 0 ) capacitor c=0.0148884f //x=12.37 //y=1.585
c519 ( 167 0 ) capacitor c=0.0157803f //x=12.37 //y=0.93
c520 ( 165 0 ) capacitor c=0.0295235f //x=12.365 //y=4.97
c521 ( 160 0 ) capacitor c=0.0204188f //x=11.995 //y=1.74
c522 ( 159 0 ) capacitor c=0.0168481f //x=11.995 //y=1.43
c523 ( 158 0 ) capacitor c=0.0174783f //x=11.995 //y=1.085
c524 ( 154 0 ) capacitor c=0.0559896f //x=1.875 //y=4.97
c525 ( 153 0 ) capacitor c=0.0298189f //x=2.165 //y=4.97
c526 ( 152 0 ) capacitor c=0.0347816f //x=1.83 //y=1.4
c527 ( 151 0 ) capacitor c=0.0187487f //x=1.83 //y=1.055
c528 ( 145 0 ) capacitor c=0.0137055f //x=1.675 //y=1.555
c529 ( 143 0 ) capacitor c=0.0149861f //x=1.675 //y=0.9
c530 ( 142 0 ) capacitor c=0.102158f //x=1.3 //y=2.095
c531 ( 141 0 ) capacitor c=0.0229444f //x=1.3 //y=1.71
c532 ( 140 0 ) capacitor c=0.0234352f //x=1.3 //y=1.4
c533 ( 139 0 ) capacitor c=0.0198724f //x=1.3 //y=1.055
c534 ( 138 0 ) capacitor c=0.15358f //x=25.39 //y=6.2
c535 ( 137 0 ) capacitor c=0.116098f //x=24.95 //y=6.2
c536 ( 136 0 ) capacitor c=0.116091f //x=24.51 //y=6.2
c537 ( 135 0 ) capacitor c=0.154305f //x=24.07 //y=6.2
c538 ( 134 0 ) capacitor c=0.15358f //x=12.44 //y=6.2
c539 ( 133 0 ) capacitor c=0.110281f //x=12 //y=6.2
c540 ( 132 0 ) capacitor c=0.110114f //x=2.24 //y=6.2
c541 ( 131 0 ) capacitor c=0.158956f //x=1.8 //y=6.2
c542 ( 124 0 ) capacitor c=0.00106608f //x=21.54 //y=5.335
c543 ( 123 0 ) capacitor c=0.00207319f //x=20.66 //y=5.335
c544 ( 122 0 ) capacitor c=0.00106608f //x=16.73 //y=5.335
c545 ( 121 0 ) capacitor c=0.00207162f //x=15.85 //y=5.335
c546 ( 115 0 ) capacitor c=0.0695278f //x=24.91 //y=2.26
c547 ( 113 0 ) capacitor c=0.00453889f //x=24.91 //y=4.715
c548 ( 106 0 ) capacitor c=0.0878398f //x=24.17 //y=2.26
c549 ( 104 0 ) capacitor c=0.109391f //x=22.32 //y=4.25
c550 ( 100 0 ) capacitor c=0.00398962f //x=21.92 //y=1.845
c551 ( 99 0 ) capacitor c=0.0137288f //x=22.235 //y=1.845
c552 ( 93 0 ) capacitor c=0.0284988f //x=22.235 //y=5.335
c553 ( 85 0 ) capacitor c=0.0176454f //x=21.455 //y=5.335
c554 ( 78 0 ) capacitor c=0.00332903f //x=19.865 //y=5.335
c555 ( 77 0 ) capacitor c=0.0148427f //x=20.575 //y=5.335
c556 ( 70 0 ) capacitor c=0.109457f //x=17.51 //y=4.25
c557 ( 66 0 ) capacitor c=0.00398962f //x=17.11 //y=1.845
c558 ( 65 0 ) capacitor c=0.0137288f //x=17.425 //y=1.845
c559 ( 59 0 ) capacitor c=0.0283082f //x=17.425 //y=5.335
c560 ( 51 0 ) capacitor c=0.0176454f //x=16.645 //y=5.335
c561 ( 44 0 ) capacitor c=0.00332903f //x=15.055 //y=5.335
c562 ( 43 0 ) capacitor c=0.014837f //x=15.765 //y=5.335
c563 ( 33 0 ) capacitor c=0.0700114f //x=11.96 //y=2.26
c564 ( 31 0 ) capacitor c=0.00453889f //x=11.96 //y=4.715
c565 ( 24 0 ) capacitor c=0.124161f //x=1.6 //y=2.26
c566 ( 10 0 ) capacitor c=0.00274864f //x=24.285 //y=4.25
c567 ( 9 0 ) capacitor c=0.0190681f //x=24.795 //y=4.25
c568 ( 8 0 ) capacitor c=0.00457352f //x=22.435 //y=4.25
c569 ( 7 0 ) capacitor c=0.0387588f //x=24.055 //y=4.25
c570 ( 6 0 ) capacitor c=0.00554824f //x=17.625 //y=4.25
c571 ( 5 0 ) capacitor c=0.0842645f //x=22.205 //y=4.25
c572 ( 4 0 ) capacitor c=0.00557292f //x=12.075 //y=4.25
c573 ( 3 0 ) capacitor c=0.0725278f //x=17.395 //y=4.25
c574 ( 2 0 ) capacitor c=0.0160831f //x=1.715 //y=4.25
c575 ( 1 0 ) capacitor c=0.183938f //x=11.845 //y=4.25
r576 (  250 251 ) resistor r=32.4568 //w=0.214 //l=0.075 //layer=ply \
 //thickness=0.18 //x=24.94 //y=4.97 //x2=24.94 //y2=5.045
r577 (  248 250 ) resistor r=20.271 //w=0.214 //l=0.09 //layer=ply \
 //thickness=0.18 //x=24.94 //y=4.88 //x2=24.94 //y2=4.97
r578 (  244 245 ) resistor r=52.7279 //w=0.214 //l=0.165 //layer=ply \
 //thickness=0.18 //x=24.91 //y=2.26 //x2=24.91 //y2=2.095
r579 (  238 240 ) resistor r=20.6867 //w=0.233 //l=0.1 //layer=ply \
 //thickness=0.18 //x=24.07 //y=4.88 //x2=24.17 //y2=4.88
r580 (  228 229 ) resistor r=32.4568 //w=0.214 //l=0.075 //layer=ply \
 //thickness=0.18 //x=11.99 //y=4.97 //x2=11.99 //y2=5.045
r581 (  226 228 ) resistor r=20.271 //w=0.214 //l=0.09 //layer=ply \
 //thickness=0.18 //x=11.99 //y=4.88 //x2=11.99 //y2=4.97
r582 (  222 223 ) resistor r=52.7279 //w=0.214 //l=0.165 //layer=ply \
 //thickness=0.18 //x=11.96 //y=2.26 //x2=11.96 //y2=2.095
r583 (  212 255 ) resistor r=45.1352 //w=0.168 //l=0.173853 //layer=ply \
 //thickness=0.18 //x=25.475 //y=1.43 //x2=25.435 //y2=1.585
r584 (  211 254 ) resistor r=45.1352 //w=0.168 //l=0.173853 //layer=ply \
 //thickness=0.18 //x=25.475 //y=1.085 //x2=25.435 //y2=0.93
r585 (  211 212 ) resistor r=176.904 //w=0.094 //l=0.345 //layer=ply \
 //thickness=0.18 //x=25.475 //y=1.085 //x2=25.475 //y2=1.43
r586 (  206 253 ) resistor r=10.701 //w=0.21 //l=0.115 //layer=ply \
 //thickness=0.18 //x=25.1 //y=1.585 //x2=24.985 //y2=1.585
r587 (  205 255 ) resistor r=5.52526 //w=0.168 //l=0.115 //layer=ply \
 //thickness=0.18 //x=25.32 //y=1.585 //x2=25.435 //y2=1.585
r588 (  204 252 ) resistor r=5.52526 //w=0.168 //l=0.115 //layer=ply \
 //thickness=0.18 //x=25.1 //y=0.93 //x2=24.985 //y2=0.93
r589 (  203 254 ) resistor r=5.52526 //w=0.168 //l=0.115 //layer=ply \
 //thickness=0.18 //x=25.32 //y=0.93 //x2=25.435 //y2=0.93
r590 (  203 204 ) resistor r=112.809 //w=0.094 //l=0.22 //layer=ply \
 //thickness=0.18 //x=25.32 //y=0.93 //x2=25.1 //y2=0.93
r591 (  202 250 ) resistor r=16.5046 //w=0.27 //l=0.135 //layer=ply \
 //thickness=0.18 //x=25.075 //y=4.97 //x2=24.94 //y2=4.97
r592 (  201 208 ) resistor r=26.9307 //w=0.15 //l=0.106066 //layer=ply \
 //thickness=0.18 //x=25.315 //y=4.97 //x2=25.39 //y2=5.045
r593 (  201 202 ) resistor r=123.064 //w=0.094 //l=0.24 //layer=ply \
 //thickness=0.18 //x=25.315 //y=4.97 //x2=25.075 //y2=4.97
r594 (  196 253 ) resistor r=39.5823 //w=0.21 //l=0.173853 //layer=ply \
 //thickness=0.18 //x=24.945 //y=1.74 //x2=24.985 //y2=1.585
r595 (  196 245 ) resistor r=182.032 //w=0.094 //l=0.355 //layer=ply \
 //thickness=0.18 //x=24.945 //y=1.74 //x2=24.945 //y2=2.095
r596 (  195 253 ) resistor r=39.5823 //w=0.21 //l=0.173853 //layer=ply \
 //thickness=0.18 //x=24.945 //y=1.43 //x2=24.985 //y2=1.585
r597 (  194 252 ) resistor r=45.1352 //w=0.168 //l=0.173853 //layer=ply \
 //thickness=0.18 //x=24.945 //y=1.085 //x2=24.985 //y2=0.93
r598 (  194 195 ) resistor r=176.904 //w=0.094 //l=0.345 //layer=ply \
 //thickness=0.18 //x=24.945 //y=1.085 //x2=24.945 //y2=1.43
r599 (  191 240 ) resistor r=70.3348 //w=0.233 //l=0.414367 //layer=ply \
 //thickness=0.18 //x=24.51 //y=5.045 //x2=24.17 //y2=4.88
r600 (  190 242 ) resistor r=45.1352 //w=0.168 //l=0.173853 //layer=ply \
 //thickness=0.18 //x=24.505 //y=1.39 //x2=24.465 //y2=1.545
r601 (  189 241 ) resistor r=45.1352 //w=0.168 //l=0.173853 //layer=ply \
 //thickness=0.18 //x=24.505 //y=1.045 //x2=24.465 //y2=0.89
r602 (  189 190 ) resistor r=176.904 //w=0.094 //l=0.345 //layer=ply \
 //thickness=0.18 //x=24.505 //y=1.045 //x2=24.505 //y2=1.39
r603 (  187 237 ) resistor r=10.701 //w=0.21 //l=0.115 //layer=ply \
 //thickness=0.18 //x=24.13 //y=1.545 //x2=24.015 //y2=1.545
r604 (  186 242 ) resistor r=5.52526 //w=0.168 //l=0.115 //layer=ply \
 //thickness=0.18 //x=24.35 //y=1.545 //x2=24.465 //y2=1.545
r605 (  185 236 ) resistor r=5.52526 //w=0.168 //l=0.115 //layer=ply \
 //thickness=0.18 //x=24.13 //y=0.89 //x2=24.015 //y2=0.89
r606 (  184 241 ) resistor r=5.52526 //w=0.168 //l=0.115 //layer=ply \
 //thickness=0.18 //x=24.35 //y=0.89 //x2=24.465 //y2=0.89
r607 (  184 185 ) resistor r=112.809 //w=0.094 //l=0.22 //layer=ply \
 //thickness=0.18 //x=24.35 //y=0.89 //x2=24.13 //y2=0.89
r608 (  181 238 ) resistor r=13.0941 //w=0.233 //l=0.165 //layer=ply \
 //thickness=0.18 //x=24.07 //y=5.045 //x2=24.07 //y2=4.88
r609 (  180 235 ) resistor r=34.8111 //w=0.27 //l=0.264953 //layer=ply \
 //thickness=0.18 //x=23.975 //y=2.095 //x2=24.17 //y2=2.26
r610 (  179 237 ) resistor r=39.5823 //w=0.21 //l=0.173853 //layer=ply \
 //thickness=0.18 //x=23.975 //y=1.7 //x2=24.015 //y2=1.545
r611 (  179 180 ) resistor r=202.543 //w=0.094 //l=0.395 //layer=ply \
 //thickness=0.18 //x=23.975 //y=1.7 //x2=23.975 //y2=2.095
r612 (  178 237 ) resistor r=39.5823 //w=0.21 //l=0.173853 //layer=ply \
 //thickness=0.18 //x=23.975 //y=1.39 //x2=24.015 //y2=1.545
r613 (  177 236 ) resistor r=45.1352 //w=0.168 //l=0.173853 //layer=ply \
 //thickness=0.18 //x=23.975 //y=1.045 //x2=24.015 //y2=0.89
r614 (  177 178 ) resistor r=176.904 //w=0.094 //l=0.345 //layer=ply \
 //thickness=0.18 //x=23.975 //y=1.045 //x2=23.975 //y2=1.39
r615 (  176 233 ) resistor r=45.1352 //w=0.168 //l=0.173853 //layer=ply \
 //thickness=0.18 //x=12.525 //y=1.43 //x2=12.485 //y2=1.585
r616 (  175 232 ) resistor r=45.1352 //w=0.168 //l=0.173853 //layer=ply \
 //thickness=0.18 //x=12.525 //y=1.085 //x2=12.485 //y2=0.93
r617 (  175 176 ) resistor r=176.904 //w=0.094 //l=0.345 //layer=ply \
 //thickness=0.18 //x=12.525 //y=1.085 //x2=12.525 //y2=1.43
r618 (  170 231 ) resistor r=10.701 //w=0.21 //l=0.115 //layer=ply \
 //thickness=0.18 //x=12.15 //y=1.585 //x2=12.035 //y2=1.585
r619 (  169 233 ) resistor r=5.52526 //w=0.168 //l=0.115 //layer=ply \
 //thickness=0.18 //x=12.37 //y=1.585 //x2=12.485 //y2=1.585
r620 (  168 230 ) resistor r=5.52526 //w=0.168 //l=0.115 //layer=ply \
 //thickness=0.18 //x=12.15 //y=0.93 //x2=12.035 //y2=0.93
r621 (  167 232 ) resistor r=5.52526 //w=0.168 //l=0.115 //layer=ply \
 //thickness=0.18 //x=12.37 //y=0.93 //x2=12.485 //y2=0.93
r622 (  167 168 ) resistor r=112.809 //w=0.094 //l=0.22 //layer=ply \
 //thickness=0.18 //x=12.37 //y=0.93 //x2=12.15 //y2=0.93
r623 (  166 228 ) resistor r=16.5046 //w=0.27 //l=0.135 //layer=ply \
 //thickness=0.18 //x=12.125 //y=4.97 //x2=11.99 //y2=4.97
r624 (  165 172 ) resistor r=26.9307 //w=0.15 //l=0.106066 //layer=ply \
 //thickness=0.18 //x=12.365 //y=4.97 //x2=12.44 //y2=5.045
r625 (  165 166 ) resistor r=123.064 //w=0.094 //l=0.24 //layer=ply \
 //thickness=0.18 //x=12.365 //y=4.97 //x2=12.125 //y2=4.97
r626 (  160 231 ) resistor r=39.5823 //w=0.21 //l=0.173853 //layer=ply \
 //thickness=0.18 //x=11.995 //y=1.74 //x2=12.035 //y2=1.585
r627 (  160 223 ) resistor r=182.032 //w=0.094 //l=0.355 //layer=ply \
 //thickness=0.18 //x=11.995 //y=1.74 //x2=11.995 //y2=2.095
r628 (  159 231 ) resistor r=39.5823 //w=0.21 //l=0.173853 //layer=ply \
 //thickness=0.18 //x=11.995 //y=1.43 //x2=12.035 //y2=1.585
r629 (  158 230 ) resistor r=45.1352 //w=0.168 //l=0.173853 //layer=ply \
 //thickness=0.18 //x=11.995 //y=1.085 //x2=12.035 //y2=0.93
r630 (  158 159 ) resistor r=176.904 //w=0.094 //l=0.345 //layer=ply \
 //thickness=0.18 //x=11.995 //y=1.085 //x2=11.995 //y2=1.43
r631 (  153 155 ) resistor r=26.9307 //w=0.15 //l=0.106066 //layer=ply \
 //thickness=0.18 //x=2.165 //y=4.97 //x2=2.24 //y2=5.045
r632 (  153 154 ) resistor r=148.702 //w=0.094 //l=0.29 //layer=ply \
 //thickness=0.18 //x=2.165 //y=4.97 //x2=1.875 //y2=4.97
r633 (  152 220 ) resistor r=45.1352 //w=0.168 //l=0.173853 //layer=ply \
 //thickness=0.18 //x=1.83 //y=1.4 //x2=1.79 //y2=1.555
r634 (  151 219 ) resistor r=45.1352 //w=0.168 //l=0.173853 //layer=ply \
 //thickness=0.18 //x=1.83 //y=1.055 //x2=1.79 //y2=0.9
r635 (  151 152 ) resistor r=176.904 //w=0.094 //l=0.345 //layer=ply \
 //thickness=0.18 //x=1.83 //y=1.055 //x2=1.83 //y2=1.4
r636 (  148 154 ) resistor r=22.7971 //w=0.269 //l=0.106066 //layer=ply \
 //thickness=0.18 //x=1.8 //y=5.045 //x2=1.875 //y2=4.97
r637 (  148 218 ) resistor r=35.8364 //w=0.269 //l=0.270185 //layer=ply \
 //thickness=0.18 //x=1.8 //y=5.045 //x2=1.6 //y2=4.88
r638 (  146 214 ) resistor r=10.701 //w=0.21 //l=0.115 //layer=ply \
 //thickness=0.18 //x=1.455 //y=1.555 //x2=1.34 //y2=1.555
r639 (  145 220 ) resistor r=5.52526 //w=0.168 //l=0.115 //layer=ply \
 //thickness=0.18 //x=1.675 //y=1.555 //x2=1.79 //y2=1.555
r640 (  144 213 ) resistor r=5.52526 //w=0.168 //l=0.115 //layer=ply \
 //thickness=0.18 //x=1.455 //y=0.9 //x2=1.34 //y2=0.9
r641 (  143 219 ) resistor r=5.52526 //w=0.168 //l=0.115 //layer=ply \
 //thickness=0.18 //x=1.675 //y=0.9 //x2=1.79 //y2=0.9
r642 (  143 144 ) resistor r=112.809 //w=0.094 //l=0.22 //layer=ply \
 //thickness=0.18 //x=1.675 //y=0.9 //x2=1.455 //y2=0.9
r643 (  142 216 ) resistor r=58.7805 //w=0.246 //l=0.373497 //layer=ply \
 //thickness=0.18 //x=1.3 //y=2.095 //x2=1.6 //y2=2.26
r644 (  141 214 ) resistor r=39.5823 //w=0.21 //l=0.173853 //layer=ply \
 //thickness=0.18 //x=1.3 //y=1.71 //x2=1.34 //y2=1.555
r645 (  141 142 ) resistor r=197.415 //w=0.094 //l=0.385 //layer=ply \
 //thickness=0.18 //x=1.3 //y=1.71 //x2=1.3 //y2=2.095
r646 (  140 214 ) resistor r=39.5823 //w=0.21 //l=0.173853 //layer=ply \
 //thickness=0.18 //x=1.3 //y=1.4 //x2=1.34 //y2=1.555
r647 (  139 213 ) resistor r=45.1352 //w=0.168 //l=0.173853 //layer=ply \
 //thickness=0.18 //x=1.3 //y=1.055 //x2=1.34 //y2=0.9
r648 (  139 140 ) resistor r=176.904 //w=0.094 //l=0.345 //layer=ply \
 //thickness=0.18 //x=1.3 //y=1.055 //x2=1.3 //y2=1.4
r649 (  138 208 ) resistor r=592.245 //w=0.094 //l=1.155 //layer=ply \
 //thickness=0.18 //x=25.39 //y=6.2 //x2=25.39 //y2=5.045
r650 (  137 251 ) resistor r=592.245 //w=0.094 //l=1.155 //layer=ply \
 //thickness=0.18 //x=24.95 //y=6.2 //x2=24.95 //y2=5.045
r651 (  136 191 ) resistor r=592.245 //w=0.094 //l=1.155 //layer=ply \
 //thickness=0.18 //x=24.51 //y=6.2 //x2=24.51 //y2=5.045
r652 (  135 181 ) resistor r=592.245 //w=0.094 //l=1.155 //layer=ply \
 //thickness=0.18 //x=24.07 //y=6.2 //x2=24.07 //y2=5.045
r653 (  134 172 ) resistor r=592.245 //w=0.094 //l=1.155 //layer=ply \
 //thickness=0.18 //x=12.44 //y=6.2 //x2=12.44 //y2=5.045
r654 (  133 229 ) resistor r=592.245 //w=0.094 //l=1.155 //layer=ply \
 //thickness=0.18 //x=12 //y=6.2 //x2=12 //y2=5.045
r655 (  132 155 ) resistor r=592.245 //w=0.094 //l=1.155 //layer=ply \
 //thickness=0.18 //x=2.24 //y=6.2 //x2=2.24 //y2=5.045
r656 (  131 148 ) resistor r=592.245 //w=0.094 //l=1.155 //layer=ply \
 //thickness=0.18 //x=1.8 //y=6.2 //x2=1.8 //y2=5.045
r657 (  130 205 ) resistor r=56.4043 //w=0.094 //l=0.11 //layer=ply \
 //thickness=0.18 //x=25.21 //y=1.585 //x2=25.32 //y2=1.585
r658 (  130 206 ) resistor r=56.4043 //w=0.094 //l=0.11 //layer=ply \
 //thickness=0.18 //x=25.21 //y=1.585 //x2=25.1 //y2=1.585
r659 (  129 186 ) resistor r=56.4043 //w=0.094 //l=0.11 //layer=ply \
 //thickness=0.18 //x=24.24 //y=1.545 //x2=24.35 //y2=1.545
r660 (  129 187 ) resistor r=56.4043 //w=0.094 //l=0.11 //layer=ply \
 //thickness=0.18 //x=24.24 //y=1.545 //x2=24.13 //y2=1.545
r661 (  128 169 ) resistor r=56.4043 //w=0.094 //l=0.11 //layer=ply \
 //thickness=0.18 //x=12.26 //y=1.585 //x2=12.37 //y2=1.585
r662 (  128 170 ) resistor r=56.4043 //w=0.094 //l=0.11 //layer=ply \
 //thickness=0.18 //x=12.26 //y=1.585 //x2=12.15 //y2=1.585
r663 (  127 145 ) resistor r=56.4043 //w=0.094 //l=0.11 //layer=ply \
 //thickness=0.18 //x=1.565 //y=1.555 //x2=1.675 //y2=1.555
r664 (  127 146 ) resistor r=56.4043 //w=0.094 //l=0.11 //layer=ply \
 //thickness=0.18 //x=1.565 //y=1.555 //x2=1.455 //y2=1.555
r665 (  126 248 ) resistor r=152 //w=0.17 //l=0.17 //layer=licon //count=1 \
 //x=24.94 //y=4.88 //x2=24.94 //y2=4.88
r666 (  120 226 ) resistor r=152 //w=0.17 //l=0.17 //layer=licon //count=1 \
 //x=11.99 //y=4.88 //x2=11.99 //y2=4.88
r667 (  115 244 ) resistor r=152 //w=0.17 //l=0.17 //layer=licon //count=1 \
 //x=24.91 //y=2.26 //x2=24.91 //y2=2.26
r668 (  115 118 ) resistor r=136.214 //w=0.187 //l=1.99 //layer=li \
 //thickness=0.1 //x=24.91 //y=2.26 //x2=24.91 //y2=4.25
r669 (  113 126 ) resistor r=11.4737 //w=0.186 //l=0.172337 //layer=li \
 //thickness=0.1 //x=24.91 //y=4.715 //x2=24.925 //y2=4.88
r670 (  113 118 ) resistor r=31.8289 //w=0.187 //l=0.465 //layer=li \
 //thickness=0.1 //x=24.91 //y=4.715 //x2=24.91 //y2=4.25
r671 (  111 240 ) resistor r=152 //w=0.17 //l=0.17 //layer=licon //count=1 \
 //x=24.17 //y=4.88 //x2=24.17 //y2=4.88
r672 (  109 111 ) resistor r=43.123 //w=0.187 //l=0.63 //layer=li \
 //thickness=0.1 //x=24.17 //y=4.25 //x2=24.17 //y2=4.88
r673 (  106 235 ) resistor r=152 //w=0.17 //l=0.17 //layer=licon //count=1 \
 //x=24.17 //y=2.26 //x2=24.17 //y2=2.26
r674 (  106 109 ) resistor r=136.214 //w=0.187 //l=1.99 //layer=li \
 //thickness=0.1 //x=24.17 //y=2.26 //x2=24.17 //y2=4.25
r675 (  102 104 ) resistor r=68.4492 //w=0.187 //l=1 //layer=li \
 //thickness=0.1 //x=22.32 //y=5.25 //x2=22.32 //y2=4.25
r676 (  101 104 ) resistor r=158.802 //w=0.187 //l=2.32 //layer=li \
 //thickness=0.1 //x=22.32 //y=1.93 //x2=22.32 //y2=4.25
r677 (  99 101 ) resistor r=7.15173 //w=0.17 //l=0.120208 //layer=li \
 //thickness=0.1 //x=22.235 //y=1.845 //x2=22.32 //y2=1.93
r678 (  99 100 ) resistor r=21.5615 //w=0.187 //l=0.315 //layer=li \
 //thickness=0.1 //x=22.235 //y=1.845 //x2=21.92 //y2=1.845
r679 (  95 100 ) resistor r=7.15173 //w=0.17 //l=0.120208 //layer=li \
 //thickness=0.1 //x=21.835 //y=1.76 //x2=21.92 //y2=1.845
r680 (  95 257 ) resistor r=39.016 //w=0.187 //l=0.57 //layer=li \
 //thickness=0.1 //x=21.835 //y=1.76 //x2=21.835 //y2=1.19
r681 (  94 124 ) resistor r=5.4201 //w=0.17 //l=0.085 //layer=li \
 //thickness=0.1 //x=21.625 //y=5.335 //x2=21.54 //y2=5.335
r682 (  93 102 ) resistor r=7.15173 //w=0.17 //l=0.120208 //layer=li \
 //thickness=0.1 //x=22.235 //y=5.335 //x2=22.32 //y2=5.25
r683 (  93 94 ) resistor r=41.754 //w=0.187 //l=0.61 //layer=li \
 //thickness=0.1 //x=22.235 //y=5.335 //x2=21.625 //y2=5.335
r684 (  87 124 ) resistor r=1.40859 //w=0.34 //l=0.085 //layer=li \
 //thickness=0.1 //x=21.54 //y=5.42 //x2=21.54 //y2=5.335
r685 (  87 265 ) resistor r=33.1979 //w=0.187 //l=0.485 //layer=li \
 //thickness=0.1 //x=21.54 //y=5.42 //x2=21.54 //y2=5.905
r686 (  86 123 ) resistor r=5.4201 //w=0.17 //l=0.085 //layer=li \
 //thickness=0.1 //x=20.745 //y=5.335 //x2=20.66 //y2=5.335
r687 (  85 124 ) resistor r=5.4201 //w=0.17 //l=0.085 //layer=li \
 //thickness=0.1 //x=21.455 //y=5.335 //x2=21.54 //y2=5.335
r688 (  85 86 ) resistor r=48.5989 //w=0.187 //l=0.71 //layer=li \
 //thickness=0.1 //x=21.455 //y=5.335 //x2=20.745 //y2=5.335
r689 (  79 123 ) resistor r=1.40859 //w=0.34 //l=0.085 //layer=li \
 //thickness=0.1 //x=20.66 //y=5.42 //x2=20.66 //y2=5.335
r690 (  79 264 ) resistor r=33.1979 //w=0.187 //l=0.485 //layer=li \
 //thickness=0.1 //x=20.66 //y=5.42 //x2=20.66 //y2=5.905
r691 (  77 123 ) resistor r=5.4201 //w=0.17 //l=0.085 //layer=li \
 //thickness=0.1 //x=20.575 //y=5.335 //x2=20.66 //y2=5.335
r692 (  77 78 ) resistor r=48.5989 //w=0.187 //l=0.71 //layer=li \
 //thickness=0.1 //x=20.575 //y=5.335 //x2=19.865 //y2=5.335
r693 (  71 78 ) resistor r=7.15173 //w=0.17 //l=0.120208 //layer=li \
 //thickness=0.1 //x=19.78 //y=5.42 //x2=19.865 //y2=5.335
r694 (  71 263 ) resistor r=33.1979 //w=0.187 //l=0.485 //layer=li \
 //thickness=0.1 //x=19.78 //y=5.42 //x2=19.78 //y2=5.905
r695 (  68 70 ) resistor r=68.4492 //w=0.187 //l=1 //layer=li //thickness=0.1 \
 //x=17.51 //y=5.25 //x2=17.51 //y2=4.25
r696 (  67 70 ) resistor r=158.802 //w=0.187 //l=2.32 //layer=li \
 //thickness=0.1 //x=17.51 //y=1.93 //x2=17.51 //y2=4.25
r697 (  65 67 ) resistor r=7.15173 //w=0.17 //l=0.120208 //layer=li \
 //thickness=0.1 //x=17.425 //y=1.845 //x2=17.51 //y2=1.93
r698 (  65 66 ) resistor r=21.5615 //w=0.187 //l=0.315 //layer=li \
 //thickness=0.1 //x=17.425 //y=1.845 //x2=17.11 //y2=1.845
r699 (  61 66 ) resistor r=7.15173 //w=0.17 //l=0.120208 //layer=li \
 //thickness=0.1 //x=17.025 //y=1.76 //x2=17.11 //y2=1.845
r700 (  61 256 ) resistor r=39.016 //w=0.187 //l=0.57 //layer=li \
 //thickness=0.1 //x=17.025 //y=1.76 //x2=17.025 //y2=1.19
r701 (  60 122 ) resistor r=5.4201 //w=0.17 //l=0.085 //layer=li \
 //thickness=0.1 //x=16.815 //y=5.335 //x2=16.73 //y2=5.335
r702 (  59 68 ) resistor r=7.15173 //w=0.17 //l=0.120208 //layer=li \
 //thickness=0.1 //x=17.425 //y=5.335 //x2=17.51 //y2=5.25
r703 (  59 60 ) resistor r=41.754 //w=0.187 //l=0.61 //layer=li \
 //thickness=0.1 //x=17.425 //y=5.335 //x2=16.815 //y2=5.335
r704 (  53 122 ) resistor r=1.40859 //w=0.34 //l=0.085 //layer=li \
 //thickness=0.1 //x=16.73 //y=5.42 //x2=16.73 //y2=5.335
r705 (  53 262 ) resistor r=33.1979 //w=0.187 //l=0.485 //layer=li \
 //thickness=0.1 //x=16.73 //y=5.42 //x2=16.73 //y2=5.905
r706 (  52 121 ) resistor r=5.4201 //w=0.17 //l=0.085 //layer=li \
 //thickness=0.1 //x=15.935 //y=5.335 //x2=15.85 //y2=5.335
r707 (  51 122 ) resistor r=5.4201 //w=0.17 //l=0.085 //layer=li \
 //thickness=0.1 //x=16.645 //y=5.335 //x2=16.73 //y2=5.335
r708 (  51 52 ) resistor r=48.5989 //w=0.187 //l=0.71 //layer=li \
 //thickness=0.1 //x=16.645 //y=5.335 //x2=15.935 //y2=5.335
r709 (  45 121 ) resistor r=1.40859 //w=0.34 //l=0.085 //layer=li \
 //thickness=0.1 //x=15.85 //y=5.42 //x2=15.85 //y2=5.335
r710 (  45 261 ) resistor r=33.1979 //w=0.187 //l=0.485 //layer=li \
 //thickness=0.1 //x=15.85 //y=5.42 //x2=15.85 //y2=5.905
r711 (  43 121 ) resistor r=5.4201 //w=0.17 //l=0.085 //layer=li \
 //thickness=0.1 //x=15.765 //y=5.335 //x2=15.85 //y2=5.335
r712 (  43 44 ) resistor r=48.5989 //w=0.187 //l=0.71 //layer=li \
 //thickness=0.1 //x=15.765 //y=5.335 //x2=15.055 //y2=5.335
r713 (  37 44 ) resistor r=7.15173 //w=0.17 //l=0.120208 //layer=li \
 //thickness=0.1 //x=14.97 //y=5.42 //x2=15.055 //y2=5.335
r714 (  37 260 ) resistor r=33.1979 //w=0.187 //l=0.485 //layer=li \
 //thickness=0.1 //x=14.97 //y=5.42 //x2=14.97 //y2=5.905
r715 (  33 222 ) resistor r=152 //w=0.17 //l=0.17 //layer=licon //count=1 \
 //x=11.96 //y=2.26 //x2=11.96 //y2=2.26
r716 (  33 36 ) resistor r=136.214 //w=0.187 //l=1.99 //layer=li \
 //thickness=0.1 //x=11.96 //y=2.26 //x2=11.96 //y2=4.25
r717 (  31 120 ) resistor r=11.4737 //w=0.186 //l=0.172337 //layer=li \
 //thickness=0.1 //x=11.96 //y=4.715 //x2=11.975 //y2=4.88
r718 (  31 36 ) resistor r=31.8289 //w=0.187 //l=0.465 //layer=li \
 //thickness=0.1 //x=11.96 //y=4.715 //x2=11.96 //y2=4.25
r719 (  29 218 ) resistor r=152 //w=0.17 //l=0.17 //layer=licon //count=1 \
 //x=1.6 //y=4.88 //x2=1.6 //y2=4.88
r720 (  27 29 ) resistor r=43.123 //w=0.187 //l=0.63 //layer=li \
 //thickness=0.1 //x=1.6 //y=4.25 //x2=1.6 //y2=4.88
r721 (  24 216 ) resistor r=152 //w=0.17 //l=0.17 //layer=licon //count=1 \
 //x=1.6 //y=2.26 //x2=1.6 //y2=2.26
r722 (  24 27 ) resistor r=136.214 //w=0.187 //l=1.99 //layer=li \
 //thickness=0.1 //x=1.6 //y=2.26 //x2=1.6 //y2=4.25
r723 (  22 118 ) resistor r=9.3 //w=0.17 //l=0.17 //layer=mcon //count=1 \
 //x=24.91 //y=4.25 //x2=24.91 //y2=4.25
r724 (  20 109 ) resistor r=9.3 //w=0.17 //l=0.17 //layer=mcon //count=1 \
 //x=24.17 //y=4.25 //x2=24.17 //y2=4.25
r725 (  18 104 ) resistor r=9.3 //w=0.17 //l=0.17 //layer=mcon //count=1 \
 //x=22.32 //y=4.25 //x2=22.32 //y2=4.25
r726 (  16 70 ) resistor r=9.3 //w=0.17 //l=0.17 //layer=mcon //count=1 \
 //x=17.51 //y=4.25 //x2=17.51 //y2=4.25
r727 (  14 36 ) resistor r=9.3 //w=0.17 //l=0.17 //layer=mcon //count=1 \
 //x=11.96 //y=4.25 //x2=11.96 //y2=4.25
r728 (  12 27 ) resistor r=9.3 //w=0.17 //l=0.17 //layer=mcon //count=1 \
 //x=1.6 //y=4.25 //x2=1.6 //y2=4.25
r729 (  10 20 ) resistor r=0.0880901 //w=0.191 //l=0.115 //layer=m1 \
 //thickness=0.36 //x=24.285 //y=4.25 //x2=24.17 //y2=4.25
r730 (  9 22 ) resistor r=0.0717383 //w=0.224 //l=0.115 //layer=m1 \
 //thickness=0.36 //x=24.795 //y=4.25 //x2=24.91 //y2=4.25
r731 (  9 10 ) resistor r=0.486641 //w=0.131 //l=0.51 //layer=m1 \
 //thickness=0.36 //x=24.795 //y=4.25 //x2=24.285 //y2=4.25
r732 (  8 18 ) resistor r=0.0880901 //w=0.191 //l=0.115 //layer=m1 \
 //thickness=0.36 //x=22.435 //y=4.25 //x2=22.32 //y2=4.25
r733 (  7 20 ) resistor r=0.0880901 //w=0.191 //l=0.115 //layer=m1 \
 //thickness=0.36 //x=24.055 //y=4.25 //x2=24.17 //y2=4.25
r734 (  7 8 ) resistor r=1.5458 //w=0.131 //l=1.62 //layer=m1 //thickness=0.36 \
 //x=24.055 //y=4.25 //x2=22.435 //y2=4.25
r735 (  6 16 ) resistor r=0.0880901 //w=0.191 //l=0.115 //layer=m1 \
 //thickness=0.36 //x=17.625 //y=4.25 //x2=17.51 //y2=4.25
r736 (  5 18 ) resistor r=0.0880901 //w=0.191 //l=0.115 //layer=m1 \
 //thickness=0.36 //x=22.205 //y=4.25 //x2=22.32 //y2=4.25
r737 (  5 6 ) resistor r=4.37023 //w=0.131 //l=4.58 //layer=m1 \
 //thickness=0.36 //x=22.205 //y=4.25 //x2=17.625 //y2=4.25
r738 (  4 14 ) resistor r=0.0880901 //w=0.191 //l=0.115 //layer=m1 \
 //thickness=0.36 //x=12.075 //y=4.25 //x2=11.96 //y2=4.25
r739 (  3 16 ) resistor r=0.0880901 //w=0.191 //l=0.115 //layer=m1 \
 //thickness=0.36 //x=17.395 //y=4.25 //x2=17.51 //y2=4.25
r740 (  3 4 ) resistor r=5.07634 //w=0.131 //l=5.32 //layer=m1 \
 //thickness=0.36 //x=17.395 //y=4.25 //x2=12.075 //y2=4.25
r741 (  2 12 ) resistor r=0.0717383 //w=0.224 //l=0.115 //layer=m1 \
 //thickness=0.36 //x=1.715 //y=4.25 //x2=1.6 //y2=4.25
r742 (  1 14 ) resistor r=0.0880901 //w=0.191 //l=0.115 //layer=m1 \
 //thickness=0.36 //x=11.845 //y=4.25 //x2=11.96 //y2=4.25
r743 (  1 2 ) resistor r=9.66603 //w=0.131 //l=10.13 //layer=m1 \
 //thickness=0.36 //x=11.845 //y=4.25 //x2=1.715 //y2=4.25
ends PM_TMRDFFRNQX1\%noxref_6

subckt PM_TMRDFFRNQX1\%noxref_7 ( 1 2 3 4 12 25 26 33 41 47 48 52 54 61 62 63 \
 64 65 66 67 68 72 73 74 79 81 84 85 86 87 88 89 93 95 98 99 104 105 110 119 \
 122 124 125 126 )
c247 ( 126 0 ) capacitor c=0.023087f //x=34.345 //y=5.2
c248 ( 125 0 ) capacitor c=0.023519f //x=33.465 //y=5.2
c249 ( 124 0 ) capacitor c=0.0224735f //x=32.585 //y=5.2
c250 ( 122 0 ) capacitor c=0.00872971f //x=34.595 //y=1.095
c251 ( 119 0 ) capacitor c=0.0588816f //x=37.12 //y=4.88
c252 ( 110 0 ) capacitor c=0.058931f //x=29.72 //y=4.88
c253 ( 105 0 ) capacitor c=0.0273931f //x=29.72 //y=2.095
c254 ( 104 0 ) capacitor c=0.0456313f //x=29.72 //y=2.26
c255 ( 99 0 ) capacitor c=0.0318948f //x=37.455 //y=1.39
c256 ( 98 0 ) capacitor c=0.0187384f //x=37.455 //y=1.045
c257 ( 95 0 ) capacitor c=0.0141798f //x=37.3 //y=1.545
c258 ( 93 0 ) capacitor c=0.0149844f //x=37.3 //y=0.89
c259 ( 89 0 ) capacitor c=0.0813322f //x=36.925 //y=2.095
c260 ( 88 0 ) capacitor c=0.0229267f //x=36.925 //y=1.7
c261 ( 87 0 ) capacitor c=0.0234352f //x=36.925 //y=1.39
c262 ( 86 0 ) capacitor c=0.0199343f //x=36.925 //y=1.045
c263 ( 85 0 ) capacitor c=0.0432517f //x=30.24 //y=1.44
c264 ( 84 0 ) capacitor c=0.0200379f //x=30.24 //y=1.095
c265 ( 81 0 ) capacitor c=0.0148873f //x=30.085 //y=1.595
c266 ( 79 0 ) capacitor c=0.0157803f //x=30.085 //y=0.94
c267 ( 74 0 ) capacitor c=0.0218028f //x=29.71 //y=1.75
c268 ( 73 0 ) capacitor c=0.0207459f //x=29.71 //y=1.44
c269 ( 72 0 ) capacitor c=0.0194308f //x=29.71 //y=1.095
c270 ( 68 0 ) capacitor c=0.110275f //x=37.46 //y=6.2
c271 ( 67 0 ) capacitor c=0.154305f //x=37.02 //y=6.2
c272 ( 66 0 ) capacitor c=0.158794f //x=29.9 //y=6.2
c273 ( 65 0 ) capacitor c=0.110114f //x=29.46 //y=6.2
c274 ( 62 0 ) capacitor c=0.00106608f //x=34.49 //y=5.335
c275 ( 61 0 ) capacitor c=0.00207319f //x=33.61 //y=5.335
c276 ( 54 0 ) capacitor c=0.084205f //x=37.12 //y=2.26
c277 ( 52 0 ) capacitor c=0.103747f //x=35.27 //y=3.51
c278 ( 48 0 ) capacitor c=0.00398962f //x=34.87 //y=1.845
c279 ( 47 0 ) capacitor c=0.0137288f //x=35.185 //y=1.845
c280 ( 41 0 ) capacitor c=0.0284988f //x=35.185 //y=5.335
c281 ( 33 0 ) capacitor c=0.0176454f //x=34.405 //y=5.335
c282 ( 26 0 ) capacitor c=0.00332903f //x=32.815 //y=5.335
c283 ( 25 0 ) capacitor c=0.0148427f //x=33.525 //y=5.335
c284 ( 12 0 ) capacitor c=0.081384f //x=29.72 //y=2.26
c285 ( 4 0 ) capacitor c=0.00427986f //x=35.385 //y=3.51
c286 ( 3 0 ) capacitor c=0.0347042f //x=37.005 //y=3.51
c287 ( 2 0 ) capacitor c=0.0141678f //x=29.835 //y=3.51
c288 ( 1 0 ) capacitor c=0.077708f //x=35.155 //y=3.51
r289 (  117 119 ) resistor r=20.6867 //w=0.233 //l=0.1 //layer=ply \
 //thickness=0.18 //x=37.02 //y=4.88 //x2=37.12 //y2=4.88
r290 (  104 105 ) resistor r=52.7279 //w=0.214 //l=0.165 //layer=ply \
 //thickness=0.18 //x=29.72 //y=2.26 //x2=29.72 //y2=2.095
r291 (  100 119 ) resistor r=70.3348 //w=0.233 //l=0.414367 //layer=ply \
 //thickness=0.18 //x=37.46 //y=5.045 //x2=37.12 //y2=4.88
r292 (  99 121 ) resistor r=45.1352 //w=0.168 //l=0.173853 //layer=ply \
 //thickness=0.18 //x=37.455 //y=1.39 //x2=37.415 //y2=1.545
r293 (  98 120 ) resistor r=45.1352 //w=0.168 //l=0.173853 //layer=ply \
 //thickness=0.18 //x=37.455 //y=1.045 //x2=37.415 //y2=0.89
r294 (  98 99 ) resistor r=176.904 //w=0.094 //l=0.345 //layer=ply \
 //thickness=0.18 //x=37.455 //y=1.045 //x2=37.455 //y2=1.39
r295 (  96 116 ) resistor r=10.701 //w=0.21 //l=0.115 //layer=ply \
 //thickness=0.18 //x=37.08 //y=1.545 //x2=36.965 //y2=1.545
r296 (  95 121 ) resistor r=5.52526 //w=0.168 //l=0.115 //layer=ply \
 //thickness=0.18 //x=37.3 //y=1.545 //x2=37.415 //y2=1.545
r297 (  94 115 ) resistor r=5.52526 //w=0.168 //l=0.115 //layer=ply \
 //thickness=0.18 //x=37.08 //y=0.89 //x2=36.965 //y2=0.89
r298 (  93 120 ) resistor r=5.52526 //w=0.168 //l=0.115 //layer=ply \
 //thickness=0.18 //x=37.3 //y=0.89 //x2=37.415 //y2=0.89
r299 (  93 94 ) resistor r=112.809 //w=0.094 //l=0.22 //layer=ply \
 //thickness=0.18 //x=37.3 //y=0.89 //x2=37.08 //y2=0.89
r300 (  90 117 ) resistor r=13.0941 //w=0.233 //l=0.165 //layer=ply \
 //thickness=0.18 //x=37.02 //y=5.045 //x2=37.02 //y2=4.88
r301 (  89 114 ) resistor r=34.8111 //w=0.27 //l=0.264953 //layer=ply \
 //thickness=0.18 //x=36.925 //y=2.095 //x2=37.12 //y2=2.26
r302 (  88 116 ) resistor r=39.5823 //w=0.21 //l=0.173853 //layer=ply \
 //thickness=0.18 //x=36.925 //y=1.7 //x2=36.965 //y2=1.545
r303 (  88 89 ) resistor r=202.543 //w=0.094 //l=0.395 //layer=ply \
 //thickness=0.18 //x=36.925 //y=1.7 //x2=36.925 //y2=2.095
r304 (  87 116 ) resistor r=39.5823 //w=0.21 //l=0.173853 //layer=ply \
 //thickness=0.18 //x=36.925 //y=1.39 //x2=36.965 //y2=1.545
r305 (  86 115 ) resistor r=45.1352 //w=0.168 //l=0.173853 //layer=ply \
 //thickness=0.18 //x=36.925 //y=1.045 //x2=36.965 //y2=0.89
r306 (  86 87 ) resistor r=176.904 //w=0.094 //l=0.345 //layer=ply \
 //thickness=0.18 //x=36.925 //y=1.045 //x2=36.925 //y2=1.39
r307 (  85 112 ) resistor r=45.1352 //w=0.168 //l=0.173853 //layer=ply \
 //thickness=0.18 //x=30.24 //y=1.44 //x2=30.2 //y2=1.595
r308 (  84 111 ) resistor r=45.1352 //w=0.168 //l=0.173853 //layer=ply \
 //thickness=0.18 //x=30.24 //y=1.095 //x2=30.2 //y2=0.94
r309 (  84 85 ) resistor r=176.904 //w=0.094 //l=0.345 //layer=ply \
 //thickness=0.18 //x=30.24 //y=1.095 //x2=30.24 //y2=1.44
r310 (  82 108 ) resistor r=10.701 //w=0.21 //l=0.115 //layer=ply \
 //thickness=0.18 //x=29.865 //y=1.595 //x2=29.75 //y2=1.595
r311 (  81 112 ) resistor r=5.52526 //w=0.168 //l=0.115 //layer=ply \
 //thickness=0.18 //x=30.085 //y=1.595 //x2=30.2 //y2=1.595
r312 (  80 107 ) resistor r=5.52526 //w=0.168 //l=0.115 //layer=ply \
 //thickness=0.18 //x=29.865 //y=0.94 //x2=29.75 //y2=0.94
r313 (  79 111 ) resistor r=5.52526 //w=0.168 //l=0.115 //layer=ply \
 //thickness=0.18 //x=30.085 //y=0.94 //x2=30.2 //y2=0.94
r314 (  79 80 ) resistor r=112.809 //w=0.094 //l=0.22 //layer=ply \
 //thickness=0.18 //x=30.085 //y=0.94 //x2=29.865 //y2=0.94
r315 (  76 110 ) resistor r=37.236 //w=0.233 //l=0.249199 //layer=ply \
 //thickness=0.18 //x=29.9 //y=5.045 //x2=29.72 //y2=4.88
r316 (  74 108 ) resistor r=39.5823 //w=0.21 //l=0.173853 //layer=ply \
 //thickness=0.18 //x=29.71 //y=1.75 //x2=29.75 //y2=1.595
r317 (  74 105 ) resistor r=176.904 //w=0.094 //l=0.345 //layer=ply \
 //thickness=0.18 //x=29.71 //y=1.75 //x2=29.71 //y2=2.095
r318 (  73 108 ) resistor r=39.5823 //w=0.21 //l=0.173853 //layer=ply \
 //thickness=0.18 //x=29.71 //y=1.44 //x2=29.75 //y2=1.595
r319 (  72 107 ) resistor r=45.1352 //w=0.168 //l=0.173853 //layer=ply \
 //thickness=0.18 //x=29.71 //y=1.095 //x2=29.75 //y2=0.94
r320 (  72 73 ) resistor r=176.904 //w=0.094 //l=0.345 //layer=ply \
 //thickness=0.18 //x=29.71 //y=1.095 //x2=29.71 //y2=1.44
r321 (  69 110 ) resistor r=53.7854 //w=0.233 //l=0.332415 //layer=ply \
 //thickness=0.18 //x=29.46 //y=5.045 //x2=29.72 //y2=4.88
r322 (  68 100 ) resistor r=592.245 //w=0.094 //l=1.155 //layer=ply \
 //thickness=0.18 //x=37.46 //y=6.2 //x2=37.46 //y2=5.045
r323 (  67 90 ) resistor r=592.245 //w=0.094 //l=1.155 //layer=ply \
 //thickness=0.18 //x=37.02 //y=6.2 //x2=37.02 //y2=5.045
r324 (  66 76 ) resistor r=592.245 //w=0.094 //l=1.155 //layer=ply \
 //thickness=0.18 //x=29.9 //y=6.2 //x2=29.9 //y2=5.045
r325 (  65 69 ) resistor r=592.245 //w=0.094 //l=1.155 //layer=ply \
 //thickness=0.18 //x=29.46 //y=6.2 //x2=29.46 //y2=5.045
r326 (  64 95 ) resistor r=56.4043 //w=0.094 //l=0.11 //layer=ply \
 //thickness=0.18 //x=37.19 //y=1.545 //x2=37.3 //y2=1.545
r327 (  64 96 ) resistor r=56.4043 //w=0.094 //l=0.11 //layer=ply \
 //thickness=0.18 //x=37.19 //y=1.545 //x2=37.08 //y2=1.545
r328 (  63 81 ) resistor r=56.4043 //w=0.094 //l=0.11 //layer=ply \
 //thickness=0.18 //x=29.975 //y=1.595 //x2=30.085 //y2=1.595
r329 (  63 82 ) resistor r=56.4043 //w=0.094 //l=0.11 //layer=ply \
 //thickness=0.18 //x=29.975 //y=1.595 //x2=29.865 //y2=1.595
r330 (  59 119 ) resistor r=152 //w=0.17 //l=0.17 //layer=licon //count=1 \
 //x=37.12 //y=4.88 //x2=37.12 //y2=4.88
r331 (  57 59 ) resistor r=93.7754 //w=0.187 //l=1.37 //layer=li \
 //thickness=0.1 //x=37.12 //y=3.51 //x2=37.12 //y2=4.88
r332 (  54 114 ) resistor r=152 //w=0.17 //l=0.17 //layer=licon //count=1 \
 //x=37.12 //y=2.26 //x2=37.12 //y2=2.26
r333 (  54 57 ) resistor r=85.5615 //w=0.187 //l=1.25 //layer=li \
 //thickness=0.1 //x=37.12 //y=2.26 //x2=37.12 //y2=3.51
r334 (  50 52 ) resistor r=119.102 //w=0.187 //l=1.74 //layer=li \
 //thickness=0.1 //x=35.27 //y=5.25 //x2=35.27 //y2=3.51
r335 (  49 52 ) resistor r=108.15 //w=0.187 //l=1.58 //layer=li \
 //thickness=0.1 //x=35.27 //y=1.93 //x2=35.27 //y2=3.51
r336 (  47 49 ) resistor r=7.15173 //w=0.17 //l=0.120208 //layer=li \
 //thickness=0.1 //x=35.185 //y=1.845 //x2=35.27 //y2=1.93
r337 (  47 48 ) resistor r=21.5615 //w=0.187 //l=0.315 //layer=li \
 //thickness=0.1 //x=35.185 //y=1.845 //x2=34.87 //y2=1.845
r338 (  43 48 ) resistor r=7.15173 //w=0.17 //l=0.120208 //layer=li \
 //thickness=0.1 //x=34.785 //y=1.76 //x2=34.87 //y2=1.845
r339 (  43 122 ) resistor r=39.016 //w=0.187 //l=0.57 //layer=li \
 //thickness=0.1 //x=34.785 //y=1.76 //x2=34.785 //y2=1.19
r340 (  42 62 ) resistor r=5.4201 //w=0.17 //l=0.085 //layer=li \
 //thickness=0.1 //x=34.575 //y=5.335 //x2=34.49 //y2=5.335
r341 (  41 50 ) resistor r=7.15173 //w=0.17 //l=0.120208 //layer=li \
 //thickness=0.1 //x=35.185 //y=5.335 //x2=35.27 //y2=5.25
r342 (  41 42 ) resistor r=41.754 //w=0.187 //l=0.61 //layer=li \
 //thickness=0.1 //x=35.185 //y=5.335 //x2=34.575 //y2=5.335
r343 (  35 62 ) resistor r=1.40859 //w=0.34 //l=0.085 //layer=li \
 //thickness=0.1 //x=34.49 //y=5.42 //x2=34.49 //y2=5.335
r344 (  35 126 ) resistor r=33.1979 //w=0.187 //l=0.485 //layer=li \
 //thickness=0.1 //x=34.49 //y=5.42 //x2=34.49 //y2=5.905
r345 (  34 61 ) resistor r=5.4201 //w=0.17 //l=0.085 //layer=li \
 //thickness=0.1 //x=33.695 //y=5.335 //x2=33.61 //y2=5.335
r346 (  33 62 ) resistor r=5.4201 //w=0.17 //l=0.085 //layer=li \
 //thickness=0.1 //x=34.405 //y=5.335 //x2=34.49 //y2=5.335
r347 (  33 34 ) resistor r=48.5989 //w=0.187 //l=0.71 //layer=li \
 //thickness=0.1 //x=34.405 //y=5.335 //x2=33.695 //y2=5.335
r348 (  27 61 ) resistor r=1.40859 //w=0.34 //l=0.085 //layer=li \
 //thickness=0.1 //x=33.61 //y=5.42 //x2=33.61 //y2=5.335
r349 (  27 125 ) resistor r=33.1979 //w=0.187 //l=0.485 //layer=li \
 //thickness=0.1 //x=33.61 //y=5.42 //x2=33.61 //y2=5.905
r350 (  25 61 ) resistor r=5.4201 //w=0.17 //l=0.085 //layer=li \
 //thickness=0.1 //x=33.525 //y=5.335 //x2=33.61 //y2=5.335
r351 (  25 26 ) resistor r=48.5989 //w=0.187 //l=0.71 //layer=li \
 //thickness=0.1 //x=33.525 //y=5.335 //x2=32.815 //y2=5.335
r352 (  19 26 ) resistor r=7.15173 //w=0.17 //l=0.120208 //layer=li \
 //thickness=0.1 //x=32.73 //y=5.42 //x2=32.815 //y2=5.335
r353 (  19 124 ) resistor r=33.1979 //w=0.187 //l=0.485 //layer=li \
 //thickness=0.1 //x=32.73 //y=5.42 //x2=32.73 //y2=5.905
r354 (  17 110 ) resistor r=152 //w=0.17 //l=0.17 //layer=licon //count=1 \
 //x=29.72 //y=4.88 //x2=29.72 //y2=4.88
r355 (  15 17 ) resistor r=93.7754 //w=0.187 //l=1.37 //layer=li \
 //thickness=0.1 //x=29.72 //y=3.51 //x2=29.72 //y2=4.88
r356 (  12 104 ) resistor r=152 //w=0.17 //l=0.17 //layer=licon //count=1 \
 //x=29.72 //y=2.26 //x2=29.72 //y2=2.26
r357 (  12 15 ) resistor r=85.5615 //w=0.187 //l=1.25 //layer=li \
 //thickness=0.1 //x=29.72 //y=2.26 //x2=29.72 //y2=3.51
r358 (  10 57 ) resistor r=9.3 //w=0.17 //l=0.17 //layer=mcon //count=1 \
 //x=37.12 //y=3.51 //x2=37.12 //y2=3.51
r359 (  8 52 ) resistor r=9.3 //w=0.17 //l=0.17 //layer=mcon //count=1 \
 //x=35.27 //y=3.51 //x2=35.27 //y2=3.51
r360 (  6 15 ) resistor r=9.3 //w=0.17 //l=0.17 //layer=mcon //count=1 \
 //x=29.72 //y=3.51 //x2=29.72 //y2=3.51
r361 (  4 8 ) resistor r=0.0880901 //w=0.191 //l=0.115 //layer=m1 \
 //thickness=0.36 //x=35.385 //y=3.51 //x2=35.27 //y2=3.51
r362 (  3 10 ) resistor r=0.0717383 //w=0.224 //l=0.115 //layer=m1 \
 //thickness=0.36 //x=37.005 //y=3.51 //x2=37.12 //y2=3.51
r363 (  3 4 ) resistor r=1.5458 //w=0.131 //l=1.62 //layer=m1 //thickness=0.36 \
 //x=37.005 //y=3.51 //x2=35.385 //y2=3.51
r364 (  2 6 ) resistor r=0.0717383 //w=0.224 //l=0.115 //layer=m1 \
 //thickness=0.36 //x=29.835 //y=3.51 //x2=29.72 //y2=3.51
r365 (  1 8 ) resistor r=0.0880901 //w=0.191 //l=0.115 //layer=m1 \
 //thickness=0.36 //x=35.155 //y=3.51 //x2=35.27 //y2=3.51
r366 (  1 2 ) resistor r=5.07634 //w=0.131 //l=5.32 //layer=m1 \
 //thickness=0.36 //x=35.155 //y=3.51 //x2=29.835 //y2=3.51
ends PM_TMRDFFRNQX1\%noxref_7

subckt PM_TMRDFFRNQX1\%noxref_8 ( 1 2 13 14 25 27 28 32 34 41 42 43 44 45 46 \
 47 48 49 51 57 58 59 60 72 74 75 )
c153 ( 75 0 ) capacitor c=0.0220291f //x=37.975 //y=5.2
c154 ( 74 0 ) capacitor c=0.0217503f //x=37.095 //y=5.2
c155 ( 72 0 ) capacitor c=0.0084702f //x=37.97 //y=1.085
c156 ( 60 0 ) capacitor c=0.0557698f //x=40.725 //y=4.97
c157 ( 59 0 ) capacitor c=0.0293157f //x=41.015 //y=4.97
c158 ( 58 0 ) capacitor c=0.0347816f //x=40.68 //y=1.4
c159 ( 57 0 ) capacitor c=0.0187487f //x=40.68 //y=1.055
c160 ( 51 0 ) capacitor c=0.0137055f //x=40.525 //y=1.555
c161 ( 49 0 ) capacitor c=0.0149861f //x=40.525 //y=0.9
c162 ( 48 0 ) capacitor c=0.096037f //x=40.15 //y=2.095
c163 ( 47 0 ) capacitor c=0.0228993f //x=40.15 //y=1.71
c164 ( 46 0 ) capacitor c=0.0234352f //x=40.15 //y=1.4
c165 ( 45 0 ) capacitor c=0.0198724f //x=40.15 //y=1.055
c166 ( 44 0 ) capacitor c=0.110114f //x=41.09 //y=6.2
c167 ( 43 0 ) capacitor c=0.158956f //x=40.65 //y=6.2
c168 ( 41 0 ) capacitor c=0.00211606f //x=38.12 //y=5.38
c169 ( 34 0 ) capacitor c=0.0936549f //x=40.45 //y=2.26
c170 ( 32 0 ) capacitor c=0.102772f //x=38.6 //y=3.51
c171 ( 28 0 ) capacitor c=0.00404073f //x=38.245 //y=1.835
c172 ( 27 0 ) capacitor c=0.0122201f //x=38.515 //y=1.835
c173 ( 25 0 ) capacitor c=0.0137995f //x=38.515 //y=5.38
c174 ( 14 0 ) capacitor c=0.00251635f //x=37.325 //y=5.38
c175 ( 13 0 ) capacitor c=0.0143649f //x=38.035 //y=5.38
c176 ( 2 0 ) capacitor c=0.00668619f //x=38.715 //y=3.51
c177 ( 1 0 ) capacitor c=0.0402621f //x=40.335 //y=3.51
r178 (  59 61 ) resistor r=26.9307 //w=0.15 //l=0.106066 //layer=ply \
 //thickness=0.18 //x=41.015 //y=4.97 //x2=41.09 //y2=5.045
r179 (  59 60 ) resistor r=148.702 //w=0.094 //l=0.29 //layer=ply \
 //thickness=0.18 //x=41.015 //y=4.97 //x2=40.725 //y2=4.97
r180 (  58 71 ) resistor r=45.1352 //w=0.168 //l=0.173853 //layer=ply \
 //thickness=0.18 //x=40.68 //y=1.4 //x2=40.64 //y2=1.555
r181 (  57 70 ) resistor r=45.1352 //w=0.168 //l=0.173853 //layer=ply \
 //thickness=0.18 //x=40.68 //y=1.055 //x2=40.64 //y2=0.9
r182 (  57 58 ) resistor r=176.904 //w=0.094 //l=0.345 //layer=ply \
 //thickness=0.18 //x=40.68 //y=1.055 //x2=40.68 //y2=1.4
r183 (  54 60 ) resistor r=22.7971 //w=0.269 //l=0.106066 //layer=ply \
 //thickness=0.18 //x=40.65 //y=5.045 //x2=40.725 //y2=4.97
r184 (  54 69 ) resistor r=35.8364 //w=0.269 //l=0.270185 //layer=ply \
 //thickness=0.18 //x=40.65 //y=5.045 //x2=40.45 //y2=4.88
r185 (  52 65 ) resistor r=10.701 //w=0.21 //l=0.115 //layer=ply \
 //thickness=0.18 //x=40.305 //y=1.555 //x2=40.19 //y2=1.555
r186 (  51 71 ) resistor r=5.52526 //w=0.168 //l=0.115 //layer=ply \
 //thickness=0.18 //x=40.525 //y=1.555 //x2=40.64 //y2=1.555
r187 (  50 64 ) resistor r=5.52526 //w=0.168 //l=0.115 //layer=ply \
 //thickness=0.18 //x=40.305 //y=0.9 //x2=40.19 //y2=0.9
r188 (  49 70 ) resistor r=5.52526 //w=0.168 //l=0.115 //layer=ply \
 //thickness=0.18 //x=40.525 //y=0.9 //x2=40.64 //y2=0.9
r189 (  49 50 ) resistor r=112.809 //w=0.094 //l=0.22 //layer=ply \
 //thickness=0.18 //x=40.525 //y=0.9 //x2=40.305 //y2=0.9
r190 (  48 67 ) resistor r=58.7805 //w=0.246 //l=0.373497 //layer=ply \
 //thickness=0.18 //x=40.15 //y=2.095 //x2=40.45 //y2=2.26
r191 (  47 65 ) resistor r=39.5823 //w=0.21 //l=0.173853 //layer=ply \
 //thickness=0.18 //x=40.15 //y=1.71 //x2=40.19 //y2=1.555
r192 (  47 48 ) resistor r=197.415 //w=0.094 //l=0.385 //layer=ply \
 //thickness=0.18 //x=40.15 //y=1.71 //x2=40.15 //y2=2.095
r193 (  46 65 ) resistor r=39.5823 //w=0.21 //l=0.173853 //layer=ply \
 //thickness=0.18 //x=40.15 //y=1.4 //x2=40.19 //y2=1.555
r194 (  45 64 ) resistor r=45.1352 //w=0.168 //l=0.173853 //layer=ply \
 //thickness=0.18 //x=40.15 //y=1.055 //x2=40.19 //y2=0.9
r195 (  45 46 ) resistor r=176.904 //w=0.094 //l=0.345 //layer=ply \
 //thickness=0.18 //x=40.15 //y=1.055 //x2=40.15 //y2=1.4
r196 (  44 61 ) resistor r=592.245 //w=0.094 //l=1.155 //layer=ply \
 //thickness=0.18 //x=41.09 //y=6.2 //x2=41.09 //y2=5.045
r197 (  43 54 ) resistor r=592.245 //w=0.094 //l=1.155 //layer=ply \
 //thickness=0.18 //x=40.65 //y=6.2 //x2=40.65 //y2=5.045
r198 (  42 51 ) resistor r=56.4043 //w=0.094 //l=0.11 //layer=ply \
 //thickness=0.18 //x=40.415 //y=1.555 //x2=40.525 //y2=1.555
r199 (  42 52 ) resistor r=56.4043 //w=0.094 //l=0.11 //layer=ply \
 //thickness=0.18 //x=40.415 //y=1.555 //x2=40.305 //y2=1.555
r200 (  39 69 ) resistor r=152 //w=0.17 //l=0.17 //layer=licon //count=1 \
 //x=40.45 //y=4.88 //x2=40.45 //y2=4.88
r201 (  37 39 ) resistor r=93.7754 //w=0.187 //l=1.37 //layer=li \
 //thickness=0.1 //x=40.45 //y=3.51 //x2=40.45 //y2=4.88
r202 (  34 67 ) resistor r=152 //w=0.17 //l=0.17 //layer=licon //count=1 \
 //x=40.45 //y=2.26 //x2=40.45 //y2=2.26
r203 (  34 37 ) resistor r=85.5615 //w=0.187 //l=1.25 //layer=li \
 //thickness=0.1 //x=40.45 //y=2.26 //x2=40.45 //y2=3.51
r204 (  30 32 ) resistor r=122.182 //w=0.187 //l=1.785 //layer=li \
 //thickness=0.1 //x=38.6 //y=5.295 //x2=38.6 //y2=3.51
r205 (  29 32 ) resistor r=108.834 //w=0.187 //l=1.59 //layer=li \
 //thickness=0.1 //x=38.6 //y=1.92 //x2=38.6 //y2=3.51
r206 (  27 29 ) resistor r=7.15173 //w=0.17 //l=0.120208 //layer=li \
 //thickness=0.1 //x=38.515 //y=1.835 //x2=38.6 //y2=1.92
r207 (  27 28 ) resistor r=18.4813 //w=0.187 //l=0.27 //layer=li \
 //thickness=0.1 //x=38.515 //y=1.835 //x2=38.245 //y2=1.835
r208 (  26 41 ) resistor r=5.4201 //w=0.17 //l=0.085 //layer=li \
 //thickness=0.1 //x=38.205 //y=5.38 //x2=38.12 //y2=5.38
r209 (  25 30 ) resistor r=7.15173 //w=0.17 //l=0.120208 //layer=li \
 //thickness=0.1 //x=38.515 //y=5.38 //x2=38.6 //y2=5.295
r210 (  25 26 ) resistor r=21.2193 //w=0.187 //l=0.31 //layer=li \
 //thickness=0.1 //x=38.515 //y=5.38 //x2=38.205 //y2=5.38
r211 (  21 28 ) resistor r=7.15173 //w=0.17 //l=0.120208 //layer=li \
 //thickness=0.1 //x=38.16 //y=1.75 //x2=38.245 //y2=1.835
r212 (  21 72 ) resistor r=39.016 //w=0.187 //l=0.57 //layer=li \
 //thickness=0.1 //x=38.16 //y=1.75 //x2=38.16 //y2=1.18
r213 (  15 41 ) resistor r=1.40859 //w=0.34 //l=0.085 //layer=li \
 //thickness=0.1 //x=38.12 //y=5.465 //x2=38.12 //y2=5.38
r214 (  15 75 ) resistor r=30.1176 //w=0.187 //l=0.44 //layer=li \
 //thickness=0.1 //x=38.12 //y=5.465 //x2=38.12 //y2=5.905
r215 (  13 41 ) resistor r=5.4201 //w=0.17 //l=0.085 //layer=li \
 //thickness=0.1 //x=38.035 //y=5.38 //x2=38.12 //y2=5.38
r216 (  13 14 ) resistor r=48.5989 //w=0.187 //l=0.71 //layer=li \
 //thickness=0.1 //x=38.035 //y=5.38 //x2=37.325 //y2=5.38
r217 (  7 14 ) resistor r=7.15173 //w=0.17 //l=0.120208 //layer=li \
 //thickness=0.1 //x=37.24 //y=5.465 //x2=37.325 //y2=5.38
r218 (  7 74 ) resistor r=30.1176 //w=0.187 //l=0.44 //layer=li \
 //thickness=0.1 //x=37.24 //y=5.465 //x2=37.24 //y2=5.905
r219 (  6 37 ) resistor r=9.3 //w=0.17 //l=0.17 //layer=mcon //count=1 \
 //x=40.45 //y=3.51 //x2=40.45 //y2=3.51
r220 (  4 32 ) resistor r=9.3 //w=0.17 //l=0.17 //layer=mcon //count=1 \
 //x=38.6 //y=3.51 //x2=38.6 //y2=3.51
r221 (  2 4 ) resistor r=0.0717383 //w=0.224 //l=0.115 //layer=m1 \
 //thickness=0.36 //x=38.715 //y=3.51 //x2=38.6 //y2=3.51
r222 (  1 6 ) resistor r=0.0717383 //w=0.224 //l=0.115 //layer=m1 \
 //thickness=0.36 //x=40.335 //y=3.51 //x2=40.45 //y2=3.51
r223 (  1 2 ) resistor r=1.5458 //w=0.131 //l=1.62 //layer=m1 //thickness=0.36 \
 //x=40.335 //y=3.51 //x2=38.715 //y2=3.51
ends PM_TMRDFFRNQX1\%noxref_8

subckt PM_TMRDFFRNQX1\%noxref_9 ( 1 2 3 4 17 18 25 33 39 40 44 46 54 61 62 63 \
 64 65 66 67 68 69 70 71 72 73 75 81 82 83 84 88 89 90 91 92 94 100 101 102 \
 103 123 125 126 127 )
c262 ( 127 0 ) capacitor c=0.023087f //x=29.535 //y=5.2
c263 ( 126 0 ) capacitor c=0.023519f //x=28.655 //y=5.2
c264 ( 125 0 ) capacitor c=0.0224735f //x=27.775 //y=5.2
c265 ( 123 0 ) capacitor c=0.00853354f //x=29.785 //y=1.095
c266 ( 103 0 ) capacitor c=0.0556143f //x=45.535 //y=4.97
c267 ( 102 0 ) capacitor c=0.0293157f //x=45.825 //y=4.97
c268 ( 101 0 ) capacitor c=0.0347816f //x=45.49 //y=1.4
c269 ( 100 0 ) capacitor c=0.0187487f //x=45.49 //y=1.055
c270 ( 94 0 ) capacitor c=0.0137055f //x=45.335 //y=1.555
c271 ( 92 0 ) capacitor c=0.0149861f //x=45.335 //y=0.9
c272 ( 91 0 ) capacitor c=0.096037f //x=44.96 //y=2.095
c273 ( 90 0 ) capacitor c=0.0228993f //x=44.96 //y=1.71
c274 ( 89 0 ) capacitor c=0.0234352f //x=44.96 //y=1.4
c275 ( 88 0 ) capacitor c=0.0198724f //x=44.96 //y=1.055
c276 ( 84 0 ) capacitor c=0.0556143f //x=32.585 //y=4.97
c277 ( 83 0 ) capacitor c=0.0293157f //x=32.875 //y=4.97
c278 ( 82 0 ) capacitor c=0.0347816f //x=32.54 //y=1.4
c279 ( 81 0 ) capacitor c=0.0187487f //x=32.54 //y=1.055
c280 ( 75 0 ) capacitor c=0.0137055f //x=32.385 //y=1.555
c281 ( 73 0 ) capacitor c=0.0149861f //x=32.385 //y=0.9
c282 ( 72 0 ) capacitor c=0.096037f //x=32.01 //y=2.095
c283 ( 71 0 ) capacitor c=0.0228993f //x=32.01 //y=1.71
c284 ( 70 0 ) capacitor c=0.0234352f //x=32.01 //y=1.4
c285 ( 69 0 ) capacitor c=0.0198724f //x=32.01 //y=1.055
c286 ( 68 0 ) capacitor c=0.110114f //x=45.9 //y=6.2
c287 ( 67 0 ) capacitor c=0.158956f //x=45.46 //y=6.2
c288 ( 66 0 ) capacitor c=0.110114f //x=32.95 //y=6.2
c289 ( 65 0 ) capacitor c=0.158956f //x=32.51 //y=6.2
c290 ( 62 0 ) capacitor c=0.00106608f //x=29.68 //y=5.335
c291 ( 61 0 ) capacitor c=0.00207162f //x=28.8 //y=5.335
c292 ( 54 0 ) capacitor c=0.0974046f //x=45.26 //y=2.26
c293 ( 46 0 ) capacitor c=0.0936123f //x=32.31 //y=2.26
c294 ( 44 0 ) capacitor c=0.103742f //x=30.46 //y=3.88
c295 ( 40 0 ) capacitor c=0.00398962f //x=30.06 //y=1.845
c296 ( 39 0 ) capacitor c=0.0137288f //x=30.375 //y=1.845
c297 ( 33 0 ) capacitor c=0.0283082f //x=30.375 //y=5.335
c298 ( 25 0 ) capacitor c=0.0176454f //x=29.595 //y=5.335
c299 ( 18 0 ) capacitor c=0.00332903f //x=28.005 //y=5.335
c300 ( 17 0 ) capacitor c=0.014837f //x=28.715 //y=5.335
c301 ( 4 0 ) capacitor c=0.00424246f //x=32.425 //y=3.88
c302 ( 3 0 ) capacitor c=0.210233f //x=45.145 //y=3.88
c303 ( 2 0 ) capacitor c=0.0125346f //x=30.575 //y=3.88
c304 ( 1 0 ) capacitor c=0.0288301f //x=32.195 //y=3.88
r305 (  102 104 ) resistor r=26.9307 //w=0.15 //l=0.106066 //layer=ply \
 //thickness=0.18 //x=45.825 //y=4.97 //x2=45.9 //y2=5.045
r306 (  102 103 ) resistor r=148.702 //w=0.094 //l=0.29 //layer=ply \
 //thickness=0.18 //x=45.825 //y=4.97 //x2=45.535 //y2=4.97
r307 (  101 122 ) resistor r=45.1352 //w=0.168 //l=0.173853 //layer=ply \
 //thickness=0.18 //x=45.49 //y=1.4 //x2=45.45 //y2=1.555
r308 (  100 121 ) resistor r=45.1352 //w=0.168 //l=0.173853 //layer=ply \
 //thickness=0.18 //x=45.49 //y=1.055 //x2=45.45 //y2=0.9
r309 (  100 101 ) resistor r=176.904 //w=0.094 //l=0.345 //layer=ply \
 //thickness=0.18 //x=45.49 //y=1.055 //x2=45.49 //y2=1.4
r310 (  97 103 ) resistor r=22.7971 //w=0.269 //l=0.106066 //layer=ply \
 //thickness=0.18 //x=45.46 //y=5.045 //x2=45.535 //y2=4.97
r311 (  97 120 ) resistor r=35.8364 //w=0.269 //l=0.270185 //layer=ply \
 //thickness=0.18 //x=45.46 //y=5.045 //x2=45.26 //y2=4.88
r312 (  95 116 ) resistor r=10.701 //w=0.21 //l=0.115 //layer=ply \
 //thickness=0.18 //x=45.115 //y=1.555 //x2=45 //y2=1.555
r313 (  94 122 ) resistor r=5.52526 //w=0.168 //l=0.115 //layer=ply \
 //thickness=0.18 //x=45.335 //y=1.555 //x2=45.45 //y2=1.555
r314 (  93 115 ) resistor r=5.52526 //w=0.168 //l=0.115 //layer=ply \
 //thickness=0.18 //x=45.115 //y=0.9 //x2=45 //y2=0.9
r315 (  92 121 ) resistor r=5.52526 //w=0.168 //l=0.115 //layer=ply \
 //thickness=0.18 //x=45.335 //y=0.9 //x2=45.45 //y2=0.9
r316 (  92 93 ) resistor r=112.809 //w=0.094 //l=0.22 //layer=ply \
 //thickness=0.18 //x=45.335 //y=0.9 //x2=45.115 //y2=0.9
r317 (  91 118 ) resistor r=58.7805 //w=0.246 //l=0.373497 //layer=ply \
 //thickness=0.18 //x=44.96 //y=2.095 //x2=45.26 //y2=2.26
r318 (  90 116 ) resistor r=39.5823 //w=0.21 //l=0.173853 //layer=ply \
 //thickness=0.18 //x=44.96 //y=1.71 //x2=45 //y2=1.555
r319 (  90 91 ) resistor r=197.415 //w=0.094 //l=0.385 //layer=ply \
 //thickness=0.18 //x=44.96 //y=1.71 //x2=44.96 //y2=2.095
r320 (  89 116 ) resistor r=39.5823 //w=0.21 //l=0.173853 //layer=ply \
 //thickness=0.18 //x=44.96 //y=1.4 //x2=45 //y2=1.555
r321 (  88 115 ) resistor r=45.1352 //w=0.168 //l=0.173853 //layer=ply \
 //thickness=0.18 //x=44.96 //y=1.055 //x2=45 //y2=0.9
r322 (  88 89 ) resistor r=176.904 //w=0.094 //l=0.345 //layer=ply \
 //thickness=0.18 //x=44.96 //y=1.055 //x2=44.96 //y2=1.4
r323 (  83 85 ) resistor r=26.9307 //w=0.15 //l=0.106066 //layer=ply \
 //thickness=0.18 //x=32.875 //y=4.97 //x2=32.95 //y2=5.045
r324 (  83 84 ) resistor r=148.702 //w=0.094 //l=0.29 //layer=ply \
 //thickness=0.18 //x=32.875 //y=4.97 //x2=32.585 //y2=4.97
r325 (  82 114 ) resistor r=45.1352 //w=0.168 //l=0.173853 //layer=ply \
 //thickness=0.18 //x=32.54 //y=1.4 //x2=32.5 //y2=1.555
r326 (  81 113 ) resistor r=45.1352 //w=0.168 //l=0.173853 //layer=ply \
 //thickness=0.18 //x=32.54 //y=1.055 //x2=32.5 //y2=0.9
r327 (  81 82 ) resistor r=176.904 //w=0.094 //l=0.345 //layer=ply \
 //thickness=0.18 //x=32.54 //y=1.055 //x2=32.54 //y2=1.4
r328 (  78 84 ) resistor r=22.7971 //w=0.269 //l=0.106066 //layer=ply \
 //thickness=0.18 //x=32.51 //y=5.045 //x2=32.585 //y2=4.97
r329 (  78 112 ) resistor r=35.8364 //w=0.269 //l=0.270185 //layer=ply \
 //thickness=0.18 //x=32.51 //y=5.045 //x2=32.31 //y2=4.88
r330 (  76 108 ) resistor r=10.701 //w=0.21 //l=0.115 //layer=ply \
 //thickness=0.18 //x=32.165 //y=1.555 //x2=32.05 //y2=1.555
r331 (  75 114 ) resistor r=5.52526 //w=0.168 //l=0.115 //layer=ply \
 //thickness=0.18 //x=32.385 //y=1.555 //x2=32.5 //y2=1.555
r332 (  74 107 ) resistor r=5.52526 //w=0.168 //l=0.115 //layer=ply \
 //thickness=0.18 //x=32.165 //y=0.9 //x2=32.05 //y2=0.9
r333 (  73 113 ) resistor r=5.52526 //w=0.168 //l=0.115 //layer=ply \
 //thickness=0.18 //x=32.385 //y=0.9 //x2=32.5 //y2=0.9
r334 (  73 74 ) resistor r=112.809 //w=0.094 //l=0.22 //layer=ply \
 //thickness=0.18 //x=32.385 //y=0.9 //x2=32.165 //y2=0.9
r335 (  72 110 ) resistor r=58.7805 //w=0.246 //l=0.373497 //layer=ply \
 //thickness=0.18 //x=32.01 //y=2.095 //x2=32.31 //y2=2.26
r336 (  71 108 ) resistor r=39.5823 //w=0.21 //l=0.173853 //layer=ply \
 //thickness=0.18 //x=32.01 //y=1.71 //x2=32.05 //y2=1.555
r337 (  71 72 ) resistor r=197.415 //w=0.094 //l=0.385 //layer=ply \
 //thickness=0.18 //x=32.01 //y=1.71 //x2=32.01 //y2=2.095
r338 (  70 108 ) resistor r=39.5823 //w=0.21 //l=0.173853 //layer=ply \
 //thickness=0.18 //x=32.01 //y=1.4 //x2=32.05 //y2=1.555
r339 (  69 107 ) resistor r=45.1352 //w=0.168 //l=0.173853 //layer=ply \
 //thickness=0.18 //x=32.01 //y=1.055 //x2=32.05 //y2=0.9
r340 (  69 70 ) resistor r=176.904 //w=0.094 //l=0.345 //layer=ply \
 //thickness=0.18 //x=32.01 //y=1.055 //x2=32.01 //y2=1.4
r341 (  68 104 ) resistor r=592.245 //w=0.094 //l=1.155 //layer=ply \
 //thickness=0.18 //x=45.9 //y=6.2 //x2=45.9 //y2=5.045
r342 (  67 97 ) resistor r=592.245 //w=0.094 //l=1.155 //layer=ply \
 //thickness=0.18 //x=45.46 //y=6.2 //x2=45.46 //y2=5.045
r343 (  66 85 ) resistor r=592.245 //w=0.094 //l=1.155 //layer=ply \
 //thickness=0.18 //x=32.95 //y=6.2 //x2=32.95 //y2=5.045
r344 (  65 78 ) resistor r=592.245 //w=0.094 //l=1.155 //layer=ply \
 //thickness=0.18 //x=32.51 //y=6.2 //x2=32.51 //y2=5.045
r345 (  64 94 ) resistor r=56.4043 //w=0.094 //l=0.11 //layer=ply \
 //thickness=0.18 //x=45.225 //y=1.555 //x2=45.335 //y2=1.555
r346 (  64 95 ) resistor r=56.4043 //w=0.094 //l=0.11 //layer=ply \
 //thickness=0.18 //x=45.225 //y=1.555 //x2=45.115 //y2=1.555
r347 (  63 75 ) resistor r=56.4043 //w=0.094 //l=0.11 //layer=ply \
 //thickness=0.18 //x=32.275 //y=1.555 //x2=32.385 //y2=1.555
r348 (  63 76 ) resistor r=56.4043 //w=0.094 //l=0.11 //layer=ply \
 //thickness=0.18 //x=32.275 //y=1.555 //x2=32.165 //y2=1.555
r349 (  59 120 ) resistor r=152 //w=0.17 //l=0.17 //layer=licon //count=1 \
 //x=45.26 //y=4.88 //x2=45.26 //y2=4.88
r350 (  57 59 ) resistor r=68.4492 //w=0.187 //l=1 //layer=li //thickness=0.1 \
 //x=45.26 //y=3.88 //x2=45.26 //y2=4.88
r351 (  54 118 ) resistor r=152 //w=0.17 //l=0.17 //layer=licon //count=1 \
 //x=45.26 //y=2.26 //x2=45.26 //y2=2.26
r352 (  54 57 ) resistor r=110.888 //w=0.187 //l=1.62 //layer=li \
 //thickness=0.1 //x=45.26 //y=2.26 //x2=45.26 //y2=3.88
r353 (  51 112 ) resistor r=152 //w=0.17 //l=0.17 //layer=licon //count=1 \
 //x=32.31 //y=4.88 //x2=32.31 //y2=4.88
r354 (  49 51 ) resistor r=68.4492 //w=0.187 //l=1 //layer=li //thickness=0.1 \
 //x=32.31 //y=3.88 //x2=32.31 //y2=4.88
r355 (  46 110 ) resistor r=152 //w=0.17 //l=0.17 //layer=licon //count=1 \
 //x=32.31 //y=2.26 //x2=32.31 //y2=2.26
r356 (  46 49 ) resistor r=110.888 //w=0.187 //l=1.62 //layer=li \
 //thickness=0.1 //x=32.31 //y=2.26 //x2=32.31 //y2=3.88
r357 (  42 44 ) resistor r=93.7754 //w=0.187 //l=1.37 //layer=li \
 //thickness=0.1 //x=30.46 //y=5.25 //x2=30.46 //y2=3.88
r358 (  41 44 ) resistor r=133.476 //w=0.187 //l=1.95 //layer=li \
 //thickness=0.1 //x=30.46 //y=1.93 //x2=30.46 //y2=3.88
r359 (  39 41 ) resistor r=7.15173 //w=0.17 //l=0.120208 //layer=li \
 //thickness=0.1 //x=30.375 //y=1.845 //x2=30.46 //y2=1.93
r360 (  39 40 ) resistor r=21.5615 //w=0.187 //l=0.315 //layer=li \
 //thickness=0.1 //x=30.375 //y=1.845 //x2=30.06 //y2=1.845
r361 (  35 40 ) resistor r=7.15173 //w=0.17 //l=0.120208 //layer=li \
 //thickness=0.1 //x=29.975 //y=1.76 //x2=30.06 //y2=1.845
r362 (  35 123 ) resistor r=39.016 //w=0.187 //l=0.57 //layer=li \
 //thickness=0.1 //x=29.975 //y=1.76 //x2=29.975 //y2=1.19
r363 (  34 62 ) resistor r=5.4201 //w=0.17 //l=0.085 //layer=li \
 //thickness=0.1 //x=29.765 //y=5.335 //x2=29.68 //y2=5.335
r364 (  33 42 ) resistor r=7.15173 //w=0.17 //l=0.120208 //layer=li \
 //thickness=0.1 //x=30.375 //y=5.335 //x2=30.46 //y2=5.25
r365 (  33 34 ) resistor r=41.754 //w=0.187 //l=0.61 //layer=li \
 //thickness=0.1 //x=30.375 //y=5.335 //x2=29.765 //y2=5.335
r366 (  27 62 ) resistor r=1.40859 //w=0.34 //l=0.085 //layer=li \
 //thickness=0.1 //x=29.68 //y=5.42 //x2=29.68 //y2=5.335
r367 (  27 127 ) resistor r=33.1979 //w=0.187 //l=0.485 //layer=li \
 //thickness=0.1 //x=29.68 //y=5.42 //x2=29.68 //y2=5.905
r368 (  26 61 ) resistor r=5.4201 //w=0.17 //l=0.085 //layer=li \
 //thickness=0.1 //x=28.885 //y=5.335 //x2=28.8 //y2=5.335
r369 (  25 62 ) resistor r=5.4201 //w=0.17 //l=0.085 //layer=li \
 //thickness=0.1 //x=29.595 //y=5.335 //x2=29.68 //y2=5.335
r370 (  25 26 ) resistor r=48.5989 //w=0.187 //l=0.71 //layer=li \
 //thickness=0.1 //x=29.595 //y=5.335 //x2=28.885 //y2=5.335
r371 (  19 61 ) resistor r=1.40859 //w=0.34 //l=0.085 //layer=li \
 //thickness=0.1 //x=28.8 //y=5.42 //x2=28.8 //y2=5.335
r372 (  19 126 ) resistor r=33.1979 //w=0.187 //l=0.485 //layer=li \
 //thickness=0.1 //x=28.8 //y=5.42 //x2=28.8 //y2=5.905
r373 (  17 61 ) resistor r=5.4201 //w=0.17 //l=0.085 //layer=li \
 //thickness=0.1 //x=28.715 //y=5.335 //x2=28.8 //y2=5.335
r374 (  17 18 ) resistor r=48.5989 //w=0.187 //l=0.71 //layer=li \
 //thickness=0.1 //x=28.715 //y=5.335 //x2=28.005 //y2=5.335
r375 (  11 18 ) resistor r=7.15173 //w=0.17 //l=0.120208 //layer=li \
 //thickness=0.1 //x=27.92 //y=5.42 //x2=28.005 //y2=5.335
r376 (  11 125 ) resistor r=33.1979 //w=0.187 //l=0.485 //layer=li \
 //thickness=0.1 //x=27.92 //y=5.42 //x2=27.92 //y2=5.905
r377 (  10 57 ) resistor r=9.3 //w=0.17 //l=0.17 //layer=mcon //count=1 \
 //x=45.26 //y=3.88 //x2=45.26 //y2=3.88
r378 (  8 49 ) resistor r=9.3 //w=0.17 //l=0.17 //layer=mcon //count=1 \
 //x=32.31 //y=3.88 //x2=32.31 //y2=3.88
r379 (  6 44 ) resistor r=9.3 //w=0.17 //l=0.17 //layer=mcon //count=1 \
 //x=30.46 //y=3.88 //x2=30.46 //y2=3.88
r380 (  4 8 ) resistor r=0.0880901 //w=0.191 //l=0.115 //layer=m1 \
 //thickness=0.36 //x=32.425 //y=3.88 //x2=32.31 //y2=3.88
r381 (  3 10 ) resistor r=0.0717383 //w=0.224 //l=0.115 //layer=m1 \
 //thickness=0.36 //x=45.145 //y=3.88 //x2=45.26 //y2=3.88
r382 (  3 4 ) resistor r=12.1374 //w=0.131 //l=12.72 //layer=m1 \
 //thickness=0.36 //x=45.145 //y=3.88 //x2=32.425 //y2=3.88
r383 (  2 6 ) resistor r=0.0717383 //w=0.224 //l=0.115 //layer=m1 \
 //thickness=0.36 //x=30.575 //y=3.88 //x2=30.46 //y2=3.88
r384 (  1 8 ) resistor r=0.0880901 //w=0.191 //l=0.115 //layer=m1 \
 //thickness=0.36 //x=32.195 //y=3.88 //x2=32.31 //y2=3.88
r385 (  1 2 ) resistor r=1.5458 //w=0.131 //l=1.62 //layer=m1 //thickness=0.36 \
 //x=32.195 //y=3.88 //x2=30.575 //y2=3.88
ends PM_TMRDFFRNQX1\%noxref_9

subckt PM_TMRDFFRNQX1\%noxref_10 ( 1 2 13 14 21 29 35 36 40 42 49 50 51 52 53 \
 54 55 56 57 61 63 66 67 77 80 82 83 84 )
c163 ( 84 0 ) capacitor c=0.023087f //x=47.295 //y=5.2
c164 ( 83 0 ) capacitor c=0.023519f //x=46.415 //y=5.2
c165 ( 82 0 ) capacitor c=0.0224735f //x=45.535 //y=5.2
c166 ( 80 0 ) capacitor c=0.00872971f //x=47.545 //y=1.095
c167 ( 77 0 ) capacitor c=0.0588816f //x=50.07 //y=4.88
c168 ( 67 0 ) capacitor c=0.0318948f //x=50.405 //y=1.39
c169 ( 66 0 ) capacitor c=0.0187384f //x=50.405 //y=1.045
c170 ( 63 0 ) capacitor c=0.0141798f //x=50.25 //y=1.545
c171 ( 61 0 ) capacitor c=0.0149844f //x=50.25 //y=0.89
c172 ( 57 0 ) capacitor c=0.0813322f //x=49.875 //y=2.095
c173 ( 56 0 ) capacitor c=0.0229267f //x=49.875 //y=1.7
c174 ( 55 0 ) capacitor c=0.0234352f //x=49.875 //y=1.39
c175 ( 54 0 ) capacitor c=0.0199343f //x=49.875 //y=1.045
c176 ( 53 0 ) capacitor c=0.110275f //x=50.41 //y=6.2
c177 ( 52 0 ) capacitor c=0.154305f //x=49.97 //y=6.2
c178 ( 50 0 ) capacitor c=0.00106608f //x=47.44 //y=5.335
c179 ( 49 0 ) capacitor c=0.00207319f //x=46.56 //y=5.335
c180 ( 42 0 ) capacitor c=0.0836545f //x=50.07 //y=2.26
c181 ( 40 0 ) capacitor c=0.104238f //x=48.22 //y=3.88
c182 ( 36 0 ) capacitor c=0.00398962f //x=47.82 //y=1.845
c183 ( 35 0 ) capacitor c=0.0137288f //x=48.135 //y=1.845
c184 ( 29 0 ) capacitor c=0.0284988f //x=48.135 //y=5.335
c185 ( 21 0 ) capacitor c=0.0176454f //x=47.355 //y=5.335
c186 ( 14 0 ) capacitor c=0.00332903f //x=45.765 //y=5.335
c187 ( 13 0 ) capacitor c=0.0148427f //x=46.475 //y=5.335
c188 ( 2 0 ) capacitor c=0.00854301f //x=48.335 //y=3.88
c189 ( 1 0 ) capacitor c=0.0405342f //x=49.955 //y=3.88
r190 (  75 77 ) resistor r=20.6867 //w=0.233 //l=0.1 //layer=ply \
 //thickness=0.18 //x=49.97 //y=4.88 //x2=50.07 //y2=4.88
r191 (  68 77 ) resistor r=70.3348 //w=0.233 //l=0.414367 //layer=ply \
 //thickness=0.18 //x=50.41 //y=5.045 //x2=50.07 //y2=4.88
r192 (  67 79 ) resistor r=45.1352 //w=0.168 //l=0.173853 //layer=ply \
 //thickness=0.18 //x=50.405 //y=1.39 //x2=50.365 //y2=1.545
r193 (  66 78 ) resistor r=45.1352 //w=0.168 //l=0.173853 //layer=ply \
 //thickness=0.18 //x=50.405 //y=1.045 //x2=50.365 //y2=0.89
r194 (  66 67 ) resistor r=176.904 //w=0.094 //l=0.345 //layer=ply \
 //thickness=0.18 //x=50.405 //y=1.045 //x2=50.405 //y2=1.39
r195 (  64 74 ) resistor r=10.701 //w=0.21 //l=0.115 //layer=ply \
 //thickness=0.18 //x=50.03 //y=1.545 //x2=49.915 //y2=1.545
r196 (  63 79 ) resistor r=5.52526 //w=0.168 //l=0.115 //layer=ply \
 //thickness=0.18 //x=50.25 //y=1.545 //x2=50.365 //y2=1.545
r197 (  62 73 ) resistor r=5.52526 //w=0.168 //l=0.115 //layer=ply \
 //thickness=0.18 //x=50.03 //y=0.89 //x2=49.915 //y2=0.89
r198 (  61 78 ) resistor r=5.52526 //w=0.168 //l=0.115 //layer=ply \
 //thickness=0.18 //x=50.25 //y=0.89 //x2=50.365 //y2=0.89
r199 (  61 62 ) resistor r=112.809 //w=0.094 //l=0.22 //layer=ply \
 //thickness=0.18 //x=50.25 //y=0.89 //x2=50.03 //y2=0.89
r200 (  58 75 ) resistor r=13.0941 //w=0.233 //l=0.165 //layer=ply \
 //thickness=0.18 //x=49.97 //y=5.045 //x2=49.97 //y2=4.88
r201 (  57 72 ) resistor r=34.8111 //w=0.27 //l=0.264953 //layer=ply \
 //thickness=0.18 //x=49.875 //y=2.095 //x2=50.07 //y2=2.26
r202 (  56 74 ) resistor r=39.5823 //w=0.21 //l=0.173853 //layer=ply \
 //thickness=0.18 //x=49.875 //y=1.7 //x2=49.915 //y2=1.545
r203 (  56 57 ) resistor r=202.543 //w=0.094 //l=0.395 //layer=ply \
 //thickness=0.18 //x=49.875 //y=1.7 //x2=49.875 //y2=2.095
r204 (  55 74 ) resistor r=39.5823 //w=0.21 //l=0.173853 //layer=ply \
 //thickness=0.18 //x=49.875 //y=1.39 //x2=49.915 //y2=1.545
r205 (  54 73 ) resistor r=45.1352 //w=0.168 //l=0.173853 //layer=ply \
 //thickness=0.18 //x=49.875 //y=1.045 //x2=49.915 //y2=0.89
r206 (  54 55 ) resistor r=176.904 //w=0.094 //l=0.345 //layer=ply \
 //thickness=0.18 //x=49.875 //y=1.045 //x2=49.875 //y2=1.39
r207 (  53 68 ) resistor r=592.245 //w=0.094 //l=1.155 //layer=ply \
 //thickness=0.18 //x=50.41 //y=6.2 //x2=50.41 //y2=5.045
r208 (  52 58 ) resistor r=592.245 //w=0.094 //l=1.155 //layer=ply \
 //thickness=0.18 //x=49.97 //y=6.2 //x2=49.97 //y2=5.045
r209 (  51 63 ) resistor r=56.4043 //w=0.094 //l=0.11 //layer=ply \
 //thickness=0.18 //x=50.14 //y=1.545 //x2=50.25 //y2=1.545
r210 (  51 64 ) resistor r=56.4043 //w=0.094 //l=0.11 //layer=ply \
 //thickness=0.18 //x=50.14 //y=1.545 //x2=50.03 //y2=1.545
r211 (  47 77 ) resistor r=152 //w=0.17 //l=0.17 //layer=licon //count=1 \
 //x=50.07 //y=4.88 //x2=50.07 //y2=4.88
r212 (  45 47 ) resistor r=68.4492 //w=0.187 //l=1 //layer=li //thickness=0.1 \
 //x=50.07 //y=3.88 //x2=50.07 //y2=4.88
r213 (  42 72 ) resistor r=152 //w=0.17 //l=0.17 //layer=licon //count=1 \
 //x=50.07 //y=2.26 //x2=50.07 //y2=2.26
r214 (  42 45 ) resistor r=110.888 //w=0.187 //l=1.62 //layer=li \
 //thickness=0.1 //x=50.07 //y=2.26 //x2=50.07 //y2=3.88
r215 (  38 40 ) resistor r=93.7754 //w=0.187 //l=1.37 //layer=li \
 //thickness=0.1 //x=48.22 //y=5.25 //x2=48.22 //y2=3.88
r216 (  37 40 ) resistor r=133.476 //w=0.187 //l=1.95 //layer=li \
 //thickness=0.1 //x=48.22 //y=1.93 //x2=48.22 //y2=3.88
r217 (  35 37 ) resistor r=7.15173 //w=0.17 //l=0.120208 //layer=li \
 //thickness=0.1 //x=48.135 //y=1.845 //x2=48.22 //y2=1.93
r218 (  35 36 ) resistor r=21.5615 //w=0.187 //l=0.315 //layer=li \
 //thickness=0.1 //x=48.135 //y=1.845 //x2=47.82 //y2=1.845
r219 (  31 36 ) resistor r=7.15173 //w=0.17 //l=0.120208 //layer=li \
 //thickness=0.1 //x=47.735 //y=1.76 //x2=47.82 //y2=1.845
r220 (  31 80 ) resistor r=39.016 //w=0.187 //l=0.57 //layer=li \
 //thickness=0.1 //x=47.735 //y=1.76 //x2=47.735 //y2=1.19
r221 (  30 50 ) resistor r=5.4201 //w=0.17 //l=0.085 //layer=li \
 //thickness=0.1 //x=47.525 //y=5.335 //x2=47.44 //y2=5.335
r222 (  29 38 ) resistor r=7.15173 //w=0.17 //l=0.120208 //layer=li \
 //thickness=0.1 //x=48.135 //y=5.335 //x2=48.22 //y2=5.25
r223 (  29 30 ) resistor r=41.754 //w=0.187 //l=0.61 //layer=li \
 //thickness=0.1 //x=48.135 //y=5.335 //x2=47.525 //y2=5.335
r224 (  23 50 ) resistor r=1.40859 //w=0.34 //l=0.085 //layer=li \
 //thickness=0.1 //x=47.44 //y=5.42 //x2=47.44 //y2=5.335
r225 (  23 84 ) resistor r=33.1979 //w=0.187 //l=0.485 //layer=li \
 //thickness=0.1 //x=47.44 //y=5.42 //x2=47.44 //y2=5.905
r226 (  22 49 ) resistor r=5.4201 //w=0.17 //l=0.085 //layer=li \
 //thickness=0.1 //x=46.645 //y=5.335 //x2=46.56 //y2=5.335
r227 (  21 50 ) resistor r=5.4201 //w=0.17 //l=0.085 //layer=li \
 //thickness=0.1 //x=47.355 //y=5.335 //x2=47.44 //y2=5.335
r228 (  21 22 ) resistor r=48.5989 //w=0.187 //l=0.71 //layer=li \
 //thickness=0.1 //x=47.355 //y=5.335 //x2=46.645 //y2=5.335
r229 (  15 49 ) resistor r=1.40859 //w=0.34 //l=0.085 //layer=li \
 //thickness=0.1 //x=46.56 //y=5.42 //x2=46.56 //y2=5.335
r230 (  15 83 ) resistor r=33.1979 //w=0.187 //l=0.485 //layer=li \
 //thickness=0.1 //x=46.56 //y=5.42 //x2=46.56 //y2=5.905
r231 (  13 49 ) resistor r=5.4201 //w=0.17 //l=0.085 //layer=li \
 //thickness=0.1 //x=46.475 //y=5.335 //x2=46.56 //y2=5.335
r232 (  13 14 ) resistor r=48.5989 //w=0.187 //l=0.71 //layer=li \
 //thickness=0.1 //x=46.475 //y=5.335 //x2=45.765 //y2=5.335
r233 (  7 14 ) resistor r=7.15173 //w=0.17 //l=0.120208 //layer=li \
 //thickness=0.1 //x=45.68 //y=5.42 //x2=45.765 //y2=5.335
r234 (  7 82 ) resistor r=33.1979 //w=0.187 //l=0.485 //layer=li \
 //thickness=0.1 //x=45.68 //y=5.42 //x2=45.68 //y2=5.905
r235 (  6 45 ) resistor r=9.3 //w=0.17 //l=0.17 //layer=mcon //count=1 \
 //x=50.07 //y=3.88 //x2=50.07 //y2=3.88
r236 (  4 40 ) resistor r=9.3 //w=0.17 //l=0.17 //layer=mcon //count=1 \
 //x=48.22 //y=3.88 //x2=48.22 //y2=3.88
r237 (  2 4 ) resistor r=0.0717383 //w=0.224 //l=0.115 //layer=m1 \
 //thickness=0.36 //x=48.335 //y=3.88 //x2=48.22 //y2=3.88
r238 (  1 6 ) resistor r=0.0717383 //w=0.224 //l=0.115 //layer=m1 \
 //thickness=0.36 //x=49.955 //y=3.88 //x2=50.07 //y2=3.88
r239 (  1 2 ) resistor r=1.5458 //w=0.131 //l=1.62 //layer=m1 //thickness=0.36 \
 //x=49.955 //y=3.88 //x2=48.335 //y2=3.88
ends PM_TMRDFFRNQX1\%noxref_10

subckt PM_TMRDFFRNQX1\%noxref_11 ( 1 2 3 4 5 6 16 23 25 35 36 43 51 57 58 62 \
 63 65 71 72 75 76 77 78 79 80 81 82 83 84 85 86 87 88 90 96 97 98 99 103 104 \
 105 110 112 114 120 121 122 123 124 129 131 133 139 140 150 151 154 163 164 \
 167 175 177 178 179 )
c376 ( 179 0 ) capacitor c=0.023087f //x=42.485 //y=5.2
c377 ( 178 0 ) capacitor c=0.023519f //x=41.605 //y=5.2
c378 ( 177 0 ) capacitor c=0.0224735f //x=40.725 //y=5.2
c379 ( 175 0 ) capacitor c=0.00853354f //x=42.735 //y=1.095
c380 ( 167 0 ) capacitor c=0.0331095f //x=50.84 //y=4.88
c381 ( 164 0 ) capacitor c=0.0279499f //x=50.81 //y=2.095
c382 ( 163 0 ) capacitor c=0.0421676f //x=50.81 //y=2.26
c383 ( 154 0 ) capacitor c=0.0331095f //x=37.89 //y=4.88
c384 ( 151 0 ) capacitor c=0.0279499f //x=37.86 //y=2.095
c385 ( 150 0 ) capacitor c=0.0421676f //x=37.86 //y=2.26
c386 ( 140 0 ) capacitor c=0.0429696f //x=51.375 //y=1.43
c387 ( 139 0 ) capacitor c=0.0192208f //x=51.375 //y=1.085
c388 ( 133 0 ) capacitor c=0.0148884f //x=51.22 //y=1.585
c389 ( 131 0 ) capacitor c=0.0157803f //x=51.22 //y=0.93
c390 ( 129 0 ) capacitor c=0.0295235f //x=51.215 //y=4.97
c391 ( 124 0 ) capacitor c=0.0204188f //x=50.845 //y=1.74
c392 ( 123 0 ) capacitor c=0.0168481f //x=50.845 //y=1.43
c393 ( 122 0 ) capacitor c=0.0174783f //x=50.845 //y=1.085
c394 ( 121 0 ) capacitor c=0.0429696f //x=38.425 //y=1.43
c395 ( 120 0 ) capacitor c=0.0192208f //x=38.425 //y=1.085
c396 ( 114 0 ) capacitor c=0.0148884f //x=38.27 //y=1.585
c397 ( 112 0 ) capacitor c=0.0157803f //x=38.27 //y=0.93
c398 ( 110 0 ) capacitor c=0.0295235f //x=38.265 //y=4.97
c399 ( 105 0 ) capacitor c=0.0204188f //x=37.895 //y=1.74
c400 ( 104 0 ) capacitor c=0.0168481f //x=37.895 //y=1.43
c401 ( 103 0 ) capacitor c=0.0174783f //x=37.895 //y=1.085
c402 ( 99 0 ) capacitor c=0.0557698f //x=27.775 //y=4.97
c403 ( 98 0 ) capacitor c=0.0293157f //x=28.065 //y=4.97
c404 ( 97 0 ) capacitor c=0.0347816f //x=27.73 //y=1.4
c405 ( 96 0 ) capacitor c=0.0187487f //x=27.73 //y=1.055
c406 ( 90 0 ) capacitor c=0.0137055f //x=27.575 //y=1.555
c407 ( 88 0 ) capacitor c=0.0149861f //x=27.575 //y=0.9
c408 ( 87 0 ) capacitor c=0.096037f //x=27.2 //y=2.095
c409 ( 86 0 ) capacitor c=0.0228993f //x=27.2 //y=1.71
c410 ( 85 0 ) capacitor c=0.0234352f //x=27.2 //y=1.4
c411 ( 84 0 ) capacitor c=0.0198724f //x=27.2 //y=1.055
c412 ( 83 0 ) capacitor c=0.15358f //x=51.29 //y=6.2
c413 ( 82 0 ) capacitor c=0.110281f //x=50.85 //y=6.2
c414 ( 81 0 ) capacitor c=0.15358f //x=38.34 //y=6.2
c415 ( 80 0 ) capacitor c=0.110281f //x=37.9 //y=6.2
c416 ( 79 0 ) capacitor c=0.110114f //x=28.14 //y=6.2
c417 ( 78 0 ) capacitor c=0.158956f //x=27.7 //y=6.2
c418 ( 72 0 ) capacitor c=0.00106608f //x=42.63 //y=5.335
c419 ( 71 0 ) capacitor c=0.00207162f //x=41.75 //y=5.335
c420 ( 65 0 ) capacitor c=0.0690311f //x=50.81 //y=2.26
c421 ( 63 0 ) capacitor c=0.00453889f //x=50.81 //y=4.715
c422 ( 62 0 ) capacitor c=0.106357f //x=43.41 //y=4.25
c423 ( 58 0 ) capacitor c=0.00398962f //x=43.01 //y=1.845
c424 ( 57 0 ) capacitor c=0.0137288f //x=43.325 //y=1.845
c425 ( 51 0 ) capacitor c=0.0283082f //x=43.325 //y=5.335
c426 ( 43 0 ) capacitor c=0.0176454f //x=42.545 //y=5.335
c427 ( 36 0 ) capacitor c=0.00332903f //x=40.955 //y=5.335
c428 ( 35 0 ) capacitor c=0.014837f //x=41.665 //y=5.335
c429 ( 25 0 ) capacitor c=0.0680284f //x=37.86 //y=2.26
c430 ( 23 0 ) capacitor c=0.00453889f //x=37.86 //y=4.715
c431 ( 16 0 ) capacitor c=0.100832f //x=27.5 //y=2.26
c432 ( 6 0 ) capacitor c=0.00554824f //x=43.525 //y=4.25
c433 ( 5 0 ) capacitor c=0.124977f //x=50.695 //y=4.25
c434 ( 4 0 ) capacitor c=0.00557292f //x=37.975 //y=4.25
c435 ( 3 0 ) capacitor c=0.0725278f //x=43.295 //y=4.25
c436 ( 2 0 ) capacitor c=0.0102374f //x=27.615 //y=4.25
c437 ( 1 0 ) capacitor c=0.151078f //x=37.745 //y=4.25
r438 (  169 170 ) resistor r=32.4568 //w=0.214 //l=0.075 //layer=ply \
 //thickness=0.18 //x=50.84 //y=4.97 //x2=50.84 //y2=5.045
r439 (  167 169 ) resistor r=20.271 //w=0.214 //l=0.09 //layer=ply \
 //thickness=0.18 //x=50.84 //y=4.88 //x2=50.84 //y2=4.97
r440 (  163 164 ) resistor r=52.7279 //w=0.214 //l=0.165 //layer=ply \
 //thickness=0.18 //x=50.81 //y=2.26 //x2=50.81 //y2=2.095
r441 (  156 157 ) resistor r=32.4568 //w=0.214 //l=0.075 //layer=ply \
 //thickness=0.18 //x=37.89 //y=4.97 //x2=37.89 //y2=5.045
r442 (  154 156 ) resistor r=20.271 //w=0.214 //l=0.09 //layer=ply \
 //thickness=0.18 //x=37.89 //y=4.88 //x2=37.89 //y2=4.97
r443 (  150 151 ) resistor r=52.7279 //w=0.214 //l=0.165 //layer=ply \
 //thickness=0.18 //x=37.86 //y=2.26 //x2=37.86 //y2=2.095
r444 (  140 174 ) resistor r=45.1352 //w=0.168 //l=0.173853 //layer=ply \
 //thickness=0.18 //x=51.375 //y=1.43 //x2=51.335 //y2=1.585
r445 (  139 173 ) resistor r=45.1352 //w=0.168 //l=0.173853 //layer=ply \
 //thickness=0.18 //x=51.375 //y=1.085 //x2=51.335 //y2=0.93
r446 (  139 140 ) resistor r=176.904 //w=0.094 //l=0.345 //layer=ply \
 //thickness=0.18 //x=51.375 //y=1.085 //x2=51.375 //y2=1.43
r447 (  134 172 ) resistor r=10.701 //w=0.21 //l=0.115 //layer=ply \
 //thickness=0.18 //x=51 //y=1.585 //x2=50.885 //y2=1.585
r448 (  133 174 ) resistor r=5.52526 //w=0.168 //l=0.115 //layer=ply \
 //thickness=0.18 //x=51.22 //y=1.585 //x2=51.335 //y2=1.585
r449 (  132 171 ) resistor r=5.52526 //w=0.168 //l=0.115 //layer=ply \
 //thickness=0.18 //x=51 //y=0.93 //x2=50.885 //y2=0.93
r450 (  131 173 ) resistor r=5.52526 //w=0.168 //l=0.115 //layer=ply \
 //thickness=0.18 //x=51.22 //y=0.93 //x2=51.335 //y2=0.93
r451 (  131 132 ) resistor r=112.809 //w=0.094 //l=0.22 //layer=ply \
 //thickness=0.18 //x=51.22 //y=0.93 //x2=51 //y2=0.93
r452 (  130 169 ) resistor r=16.5046 //w=0.27 //l=0.135 //layer=ply \
 //thickness=0.18 //x=50.975 //y=4.97 //x2=50.84 //y2=4.97
r453 (  129 136 ) resistor r=26.9307 //w=0.15 //l=0.106066 //layer=ply \
 //thickness=0.18 //x=51.215 //y=4.97 //x2=51.29 //y2=5.045
r454 (  129 130 ) resistor r=123.064 //w=0.094 //l=0.24 //layer=ply \
 //thickness=0.18 //x=51.215 //y=4.97 //x2=50.975 //y2=4.97
r455 (  124 172 ) resistor r=39.5823 //w=0.21 //l=0.173853 //layer=ply \
 //thickness=0.18 //x=50.845 //y=1.74 //x2=50.885 //y2=1.585
r456 (  124 164 ) resistor r=182.032 //w=0.094 //l=0.355 //layer=ply \
 //thickness=0.18 //x=50.845 //y=1.74 //x2=50.845 //y2=2.095
r457 (  123 172 ) resistor r=39.5823 //w=0.21 //l=0.173853 //layer=ply \
 //thickness=0.18 //x=50.845 //y=1.43 //x2=50.885 //y2=1.585
r458 (  122 171 ) resistor r=45.1352 //w=0.168 //l=0.173853 //layer=ply \
 //thickness=0.18 //x=50.845 //y=1.085 //x2=50.885 //y2=0.93
r459 (  122 123 ) resistor r=176.904 //w=0.094 //l=0.345 //layer=ply \
 //thickness=0.18 //x=50.845 //y=1.085 //x2=50.845 //y2=1.43
r460 (  121 161 ) resistor r=45.1352 //w=0.168 //l=0.173853 //layer=ply \
 //thickness=0.18 //x=38.425 //y=1.43 //x2=38.385 //y2=1.585
r461 (  120 160 ) resistor r=45.1352 //w=0.168 //l=0.173853 //layer=ply \
 //thickness=0.18 //x=38.425 //y=1.085 //x2=38.385 //y2=0.93
r462 (  120 121 ) resistor r=176.904 //w=0.094 //l=0.345 //layer=ply \
 //thickness=0.18 //x=38.425 //y=1.085 //x2=38.425 //y2=1.43
r463 (  115 159 ) resistor r=10.701 //w=0.21 //l=0.115 //layer=ply \
 //thickness=0.18 //x=38.05 //y=1.585 //x2=37.935 //y2=1.585
r464 (  114 161 ) resistor r=5.52526 //w=0.168 //l=0.115 //layer=ply \
 //thickness=0.18 //x=38.27 //y=1.585 //x2=38.385 //y2=1.585
r465 (  113 158 ) resistor r=5.52526 //w=0.168 //l=0.115 //layer=ply \
 //thickness=0.18 //x=38.05 //y=0.93 //x2=37.935 //y2=0.93
r466 (  112 160 ) resistor r=5.52526 //w=0.168 //l=0.115 //layer=ply \
 //thickness=0.18 //x=38.27 //y=0.93 //x2=38.385 //y2=0.93
r467 (  112 113 ) resistor r=112.809 //w=0.094 //l=0.22 //layer=ply \
 //thickness=0.18 //x=38.27 //y=0.93 //x2=38.05 //y2=0.93
r468 (  111 156 ) resistor r=16.5046 //w=0.27 //l=0.135 //layer=ply \
 //thickness=0.18 //x=38.025 //y=4.97 //x2=37.89 //y2=4.97
r469 (  110 117 ) resistor r=26.9307 //w=0.15 //l=0.106066 //layer=ply \
 //thickness=0.18 //x=38.265 //y=4.97 //x2=38.34 //y2=5.045
r470 (  110 111 ) resistor r=123.064 //w=0.094 //l=0.24 //layer=ply \
 //thickness=0.18 //x=38.265 //y=4.97 //x2=38.025 //y2=4.97
r471 (  105 159 ) resistor r=39.5823 //w=0.21 //l=0.173853 //layer=ply \
 //thickness=0.18 //x=37.895 //y=1.74 //x2=37.935 //y2=1.585
r472 (  105 151 ) resistor r=182.032 //w=0.094 //l=0.355 //layer=ply \
 //thickness=0.18 //x=37.895 //y=1.74 //x2=37.895 //y2=2.095
r473 (  104 159 ) resistor r=39.5823 //w=0.21 //l=0.173853 //layer=ply \
 //thickness=0.18 //x=37.895 //y=1.43 //x2=37.935 //y2=1.585
r474 (  103 158 ) resistor r=45.1352 //w=0.168 //l=0.173853 //layer=ply \
 //thickness=0.18 //x=37.895 //y=1.085 //x2=37.935 //y2=0.93
r475 (  103 104 ) resistor r=176.904 //w=0.094 //l=0.345 //layer=ply \
 //thickness=0.18 //x=37.895 //y=1.085 //x2=37.895 //y2=1.43
r476 (  98 100 ) resistor r=26.9307 //w=0.15 //l=0.106066 //layer=ply \
 //thickness=0.18 //x=28.065 //y=4.97 //x2=28.14 //y2=5.045
r477 (  98 99 ) resistor r=148.702 //w=0.094 //l=0.29 //layer=ply \
 //thickness=0.18 //x=28.065 //y=4.97 //x2=27.775 //y2=4.97
r478 (  97 148 ) resistor r=45.1352 //w=0.168 //l=0.173853 //layer=ply \
 //thickness=0.18 //x=27.73 //y=1.4 //x2=27.69 //y2=1.555
r479 (  96 147 ) resistor r=45.1352 //w=0.168 //l=0.173853 //layer=ply \
 //thickness=0.18 //x=27.73 //y=1.055 //x2=27.69 //y2=0.9
r480 (  96 97 ) resistor r=176.904 //w=0.094 //l=0.345 //layer=ply \
 //thickness=0.18 //x=27.73 //y=1.055 //x2=27.73 //y2=1.4
r481 (  93 99 ) resistor r=22.7971 //w=0.269 //l=0.106066 //layer=ply \
 //thickness=0.18 //x=27.7 //y=5.045 //x2=27.775 //y2=4.97
r482 (  93 146 ) resistor r=35.8364 //w=0.269 //l=0.270185 //layer=ply \
 //thickness=0.18 //x=27.7 //y=5.045 //x2=27.5 //y2=4.88
r483 (  91 142 ) resistor r=10.701 //w=0.21 //l=0.115 //layer=ply \
 //thickness=0.18 //x=27.355 //y=1.555 //x2=27.24 //y2=1.555
r484 (  90 148 ) resistor r=5.52526 //w=0.168 //l=0.115 //layer=ply \
 //thickness=0.18 //x=27.575 //y=1.555 //x2=27.69 //y2=1.555
r485 (  89 141 ) resistor r=5.52526 //w=0.168 //l=0.115 //layer=ply \
 //thickness=0.18 //x=27.355 //y=0.9 //x2=27.24 //y2=0.9
r486 (  88 147 ) resistor r=5.52526 //w=0.168 //l=0.115 //layer=ply \
 //thickness=0.18 //x=27.575 //y=0.9 //x2=27.69 //y2=0.9
r487 (  88 89 ) resistor r=112.809 //w=0.094 //l=0.22 //layer=ply \
 //thickness=0.18 //x=27.575 //y=0.9 //x2=27.355 //y2=0.9
r488 (  87 144 ) resistor r=58.7805 //w=0.246 //l=0.373497 //layer=ply \
 //thickness=0.18 //x=27.2 //y=2.095 //x2=27.5 //y2=2.26
r489 (  86 142 ) resistor r=39.5823 //w=0.21 //l=0.173853 //layer=ply \
 //thickness=0.18 //x=27.2 //y=1.71 //x2=27.24 //y2=1.555
r490 (  86 87 ) resistor r=197.415 //w=0.094 //l=0.385 //layer=ply \
 //thickness=0.18 //x=27.2 //y=1.71 //x2=27.2 //y2=2.095
r491 (  85 142 ) resistor r=39.5823 //w=0.21 //l=0.173853 //layer=ply \
 //thickness=0.18 //x=27.2 //y=1.4 //x2=27.24 //y2=1.555
r492 (  84 141 ) resistor r=45.1352 //w=0.168 //l=0.173853 //layer=ply \
 //thickness=0.18 //x=27.2 //y=1.055 //x2=27.24 //y2=0.9
r493 (  84 85 ) resistor r=176.904 //w=0.094 //l=0.345 //layer=ply \
 //thickness=0.18 //x=27.2 //y=1.055 //x2=27.2 //y2=1.4
r494 (  83 136 ) resistor r=592.245 //w=0.094 //l=1.155 //layer=ply \
 //thickness=0.18 //x=51.29 //y=6.2 //x2=51.29 //y2=5.045
r495 (  82 170 ) resistor r=592.245 //w=0.094 //l=1.155 //layer=ply \
 //thickness=0.18 //x=50.85 //y=6.2 //x2=50.85 //y2=5.045
r496 (  81 117 ) resistor r=592.245 //w=0.094 //l=1.155 //layer=ply \
 //thickness=0.18 //x=38.34 //y=6.2 //x2=38.34 //y2=5.045
r497 (  80 157 ) resistor r=592.245 //w=0.094 //l=1.155 //layer=ply \
 //thickness=0.18 //x=37.9 //y=6.2 //x2=37.9 //y2=5.045
r498 (  79 100 ) resistor r=592.245 //w=0.094 //l=1.155 //layer=ply \
 //thickness=0.18 //x=28.14 //y=6.2 //x2=28.14 //y2=5.045
r499 (  78 93 ) resistor r=592.245 //w=0.094 //l=1.155 //layer=ply \
 //thickness=0.18 //x=27.7 //y=6.2 //x2=27.7 //y2=5.045
r500 (  77 133 ) resistor r=56.4043 //w=0.094 //l=0.11 //layer=ply \
 //thickness=0.18 //x=51.11 //y=1.585 //x2=51.22 //y2=1.585
r501 (  77 134 ) resistor r=56.4043 //w=0.094 //l=0.11 //layer=ply \
 //thickness=0.18 //x=51.11 //y=1.585 //x2=51 //y2=1.585
r502 (  76 114 ) resistor r=56.4043 //w=0.094 //l=0.11 //layer=ply \
 //thickness=0.18 //x=38.16 //y=1.585 //x2=38.27 //y2=1.585
r503 (  76 115 ) resistor r=56.4043 //w=0.094 //l=0.11 //layer=ply \
 //thickness=0.18 //x=38.16 //y=1.585 //x2=38.05 //y2=1.585
r504 (  75 90 ) resistor r=56.4043 //w=0.094 //l=0.11 //layer=ply \
 //thickness=0.18 //x=27.465 //y=1.555 //x2=27.575 //y2=1.555
r505 (  75 91 ) resistor r=56.4043 //w=0.094 //l=0.11 //layer=ply \
 //thickness=0.18 //x=27.465 //y=1.555 //x2=27.355 //y2=1.555
r506 (  74 167 ) resistor r=152 //w=0.17 //l=0.17 //layer=licon //count=1 \
 //x=50.84 //y=4.88 //x2=50.84 //y2=4.88
r507 (  70 154 ) resistor r=152 //w=0.17 //l=0.17 //layer=licon //count=1 \
 //x=37.89 //y=4.88 //x2=37.89 //y2=4.88
r508 (  65 163 ) resistor r=152 //w=0.17 //l=0.17 //layer=licon //count=1 \
 //x=50.81 //y=2.26 //x2=50.81 //y2=2.26
r509 (  65 68 ) resistor r=136.214 //w=0.187 //l=1.99 //layer=li \
 //thickness=0.1 //x=50.81 //y=2.26 //x2=50.81 //y2=4.25
r510 (  63 74 ) resistor r=11.4737 //w=0.186 //l=0.172337 //layer=li \
 //thickness=0.1 //x=50.81 //y=4.715 //x2=50.825 //y2=4.88
r511 (  63 68 ) resistor r=31.8289 //w=0.187 //l=0.465 //layer=li \
 //thickness=0.1 //x=50.81 //y=4.715 //x2=50.81 //y2=4.25
r512 (  60 62 ) resistor r=68.4492 //w=0.187 //l=1 //layer=li //thickness=0.1 \
 //x=43.41 //y=5.25 //x2=43.41 //y2=4.25
r513 (  59 62 ) resistor r=158.802 //w=0.187 //l=2.32 //layer=li \
 //thickness=0.1 //x=43.41 //y=1.93 //x2=43.41 //y2=4.25
r514 (  57 59 ) resistor r=7.15173 //w=0.17 //l=0.120208 //layer=li \
 //thickness=0.1 //x=43.325 //y=1.845 //x2=43.41 //y2=1.93
r515 (  57 58 ) resistor r=21.5615 //w=0.187 //l=0.315 //layer=li \
 //thickness=0.1 //x=43.325 //y=1.845 //x2=43.01 //y2=1.845
r516 (  53 58 ) resistor r=7.15173 //w=0.17 //l=0.120208 //layer=li \
 //thickness=0.1 //x=42.925 //y=1.76 //x2=43.01 //y2=1.845
r517 (  53 175 ) resistor r=39.016 //w=0.187 //l=0.57 //layer=li \
 //thickness=0.1 //x=42.925 //y=1.76 //x2=42.925 //y2=1.19
r518 (  52 72 ) resistor r=5.4201 //w=0.17 //l=0.085 //layer=li \
 //thickness=0.1 //x=42.715 //y=5.335 //x2=42.63 //y2=5.335
r519 (  51 60 ) resistor r=7.15173 //w=0.17 //l=0.120208 //layer=li \
 //thickness=0.1 //x=43.325 //y=5.335 //x2=43.41 //y2=5.25
r520 (  51 52 ) resistor r=41.754 //w=0.187 //l=0.61 //layer=li \
 //thickness=0.1 //x=43.325 //y=5.335 //x2=42.715 //y2=5.335
r521 (  45 72 ) resistor r=1.40859 //w=0.34 //l=0.085 //layer=li \
 //thickness=0.1 //x=42.63 //y=5.42 //x2=42.63 //y2=5.335
r522 (  45 179 ) resistor r=33.1979 //w=0.187 //l=0.485 //layer=li \
 //thickness=0.1 //x=42.63 //y=5.42 //x2=42.63 //y2=5.905
r523 (  44 71 ) resistor r=5.4201 //w=0.17 //l=0.085 //layer=li \
 //thickness=0.1 //x=41.835 //y=5.335 //x2=41.75 //y2=5.335
r524 (  43 72 ) resistor r=5.4201 //w=0.17 //l=0.085 //layer=li \
 //thickness=0.1 //x=42.545 //y=5.335 //x2=42.63 //y2=5.335
r525 (  43 44 ) resistor r=48.5989 //w=0.187 //l=0.71 //layer=li \
 //thickness=0.1 //x=42.545 //y=5.335 //x2=41.835 //y2=5.335
r526 (  37 71 ) resistor r=1.40859 //w=0.34 //l=0.085 //layer=li \
 //thickness=0.1 //x=41.75 //y=5.42 //x2=41.75 //y2=5.335
r527 (  37 178 ) resistor r=33.1979 //w=0.187 //l=0.485 //layer=li \
 //thickness=0.1 //x=41.75 //y=5.42 //x2=41.75 //y2=5.905
r528 (  35 71 ) resistor r=5.4201 //w=0.17 //l=0.085 //layer=li \
 //thickness=0.1 //x=41.665 //y=5.335 //x2=41.75 //y2=5.335
r529 (  35 36 ) resistor r=48.5989 //w=0.187 //l=0.71 //layer=li \
 //thickness=0.1 //x=41.665 //y=5.335 //x2=40.955 //y2=5.335
r530 (  29 36 ) resistor r=7.15173 //w=0.17 //l=0.120208 //layer=li \
 //thickness=0.1 //x=40.87 //y=5.42 //x2=40.955 //y2=5.335
r531 (  29 177 ) resistor r=33.1979 //w=0.187 //l=0.485 //layer=li \
 //thickness=0.1 //x=40.87 //y=5.42 //x2=40.87 //y2=5.905
r532 (  25 150 ) resistor r=152 //w=0.17 //l=0.17 //layer=licon //count=1 \
 //x=37.86 //y=2.26 //x2=37.86 //y2=2.26
r533 (  25 28 ) resistor r=136.214 //w=0.187 //l=1.99 //layer=li \
 //thickness=0.1 //x=37.86 //y=2.26 //x2=37.86 //y2=4.25
r534 (  23 70 ) resistor r=11.4737 //w=0.186 //l=0.172337 //layer=li \
 //thickness=0.1 //x=37.86 //y=4.715 //x2=37.875 //y2=4.88
r535 (  23 28 ) resistor r=31.8289 //w=0.187 //l=0.465 //layer=li \
 //thickness=0.1 //x=37.86 //y=4.715 //x2=37.86 //y2=4.25
r536 (  21 146 ) resistor r=152 //w=0.17 //l=0.17 //layer=licon //count=1 \
 //x=27.5 //y=4.88 //x2=27.5 //y2=4.88
r537 (  19 21 ) resistor r=43.123 //w=0.187 //l=0.63 //layer=li \
 //thickness=0.1 //x=27.5 //y=4.25 //x2=27.5 //y2=4.88
r538 (  16 144 ) resistor r=152 //w=0.17 //l=0.17 //layer=licon //count=1 \
 //x=27.5 //y=2.26 //x2=27.5 //y2=2.26
r539 (  16 19 ) resistor r=136.214 //w=0.187 //l=1.99 //layer=li \
 //thickness=0.1 //x=27.5 //y=2.26 //x2=27.5 //y2=4.25
r540 (  14 68 ) resistor r=9.3 //w=0.17 //l=0.17 //layer=mcon //count=1 \
 //x=50.81 //y=4.25 //x2=50.81 //y2=4.25
r541 (  12 62 ) resistor r=9.3 //w=0.17 //l=0.17 //layer=mcon //count=1 \
 //x=43.41 //y=4.25 //x2=43.41 //y2=4.25
r542 (  10 28 ) resistor r=9.3 //w=0.17 //l=0.17 //layer=mcon //count=1 \
 //x=37.86 //y=4.25 //x2=37.86 //y2=4.25
r543 (  8 19 ) resistor r=9.3 //w=0.17 //l=0.17 //layer=mcon //count=1 \
 //x=27.5 //y=4.25 //x2=27.5 //y2=4.25
r544 (  6 12 ) resistor r=0.0880901 //w=0.191 //l=0.115 //layer=m1 \
 //thickness=0.36 //x=43.525 //y=4.25 //x2=43.41 //y2=4.25
r545 (  5 14 ) resistor r=0.0717383 //w=0.224 //l=0.115 //layer=m1 \
 //thickness=0.36 //x=50.695 //y=4.25 //x2=50.81 //y2=4.25
r546 (  5 6 ) resistor r=6.8416 //w=0.131 //l=7.17 //layer=m1 //thickness=0.36 \
 //x=50.695 //y=4.25 //x2=43.525 //y2=4.25
r547 (  4 10 ) resistor r=0.0880901 //w=0.191 //l=0.115 //layer=m1 \
 //thickness=0.36 //x=37.975 //y=4.25 //x2=37.86 //y2=4.25
r548 (  3 12 ) resistor r=0.0880901 //w=0.191 //l=0.115 //layer=m1 \
 //thickness=0.36 //x=43.295 //y=4.25 //x2=43.41 //y2=4.25
r549 (  3 4 ) resistor r=5.07634 //w=0.131 //l=5.32 //layer=m1 \
 //thickness=0.36 //x=43.295 //y=4.25 //x2=37.975 //y2=4.25
r550 (  2 8 ) resistor r=0.0717383 //w=0.224 //l=0.115 //layer=m1 \
 //thickness=0.36 //x=27.615 //y=4.25 //x2=27.5 //y2=4.25
r551 (  1 10 ) resistor r=0.0880901 //w=0.191 //l=0.115 //layer=m1 \
 //thickness=0.36 //x=37.745 //y=4.25 //x2=37.86 //y2=4.25
r552 (  1 2 ) resistor r=9.66603 //w=0.131 //l=10.13 //layer=m1 \
 //thickness=0.36 //x=37.745 //y=4.25 //x2=27.615 //y2=4.25
ends PM_TMRDFFRNQX1\%noxref_11

subckt PM_TMRDFFRNQX1\%D ( 1 2 3 4 11 12 14 23 31 38 39 40 41 42 43 44 45 46 \
 47 48 49 51 57 58 59 60 61 66 67 68 70 76 77 78 79 80 85 86 87 89 95 96 97 98 \
 99 107 118 129 )
c368 ( 129 0 ) capacitor c=0.0335551f //x=59.32 //y=4.88
c369 ( 118 0 ) capacitor c=0.0335551f //x=33.42 //y=4.88
c370 ( 107 0 ) capacitor c=0.0335551f //x=7.52 //y=4.88
c371 ( 99 0 ) capacitor c=0.0245352f //x=59.655 //y=4.97
c372 ( 98 0 ) capacitor c=0.0825763f //x=59.41 //y=2.095
c373 ( 97 0 ) capacitor c=0.0170266f //x=59.41 //y=1.63
c374 ( 96 0 ) capacitor c=0.018609f //x=59.41 //y=1.4
c375 ( 95 0 ) capacitor c=0.0187309f //x=59.41 //y=1.09
c376 ( 89 0 ) capacitor c=0.014725f //x=59.255 //y=1.555
c377 ( 87 0 ) capacitor c=0.0146567f //x=59.255 //y=0.935
c378 ( 86 0 ) capacitor c=0.0335408f //x=58.885 //y=1.4
c379 ( 85 0 ) capacitor c=0.0173761f //x=58.885 //y=1.09
c380 ( 80 0 ) capacitor c=0.0245352f //x=33.755 //y=4.97
c381 ( 79 0 ) capacitor c=0.0825763f //x=33.51 //y=2.095
c382 ( 78 0 ) capacitor c=0.0170266f //x=33.51 //y=1.63
c383 ( 77 0 ) capacitor c=0.018609f //x=33.51 //y=1.4
c384 ( 76 0 ) capacitor c=0.0187309f //x=33.51 //y=1.09
c385 ( 70 0 ) capacitor c=0.014725f //x=33.355 //y=1.555
c386 ( 68 0 ) capacitor c=0.0146567f //x=33.355 //y=0.935
c387 ( 67 0 ) capacitor c=0.0335408f //x=32.985 //y=1.4
c388 ( 66 0 ) capacitor c=0.0173761f //x=32.985 //y=1.09
c389 ( 61 0 ) capacitor c=0.0245352f //x=7.855 //y=4.97
c390 ( 60 0 ) capacitor c=0.0826363f //x=7.61 //y=2.095
c391 ( 59 0 ) capacitor c=0.0170266f //x=7.61 //y=1.63
c392 ( 58 0 ) capacitor c=0.018609f //x=7.61 //y=1.4
c393 ( 57 0 ) capacitor c=0.0187309f //x=7.61 //y=1.09
c394 ( 51 0 ) capacitor c=0.014725f //x=7.455 //y=1.555
c395 ( 49 0 ) capacitor c=0.0146567f //x=7.455 //y=0.935
c396 ( 48 0 ) capacitor c=0.0335408f //x=7.085 //y=1.4
c397 ( 47 0 ) capacitor c=0.0173761f //x=7.085 //y=1.09
c398 ( 46 0 ) capacitor c=0.110114f //x=59.73 //y=6.2
c399 ( 45 0 ) capacitor c=0.11012f //x=59.29 //y=6.2
c400 ( 44 0 ) capacitor c=0.110114f //x=33.83 //y=6.2
c401 ( 43 0 ) capacitor c=0.11012f //x=33.39 //y=6.2
c402 ( 42 0 ) capacitor c=0.110114f //x=7.93 //y=6.2
c403 ( 41 0 ) capacitor c=0.11012f //x=7.49 //y=6.2
c404 ( 31 0 ) capacitor c=0.0879663f //x=59.32 //y=2.26
c405 ( 23 0 ) capacitor c=0.0879663f //x=33.42 //y=2.26
c406 ( 14 0 ) capacitor c=0.0930795f //x=7.52 //y=2.26
c407 ( 4 0 ) capacitor c=0.00558494f //x=33.535 //y=2.77
c408 ( 3 0 ) capacitor c=0.34213f //x=59.205 //y=2.77
c409 ( 2 0 ) capacitor c=0.0159757f //x=7.635 //y=2.77
c410 ( 1 0 ) capacitor c=0.411825f //x=33.305 //y=2.77
r411 (  131 132 ) resistor r=32.4568 //w=0.214 //l=0.075 //layer=ply \
 //thickness=0.18 //x=59.32 //y=4.97 //x2=59.32 //y2=5.045
r412 (  129 131 ) resistor r=20.271 //w=0.214 //l=0.09 //layer=ply \
 //thickness=0.18 //x=59.32 //y=4.88 //x2=59.32 //y2=4.97
r413 (  120 121 ) resistor r=32.4568 //w=0.214 //l=0.075 //layer=ply \
 //thickness=0.18 //x=33.42 //y=4.97 //x2=33.42 //y2=5.045
r414 (  118 120 ) resistor r=20.271 //w=0.214 //l=0.09 //layer=ply \
 //thickness=0.18 //x=33.42 //y=4.88 //x2=33.42 //y2=4.97
r415 (  109 110 ) resistor r=32.4568 //w=0.214 //l=0.075 //layer=ply \
 //thickness=0.18 //x=7.52 //y=4.97 //x2=7.52 //y2=5.045
r416 (  107 109 ) resistor r=20.271 //w=0.214 //l=0.09 //layer=ply \
 //thickness=0.18 //x=7.52 //y=4.88 //x2=7.52 //y2=4.97
r417 (  100 131 ) resistor r=16.5046 //w=0.27 //l=0.135 //layer=ply \
 //thickness=0.18 //x=59.455 //y=4.97 //x2=59.32 //y2=4.97
r418 (  99 101 ) resistor r=26.9307 //w=0.15 //l=0.106066 //layer=ply \
 //thickness=0.18 //x=59.655 //y=4.97 //x2=59.73 //y2=5.045
r419 (  99 100 ) resistor r=102.553 //w=0.094 //l=0.2 //layer=ply \
 //thickness=0.18 //x=59.655 //y=4.97 //x2=59.455 //y2=4.97
r420 (  98 136 ) resistor r=38.6777 //w=0.284 //l=0.198997 //layer=ply \
 //thickness=0.18 //x=59.41 //y=2.095 //x2=59.335 //y2=2.26
r421 (  97 134 ) resistor r=21.2976 //w=0.217 //l=0.0928709 //layer=ply \
 //thickness=0.18 //x=59.41 //y=1.63 //x2=59.37 //y2=1.555
r422 (  97 98 ) resistor r=238.436 //w=0.094 //l=0.465 //layer=ply \
 //thickness=0.18 //x=59.41 //y=1.63 //x2=59.41 //y2=2.095
r423 (  96 134 ) resistor r=39.0671 //w=0.217 //l=0.173853 //layer=ply \
 //thickness=0.18 //x=59.41 //y=1.4 //x2=59.37 //y2=1.555
r424 (  95 133 ) resistor r=45.1352 //w=0.168 //l=0.173853 //layer=ply \
 //thickness=0.18 //x=59.41 //y=1.09 //x2=59.37 //y2=0.935
r425 (  95 96 ) resistor r=158.957 //w=0.094 //l=0.31 //layer=ply \
 //thickness=0.18 //x=59.41 //y=1.09 //x2=59.41 //y2=1.4
r426 (  90 127 ) resistor r=5.52526 //w=0.168 //l=0.115 //layer=ply \
 //thickness=0.18 //x=59.04 //y=1.555 //x2=58.925 //y2=1.555
r427 (  89 134 ) resistor r=11.4558 //w=0.217 //l=0.115 //layer=ply \
 //thickness=0.18 //x=59.255 //y=1.555 //x2=59.37 //y2=1.555
r428 (  88 126 ) resistor r=5.52526 //w=0.168 //l=0.115 //layer=ply \
 //thickness=0.18 //x=59.04 //y=0.935 //x2=58.925 //y2=0.935
r429 (  87 133 ) resistor r=5.52526 //w=0.168 //l=0.115 //layer=ply \
 //thickness=0.18 //x=59.255 //y=0.935 //x2=59.37 //y2=0.935
r430 (  87 88 ) resistor r=110.245 //w=0.094 //l=0.215 //layer=ply \
 //thickness=0.18 //x=59.255 //y=0.935 //x2=59.04 //y2=0.935
r431 (  86 127 ) resistor r=45.1352 //w=0.168 //l=0.173853 //layer=ply \
 //thickness=0.18 //x=58.885 //y=1.4 //x2=58.925 //y2=1.555
r432 (  85 126 ) resistor r=45.1352 //w=0.168 //l=0.173853 //layer=ply \
 //thickness=0.18 //x=58.885 //y=1.09 //x2=58.925 //y2=0.935
r433 (  85 86 ) resistor r=158.957 //w=0.094 //l=0.31 //layer=ply \
 //thickness=0.18 //x=58.885 //y=1.09 //x2=58.885 //y2=1.4
r434 (  81 120 ) resistor r=16.5046 //w=0.27 //l=0.135 //layer=ply \
 //thickness=0.18 //x=33.555 //y=4.97 //x2=33.42 //y2=4.97
r435 (  80 82 ) resistor r=26.9307 //w=0.15 //l=0.106066 //layer=ply \
 //thickness=0.18 //x=33.755 //y=4.97 //x2=33.83 //y2=5.045
r436 (  80 81 ) resistor r=102.553 //w=0.094 //l=0.2 //layer=ply \
 //thickness=0.18 //x=33.755 //y=4.97 //x2=33.555 //y2=4.97
r437 (  79 125 ) resistor r=38.6777 //w=0.284 //l=0.198997 //layer=ply \
 //thickness=0.18 //x=33.51 //y=2.095 //x2=33.435 //y2=2.26
r438 (  78 123 ) resistor r=21.2976 //w=0.217 //l=0.0928709 //layer=ply \
 //thickness=0.18 //x=33.51 //y=1.63 //x2=33.47 //y2=1.555
r439 (  78 79 ) resistor r=238.436 //w=0.094 //l=0.465 //layer=ply \
 //thickness=0.18 //x=33.51 //y=1.63 //x2=33.51 //y2=2.095
r440 (  77 123 ) resistor r=39.0671 //w=0.217 //l=0.173853 //layer=ply \
 //thickness=0.18 //x=33.51 //y=1.4 //x2=33.47 //y2=1.555
r441 (  76 122 ) resistor r=45.1352 //w=0.168 //l=0.173853 //layer=ply \
 //thickness=0.18 //x=33.51 //y=1.09 //x2=33.47 //y2=0.935
r442 (  76 77 ) resistor r=158.957 //w=0.094 //l=0.31 //layer=ply \
 //thickness=0.18 //x=33.51 //y=1.09 //x2=33.51 //y2=1.4
r443 (  71 116 ) resistor r=5.52526 //w=0.168 //l=0.115 //layer=ply \
 //thickness=0.18 //x=33.14 //y=1.555 //x2=33.025 //y2=1.555
r444 (  70 123 ) resistor r=11.4558 //w=0.217 //l=0.115 //layer=ply \
 //thickness=0.18 //x=33.355 //y=1.555 //x2=33.47 //y2=1.555
r445 (  69 115 ) resistor r=5.52526 //w=0.168 //l=0.115 //layer=ply \
 //thickness=0.18 //x=33.14 //y=0.935 //x2=33.025 //y2=0.935
r446 (  68 122 ) resistor r=5.52526 //w=0.168 //l=0.115 //layer=ply \
 //thickness=0.18 //x=33.355 //y=0.935 //x2=33.47 //y2=0.935
r447 (  68 69 ) resistor r=110.245 //w=0.094 //l=0.215 //layer=ply \
 //thickness=0.18 //x=33.355 //y=0.935 //x2=33.14 //y2=0.935
r448 (  67 116 ) resistor r=45.1352 //w=0.168 //l=0.173853 //layer=ply \
 //thickness=0.18 //x=32.985 //y=1.4 //x2=33.025 //y2=1.555
r449 (  66 115 ) resistor r=45.1352 //w=0.168 //l=0.173853 //layer=ply \
 //thickness=0.18 //x=32.985 //y=1.09 //x2=33.025 //y2=0.935
r450 (  66 67 ) resistor r=158.957 //w=0.094 //l=0.31 //layer=ply \
 //thickness=0.18 //x=32.985 //y=1.09 //x2=32.985 //y2=1.4
r451 (  62 109 ) resistor r=16.5046 //w=0.27 //l=0.135 //layer=ply \
 //thickness=0.18 //x=7.655 //y=4.97 //x2=7.52 //y2=4.97
r452 (  61 63 ) resistor r=26.9307 //w=0.15 //l=0.106066 //layer=ply \
 //thickness=0.18 //x=7.855 //y=4.97 //x2=7.93 //y2=5.045
r453 (  61 62 ) resistor r=102.553 //w=0.094 //l=0.2 //layer=ply \
 //thickness=0.18 //x=7.855 //y=4.97 //x2=7.655 //y2=4.97
r454 (  60 114 ) resistor r=38.6777 //w=0.284 //l=0.198997 //layer=ply \
 //thickness=0.18 //x=7.61 //y=2.095 //x2=7.535 //y2=2.26
r455 (  59 112 ) resistor r=21.2976 //w=0.217 //l=0.0928709 //layer=ply \
 //thickness=0.18 //x=7.61 //y=1.63 //x2=7.57 //y2=1.555
r456 (  59 60 ) resistor r=238.436 //w=0.094 //l=0.465 //layer=ply \
 //thickness=0.18 //x=7.61 //y=1.63 //x2=7.61 //y2=2.095
r457 (  58 112 ) resistor r=39.0671 //w=0.217 //l=0.173853 //layer=ply \
 //thickness=0.18 //x=7.61 //y=1.4 //x2=7.57 //y2=1.555
r458 (  57 111 ) resistor r=45.1352 //w=0.168 //l=0.173853 //layer=ply \
 //thickness=0.18 //x=7.61 //y=1.09 //x2=7.57 //y2=0.935
r459 (  57 58 ) resistor r=158.957 //w=0.094 //l=0.31 //layer=ply \
 //thickness=0.18 //x=7.61 //y=1.09 //x2=7.61 //y2=1.4
r460 (  52 105 ) resistor r=5.52526 //w=0.168 //l=0.115 //layer=ply \
 //thickness=0.18 //x=7.24 //y=1.555 //x2=7.125 //y2=1.555
r461 (  51 112 ) resistor r=11.4558 //w=0.217 //l=0.115 //layer=ply \
 //thickness=0.18 //x=7.455 //y=1.555 //x2=7.57 //y2=1.555
r462 (  50 104 ) resistor r=5.52526 //w=0.168 //l=0.115 //layer=ply \
 //thickness=0.18 //x=7.24 //y=0.935 //x2=7.125 //y2=0.935
r463 (  49 111 ) resistor r=5.52526 //w=0.168 //l=0.115 //layer=ply \
 //thickness=0.18 //x=7.455 //y=0.935 //x2=7.57 //y2=0.935
r464 (  49 50 ) resistor r=110.245 //w=0.094 //l=0.215 //layer=ply \
 //thickness=0.18 //x=7.455 //y=0.935 //x2=7.24 //y2=0.935
r465 (  48 105 ) resistor r=45.1352 //w=0.168 //l=0.173853 //layer=ply \
 //thickness=0.18 //x=7.085 //y=1.4 //x2=7.125 //y2=1.555
r466 (  47 104 ) resistor r=45.1352 //w=0.168 //l=0.173853 //layer=ply \
 //thickness=0.18 //x=7.085 //y=1.09 //x2=7.125 //y2=0.935
r467 (  47 48 ) resistor r=158.957 //w=0.094 //l=0.31 //layer=ply \
 //thickness=0.18 //x=7.085 //y=1.09 //x2=7.085 //y2=1.4
r468 (  46 101 ) resistor r=592.245 //w=0.094 //l=1.155 //layer=ply \
 //thickness=0.18 //x=59.73 //y=6.2 //x2=59.73 //y2=5.045
r469 (  45 132 ) resistor r=592.245 //w=0.094 //l=1.155 //layer=ply \
 //thickness=0.18 //x=59.29 //y=6.2 //x2=59.29 //y2=5.045
r470 (  44 82 ) resistor r=592.245 //w=0.094 //l=1.155 //layer=ply \
 //thickness=0.18 //x=33.83 //y=6.2 //x2=33.83 //y2=5.045
r471 (  43 121 ) resistor r=592.245 //w=0.094 //l=1.155 //layer=ply \
 //thickness=0.18 //x=33.39 //y=6.2 //x2=33.39 //y2=5.045
r472 (  42 63 ) resistor r=592.245 //w=0.094 //l=1.155 //layer=ply \
 //thickness=0.18 //x=7.93 //y=6.2 //x2=7.93 //y2=5.045
r473 (  41 110 ) resistor r=592.245 //w=0.094 //l=1.155 //layer=ply \
 //thickness=0.18 //x=7.49 //y=6.2 //x2=7.49 //y2=5.045
r474 (  40 89 ) resistor r=55.3787 //w=0.094 //l=0.108 //layer=ply \
 //thickness=0.18 //x=59.147 //y=1.555 //x2=59.255 //y2=1.555
r475 (  40 90 ) resistor r=54.866 //w=0.094 //l=0.107 //layer=ply \
 //thickness=0.18 //x=59.147 //y=1.555 //x2=59.04 //y2=1.555
r476 (  39 70 ) resistor r=55.3787 //w=0.094 //l=0.108 //layer=ply \
 //thickness=0.18 //x=33.247 //y=1.555 //x2=33.355 //y2=1.555
r477 (  39 71 ) resistor r=54.866 //w=0.094 //l=0.107 //layer=ply \
 //thickness=0.18 //x=33.247 //y=1.555 //x2=33.14 //y2=1.555
r478 (  38 51 ) resistor r=55.3787 //w=0.094 //l=0.108 //layer=ply \
 //thickness=0.18 //x=7.347 //y=1.555 //x2=7.455 //y2=1.555
r479 (  38 52 ) resistor r=54.866 //w=0.094 //l=0.107 //layer=ply \
 //thickness=0.18 //x=7.347 //y=1.555 //x2=7.24 //y2=1.555
r480 (  36 129 ) resistor r=152 //w=0.17 //l=0.17 //layer=licon //count=1 \
 //x=59.32 //y=4.88 //x2=59.32 //y2=4.88
r481 (  34 36 ) resistor r=144.428 //w=0.187 //l=2.11 //layer=li \
 //thickness=0.1 //x=59.32 //y=2.77 //x2=59.32 //y2=4.88
r482 (  31 136 ) resistor r=152 //w=0.17 //l=0.17 //layer=licon //count=1 \
 //x=59.32 //y=2.26 //x2=59.32 //y2=2.26
r483 (  31 34 ) resistor r=34.9091 //w=0.187 //l=0.51 //layer=li \
 //thickness=0.1 //x=59.32 //y=2.26 //x2=59.32 //y2=2.77
r484 (  28 118 ) resistor r=152 //w=0.17 //l=0.17 //layer=licon //count=1 \
 //x=33.42 //y=4.88 //x2=33.42 //y2=4.88
r485 (  26 28 ) resistor r=144.428 //w=0.187 //l=2.11 //layer=li \
 //thickness=0.1 //x=33.42 //y=2.77 //x2=33.42 //y2=4.88
r486 (  23 125 ) resistor r=152 //w=0.17 //l=0.17 //layer=licon //count=1 \
 //x=33.42 //y=2.26 //x2=33.42 //y2=2.26
r487 (  23 26 ) resistor r=34.9091 //w=0.187 //l=0.51 //layer=li \
 //thickness=0.1 //x=33.42 //y=2.26 //x2=33.42 //y2=2.77
r488 (  20 107 ) resistor r=152 //w=0.17 //l=0.17 //layer=licon //count=1 \
 //x=7.52 //y=4.88 //x2=7.52 //y2=4.88
r489 (  14 114 ) resistor r=152 //w=0.17 //l=0.17 //layer=licon //count=1 \
 //x=7.52 //y=2.26 //x2=7.52 //y2=2.26
r490 (  12 20 ) resistor r=119.102 //w=0.187 //l=1.74 //layer=li \
 //thickness=0.1 //x=7.52 //y=3.14 //x2=7.52 //y2=4.88
r491 (  11 12 ) resistor r=25.3262 //w=0.187 //l=0.37 //layer=li \
 //thickness=0.1 //x=7.52 //y=2.77 //x2=7.52 //y2=3.14
r492 (  11 14 ) resistor r=34.9091 //w=0.187 //l=0.51 //layer=li \
 //thickness=0.1 //x=7.52 //y=2.77 //x2=7.52 //y2=2.26
r493 (  10 34 ) resistor r=9.3 //w=0.17 //l=0.17 //layer=mcon //count=1 \
 //x=59.32 //y=2.77 //x2=59.32 //y2=2.77
r494 (  8 26 ) resistor r=9.3 //w=0.17 //l=0.17 //layer=mcon //count=1 \
 //x=33.42 //y=2.77 //x2=33.42 //y2=2.77
r495 (  6 11 ) resistor r=9.3 //w=0.17 //l=0.17 //layer=mcon //count=1 \
 //x=7.52 //y=2.77 //x2=7.52 //y2=2.77
r496 (  4 8 ) resistor r=0.0880901 //w=0.191 //l=0.115 //layer=m1 \
 //thickness=0.36 //x=33.535 //y=2.77 //x2=33.42 //y2=2.77
r497 (  3 10 ) resistor r=0.0738079 //w=0.207 //l=0.115 //layer=m1 \
 //thickness=0.36 //x=59.205 //y=2.77 //x2=59.32 //y2=2.77
r498 (  3 4 ) resistor r=24.4943 //w=0.131 //l=25.67 //layer=m1 \
 //thickness=0.36 //x=59.205 //y=2.77 //x2=33.535 //y2=2.77
r499 (  2 6 ) resistor r=0.0717383 //w=0.224 //l=0.115 //layer=m1 \
 //thickness=0.36 //x=7.635 //y=2.77 //x2=7.52 //y2=2.77
r500 (  1 8 ) resistor r=0.0880901 //w=0.191 //l=0.115 //layer=m1 \
 //thickness=0.36 //x=33.305 //y=2.77 //x2=33.42 //y2=2.77
r501 (  1 2 ) resistor r=24.4943 //w=0.131 //l=25.67 //layer=m1 \
 //thickness=0.36 //x=33.305 //y=2.77 //x2=7.635 //y2=2.77
ends PM_TMRDFFRNQX1\%D

subckt PM_TMRDFFRNQX1\%CLK ( 1 2 3 4 5 6 7 8 9 10 23 24 25 26 27 28 29 30 31 \
 32 33 34 35 36 37 38 40 52 62 72 81 90 97 98 99 100 101 102 103 104 105 106 \
 107 108 109 110 111 112 113 114 115 116 117 119 125 126 127 128 129 134 135 \
 136 138 144 145 146 147 148 153 154 155 157 163 164 165 166 167 172 173 174 \
 176 182 183 184 185 186 191 192 193 195 201 202 203 204 205 210 211 212 214 \
 220 221 222 223 224 232 243 254 265 276 287 )
c785 ( 287 0 ) capacitor c=0.0334842f //x=67.46 //y=4.88
c786 ( 276 0 ) capacitor c=0.0334842f //x=54.51 //y=4.88
c787 ( 265 0 ) capacitor c=0.0334842f //x=41.56 //y=4.88
c788 ( 254 0 ) capacitor c=0.0334842f //x=28.61 //y=4.88
c789 ( 243 0 ) capacitor c=0.0334842f //x=15.66 //y=4.88
c790 ( 232 0 ) capacitor c=0.0334842f //x=2.71 //y=4.88
c791 ( 224 0 ) capacitor c=0.0249231f //x=67.795 //y=4.97
c792 ( 223 0 ) capacitor c=0.0825763f //x=67.55 //y=2.095
c793 ( 222 0 ) capacitor c=0.0170266f //x=67.55 //y=1.63
c794 ( 221 0 ) capacitor c=0.018609f //x=67.55 //y=1.4
c795 ( 220 0 ) capacitor c=0.0187309f //x=67.55 //y=1.09
c796 ( 214 0 ) capacitor c=0.014725f //x=67.395 //y=1.555
c797 ( 212 0 ) capacitor c=0.0146567f //x=67.395 //y=0.935
c798 ( 211 0 ) capacitor c=0.0335408f //x=67.025 //y=1.4
c799 ( 210 0 ) capacitor c=0.0173761f //x=67.025 //y=1.09
c800 ( 205 0 ) capacitor c=0.0245352f //x=54.845 //y=4.97
c801 ( 204 0 ) capacitor c=0.0825763f //x=54.6 //y=2.095
c802 ( 203 0 ) capacitor c=0.0170266f //x=54.6 //y=1.63
c803 ( 202 0 ) capacitor c=0.018609f //x=54.6 //y=1.4
c804 ( 201 0 ) capacitor c=0.0187309f //x=54.6 //y=1.09
c805 ( 195 0 ) capacitor c=0.014725f //x=54.445 //y=1.555
c806 ( 193 0 ) capacitor c=0.0146567f //x=54.445 //y=0.935
c807 ( 192 0 ) capacitor c=0.0335408f //x=54.075 //y=1.4
c808 ( 191 0 ) capacitor c=0.0173761f //x=54.075 //y=1.09
c809 ( 186 0 ) capacitor c=0.0245352f //x=41.895 //y=4.97
c810 ( 185 0 ) capacitor c=0.0825763f //x=41.65 //y=2.095
c811 ( 184 0 ) capacitor c=0.0170266f //x=41.65 //y=1.63
c812 ( 183 0 ) capacitor c=0.018609f //x=41.65 //y=1.4
c813 ( 182 0 ) capacitor c=0.0187309f //x=41.65 //y=1.09
c814 ( 176 0 ) capacitor c=0.014725f //x=41.495 //y=1.555
c815 ( 174 0 ) capacitor c=0.0146567f //x=41.495 //y=0.935
c816 ( 173 0 ) capacitor c=0.0335408f //x=41.125 //y=1.4
c817 ( 172 0 ) capacitor c=0.0173761f //x=41.125 //y=1.09
c818 ( 167 0 ) capacitor c=0.0245352f //x=28.945 //y=4.97
c819 ( 166 0 ) capacitor c=0.0825763f //x=28.7 //y=2.095
c820 ( 165 0 ) capacitor c=0.0170266f //x=28.7 //y=1.63
c821 ( 164 0 ) capacitor c=0.018609f //x=28.7 //y=1.4
c822 ( 163 0 ) capacitor c=0.0187309f //x=28.7 //y=1.09
c823 ( 157 0 ) capacitor c=0.014725f //x=28.545 //y=1.555
c824 ( 155 0 ) capacitor c=0.0146567f //x=28.545 //y=0.935
c825 ( 154 0 ) capacitor c=0.0335408f //x=28.175 //y=1.4
c826 ( 153 0 ) capacitor c=0.0173761f //x=28.175 //y=1.09
c827 ( 148 0 ) capacitor c=0.0245352f //x=15.995 //y=4.97
c828 ( 147 0 ) capacitor c=0.0825763f //x=15.75 //y=2.095
c829 ( 146 0 ) capacitor c=0.0170266f //x=15.75 //y=1.63
c830 ( 145 0 ) capacitor c=0.018609f //x=15.75 //y=1.4
c831 ( 144 0 ) capacitor c=0.0187309f //x=15.75 //y=1.09
c832 ( 138 0 ) capacitor c=0.014725f //x=15.595 //y=1.555
c833 ( 136 0 ) capacitor c=0.0146567f //x=15.595 //y=0.935
c834 ( 135 0 ) capacitor c=0.0335408f //x=15.225 //y=1.4
c835 ( 134 0 ) capacitor c=0.0173761f //x=15.225 //y=1.09
c836 ( 129 0 ) capacitor c=0.0245352f //x=3.045 //y=4.97
c837 ( 128 0 ) capacitor c=0.0850619f //x=2.8 //y=2.095
c838 ( 127 0 ) capacitor c=0.0170266f //x=2.8 //y=1.63
c839 ( 126 0 ) capacitor c=0.018609f //x=2.8 //y=1.4
c840 ( 125 0 ) capacitor c=0.0187309f //x=2.8 //y=1.09
c841 ( 119 0 ) capacitor c=0.014725f //x=2.645 //y=1.555
c842 ( 117 0 ) capacitor c=0.0146567f //x=2.645 //y=0.935
c843 ( 116 0 ) capacitor c=0.0335408f //x=2.275 //y=1.4
c844 ( 115 0 ) capacitor c=0.0173761f //x=2.275 //y=1.09
c845 ( 114 0 ) capacitor c=0.110114f //x=67.87 //y=6.2
c846 ( 113 0 ) capacitor c=0.11012f //x=67.43 //y=6.2
c847 ( 112 0 ) capacitor c=0.110114f //x=54.92 //y=6.2
c848 ( 111 0 ) capacitor c=0.11012f //x=54.48 //y=6.2
c849 ( 110 0 ) capacitor c=0.110114f //x=41.97 //y=6.2
c850 ( 109 0 ) capacitor c=0.11012f //x=41.53 //y=6.2
c851 ( 108 0 ) capacitor c=0.110114f //x=29.02 //y=6.2
c852 ( 107 0 ) capacitor c=0.11012f //x=28.58 //y=6.2
c853 ( 106 0 ) capacitor c=0.110114f //x=16.07 //y=6.2
c854 ( 105 0 ) capacitor c=0.11012f //x=15.63 //y=6.2
c855 ( 104 0 ) capacitor c=0.110114f //x=3.12 //y=6.2
c856 ( 103 0 ) capacitor c=0.11012f //x=2.68 //y=6.2
c857 ( 90 0 ) capacitor c=0.0906039f //x=67.46 //y=2.26
c858 ( 81 0 ) capacitor c=0.0901246f //x=54.51 //y=2.26
c859 ( 72 0 ) capacitor c=0.0899873f //x=41.56 //y=2.26
c860 ( 62 0 ) capacitor c=0.0921514f //x=28.61 //y=2.26
c861 ( 52 0 ) capacitor c=0.0926307f //x=15.66 //y=2.26
c862 ( 40 0 ) capacitor c=0.100158f //x=2.71 //y=2.26
c863 ( 10 0 ) capacitor c=0.00697397f //x=54.625 //y=4.62
c864 ( 9 0 ) capacitor c=0.301662f //x=67.345 //y=4.62
c865 ( 8 0 ) capacitor c=0.00697397f //x=41.675 //y=4.62
c866 ( 7 0 ) capacitor c=0.301789f //x=54.395 //y=4.62
c867 ( 6 0 ) capacitor c=0.00697397f //x=28.725 //y=4.62
c868 ( 5 0 ) capacitor c=0.286372f //x=41.445 //y=4.62
c869 ( 4 0 ) capacitor c=0.00697397f //x=15.775 //y=4.62
c870 ( 3 0 ) capacitor c=0.307121f //x=28.495 //y=4.62
c871 ( 2 0 ) capacitor c=0.0154455f //x=2.825 //y=4.62
c872 ( 1 0 ) capacitor c=0.286372f //x=15.545 //y=4.62
r873 (  289 290 ) resistor r=32.4568 //w=0.214 //l=0.075 //layer=ply \
 //thickness=0.18 //x=67.46 //y=4.97 //x2=67.46 //y2=5.045
r874 (  287 289 ) resistor r=20.271 //w=0.214 //l=0.09 //layer=ply \
 //thickness=0.18 //x=67.46 //y=4.88 //x2=67.46 //y2=4.97
r875 (  278 279 ) resistor r=32.4568 //w=0.214 //l=0.075 //layer=ply \
 //thickness=0.18 //x=54.51 //y=4.97 //x2=54.51 //y2=5.045
r876 (  276 278 ) resistor r=20.271 //w=0.214 //l=0.09 //layer=ply \
 //thickness=0.18 //x=54.51 //y=4.88 //x2=54.51 //y2=4.97
r877 (  267 268 ) resistor r=32.4568 //w=0.214 //l=0.075 //layer=ply \
 //thickness=0.18 //x=41.56 //y=4.97 //x2=41.56 //y2=5.045
r878 (  265 267 ) resistor r=20.271 //w=0.214 //l=0.09 //layer=ply \
 //thickness=0.18 //x=41.56 //y=4.88 //x2=41.56 //y2=4.97
r879 (  256 257 ) resistor r=32.4568 //w=0.214 //l=0.075 //layer=ply \
 //thickness=0.18 //x=28.61 //y=4.97 //x2=28.61 //y2=5.045
r880 (  254 256 ) resistor r=20.271 //w=0.214 //l=0.09 //layer=ply \
 //thickness=0.18 //x=28.61 //y=4.88 //x2=28.61 //y2=4.97
r881 (  245 246 ) resistor r=32.4568 //w=0.214 //l=0.075 //layer=ply \
 //thickness=0.18 //x=15.66 //y=4.97 //x2=15.66 //y2=5.045
r882 (  243 245 ) resistor r=20.271 //w=0.214 //l=0.09 //layer=ply \
 //thickness=0.18 //x=15.66 //y=4.88 //x2=15.66 //y2=4.97
r883 (  234 235 ) resistor r=32.4568 //w=0.214 //l=0.075 //layer=ply \
 //thickness=0.18 //x=2.71 //y=4.97 //x2=2.71 //y2=5.045
r884 (  232 234 ) resistor r=20.271 //w=0.214 //l=0.09 //layer=ply \
 //thickness=0.18 //x=2.71 //y=4.88 //x2=2.71 //y2=4.97
r885 (  225 289 ) resistor r=16.5046 //w=0.27 //l=0.135 //layer=ply \
 //thickness=0.18 //x=67.595 //y=4.97 //x2=67.46 //y2=4.97
r886 (  224 226 ) resistor r=26.9307 //w=0.15 //l=0.106066 //layer=ply \
 //thickness=0.18 //x=67.795 //y=4.97 //x2=67.87 //y2=5.045
r887 (  224 225 ) resistor r=102.553 //w=0.094 //l=0.2 //layer=ply \
 //thickness=0.18 //x=67.795 //y=4.97 //x2=67.595 //y2=4.97
r888 (  223 294 ) resistor r=38.6777 //w=0.284 //l=0.198997 //layer=ply \
 //thickness=0.18 //x=67.55 //y=2.095 //x2=67.475 //y2=2.26
r889 (  222 292 ) resistor r=21.2976 //w=0.217 //l=0.0928709 //layer=ply \
 //thickness=0.18 //x=67.55 //y=1.63 //x2=67.51 //y2=1.555
r890 (  222 223 ) resistor r=238.436 //w=0.094 //l=0.465 //layer=ply \
 //thickness=0.18 //x=67.55 //y=1.63 //x2=67.55 //y2=2.095
r891 (  221 292 ) resistor r=39.0671 //w=0.217 //l=0.173853 //layer=ply \
 //thickness=0.18 //x=67.55 //y=1.4 //x2=67.51 //y2=1.555
r892 (  220 291 ) resistor r=45.1352 //w=0.168 //l=0.173853 //layer=ply \
 //thickness=0.18 //x=67.55 //y=1.09 //x2=67.51 //y2=0.935
r893 (  220 221 ) resistor r=158.957 //w=0.094 //l=0.31 //layer=ply \
 //thickness=0.18 //x=67.55 //y=1.09 //x2=67.55 //y2=1.4
r894 (  215 285 ) resistor r=5.52526 //w=0.168 //l=0.115 //layer=ply \
 //thickness=0.18 //x=67.18 //y=1.555 //x2=67.065 //y2=1.555
r895 (  214 292 ) resistor r=11.4558 //w=0.217 //l=0.115 //layer=ply \
 //thickness=0.18 //x=67.395 //y=1.555 //x2=67.51 //y2=1.555
r896 (  213 284 ) resistor r=5.52526 //w=0.168 //l=0.115 //layer=ply \
 //thickness=0.18 //x=67.18 //y=0.935 //x2=67.065 //y2=0.935
r897 (  212 291 ) resistor r=5.52526 //w=0.168 //l=0.115 //layer=ply \
 //thickness=0.18 //x=67.395 //y=0.935 //x2=67.51 //y2=0.935
r898 (  212 213 ) resistor r=110.245 //w=0.094 //l=0.215 //layer=ply \
 //thickness=0.18 //x=67.395 //y=0.935 //x2=67.18 //y2=0.935
r899 (  211 285 ) resistor r=45.1352 //w=0.168 //l=0.173853 //layer=ply \
 //thickness=0.18 //x=67.025 //y=1.4 //x2=67.065 //y2=1.555
r900 (  210 284 ) resistor r=45.1352 //w=0.168 //l=0.173853 //layer=ply \
 //thickness=0.18 //x=67.025 //y=1.09 //x2=67.065 //y2=0.935
r901 (  210 211 ) resistor r=158.957 //w=0.094 //l=0.31 //layer=ply \
 //thickness=0.18 //x=67.025 //y=1.09 //x2=67.025 //y2=1.4
r902 (  206 278 ) resistor r=16.5046 //w=0.27 //l=0.135 //layer=ply \
 //thickness=0.18 //x=54.645 //y=4.97 //x2=54.51 //y2=4.97
r903 (  205 207 ) resistor r=26.9307 //w=0.15 //l=0.106066 //layer=ply \
 //thickness=0.18 //x=54.845 //y=4.97 //x2=54.92 //y2=5.045
r904 (  205 206 ) resistor r=102.553 //w=0.094 //l=0.2 //layer=ply \
 //thickness=0.18 //x=54.845 //y=4.97 //x2=54.645 //y2=4.97
r905 (  204 283 ) resistor r=38.6777 //w=0.284 //l=0.198997 //layer=ply \
 //thickness=0.18 //x=54.6 //y=2.095 //x2=54.525 //y2=2.26
r906 (  203 281 ) resistor r=21.2976 //w=0.217 //l=0.0928709 //layer=ply \
 //thickness=0.18 //x=54.6 //y=1.63 //x2=54.56 //y2=1.555
r907 (  203 204 ) resistor r=238.436 //w=0.094 //l=0.465 //layer=ply \
 //thickness=0.18 //x=54.6 //y=1.63 //x2=54.6 //y2=2.095
r908 (  202 281 ) resistor r=39.0671 //w=0.217 //l=0.173853 //layer=ply \
 //thickness=0.18 //x=54.6 //y=1.4 //x2=54.56 //y2=1.555
r909 (  201 280 ) resistor r=45.1352 //w=0.168 //l=0.173853 //layer=ply \
 //thickness=0.18 //x=54.6 //y=1.09 //x2=54.56 //y2=0.935
r910 (  201 202 ) resistor r=158.957 //w=0.094 //l=0.31 //layer=ply \
 //thickness=0.18 //x=54.6 //y=1.09 //x2=54.6 //y2=1.4
r911 (  196 274 ) resistor r=5.52526 //w=0.168 //l=0.115 //layer=ply \
 //thickness=0.18 //x=54.23 //y=1.555 //x2=54.115 //y2=1.555
r912 (  195 281 ) resistor r=11.4558 //w=0.217 //l=0.115 //layer=ply \
 //thickness=0.18 //x=54.445 //y=1.555 //x2=54.56 //y2=1.555
r913 (  194 273 ) resistor r=5.52526 //w=0.168 //l=0.115 //layer=ply \
 //thickness=0.18 //x=54.23 //y=0.935 //x2=54.115 //y2=0.935
r914 (  193 280 ) resistor r=5.52526 //w=0.168 //l=0.115 //layer=ply \
 //thickness=0.18 //x=54.445 //y=0.935 //x2=54.56 //y2=0.935
r915 (  193 194 ) resistor r=110.245 //w=0.094 //l=0.215 //layer=ply \
 //thickness=0.18 //x=54.445 //y=0.935 //x2=54.23 //y2=0.935
r916 (  192 274 ) resistor r=45.1352 //w=0.168 //l=0.173853 //layer=ply \
 //thickness=0.18 //x=54.075 //y=1.4 //x2=54.115 //y2=1.555
r917 (  191 273 ) resistor r=45.1352 //w=0.168 //l=0.173853 //layer=ply \
 //thickness=0.18 //x=54.075 //y=1.09 //x2=54.115 //y2=0.935
r918 (  191 192 ) resistor r=158.957 //w=0.094 //l=0.31 //layer=ply \
 //thickness=0.18 //x=54.075 //y=1.09 //x2=54.075 //y2=1.4
r919 (  187 267 ) resistor r=16.5046 //w=0.27 //l=0.135 //layer=ply \
 //thickness=0.18 //x=41.695 //y=4.97 //x2=41.56 //y2=4.97
r920 (  186 188 ) resistor r=26.9307 //w=0.15 //l=0.106066 //layer=ply \
 //thickness=0.18 //x=41.895 //y=4.97 //x2=41.97 //y2=5.045
r921 (  186 187 ) resistor r=102.553 //w=0.094 //l=0.2 //layer=ply \
 //thickness=0.18 //x=41.895 //y=4.97 //x2=41.695 //y2=4.97
r922 (  185 272 ) resistor r=38.6777 //w=0.284 //l=0.198997 //layer=ply \
 //thickness=0.18 //x=41.65 //y=2.095 //x2=41.575 //y2=2.26
r923 (  184 270 ) resistor r=21.2976 //w=0.217 //l=0.0928709 //layer=ply \
 //thickness=0.18 //x=41.65 //y=1.63 //x2=41.61 //y2=1.555
r924 (  184 185 ) resistor r=238.436 //w=0.094 //l=0.465 //layer=ply \
 //thickness=0.18 //x=41.65 //y=1.63 //x2=41.65 //y2=2.095
r925 (  183 270 ) resistor r=39.0671 //w=0.217 //l=0.173853 //layer=ply \
 //thickness=0.18 //x=41.65 //y=1.4 //x2=41.61 //y2=1.555
r926 (  182 269 ) resistor r=45.1352 //w=0.168 //l=0.173853 //layer=ply \
 //thickness=0.18 //x=41.65 //y=1.09 //x2=41.61 //y2=0.935
r927 (  182 183 ) resistor r=158.957 //w=0.094 //l=0.31 //layer=ply \
 //thickness=0.18 //x=41.65 //y=1.09 //x2=41.65 //y2=1.4
r928 (  177 263 ) resistor r=5.52526 //w=0.168 //l=0.115 //layer=ply \
 //thickness=0.18 //x=41.28 //y=1.555 //x2=41.165 //y2=1.555
r929 (  176 270 ) resistor r=11.4558 //w=0.217 //l=0.115 //layer=ply \
 //thickness=0.18 //x=41.495 //y=1.555 //x2=41.61 //y2=1.555
r930 (  175 262 ) resistor r=5.52526 //w=0.168 //l=0.115 //layer=ply \
 //thickness=0.18 //x=41.28 //y=0.935 //x2=41.165 //y2=0.935
r931 (  174 269 ) resistor r=5.52526 //w=0.168 //l=0.115 //layer=ply \
 //thickness=0.18 //x=41.495 //y=0.935 //x2=41.61 //y2=0.935
r932 (  174 175 ) resistor r=110.245 //w=0.094 //l=0.215 //layer=ply \
 //thickness=0.18 //x=41.495 //y=0.935 //x2=41.28 //y2=0.935
r933 (  173 263 ) resistor r=45.1352 //w=0.168 //l=0.173853 //layer=ply \
 //thickness=0.18 //x=41.125 //y=1.4 //x2=41.165 //y2=1.555
r934 (  172 262 ) resistor r=45.1352 //w=0.168 //l=0.173853 //layer=ply \
 //thickness=0.18 //x=41.125 //y=1.09 //x2=41.165 //y2=0.935
r935 (  172 173 ) resistor r=158.957 //w=0.094 //l=0.31 //layer=ply \
 //thickness=0.18 //x=41.125 //y=1.09 //x2=41.125 //y2=1.4
r936 (  168 256 ) resistor r=16.5046 //w=0.27 //l=0.135 //layer=ply \
 //thickness=0.18 //x=28.745 //y=4.97 //x2=28.61 //y2=4.97
r937 (  167 169 ) resistor r=26.9307 //w=0.15 //l=0.106066 //layer=ply \
 //thickness=0.18 //x=28.945 //y=4.97 //x2=29.02 //y2=5.045
r938 (  167 168 ) resistor r=102.553 //w=0.094 //l=0.2 //layer=ply \
 //thickness=0.18 //x=28.945 //y=4.97 //x2=28.745 //y2=4.97
r939 (  166 261 ) resistor r=38.6777 //w=0.284 //l=0.198997 //layer=ply \
 //thickness=0.18 //x=28.7 //y=2.095 //x2=28.625 //y2=2.26
r940 (  165 259 ) resistor r=21.2976 //w=0.217 //l=0.0928709 //layer=ply \
 //thickness=0.18 //x=28.7 //y=1.63 //x2=28.66 //y2=1.555
r941 (  165 166 ) resistor r=238.436 //w=0.094 //l=0.465 //layer=ply \
 //thickness=0.18 //x=28.7 //y=1.63 //x2=28.7 //y2=2.095
r942 (  164 259 ) resistor r=39.0671 //w=0.217 //l=0.173853 //layer=ply \
 //thickness=0.18 //x=28.7 //y=1.4 //x2=28.66 //y2=1.555
r943 (  163 258 ) resistor r=45.1352 //w=0.168 //l=0.173853 //layer=ply \
 //thickness=0.18 //x=28.7 //y=1.09 //x2=28.66 //y2=0.935
r944 (  163 164 ) resistor r=158.957 //w=0.094 //l=0.31 //layer=ply \
 //thickness=0.18 //x=28.7 //y=1.09 //x2=28.7 //y2=1.4
r945 (  158 252 ) resistor r=5.52526 //w=0.168 //l=0.115 //layer=ply \
 //thickness=0.18 //x=28.33 //y=1.555 //x2=28.215 //y2=1.555
r946 (  157 259 ) resistor r=11.4558 //w=0.217 //l=0.115 //layer=ply \
 //thickness=0.18 //x=28.545 //y=1.555 //x2=28.66 //y2=1.555
r947 (  156 251 ) resistor r=5.52526 //w=0.168 //l=0.115 //layer=ply \
 //thickness=0.18 //x=28.33 //y=0.935 //x2=28.215 //y2=0.935
r948 (  155 258 ) resistor r=5.52526 //w=0.168 //l=0.115 //layer=ply \
 //thickness=0.18 //x=28.545 //y=0.935 //x2=28.66 //y2=0.935
r949 (  155 156 ) resistor r=110.245 //w=0.094 //l=0.215 //layer=ply \
 //thickness=0.18 //x=28.545 //y=0.935 //x2=28.33 //y2=0.935
r950 (  154 252 ) resistor r=45.1352 //w=0.168 //l=0.173853 //layer=ply \
 //thickness=0.18 //x=28.175 //y=1.4 //x2=28.215 //y2=1.555
r951 (  153 251 ) resistor r=45.1352 //w=0.168 //l=0.173853 //layer=ply \
 //thickness=0.18 //x=28.175 //y=1.09 //x2=28.215 //y2=0.935
r952 (  153 154 ) resistor r=158.957 //w=0.094 //l=0.31 //layer=ply \
 //thickness=0.18 //x=28.175 //y=1.09 //x2=28.175 //y2=1.4
r953 (  149 245 ) resistor r=16.5046 //w=0.27 //l=0.135 //layer=ply \
 //thickness=0.18 //x=15.795 //y=4.97 //x2=15.66 //y2=4.97
r954 (  148 150 ) resistor r=26.9307 //w=0.15 //l=0.106066 //layer=ply \
 //thickness=0.18 //x=15.995 //y=4.97 //x2=16.07 //y2=5.045
r955 (  148 149 ) resistor r=102.553 //w=0.094 //l=0.2 //layer=ply \
 //thickness=0.18 //x=15.995 //y=4.97 //x2=15.795 //y2=4.97
r956 (  147 250 ) resistor r=38.6777 //w=0.284 //l=0.198997 //layer=ply \
 //thickness=0.18 //x=15.75 //y=2.095 //x2=15.675 //y2=2.26
r957 (  146 248 ) resistor r=21.2976 //w=0.217 //l=0.0928709 //layer=ply \
 //thickness=0.18 //x=15.75 //y=1.63 //x2=15.71 //y2=1.555
r958 (  146 147 ) resistor r=238.436 //w=0.094 //l=0.465 //layer=ply \
 //thickness=0.18 //x=15.75 //y=1.63 //x2=15.75 //y2=2.095
r959 (  145 248 ) resistor r=39.0671 //w=0.217 //l=0.173853 //layer=ply \
 //thickness=0.18 //x=15.75 //y=1.4 //x2=15.71 //y2=1.555
r960 (  144 247 ) resistor r=45.1352 //w=0.168 //l=0.173853 //layer=ply \
 //thickness=0.18 //x=15.75 //y=1.09 //x2=15.71 //y2=0.935
r961 (  144 145 ) resistor r=158.957 //w=0.094 //l=0.31 //layer=ply \
 //thickness=0.18 //x=15.75 //y=1.09 //x2=15.75 //y2=1.4
r962 (  139 241 ) resistor r=5.52526 //w=0.168 //l=0.115 //layer=ply \
 //thickness=0.18 //x=15.38 //y=1.555 //x2=15.265 //y2=1.555
r963 (  138 248 ) resistor r=11.4558 //w=0.217 //l=0.115 //layer=ply \
 //thickness=0.18 //x=15.595 //y=1.555 //x2=15.71 //y2=1.555
r964 (  137 240 ) resistor r=5.52526 //w=0.168 //l=0.115 //layer=ply \
 //thickness=0.18 //x=15.38 //y=0.935 //x2=15.265 //y2=0.935
r965 (  136 247 ) resistor r=5.52526 //w=0.168 //l=0.115 //layer=ply \
 //thickness=0.18 //x=15.595 //y=0.935 //x2=15.71 //y2=0.935
r966 (  136 137 ) resistor r=110.245 //w=0.094 //l=0.215 //layer=ply \
 //thickness=0.18 //x=15.595 //y=0.935 //x2=15.38 //y2=0.935
r967 (  135 241 ) resistor r=45.1352 //w=0.168 //l=0.173853 //layer=ply \
 //thickness=0.18 //x=15.225 //y=1.4 //x2=15.265 //y2=1.555
r968 (  134 240 ) resistor r=45.1352 //w=0.168 //l=0.173853 //layer=ply \
 //thickness=0.18 //x=15.225 //y=1.09 //x2=15.265 //y2=0.935
r969 (  134 135 ) resistor r=158.957 //w=0.094 //l=0.31 //layer=ply \
 //thickness=0.18 //x=15.225 //y=1.09 //x2=15.225 //y2=1.4
r970 (  130 234 ) resistor r=16.5046 //w=0.27 //l=0.135 //layer=ply \
 //thickness=0.18 //x=2.845 //y=4.97 //x2=2.71 //y2=4.97
r971 (  129 131 ) resistor r=26.9307 //w=0.15 //l=0.106066 //layer=ply \
 //thickness=0.18 //x=3.045 //y=4.97 //x2=3.12 //y2=5.045
r972 (  129 130 ) resistor r=102.553 //w=0.094 //l=0.2 //layer=ply \
 //thickness=0.18 //x=3.045 //y=4.97 //x2=2.845 //y2=4.97
r973 (  128 239 ) resistor r=38.6777 //w=0.284 //l=0.198997 //layer=ply \
 //thickness=0.18 //x=2.8 //y=2.095 //x2=2.725 //y2=2.26
r974 (  127 237 ) resistor r=21.2976 //w=0.217 //l=0.0928709 //layer=ply \
 //thickness=0.18 //x=2.8 //y=1.63 //x2=2.76 //y2=1.555
r975 (  127 128 ) resistor r=238.436 //w=0.094 //l=0.465 //layer=ply \
 //thickness=0.18 //x=2.8 //y=1.63 //x2=2.8 //y2=2.095
r976 (  126 237 ) resistor r=39.0671 //w=0.217 //l=0.173853 //layer=ply \
 //thickness=0.18 //x=2.8 //y=1.4 //x2=2.76 //y2=1.555
r977 (  125 236 ) resistor r=45.1352 //w=0.168 //l=0.173853 //layer=ply \
 //thickness=0.18 //x=2.8 //y=1.09 //x2=2.76 //y2=0.935
r978 (  125 126 ) resistor r=158.957 //w=0.094 //l=0.31 //layer=ply \
 //thickness=0.18 //x=2.8 //y=1.09 //x2=2.8 //y2=1.4
r979 (  120 230 ) resistor r=5.52526 //w=0.168 //l=0.115 //layer=ply \
 //thickness=0.18 //x=2.43 //y=1.555 //x2=2.315 //y2=1.555
r980 (  119 237 ) resistor r=11.4558 //w=0.217 //l=0.115 //layer=ply \
 //thickness=0.18 //x=2.645 //y=1.555 //x2=2.76 //y2=1.555
r981 (  118 229 ) resistor r=5.52526 //w=0.168 //l=0.115 //layer=ply \
 //thickness=0.18 //x=2.43 //y=0.935 //x2=2.315 //y2=0.935
r982 (  117 236 ) resistor r=5.52526 //w=0.168 //l=0.115 //layer=ply \
 //thickness=0.18 //x=2.645 //y=0.935 //x2=2.76 //y2=0.935
r983 (  117 118 ) resistor r=110.245 //w=0.094 //l=0.215 //layer=ply \
 //thickness=0.18 //x=2.645 //y=0.935 //x2=2.43 //y2=0.935
r984 (  116 230 ) resistor r=45.1352 //w=0.168 //l=0.173853 //layer=ply \
 //thickness=0.18 //x=2.275 //y=1.4 //x2=2.315 //y2=1.555
r985 (  115 229 ) resistor r=45.1352 //w=0.168 //l=0.173853 //layer=ply \
 //thickness=0.18 //x=2.275 //y=1.09 //x2=2.315 //y2=0.935
r986 (  115 116 ) resistor r=158.957 //w=0.094 //l=0.31 //layer=ply \
 //thickness=0.18 //x=2.275 //y=1.09 //x2=2.275 //y2=1.4
r987 (  114 226 ) resistor r=592.245 //w=0.094 //l=1.155 //layer=ply \
 //thickness=0.18 //x=67.87 //y=6.2 //x2=67.87 //y2=5.045
r988 (  113 290 ) resistor r=592.245 //w=0.094 //l=1.155 //layer=ply \
 //thickness=0.18 //x=67.43 //y=6.2 //x2=67.43 //y2=5.045
r989 (  112 207 ) resistor r=592.245 //w=0.094 //l=1.155 //layer=ply \
 //thickness=0.18 //x=54.92 //y=6.2 //x2=54.92 //y2=5.045
r990 (  111 279 ) resistor r=592.245 //w=0.094 //l=1.155 //layer=ply \
 //thickness=0.18 //x=54.48 //y=6.2 //x2=54.48 //y2=5.045
r991 (  110 188 ) resistor r=592.245 //w=0.094 //l=1.155 //layer=ply \
 //thickness=0.18 //x=41.97 //y=6.2 //x2=41.97 //y2=5.045
r992 (  109 268 ) resistor r=592.245 //w=0.094 //l=1.155 //layer=ply \
 //thickness=0.18 //x=41.53 //y=6.2 //x2=41.53 //y2=5.045
r993 (  108 169 ) resistor r=592.245 //w=0.094 //l=1.155 //layer=ply \
 //thickness=0.18 //x=29.02 //y=6.2 //x2=29.02 //y2=5.045
r994 (  107 257 ) resistor r=592.245 //w=0.094 //l=1.155 //layer=ply \
 //thickness=0.18 //x=28.58 //y=6.2 //x2=28.58 //y2=5.045
r995 (  106 150 ) resistor r=592.245 //w=0.094 //l=1.155 //layer=ply \
 //thickness=0.18 //x=16.07 //y=6.2 //x2=16.07 //y2=5.045
r996 (  105 246 ) resistor r=592.245 //w=0.094 //l=1.155 //layer=ply \
 //thickness=0.18 //x=15.63 //y=6.2 //x2=15.63 //y2=5.045
r997 (  104 131 ) resistor r=592.245 //w=0.094 //l=1.155 //layer=ply \
 //thickness=0.18 //x=3.12 //y=6.2 //x2=3.12 //y2=5.045
r998 (  103 235 ) resistor r=592.245 //w=0.094 //l=1.155 //layer=ply \
 //thickness=0.18 //x=2.68 //y=6.2 //x2=2.68 //y2=5.045
r999 (  102 214 ) resistor r=55.3787 //w=0.094 //l=0.108 //layer=ply \
 //thickness=0.18 //x=67.287 //y=1.555 //x2=67.395 //y2=1.555
r1000 (  102 215 ) resistor r=54.866 //w=0.094 //l=0.107 //layer=ply \
 //thickness=0.18 //x=67.287 //y=1.555 //x2=67.18 //y2=1.555
r1001 (  101 195 ) resistor r=55.3787 //w=0.094 //l=0.108 //layer=ply \
 //thickness=0.18 //x=54.337 //y=1.555 //x2=54.445 //y2=1.555
r1002 (  101 196 ) resistor r=54.866 //w=0.094 //l=0.107 //layer=ply \
 //thickness=0.18 //x=54.337 //y=1.555 //x2=54.23 //y2=1.555
r1003 (  100 176 ) resistor r=55.3787 //w=0.094 //l=0.108 //layer=ply \
 //thickness=0.18 //x=41.387 //y=1.555 //x2=41.495 //y2=1.555
r1004 (  100 177 ) resistor r=54.866 //w=0.094 //l=0.107 //layer=ply \
 //thickness=0.18 //x=41.387 //y=1.555 //x2=41.28 //y2=1.555
r1005 (  99 157 ) resistor r=55.3787 //w=0.094 //l=0.108 //layer=ply \
 //thickness=0.18 //x=28.437 //y=1.555 //x2=28.545 //y2=1.555
r1006 (  99 158 ) resistor r=54.866 //w=0.094 //l=0.107 //layer=ply \
 //thickness=0.18 //x=28.437 //y=1.555 //x2=28.33 //y2=1.555
r1007 (  98 138 ) resistor r=55.3787 //w=0.094 //l=0.108 //layer=ply \
 //thickness=0.18 //x=15.487 //y=1.555 //x2=15.595 //y2=1.555
r1008 (  98 139 ) resistor r=54.866 //w=0.094 //l=0.107 //layer=ply \
 //thickness=0.18 //x=15.487 //y=1.555 //x2=15.38 //y2=1.555
r1009 (  97 119 ) resistor r=55.3787 //w=0.094 //l=0.108 //layer=ply \
 //thickness=0.18 //x=2.537 //y=1.555 //x2=2.645 //y2=1.555
r1010 (  97 120 ) resistor r=54.866 //w=0.094 //l=0.107 //layer=ply \
 //thickness=0.18 //x=2.537 //y=1.555 //x2=2.43 //y2=1.555
r1011 (  95 287 ) resistor r=152 //w=0.17 //l=0.17 //layer=licon //count=1 \
 //x=67.46 //y=4.88 //x2=67.46 //y2=4.88
r1012 (  90 294 ) resistor r=152 //w=0.17 //l=0.17 //layer=licon //count=1 \
 //x=67.46 //y=2.26 //x2=67.46 //y2=2.26
r1013 (  87 276 ) resistor r=152 //w=0.17 //l=0.17 //layer=licon //count=1 \
 //x=54.51 //y=4.88 //x2=54.51 //y2=4.88
r1014 (  81 283 ) resistor r=152 //w=0.17 //l=0.17 //layer=licon //count=1 \
 //x=54.51 //y=2.26 //x2=54.51 //y2=2.26
r1015 (  78 265 ) resistor r=152 //w=0.17 //l=0.17 //layer=licon //count=1 \
 //x=41.56 //y=4.88 //x2=41.56 //y2=4.88
r1016 (  72 272 ) resistor r=152 //w=0.17 //l=0.17 //layer=licon //count=1 \
 //x=41.56 //y=2.26 //x2=41.56 //y2=2.26
r1017 (  69 254 ) resistor r=152 //w=0.17 //l=0.17 //layer=licon //count=1 \
 //x=28.61 //y=4.88 //x2=28.61 //y2=4.88
r1018 (  62 261 ) resistor r=152 //w=0.17 //l=0.17 //layer=licon //count=1 \
 //x=28.61 //y=2.26 //x2=28.61 //y2=2.26
r1019 (  59 243 ) resistor r=152 //w=0.17 //l=0.17 //layer=licon //count=1 \
 //x=15.66 //y=4.88 //x2=15.66 //y2=4.88
r1020 (  52 250 ) resistor r=152 //w=0.17 //l=0.17 //layer=licon //count=1 \
 //x=15.66 //y=2.26 //x2=15.66 //y2=2.26
r1021 (  49 232 ) resistor r=152 //w=0.17 //l=0.17 //layer=licon //count=1 \
 //x=2.71 //y=4.88 //x2=2.71 //y2=4.88
r1022 (  40 239 ) resistor r=152 //w=0.17 //l=0.17 //layer=licon //count=1 \
 //x=2.71 //y=2.26 //x2=2.71 //y2=2.26
r1023 (  38 95 ) resistor r=17.7968 //w=0.187 //l=0.26 //layer=li \
 //thickness=0.1 //x=67.46 //y=4.62 //x2=67.46 //y2=4.88
r1024 (  38 90 ) resistor r=161.54 //w=0.187 //l=2.36 //layer=li \
 //thickness=0.1 //x=67.46 //y=4.62 //x2=67.46 //y2=2.26
r1025 (  37 87 ) resistor r=17.7968 //w=0.187 //l=0.26 //layer=li \
 //thickness=0.1 //x=54.51 //y=4.62 //x2=54.51 //y2=4.88
r1026 (  36 37 ) resistor r=50.6524 //w=0.187 //l=0.74 //layer=li \
 //thickness=0.1 //x=54.51 //y=3.88 //x2=54.51 //y2=4.62
r1027 (  36 81 ) resistor r=110.888 //w=0.187 //l=1.62 //layer=li \
 //thickness=0.1 //x=54.51 //y=3.88 //x2=54.51 //y2=2.26
r1028 (  35 78 ) resistor r=17.7968 //w=0.187 //l=0.26 //layer=li \
 //thickness=0.1 //x=41.56 //y=4.62 //x2=41.56 //y2=4.88
r1029 (  34 35 ) resistor r=75.9786 //w=0.187 //l=1.11 //layer=li \
 //thickness=0.1 //x=41.56 //y=3.51 //x2=41.56 //y2=4.62
r1030 (  34 72 ) resistor r=85.5615 //w=0.187 //l=1.25 //layer=li \
 //thickness=0.1 //x=41.56 //y=3.51 //x2=41.56 //y2=2.26
r1031 (  33 69 ) resistor r=17.7968 //w=0.187 //l=0.26 //layer=li \
 //thickness=0.1 //x=28.61 //y=4.62 //x2=28.61 //y2=4.88
r1032 (  32 33 ) resistor r=50.6524 //w=0.187 //l=0.74 //layer=li \
 //thickness=0.1 //x=28.61 //y=3.88 //x2=28.61 //y2=4.62
r1033 (  31 32 ) resistor r=25.3262 //w=0.187 //l=0.37 //layer=li \
 //thickness=0.1 //x=28.61 //y=3.51 //x2=28.61 //y2=3.88
r1034 (  31 62 ) resistor r=85.5615 //w=0.187 //l=1.25 //layer=li \
 //thickness=0.1 //x=28.61 //y=3.51 //x2=28.61 //y2=2.26
r1035 (  30 59 ) resistor r=17.7968 //w=0.187 //l=0.26 //layer=li \
 //thickness=0.1 //x=15.66 //y=4.62 //x2=15.66 //y2=4.88
r1036 (  29 30 ) resistor r=75.9786 //w=0.187 //l=1.11 //layer=li \
 //thickness=0.1 //x=15.66 //y=3.51 //x2=15.66 //y2=4.62
r1037 (  28 29 ) resistor r=25.3262 //w=0.187 //l=0.37 //layer=li \
 //thickness=0.1 //x=15.66 //y=3.14 //x2=15.66 //y2=3.51
r1038 (  28 52 ) resistor r=60.2353 //w=0.187 //l=0.88 //layer=li \
 //thickness=0.1 //x=15.66 //y=3.14 //x2=15.66 //y2=2.26
r1039 (  27 49 ) resistor r=17.7968 //w=0.187 //l=0.26 //layer=li \
 //thickness=0.1 //x=2.71 //y=4.62 //x2=2.71 //y2=4.88
r1040 (  26 27 ) resistor r=50.6524 //w=0.187 //l=0.74 //layer=li \
 //thickness=0.1 //x=2.71 //y=3.88 //x2=2.71 //y2=4.62
r1041 (  25 26 ) resistor r=25.3262 //w=0.187 //l=0.37 //layer=li \
 //thickness=0.1 //x=2.71 //y=3.51 //x2=2.71 //y2=3.88
r1042 (  24 25 ) resistor r=25.3262 //w=0.187 //l=0.37 //layer=li \
 //thickness=0.1 //x=2.71 //y=3.14 //x2=2.71 //y2=3.51
r1043 (  23 24 ) resistor r=25.3262 //w=0.187 //l=0.37 //layer=li \
 //thickness=0.1 //x=2.71 //y=2.77 //x2=2.71 //y2=3.14
r1044 (  23 40 ) resistor r=34.9091 //w=0.187 //l=0.51 //layer=li \
 //thickness=0.1 //x=2.71 //y=2.77 //x2=2.71 //y2=2.26
r1045 (  22 38 ) resistor r=9.3 //w=0.17 //l=0.17 //layer=mcon //count=1 \
 //x=67.46 //y=4.62 //x2=67.46 //y2=4.62
r1046 (  20 37 ) resistor r=9.3 //w=0.17 //l=0.17 //layer=mcon //count=1 \
 //x=54.51 //y=4.62 //x2=54.51 //y2=4.62
r1047 (  18 35 ) resistor r=9.3 //w=0.17 //l=0.17 //layer=mcon //count=1 \
 //x=41.56 //y=4.62 //x2=41.56 //y2=4.62
r1048 (  16 33 ) resistor r=9.3 //w=0.17 //l=0.17 //layer=mcon //count=1 \
 //x=28.61 //y=4.62 //x2=28.61 //y2=4.62
r1049 (  14 30 ) resistor r=9.3 //w=0.17 //l=0.17 //layer=mcon //count=1 \
 //x=15.66 //y=4.62 //x2=15.66 //y2=4.62
r1050 (  12 27 ) resistor r=9.3 //w=0.17 //l=0.17 //layer=mcon //count=1 \
 //x=2.71 //y=4.62 //x2=2.71 //y2=4.62
r1051 (  10 20 ) resistor r=0.0880901 //w=0.191 //l=0.115 //layer=m1 \
 //thickness=0.36 //x=54.625 //y=4.62 //x2=54.51 //y2=4.62
r1052 (  9 22 ) resistor r=0.0717383 //w=0.224 //l=0.115 //layer=m1 \
 //thickness=0.36 //x=67.345 //y=4.62 //x2=67.46 //y2=4.62
r1053 (  9 10 ) resistor r=12.1374 //w=0.131 //l=12.72 //layer=m1 \
 //thickness=0.36 //x=67.345 //y=4.62 //x2=54.625 //y2=4.62
r1054 (  8 18 ) resistor r=0.0880901 //w=0.191 //l=0.115 //layer=m1 \
 //thickness=0.36 //x=41.675 //y=4.62 //x2=41.56 //y2=4.62
r1055 (  7 20 ) resistor r=0.0880901 //w=0.191 //l=0.115 //layer=m1 \
 //thickness=0.36 //x=54.395 //y=4.62 //x2=54.51 //y2=4.62
r1056 (  7 8 ) resistor r=12.1374 //w=0.131 //l=12.72 //layer=m1 \
 //thickness=0.36 //x=54.395 //y=4.62 //x2=41.675 //y2=4.62
r1057 (  6 16 ) resistor r=0.0880901 //w=0.191 //l=0.115 //layer=m1 \
 //thickness=0.36 //x=28.725 //y=4.62 //x2=28.61 //y2=4.62
r1058 (  5 18 ) resistor r=0.0880901 //w=0.191 //l=0.115 //layer=m1 \
 //thickness=0.36 //x=41.445 //y=4.62 //x2=41.56 //y2=4.62
r1059 (  5 6 ) resistor r=12.1374 //w=0.131 //l=12.72 //layer=m1 \
 //thickness=0.36 //x=41.445 //y=4.62 //x2=28.725 //y2=4.62
r1060 (  4 14 ) resistor r=0.0880901 //w=0.191 //l=0.115 //layer=m1 \
 //thickness=0.36 //x=15.775 //y=4.62 //x2=15.66 //y2=4.62
r1061 (  3 16 ) resistor r=0.0880901 //w=0.191 //l=0.115 //layer=m1 \
 //thickness=0.36 //x=28.495 //y=4.62 //x2=28.61 //y2=4.62
r1062 (  3 4 ) resistor r=12.1374 //w=0.131 //l=12.72 //layer=m1 \
 //thickness=0.36 //x=28.495 //y=4.62 //x2=15.775 //y2=4.62
r1063 (  2 12 ) resistor r=0.0717383 //w=0.224 //l=0.115 //layer=m1 \
 //thickness=0.36 //x=2.825 //y=4.62 //x2=2.71 //y2=4.62
r1064 (  1 14 ) resistor r=0.0880901 //w=0.191 //l=0.115 //layer=m1 \
 //thickness=0.36 //x=15.545 //y=4.62 //x2=15.66 //y2=4.62
r1065 (  1 2 ) resistor r=12.1374 //w=0.131 //l=12.72 //layer=m1 \
 //thickness=0.36 //x=15.545 //y=4.62 //x2=2.825 //y2=4.62
ends PM_TMRDFFRNQX1\%CLK

subckt PM_TMRDFFRNQX1\%noxref_14 ( 1 2 3 4 17 18 25 33 39 40 44 46 54 61 62 63 \
 64 65 66 67 68 69 70 71 72 73 75 81 82 83 84 88 89 90 91 92 94 100 101 102 \
 103 123 125 126 127 )
c259 ( 127 0 ) capacitor c=0.023087f //x=55.435 //y=5.2
c260 ( 126 0 ) capacitor c=0.023519f //x=54.555 //y=5.2
c261 ( 125 0 ) capacitor c=0.0224735f //x=53.675 //y=5.2
c262 ( 123 0 ) capacitor c=0.00853354f //x=55.685 //y=1.095
c263 ( 103 0 ) capacitor c=0.0558396f //x=71.435 //y=4.97
c264 ( 102 0 ) capacitor c=0.0298189f //x=71.725 //y=4.97
c265 ( 101 0 ) capacitor c=0.0347816f //x=71.39 //y=1.4
c266 ( 100 0 ) capacitor c=0.0187487f //x=71.39 //y=1.055
c267 ( 94 0 ) capacitor c=0.0137055f //x=71.235 //y=1.555
c268 ( 92 0 ) capacitor c=0.0149861f //x=71.235 //y=0.9
c269 ( 91 0 ) capacitor c=0.096037f //x=70.86 //y=2.095
c270 ( 90 0 ) capacitor c=0.0228993f //x=70.86 //y=1.71
c271 ( 89 0 ) capacitor c=0.0234352f //x=70.86 //y=1.4
c272 ( 88 0 ) capacitor c=0.0198724f //x=70.86 //y=1.055
c273 ( 84 0 ) capacitor c=0.0556143f //x=58.485 //y=4.97
c274 ( 83 0 ) capacitor c=0.0293157f //x=58.775 //y=4.97
c275 ( 82 0 ) capacitor c=0.0347816f //x=58.44 //y=1.4
c276 ( 81 0 ) capacitor c=0.0187487f //x=58.44 //y=1.055
c277 ( 75 0 ) capacitor c=0.0137055f //x=58.285 //y=1.555
c278 ( 73 0 ) capacitor c=0.0149861f //x=58.285 //y=0.9
c279 ( 72 0 ) capacitor c=0.096037f //x=57.91 //y=2.095
c280 ( 71 0 ) capacitor c=0.0228993f //x=57.91 //y=1.71
c281 ( 70 0 ) capacitor c=0.0234352f //x=57.91 //y=1.4
c282 ( 69 0 ) capacitor c=0.0198724f //x=57.91 //y=1.055
c283 ( 68 0 ) capacitor c=0.110114f //x=71.8 //y=6.2
c284 ( 67 0 ) capacitor c=0.158956f //x=71.36 //y=6.2
c285 ( 66 0 ) capacitor c=0.110114f //x=58.85 //y=6.2
c286 ( 65 0 ) capacitor c=0.158956f //x=58.41 //y=6.2
c287 ( 62 0 ) capacitor c=0.00106608f //x=55.58 //y=5.335
c288 ( 61 0 ) capacitor c=0.00207162f //x=54.7 //y=5.335
c289 ( 54 0 ) capacitor c=0.0992856f //x=71.16 //y=2.26
c290 ( 46 0 ) capacitor c=0.0936123f //x=58.21 //y=2.26
c291 ( 44 0 ) capacitor c=0.103742f //x=56.36 //y=3.88
c292 ( 40 0 ) capacitor c=0.00398962f //x=55.96 //y=1.845
c293 ( 39 0 ) capacitor c=0.0137288f //x=56.275 //y=1.845
c294 ( 33 0 ) capacitor c=0.0283082f //x=56.275 //y=5.335
c295 ( 25 0 ) capacitor c=0.0176454f //x=55.495 //y=5.335
c296 ( 18 0 ) capacitor c=0.00332903f //x=53.905 //y=5.335
c297 ( 17 0 ) capacitor c=0.014837f //x=54.615 //y=5.335
c298 ( 4 0 ) capacitor c=0.00424246f //x=58.325 //y=3.88
c299 ( 3 0 ) capacitor c=0.191185f //x=71.045 //y=3.88
c300 ( 2 0 ) capacitor c=0.0125346f //x=56.475 //y=3.88
c301 ( 1 0 ) capacitor c=0.0288301f //x=58.095 //y=3.88
r302 (  102 104 ) resistor r=26.9307 //w=0.15 //l=0.106066 //layer=ply \
 //thickness=0.18 //x=71.725 //y=4.97 //x2=71.8 //y2=5.045
r303 (  102 103 ) resistor r=148.702 //w=0.094 //l=0.29 //layer=ply \
 //thickness=0.18 //x=71.725 //y=4.97 //x2=71.435 //y2=4.97
r304 (  101 122 ) resistor r=45.1352 //w=0.168 //l=0.173853 //layer=ply \
 //thickness=0.18 //x=71.39 //y=1.4 //x2=71.35 //y2=1.555
r305 (  100 121 ) resistor r=45.1352 //w=0.168 //l=0.173853 //layer=ply \
 //thickness=0.18 //x=71.39 //y=1.055 //x2=71.35 //y2=0.9
r306 (  100 101 ) resistor r=176.904 //w=0.094 //l=0.345 //layer=ply \
 //thickness=0.18 //x=71.39 //y=1.055 //x2=71.39 //y2=1.4
r307 (  97 103 ) resistor r=22.7971 //w=0.269 //l=0.106066 //layer=ply \
 //thickness=0.18 //x=71.36 //y=5.045 //x2=71.435 //y2=4.97
r308 (  97 120 ) resistor r=35.8364 //w=0.269 //l=0.270185 //layer=ply \
 //thickness=0.18 //x=71.36 //y=5.045 //x2=71.16 //y2=4.88
r309 (  95 116 ) resistor r=10.701 //w=0.21 //l=0.115 //layer=ply \
 //thickness=0.18 //x=71.015 //y=1.555 //x2=70.9 //y2=1.555
r310 (  94 122 ) resistor r=5.52526 //w=0.168 //l=0.115 //layer=ply \
 //thickness=0.18 //x=71.235 //y=1.555 //x2=71.35 //y2=1.555
r311 (  93 115 ) resistor r=5.52526 //w=0.168 //l=0.115 //layer=ply \
 //thickness=0.18 //x=71.015 //y=0.9 //x2=70.9 //y2=0.9
r312 (  92 121 ) resistor r=5.52526 //w=0.168 //l=0.115 //layer=ply \
 //thickness=0.18 //x=71.235 //y=0.9 //x2=71.35 //y2=0.9
r313 (  92 93 ) resistor r=112.809 //w=0.094 //l=0.22 //layer=ply \
 //thickness=0.18 //x=71.235 //y=0.9 //x2=71.015 //y2=0.9
r314 (  91 118 ) resistor r=58.7805 //w=0.246 //l=0.373497 //layer=ply \
 //thickness=0.18 //x=70.86 //y=2.095 //x2=71.16 //y2=2.26
r315 (  90 116 ) resistor r=39.5823 //w=0.21 //l=0.173853 //layer=ply \
 //thickness=0.18 //x=70.86 //y=1.71 //x2=70.9 //y2=1.555
r316 (  90 91 ) resistor r=197.415 //w=0.094 //l=0.385 //layer=ply \
 //thickness=0.18 //x=70.86 //y=1.71 //x2=70.86 //y2=2.095
r317 (  89 116 ) resistor r=39.5823 //w=0.21 //l=0.173853 //layer=ply \
 //thickness=0.18 //x=70.86 //y=1.4 //x2=70.9 //y2=1.555
r318 (  88 115 ) resistor r=45.1352 //w=0.168 //l=0.173853 //layer=ply \
 //thickness=0.18 //x=70.86 //y=1.055 //x2=70.9 //y2=0.9
r319 (  88 89 ) resistor r=176.904 //w=0.094 //l=0.345 //layer=ply \
 //thickness=0.18 //x=70.86 //y=1.055 //x2=70.86 //y2=1.4
r320 (  83 85 ) resistor r=26.9307 //w=0.15 //l=0.106066 //layer=ply \
 //thickness=0.18 //x=58.775 //y=4.97 //x2=58.85 //y2=5.045
r321 (  83 84 ) resistor r=148.702 //w=0.094 //l=0.29 //layer=ply \
 //thickness=0.18 //x=58.775 //y=4.97 //x2=58.485 //y2=4.97
r322 (  82 114 ) resistor r=45.1352 //w=0.168 //l=0.173853 //layer=ply \
 //thickness=0.18 //x=58.44 //y=1.4 //x2=58.4 //y2=1.555
r323 (  81 113 ) resistor r=45.1352 //w=0.168 //l=0.173853 //layer=ply \
 //thickness=0.18 //x=58.44 //y=1.055 //x2=58.4 //y2=0.9
r324 (  81 82 ) resistor r=176.904 //w=0.094 //l=0.345 //layer=ply \
 //thickness=0.18 //x=58.44 //y=1.055 //x2=58.44 //y2=1.4
r325 (  78 84 ) resistor r=22.7971 //w=0.269 //l=0.106066 //layer=ply \
 //thickness=0.18 //x=58.41 //y=5.045 //x2=58.485 //y2=4.97
r326 (  78 112 ) resistor r=35.8364 //w=0.269 //l=0.270185 //layer=ply \
 //thickness=0.18 //x=58.41 //y=5.045 //x2=58.21 //y2=4.88
r327 (  76 108 ) resistor r=10.701 //w=0.21 //l=0.115 //layer=ply \
 //thickness=0.18 //x=58.065 //y=1.555 //x2=57.95 //y2=1.555
r328 (  75 114 ) resistor r=5.52526 //w=0.168 //l=0.115 //layer=ply \
 //thickness=0.18 //x=58.285 //y=1.555 //x2=58.4 //y2=1.555
r329 (  74 107 ) resistor r=5.52526 //w=0.168 //l=0.115 //layer=ply \
 //thickness=0.18 //x=58.065 //y=0.9 //x2=57.95 //y2=0.9
r330 (  73 113 ) resistor r=5.52526 //w=0.168 //l=0.115 //layer=ply \
 //thickness=0.18 //x=58.285 //y=0.9 //x2=58.4 //y2=0.9
r331 (  73 74 ) resistor r=112.809 //w=0.094 //l=0.22 //layer=ply \
 //thickness=0.18 //x=58.285 //y=0.9 //x2=58.065 //y2=0.9
r332 (  72 110 ) resistor r=58.7805 //w=0.246 //l=0.373497 //layer=ply \
 //thickness=0.18 //x=57.91 //y=2.095 //x2=58.21 //y2=2.26
r333 (  71 108 ) resistor r=39.5823 //w=0.21 //l=0.173853 //layer=ply \
 //thickness=0.18 //x=57.91 //y=1.71 //x2=57.95 //y2=1.555
r334 (  71 72 ) resistor r=197.415 //w=0.094 //l=0.385 //layer=ply \
 //thickness=0.18 //x=57.91 //y=1.71 //x2=57.91 //y2=2.095
r335 (  70 108 ) resistor r=39.5823 //w=0.21 //l=0.173853 //layer=ply \
 //thickness=0.18 //x=57.91 //y=1.4 //x2=57.95 //y2=1.555
r336 (  69 107 ) resistor r=45.1352 //w=0.168 //l=0.173853 //layer=ply \
 //thickness=0.18 //x=57.91 //y=1.055 //x2=57.95 //y2=0.9
r337 (  69 70 ) resistor r=176.904 //w=0.094 //l=0.345 //layer=ply \
 //thickness=0.18 //x=57.91 //y=1.055 //x2=57.91 //y2=1.4
r338 (  68 104 ) resistor r=592.245 //w=0.094 //l=1.155 //layer=ply \
 //thickness=0.18 //x=71.8 //y=6.2 //x2=71.8 //y2=5.045
r339 (  67 97 ) resistor r=592.245 //w=0.094 //l=1.155 //layer=ply \
 //thickness=0.18 //x=71.36 //y=6.2 //x2=71.36 //y2=5.045
r340 (  66 85 ) resistor r=592.245 //w=0.094 //l=1.155 //layer=ply \
 //thickness=0.18 //x=58.85 //y=6.2 //x2=58.85 //y2=5.045
r341 (  65 78 ) resistor r=592.245 //w=0.094 //l=1.155 //layer=ply \
 //thickness=0.18 //x=58.41 //y=6.2 //x2=58.41 //y2=5.045
r342 (  64 94 ) resistor r=56.4043 //w=0.094 //l=0.11 //layer=ply \
 //thickness=0.18 //x=71.125 //y=1.555 //x2=71.235 //y2=1.555
r343 (  64 95 ) resistor r=56.4043 //w=0.094 //l=0.11 //layer=ply \
 //thickness=0.18 //x=71.125 //y=1.555 //x2=71.015 //y2=1.555
r344 (  63 75 ) resistor r=56.4043 //w=0.094 //l=0.11 //layer=ply \
 //thickness=0.18 //x=58.175 //y=1.555 //x2=58.285 //y2=1.555
r345 (  63 76 ) resistor r=56.4043 //w=0.094 //l=0.11 //layer=ply \
 //thickness=0.18 //x=58.175 //y=1.555 //x2=58.065 //y2=1.555
r346 (  59 120 ) resistor r=152 //w=0.17 //l=0.17 //layer=licon //count=1 \
 //x=71.16 //y=4.88 //x2=71.16 //y2=4.88
r347 (  57 59 ) resistor r=68.4492 //w=0.187 //l=1 //layer=li //thickness=0.1 \
 //x=71.16 //y=3.88 //x2=71.16 //y2=4.88
r348 (  54 118 ) resistor r=152 //w=0.17 //l=0.17 //layer=licon //count=1 \
 //x=71.16 //y=2.26 //x2=71.16 //y2=2.26
r349 (  54 57 ) resistor r=110.888 //w=0.187 //l=1.62 //layer=li \
 //thickness=0.1 //x=71.16 //y=2.26 //x2=71.16 //y2=3.88
r350 (  51 112 ) resistor r=152 //w=0.17 //l=0.17 //layer=licon //count=1 \
 //x=58.21 //y=4.88 //x2=58.21 //y2=4.88
r351 (  49 51 ) resistor r=68.4492 //w=0.187 //l=1 //layer=li //thickness=0.1 \
 //x=58.21 //y=3.88 //x2=58.21 //y2=4.88
r352 (  46 110 ) resistor r=152 //w=0.17 //l=0.17 //layer=licon //count=1 \
 //x=58.21 //y=2.26 //x2=58.21 //y2=2.26
r353 (  46 49 ) resistor r=110.888 //w=0.187 //l=1.62 //layer=li \
 //thickness=0.1 //x=58.21 //y=2.26 //x2=58.21 //y2=3.88
r354 (  42 44 ) resistor r=93.7754 //w=0.187 //l=1.37 //layer=li \
 //thickness=0.1 //x=56.36 //y=5.25 //x2=56.36 //y2=3.88
r355 (  41 44 ) resistor r=133.476 //w=0.187 //l=1.95 //layer=li \
 //thickness=0.1 //x=56.36 //y=1.93 //x2=56.36 //y2=3.88
r356 (  39 41 ) resistor r=7.15173 //w=0.17 //l=0.120208 //layer=li \
 //thickness=0.1 //x=56.275 //y=1.845 //x2=56.36 //y2=1.93
r357 (  39 40 ) resistor r=21.5615 //w=0.187 //l=0.315 //layer=li \
 //thickness=0.1 //x=56.275 //y=1.845 //x2=55.96 //y2=1.845
r358 (  35 40 ) resistor r=7.15173 //w=0.17 //l=0.120208 //layer=li \
 //thickness=0.1 //x=55.875 //y=1.76 //x2=55.96 //y2=1.845
r359 (  35 123 ) resistor r=39.016 //w=0.187 //l=0.57 //layer=li \
 //thickness=0.1 //x=55.875 //y=1.76 //x2=55.875 //y2=1.19
r360 (  34 62 ) resistor r=5.4201 //w=0.17 //l=0.085 //layer=li \
 //thickness=0.1 //x=55.665 //y=5.335 //x2=55.58 //y2=5.335
r361 (  33 42 ) resistor r=7.15173 //w=0.17 //l=0.120208 //layer=li \
 //thickness=0.1 //x=56.275 //y=5.335 //x2=56.36 //y2=5.25
r362 (  33 34 ) resistor r=41.754 //w=0.187 //l=0.61 //layer=li \
 //thickness=0.1 //x=56.275 //y=5.335 //x2=55.665 //y2=5.335
r363 (  27 62 ) resistor r=1.40859 //w=0.34 //l=0.085 //layer=li \
 //thickness=0.1 //x=55.58 //y=5.42 //x2=55.58 //y2=5.335
r364 (  27 127 ) resistor r=33.1979 //w=0.187 //l=0.485 //layer=li \
 //thickness=0.1 //x=55.58 //y=5.42 //x2=55.58 //y2=5.905
r365 (  26 61 ) resistor r=5.4201 //w=0.17 //l=0.085 //layer=li \
 //thickness=0.1 //x=54.785 //y=5.335 //x2=54.7 //y2=5.335
r366 (  25 62 ) resistor r=5.4201 //w=0.17 //l=0.085 //layer=li \
 //thickness=0.1 //x=55.495 //y=5.335 //x2=55.58 //y2=5.335
r367 (  25 26 ) resistor r=48.5989 //w=0.187 //l=0.71 //layer=li \
 //thickness=0.1 //x=55.495 //y=5.335 //x2=54.785 //y2=5.335
r368 (  19 61 ) resistor r=1.40859 //w=0.34 //l=0.085 //layer=li \
 //thickness=0.1 //x=54.7 //y=5.42 //x2=54.7 //y2=5.335
r369 (  19 126 ) resistor r=33.1979 //w=0.187 //l=0.485 //layer=li \
 //thickness=0.1 //x=54.7 //y=5.42 //x2=54.7 //y2=5.905
r370 (  17 61 ) resistor r=5.4201 //w=0.17 //l=0.085 //layer=li \
 //thickness=0.1 //x=54.615 //y=5.335 //x2=54.7 //y2=5.335
r371 (  17 18 ) resistor r=48.5989 //w=0.187 //l=0.71 //layer=li \
 //thickness=0.1 //x=54.615 //y=5.335 //x2=53.905 //y2=5.335
r372 (  11 18 ) resistor r=7.15173 //w=0.17 //l=0.120208 //layer=li \
 //thickness=0.1 //x=53.82 //y=5.42 //x2=53.905 //y2=5.335
r373 (  11 125 ) resistor r=33.1979 //w=0.187 //l=0.485 //layer=li \
 //thickness=0.1 //x=53.82 //y=5.42 //x2=53.82 //y2=5.905
r374 (  10 57 ) resistor r=9.3 //w=0.17 //l=0.17 //layer=mcon //count=1 \
 //x=71.16 //y=3.88 //x2=71.16 //y2=3.88
r375 (  8 49 ) resistor r=9.3 //w=0.17 //l=0.17 //layer=mcon //count=1 \
 //x=58.21 //y=3.88 //x2=58.21 //y2=3.88
r376 (  6 44 ) resistor r=9.3 //w=0.17 //l=0.17 //layer=mcon //count=1 \
 //x=56.36 //y=3.88 //x2=56.36 //y2=3.88
r377 (  4 8 ) resistor r=0.0880901 //w=0.191 //l=0.115 //layer=m1 \
 //thickness=0.36 //x=58.325 //y=3.88 //x2=58.21 //y2=3.88
r378 (  3 10 ) resistor r=0.0717383 //w=0.224 //l=0.115 //layer=m1 \
 //thickness=0.36 //x=71.045 //y=3.88 //x2=71.16 //y2=3.88
r379 (  3 4 ) resistor r=12.1374 //w=0.131 //l=12.72 //layer=m1 \
 //thickness=0.36 //x=71.045 //y=3.88 //x2=58.325 //y2=3.88
r380 (  2 6 ) resistor r=0.0717383 //w=0.224 //l=0.115 //layer=m1 \
 //thickness=0.36 //x=56.475 //y=3.88 //x2=56.36 //y2=3.88
r381 (  1 8 ) resistor r=0.0880901 //w=0.191 //l=0.115 //layer=m1 \
 //thickness=0.36 //x=58.095 //y=3.88 //x2=58.21 //y2=3.88
r382 (  1 2 ) resistor r=1.5458 //w=0.131 //l=1.62 //layer=m1 //thickness=0.36 \
 //x=58.095 //y=3.88 //x2=56.475 //y2=3.88
ends PM_TMRDFFRNQX1\%noxref_14

subckt PM_TMRDFFRNQX1\%RN ( 1 2 3 4 5 6 7 8 9 10 11 12 13 14 15 16 35 36 37 38 \
 39 40 41 42 43 44 46 55 65 75 83 92 102 110 118 126 127 128 129 130 131 132 \
 133 134 135 136 137 138 139 140 141 142 143 144 145 146 147 148 149 150 151 \
 152 156 157 158 163 165 168 169 173 174 175 180 182 185 186 187 188 189 191 \
 197 198 199 200 201 209 210 211 216 218 221 222 226 227 228 233 235 238 239 \
 240 241 242 244 250 251 252 253 254 262 263 264 269 271 274 275 279 280 281 \
 286 288 291 292 293 294 295 297 303 304 305 306 307 313 314 319 323 324 329 \
 335 344 345 350 354 355 360 366 375 376 381 385 386 391 397 )
c955 ( 397 0 ) capacitor c=0.0336203f //x=72.27 //y=4.88
c956 ( 391 0 ) capacitor c=0.0593675f //x=68.57 //y=4.88
c957 ( 386 0 ) capacitor c=0.0273931f //x=68.57 //y=2.095
c958 ( 385 0 ) capacitor c=0.0455604f //x=68.57 //y=2.26
c959 ( 381 0 ) capacitor c=0.0587755f //x=60.43 //y=4.88
c960 ( 376 0 ) capacitor c=0.0273931f //x=60.43 //y=2.095
c961 ( 375 0 ) capacitor c=0.0455604f //x=60.43 //y=2.26
c962 ( 366 0 ) capacitor c=0.0335551f //x=46.37 //y=4.88
c963 ( 360 0 ) capacitor c=0.058931f //x=42.67 //y=4.88
c964 ( 355 0 ) capacitor c=0.0273931f //x=42.67 //y=2.095
c965 ( 354 0 ) capacitor c=0.0455604f //x=42.67 //y=2.26
c966 ( 350 0 ) capacitor c=0.0587755f //x=34.53 //y=4.88
c967 ( 345 0 ) capacitor c=0.0273931f //x=34.53 //y=2.095
c968 ( 344 0 ) capacitor c=0.0455604f //x=34.53 //y=2.26
c969 ( 335 0 ) capacitor c=0.0335551f //x=20.47 //y=4.88
c970 ( 329 0 ) capacitor c=0.058931f //x=16.77 //y=4.88
c971 ( 324 0 ) capacitor c=0.0273931f //x=16.77 //y=2.095
c972 ( 323 0 ) capacitor c=0.0455604f //x=16.77 //y=2.26
c973 ( 319 0 ) capacitor c=0.0587755f //x=8.63 //y=4.88
c974 ( 314 0 ) capacitor c=0.0273931f //x=8.63 //y=2.095
c975 ( 313 0 ) capacitor c=0.0457326f //x=8.63 //y=2.26
c976 ( 307 0 ) capacitor c=0.024933f //x=72.605 //y=4.97
c977 ( 306 0 ) capacitor c=0.0827272f //x=72.36 //y=2.095
c978 ( 305 0 ) capacitor c=0.0170266f //x=72.36 //y=1.63
c979 ( 304 0 ) capacitor c=0.018609f //x=72.36 //y=1.4
c980 ( 303 0 ) capacitor c=0.0187309f //x=72.36 //y=1.09
c981 ( 297 0 ) capacitor c=0.014725f //x=72.205 //y=1.555
c982 ( 295 0 ) capacitor c=0.0146567f //x=72.205 //y=0.935
c983 ( 294 0 ) capacitor c=0.0335408f //x=71.835 //y=1.4
c984 ( 293 0 ) capacitor c=0.0173761f //x=71.835 //y=1.09
c985 ( 292 0 ) capacitor c=0.0432517f //x=69.09 //y=1.44
c986 ( 291 0 ) capacitor c=0.0200379f //x=69.09 //y=1.095
c987 ( 288 0 ) capacitor c=0.0148873f //x=68.935 //y=1.595
c988 ( 286 0 ) capacitor c=0.0157803f //x=68.935 //y=0.94
c989 ( 281 0 ) capacitor c=0.0218028f //x=68.56 //y=1.75
c990 ( 280 0 ) capacitor c=0.0207459f //x=68.56 //y=1.44
c991 ( 279 0 ) capacitor c=0.0194308f //x=68.56 //y=1.095
c992 ( 275 0 ) capacitor c=0.0432517f //x=60.95 //y=1.44
c993 ( 274 0 ) capacitor c=0.0200379f //x=60.95 //y=1.095
c994 ( 271 0 ) capacitor c=0.0148873f //x=60.795 //y=1.595
c995 ( 269 0 ) capacitor c=0.0157803f //x=60.795 //y=0.94
c996 ( 264 0 ) capacitor c=0.0218028f //x=60.42 //y=1.75
c997 ( 263 0 ) capacitor c=0.0207459f //x=60.42 //y=1.44
c998 ( 262 0 ) capacitor c=0.0194308f //x=60.42 //y=1.095
c999 ( 254 0 ) capacitor c=0.0245352f //x=46.705 //y=4.97
c1000 ( 253 0 ) capacitor c=0.0825033f //x=46.46 //y=2.095
c1001 ( 252 0 ) capacitor c=0.0170266f //x=46.46 //y=1.63
c1002 ( 251 0 ) capacitor c=0.018609f //x=46.46 //y=1.4
c1003 ( 250 0 ) capacitor c=0.0187309f //x=46.46 //y=1.09
c1004 ( 244 0 ) capacitor c=0.014725f //x=46.305 //y=1.555
c1005 ( 242 0 ) capacitor c=0.0146567f //x=46.305 //y=0.935
c1006 ( 241 0 ) capacitor c=0.0335408f //x=45.935 //y=1.4
c1007 ( 240 0 ) capacitor c=0.0173761f //x=45.935 //y=1.09
c1008 ( 239 0 ) capacitor c=0.0432517f //x=43.19 //y=1.44
c1009 ( 238 0 ) capacitor c=0.0200379f //x=43.19 //y=1.095
c1010 ( 235 0 ) capacitor c=0.0148873f //x=43.035 //y=1.595
c1011 ( 233 0 ) capacitor c=0.0157803f //x=43.035 //y=0.94
c1012 ( 228 0 ) capacitor c=0.0218028f //x=42.66 //y=1.75
c1013 ( 227 0 ) capacitor c=0.0207459f //x=42.66 //y=1.44
c1014 ( 226 0 ) capacitor c=0.0194308f //x=42.66 //y=1.095
c1015 ( 222 0 ) capacitor c=0.0432517f //x=35.05 //y=1.44
c1016 ( 221 0 ) capacitor c=0.0200379f //x=35.05 //y=1.095
c1017 ( 218 0 ) capacitor c=0.0148873f //x=34.895 //y=1.595
c1018 ( 216 0 ) capacitor c=0.0157803f //x=34.895 //y=0.94
c1019 ( 211 0 ) capacitor c=0.0218028f //x=34.52 //y=1.75
c1020 ( 210 0 ) capacitor c=0.0207459f //x=34.52 //y=1.44
c1021 ( 209 0 ) capacitor c=0.0194308f //x=34.52 //y=1.095
c1022 ( 201 0 ) capacitor c=0.0245352f //x=20.805 //y=4.97
c1023 ( 200 0 ) capacitor c=0.0825033f //x=20.56 //y=2.095
c1024 ( 199 0 ) capacitor c=0.0170266f //x=20.56 //y=1.63
c1025 ( 198 0 ) capacitor c=0.018609f //x=20.56 //y=1.4
c1026 ( 197 0 ) capacitor c=0.0187309f //x=20.56 //y=1.09
c1027 ( 191 0 ) capacitor c=0.014725f //x=20.405 //y=1.555
c1028 ( 189 0 ) capacitor c=0.0146567f //x=20.405 //y=0.935
c1029 ( 188 0 ) capacitor c=0.0335408f //x=20.035 //y=1.4
c1030 ( 187 0 ) capacitor c=0.0173761f //x=20.035 //y=1.09
c1031 ( 186 0 ) capacitor c=0.0432517f //x=17.29 //y=1.44
c1032 ( 185 0 ) capacitor c=0.0200379f //x=17.29 //y=1.095
c1033 ( 182 0 ) capacitor c=0.0148873f //x=17.135 //y=1.595
c1034 ( 180 0 ) capacitor c=0.0157803f //x=17.135 //y=0.94
c1035 ( 175 0 ) capacitor c=0.0218028f //x=16.76 //y=1.75
c1036 ( 174 0 ) capacitor c=0.0207459f //x=16.76 //y=1.44
c1037 ( 173 0 ) capacitor c=0.0194308f //x=16.76 //y=1.095
c1038 ( 169 0 ) capacitor c=0.0432517f //x=9.15 //y=1.44
c1039 ( 168 0 ) capacitor c=0.0200379f //x=9.15 //y=1.095
c1040 ( 165 0 ) capacitor c=0.0148873f //x=8.995 //y=1.595
c1041 ( 163 0 ) capacitor c=0.0157803f //x=8.995 //y=0.94
c1042 ( 158 0 ) capacitor c=0.0218028f //x=8.62 //y=1.75
c1043 ( 157 0 ) capacitor c=0.0207459f //x=8.62 //y=1.44
c1044 ( 156 0 ) capacitor c=0.0194308f //x=8.62 //y=1.095
c1045 ( 152 0 ) capacitor c=0.110114f //x=72.68 //y=6.2
c1046 ( 151 0 ) capacitor c=0.11012f //x=72.24 //y=6.2
c1047 ( 150 0 ) capacitor c=0.158794f //x=68.75 //y=6.2
c1048 ( 149 0 ) capacitor c=0.110114f //x=68.31 //y=6.2
c1049 ( 148 0 ) capacitor c=0.158794f //x=60.61 //y=6.2
c1050 ( 147 0 ) capacitor c=0.110114f //x=60.17 //y=6.2
c1051 ( 146 0 ) capacitor c=0.110114f //x=46.78 //y=6.2
c1052 ( 145 0 ) capacitor c=0.11012f //x=46.34 //y=6.2
c1053 ( 144 0 ) capacitor c=0.158794f //x=42.85 //y=6.2
c1054 ( 143 0 ) capacitor c=0.110114f //x=42.41 //y=6.2
c1055 ( 142 0 ) capacitor c=0.158794f //x=34.71 //y=6.2
c1056 ( 141 0 ) capacitor c=0.110114f //x=34.27 //y=6.2
c1057 ( 140 0 ) capacitor c=0.110114f //x=20.88 //y=6.2
c1058 ( 139 0 ) capacitor c=0.11012f //x=20.44 //y=6.2
c1059 ( 138 0 ) capacitor c=0.158794f //x=16.95 //y=6.2
c1060 ( 137 0 ) capacitor c=0.110114f //x=16.51 //y=6.2
c1061 ( 136 0 ) capacitor c=0.158794f //x=8.81 //y=6.2
c1062 ( 135 0 ) capacitor c=0.110114f //x=8.37 //y=6.2
c1063 ( 118 0 ) capacitor c=0.0945052f //x=72.27 //y=2.26
c1064 ( 110 0 ) capacitor c=0.0837702f //x=68.57 //y=2.26
c1065 ( 102 0 ) capacitor c=0.0813451f //x=60.43 //y=2.26
c1066 ( 92 0 ) capacitor c=0.0915318f //x=46.37 //y=2.26
c1067 ( 83 0 ) capacitor c=0.081834f //x=42.67 //y=2.26
c1068 ( 75 0 ) capacitor c=0.0797116f //x=34.53 //y=2.26
c1069 ( 65 0 ) capacitor c=0.0945052f //x=20.47 //y=2.26
c1070 ( 55 0 ) capacitor c=0.0841472f //x=16.77 //y=2.26
c1071 ( 46 0 ) capacitor c=0.0820248f //x=8.63 //y=2.26
c1072 ( 16 0 ) capacitor c=0.00626811f //x=68.685 //y=2.4
c1073 ( 15 0 ) capacitor c=0.0949894f //x=72.155 //y=2.4
c1074 ( 14 0 ) capacitor c=0.00730634f //x=60.545 //y=2.4
c1075 ( 13 0 ) capacitor c=0.180678f //x=68.455 //y=2.4
c1076 ( 12 0 ) capacitor c=0.00575878f //x=46.485 //y=2.4
c1077 ( 11 0 ) capacitor c=0.271811f //x=60.315 //y=2.4
c1078 ( 10 0 ) capacitor c=0.00601484f //x=42.785 //y=2.4
c1079 ( 9 0 ) capacitor c=0.0680922f //x=46.255 //y=2.4
c1080 ( 8 0 ) capacitor c=0.00705307f //x=34.645 //y=2.4
c1081 ( 7 0 ) capacitor c=0.153868f //x=42.555 //y=2.4
c1082 ( 6 0 ) capacitor c=0.00575878f //x=20.585 //y=2.4
c1083 ( 5 0 ) capacitor c=0.269152f //x=34.415 //y=2.4
c1084 ( 4 0 ) capacitor c=0.00601484f //x=16.885 //y=2.4
c1085 ( 3 0 ) capacitor c=0.0680922f //x=20.355 //y=2.4
c1086 ( 2 0 ) capacitor c=0.0153965f //x=8.745 //y=2.4
c1087 ( 1 0 ) capacitor c=0.153868f //x=16.655 //y=2.4
r1088 (  399 400 ) resistor r=32.4568 //w=0.214 //l=0.075 //layer=ply \
 //thickness=0.18 //x=72.27 //y=4.97 //x2=72.27 //y2=5.045
r1089 (  397 399 ) resistor r=20.271 //w=0.214 //l=0.09 //layer=ply \
 //thickness=0.18 //x=72.27 //y=4.88 //x2=72.27 //y2=4.97
r1090 (  385 386 ) resistor r=52.7279 //w=0.214 //l=0.165 //layer=ply \
 //thickness=0.18 //x=68.57 //y=2.26 //x2=68.57 //y2=2.095
r1091 (  375 376 ) resistor r=52.7279 //w=0.214 //l=0.165 //layer=ply \
 //thickness=0.18 //x=60.43 //y=2.26 //x2=60.43 //y2=2.095
r1092 (  368 369 ) resistor r=32.4568 //w=0.214 //l=0.075 //layer=ply \
 //thickness=0.18 //x=46.37 //y=4.97 //x2=46.37 //y2=5.045
r1093 (  366 368 ) resistor r=20.271 //w=0.214 //l=0.09 //layer=ply \
 //thickness=0.18 //x=46.37 //y=4.88 //x2=46.37 //y2=4.97
r1094 (  354 355 ) resistor r=52.7279 //w=0.214 //l=0.165 //layer=ply \
 //thickness=0.18 //x=42.67 //y=2.26 //x2=42.67 //y2=2.095
r1095 (  344 345 ) resistor r=52.7279 //w=0.214 //l=0.165 //layer=ply \
 //thickness=0.18 //x=34.53 //y=2.26 //x2=34.53 //y2=2.095
r1096 (  337 338 ) resistor r=32.4568 //w=0.214 //l=0.075 //layer=ply \
 //thickness=0.18 //x=20.47 //y=4.97 //x2=20.47 //y2=5.045
r1097 (  335 337 ) resistor r=20.271 //w=0.214 //l=0.09 //layer=ply \
 //thickness=0.18 //x=20.47 //y=4.88 //x2=20.47 //y2=4.97
r1098 (  323 324 ) resistor r=52.7279 //w=0.214 //l=0.165 //layer=ply \
 //thickness=0.18 //x=16.77 //y=2.26 //x2=16.77 //y2=2.095
r1099 (  313 314 ) resistor r=52.7279 //w=0.214 //l=0.165 //layer=ply \
 //thickness=0.18 //x=8.63 //y=2.26 //x2=8.63 //y2=2.095
r1100 (  308 399 ) resistor r=16.5046 //w=0.27 //l=0.135 //layer=ply \
 //thickness=0.18 //x=72.405 //y=4.97 //x2=72.27 //y2=4.97
r1101 (  307 309 ) resistor r=26.9307 //w=0.15 //l=0.106066 //layer=ply \
 //thickness=0.18 //x=72.605 //y=4.97 //x2=72.68 //y2=5.045
r1102 (  307 308 ) resistor r=102.553 //w=0.094 //l=0.2 //layer=ply \
 //thickness=0.18 //x=72.605 //y=4.97 //x2=72.405 //y2=4.97
r1103 (  306 404 ) resistor r=38.6777 //w=0.284 //l=0.198997 //layer=ply \
 //thickness=0.18 //x=72.36 //y=2.095 //x2=72.285 //y2=2.26
r1104 (  305 402 ) resistor r=21.2976 //w=0.217 //l=0.0928709 //layer=ply \
 //thickness=0.18 //x=72.36 //y=1.63 //x2=72.32 //y2=1.555
r1105 (  305 306 ) resistor r=238.436 //w=0.094 //l=0.465 //layer=ply \
 //thickness=0.18 //x=72.36 //y=1.63 //x2=72.36 //y2=2.095
r1106 (  304 402 ) resistor r=39.0671 //w=0.217 //l=0.173853 //layer=ply \
 //thickness=0.18 //x=72.36 //y=1.4 //x2=72.32 //y2=1.555
r1107 (  303 401 ) resistor r=45.1352 //w=0.168 //l=0.173853 //layer=ply \
 //thickness=0.18 //x=72.36 //y=1.09 //x2=72.32 //y2=0.935
r1108 (  303 304 ) resistor r=158.957 //w=0.094 //l=0.31 //layer=ply \
 //thickness=0.18 //x=72.36 //y=1.09 //x2=72.36 //y2=1.4
r1109 (  298 395 ) resistor r=5.52526 //w=0.168 //l=0.115 //layer=ply \
 //thickness=0.18 //x=71.99 //y=1.555 //x2=71.875 //y2=1.555
r1110 (  297 402 ) resistor r=11.4558 //w=0.217 //l=0.115 //layer=ply \
 //thickness=0.18 //x=72.205 //y=1.555 //x2=72.32 //y2=1.555
r1111 (  296 394 ) resistor r=5.52526 //w=0.168 //l=0.115 //layer=ply \
 //thickness=0.18 //x=71.99 //y=0.935 //x2=71.875 //y2=0.935
r1112 (  295 401 ) resistor r=5.52526 //w=0.168 //l=0.115 //layer=ply \
 //thickness=0.18 //x=72.205 //y=0.935 //x2=72.32 //y2=0.935
r1113 (  295 296 ) resistor r=110.245 //w=0.094 //l=0.215 //layer=ply \
 //thickness=0.18 //x=72.205 //y=0.935 //x2=71.99 //y2=0.935
r1114 (  294 395 ) resistor r=45.1352 //w=0.168 //l=0.173853 //layer=ply \
 //thickness=0.18 //x=71.835 //y=1.4 //x2=71.875 //y2=1.555
r1115 (  293 394 ) resistor r=45.1352 //w=0.168 //l=0.173853 //layer=ply \
 //thickness=0.18 //x=71.835 //y=1.09 //x2=71.875 //y2=0.935
r1116 (  293 294 ) resistor r=158.957 //w=0.094 //l=0.31 //layer=ply \
 //thickness=0.18 //x=71.835 //y=1.09 //x2=71.835 //y2=1.4
r1117 (  292 393 ) resistor r=45.1352 //w=0.168 //l=0.173853 //layer=ply \
 //thickness=0.18 //x=69.09 //y=1.44 //x2=69.05 //y2=1.595
r1118 (  291 392 ) resistor r=45.1352 //w=0.168 //l=0.173853 //layer=ply \
 //thickness=0.18 //x=69.09 //y=1.095 //x2=69.05 //y2=0.94
r1119 (  291 292 ) resistor r=176.904 //w=0.094 //l=0.345 //layer=ply \
 //thickness=0.18 //x=69.09 //y=1.095 //x2=69.09 //y2=1.44
r1120 (  289 389 ) resistor r=10.701 //w=0.21 //l=0.115 //layer=ply \
 //thickness=0.18 //x=68.715 //y=1.595 //x2=68.6 //y2=1.595
r1121 (  288 393 ) resistor r=5.52526 //w=0.168 //l=0.115 //layer=ply \
 //thickness=0.18 //x=68.935 //y=1.595 //x2=69.05 //y2=1.595
r1122 (  287 388 ) resistor r=5.52526 //w=0.168 //l=0.115 //layer=ply \
 //thickness=0.18 //x=68.715 //y=0.94 //x2=68.6 //y2=0.94
r1123 (  286 392 ) resistor r=5.52526 //w=0.168 //l=0.115 //layer=ply \
 //thickness=0.18 //x=68.935 //y=0.94 //x2=69.05 //y2=0.94
r1124 (  286 287 ) resistor r=112.809 //w=0.094 //l=0.22 //layer=ply \
 //thickness=0.18 //x=68.935 //y=0.94 //x2=68.715 //y2=0.94
r1125 (  283 391 ) resistor r=37.236 //w=0.233 //l=0.249199 //layer=ply \
 //thickness=0.18 //x=68.75 //y=5.045 //x2=68.57 //y2=4.88
r1126 (  281 389 ) resistor r=39.5823 //w=0.21 //l=0.173853 //layer=ply \
 //thickness=0.18 //x=68.56 //y=1.75 //x2=68.6 //y2=1.595
r1127 (  281 386 ) resistor r=176.904 //w=0.094 //l=0.345 //layer=ply \
 //thickness=0.18 //x=68.56 //y=1.75 //x2=68.56 //y2=2.095
r1128 (  280 389 ) resistor r=39.5823 //w=0.21 //l=0.173853 //layer=ply \
 //thickness=0.18 //x=68.56 //y=1.44 //x2=68.6 //y2=1.595
r1129 (  279 388 ) resistor r=45.1352 //w=0.168 //l=0.173853 //layer=ply \
 //thickness=0.18 //x=68.56 //y=1.095 //x2=68.6 //y2=0.94
r1130 (  279 280 ) resistor r=176.904 //w=0.094 //l=0.345 //layer=ply \
 //thickness=0.18 //x=68.56 //y=1.095 //x2=68.56 //y2=1.44
r1131 (  276 391 ) resistor r=53.7854 //w=0.233 //l=0.332415 //layer=ply \
 //thickness=0.18 //x=68.31 //y=5.045 //x2=68.57 //y2=4.88
r1132 (  275 383 ) resistor r=45.1352 //w=0.168 //l=0.173853 //layer=ply \
 //thickness=0.18 //x=60.95 //y=1.44 //x2=60.91 //y2=1.595
r1133 (  274 382 ) resistor r=45.1352 //w=0.168 //l=0.173853 //layer=ply \
 //thickness=0.18 //x=60.95 //y=1.095 //x2=60.91 //y2=0.94
r1134 (  274 275 ) resistor r=176.904 //w=0.094 //l=0.345 //layer=ply \
 //thickness=0.18 //x=60.95 //y=1.095 //x2=60.95 //y2=1.44
r1135 (  272 379 ) resistor r=10.701 //w=0.21 //l=0.115 //layer=ply \
 //thickness=0.18 //x=60.575 //y=1.595 //x2=60.46 //y2=1.595
r1136 (  271 383 ) resistor r=5.52526 //w=0.168 //l=0.115 //layer=ply \
 //thickness=0.18 //x=60.795 //y=1.595 //x2=60.91 //y2=1.595
r1137 (  270 378 ) resistor r=5.52526 //w=0.168 //l=0.115 //layer=ply \
 //thickness=0.18 //x=60.575 //y=0.94 //x2=60.46 //y2=0.94
r1138 (  269 382 ) resistor r=5.52526 //w=0.168 //l=0.115 //layer=ply \
 //thickness=0.18 //x=60.795 //y=0.94 //x2=60.91 //y2=0.94
r1139 (  269 270 ) resistor r=112.809 //w=0.094 //l=0.22 //layer=ply \
 //thickness=0.18 //x=60.795 //y=0.94 //x2=60.575 //y2=0.94
r1140 (  266 381 ) resistor r=37.236 //w=0.233 //l=0.249199 //layer=ply \
 //thickness=0.18 //x=60.61 //y=5.045 //x2=60.43 //y2=4.88
r1141 (  264 379 ) resistor r=39.5823 //w=0.21 //l=0.173853 //layer=ply \
 //thickness=0.18 //x=60.42 //y=1.75 //x2=60.46 //y2=1.595
r1142 (  264 376 ) resistor r=176.904 //w=0.094 //l=0.345 //layer=ply \
 //thickness=0.18 //x=60.42 //y=1.75 //x2=60.42 //y2=2.095
r1143 (  263 379 ) resistor r=39.5823 //w=0.21 //l=0.173853 //layer=ply \
 //thickness=0.18 //x=60.42 //y=1.44 //x2=60.46 //y2=1.595
r1144 (  262 378 ) resistor r=45.1352 //w=0.168 //l=0.173853 //layer=ply \
 //thickness=0.18 //x=60.42 //y=1.095 //x2=60.46 //y2=0.94
r1145 (  262 263 ) resistor r=176.904 //w=0.094 //l=0.345 //layer=ply \
 //thickness=0.18 //x=60.42 //y=1.095 //x2=60.42 //y2=1.44
r1146 (  259 381 ) resistor r=53.7854 //w=0.233 //l=0.332415 //layer=ply \
 //thickness=0.18 //x=60.17 //y=5.045 //x2=60.43 //y2=4.88
r1147 (  255 368 ) resistor r=16.5046 //w=0.27 //l=0.135 //layer=ply \
 //thickness=0.18 //x=46.505 //y=4.97 //x2=46.37 //y2=4.97
r1148 (  254 256 ) resistor r=26.9307 //w=0.15 //l=0.106066 //layer=ply \
 //thickness=0.18 //x=46.705 //y=4.97 //x2=46.78 //y2=5.045
r1149 (  254 255 ) resistor r=102.553 //w=0.094 //l=0.2 //layer=ply \
 //thickness=0.18 //x=46.705 //y=4.97 //x2=46.505 //y2=4.97
r1150 (  253 373 ) resistor r=38.6777 //w=0.284 //l=0.198997 //layer=ply \
 //thickness=0.18 //x=46.46 //y=2.095 //x2=46.385 //y2=2.26
r1151 (  252 371 ) resistor r=21.2976 //w=0.217 //l=0.0928709 //layer=ply \
 //thickness=0.18 //x=46.46 //y=1.63 //x2=46.42 //y2=1.555
r1152 (  252 253 ) resistor r=238.436 //w=0.094 //l=0.465 //layer=ply \
 //thickness=0.18 //x=46.46 //y=1.63 //x2=46.46 //y2=2.095
r1153 (  251 371 ) resistor r=39.0671 //w=0.217 //l=0.173853 //layer=ply \
 //thickness=0.18 //x=46.46 //y=1.4 //x2=46.42 //y2=1.555
r1154 (  250 370 ) resistor r=45.1352 //w=0.168 //l=0.173853 //layer=ply \
 //thickness=0.18 //x=46.46 //y=1.09 //x2=46.42 //y2=0.935
r1155 (  250 251 ) resistor r=158.957 //w=0.094 //l=0.31 //layer=ply \
 //thickness=0.18 //x=46.46 //y=1.09 //x2=46.46 //y2=1.4
r1156 (  245 364 ) resistor r=5.52526 //w=0.168 //l=0.115 //layer=ply \
 //thickness=0.18 //x=46.09 //y=1.555 //x2=45.975 //y2=1.555
r1157 (  244 371 ) resistor r=11.4558 //w=0.217 //l=0.115 //layer=ply \
 //thickness=0.18 //x=46.305 //y=1.555 //x2=46.42 //y2=1.555
r1158 (  243 363 ) resistor r=5.52526 //w=0.168 //l=0.115 //layer=ply \
 //thickness=0.18 //x=46.09 //y=0.935 //x2=45.975 //y2=0.935
r1159 (  242 370 ) resistor r=5.52526 //w=0.168 //l=0.115 //layer=ply \
 //thickness=0.18 //x=46.305 //y=0.935 //x2=46.42 //y2=0.935
r1160 (  242 243 ) resistor r=110.245 //w=0.094 //l=0.215 //layer=ply \
 //thickness=0.18 //x=46.305 //y=0.935 //x2=46.09 //y2=0.935
r1161 (  241 364 ) resistor r=45.1352 //w=0.168 //l=0.173853 //layer=ply \
 //thickness=0.18 //x=45.935 //y=1.4 //x2=45.975 //y2=1.555
r1162 (  240 363 ) resistor r=45.1352 //w=0.168 //l=0.173853 //layer=ply \
 //thickness=0.18 //x=45.935 //y=1.09 //x2=45.975 //y2=0.935
r1163 (  240 241 ) resistor r=158.957 //w=0.094 //l=0.31 //layer=ply \
 //thickness=0.18 //x=45.935 //y=1.09 //x2=45.935 //y2=1.4
r1164 (  239 362 ) resistor r=45.1352 //w=0.168 //l=0.173853 //layer=ply \
 //thickness=0.18 //x=43.19 //y=1.44 //x2=43.15 //y2=1.595
r1165 (  238 361 ) resistor r=45.1352 //w=0.168 //l=0.173853 //layer=ply \
 //thickness=0.18 //x=43.19 //y=1.095 //x2=43.15 //y2=0.94
r1166 (  238 239 ) resistor r=176.904 //w=0.094 //l=0.345 //layer=ply \
 //thickness=0.18 //x=43.19 //y=1.095 //x2=43.19 //y2=1.44
r1167 (  236 358 ) resistor r=10.701 //w=0.21 //l=0.115 //layer=ply \
 //thickness=0.18 //x=42.815 //y=1.595 //x2=42.7 //y2=1.595
r1168 (  235 362 ) resistor r=5.52526 //w=0.168 //l=0.115 //layer=ply \
 //thickness=0.18 //x=43.035 //y=1.595 //x2=43.15 //y2=1.595
r1169 (  234 357 ) resistor r=5.52526 //w=0.168 //l=0.115 //layer=ply \
 //thickness=0.18 //x=42.815 //y=0.94 //x2=42.7 //y2=0.94
r1170 (  233 361 ) resistor r=5.52526 //w=0.168 //l=0.115 //layer=ply \
 //thickness=0.18 //x=43.035 //y=0.94 //x2=43.15 //y2=0.94
r1171 (  233 234 ) resistor r=112.809 //w=0.094 //l=0.22 //layer=ply \
 //thickness=0.18 //x=43.035 //y=0.94 //x2=42.815 //y2=0.94
r1172 (  230 360 ) resistor r=37.236 //w=0.233 //l=0.249199 //layer=ply \
 //thickness=0.18 //x=42.85 //y=5.045 //x2=42.67 //y2=4.88
r1173 (  228 358 ) resistor r=39.5823 //w=0.21 //l=0.173853 //layer=ply \
 //thickness=0.18 //x=42.66 //y=1.75 //x2=42.7 //y2=1.595
r1174 (  228 355 ) resistor r=176.904 //w=0.094 //l=0.345 //layer=ply \
 //thickness=0.18 //x=42.66 //y=1.75 //x2=42.66 //y2=2.095
r1175 (  227 358 ) resistor r=39.5823 //w=0.21 //l=0.173853 //layer=ply \
 //thickness=0.18 //x=42.66 //y=1.44 //x2=42.7 //y2=1.595
r1176 (  226 357 ) resistor r=45.1352 //w=0.168 //l=0.173853 //layer=ply \
 //thickness=0.18 //x=42.66 //y=1.095 //x2=42.7 //y2=0.94
r1177 (  226 227 ) resistor r=176.904 //w=0.094 //l=0.345 //layer=ply \
 //thickness=0.18 //x=42.66 //y=1.095 //x2=42.66 //y2=1.44
r1178 (  223 360 ) resistor r=53.7854 //w=0.233 //l=0.332415 //layer=ply \
 //thickness=0.18 //x=42.41 //y=5.045 //x2=42.67 //y2=4.88
r1179 (  222 352 ) resistor r=45.1352 //w=0.168 //l=0.173853 //layer=ply \
 //thickness=0.18 //x=35.05 //y=1.44 //x2=35.01 //y2=1.595
r1180 (  221 351 ) resistor r=45.1352 //w=0.168 //l=0.173853 //layer=ply \
 //thickness=0.18 //x=35.05 //y=1.095 //x2=35.01 //y2=0.94
r1181 (  221 222 ) resistor r=176.904 //w=0.094 //l=0.345 //layer=ply \
 //thickness=0.18 //x=35.05 //y=1.095 //x2=35.05 //y2=1.44
r1182 (  219 348 ) resistor r=10.701 //w=0.21 //l=0.115 //layer=ply \
 //thickness=0.18 //x=34.675 //y=1.595 //x2=34.56 //y2=1.595
r1183 (  218 352 ) resistor r=5.52526 //w=0.168 //l=0.115 //layer=ply \
 //thickness=0.18 //x=34.895 //y=1.595 //x2=35.01 //y2=1.595
r1184 (  217 347 ) resistor r=5.52526 //w=0.168 //l=0.115 //layer=ply \
 //thickness=0.18 //x=34.675 //y=0.94 //x2=34.56 //y2=0.94
r1185 (  216 351 ) resistor r=5.52526 //w=0.168 //l=0.115 //layer=ply \
 //thickness=0.18 //x=34.895 //y=0.94 //x2=35.01 //y2=0.94
r1186 (  216 217 ) resistor r=112.809 //w=0.094 //l=0.22 //layer=ply \
 //thickness=0.18 //x=34.895 //y=0.94 //x2=34.675 //y2=0.94
r1187 (  213 350 ) resistor r=37.236 //w=0.233 //l=0.249199 //layer=ply \
 //thickness=0.18 //x=34.71 //y=5.045 //x2=34.53 //y2=4.88
r1188 (  211 348 ) resistor r=39.5823 //w=0.21 //l=0.173853 //layer=ply \
 //thickness=0.18 //x=34.52 //y=1.75 //x2=34.56 //y2=1.595
r1189 (  211 345 ) resistor r=176.904 //w=0.094 //l=0.345 //layer=ply \
 //thickness=0.18 //x=34.52 //y=1.75 //x2=34.52 //y2=2.095
r1190 (  210 348 ) resistor r=39.5823 //w=0.21 //l=0.173853 //layer=ply \
 //thickness=0.18 //x=34.52 //y=1.44 //x2=34.56 //y2=1.595
r1191 (  209 347 ) resistor r=45.1352 //w=0.168 //l=0.173853 //layer=ply \
 //thickness=0.18 //x=34.52 //y=1.095 //x2=34.56 //y2=0.94
r1192 (  209 210 ) resistor r=176.904 //w=0.094 //l=0.345 //layer=ply \
 //thickness=0.18 //x=34.52 //y=1.095 //x2=34.52 //y2=1.44
r1193 (  206 350 ) resistor r=53.7854 //w=0.233 //l=0.332415 //layer=ply \
 //thickness=0.18 //x=34.27 //y=5.045 //x2=34.53 //y2=4.88
r1194 (  202 337 ) resistor r=16.5046 //w=0.27 //l=0.135 //layer=ply \
 //thickness=0.18 //x=20.605 //y=4.97 //x2=20.47 //y2=4.97
r1195 (  201 203 ) resistor r=26.9307 //w=0.15 //l=0.106066 //layer=ply \
 //thickness=0.18 //x=20.805 //y=4.97 //x2=20.88 //y2=5.045
r1196 (  201 202 ) resistor r=102.553 //w=0.094 //l=0.2 //layer=ply \
 //thickness=0.18 //x=20.805 //y=4.97 //x2=20.605 //y2=4.97
r1197 (  200 342 ) resistor r=38.6777 //w=0.284 //l=0.198997 //layer=ply \
 //thickness=0.18 //x=20.56 //y=2.095 //x2=20.485 //y2=2.26
r1198 (  199 340 ) resistor r=21.2976 //w=0.217 //l=0.0928709 //layer=ply \
 //thickness=0.18 //x=20.56 //y=1.63 //x2=20.52 //y2=1.555
r1199 (  199 200 ) resistor r=238.436 //w=0.094 //l=0.465 //layer=ply \
 //thickness=0.18 //x=20.56 //y=1.63 //x2=20.56 //y2=2.095
r1200 (  198 340 ) resistor r=39.0671 //w=0.217 //l=0.173853 //layer=ply \
 //thickness=0.18 //x=20.56 //y=1.4 //x2=20.52 //y2=1.555
r1201 (  197 339 ) resistor r=45.1352 //w=0.168 //l=0.173853 //layer=ply \
 //thickness=0.18 //x=20.56 //y=1.09 //x2=20.52 //y2=0.935
r1202 (  197 198 ) resistor r=158.957 //w=0.094 //l=0.31 //layer=ply \
 //thickness=0.18 //x=20.56 //y=1.09 //x2=20.56 //y2=1.4
r1203 (  192 333 ) resistor r=5.52526 //w=0.168 //l=0.115 //layer=ply \
 //thickness=0.18 //x=20.19 //y=1.555 //x2=20.075 //y2=1.555
r1204 (  191 340 ) resistor r=11.4558 //w=0.217 //l=0.115 //layer=ply \
 //thickness=0.18 //x=20.405 //y=1.555 //x2=20.52 //y2=1.555
r1205 (  190 332 ) resistor r=5.52526 //w=0.168 //l=0.115 //layer=ply \
 //thickness=0.18 //x=20.19 //y=0.935 //x2=20.075 //y2=0.935
r1206 (  189 339 ) resistor r=5.52526 //w=0.168 //l=0.115 //layer=ply \
 //thickness=0.18 //x=20.405 //y=0.935 //x2=20.52 //y2=0.935
r1207 (  189 190 ) resistor r=110.245 //w=0.094 //l=0.215 //layer=ply \
 //thickness=0.18 //x=20.405 //y=0.935 //x2=20.19 //y2=0.935
r1208 (  188 333 ) resistor r=45.1352 //w=0.168 //l=0.173853 //layer=ply \
 //thickness=0.18 //x=20.035 //y=1.4 //x2=20.075 //y2=1.555
r1209 (  187 332 ) resistor r=45.1352 //w=0.168 //l=0.173853 //layer=ply \
 //thickness=0.18 //x=20.035 //y=1.09 //x2=20.075 //y2=0.935
r1210 (  187 188 ) resistor r=158.957 //w=0.094 //l=0.31 //layer=ply \
 //thickness=0.18 //x=20.035 //y=1.09 //x2=20.035 //y2=1.4
r1211 (  186 331 ) resistor r=45.1352 //w=0.168 //l=0.173853 //layer=ply \
 //thickness=0.18 //x=17.29 //y=1.44 //x2=17.25 //y2=1.595
r1212 (  185 330 ) resistor r=45.1352 //w=0.168 //l=0.173853 //layer=ply \
 //thickness=0.18 //x=17.29 //y=1.095 //x2=17.25 //y2=0.94
r1213 (  185 186 ) resistor r=176.904 //w=0.094 //l=0.345 //layer=ply \
 //thickness=0.18 //x=17.29 //y=1.095 //x2=17.29 //y2=1.44
r1214 (  183 327 ) resistor r=10.701 //w=0.21 //l=0.115 //layer=ply \
 //thickness=0.18 //x=16.915 //y=1.595 //x2=16.8 //y2=1.595
r1215 (  182 331 ) resistor r=5.52526 //w=0.168 //l=0.115 //layer=ply \
 //thickness=0.18 //x=17.135 //y=1.595 //x2=17.25 //y2=1.595
r1216 (  181 326 ) resistor r=5.52526 //w=0.168 //l=0.115 //layer=ply \
 //thickness=0.18 //x=16.915 //y=0.94 //x2=16.8 //y2=0.94
r1217 (  180 330 ) resistor r=5.52526 //w=0.168 //l=0.115 //layer=ply \
 //thickness=0.18 //x=17.135 //y=0.94 //x2=17.25 //y2=0.94
r1218 (  180 181 ) resistor r=112.809 //w=0.094 //l=0.22 //layer=ply \
 //thickness=0.18 //x=17.135 //y=0.94 //x2=16.915 //y2=0.94
r1219 (  177 329 ) resistor r=37.236 //w=0.233 //l=0.249199 //layer=ply \
 //thickness=0.18 //x=16.95 //y=5.045 //x2=16.77 //y2=4.88
r1220 (  175 327 ) resistor r=39.5823 //w=0.21 //l=0.173853 //layer=ply \
 //thickness=0.18 //x=16.76 //y=1.75 //x2=16.8 //y2=1.595
r1221 (  175 324 ) resistor r=176.904 //w=0.094 //l=0.345 //layer=ply \
 //thickness=0.18 //x=16.76 //y=1.75 //x2=16.76 //y2=2.095
r1222 (  174 327 ) resistor r=39.5823 //w=0.21 //l=0.173853 //layer=ply \
 //thickness=0.18 //x=16.76 //y=1.44 //x2=16.8 //y2=1.595
r1223 (  173 326 ) resistor r=45.1352 //w=0.168 //l=0.173853 //layer=ply \
 //thickness=0.18 //x=16.76 //y=1.095 //x2=16.8 //y2=0.94
r1224 (  173 174 ) resistor r=176.904 //w=0.094 //l=0.345 //layer=ply \
 //thickness=0.18 //x=16.76 //y=1.095 //x2=16.76 //y2=1.44
r1225 (  170 329 ) resistor r=53.7854 //w=0.233 //l=0.332415 //layer=ply \
 //thickness=0.18 //x=16.51 //y=5.045 //x2=16.77 //y2=4.88
r1226 (  169 321 ) resistor r=45.1352 //w=0.168 //l=0.173853 //layer=ply \
 //thickness=0.18 //x=9.15 //y=1.44 //x2=9.11 //y2=1.595
r1227 (  168 320 ) resistor r=45.1352 //w=0.168 //l=0.173853 //layer=ply \
 //thickness=0.18 //x=9.15 //y=1.095 //x2=9.11 //y2=0.94
r1228 (  168 169 ) resistor r=176.904 //w=0.094 //l=0.345 //layer=ply \
 //thickness=0.18 //x=9.15 //y=1.095 //x2=9.15 //y2=1.44
r1229 (  166 317 ) resistor r=10.701 //w=0.21 //l=0.115 //layer=ply \
 //thickness=0.18 //x=8.775 //y=1.595 //x2=8.66 //y2=1.595
r1230 (  165 321 ) resistor r=5.52526 //w=0.168 //l=0.115 //layer=ply \
 //thickness=0.18 //x=8.995 //y=1.595 //x2=9.11 //y2=1.595
r1231 (  164 316 ) resistor r=5.52526 //w=0.168 //l=0.115 //layer=ply \
 //thickness=0.18 //x=8.775 //y=0.94 //x2=8.66 //y2=0.94
r1232 (  163 320 ) resistor r=5.52526 //w=0.168 //l=0.115 //layer=ply \
 //thickness=0.18 //x=8.995 //y=0.94 //x2=9.11 //y2=0.94
r1233 (  163 164 ) resistor r=112.809 //w=0.094 //l=0.22 //layer=ply \
 //thickness=0.18 //x=8.995 //y=0.94 //x2=8.775 //y2=0.94
r1234 (  160 319 ) resistor r=37.236 //w=0.233 //l=0.249199 //layer=ply \
 //thickness=0.18 //x=8.81 //y=5.045 //x2=8.63 //y2=4.88
r1235 (  158 317 ) resistor r=39.5823 //w=0.21 //l=0.173853 //layer=ply \
 //thickness=0.18 //x=8.62 //y=1.75 //x2=8.66 //y2=1.595
r1236 (  158 314 ) resistor r=176.904 //w=0.094 //l=0.345 //layer=ply \
 //thickness=0.18 //x=8.62 //y=1.75 //x2=8.62 //y2=2.095
r1237 (  157 317 ) resistor r=39.5823 //w=0.21 //l=0.173853 //layer=ply \
 //thickness=0.18 //x=8.62 //y=1.44 //x2=8.66 //y2=1.595
r1238 (  156 316 ) resistor r=45.1352 //w=0.168 //l=0.173853 //layer=ply \
 //thickness=0.18 //x=8.62 //y=1.095 //x2=8.66 //y2=0.94
r1239 (  156 157 ) resistor r=176.904 //w=0.094 //l=0.345 //layer=ply \
 //thickness=0.18 //x=8.62 //y=1.095 //x2=8.62 //y2=1.44
r1240 (  153 319 ) resistor r=53.7854 //w=0.233 //l=0.332415 //layer=ply \
 //thickness=0.18 //x=8.37 //y=5.045 //x2=8.63 //y2=4.88
r1241 (  152 309 ) resistor r=592.245 //w=0.094 //l=1.155 //layer=ply \
 //thickness=0.18 //x=72.68 //y=6.2 //x2=72.68 //y2=5.045
r1242 (  151 400 ) resistor r=592.245 //w=0.094 //l=1.155 //layer=ply \
 //thickness=0.18 //x=72.24 //y=6.2 //x2=72.24 //y2=5.045
r1243 (  150 283 ) resistor r=592.245 //w=0.094 //l=1.155 //layer=ply \
 //thickness=0.18 //x=68.75 //y=6.2 //x2=68.75 //y2=5.045
r1244 (  149 276 ) resistor r=592.245 //w=0.094 //l=1.155 //layer=ply \
 //thickness=0.18 //x=68.31 //y=6.2 //x2=68.31 //y2=5.045
r1245 (  148 266 ) resistor r=592.245 //w=0.094 //l=1.155 //layer=ply \
 //thickness=0.18 //x=60.61 //y=6.2 //x2=60.61 //y2=5.045
r1246 (  147 259 ) resistor r=592.245 //w=0.094 //l=1.155 //layer=ply \
 //thickness=0.18 //x=60.17 //y=6.2 //x2=60.17 //y2=5.045
r1247 (  146 256 ) resistor r=592.245 //w=0.094 //l=1.155 //layer=ply \
 //thickness=0.18 //x=46.78 //y=6.2 //x2=46.78 //y2=5.045
r1248 (  145 369 ) resistor r=592.245 //w=0.094 //l=1.155 //layer=ply \
 //thickness=0.18 //x=46.34 //y=6.2 //x2=46.34 //y2=5.045
r1249 (  144 230 ) resistor r=592.245 //w=0.094 //l=1.155 //layer=ply \
 //thickness=0.18 //x=42.85 //y=6.2 //x2=42.85 //y2=5.045
r1250 (  143 223 ) resistor r=592.245 //w=0.094 //l=1.155 //layer=ply \
 //thickness=0.18 //x=42.41 //y=6.2 //x2=42.41 //y2=5.045
r1251 (  142 213 ) resistor r=592.245 //w=0.094 //l=1.155 //layer=ply \
 //thickness=0.18 //x=34.71 //y=6.2 //x2=34.71 //y2=5.045
r1252 (  141 206 ) resistor r=592.245 //w=0.094 //l=1.155 //layer=ply \
 //thickness=0.18 //x=34.27 //y=6.2 //x2=34.27 //y2=5.045
r1253 (  140 203 ) resistor r=592.245 //w=0.094 //l=1.155 //layer=ply \
 //thickness=0.18 //x=20.88 //y=6.2 //x2=20.88 //y2=5.045
r1254 (  139 338 ) resistor r=592.245 //w=0.094 //l=1.155 //layer=ply \
 //thickness=0.18 //x=20.44 //y=6.2 //x2=20.44 //y2=5.045
r1255 (  138 177 ) resistor r=592.245 //w=0.094 //l=1.155 //layer=ply \
 //thickness=0.18 //x=16.95 //y=6.2 //x2=16.95 //y2=5.045
r1256 (  137 170 ) resistor r=592.245 //w=0.094 //l=1.155 //layer=ply \
 //thickness=0.18 //x=16.51 //y=6.2 //x2=16.51 //y2=5.045
r1257 (  136 160 ) resistor r=592.245 //w=0.094 //l=1.155 //layer=ply \
 //thickness=0.18 //x=8.81 //y=6.2 //x2=8.81 //y2=5.045
r1258 (  135 153 ) resistor r=592.245 //w=0.094 //l=1.155 //layer=ply \
 //thickness=0.18 //x=8.37 //y=6.2 //x2=8.37 //y2=5.045
r1259 (  134 297 ) resistor r=55.3787 //w=0.094 //l=0.108 //layer=ply \
 //thickness=0.18 //x=72.097 //y=1.555 //x2=72.205 //y2=1.555
r1260 (  134 298 ) resistor r=54.866 //w=0.094 //l=0.107 //layer=ply \
 //thickness=0.18 //x=72.097 //y=1.555 //x2=71.99 //y2=1.555
r1261 (  133 288 ) resistor r=56.4043 //w=0.094 //l=0.11 //layer=ply \
 //thickness=0.18 //x=68.825 //y=1.595 //x2=68.935 //y2=1.595
r1262 (  133 289 ) resistor r=56.4043 //w=0.094 //l=0.11 //layer=ply \
 //thickness=0.18 //x=68.825 //y=1.595 //x2=68.715 //y2=1.595
r1263 (  132 271 ) resistor r=56.4043 //w=0.094 //l=0.11 //layer=ply \
 //thickness=0.18 //x=60.685 //y=1.595 //x2=60.795 //y2=1.595
r1264 (  132 272 ) resistor r=56.4043 //w=0.094 //l=0.11 //layer=ply \
 //thickness=0.18 //x=60.685 //y=1.595 //x2=60.575 //y2=1.595
r1265 (  131 244 ) resistor r=55.3787 //w=0.094 //l=0.108 //layer=ply \
 //thickness=0.18 //x=46.197 //y=1.555 //x2=46.305 //y2=1.555
r1266 (  131 245 ) resistor r=54.866 //w=0.094 //l=0.107 //layer=ply \
 //thickness=0.18 //x=46.197 //y=1.555 //x2=46.09 //y2=1.555
r1267 (  130 235 ) resistor r=56.4043 //w=0.094 //l=0.11 //layer=ply \
 //thickness=0.18 //x=42.925 //y=1.595 //x2=43.035 //y2=1.595
r1268 (  130 236 ) resistor r=56.4043 //w=0.094 //l=0.11 //layer=ply \
 //thickness=0.18 //x=42.925 //y=1.595 //x2=42.815 //y2=1.595
r1269 (  129 218 ) resistor r=56.4043 //w=0.094 //l=0.11 //layer=ply \
 //thickness=0.18 //x=34.785 //y=1.595 //x2=34.895 //y2=1.595
r1270 (  129 219 ) resistor r=56.4043 //w=0.094 //l=0.11 //layer=ply \
 //thickness=0.18 //x=34.785 //y=1.595 //x2=34.675 //y2=1.595
r1271 (  128 191 ) resistor r=55.3787 //w=0.094 //l=0.108 //layer=ply \
 //thickness=0.18 //x=20.297 //y=1.555 //x2=20.405 //y2=1.555
r1272 (  128 192 ) resistor r=54.866 //w=0.094 //l=0.107 //layer=ply \
 //thickness=0.18 //x=20.297 //y=1.555 //x2=20.19 //y2=1.555
r1273 (  127 182 ) resistor r=56.4043 //w=0.094 //l=0.11 //layer=ply \
 //thickness=0.18 //x=17.025 //y=1.595 //x2=17.135 //y2=1.595
r1274 (  127 183 ) resistor r=56.4043 //w=0.094 //l=0.11 //layer=ply \
 //thickness=0.18 //x=17.025 //y=1.595 //x2=16.915 //y2=1.595
r1275 (  126 165 ) resistor r=56.4043 //w=0.094 //l=0.11 //layer=ply \
 //thickness=0.18 //x=8.885 //y=1.595 //x2=8.995 //y2=1.595
r1276 (  126 166 ) resistor r=56.4043 //w=0.094 //l=0.11 //layer=ply \
 //thickness=0.18 //x=8.885 //y=1.595 //x2=8.775 //y2=1.595
r1277 (  124 397 ) resistor r=152 //w=0.17 //l=0.17 //layer=licon //count=1 \
 //x=72.27 //y=4.88 //x2=72.27 //y2=4.88
r1278 (  118 404 ) resistor r=152 //w=0.17 //l=0.17 //layer=licon //count=1 \
 //x=72.27 //y=2.26 //x2=72.27 //y2=2.26
r1279 (  118 121 ) resistor r=9.58289 //w=0.187 //l=0.14 //layer=li \
 //thickness=0.1 //x=72.27 //y=2.26 //x2=72.27 //y2=2.4
r1280 (  115 391 ) resistor r=152 //w=0.17 //l=0.17 //layer=licon //count=1 \
 //x=68.57 //y=4.88 //x2=68.57 //y2=4.88
r1281 (  113 115 ) resistor r=169.754 //w=0.187 //l=2.48 //layer=li \
 //thickness=0.1 //x=68.57 //y=2.4 //x2=68.57 //y2=4.88
r1282 (  110 385 ) resistor r=152 //w=0.17 //l=0.17 //layer=licon //count=1 \
 //x=68.57 //y=2.26 //x2=68.57 //y2=2.26
r1283 (  110 113 ) resistor r=9.58289 //w=0.187 //l=0.14 //layer=li \
 //thickness=0.1 //x=68.57 //y=2.26 //x2=68.57 //y2=2.4
r1284 (  107 381 ) resistor r=152 //w=0.17 //l=0.17 //layer=licon //count=1 \
 //x=60.43 //y=4.88 //x2=60.43 //y2=4.88
r1285 (  105 107 ) resistor r=169.754 //w=0.187 //l=2.48 //layer=li \
 //thickness=0.1 //x=60.43 //y=2.4 //x2=60.43 //y2=4.88
r1286 (  102 375 ) resistor r=152 //w=0.17 //l=0.17 //layer=licon //count=1 \
 //x=60.43 //y=2.26 //x2=60.43 //y2=2.26
r1287 (  102 105 ) resistor r=9.58289 //w=0.187 //l=0.14 //layer=li \
 //thickness=0.1 //x=60.43 //y=2.26 //x2=60.43 //y2=2.4
r1288 (  99 366 ) resistor r=152 //w=0.17 //l=0.17 //layer=licon //count=1 \
 //x=46.37 //y=4.88 //x2=46.37 //y2=4.88
r1289 (  92 373 ) resistor r=152 //w=0.17 //l=0.17 //layer=licon //count=1 \
 //x=46.37 //y=2.26 //x2=46.37 //y2=2.26
r1290 (  92 95 ) resistor r=9.58289 //w=0.187 //l=0.14 //layer=li \
 //thickness=0.1 //x=46.37 //y=2.26 //x2=46.37 //y2=2.4
r1291 (  89 360 ) resistor r=152 //w=0.17 //l=0.17 //layer=licon //count=1 \
 //x=42.67 //y=4.88 //x2=42.67 //y2=4.88
r1292 (  83 354 ) resistor r=152 //w=0.17 //l=0.17 //layer=licon //count=1 \
 //x=42.67 //y=2.26 //x2=42.67 //y2=2.26
r1293 (  83 86 ) resistor r=9.58289 //w=0.187 //l=0.14 //layer=li \
 //thickness=0.1 //x=42.67 //y=2.26 //x2=42.67 //y2=2.4
r1294 (  80 350 ) resistor r=152 //w=0.17 //l=0.17 //layer=licon //count=1 \
 //x=34.53 //y=4.88 //x2=34.53 //y2=4.88
r1295 (  78 80 ) resistor r=169.754 //w=0.187 //l=2.48 //layer=li \
 //thickness=0.1 //x=34.53 //y=2.4 //x2=34.53 //y2=4.88
r1296 (  75 344 ) resistor r=152 //w=0.17 //l=0.17 //layer=licon //count=1 \
 //x=34.53 //y=2.26 //x2=34.53 //y2=2.26
r1297 (  75 78 ) resistor r=9.58289 //w=0.187 //l=0.14 //layer=li \
 //thickness=0.1 //x=34.53 //y=2.26 //x2=34.53 //y2=2.4
r1298 (  72 335 ) resistor r=152 //w=0.17 //l=0.17 //layer=licon //count=1 \
 //x=20.47 //y=4.88 //x2=20.47 //y2=4.88
r1299 (  65 342 ) resistor r=152 //w=0.17 //l=0.17 //layer=licon //count=1 \
 //x=20.47 //y=2.26 //x2=20.47 //y2=2.26
r1300 (  65 68 ) resistor r=9.58289 //w=0.187 //l=0.14 //layer=li \
 //thickness=0.1 //x=20.47 //y=2.26 //x2=20.47 //y2=2.4
r1301 (  62 329 ) resistor r=152 //w=0.17 //l=0.17 //layer=licon //count=1 \
 //x=16.77 //y=4.88 //x2=16.77 //y2=4.88
r1302 (  55 323 ) resistor r=152 //w=0.17 //l=0.17 //layer=licon //count=1 \
 //x=16.77 //y=2.26 //x2=16.77 //y2=2.26
r1303 (  55 58 ) resistor r=9.58289 //w=0.187 //l=0.14 //layer=li \
 //thickness=0.1 //x=16.77 //y=2.26 //x2=16.77 //y2=2.4
r1304 (  52 319 ) resistor r=152 //w=0.17 //l=0.17 //layer=licon //count=1 \
 //x=8.63 //y=4.88 //x2=8.63 //y2=4.88
r1305 (  46 313 ) resistor r=152 //w=0.17 //l=0.17 //layer=licon //count=1 \
 //x=8.63 //y=2.26 //x2=8.63 //y2=2.26
r1306 (  44 124 ) resistor r=68.4492 //w=0.187 //l=1 //layer=li \
 //thickness=0.1 //x=72.27 //y=3.88 //x2=72.27 //y2=4.88
r1307 (  44 121 ) resistor r=101.305 //w=0.187 //l=1.48 //layer=li \
 //thickness=0.1 //x=72.27 //y=3.88 //x2=72.27 //y2=2.4
r1308 (  43 99 ) resistor r=68.4492 //w=0.187 //l=1 //layer=li //thickness=0.1 \
 //x=46.37 //y=3.88 //x2=46.37 //y2=4.88
r1309 (  42 43 ) resistor r=25.3262 //w=0.187 //l=0.37 //layer=li \
 //thickness=0.1 //x=46.37 //y=3.51 //x2=46.37 //y2=3.88
r1310 (  42 95 ) resistor r=75.9786 //w=0.187 //l=1.11 //layer=li \
 //thickness=0.1 //x=46.37 //y=3.51 //x2=46.37 //y2=2.4
r1311 (  41 89 ) resistor r=93.7754 //w=0.187 //l=1.37 //layer=li \
 //thickness=0.1 //x=42.67 //y=3.51 //x2=42.67 //y2=4.88
r1312 (  41 86 ) resistor r=75.9786 //w=0.187 //l=1.11 //layer=li \
 //thickness=0.1 //x=42.67 //y=3.51 //x2=42.67 //y2=2.4
r1313 (  40 72 ) resistor r=93.7754 //w=0.187 //l=1.37 //layer=li \
 //thickness=0.1 //x=20.47 //y=3.51 //x2=20.47 //y2=4.88
r1314 (  39 40 ) resistor r=25.3262 //w=0.187 //l=0.37 //layer=li \
 //thickness=0.1 //x=20.47 //y=3.14 //x2=20.47 //y2=3.51
r1315 (  39 68 ) resistor r=50.6524 //w=0.187 //l=0.74 //layer=li \
 //thickness=0.1 //x=20.47 //y=3.14 //x2=20.47 //y2=2.4
r1316 (  38 62 ) resistor r=93.7754 //w=0.187 //l=1.37 //layer=li \
 //thickness=0.1 //x=16.77 //y=3.51 //x2=16.77 //y2=4.88
r1317 (  37 38 ) resistor r=25.3262 //w=0.187 //l=0.37 //layer=li \
 //thickness=0.1 //x=16.77 //y=3.14 //x2=16.77 //y2=3.51
r1318 (  37 58 ) resistor r=50.6524 //w=0.187 //l=0.74 //layer=li \
 //thickness=0.1 //x=16.77 //y=3.14 //x2=16.77 //y2=2.4
r1319 (  36 52 ) resistor r=119.102 //w=0.187 //l=1.74 //layer=li \
 //thickness=0.1 //x=8.63 //y=3.14 //x2=8.63 //y2=4.88
r1320 (  35 36 ) resistor r=50.6524 //w=0.187 //l=0.74 //layer=li \
 //thickness=0.1 //x=8.63 //y=2.4 //x2=8.63 //y2=3.14
r1321 (  35 46 ) resistor r=9.58289 //w=0.187 //l=0.14 //layer=li \
 //thickness=0.1 //x=8.63 //y=2.4 //x2=8.63 //y2=2.26
r1322 (  34 121 ) resistor r=9.3 //w=0.17 //l=0.17 //layer=mcon //count=1 \
 //x=72.27 //y=2.4 //x2=72.27 //y2=2.4
r1323 (  32 113 ) resistor r=9.3 //w=0.17 //l=0.17 //layer=mcon //count=1 \
 //x=68.57 //y=2.4 //x2=68.57 //y2=2.4
r1324 (  30 105 ) resistor r=9.3 //w=0.17 //l=0.17 //layer=mcon //count=1 \
 //x=60.43 //y=2.4 //x2=60.43 //y2=2.4
r1325 (  28 95 ) resistor r=9.3 //w=0.17 //l=0.17 //layer=mcon //count=1 \
 //x=46.37 //y=2.4 //x2=46.37 //y2=2.4
r1326 (  26 86 ) resistor r=9.3 //w=0.17 //l=0.17 //layer=mcon //count=1 \
 //x=42.67 //y=2.4 //x2=42.67 //y2=2.4
r1327 (  24 78 ) resistor r=9.3 //w=0.17 //l=0.17 //layer=mcon //count=1 \
 //x=34.53 //y=2.4 //x2=34.53 //y2=2.4
r1328 (  22 68 ) resistor r=9.3 //w=0.17 //l=0.17 //layer=mcon //count=1 \
 //x=20.47 //y=2.4 //x2=20.47 //y2=2.4
r1329 (  20 58 ) resistor r=9.3 //w=0.17 //l=0.17 //layer=mcon //count=1 \
 //x=16.77 //y=2.4 //x2=16.77 //y2=2.4
r1330 (  18 35 ) resistor r=9.3 //w=0.17 //l=0.17 //layer=mcon //count=1 \
 //x=8.63 //y=2.4 //x2=8.63 //y2=2.4
r1331 (  16 32 ) resistor r=0.0880901 //w=0.191 //l=0.115 //layer=m1 \
 //thickness=0.36 //x=68.685 //y=2.4 //x2=68.57 //y2=2.4
r1332 (  15 34 ) resistor r=0.0717383 //w=0.224 //l=0.115 //layer=m1 \
 //thickness=0.36 //x=72.155 //y=2.4 //x2=72.27 //y2=2.4
r1333 (  15 16 ) resistor r=3.31107 //w=0.131 //l=3.47 //layer=m1 \
 //thickness=0.36 //x=72.155 //y=2.4 //x2=68.685 //y2=2.4
r1334 (  14 30 ) resistor r=0.0880901 //w=0.191 //l=0.115 //layer=m1 \
 //thickness=0.36 //x=60.545 //y=2.4 //x2=60.43 //y2=2.4
r1335 (  13 32 ) resistor r=0.0880901 //w=0.191 //l=0.115 //layer=m1 \
 //thickness=0.36 //x=68.455 //y=2.4 //x2=68.57 //y2=2.4
r1336 (  13 14 ) resistor r=7.54771 //w=0.131 //l=7.91 //layer=m1 \
 //thickness=0.36 //x=68.455 //y=2.4 //x2=60.545 //y2=2.4
r1337 (  12 28 ) resistor r=0.0880901 //w=0.191 //l=0.115 //layer=m1 \
 //thickness=0.36 //x=46.485 //y=2.4 //x2=46.37 //y2=2.4
r1338 (  11 30 ) resistor r=0.0880901 //w=0.191 //l=0.115 //layer=m1 \
 //thickness=0.36 //x=60.315 //y=2.4 //x2=60.43 //y2=2.4
r1339 (  11 12 ) resistor r=13.1966 //w=0.131 //l=13.83 //layer=m1 \
 //thickness=0.36 //x=60.315 //y=2.4 //x2=46.485 //y2=2.4
r1340 (  10 26 ) resistor r=0.0880901 //w=0.191 //l=0.115 //layer=m1 \
 //thickness=0.36 //x=42.785 //y=2.4 //x2=42.67 //y2=2.4
r1341 (  9 28 ) resistor r=0.0880901 //w=0.191 //l=0.115 //layer=m1 \
 //thickness=0.36 //x=46.255 //y=2.4 //x2=46.37 //y2=2.4
r1342 (  9 10 ) resistor r=3.31107 //w=0.131 //l=3.47 //layer=m1 \
 //thickness=0.36 //x=46.255 //y=2.4 //x2=42.785 //y2=2.4
r1343 (  8 24 ) resistor r=0.0880901 //w=0.191 //l=0.115 //layer=m1 \
 //thickness=0.36 //x=34.645 //y=2.4 //x2=34.53 //y2=2.4
r1344 (  7 26 ) resistor r=0.0880901 //w=0.191 //l=0.115 //layer=m1 \
 //thickness=0.36 //x=42.555 //y=2.4 //x2=42.67 //y2=2.4
r1345 (  7 8 ) resistor r=7.54771 //w=0.131 //l=7.91 //layer=m1 \
 //thickness=0.36 //x=42.555 //y=2.4 //x2=34.645 //y2=2.4
r1346 (  6 22 ) resistor r=0.0880901 //w=0.191 //l=0.115 //layer=m1 \
 //thickness=0.36 //x=20.585 //y=2.4 //x2=20.47 //y2=2.4
r1347 (  5 24 ) resistor r=0.0880901 //w=0.191 //l=0.115 //layer=m1 \
 //thickness=0.36 //x=34.415 //y=2.4 //x2=34.53 //y2=2.4
r1348 (  5 6 ) resistor r=13.1966 //w=0.131 //l=13.83 //layer=m1 \
 //thickness=0.36 //x=34.415 //y=2.4 //x2=20.585 //y2=2.4
r1349 (  4 20 ) resistor r=0.0880901 //w=0.191 //l=0.115 //layer=m1 \
 //thickness=0.36 //x=16.885 //y=2.4 //x2=16.77 //y2=2.4
r1350 (  3 22 ) resistor r=0.0880901 //w=0.191 //l=0.115 //layer=m1 \
 //thickness=0.36 //x=20.355 //y=2.4 //x2=20.47 //y2=2.4
r1351 (  3 4 ) resistor r=3.31107 //w=0.131 //l=3.47 //layer=m1 \
 //thickness=0.36 //x=20.355 //y=2.4 //x2=16.885 //y2=2.4
r1352 (  2 18 ) resistor r=0.0717383 //w=0.224 //l=0.115 //layer=m1 \
 //thickness=0.36 //x=8.745 //y=2.4 //x2=8.63 //y2=2.4
r1353 (  1 20 ) resistor r=0.0880901 //w=0.191 //l=0.115 //layer=m1 \
 //thickness=0.36 //x=16.655 //y=2.4 //x2=16.77 //y2=2.4
r1354 (  1 2 ) resistor r=7.54771 //w=0.131 //l=7.91 //layer=m1 \
 //thickness=0.36 //x=16.655 //y=2.4 //x2=8.745 //y2=2.4
ends PM_TMRDFFRNQX1\%RN

subckt PM_TMRDFFRNQX1\%noxref_16 ( 1 2 3 4 5 6 7 8 9 10 24 31 33 43 44 51 59 \
 65 66 70 77 78 85 93 99 100 104 106 113 115 121 122 123 124 127 128 129 130 \
 131 132 133 134 135 136 137 138 139 140 141 142 143 145 151 152 153 154 158 \
 159 160 165 167 169 175 176 177 178 179 180 184 186 189 190 194 195 196 201 \
 203 205 211 212 222 223 226 240 244 245 248 256 257 260 261 262 263 264 265 )
c500 ( 265 0 ) capacitor c=0.023087f //x=73.195 //y=5.2
c501 ( 264 0 ) capacitor c=0.023519f //x=72.315 //y=5.2
c502 ( 263 0 ) capacitor c=0.0224735f //x=71.435 //y=5.2
c503 ( 262 0 ) capacitor c=0.023087f //x=68.385 //y=5.2
c504 ( 261 0 ) capacitor c=0.023519f //x=67.505 //y=5.2
c505 ( 260 0 ) capacitor c=0.0224735f //x=66.625 //y=5.2
c506 ( 257 0 ) capacitor c=0.00872971f //x=73.445 //y=1.095
c507 ( 256 0 ) capacitor c=0.00853354f //x=68.635 //y=1.095
c508 ( 248 0 ) capacitor c=0.0340473f //x=76.74 //y=4.88
c509 ( 245 0 ) capacitor c=0.0292616f //x=76.71 //y=2.095
c510 ( 244 0 ) capacitor c=0.0436018f //x=76.71 //y=2.26
c511 ( 240 0 ) capacitor c=0.0602694f //x=75.97 //y=4.88
c512 ( 226 0 ) capacitor c=0.0331095f //x=63.79 //y=4.88
c513 ( 223 0 ) capacitor c=0.0279499f //x=63.76 //y=2.095
c514 ( 222 0 ) capacitor c=0.0421676f //x=63.76 //y=2.26
c515 ( 212 0 ) capacitor c=0.0431781f //x=77.275 //y=1.43
c516 ( 211 0 ) capacitor c=0.0197948f //x=77.275 //y=1.085
c517 ( 205 0 ) capacitor c=0.0158629f //x=77.12 //y=1.585
c518 ( 203 0 ) capacitor c=0.0157803f //x=77.12 //y=0.93
c519 ( 201 0 ) capacitor c=0.0307199f //x=77.115 //y=4.97
c520 ( 196 0 ) capacitor c=0.0210775f //x=76.745 //y=1.74
c521 ( 195 0 ) capacitor c=0.0179879f //x=76.745 //y=1.43
c522 ( 194 0 ) capacitor c=0.0177928f //x=76.745 //y=1.085
c523 ( 190 0 ) capacitor c=0.0338875f //x=76.305 //y=1.39
c524 ( 189 0 ) capacitor c=0.0189263f //x=76.305 //y=1.045
c525 ( 186 0 ) capacitor c=0.0141798f //x=76.15 //y=1.545
c526 ( 184 0 ) capacitor c=0.0149844f //x=76.15 //y=0.89
c527 ( 180 0 ) capacitor c=0.083929f //x=75.775 //y=2.095
c528 ( 179 0 ) capacitor c=0.0231111f //x=75.775 //y=1.7
c529 ( 178 0 ) capacitor c=0.0234352f //x=75.775 //y=1.39
c530 ( 177 0 ) capacitor c=0.0201338f //x=75.775 //y=1.045
c531 ( 176 0 ) capacitor c=0.0429696f //x=64.325 //y=1.43
c532 ( 175 0 ) capacitor c=0.0192208f //x=64.325 //y=1.085
c533 ( 169 0 ) capacitor c=0.0148884f //x=64.17 //y=1.585
c534 ( 167 0 ) capacitor c=0.0157803f //x=64.17 //y=0.93
c535 ( 165 0 ) capacitor c=0.0295235f //x=64.165 //y=4.97
c536 ( 160 0 ) capacitor c=0.0205163f //x=63.795 //y=1.74
c537 ( 159 0 ) capacitor c=0.0168481f //x=63.795 //y=1.43
c538 ( 158 0 ) capacitor c=0.0174783f //x=63.795 //y=1.085
c539 ( 154 0 ) capacitor c=0.0557698f //x=53.675 //y=4.97
c540 ( 153 0 ) capacitor c=0.0293157f //x=53.965 //y=4.97
c541 ( 152 0 ) capacitor c=0.0347816f //x=53.63 //y=1.4
c542 ( 151 0 ) capacitor c=0.0187487f //x=53.63 //y=1.055
c543 ( 145 0 ) capacitor c=0.0137055f //x=53.475 //y=1.555
c544 ( 143 0 ) capacitor c=0.0149861f //x=53.475 //y=0.9
c545 ( 142 0 ) capacitor c=0.096037f //x=53.1 //y=2.095
c546 ( 141 0 ) capacitor c=0.0228993f //x=53.1 //y=1.71
c547 ( 140 0 ) capacitor c=0.0234352f //x=53.1 //y=1.4
c548 ( 139 0 ) capacitor c=0.0198724f //x=53.1 //y=1.055
c549 ( 138 0 ) capacitor c=0.15358f //x=77.19 //y=6.2
c550 ( 137 0 ) capacitor c=0.116098f //x=76.75 //y=6.2
c551 ( 136 0 ) capacitor c=0.116091f //x=76.31 //y=6.2
c552 ( 135 0 ) capacitor c=0.154305f //x=75.87 //y=6.2
c553 ( 134 0 ) capacitor c=0.15358f //x=64.24 //y=6.2
c554 ( 133 0 ) capacitor c=0.110281f //x=63.8 //y=6.2
c555 ( 132 0 ) capacitor c=0.110114f //x=54.04 //y=6.2
c556 ( 131 0 ) capacitor c=0.158956f //x=53.6 //y=6.2
c557 ( 124 0 ) capacitor c=0.00116729f //x=73.34 //y=5.335
c558 ( 123 0 ) capacitor c=0.00226015f //x=72.46 //y=5.335
c559 ( 122 0 ) capacitor c=0.00116729f //x=68.53 //y=5.335
c560 ( 121 0 ) capacitor c=0.0021933f //x=67.65 //y=5.335
c561 ( 115 0 ) capacitor c=0.0711582f //x=76.71 //y=2.26
c562 ( 113 0 ) capacitor c=0.00453889f //x=76.71 //y=4.715
c563 ( 106 0 ) capacitor c=0.0883483f //x=75.97 //y=2.26
c564 ( 104 0 ) capacitor c=0.108107f //x=74.12 //y=4.25
c565 ( 100 0 ) capacitor c=0.00463522f //x=73.72 //y=1.845
c566 ( 99 0 ) capacitor c=0.0148737f //x=74.035 //y=1.845
c567 ( 93 0 ) capacitor c=0.0292981f //x=74.035 //y=5.335
c568 ( 85 0 ) capacitor c=0.0184197f //x=73.255 //y=5.335
c569 ( 78 0 ) capacitor c=0.00351598f //x=71.665 //y=5.335
c570 ( 77 0 ) capacitor c=0.0155255f //x=72.375 //y=5.335
c571 ( 70 0 ) capacitor c=0.106966f //x=69.31 //y=4.25
c572 ( 66 0 ) capacitor c=0.00398962f //x=68.91 //y=1.845
c573 ( 65 0 ) capacitor c=0.0137288f //x=69.225 //y=1.845
c574 ( 59 0 ) capacitor c=0.0291076f //x=69.225 //y=5.335
c575 ( 51 0 ) capacitor c=0.0184197f //x=68.445 //y=5.335
c576 ( 44 0 ) capacitor c=0.00332903f //x=66.855 //y=5.335
c577 ( 43 0 ) capacitor c=0.014837f //x=67.565 //y=5.335
c578 ( 33 0 ) capacitor c=0.0693025f //x=63.76 //y=2.26
c579 ( 31 0 ) capacitor c=0.00453889f //x=63.76 //y=4.715
c580 ( 24 0 ) capacitor c=0.0974753f //x=53.4 //y=2.26
c581 ( 10 0 ) capacitor c=0.00400147f //x=76.085 //y=4.25
c582 ( 9 0 ) capacitor c=0.0236326f //x=76.595 //y=4.25
c583 ( 8 0 ) capacitor c=0.00570859f //x=74.235 //y=4.25
c584 ( 7 0 ) capacitor c=0.0482058f //x=75.855 //y=4.25
c585 ( 6 0 ) capacitor c=0.00720076f //x=69.425 //y=4.25
c586 ( 5 0 ) capacitor c=0.124606f //x=74.005 //y=4.25
c587 ( 4 0 ) capacitor c=0.00557292f //x=63.875 //y=4.25
c588 ( 3 0 ) capacitor c=0.0897132f //x=69.195 //y=4.25
c589 ( 2 0 ) capacitor c=0.00985259f //x=53.515 //y=4.25
c590 ( 1 0 ) capacitor c=0.145635f //x=63.645 //y=4.25
r591 (  250 251 ) resistor r=32.4568 //w=0.214 //l=0.075 //layer=ply \
 //thickness=0.18 //x=76.74 //y=4.97 //x2=76.74 //y2=5.045
r592 (  248 250 ) resistor r=20.271 //w=0.214 //l=0.09 //layer=ply \
 //thickness=0.18 //x=76.74 //y=4.88 //x2=76.74 //y2=4.97
r593 (  244 245 ) resistor r=52.7279 //w=0.214 //l=0.165 //layer=ply \
 //thickness=0.18 //x=76.71 //y=2.26 //x2=76.71 //y2=2.095
r594 (  238 240 ) resistor r=20.6867 //w=0.233 //l=0.1 //layer=ply \
 //thickness=0.18 //x=75.87 //y=4.88 //x2=75.97 //y2=4.88
r595 (  228 229 ) resistor r=32.4568 //w=0.214 //l=0.075 //layer=ply \
 //thickness=0.18 //x=63.79 //y=4.97 //x2=63.79 //y2=5.045
r596 (  226 228 ) resistor r=20.271 //w=0.214 //l=0.09 //layer=ply \
 //thickness=0.18 //x=63.79 //y=4.88 //x2=63.79 //y2=4.97
r597 (  222 223 ) resistor r=52.7279 //w=0.214 //l=0.165 //layer=ply \
 //thickness=0.18 //x=63.76 //y=2.26 //x2=63.76 //y2=2.095
r598 (  212 255 ) resistor r=45.1352 //w=0.168 //l=0.173853 //layer=ply \
 //thickness=0.18 //x=77.275 //y=1.43 //x2=77.235 //y2=1.585
r599 (  211 254 ) resistor r=45.1352 //w=0.168 //l=0.173853 //layer=ply \
 //thickness=0.18 //x=77.275 //y=1.085 //x2=77.235 //y2=0.93
r600 (  211 212 ) resistor r=176.904 //w=0.094 //l=0.345 //layer=ply \
 //thickness=0.18 //x=77.275 //y=1.085 //x2=77.275 //y2=1.43
r601 (  206 253 ) resistor r=10.701 //w=0.21 //l=0.115 //layer=ply \
 //thickness=0.18 //x=76.9 //y=1.585 //x2=76.785 //y2=1.585
r602 (  205 255 ) resistor r=5.52526 //w=0.168 //l=0.115 //layer=ply \
 //thickness=0.18 //x=77.12 //y=1.585 //x2=77.235 //y2=1.585
r603 (  204 252 ) resistor r=5.52526 //w=0.168 //l=0.115 //layer=ply \
 //thickness=0.18 //x=76.9 //y=0.93 //x2=76.785 //y2=0.93
r604 (  203 254 ) resistor r=5.52526 //w=0.168 //l=0.115 //layer=ply \
 //thickness=0.18 //x=77.12 //y=0.93 //x2=77.235 //y2=0.93
r605 (  203 204 ) resistor r=112.809 //w=0.094 //l=0.22 //layer=ply \
 //thickness=0.18 //x=77.12 //y=0.93 //x2=76.9 //y2=0.93
r606 (  202 250 ) resistor r=16.5046 //w=0.27 //l=0.135 //layer=ply \
 //thickness=0.18 //x=76.875 //y=4.97 //x2=76.74 //y2=4.97
r607 (  201 208 ) resistor r=26.9307 //w=0.15 //l=0.106066 //layer=ply \
 //thickness=0.18 //x=77.115 //y=4.97 //x2=77.19 //y2=5.045
r608 (  201 202 ) resistor r=123.064 //w=0.094 //l=0.24 //layer=ply \
 //thickness=0.18 //x=77.115 //y=4.97 //x2=76.875 //y2=4.97
r609 (  196 253 ) resistor r=39.5823 //w=0.21 //l=0.173853 //layer=ply \
 //thickness=0.18 //x=76.745 //y=1.74 //x2=76.785 //y2=1.585
r610 (  196 245 ) resistor r=182.032 //w=0.094 //l=0.355 //layer=ply \
 //thickness=0.18 //x=76.745 //y=1.74 //x2=76.745 //y2=2.095
r611 (  195 253 ) resistor r=39.5823 //w=0.21 //l=0.173853 //layer=ply \
 //thickness=0.18 //x=76.745 //y=1.43 //x2=76.785 //y2=1.585
r612 (  194 252 ) resistor r=45.1352 //w=0.168 //l=0.173853 //layer=ply \
 //thickness=0.18 //x=76.745 //y=1.085 //x2=76.785 //y2=0.93
r613 (  194 195 ) resistor r=176.904 //w=0.094 //l=0.345 //layer=ply \
 //thickness=0.18 //x=76.745 //y=1.085 //x2=76.745 //y2=1.43
r614 (  191 240 ) resistor r=70.3348 //w=0.233 //l=0.414367 //layer=ply \
 //thickness=0.18 //x=76.31 //y=5.045 //x2=75.97 //y2=4.88
r615 (  190 242 ) resistor r=45.1352 //w=0.168 //l=0.173853 //layer=ply \
 //thickness=0.18 //x=76.305 //y=1.39 //x2=76.265 //y2=1.545
r616 (  189 241 ) resistor r=45.1352 //w=0.168 //l=0.173853 //layer=ply \
 //thickness=0.18 //x=76.305 //y=1.045 //x2=76.265 //y2=0.89
r617 (  189 190 ) resistor r=176.904 //w=0.094 //l=0.345 //layer=ply \
 //thickness=0.18 //x=76.305 //y=1.045 //x2=76.305 //y2=1.39
r618 (  187 237 ) resistor r=10.701 //w=0.21 //l=0.115 //layer=ply \
 //thickness=0.18 //x=75.93 //y=1.545 //x2=75.815 //y2=1.545
r619 (  186 242 ) resistor r=5.52526 //w=0.168 //l=0.115 //layer=ply \
 //thickness=0.18 //x=76.15 //y=1.545 //x2=76.265 //y2=1.545
r620 (  185 236 ) resistor r=5.52526 //w=0.168 //l=0.115 //layer=ply \
 //thickness=0.18 //x=75.93 //y=0.89 //x2=75.815 //y2=0.89
r621 (  184 241 ) resistor r=5.52526 //w=0.168 //l=0.115 //layer=ply \
 //thickness=0.18 //x=76.15 //y=0.89 //x2=76.265 //y2=0.89
r622 (  184 185 ) resistor r=112.809 //w=0.094 //l=0.22 //layer=ply \
 //thickness=0.18 //x=76.15 //y=0.89 //x2=75.93 //y2=0.89
r623 (  181 238 ) resistor r=13.0941 //w=0.233 //l=0.165 //layer=ply \
 //thickness=0.18 //x=75.87 //y=5.045 //x2=75.87 //y2=4.88
r624 (  180 235 ) resistor r=34.8111 //w=0.27 //l=0.264953 //layer=ply \
 //thickness=0.18 //x=75.775 //y=2.095 //x2=75.97 //y2=2.26
r625 (  179 237 ) resistor r=39.5823 //w=0.21 //l=0.173853 //layer=ply \
 //thickness=0.18 //x=75.775 //y=1.7 //x2=75.815 //y2=1.545
r626 (  179 180 ) resistor r=202.543 //w=0.094 //l=0.395 //layer=ply \
 //thickness=0.18 //x=75.775 //y=1.7 //x2=75.775 //y2=2.095
r627 (  178 237 ) resistor r=39.5823 //w=0.21 //l=0.173853 //layer=ply \
 //thickness=0.18 //x=75.775 //y=1.39 //x2=75.815 //y2=1.545
r628 (  177 236 ) resistor r=45.1352 //w=0.168 //l=0.173853 //layer=ply \
 //thickness=0.18 //x=75.775 //y=1.045 //x2=75.815 //y2=0.89
r629 (  177 178 ) resistor r=176.904 //w=0.094 //l=0.345 //layer=ply \
 //thickness=0.18 //x=75.775 //y=1.045 //x2=75.775 //y2=1.39
r630 (  176 233 ) resistor r=45.1352 //w=0.168 //l=0.173853 //layer=ply \
 //thickness=0.18 //x=64.325 //y=1.43 //x2=64.285 //y2=1.585
r631 (  175 232 ) resistor r=45.1352 //w=0.168 //l=0.173853 //layer=ply \
 //thickness=0.18 //x=64.325 //y=1.085 //x2=64.285 //y2=0.93
r632 (  175 176 ) resistor r=176.904 //w=0.094 //l=0.345 //layer=ply \
 //thickness=0.18 //x=64.325 //y=1.085 //x2=64.325 //y2=1.43
r633 (  170 231 ) resistor r=10.701 //w=0.21 //l=0.115 //layer=ply \
 //thickness=0.18 //x=63.95 //y=1.585 //x2=63.835 //y2=1.585
r634 (  169 233 ) resistor r=5.52526 //w=0.168 //l=0.115 //layer=ply \
 //thickness=0.18 //x=64.17 //y=1.585 //x2=64.285 //y2=1.585
r635 (  168 230 ) resistor r=5.52526 //w=0.168 //l=0.115 //layer=ply \
 //thickness=0.18 //x=63.95 //y=0.93 //x2=63.835 //y2=0.93
r636 (  167 232 ) resistor r=5.52526 //w=0.168 //l=0.115 //layer=ply \
 //thickness=0.18 //x=64.17 //y=0.93 //x2=64.285 //y2=0.93
r637 (  167 168 ) resistor r=112.809 //w=0.094 //l=0.22 //layer=ply \
 //thickness=0.18 //x=64.17 //y=0.93 //x2=63.95 //y2=0.93
r638 (  166 228 ) resistor r=16.5046 //w=0.27 //l=0.135 //layer=ply \
 //thickness=0.18 //x=63.925 //y=4.97 //x2=63.79 //y2=4.97
r639 (  165 172 ) resistor r=26.9307 //w=0.15 //l=0.106066 //layer=ply \
 //thickness=0.18 //x=64.165 //y=4.97 //x2=64.24 //y2=5.045
r640 (  165 166 ) resistor r=123.064 //w=0.094 //l=0.24 //layer=ply \
 //thickness=0.18 //x=64.165 //y=4.97 //x2=63.925 //y2=4.97
r641 (  160 231 ) resistor r=39.5823 //w=0.21 //l=0.173853 //layer=ply \
 //thickness=0.18 //x=63.795 //y=1.74 //x2=63.835 //y2=1.585
r642 (  160 223 ) resistor r=182.032 //w=0.094 //l=0.355 //layer=ply \
 //thickness=0.18 //x=63.795 //y=1.74 //x2=63.795 //y2=2.095
r643 (  159 231 ) resistor r=39.5823 //w=0.21 //l=0.173853 //layer=ply \
 //thickness=0.18 //x=63.795 //y=1.43 //x2=63.835 //y2=1.585
r644 (  158 230 ) resistor r=45.1352 //w=0.168 //l=0.173853 //layer=ply \
 //thickness=0.18 //x=63.795 //y=1.085 //x2=63.835 //y2=0.93
r645 (  158 159 ) resistor r=176.904 //w=0.094 //l=0.345 //layer=ply \
 //thickness=0.18 //x=63.795 //y=1.085 //x2=63.795 //y2=1.43
r646 (  153 155 ) resistor r=26.9307 //w=0.15 //l=0.106066 //layer=ply \
 //thickness=0.18 //x=53.965 //y=4.97 //x2=54.04 //y2=5.045
r647 (  153 154 ) resistor r=148.702 //w=0.094 //l=0.29 //layer=ply \
 //thickness=0.18 //x=53.965 //y=4.97 //x2=53.675 //y2=4.97
r648 (  152 220 ) resistor r=45.1352 //w=0.168 //l=0.173853 //layer=ply \
 //thickness=0.18 //x=53.63 //y=1.4 //x2=53.59 //y2=1.555
r649 (  151 219 ) resistor r=45.1352 //w=0.168 //l=0.173853 //layer=ply \
 //thickness=0.18 //x=53.63 //y=1.055 //x2=53.59 //y2=0.9
r650 (  151 152 ) resistor r=176.904 //w=0.094 //l=0.345 //layer=ply \
 //thickness=0.18 //x=53.63 //y=1.055 //x2=53.63 //y2=1.4
r651 (  148 154 ) resistor r=22.7971 //w=0.269 //l=0.106066 //layer=ply \
 //thickness=0.18 //x=53.6 //y=5.045 //x2=53.675 //y2=4.97
r652 (  148 218 ) resistor r=35.8364 //w=0.269 //l=0.270185 //layer=ply \
 //thickness=0.18 //x=53.6 //y=5.045 //x2=53.4 //y2=4.88
r653 (  146 214 ) resistor r=10.701 //w=0.21 //l=0.115 //layer=ply \
 //thickness=0.18 //x=53.255 //y=1.555 //x2=53.14 //y2=1.555
r654 (  145 220 ) resistor r=5.52526 //w=0.168 //l=0.115 //layer=ply \
 //thickness=0.18 //x=53.475 //y=1.555 //x2=53.59 //y2=1.555
r655 (  144 213 ) resistor r=5.52526 //w=0.168 //l=0.115 //layer=ply \
 //thickness=0.18 //x=53.255 //y=0.9 //x2=53.14 //y2=0.9
r656 (  143 219 ) resistor r=5.52526 //w=0.168 //l=0.115 //layer=ply \
 //thickness=0.18 //x=53.475 //y=0.9 //x2=53.59 //y2=0.9
r657 (  143 144 ) resistor r=112.809 //w=0.094 //l=0.22 //layer=ply \
 //thickness=0.18 //x=53.475 //y=0.9 //x2=53.255 //y2=0.9
r658 (  142 216 ) resistor r=58.7805 //w=0.246 //l=0.373497 //layer=ply \
 //thickness=0.18 //x=53.1 //y=2.095 //x2=53.4 //y2=2.26
r659 (  141 214 ) resistor r=39.5823 //w=0.21 //l=0.173853 //layer=ply \
 //thickness=0.18 //x=53.1 //y=1.71 //x2=53.14 //y2=1.555
r660 (  141 142 ) resistor r=197.415 //w=0.094 //l=0.385 //layer=ply \
 //thickness=0.18 //x=53.1 //y=1.71 //x2=53.1 //y2=2.095
r661 (  140 214 ) resistor r=39.5823 //w=0.21 //l=0.173853 //layer=ply \
 //thickness=0.18 //x=53.1 //y=1.4 //x2=53.14 //y2=1.555
r662 (  139 213 ) resistor r=45.1352 //w=0.168 //l=0.173853 //layer=ply \
 //thickness=0.18 //x=53.1 //y=1.055 //x2=53.14 //y2=0.9
r663 (  139 140 ) resistor r=176.904 //w=0.094 //l=0.345 //layer=ply \
 //thickness=0.18 //x=53.1 //y=1.055 //x2=53.1 //y2=1.4
r664 (  138 208 ) resistor r=592.245 //w=0.094 //l=1.155 //layer=ply \
 //thickness=0.18 //x=77.19 //y=6.2 //x2=77.19 //y2=5.045
r665 (  137 251 ) resistor r=592.245 //w=0.094 //l=1.155 //layer=ply \
 //thickness=0.18 //x=76.75 //y=6.2 //x2=76.75 //y2=5.045
r666 (  136 191 ) resistor r=592.245 //w=0.094 //l=1.155 //layer=ply \
 //thickness=0.18 //x=76.31 //y=6.2 //x2=76.31 //y2=5.045
r667 (  135 181 ) resistor r=592.245 //w=0.094 //l=1.155 //layer=ply \
 //thickness=0.18 //x=75.87 //y=6.2 //x2=75.87 //y2=5.045
r668 (  134 172 ) resistor r=592.245 //w=0.094 //l=1.155 //layer=ply \
 //thickness=0.18 //x=64.24 //y=6.2 //x2=64.24 //y2=5.045
r669 (  133 229 ) resistor r=592.245 //w=0.094 //l=1.155 //layer=ply \
 //thickness=0.18 //x=63.8 //y=6.2 //x2=63.8 //y2=5.045
r670 (  132 155 ) resistor r=592.245 //w=0.094 //l=1.155 //layer=ply \
 //thickness=0.18 //x=54.04 //y=6.2 //x2=54.04 //y2=5.045
r671 (  131 148 ) resistor r=592.245 //w=0.094 //l=1.155 //layer=ply \
 //thickness=0.18 //x=53.6 //y=6.2 //x2=53.6 //y2=5.045
r672 (  130 205 ) resistor r=56.4043 //w=0.094 //l=0.11 //layer=ply \
 //thickness=0.18 //x=77.01 //y=1.585 //x2=77.12 //y2=1.585
r673 (  130 206 ) resistor r=56.4043 //w=0.094 //l=0.11 //layer=ply \
 //thickness=0.18 //x=77.01 //y=1.585 //x2=76.9 //y2=1.585
r674 (  129 186 ) resistor r=56.4043 //w=0.094 //l=0.11 //layer=ply \
 //thickness=0.18 //x=76.04 //y=1.545 //x2=76.15 //y2=1.545
r675 (  129 187 ) resistor r=56.4043 //w=0.094 //l=0.11 //layer=ply \
 //thickness=0.18 //x=76.04 //y=1.545 //x2=75.93 //y2=1.545
r676 (  128 169 ) resistor r=56.4043 //w=0.094 //l=0.11 //layer=ply \
 //thickness=0.18 //x=64.06 //y=1.585 //x2=64.17 //y2=1.585
r677 (  128 170 ) resistor r=56.4043 //w=0.094 //l=0.11 //layer=ply \
 //thickness=0.18 //x=64.06 //y=1.585 //x2=63.95 //y2=1.585
r678 (  127 145 ) resistor r=56.4043 //w=0.094 //l=0.11 //layer=ply \
 //thickness=0.18 //x=53.365 //y=1.555 //x2=53.475 //y2=1.555
r679 (  127 146 ) resistor r=56.4043 //w=0.094 //l=0.11 //layer=ply \
 //thickness=0.18 //x=53.365 //y=1.555 //x2=53.255 //y2=1.555
r680 (  126 248 ) resistor r=152 //w=0.17 //l=0.17 //layer=licon //count=1 \
 //x=76.74 //y=4.88 //x2=76.74 //y2=4.88
r681 (  120 226 ) resistor r=152 //w=0.17 //l=0.17 //layer=licon //count=1 \
 //x=63.79 //y=4.88 //x2=63.79 //y2=4.88
r682 (  115 244 ) resistor r=152 //w=0.17 //l=0.17 //layer=licon //count=1 \
 //x=76.71 //y=2.26 //x2=76.71 //y2=2.26
r683 (  115 118 ) resistor r=136.214 //w=0.187 //l=1.99 //layer=li \
 //thickness=0.1 //x=76.71 //y=2.26 //x2=76.71 //y2=4.25
r684 (  113 126 ) resistor r=11.4737 //w=0.186 //l=0.172337 //layer=li \
 //thickness=0.1 //x=76.71 //y=4.715 //x2=76.725 //y2=4.88
r685 (  113 118 ) resistor r=31.8289 //w=0.187 //l=0.465 //layer=li \
 //thickness=0.1 //x=76.71 //y=4.715 //x2=76.71 //y2=4.25
r686 (  111 240 ) resistor r=152 //w=0.17 //l=0.17 //layer=licon //count=1 \
 //x=75.97 //y=4.88 //x2=75.97 //y2=4.88
r687 (  109 111 ) resistor r=43.123 //w=0.187 //l=0.63 //layer=li \
 //thickness=0.1 //x=75.97 //y=4.25 //x2=75.97 //y2=4.88
r688 (  106 235 ) resistor r=152 //w=0.17 //l=0.17 //layer=licon //count=1 \
 //x=75.97 //y=2.26 //x2=75.97 //y2=2.26
r689 (  106 109 ) resistor r=136.214 //w=0.187 //l=1.99 //layer=li \
 //thickness=0.1 //x=75.97 //y=2.26 //x2=75.97 //y2=4.25
r690 (  102 104 ) resistor r=68.4492 //w=0.187 //l=1 //layer=li \
 //thickness=0.1 //x=74.12 //y=5.25 //x2=74.12 //y2=4.25
r691 (  101 104 ) resistor r=158.802 //w=0.187 //l=2.32 //layer=li \
 //thickness=0.1 //x=74.12 //y=1.93 //x2=74.12 //y2=4.25
r692 (  99 101 ) resistor r=7.15173 //w=0.17 //l=0.120208 //layer=li \
 //thickness=0.1 //x=74.035 //y=1.845 //x2=74.12 //y2=1.93
r693 (  99 100 ) resistor r=21.5615 //w=0.187 //l=0.315 //layer=li \
 //thickness=0.1 //x=74.035 //y=1.845 //x2=73.72 //y2=1.845
r694 (  95 100 ) resistor r=7.15173 //w=0.17 //l=0.120208 //layer=li \
 //thickness=0.1 //x=73.635 //y=1.76 //x2=73.72 //y2=1.845
r695 (  95 257 ) resistor r=39.016 //w=0.187 //l=0.57 //layer=li \
 //thickness=0.1 //x=73.635 //y=1.76 //x2=73.635 //y2=1.19
r696 (  94 124 ) resistor r=5.4201 //w=0.17 //l=0.085 //layer=li \
 //thickness=0.1 //x=73.425 //y=5.335 //x2=73.34 //y2=5.335
r697 (  93 102 ) resistor r=7.15173 //w=0.17 //l=0.120208 //layer=li \
 //thickness=0.1 //x=74.035 //y=5.335 //x2=74.12 //y2=5.25
r698 (  93 94 ) resistor r=41.754 //w=0.187 //l=0.61 //layer=li \
 //thickness=0.1 //x=74.035 //y=5.335 //x2=73.425 //y2=5.335
r699 (  87 124 ) resistor r=1.40859 //w=0.34 //l=0.085 //layer=li \
 //thickness=0.1 //x=73.34 //y=5.42 //x2=73.34 //y2=5.335
r700 (  87 265 ) resistor r=33.1979 //w=0.187 //l=0.485 //layer=li \
 //thickness=0.1 //x=73.34 //y=5.42 //x2=73.34 //y2=5.905
r701 (  86 123 ) resistor r=5.4201 //w=0.17 //l=0.085 //layer=li \
 //thickness=0.1 //x=72.545 //y=5.335 //x2=72.46 //y2=5.335
r702 (  85 124 ) resistor r=5.4201 //w=0.17 //l=0.085 //layer=li \
 //thickness=0.1 //x=73.255 //y=5.335 //x2=73.34 //y2=5.335
r703 (  85 86 ) resistor r=48.5989 //w=0.187 //l=0.71 //layer=li \
 //thickness=0.1 //x=73.255 //y=5.335 //x2=72.545 //y2=5.335
r704 (  79 123 ) resistor r=1.40859 //w=0.34 //l=0.085 //layer=li \
 //thickness=0.1 //x=72.46 //y=5.42 //x2=72.46 //y2=5.335
r705 (  79 264 ) resistor r=33.1979 //w=0.187 //l=0.485 //layer=li \
 //thickness=0.1 //x=72.46 //y=5.42 //x2=72.46 //y2=5.905
r706 (  77 123 ) resistor r=5.4201 //w=0.17 //l=0.085 //layer=li \
 //thickness=0.1 //x=72.375 //y=5.335 //x2=72.46 //y2=5.335
r707 (  77 78 ) resistor r=48.5989 //w=0.187 //l=0.71 //layer=li \
 //thickness=0.1 //x=72.375 //y=5.335 //x2=71.665 //y2=5.335
r708 (  71 78 ) resistor r=7.15173 //w=0.17 //l=0.120208 //layer=li \
 //thickness=0.1 //x=71.58 //y=5.42 //x2=71.665 //y2=5.335
r709 (  71 263 ) resistor r=33.1979 //w=0.187 //l=0.485 //layer=li \
 //thickness=0.1 //x=71.58 //y=5.42 //x2=71.58 //y2=5.905
r710 (  68 70 ) resistor r=68.4492 //w=0.187 //l=1 //layer=li //thickness=0.1 \
 //x=69.31 //y=5.25 //x2=69.31 //y2=4.25
r711 (  67 70 ) resistor r=158.802 //w=0.187 //l=2.32 //layer=li \
 //thickness=0.1 //x=69.31 //y=1.93 //x2=69.31 //y2=4.25
r712 (  65 67 ) resistor r=7.15173 //w=0.17 //l=0.120208 //layer=li \
 //thickness=0.1 //x=69.225 //y=1.845 //x2=69.31 //y2=1.93
r713 (  65 66 ) resistor r=21.5615 //w=0.187 //l=0.315 //layer=li \
 //thickness=0.1 //x=69.225 //y=1.845 //x2=68.91 //y2=1.845
r714 (  61 66 ) resistor r=7.15173 //w=0.17 //l=0.120208 //layer=li \
 //thickness=0.1 //x=68.825 //y=1.76 //x2=68.91 //y2=1.845
r715 (  61 256 ) resistor r=39.016 //w=0.187 //l=0.57 //layer=li \
 //thickness=0.1 //x=68.825 //y=1.76 //x2=68.825 //y2=1.19
r716 (  60 122 ) resistor r=5.4201 //w=0.17 //l=0.085 //layer=li \
 //thickness=0.1 //x=68.615 //y=5.335 //x2=68.53 //y2=5.335
r717 (  59 68 ) resistor r=7.15173 //w=0.17 //l=0.120208 //layer=li \
 //thickness=0.1 //x=69.225 //y=5.335 //x2=69.31 //y2=5.25
r718 (  59 60 ) resistor r=41.754 //w=0.187 //l=0.61 //layer=li \
 //thickness=0.1 //x=69.225 //y=5.335 //x2=68.615 //y2=5.335
r719 (  53 122 ) resistor r=1.40859 //w=0.34 //l=0.085 //layer=li \
 //thickness=0.1 //x=68.53 //y=5.42 //x2=68.53 //y2=5.335
r720 (  53 262 ) resistor r=33.1979 //w=0.187 //l=0.485 //layer=li \
 //thickness=0.1 //x=68.53 //y=5.42 //x2=68.53 //y2=5.905
r721 (  52 121 ) resistor r=5.4201 //w=0.17 //l=0.085 //layer=li \
 //thickness=0.1 //x=67.735 //y=5.335 //x2=67.65 //y2=5.335
r722 (  51 122 ) resistor r=5.4201 //w=0.17 //l=0.085 //layer=li \
 //thickness=0.1 //x=68.445 //y=5.335 //x2=68.53 //y2=5.335
r723 (  51 52 ) resistor r=48.5989 //w=0.187 //l=0.71 //layer=li \
 //thickness=0.1 //x=68.445 //y=5.335 //x2=67.735 //y2=5.335
r724 (  45 121 ) resistor r=1.40859 //w=0.34 //l=0.085 //layer=li \
 //thickness=0.1 //x=67.65 //y=5.42 //x2=67.65 //y2=5.335
r725 (  45 261 ) resistor r=33.1979 //w=0.187 //l=0.485 //layer=li \
 //thickness=0.1 //x=67.65 //y=5.42 //x2=67.65 //y2=5.905
r726 (  43 121 ) resistor r=5.4201 //w=0.17 //l=0.085 //layer=li \
 //thickness=0.1 //x=67.565 //y=5.335 //x2=67.65 //y2=5.335
r727 (  43 44 ) resistor r=48.5989 //w=0.187 //l=0.71 //layer=li \
 //thickness=0.1 //x=67.565 //y=5.335 //x2=66.855 //y2=5.335
r728 (  37 44 ) resistor r=7.15173 //w=0.17 //l=0.120208 //layer=li \
 //thickness=0.1 //x=66.77 //y=5.42 //x2=66.855 //y2=5.335
r729 (  37 260 ) resistor r=33.1979 //w=0.187 //l=0.485 //layer=li \
 //thickness=0.1 //x=66.77 //y=5.42 //x2=66.77 //y2=5.905
r730 (  33 222 ) resistor r=152 //w=0.17 //l=0.17 //layer=licon //count=1 \
 //x=63.76 //y=2.26 //x2=63.76 //y2=2.26
r731 (  33 36 ) resistor r=136.214 //w=0.187 //l=1.99 //layer=li \
 //thickness=0.1 //x=63.76 //y=2.26 //x2=63.76 //y2=4.25
r732 (  31 120 ) resistor r=11.4737 //w=0.186 //l=0.172337 //layer=li \
 //thickness=0.1 //x=63.76 //y=4.715 //x2=63.775 //y2=4.88
r733 (  31 36 ) resistor r=31.8289 //w=0.187 //l=0.465 //layer=li \
 //thickness=0.1 //x=63.76 //y=4.715 //x2=63.76 //y2=4.25
r734 (  29 218 ) resistor r=152 //w=0.17 //l=0.17 //layer=licon //count=1 \
 //x=53.4 //y=4.88 //x2=53.4 //y2=4.88
r735 (  27 29 ) resistor r=43.123 //w=0.187 //l=0.63 //layer=li \
 //thickness=0.1 //x=53.4 //y=4.25 //x2=53.4 //y2=4.88
r736 (  24 216 ) resistor r=152 //w=0.17 //l=0.17 //layer=licon //count=1 \
 //x=53.4 //y=2.26 //x2=53.4 //y2=2.26
r737 (  24 27 ) resistor r=136.214 //w=0.187 //l=1.99 //layer=li \
 //thickness=0.1 //x=53.4 //y=2.26 //x2=53.4 //y2=4.25
r738 (  22 118 ) resistor r=9.3 //w=0.17 //l=0.17 //layer=mcon //count=1 \
 //x=76.71 //y=4.25 //x2=76.71 //y2=4.25
r739 (  20 109 ) resistor r=9.3 //w=0.17 //l=0.17 //layer=mcon //count=1 \
 //x=75.97 //y=4.25 //x2=75.97 //y2=4.25
r740 (  18 104 ) resistor r=9.3 //w=0.17 //l=0.17 //layer=mcon //count=1 \
 //x=74.12 //y=4.25 //x2=74.12 //y2=4.25
r741 (  16 70 ) resistor r=9.3 //w=0.17 //l=0.17 //layer=mcon //count=1 \
 //x=69.31 //y=4.25 //x2=69.31 //y2=4.25
r742 (  14 36 ) resistor r=9.3 //w=0.17 //l=0.17 //layer=mcon //count=1 \
 //x=63.76 //y=4.25 //x2=63.76 //y2=4.25
r743 (  12 27 ) resistor r=9.3 //w=0.17 //l=0.17 //layer=mcon //count=1 \
 //x=53.4 //y=4.25 //x2=53.4 //y2=4.25
r744 (  10 20 ) resistor r=0.0880901 //w=0.191 //l=0.115 //layer=m1 \
 //thickness=0.36 //x=76.085 //y=4.25 //x2=75.97 //y2=4.25
r745 (  9 22 ) resistor r=0.0717383 //w=0.224 //l=0.115 //layer=m1 \
 //thickness=0.36 //x=76.595 //y=4.25 //x2=76.71 //y2=4.25
r746 (  9 10 ) resistor r=0.486641 //w=0.131 //l=0.51 //layer=m1 \
 //thickness=0.36 //x=76.595 //y=4.25 //x2=76.085 //y2=4.25
r747 (  8 18 ) resistor r=0.0880901 //w=0.191 //l=0.115 //layer=m1 \
 //thickness=0.36 //x=74.235 //y=4.25 //x2=74.12 //y2=4.25
r748 (  7 20 ) resistor r=0.0880901 //w=0.191 //l=0.115 //layer=m1 \
 //thickness=0.36 //x=75.855 //y=4.25 //x2=75.97 //y2=4.25
r749 (  7 8 ) resistor r=1.5458 //w=0.131 //l=1.62 //layer=m1 //thickness=0.36 \
 //x=75.855 //y=4.25 //x2=74.235 //y2=4.25
r750 (  6 16 ) resistor r=0.0880901 //w=0.191 //l=0.115 //layer=m1 \
 //thickness=0.36 //x=69.425 //y=4.25 //x2=69.31 //y2=4.25
r751 (  5 18 ) resistor r=0.0880901 //w=0.191 //l=0.115 //layer=m1 \
 //thickness=0.36 //x=74.005 //y=4.25 //x2=74.12 //y2=4.25
r752 (  5 6 ) resistor r=4.37023 //w=0.131 //l=4.58 //layer=m1 \
 //thickness=0.36 //x=74.005 //y=4.25 //x2=69.425 //y2=4.25
r753 (  4 14 ) resistor r=0.0880901 //w=0.191 //l=0.115 //layer=m1 \
 //thickness=0.36 //x=63.875 //y=4.25 //x2=63.76 //y2=4.25
r754 (  3 16 ) resistor r=0.0880901 //w=0.191 //l=0.115 //layer=m1 \
 //thickness=0.36 //x=69.195 //y=4.25 //x2=69.31 //y2=4.25
r755 (  3 4 ) resistor r=5.07634 //w=0.131 //l=5.32 //layer=m1 \
 //thickness=0.36 //x=69.195 //y=4.25 //x2=63.875 //y2=4.25
r756 (  2 12 ) resistor r=0.0717383 //w=0.224 //l=0.115 //layer=m1 \
 //thickness=0.36 //x=53.515 //y=4.25 //x2=53.4 //y2=4.25
r757 (  1 14 ) resistor r=0.0880901 //w=0.191 //l=0.115 //layer=m1 \
 //thickness=0.36 //x=63.645 //y=4.25 //x2=63.76 //y2=4.25
r758 (  1 2 ) resistor r=9.66603 //w=0.131 //l=10.13 //layer=m1 \
 //thickness=0.36 //x=63.645 //y=4.25 //x2=53.515 //y2=4.25
ends PM_TMRDFFRNQX1\%noxref_16

subckt PM_TMRDFFRNQX1\%noxref_17 ( 1 2 3 4 5 6 7 8 9 10 11 12 13 14 15 16 38 \
 51 52 63 65 66 70 72 85 86 93 101 107 108 112 114 127 128 139 141 142 146 148 \
 156 166 173 174 175 176 177 178 179 180 181 182 183 184 185 186 187 188 189 \
 190 191 192 193 194 198 199 200 205 207 210 211 215 216 217 222 224 227 228 \
 229 230 231 232 236 238 241 242 246 247 248 249 250 252 258 259 260 261 265 \
 266 267 268 272 274 277 278 279 280 284 285 286 287 291 293 299 300 302 303 \
 308 312 313 318 327 339 352 355 356 357 361 362 363 364 365 366 367 )
c763 ( 367 0 ) capacitor c=0.0220291f //x=63.875 //y=5.2
c764 ( 366 0 ) capacitor c=0.0217503f //x=62.995 //y=5.2
c765 ( 365 0 ) capacitor c=0.023087f //x=60.245 //y=5.2
c766 ( 364 0 ) capacitor c=0.023519f //x=59.365 //y=5.2
c767 ( 363 0 ) capacitor c=0.0224735f //x=58.485 //y=5.2
c768 ( 362 0 ) capacitor c=0.0220291f //x=50.925 //y=5.2
c769 ( 361 0 ) capacitor c=0.0217503f //x=50.045 //y=5.2
c770 ( 357 0 ) capacitor c=0.0084702f //x=63.87 //y=1.085
c771 ( 356 0 ) capacitor c=0.00872971f //x=60.495 //y=1.095
c772 ( 355 0 ) capacitor c=0.0084702f //x=50.92 //y=1.085
c773 ( 352 0 ) capacitor c=0.0655948f //x=82.63 //y=4.885
c774 ( 339 0 ) capacitor c=0.0545009f //x=78.93 //y=2.26
c775 ( 327 0 ) capacitor c=0.0588816f //x=63.02 //y=4.88
c776 ( 318 0 ) capacitor c=0.058931f //x=55.62 //y=4.88
c777 ( 313 0 ) capacitor c=0.0273931f //x=55.62 //y=2.095
c778 ( 312 0 ) capacitor c=0.0456313f //x=55.62 //y=2.26
c779 ( 308 0 ) capacitor c=0.0587755f //x=47.48 //y=4.88
c780 ( 303 0 ) capacitor c=0.0273931f //x=47.48 //y=2.095
c781 ( 302 0 ) capacitor c=0.0456313f //x=47.48 //y=2.26
c782 ( 300 0 ) capacitor c=0.0342409f //x=82.965 //y=1.39
c783 ( 299 0 ) capacitor c=0.0187384f //x=82.965 //y=1.045
c784 ( 293 0 ) capacitor c=0.0141797f //x=82.81 //y=1.545
c785 ( 291 0 ) capacitor c=0.0149844f //x=82.81 //y=0.89
c786 ( 287 0 ) capacitor c=0.0979048f //x=82.435 //y=2.095
c787 ( 286 0 ) capacitor c=0.0225105f //x=82.435 //y=1.7
c788 ( 285 0 ) capacitor c=0.0234376f //x=82.435 //y=1.39
c789 ( 284 0 ) capacitor c=0.0199343f //x=82.435 //y=1.045
c790 ( 280 0 ) capacitor c=0.0318948f //x=79.635 //y=1.39
c791 ( 279 0 ) capacitor c=0.0187384f //x=79.635 //y=1.045
c792 ( 278 0 ) capacitor c=0.0606536f //x=79.275 //y=4.975
c793 ( 277 0 ) capacitor c=0.0292043f //x=79.565 //y=4.975
c794 ( 274 0 ) capacitor c=0.0157913f //x=79.48 //y=1.545
c795 ( 272 0 ) capacitor c=0.0149844f //x=79.48 //y=0.89
c796 ( 268 0 ) capacitor c=0.0302441f //x=79.105 //y=2.095
c797 ( 267 0 ) capacitor c=0.0238107f //x=79.105 //y=1.7
c798 ( 266 0 ) capacitor c=0.0234352f //x=79.105 //y=1.39
c799 ( 265 0 ) capacitor c=0.0199931f //x=79.105 //y=1.045
c800 ( 261 0 ) capacitor c=0.0556143f //x=66.625 //y=4.97
c801 ( 260 0 ) capacitor c=0.0293157f //x=66.915 //y=4.97
c802 ( 259 0 ) capacitor c=0.0347816f //x=66.58 //y=1.4
c803 ( 258 0 ) capacitor c=0.0187487f //x=66.58 //y=1.055
c804 ( 252 0 ) capacitor c=0.0137055f //x=66.425 //y=1.555
c805 ( 250 0 ) capacitor c=0.0149861f //x=66.425 //y=0.9
c806 ( 249 0 ) capacitor c=0.096037f //x=66.05 //y=2.095
c807 ( 248 0 ) capacitor c=0.0228993f //x=66.05 //y=1.71
c808 ( 247 0 ) capacitor c=0.0234352f //x=66.05 //y=1.4
c809 ( 246 0 ) capacitor c=0.0198724f //x=66.05 //y=1.055
c810 ( 242 0 ) capacitor c=0.0318948f //x=63.355 //y=1.39
c811 ( 241 0 ) capacitor c=0.0187384f //x=63.355 //y=1.045
c812 ( 238 0 ) capacitor c=0.0141798f //x=63.2 //y=1.545
c813 ( 236 0 ) capacitor c=0.0149844f //x=63.2 //y=0.89
c814 ( 232 0 ) capacitor c=0.0813322f //x=62.825 //y=2.095
c815 ( 231 0 ) capacitor c=0.0229267f //x=62.825 //y=1.7
c816 ( 230 0 ) capacitor c=0.0234352f //x=62.825 //y=1.39
c817 ( 229 0 ) capacitor c=0.0199343f //x=62.825 //y=1.045
c818 ( 228 0 ) capacitor c=0.0432517f //x=56.14 //y=1.44
c819 ( 227 0 ) capacitor c=0.0200379f //x=56.14 //y=1.095
c820 ( 224 0 ) capacitor c=0.0148873f //x=55.985 //y=1.595
c821 ( 222 0 ) capacitor c=0.0157803f //x=55.985 //y=0.94
c822 ( 217 0 ) capacitor c=0.0218028f //x=55.61 //y=1.75
c823 ( 216 0 ) capacitor c=0.0207459f //x=55.61 //y=1.44
c824 ( 215 0 ) capacitor c=0.0194308f //x=55.61 //y=1.095
c825 ( 211 0 ) capacitor c=0.0432517f //x=48 //y=1.44
c826 ( 210 0 ) capacitor c=0.0200379f //x=48 //y=1.095
c827 ( 207 0 ) capacitor c=0.0148873f //x=47.845 //y=1.595
c828 ( 205 0 ) capacitor c=0.0157803f //x=47.845 //y=0.94
c829 ( 200 0 ) capacitor c=0.0218028f //x=47.47 //y=1.75
c830 ( 199 0 ) capacitor c=0.0207459f //x=47.47 //y=1.44
c831 ( 198 0 ) capacitor c=0.0194308f //x=47.47 //y=1.095
c832 ( 194 0 ) capacitor c=0.110336f //x=82.96 //y=6.205
c833 ( 193 0 ) capacitor c=0.154049f //x=82.52 //y=6.205
c834 ( 192 0 ) capacitor c=0.110003f //x=79.64 //y=6.205
c835 ( 191 0 ) capacitor c=0.15424f //x=79.2 //y=6.205
c836 ( 190 0 ) capacitor c=0.110114f //x=66.99 //y=6.2
c837 ( 189 0 ) capacitor c=0.158956f //x=66.55 //y=6.2
c838 ( 188 0 ) capacitor c=0.110275f //x=63.36 //y=6.2
c839 ( 187 0 ) capacitor c=0.154305f //x=62.92 //y=6.2
c840 ( 186 0 ) capacitor c=0.158794f //x=55.8 //y=6.2
c841 ( 185 0 ) capacitor c=0.110114f //x=55.36 //y=6.2
c842 ( 184 0 ) capacitor c=0.158794f //x=47.66 //y=6.2
c843 ( 183 0 ) capacitor c=0.110114f //x=47.22 //y=6.2
c844 ( 176 0 ) capacitor c=0.00211606f //x=64.02 //y=5.38
c845 ( 175 0 ) capacitor c=0.00106608f //x=60.39 //y=5.335
c846 ( 174 0 ) capacitor c=0.00207319f //x=59.51 //y=5.335
c847 ( 173 0 ) capacitor c=0.00211606f //x=51.07 //y=5.38
c848 ( 166 0 ) capacitor c=0.117496f //x=82.63 //y=2.26
c849 ( 156 0 ) capacitor c=0.0945553f //x=78.93 //y=2.26
c850 ( 148 0 ) capacitor c=0.096212f //x=66.35 //y=2.26
c851 ( 146 0 ) capacitor c=0.104337f //x=64.5 //y=3.51
c852 ( 142 0 ) capacitor c=0.00404073f //x=64.145 //y=1.835
c853 ( 141 0 ) capacitor c=0.0122201f //x=64.415 //y=1.835
c854 ( 139 0 ) capacitor c=0.0137995f //x=64.415 //y=5.38
c855 ( 128 0 ) capacitor c=0.00249378f //x=63.225 //y=5.38
c856 ( 127 0 ) capacitor c=0.0143649f //x=63.935 //y=5.38
c857 ( 114 0 ) capacitor c=0.0860657f //x=63.02 //y=2.26
c858 ( 112 0 ) capacitor c=0.105397f //x=61.17 //y=3.51
c859 ( 108 0 ) capacitor c=0.00398962f //x=60.77 //y=1.845
c860 ( 107 0 ) capacitor c=0.0137288f //x=61.085 //y=1.845
c861 ( 101 0 ) capacitor c=0.0284518f //x=61.085 //y=5.335
c862 ( 93 0 ) capacitor c=0.0176454f //x=60.305 //y=5.335
c863 ( 86 0 ) capacitor c=0.00332903f //x=58.715 //y=5.335
c864 ( 85 0 ) capacitor c=0.0148427f //x=59.425 //y=5.335
c865 ( 72 0 ) capacitor c=0.081384f //x=55.62 //y=2.26
c866 ( 70 0 ) capacitor c=0.106559f //x=51.55 //y=3.51
c867 ( 66 0 ) capacitor c=0.00404073f //x=51.195 //y=1.835
c868 ( 65 0 ) capacitor c=0.0122201f //x=51.465 //y=1.835
c869 ( 63 0 ) capacitor c=0.0137995f //x=51.465 //y=5.38
c870 ( 52 0 ) capacitor c=0.00251635f //x=50.275 //y=5.38
c871 ( 51 0 ) capacitor c=0.0143649f //x=50.985 //y=5.38
c872 ( 38 0 ) capacitor c=0.0811555f //x=47.48 //y=2.26
c873 ( 16 0 ) capacitor c=0.0152968f //x=79.045 //y=4.62
c874 ( 15 0 ) capacitor c=0.0828557f //x=82.515 //y=4.62
c875 ( 14 0 ) capacitor c=0.004304f //x=66.465 //y=3.51
c876 ( 13 0 ) capacitor c=0.195727f //x=78.815 //y=3.51
c877 ( 12 0 ) capacitor c=0.00246264f //x=64.615 //y=3.51
c878 ( 11 0 ) capacitor c=0.0280612f //x=66.235 //y=3.51
c879 ( 10 0 ) capacitor c=0.00253051f //x=63.135 //y=3.51
c880 ( 9 0 ) capacitor c=0.0166351f //x=64.385 //y=3.51
c881 ( 8 0 ) capacitor c=0.00424937f //x=61.285 //y=3.51
c882 ( 7 0 ) capacitor c=0.0279453f //x=62.905 //y=3.51
c883 ( 6 0 ) capacitor c=0.00458481f //x=55.735 //y=3.51
c884 ( 5 0 ) capacitor c=0.077708f //x=61.055 //y=3.51
c885 ( 4 0 ) capacitor c=0.00376077f //x=51.665 //y=3.51
c886 ( 3 0 ) capacitor c=0.0767635f //x=55.505 //y=3.51
c887 ( 2 0 ) capacitor c=0.0127233f //x=47.595 //y=3.51
c888 ( 1 0 ) capacitor c=0.060553f //x=51.435 //y=3.51
r889 (  350 352 ) resistor r=22.7554 //w=0.233 //l=0.11 //layer=ply \
 //thickness=0.18 //x=82.52 //y=4.885 //x2=82.63 //y2=4.885
r890 (  325 327 ) resistor r=20.6867 //w=0.233 //l=0.1 //layer=ply \
 //thickness=0.18 //x=62.92 //y=4.88 //x2=63.02 //y2=4.88
r891 (  312 313 ) resistor r=52.7279 //w=0.214 //l=0.165 //layer=ply \
 //thickness=0.18 //x=55.62 //y=2.26 //x2=55.62 //y2=2.095
r892 (  302 303 ) resistor r=52.7279 //w=0.214 //l=0.165 //layer=ply \
 //thickness=0.18 //x=47.48 //y=2.26 //x2=47.48 //y2=2.095
r893 (  300 354 ) resistor r=45.1352 //w=0.168 //l=0.173853 //layer=ply \
 //thickness=0.18 //x=82.965 //y=1.39 //x2=82.925 //y2=1.545
r894 (  299 353 ) resistor r=45.1352 //w=0.168 //l=0.173853 //layer=ply \
 //thickness=0.18 //x=82.965 //y=1.045 //x2=82.925 //y2=0.89
r895 (  299 300 ) resistor r=176.904 //w=0.094 //l=0.345 //layer=ply \
 //thickness=0.18 //x=82.965 //y=1.045 //x2=82.965 //y2=1.39
r896 (  296 352 ) resistor r=68.2661 //w=0.233 //l=0.404166 //layer=ply \
 //thickness=0.18 //x=82.96 //y=5.05 //x2=82.63 //y2=4.885
r897 (  294 349 ) resistor r=10.701 //w=0.21 //l=0.115 //layer=ply \
 //thickness=0.18 //x=82.59 //y=1.545 //x2=82.475 //y2=1.545
r898 (  293 354 ) resistor r=5.52526 //w=0.168 //l=0.115 //layer=ply \
 //thickness=0.18 //x=82.81 //y=1.545 //x2=82.925 //y2=1.545
r899 (  292 348 ) resistor r=5.52526 //w=0.168 //l=0.115 //layer=ply \
 //thickness=0.18 //x=82.59 //y=0.89 //x2=82.475 //y2=0.89
r900 (  291 353 ) resistor r=5.52526 //w=0.168 //l=0.115 //layer=ply \
 //thickness=0.18 //x=82.81 //y=0.89 //x2=82.925 //y2=0.89
r901 (  291 292 ) resistor r=112.809 //w=0.094 //l=0.22 //layer=ply \
 //thickness=0.18 //x=82.81 //y=0.89 //x2=82.59 //y2=0.89
r902 (  288 350 ) resistor r=13.0941 //w=0.233 //l=0.165 //layer=ply \
 //thickness=0.18 //x=82.52 //y=5.05 //x2=82.52 //y2=4.885
r903 (  287 347 ) resistor r=34.8111 //w=0.27 //l=0.264953 //layer=ply \
 //thickness=0.18 //x=82.435 //y=2.095 //x2=82.63 //y2=2.26
r904 (  286 349 ) resistor r=39.5823 //w=0.21 //l=0.173853 //layer=ply \
 //thickness=0.18 //x=82.435 //y=1.7 //x2=82.475 //y2=1.545
r905 (  286 287 ) resistor r=202.543 //w=0.094 //l=0.395 //layer=ply \
 //thickness=0.18 //x=82.435 //y=1.7 //x2=82.435 //y2=2.095
r906 (  285 349 ) resistor r=39.5823 //w=0.21 //l=0.173853 //layer=ply \
 //thickness=0.18 //x=82.435 //y=1.39 //x2=82.475 //y2=1.545
r907 (  284 348 ) resistor r=45.1352 //w=0.168 //l=0.173853 //layer=ply \
 //thickness=0.18 //x=82.435 //y=1.045 //x2=82.475 //y2=0.89
r908 (  284 285 ) resistor r=176.904 //w=0.094 //l=0.345 //layer=ply \
 //thickness=0.18 //x=82.435 //y=1.045 //x2=82.435 //y2=1.39
r909 (  280 345 ) resistor r=45.1352 //w=0.168 //l=0.173853 //layer=ply \
 //thickness=0.18 //x=79.635 //y=1.39 //x2=79.595 //y2=1.545
r910 (  279 344 ) resistor r=45.1352 //w=0.168 //l=0.173853 //layer=ply \
 //thickness=0.18 //x=79.635 //y=1.045 //x2=79.595 //y2=0.89
r911 (  279 280 ) resistor r=176.904 //w=0.094 //l=0.345 //layer=ply \
 //thickness=0.18 //x=79.635 //y=1.045 //x2=79.635 //y2=1.39
r912 (  277 281 ) resistor r=26.9307 //w=0.15 //l=0.106066 //layer=ply \
 //thickness=0.18 //x=79.565 //y=4.975 //x2=79.64 //y2=5.05
r913 (  277 278 ) resistor r=148.702 //w=0.094 //l=0.29 //layer=ply \
 //thickness=0.18 //x=79.565 //y=4.975 //x2=79.275 //y2=4.975
r914 (  275 343 ) resistor r=10.701 //w=0.21 //l=0.115 //layer=ply \
 //thickness=0.18 //x=79.26 //y=1.545 //x2=79.145 //y2=1.545
r915 (  274 345 ) resistor r=5.52526 //w=0.168 //l=0.115 //layer=ply \
 //thickness=0.18 //x=79.48 //y=1.545 //x2=79.595 //y2=1.545
r916 (  273 342 ) resistor r=5.52526 //w=0.168 //l=0.115 //layer=ply \
 //thickness=0.18 //x=79.26 //y=0.89 //x2=79.145 //y2=0.89
r917 (  272 344 ) resistor r=5.52526 //w=0.168 //l=0.115 //layer=ply \
 //thickness=0.18 //x=79.48 //y=0.89 //x2=79.595 //y2=0.89
r918 (  272 273 ) resistor r=112.809 //w=0.094 //l=0.22 //layer=ply \
 //thickness=0.18 //x=79.48 //y=0.89 //x2=79.26 //y2=0.89
r919 (  269 278 ) resistor r=22.1787 //w=0.252 //l=0.106066 //layer=ply \
 //thickness=0.18 //x=79.2 //y=5.05 //x2=79.275 //y2=4.975
r920 (  269 341 ) resistor r=51.6429 //w=0.252 //l=0.34271 //layer=ply \
 //thickness=0.18 //x=79.2 //y=5.05 //x2=78.93 //y2=4.885
r921 (  268 339 ) resistor r=30.4513 //w=0.277 //l=0.243926 //layer=ply \
 //thickness=0.18 //x=79.105 //y=2.095 //x2=78.93 //y2=2.26
r922 (  267 343 ) resistor r=39.5823 //w=0.21 //l=0.173853 //layer=ply \
 //thickness=0.18 //x=79.105 //y=1.7 //x2=79.145 //y2=1.545
r923 (  267 268 ) resistor r=202.543 //w=0.094 //l=0.395 //layer=ply \
 //thickness=0.18 //x=79.105 //y=1.7 //x2=79.105 //y2=2.095
r924 (  266 343 ) resistor r=39.5823 //w=0.21 //l=0.173853 //layer=ply \
 //thickness=0.18 //x=79.105 //y=1.39 //x2=79.145 //y2=1.545
r925 (  265 342 ) resistor r=45.1352 //w=0.168 //l=0.173853 //layer=ply \
 //thickness=0.18 //x=79.105 //y=1.045 //x2=79.145 //y2=0.89
r926 (  265 266 ) resistor r=176.904 //w=0.094 //l=0.345 //layer=ply \
 //thickness=0.18 //x=79.105 //y=1.045 //x2=79.105 //y2=1.39
r927 (  260 262 ) resistor r=26.9307 //w=0.15 //l=0.106066 //layer=ply \
 //thickness=0.18 //x=66.915 //y=4.97 //x2=66.99 //y2=5.045
r928 (  260 261 ) resistor r=148.702 //w=0.094 //l=0.29 //layer=ply \
 //thickness=0.18 //x=66.915 //y=4.97 //x2=66.625 //y2=4.97
r929 (  259 337 ) resistor r=45.1352 //w=0.168 //l=0.173853 //layer=ply \
 //thickness=0.18 //x=66.58 //y=1.4 //x2=66.54 //y2=1.555
r930 (  258 336 ) resistor r=45.1352 //w=0.168 //l=0.173853 //layer=ply \
 //thickness=0.18 //x=66.58 //y=1.055 //x2=66.54 //y2=0.9
r931 (  258 259 ) resistor r=176.904 //w=0.094 //l=0.345 //layer=ply \
 //thickness=0.18 //x=66.58 //y=1.055 //x2=66.58 //y2=1.4
r932 (  255 261 ) resistor r=22.7971 //w=0.269 //l=0.106066 //layer=ply \
 //thickness=0.18 //x=66.55 //y=5.045 //x2=66.625 //y2=4.97
r933 (  255 335 ) resistor r=35.8364 //w=0.269 //l=0.270185 //layer=ply \
 //thickness=0.18 //x=66.55 //y=5.045 //x2=66.35 //y2=4.88
r934 (  253 331 ) resistor r=10.701 //w=0.21 //l=0.115 //layer=ply \
 //thickness=0.18 //x=66.205 //y=1.555 //x2=66.09 //y2=1.555
r935 (  252 337 ) resistor r=5.52526 //w=0.168 //l=0.115 //layer=ply \
 //thickness=0.18 //x=66.425 //y=1.555 //x2=66.54 //y2=1.555
r936 (  251 330 ) resistor r=5.52526 //w=0.168 //l=0.115 //layer=ply \
 //thickness=0.18 //x=66.205 //y=0.9 //x2=66.09 //y2=0.9
r937 (  250 336 ) resistor r=5.52526 //w=0.168 //l=0.115 //layer=ply \
 //thickness=0.18 //x=66.425 //y=0.9 //x2=66.54 //y2=0.9
r938 (  250 251 ) resistor r=112.809 //w=0.094 //l=0.22 //layer=ply \
 //thickness=0.18 //x=66.425 //y=0.9 //x2=66.205 //y2=0.9
r939 (  249 333 ) resistor r=58.7805 //w=0.246 //l=0.373497 //layer=ply \
 //thickness=0.18 //x=66.05 //y=2.095 //x2=66.35 //y2=2.26
r940 (  248 331 ) resistor r=39.5823 //w=0.21 //l=0.173853 //layer=ply \
 //thickness=0.18 //x=66.05 //y=1.71 //x2=66.09 //y2=1.555
r941 (  248 249 ) resistor r=197.415 //w=0.094 //l=0.385 //layer=ply \
 //thickness=0.18 //x=66.05 //y=1.71 //x2=66.05 //y2=2.095
r942 (  247 331 ) resistor r=39.5823 //w=0.21 //l=0.173853 //layer=ply \
 //thickness=0.18 //x=66.05 //y=1.4 //x2=66.09 //y2=1.555
r943 (  246 330 ) resistor r=45.1352 //w=0.168 //l=0.173853 //layer=ply \
 //thickness=0.18 //x=66.05 //y=1.055 //x2=66.09 //y2=0.9
r944 (  246 247 ) resistor r=176.904 //w=0.094 //l=0.345 //layer=ply \
 //thickness=0.18 //x=66.05 //y=1.055 //x2=66.05 //y2=1.4
r945 (  243 327 ) resistor r=70.3348 //w=0.233 //l=0.414367 //layer=ply \
 //thickness=0.18 //x=63.36 //y=5.045 //x2=63.02 //y2=4.88
r946 (  242 329 ) resistor r=45.1352 //w=0.168 //l=0.173853 //layer=ply \
 //thickness=0.18 //x=63.355 //y=1.39 //x2=63.315 //y2=1.545
r947 (  241 328 ) resistor r=45.1352 //w=0.168 //l=0.173853 //layer=ply \
 //thickness=0.18 //x=63.355 //y=1.045 //x2=63.315 //y2=0.89
r948 (  241 242 ) resistor r=176.904 //w=0.094 //l=0.345 //layer=ply \
 //thickness=0.18 //x=63.355 //y=1.045 //x2=63.355 //y2=1.39
r949 (  239 324 ) resistor r=10.701 //w=0.21 //l=0.115 //layer=ply \
 //thickness=0.18 //x=62.98 //y=1.545 //x2=62.865 //y2=1.545
r950 (  238 329 ) resistor r=5.52526 //w=0.168 //l=0.115 //layer=ply \
 //thickness=0.18 //x=63.2 //y=1.545 //x2=63.315 //y2=1.545
r951 (  237 323 ) resistor r=5.52526 //w=0.168 //l=0.115 //layer=ply \
 //thickness=0.18 //x=62.98 //y=0.89 //x2=62.865 //y2=0.89
r952 (  236 328 ) resistor r=5.52526 //w=0.168 //l=0.115 //layer=ply \
 //thickness=0.18 //x=63.2 //y=0.89 //x2=63.315 //y2=0.89
r953 (  236 237 ) resistor r=112.809 //w=0.094 //l=0.22 //layer=ply \
 //thickness=0.18 //x=63.2 //y=0.89 //x2=62.98 //y2=0.89
r954 (  233 325 ) resistor r=13.0941 //w=0.233 //l=0.165 //layer=ply \
 //thickness=0.18 //x=62.92 //y=5.045 //x2=62.92 //y2=4.88
r955 (  232 322 ) resistor r=34.8111 //w=0.27 //l=0.264953 //layer=ply \
 //thickness=0.18 //x=62.825 //y=2.095 //x2=63.02 //y2=2.26
r956 (  231 324 ) resistor r=39.5823 //w=0.21 //l=0.173853 //layer=ply \
 //thickness=0.18 //x=62.825 //y=1.7 //x2=62.865 //y2=1.545
r957 (  231 232 ) resistor r=202.543 //w=0.094 //l=0.395 //layer=ply \
 //thickness=0.18 //x=62.825 //y=1.7 //x2=62.825 //y2=2.095
r958 (  230 324 ) resistor r=39.5823 //w=0.21 //l=0.173853 //layer=ply \
 //thickness=0.18 //x=62.825 //y=1.39 //x2=62.865 //y2=1.545
r959 (  229 323 ) resistor r=45.1352 //w=0.168 //l=0.173853 //layer=ply \
 //thickness=0.18 //x=62.825 //y=1.045 //x2=62.865 //y2=0.89
r960 (  229 230 ) resistor r=176.904 //w=0.094 //l=0.345 //layer=ply \
 //thickness=0.18 //x=62.825 //y=1.045 //x2=62.825 //y2=1.39
r961 (  228 320 ) resistor r=45.1352 //w=0.168 //l=0.173853 //layer=ply \
 //thickness=0.18 //x=56.14 //y=1.44 //x2=56.1 //y2=1.595
r962 (  227 319 ) resistor r=45.1352 //w=0.168 //l=0.173853 //layer=ply \
 //thickness=0.18 //x=56.14 //y=1.095 //x2=56.1 //y2=0.94
r963 (  227 228 ) resistor r=176.904 //w=0.094 //l=0.345 //layer=ply \
 //thickness=0.18 //x=56.14 //y=1.095 //x2=56.14 //y2=1.44
r964 (  225 316 ) resistor r=10.701 //w=0.21 //l=0.115 //layer=ply \
 //thickness=0.18 //x=55.765 //y=1.595 //x2=55.65 //y2=1.595
r965 (  224 320 ) resistor r=5.52526 //w=0.168 //l=0.115 //layer=ply \
 //thickness=0.18 //x=55.985 //y=1.595 //x2=56.1 //y2=1.595
r966 (  223 315 ) resistor r=5.52526 //w=0.168 //l=0.115 //layer=ply \
 //thickness=0.18 //x=55.765 //y=0.94 //x2=55.65 //y2=0.94
r967 (  222 319 ) resistor r=5.52526 //w=0.168 //l=0.115 //layer=ply \
 //thickness=0.18 //x=55.985 //y=0.94 //x2=56.1 //y2=0.94
r968 (  222 223 ) resistor r=112.809 //w=0.094 //l=0.22 //layer=ply \
 //thickness=0.18 //x=55.985 //y=0.94 //x2=55.765 //y2=0.94
r969 (  219 318 ) resistor r=37.236 //w=0.233 //l=0.249199 //layer=ply \
 //thickness=0.18 //x=55.8 //y=5.045 //x2=55.62 //y2=4.88
r970 (  217 316 ) resistor r=39.5823 //w=0.21 //l=0.173853 //layer=ply \
 //thickness=0.18 //x=55.61 //y=1.75 //x2=55.65 //y2=1.595
r971 (  217 313 ) resistor r=176.904 //w=0.094 //l=0.345 //layer=ply \
 //thickness=0.18 //x=55.61 //y=1.75 //x2=55.61 //y2=2.095
r972 (  216 316 ) resistor r=39.5823 //w=0.21 //l=0.173853 //layer=ply \
 //thickness=0.18 //x=55.61 //y=1.44 //x2=55.65 //y2=1.595
r973 (  215 315 ) resistor r=45.1352 //w=0.168 //l=0.173853 //layer=ply \
 //thickness=0.18 //x=55.61 //y=1.095 //x2=55.65 //y2=0.94
r974 (  215 216 ) resistor r=176.904 //w=0.094 //l=0.345 //layer=ply \
 //thickness=0.18 //x=55.61 //y=1.095 //x2=55.61 //y2=1.44
r975 (  212 318 ) resistor r=53.7854 //w=0.233 //l=0.332415 //layer=ply \
 //thickness=0.18 //x=55.36 //y=5.045 //x2=55.62 //y2=4.88
r976 (  211 310 ) resistor r=45.1352 //w=0.168 //l=0.173853 //layer=ply \
 //thickness=0.18 //x=48 //y=1.44 //x2=47.96 //y2=1.595
r977 (  210 309 ) resistor r=45.1352 //w=0.168 //l=0.173853 //layer=ply \
 //thickness=0.18 //x=48 //y=1.095 //x2=47.96 //y2=0.94
r978 (  210 211 ) resistor r=176.904 //w=0.094 //l=0.345 //layer=ply \
 //thickness=0.18 //x=48 //y=1.095 //x2=48 //y2=1.44
r979 (  208 306 ) resistor r=10.701 //w=0.21 //l=0.115 //layer=ply \
 //thickness=0.18 //x=47.625 //y=1.595 //x2=47.51 //y2=1.595
r980 (  207 310 ) resistor r=5.52526 //w=0.168 //l=0.115 //layer=ply \
 //thickness=0.18 //x=47.845 //y=1.595 //x2=47.96 //y2=1.595
r981 (  206 305 ) resistor r=5.52526 //w=0.168 //l=0.115 //layer=ply \
 //thickness=0.18 //x=47.625 //y=0.94 //x2=47.51 //y2=0.94
r982 (  205 309 ) resistor r=5.52526 //w=0.168 //l=0.115 //layer=ply \
 //thickness=0.18 //x=47.845 //y=0.94 //x2=47.96 //y2=0.94
r983 (  205 206 ) resistor r=112.809 //w=0.094 //l=0.22 //layer=ply \
 //thickness=0.18 //x=47.845 //y=0.94 //x2=47.625 //y2=0.94
r984 (  202 308 ) resistor r=37.236 //w=0.233 //l=0.249199 //layer=ply \
 //thickness=0.18 //x=47.66 //y=5.045 //x2=47.48 //y2=4.88
r985 (  200 306 ) resistor r=39.5823 //w=0.21 //l=0.173853 //layer=ply \
 //thickness=0.18 //x=47.47 //y=1.75 //x2=47.51 //y2=1.595
r986 (  200 303 ) resistor r=176.904 //w=0.094 //l=0.345 //layer=ply \
 //thickness=0.18 //x=47.47 //y=1.75 //x2=47.47 //y2=2.095
r987 (  199 306 ) resistor r=39.5823 //w=0.21 //l=0.173853 //layer=ply \
 //thickness=0.18 //x=47.47 //y=1.44 //x2=47.51 //y2=1.595
r988 (  198 305 ) resistor r=45.1352 //w=0.168 //l=0.173853 //layer=ply \
 //thickness=0.18 //x=47.47 //y=1.095 //x2=47.51 //y2=0.94
r989 (  198 199 ) resistor r=176.904 //w=0.094 //l=0.345 //layer=ply \
 //thickness=0.18 //x=47.47 //y=1.095 //x2=47.47 //y2=1.44
r990 (  195 308 ) resistor r=53.7854 //w=0.233 //l=0.332415 //layer=ply \
 //thickness=0.18 //x=47.22 //y=5.045 //x2=47.48 //y2=4.88
r991 (  194 296 ) resistor r=592.245 //w=0.094 //l=1.155 //layer=ply \
 //thickness=0.18 //x=82.96 //y=6.205 //x2=82.96 //y2=5.05
r992 (  193 288 ) resistor r=592.245 //w=0.094 //l=1.155 //layer=ply \
 //thickness=0.18 //x=82.52 //y=6.205 //x2=82.52 //y2=5.05
r993 (  192 281 ) resistor r=592.245 //w=0.094 //l=1.155 //layer=ply \
 //thickness=0.18 //x=79.64 //y=6.205 //x2=79.64 //y2=5.05
r994 (  191 269 ) resistor r=592.245 //w=0.094 //l=1.155 //layer=ply \
 //thickness=0.18 //x=79.2 //y=6.205 //x2=79.2 //y2=5.05
r995 (  190 262 ) resistor r=592.245 //w=0.094 //l=1.155 //layer=ply \
 //thickness=0.18 //x=66.99 //y=6.2 //x2=66.99 //y2=5.045
r996 (  189 255 ) resistor r=592.245 //w=0.094 //l=1.155 //layer=ply \
 //thickness=0.18 //x=66.55 //y=6.2 //x2=66.55 //y2=5.045
r997 (  188 243 ) resistor r=592.245 //w=0.094 //l=1.155 //layer=ply \
 //thickness=0.18 //x=63.36 //y=6.2 //x2=63.36 //y2=5.045
r998 (  187 233 ) resistor r=592.245 //w=0.094 //l=1.155 //layer=ply \
 //thickness=0.18 //x=62.92 //y=6.2 //x2=62.92 //y2=5.045
r999 (  186 219 ) resistor r=592.245 //w=0.094 //l=1.155 //layer=ply \
 //thickness=0.18 //x=55.8 //y=6.2 //x2=55.8 //y2=5.045
r1000 (  185 212 ) resistor r=592.245 //w=0.094 //l=1.155 //layer=ply \
 //thickness=0.18 //x=55.36 //y=6.2 //x2=55.36 //y2=5.045
r1001 (  184 202 ) resistor r=592.245 //w=0.094 //l=1.155 //layer=ply \
 //thickness=0.18 //x=47.66 //y=6.2 //x2=47.66 //y2=5.045
r1002 (  183 195 ) resistor r=592.245 //w=0.094 //l=1.155 //layer=ply \
 //thickness=0.18 //x=47.22 //y=6.2 //x2=47.22 //y2=5.045
r1003 (  182 293 ) resistor r=56.4043 //w=0.094 //l=0.11 //layer=ply \
 //thickness=0.18 //x=82.7 //y=1.545 //x2=82.81 //y2=1.545
r1004 (  182 294 ) resistor r=56.4043 //w=0.094 //l=0.11 //layer=ply \
 //thickness=0.18 //x=82.7 //y=1.545 //x2=82.59 //y2=1.545
r1005 (  181 274 ) resistor r=56.4043 //w=0.094 //l=0.11 //layer=ply \
 //thickness=0.18 //x=79.37 //y=1.545 //x2=79.48 //y2=1.545
r1006 (  181 275 ) resistor r=56.4043 //w=0.094 //l=0.11 //layer=ply \
 //thickness=0.18 //x=79.37 //y=1.545 //x2=79.26 //y2=1.545
r1007 (  180 252 ) resistor r=56.4043 //w=0.094 //l=0.11 //layer=ply \
 //thickness=0.18 //x=66.315 //y=1.555 //x2=66.425 //y2=1.555
r1008 (  180 253 ) resistor r=56.4043 //w=0.094 //l=0.11 //layer=ply \
 //thickness=0.18 //x=66.315 //y=1.555 //x2=66.205 //y2=1.555
r1009 (  179 238 ) resistor r=56.4043 //w=0.094 //l=0.11 //layer=ply \
 //thickness=0.18 //x=63.09 //y=1.545 //x2=63.2 //y2=1.545
r1010 (  179 239 ) resistor r=56.4043 //w=0.094 //l=0.11 //layer=ply \
 //thickness=0.18 //x=63.09 //y=1.545 //x2=62.98 //y2=1.545
r1011 (  178 224 ) resistor r=56.4043 //w=0.094 //l=0.11 //layer=ply \
 //thickness=0.18 //x=55.875 //y=1.595 //x2=55.985 //y2=1.595
r1012 (  178 225 ) resistor r=56.4043 //w=0.094 //l=0.11 //layer=ply \
 //thickness=0.18 //x=55.875 //y=1.595 //x2=55.765 //y2=1.595
r1013 (  177 207 ) resistor r=56.4043 //w=0.094 //l=0.11 //layer=ply \
 //thickness=0.18 //x=47.735 //y=1.595 //x2=47.845 //y2=1.595
r1014 (  177 208 ) resistor r=56.4043 //w=0.094 //l=0.11 //layer=ply \
 //thickness=0.18 //x=47.735 //y=1.595 //x2=47.625 //y2=1.595
r1015 (  171 352 ) resistor r=152 //w=0.17 //l=0.17 //layer=licon //count=1 \
 //x=82.63 //y=4.885 //x2=82.63 //y2=4.885
r1016 (  169 171 ) resistor r=18.139 //w=0.187 //l=0.265 //layer=li \
 //thickness=0.1 //x=82.63 //y=4.62 //x2=82.63 //y2=4.885
r1017 (  166 347 ) resistor r=152 //w=0.17 //l=0.17 //layer=licon //count=1 \
 //x=82.63 //y=2.26 //x2=82.63 //y2=2.26
r1018 (  166 169 ) resistor r=161.54 //w=0.187 //l=2.36 //layer=li \
 //thickness=0.1 //x=82.63 //y=2.26 //x2=82.63 //y2=4.62
r1019 (  163 341 ) resistor r=152 //w=0.17 //l=0.17 //layer=licon //count=1 \
 //x=78.93 //y=4.885 //x2=78.93 //y2=4.885
r1020 (  161 163 ) resistor r=18.139 //w=0.187 //l=0.265 //layer=li \
 //thickness=0.1 //x=78.93 //y=4.62 //x2=78.93 //y2=4.885
r1021 (  159 161 ) resistor r=75.9786 //w=0.187 //l=1.11 //layer=li \
 //thickness=0.1 //x=78.93 //y=3.51 //x2=78.93 //y2=4.62
r1022 (  156 339 ) resistor r=152 //w=0.17 //l=0.17 //layer=licon //count=1 \
 //x=78.93 //y=2.26 //x2=78.93 //y2=2.26
r1023 (  156 159 ) resistor r=85.5615 //w=0.187 //l=1.25 //layer=li \
 //thickness=0.1 //x=78.93 //y=2.26 //x2=78.93 //y2=3.51
r1024 (  153 335 ) resistor r=152 //w=0.17 //l=0.17 //layer=licon //count=1 \
 //x=66.35 //y=4.88 //x2=66.35 //y2=4.88
r1025 (  151 153 ) resistor r=93.7754 //w=0.187 //l=1.37 //layer=li \
 //thickness=0.1 //x=66.35 //y=3.51 //x2=66.35 //y2=4.88
r1026 (  148 333 ) resistor r=152 //w=0.17 //l=0.17 //layer=licon //count=1 \
 //x=66.35 //y=2.26 //x2=66.35 //y2=2.26
r1027 (  148 151 ) resistor r=85.5615 //w=0.187 //l=1.25 //layer=li \
 //thickness=0.1 //x=66.35 //y=2.26 //x2=66.35 //y2=3.51
r1028 (  144 146 ) resistor r=122.182 //w=0.187 //l=1.785 //layer=li \
 //thickness=0.1 //x=64.5 //y=5.295 //x2=64.5 //y2=3.51
r1029 (  143 146 ) resistor r=108.834 //w=0.187 //l=1.59 //layer=li \
 //thickness=0.1 //x=64.5 //y=1.92 //x2=64.5 //y2=3.51
r1030 (  141 143 ) resistor r=7.15173 //w=0.17 //l=0.120208 //layer=li \
 //thickness=0.1 //x=64.415 //y=1.835 //x2=64.5 //y2=1.92
r1031 (  141 142 ) resistor r=18.4813 //w=0.187 //l=0.27 //layer=li \
 //thickness=0.1 //x=64.415 //y=1.835 //x2=64.145 //y2=1.835
r1032 (  140 176 ) resistor r=5.4201 //w=0.17 //l=0.085 //layer=li \
 //thickness=0.1 //x=64.105 //y=5.38 //x2=64.02 //y2=5.38
r1033 (  139 144 ) resistor r=7.15173 //w=0.17 //l=0.120208 //layer=li \
 //thickness=0.1 //x=64.415 //y=5.38 //x2=64.5 //y2=5.295
r1034 (  139 140 ) resistor r=21.2193 //w=0.187 //l=0.31 //layer=li \
 //thickness=0.1 //x=64.415 //y=5.38 //x2=64.105 //y2=5.38
r1035 (  135 142 ) resistor r=7.15173 //w=0.17 //l=0.120208 //layer=li \
 //thickness=0.1 //x=64.06 //y=1.75 //x2=64.145 //y2=1.835
r1036 (  135 357 ) resistor r=39.016 //w=0.187 //l=0.57 //layer=li \
 //thickness=0.1 //x=64.06 //y=1.75 //x2=64.06 //y2=1.18
r1037 (  129 176 ) resistor r=1.40859 //w=0.34 //l=0.085 //layer=li \
 //thickness=0.1 //x=64.02 //y=5.465 //x2=64.02 //y2=5.38
r1038 (  129 367 ) resistor r=30.1176 //w=0.187 //l=0.44 //layer=li \
 //thickness=0.1 //x=64.02 //y=5.465 //x2=64.02 //y2=5.905
r1039 (  127 176 ) resistor r=5.4201 //w=0.17 //l=0.085 //layer=li \
 //thickness=0.1 //x=63.935 //y=5.38 //x2=64.02 //y2=5.38
r1040 (  127 128 ) resistor r=48.5989 //w=0.187 //l=0.71 //layer=li \
 //thickness=0.1 //x=63.935 //y=5.38 //x2=63.225 //y2=5.38
r1041 (  121 128 ) resistor r=7.15173 //w=0.17 //l=0.120208 //layer=li \
 //thickness=0.1 //x=63.14 //y=5.465 //x2=63.225 //y2=5.38
r1042 (  121 366 ) resistor r=30.1176 //w=0.187 //l=0.44 //layer=li \
 //thickness=0.1 //x=63.14 //y=5.465 //x2=63.14 //y2=5.905
r1043 (  119 327 ) resistor r=152 //w=0.17 //l=0.17 //layer=licon //count=1 \
 //x=63.02 //y=4.88 //x2=63.02 //y2=4.88
r1044 (  117 119 ) resistor r=93.7754 //w=0.187 //l=1.37 //layer=li \
 //thickness=0.1 //x=63.02 //y=3.51 //x2=63.02 //y2=4.88
r1045 (  114 322 ) resistor r=152 //w=0.17 //l=0.17 //layer=licon //count=1 \
 //x=63.02 //y=2.26 //x2=63.02 //y2=2.26
r1046 (  114 117 ) resistor r=85.5615 //w=0.187 //l=1.25 //layer=li \
 //thickness=0.1 //x=63.02 //y=2.26 //x2=63.02 //y2=3.51
r1047 (  110 112 ) resistor r=119.102 //w=0.187 //l=1.74 //layer=li \
 //thickness=0.1 //x=61.17 //y=5.25 //x2=61.17 //y2=3.51
r1048 (  109 112 ) resistor r=108.15 //w=0.187 //l=1.58 //layer=li \
 //thickness=0.1 //x=61.17 //y=1.93 //x2=61.17 //y2=3.51
r1049 (  107 109 ) resistor r=7.15173 //w=0.17 //l=0.120208 //layer=li \
 //thickness=0.1 //x=61.085 //y=1.845 //x2=61.17 //y2=1.93
r1050 (  107 108 ) resistor r=21.5615 //w=0.187 //l=0.315 //layer=li \
 //thickness=0.1 //x=61.085 //y=1.845 //x2=60.77 //y2=1.845
r1051 (  103 108 ) resistor r=7.15173 //w=0.17 //l=0.120208 //layer=li \
 //thickness=0.1 //x=60.685 //y=1.76 //x2=60.77 //y2=1.845
r1052 (  103 356 ) resistor r=39.016 //w=0.187 //l=0.57 //layer=li \
 //thickness=0.1 //x=60.685 //y=1.76 //x2=60.685 //y2=1.19
r1053 (  102 175 ) resistor r=5.4201 //w=0.17 //l=0.085 //layer=li \
 //thickness=0.1 //x=60.475 //y=5.335 //x2=60.39 //y2=5.335
r1054 (  101 110 ) resistor r=7.15173 //w=0.17 //l=0.120208 //layer=li \
 //thickness=0.1 //x=61.085 //y=5.335 //x2=61.17 //y2=5.25
r1055 (  101 102 ) resistor r=41.754 //w=0.187 //l=0.61 //layer=li \
 //thickness=0.1 //x=61.085 //y=5.335 //x2=60.475 //y2=5.335
r1056 (  95 175 ) resistor r=1.40859 //w=0.34 //l=0.085 //layer=li \
 //thickness=0.1 //x=60.39 //y=5.42 //x2=60.39 //y2=5.335
r1057 (  95 365 ) resistor r=33.1979 //w=0.187 //l=0.485 //layer=li \
 //thickness=0.1 //x=60.39 //y=5.42 //x2=60.39 //y2=5.905
r1058 (  94 174 ) resistor r=5.4201 //w=0.17 //l=0.085 //layer=li \
 //thickness=0.1 //x=59.595 //y=5.335 //x2=59.51 //y2=5.335
r1059 (  93 175 ) resistor r=5.4201 //w=0.17 //l=0.085 //layer=li \
 //thickness=0.1 //x=60.305 //y=5.335 //x2=60.39 //y2=5.335
r1060 (  93 94 ) resistor r=48.5989 //w=0.187 //l=0.71 //layer=li \
 //thickness=0.1 //x=60.305 //y=5.335 //x2=59.595 //y2=5.335
r1061 (  87 174 ) resistor r=1.40859 //w=0.34 //l=0.085 //layer=li \
 //thickness=0.1 //x=59.51 //y=5.42 //x2=59.51 //y2=5.335
r1062 (  87 364 ) resistor r=33.1979 //w=0.187 //l=0.485 //layer=li \
 //thickness=0.1 //x=59.51 //y=5.42 //x2=59.51 //y2=5.905
r1063 (  85 174 ) resistor r=5.4201 //w=0.17 //l=0.085 //layer=li \
 //thickness=0.1 //x=59.425 //y=5.335 //x2=59.51 //y2=5.335
r1064 (  85 86 ) resistor r=48.5989 //w=0.187 //l=0.71 //layer=li \
 //thickness=0.1 //x=59.425 //y=5.335 //x2=58.715 //y2=5.335
r1065 (  79 86 ) resistor r=7.15173 //w=0.17 //l=0.120208 //layer=li \
 //thickness=0.1 //x=58.63 //y=5.42 //x2=58.715 //y2=5.335
r1066 (  79 363 ) resistor r=33.1979 //w=0.187 //l=0.485 //layer=li \
 //thickness=0.1 //x=58.63 //y=5.42 //x2=58.63 //y2=5.905
r1067 (  77 318 ) resistor r=152 //w=0.17 //l=0.17 //layer=licon //count=1 \
 //x=55.62 //y=4.88 //x2=55.62 //y2=4.88
r1068 (  75 77 ) resistor r=93.7754 //w=0.187 //l=1.37 //layer=li \
 //thickness=0.1 //x=55.62 //y=3.51 //x2=55.62 //y2=4.88
r1069 (  72 312 ) resistor r=152 //w=0.17 //l=0.17 //layer=licon //count=1 \
 //x=55.62 //y=2.26 //x2=55.62 //y2=2.26
r1070 (  72 75 ) resistor r=85.5615 //w=0.187 //l=1.25 //layer=li \
 //thickness=0.1 //x=55.62 //y=2.26 //x2=55.62 //y2=3.51
r1071 (  68 70 ) resistor r=122.182 //w=0.187 //l=1.785 //layer=li \
 //thickness=0.1 //x=51.55 //y=5.295 //x2=51.55 //y2=3.51
r1072 (  67 70 ) resistor r=108.834 //w=0.187 //l=1.59 //layer=li \
 //thickness=0.1 //x=51.55 //y=1.92 //x2=51.55 //y2=3.51
r1073 (  65 67 ) resistor r=7.15173 //w=0.17 //l=0.120208 //layer=li \
 //thickness=0.1 //x=51.465 //y=1.835 //x2=51.55 //y2=1.92
r1074 (  65 66 ) resistor r=18.4813 //w=0.187 //l=0.27 //layer=li \
 //thickness=0.1 //x=51.465 //y=1.835 //x2=51.195 //y2=1.835
r1075 (  64 173 ) resistor r=5.4201 //w=0.17 //l=0.085 //layer=li \
 //thickness=0.1 //x=51.155 //y=5.38 //x2=51.07 //y2=5.38
r1076 (  63 68 ) resistor r=7.15173 //w=0.17 //l=0.120208 //layer=li \
 //thickness=0.1 //x=51.465 //y=5.38 //x2=51.55 //y2=5.295
r1077 (  63 64 ) resistor r=21.2193 //w=0.187 //l=0.31 //layer=li \
 //thickness=0.1 //x=51.465 //y=5.38 //x2=51.155 //y2=5.38
r1078 (  59 66 ) resistor r=7.15173 //w=0.17 //l=0.120208 //layer=li \
 //thickness=0.1 //x=51.11 //y=1.75 //x2=51.195 //y2=1.835
r1079 (  59 355 ) resistor r=39.016 //w=0.187 //l=0.57 //layer=li \
 //thickness=0.1 //x=51.11 //y=1.75 //x2=51.11 //y2=1.18
r1080 (  53 173 ) resistor r=1.40859 //w=0.34 //l=0.085 //layer=li \
 //thickness=0.1 //x=51.07 //y=5.465 //x2=51.07 //y2=5.38
r1081 (  53 362 ) resistor r=30.1176 //w=0.187 //l=0.44 //layer=li \
 //thickness=0.1 //x=51.07 //y=5.465 //x2=51.07 //y2=5.905
r1082 (  51 173 ) resistor r=5.4201 //w=0.17 //l=0.085 //layer=li \
 //thickness=0.1 //x=50.985 //y=5.38 //x2=51.07 //y2=5.38
r1083 (  51 52 ) resistor r=48.5989 //w=0.187 //l=0.71 //layer=li \
 //thickness=0.1 //x=50.985 //y=5.38 //x2=50.275 //y2=5.38
r1084 (  45 52 ) resistor r=7.15173 //w=0.17 //l=0.120208 //layer=li \
 //thickness=0.1 //x=50.19 //y=5.465 //x2=50.275 //y2=5.38
r1085 (  45 361 ) resistor r=30.1176 //w=0.187 //l=0.44 //layer=li \
 //thickness=0.1 //x=50.19 //y=5.465 //x2=50.19 //y2=5.905
r1086 (  43 308 ) resistor r=152 //w=0.17 //l=0.17 //layer=licon //count=1 \
 //x=47.48 //y=4.88 //x2=47.48 //y2=4.88
r1087 (  41 43 ) resistor r=93.7754 //w=0.187 //l=1.37 //layer=li \
 //thickness=0.1 //x=47.48 //y=3.51 //x2=47.48 //y2=4.88
r1088 (  38 302 ) resistor r=152 //w=0.17 //l=0.17 //layer=licon //count=1 \
 //x=47.48 //y=2.26 //x2=47.48 //y2=2.26
r1089 (  38 41 ) resistor r=85.5615 //w=0.187 //l=1.25 //layer=li \
 //thickness=0.1 //x=47.48 //y=2.26 //x2=47.48 //y2=3.51
r1090 (  36 169 ) resistor r=9.3 //w=0.17 //l=0.17 //layer=mcon //count=1 \
 //x=82.63 //y=4.62 //x2=82.63 //y2=4.62
r1091 (  34 159 ) resistor r=9.3 //w=0.17 //l=0.17 //layer=mcon //count=1 \
 //x=78.93 //y=3.51 //x2=78.93 //y2=3.51
r1092 (  32 161 ) resistor r=9.3 //w=0.17 //l=0.17 //layer=mcon //count=1 \
 //x=78.93 //y=4.62 //x2=78.93 //y2=4.62
r1093 (  30 151 ) resistor r=9.3 //w=0.17 //l=0.17 //layer=mcon //count=1 \
 //x=66.35 //y=3.51 //x2=66.35 //y2=3.51
r1094 (  28 146 ) resistor r=9.3 //w=0.17 //l=0.17 //layer=mcon //count=1 \
 //x=64.5 //y=3.51 //x2=64.5 //y2=3.51
r1095 (  26 117 ) resistor r=9.3 //w=0.17 //l=0.17 //layer=mcon //count=1 \
 //x=63.02 //y=3.51 //x2=63.02 //y2=3.51
r1096 (  24 112 ) resistor r=9.3 //w=0.17 //l=0.17 //layer=mcon //count=1 \
 //x=61.17 //y=3.51 //x2=61.17 //y2=3.51
r1097 (  22 75 ) resistor r=9.3 //w=0.17 //l=0.17 //layer=mcon //count=1 \
 //x=55.62 //y=3.51 //x2=55.62 //y2=3.51
r1098 (  20 70 ) resistor r=9.3 //w=0.17 //l=0.17 //layer=mcon //count=1 \
 //x=51.55 //y=3.51 //x2=51.55 //y2=3.51
r1099 (  18 41 ) resistor r=9.3 //w=0.17 //l=0.17 //layer=mcon //count=1 \
 //x=47.48 //y=3.51 //x2=47.48 //y2=3.51
r1100 (  16 32 ) resistor r=0.0717383 //w=0.224 //l=0.115 //layer=m1 \
 //thickness=0.36 //x=79.045 //y=4.62 //x2=78.93 //y2=4.62
r1101 (  15 36 ) resistor r=0.0717383 //w=0.224 //l=0.115 //layer=m1 \
 //thickness=0.36 //x=82.515 //y=4.62 //x2=82.63 //y2=4.62
r1102 (  15 16 ) resistor r=3.31107 //w=0.131 //l=3.47 //layer=m1 \
 //thickness=0.36 //x=82.515 //y=4.62 //x2=79.045 //y2=4.62
r1103 (  14 30 ) resistor r=0.0880901 //w=0.191 //l=0.115 //layer=m1 \
 //thickness=0.36 //x=66.465 //y=3.51 //x2=66.35 //y2=3.51
r1104 (  13 34 ) resistor r=0.0717383 //w=0.224 //l=0.115 //layer=m1 \
 //thickness=0.36 //x=78.815 //y=3.51 //x2=78.93 //y2=3.51
r1105 (  13 14 ) resistor r=11.7844 //w=0.131 //l=12.35 //layer=m1 \
 //thickness=0.36 //x=78.815 //y=3.51 //x2=66.465 //y2=3.51
r1106 (  12 28 ) resistor r=0.0880901 //w=0.191 //l=0.115 //layer=m1 \
 //thickness=0.36 //x=64.615 //y=3.51 //x2=64.5 //y2=3.51
r1107 (  11 30 ) resistor r=0.0880901 //w=0.191 //l=0.115 //layer=m1 \
 //thickness=0.36 //x=66.235 //y=3.51 //x2=66.35 //y2=3.51
r1108 (  11 12 ) resistor r=1.5458 //w=0.131 //l=1.62 //layer=m1 \
 //thickness=0.36 //x=66.235 //y=3.51 //x2=64.615 //y2=3.51
r1109 (  10 26 ) resistor r=0.0880901 //w=0.191 //l=0.115 //layer=m1 \
 //thickness=0.36 //x=63.135 //y=3.51 //x2=63.02 //y2=3.51
r1110 (  9 28 ) resistor r=0.0880901 //w=0.191 //l=0.115 //layer=m1 \
 //thickness=0.36 //x=64.385 //y=3.51 //x2=64.5 //y2=3.51
r1111 (  9 10 ) resistor r=1.19275 //w=0.131 //l=1.25 //layer=m1 \
 //thickness=0.36 //x=64.385 //y=3.51 //x2=63.135 //y2=3.51
r1112 (  8 24 ) resistor r=0.0880901 //w=0.191 //l=0.115 //layer=m1 \
 //thickness=0.36 //x=61.285 //y=3.51 //x2=61.17 //y2=3.51
r1113 (  7 26 ) resistor r=0.0880901 //w=0.191 //l=0.115 //layer=m1 \
 //thickness=0.36 //x=62.905 //y=3.51 //x2=63.02 //y2=3.51
r1114 (  7 8 ) resistor r=1.5458 //w=0.131 //l=1.62 //layer=m1 \
 //thickness=0.36 //x=62.905 //y=3.51 //x2=61.285 //y2=3.51
r1115 (  6 22 ) resistor r=0.0880901 //w=0.191 //l=0.115 //layer=m1 \
 //thickness=0.36 //x=55.735 //y=3.51 //x2=55.62 //y2=3.51
r1116 (  5 24 ) resistor r=0.0880901 //w=0.191 //l=0.115 //layer=m1 \
 //thickness=0.36 //x=61.055 //y=3.51 //x2=61.17 //y2=3.51
r1117 (  5 6 ) resistor r=5.07634 //w=0.131 //l=5.32 //layer=m1 \
 //thickness=0.36 //x=61.055 //y=3.51 //x2=55.735 //y2=3.51
r1118 (  4 20 ) resistor r=0.0880901 //w=0.191 //l=0.115 //layer=m1 \
 //thickness=0.36 //x=51.665 //y=3.51 //x2=51.55 //y2=3.51
r1119 (  3 22 ) resistor r=0.0880901 //w=0.191 //l=0.115 //layer=m1 \
 //thickness=0.36 //x=55.505 //y=3.51 //x2=55.62 //y2=3.51
r1120 (  3 4 ) resistor r=3.66412 //w=0.131 //l=3.84 //layer=m1 \
 //thickness=0.36 //x=55.505 //y=3.51 //x2=51.665 //y2=3.51
r1121 (  2 18 ) resistor r=0.0717383 //w=0.224 //l=0.115 //layer=m1 \
 //thickness=0.36 //x=47.595 //y=3.51 //x2=47.48 //y2=3.51
r1122 (  1 20 ) resistor r=0.0880901 //w=0.191 //l=0.115 //layer=m1 \
 //thickness=0.36 //x=51.435 //y=3.51 //x2=51.55 //y2=3.51
r1123 (  1 2 ) resistor r=3.66412 //w=0.131 //l=3.84 //layer=m1 \
 //thickness=0.36 //x=51.435 //y=3.51 //x2=47.595 //y2=3.51
ends PM_TMRDFFRNQX1\%noxref_17

subckt PM_TMRDFFRNQX1\%noxref_18 ( 1 2 3 4 5 6 18 31 32 43 45 46 50 51 53 61 \
 65 69 72 73 74 75 76 77 78 79 80 84 85 86 91 93 96 97 98 99 100 105 107 109 \
 115 116 117 118 119 124 126 128 134 135 137 138 143 147 148 151 159 160 163 \
 171 173 174 )
c364 ( 174 0 ) capacitor c=0.0220235f //x=76.825 //y=5.2
c365 ( 173 0 ) capacitor c=0.0217503f //x=75.945 //y=5.2
c366 ( 171 0 ) capacitor c=0.00864721f //x=76.82 //y=1.085
c367 ( 163 0 ) capacitor c=0.0352016f //x=86.72 //y=4.885
c368 ( 160 0 ) capacitor c=0.0279733f //x=86.7 //y=2.095
c369 ( 159 0 ) capacitor c=0.0467621f //x=86.7 //y=2.26
c370 ( 151 0 ) capacitor c=0.03845f //x=80.08 //y=4.885
c371 ( 148 0 ) capacitor c=0.0300885f //x=80.04 //y=2.095
c372 ( 147 0 ) capacitor c=0.0520335f //x=80.04 //y=2.26
c373 ( 143 0 ) capacitor c=0.059212f //x=73.38 //y=4.88
c374 ( 138 0 ) capacitor c=0.0273931f //x=73.38 //y=2.095
c375 ( 137 0 ) capacitor c=0.0458323f //x=73.38 //y=2.26
c376 ( 135 0 ) capacitor c=0.0237734f //x=87.265 //y=1.435
c377 ( 134 0 ) capacitor c=0.0191782f //x=87.265 //y=1.085
c378 ( 128 0 ) capacitor c=0.0351663f //x=87.11 //y=1.585
c379 ( 126 0 ) capacitor c=0.0157803f //x=87.11 //y=0.93
c380 ( 124 0 ) capacitor c=0.0374703f //x=87.105 //y=4.975
c381 ( 119 0 ) capacitor c=0.0200628f //x=86.735 //y=1.74
c382 ( 118 0 ) capacitor c=0.0168575f //x=86.735 //y=1.435
c383 ( 117 0 ) capacitor c=0.0174993f //x=86.735 //y=1.085
c384 ( 116 0 ) capacitor c=0.0447087f //x=80.605 //y=1.43
c385 ( 115 0 ) capacitor c=0.019286f //x=80.605 //y=1.085
c386 ( 109 0 ) capacitor c=0.0187932f //x=80.45 //y=1.585
c387 ( 107 0 ) capacitor c=0.0157795f //x=80.45 //y=0.93
c388 ( 105 0 ) capacitor c=0.029531f //x=80.445 //y=4.975
c389 ( 100 0 ) capacitor c=0.0206178f //x=80.075 //y=1.74
c390 ( 99 0 ) capacitor c=0.016848f //x=80.075 //y=1.43
c391 ( 98 0 ) capacitor c=0.0174777f //x=80.075 //y=1.085
c392 ( 97 0 ) capacitor c=0.0432517f //x=73.9 //y=1.44
c393 ( 96 0 ) capacitor c=0.0200379f //x=73.9 //y=1.095
c394 ( 93 0 ) capacitor c=0.0158629f //x=73.745 //y=1.595
c395 ( 91 0 ) capacitor c=0.0157803f //x=73.745 //y=0.94
c396 ( 86 0 ) capacitor c=0.0218028f //x=73.37 //y=1.75
c397 ( 85 0 ) capacitor c=0.0207459f //x=73.37 //y=1.44
c398 ( 84 0 ) capacitor c=0.0194308f //x=73.37 //y=1.095
c399 ( 80 0 ) capacitor c=0.15325f //x=87.18 //y=6.205
c400 ( 79 0 ) capacitor c=0.110411f //x=86.74 //y=6.205
c401 ( 78 0 ) capacitor c=0.154236f //x=80.52 //y=6.205
c402 ( 77 0 ) capacitor c=0.110294f //x=80.08 //y=6.205
c403 ( 76 0 ) capacitor c=0.158794f //x=73.56 //y=6.2
c404 ( 75 0 ) capacitor c=0.110114f //x=73.12 //y=6.2
c405 ( 69 0 ) capacitor c=0.00501304f //x=86.72 //y=4.885
c406 ( 65 0 ) capacitor c=0.0024826f //x=76.97 //y=5.38
c407 ( 61 0 ) capacitor c=0.0901308f //x=86.7 //y=2.26
c408 ( 53 0 ) capacitor c=0.10473f //x=80.04 //y=2.26
c409 ( 51 0 ) capacitor c=0.00669947f //x=80.04 //y=4.72
c410 ( 50 0 ) capacitor c=0.106148f //x=77.45 //y=3.88
c411 ( 46 0 ) capacitor c=0.00468667f //x=77.095 //y=1.835
c412 ( 45 0 ) capacitor c=0.0131863f //x=77.365 //y=1.835
c413 ( 43 0 ) capacitor c=0.0141743f //x=77.365 //y=5.38
c414 ( 32 0 ) capacitor c=0.00265272f //x=76.175 //y=5.38
c415 ( 31 0 ) capacitor c=0.0150834f //x=76.885 //y=5.38
c416 ( 18 0 ) capacitor c=0.0870564f //x=73.38 //y=2.26
c417 ( 6 0 ) capacitor c=0.0101803f //x=80.155 //y=4.25
c418 ( 5 0 ) capacitor c=0.193689f //x=86.585 //y=4.25
c419 ( 4 0 ) capacitor c=0.00450722f //x=77.565 //y=3.88
c420 ( 3 0 ) capacitor c=0.0754105f //x=79.925 //y=3.88
c421 ( 2 0 ) capacitor c=0.00769527f //x=73.495 //y=3.88
c422 ( 1 0 ) capacitor c=0.0613342f //x=77.335 //y=3.88
r423 (  165 166 ) resistor r=32.4568 //w=0.214 //l=0.075 //layer=ply \
 //thickness=0.18 //x=86.72 //y=4.975 //x2=86.72 //y2=5.05
r424 (  163 165 ) resistor r=20.271 //w=0.214 //l=0.09 //layer=ply \
 //thickness=0.18 //x=86.72 //y=4.885 //x2=86.72 //y2=4.975
r425 (  159 160 ) resistor r=52.7279 //w=0.214 //l=0.165 //layer=ply \
 //thickness=0.18 //x=86.7 //y=2.26 //x2=86.7 //y2=2.095
r426 (  151 153 ) resistor r=20.271 //w=0.214 //l=0.09 //layer=ply \
 //thickness=0.18 //x=80.08 //y=4.885 //x2=80.08 //y2=4.975
r427 (  147 148 ) resistor r=52.7279 //w=0.214 //l=0.165 //layer=ply \
 //thickness=0.18 //x=80.04 //y=2.26 //x2=80.04 //y2=2.095
r428 (  137 138 ) resistor r=52.7279 //w=0.214 //l=0.165 //layer=ply \
 //thickness=0.18 //x=73.38 //y=2.26 //x2=73.38 //y2=2.095
r429 (  135 170 ) resistor r=4.95774 //w=0.164 //l=0.112 //layer=ply \
 //thickness=0.18 //x=87.265 //y=1.435 //x2=87.265 //y2=1.547
r430 (  134 169 ) resistor r=45.1352 //w=0.168 //l=0.173853 //layer=ply \
 //thickness=0.18 //x=87.265 //y=1.085 //x2=87.225 //y2=0.93
r431 (  134 135 ) resistor r=179.468 //w=0.094 //l=0.35 //layer=ply \
 //thickness=0.18 //x=87.265 //y=1.085 //x2=87.265 //y2=1.435
r432 (  129 168 ) resistor r=10.8103 //w=0.211 //l=0.115 //layer=ply \
 //thickness=0.18 //x=86.89 //y=1.585 //x2=86.775 //y2=1.585
r433 (  128 170 ) resistor r=45.9962 //w=0.164 //l=0.17296 //layer=ply \
 //thickness=0.18 //x=87.11 //y=1.585 //x2=87.265 //y2=1.547
r434 (  127 167 ) resistor r=5.52526 //w=0.168 //l=0.115 //layer=ply \
 //thickness=0.18 //x=86.89 //y=0.93 //x2=86.775 //y2=0.93
r435 (  126 169 ) resistor r=5.52526 //w=0.168 //l=0.115 //layer=ply \
 //thickness=0.18 //x=87.11 //y=0.93 //x2=87.225 //y2=0.93
r436 (  126 127 ) resistor r=112.809 //w=0.094 //l=0.22 //layer=ply \
 //thickness=0.18 //x=87.11 //y=0.93 //x2=86.89 //y2=0.93
r437 (  125 165 ) resistor r=16.5046 //w=0.27 //l=0.135 //layer=ply \
 //thickness=0.18 //x=86.855 //y=4.975 //x2=86.72 //y2=4.975
r438 (  124 131 ) resistor r=26.9307 //w=0.15 //l=0.106066 //layer=ply \
 //thickness=0.18 //x=87.105 //y=4.975 //x2=87.18 //y2=5.05
r439 (  124 125 ) resistor r=128.191 //w=0.094 //l=0.25 //layer=ply \
 //thickness=0.18 //x=87.105 //y=4.975 //x2=86.855 //y2=4.975
r440 (  119 168 ) resistor r=39.5036 //w=0.211 //l=0.173853 //layer=ply \
 //thickness=0.18 //x=86.735 //y=1.74 //x2=86.775 //y2=1.585
r441 (  119 160 ) resistor r=182.032 //w=0.094 //l=0.355 //layer=ply \
 //thickness=0.18 //x=86.735 //y=1.74 //x2=86.735 //y2=2.095
r442 (  118 168 ) resistor r=38.3614 //w=0.211 //l=0.168819 //layer=ply \
 //thickness=0.18 //x=86.735 //y=1.435 //x2=86.775 //y2=1.585
r443 (  117 167 ) resistor r=45.1352 //w=0.168 //l=0.173853 //layer=ply \
 //thickness=0.18 //x=86.735 //y=1.085 //x2=86.775 //y2=0.93
r444 (  117 118 ) resistor r=179.468 //w=0.094 //l=0.35 //layer=ply \
 //thickness=0.18 //x=86.735 //y=1.085 //x2=86.735 //y2=1.435
r445 (  116 157 ) resistor r=45.1352 //w=0.168 //l=0.173853 //layer=ply \
 //thickness=0.18 //x=80.605 //y=1.43 //x2=80.565 //y2=1.585
r446 (  115 156 ) resistor r=45.1352 //w=0.168 //l=0.173853 //layer=ply \
 //thickness=0.18 //x=80.605 //y=1.085 //x2=80.565 //y2=0.93
r447 (  115 116 ) resistor r=176.904 //w=0.094 //l=0.345 //layer=ply \
 //thickness=0.18 //x=80.605 //y=1.085 //x2=80.605 //y2=1.43
r448 (  110 155 ) resistor r=10.701 //w=0.21 //l=0.115 //layer=ply \
 //thickness=0.18 //x=80.23 //y=1.585 //x2=80.115 //y2=1.585
r449 (  109 157 ) resistor r=5.52526 //w=0.168 //l=0.115 //layer=ply \
 //thickness=0.18 //x=80.45 //y=1.585 //x2=80.565 //y2=1.585
r450 (  108 154 ) resistor r=5.52526 //w=0.168 //l=0.115 //layer=ply \
 //thickness=0.18 //x=80.23 //y=0.93 //x2=80.115 //y2=0.93
r451 (  107 156 ) resistor r=5.52526 //w=0.168 //l=0.115 //layer=ply \
 //thickness=0.18 //x=80.45 //y=0.93 //x2=80.565 //y2=0.93
r452 (  107 108 ) resistor r=112.809 //w=0.094 //l=0.22 //layer=ply \
 //thickness=0.18 //x=80.45 //y=0.93 //x2=80.23 //y2=0.93
r453 (  106 153 ) resistor r=16.5046 //w=0.27 //l=0.135 //layer=ply \
 //thickness=0.18 //x=80.215 //y=4.975 //x2=80.08 //y2=4.975
r454 (  105 112 ) resistor r=26.9307 //w=0.15 //l=0.106066 //layer=ply \
 //thickness=0.18 //x=80.445 //y=4.975 //x2=80.52 //y2=5.05
r455 (  105 106 ) resistor r=117.936 //w=0.094 //l=0.23 //layer=ply \
 //thickness=0.18 //x=80.445 //y=4.975 //x2=80.215 //y2=4.975
r456 (  102 153 ) resistor r=32.4568 //w=0.214 //l=0.075 //layer=ply \
 //thickness=0.18 //x=80.08 //y=5.05 //x2=80.08 //y2=4.975
r457 (  100 155 ) resistor r=39.5823 //w=0.21 //l=0.173853 //layer=ply \
 //thickness=0.18 //x=80.075 //y=1.74 //x2=80.115 //y2=1.585
r458 (  100 148 ) resistor r=182.032 //w=0.094 //l=0.355 //layer=ply \
 //thickness=0.18 //x=80.075 //y=1.74 //x2=80.075 //y2=2.095
r459 (  99 155 ) resistor r=39.5823 //w=0.21 //l=0.173853 //layer=ply \
 //thickness=0.18 //x=80.075 //y=1.43 //x2=80.115 //y2=1.585
r460 (  98 154 ) resistor r=45.1352 //w=0.168 //l=0.173853 //layer=ply \
 //thickness=0.18 //x=80.075 //y=1.085 //x2=80.115 //y2=0.93
r461 (  98 99 ) resistor r=176.904 //w=0.094 //l=0.345 //layer=ply \
 //thickness=0.18 //x=80.075 //y=1.085 //x2=80.075 //y2=1.43
r462 (  97 145 ) resistor r=45.1352 //w=0.168 //l=0.173853 //layer=ply \
 //thickness=0.18 //x=73.9 //y=1.44 //x2=73.86 //y2=1.595
r463 (  96 144 ) resistor r=45.1352 //w=0.168 //l=0.173853 //layer=ply \
 //thickness=0.18 //x=73.9 //y=1.095 //x2=73.86 //y2=0.94
r464 (  96 97 ) resistor r=176.904 //w=0.094 //l=0.345 //layer=ply \
 //thickness=0.18 //x=73.9 //y=1.095 //x2=73.9 //y2=1.44
r465 (  94 141 ) resistor r=10.701 //w=0.21 //l=0.115 //layer=ply \
 //thickness=0.18 //x=73.525 //y=1.595 //x2=73.41 //y2=1.595
r466 (  93 145 ) resistor r=5.52526 //w=0.168 //l=0.115 //layer=ply \
 //thickness=0.18 //x=73.745 //y=1.595 //x2=73.86 //y2=1.595
r467 (  92 140 ) resistor r=5.52526 //w=0.168 //l=0.115 //layer=ply \
 //thickness=0.18 //x=73.525 //y=0.94 //x2=73.41 //y2=0.94
r468 (  91 144 ) resistor r=5.52526 //w=0.168 //l=0.115 //layer=ply \
 //thickness=0.18 //x=73.745 //y=0.94 //x2=73.86 //y2=0.94
r469 (  91 92 ) resistor r=112.809 //w=0.094 //l=0.22 //layer=ply \
 //thickness=0.18 //x=73.745 //y=0.94 //x2=73.525 //y2=0.94
r470 (  88 143 ) resistor r=37.236 //w=0.233 //l=0.249199 //layer=ply \
 //thickness=0.18 //x=73.56 //y=5.045 //x2=73.38 //y2=4.88
r471 (  86 141 ) resistor r=39.5823 //w=0.21 //l=0.173853 //layer=ply \
 //thickness=0.18 //x=73.37 //y=1.75 //x2=73.41 //y2=1.595
r472 (  86 138 ) resistor r=176.904 //w=0.094 //l=0.345 //layer=ply \
 //thickness=0.18 //x=73.37 //y=1.75 //x2=73.37 //y2=2.095
r473 (  85 141 ) resistor r=39.5823 //w=0.21 //l=0.173853 //layer=ply \
 //thickness=0.18 //x=73.37 //y=1.44 //x2=73.41 //y2=1.595
r474 (  84 140 ) resistor r=45.1352 //w=0.168 //l=0.173853 //layer=ply \
 //thickness=0.18 //x=73.37 //y=1.095 //x2=73.41 //y2=0.94
r475 (  84 85 ) resistor r=176.904 //w=0.094 //l=0.345 //layer=ply \
 //thickness=0.18 //x=73.37 //y=1.095 //x2=73.37 //y2=1.44
r476 (  81 143 ) resistor r=53.7854 //w=0.233 //l=0.332415 //layer=ply \
 //thickness=0.18 //x=73.12 //y=5.045 //x2=73.38 //y2=4.88
r477 (  80 131 ) resistor r=592.245 //w=0.094 //l=1.155 //layer=ply \
 //thickness=0.18 //x=87.18 //y=6.205 //x2=87.18 //y2=5.05
r478 (  79 166 ) resistor r=592.245 //w=0.094 //l=1.155 //layer=ply \
 //thickness=0.18 //x=86.74 //y=6.205 //x2=86.74 //y2=5.05
r479 (  78 112 ) resistor r=592.245 //w=0.094 //l=1.155 //layer=ply \
 //thickness=0.18 //x=80.52 //y=6.205 //x2=80.52 //y2=5.05
r480 (  77 102 ) resistor r=592.245 //w=0.094 //l=1.155 //layer=ply \
 //thickness=0.18 //x=80.08 //y=6.205 //x2=80.08 //y2=5.05
r481 (  76 88 ) resistor r=592.245 //w=0.094 //l=1.155 //layer=ply \
 //thickness=0.18 //x=73.56 //y=6.2 //x2=73.56 //y2=5.045
r482 (  75 81 ) resistor r=592.245 //w=0.094 //l=1.155 //layer=ply \
 //thickness=0.18 //x=73.12 //y=6.2 //x2=73.12 //y2=5.045
r483 (  74 128 ) resistor r=56.4043 //w=0.094 //l=0.11 //layer=ply \
 //thickness=0.18 //x=87 //y=1.585 //x2=87.11 //y2=1.585
r484 (  74 129 ) resistor r=56.4043 //w=0.094 //l=0.11 //layer=ply \
 //thickness=0.18 //x=87 //y=1.585 //x2=86.89 //y2=1.585
r485 (  73 109 ) resistor r=56.4043 //w=0.094 //l=0.11 //layer=ply \
 //thickness=0.18 //x=80.34 //y=1.585 //x2=80.45 //y2=1.585
r486 (  73 110 ) resistor r=56.4043 //w=0.094 //l=0.11 //layer=ply \
 //thickness=0.18 //x=80.34 //y=1.585 //x2=80.23 //y2=1.585
r487 (  72 93 ) resistor r=56.4043 //w=0.094 //l=0.11 //layer=ply \
 //thickness=0.18 //x=73.635 //y=1.595 //x2=73.745 //y2=1.595
r488 (  72 94 ) resistor r=56.4043 //w=0.094 //l=0.11 //layer=ply \
 //thickness=0.18 //x=73.635 //y=1.595 //x2=73.525 //y2=1.595
r489 (  69 163 ) resistor r=152 //w=0.17 //l=0.17 //layer=licon //count=1 \
 //x=86.72 //y=4.885 //x2=86.72 //y2=4.885
r490 (  69 70 ) resistor r=10.3507 //w=0.207 //l=0.165 //layer=li \
 //thickness=0.1 //x=86.71 //y=4.885 //x2=86.71 //y2=4.72
r491 (  67 151 ) resistor r=152 //w=0.17 //l=0.17 //layer=licon //count=1 \
 //x=80.08 //y=4.885 //x2=80.08 //y2=4.885
r492 (  64 70 ) resistor r=32.1711 //w=0.187 //l=0.47 //layer=li \
 //thickness=0.1 //x=86.7 //y=4.25 //x2=86.7 //y2=4.72
r493 (  61 159 ) resistor r=152 //w=0.17 //l=0.17 //layer=licon //count=1 \
 //x=86.7 //y=2.26 //x2=86.7 //y2=2.26
r494 (  61 64 ) resistor r=136.214 //w=0.187 //l=1.99 //layer=li \
 //thickness=0.1 //x=86.7 //y=2.26 //x2=86.7 //y2=4.25
r495 (  56 58 ) resistor r=25.3262 //w=0.187 //l=0.37 //layer=li \
 //thickness=0.1 //x=80.04 //y=3.88 //x2=80.04 //y2=4.25
r496 (  53 147 ) resistor r=152 //w=0.17 //l=0.17 //layer=licon //count=1 \
 //x=80.04 //y=2.26 //x2=80.04 //y2=2.26
r497 (  53 56 ) resistor r=110.888 //w=0.187 //l=1.62 //layer=li \
 //thickness=0.1 //x=80.04 //y=2.26 //x2=80.04 //y2=3.88
r498 (  51 67 ) resistor r=11.2426 //w=0.191 //l=0.174714 //layer=li \
 //thickness=0.1 //x=80.04 //y=4.72 //x2=80.06 //y2=4.885
r499 (  51 58 ) resistor r=32.1711 //w=0.187 //l=0.47 //layer=li \
 //thickness=0.1 //x=80.04 //y=4.72 //x2=80.04 //y2=4.25
r500 (  48 50 ) resistor r=96.8556 //w=0.187 //l=1.415 //layer=li \
 //thickness=0.1 //x=77.45 //y=5.295 //x2=77.45 //y2=3.88
r501 (  47 50 ) resistor r=134.16 //w=0.187 //l=1.96 //layer=li \
 //thickness=0.1 //x=77.45 //y=1.92 //x2=77.45 //y2=3.88
r502 (  45 47 ) resistor r=7.15173 //w=0.17 //l=0.120208 //layer=li \
 //thickness=0.1 //x=77.365 //y=1.835 //x2=77.45 //y2=1.92
r503 (  45 46 ) resistor r=18.4813 //w=0.187 //l=0.27 //layer=li \
 //thickness=0.1 //x=77.365 //y=1.835 //x2=77.095 //y2=1.835
r504 (  44 65 ) resistor r=5.4201 //w=0.17 //l=0.085 //layer=li \
 //thickness=0.1 //x=77.055 //y=5.38 //x2=76.97 //y2=5.38
r505 (  43 48 ) resistor r=7.15173 //w=0.17 //l=0.120208 //layer=li \
 //thickness=0.1 //x=77.365 //y=5.38 //x2=77.45 //y2=5.295
r506 (  43 44 ) resistor r=21.2193 //w=0.187 //l=0.31 //layer=li \
 //thickness=0.1 //x=77.365 //y=5.38 //x2=77.055 //y2=5.38
r507 (  39 46 ) resistor r=7.15173 //w=0.17 //l=0.120208 //layer=li \
 //thickness=0.1 //x=77.01 //y=1.75 //x2=77.095 //y2=1.835
r508 (  39 171 ) resistor r=39.016 //w=0.187 //l=0.57 //layer=li \
 //thickness=0.1 //x=77.01 //y=1.75 //x2=77.01 //y2=1.18
r509 (  33 65 ) resistor r=1.40859 //w=0.34 //l=0.085 //layer=li \
 //thickness=0.1 //x=76.97 //y=5.465 //x2=76.97 //y2=5.38
r510 (  33 174 ) resistor r=30.1176 //w=0.187 //l=0.44 //layer=li \
 //thickness=0.1 //x=76.97 //y=5.465 //x2=76.97 //y2=5.905
r511 (  31 65 ) resistor r=5.4201 //w=0.17 //l=0.085 //layer=li \
 //thickness=0.1 //x=76.885 //y=5.38 //x2=76.97 //y2=5.38
r512 (  31 32 ) resistor r=48.5989 //w=0.187 //l=0.71 //layer=li \
 //thickness=0.1 //x=76.885 //y=5.38 //x2=76.175 //y2=5.38
r513 (  25 32 ) resistor r=7.15173 //w=0.17 //l=0.120208 //layer=li \
 //thickness=0.1 //x=76.09 //y=5.465 //x2=76.175 //y2=5.38
r514 (  25 173 ) resistor r=30.1176 //w=0.187 //l=0.44 //layer=li \
 //thickness=0.1 //x=76.09 //y=5.465 //x2=76.09 //y2=5.905
r515 (  23 143 ) resistor r=152 //w=0.17 //l=0.17 //layer=licon //count=1 \
 //x=73.38 //y=4.88 //x2=73.38 //y2=4.88
r516 (  21 23 ) resistor r=68.4492 //w=0.187 //l=1 //layer=li //thickness=0.1 \
 //x=73.38 //y=3.88 //x2=73.38 //y2=4.88
r517 (  18 137 ) resistor r=152 //w=0.17 //l=0.17 //layer=licon //count=1 \
 //x=73.38 //y=2.26 //x2=73.38 //y2=2.26
r518 (  18 21 ) resistor r=110.888 //w=0.187 //l=1.62 //layer=li \
 //thickness=0.1 //x=73.38 //y=2.26 //x2=73.38 //y2=3.88
r519 (  16 64 ) resistor r=9.3 //w=0.17 //l=0.17 //layer=mcon //count=1 \
 //x=86.7 //y=4.25 //x2=86.7 //y2=4.25
r520 (  14 56 ) resistor r=9.3 //w=0.17 //l=0.17 //layer=mcon //count=1 \
 //x=80.04 //y=3.88 //x2=80.04 //y2=3.88
r521 (  12 58 ) resistor r=9.3 //w=0.17 //l=0.17 //layer=mcon //count=1 \
 //x=80.04 //y=4.25 //x2=80.04 //y2=4.25
r522 (  10 50 ) resistor r=9.3 //w=0.17 //l=0.17 //layer=mcon //count=1 \
 //x=77.45 //y=3.88 //x2=77.45 //y2=3.88
r523 (  8 21 ) resistor r=9.3 //w=0.17 //l=0.17 //layer=mcon //count=1 \
 //x=73.38 //y=3.88 //x2=73.38 //y2=3.88
r524 (  6 12 ) resistor r=0.0717383 //w=0.224 //l=0.115 //layer=m1 \
 //thickness=0.36 //x=80.155 //y=4.25 //x2=80.04 //y2=4.25
r525 (  5 16 ) resistor r=0.0717383 //w=0.224 //l=0.115 //layer=m1 \
 //thickness=0.36 //x=86.585 //y=4.25 //x2=86.7 //y2=4.25
r526 (  5 6 ) resistor r=6.1355 //w=0.131 //l=6.43 //layer=m1 //thickness=0.36 \
 //x=86.585 //y=4.25 //x2=80.155 //y2=4.25
r527 (  4 10 ) resistor r=0.0880901 //w=0.191 //l=0.115 //layer=m1 \
 //thickness=0.36 //x=77.565 //y=3.88 //x2=77.45 //y2=3.88
r528 (  3 14 ) resistor r=0.0717383 //w=0.224 //l=0.115 //layer=m1 \
 //thickness=0.36 //x=79.925 //y=3.88 //x2=80.04 //y2=3.88
r529 (  3 4 ) resistor r=2.25191 //w=0.131 //l=2.36 //layer=m1 \
 //thickness=0.36 //x=79.925 //y=3.88 //x2=77.565 //y2=3.88
r530 (  2 8 ) resistor r=0.0717383 //w=0.224 //l=0.115 //layer=m1 \
 //thickness=0.36 //x=73.495 //y=3.88 //x2=73.38 //y2=3.88
r531 (  1 10 ) resistor r=0.0880901 //w=0.191 //l=0.115 //layer=m1 \
 //thickness=0.36 //x=77.335 //y=3.88 //x2=77.45 //y2=3.88
r532 (  1 2 ) resistor r=3.66412 //w=0.131 //l=3.84 //layer=m1 \
 //thickness=0.36 //x=77.335 //y=3.88 //x2=73.495 //y2=3.88
ends PM_TMRDFFRNQX1\%noxref_18

subckt PM_TMRDFFRNQX1\%noxref_19 ( 1 2 13 14 15 23 29 30 37 50 51 52 53 54 )
c91 ( 54 0 ) capacitor c=0.034295f //x=83.915 //y=5.205
c92 ( 53 0 ) capacitor c=0.0174957f //x=83.035 //y=5.205
c93 ( 51 0 ) capacitor c=0.0214849f //x=80.155 //y=5.205
c94 ( 50 0 ) capacitor c=0.0217161f //x=79.275 //y=5.205
c95 ( 49 0 ) capacitor c=0.00115294f //x=83.18 //y=7.09
c96 ( 37 0 ) capacitor c=0.0131238f //x=83.975 //y=7.09
c97 ( 30 0 ) capacitor c=0.00386507f //x=82.385 //y=7.09
c98 ( 29 0 ) capacitor c=0.00951687f //x=83.095 //y=7.09
c99 ( 23 0 ) capacitor c=0.0455351f //x=82.3 //y=5.39
c100 ( 15 0 ) capacitor c=0.00869404f //x=80.3 //y=5.475
c101 ( 14 0 ) capacitor c=0.00290434f //x=79.505 //y=5.39
c102 ( 13 0 ) capacitor c=0.0139202f //x=80.215 //y=5.39
c103 ( 2 0 ) capacitor c=0.0091252f //x=80.415 //y=5.39
c104 ( 1 0 ) capacitor c=0.0484159f //x=82.185 //y=5.39
r105 (  39 54 ) resistor r=5.81818 //w=0.187 //l=0.085 //layer=li \
 //thickness=0.1 //x=84.06 //y=7.005 //x2=84.06 //y2=6.92
r106 (  38 49 ) resistor r=5.4201 //w=0.17 //l=0.085 //layer=li \
 //thickness=0.1 //x=83.265 //y=7.09 //x2=83.18 //y2=7.09
r107 (  37 39 ) resistor r=7.15173 //w=0.17 //l=0.120208 //layer=li \
 //thickness=0.1 //x=83.975 //y=7.09 //x2=84.06 //y2=7.005
r108 (  37 38 ) resistor r=48.5989 //w=0.187 //l=0.71 //layer=li \
 //thickness=0.1 //x=83.975 //y=7.09 //x2=83.265 //y2=7.09
r109 (  31 49 ) resistor r=1.40859 //w=0.34 //l=0.085 //layer=li \
 //thickness=0.1 //x=83.18 //y=7.005 //x2=83.18 //y2=7.09
r110 (  31 53 ) resistor r=5.81818 //w=0.187 //l=0.085 //layer=li \
 //thickness=0.1 //x=83.18 //y=7.005 //x2=83.18 //y2=6.92
r111 (  29 49 ) resistor r=5.4201 //w=0.17 //l=0.085 //layer=li \
 //thickness=0.1 //x=83.095 //y=7.09 //x2=83.18 //y2=7.09
r112 (  29 30 ) resistor r=48.5989 //w=0.187 //l=0.71 //layer=li \
 //thickness=0.1 //x=83.095 //y=7.09 //x2=82.385 //y2=7.09
r113 (  23 52 ) resistor r=58.1818 //w=0.187 //l=0.85 //layer=li \
 //thickness=0.1 //x=82.3 //y=5.39 //x2=82.3 //y2=6.24
r114 (  21 30 ) resistor r=7.15173 //w=0.17 //l=0.120208 //layer=li \
 //thickness=0.1 //x=82.3 //y=7.005 //x2=82.385 //y2=7.09
r115 (  21 52 ) resistor r=5.81818 //w=0.187 //l=0.085 //layer=li \
 //thickness=0.1 //x=82.3 //y=7.005 //x2=82.3 //y2=6.92
r116 (  15 48 ) resistor r=3.57586 //w=0.17 //l=0.125 //layer=li \
 //thickness=0.1 //x=80.3 //y=5.475 //x2=80.3 //y2=5.35
r117 (  15 51 ) resistor r=52.3636 //w=0.187 //l=0.765 //layer=li \
 //thickness=0.1 //x=80.3 //y=5.475 //x2=80.3 //y2=6.24
r118 (  13 48 ) resistor r=3.57586 //w=0.17 //l=0.103078 //layer=li \
 //thickness=0.1 //x=80.215 //y=5.39 //x2=80.3 //y2=5.35
r119 (  13 14 ) resistor r=48.5989 //w=0.187 //l=0.71 //layer=li \
 //thickness=0.1 //x=80.215 //y=5.39 //x2=79.505 //y2=5.39
r120 (  7 14 ) resistor r=7.15173 //w=0.17 //l=0.120208 //layer=li \
 //thickness=0.1 //x=79.42 //y=5.475 //x2=79.505 //y2=5.39
r121 (  7 50 ) resistor r=29.0909 //w=0.187 //l=0.425 //layer=li \
 //thickness=0.1 //x=79.42 //y=5.475 //x2=79.42 //y2=5.9
r122 (  6 23 ) resistor r=9.3 //w=0.17 //l=0.17 //layer=mcon //count=1 \
 //x=82.3 //y=5.39 //x2=82.3 //y2=5.39
r123 (  4 48 ) resistor r=9.3 //w=0.17 //l=0.17 //layer=mcon //count=1 \
 //x=80.3 //y=5.39 //x2=80.3 //y2=5.39
r124 (  2 4 ) resistor r=0.0717383 //w=0.224 //l=0.115 //layer=m1 \
 //thickness=0.36 //x=80.415 //y=5.39 //x2=80.3 //y2=5.39
r125 (  1 6 ) resistor r=0.0717383 //w=0.224 //l=0.115 //layer=m1 \
 //thickness=0.36 //x=82.185 //y=5.39 //x2=82.3 //y2=5.39
r126 (  1 2 ) resistor r=1.68893 //w=0.131 //l=1.77 //layer=m1 \
 //thickness=0.36 //x=82.185 //y=5.39 //x2=80.415 //y2=5.39
ends PM_TMRDFFRNQX1\%noxref_19

subckt PM_TMRDFFRNQX1\%noxref_20 ( 1 2 3 4 5 6 18 31 32 43 45 46 50 52 61 67 \
 68 69 70 71 72 73 74 75 76 80 81 82 87 89 92 93 97 98 99 100 101 103 106 109 \
 110 111 112 113 114 115 116 120 122 125 126 127 128 133 134 139 151 158 160 \
 161 )
c493 ( 161 0 ) capacitor c=0.0220291f //x=25.025 //y=5.2
c494 ( 160 0 ) capacitor c=0.0217503f //x=24.145 //y=5.2
c495 ( 158 0 ) capacitor c=0.0084702f //x=25.02 //y=1.085
c496 ( 151 0 ) capacitor c=0.0583848f //x=85.59 //y=2.26
c497 ( 139 0 ) capacitor c=0.0587755f //x=21.58 //y=4.88
c498 ( 134 0 ) capacitor c=0.0273931f //x=21.58 //y=2.095
c499 ( 133 0 ) capacitor c=0.0456313f //x=21.58 //y=2.26
c500 ( 128 0 ) capacitor c=0.0316774f //x=86.295 //y=1.39
c501 ( 127 0 ) capacitor c=0.0187384f //x=86.295 //y=1.045
c502 ( 126 0 ) capacitor c=0.0590362f //x=85.935 //y=4.975
c503 ( 125 0 ) capacitor c=0.0296075f //x=86.225 //y=4.975
c504 ( 122 0 ) capacitor c=0.0157912f //x=86.14 //y=1.545
c505 ( 120 0 ) capacitor c=0.0149844f //x=86.14 //y=0.89
c506 ( 116 0 ) capacitor c=0.0302441f //x=85.765 //y=2.095
c507 ( 115 0 ) capacitor c=0.0234157f //x=85.765 //y=1.7
c508 ( 114 0 ) capacitor c=0.0234376f //x=85.765 //y=1.39
c509 ( 113 0 ) capacitor c=0.0199931f //x=85.765 //y=1.045
c510 ( 112 0 ) capacitor c=0.093437f //x=83.935 //y=2.095
c511 ( 111 0 ) capacitor c=0.0249466f //x=83.935 //y=1.74
c512 ( 110 0 ) capacitor c=0.0234397f //x=83.935 //y=1.43
c513 ( 109 0 ) capacitor c=0.0193195f //x=83.935 //y=1.085
c514 ( 106 0 ) capacitor c=0.0631944f //x=83.84 //y=5.05
c515 ( 103 0 ) capacitor c=0.0187941f //x=83.78 //y=1.585
c516 ( 101 0 ) capacitor c=0.0157803f //x=83.78 //y=0.93
c517 ( 100 0 ) capacitor c=0.010629f //x=83.475 //y=4.975
c518 ( 99 0 ) capacitor c=0.0194269f //x=83.765 //y=4.975
c519 ( 98 0 ) capacitor c=0.0365717f //x=83.405 //y=1.43
c520 ( 97 0 ) capacitor c=0.0175988f //x=83.405 //y=1.085
c521 ( 93 0 ) capacitor c=0.0432517f //x=22.1 //y=1.44
c522 ( 92 0 ) capacitor c=0.0200379f //x=22.1 //y=1.095
c523 ( 89 0 ) capacitor c=0.0148873f //x=21.945 //y=1.595
c524 ( 87 0 ) capacitor c=0.0157803f //x=21.945 //y=0.94
c525 ( 82 0 ) capacitor c=0.0218028f //x=21.57 //y=1.75
c526 ( 81 0 ) capacitor c=0.0207459f //x=21.57 //y=1.44
c527 ( 80 0 ) capacitor c=0.0194308f //x=21.57 //y=1.095
c528 ( 76 0 ) capacitor c=0.110622f //x=86.3 //y=6.205
c529 ( 75 0 ) capacitor c=0.154068f //x=85.86 //y=6.205
c530 ( 74 0 ) capacitor c=0.154291f //x=83.84 //y=6.205
c531 ( 73 0 ) capacitor c=0.110404f //x=83.4 //y=6.205
c532 ( 72 0 ) capacitor c=0.158794f //x=21.76 //y=6.2
c533 ( 71 0 ) capacitor c=0.110114f //x=21.32 //y=6.2
c534 ( 67 0 ) capacitor c=0.00211606f //x=25.17 //y=5.38
c535 ( 61 0 ) capacitor c=0.100881f //x=85.59 //y=2.26
c536 ( 52 0 ) capacitor c=0.105664f //x=84.11 //y=2.26
c537 ( 50 0 ) capacitor c=0.110129f //x=25.65 //y=3.14
c538 ( 46 0 ) capacitor c=0.00404073f //x=25.295 //y=1.835
c539 ( 45 0 ) capacitor c=0.0122201f //x=25.565 //y=1.835
c540 ( 43 0 ) capacitor c=0.0137995f //x=25.565 //y=5.38
c541 ( 32 0 ) capacitor c=0.00251635f //x=24.375 //y=5.38
c542 ( 31 0 ) capacitor c=0.0143649f //x=25.085 //y=5.38
c543 ( 18 0 ) capacitor c=0.0841327f //x=21.58 //y=2.26
c544 ( 6 0 ) capacitor c=0.0110448f //x=84.225 //y=2.26
c545 ( 5 0 ) capacitor c=0.0462526f //x=85.475 //y=2.26
c546 ( 4 0 ) capacitor c=0.00475948f //x=25.765 //y=3.14
c547 ( 3 0 ) capacitor c=1.08103f //x=83.995 //y=3.14
c548 ( 2 0 ) capacitor c=0.0130277f //x=21.695 //y=3.14
c549 ( 1 0 ) capacitor c=0.0776942f //x=25.535 //y=3.14
r550 (  133 134 ) resistor r=52.7279 //w=0.214 //l=0.165 //layer=ply \
 //thickness=0.18 //x=21.58 //y=2.26 //x2=21.58 //y2=2.095
r551 (  128 157 ) resistor r=45.1352 //w=0.168 //l=0.173853 //layer=ply \
 //thickness=0.18 //x=86.295 //y=1.39 //x2=86.255 //y2=1.545
r552 (  127 156 ) resistor r=45.1352 //w=0.168 //l=0.173853 //layer=ply \
 //thickness=0.18 //x=86.295 //y=1.045 //x2=86.255 //y2=0.89
r553 (  127 128 ) resistor r=176.904 //w=0.094 //l=0.345 //layer=ply \
 //thickness=0.18 //x=86.295 //y=1.045 //x2=86.295 //y2=1.39
r554 (  125 129 ) resistor r=26.9307 //w=0.15 //l=0.106066 //layer=ply \
 //thickness=0.18 //x=86.225 //y=4.975 //x2=86.3 //y2=5.05
r555 (  125 126 ) resistor r=148.702 //w=0.094 //l=0.29 //layer=ply \
 //thickness=0.18 //x=86.225 //y=4.975 //x2=85.935 //y2=4.975
r556 (  123 155 ) resistor r=10.701 //w=0.21 //l=0.115 //layer=ply \
 //thickness=0.18 //x=85.92 //y=1.545 //x2=85.805 //y2=1.545
r557 (  122 157 ) resistor r=5.52526 //w=0.168 //l=0.115 //layer=ply \
 //thickness=0.18 //x=86.14 //y=1.545 //x2=86.255 //y2=1.545
r558 (  121 154 ) resistor r=5.52526 //w=0.168 //l=0.115 //layer=ply \
 //thickness=0.18 //x=85.92 //y=0.89 //x2=85.805 //y2=0.89
r559 (  120 156 ) resistor r=5.52526 //w=0.168 //l=0.115 //layer=ply \
 //thickness=0.18 //x=86.14 //y=0.89 //x2=86.255 //y2=0.89
r560 (  120 121 ) resistor r=112.809 //w=0.094 //l=0.22 //layer=ply \
 //thickness=0.18 //x=86.14 //y=0.89 //x2=85.92 //y2=0.89
r561 (  117 126 ) resistor r=22.1787 //w=0.252 //l=0.106066 //layer=ply \
 //thickness=0.18 //x=85.86 //y=5.05 //x2=85.935 //y2=4.975
r562 (  117 153 ) resistor r=51.6429 //w=0.252 //l=0.34271 //layer=ply \
 //thickness=0.18 //x=85.86 //y=5.05 //x2=85.59 //y2=4.885
r563 (  116 151 ) resistor r=30.4513 //w=0.277 //l=0.243926 //layer=ply \
 //thickness=0.18 //x=85.765 //y=2.095 //x2=85.59 //y2=2.26
r564 (  115 155 ) resistor r=39.5823 //w=0.21 //l=0.173853 //layer=ply \
 //thickness=0.18 //x=85.765 //y=1.7 //x2=85.805 //y2=1.545
r565 (  115 116 ) resistor r=202.543 //w=0.094 //l=0.395 //layer=ply \
 //thickness=0.18 //x=85.765 //y=1.7 //x2=85.765 //y2=2.095
r566 (  114 155 ) resistor r=39.5823 //w=0.21 //l=0.173853 //layer=ply \
 //thickness=0.18 //x=85.765 //y=1.39 //x2=85.805 //y2=1.545
r567 (  113 154 ) resistor r=45.1352 //w=0.168 //l=0.173853 //layer=ply \
 //thickness=0.18 //x=85.765 //y=1.045 //x2=85.805 //y2=0.89
r568 (  113 114 ) resistor r=176.904 //w=0.094 //l=0.345 //layer=ply \
 //thickness=0.18 //x=85.765 //y=1.045 //x2=85.765 //y2=1.39
r569 (  112 147 ) resistor r=30.4513 //w=0.277 //l=0.243926 //layer=ply \
 //thickness=0.18 //x=83.935 //y=2.095 //x2=84.11 //y2=2.26
r570 (  111 145 ) resistor r=39.5823 //w=0.21 //l=0.173853 //layer=ply \
 //thickness=0.18 //x=83.935 //y=1.74 //x2=83.895 //y2=1.585
r571 (  111 112 ) resistor r=182.032 //w=0.094 //l=0.355 //layer=ply \
 //thickness=0.18 //x=83.935 //y=1.74 //x2=83.935 //y2=2.095
r572 (  110 145 ) resistor r=39.5823 //w=0.21 //l=0.173853 //layer=ply \
 //thickness=0.18 //x=83.935 //y=1.43 //x2=83.895 //y2=1.585
r573 (  109 144 ) resistor r=45.1352 //w=0.168 //l=0.173853 //layer=ply \
 //thickness=0.18 //x=83.935 //y=1.085 //x2=83.895 //y2=0.93
r574 (  109 110 ) resistor r=176.904 //w=0.094 //l=0.345 //layer=ply \
 //thickness=0.18 //x=83.935 //y=1.085 //x2=83.935 //y2=1.43
r575 (  106 149 ) resistor r=51.6429 //w=0.252 //l=0.34271 //layer=ply \
 //thickness=0.18 //x=83.84 //y=5.05 //x2=84.11 //y2=4.885
r576 (  104 143 ) resistor r=5.52526 //w=0.168 //l=0.115 //layer=ply \
 //thickness=0.18 //x=83.56 //y=1.585 //x2=83.445 //y2=1.585
r577 (  103 145 ) resistor r=10.701 //w=0.21 //l=0.115 //layer=ply \
 //thickness=0.18 //x=83.78 //y=1.585 //x2=83.895 //y2=1.585
r578 (  102 142 ) resistor r=5.52526 //w=0.168 //l=0.115 //layer=ply \
 //thickness=0.18 //x=83.56 //y=0.93 //x2=83.445 //y2=0.93
r579 (  101 144 ) resistor r=5.52526 //w=0.168 //l=0.115 //layer=ply \
 //thickness=0.18 //x=83.78 //y=0.93 //x2=83.895 //y2=0.93
r580 (  101 102 ) resistor r=112.809 //w=0.094 //l=0.22 //layer=ply \
 //thickness=0.18 //x=83.78 //y=0.93 //x2=83.56 //y2=0.93
r581 (  99 106 ) resistor r=22.1787 //w=0.252 //l=0.106066 //layer=ply \
 //thickness=0.18 //x=83.765 //y=4.975 //x2=83.84 //y2=5.05
r582 (  99 100 ) resistor r=148.702 //w=0.094 //l=0.29 //layer=ply \
 //thickness=0.18 //x=83.765 //y=4.975 //x2=83.475 //y2=4.975
r583 (  98 143 ) resistor r=45.1352 //w=0.168 //l=0.173853 //layer=ply \
 //thickness=0.18 //x=83.405 //y=1.43 //x2=83.445 //y2=1.585
r584 (  97 142 ) resistor r=45.1352 //w=0.168 //l=0.173853 //layer=ply \
 //thickness=0.18 //x=83.405 //y=1.085 //x2=83.445 //y2=0.93
r585 (  97 98 ) resistor r=176.904 //w=0.094 //l=0.345 //layer=ply \
 //thickness=0.18 //x=83.405 //y=1.085 //x2=83.405 //y2=1.43
r586 (  94 100 ) resistor r=26.9307 //w=0.15 //l=0.106066 //layer=ply \
 //thickness=0.18 //x=83.4 //y=5.05 //x2=83.475 //y2=4.975
r587 (  93 141 ) resistor r=45.1352 //w=0.168 //l=0.173853 //layer=ply \
 //thickness=0.18 //x=22.1 //y=1.44 //x2=22.06 //y2=1.595
r588 (  92 140 ) resistor r=45.1352 //w=0.168 //l=0.173853 //layer=ply \
 //thickness=0.18 //x=22.1 //y=1.095 //x2=22.06 //y2=0.94
r589 (  92 93 ) resistor r=176.904 //w=0.094 //l=0.345 //layer=ply \
 //thickness=0.18 //x=22.1 //y=1.095 //x2=22.1 //y2=1.44
r590 (  90 137 ) resistor r=10.701 //w=0.21 //l=0.115 //layer=ply \
 //thickness=0.18 //x=21.725 //y=1.595 //x2=21.61 //y2=1.595
r591 (  89 141 ) resistor r=5.52526 //w=0.168 //l=0.115 //layer=ply \
 //thickness=0.18 //x=21.945 //y=1.595 //x2=22.06 //y2=1.595
r592 (  88 136 ) resistor r=5.52526 //w=0.168 //l=0.115 //layer=ply \
 //thickness=0.18 //x=21.725 //y=0.94 //x2=21.61 //y2=0.94
r593 (  87 140 ) resistor r=5.52526 //w=0.168 //l=0.115 //layer=ply \
 //thickness=0.18 //x=21.945 //y=0.94 //x2=22.06 //y2=0.94
r594 (  87 88 ) resistor r=112.809 //w=0.094 //l=0.22 //layer=ply \
 //thickness=0.18 //x=21.945 //y=0.94 //x2=21.725 //y2=0.94
r595 (  84 139 ) resistor r=37.236 //w=0.233 //l=0.249199 //layer=ply \
 //thickness=0.18 //x=21.76 //y=5.045 //x2=21.58 //y2=4.88
r596 (  82 137 ) resistor r=39.5823 //w=0.21 //l=0.173853 //layer=ply \
 //thickness=0.18 //x=21.57 //y=1.75 //x2=21.61 //y2=1.595
r597 (  82 134 ) resistor r=176.904 //w=0.094 //l=0.345 //layer=ply \
 //thickness=0.18 //x=21.57 //y=1.75 //x2=21.57 //y2=2.095
r598 (  81 137 ) resistor r=39.5823 //w=0.21 //l=0.173853 //layer=ply \
 //thickness=0.18 //x=21.57 //y=1.44 //x2=21.61 //y2=1.595
r599 (  80 136 ) resistor r=45.1352 //w=0.168 //l=0.173853 //layer=ply \
 //thickness=0.18 //x=21.57 //y=1.095 //x2=21.61 //y2=0.94
r600 (  80 81 ) resistor r=176.904 //w=0.094 //l=0.345 //layer=ply \
 //thickness=0.18 //x=21.57 //y=1.095 //x2=21.57 //y2=1.44
r601 (  77 139 ) resistor r=53.7854 //w=0.233 //l=0.332415 //layer=ply \
 //thickness=0.18 //x=21.32 //y=5.045 //x2=21.58 //y2=4.88
r602 (  76 129 ) resistor r=592.245 //w=0.094 //l=1.155 //layer=ply \
 //thickness=0.18 //x=86.3 //y=6.205 //x2=86.3 //y2=5.05
r603 (  75 117 ) resistor r=592.245 //w=0.094 //l=1.155 //layer=ply \
 //thickness=0.18 //x=85.86 //y=6.205 //x2=85.86 //y2=5.05
r604 (  74 106 ) resistor r=592.245 //w=0.094 //l=1.155 //layer=ply \
 //thickness=0.18 //x=83.84 //y=6.205 //x2=83.84 //y2=5.05
r605 (  73 94 ) resistor r=592.245 //w=0.094 //l=1.155 //layer=ply \
 //thickness=0.18 //x=83.4 //y=6.205 //x2=83.4 //y2=5.05
r606 (  72 84 ) resistor r=592.245 //w=0.094 //l=1.155 //layer=ply \
 //thickness=0.18 //x=21.76 //y=6.2 //x2=21.76 //y2=5.045
r607 (  71 77 ) resistor r=592.245 //w=0.094 //l=1.155 //layer=ply \
 //thickness=0.18 //x=21.32 //y=6.2 //x2=21.32 //y2=5.045
r608 (  70 122 ) resistor r=56.4043 //w=0.094 //l=0.11 //layer=ply \
 //thickness=0.18 //x=86.03 //y=1.545 //x2=86.14 //y2=1.545
r609 (  70 123 ) resistor r=56.4043 //w=0.094 //l=0.11 //layer=ply \
 //thickness=0.18 //x=86.03 //y=1.545 //x2=85.92 //y2=1.545
r610 (  69 103 ) resistor r=56.4043 //w=0.094 //l=0.11 //layer=ply \
 //thickness=0.18 //x=83.67 //y=1.585 //x2=83.78 //y2=1.585
r611 (  69 104 ) resistor r=56.4043 //w=0.094 //l=0.11 //layer=ply \
 //thickness=0.18 //x=83.67 //y=1.585 //x2=83.56 //y2=1.585
r612 (  68 89 ) resistor r=56.4043 //w=0.094 //l=0.11 //layer=ply \
 //thickness=0.18 //x=21.835 //y=1.595 //x2=21.945 //y2=1.595
r613 (  68 90 ) resistor r=56.4043 //w=0.094 //l=0.11 //layer=ply \
 //thickness=0.18 //x=21.835 //y=1.595 //x2=21.725 //y2=1.595
r614 (  65 153 ) resistor r=152 //w=0.17 //l=0.17 //layer=licon //count=1 \
 //x=85.59 //y=4.885 //x2=85.59 //y2=4.885
r615 (  61 151 ) resistor r=152 //w=0.17 //l=0.17 //layer=licon //count=1 \
 //x=85.59 //y=2.26 //x2=85.59 //y2=2.26
r616 (  61 65 ) resistor r=179.679 //w=0.187 //l=2.625 //layer=li \
 //thickness=0.1 //x=85.59 //y=2.26 //x2=85.59 //y2=4.885
r617 (  58 149 ) resistor r=152 //w=0.17 //l=0.17 //layer=licon //count=1 \
 //x=84.11 //y=4.885 //x2=84.11 //y2=4.885
r618 (  56 58 ) resistor r=119.444 //w=0.187 //l=1.745 //layer=li \
 //thickness=0.1 //x=84.11 //y=3.14 //x2=84.11 //y2=4.885
r619 (  52 147 ) resistor r=152 //w=0.17 //l=0.17 //layer=licon //count=1 \
 //x=84.11 //y=2.26 //x2=84.11 //y2=2.26
r620 (  52 56 ) resistor r=60.2353 //w=0.187 //l=0.88 //layer=li \
 //thickness=0.1 //x=84.11 //y=2.26 //x2=84.11 //y2=3.14
r621 (  48 50 ) resistor r=147.508 //w=0.187 //l=2.155 //layer=li \
 //thickness=0.1 //x=25.65 //y=5.295 //x2=25.65 //y2=3.14
r622 (  47 50 ) resistor r=83.508 //w=0.187 //l=1.22 //layer=li \
 //thickness=0.1 //x=25.65 //y=1.92 //x2=25.65 //y2=3.14
r623 (  45 47 ) resistor r=7.15173 //w=0.17 //l=0.120208 //layer=li \
 //thickness=0.1 //x=25.565 //y=1.835 //x2=25.65 //y2=1.92
r624 (  45 46 ) resistor r=18.4813 //w=0.187 //l=0.27 //layer=li \
 //thickness=0.1 //x=25.565 //y=1.835 //x2=25.295 //y2=1.835
r625 (  44 67 ) resistor r=5.4201 //w=0.17 //l=0.085 //layer=li \
 //thickness=0.1 //x=25.255 //y=5.38 //x2=25.17 //y2=5.38
r626 (  43 48 ) resistor r=7.15173 //w=0.17 //l=0.120208 //layer=li \
 //thickness=0.1 //x=25.565 //y=5.38 //x2=25.65 //y2=5.295
r627 (  43 44 ) resistor r=21.2193 //w=0.187 //l=0.31 //layer=li \
 //thickness=0.1 //x=25.565 //y=5.38 //x2=25.255 //y2=5.38
r628 (  39 46 ) resistor r=7.15173 //w=0.17 //l=0.120208 //layer=li \
 //thickness=0.1 //x=25.21 //y=1.75 //x2=25.295 //y2=1.835
r629 (  39 158 ) resistor r=39.016 //w=0.187 //l=0.57 //layer=li \
 //thickness=0.1 //x=25.21 //y=1.75 //x2=25.21 //y2=1.18
r630 (  33 67 ) resistor r=1.40859 //w=0.34 //l=0.085 //layer=li \
 //thickness=0.1 //x=25.17 //y=5.465 //x2=25.17 //y2=5.38
r631 (  33 161 ) resistor r=30.1176 //w=0.187 //l=0.44 //layer=li \
 //thickness=0.1 //x=25.17 //y=5.465 //x2=25.17 //y2=5.905
r632 (  31 67 ) resistor r=5.4201 //w=0.17 //l=0.085 //layer=li \
 //thickness=0.1 //x=25.085 //y=5.38 //x2=25.17 //y2=5.38
r633 (  31 32 ) resistor r=48.5989 //w=0.187 //l=0.71 //layer=li \
 //thickness=0.1 //x=25.085 //y=5.38 //x2=24.375 //y2=5.38
r634 (  25 32 ) resistor r=7.15173 //w=0.17 //l=0.120208 //layer=li \
 //thickness=0.1 //x=24.29 //y=5.465 //x2=24.375 //y2=5.38
r635 (  25 160 ) resistor r=30.1176 //w=0.187 //l=0.44 //layer=li \
 //thickness=0.1 //x=24.29 //y=5.465 //x2=24.29 //y2=5.905
r636 (  23 139 ) resistor r=152 //w=0.17 //l=0.17 //layer=licon //count=1 \
 //x=21.58 //y=4.88 //x2=21.58 //y2=4.88
r637 (  21 23 ) resistor r=119.102 //w=0.187 //l=1.74 //layer=li \
 //thickness=0.1 //x=21.58 //y=3.14 //x2=21.58 //y2=4.88
r638 (  18 133 ) resistor r=152 //w=0.17 //l=0.17 //layer=licon //count=1 \
 //x=21.58 //y=2.26 //x2=21.58 //y2=2.26
r639 (  18 21 ) resistor r=60.2353 //w=0.187 //l=0.88 //layer=li \
 //thickness=0.1 //x=21.58 //y=2.26 //x2=21.58 //y2=3.14
r640 (  16 61 ) resistor r=9.3 //w=0.17 //l=0.17 //layer=mcon //count=1 \
 //x=85.59 //y=2.26 //x2=85.59 //y2=2.26
r641 (  14 56 ) resistor r=9.3 //w=0.17 //l=0.17 //layer=mcon //count=1 \
 //x=84.11 //y=3.14 //x2=84.11 //y2=3.14
r642 (  12 52 ) resistor r=9.3 //w=0.17 //l=0.17 //layer=mcon //count=1 \
 //x=84.11 //y=2.26 //x2=84.11 //y2=2.26
r643 (  10 50 ) resistor r=9.3 //w=0.17 //l=0.17 //layer=mcon //count=1 \
 //x=25.65 //y=3.14 //x2=25.65 //y2=3.14
r644 (  8 21 ) resistor r=9.3 //w=0.17 //l=0.17 //layer=mcon //count=1 \
 //x=21.58 //y=3.14 //x2=21.58 //y2=3.14
r645 (  6 12 ) resistor r=0.0717383 //w=0.224 //l=0.115 //layer=m1 \
 //thickness=0.36 //x=84.225 //y=2.26 //x2=84.11 //y2=2.26
r646 (  5 16 ) resistor r=0.0717383 //w=0.224 //l=0.115 //layer=m1 \
 //thickness=0.36 //x=85.475 //y=2.26 //x2=85.59 //y2=2.26
r647 (  5 6 ) resistor r=1.19275 //w=0.131 //l=1.25 //layer=m1 \
 //thickness=0.36 //x=85.475 //y=2.26 //x2=84.225 //y2=2.26
r648 (  4 10 ) resistor r=0.0880901 //w=0.191 //l=0.115 //layer=m1 \
 //thickness=0.36 //x=25.765 //y=3.14 //x2=25.65 //y2=3.14
r649 (  3 14 ) resistor r=0.0717383 //w=0.224 //l=0.115 //layer=m1 \
 //thickness=0.36 //x=83.995 //y=3.14 //x2=84.11 //y2=3.14
r650 (  3 4 ) resistor r=55.563 //w=0.131 //l=58.23 //layer=m1 \
 //thickness=0.36 //x=83.995 //y=3.14 //x2=25.765 //y2=3.14
r651 (  2 8 ) resistor r=0.0717383 //w=0.224 //l=0.115 //layer=m1 \
 //thickness=0.36 //x=21.695 //y=3.14 //x2=21.58 //y2=3.14
r652 (  1 10 ) resistor r=0.0880901 //w=0.191 //l=0.115 //layer=m1 \
 //thickness=0.36 //x=25.535 //y=3.14 //x2=25.65 //y2=3.14
r653 (  1 2 ) resistor r=3.66412 //w=0.131 //l=3.84 //layer=m1 \
 //thickness=0.36 //x=25.535 //y=3.14 //x2=21.695 //y2=3.14
ends PM_TMRDFFRNQX1\%noxref_20

subckt PM_TMRDFFRNQX1\%noxref_21 ( 1 2 13 14 15 21 27 28 35 46 47 48 49 50 )
c90 ( 50 0 ) capacitor c=0.0306574f //x=87.255 //y=5.205
c91 ( 49 0 ) capacitor c=0.0173945f //x=86.375 //y=5.205
c92 ( 47 0 ) capacitor c=0.0169278f //x=83.475 //y=5.205
c93 ( 46 0 ) capacitor c=0.0166762f //x=82.595 //y=5.205
c94 ( 45 0 ) capacitor c=0.00115294f //x=86.52 //y=7.09
c95 ( 35 0 ) capacitor c=0.0132983f //x=87.315 //y=7.09
c96 ( 28 0 ) capacitor c=0.00388794f //x=85.725 //y=7.09
c97 ( 27 0 ) capacitor c=0.00985708f //x=86.435 //y=7.09
c98 ( 21 0 ) capacitor c=0.0442221f //x=85.64 //y=5.39
c99 ( 15 0 ) capacitor c=0.0105083f //x=83.62 //y=5.475
c100 ( 14 0 ) capacitor c=0.00227812f //x=82.825 //y=5.39
c101 ( 13 0 ) capacitor c=0.0174384f //x=83.535 //y=5.39
c102 ( 2 0 ) capacitor c=0.00682032f //x=83.735 //y=5.39
c103 ( 1 0 ) capacitor c=0.0573196f //x=85.525 //y=5.39
r104 (  37 50 ) resistor r=5.81818 //w=0.187 //l=0.085 //layer=li \
 //thickness=0.1 //x=87.4 //y=7.005 //x2=87.4 //y2=6.92
r105 (  36 45 ) resistor r=5.4201 //w=0.17 //l=0.085 //layer=li \
 //thickness=0.1 //x=86.605 //y=7.09 //x2=86.52 //y2=7.09
r106 (  35 37 ) resistor r=7.15173 //w=0.17 //l=0.120208 //layer=li \
 //thickness=0.1 //x=87.315 //y=7.09 //x2=87.4 //y2=7.005
r107 (  35 36 ) resistor r=48.5989 //w=0.187 //l=0.71 //layer=li \
 //thickness=0.1 //x=87.315 //y=7.09 //x2=86.605 //y2=7.09
r108 (  29 45 ) resistor r=1.40859 //w=0.34 //l=0.085 //layer=li \
 //thickness=0.1 //x=86.52 //y=7.005 //x2=86.52 //y2=7.09
r109 (  29 49 ) resistor r=5.81818 //w=0.187 //l=0.085 //layer=li \
 //thickness=0.1 //x=86.52 //y=7.005 //x2=86.52 //y2=6.92
r110 (  27 45 ) resistor r=5.4201 //w=0.17 //l=0.085 //layer=li \
 //thickness=0.1 //x=86.435 //y=7.09 //x2=86.52 //y2=7.09
r111 (  27 28 ) resistor r=48.5989 //w=0.187 //l=0.71 //layer=li \
 //thickness=0.1 //x=86.435 //y=7.09 //x2=85.725 //y2=7.09
r112 (  21 48 ) resistor r=58.1818 //w=0.187 //l=0.85 //layer=li \
 //thickness=0.1 //x=85.64 //y=5.39 //x2=85.64 //y2=6.24
r113 (  19 28 ) resistor r=7.15173 //w=0.17 //l=0.120208 //layer=li \
 //thickness=0.1 //x=85.64 //y=7.005 //x2=85.725 //y2=7.09
r114 (  19 48 ) resistor r=5.81818 //w=0.187 //l=0.085 //layer=li \
 //thickness=0.1 //x=85.64 //y=7.005 //x2=85.64 //y2=6.92
r115 (  15 44 ) resistor r=3.57586 //w=0.17 //l=0.125 //layer=li \
 //thickness=0.1 //x=83.62 //y=5.475 //x2=83.62 //y2=5.35
r116 (  15 47 ) resistor r=52.3636 //w=0.187 //l=0.765 //layer=li \
 //thickness=0.1 //x=83.62 //y=5.475 //x2=83.62 //y2=6.24
r117 (  13 44 ) resistor r=3.57586 //w=0.17 //l=0.103078 //layer=li \
 //thickness=0.1 //x=83.535 //y=5.39 //x2=83.62 //y2=5.35
r118 (  13 14 ) resistor r=48.5989 //w=0.187 //l=0.71 //layer=li \
 //thickness=0.1 //x=83.535 //y=5.39 //x2=82.825 //y2=5.39
r119 (  7 14 ) resistor r=7.15173 //w=0.17 //l=0.120208 //layer=li \
 //thickness=0.1 //x=82.74 //y=5.475 //x2=82.825 //y2=5.39
r120 (  7 46 ) resistor r=29.0909 //w=0.187 //l=0.425 //layer=li \
 //thickness=0.1 //x=82.74 //y=5.475 //x2=82.74 //y2=5.9
r121 (  6 21 ) resistor r=9.3 //w=0.17 //l=0.17 //layer=mcon //count=1 \
 //x=85.64 //y=5.39 //x2=85.64 //y2=5.39
r122 (  4 44 ) resistor r=9.3 //w=0.17 //l=0.17 //layer=mcon //count=1 \
 //x=83.62 //y=5.39 //x2=83.62 //y2=5.39
r123 (  2 4 ) resistor r=0.0717383 //w=0.224 //l=0.115 //layer=m1 \
 //thickness=0.36 //x=83.735 //y=5.39 //x2=83.62 //y2=5.39
r124 (  1 6 ) resistor r=0.0717383 //w=0.224 //l=0.115 //layer=m1 \
 //thickness=0.36 //x=85.525 //y=5.39 //x2=85.64 //y2=5.39
r125 (  1 2 ) resistor r=1.70802 //w=0.131 //l=1.79 //layer=m1 \
 //thickness=0.36 //x=85.525 //y=5.39 //x2=83.735 //y2=5.39
ends PM_TMRDFFRNQX1\%noxref_21

subckt PM_TMRDFFRNQX1\%noxref_22 ( 1 2 3 4 5 6 29 30 43 45 46 50 52 63 64 65 \
 66 67 68 69 70 74 75 76 78 84 85 87 95 96 97 101 102 )
c240 ( 102 0 ) capacitor c=0.0167617f //x=86.815 //y=5.205
c241 ( 101 0 ) capacitor c=0.0164812f //x=85.935 //y=5.205
c242 ( 97 0 ) capacitor c=0.0110092f //x=86.81 //y=1.085
c243 ( 96 0 ) capacitor c=0.0131637f //x=83.48 //y=1.085
c244 ( 95 0 ) capacitor c=0.0131367f //x=80.15 //y=1.085
c245 ( 87 0 ) capacitor c=0.0537799f //x=88.92 //y=2.265
c246 ( 85 0 ) capacitor c=0.0435629f //x=89.56 //y=1.435
c247 ( 84 0 ) capacitor c=0.0200386f //x=89.56 //y=1.09
c248 ( 78 0 ) capacitor c=0.0152946f //x=89.405 //y=1.59
c249 ( 76 0 ) capacitor c=0.0157804f //x=89.405 //y=0.935
c250 ( 75 0 ) capacitor c=0.05065f //x=89.15 //y=4.97
c251 ( 74 0 ) capacitor c=0.0322983f //x=89.44 //y=4.97
c252 ( 70 0 ) capacitor c=0.0290017f //x=89.03 //y=2.1
c253 ( 69 0 ) capacitor c=0.0250027f //x=89.03 //y=1.745
c254 ( 68 0 ) capacitor c=0.0234316f //x=89.03 //y=1.435
c255 ( 67 0 ) capacitor c=0.0200596f //x=89.03 //y=1.09
c256 ( 66 0 ) capacitor c=0.154218f //x=89.515 //y=6.2
c257 ( 65 0 ) capacitor c=0.154243f //x=89.075 //y=6.2
c258 ( 63 0 ) capacitor c=0.00421476f //x=86.96 //y=5.39
c259 ( 52 0 ) capacitor c=0.094257f //x=88.92 //y=2.265
c260 ( 50 0 ) capacitor c=0.112965f //x=87.44 //y=4.25
c261 ( 46 0 ) capacitor c=0.00775877f //x=87.085 //y=1.825
c262 ( 45 0 ) capacitor c=0.0161066f //x=87.355 //y=1.825
c263 ( 43 0 ) capacitor c=0.0151634f //x=87.355 //y=5.39
c264 ( 30 0 ) capacitor c=0.0029383f //x=86.165 //y=5.39
c265 ( 29 0 ) capacitor c=0.0155464f //x=86.875 //y=5.39
c266 ( 6 0 ) capacitor c=0.00867855f //x=87.555 //y=4.25
c267 ( 5 0 ) capacitor c=0.0786471f //x=88.805 //y=4.25
c268 ( 4 0 ) capacitor c=0.00511584f //x=83.785 //y=1.36
c269 ( 3 0 ) capacitor c=0.0702096f //x=86.885 //y=1.36
c270 ( 2 0 ) capacitor c=0.0150174f //x=80.455 //y=1.36
c271 ( 1 0 ) capacitor c=0.0604206f //x=83.555 //y=1.36
r272 (  87 88 ) resistor r=17.5563 //w=0.302 //l=0.11 //layer=ply \
 //thickness=0.18 //x=88.92 //y=2.265 //x2=89.03 //y2=2.265
r273 (  85 94 ) resistor r=45.1352 //w=0.168 //l=0.173853 //layer=ply \
 //thickness=0.18 //x=89.56 //y=1.435 //x2=89.52 //y2=1.59
r274 (  84 93 ) resistor r=45.1352 //w=0.168 //l=0.173853 //layer=ply \
 //thickness=0.18 //x=89.56 //y=1.09 //x2=89.52 //y2=0.935
r275 (  84 85 ) resistor r=176.904 //w=0.094 //l=0.345 //layer=ply \
 //thickness=0.18 //x=89.56 //y=1.09 //x2=89.56 //y2=1.435
r276 (  79 92 ) resistor r=10.701 //w=0.21 //l=0.115 //layer=ply \
 //thickness=0.18 //x=89.185 //y=1.59 //x2=89.07 //y2=1.59
r277 (  78 94 ) resistor r=5.52526 //w=0.168 //l=0.115 //layer=ply \
 //thickness=0.18 //x=89.405 //y=1.59 //x2=89.52 //y2=1.59
r278 (  77 91 ) resistor r=5.52526 //w=0.168 //l=0.115 //layer=ply \
 //thickness=0.18 //x=89.185 //y=0.935 //x2=89.07 //y2=0.935
r279 (  76 93 ) resistor r=5.52526 //w=0.168 //l=0.115 //layer=ply \
 //thickness=0.18 //x=89.405 //y=0.935 //x2=89.52 //y2=0.935
r280 (  76 77 ) resistor r=112.809 //w=0.094 //l=0.22 //layer=ply \
 //thickness=0.18 //x=89.405 //y=0.935 //x2=89.185 //y2=0.935
r281 (  74 81 ) resistor r=26.9307 //w=0.15 //l=0.106066 //layer=ply \
 //thickness=0.18 //x=89.44 //y=4.97 //x2=89.515 //y2=5.045
r282 (  74 75 ) resistor r=148.702 //w=0.094 //l=0.29 //layer=ply \
 //thickness=0.18 //x=89.44 //y=4.97 //x2=89.15 //y2=4.97
r283 (  71 75 ) resistor r=23.403 //w=0.284 //l=0.106066 //layer=ply \
 //thickness=0.18 //x=89.075 //y=5.045 //x2=89.15 //y2=4.97
r284 (  71 90 ) resistor r=26.3063 //w=0.284 //l=0.229783 //layer=ply \
 //thickness=0.18 //x=89.075 //y=5.045 //x2=88.92 //y2=4.88
r285 (  70 88 ) resistor r=19.1248 //w=0.302 //l=0.165 //layer=ply \
 //thickness=0.18 //x=89.03 //y=2.1 //x2=89.03 //y2=2.265
r286 (  69 92 ) resistor r=39.5823 //w=0.21 //l=0.173853 //layer=ply \
 //thickness=0.18 //x=89.03 //y=1.745 //x2=89.07 //y2=1.59
r287 (  69 70 ) resistor r=182.032 //w=0.094 //l=0.355 //layer=ply \
 //thickness=0.18 //x=89.03 //y=1.745 //x2=89.03 //y2=2.1
r288 (  68 92 ) resistor r=39.5823 //w=0.21 //l=0.173853 //layer=ply \
 //thickness=0.18 //x=89.03 //y=1.435 //x2=89.07 //y2=1.59
r289 (  67 91 ) resistor r=45.1352 //w=0.168 //l=0.173853 //layer=ply \
 //thickness=0.18 //x=89.03 //y=1.09 //x2=89.07 //y2=0.935
r290 (  67 68 ) resistor r=176.904 //w=0.094 //l=0.345 //layer=ply \
 //thickness=0.18 //x=89.03 //y=1.09 //x2=89.03 //y2=1.435
r291 (  66 81 ) resistor r=592.245 //w=0.094 //l=1.155 //layer=ply \
 //thickness=0.18 //x=89.515 //y=6.2 //x2=89.515 //y2=5.045
r292 (  65 71 ) resistor r=592.245 //w=0.094 //l=1.155 //layer=ply \
 //thickness=0.18 //x=89.075 //y=6.2 //x2=89.075 //y2=5.045
r293 (  64 78 ) resistor r=56.4043 //w=0.094 //l=0.11 //layer=ply \
 //thickness=0.18 //x=89.295 //y=1.59 //x2=89.405 //y2=1.59
r294 (  64 79 ) resistor r=56.4043 //w=0.094 //l=0.11 //layer=ply \
 //thickness=0.18 //x=89.295 //y=1.59 //x2=89.185 //y2=1.59
r295 (  62 95 ) resistor r=13.3953 //w=0.172 //l=0.18 //layer=li \
 //thickness=0.1 //x=80.337 //y=1.36 //x2=80.337 //y2=1.18
r296 (  57 90 ) resistor r=152 //w=0.17 //l=0.17 //layer=licon //count=1 \
 //x=88.92 //y=4.88 //x2=88.92 //y2=4.88
r297 (  55 57 ) resistor r=43.123 //w=0.187 //l=0.63 //layer=li \
 //thickness=0.1 //x=88.92 //y=4.25 //x2=88.92 //y2=4.88
r298 (  52 87 ) resistor r=152 //w=0.17 //l=0.17 //layer=licon //count=1 \
 //x=88.92 //y=2.265 //x2=88.92 //y2=2.265
r299 (  52 55 ) resistor r=135.872 //w=0.187 //l=1.985 //layer=li \
 //thickness=0.1 //x=88.92 //y=2.265 //x2=88.92 //y2=4.25
r300 (  48 50 ) resistor r=72.2139 //w=0.187 //l=1.055 //layer=li \
 //thickness=0.1 //x=87.44 //y=5.305 //x2=87.44 //y2=4.25
r301 (  47 50 ) resistor r=160.171 //w=0.187 //l=2.34 //layer=li \
 //thickness=0.1 //x=87.44 //y=1.91 //x2=87.44 //y2=4.25
r302 (  45 47 ) resistor r=7.15173 //w=0.17 //l=0.120208 //layer=li \
 //thickness=0.1 //x=87.355 //y=1.825 //x2=87.44 //y2=1.91
r303 (  45 46 ) resistor r=18.4813 //w=0.187 //l=0.27 //layer=li \
 //thickness=0.1 //x=87.355 //y=1.825 //x2=87.085 //y2=1.825
r304 (  44 63 ) resistor r=5.4201 //w=0.17 //l=0.085 //layer=li \
 //thickness=0.1 //x=87.045 //y=5.39 //x2=86.96 //y2=5.39
r305 (  43 48 ) resistor r=7.15173 //w=0.17 //l=0.120208 //layer=li \
 //thickness=0.1 //x=87.355 //y=5.39 //x2=87.44 //y2=5.305
r306 (  43 44 ) resistor r=21.2193 //w=0.187 //l=0.31 //layer=li \
 //thickness=0.1 //x=87.355 //y=5.39 //x2=87.045 //y2=5.39
r307 (  42 97 ) resistor r=12.3209 //w=0.187 //l=0.18 //layer=li \
 //thickness=0.1 //x=87 //y=1.36 //x2=87 //y2=1.18
r308 (  37 46 ) resistor r=7.15173 //w=0.17 //l=0.120208 //layer=li \
 //thickness=0.1 //x=87 //y=1.74 //x2=87.085 //y2=1.825
r309 (  37 42 ) resistor r=26.0107 //w=0.187 //l=0.38 //layer=li \
 //thickness=0.1 //x=87 //y=1.74 //x2=87 //y2=1.36
r310 (  31 63 ) resistor r=1.40859 //w=0.34 //l=0.085 //layer=li \
 //thickness=0.1 //x=86.96 //y=5.475 //x2=86.96 //y2=5.39
r311 (  31 102 ) resistor r=29.0909 //w=0.187 //l=0.425 //layer=li \
 //thickness=0.1 //x=86.96 //y=5.475 //x2=86.96 //y2=5.9
r312 (  29 63 ) resistor r=5.4201 //w=0.17 //l=0.085 //layer=li \
 //thickness=0.1 //x=86.875 //y=5.39 //x2=86.96 //y2=5.39
r313 (  29 30 ) resistor r=48.5989 //w=0.187 //l=0.71 //layer=li \
 //thickness=0.1 //x=86.875 //y=5.39 //x2=86.165 //y2=5.39
r314 (  23 30 ) resistor r=7.15173 //w=0.17 //l=0.120208 //layer=li \
 //thickness=0.1 //x=86.08 //y=5.475 //x2=86.165 //y2=5.39
r315 (  23 101 ) resistor r=29.0909 //w=0.187 //l=0.425 //layer=li \
 //thickness=0.1 //x=86.08 //y=5.475 //x2=86.08 //y2=5.9
r316 (  21 96 ) resistor r=12.3209 //w=0.187 //l=0.18 //layer=li \
 //thickness=0.1 //x=83.67 //y=1.36 //x2=83.67 //y2=1.18
r317 (  16 55 ) resistor r=9.3 //w=0.17 //l=0.17 //layer=mcon //count=1 \
 //x=88.92 //y=4.25 //x2=88.92 //y2=4.25
r318 (  14 50 ) resistor r=9.3 //w=0.17 //l=0.17 //layer=mcon //count=1 \
 //x=87.44 //y=4.25 //x2=87.44 //y2=4.25
r319 (  12 42 ) resistor r=9.3 //w=0.17 //l=0.17 //layer=mcon //count=1 //x=87 \
 //y=1.36 //x2=87 //y2=1.36
r320 (  10 21 ) resistor r=9.3 //w=0.17 //l=0.17 //layer=mcon //count=1 \
 //x=83.67 //y=1.36 //x2=83.67 //y2=1.36
r321 (  8 62 ) resistor r=9.3 //w=0.17 //l=0.17 //layer=mcon //count=1 \
 //x=80.34 //y=1.36 //x2=80.34 //y2=1.36
r322 (  6 14 ) resistor r=0.0717383 //w=0.224 //l=0.115 //layer=m1 \
 //thickness=0.36 //x=87.555 //y=4.25 //x2=87.44 //y2=4.25
r323 (  5 16 ) resistor r=0.0717383 //w=0.224 //l=0.115 //layer=m1 \
 //thickness=0.36 //x=88.805 //y=4.25 //x2=88.92 //y2=4.25
r324 (  5 6 ) resistor r=1.19275 //w=0.131 //l=1.25 //layer=m1 \
 //thickness=0.36 //x=88.805 //y=4.25 //x2=87.555 //y2=4.25
r325 (  4 10 ) resistor r=0.0880901 //w=0.191 //l=0.115 //layer=m1 \
 //thickness=0.36 //x=83.785 //y=1.36 //x2=83.67 //y2=1.36
r326 (  3 12 ) resistor r=0.0717383 //w=0.224 //l=0.115 //layer=m1 \
 //thickness=0.36 //x=86.885 //y=1.36 //x2=87 //y2=1.36
r327 (  3 4 ) resistor r=2.95802 //w=0.131 //l=3.1 //layer=m1 //thickness=0.36 \
 //x=86.885 //y=1.36 //x2=83.785 //y2=1.36
r328 (  2 8 ) resistor r=0.0717383 //w=0.224 //l=0.115 //layer=m1 \
 //thickness=0.36 //x=80.455 //y=1.36 //x2=80.34 //y2=1.36
r329 (  1 10 ) resistor r=0.0880901 //w=0.191 //l=0.115 //layer=m1 \
 //thickness=0.36 //x=83.555 //y=1.36 //x2=83.67 //y2=1.36
r330 (  1 2 ) resistor r=2.95802 //w=0.131 //l=3.1 //layer=m1 //thickness=0.36 \
 //x=83.555 //y=1.36 //x2=80.455 //y2=1.36
ends PM_TMRDFFRNQX1\%noxref_22

subckt PM_TMRDFFRNQX1\%noxref_23 ( 1 5 9 13 17 35 )
c46 ( 35 0 ) capacitor c=0.0703709f //x=0.945 //y=0.555
c47 ( 17 0 ) capacitor c=0.0221229f //x=2.935 //y=1.77
c48 ( 13 0 ) capacitor c=0.0156939f //x=2.935 //y=0.72
c49 ( 9 0 ) capacitor c=0.00678203f //x=2.05 //y=0.805
c50 ( 5 0 ) capacitor c=0.0206412f //x=1.965 //y=1.77
c51 ( 1 0 ) capacitor c=0.0109947f //x=1.08 //y=1.685
r52 (  18 35 ) resistor r=5.4201 //w=0.17 //l=0.103078 //layer=li \
 //thickness=0.1 //x=2.135 //y=1.77 //x2=2.05 //y2=1.81
r53 (  18 35 ) resistor r=27.3797 //w=0.187 //l=0.4 //layer=li //thickness=0.1 \
 //x=2.135 //y=1.77 //x2=2.535 //y2=1.77
r54 (  17 35 ) resistor r=0.751729 //w=0.17 //l=0.085 //layer=li \
 //thickness=0.1 //x=2.935 //y=1.77 //x2=3.02 //y2=1.77
r55 (  17 35 ) resistor r=27.3797 //w=0.187 //l=0.4 //layer=li //thickness=0.1 \
 //x=2.935 //y=1.77 //x2=2.535 //y2=1.77
r56 (  14 35 ) resistor r=3.57586 //w=0.17 //l=0.103078 //layer=li \
 //thickness=0.1 //x=2.135 //y=0.72 //x2=2.05 //y2=0.68
r57 (  14 35 ) resistor r=27.3797 //w=0.187 //l=0.4 //layer=li //thickness=0.1 \
 //x=2.135 //y=0.72 //x2=2.535 //y2=0.72
r58 (  13 35 ) resistor r=0.751729 //w=0.17 //l=0.085 //layer=li \
 //thickness=0.1 //x=2.935 //y=0.72 //x2=3.02 //y2=0.72
r59 (  13 35 ) resistor r=27.3797 //w=0.187 //l=0.4 //layer=li //thickness=0.1 \
 //x=2.935 //y=0.72 //x2=2.535 //y2=0.72
r60 (  10 35 ) resistor r=1.40859 //w=0.34 //l=0.125 //layer=li \
 //thickness=0.1 //x=2.05 //y=1.685 //x2=2.05 //y2=1.81
r61 (  10 35 ) resistor r=42.0963 //w=0.187 //l=0.615 //layer=li \
 //thickness=0.1 //x=2.05 //y=1.685 //x2=2.05 //y2=1.07
r62 (  9 35 ) resistor r=3.57586 //w=0.17 //l=0.125 //layer=li //thickness=0.1 \
 //x=2.05 //y=0.805 //x2=2.05 //y2=0.68
r63 (  9 35 ) resistor r=18.139 //w=0.187 //l=0.265 //layer=li //thickness=0.1 \
 //x=2.05 //y=0.805 //x2=2.05 //y2=1.07
r64 (  6 35 ) resistor r=3.57586 //w=0.17 //l=0.103078 //layer=li \
 //thickness=0.1 //x=1.165 //y=1.77 //x2=1.08 //y2=1.81
r65 (  6 35 ) resistor r=27.3797 //w=0.187 //l=0.4 //layer=li //thickness=0.1 \
 //x=1.165 //y=1.77 //x2=1.565 //y2=1.77
r66 (  5 35 ) resistor r=5.4201 //w=0.17 //l=0.103078 //layer=li \
 //thickness=0.1 //x=1.965 //y=1.77 //x2=2.05 //y2=1.81
r67 (  5 35 ) resistor r=27.3797 //w=0.187 //l=0.4 //layer=li //thickness=0.1 \
 //x=1.965 //y=1.77 //x2=1.565 //y2=1.77
r68 (  1 35 ) resistor r=3.57586 //w=0.17 //l=0.125 //layer=li //thickness=0.1 \
 //x=1.08 //y=1.685 //x2=1.08 //y2=1.81
r69 (  1 35 ) resistor r=42.0963 //w=0.187 //l=0.615 //layer=li \
 //thickness=0.1 //x=1.08 //y=1.685 //x2=1.08 //y2=1.07
ends PM_TMRDFFRNQX1\%noxref_23

subckt PM_TMRDFFRNQX1\%noxref_24 ( 1 3 11 15 25 28 29 )
c52 ( 29 0 ) capacitor c=0.043074f //x=3.455 //y=0.555
c53 ( 28 0 ) capacitor c=0.00465142f //x=2.35 //y=1.09
c54 ( 25 0 ) capacitor c=0.00156479f //x=3.59 //y=1.175
c55 ( 15 0 ) capacitor c=0.00737666f //x=4.56 //y=0.805
c56 ( 11 0 ) capacitor c=0.0149771f //x=4.475 //y=0.72
c57 ( 3 0 ) capacitor c=0.00718386f //x=3.59 //y=0.805
c58 ( 1 0 ) capacitor c=0.0251532f //x=3.505 //y=1.175
r59 (  15 29 ) resistor r=3.57586 //w=0.17 //l=0.125 //layer=li \
 //thickness=0.1 //x=4.56 //y=0.805 //x2=4.56 //y2=0.68
r60 (  15 29 ) resistor r=18.139 //w=0.187 //l=0.265 //layer=li \
 //thickness=0.1 //x=4.56 //y=0.805 //x2=4.56 //y2=1.07
r61 (  12 29 ) resistor r=3.57586 //w=0.17 //l=0.103078 //layer=li \
 //thickness=0.1 //x=3.675 //y=0.72 //x2=3.59 //y2=0.68
r62 (  12 29 ) resistor r=27.3797 //w=0.187 //l=0.4 //layer=li //thickness=0.1 \
 //x=3.675 //y=0.72 //x2=4.075 //y2=0.72
r63 (  11 29 ) resistor r=3.57586 //w=0.17 //l=0.103078 //layer=li \
 //thickness=0.1 //x=4.475 //y=0.72 //x2=4.56 //y2=0.68
r64 (  11 29 ) resistor r=27.3797 //w=0.187 //l=0.4 //layer=li //thickness=0.1 \
 //x=4.475 //y=0.72 //x2=4.075 //y2=0.72
r65 (  7 25 ) resistor r=5.4201 //w=0.17 //l=0.085 //layer=li //thickness=0.1 \
 //x=3.59 //y=1.26 //x2=3.59 //y2=1.175
r66 (  7 29 ) resistor r=10.2674 //w=0.187 //l=0.15 //layer=li //thickness=0.1 \
 //x=3.59 //y=1.26 //x2=3.59 //y2=1.41
r67 (  4 25 ) resistor r=5.4201 //w=0.17 //l=0.085 //layer=li //thickness=0.1 \
 //x=3.59 //y=1.09 //x2=3.59 //y2=1.175
r68 (  4 29 ) resistor r=1.36898 //w=0.187 //l=0.02 //layer=li //thickness=0.1 \
 //x=3.59 //y=1.09 //x2=3.59 //y2=1.07
r69 (  3 29 ) resistor r=3.57586 //w=0.17 //l=0.125 //layer=li //thickness=0.1 \
 //x=3.59 //y=0.805 //x2=3.59 //y2=0.68
r70 (  3 29 ) resistor r=18.139 //w=0.187 //l=0.265 //layer=li //thickness=0.1 \
 //x=3.59 //y=0.805 //x2=3.59 //y2=1.07
r71 (  2 28 ) resistor r=0.751729 //w=0.17 //l=0.085 //layer=li \
 //thickness=0.1 //x=2.625 //y=1.175 //x2=2.54 //y2=1.175
r72 (  1 25 ) resistor r=1.40859 //w=0.34 //l=0.085 //layer=li //thickness=0.1 \
 //x=3.505 //y=1.175 //x2=3.59 //y2=1.175
r73 (  1 2 ) resistor r=60.2353 //w=0.187 //l=0.88 //layer=li //thickness=0.1 \
 //x=3.505 //y=1.175 //x2=2.625 //y2=1.175
ends PM_TMRDFFRNQX1\%noxref_24

subckt PM_TMRDFFRNQX1\%noxref_25 ( 1 5 9 13 17 35 )
c52 ( 35 0 ) capacitor c=0.0686255f //x=5.755 //y=0.555
c53 ( 17 0 ) capacitor c=0.020294f //x=7.745 //y=1.77
c54 ( 13 0 ) capacitor c=0.0155578f //x=7.745 //y=0.72
c55 ( 9 0 ) capacitor c=0.00678203f //x=6.86 //y=0.805
c56 ( 5 0 ) capacitor c=0.0183576f //x=6.775 //y=1.77
c57 ( 1 0 ) capacitor c=0.00791969f //x=5.89 //y=1.685
r58 (  18 35 ) resistor r=5.4201 //w=0.17 //l=0.103078 //layer=li \
 //thickness=0.1 //x=6.945 //y=1.77 //x2=6.86 //y2=1.81
r59 (  18 35 ) resistor r=27.3797 //w=0.187 //l=0.4 //layer=li //thickness=0.1 \
 //x=6.945 //y=1.77 //x2=7.345 //y2=1.77
r60 (  17 35 ) resistor r=0.751729 //w=0.17 //l=0.085 //layer=li \
 //thickness=0.1 //x=7.745 //y=1.77 //x2=7.83 //y2=1.77
r61 (  17 35 ) resistor r=27.3797 //w=0.187 //l=0.4 //layer=li //thickness=0.1 \
 //x=7.745 //y=1.77 //x2=7.345 //y2=1.77
r62 (  14 35 ) resistor r=3.57586 //w=0.17 //l=0.103078 //layer=li \
 //thickness=0.1 //x=6.945 //y=0.72 //x2=6.86 //y2=0.68
r63 (  14 35 ) resistor r=27.3797 //w=0.187 //l=0.4 //layer=li //thickness=0.1 \
 //x=6.945 //y=0.72 //x2=7.345 //y2=0.72
r64 (  13 35 ) resistor r=0.751729 //w=0.17 //l=0.085 //layer=li \
 //thickness=0.1 //x=7.745 //y=0.72 //x2=7.83 //y2=0.72
r65 (  13 35 ) resistor r=27.3797 //w=0.187 //l=0.4 //layer=li //thickness=0.1 \
 //x=7.745 //y=0.72 //x2=7.345 //y2=0.72
r66 (  10 35 ) resistor r=1.40859 //w=0.34 //l=0.125 //layer=li \
 //thickness=0.1 //x=6.86 //y=1.685 //x2=6.86 //y2=1.81
r67 (  10 35 ) resistor r=42.0963 //w=0.187 //l=0.615 //layer=li \
 //thickness=0.1 //x=6.86 //y=1.685 //x2=6.86 //y2=1.07
r68 (  9 35 ) resistor r=3.57586 //w=0.17 //l=0.125 //layer=li //thickness=0.1 \
 //x=6.86 //y=0.805 //x2=6.86 //y2=0.68
r69 (  9 35 ) resistor r=18.139 //w=0.187 //l=0.265 //layer=li //thickness=0.1 \
 //x=6.86 //y=0.805 //x2=6.86 //y2=1.07
r70 (  6 35 ) resistor r=3.57586 //w=0.17 //l=0.103078 //layer=li \
 //thickness=0.1 //x=5.975 //y=1.77 //x2=5.89 //y2=1.81
r71 (  6 35 ) resistor r=27.3797 //w=0.187 //l=0.4 //layer=li //thickness=0.1 \
 //x=5.975 //y=1.77 //x2=6.375 //y2=1.77
r72 (  5 35 ) resistor r=5.4201 //w=0.17 //l=0.103078 //layer=li \
 //thickness=0.1 //x=6.775 //y=1.77 //x2=6.86 //y2=1.81
r73 (  5 35 ) resistor r=27.3797 //w=0.187 //l=0.4 //layer=li //thickness=0.1 \
 //x=6.775 //y=1.77 //x2=6.375 //y2=1.77
r74 (  1 35 ) resistor r=3.57586 //w=0.17 //l=0.125 //layer=li //thickness=0.1 \
 //x=5.89 //y=1.685 //x2=5.89 //y2=1.81
r75 (  1 35 ) resistor r=42.0963 //w=0.187 //l=0.615 //layer=li \
 //thickness=0.1 //x=5.89 //y=1.685 //x2=5.89 //y2=1.07
ends PM_TMRDFFRNQX1\%noxref_25

subckt PM_TMRDFFRNQX1\%noxref_26 ( 1 3 11 15 25 28 29 )
c53 ( 29 0 ) capacitor c=0.041714f //x=8.265 //y=0.555
c54 ( 28 0 ) capacitor c=0.00462171f //x=7.16 //y=1.09
c55 ( 25 0 ) capacitor c=0.00156479f //x=8.4 //y=1.175
c56 ( 15 0 ) capacitor c=0.00737666f //x=9.37 //y=0.805
c57 ( 11 0 ) capacitor c=0.0144218f //x=9.285 //y=0.72
c58 ( 3 0 ) capacitor c=0.00718386f //x=8.4 //y=0.805
c59 ( 1 0 ) capacitor c=0.0227139f //x=8.315 //y=1.175
r60 (  15 29 ) resistor r=3.57586 //w=0.17 //l=0.125 //layer=li \
 //thickness=0.1 //x=9.37 //y=0.805 //x2=9.37 //y2=0.68
r61 (  15 29 ) resistor r=18.139 //w=0.187 //l=0.265 //layer=li \
 //thickness=0.1 //x=9.37 //y=0.805 //x2=9.37 //y2=1.07
r62 (  12 29 ) resistor r=3.57586 //w=0.17 //l=0.103078 //layer=li \
 //thickness=0.1 //x=8.485 //y=0.72 //x2=8.4 //y2=0.68
r63 (  12 29 ) resistor r=27.3797 //w=0.187 //l=0.4 //layer=li //thickness=0.1 \
 //x=8.485 //y=0.72 //x2=8.885 //y2=0.72
r64 (  11 29 ) resistor r=3.57586 //w=0.17 //l=0.103078 //layer=li \
 //thickness=0.1 //x=9.285 //y=0.72 //x2=9.37 //y2=0.68
r65 (  11 29 ) resistor r=27.3797 //w=0.187 //l=0.4 //layer=li //thickness=0.1 \
 //x=9.285 //y=0.72 //x2=8.885 //y2=0.72
r66 (  7 25 ) resistor r=5.4201 //w=0.17 //l=0.085 //layer=li //thickness=0.1 \
 //x=8.4 //y=1.26 //x2=8.4 //y2=1.175
r67 (  7 29 ) resistor r=10.2674 //w=0.187 //l=0.15 //layer=li //thickness=0.1 \
 //x=8.4 //y=1.26 //x2=8.4 //y2=1.41
r68 (  4 25 ) resistor r=5.4201 //w=0.17 //l=0.085 //layer=li //thickness=0.1 \
 //x=8.4 //y=1.09 //x2=8.4 //y2=1.175
r69 (  4 29 ) resistor r=1.36898 //w=0.187 //l=0.02 //layer=li //thickness=0.1 \
 //x=8.4 //y=1.09 //x2=8.4 //y2=1.07
r70 (  3 29 ) resistor r=3.57586 //w=0.17 //l=0.125 //layer=li //thickness=0.1 \
 //x=8.4 //y=0.805 //x2=8.4 //y2=0.68
r71 (  3 29 ) resistor r=18.139 //w=0.187 //l=0.265 //layer=li //thickness=0.1 \
 //x=8.4 //y=0.805 //x2=8.4 //y2=1.07
r72 (  2 28 ) resistor r=0.751729 //w=0.17 //l=0.085 //layer=li \
 //thickness=0.1 //x=7.435 //y=1.175 //x2=7.35 //y2=1.175
r73 (  1 25 ) resistor r=1.40859 //w=0.34 //l=0.085 //layer=li //thickness=0.1 \
 //x=8.315 //y=1.175 //x2=8.4 //y2=1.175
r74 (  1 2 ) resistor r=60.2353 //w=0.187 //l=0.88 //layer=li //thickness=0.1 \
 //x=8.315 //y=1.175 //x2=7.435 //y2=1.175
ends PM_TMRDFFRNQX1\%noxref_26

subckt PM_TMRDFFRNQX1\%noxref_27 ( 1 5 9 10 13 17 29 )
c51 ( 29 0 ) capacitor c=0.0632682f //x=10.67 //y=0.545
c52 ( 17 0 ) capacitor c=0.0072343f //x=12.745 //y=0.795
c53 ( 13 0 ) capacitor c=0.0145084f //x=12.66 //y=0.71
c54 ( 10 0 ) capacitor c=0.00582081f //x=11.775 //y=1.675
c55 ( 9 0 ) capacitor c=0.006761f //x=11.775 //y=0.795
c56 ( 5 0 ) capacitor c=0.0173046f //x=11.69 //y=1.76
c57 ( 1 0 ) capacitor c=0.00733328f //x=10.805 //y=1.675
r58 (  17 29 ) resistor r=3.57586 //w=0.17 //l=0.125 //layer=li \
 //thickness=0.1 //x=12.745 //y=0.795 //x2=12.745 //y2=0.67
r59 (  17 29 ) resistor r=18.139 //w=0.187 //l=0.265 //layer=li \
 //thickness=0.1 //x=12.745 //y=0.795 //x2=12.745 //y2=1.06
r60 (  14 29 ) resistor r=3.57586 //w=0.17 //l=0.103078 //layer=li \
 //thickness=0.1 //x=11.86 //y=0.71 //x2=11.775 //y2=0.67
r61 (  14 29 ) resistor r=27.3797 //w=0.187 //l=0.4 //layer=li //thickness=0.1 \
 //x=11.86 //y=0.71 //x2=12.26 //y2=0.71
r62 (  13 29 ) resistor r=3.57586 //w=0.17 //l=0.103078 //layer=li \
 //thickness=0.1 //x=12.66 //y=0.71 //x2=12.745 //y2=0.67
r63 (  13 29 ) resistor r=27.3797 //w=0.187 //l=0.4 //layer=li //thickness=0.1 \
 //x=12.66 //y=0.71 //x2=12.26 //y2=0.71
r64 (  10 29 ) resistor r=3.57586 //w=0.17 //l=0.125 //layer=li \
 //thickness=0.1 //x=11.775 //y=1.675 //x2=11.775 //y2=1.8
r65 (  10 29 ) resistor r=42.0963 //w=0.187 //l=0.615 //layer=li \
 //thickness=0.1 //x=11.775 //y=1.675 //x2=11.775 //y2=1.06
r66 (  9 29 ) resistor r=3.57586 //w=0.17 //l=0.125 //layer=li //thickness=0.1 \
 //x=11.775 //y=0.795 //x2=11.775 //y2=0.67
r67 (  9 29 ) resistor r=18.139 //w=0.187 //l=0.265 //layer=li //thickness=0.1 \
 //x=11.775 //y=0.795 //x2=11.775 //y2=1.06
r68 (  6 29 ) resistor r=3.57586 //w=0.17 //l=0.103078 //layer=li \
 //thickness=0.1 //x=10.89 //y=1.76 //x2=10.805 //y2=1.8
r69 (  6 29 ) resistor r=27.3797 //w=0.187 //l=0.4 //layer=li //thickness=0.1 \
 //x=10.89 //y=1.76 //x2=11.29 //y2=1.76
r70 (  5 29 ) resistor r=3.57586 //w=0.17 //l=0.103078 //layer=li \
 //thickness=0.1 //x=11.69 //y=1.76 //x2=11.775 //y2=1.8
r71 (  5 29 ) resistor r=27.3797 //w=0.187 //l=0.4 //layer=li //thickness=0.1 \
 //x=11.69 //y=1.76 //x2=11.29 //y2=1.76
r72 (  1 29 ) resistor r=3.57586 //w=0.17 //l=0.125 //layer=li //thickness=0.1 \
 //x=10.805 //y=1.675 //x2=10.805 //y2=1.8
r73 (  1 29 ) resistor r=42.0963 //w=0.187 //l=0.615 //layer=li \
 //thickness=0.1 //x=10.805 //y=1.675 //x2=10.805 //y2=1.06
ends PM_TMRDFFRNQX1\%noxref_27

subckt PM_TMRDFFRNQX1\%noxref_28 ( 1 5 9 13 17 35 )
c49 ( 35 0 ) capacitor c=0.0673029f //x=13.895 //y=0.555
c50 ( 17 0 ) capacitor c=0.0178317f //x=15.885 //y=1.77
c51 ( 13 0 ) capacitor c=0.0154936f //x=15.885 //y=0.72
c52 ( 9 0 ) capacitor c=0.00678203f //x=15 //y=0.805
c53 ( 5 0 ) capacitor c=0.0164013f //x=14.915 //y=1.77
c54 ( 1 0 ) capacitor c=0.00696517f //x=14.03 //y=1.685
r55 (  18 35 ) resistor r=5.4201 //w=0.17 //l=0.103078 //layer=li \
 //thickness=0.1 //x=15.085 //y=1.77 //x2=15 //y2=1.81
r56 (  18 35 ) resistor r=27.3797 //w=0.187 //l=0.4 //layer=li //thickness=0.1 \
 //x=15.085 //y=1.77 //x2=15.485 //y2=1.77
r57 (  17 35 ) resistor r=0.751729 //w=0.17 //l=0.085 //layer=li \
 //thickness=0.1 //x=15.885 //y=1.77 //x2=15.97 //y2=1.77
r58 (  17 35 ) resistor r=27.3797 //w=0.187 //l=0.4 //layer=li //thickness=0.1 \
 //x=15.885 //y=1.77 //x2=15.485 //y2=1.77
r59 (  14 35 ) resistor r=3.57586 //w=0.17 //l=0.103078 //layer=li \
 //thickness=0.1 //x=15.085 //y=0.72 //x2=15 //y2=0.68
r60 (  14 35 ) resistor r=27.3797 //w=0.187 //l=0.4 //layer=li //thickness=0.1 \
 //x=15.085 //y=0.72 //x2=15.485 //y2=0.72
r61 (  13 35 ) resistor r=0.751729 //w=0.17 //l=0.085 //layer=li \
 //thickness=0.1 //x=15.885 //y=0.72 //x2=15.97 //y2=0.72
r62 (  13 35 ) resistor r=27.3797 //w=0.187 //l=0.4 //layer=li //thickness=0.1 \
 //x=15.885 //y=0.72 //x2=15.485 //y2=0.72
r63 (  10 35 ) resistor r=1.40859 //w=0.34 //l=0.125 //layer=li \
 //thickness=0.1 //x=15 //y=1.685 //x2=15 //y2=1.81
r64 (  10 35 ) resistor r=42.0963 //w=0.187 //l=0.615 //layer=li \
 //thickness=0.1 //x=15 //y=1.685 //x2=15 //y2=1.07
r65 (  9 35 ) resistor r=3.57586 //w=0.17 //l=0.125 //layer=li //thickness=0.1 \
 //x=15 //y=0.805 //x2=15 //y2=0.68
r66 (  9 35 ) resistor r=18.139 //w=0.187 //l=0.265 //layer=li //thickness=0.1 \
 //x=15 //y=0.805 //x2=15 //y2=1.07
r67 (  6 35 ) resistor r=3.57586 //w=0.17 //l=0.103078 //layer=li \
 //thickness=0.1 //x=14.115 //y=1.77 //x2=14.03 //y2=1.81
r68 (  6 35 ) resistor r=27.3797 //w=0.187 //l=0.4 //layer=li //thickness=0.1 \
 //x=14.115 //y=1.77 //x2=14.515 //y2=1.77
r69 (  5 35 ) resistor r=5.4201 //w=0.17 //l=0.103078 //layer=li \
 //thickness=0.1 //x=14.915 //y=1.77 //x2=15 //y2=1.81
r70 (  5 35 ) resistor r=27.3797 //w=0.187 //l=0.4 //layer=li //thickness=0.1 \
 //x=14.915 //y=1.77 //x2=14.515 //y2=1.77
r71 (  1 35 ) resistor r=3.57586 //w=0.17 //l=0.125 //layer=li //thickness=0.1 \
 //x=14.03 //y=1.685 //x2=14.03 //y2=1.81
r72 (  1 35 ) resistor r=42.0963 //w=0.187 //l=0.615 //layer=li \
 //thickness=0.1 //x=14.03 //y=1.685 //x2=14.03 //y2=1.07
ends PM_TMRDFFRNQX1\%noxref_28

subckt PM_TMRDFFRNQX1\%noxref_29 ( 1 3 11 15 25 28 29 )
c53 ( 29 0 ) capacitor c=0.0413887f //x=16.405 //y=0.555
c54 ( 28 0 ) capacitor c=0.0045748f //x=15.3 //y=1.09
c55 ( 25 0 ) capacitor c=0.00156479f //x=16.54 //y=1.175
c56 ( 15 0 ) capacitor c=0.00737666f //x=17.51 //y=0.805
c57 ( 11 0 ) capacitor c=0.0144218f //x=17.425 //y=0.72
c58 ( 3 0 ) capacitor c=0.00718386f //x=16.54 //y=0.805
c59 ( 1 0 ) capacitor c=0.0218888f //x=16.455 //y=1.175
r60 (  15 29 ) resistor r=3.57586 //w=0.17 //l=0.125 //layer=li \
 //thickness=0.1 //x=17.51 //y=0.805 //x2=17.51 //y2=0.68
r61 (  15 29 ) resistor r=18.139 //w=0.187 //l=0.265 //layer=li \
 //thickness=0.1 //x=17.51 //y=0.805 //x2=17.51 //y2=1.07
r62 (  12 29 ) resistor r=3.57586 //w=0.17 //l=0.103078 //layer=li \
 //thickness=0.1 //x=16.625 //y=0.72 //x2=16.54 //y2=0.68
r63 (  12 29 ) resistor r=27.3797 //w=0.187 //l=0.4 //layer=li //thickness=0.1 \
 //x=16.625 //y=0.72 //x2=17.025 //y2=0.72
r64 (  11 29 ) resistor r=3.57586 //w=0.17 //l=0.103078 //layer=li \
 //thickness=0.1 //x=17.425 //y=0.72 //x2=17.51 //y2=0.68
r65 (  11 29 ) resistor r=27.3797 //w=0.187 //l=0.4 //layer=li //thickness=0.1 \
 //x=17.425 //y=0.72 //x2=17.025 //y2=0.72
r66 (  7 25 ) resistor r=5.4201 //w=0.17 //l=0.085 //layer=li //thickness=0.1 \
 //x=16.54 //y=1.26 //x2=16.54 //y2=1.175
r67 (  7 29 ) resistor r=10.2674 //w=0.187 //l=0.15 //layer=li //thickness=0.1 \
 //x=16.54 //y=1.26 //x2=16.54 //y2=1.41
r68 (  4 25 ) resistor r=5.4201 //w=0.17 //l=0.085 //layer=li //thickness=0.1 \
 //x=16.54 //y=1.09 //x2=16.54 //y2=1.175
r69 (  4 29 ) resistor r=1.36898 //w=0.187 //l=0.02 //layer=li //thickness=0.1 \
 //x=16.54 //y=1.09 //x2=16.54 //y2=1.07
r70 (  3 29 ) resistor r=3.57586 //w=0.17 //l=0.125 //layer=li //thickness=0.1 \
 //x=16.54 //y=0.805 //x2=16.54 //y2=0.68
r71 (  3 29 ) resistor r=18.139 //w=0.187 //l=0.265 //layer=li //thickness=0.1 \
 //x=16.54 //y=0.805 //x2=16.54 //y2=1.07
r72 (  2 28 ) resistor r=0.751729 //w=0.17 //l=0.085 //layer=li \
 //thickness=0.1 //x=15.575 //y=1.175 //x2=15.49 //y2=1.175
r73 (  1 25 ) resistor r=1.40859 //w=0.34 //l=0.085 //layer=li //thickness=0.1 \
 //x=16.455 //y=1.175 //x2=16.54 //y2=1.175
r74 (  1 2 ) resistor r=60.2353 //w=0.187 //l=0.88 //layer=li //thickness=0.1 \
 //x=16.455 //y=1.175 //x2=15.575 //y2=1.175
ends PM_TMRDFFRNQX1\%noxref_29

subckt PM_TMRDFFRNQX1\%noxref_30 ( 1 5 9 13 17 35 )
c52 ( 35 0 ) capacitor c=0.0673029f //x=18.705 //y=0.555
c53 ( 17 0 ) capacitor c=0.0178286f //x=20.695 //y=1.77
c54 ( 13 0 ) capacitor c=0.0154917f //x=20.695 //y=0.72
c55 ( 9 0 ) capacitor c=0.00678203f //x=19.81 //y=0.805
c56 ( 5 0 ) capacitor c=0.0164013f //x=19.725 //y=1.77
c57 ( 1 0 ) capacitor c=0.00696517f //x=18.84 //y=1.685
r58 (  18 35 ) resistor r=5.4201 //w=0.17 //l=0.103078 //layer=li \
 //thickness=0.1 //x=19.895 //y=1.77 //x2=19.81 //y2=1.81
r59 (  18 35 ) resistor r=27.3797 //w=0.187 //l=0.4 //layer=li //thickness=0.1 \
 //x=19.895 //y=1.77 //x2=20.295 //y2=1.77
r60 (  17 35 ) resistor r=0.751729 //w=0.17 //l=0.085 //layer=li \
 //thickness=0.1 //x=20.695 //y=1.77 //x2=20.78 //y2=1.77
r61 (  17 35 ) resistor r=27.3797 //w=0.187 //l=0.4 //layer=li //thickness=0.1 \
 //x=20.695 //y=1.77 //x2=20.295 //y2=1.77
r62 (  14 35 ) resistor r=3.57586 //w=0.17 //l=0.103078 //layer=li \
 //thickness=0.1 //x=19.895 //y=0.72 //x2=19.81 //y2=0.68
r63 (  14 35 ) resistor r=27.3797 //w=0.187 //l=0.4 //layer=li //thickness=0.1 \
 //x=19.895 //y=0.72 //x2=20.295 //y2=0.72
r64 (  13 35 ) resistor r=0.751729 //w=0.17 //l=0.085 //layer=li \
 //thickness=0.1 //x=20.695 //y=0.72 //x2=20.78 //y2=0.72
r65 (  13 35 ) resistor r=27.3797 //w=0.187 //l=0.4 //layer=li //thickness=0.1 \
 //x=20.695 //y=0.72 //x2=20.295 //y2=0.72
r66 (  10 35 ) resistor r=1.40859 //w=0.34 //l=0.125 //layer=li \
 //thickness=0.1 //x=19.81 //y=1.685 //x2=19.81 //y2=1.81
r67 (  10 35 ) resistor r=42.0963 //w=0.187 //l=0.615 //layer=li \
 //thickness=0.1 //x=19.81 //y=1.685 //x2=19.81 //y2=1.07
r68 (  9 35 ) resistor r=3.57586 //w=0.17 //l=0.125 //layer=li //thickness=0.1 \
 //x=19.81 //y=0.805 //x2=19.81 //y2=0.68
r69 (  9 35 ) resistor r=18.139 //w=0.187 //l=0.265 //layer=li //thickness=0.1 \
 //x=19.81 //y=0.805 //x2=19.81 //y2=1.07
r70 (  6 35 ) resistor r=3.57586 //w=0.17 //l=0.103078 //layer=li \
 //thickness=0.1 //x=18.925 //y=1.77 //x2=18.84 //y2=1.81
r71 (  6 35 ) resistor r=27.3797 //w=0.187 //l=0.4 //layer=li //thickness=0.1 \
 //x=18.925 //y=1.77 //x2=19.325 //y2=1.77
r72 (  5 35 ) resistor r=5.4201 //w=0.17 //l=0.103078 //layer=li \
 //thickness=0.1 //x=19.725 //y=1.77 //x2=19.81 //y2=1.81
r73 (  5 35 ) resistor r=27.3797 //w=0.187 //l=0.4 //layer=li //thickness=0.1 \
 //x=19.725 //y=1.77 //x2=19.325 //y2=1.77
r74 (  1 35 ) resistor r=3.57586 //w=0.17 //l=0.125 //layer=li //thickness=0.1 \
 //x=18.84 //y=1.685 //x2=18.84 //y2=1.81
r75 (  1 35 ) resistor r=42.0963 //w=0.187 //l=0.615 //layer=li \
 //thickness=0.1 //x=18.84 //y=1.685 //x2=18.84 //y2=1.07
ends PM_TMRDFFRNQX1\%noxref_30

subckt PM_TMRDFFRNQX1\%noxref_31 ( 1 3 11 15 25 28 29 )
c52 ( 29 0 ) capacitor c=0.0413887f //x=21.215 //y=0.555
c53 ( 28 0 ) capacitor c=0.00457437f //x=20.11 //y=1.09
c54 ( 25 0 ) capacitor c=0.00156479f //x=21.35 //y=1.175
c55 ( 15 0 ) capacitor c=0.00737666f //x=22.32 //y=0.805
c56 ( 11 0 ) capacitor c=0.0144274f //x=22.235 //y=0.72
c57 ( 3 0 ) capacitor c=0.00718386f //x=21.35 //y=0.805
c58 ( 1 0 ) capacitor c=0.0218873f //x=21.265 //y=1.175
r59 (  15 29 ) resistor r=3.57586 //w=0.17 //l=0.125 //layer=li \
 //thickness=0.1 //x=22.32 //y=0.805 //x2=22.32 //y2=0.68
r60 (  15 29 ) resistor r=18.139 //w=0.187 //l=0.265 //layer=li \
 //thickness=0.1 //x=22.32 //y=0.805 //x2=22.32 //y2=1.07
r61 (  12 29 ) resistor r=3.57586 //w=0.17 //l=0.103078 //layer=li \
 //thickness=0.1 //x=21.435 //y=0.72 //x2=21.35 //y2=0.68
r62 (  12 29 ) resistor r=27.3797 //w=0.187 //l=0.4 //layer=li //thickness=0.1 \
 //x=21.435 //y=0.72 //x2=21.835 //y2=0.72
r63 (  11 29 ) resistor r=3.57586 //w=0.17 //l=0.103078 //layer=li \
 //thickness=0.1 //x=22.235 //y=0.72 //x2=22.32 //y2=0.68
r64 (  11 29 ) resistor r=27.3797 //w=0.187 //l=0.4 //layer=li //thickness=0.1 \
 //x=22.235 //y=0.72 //x2=21.835 //y2=0.72
r65 (  7 25 ) resistor r=5.4201 //w=0.17 //l=0.085 //layer=li //thickness=0.1 \
 //x=21.35 //y=1.26 //x2=21.35 //y2=1.175
r66 (  7 29 ) resistor r=10.2674 //w=0.187 //l=0.15 //layer=li //thickness=0.1 \
 //x=21.35 //y=1.26 //x2=21.35 //y2=1.41
r67 (  4 25 ) resistor r=5.4201 //w=0.17 //l=0.085 //layer=li //thickness=0.1 \
 //x=21.35 //y=1.09 //x2=21.35 //y2=1.175
r68 (  4 29 ) resistor r=1.36898 //w=0.187 //l=0.02 //layer=li //thickness=0.1 \
 //x=21.35 //y=1.09 //x2=21.35 //y2=1.07
r69 (  3 29 ) resistor r=3.57586 //w=0.17 //l=0.125 //layer=li //thickness=0.1 \
 //x=21.35 //y=0.805 //x2=21.35 //y2=0.68
r70 (  3 29 ) resistor r=18.139 //w=0.187 //l=0.265 //layer=li //thickness=0.1 \
 //x=21.35 //y=0.805 //x2=21.35 //y2=1.07
r71 (  2 28 ) resistor r=0.751729 //w=0.17 //l=0.085 //layer=li \
 //thickness=0.1 //x=20.385 //y=1.175 //x2=20.3 //y2=1.175
r72 (  1 25 ) resistor r=1.40859 //w=0.34 //l=0.085 //layer=li //thickness=0.1 \
 //x=21.265 //y=1.175 //x2=21.35 //y2=1.175
r73 (  1 2 ) resistor r=60.2353 //w=0.187 //l=0.88 //layer=li //thickness=0.1 \
 //x=21.265 //y=1.175 //x2=20.385 //y2=1.175
ends PM_TMRDFFRNQX1\%noxref_31

subckt PM_TMRDFFRNQX1\%noxref_32 ( 1 5 9 10 13 17 29 )
c51 ( 29 0 ) capacitor c=0.0632682f //x=23.62 //y=0.545
c52 ( 17 0 ) capacitor c=0.0072343f //x=25.695 //y=0.795
c53 ( 13 0 ) capacitor c=0.0145084f //x=25.61 //y=0.71
c54 ( 10 0 ) capacitor c=0.00582081f //x=24.725 //y=1.675
c55 ( 9 0 ) capacitor c=0.006761f //x=24.725 //y=0.795
c56 ( 5 0 ) capacitor c=0.0173046f //x=24.64 //y=1.76
c57 ( 1 0 ) capacitor c=0.00733328f //x=23.755 //y=1.675
r58 (  17 29 ) resistor r=3.57586 //w=0.17 //l=0.125 //layer=li \
 //thickness=0.1 //x=25.695 //y=0.795 //x2=25.695 //y2=0.67
r59 (  17 29 ) resistor r=18.139 //w=0.187 //l=0.265 //layer=li \
 //thickness=0.1 //x=25.695 //y=0.795 //x2=25.695 //y2=1.06
r60 (  14 29 ) resistor r=3.57586 //w=0.17 //l=0.103078 //layer=li \
 //thickness=0.1 //x=24.81 //y=0.71 //x2=24.725 //y2=0.67
r61 (  14 29 ) resistor r=27.3797 //w=0.187 //l=0.4 //layer=li //thickness=0.1 \
 //x=24.81 //y=0.71 //x2=25.21 //y2=0.71
r62 (  13 29 ) resistor r=3.57586 //w=0.17 //l=0.103078 //layer=li \
 //thickness=0.1 //x=25.61 //y=0.71 //x2=25.695 //y2=0.67
r63 (  13 29 ) resistor r=27.3797 //w=0.187 //l=0.4 //layer=li //thickness=0.1 \
 //x=25.61 //y=0.71 //x2=25.21 //y2=0.71
r64 (  10 29 ) resistor r=3.57586 //w=0.17 //l=0.125 //layer=li \
 //thickness=0.1 //x=24.725 //y=1.675 //x2=24.725 //y2=1.8
r65 (  10 29 ) resistor r=42.0963 //w=0.187 //l=0.615 //layer=li \
 //thickness=0.1 //x=24.725 //y=1.675 //x2=24.725 //y2=1.06
r66 (  9 29 ) resistor r=3.57586 //w=0.17 //l=0.125 //layer=li //thickness=0.1 \
 //x=24.725 //y=0.795 //x2=24.725 //y2=0.67
r67 (  9 29 ) resistor r=18.139 //w=0.187 //l=0.265 //layer=li //thickness=0.1 \
 //x=24.725 //y=0.795 //x2=24.725 //y2=1.06
r68 (  6 29 ) resistor r=3.57586 //w=0.17 //l=0.103078 //layer=li \
 //thickness=0.1 //x=23.84 //y=1.76 //x2=23.755 //y2=1.8
r69 (  6 29 ) resistor r=27.3797 //w=0.187 //l=0.4 //layer=li //thickness=0.1 \
 //x=23.84 //y=1.76 //x2=24.24 //y2=1.76
r70 (  5 29 ) resistor r=3.57586 //w=0.17 //l=0.103078 //layer=li \
 //thickness=0.1 //x=24.64 //y=1.76 //x2=24.725 //y2=1.8
r71 (  5 29 ) resistor r=27.3797 //w=0.187 //l=0.4 //layer=li //thickness=0.1 \
 //x=24.64 //y=1.76 //x2=24.24 //y2=1.76
r72 (  1 29 ) resistor r=3.57586 //w=0.17 //l=0.125 //layer=li //thickness=0.1 \
 //x=23.755 //y=1.675 //x2=23.755 //y2=1.8
r73 (  1 29 ) resistor r=42.0963 //w=0.187 //l=0.615 //layer=li \
 //thickness=0.1 //x=23.755 //y=1.675 //x2=23.755 //y2=1.06
ends PM_TMRDFFRNQX1\%noxref_32

subckt PM_TMRDFFRNQX1\%noxref_33 ( 1 5 9 13 17 35 )
c49 ( 35 0 ) capacitor c=0.0673029f //x=26.845 //y=0.555
c50 ( 17 0 ) capacitor c=0.0178317f //x=28.835 //y=1.77
c51 ( 13 0 ) capacitor c=0.0154936f //x=28.835 //y=0.72
c52 ( 9 0 ) capacitor c=0.00678203f //x=27.95 //y=0.805
c53 ( 5 0 ) capacitor c=0.0164013f //x=27.865 //y=1.77
c54 ( 1 0 ) capacitor c=0.00696517f //x=26.98 //y=1.685
r55 (  18 35 ) resistor r=5.4201 //w=0.17 //l=0.103078 //layer=li \
 //thickness=0.1 //x=28.035 //y=1.77 //x2=27.95 //y2=1.81
r56 (  18 35 ) resistor r=27.3797 //w=0.187 //l=0.4 //layer=li //thickness=0.1 \
 //x=28.035 //y=1.77 //x2=28.435 //y2=1.77
r57 (  17 35 ) resistor r=0.751729 //w=0.17 //l=0.085 //layer=li \
 //thickness=0.1 //x=28.835 //y=1.77 //x2=28.92 //y2=1.77
r58 (  17 35 ) resistor r=27.3797 //w=0.187 //l=0.4 //layer=li //thickness=0.1 \
 //x=28.835 //y=1.77 //x2=28.435 //y2=1.77
r59 (  14 35 ) resistor r=3.57586 //w=0.17 //l=0.103078 //layer=li \
 //thickness=0.1 //x=28.035 //y=0.72 //x2=27.95 //y2=0.68
r60 (  14 35 ) resistor r=27.3797 //w=0.187 //l=0.4 //layer=li //thickness=0.1 \
 //x=28.035 //y=0.72 //x2=28.435 //y2=0.72
r61 (  13 35 ) resistor r=0.751729 //w=0.17 //l=0.085 //layer=li \
 //thickness=0.1 //x=28.835 //y=0.72 //x2=28.92 //y2=0.72
r62 (  13 35 ) resistor r=27.3797 //w=0.187 //l=0.4 //layer=li //thickness=0.1 \
 //x=28.835 //y=0.72 //x2=28.435 //y2=0.72
r63 (  10 35 ) resistor r=1.40859 //w=0.34 //l=0.125 //layer=li \
 //thickness=0.1 //x=27.95 //y=1.685 //x2=27.95 //y2=1.81
r64 (  10 35 ) resistor r=42.0963 //w=0.187 //l=0.615 //layer=li \
 //thickness=0.1 //x=27.95 //y=1.685 //x2=27.95 //y2=1.07
r65 (  9 35 ) resistor r=3.57586 //w=0.17 //l=0.125 //layer=li //thickness=0.1 \
 //x=27.95 //y=0.805 //x2=27.95 //y2=0.68
r66 (  9 35 ) resistor r=18.139 //w=0.187 //l=0.265 //layer=li //thickness=0.1 \
 //x=27.95 //y=0.805 //x2=27.95 //y2=1.07
r67 (  6 35 ) resistor r=3.57586 //w=0.17 //l=0.103078 //layer=li \
 //thickness=0.1 //x=27.065 //y=1.77 //x2=26.98 //y2=1.81
r68 (  6 35 ) resistor r=27.3797 //w=0.187 //l=0.4 //layer=li //thickness=0.1 \
 //x=27.065 //y=1.77 //x2=27.465 //y2=1.77
r69 (  5 35 ) resistor r=5.4201 //w=0.17 //l=0.103078 //layer=li \
 //thickness=0.1 //x=27.865 //y=1.77 //x2=27.95 //y2=1.81
r70 (  5 35 ) resistor r=27.3797 //w=0.187 //l=0.4 //layer=li //thickness=0.1 \
 //x=27.865 //y=1.77 //x2=27.465 //y2=1.77
r71 (  1 35 ) resistor r=3.57586 //w=0.17 //l=0.125 //layer=li //thickness=0.1 \
 //x=26.98 //y=1.685 //x2=26.98 //y2=1.81
r72 (  1 35 ) resistor r=42.0963 //w=0.187 //l=0.615 //layer=li \
 //thickness=0.1 //x=26.98 //y=1.685 //x2=26.98 //y2=1.07
ends PM_TMRDFFRNQX1\%noxref_33

subckt PM_TMRDFFRNQX1\%noxref_34 ( 1 3 11 15 25 28 29 )
c52 ( 29 0 ) capacitor c=0.0413887f //x=29.355 //y=0.555
c53 ( 28 0 ) capacitor c=0.0045748f //x=28.25 //y=1.09
c54 ( 25 0 ) capacitor c=0.00156479f //x=29.49 //y=1.175
c55 ( 15 0 ) capacitor c=0.00737666f //x=30.46 //y=0.805
c56 ( 11 0 ) capacitor c=0.0144274f //x=30.375 //y=0.72
c57 ( 3 0 ) capacitor c=0.00718386f //x=29.49 //y=0.805
c58 ( 1 0 ) capacitor c=0.0218888f //x=29.405 //y=1.175
r59 (  15 29 ) resistor r=3.57586 //w=0.17 //l=0.125 //layer=li \
 //thickness=0.1 //x=30.46 //y=0.805 //x2=30.46 //y2=0.68
r60 (  15 29 ) resistor r=18.139 //w=0.187 //l=0.265 //layer=li \
 //thickness=0.1 //x=30.46 //y=0.805 //x2=30.46 //y2=1.07
r61 (  12 29 ) resistor r=3.57586 //w=0.17 //l=0.103078 //layer=li \
 //thickness=0.1 //x=29.575 //y=0.72 //x2=29.49 //y2=0.68
r62 (  12 29 ) resistor r=27.3797 //w=0.187 //l=0.4 //layer=li //thickness=0.1 \
 //x=29.575 //y=0.72 //x2=29.975 //y2=0.72
r63 (  11 29 ) resistor r=3.57586 //w=0.17 //l=0.103078 //layer=li \
 //thickness=0.1 //x=30.375 //y=0.72 //x2=30.46 //y2=0.68
r64 (  11 29 ) resistor r=27.3797 //w=0.187 //l=0.4 //layer=li //thickness=0.1 \
 //x=30.375 //y=0.72 //x2=29.975 //y2=0.72
r65 (  7 25 ) resistor r=5.4201 //w=0.17 //l=0.085 //layer=li //thickness=0.1 \
 //x=29.49 //y=1.26 //x2=29.49 //y2=1.175
r66 (  7 29 ) resistor r=10.2674 //w=0.187 //l=0.15 //layer=li //thickness=0.1 \
 //x=29.49 //y=1.26 //x2=29.49 //y2=1.41
r67 (  4 25 ) resistor r=5.4201 //w=0.17 //l=0.085 //layer=li //thickness=0.1 \
 //x=29.49 //y=1.09 //x2=29.49 //y2=1.175
r68 (  4 29 ) resistor r=1.36898 //w=0.187 //l=0.02 //layer=li //thickness=0.1 \
 //x=29.49 //y=1.09 //x2=29.49 //y2=1.07
r69 (  3 29 ) resistor r=3.57586 //w=0.17 //l=0.125 //layer=li //thickness=0.1 \
 //x=29.49 //y=0.805 //x2=29.49 //y2=0.68
r70 (  3 29 ) resistor r=18.139 //w=0.187 //l=0.265 //layer=li //thickness=0.1 \
 //x=29.49 //y=0.805 //x2=29.49 //y2=1.07
r71 (  2 28 ) resistor r=0.751729 //w=0.17 //l=0.085 //layer=li \
 //thickness=0.1 //x=28.525 //y=1.175 //x2=28.44 //y2=1.175
r72 (  1 25 ) resistor r=1.40859 //w=0.34 //l=0.085 //layer=li //thickness=0.1 \
 //x=29.405 //y=1.175 //x2=29.49 //y2=1.175
r73 (  1 2 ) resistor r=60.2353 //w=0.187 //l=0.88 //layer=li //thickness=0.1 \
 //x=29.405 //y=1.175 //x2=28.525 //y2=1.175
ends PM_TMRDFFRNQX1\%noxref_34

subckt PM_TMRDFFRNQX1\%noxref_35 ( 1 5 9 13 17 35 )
c49 ( 35 0 ) capacitor c=0.0673029f //x=31.655 //y=0.555
c50 ( 17 0 ) capacitor c=0.0178317f //x=33.645 //y=1.77
c51 ( 13 0 ) capacitor c=0.0154936f //x=33.645 //y=0.72
c52 ( 9 0 ) capacitor c=0.00678203f //x=32.76 //y=0.805
c53 ( 5 0 ) capacitor c=0.0164013f //x=32.675 //y=1.77
c54 ( 1 0 ) capacitor c=0.00696517f //x=31.79 //y=1.685
r55 (  18 35 ) resistor r=5.4201 //w=0.17 //l=0.103078 //layer=li \
 //thickness=0.1 //x=32.845 //y=1.77 //x2=32.76 //y2=1.81
r56 (  18 35 ) resistor r=27.3797 //w=0.187 //l=0.4 //layer=li //thickness=0.1 \
 //x=32.845 //y=1.77 //x2=33.245 //y2=1.77
r57 (  17 35 ) resistor r=0.751729 //w=0.17 //l=0.085 //layer=li \
 //thickness=0.1 //x=33.645 //y=1.77 //x2=33.73 //y2=1.77
r58 (  17 35 ) resistor r=27.3797 //w=0.187 //l=0.4 //layer=li //thickness=0.1 \
 //x=33.645 //y=1.77 //x2=33.245 //y2=1.77
r59 (  14 35 ) resistor r=3.57586 //w=0.17 //l=0.103078 //layer=li \
 //thickness=0.1 //x=32.845 //y=0.72 //x2=32.76 //y2=0.68
r60 (  14 35 ) resistor r=27.3797 //w=0.187 //l=0.4 //layer=li //thickness=0.1 \
 //x=32.845 //y=0.72 //x2=33.245 //y2=0.72
r61 (  13 35 ) resistor r=0.751729 //w=0.17 //l=0.085 //layer=li \
 //thickness=0.1 //x=33.645 //y=0.72 //x2=33.73 //y2=0.72
r62 (  13 35 ) resistor r=27.3797 //w=0.187 //l=0.4 //layer=li //thickness=0.1 \
 //x=33.645 //y=0.72 //x2=33.245 //y2=0.72
r63 (  10 35 ) resistor r=1.40859 //w=0.34 //l=0.125 //layer=li \
 //thickness=0.1 //x=32.76 //y=1.685 //x2=32.76 //y2=1.81
r64 (  10 35 ) resistor r=42.0963 //w=0.187 //l=0.615 //layer=li \
 //thickness=0.1 //x=32.76 //y=1.685 //x2=32.76 //y2=1.07
r65 (  9 35 ) resistor r=3.57586 //w=0.17 //l=0.125 //layer=li //thickness=0.1 \
 //x=32.76 //y=0.805 //x2=32.76 //y2=0.68
r66 (  9 35 ) resistor r=18.139 //w=0.187 //l=0.265 //layer=li //thickness=0.1 \
 //x=32.76 //y=0.805 //x2=32.76 //y2=1.07
r67 (  6 35 ) resistor r=3.57586 //w=0.17 //l=0.103078 //layer=li \
 //thickness=0.1 //x=31.875 //y=1.77 //x2=31.79 //y2=1.81
r68 (  6 35 ) resistor r=27.3797 //w=0.187 //l=0.4 //layer=li //thickness=0.1 \
 //x=31.875 //y=1.77 //x2=32.275 //y2=1.77
r69 (  5 35 ) resistor r=5.4201 //w=0.17 //l=0.103078 //layer=li \
 //thickness=0.1 //x=32.675 //y=1.77 //x2=32.76 //y2=1.81
r70 (  5 35 ) resistor r=27.3797 //w=0.187 //l=0.4 //layer=li //thickness=0.1 \
 //x=32.675 //y=1.77 //x2=32.275 //y2=1.77
r71 (  1 35 ) resistor r=3.57586 //w=0.17 //l=0.125 //layer=li //thickness=0.1 \
 //x=31.79 //y=1.685 //x2=31.79 //y2=1.81
r72 (  1 35 ) resistor r=42.0963 //w=0.187 //l=0.615 //layer=li \
 //thickness=0.1 //x=31.79 //y=1.685 //x2=31.79 //y2=1.07
ends PM_TMRDFFRNQX1\%noxref_35

subckt PM_TMRDFFRNQX1\%noxref_36 ( 1 3 11 15 25 28 29 )
c53 ( 29 0 ) capacitor c=0.0413887f //x=34.165 //y=0.555
c54 ( 28 0 ) capacitor c=0.0045748f //x=33.06 //y=1.09
c55 ( 25 0 ) capacitor c=0.00156479f //x=34.3 //y=1.175
c56 ( 15 0 ) capacitor c=0.00737666f //x=35.27 //y=0.805
c57 ( 11 0 ) capacitor c=0.0144218f //x=35.185 //y=0.72
c58 ( 3 0 ) capacitor c=0.00718386f //x=34.3 //y=0.805
c59 ( 1 0 ) capacitor c=0.0218888f //x=34.215 //y=1.175
r60 (  15 29 ) resistor r=3.57586 //w=0.17 //l=0.125 //layer=li \
 //thickness=0.1 //x=35.27 //y=0.805 //x2=35.27 //y2=0.68
r61 (  15 29 ) resistor r=18.139 //w=0.187 //l=0.265 //layer=li \
 //thickness=0.1 //x=35.27 //y=0.805 //x2=35.27 //y2=1.07
r62 (  12 29 ) resistor r=3.57586 //w=0.17 //l=0.103078 //layer=li \
 //thickness=0.1 //x=34.385 //y=0.72 //x2=34.3 //y2=0.68
r63 (  12 29 ) resistor r=27.3797 //w=0.187 //l=0.4 //layer=li //thickness=0.1 \
 //x=34.385 //y=0.72 //x2=34.785 //y2=0.72
r64 (  11 29 ) resistor r=3.57586 //w=0.17 //l=0.103078 //layer=li \
 //thickness=0.1 //x=35.185 //y=0.72 //x2=35.27 //y2=0.68
r65 (  11 29 ) resistor r=27.3797 //w=0.187 //l=0.4 //layer=li //thickness=0.1 \
 //x=35.185 //y=0.72 //x2=34.785 //y2=0.72
r66 (  7 25 ) resistor r=5.4201 //w=0.17 //l=0.085 //layer=li //thickness=0.1 \
 //x=34.3 //y=1.26 //x2=34.3 //y2=1.175
r67 (  7 29 ) resistor r=10.2674 //w=0.187 //l=0.15 //layer=li //thickness=0.1 \
 //x=34.3 //y=1.26 //x2=34.3 //y2=1.41
r68 (  4 25 ) resistor r=5.4201 //w=0.17 //l=0.085 //layer=li //thickness=0.1 \
 //x=34.3 //y=1.09 //x2=34.3 //y2=1.175
r69 (  4 29 ) resistor r=1.36898 //w=0.187 //l=0.02 //layer=li //thickness=0.1 \
 //x=34.3 //y=1.09 //x2=34.3 //y2=1.07
r70 (  3 29 ) resistor r=3.57586 //w=0.17 //l=0.125 //layer=li //thickness=0.1 \
 //x=34.3 //y=0.805 //x2=34.3 //y2=0.68
r71 (  3 29 ) resistor r=18.139 //w=0.187 //l=0.265 //layer=li //thickness=0.1 \
 //x=34.3 //y=0.805 //x2=34.3 //y2=1.07
r72 (  2 28 ) resistor r=0.751729 //w=0.17 //l=0.085 //layer=li \
 //thickness=0.1 //x=33.335 //y=1.175 //x2=33.25 //y2=1.175
r73 (  1 25 ) resistor r=1.40859 //w=0.34 //l=0.085 //layer=li //thickness=0.1 \
 //x=34.215 //y=1.175 //x2=34.3 //y2=1.175
r74 (  1 2 ) resistor r=60.2353 //w=0.187 //l=0.88 //layer=li //thickness=0.1 \
 //x=34.215 //y=1.175 //x2=33.335 //y2=1.175
ends PM_TMRDFFRNQX1\%noxref_36

subckt PM_TMRDFFRNQX1\%noxref_37 ( 1 5 9 10 13 17 29 )
c51 ( 29 0 ) capacitor c=0.0632682f //x=36.57 //y=0.545
c52 ( 17 0 ) capacitor c=0.0072343f //x=38.645 //y=0.795
c53 ( 13 0 ) capacitor c=0.0145084f //x=38.56 //y=0.71
c54 ( 10 0 ) capacitor c=0.00582081f //x=37.675 //y=1.675
c55 ( 9 0 ) capacitor c=0.006761f //x=37.675 //y=0.795
c56 ( 5 0 ) capacitor c=0.0173046f //x=37.59 //y=1.76
c57 ( 1 0 ) capacitor c=0.00733328f //x=36.705 //y=1.675
r58 (  17 29 ) resistor r=3.57586 //w=0.17 //l=0.125 //layer=li \
 //thickness=0.1 //x=38.645 //y=0.795 //x2=38.645 //y2=0.67
r59 (  17 29 ) resistor r=18.139 //w=0.187 //l=0.265 //layer=li \
 //thickness=0.1 //x=38.645 //y=0.795 //x2=38.645 //y2=1.06
r60 (  14 29 ) resistor r=3.57586 //w=0.17 //l=0.103078 //layer=li \
 //thickness=0.1 //x=37.76 //y=0.71 //x2=37.675 //y2=0.67
r61 (  14 29 ) resistor r=27.3797 //w=0.187 //l=0.4 //layer=li //thickness=0.1 \
 //x=37.76 //y=0.71 //x2=38.16 //y2=0.71
r62 (  13 29 ) resistor r=3.57586 //w=0.17 //l=0.103078 //layer=li \
 //thickness=0.1 //x=38.56 //y=0.71 //x2=38.645 //y2=0.67
r63 (  13 29 ) resistor r=27.3797 //w=0.187 //l=0.4 //layer=li //thickness=0.1 \
 //x=38.56 //y=0.71 //x2=38.16 //y2=0.71
r64 (  10 29 ) resistor r=3.57586 //w=0.17 //l=0.125 //layer=li \
 //thickness=0.1 //x=37.675 //y=1.675 //x2=37.675 //y2=1.8
r65 (  10 29 ) resistor r=42.0963 //w=0.187 //l=0.615 //layer=li \
 //thickness=0.1 //x=37.675 //y=1.675 //x2=37.675 //y2=1.06
r66 (  9 29 ) resistor r=3.57586 //w=0.17 //l=0.125 //layer=li //thickness=0.1 \
 //x=37.675 //y=0.795 //x2=37.675 //y2=0.67
r67 (  9 29 ) resistor r=18.139 //w=0.187 //l=0.265 //layer=li //thickness=0.1 \
 //x=37.675 //y=0.795 //x2=37.675 //y2=1.06
r68 (  6 29 ) resistor r=3.57586 //w=0.17 //l=0.103078 //layer=li \
 //thickness=0.1 //x=36.79 //y=1.76 //x2=36.705 //y2=1.8
r69 (  6 29 ) resistor r=27.3797 //w=0.187 //l=0.4 //layer=li //thickness=0.1 \
 //x=36.79 //y=1.76 //x2=37.19 //y2=1.76
r70 (  5 29 ) resistor r=3.57586 //w=0.17 //l=0.103078 //layer=li \
 //thickness=0.1 //x=37.59 //y=1.76 //x2=37.675 //y2=1.8
r71 (  5 29 ) resistor r=27.3797 //w=0.187 //l=0.4 //layer=li //thickness=0.1 \
 //x=37.59 //y=1.76 //x2=37.19 //y2=1.76
r72 (  1 29 ) resistor r=3.57586 //w=0.17 //l=0.125 //layer=li //thickness=0.1 \
 //x=36.705 //y=1.675 //x2=36.705 //y2=1.8
r73 (  1 29 ) resistor r=42.0963 //w=0.187 //l=0.615 //layer=li \
 //thickness=0.1 //x=36.705 //y=1.675 //x2=36.705 //y2=1.06
ends PM_TMRDFFRNQX1\%noxref_37

subckt PM_TMRDFFRNQX1\%noxref_38 ( 1 5 9 13 17 35 )
c49 ( 35 0 ) capacitor c=0.0673029f //x=39.795 //y=0.555
c50 ( 17 0 ) capacitor c=0.0178317f //x=41.785 //y=1.77
c51 ( 13 0 ) capacitor c=0.0154936f //x=41.785 //y=0.72
c52 ( 9 0 ) capacitor c=0.00678203f //x=40.9 //y=0.805
c53 ( 5 0 ) capacitor c=0.0164013f //x=40.815 //y=1.77
c54 ( 1 0 ) capacitor c=0.00696517f //x=39.93 //y=1.685
r55 (  18 35 ) resistor r=5.4201 //w=0.17 //l=0.103078 //layer=li \
 //thickness=0.1 //x=40.985 //y=1.77 //x2=40.9 //y2=1.81
r56 (  18 35 ) resistor r=27.3797 //w=0.187 //l=0.4 //layer=li //thickness=0.1 \
 //x=40.985 //y=1.77 //x2=41.385 //y2=1.77
r57 (  17 35 ) resistor r=0.751729 //w=0.17 //l=0.085 //layer=li \
 //thickness=0.1 //x=41.785 //y=1.77 //x2=41.87 //y2=1.77
r58 (  17 35 ) resistor r=27.3797 //w=0.187 //l=0.4 //layer=li //thickness=0.1 \
 //x=41.785 //y=1.77 //x2=41.385 //y2=1.77
r59 (  14 35 ) resistor r=3.57586 //w=0.17 //l=0.103078 //layer=li \
 //thickness=0.1 //x=40.985 //y=0.72 //x2=40.9 //y2=0.68
r60 (  14 35 ) resistor r=27.3797 //w=0.187 //l=0.4 //layer=li //thickness=0.1 \
 //x=40.985 //y=0.72 //x2=41.385 //y2=0.72
r61 (  13 35 ) resistor r=0.751729 //w=0.17 //l=0.085 //layer=li \
 //thickness=0.1 //x=41.785 //y=0.72 //x2=41.87 //y2=0.72
r62 (  13 35 ) resistor r=27.3797 //w=0.187 //l=0.4 //layer=li //thickness=0.1 \
 //x=41.785 //y=0.72 //x2=41.385 //y2=0.72
r63 (  10 35 ) resistor r=1.40859 //w=0.34 //l=0.125 //layer=li \
 //thickness=0.1 //x=40.9 //y=1.685 //x2=40.9 //y2=1.81
r64 (  10 35 ) resistor r=42.0963 //w=0.187 //l=0.615 //layer=li \
 //thickness=0.1 //x=40.9 //y=1.685 //x2=40.9 //y2=1.07
r65 (  9 35 ) resistor r=3.57586 //w=0.17 //l=0.125 //layer=li //thickness=0.1 \
 //x=40.9 //y=0.805 //x2=40.9 //y2=0.68
r66 (  9 35 ) resistor r=18.139 //w=0.187 //l=0.265 //layer=li //thickness=0.1 \
 //x=40.9 //y=0.805 //x2=40.9 //y2=1.07
r67 (  6 35 ) resistor r=3.57586 //w=0.17 //l=0.103078 //layer=li \
 //thickness=0.1 //x=40.015 //y=1.77 //x2=39.93 //y2=1.81
r68 (  6 35 ) resistor r=27.3797 //w=0.187 //l=0.4 //layer=li //thickness=0.1 \
 //x=40.015 //y=1.77 //x2=40.415 //y2=1.77
r69 (  5 35 ) resistor r=5.4201 //w=0.17 //l=0.103078 //layer=li \
 //thickness=0.1 //x=40.815 //y=1.77 //x2=40.9 //y2=1.81
r70 (  5 35 ) resistor r=27.3797 //w=0.187 //l=0.4 //layer=li //thickness=0.1 \
 //x=40.815 //y=1.77 //x2=40.415 //y2=1.77
r71 (  1 35 ) resistor r=3.57586 //w=0.17 //l=0.125 //layer=li //thickness=0.1 \
 //x=39.93 //y=1.685 //x2=39.93 //y2=1.81
r72 (  1 35 ) resistor r=42.0963 //w=0.187 //l=0.615 //layer=li \
 //thickness=0.1 //x=39.93 //y=1.685 //x2=39.93 //y2=1.07
ends PM_TMRDFFRNQX1\%noxref_38

subckt PM_TMRDFFRNQX1\%noxref_39 ( 1 3 11 15 25 28 29 )
c53 ( 29 0 ) capacitor c=0.0413887f //x=42.305 //y=0.555
c54 ( 28 0 ) capacitor c=0.0045748f //x=41.2 //y=1.09
c55 ( 25 0 ) capacitor c=0.00156479f //x=42.44 //y=1.175
c56 ( 15 0 ) capacitor c=0.00737666f //x=43.41 //y=0.805
c57 ( 11 0 ) capacitor c=0.0144218f //x=43.325 //y=0.72
c58 ( 3 0 ) capacitor c=0.00718386f //x=42.44 //y=0.805
c59 ( 1 0 ) capacitor c=0.0218888f //x=42.355 //y=1.175
r60 (  15 29 ) resistor r=3.57586 //w=0.17 //l=0.125 //layer=li \
 //thickness=0.1 //x=43.41 //y=0.805 //x2=43.41 //y2=0.68
r61 (  15 29 ) resistor r=18.139 //w=0.187 //l=0.265 //layer=li \
 //thickness=0.1 //x=43.41 //y=0.805 //x2=43.41 //y2=1.07
r62 (  12 29 ) resistor r=3.57586 //w=0.17 //l=0.103078 //layer=li \
 //thickness=0.1 //x=42.525 //y=0.72 //x2=42.44 //y2=0.68
r63 (  12 29 ) resistor r=27.3797 //w=0.187 //l=0.4 //layer=li //thickness=0.1 \
 //x=42.525 //y=0.72 //x2=42.925 //y2=0.72
r64 (  11 29 ) resistor r=3.57586 //w=0.17 //l=0.103078 //layer=li \
 //thickness=0.1 //x=43.325 //y=0.72 //x2=43.41 //y2=0.68
r65 (  11 29 ) resistor r=27.3797 //w=0.187 //l=0.4 //layer=li //thickness=0.1 \
 //x=43.325 //y=0.72 //x2=42.925 //y2=0.72
r66 (  7 25 ) resistor r=5.4201 //w=0.17 //l=0.085 //layer=li //thickness=0.1 \
 //x=42.44 //y=1.26 //x2=42.44 //y2=1.175
r67 (  7 29 ) resistor r=10.2674 //w=0.187 //l=0.15 //layer=li //thickness=0.1 \
 //x=42.44 //y=1.26 //x2=42.44 //y2=1.41
r68 (  4 25 ) resistor r=5.4201 //w=0.17 //l=0.085 //layer=li //thickness=0.1 \
 //x=42.44 //y=1.09 //x2=42.44 //y2=1.175
r69 (  4 29 ) resistor r=1.36898 //w=0.187 //l=0.02 //layer=li //thickness=0.1 \
 //x=42.44 //y=1.09 //x2=42.44 //y2=1.07
r70 (  3 29 ) resistor r=3.57586 //w=0.17 //l=0.125 //layer=li //thickness=0.1 \
 //x=42.44 //y=0.805 //x2=42.44 //y2=0.68
r71 (  3 29 ) resistor r=18.139 //w=0.187 //l=0.265 //layer=li //thickness=0.1 \
 //x=42.44 //y=0.805 //x2=42.44 //y2=1.07
r72 (  2 28 ) resistor r=0.751729 //w=0.17 //l=0.085 //layer=li \
 //thickness=0.1 //x=41.475 //y=1.175 //x2=41.39 //y2=1.175
r73 (  1 25 ) resistor r=1.40859 //w=0.34 //l=0.085 //layer=li //thickness=0.1 \
 //x=42.355 //y=1.175 //x2=42.44 //y2=1.175
r74 (  1 2 ) resistor r=60.2353 //w=0.187 //l=0.88 //layer=li //thickness=0.1 \
 //x=42.355 //y=1.175 //x2=41.475 //y2=1.175
ends PM_TMRDFFRNQX1\%noxref_39

subckt PM_TMRDFFRNQX1\%noxref_40 ( 1 5 9 13 17 35 )
c52 ( 35 0 ) capacitor c=0.0673029f //x=44.605 //y=0.555
c53 ( 17 0 ) capacitor c=0.0178286f //x=46.595 //y=1.77
c54 ( 13 0 ) capacitor c=0.0154917f //x=46.595 //y=0.72
c55 ( 9 0 ) capacitor c=0.00678203f //x=45.71 //y=0.805
c56 ( 5 0 ) capacitor c=0.0164013f //x=45.625 //y=1.77
c57 ( 1 0 ) capacitor c=0.00696517f //x=44.74 //y=1.685
r58 (  18 35 ) resistor r=5.4201 //w=0.17 //l=0.103078 //layer=li \
 //thickness=0.1 //x=45.795 //y=1.77 //x2=45.71 //y2=1.81
r59 (  18 35 ) resistor r=27.3797 //w=0.187 //l=0.4 //layer=li //thickness=0.1 \
 //x=45.795 //y=1.77 //x2=46.195 //y2=1.77
r60 (  17 35 ) resistor r=0.751729 //w=0.17 //l=0.085 //layer=li \
 //thickness=0.1 //x=46.595 //y=1.77 //x2=46.68 //y2=1.77
r61 (  17 35 ) resistor r=27.3797 //w=0.187 //l=0.4 //layer=li //thickness=0.1 \
 //x=46.595 //y=1.77 //x2=46.195 //y2=1.77
r62 (  14 35 ) resistor r=3.57586 //w=0.17 //l=0.103078 //layer=li \
 //thickness=0.1 //x=45.795 //y=0.72 //x2=45.71 //y2=0.68
r63 (  14 35 ) resistor r=27.3797 //w=0.187 //l=0.4 //layer=li //thickness=0.1 \
 //x=45.795 //y=0.72 //x2=46.195 //y2=0.72
r64 (  13 35 ) resistor r=0.751729 //w=0.17 //l=0.085 //layer=li \
 //thickness=0.1 //x=46.595 //y=0.72 //x2=46.68 //y2=0.72
r65 (  13 35 ) resistor r=27.3797 //w=0.187 //l=0.4 //layer=li //thickness=0.1 \
 //x=46.595 //y=0.72 //x2=46.195 //y2=0.72
r66 (  10 35 ) resistor r=1.40859 //w=0.34 //l=0.125 //layer=li \
 //thickness=0.1 //x=45.71 //y=1.685 //x2=45.71 //y2=1.81
r67 (  10 35 ) resistor r=42.0963 //w=0.187 //l=0.615 //layer=li \
 //thickness=0.1 //x=45.71 //y=1.685 //x2=45.71 //y2=1.07
r68 (  9 35 ) resistor r=3.57586 //w=0.17 //l=0.125 //layer=li //thickness=0.1 \
 //x=45.71 //y=0.805 //x2=45.71 //y2=0.68
r69 (  9 35 ) resistor r=18.139 //w=0.187 //l=0.265 //layer=li //thickness=0.1 \
 //x=45.71 //y=0.805 //x2=45.71 //y2=1.07
r70 (  6 35 ) resistor r=3.57586 //w=0.17 //l=0.103078 //layer=li \
 //thickness=0.1 //x=44.825 //y=1.77 //x2=44.74 //y2=1.81
r71 (  6 35 ) resistor r=27.3797 //w=0.187 //l=0.4 //layer=li //thickness=0.1 \
 //x=44.825 //y=1.77 //x2=45.225 //y2=1.77
r72 (  5 35 ) resistor r=5.4201 //w=0.17 //l=0.103078 //layer=li \
 //thickness=0.1 //x=45.625 //y=1.77 //x2=45.71 //y2=1.81
r73 (  5 35 ) resistor r=27.3797 //w=0.187 //l=0.4 //layer=li //thickness=0.1 \
 //x=45.625 //y=1.77 //x2=45.225 //y2=1.77
r74 (  1 35 ) resistor r=3.57586 //w=0.17 //l=0.125 //layer=li //thickness=0.1 \
 //x=44.74 //y=1.685 //x2=44.74 //y2=1.81
r75 (  1 35 ) resistor r=42.0963 //w=0.187 //l=0.615 //layer=li \
 //thickness=0.1 //x=44.74 //y=1.685 //x2=44.74 //y2=1.07
ends PM_TMRDFFRNQX1\%noxref_40

subckt PM_TMRDFFRNQX1\%noxref_41 ( 1 3 11 15 25 28 29 )
c52 ( 29 0 ) capacitor c=0.0413887f //x=47.115 //y=0.555
c53 ( 28 0 ) capacitor c=0.00457437f //x=46.01 //y=1.09
c54 ( 25 0 ) capacitor c=0.00156479f //x=47.25 //y=1.175
c55 ( 15 0 ) capacitor c=0.00737666f //x=48.22 //y=0.805
c56 ( 11 0 ) capacitor c=0.0144274f //x=48.135 //y=0.72
c57 ( 3 0 ) capacitor c=0.00718386f //x=47.25 //y=0.805
c58 ( 1 0 ) capacitor c=0.0218873f //x=47.165 //y=1.175
r59 (  15 29 ) resistor r=3.57586 //w=0.17 //l=0.125 //layer=li \
 //thickness=0.1 //x=48.22 //y=0.805 //x2=48.22 //y2=0.68
r60 (  15 29 ) resistor r=18.139 //w=0.187 //l=0.265 //layer=li \
 //thickness=0.1 //x=48.22 //y=0.805 //x2=48.22 //y2=1.07
r61 (  12 29 ) resistor r=3.57586 //w=0.17 //l=0.103078 //layer=li \
 //thickness=0.1 //x=47.335 //y=0.72 //x2=47.25 //y2=0.68
r62 (  12 29 ) resistor r=27.3797 //w=0.187 //l=0.4 //layer=li //thickness=0.1 \
 //x=47.335 //y=0.72 //x2=47.735 //y2=0.72
r63 (  11 29 ) resistor r=3.57586 //w=0.17 //l=0.103078 //layer=li \
 //thickness=0.1 //x=48.135 //y=0.72 //x2=48.22 //y2=0.68
r64 (  11 29 ) resistor r=27.3797 //w=0.187 //l=0.4 //layer=li //thickness=0.1 \
 //x=48.135 //y=0.72 //x2=47.735 //y2=0.72
r65 (  7 25 ) resistor r=5.4201 //w=0.17 //l=0.085 //layer=li //thickness=0.1 \
 //x=47.25 //y=1.26 //x2=47.25 //y2=1.175
r66 (  7 29 ) resistor r=10.2674 //w=0.187 //l=0.15 //layer=li //thickness=0.1 \
 //x=47.25 //y=1.26 //x2=47.25 //y2=1.41
r67 (  4 25 ) resistor r=5.4201 //w=0.17 //l=0.085 //layer=li //thickness=0.1 \
 //x=47.25 //y=1.09 //x2=47.25 //y2=1.175
r68 (  4 29 ) resistor r=1.36898 //w=0.187 //l=0.02 //layer=li //thickness=0.1 \
 //x=47.25 //y=1.09 //x2=47.25 //y2=1.07
r69 (  3 29 ) resistor r=3.57586 //w=0.17 //l=0.125 //layer=li //thickness=0.1 \
 //x=47.25 //y=0.805 //x2=47.25 //y2=0.68
r70 (  3 29 ) resistor r=18.139 //w=0.187 //l=0.265 //layer=li //thickness=0.1 \
 //x=47.25 //y=0.805 //x2=47.25 //y2=1.07
r71 (  2 28 ) resistor r=0.751729 //w=0.17 //l=0.085 //layer=li \
 //thickness=0.1 //x=46.285 //y=1.175 //x2=46.2 //y2=1.175
r72 (  1 25 ) resistor r=1.40859 //w=0.34 //l=0.085 //layer=li //thickness=0.1 \
 //x=47.165 //y=1.175 //x2=47.25 //y2=1.175
r73 (  1 2 ) resistor r=60.2353 //w=0.187 //l=0.88 //layer=li //thickness=0.1 \
 //x=47.165 //y=1.175 //x2=46.285 //y2=1.175
ends PM_TMRDFFRNQX1\%noxref_41

subckt PM_TMRDFFRNQX1\%noxref_42 ( 1 5 9 10 13 17 29 )
c51 ( 29 0 ) capacitor c=0.0632682f //x=49.52 //y=0.545
c52 ( 17 0 ) capacitor c=0.0072343f //x=51.595 //y=0.795
c53 ( 13 0 ) capacitor c=0.0145084f //x=51.51 //y=0.71
c54 ( 10 0 ) capacitor c=0.00582081f //x=50.625 //y=1.675
c55 ( 9 0 ) capacitor c=0.006761f //x=50.625 //y=0.795
c56 ( 5 0 ) capacitor c=0.0173046f //x=50.54 //y=1.76
c57 ( 1 0 ) capacitor c=0.00733328f //x=49.655 //y=1.675
r58 (  17 29 ) resistor r=3.57586 //w=0.17 //l=0.125 //layer=li \
 //thickness=0.1 //x=51.595 //y=0.795 //x2=51.595 //y2=0.67
r59 (  17 29 ) resistor r=18.139 //w=0.187 //l=0.265 //layer=li \
 //thickness=0.1 //x=51.595 //y=0.795 //x2=51.595 //y2=1.06
r60 (  14 29 ) resistor r=3.57586 //w=0.17 //l=0.103078 //layer=li \
 //thickness=0.1 //x=50.71 //y=0.71 //x2=50.625 //y2=0.67
r61 (  14 29 ) resistor r=27.3797 //w=0.187 //l=0.4 //layer=li //thickness=0.1 \
 //x=50.71 //y=0.71 //x2=51.11 //y2=0.71
r62 (  13 29 ) resistor r=3.57586 //w=0.17 //l=0.103078 //layer=li \
 //thickness=0.1 //x=51.51 //y=0.71 //x2=51.595 //y2=0.67
r63 (  13 29 ) resistor r=27.3797 //w=0.187 //l=0.4 //layer=li //thickness=0.1 \
 //x=51.51 //y=0.71 //x2=51.11 //y2=0.71
r64 (  10 29 ) resistor r=3.57586 //w=0.17 //l=0.125 //layer=li \
 //thickness=0.1 //x=50.625 //y=1.675 //x2=50.625 //y2=1.8
r65 (  10 29 ) resistor r=42.0963 //w=0.187 //l=0.615 //layer=li \
 //thickness=0.1 //x=50.625 //y=1.675 //x2=50.625 //y2=1.06
r66 (  9 29 ) resistor r=3.57586 //w=0.17 //l=0.125 //layer=li //thickness=0.1 \
 //x=50.625 //y=0.795 //x2=50.625 //y2=0.67
r67 (  9 29 ) resistor r=18.139 //w=0.187 //l=0.265 //layer=li //thickness=0.1 \
 //x=50.625 //y=0.795 //x2=50.625 //y2=1.06
r68 (  6 29 ) resistor r=3.57586 //w=0.17 //l=0.103078 //layer=li \
 //thickness=0.1 //x=49.74 //y=1.76 //x2=49.655 //y2=1.8
r69 (  6 29 ) resistor r=27.3797 //w=0.187 //l=0.4 //layer=li //thickness=0.1 \
 //x=49.74 //y=1.76 //x2=50.14 //y2=1.76
r70 (  5 29 ) resistor r=3.57586 //w=0.17 //l=0.103078 //layer=li \
 //thickness=0.1 //x=50.54 //y=1.76 //x2=50.625 //y2=1.8
r71 (  5 29 ) resistor r=27.3797 //w=0.187 //l=0.4 //layer=li //thickness=0.1 \
 //x=50.54 //y=1.76 //x2=50.14 //y2=1.76
r72 (  1 29 ) resistor r=3.57586 //w=0.17 //l=0.125 //layer=li //thickness=0.1 \
 //x=49.655 //y=1.675 //x2=49.655 //y2=1.8
r73 (  1 29 ) resistor r=42.0963 //w=0.187 //l=0.615 //layer=li \
 //thickness=0.1 //x=49.655 //y=1.675 //x2=49.655 //y2=1.06
ends PM_TMRDFFRNQX1\%noxref_42

subckt PM_TMRDFFRNQX1\%noxref_43 ( 1 5 9 13 17 35 )
c49 ( 35 0 ) capacitor c=0.0673029f //x=52.745 //y=0.555
c50 ( 17 0 ) capacitor c=0.0178317f //x=54.735 //y=1.77
c51 ( 13 0 ) capacitor c=0.0154936f //x=54.735 //y=0.72
c52 ( 9 0 ) capacitor c=0.00678203f //x=53.85 //y=0.805
c53 ( 5 0 ) capacitor c=0.0164013f //x=53.765 //y=1.77
c54 ( 1 0 ) capacitor c=0.00696517f //x=52.88 //y=1.685
r55 (  18 35 ) resistor r=5.4201 //w=0.17 //l=0.103078 //layer=li \
 //thickness=0.1 //x=53.935 //y=1.77 //x2=53.85 //y2=1.81
r56 (  18 35 ) resistor r=27.3797 //w=0.187 //l=0.4 //layer=li //thickness=0.1 \
 //x=53.935 //y=1.77 //x2=54.335 //y2=1.77
r57 (  17 35 ) resistor r=0.751729 //w=0.17 //l=0.085 //layer=li \
 //thickness=0.1 //x=54.735 //y=1.77 //x2=54.82 //y2=1.77
r58 (  17 35 ) resistor r=27.3797 //w=0.187 //l=0.4 //layer=li //thickness=0.1 \
 //x=54.735 //y=1.77 //x2=54.335 //y2=1.77
r59 (  14 35 ) resistor r=3.57586 //w=0.17 //l=0.103078 //layer=li \
 //thickness=0.1 //x=53.935 //y=0.72 //x2=53.85 //y2=0.68
r60 (  14 35 ) resistor r=27.3797 //w=0.187 //l=0.4 //layer=li //thickness=0.1 \
 //x=53.935 //y=0.72 //x2=54.335 //y2=0.72
r61 (  13 35 ) resistor r=0.751729 //w=0.17 //l=0.085 //layer=li \
 //thickness=0.1 //x=54.735 //y=0.72 //x2=54.82 //y2=0.72
r62 (  13 35 ) resistor r=27.3797 //w=0.187 //l=0.4 //layer=li //thickness=0.1 \
 //x=54.735 //y=0.72 //x2=54.335 //y2=0.72
r63 (  10 35 ) resistor r=1.40859 //w=0.34 //l=0.125 //layer=li \
 //thickness=0.1 //x=53.85 //y=1.685 //x2=53.85 //y2=1.81
r64 (  10 35 ) resistor r=42.0963 //w=0.187 //l=0.615 //layer=li \
 //thickness=0.1 //x=53.85 //y=1.685 //x2=53.85 //y2=1.07
r65 (  9 35 ) resistor r=3.57586 //w=0.17 //l=0.125 //layer=li //thickness=0.1 \
 //x=53.85 //y=0.805 //x2=53.85 //y2=0.68
r66 (  9 35 ) resistor r=18.139 //w=0.187 //l=0.265 //layer=li //thickness=0.1 \
 //x=53.85 //y=0.805 //x2=53.85 //y2=1.07
r67 (  6 35 ) resistor r=3.57586 //w=0.17 //l=0.103078 //layer=li \
 //thickness=0.1 //x=52.965 //y=1.77 //x2=52.88 //y2=1.81
r68 (  6 35 ) resistor r=27.3797 //w=0.187 //l=0.4 //layer=li //thickness=0.1 \
 //x=52.965 //y=1.77 //x2=53.365 //y2=1.77
r69 (  5 35 ) resistor r=5.4201 //w=0.17 //l=0.103078 //layer=li \
 //thickness=0.1 //x=53.765 //y=1.77 //x2=53.85 //y2=1.81
r70 (  5 35 ) resistor r=27.3797 //w=0.187 //l=0.4 //layer=li //thickness=0.1 \
 //x=53.765 //y=1.77 //x2=53.365 //y2=1.77
r71 (  1 35 ) resistor r=3.57586 //w=0.17 //l=0.125 //layer=li //thickness=0.1 \
 //x=52.88 //y=1.685 //x2=52.88 //y2=1.81
r72 (  1 35 ) resistor r=42.0963 //w=0.187 //l=0.615 //layer=li \
 //thickness=0.1 //x=52.88 //y=1.685 //x2=52.88 //y2=1.07
ends PM_TMRDFFRNQX1\%noxref_43

subckt PM_TMRDFFRNQX1\%noxref_44 ( 1 3 11 15 25 28 29 )
c52 ( 29 0 ) capacitor c=0.0413887f //x=55.255 //y=0.555
c53 ( 28 0 ) capacitor c=0.0045748f //x=54.15 //y=1.09
c54 ( 25 0 ) capacitor c=0.00156479f //x=55.39 //y=1.175
c55 ( 15 0 ) capacitor c=0.00737666f //x=56.36 //y=0.805
c56 ( 11 0 ) capacitor c=0.0144274f //x=56.275 //y=0.72
c57 ( 3 0 ) capacitor c=0.00718386f //x=55.39 //y=0.805
c58 ( 1 0 ) capacitor c=0.0218888f //x=55.305 //y=1.175
r59 (  15 29 ) resistor r=3.57586 //w=0.17 //l=0.125 //layer=li \
 //thickness=0.1 //x=56.36 //y=0.805 //x2=56.36 //y2=0.68
r60 (  15 29 ) resistor r=18.139 //w=0.187 //l=0.265 //layer=li \
 //thickness=0.1 //x=56.36 //y=0.805 //x2=56.36 //y2=1.07
r61 (  12 29 ) resistor r=3.57586 //w=0.17 //l=0.103078 //layer=li \
 //thickness=0.1 //x=55.475 //y=0.72 //x2=55.39 //y2=0.68
r62 (  12 29 ) resistor r=27.3797 //w=0.187 //l=0.4 //layer=li //thickness=0.1 \
 //x=55.475 //y=0.72 //x2=55.875 //y2=0.72
r63 (  11 29 ) resistor r=3.57586 //w=0.17 //l=0.103078 //layer=li \
 //thickness=0.1 //x=56.275 //y=0.72 //x2=56.36 //y2=0.68
r64 (  11 29 ) resistor r=27.3797 //w=0.187 //l=0.4 //layer=li //thickness=0.1 \
 //x=56.275 //y=0.72 //x2=55.875 //y2=0.72
r65 (  7 25 ) resistor r=5.4201 //w=0.17 //l=0.085 //layer=li //thickness=0.1 \
 //x=55.39 //y=1.26 //x2=55.39 //y2=1.175
r66 (  7 29 ) resistor r=10.2674 //w=0.187 //l=0.15 //layer=li //thickness=0.1 \
 //x=55.39 //y=1.26 //x2=55.39 //y2=1.41
r67 (  4 25 ) resistor r=5.4201 //w=0.17 //l=0.085 //layer=li //thickness=0.1 \
 //x=55.39 //y=1.09 //x2=55.39 //y2=1.175
r68 (  4 29 ) resistor r=1.36898 //w=0.187 //l=0.02 //layer=li //thickness=0.1 \
 //x=55.39 //y=1.09 //x2=55.39 //y2=1.07
r69 (  3 29 ) resistor r=3.57586 //w=0.17 //l=0.125 //layer=li //thickness=0.1 \
 //x=55.39 //y=0.805 //x2=55.39 //y2=0.68
r70 (  3 29 ) resistor r=18.139 //w=0.187 //l=0.265 //layer=li //thickness=0.1 \
 //x=55.39 //y=0.805 //x2=55.39 //y2=1.07
r71 (  2 28 ) resistor r=0.751729 //w=0.17 //l=0.085 //layer=li \
 //thickness=0.1 //x=54.425 //y=1.175 //x2=54.34 //y2=1.175
r72 (  1 25 ) resistor r=1.40859 //w=0.34 //l=0.085 //layer=li //thickness=0.1 \
 //x=55.305 //y=1.175 //x2=55.39 //y2=1.175
r73 (  1 2 ) resistor r=60.2353 //w=0.187 //l=0.88 //layer=li //thickness=0.1 \
 //x=55.305 //y=1.175 //x2=54.425 //y2=1.175
ends PM_TMRDFFRNQX1\%noxref_44

subckt PM_TMRDFFRNQX1\%noxref_45 ( 1 5 9 13 17 35 )
c49 ( 35 0 ) capacitor c=0.0673029f //x=57.555 //y=0.555
c50 ( 17 0 ) capacitor c=0.0178317f //x=59.545 //y=1.77
c51 ( 13 0 ) capacitor c=0.0154936f //x=59.545 //y=0.72
c52 ( 9 0 ) capacitor c=0.00678203f //x=58.66 //y=0.805
c53 ( 5 0 ) capacitor c=0.0164013f //x=58.575 //y=1.77
c54 ( 1 0 ) capacitor c=0.00696517f //x=57.69 //y=1.685
r55 (  18 35 ) resistor r=5.4201 //w=0.17 //l=0.103078 //layer=li \
 //thickness=0.1 //x=58.745 //y=1.77 //x2=58.66 //y2=1.81
r56 (  18 35 ) resistor r=27.3797 //w=0.187 //l=0.4 //layer=li //thickness=0.1 \
 //x=58.745 //y=1.77 //x2=59.145 //y2=1.77
r57 (  17 35 ) resistor r=0.751729 //w=0.17 //l=0.085 //layer=li \
 //thickness=0.1 //x=59.545 //y=1.77 //x2=59.63 //y2=1.77
r58 (  17 35 ) resistor r=27.3797 //w=0.187 //l=0.4 //layer=li //thickness=0.1 \
 //x=59.545 //y=1.77 //x2=59.145 //y2=1.77
r59 (  14 35 ) resistor r=3.57586 //w=0.17 //l=0.103078 //layer=li \
 //thickness=0.1 //x=58.745 //y=0.72 //x2=58.66 //y2=0.68
r60 (  14 35 ) resistor r=27.3797 //w=0.187 //l=0.4 //layer=li //thickness=0.1 \
 //x=58.745 //y=0.72 //x2=59.145 //y2=0.72
r61 (  13 35 ) resistor r=0.751729 //w=0.17 //l=0.085 //layer=li \
 //thickness=0.1 //x=59.545 //y=0.72 //x2=59.63 //y2=0.72
r62 (  13 35 ) resistor r=27.3797 //w=0.187 //l=0.4 //layer=li //thickness=0.1 \
 //x=59.545 //y=0.72 //x2=59.145 //y2=0.72
r63 (  10 35 ) resistor r=1.40859 //w=0.34 //l=0.125 //layer=li \
 //thickness=0.1 //x=58.66 //y=1.685 //x2=58.66 //y2=1.81
r64 (  10 35 ) resistor r=42.0963 //w=0.187 //l=0.615 //layer=li \
 //thickness=0.1 //x=58.66 //y=1.685 //x2=58.66 //y2=1.07
r65 (  9 35 ) resistor r=3.57586 //w=0.17 //l=0.125 //layer=li //thickness=0.1 \
 //x=58.66 //y=0.805 //x2=58.66 //y2=0.68
r66 (  9 35 ) resistor r=18.139 //w=0.187 //l=0.265 //layer=li //thickness=0.1 \
 //x=58.66 //y=0.805 //x2=58.66 //y2=1.07
r67 (  6 35 ) resistor r=3.57586 //w=0.17 //l=0.103078 //layer=li \
 //thickness=0.1 //x=57.775 //y=1.77 //x2=57.69 //y2=1.81
r68 (  6 35 ) resistor r=27.3797 //w=0.187 //l=0.4 //layer=li //thickness=0.1 \
 //x=57.775 //y=1.77 //x2=58.175 //y2=1.77
r69 (  5 35 ) resistor r=5.4201 //w=0.17 //l=0.103078 //layer=li \
 //thickness=0.1 //x=58.575 //y=1.77 //x2=58.66 //y2=1.81
r70 (  5 35 ) resistor r=27.3797 //w=0.187 //l=0.4 //layer=li //thickness=0.1 \
 //x=58.575 //y=1.77 //x2=58.175 //y2=1.77
r71 (  1 35 ) resistor r=3.57586 //w=0.17 //l=0.125 //layer=li //thickness=0.1 \
 //x=57.69 //y=1.685 //x2=57.69 //y2=1.81
r72 (  1 35 ) resistor r=42.0963 //w=0.187 //l=0.615 //layer=li \
 //thickness=0.1 //x=57.69 //y=1.685 //x2=57.69 //y2=1.07
ends PM_TMRDFFRNQX1\%noxref_45

subckt PM_TMRDFFRNQX1\%noxref_46 ( 1 3 11 15 25 28 29 )
c53 ( 29 0 ) capacitor c=0.0413887f //x=60.065 //y=0.555
c54 ( 28 0 ) capacitor c=0.0045748f //x=58.96 //y=1.09
c55 ( 25 0 ) capacitor c=0.00156479f //x=60.2 //y=1.175
c56 ( 15 0 ) capacitor c=0.00737666f //x=61.17 //y=0.805
c57 ( 11 0 ) capacitor c=0.0144218f //x=61.085 //y=0.72
c58 ( 3 0 ) capacitor c=0.00718386f //x=60.2 //y=0.805
c59 ( 1 0 ) capacitor c=0.0218888f //x=60.115 //y=1.175
r60 (  15 29 ) resistor r=3.57586 //w=0.17 //l=0.125 //layer=li \
 //thickness=0.1 //x=61.17 //y=0.805 //x2=61.17 //y2=0.68
r61 (  15 29 ) resistor r=18.139 //w=0.187 //l=0.265 //layer=li \
 //thickness=0.1 //x=61.17 //y=0.805 //x2=61.17 //y2=1.07
r62 (  12 29 ) resistor r=3.57586 //w=0.17 //l=0.103078 //layer=li \
 //thickness=0.1 //x=60.285 //y=0.72 //x2=60.2 //y2=0.68
r63 (  12 29 ) resistor r=27.3797 //w=0.187 //l=0.4 //layer=li //thickness=0.1 \
 //x=60.285 //y=0.72 //x2=60.685 //y2=0.72
r64 (  11 29 ) resistor r=3.57586 //w=0.17 //l=0.103078 //layer=li \
 //thickness=0.1 //x=61.085 //y=0.72 //x2=61.17 //y2=0.68
r65 (  11 29 ) resistor r=27.3797 //w=0.187 //l=0.4 //layer=li //thickness=0.1 \
 //x=61.085 //y=0.72 //x2=60.685 //y2=0.72
r66 (  7 25 ) resistor r=5.4201 //w=0.17 //l=0.085 //layer=li //thickness=0.1 \
 //x=60.2 //y=1.26 //x2=60.2 //y2=1.175
r67 (  7 29 ) resistor r=10.2674 //w=0.187 //l=0.15 //layer=li //thickness=0.1 \
 //x=60.2 //y=1.26 //x2=60.2 //y2=1.41
r68 (  4 25 ) resistor r=5.4201 //w=0.17 //l=0.085 //layer=li //thickness=0.1 \
 //x=60.2 //y=1.09 //x2=60.2 //y2=1.175
r69 (  4 29 ) resistor r=1.36898 //w=0.187 //l=0.02 //layer=li //thickness=0.1 \
 //x=60.2 //y=1.09 //x2=60.2 //y2=1.07
r70 (  3 29 ) resistor r=3.57586 //w=0.17 //l=0.125 //layer=li //thickness=0.1 \
 //x=60.2 //y=0.805 //x2=60.2 //y2=0.68
r71 (  3 29 ) resistor r=18.139 //w=0.187 //l=0.265 //layer=li //thickness=0.1 \
 //x=60.2 //y=0.805 //x2=60.2 //y2=1.07
r72 (  2 28 ) resistor r=0.751729 //w=0.17 //l=0.085 //layer=li \
 //thickness=0.1 //x=59.235 //y=1.175 //x2=59.15 //y2=1.175
r73 (  1 25 ) resistor r=1.40859 //w=0.34 //l=0.085 //layer=li //thickness=0.1 \
 //x=60.115 //y=1.175 //x2=60.2 //y2=1.175
r74 (  1 2 ) resistor r=60.2353 //w=0.187 //l=0.88 //layer=li //thickness=0.1 \
 //x=60.115 //y=1.175 //x2=59.235 //y2=1.175
ends PM_TMRDFFRNQX1\%noxref_46

subckt PM_TMRDFFRNQX1\%noxref_47 ( 1 5 9 10 13 17 29 )
c51 ( 29 0 ) capacitor c=0.0632682f //x=62.47 //y=0.545
c52 ( 17 0 ) capacitor c=0.0072343f //x=64.545 //y=0.795
c53 ( 13 0 ) capacitor c=0.0145084f //x=64.46 //y=0.71
c54 ( 10 0 ) capacitor c=0.00582081f //x=63.575 //y=1.675
c55 ( 9 0 ) capacitor c=0.006761f //x=63.575 //y=0.795
c56 ( 5 0 ) capacitor c=0.0173046f //x=63.49 //y=1.76
c57 ( 1 0 ) capacitor c=0.00733328f //x=62.605 //y=1.675
r58 (  17 29 ) resistor r=3.57586 //w=0.17 //l=0.125 //layer=li \
 //thickness=0.1 //x=64.545 //y=0.795 //x2=64.545 //y2=0.67
r59 (  17 29 ) resistor r=18.139 //w=0.187 //l=0.265 //layer=li \
 //thickness=0.1 //x=64.545 //y=0.795 //x2=64.545 //y2=1.06
r60 (  14 29 ) resistor r=3.57586 //w=0.17 //l=0.103078 //layer=li \
 //thickness=0.1 //x=63.66 //y=0.71 //x2=63.575 //y2=0.67
r61 (  14 29 ) resistor r=27.3797 //w=0.187 //l=0.4 //layer=li //thickness=0.1 \
 //x=63.66 //y=0.71 //x2=64.06 //y2=0.71
r62 (  13 29 ) resistor r=3.57586 //w=0.17 //l=0.103078 //layer=li \
 //thickness=0.1 //x=64.46 //y=0.71 //x2=64.545 //y2=0.67
r63 (  13 29 ) resistor r=27.3797 //w=0.187 //l=0.4 //layer=li //thickness=0.1 \
 //x=64.46 //y=0.71 //x2=64.06 //y2=0.71
r64 (  10 29 ) resistor r=3.57586 //w=0.17 //l=0.125 //layer=li \
 //thickness=0.1 //x=63.575 //y=1.675 //x2=63.575 //y2=1.8
r65 (  10 29 ) resistor r=42.0963 //w=0.187 //l=0.615 //layer=li \
 //thickness=0.1 //x=63.575 //y=1.675 //x2=63.575 //y2=1.06
r66 (  9 29 ) resistor r=3.57586 //w=0.17 //l=0.125 //layer=li //thickness=0.1 \
 //x=63.575 //y=0.795 //x2=63.575 //y2=0.67
r67 (  9 29 ) resistor r=18.139 //w=0.187 //l=0.265 //layer=li //thickness=0.1 \
 //x=63.575 //y=0.795 //x2=63.575 //y2=1.06
r68 (  6 29 ) resistor r=3.57586 //w=0.17 //l=0.103078 //layer=li \
 //thickness=0.1 //x=62.69 //y=1.76 //x2=62.605 //y2=1.8
r69 (  6 29 ) resistor r=27.3797 //w=0.187 //l=0.4 //layer=li //thickness=0.1 \
 //x=62.69 //y=1.76 //x2=63.09 //y2=1.76
r70 (  5 29 ) resistor r=3.57586 //w=0.17 //l=0.103078 //layer=li \
 //thickness=0.1 //x=63.49 //y=1.76 //x2=63.575 //y2=1.8
r71 (  5 29 ) resistor r=27.3797 //w=0.187 //l=0.4 //layer=li //thickness=0.1 \
 //x=63.49 //y=1.76 //x2=63.09 //y2=1.76
r72 (  1 29 ) resistor r=3.57586 //w=0.17 //l=0.125 //layer=li //thickness=0.1 \
 //x=62.605 //y=1.675 //x2=62.605 //y2=1.8
r73 (  1 29 ) resistor r=42.0963 //w=0.187 //l=0.615 //layer=li \
 //thickness=0.1 //x=62.605 //y=1.675 //x2=62.605 //y2=1.06
ends PM_TMRDFFRNQX1\%noxref_47

subckt PM_TMRDFFRNQX1\%noxref_48 ( 1 5 9 13 17 35 )
c49 ( 35 0 ) capacitor c=0.0673029f //x=65.695 //y=0.555
c50 ( 17 0 ) capacitor c=0.0178317f //x=67.685 //y=1.77
c51 ( 13 0 ) capacitor c=0.0154936f //x=67.685 //y=0.72
c52 ( 9 0 ) capacitor c=0.00678203f //x=66.8 //y=0.805
c53 ( 5 0 ) capacitor c=0.0164013f //x=66.715 //y=1.77
c54 ( 1 0 ) capacitor c=0.00696517f //x=65.83 //y=1.685
r55 (  18 35 ) resistor r=5.4201 //w=0.17 //l=0.103078 //layer=li \
 //thickness=0.1 //x=66.885 //y=1.77 //x2=66.8 //y2=1.81
r56 (  18 35 ) resistor r=27.3797 //w=0.187 //l=0.4 //layer=li //thickness=0.1 \
 //x=66.885 //y=1.77 //x2=67.285 //y2=1.77
r57 (  17 35 ) resistor r=0.751729 //w=0.17 //l=0.085 //layer=li \
 //thickness=0.1 //x=67.685 //y=1.77 //x2=67.77 //y2=1.77
r58 (  17 35 ) resistor r=27.3797 //w=0.187 //l=0.4 //layer=li //thickness=0.1 \
 //x=67.685 //y=1.77 //x2=67.285 //y2=1.77
r59 (  14 35 ) resistor r=3.57586 //w=0.17 //l=0.103078 //layer=li \
 //thickness=0.1 //x=66.885 //y=0.72 //x2=66.8 //y2=0.68
r60 (  14 35 ) resistor r=27.3797 //w=0.187 //l=0.4 //layer=li //thickness=0.1 \
 //x=66.885 //y=0.72 //x2=67.285 //y2=0.72
r61 (  13 35 ) resistor r=0.751729 //w=0.17 //l=0.085 //layer=li \
 //thickness=0.1 //x=67.685 //y=0.72 //x2=67.77 //y2=0.72
r62 (  13 35 ) resistor r=27.3797 //w=0.187 //l=0.4 //layer=li //thickness=0.1 \
 //x=67.685 //y=0.72 //x2=67.285 //y2=0.72
r63 (  10 35 ) resistor r=1.40859 //w=0.34 //l=0.125 //layer=li \
 //thickness=0.1 //x=66.8 //y=1.685 //x2=66.8 //y2=1.81
r64 (  10 35 ) resistor r=42.0963 //w=0.187 //l=0.615 //layer=li \
 //thickness=0.1 //x=66.8 //y=1.685 //x2=66.8 //y2=1.07
r65 (  9 35 ) resistor r=3.57586 //w=0.17 //l=0.125 //layer=li //thickness=0.1 \
 //x=66.8 //y=0.805 //x2=66.8 //y2=0.68
r66 (  9 35 ) resistor r=18.139 //w=0.187 //l=0.265 //layer=li //thickness=0.1 \
 //x=66.8 //y=0.805 //x2=66.8 //y2=1.07
r67 (  6 35 ) resistor r=3.57586 //w=0.17 //l=0.103078 //layer=li \
 //thickness=0.1 //x=65.915 //y=1.77 //x2=65.83 //y2=1.81
r68 (  6 35 ) resistor r=27.3797 //w=0.187 //l=0.4 //layer=li //thickness=0.1 \
 //x=65.915 //y=1.77 //x2=66.315 //y2=1.77
r69 (  5 35 ) resistor r=5.4201 //w=0.17 //l=0.103078 //layer=li \
 //thickness=0.1 //x=66.715 //y=1.77 //x2=66.8 //y2=1.81
r70 (  5 35 ) resistor r=27.3797 //w=0.187 //l=0.4 //layer=li //thickness=0.1 \
 //x=66.715 //y=1.77 //x2=66.315 //y2=1.77
r71 (  1 35 ) resistor r=3.57586 //w=0.17 //l=0.125 //layer=li //thickness=0.1 \
 //x=65.83 //y=1.685 //x2=65.83 //y2=1.81
r72 (  1 35 ) resistor r=42.0963 //w=0.187 //l=0.615 //layer=li \
 //thickness=0.1 //x=65.83 //y=1.685 //x2=65.83 //y2=1.07
ends PM_TMRDFFRNQX1\%noxref_48

subckt PM_TMRDFFRNQX1\%noxref_49 ( 1 3 11 15 25 28 29 )
c53 ( 29 0 ) capacitor c=0.0413887f //x=68.205 //y=0.555
c54 ( 28 0 ) capacitor c=0.0045748f //x=67.1 //y=1.09
c55 ( 25 0 ) capacitor c=0.00156479f //x=68.34 //y=1.175
c56 ( 15 0 ) capacitor c=0.00737666f //x=69.31 //y=0.805
c57 ( 11 0 ) capacitor c=0.0144218f //x=69.225 //y=0.72
c58 ( 3 0 ) capacitor c=0.00718386f //x=68.34 //y=0.805
c59 ( 1 0 ) capacitor c=0.0218888f //x=68.255 //y=1.175
r60 (  15 29 ) resistor r=3.57586 //w=0.17 //l=0.125 //layer=li \
 //thickness=0.1 //x=69.31 //y=0.805 //x2=69.31 //y2=0.68
r61 (  15 29 ) resistor r=18.139 //w=0.187 //l=0.265 //layer=li \
 //thickness=0.1 //x=69.31 //y=0.805 //x2=69.31 //y2=1.07
r62 (  12 29 ) resistor r=3.57586 //w=0.17 //l=0.103078 //layer=li \
 //thickness=0.1 //x=68.425 //y=0.72 //x2=68.34 //y2=0.68
r63 (  12 29 ) resistor r=27.3797 //w=0.187 //l=0.4 //layer=li //thickness=0.1 \
 //x=68.425 //y=0.72 //x2=68.825 //y2=0.72
r64 (  11 29 ) resistor r=3.57586 //w=0.17 //l=0.103078 //layer=li \
 //thickness=0.1 //x=69.225 //y=0.72 //x2=69.31 //y2=0.68
r65 (  11 29 ) resistor r=27.3797 //w=0.187 //l=0.4 //layer=li //thickness=0.1 \
 //x=69.225 //y=0.72 //x2=68.825 //y2=0.72
r66 (  7 25 ) resistor r=5.4201 //w=0.17 //l=0.085 //layer=li //thickness=0.1 \
 //x=68.34 //y=1.26 //x2=68.34 //y2=1.175
r67 (  7 29 ) resistor r=10.2674 //w=0.187 //l=0.15 //layer=li //thickness=0.1 \
 //x=68.34 //y=1.26 //x2=68.34 //y2=1.41
r68 (  4 25 ) resistor r=5.4201 //w=0.17 //l=0.085 //layer=li //thickness=0.1 \
 //x=68.34 //y=1.09 //x2=68.34 //y2=1.175
r69 (  4 29 ) resistor r=1.36898 //w=0.187 //l=0.02 //layer=li //thickness=0.1 \
 //x=68.34 //y=1.09 //x2=68.34 //y2=1.07
r70 (  3 29 ) resistor r=3.57586 //w=0.17 //l=0.125 //layer=li //thickness=0.1 \
 //x=68.34 //y=0.805 //x2=68.34 //y2=0.68
r71 (  3 29 ) resistor r=18.139 //w=0.187 //l=0.265 //layer=li //thickness=0.1 \
 //x=68.34 //y=0.805 //x2=68.34 //y2=1.07
r72 (  2 28 ) resistor r=0.751729 //w=0.17 //l=0.085 //layer=li \
 //thickness=0.1 //x=67.375 //y=1.175 //x2=67.29 //y2=1.175
r73 (  1 25 ) resistor r=1.40859 //w=0.34 //l=0.085 //layer=li //thickness=0.1 \
 //x=68.255 //y=1.175 //x2=68.34 //y2=1.175
r74 (  1 2 ) resistor r=60.2353 //w=0.187 //l=0.88 //layer=li //thickness=0.1 \
 //x=68.255 //y=1.175 //x2=67.375 //y2=1.175
ends PM_TMRDFFRNQX1\%noxref_49

subckt PM_TMRDFFRNQX1\%noxref_50 ( 1 5 9 13 17 35 )
c51 ( 35 0 ) capacitor c=0.0680259f //x=70.505 //y=0.555
c52 ( 17 0 ) capacitor c=0.0180446f //x=72.495 //y=1.77
c53 ( 13 0 ) capacitor c=0.0155283f //x=72.495 //y=0.72
c54 ( 9 0 ) capacitor c=0.00678203f //x=71.61 //y=0.805
c55 ( 5 0 ) capacitor c=0.0164013f //x=71.525 //y=1.77
c56 ( 1 0 ) capacitor c=0.00696517f //x=70.64 //y=1.685
r57 (  18 35 ) resistor r=5.4201 //w=0.17 //l=0.103078 //layer=li \
 //thickness=0.1 //x=71.695 //y=1.77 //x2=71.61 //y2=1.81
r58 (  18 35 ) resistor r=27.3797 //w=0.187 //l=0.4 //layer=li //thickness=0.1 \
 //x=71.695 //y=1.77 //x2=72.095 //y2=1.77
r59 (  17 35 ) resistor r=0.751729 //w=0.17 //l=0.085 //layer=li \
 //thickness=0.1 //x=72.495 //y=1.77 //x2=72.58 //y2=1.77
r60 (  17 35 ) resistor r=27.3797 //w=0.187 //l=0.4 //layer=li //thickness=0.1 \
 //x=72.495 //y=1.77 //x2=72.095 //y2=1.77
r61 (  14 35 ) resistor r=3.57586 //w=0.17 //l=0.103078 //layer=li \
 //thickness=0.1 //x=71.695 //y=0.72 //x2=71.61 //y2=0.68
r62 (  14 35 ) resistor r=27.3797 //w=0.187 //l=0.4 //layer=li //thickness=0.1 \
 //x=71.695 //y=0.72 //x2=72.095 //y2=0.72
r63 (  13 35 ) resistor r=0.751729 //w=0.17 //l=0.085 //layer=li \
 //thickness=0.1 //x=72.495 //y=0.72 //x2=72.58 //y2=0.72
r64 (  13 35 ) resistor r=27.3797 //w=0.187 //l=0.4 //layer=li //thickness=0.1 \
 //x=72.495 //y=0.72 //x2=72.095 //y2=0.72
r65 (  10 35 ) resistor r=1.40859 //w=0.34 //l=0.125 //layer=li \
 //thickness=0.1 //x=71.61 //y=1.685 //x2=71.61 //y2=1.81
r66 (  10 35 ) resistor r=42.0963 //w=0.187 //l=0.615 //layer=li \
 //thickness=0.1 //x=71.61 //y=1.685 //x2=71.61 //y2=1.07
r67 (  9 35 ) resistor r=3.57586 //w=0.17 //l=0.125 //layer=li //thickness=0.1 \
 //x=71.61 //y=0.805 //x2=71.61 //y2=0.68
r68 (  9 35 ) resistor r=18.139 //w=0.187 //l=0.265 //layer=li //thickness=0.1 \
 //x=71.61 //y=0.805 //x2=71.61 //y2=1.07
r69 (  6 35 ) resistor r=3.57586 //w=0.17 //l=0.103078 //layer=li \
 //thickness=0.1 //x=70.725 //y=1.77 //x2=70.64 //y2=1.81
r70 (  6 35 ) resistor r=27.3797 //w=0.187 //l=0.4 //layer=li //thickness=0.1 \
 //x=70.725 //y=1.77 //x2=71.125 //y2=1.77
r71 (  5 35 ) resistor r=5.4201 //w=0.17 //l=0.103078 //layer=li \
 //thickness=0.1 //x=71.525 //y=1.77 //x2=71.61 //y2=1.81
r72 (  5 35 ) resistor r=27.3797 //w=0.187 //l=0.4 //layer=li //thickness=0.1 \
 //x=71.525 //y=1.77 //x2=71.125 //y2=1.77
r73 (  1 35 ) resistor r=3.57586 //w=0.17 //l=0.125 //layer=li //thickness=0.1 \
 //x=70.64 //y=1.685 //x2=70.64 //y2=1.81
r74 (  1 35 ) resistor r=42.0963 //w=0.187 //l=0.615 //layer=li \
 //thickness=0.1 //x=70.64 //y=1.685 //x2=70.64 //y2=1.07
ends PM_TMRDFFRNQX1\%noxref_50

subckt PM_TMRDFFRNQX1\%noxref_51 ( 1 3 11 15 25 28 29 )
c52 ( 29 0 ) capacitor c=0.0421963f //x=73.015 //y=0.555
c53 ( 28 0 ) capacitor c=0.00457437f //x=71.91 //y=1.09
c54 ( 25 0 ) capacitor c=0.00156479f //x=73.15 //y=1.175
c55 ( 15 0 ) capacitor c=0.00737666f //x=74.12 //y=0.805
c56 ( 11 0 ) capacitor c=0.014695f //x=74.035 //y=0.72
c57 ( 3 0 ) capacitor c=0.00718386f //x=73.15 //y=0.805
c58 ( 1 0 ) capacitor c=0.0234159f //x=73.065 //y=1.175
r59 (  15 29 ) resistor r=3.57586 //w=0.17 //l=0.125 //layer=li \
 //thickness=0.1 //x=74.12 //y=0.805 //x2=74.12 //y2=0.68
r60 (  15 29 ) resistor r=18.139 //w=0.187 //l=0.265 //layer=li \
 //thickness=0.1 //x=74.12 //y=0.805 //x2=74.12 //y2=1.07
r61 (  12 29 ) resistor r=3.57586 //w=0.17 //l=0.103078 //layer=li \
 //thickness=0.1 //x=73.235 //y=0.72 //x2=73.15 //y2=0.68
r62 (  12 29 ) resistor r=27.3797 //w=0.187 //l=0.4 //layer=li //thickness=0.1 \
 //x=73.235 //y=0.72 //x2=73.635 //y2=0.72
r63 (  11 29 ) resistor r=3.57586 //w=0.17 //l=0.103078 //layer=li \
 //thickness=0.1 //x=74.035 //y=0.72 //x2=74.12 //y2=0.68
r64 (  11 29 ) resistor r=27.3797 //w=0.187 //l=0.4 //layer=li //thickness=0.1 \
 //x=74.035 //y=0.72 //x2=73.635 //y2=0.72
r65 (  7 25 ) resistor r=5.4201 //w=0.17 //l=0.085 //layer=li //thickness=0.1 \
 //x=73.15 //y=1.26 //x2=73.15 //y2=1.175
r66 (  7 29 ) resistor r=10.2674 //w=0.187 //l=0.15 //layer=li //thickness=0.1 \
 //x=73.15 //y=1.26 //x2=73.15 //y2=1.41
r67 (  4 25 ) resistor r=5.4201 //w=0.17 //l=0.085 //layer=li //thickness=0.1 \
 //x=73.15 //y=1.09 //x2=73.15 //y2=1.175
r68 (  4 29 ) resistor r=1.36898 //w=0.187 //l=0.02 //layer=li //thickness=0.1 \
 //x=73.15 //y=1.09 //x2=73.15 //y2=1.07
r69 (  3 29 ) resistor r=3.57586 //w=0.17 //l=0.125 //layer=li //thickness=0.1 \
 //x=73.15 //y=0.805 //x2=73.15 //y2=0.68
r70 (  3 29 ) resistor r=18.139 //w=0.187 //l=0.265 //layer=li //thickness=0.1 \
 //x=73.15 //y=0.805 //x2=73.15 //y2=1.07
r71 (  2 28 ) resistor r=0.751729 //w=0.17 //l=0.085 //layer=li \
 //thickness=0.1 //x=72.185 //y=1.175 //x2=72.1 //y2=1.175
r72 (  1 25 ) resistor r=1.40859 //w=0.34 //l=0.085 //layer=li //thickness=0.1 \
 //x=73.065 //y=1.175 //x2=73.15 //y2=1.175
r73 (  1 2 ) resistor r=60.2353 //w=0.187 //l=0.88 //layer=li //thickness=0.1 \
 //x=73.065 //y=1.175 //x2=72.185 //y2=1.175
ends PM_TMRDFFRNQX1\%noxref_51

subckt PM_TMRDFFRNQX1\%noxref_52 ( 1 5 9 10 13 17 29 )
c51 ( 29 0 ) capacitor c=0.0634202f //x=75.42 //y=0.545
c52 ( 17 0 ) capacitor c=0.00722223f //x=77.495 //y=0.795
c53 ( 13 0 ) capacitor c=0.0147854f //x=77.41 //y=0.71
c54 ( 10 0 ) capacitor c=0.00638095f //x=76.525 //y=1.675
c55 ( 9 0 ) capacitor c=0.006761f //x=76.525 //y=0.795
c56 ( 5 0 ) capacitor c=0.0189075f //x=76.44 //y=1.76
c57 ( 1 0 ) capacitor c=0.00798521f //x=75.555 //y=1.675
r58 (  17 29 ) resistor r=3.57586 //w=0.17 //l=0.125 //layer=li \
 //thickness=0.1 //x=77.495 //y=0.795 //x2=77.495 //y2=0.67
r59 (  17 29 ) resistor r=18.139 //w=0.187 //l=0.265 //layer=li \
 //thickness=0.1 //x=77.495 //y=0.795 //x2=77.495 //y2=1.06
r60 (  14 29 ) resistor r=3.57586 //w=0.17 //l=0.103078 //layer=li \
 //thickness=0.1 //x=76.61 //y=0.71 //x2=76.525 //y2=0.67
r61 (  14 29 ) resistor r=27.3797 //w=0.187 //l=0.4 //layer=li //thickness=0.1 \
 //x=76.61 //y=0.71 //x2=77.01 //y2=0.71
r62 (  13 29 ) resistor r=3.57586 //w=0.17 //l=0.103078 //layer=li \
 //thickness=0.1 //x=77.41 //y=0.71 //x2=77.495 //y2=0.67
r63 (  13 29 ) resistor r=27.3797 //w=0.187 //l=0.4 //layer=li //thickness=0.1 \
 //x=77.41 //y=0.71 //x2=77.01 //y2=0.71
r64 (  10 29 ) resistor r=3.57586 //w=0.17 //l=0.125 //layer=li \
 //thickness=0.1 //x=76.525 //y=1.675 //x2=76.525 //y2=1.8
r65 (  10 29 ) resistor r=42.0963 //w=0.187 //l=0.615 //layer=li \
 //thickness=0.1 //x=76.525 //y=1.675 //x2=76.525 //y2=1.06
r66 (  9 29 ) resistor r=3.57586 //w=0.17 //l=0.125 //layer=li //thickness=0.1 \
 //x=76.525 //y=0.795 //x2=76.525 //y2=0.67
r67 (  9 29 ) resistor r=18.139 //w=0.187 //l=0.265 //layer=li //thickness=0.1 \
 //x=76.525 //y=0.795 //x2=76.525 //y2=1.06
r68 (  6 29 ) resistor r=3.57586 //w=0.17 //l=0.103078 //layer=li \
 //thickness=0.1 //x=75.64 //y=1.76 //x2=75.555 //y2=1.8
r69 (  6 29 ) resistor r=27.3797 //w=0.187 //l=0.4 //layer=li //thickness=0.1 \
 //x=75.64 //y=1.76 //x2=76.04 //y2=1.76
r70 (  5 29 ) resistor r=3.57586 //w=0.17 //l=0.103078 //layer=li \
 //thickness=0.1 //x=76.44 //y=1.76 //x2=76.525 //y2=1.8
r71 (  5 29 ) resistor r=27.3797 //w=0.187 //l=0.4 //layer=li //thickness=0.1 \
 //x=76.44 //y=1.76 //x2=76.04 //y2=1.76
r72 (  1 29 ) resistor r=3.57586 //w=0.17 //l=0.125 //layer=li //thickness=0.1 \
 //x=75.555 //y=1.675 //x2=75.555 //y2=1.8
r73 (  1 29 ) resistor r=42.0963 //w=0.187 //l=0.615 //layer=li \
 //thickness=0.1 //x=75.555 //y=1.675 //x2=75.555 //y2=1.06
ends PM_TMRDFFRNQX1\%noxref_52

subckt PM_TMRDFFRNQX1\%noxref_53 ( 1 5 9 10 13 17 29 )
c57 ( 29 0 ) capacitor c=0.0758145f //x=78.75 //y=0.545
c58 ( 17 0 ) capacitor c=0.0072249f //x=80.825 //y=0.795
c59 ( 13 0 ) capacitor c=0.0153682f //x=80.74 //y=0.71
c60 ( 10 0 ) capacitor c=0.00754305f //x=79.855 //y=1.675
c61 ( 9 0 ) capacitor c=0.006761f //x=79.855 //y=0.795
c62 ( 5 0 ) capacitor c=0.0213241f //x=79.77 //y=1.76
c63 ( 1 0 ) capacitor c=0.00492513f //x=78.885 //y=1.675
r64 (  17 29 ) resistor r=3.57586 //w=0.17 //l=0.125 //layer=li \
 //thickness=0.1 //x=80.825 //y=0.795 //x2=80.825 //y2=0.67
r65 (  17 29 ) resistor r=41.4118 //w=0.187 //l=0.605 //layer=li \
 //thickness=0.1 //x=80.825 //y=0.795 //x2=80.825 //y2=1.4
r66 (  14 29 ) resistor r=3.57586 //w=0.17 //l=0.103078 //layer=li \
 //thickness=0.1 //x=79.94 //y=0.71 //x2=79.855 //y2=0.67
r67 (  14 29 ) resistor r=27.0374 //w=0.187 //l=0.395 //layer=li \
 //thickness=0.1 //x=79.94 //y=0.71 //x2=80.335 //y2=0.71
r68 (  13 29 ) resistor r=3.57586 //w=0.17 //l=0.103078 //layer=li \
 //thickness=0.1 //x=80.74 //y=0.71 //x2=80.825 //y2=0.67
r69 (  13 29 ) resistor r=27.7219 //w=0.187 //l=0.405 //layer=li \
 //thickness=0.1 //x=80.74 //y=0.71 //x2=80.335 //y2=0.71
r70 (  10 29 ) resistor r=3.57586 //w=0.17 //l=0.125 //layer=li \
 //thickness=0.1 //x=79.855 //y=1.675 //x2=79.855 //y2=1.8
r71 (  10 29 ) resistor r=42.0963 //w=0.187 //l=0.615 //layer=li \
 //thickness=0.1 //x=79.855 //y=1.675 //x2=79.855 //y2=1.06
r72 (  9 29 ) resistor r=3.57586 //w=0.17 //l=0.125 //layer=li //thickness=0.1 \
 //x=79.855 //y=0.795 //x2=79.855 //y2=0.67
r73 (  9 29 ) resistor r=18.139 //w=0.187 //l=0.265 //layer=li //thickness=0.1 \
 //x=79.855 //y=0.795 //x2=79.855 //y2=1.06
r74 (  6 29 ) resistor r=3.57586 //w=0.17 //l=0.103078 //layer=li \
 //thickness=0.1 //x=78.97 //y=1.76 //x2=78.885 //y2=1.8
r75 (  6 29 ) resistor r=27.3797 //w=0.187 //l=0.4 //layer=li //thickness=0.1 \
 //x=78.97 //y=1.76 //x2=79.37 //y2=1.76
r76 (  5 29 ) resistor r=3.57586 //w=0.17 //l=0.103078 //layer=li \
 //thickness=0.1 //x=79.77 //y=1.76 //x2=79.855 //y2=1.8
r77 (  5 29 ) resistor r=27.3797 //w=0.187 //l=0.4 //layer=li //thickness=0.1 \
 //x=79.77 //y=1.76 //x2=79.37 //y2=1.76
r78 (  1 29 ) resistor r=3.57586 //w=0.17 //l=0.125 //layer=li //thickness=0.1 \
 //x=78.885 //y=1.675 //x2=78.885 //y2=1.8
r79 (  1 29 ) resistor r=42.0963 //w=0.187 //l=0.615 //layer=li \
 //thickness=0.1 //x=78.885 //y=1.675 //x2=78.885 //y2=1.06
ends PM_TMRDFFRNQX1\%noxref_53

subckt PM_TMRDFFRNQX1\%noxref_54 ( 1 5 9 10 13 17 29 )
c55 ( 29 0 ) capacitor c=0.0723103f //x=82.08 //y=0.545
c56 ( 17 0 ) capacitor c=0.0072249f //x=84.155 //y=0.795
c57 ( 13 0 ) capacitor c=0.0155051f //x=84.07 //y=0.71
c58 ( 10 0 ) capacitor c=0.00876912f //x=83.185 //y=1.675
c59 ( 9 0 ) capacitor c=0.006761f //x=83.185 //y=0.795
c60 ( 5 0 ) capacitor c=0.0182818f //x=83.1 //y=1.76
c61 ( 1 0 ) capacitor c=0.00857722f //x=82.215 //y=1.675
r62 (  17 29 ) resistor r=3.57586 //w=0.17 //l=0.125 //layer=li \
 //thickness=0.1 //x=84.155 //y=0.795 //x2=84.155 //y2=0.67
r63 (  17 29 ) resistor r=41.4118 //w=0.187 //l=0.605 //layer=li \
 //thickness=0.1 //x=84.155 //y=0.795 //x2=84.155 //y2=1.4
r64 (  14 29 ) resistor r=3.57586 //w=0.17 //l=0.103078 //layer=li \
 //thickness=0.1 //x=83.27 //y=0.71 //x2=83.185 //y2=0.67
r65 (  14 29 ) resistor r=27.3797 //w=0.187 //l=0.4 //layer=li //thickness=0.1 \
 //x=83.27 //y=0.71 //x2=83.67 //y2=0.71
r66 (  13 29 ) resistor r=3.57586 //w=0.17 //l=0.103078 //layer=li \
 //thickness=0.1 //x=84.07 //y=0.71 //x2=84.155 //y2=0.67
r67 (  13 29 ) resistor r=27.3797 //w=0.187 //l=0.4 //layer=li //thickness=0.1 \
 //x=84.07 //y=0.71 //x2=83.67 //y2=0.71
r68 (  10 29 ) resistor r=3.57586 //w=0.17 //l=0.125 //layer=li \
 //thickness=0.1 //x=83.185 //y=1.675 //x2=83.185 //y2=1.8
r69 (  10 29 ) resistor r=42.0963 //w=0.187 //l=0.615 //layer=li \
 //thickness=0.1 //x=83.185 //y=1.675 //x2=83.185 //y2=1.06
r70 (  9 29 ) resistor r=3.57586 //w=0.17 //l=0.125 //layer=li //thickness=0.1 \
 //x=83.185 //y=0.795 //x2=83.185 //y2=0.67
r71 (  9 29 ) resistor r=18.139 //w=0.187 //l=0.265 //layer=li //thickness=0.1 \
 //x=83.185 //y=0.795 //x2=83.185 //y2=1.06
r72 (  6 29 ) resistor r=3.57586 //w=0.17 //l=0.103078 //layer=li \
 //thickness=0.1 //x=82.3 //y=1.76 //x2=82.215 //y2=1.8
r73 (  6 29 ) resistor r=27.3797 //w=0.187 //l=0.4 //layer=li //thickness=0.1 \
 //x=82.3 //y=1.76 //x2=82.7 //y2=1.76
r74 (  5 29 ) resistor r=3.57586 //w=0.17 //l=0.103078 //layer=li \
 //thickness=0.1 //x=83.1 //y=1.76 //x2=83.185 //y2=1.8
r75 (  5 29 ) resistor r=27.3797 //w=0.187 //l=0.4 //layer=li //thickness=0.1 \
 //x=83.1 //y=1.76 //x2=82.7 //y2=1.76
r76 (  1 29 ) resistor r=3.57586 //w=0.17 //l=0.125 //layer=li //thickness=0.1 \
 //x=82.215 //y=1.675 //x2=82.215 //y2=1.8
r77 (  1 29 ) resistor r=42.0963 //w=0.187 //l=0.615 //layer=li \
 //thickness=0.1 //x=82.215 //y=1.675 //x2=82.215 //y2=1.06
ends PM_TMRDFFRNQX1\%noxref_54

subckt PM_TMRDFFRNQX1\%noxref_55 ( 1 5 9 10 13 17 29 )
c56 ( 29 0 ) capacitor c=0.0637832f //x=85.41 //y=0.545
c57 ( 17 0 ) capacitor c=0.00722228f //x=87.485 //y=0.795
c58 ( 13 0 ) capacitor c=0.0141607f //x=87.4 //y=0.71
c59 ( 10 0 ) capacitor c=0.00712138f //x=86.515 //y=1.675
c60 ( 9 0 ) capacitor c=0.006761f //x=86.515 //y=0.795
c61 ( 5 0 ) capacitor c=0.0233454f //x=86.43 //y=1.76
c62 ( 1 0 ) capacitor c=0.00481264f //x=85.545 //y=1.675
r63 (  17 29 ) resistor r=3.57586 //w=0.17 //l=0.125 //layer=li \
 //thickness=0.1 //x=87.485 //y=0.795 //x2=87.485 //y2=0.67
r64 (  17 29 ) resistor r=18.139 //w=0.187 //l=0.265 //layer=li \
 //thickness=0.1 //x=87.485 //y=0.795 //x2=87.485 //y2=1.06
r65 (  14 29 ) resistor r=3.57586 //w=0.17 //l=0.103078 //layer=li \
 //thickness=0.1 //x=86.6 //y=0.71 //x2=86.515 //y2=0.67
r66 (  14 29 ) resistor r=27.3797 //w=0.187 //l=0.4 //layer=li //thickness=0.1 \
 //x=86.6 //y=0.71 //x2=87 //y2=0.71
r67 (  13 29 ) resistor r=3.57586 //w=0.17 //l=0.103078 //layer=li \
 //thickness=0.1 //x=87.4 //y=0.71 //x2=87.485 //y2=0.67
r68 (  13 29 ) resistor r=27.3797 //w=0.187 //l=0.4 //layer=li //thickness=0.1 \
 //x=87.4 //y=0.71 //x2=87 //y2=0.71
r69 (  10 29 ) resistor r=3.57586 //w=0.17 //l=0.125 //layer=li \
 //thickness=0.1 //x=86.515 //y=1.675 //x2=86.515 //y2=1.8
r70 (  10 29 ) resistor r=42.0963 //w=0.187 //l=0.615 //layer=li \
 //thickness=0.1 //x=86.515 //y=1.675 //x2=86.515 //y2=1.06
r71 (  9 29 ) resistor r=3.57586 //w=0.17 //l=0.125 //layer=li //thickness=0.1 \
 //x=86.515 //y=0.795 //x2=86.515 //y2=0.67
r72 (  9 29 ) resistor r=18.139 //w=0.187 //l=0.265 //layer=li //thickness=0.1 \
 //x=86.515 //y=0.795 //x2=86.515 //y2=1.06
r73 (  6 29 ) resistor r=3.57586 //w=0.17 //l=0.103078 //layer=li \
 //thickness=0.1 //x=85.63 //y=1.76 //x2=85.545 //y2=1.8
r74 (  6 29 ) resistor r=27.3797 //w=0.187 //l=0.4 //layer=li //thickness=0.1 \
 //x=85.63 //y=1.76 //x2=86.03 //y2=1.76
r75 (  5 29 ) resistor r=3.57586 //w=0.17 //l=0.103078 //layer=li \
 //thickness=0.1 //x=86.43 //y=1.76 //x2=86.515 //y2=1.8
r76 (  5 29 ) resistor r=27.3797 //w=0.187 //l=0.4 //layer=li //thickness=0.1 \
 //x=86.43 //y=1.76 //x2=86.03 //y2=1.76
r77 (  1 29 ) resistor r=3.57586 //w=0.17 //l=0.125 //layer=li //thickness=0.1 \
 //x=85.545 //y=1.675 //x2=85.545 //y2=1.8
r78 (  1 29 ) resistor r=42.0963 //w=0.187 //l=0.615 //layer=li \
 //thickness=0.1 //x=85.545 //y=1.675 //x2=85.545 //y2=1.06
ends PM_TMRDFFRNQX1\%noxref_55

subckt PM_TMRDFFRNQX1\%Q ( 1 2 3 4 5 6 7 18 19 20 21 31 33 )
c44 ( 33 0 ) capacitor c=0.028734f //x=89.15 //y=5.2
c45 ( 31 0 ) capacitor c=0.0172744f //x=89.105 //y=1.09
c46 ( 21 0 ) capacitor c=0.00575887f //x=89.38 //y=4.76
c47 ( 20 0 ) capacitor c=0.0136889f //x=89.575 //y=4.76
c48 ( 19 0 ) capacitor c=0.00636159f //x=89.375 //y=2.26
c49 ( 18 0 ) capacitor c=0.0140707f //x=89.575 //y=2.26
c50 ( 1 0 ) capacitor c=0.105613f //x=89.66 //y=2.4
r51 (  20 23 ) resistor r=7.15173 //w=0.17 //l=0.120208 //layer=li \
 //thickness=0.1 //x=89.575 //y=4.76 //x2=89.66 //y2=4.675
r52 (  20 21 ) resistor r=13.3476 //w=0.187 //l=0.195 //layer=li \
 //thickness=0.1 //x=89.575 //y=4.76 //x2=89.38 //y2=4.76
r53 (  18 22 ) resistor r=7.15173 //w=0.17 //l=0.120208 //layer=li \
 //thickness=0.1 //x=89.575 //y=2.26 //x2=89.66 //y2=2.345
r54 (  18 19 ) resistor r=13.6898 //w=0.187 //l=0.2 //layer=li //thickness=0.1 \
 //x=89.575 //y=2.26 //x2=89.375 //y2=2.26
r55 (  12 21 ) resistor r=7.15173 //w=0.17 //l=0.120208 //layer=li \
 //thickness=0.1 //x=89.295 //y=4.845 //x2=89.38 //y2=4.76
r56 (  12 33 ) resistor r=72.5562 //w=0.187 //l=1.06 //layer=li \
 //thickness=0.1 //x=89.295 //y=4.845 //x2=89.295 //y2=5.905
r57 (  8 19 ) resistor r=7.15173 //w=0.17 //l=0.120208 //layer=li \
 //thickness=0.1 //x=89.29 //y=2.175 //x2=89.375 //y2=2.26
r58 (  8 31 ) resistor r=67.7647 //w=0.187 //l=0.99 //layer=li //thickness=0.1 \
 //x=89.29 //y=2.175 //x2=89.29 //y2=1.185
r59 (  7 23 ) resistor r=3.76471 //w=0.187 //l=0.055 //layer=li \
 //thickness=0.1 //x=89.66 //y=4.62 //x2=89.66 //y2=4.675
r60 (  6 7 ) resistor r=25.3262 //w=0.187 //l=0.37 //layer=li //thickness=0.1 \
 //x=89.66 //y=4.25 //x2=89.66 //y2=4.62
r61 (  5 6 ) resistor r=25.3262 //w=0.187 //l=0.37 //layer=li //thickness=0.1 \
 //x=89.66 //y=3.88 //x2=89.66 //y2=4.25
r62 (  4 5 ) resistor r=25.3262 //w=0.187 //l=0.37 //layer=li //thickness=0.1 \
 //x=89.66 //y=3.51 //x2=89.66 //y2=3.88
r63 (  3 4 ) resistor r=25.3262 //w=0.187 //l=0.37 //layer=li //thickness=0.1 \
 //x=89.66 //y=3.14 //x2=89.66 //y2=3.51
r64 (  2 3 ) resistor r=25.3262 //w=0.187 //l=0.37 //layer=li //thickness=0.1 \
 //x=89.66 //y=2.77 //x2=89.66 //y2=3.14
r65 (  1 2 ) resistor r=25.3262 //w=0.187 //l=0.37 //layer=li //thickness=0.1 \
 //x=89.66 //y=2.4 //x2=89.66 //y2=2.77
r66 (  1 22 ) resistor r=3.76471 //w=0.187 //l=0.055 //layer=li \
 //thickness=0.1 //x=89.66 //y=2.4 //x2=89.66 //y2=2.345
ends PM_TMRDFFRNQX1\%Q
