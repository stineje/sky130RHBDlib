// File: ao3x1_pcell.spi.pex
// Created: Fri Feb 20 10:18:17 2026
// Program "Calibre xRC"
// Version "v2023.2_27.15"
// Nominal Temperature: 30C
// Circuit Temperature: 30C
//
simulator lang=spectre
subckt PM_AO3X1_PCELL\%noxref_1 ( 3 8 9 11 12 14 15 16 18 19 20 23 24 27 29 32 \
 35 38 42 44 45 50 53 61 78 83 91 92 93 94 95 96 97 101 103 106 108 109 114 \
 124 126 127 )
c264 ( 124 0 ) capacitor c=0.00878249f //x=1.96 //y=0.905
c265 ( 114 0 ) capacitor c=0.0426341f //x=4.285 //y=4.705
c266 ( 109 0 ) capacitor c=0.0337825f //x=4.775 //y=1.25
c267 ( 108 0 ) capacitor c=0.0183823f //x=4.775 //y=0.905
c268 ( 106 0 ) capacitor c=0.0350928f //x=4.705 //y=4.795
c269 ( 103 0 ) capacitor c=0.013578f //x=4.62 //y=1.405
c270 ( 101 0 ) capacitor c=0.0157803f //x=4.62 //y=0.75
c271 ( 97 0 ) capacitor c=0.0787244f //x=4.245 //y=1.915
c272 ( 96 0 ) capacitor c=0.0230165f //x=4.245 //y=1.56
c273 ( 95 0 ) capacitor c=0.0234348f //x=4.245 //y=1.25
c274 ( 94 0 ) capacitor c=0.019134f //x=4.245 //y=0.905
c275 ( 93 0 ) capacitor c=0.110994f //x=4.78 //y=6.025
c276 ( 92 0 ) capacitor c=0.154777f //x=4.34 //y=6.025
c277 ( 83 0 ) capacitor c=4.74639e-19 //x=4.44 //y=2.08
c278 ( 78 0 ) capacitor c=0.00705226f //x=4.285 //y=4.705
c279 ( 61 0 ) capacitor c=0.0325392f //x=2.11 //y=5.38
c280 ( 53 0 ) capacitor c=0.0291911f //x=1.23 //y=5.38
c281 ( 50 0 ) capacitor c=0.00527867f //x=4.435 //y=2.59
c282 ( 45 0 ) capacitor c=0.00557348f //x=2.75 //y=2.59
c283 ( 44 0 ) capacitor c=0.0774598f //x=4.275 //y=2.59
c284 ( 42 0 ) capacitor c=0.00772583f //x=4.285 //y=4.705
c285 ( 38 0 ) capacitor c=0.00636094f //x=4.44 //y=2.08
c286 ( 35 0 ) capacitor c=0.0139347f //x=4.435 //y=2.59
c287 ( 32 0 ) capacitor c=0.0146565f //x=2.59 //y=2.59
c288 ( 29 0 ) capacitor c=0.011771f //x=2.15 //y=1
c289 ( 27 0 ) capacitor c=6.70882e-19 //x=2.11 //y=5.38
c290 ( 24 0 ) capacitor c=0.0129472f //x=2.11 //y=5.2
c291 ( 23 0 ) capacitor c=0.0106213f //x=1.23 //y=5.38
c292 ( 20 0 ) capacitor c=0.0625282f //x=4.44 //y=4.585
c293 ( 19 0 ) capacitor c=0.0110433f //x=4.44 //y=2.75
c294 ( 18 0 ) capacitor c=0.00430528f //x=4.44 //y=2.43
c295 ( 16 0 ) capacitor c=0.0760906f //x=2.59 //y=5.115
c296 ( 15 0 ) capacitor c=0.0117792f //x=2.59 //y=2.75
c297 ( 14 0 ) capacitor c=0.0170528f //x=2.59 //y=2.43
c298 ( 12 0 ) capacitor c=0.00837358f //x=2.235 //y=1.655
c299 ( 11 0 ) capacitor c=0.0136835f //x=2.505 //y=1.655
c300 ( 9 0 ) capacitor c=0.0123375f //x=2.505 //y=5.2
c301 ( 8 0 ) capacitor c=0.012699f //x=2.15 //y=1.57
c302 ( 3 0 ) capacitor c=0.019362f //x=1.995 //y=5.2
r303 (  116 117 ) resistor r=32.4568 //w=0.214 //l=0.075 //layer=ply \
 //thickness=0.18 //x=4.285 //y=4.795 //x2=4.285 //y2=4.87
r304 (  114 116 ) resistor r=20.271 //w=0.214 //l=0.09 //layer=ply \
 //thickness=0.18 //x=4.285 //y=4.705 //x2=4.285 //y2=4.795
r305 (  109 123 ) resistor r=45.1352 //w=0.168 //l=0.173853 //layer=ply \
 //thickness=0.18 //x=4.775 //y=1.25 //x2=4.735 //y2=1.405
r306 (  108 122 ) resistor r=45.1352 //w=0.168 //l=0.173853 //layer=ply \
 //thickness=0.18 //x=4.775 //y=0.905 //x2=4.735 //y2=0.75
r307 (  108 109 ) resistor r=176.904 //w=0.094 //l=0.345 //layer=ply \
 //thickness=0.18 //x=4.775 //y=0.905 //x2=4.775 //y2=1.25
r308 (  107 116 ) resistor r=16.5046 //w=0.27 //l=0.135 //layer=ply \
 //thickness=0.18 //x=4.42 //y=4.795 //x2=4.285 //y2=4.795
r309 (  106 110 ) resistor r=26.9307 //w=0.15 //l=0.106066 //layer=ply \
 //thickness=0.18 //x=4.705 //y=4.795 //x2=4.78 //y2=4.87
r310 (  106 107 ) resistor r=146.138 //w=0.094 //l=0.285 //layer=ply \
 //thickness=0.18 //x=4.705 //y=4.795 //x2=4.42 //y2=4.795
r311 (  104 121 ) resistor r=10.701 //w=0.21 //l=0.115 //layer=ply \
 //thickness=0.18 //x=4.4 //y=1.405 //x2=4.285 //y2=1.405
r312 (  103 123 ) resistor r=5.52526 //w=0.168 //l=0.115 //layer=ply \
 //thickness=0.18 //x=4.62 //y=1.405 //x2=4.735 //y2=1.405
r313 (  102 120 ) resistor r=5.52526 //w=0.168 //l=0.115 //layer=ply \
 //thickness=0.18 //x=4.4 //y=0.75 //x2=4.285 //y2=0.75
r314 (  101 122 ) resistor r=5.52526 //w=0.168 //l=0.115 //layer=ply \
 //thickness=0.18 //x=4.62 //y=0.75 //x2=4.735 //y2=0.75
r315 (  101 102 ) resistor r=112.809 //w=0.094 //l=0.22 //layer=ply \
 //thickness=0.18 //x=4.62 //y=0.75 //x2=4.4 //y2=0.75
r316 (  97 119 ) resistor r=34.8111 //w=0.27 //l=0.264953 //layer=ply \
 //thickness=0.18 //x=4.245 //y=1.915 //x2=4.44 //y2=2.08
r317 (  96 121 ) resistor r=39.5823 //w=0.21 //l=0.173853 //layer=ply \
 //thickness=0.18 //x=4.245 //y=1.56 //x2=4.285 //y2=1.405
r318 (  96 97 ) resistor r=182.032 //w=0.094 //l=0.355 //layer=ply \
 //thickness=0.18 //x=4.245 //y=1.56 //x2=4.245 //y2=1.915
r319 (  95 121 ) resistor r=39.5823 //w=0.21 //l=0.173853 //layer=ply \
 //thickness=0.18 //x=4.245 //y=1.25 //x2=4.285 //y2=1.405
r320 (  94 120 ) resistor r=45.1352 //w=0.168 //l=0.173853 //layer=ply \
 //thickness=0.18 //x=4.245 //y=0.905 //x2=4.285 //y2=0.75
r321 (  94 95 ) resistor r=176.904 //w=0.094 //l=0.345 //layer=ply \
 //thickness=0.18 //x=4.245 //y=0.905 //x2=4.245 //y2=1.25
r322 (  93 110 ) resistor r=592.245 //w=0.094 //l=1.155 //layer=ply \
 //thickness=0.18 //x=4.78 //y=6.025 //x2=4.78 //y2=4.87
r323 (  92 117 ) resistor r=592.245 //w=0.094 //l=1.155 //layer=ply \
 //thickness=0.18 //x=4.34 //y=6.025 //x2=4.34 //y2=4.87
r324 (  91 103 ) resistor r=56.4043 //w=0.094 //l=0.11 //layer=ply \
 //thickness=0.18 //x=4.51 //y=1.405 //x2=4.62 //y2=1.405
r325 (  91 104 ) resistor r=56.4043 //w=0.094 //l=0.11 //layer=ply \
 //thickness=0.18 //x=4.51 //y=1.405 //x2=4.4 //y2=1.405
r326 (  83 119 ) resistor r=152 //w=0.17 //l=0.17 //layer=licon //count=1 \
 //x=4.44 //y=2.08 //x2=4.44 //y2=2.08
r327 (  78 114 ) resistor r=152 //w=0.17 //l=0.17 //layer=licon //count=1 \
 //x=4.285 //y=4.705 //x2=4.285 //y2=4.705
r328 (  61 127 ) resistor r=23.615 //w=0.187 //l=0.345 //layer=li \
 //thickness=0.1 //x=2.11 //y=5.38 //x2=2.11 //y2=5.725
r329 (  53 126 ) resistor r=23.615 //w=0.187 //l=0.345 //layer=li \
 //thickness=0.1 //x=1.23 //y=5.38 //x2=1.23 //y2=5.725
r330 (  45 47 ) resistor r=0.10734 //w=0.281 //l=0.16 //layer=m2 \
 //thickness=0.36 //x=2.75 //y=2.59 //x2=2.59 //y2=2.59
r331 (  44 50 ) resistor r=0.10734 //w=0.281 //l=0.16 //layer=m2 \
 //thickness=0.36 //x=4.275 //y=2.59 //x2=4.435 //y2=2.59
r332 (  44 45 ) resistor r=1.45515 //w=0.131 //l=1.525 //layer=m2 \
 //thickness=0.36 //x=4.275 //y=2.59 //x2=2.75 //y2=2.59
r333 (  42 78 ) resistor r=9.3 //w=0.17 //l=0.17 //layer=mcon //count=1 \
 //x=4.285 //y=4.705 //x2=4.285 //y2=4.705
r334 (  42 43 ) resistor r=0.0853524 //w=0.227 //l=0.155 //layer=m1 \
 //thickness=0.36 //x=4.285 //y=4.702 //x2=4.44 //y2=4.702
r335 (  38 83 ) resistor r=9.3 //w=0.17 //l=0.17 //layer=mcon //count=1 \
 //x=4.44 //y=2.08 //x2=4.44 //y2=2.08
r336 (  38 40 ) resistor r=0.0985786 //w=0.206 //l=0.135 //layer=m1 \
 //thickness=0.36 //x=4.437 //y=2.08 //x2=4.437 //y2=2.215
r337 (  35 50 ) resistor r=4.5 //w=0.15 //l=0.15 //layer=via1 //count=1 \
 //x=4.435 //y=2.59 //x2=4.435 //y2=2.59
r338 (  32 47 ) resistor r=4.5 //w=0.15 //l=0.15 //layer=via1 //count=1 \
 //x=2.59 //y=2.59 //x2=2.59 //y2=2.59
r339 (  29 124 ) resistor r=9.3 //w=0.17 //l=0.17 //layer=mcon //count=1 \
 //x=2.15 //y=1 //x2=2.15 //y2=1
r340 (  27 61 ) resistor r=9.3 //w=0.17 //l=0.17 //layer=mcon //count=1 \
 //x=2.11 //y=5.38 //x2=2.11 //y2=5.38
r341 (  24 27 ) resistor r=0.117801 //w=0.191 //l=0.18 //layer=m1 \
 //thickness=0.36 //x=2.11 //y=5.2 //x2=2.11 //y2=5.38
r342 (  23 53 ) resistor r=9.3 //w=0.17 //l=0.17 //layer=mcon //count=1 \
 //x=1.23 //y=5.38 //x2=1.23 //y2=5.38
r343 (  21 23 ) resistor r=0.10274 //w=0.219 //l=0.18 //layer=m1 \
 //thickness=0.36 //x=1.23 //y=5.2 //x2=1.23 //y2=5.38
r344 (  20 43 ) resistor r=0.0249239 //w=0.227 //l=0.117 //layer=m1 \
 //thickness=0.36 //x=4.44 //y=4.585 //x2=4.44 //y2=4.702
r345 (  19 35 ) resistor r=0.0910802 //w=0.374 //l=0.185472 //layer=m1 \
 //thickness=0.36 //x=4.44 //y=2.75 //x2=4.385 //y2=2.59
r346 (  19 20 ) resistor r=1.75095 //w=0.131 //l=1.835 //layer=m1 \
 //thickness=0.36 //x=4.44 //y=2.75 //x2=4.44 //y2=4.585
r347 (  18 35 ) resistor r=0.0910802 //w=0.374 //l=0.185472 //layer=m1 \
 //thickness=0.36 //x=4.44 //y=2.43 //x2=4.385 //y2=2.59
r348 (  18 40 ) resistor r=0.205153 //w=0.131 //l=0.215 //layer=m1 \
 //thickness=0.36 //x=4.44 //y=2.43 //x2=4.44 //y2=2.215
r349 (  15 32 ) resistor r=0.0911593 //w=0.376 //l=0.184174 //layer=m1 \
 //thickness=0.36 //x=2.59 //y=2.75 //x2=2.642 //y2=2.59
r350 (  15 16 ) resistor r=2.25668 //w=0.131 //l=2.365 //layer=m1 \
 //thickness=0.36 //x=2.59 //y=2.75 //x2=2.59 //y2=5.115
r351 (  14 32 ) resistor r=0.0911593 //w=0.376 //l=0.184174 //layer=m1 \
 //thickness=0.36 //x=2.59 //y=2.43 //x2=2.642 //y2=2.59
r352 (  13 14 ) resistor r=0.658397 //w=0.131 //l=0.69 //layer=m1 \
 //thickness=0.36 //x=2.59 //y=1.74 //x2=2.59 //y2=2.43
r353 (  11 13 ) resistor r=0.0698411 //w=0.17 //l=0.120208 //layer=m1 \
 //thickness=0.36 //x=2.505 //y=1.655 //x2=2.59 //y2=1.74
r354 (  11 12 ) resistor r=0.257634 //w=0.131 //l=0.27 //layer=m1 \
 //thickness=0.36 //x=2.505 //y=1.655 //x2=2.235 //y2=1.655
r355 (  10 24 ) resistor r=0.0257089 //w=0.23 //l=0.115 //layer=m1 \
 //thickness=0.36 //x=2.225 //y=5.2 //x2=2.11 //y2=5.2
r356 (  9 16 ) resistor r=0.0698411 //w=0.17 //l=0.120208 //layer=m1 \
 //thickness=0.36 //x=2.505 //y=5.2 //x2=2.59 //y2=5.115
r357 (  9 10 ) resistor r=0.267176 //w=0.131 //l=0.28 //layer=m1 \
 //thickness=0.36 //x=2.505 //y=5.2 //x2=2.225 //y2=5.2
r358 (  8 12 ) resistor r=0.0698411 //w=0.17 //l=0.120208 //layer=m1 \
 //thickness=0.36 //x=2.15 //y=1.57 //x2=2.235 //y2=1.655
r359 (  7 29 ) resistor r=0.0913624 //w=0.191 //l=0.12 //layer=m1 \
 //thickness=0.36 //x=2.15 //y=1.12 //x2=2.15 //y2=1
r360 (  7 8 ) resistor r=0.429389 //w=0.131 //l=0.45 //layer=m1 \
 //thickness=0.36 //x=2.15 //y=1.12 //x2=2.15 //y2=1.57
r361 (  4 21 ) resistor r=0.0227762 //w=0.219 //l=0.115 //layer=m1 \
 //thickness=0.36 //x=1.345 //y=5.2 //x2=1.23 //y2=5.2
r362 (  3 24 ) resistor r=0.0257089 //w=0.23 //l=0.115 //layer=m1 \
 //thickness=0.36 //x=1.995 //y=5.2 //x2=2.11 //y2=5.2
r363 (  3 4 ) resistor r=0.620229 //w=0.131 //l=0.65 //layer=m1 \
 //thickness=0.36 //x=1.995 //y=5.2 //x2=1.345 //y2=5.2
ends PM_AO3X1_PCELL\%noxref_1

subckt PM_AO3X1_PCELL\%noxref_2 ( 1 2 3 4 5 6 7 9 12 13 14 16 17 18 22 28 31 \
 34 43 45 46 54 71 80 84 85 86 87 88 89 90 94 95 96 98 104 105 107 115 116 119 )
c246 ( 116 0 ) capacitor c=0.00901091f //x=5.29 //y=0.905
c247 ( 115 0 ) capacitor c=0.00876479f //x=4.32 //y=0.905
c248 ( 107 0 ) capacitor c=0.0556167f //x=7.4 //y=2.085
c249 ( 105 0 ) capacitor c=0.0439576f //x=8.04 //y=1.255
c250 ( 104 0 ) capacitor c=0.0201087f //x=8.04 //y=0.91
c251 ( 98 0 ) capacitor c=0.0161986f //x=7.885 //y=1.41
c252 ( 96 0 ) capacitor c=0.0157807f //x=7.885 //y=0.755
c253 ( 95 0 ) capacitor c=0.0557689f //x=7.63 //y=4.79
c254 ( 94 0 ) capacitor c=0.0406047f //x=7.92 //y=4.79
c255 ( 90 0 ) capacitor c=0.0301471f //x=7.51 //y=1.92
c256 ( 89 0 ) capacitor c=0.0255349f //x=7.51 //y=1.565
c257 ( 88 0 ) capacitor c=0.0234346f //x=7.51 //y=1.255
c258 ( 87 0 ) capacitor c=0.02013f //x=7.51 //y=0.91
c259 ( 86 0 ) capacitor c=0.153839f //x=7.995 //y=6.02
c260 ( 85 0 ) capacitor c=0.15434f //x=7.555 //y=6.02
c261 ( 80 0 ) capacitor c=9.45276e-19 //x=7.4 //y=4.7
c262 ( 71 0 ) capacitor c=6.43121e-19 //x=7.4 //y=2.085
c263 ( 54 0 ) capacitor c=0.0246131f //x=5.44 //y=5.38
c264 ( 46 0 ) capacitor c=0.0582172f //x=7.235 //y=2.59
c265 ( 45 0 ) capacitor c=0.00440097f //x=7.395 //y=2.59
c266 ( 43 0 ) capacitor c=0.00546501f //x=6.075 //y=2.59
c267 ( 34 0 ) capacitor c=0.0110655f //x=7.4 //y=2.085
c268 ( 31 0 ) capacitor c=0.012167f //x=7.395 //y=2.59
c269 ( 28 0 ) capacitor c=0.0140157f //x=5.915 //y=2.59
c270 ( 22 0 ) capacitor c=0.0135175f //x=5.435 //y=5.21
c271 ( 21 0 ) capacitor c=0.00513603f //x=5.48 //y=1.655
c272 ( 18 0 ) capacitor c=0.0607198f //x=7.4 //y=4.58
c273 ( 17 0 ) capacitor c=0.0115241f //x=7.4 //y=2.75
c274 ( 16 0 ) capacitor c=0.00275838f //x=7.4 //y=2.43
c275 ( 14 0 ) capacitor c=0.0691584f //x=5.92 //y=5.125
c276 ( 13 0 ) capacitor c=0.012052f //x=5.92 //y=2.75
c277 ( 12 0 ) capacitor c=0.0149172f //x=5.92 //y=2.43
c278 ( 9 0 ) capacitor c=0.0137393f //x=5.835 //y=1.655
c279 ( 7 0 ) capacitor c=0.0111434f //x=5.835 //y=5.21
c280 ( 6 0 ) capacitor c=0.00690516f //x=5.48 //y=1.57
c281 ( 5 0 ) capacitor c=0.00843314f //x=5.48 //y=1.12
c282 ( 4 0 ) capacitor c=0.0023108f //x=4.595 //y=1.655
c283 ( 3 0 ) capacitor c=0.0217217f //x=5.395 //y=1.655
c284 ( 2 0 ) capacitor c=0.00638036f //x=4.51 //y=1.57
c285 ( 1 0 ) capacitor c=0.00825944f //x=4.51 //y=1.125
r286 (  107 108 ) resistor r=17.5563 //w=0.302 //l=0.11 //layer=ply \
 //thickness=0.18 //x=7.4 //y=2.085 //x2=7.51 //y2=2.085
r287 (  105 114 ) resistor r=45.1352 //w=0.168 //l=0.173853 //layer=ply \
 //thickness=0.18 //x=8.04 //y=1.255 //x2=8 //y2=1.41
r288 (  104 113 ) resistor r=45.1352 //w=0.168 //l=0.173853 //layer=ply \
 //thickness=0.18 //x=8.04 //y=0.91 //x2=8 //y2=0.755
r289 (  104 105 ) resistor r=176.904 //w=0.094 //l=0.345 //layer=ply \
 //thickness=0.18 //x=8.04 //y=0.91 //x2=8.04 //y2=1.255
r290 (  99 112 ) resistor r=10.701 //w=0.21 //l=0.115 //layer=ply \
 //thickness=0.18 //x=7.665 //y=1.41 //x2=7.55 //y2=1.41
r291 (  98 114 ) resistor r=5.52526 //w=0.168 //l=0.115 //layer=ply \
 //thickness=0.18 //x=7.885 //y=1.41 //x2=8 //y2=1.41
r292 (  97 111 ) resistor r=5.52526 //w=0.168 //l=0.115 //layer=ply \
 //thickness=0.18 //x=7.665 //y=0.755 //x2=7.55 //y2=0.755
r293 (  96 113 ) resistor r=5.52526 //w=0.168 //l=0.115 //layer=ply \
 //thickness=0.18 //x=7.885 //y=0.755 //x2=8 //y2=0.755
r294 (  96 97 ) resistor r=112.809 //w=0.094 //l=0.22 //layer=ply \
 //thickness=0.18 //x=7.885 //y=0.755 //x2=7.665 //y2=0.755
r295 (  94 101 ) resistor r=26.9307 //w=0.15 //l=0.106066 //layer=ply \
 //thickness=0.18 //x=7.92 //y=4.79 //x2=7.995 //y2=4.865
r296 (  94 95 ) resistor r=148.702 //w=0.094 //l=0.29 //layer=ply \
 //thickness=0.18 //x=7.92 //y=4.79 //x2=7.63 //y2=4.79
r297 (  91 95 ) resistor r=23.403 //w=0.284 //l=0.106066 //layer=ply \
 //thickness=0.18 //x=7.555 //y=4.865 //x2=7.63 //y2=4.79
r298 (  91 110 ) resistor r=26.3063 //w=0.284 //l=0.229783 //layer=ply \
 //thickness=0.18 //x=7.555 //y=4.865 //x2=7.4 //y2=4.7
r299 (  90 108 ) resistor r=19.1248 //w=0.302 //l=0.165 //layer=ply \
 //thickness=0.18 //x=7.51 //y=1.92 //x2=7.51 //y2=2.085
r300 (  89 112 ) resistor r=39.5823 //w=0.21 //l=0.173853 //layer=ply \
 //thickness=0.18 //x=7.51 //y=1.565 //x2=7.55 //y2=1.41
r301 (  89 90 ) resistor r=182.032 //w=0.094 //l=0.355 //layer=ply \
 //thickness=0.18 //x=7.51 //y=1.565 //x2=7.51 //y2=1.92
r302 (  88 112 ) resistor r=39.5823 //w=0.21 //l=0.173853 //layer=ply \
 //thickness=0.18 //x=7.51 //y=1.255 //x2=7.55 //y2=1.41
r303 (  87 111 ) resistor r=45.1352 //w=0.168 //l=0.173853 //layer=ply \
 //thickness=0.18 //x=7.51 //y=0.91 //x2=7.55 //y2=0.755
r304 (  87 88 ) resistor r=176.904 //w=0.094 //l=0.345 //layer=ply \
 //thickness=0.18 //x=7.51 //y=0.91 //x2=7.51 //y2=1.255
r305 (  86 101 ) resistor r=592.245 //w=0.094 //l=1.155 //layer=ply \
 //thickness=0.18 //x=7.995 //y=6.02 //x2=7.995 //y2=4.865
r306 (  85 91 ) resistor r=592.245 //w=0.094 //l=1.155 //layer=ply \
 //thickness=0.18 //x=7.555 //y=6.02 //x2=7.555 //y2=4.865
r307 (  84 98 ) resistor r=56.4043 //w=0.094 //l=0.11 //layer=ply \
 //thickness=0.18 //x=7.775 //y=1.41 //x2=7.885 //y2=1.41
r308 (  84 99 ) resistor r=56.4043 //w=0.094 //l=0.11 //layer=ply \
 //thickness=0.18 //x=7.775 //y=1.41 //x2=7.665 //y2=1.41
r309 (  80 110 ) resistor r=152 //w=0.17 //l=0.17 //layer=licon //count=1 \
 //x=7.4 //y=4.7 //x2=7.4 //y2=4.7
r310 (  71 107 ) resistor r=152 //w=0.17 //l=0.17 //layer=licon //count=1 \
 //x=7.4 //y=2.085 //x2=7.4 //y2=2.085
r311 (  54 119 ) resistor r=23.2727 //w=0.187 //l=0.34 //layer=li \
 //thickness=0.1 //x=5.44 //y=5.38 //x2=5.44 //y2=5.72
r312 (  45 46 ) resistor r=0.101938 //w=0.281 //l=0.16 //layer=m2 \
 //thickness=0.36 //x=7.395 //y=2.59 //x2=7.235 //y2=2.59
r313 (  43 46 ) resistor r=1.02837 //w=0.141 //l=1.16 //layer=m2 \
 //thickness=0.36 //x=6.075 //y=2.585 //x2=7.235 //y2=2.585
r314 (  41 43 ) resistor r=0.101938 //w=0.281 //l=0.16 //layer=m2 \
 //thickness=0.36 //x=5.915 //y=2.59 //x2=6.075 //y2=2.59
r315 (  37 80 ) resistor r=9.3 //w=0.17 //l=0.17 //layer=mcon //count=1 \
 //x=7.4 //y=4.7 //x2=7.4 //y2=4.7
r316 (  34 71 ) resistor r=9.3 //w=0.17 //l=0.17 //layer=mcon //count=1 \
 //x=7.4 //y=2.085 //x2=7.4 //y2=2.085
r317 (  31 45 ) resistor r=4.5 //w=0.15 //l=0.15 //layer=via1 //count=1 \
 //x=7.395 //y=2.59 //x2=7.395 //y2=2.59
r318 (  28 41 ) resistor r=4.5 //w=0.15 //l=0.15 //layer=via1 //count=1 \
 //x=5.915 //y=2.59 //x2=5.915 //y2=2.59
r319 (  26 116 ) resistor r=9.3 //w=0.17 //l=0.17 //layer=mcon //count=1 \
 //x=5.48 //y=1 //x2=5.48 //y2=1
r320 (  24 54 ) resistor r=9.3 //w=0.17 //l=0.17 //layer=mcon //count=1 \
 //x=5.44 //y=5.38 //x2=5.44 //y2=5.38
r321 (  22 24 ) resistor r=0.0974771 //w=0.218 //l=0.17 //layer=m1 \
 //thickness=0.36 //x=5.435 //y=5.21 //x2=5.435 //y2=5.38
r322 (  20 115 ) resistor r=9.3 //w=0.17 //l=0.17 //layer=mcon //count=1 \
 //x=4.51 //y=1 //x2=4.51 //y2=1
r323 (  18 37 ) resistor r=0.0732479 //w=0.241 //l=0.122474 //layer=m1 \
 //thickness=0.36 //x=7.4 //y=4.58 //x2=7.405 //y2=4.7
r324 (  17 31 ) resistor r=0.0910802 //w=0.374 //l=0.185472 //layer=m1 \
 //thickness=0.36 //x=7.4 //y=2.75 //x2=7.345 //y2=2.59
r325 (  17 18 ) resistor r=1.74618 //w=0.131 //l=1.83 //layer=m1 \
 //thickness=0.36 //x=7.4 //y=2.75 //x2=7.4 //y2=4.58
r326 (  16 31 ) resistor r=0.0910802 //w=0.374 //l=0.185472 //layer=m1 \
 //thickness=0.36 //x=7.4 //y=2.43 //x2=7.345 //y2=2.59
r327 (  15 34 ) resistor r=0.116051 //w=0.211 //l=0.165 //layer=m1 \
 //thickness=0.36 //x=7.4 //y=2.25 //x2=7.4 //y2=2.085
r328 (  15 16 ) resistor r=0.171756 //w=0.131 //l=0.18 //layer=m1 \
 //thickness=0.36 //x=7.4 //y=2.25 //x2=7.4 //y2=2.43
r329 (  13 28 ) resistor r=0.0912814 //w=0.379 //l=0.183303 //layer=m1 \
 //thickness=0.36 //x=5.92 //y=2.75 //x2=5.97 //y2=2.59
r330 (  13 14 ) resistor r=2.26622 //w=0.131 //l=2.375 //layer=m1 \
 //thickness=0.36 //x=5.92 //y=2.75 //x2=5.92 //y2=5.125
r331 (  12 28 ) resistor r=0.0912814 //w=0.379 //l=0.183303 //layer=m1 \
 //thickness=0.36 //x=5.92 //y=2.43 //x2=5.97 //y2=2.59
r332 (  11 12 ) resistor r=0.658397 //w=0.131 //l=0.69 //layer=m1 \
 //thickness=0.36 //x=5.92 //y=1.74 //x2=5.92 //y2=2.43
r333 (  10 21 ) resistor r=0.0529306 //w=0.17 //l=0.085 //layer=m1 \
 //thickness=0.36 //x=5.565 //y=1.655 //x2=5.48 //y2=1.655
r334 (  9 11 ) resistor r=0.0698411 //w=0.17 //l=0.120208 //layer=m1 \
 //thickness=0.36 //x=5.835 //y=1.655 //x2=5.92 //y2=1.74
r335 (  9 10 ) resistor r=0.257634 //w=0.131 //l=0.27 //layer=m1 \
 //thickness=0.36 //x=5.835 //y=1.655 //x2=5.565 //y2=1.655
r336 (  8 22 ) resistor r=0.0225019 //w=0.218 //l=0.12 //layer=m1 \
 //thickness=0.36 //x=5.555 //y=5.21 //x2=5.435 //y2=5.21
r337 (  7 14 ) resistor r=0.0698411 //w=0.17 //l=0.120208 //layer=m1 \
 //thickness=0.36 //x=5.835 //y=5.21 //x2=5.92 //y2=5.125
r338 (  7 8 ) resistor r=0.267176 //w=0.131 //l=0.28 //layer=m1 \
 //thickness=0.36 //x=5.835 //y=5.21 //x2=5.555 //y2=5.21
r339 (  6 21 ) resistor r=0.0137558 //w=0.34 //l=0.085 //layer=m1 \
 //thickness=0.36 //x=5.48 //y=1.57 //x2=5.48 //y2=1.655
r340 (  5 26 ) resistor r=0.0728765 //w=0.25 //l=0.121491 //layer=m1 \
 //thickness=0.36 //x=5.48 //y=1.12 //x2=5.477 //y2=1
r341 (  5 6 ) resistor r=0.429389 //w=0.131 //l=0.45 //layer=m1 \
 //thickness=0.36 //x=5.48 //y=1.12 //x2=5.48 //y2=1.57
r342 (  3 21 ) resistor r=0.0529306 //w=0.17 //l=0.085 //layer=m1 \
 //thickness=0.36 //x=5.395 //y=1.655 //x2=5.48 //y2=1.655
r343 (  3 4 ) resistor r=0.763359 //w=0.131 //l=0.8 //layer=m1 \
 //thickness=0.36 //x=5.395 //y=1.655 //x2=4.595 //y2=1.655
r344 (  2 4 ) resistor r=0.0698411 //w=0.17 //l=0.120208 //layer=m1 \
 //thickness=0.36 //x=4.51 //y=1.57 //x2=4.595 //y2=1.655
r345 (  1 20 ) resistor r=0.0764279 //w=0.233 //l=0.126491 //layer=m1 \
 //thickness=0.36 //x=4.51 //y=1.125 //x2=4.507 //y2=1
r346 (  1 2 ) resistor r=0.424618 //w=0.131 //l=0.445 //layer=m1 \
 //thickness=0.36 //x=4.51 //y=1.125 //x2=4.51 //y2=1.57
ends PM_AO3X1_PCELL\%noxref_2

subckt PM_AO3X1_PCELL\%noxref_3 ( 1 11 12 19 42 50 66 93 108 111 112 115 116 \
 117 118 119 120 121 )
c172 ( 121 0 ) capacitor c=0.0631391f //x=8.07 //y=5.02
c173 ( 120 0 ) capacitor c=0.0581255f //x=7.2 //y=5.02
c174 ( 119 0 ) capacitor c=0.0230394f //x=4.415 //y=5.025
c175 ( 118 0 ) capacitor c=0.0399063f //x=2.405 //y=5.02
c176 ( 117 0 ) capacitor c=0.0247431f //x=1.525 //y=5.02
c177 ( 116 0 ) capacitor c=0.0678024f //x=0.655 //y=5.02
c178 ( 115 0 ) capacitor c=0.240846f //x=8.14 //y=7.4
c179 ( 113 0 ) capacitor c=0.00591168f //x=7.335 //y=7.4
c180 ( 112 0 ) capacitor c=0.122876f //x=6.66 //y=7.4
c181 ( 111 0 ) capacitor c=0.126437f //x=3.33 //y=7.4
c182 ( 110 0 ) capacitor c=0.00591168f //x=2.55 //y=7.4
c183 ( 109 0 ) capacitor c=0.00591168f //x=1.67 //y=7.4
c184 ( 108 0 ) capacitor c=0.253139f //x=0.74 //y=7.4
c185 ( 93 0 ) capacitor c=0.028723f //x=8.13 //y=7.4
c186 ( 81 0 ) capacitor c=0.0216067f //x=7.25 //y=7.4
c187 ( 66 0 ) capacitor c=0.137893f //x=6.49 //y=7.4
c188 ( 60 0 ) capacitor c=0.0275781f //x=3.16 //y=7.4
c189 ( 50 0 ) capacitor c=0.0284687f //x=2.465 //y=7.4
c190 ( 42 0 ) capacitor c=0.0288404f //x=1.585 //y=7.4
c191 ( 23 0 ) capacitor c=0.00498911f //x=4.56 //y=7.4
c192 ( 19 0 ) capacitor c=0.16507f //x=8.14 //y=7.4
c193 ( 12 0 ) capacitor c=0.00916089f //x=4.56 //y=7.23
c194 ( 11 0 ) capacitor c=0.00572492f //x=4.56 //y=6.855
c195 ( 1 0 ) capacitor c=0.17911f //x=4.475 //y=7.4
r196 (  95 115 ) resistor r=4.11603 //w=0.68 //l=0.17 //layer=li \
 //thickness=0.1 //x=8.215 //y=7.23 //x2=8.215 //y2=7.4
r197 (  95 121 ) resistor r=56.4706 //w=0.187 //l=0.825 //layer=li \
 //thickness=0.1 //x=8.215 //y=7.23 //x2=8.215 //y2=6.405
r198 (  94 113 ) resistor r=2.94794 //w=0.34 //l=0.085 //layer=li \
 //thickness=0.1 //x=7.42 //y=7.4 //x2=7.335 //y2=7.4
r199 (  93 115 ) resistor r=2.94794 //w=0.34 //l=0.085 //layer=li \
 //thickness=0.1 //x=8.13 //y=7.4 //x2=8.215 //y2=7.4
r200 (  93 94 ) resistor r=25.4566 //w=0.357 //l=0.71 //layer=li \
 //thickness=0.1 //x=8.13 //y=7.4 //x2=7.42 //y2=7.4
r201 (  85 113 ) resistor r=4.11603 //w=0.68 //l=0.17 //layer=li \
 //thickness=0.1 //x=7.335 //y=7.23 //x2=7.335 //y2=7.4
r202 (  85 120 ) resistor r=56.4706 //w=0.187 //l=0.825 //layer=li \
 //thickness=0.1 //x=7.335 //y=7.23 //x2=7.335 //y2=6.405
r203 (  82 112 ) resistor r=5.4201 //w=0.34 //l=0.17 //layer=li \
 //thickness=0.1 //x=6.83 //y=7.4 //x2=6.66 //y2=7.4
r204 (  82 84 ) resistor r=7.17087 //w=0.357 //l=0.2 //layer=li \
 //thickness=0.1 //x=6.83 //y=7.4 //x2=7.03 //y2=7.4
r205 (  81 113 ) resistor r=2.94794 //w=0.34 //l=0.085 //layer=li \
 //thickness=0.1 //x=7.25 //y=7.4 //x2=7.335 //y2=7.4
r206 (  81 84 ) resistor r=7.88796 //w=0.357 //l=0.22 //layer=li \
 //thickness=0.1 //x=7.25 //y=7.4 //x2=7.03 //y2=7.4
r207 (  69 71 ) resistor r=39.7983 //w=0.357 //l=1.11 //layer=li \
 //thickness=0.1 //x=4.44 //y=7.4 //x2=5.55 //y2=7.4
r208 (  67 111 ) resistor r=5.4201 //w=0.34 //l=0.17 //layer=li \
 //thickness=0.1 //x=3.5 //y=7.4 //x2=3.33 //y2=7.4
r209 (  67 69 ) resistor r=33.7031 //w=0.357 //l=0.94 //layer=li \
 //thickness=0.1 //x=3.5 //y=7.4 //x2=4.44 //y2=7.4
r210 (  66 112 ) resistor r=5.4201 //w=0.34 //l=0.17 //layer=li \
 //thickness=0.1 //x=6.49 //y=7.4 //x2=6.66 //y2=7.4
r211 (  66 71 ) resistor r=33.7031 //w=0.357 //l=0.94 //layer=li \
 //thickness=0.1 //x=6.49 //y=7.4 //x2=5.55 //y2=7.4
r212 (  61 110 ) resistor r=2.94794 //w=0.34 //l=0.085 //layer=li \
 //thickness=0.1 //x=2.635 //y=7.4 //x2=2.55 //y2=7.4
r213 (  61 63 ) resistor r=11.6527 //w=0.357 //l=0.325 //layer=li \
 //thickness=0.1 //x=2.635 //y=7.4 //x2=2.96 //y2=7.4
r214 (  60 111 ) resistor r=5.4201 //w=0.34 //l=0.17 //layer=li \
 //thickness=0.1 //x=3.16 //y=7.4 //x2=3.33 //y2=7.4
r215 (  60 63 ) resistor r=7.17087 //w=0.357 //l=0.2 //layer=li \
 //thickness=0.1 //x=3.16 //y=7.4 //x2=2.96 //y2=7.4
r216 (  54 110 ) resistor r=4.11603 //w=0.68 //l=0.17 //layer=li \
 //thickness=0.1 //x=2.55 //y=7.23 //x2=2.55 //y2=7.4
r217 (  54 118 ) resistor r=33.1979 //w=0.187 //l=0.485 //layer=li \
 //thickness=0.1 //x=2.55 //y=7.23 //x2=2.55 //y2=6.745
r218 (  51 109 ) resistor r=2.94794 //w=0.34 //l=0.085 //layer=li \
 //thickness=0.1 //x=1.755 //y=7.4 //x2=1.67 //y2=7.4
r219 (  51 53 ) resistor r=3.40616 //w=0.357 //l=0.095 //layer=li \
 //thickness=0.1 //x=1.755 //y=7.4 //x2=1.85 //y2=7.4
r220 (  50 110 ) resistor r=2.94794 //w=0.34 //l=0.085 //layer=li \
 //thickness=0.1 //x=2.465 //y=7.4 //x2=2.55 //y2=7.4
r221 (  50 53 ) resistor r=22.0504 //w=0.357 //l=0.615 //layer=li \
 //thickness=0.1 //x=2.465 //y=7.4 //x2=1.85 //y2=7.4
r222 (  44 109 ) resistor r=4.11603 //w=0.68 //l=0.17 //layer=li \
 //thickness=0.1 //x=1.67 //y=7.23 //x2=1.67 //y2=7.4
r223 (  44 117 ) resistor r=33.1979 //w=0.187 //l=0.485 //layer=li \
 //thickness=0.1 //x=1.67 //y=7.23 //x2=1.67 //y2=6.745
r224 (  43 108 ) resistor r=2.94794 //w=0.34 //l=0.085 //layer=li \
 //thickness=0.1 //x=0.875 //y=7.4 //x2=0.79 //y2=7.4
r225 (  42 109 ) resistor r=2.94794 //w=0.34 //l=0.085 //layer=li \
 //thickness=0.1 //x=1.585 //y=7.4 //x2=1.67 //y2=7.4
r226 (  42 43 ) resistor r=25.4566 //w=0.357 //l=0.71 //layer=li \
 //thickness=0.1 //x=1.585 //y=7.4 //x2=0.875 //y2=7.4
r227 (  34 108 ) resistor r=4.11603 //w=0.68 //l=0.17 //layer=li \
 //thickness=0.1 //x=0.79 //y=7.23 //x2=0.79 //y2=7.4
r228 (  34 116 ) resistor r=56.4706 //w=0.187 //l=0.825 //layer=li \
 //thickness=0.1 //x=0.79 //y=7.23 //x2=0.79 //y2=6.405
r229 (  25 119 ) resistor r=9.3 //w=0.17 //l=0.17 //layer=mcon //count=1 \
 //x=4.56 //y=6.74 //x2=4.56 //y2=6.74
r230 (  19 115 ) resistor r=3.1 //w=0.17 //l=0.51 //layer=mcon //count=3 \
 //x=8.14 //y=7.4 //x2=8.14 //y2=7.4
r231 (  17 84 ) resistor r=3.1 //w=0.17 //l=0.51 //layer=mcon //count=3 \
 //x=7.03 //y=7.4 //x2=7.03 //y2=7.4
r232 (  17 19 ) resistor r=0.460963 //w=0.301 //l=1.11 //layer=m1 \
 //thickness=0.36 //x=7.03 //y=7.4 //x2=8.14 //y2=7.4
r233 (  15 71 ) resistor r=3.1 //w=0.17 //l=0.51 //layer=mcon //count=3 \
 //x=5.55 //y=7.4 //x2=5.55 //y2=7.4
r234 (  15 17 ) resistor r=0.614618 //w=0.301 //l=1.48 //layer=m1 \
 //thickness=0.36 //x=5.55 //y=7.4 //x2=7.03 //y2=7.4
r235 (  13 23 ) resistor r=0.0287885 //w=0.34 //l=0.085 //layer=m1 \
 //thickness=0.36 //x=4.645 //y=7.4 //x2=4.56 //y2=7.4
r236 (  13 15 ) resistor r=0.375831 //w=0.301 //l=0.905 //layer=m1 \
 //thickness=0.36 //x=4.645 //y=7.4 //x2=5.55 //y2=7.4
r237 (  12 23 ) resistor r=0.0401957 //w=0.68 //l=0.17 //layer=m1 \
 //thickness=0.36 //x=4.56 //y=7.23 //x2=4.56 //y2=7.4
r238 (  11 25 ) resistor r=0.0723371 //w=0.218 //l=0.115 //layer=m1 \
 //thickness=0.36 //x=4.56 //y=6.855 //x2=4.56 //y2=6.74
r239 (  11 12 ) resistor r=0.357824 //w=0.131 //l=0.375 //layer=m1 \
 //thickness=0.36 //x=4.56 //y=6.855 //x2=4.56 //y2=7.23
r240 (  10 69 ) resistor r=3.1 //w=0.17 //l=0.51 //layer=mcon //count=3 \
 //x=4.44 //y=7.4 //x2=4.44 //y2=7.4
r241 (  8 63 ) resistor r=3.1 //w=0.17 //l=0.51 //layer=mcon //count=3 \
 //x=2.96 //y=7.4 //x2=2.96 //y2=7.4
r242 (  8 10 ) resistor r=0.614618 //w=0.301 //l=1.48 //layer=m1 \
 //thickness=0.36 //x=2.96 //y=7.4 //x2=4.44 //y2=7.4
r243 (  6 53 ) resistor r=3.1 //w=0.17 //l=0.51 //layer=mcon //count=3 \
 //x=1.85 //y=7.4 //x2=1.85 //y2=7.4
r244 (  6 8 ) resistor r=0.460963 //w=0.301 //l=1.11 //layer=m1 \
 //thickness=0.36 //x=1.85 //y=7.4 //x2=2.96 //y2=7.4
r245 (  3 108 ) resistor r=3.1 //w=0.17 //l=0.51 //layer=mcon //count=3 \
 //x=0.74 //y=7.4 //x2=0.74 //y2=7.4
r246 (  3 6 ) resistor r=0.460963 //w=0.301 //l=1.11 //layer=m1 \
 //thickness=0.36 //x=0.74 //y=7.4 //x2=1.85 //y2=7.4
r247 (  1 23 ) resistor r=0.0287885 //w=0.34 //l=0.085 //layer=m1 \
 //thickness=0.36 //x=4.475 //y=7.4 //x2=4.56 //y2=7.4
r248 (  1 10 ) resistor r=0.0145349 //w=0.301 //l=0.035 //layer=m1 \
 //thickness=0.36 //x=4.475 //y=7.4 //x2=4.44 //y2=7.4
ends PM_AO3X1_PCELL\%noxref_3

subckt PM_AO3X1_PCELL\%noxref_4 ( 4 7 8 11 16 20 21 22 23 24 25 26 30 32 35 36 \
 46 )
c96 ( 46 0 ) capacitor c=0.0682508f //x=1.11 //y=4.7
c97 ( 36 0 ) capacitor c=0.0318956f //x=1.445 //y=1.21
c98 ( 35 0 ) capacitor c=0.0186809f //x=1.445 //y=0.865
c99 ( 32 0 ) capacitor c=0.0141821f //x=1.29 //y=1.365
c100 ( 30 0 ) capacitor c=0.0158553f //x=1.29 //y=0.71
c101 ( 26 0 ) capacitor c=0.088055f //x=0.915 //y=1.915
c102 ( 25 0 ) capacitor c=0.0229235f //x=0.915 //y=1.52
c103 ( 24 0 ) capacitor c=0.0234359f //x=0.915 //y=1.21
c104 ( 23 0 ) capacitor c=0.0198759f //x=0.915 //y=0.865
c105 ( 22 0 ) capacitor c=0.110369f //x=1.45 //y=6.02
c106 ( 21 0 ) capacitor c=0.154619f //x=1.01 //y=6.02
c107 ( 16 0 ) capacitor c=8.13451e-19 //x=1.11 //y=4.7
c108 ( 11 0 ) capacitor c=7.85889e-19 //x=1.11 //y=2.08
c109 ( 8 0 ) capacitor c=0.10646f //x=1.112 //y=4.56
c110 ( 7 0 ) capacitor c=0.0113945f //x=1.11 //y=4.7
c111 ( 4 0 ) capacitor c=0.0108617f //x=1.11 //y=2.08
r112 (  44 46 ) resistor r=20.6867 //w=0.233 //l=0.1 //layer=ply \
 //thickness=0.18 //x=1.01 //y=4.7 //x2=1.11 //y2=4.7
r113 (  37 46 ) resistor r=70.3348 //w=0.233 //l=0.414367 //layer=ply \
 //thickness=0.18 //x=1.45 //y=4.865 //x2=1.11 //y2=4.7
r114 (  36 48 ) resistor r=45.1352 //w=0.168 //l=0.173853 //layer=ply \
 //thickness=0.18 //x=1.445 //y=1.21 //x2=1.405 //y2=1.365
r115 (  35 47 ) resistor r=45.1352 //w=0.168 //l=0.173853 //layer=ply \
 //thickness=0.18 //x=1.445 //y=0.865 //x2=1.405 //y2=0.71
r116 (  35 36 ) resistor r=176.904 //w=0.094 //l=0.345 //layer=ply \
 //thickness=0.18 //x=1.445 //y=0.865 //x2=1.445 //y2=1.21
r117 (  33 43 ) resistor r=10.701 //w=0.21 //l=0.115 //layer=ply \
 //thickness=0.18 //x=1.07 //y=1.365 //x2=0.955 //y2=1.365
r118 (  32 48 ) resistor r=5.52526 //w=0.168 //l=0.115 //layer=ply \
 //thickness=0.18 //x=1.29 //y=1.365 //x2=1.405 //y2=1.365
r119 (  31 42 ) resistor r=5.52526 //w=0.168 //l=0.115 //layer=ply \
 //thickness=0.18 //x=1.07 //y=0.71 //x2=0.955 //y2=0.71
r120 (  30 47 ) resistor r=5.52526 //w=0.168 //l=0.115 //layer=ply \
 //thickness=0.18 //x=1.29 //y=0.71 //x2=1.405 //y2=0.71
r121 (  30 31 ) resistor r=112.809 //w=0.094 //l=0.22 //layer=ply \
 //thickness=0.18 //x=1.29 //y=0.71 //x2=1.07 //y2=0.71
r122 (  27 44 ) resistor r=13.0941 //w=0.233 //l=0.165 //layer=ply \
 //thickness=0.18 //x=1.01 //y=4.865 //x2=1.01 //y2=4.7
r123 (  26 41 ) resistor r=34.8111 //w=0.27 //l=0.264953 //layer=ply \
 //thickness=0.18 //x=0.915 //y=1.915 //x2=1.11 //y2=2.08
r124 (  25 43 ) resistor r=39.5823 //w=0.21 //l=0.173853 //layer=ply \
 //thickness=0.18 //x=0.915 //y=1.52 //x2=0.955 //y2=1.365
r125 (  25 26 ) resistor r=202.543 //w=0.094 //l=0.395 //layer=ply \
 //thickness=0.18 //x=0.915 //y=1.52 //x2=0.915 //y2=1.915
r126 (  24 43 ) resistor r=39.5823 //w=0.21 //l=0.173853 //layer=ply \
 //thickness=0.18 //x=0.915 //y=1.21 //x2=0.955 //y2=1.365
r127 (  23 42 ) resistor r=45.1352 //w=0.168 //l=0.173853 //layer=ply \
 //thickness=0.18 //x=0.915 //y=0.865 //x2=0.955 //y2=0.71
r128 (  23 24 ) resistor r=176.904 //w=0.094 //l=0.345 //layer=ply \
 //thickness=0.18 //x=0.915 //y=0.865 //x2=0.915 //y2=1.21
r129 (  22 37 ) resistor r=592.245 //w=0.094 //l=1.155 //layer=ply \
 //thickness=0.18 //x=1.45 //y=6.02 //x2=1.45 //y2=4.865
r130 (  21 27 ) resistor r=592.245 //w=0.094 //l=1.155 //layer=ply \
 //thickness=0.18 //x=1.01 //y=6.02 //x2=1.01 //y2=4.865
r131 (  20 32 ) resistor r=56.4043 //w=0.094 //l=0.11 //layer=ply \
 //thickness=0.18 //x=1.18 //y=1.365 //x2=1.29 //y2=1.365
r132 (  20 33 ) resistor r=56.4043 //w=0.094 //l=0.11 //layer=ply \
 //thickness=0.18 //x=1.18 //y=1.365 //x2=1.07 //y2=1.365
r133 (  16 46 ) resistor r=152 //w=0.17 //l=0.17 //layer=licon //count=1 \
 //x=1.11 //y=4.7 //x2=1.11 //y2=4.7
r134 (  11 41 ) resistor r=152 //w=0.17 //l=0.17 //layer=licon //count=1 \
 //x=1.11 //y=2.08 //x2=1.11 //y2=2.08
r135 (  7 16 ) resistor r=9.3 //w=0.17 //l=0.17 //layer=mcon //count=1 \
 //x=1.11 //y=4.7 //x2=1.11 //y2=4.7
r136 (  7 8 ) resistor r=0.103207 //w=0.196 //l=0.14 //layer=m1 \
 //thickness=0.36 //x=1.112 //y=4.7 //x2=1.112 //y2=4.56
r137 (  4 11 ) resistor r=9.3 //w=0.17 //l=0.17 //layer=mcon //count=1 \
 //x=1.11 //y=2.08 //x2=1.11 //y2=2.08
r138 (  1 4 ) resistor r=0.0933015 //w=0.201 //l=0.125 //layer=m1 \
 //thickness=0.36 //x=1.11 //y=2.205 //x2=1.11 //y2=2.08
r139 (  1 8 ) resistor r=2.24714 //w=0.131 //l=2.355 //layer=m1 \
 //thickness=0.36 //x=1.11 //y=2.205 //x2=1.11 //y2=4.56
ends PM_AO3X1_PCELL\%noxref_4

subckt PM_AO3X1_PCELL\%noxref_5 ( 1 19 22 23 28 31 46 55 69 79 93 97 109 119 \
 124 131 132 133 )
c192 ( 133 0 ) capacitor c=0.0650072f //x=7.155 //y=0.37
c193 ( 132 0 ) capacitor c=0.0734737f //x=3.89 //y=0.365
c194 ( 131 0 ) capacitor c=0.00843555f //x=0.99 //y=0.865
c195 ( 124 0 ) capacitor c=0.237692f //x=8.26 //y=0
c196 ( 119 0 ) capacitor c=0.107419f //x=6.66 //y=0
c197 ( 116 0 ) capacitor c=0.00591168f //x=5.965 //y=0
c198 ( 113 0 ) capacitor c=0.00591168f //x=4.995 //y=0
c199 ( 110 0 ) capacitor c=0.00591168f //x=4.025 //y=0
c200 ( 109 0 ) capacitor c=0.112694f //x=3.33 //y=0
c201 ( 100 0 ) capacitor c=0.00589014f //x=8.26 //y=0.45
c202 ( 97 0 ) capacitor c=0.00625302f //x=8.175 //y=0.535
c203 ( 96 0 ) capacitor c=0.00479851f //x=7.77 //y=0.45
c204 ( 93 0 ) capacitor c=0.00635508f //x=7.685 //y=0.535
c205 ( 88 0 ) capacitor c=0.00590583f //x=7.29 //y=0.45
c206 ( 83 0 ) capacitor c=0.0189275f //x=7.205 //y=0
c207 ( 79 0 ) capacitor c=0.0219529f //x=6.49 //y=0
c208 ( 74 0 ) capacitor c=0.00739123f //x=5.965 //y=0.445
c209 ( 69 0 ) capacitor c=0.0152893f //x=5.88 //y=0.53
c210 ( 65 0 ) capacitor c=0.0253251f //x=5.88 //y=0
c211 ( 60 0 ) capacitor c=0.00726869f //x=4.995 //y=0.445
c212 ( 55 0 ) capacitor c=0.016551f //x=4.91 //y=0.53
c213 ( 51 0 ) capacitor c=0.025309f //x=4.91 //y=0
c214 ( 46 0 ) capacitor c=0.00739123f //x=4.025 //y=0.445
c215 ( 43 0 ) capacitor c=0.0227441f //x=3.94 //y=0
c216 ( 31 0 ) capacitor c=0.183052f //x=0.74 //y=0
c217 ( 28 0 ) capacitor c=0.123925f //x=3.16 //y=0
c218 ( 25 0 ) capacitor c=0.0050875f //x=1.18 //y=0
c219 ( 23 0 ) capacitor c=0.0278993f //x=1.177 //y=0.825
c220 ( 22 0 ) capacitor c=0.0161817f //x=1.18 //y=0.955
c221 ( 19 0 ) capacitor c=0.270862f //x=8.14 //y=0
c222 ( 1 0 ) capacitor c=0.0587616f //x=1.095 //y=0
r223 (  123 124 ) resistor r=4.30252 //w=0.357 //l=0.12 //layer=li \
 //thickness=0.1 //x=8.14 //y=0 //x2=8.26 //y2=0
r224 (  121 123 ) resistor r=13.2661 //w=0.357 //l=0.37 //layer=li \
 //thickness=0.1 //x=7.77 //y=0 //x2=8.14 //y2=0
r225 (  120 121 ) resistor r=17.2101 //w=0.357 //l=0.48 //layer=li \
 //thickness=0.1 //x=7.29 //y=0 //x2=7.77 //y2=0
r226 (  101 133 ) resistor r=5.4201 //w=0.17 //l=0.085 //layer=li \
 //thickness=0.1 //x=8.26 //y=0.62 //x2=8.26 //y2=0.535
r227 (  101 133 ) resistor r=41.4118 //w=0.187 //l=0.605 //layer=li \
 //thickness=0.1 //x=8.26 //y=0.62 //x2=8.26 //y2=1.225
r228 (  100 133 ) resistor r=5.4201 //w=0.17 //l=0.085 //layer=li \
 //thickness=0.1 //x=8.26 //y=0.45 //x2=8.26 //y2=0.535
r229 (  99 124 ) resistor r=5.03728 //w=0.34 //l=0.17 //layer=li \
 //thickness=0.1 //x=8.26 //y=0.17 //x2=8.26 //y2=0
r230 (  99 100 ) resistor r=19.1658 //w=0.187 //l=0.28 //layer=li \
 //thickness=0.1 //x=8.26 //y=0.17 //x2=8.26 //y2=0.45
r231 (  98 133 ) resistor r=5.4201 //w=0.17 //l=0.085 //layer=li \
 //thickness=0.1 //x=7.855 //y=0.535 //x2=7.77 //y2=0.535
r232 (  97 133 ) resistor r=1.40859 //w=0.34 //l=0.085 //layer=li \
 //thickness=0.1 //x=8.175 //y=0.535 //x2=8.26 //y2=0.535
r233 (  97 98 ) resistor r=21.9037 //w=0.187 //l=0.32 //layer=li \
 //thickness=0.1 //x=8.175 //y=0.535 //x2=7.855 //y2=0.535
r234 (  96 133 ) resistor r=1.40859 //w=0.34 //l=0.085 //layer=li \
 //thickness=0.1 //x=7.77 //y=0.45 //x2=7.77 //y2=0.535
r235 (  95 121 ) resistor r=5.03728 //w=0.34 //l=0.17 //layer=li \
 //thickness=0.1 //x=7.77 //y=0.17 //x2=7.77 //y2=0
r236 (  95 96 ) resistor r=19.1658 //w=0.187 //l=0.28 //layer=li \
 //thickness=0.1 //x=7.77 //y=0.17 //x2=7.77 //y2=0.45
r237 (  94 133 ) resistor r=1.40859 //w=0.34 //l=0.085 //layer=li \
 //thickness=0.1 //x=7.375 //y=0.535 //x2=7.29 //y2=0.535
r238 (  93 133 ) resistor r=5.4201 //w=0.17 //l=0.085 //layer=li \
 //thickness=0.1 //x=7.685 //y=0.535 //x2=7.77 //y2=0.535
r239 (  93 94 ) resistor r=21.2193 //w=0.187 //l=0.31 //layer=li \
 //thickness=0.1 //x=7.685 //y=0.535 //x2=7.375 //y2=0.535
r240 (  89 133 ) resistor r=5.4201 //w=0.17 //l=0.085 //layer=li \
 //thickness=0.1 //x=7.29 //y=0.62 //x2=7.29 //y2=0.535
r241 (  89 133 ) resistor r=41.4118 //w=0.187 //l=0.605 //layer=li \
 //thickness=0.1 //x=7.29 //y=0.62 //x2=7.29 //y2=1.225
r242 (  88 133 ) resistor r=5.4201 //w=0.17 //l=0.085 //layer=li \
 //thickness=0.1 //x=7.29 //y=0.45 //x2=7.29 //y2=0.535
r243 (  87 120 ) resistor r=5.03728 //w=0.34 //l=0.17 //layer=li \
 //thickness=0.1 //x=7.29 //y=0.17 //x2=7.29 //y2=0
r244 (  87 88 ) resistor r=19.1658 //w=0.187 //l=0.28 //layer=li \
 //thickness=0.1 //x=7.29 //y=0.17 //x2=7.29 //y2=0.45
r245 (  84 119 ) resistor r=5.4201 //w=0.34 //l=0.17 //layer=li \
 //thickness=0.1 //x=6.83 //y=0 //x2=6.66 //y2=0
r246 (  84 86 ) resistor r=7.17087 //w=0.357 //l=0.2 //layer=li \
 //thickness=0.1 //x=6.83 //y=0 //x2=7.03 //y2=0
r247 (  83 120 ) resistor r=3.04762 //w=0.357 //l=0.085 //layer=li \
 //thickness=0.1 //x=7.205 //y=0 //x2=7.29 //y2=0
r248 (  83 86 ) resistor r=6.27451 //w=0.357 //l=0.175 //layer=li \
 //thickness=0.1 //x=7.205 //y=0 //x2=7.03 //y2=0
r249 (  80 116 ) resistor r=2.94794 //w=0.34 //l=0.085 //layer=li \
 //thickness=0.1 //x=6.05 //y=0 //x2=5.965 //y2=0
r250 (  79 119 ) resistor r=5.4201 //w=0.34 //l=0.17 //layer=li \
 //thickness=0.1 //x=6.49 //y=0 //x2=6.66 //y2=0
r251 (  79 80 ) resistor r=15.7759 //w=0.357 //l=0.44 //layer=li \
 //thickness=0.1 //x=6.49 //y=0 //x2=6.05 //y2=0
r252 (  75 132 ) resistor r=5.4201 //w=0.17 //l=0.085 //layer=li \
 //thickness=0.1 //x=5.965 //y=0.615 //x2=5.965 //y2=0.53
r253 (  75 132 ) resistor r=18.139 //w=0.187 //l=0.265 //layer=li \
 //thickness=0.1 //x=5.965 //y=0.615 //x2=5.965 //y2=0.88
r254 (  74 132 ) resistor r=5.4201 //w=0.17 //l=0.085 //layer=li \
 //thickness=0.1 //x=5.965 //y=0.445 //x2=5.965 //y2=0.53
r255 (  73 116 ) resistor r=4.11603 //w=0.68 //l=0.17 //layer=li \
 //thickness=0.1 //x=5.965 //y=0.17 //x2=5.965 //y2=0
r256 (  73 74 ) resistor r=18.8235 //w=0.187 //l=0.275 //layer=li \
 //thickness=0.1 //x=5.965 //y=0.17 //x2=5.965 //y2=0.445
r257 (  70 132 ) resistor r=6.4 //w=0.17 //l=0.085 //layer=li //thickness=0.1 \
 //x=5.08 //y=0.53 //x2=4.995 //y2=0.53
r258 (  70 132 ) resistor r=27.3797 //w=0.187 //l=0.4 //layer=li \
 //thickness=0.1 //x=5.08 //y=0.53 //x2=5.48 //y2=0.53
r259 (  69 132 ) resistor r=1.40859 //w=0.34 //l=0.085 //layer=li \
 //thickness=0.1 //x=5.88 //y=0.53 //x2=5.965 //y2=0.53
r260 (  69 132 ) resistor r=27.3797 //w=0.187 //l=0.4 //layer=li \
 //thickness=0.1 //x=5.88 //y=0.53 //x2=5.48 //y2=0.53
r261 (  66 113 ) resistor r=2.94794 //w=0.34 //l=0.085 //layer=li \
 //thickness=0.1 //x=5.08 //y=0 //x2=4.995 //y2=0
r262 (  66 68 ) resistor r=16.8515 //w=0.357 //l=0.47 //layer=li \
 //thickness=0.1 //x=5.08 //y=0 //x2=5.55 //y2=0
r263 (  65 116 ) resistor r=2.94794 //w=0.34 //l=0.085 //layer=li \
 //thickness=0.1 //x=5.88 //y=0 //x2=5.965 //y2=0
r264 (  65 68 ) resistor r=11.8319 //w=0.357 //l=0.33 //layer=li \
 //thickness=0.1 //x=5.88 //y=0 //x2=5.55 //y2=0
r265 (  61 132 ) resistor r=6.4 //w=0.17 //l=0.085 //layer=li //thickness=0.1 \
 //x=4.995 //y=0.615 //x2=4.995 //y2=0.53
r266 (  61 132 ) resistor r=18.139 //w=0.187 //l=0.265 //layer=li \
 //thickness=0.1 //x=4.995 //y=0.615 //x2=4.995 //y2=0.88
r267 (  60 132 ) resistor r=6.4 //w=0.17 //l=0.085 //layer=li //thickness=0.1 \
 //x=4.995 //y=0.445 //x2=4.995 //y2=0.53
r268 (  59 113 ) resistor r=4.11603 //w=0.68 //l=0.17 //layer=li \
 //thickness=0.1 //x=4.995 //y=0.17 //x2=4.995 //y2=0
r269 (  59 60 ) resistor r=18.8235 //w=0.187 //l=0.275 //layer=li \
 //thickness=0.1 //x=4.995 //y=0.17 //x2=4.995 //y2=0.445
r270 (  56 132 ) resistor r=1.40859 //w=0.34 //l=0.085 //layer=li \
 //thickness=0.1 //x=4.11 //y=0.53 //x2=4.025 //y2=0.53
r271 (  56 132 ) resistor r=27.3797 //w=0.187 //l=0.4 //layer=li \
 //thickness=0.1 //x=4.11 //y=0.53 //x2=4.51 //y2=0.53
r272 (  55 132 ) resistor r=6.4 //w=0.17 //l=0.085 //layer=li //thickness=0.1 \
 //x=4.91 //y=0.53 //x2=4.995 //y2=0.53
r273 (  55 132 ) resistor r=27.3797 //w=0.187 //l=0.4 //layer=li \
 //thickness=0.1 //x=4.91 //y=0.53 //x2=4.51 //y2=0.53
r274 (  52 110 ) resistor r=2.94794 //w=0.34 //l=0.085 //layer=li \
 //thickness=0.1 //x=4.11 //y=0 //x2=4.025 //y2=0
r275 (  52 54 ) resistor r=11.8319 //w=0.357 //l=0.33 //layer=li \
 //thickness=0.1 //x=4.11 //y=0 //x2=4.44 //y2=0
r276 (  51 113 ) resistor r=2.94794 //w=0.34 //l=0.085 //layer=li \
 //thickness=0.1 //x=4.91 //y=0 //x2=4.995 //y2=0
r277 (  51 54 ) resistor r=16.8515 //w=0.357 //l=0.47 //layer=li \
 //thickness=0.1 //x=4.91 //y=0 //x2=4.44 //y2=0
r278 (  47 132 ) resistor r=5.4201 //w=0.17 //l=0.085 //layer=li \
 //thickness=0.1 //x=4.025 //y=0.615 //x2=4.025 //y2=0.53
r279 (  47 132 ) resistor r=41.4118 //w=0.187 //l=0.605 //layer=li \
 //thickness=0.1 //x=4.025 //y=0.615 //x2=4.025 //y2=1.22
r280 (  46 132 ) resistor r=5.4201 //w=0.17 //l=0.085 //layer=li \
 //thickness=0.1 //x=4.025 //y=0.445 //x2=4.025 //y2=0.53
r281 (  45 110 ) resistor r=4.11603 //w=0.68 //l=0.17 //layer=li \
 //thickness=0.1 //x=4.025 //y=0.17 //x2=4.025 //y2=0
r282 (  45 46 ) resistor r=18.8235 //w=0.187 //l=0.275 //layer=li \
 //thickness=0.1 //x=4.025 //y=0.17 //x2=4.025 //y2=0.445
r283 (  44 109 ) resistor r=5.4201 //w=0.34 //l=0.17 //layer=li \
 //thickness=0.1 //x=3.5 //y=0 //x2=3.33 //y2=0
r284 (  43 110 ) resistor r=2.94794 //w=0.34 //l=0.085 //layer=li \
 //thickness=0.1 //x=3.94 //y=0 //x2=4.025 //y2=0
r285 (  43 44 ) resistor r=15.7759 //w=0.357 //l=0.44 //layer=li \
 //thickness=0.1 //x=3.94 //y=0 //x2=3.5 //y2=0
r286 (  33 35 ) resistor r=39.7983 //w=0.357 //l=1.11 //layer=li \
 //thickness=0.1 //x=1.85 //y=0 //x2=2.96 //y2=0
r287 (  31 33 ) resistor r=39.7983 //w=0.357 //l=1.11 //layer=li \
 //thickness=0.1 //x=0.74 //y=0 //x2=1.85 //y2=0
r288 (  28 109 ) resistor r=5.4201 //w=0.34 //l=0.17 //layer=li \
 //thickness=0.1 //x=3.16 //y=0 //x2=3.33 //y2=0
r289 (  28 35 ) resistor r=7.17087 //w=0.357 //l=0.2 //layer=li \
 //thickness=0.1 //x=3.16 //y=0 //x2=2.96 //y2=0
r290 (  22 131 ) resistor r=9.3 //w=0.17 //l=0.17 //layer=mcon //count=1 \
 //x=1.18 //y=0.955 //x2=1.18 //y2=0.955
r291 (  22 23 ) resistor r=0.0939994 //w=0.226 //l=0.13 //layer=m1 \
 //thickness=0.36 //x=1.177 //y=0.955 //x2=1.177 //y2=0.825
r292 (  19 123 ) resistor r=3.1 //w=0.17 //l=0.51 //layer=mcon //count=3 \
 //x=8.14 //y=0 //x2=8.14 //y2=0
r293 (  17 86 ) resistor r=3.1 //w=0.17 //l=0.51 //layer=mcon //count=3 \
 //x=7.03 //y=0 //x2=7.03 //y2=0
r294 (  17 19 ) resistor r=0.460963 //w=0.301 //l=1.11 //layer=m1 \
 //thickness=0.36 //x=7.03 //y=0 //x2=8.14 //y2=0
r295 (  15 68 ) resistor r=3.1 //w=0.17 //l=0.51 //layer=mcon //count=3 \
 //x=5.55 //y=0 //x2=5.55 //y2=0
r296 (  15 17 ) resistor r=0.614618 //w=0.301 //l=1.48 //layer=m1 \
 //thickness=0.36 //x=5.55 //y=0 //x2=7.03 //y2=0
r297 (  13 54 ) resistor r=3.1 //w=0.17 //l=0.51 //layer=mcon //count=3 \
 //x=4.44 //y=0 //x2=4.44 //y2=0
r298 (  13 15 ) resistor r=0.460963 //w=0.301 //l=1.11 //layer=m1 \
 //thickness=0.36 //x=4.44 //y=0 //x2=5.55 //y2=0
r299 (  11 35 ) resistor r=3.1 //w=0.17 //l=0.51 //layer=mcon //count=3 \
 //x=2.96 //y=0 //x2=2.96 //y2=0
r300 (  11 13 ) resistor r=0.614618 //w=0.301 //l=1.48 //layer=m1 \
 //thickness=0.36 //x=2.96 //y=0 //x2=4.44 //y2=0
r301 (  9 33 ) resistor r=3.1 //w=0.17 //l=0.51 //layer=mcon //count=3 \
 //x=1.85 //y=0 //x2=1.85 //y2=0
r302 (  9 11 ) resistor r=0.460963 //w=0.301 //l=1.11 //layer=m1 \
 //thickness=0.36 //x=1.85 //y=0 //x2=2.96 //y2=0
r303 (  7 25 ) resistor r=0.0287885 //w=0.34 //l=0.085 //layer=m1 \
 //thickness=0.36 //x=1.265 //y=0 //x2=1.18 //y2=0
r304 (  7 9 ) resistor r=0.24294 //w=0.301 //l=0.585 //layer=m1 \
 //thickness=0.36 //x=1.265 //y=0 //x2=1.85 //y2=0
r305 (  5 25 ) resistor r=0.0401957 //w=0.68 //l=0.17 //layer=m1 \
 //thickness=0.36 //x=1.18 //y=0.17 //x2=1.18 //y2=0
r306 (  5 23 ) resistor r=0.625 //w=0.131 //l=0.655 //layer=m1 \
 //thickness=0.36 //x=1.18 //y=0.17 //x2=1.18 //y2=0.825
r307 (  3 31 ) resistor r=3.1 //w=0.17 //l=0.51 //layer=mcon //count=3 \
 //x=0.74 //y=0 //x2=0.74 //y2=0
r308 (  1 25 ) resistor r=0.0287885 //w=0.34 //l=0.085 //layer=m1 \
 //thickness=0.36 //x=1.095 //y=0 //x2=1.18 //y2=0
r309 (  1 3 ) resistor r=0.147425 //w=0.301 //l=0.355 //layer=m1 \
 //thickness=0.36 //x=1.095 //y=0 //x2=0.74 //y2=0
ends PM_AO3X1_PCELL\%noxref_5

subckt PM_AO3X1_PCELL\%noxref_6 ( 2 4 10 15 19 20 21 22 23 24 29 31 33 39 40 \
 42 43 46 )
c104 ( 46 0 ) capacitor c=0.0393541f //x=1.88 //y=4.7
c105 ( 43 0 ) capacitor c=0.0284095f //x=1.85 //y=1.915
c106 ( 42 0 ) capacitor c=0.0476356f //x=1.85 //y=2.08
c107 ( 40 0 ) capacitor c=0.0439708f //x=2.415 //y=1.25
c108 ( 39 0 ) capacitor c=0.0192582f //x=2.415 //y=0.905
c109 ( 33 0 ) capacitor c=0.0162526f //x=2.26 //y=1.405
c110 ( 31 0 ) capacitor c=0.0157807f //x=2.26 //y=0.75
c111 ( 29 0 ) capacitor c=0.0372668f //x=2.255 //y=4.79
c112 ( 24 0 ) capacitor c=0.0210762f //x=1.885 //y=1.56
c113 ( 23 0 ) capacitor c=0.0168511f //x=1.885 //y=1.25
c114 ( 22 0 ) capacitor c=0.0175485f //x=1.885 //y=0.905
c115 ( 21 0 ) capacitor c=0.155269f //x=2.33 //y=6.02
c116 ( 20 0 ) capacitor c=0.110375f //x=1.89 //y=6.02
c117 ( 15 0 ) capacitor c=8.9038e-19 //x=1.88 //y=4.7
c118 ( 10 0 ) capacitor c=7.72439e-19 //x=1.85 //y=2.08
c119 ( 4 0 ) capacitor c=0.00687137f //x=1.85 //y=2.08
c120 ( 2 0 ) capacitor c=0.0640231f //x=1.85 //y=4.555
r121 (  48 49 ) resistor r=32.4568 //w=0.214 //l=0.075 //layer=ply \
 //thickness=0.18 //x=1.88 //y=4.79 //x2=1.88 //y2=4.865
r122 (  46 48 ) resistor r=20.271 //w=0.214 //l=0.09 //layer=ply \
 //thickness=0.18 //x=1.88 //y=4.7 //x2=1.88 //y2=4.79
r123 (  42 43 ) resistor r=52.7279 //w=0.214 //l=0.165 //layer=ply \
 //thickness=0.18 //x=1.85 //y=2.08 //x2=1.85 //y2=1.915
r124 (  40 53 ) resistor r=45.1352 //w=0.168 //l=0.173853 //layer=ply \
 //thickness=0.18 //x=2.415 //y=1.25 //x2=2.375 //y2=1.405
r125 (  39 52 ) resistor r=45.1352 //w=0.168 //l=0.173853 //layer=ply \
 //thickness=0.18 //x=2.415 //y=0.905 //x2=2.375 //y2=0.75
r126 (  39 40 ) resistor r=176.904 //w=0.094 //l=0.345 //layer=ply \
 //thickness=0.18 //x=2.415 //y=0.905 //x2=2.415 //y2=1.25
r127 (  34 51 ) resistor r=10.701 //w=0.21 //l=0.115 //layer=ply \
 //thickness=0.18 //x=2.04 //y=1.405 //x2=1.925 //y2=1.405
r128 (  33 53 ) resistor r=5.52526 //w=0.168 //l=0.115 //layer=ply \
 //thickness=0.18 //x=2.26 //y=1.405 //x2=2.375 //y2=1.405
r129 (  32 50 ) resistor r=5.52526 //w=0.168 //l=0.115 //layer=ply \
 //thickness=0.18 //x=2.04 //y=0.75 //x2=1.925 //y2=0.75
r130 (  31 52 ) resistor r=5.52526 //w=0.168 //l=0.115 //layer=ply \
 //thickness=0.18 //x=2.26 //y=0.75 //x2=2.375 //y2=0.75
r131 (  31 32 ) resistor r=112.809 //w=0.094 //l=0.22 //layer=ply \
 //thickness=0.18 //x=2.26 //y=0.75 //x2=2.04 //y2=0.75
r132 (  30 48 ) resistor r=16.5046 //w=0.27 //l=0.135 //layer=ply \
 //thickness=0.18 //x=2.015 //y=4.79 //x2=1.88 //y2=4.79
r133 (  29 36 ) resistor r=26.9307 //w=0.15 //l=0.106066 //layer=ply \
 //thickness=0.18 //x=2.255 //y=4.79 //x2=2.33 //y2=4.865
r134 (  29 30 ) resistor r=123.064 //w=0.094 //l=0.24 //layer=ply \
 //thickness=0.18 //x=2.255 //y=4.79 //x2=2.015 //y2=4.79
r135 (  24 51 ) resistor r=39.5823 //w=0.21 //l=0.173853 //layer=ply \
 //thickness=0.18 //x=1.885 //y=1.56 //x2=1.925 //y2=1.405
r136 (  24 43 ) resistor r=182.032 //w=0.094 //l=0.355 //layer=ply \
 //thickness=0.18 //x=1.885 //y=1.56 //x2=1.885 //y2=1.915
r137 (  23 51 ) resistor r=39.5823 //w=0.21 //l=0.173853 //layer=ply \
 //thickness=0.18 //x=1.885 //y=1.25 //x2=1.925 //y2=1.405
r138 (  22 50 ) resistor r=45.1352 //w=0.168 //l=0.173853 //layer=ply \
 //thickness=0.18 //x=1.885 //y=0.905 //x2=1.925 //y2=0.75
r139 (  22 23 ) resistor r=176.904 //w=0.094 //l=0.345 //layer=ply \
 //thickness=0.18 //x=1.885 //y=0.905 //x2=1.885 //y2=1.25
r140 (  21 36 ) resistor r=592.245 //w=0.094 //l=1.155 //layer=ply \
 //thickness=0.18 //x=2.33 //y=6.02 //x2=2.33 //y2=4.865
r141 (  20 49 ) resistor r=592.245 //w=0.094 //l=1.155 //layer=ply \
 //thickness=0.18 //x=1.89 //y=6.02 //x2=1.89 //y2=4.865
r142 (  19 33 ) resistor r=56.4043 //w=0.094 //l=0.11 //layer=ply \
 //thickness=0.18 //x=2.15 //y=1.405 //x2=2.26 //y2=1.405
r143 (  19 34 ) resistor r=56.4043 //w=0.094 //l=0.11 //layer=ply \
 //thickness=0.18 //x=2.15 //y=1.405 //x2=2.04 //y2=1.405
r144 (  15 46 ) resistor r=152 //w=0.17 //l=0.17 //layer=licon //count=1 \
 //x=1.88 //y=4.7 //x2=1.88 //y2=4.7
r145 (  10 42 ) resistor r=152 //w=0.17 //l=0.17 //layer=licon //count=1 \
 //x=1.85 //y=2.08 //x2=1.85 //y2=2.08
r146 (  8 15 ) resistor r=9.3 //w=0.17 //l=0.17 //layer=mcon //count=1 \
 //x=1.88 //y=4.7 //x2=1.88 //y2=4.7
r147 (  4 10 ) resistor r=9.3 //w=0.17 //l=0.17 //layer=mcon //count=1 \
 //x=1.85 //y=2.08 //x2=1.85 //y2=2.08
r148 (  4 6 ) resistor r=0.0936408 //w=0.196 //l=0.125 //layer=m1 \
 //thickness=0.36 //x=1.852 //y=2.08 //x2=1.852 //y2=2.205
r149 (  2 8 ) resistor r=0.0878548 //w=0.228 //l=0.159295 //layer=m1 \
 //thickness=0.36 //x=1.85 //y=4.555 //x2=1.88 //y2=4.7
r150 (  2 6 ) resistor r=2.24237 //w=0.131 //l=2.35 //layer=m1 \
 //thickness=0.36 //x=1.85 //y=4.555 //x2=1.85 //y2=2.205
ends PM_AO3X1_PCELL\%noxref_6

subckt PM_AO3X1_PCELL\%noxref_7 ( 1 3 5 10 14 17 20 30 46 47 48 )
c95 ( 48 0 ) capacitor c=0.0353235f //x=5.735 //y=5.025
c96 ( 46 0 ) capacitor c=0.0118024f //x=3.985 //y=5.025
c97 ( 30 0 ) capacitor c=0.0303001f //x=5 //y=5.38
c98 ( 20 0 ) capacitor c=0.045655f //x=4.12 //y=5.38
c99 ( 17 0 ) capacitor c=0.0164155f //x=5.88 //y=6.74
c100 ( 14 0 ) capacitor c=0.00604334f //x=5 //y=6.74
c101 ( 10 0 ) capacitor c=0.0111807f //x=5 //y=5.21
c102 ( 5 0 ) capacitor c=0.012947f //x=4.12 //y=5.21
c103 ( 3 0 ) capacitor c=0.00694548f //x=5.75 //y=6.91
c104 ( 1 0 ) capacitor c=0.0131347f //x=4.88 //y=5.21
r105 (  37 47 ) resistor r=23.2727 //w=0.187 //l=0.34 //layer=li \
 //thickness=0.1 //x=5 //y=6.74 //x2=5 //y2=6.4
r106 (  30 47 ) resistor r=23.2727 //w=0.187 //l=0.34 //layer=li \
 //thickness=0.1 //x=5 //y=5.38 //x2=5 //y2=5.72
r107 (  20 46 ) resistor r=23.2727 //w=0.187 //l=0.34 //layer=li \
 //thickness=0.1 //x=4.12 //y=5.38 //x2=4.12 //y2=5.72
r108 (  17 48 ) resistor r=9.3 //w=0.17 //l=0.17 //layer=mcon //count=1 \
 //x=5.88 //y=6.74 //x2=5.88 //y2=6.74
r109 (  17 18 ) resistor r=0.0932018 //w=0.228 //l=0.17 //layer=m1 \
 //thickness=0.36 //x=5.872 //y=6.74 //x2=5.872 //y2=6.91
r110 (  14 37 ) resistor r=9.3 //w=0.17 //l=0.17 //layer=mcon //count=1 //x=5 \
 //y=6.74 //x2=5 //y2=6.74
r111 (  14 15 ) resistor r=0.0992991 //w=0.214 //l=0.17 //layer=m1 \
 //thickness=0.36 //x=5 //y=6.74 //x2=5 //y2=6.91
r112 (  12 30 ) resistor r=9.3 //w=0.17 //l=0.17 //layer=mcon //count=1 //x=5 \
 //y=5.38 //x2=5 //y2=5.38
r113 (  10 12 ) resistor r=0.097032 //w=0.219 //l=0.17 //layer=m1 \
 //thickness=0.36 //x=5 //y=5.21 //x2=5 //y2=5.38
r114 (  7 20 ) resistor r=9.3 //w=0.17 //l=0.17 //layer=mcon //count=1 \
 //x=4.12 //y=5.38 //x2=4.12 //y2=5.38
r115 (  5 7 ) resistor r=0.0997653 //w=0.213 //l=0.17 //layer=m1 \
 //thickness=0.36 //x=4.12 //y=5.21 //x2=4.12 //y2=5.38
r116 (  4 15 ) resistor r=0.0213909 //w=0.214 //l=0.115 //layer=m1 \
 //thickness=0.36 //x=5.115 //y=6.91 //x2=5 //y2=6.91
r117 (  3 18 ) resistor r=0.0251868 //w=0.228 //l=0.122 //layer=m1 \
 //thickness=0.36 //x=5.75 //y=6.91 //x2=5.872 //y2=6.91
r118 (  3 4 ) resistor r=0.605916 //w=0.131 //l=0.635 //layer=m1 \
 //thickness=0.36 //x=5.75 //y=6.91 //x2=5.115 //y2=6.91
r119 (  2 5 ) resistor r=0.0211096 //w=0.213 //l=0.115 //layer=m1 \
 //thickness=0.36 //x=4.235 //y=5.21 //x2=4.12 //y2=5.21
r120 (  1 10 ) resistor r=0.0227762 //w=0.219 //l=0.12 //layer=m1 \
 //thickness=0.36 //x=4.88 //y=5.21 //x2=5 //y2=5.21
r121 (  1 2 ) resistor r=0.615458 //w=0.131 //l=0.645 //layer=m1 \
 //thickness=0.36 //x=4.88 //y=5.21 //x2=4.235 //y2=5.21
ends PM_AO3X1_PCELL\%noxref_7

subckt PM_AO3X1_PCELL\%noxref_8 ( 4 8 9 12 17 21 22 23 24 25 26 31 33 35 41 42 \
 44 45 48 )
c119 ( 48 0 ) capacitor c=0.0404287f //x=5.215 //y=4.705
c120 ( 45 0 ) capacitor c=0.0292709f //x=5.18 //y=1.915
c121 ( 44 0 ) capacitor c=0.0468503f //x=5.18 //y=2.08
c122 ( 42 0 ) capacitor c=0.0237765f //x=5.745 //y=1.255
c123 ( 41 0 ) capacitor c=0.0191782f //x=5.745 //y=0.905
c124 ( 35 0 ) capacitor c=0.035988f //x=5.59 //y=1.405
c125 ( 33 0 ) capacitor c=0.0157803f //x=5.59 //y=0.75
c126 ( 31 0 ) capacitor c=0.0367203f //x=5.585 //y=4.795
c127 ( 26 0 ) capacitor c=0.0206674f //x=5.215 //y=1.56
c128 ( 25 0 ) capacitor c=0.0169638f //x=5.215 //y=1.255
c129 ( 24 0 ) capacitor c=0.0185462f //x=5.215 //y=0.905
c130 ( 23 0 ) capacitor c=0.155887f //x=5.66 //y=6.025
c131 ( 22 0 ) capacitor c=0.110534f //x=5.22 //y=6.025
c132 ( 17 0 ) capacitor c=0.00113117f //x=5.215 //y=4.705
c133 ( 12 0 ) capacitor c=9.45497e-19 //x=5.18 //y=2.08
c134 ( 9 0 ) capacitor c=0.0570424f //x=5.215 //y=4.56
c135 ( 8 0 ) capacitor c=0.0061903f //x=5.215 //y=4.705
c136 ( 4 0 ) capacitor c=0.00573992f //x=5.18 //y=2.08
r137 (  50 51 ) resistor r=32.4568 //w=0.214 //l=0.075 //layer=ply \
 //thickness=0.18 //x=5.215 //y=4.795 //x2=5.215 //y2=4.87
r138 (  48 50 ) resistor r=20.271 //w=0.214 //l=0.09 //layer=ply \
 //thickness=0.18 //x=5.215 //y=4.705 //x2=5.215 //y2=4.795
r139 (  44 45 ) resistor r=52.7279 //w=0.214 //l=0.165 //layer=ply \
 //thickness=0.18 //x=5.18 //y=2.08 //x2=5.18 //y2=1.915
r140 (  42 55 ) resistor r=4.95774 //w=0.164 //l=0.112 //layer=ply \
 //thickness=0.18 //x=5.745 //y=1.255 //x2=5.745 //y2=1.367
r141 (  41 54 ) resistor r=45.1352 //w=0.168 //l=0.173853 //layer=ply \
 //thickness=0.18 //x=5.745 //y=0.905 //x2=5.705 //y2=0.75
r142 (  41 42 ) resistor r=179.468 //w=0.094 //l=0.35 //layer=ply \
 //thickness=0.18 //x=5.745 //y=0.905 //x2=5.745 //y2=1.255
r143 (  36 53 ) resistor r=10.8103 //w=0.211 //l=0.115 //layer=ply \
 //thickness=0.18 //x=5.37 //y=1.405 //x2=5.255 //y2=1.405
r144 (  35 55 ) resistor r=45.9962 //w=0.164 //l=0.17296 //layer=ply \
 //thickness=0.18 //x=5.59 //y=1.405 //x2=5.745 //y2=1.367
r145 (  34 52 ) resistor r=5.52526 //w=0.168 //l=0.115 //layer=ply \
 //thickness=0.18 //x=5.37 //y=0.75 //x2=5.255 //y2=0.75
r146 (  33 54 ) resistor r=5.52526 //w=0.168 //l=0.115 //layer=ply \
 //thickness=0.18 //x=5.59 //y=0.75 //x2=5.705 //y2=0.75
r147 (  33 34 ) resistor r=112.809 //w=0.094 //l=0.22 //layer=ply \
 //thickness=0.18 //x=5.59 //y=0.75 //x2=5.37 //y2=0.75
r148 (  32 50 ) resistor r=16.5046 //w=0.27 //l=0.135 //layer=ply \
 //thickness=0.18 //x=5.35 //y=4.795 //x2=5.215 //y2=4.795
r149 (  31 38 ) resistor r=26.9307 //w=0.15 //l=0.106066 //layer=ply \
 //thickness=0.18 //x=5.585 //y=4.795 //x2=5.66 //y2=4.87
r150 (  31 32 ) resistor r=120.5 //w=0.094 //l=0.235 //layer=ply \
 //thickness=0.18 //x=5.585 //y=4.795 //x2=5.35 //y2=4.795
r151 (  26 53 ) resistor r=39.5036 //w=0.211 //l=0.173853 //layer=ply \
 //thickness=0.18 //x=5.215 //y=1.56 //x2=5.255 //y2=1.405
r152 (  26 45 ) resistor r=182.032 //w=0.094 //l=0.355 //layer=ply \
 //thickness=0.18 //x=5.215 //y=1.56 //x2=5.215 //y2=1.915
r153 (  25 53 ) resistor r=38.3614 //w=0.211 //l=0.168819 //layer=ply \
 //thickness=0.18 //x=5.215 //y=1.255 //x2=5.255 //y2=1.405
r154 (  24 52 ) resistor r=45.1352 //w=0.168 //l=0.173853 //layer=ply \
 //thickness=0.18 //x=5.215 //y=0.905 //x2=5.255 //y2=0.75
r155 (  24 25 ) resistor r=179.468 //w=0.094 //l=0.35 //layer=ply \
 //thickness=0.18 //x=5.215 //y=0.905 //x2=5.215 //y2=1.255
r156 (  23 38 ) resistor r=592.245 //w=0.094 //l=1.155 //layer=ply \
 //thickness=0.18 //x=5.66 //y=6.025 //x2=5.66 //y2=4.87
r157 (  22 51 ) resistor r=592.245 //w=0.094 //l=1.155 //layer=ply \
 //thickness=0.18 //x=5.22 //y=6.025 //x2=5.22 //y2=4.87
r158 (  21 35 ) resistor r=56.4043 //w=0.094 //l=0.11 //layer=ply \
 //thickness=0.18 //x=5.48 //y=1.405 //x2=5.59 //y2=1.405
r159 (  21 36 ) resistor r=56.4043 //w=0.094 //l=0.11 //layer=ply \
 //thickness=0.18 //x=5.48 //y=1.405 //x2=5.37 //y2=1.405
r160 (  17 48 ) resistor r=152 //w=0.17 //l=0.17 //layer=licon //count=1 \
 //x=5.215 //y=4.705 //x2=5.215 //y2=4.705
r161 (  12 44 ) resistor r=152 //w=0.17 //l=0.17 //layer=licon //count=1 \
 //x=5.18 //y=2.08 //x2=5.18 //y2=2.08
r162 (  8 17 ) resistor r=9.3 //w=0.17 //l=0.17 //layer=mcon //count=1 \
 //x=5.215 //y=4.705 //x2=5.215 //y2=4.705
r163 (  8 9 ) resistor r=0.105739 //w=0.201 //l=0.145 //layer=m1 \
 //thickness=0.36 //x=5.215 //y=4.705 //x2=5.215 //y2=4.56
r164 (  6 9 ) resistor r=2.2376 //w=0.131 //l=2.345 //layer=m1 \
 //thickness=0.36 //x=5.18 //y=2.215 //x2=5.18 //y2=4.56
r165 (  4 12 ) resistor r=9.3 //w=0.17 //l=0.17 //layer=mcon //count=1 \
 //x=5.18 //y=2.08 //x2=5.18 //y2=2.08
r166 (  4 6 ) resistor r=0.0977888 //w=0.216 //l=0.135 //layer=m1 \
 //thickness=0.36 //x=5.177 //y=2.08 //x2=5.177 //y2=2.215
ends PM_AO3X1_PCELL\%noxref_8

subckt PM_AO3X1_PCELL\%noxref_9 ( 2 4 5 6 7 8 10 12 22 29 31 )
c81 ( 29 0 ) capacitor c=0.00869746f //x=7.585 //y=0.91
c82 ( 22 0 ) capacitor c=0.0261959f //x=7.775 //y=5.38
c83 ( 12 0 ) capacitor c=0.0191272f //x=7.77 //y=1.005
c84 ( 10 0 ) capacitor c=0.117162f //x=8.14 //y=4.875
c85 ( 8 0 ) capacitor c=0.00557311f //x=7.86 //y=4.96
c86 ( 7 0 ) capacitor c=0.00944012f //x=8.055 //y=4.96
c87 ( 6 0 ) capacitor c=0.00724565f //x=7.855 //y=1.84
c88 ( 5 0 ) capacitor c=0.0145753f //x=8.055 //y=1.84
c89 ( 4 0 ) capacitor c=0.0117594f //x=7.775 //y=5.24
c90 ( 2 0 ) capacitor c=0.0170096f //x=7.77 //y=1.755
r91 (  22 31 ) resistor r=23.615 //w=0.187 //l=0.345 //layer=li \
 //thickness=0.1 //x=7.775 //y=5.38 //x2=7.775 //y2=5.725
r92 (  15 22 ) resistor r=9.3 //w=0.17 //l=0.17 //layer=mcon //count=1 \
 //x=7.775 //y=5.38 //x2=7.775 //y2=5.38
r93 (  12 29 ) resistor r=9.3 //w=0.17 //l=0.17 //layer=mcon //count=1 \
 //x=7.77 //y=1.005 //x2=7.77 //y2=1.005
r94 (  9 10 ) resistor r=2.81489 //w=0.131 //l=2.95 //layer=m1 \
 //thickness=0.36 //x=8.14 //y=1.925 //x2=8.14 //y2=4.875
r95 (  7 10 ) resistor r=0.0698411 //w=0.17 //l=0.120208 //layer=m1 \
 //thickness=0.36 //x=8.055 //y=4.96 //x2=8.14 //y2=4.875
r96 (  7 8 ) resistor r=0.186069 //w=0.131 //l=0.195 //layer=m1 \
 //thickness=0.36 //x=8.055 //y=4.96 //x2=7.86 //y2=4.96
r97 (  5 9 ) resistor r=0.0698411 //w=0.17 //l=0.120208 //layer=m1 \
 //thickness=0.36 //x=8.055 //y=1.84 //x2=8.14 //y2=1.925
r98 (  5 6 ) resistor r=0.19084 //w=0.131 //l=0.2 //layer=m1 //thickness=0.36 \
 //x=8.055 //y=1.84 //x2=7.855 //y2=1.84
r99 (  4 15 ) resistor r=0.086672 //w=0.218 //l=0.14 //layer=m1 \
 //thickness=0.36 //x=7.775 //y=5.24 //x2=7.775 //y2=5.38
r100 (  3 8 ) resistor r=0.0698411 //w=0.17 //l=0.120208 //layer=m1 \
 //thickness=0.36 //x=7.775 //y=5.045 //x2=7.86 //y2=4.96
r101 (  3 4 ) resistor r=0.186069 //w=0.131 //l=0.195 //layer=m1 \
 //thickness=0.36 //x=7.775 //y=5.045 //x2=7.775 //y2=5.24
r102 (  2 6 ) resistor r=0.0698411 //w=0.17 //l=0.120208 //layer=m1 \
 //thickness=0.36 //x=7.77 //y=1.755 //x2=7.855 //y2=1.84
r103 (  1 12 ) resistor r=0.105739 //w=0.201 //l=0.145 //layer=m1 \
 //thickness=0.36 //x=7.77 //y=1.15 //x2=7.77 //y2=1.005
r104 (  1 2 ) resistor r=0.57729 //w=0.131 //l=0.605 //layer=m1 \
 //thickness=0.36 //x=7.77 //y=1.15 //x2=7.77 //y2=1.755
ends PM_AO3X1_PCELL\%noxref_9

subckt PM_AO3X1_PCELL\%noxref_10 ( 1 5 9 10 13 17 29 )
c61 ( 29 0 ) capacitor c=0.0672377f //x=0.56 //y=0.365
c62 ( 17 0 ) capacitor c=0.00709791f //x=2.635 //y=0.615
c63 ( 13 0 ) capacitor c=0.0157877f //x=2.55 //y=0.53
c64 ( 10 0 ) capacitor c=0.00963509f //x=1.665 //y=1.495
c65 ( 9 0 ) capacitor c=0.00770028f //x=1.665 //y=0.615
c66 ( 5 0 ) capacitor c=0.024493f //x=1.58 //y=1.58
c67 ( 1 0 ) capacitor c=0.0115037f //x=0.695 //y=1.495
r68 (  17 29 ) resistor r=3.57586 //w=0.17 //l=0.125 //layer=li \
 //thickness=0.1 //x=2.635 //y=0.615 //x2=2.635 //y2=0.49
r69 (  17 29 ) resistor r=18.139 //w=0.187 //l=0.265 //layer=li \
 //thickness=0.1 //x=2.635 //y=0.615 //x2=2.635 //y2=0.88
r70 (  14 29 ) resistor r=3.57586 //w=0.17 //l=0.103078 //layer=li \
 //thickness=0.1 //x=1.75 //y=0.53 //x2=1.665 //y2=0.49
r71 (  14 29 ) resistor r=27.3797 //w=0.187 //l=0.4 //layer=li //thickness=0.1 \
 //x=1.75 //y=0.53 //x2=2.15 //y2=0.53
r72 (  13 29 ) resistor r=3.57586 //w=0.17 //l=0.103078 //layer=li \
 //thickness=0.1 //x=2.55 //y=0.53 //x2=2.635 //y2=0.49
r73 (  13 29 ) resistor r=27.3797 //w=0.187 //l=0.4 //layer=li //thickness=0.1 \
 //x=2.55 //y=0.53 //x2=2.15 //y2=0.53
r74 (  10 29 ) resistor r=3.57586 //w=0.17 //l=0.125 //layer=li \
 //thickness=0.1 //x=1.665 //y=1.495 //x2=1.665 //y2=1.62
r75 (  10 29 ) resistor r=42.0963 //w=0.187 //l=0.615 //layer=li \
 //thickness=0.1 //x=1.665 //y=1.495 //x2=1.665 //y2=0.88
r76 (  9 29 ) resistor r=3.57586 //w=0.17 //l=0.125 //layer=li //thickness=0.1 \
 //x=1.665 //y=0.615 //x2=1.665 //y2=0.49
r77 (  9 29 ) resistor r=18.139 //w=0.187 //l=0.265 //layer=li //thickness=0.1 \
 //x=1.665 //y=0.615 //x2=1.665 //y2=0.88
r78 (  6 29 ) resistor r=3.57586 //w=0.17 //l=0.103078 //layer=li \
 //thickness=0.1 //x=0.78 //y=1.58 //x2=0.695 //y2=1.62
r79 (  6 29 ) resistor r=27.3797 //w=0.187 //l=0.4 //layer=li //thickness=0.1 \
 //x=0.78 //y=1.58 //x2=1.18 //y2=1.58
r80 (  5 29 ) resistor r=3.57586 //w=0.17 //l=0.103078 //layer=li \
 //thickness=0.1 //x=1.58 //y=1.58 //x2=1.665 //y2=1.62
r81 (  5 29 ) resistor r=27.3797 //w=0.187 //l=0.4 //layer=li //thickness=0.1 \
 //x=1.58 //y=1.58 //x2=1.18 //y2=1.58
r82 (  1 29 ) resistor r=3.57586 //w=0.17 //l=0.125 //layer=li //thickness=0.1 \
 //x=0.695 //y=1.495 //x2=0.695 //y2=1.62
r83 (  1 29 ) resistor r=42.0963 //w=0.187 //l=0.615 //layer=li \
 //thickness=0.1 //x=0.695 //y=1.495 //x2=0.695 //y2=0.88
ends PM_AO3X1_PCELL\%noxref_10
