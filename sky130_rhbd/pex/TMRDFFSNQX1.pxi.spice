// File: TMRDFFSNQX1.spi.TMRDFFSNQX1.pxi
// Created: Sun Apr 12 08:37:09 2026
//
simulator lang=spectre
x_PM_TMRDFFSNQX1\%noxref_1 ( N_noxref_1_c_16_p N_noxref_1_c_68_p \
 N_noxref_1_c_63_p N_noxref_1_c_26_p N_noxref_1_c_17_p N_noxref_1_c_9_p \
 N_noxref_1_c_10_p N_noxref_1_c_11_p N_noxref_1_c_154_p N_noxref_1_c_12_p \
 N_noxref_1_c_122_p N_noxref_1_c_13_p N_noxref_1_c_29_p N_noxref_1_c_30_p \
 N_noxref_1_c_31_p N_noxref_1_c_32_p N_noxref_1_c_108_p N_noxref_1_c_19_p \
 N_noxref_1_c_234_p N_noxref_1_c_66_p N_noxref_1_c_14_p N_noxref_1_c_150_p \
 N_noxref_1_c_5_p N_noxref_1_c_47_p N_noxref_1_c_15_p N_noxref_1_c_125_p \
 N_noxref_1_c_33_p N_noxref_1_c_25_p N_noxref_1_c_110_p N_noxref_1_c_20_p \
 N_noxref_1_c_153_p N_noxref_1_c_159_p N_noxref_1_c_197_p N_noxref_1_c_194_p \
 N_noxref_1_M2_noxref_g N_noxref_1_M5_noxref_g N_noxref_1_M56_noxref_g \
 N_noxref_1_M57_noxref_g N_noxref_1_M62_noxref_g N_noxref_1_M63_noxref_g \
 N_noxref_1_c_175_p N_noxref_1_c_176_p N_noxref_1_c_178_p N_noxref_1_c_157_p \
 N_noxref_1_c_301_p N_noxref_1_c_318_p N_noxref_1_c_177_p N_noxref_1_c_179_p \
 N_noxref_1_c_43_p N_noxref_1_c_161_p N_noxref_1_c_215_p N_noxref_1_c_216_p \
 N_noxref_1_c_218_p N_noxref_1_c_198_p N_noxref_1_c_305_p N_noxref_1_c_329_p \
 N_noxref_1_c_217_p N_noxref_1_c_219_p N_noxref_1_c_4_p N_noxref_1_c_202_p \
 N_noxref_1_M1_noxref_d N_noxref_1_M52_noxref_d N_noxref_1_M54_noxref_d )  \
 PM_TMRDFFSNQX1\%noxref_1
x_PM_TMRDFFSNQX1\%noxref_2 ( N_noxref_2_c_414_n N_noxref_2_c_435_p \
 N_noxref_2_c_452_p N_noxref_2_c_436_p N_noxref_2_c_460_p N_noxref_2_c_444_p \
 N_noxref_2_c_445_p N_noxref_2_c_424_p N_noxref_2_c_427_p N_noxref_2_c_429_p \
 N_noxref_2_c_425_p N_noxref_2_c_431_p N_noxref_2_c_454_p N_noxref_2_c_415_n \
 N_noxref_2_c_537_p N_noxref_2_c_440_p N_noxref_2_c_418_n N_noxref_2_c_523_p \
 N_noxref_2_c_527_p N_noxref_2_c_455_p N_noxref_2_c_426_p N_noxref_2_c_434_p \
 N_noxref_2_c_515_p N_noxref_2_c_464_p N_noxref_2_c_419_n N_noxref_2_c_571_p \
 N_noxref_2_c_442_p N_noxref_2_c_526_p N_noxref_2_c_456_p \
 N_noxref_2_M8_noxref_g N_noxref_2_M68_noxref_g N_noxref_2_M69_noxref_g \
 N_noxref_2_c_550_p N_noxref_2_c_551_p N_noxref_2_c_553_p N_noxref_2_c_529_p \
 N_noxref_2_c_668_p N_noxref_2_c_669_p N_noxref_2_c_552_p N_noxref_2_c_554_p \
 N_noxref_2_c_459_p N_noxref_2_M7_noxref_d N_noxref_2_M62_noxref_d \
 N_noxref_2_M64_noxref_d N_noxref_2_M66_noxref_d )  PM_TMRDFFSNQX1\%noxref_2
x_PM_TMRDFFSNQX1\%noxref_3 ( N_noxref_3_c_711_n N_noxref_3_c_718_n \
 N_noxref_3_c_723_n N_noxref_3_c_726_n N_noxref_3_c_868_p N_noxref_3_c_794_n \
 N_noxref_3_c_795_n N_noxref_3_c_727_n N_noxref_3_c_728_n N_noxref_3_c_796_n \
 N_noxref_3_c_729_n N_noxref_3_c_731_n N_noxref_3_c_737_n N_noxref_3_c_738_n \
 N_noxref_3_c_800_p N_noxref_3_c_802_p N_noxref_3_c_739_n N_noxref_3_c_740_n \
 N_noxref_3_c_741_n N_noxref_3_c_964_p N_noxref_3_c_822_p N_noxref_3_c_829_p \
 N_noxref_3_c_808_p N_noxref_3_c_836_p N_noxref_3_c_803_p N_noxref_3_c_801_p \
 N_noxref_3_c_746_n N_noxref_3_c_751_n N_noxref_3_c_752_n N_noxref_3_c_809_p \
 N_noxref_3_c_755_n N_noxref_3_c_756_n N_noxref_3_c_757_n N_noxref_3_c_759_n \
 N_noxref_3_c_966_p N_noxref_3_c_832_p N_noxref_3_c_1005_p N_noxref_3_c_804_p \
 N_noxref_3_M1_noxref_g N_noxref_3_M10_noxref_g N_noxref_3_M54_noxref_g \
 N_noxref_3_M55_noxref_g N_noxref_3_M72_noxref_g N_noxref_3_M73_noxref_g \
 N_noxref_3_c_768_n N_noxref_3_c_770_n N_noxref_3_c_773_n N_noxref_3_c_774_n \
 N_noxref_3_c_777_n N_noxref_3_c_779_n N_noxref_3_c_783_n N_noxref_3_c_785_n \
 N_noxref_3_c_1033_p N_noxref_3_c_1034_p N_noxref_3_c_1036_p \
 N_noxref_3_c_1006_p N_noxref_3_c_1148_p N_noxref_3_c_1149_p \
 N_noxref_3_c_1035_p N_noxref_3_c_1037_p N_noxref_3_c_789_n N_noxref_3_c_790_n \
 N_noxref_3_c_792_n N_noxref_3_c_807_p N_noxref_3_M4_noxref_d \
 N_noxref_3_M56_noxref_d N_noxref_3_M58_noxref_d N_noxref_3_M60_noxref_d )  \
 PM_TMRDFFSNQX1\%noxref_3
x_PM_TMRDFFSNQX1\%noxref_4 ( N_noxref_4_c_1199_n N_noxref_4_c_1216_p \
 N_noxref_4_c_1237_p N_noxref_4_c_1320_p N_noxref_4_c_1218_p \
 N_noxref_4_c_1200_n N_noxref_4_c_1227_p N_noxref_4_c_1201_n \
 N_noxref_4_c_1261_p N_noxref_4_c_1221_p N_noxref_4_c_1229_p \
 N_noxref_4_c_1222_p N_noxref_4_c_1202_n N_noxref_4_c_1240_p \
 N_noxref_4_c_1377_p N_noxref_4_c_1225_p N_noxref_4_c_1208_n \
 N_noxref_4_c_1258_p N_noxref_4_c_1209_n N_noxref_4_c_1231_p \
 N_noxref_4_c_1232_p N_noxref_4_c_1210_n N_noxref_4_c_1310_p \
 N_noxref_4_c_1263_p N_noxref_4_c_1260_p N_noxref_4_M12_noxref_g \
 N_noxref_4_M76_noxref_g N_noxref_4_M77_noxref_g N_noxref_4_c_1288_p \
 N_noxref_4_c_1289_p N_noxref_4_c_1291_p N_noxref_4_c_1264_p \
 N_noxref_4_c_1435_p N_noxref_4_c_1448_p N_noxref_4_c_1290_p \
 N_noxref_4_c_1292_p N_noxref_4_c_1267_p N_noxref_4_c_1252_p \
 N_noxref_4_M11_noxref_d N_noxref_4_M72_noxref_d N_noxref_4_M74_noxref_d )  \
 PM_TMRDFFSNQX1\%noxref_4
x_PM_TMRDFFSNQX1\%noxref_5 ( N_noxref_5_c_1491_n N_noxref_5_c_1492_n \
 N_noxref_5_c_1585_n N_noxref_5_c_1497_n N_noxref_5_c_1505_n \
 N_noxref_5_c_1499_n N_noxref_5_c_1513_n N_noxref_5_c_1501_n \
 N_noxref_5_c_1521_n N_noxref_5_c_1522_n N_noxref_5_c_1666_n \
 N_noxref_5_c_1667_n N_noxref_5_c_1523_n N_noxref_5_c_1524_n \
 N_noxref_5_c_1604_n N_noxref_5_c_1527_n N_noxref_5_c_1822_p \
 N_noxref_5_c_1670_n N_noxref_5_c_1743_p N_noxref_5_c_1671_n \
 N_noxref_5_c_1612_n N_noxref_5_c_1529_n N_noxref_5_c_1530_n \
 N_noxref_5_c_1672_n N_noxref_5_c_1673_n N_noxref_5_c_1538_n \
 N_noxref_5_c_1713_p N_noxref_5_c_1811_p N_noxref_5_c_1502_n \
 N_noxref_5_c_1615_n N_noxref_5_c_1503_n N_noxref_5_c_1621_n \
 N_noxref_5_c_1540_n N_noxref_5_c_1624_n N_noxref_5_c_1745_p \
 N_noxref_5_c_1626_n N_noxref_5_c_1630_n N_noxref_5_c_1631_n \
 N_noxref_5_c_1543_n N_noxref_5_c_1544_n N_noxref_5_c_1548_n \
 N_noxref_5_c_1726_p N_noxref_5_c_1824_p N_noxref_5_c_1814_p \
 N_noxref_5_M4_noxref_g N_noxref_5_M7_noxref_g N_noxref_5_M14_noxref_g \
 N_noxref_5_M60_noxref_g N_noxref_5_M61_noxref_g N_noxref_5_M66_noxref_g \
 N_noxref_5_M67_noxref_g N_noxref_5_M80_noxref_g N_noxref_5_M81_noxref_g \
 N_noxref_5_c_1641_n N_noxref_5_c_1643_n N_noxref_5_c_1646_n \
 N_noxref_5_c_1647_n N_noxref_5_c_1649_n N_noxref_5_c_1653_n \
 N_noxref_5_c_1655_n N_noxref_5_c_1559_n N_noxref_5_c_1561_n \
 N_noxref_5_c_1564_n N_noxref_5_c_1565_n N_noxref_5_c_1567_n \
 N_noxref_5_c_1571_n N_noxref_5_c_1573_n N_noxref_5_c_1869_p \
 N_noxref_5_c_1870_p N_noxref_5_c_1871_p N_noxref_5_c_1897_p \
 N_noxref_5_c_1898_p N_noxref_5_c_1899_p N_noxref_5_c_1900_p \
 N_noxref_5_c_1659_n N_noxref_5_c_1660_n N_noxref_5_c_1662_n \
 N_noxref_5_c_1577_n N_noxref_5_c_1578_n N_noxref_5_c_1580_n \
 N_noxref_5_c_1825_p N_noxref_5_c_1875_p N_noxref_5_c_1828_p \
 N_noxref_5_M9_noxref_d N_noxref_5_M68_noxref_d N_noxref_5_M70_noxref_d )  \
 PM_TMRDFFSNQX1\%noxref_5
x_PM_TMRDFFSNQX1\%noxref_6 ( N_noxref_6_c_2082_p N_noxref_6_c_2127_p \
 N_noxref_6_c_2122_p N_noxref_6_c_2091_p N_noxref_6_c_2083_p \
 N_noxref_6_c_2075_p N_noxref_6_c_2076_p N_noxref_6_c_2077_p \
 N_noxref_6_c_2204_p N_noxref_6_c_2078_p N_noxref_6_c_2173_p \
 N_noxref_6_c_2079_p N_noxref_6_c_2093_p N_noxref_6_c_2094_p \
 N_noxref_6_c_2095_p N_noxref_6_c_2096_p N_noxref_6_c_2164_p \
 N_noxref_6_c_2085_p N_noxref_6_c_2325_p N_noxref_6_c_2125_p \
 N_noxref_6_c_2080_p N_noxref_6_c_2200_p N_noxref_6_c_2071_p \
 N_noxref_6_c_2169_p N_noxref_6_c_2081_p N_noxref_6_c_2176_p \
 N_noxref_6_c_2097_p N_noxref_6_c_2098_p N_noxref_6_c_2166_p \
 N_noxref_6_c_2086_p N_noxref_6_c_2203_p N_noxref_6_c_2208_p \
 N_noxref_6_c_2245_p N_noxref_6_c_2252_p N_noxref_6_M17_noxref_g \
 N_noxref_6_M20_noxref_g N_noxref_6_M86_noxref_g N_noxref_6_M87_noxref_g \
 N_noxref_6_M92_noxref_g N_noxref_6_M93_noxref_g N_noxref_6_c_2229_p \
 N_noxref_6_c_2230_p N_noxref_6_c_2232_p N_noxref_6_c_2206_p \
 N_noxref_6_c_2386_p N_noxref_6_c_2401_p N_noxref_6_c_2231_p \
 N_noxref_6_c_2233_p N_noxref_6_c_2107_p N_noxref_6_c_2210_p \
 N_noxref_6_c_2293_p N_noxref_6_c_2294_p N_noxref_6_c_2296_p \
 N_noxref_6_c_2246_p N_noxref_6_c_2389_p N_noxref_6_c_2411_p \
 N_noxref_6_c_2295_p N_noxref_6_c_2297_p N_noxref_6_c_2070_p \
 N_noxref_6_c_2254_p N_noxref_6_M16_noxref_d N_noxref_6_M82_noxref_d \
 N_noxref_6_M84_noxref_d )  PM_TMRDFFSNQX1\%noxref_6
x_PM_TMRDFFSNQX1\%noxref_7 ( N_noxref_7_c_2489_n N_noxref_7_c_2510_p \
 N_noxref_7_c_2527_p N_noxref_7_c_2511_p N_noxref_7_c_2535_p \
 N_noxref_7_c_2519_p N_noxref_7_c_2520_p N_noxref_7_c_2499_p \
 N_noxref_7_c_2502_p N_noxref_7_c_2504_p N_noxref_7_c_2500_p \
 N_noxref_7_c_2506_p N_noxref_7_c_2529_p N_noxref_7_c_2490_n \
 N_noxref_7_c_2611_p N_noxref_7_c_2515_p N_noxref_7_c_2493_n \
 N_noxref_7_c_2597_p N_noxref_7_c_2601_p N_noxref_7_c_2530_p \
 N_noxref_7_c_2501_p N_noxref_7_c_2509_p N_noxref_7_c_2589_p \
 N_noxref_7_c_2585_p N_noxref_7_c_2494_n N_noxref_7_c_2645_p \
 N_noxref_7_c_2517_p N_noxref_7_c_2600_p N_noxref_7_c_2531_p \
 N_noxref_7_M23_noxref_g N_noxref_7_M98_noxref_g N_noxref_7_M99_noxref_g \
 N_noxref_7_c_2624_p N_noxref_7_c_2625_p N_noxref_7_c_2627_p \
 N_noxref_7_c_2603_p N_noxref_7_c_2746_p N_noxref_7_c_2747_p \
 N_noxref_7_c_2626_p N_noxref_7_c_2628_p N_noxref_7_c_2534_p \
 N_noxref_7_M22_noxref_d N_noxref_7_M92_noxref_d N_noxref_7_M94_noxref_d \
 N_noxref_7_M96_noxref_d )  PM_TMRDFFSNQX1\%noxref_7
x_PM_TMRDFFSNQX1\%noxref_8 ( N_noxref_8_c_2789_n N_noxref_8_c_2796_n \
 N_noxref_8_c_2801_n N_noxref_8_c_2804_n N_noxref_8_c_2938_p \
 N_noxref_8_c_2865_n N_noxref_8_c_2866_n N_noxref_8_c_2889_p \
 N_noxref_8_c_2805_n N_noxref_8_c_2867_n N_noxref_8_c_2806_n \
 N_noxref_8_c_2807_n N_noxref_8_c_2813_n N_noxref_8_c_2814_n \
 N_noxref_8_c_2871_p N_noxref_8_c_2874_p N_noxref_8_c_2815_n \
 N_noxref_8_c_2816_n N_noxref_8_c_2817_n N_noxref_8_c_3065_p \
 N_noxref_8_c_2892_p N_noxref_8_c_2899_p N_noxref_8_c_2971_p \
 N_noxref_8_c_2906_p N_noxref_8_c_2875_p N_noxref_8_c_2873_p \
 N_noxref_8_c_2822_n N_noxref_8_c_2824_n N_noxref_8_c_2825_n \
 N_noxref_8_c_2913_p N_noxref_8_c_2826_n N_noxref_8_c_2827_n \
 N_noxref_8_c_2828_n N_noxref_8_c_2830_n N_noxref_8_c_3067_p \
 N_noxref_8_c_2902_p N_noxref_8_c_2969_p N_noxref_8_c_2876_p \
 N_noxref_8_M16_noxref_g N_noxref_8_M25_noxref_g N_noxref_8_M84_noxref_g \
 N_noxref_8_M85_noxref_g N_noxref_8_M102_noxref_g N_noxref_8_M103_noxref_g \
 N_noxref_8_c_2839_n N_noxref_8_c_2841_n N_noxref_8_c_2844_n \
 N_noxref_8_c_2845_n N_noxref_8_c_2848_n N_noxref_8_c_2850_n \
 N_noxref_8_c_2854_n N_noxref_8_c_2856_n N_noxref_8_c_2994_p \
 N_noxref_8_c_2995_p N_noxref_8_c_2997_p N_noxref_8_c_2979_p \
 N_noxref_8_c_3235_p N_noxref_8_c_3236_p N_noxref_8_c_2996_p \
 N_noxref_8_c_2998_p N_noxref_8_c_2860_n N_noxref_8_c_2861_n \
 N_noxref_8_c_2863_n N_noxref_8_c_2879_p N_noxref_8_M19_noxref_d \
 N_noxref_8_M86_noxref_d N_noxref_8_M88_noxref_d N_noxref_8_M90_noxref_d )  \
 PM_TMRDFFSNQX1\%noxref_8
x_PM_TMRDFFSNQX1\%noxref_9 ( N_noxref_9_c_3286_n N_noxref_9_c_3302_p \
 N_noxref_9_c_3353_p N_noxref_9_c_3331_p N_noxref_9_c_3304_p \
 N_noxref_9_c_3287_n N_noxref_9_c_3316_p N_noxref_9_c_3288_n \
 N_noxref_9_c_3402_p N_noxref_9_c_3307_p N_noxref_9_c_3390_p \
 N_noxref_9_c_3308_p N_noxref_9_c_3290_n N_noxref_9_c_3325_p \
 N_noxref_9_c_3461_p N_noxref_9_c_3312_p N_noxref_9_c_3320_p \
 N_noxref_9_c_3340_p N_noxref_9_c_3321_p N_noxref_9_c_3392_p \
 N_noxref_9_c_3388_p N_noxref_9_c_3296_n N_noxref_9_c_3326_p \
 N_noxref_9_c_3404_p N_noxref_9_c_3412_p N_noxref_9_M27_noxref_g \
 N_noxref_9_M106_noxref_g N_noxref_9_M107_noxref_g N_noxref_9_c_3439_p \
 N_noxref_9_c_3440_p N_noxref_9_c_3442_p N_noxref_9_c_3405_p \
 N_noxref_9_c_3511_p N_noxref_9_c_3524_p N_noxref_9_c_3441_p \
 N_noxref_9_c_3443_p N_noxref_9_c_3339_p N_noxref_9_c_3414_p \
 N_noxref_9_M26_noxref_d N_noxref_9_M102_noxref_d N_noxref_9_M104_noxref_d )  \
 PM_TMRDFFSNQX1\%noxref_9
x_PM_TMRDFFSNQX1\%noxref_10 ( N_noxref_10_c_3663_n N_noxref_10_c_3575_n \
 N_noxref_10_c_3665_n N_noxref_10_c_3580_n N_noxref_10_c_3586_n \
 N_noxref_10_c_3582_n N_noxref_10_c_3594_n N_noxref_10_c_3584_n \
 N_noxref_10_c_3602_n N_noxref_10_c_3603_n N_noxref_10_c_3746_n \
 N_noxref_10_c_3747_n N_noxref_10_c_3604_n N_noxref_10_c_3605_n \
 N_noxref_10_c_3684_n N_noxref_10_c_3608_n N_noxref_10_c_3783_p \
 N_noxref_10_c_3750_n N_noxref_10_c_3762_p N_noxref_10_c_3752_n \
 N_noxref_10_c_3692_n N_noxref_10_c_3610_n N_noxref_10_c_3611_n \
 N_noxref_10_c_3753_n N_noxref_10_c_3754_n N_noxref_10_c_3619_n \
 N_noxref_10_c_3849_p N_noxref_10_c_3792_p N_noxref_10_c_3693_n \
 N_noxref_10_c_3695_n N_noxref_10_c_3585_n N_noxref_10_c_3701_n \
 N_noxref_10_c_3621_n N_noxref_10_c_3704_n N_noxref_10_c_3793_p \
 N_noxref_10_c_3706_n N_noxref_10_c_3710_n N_noxref_10_c_3711_n \
 N_noxref_10_c_3623_n N_noxref_10_c_3624_n N_noxref_10_c_3628_n \
 N_noxref_10_c_3862_p N_noxref_10_c_3785_p N_noxref_10_c_3768_p \
 N_noxref_10_M19_noxref_g N_noxref_10_M22_noxref_g N_noxref_10_M29_noxref_g \
 N_noxref_10_M90_noxref_g N_noxref_10_M91_noxref_g N_noxref_10_M96_noxref_g \
 N_noxref_10_M97_noxref_g N_noxref_10_M110_noxref_g N_noxref_10_M111_noxref_g \
 N_noxref_10_c_3721_n N_noxref_10_c_3723_n N_noxref_10_c_3726_n \
 N_noxref_10_c_3727_n N_noxref_10_c_3729_n N_noxref_10_c_3733_n \
 N_noxref_10_c_3735_n N_noxref_10_c_3639_n N_noxref_10_c_3641_n \
 N_noxref_10_c_3644_n N_noxref_10_c_3645_n N_noxref_10_c_3647_n \
 N_noxref_10_c_3651_n N_noxref_10_c_3653_n N_noxref_10_c_3770_p \
 N_noxref_10_c_3771_p N_noxref_10_c_3777_p N_noxref_10_c_3772_p \
 N_noxref_10_c_3773_p N_noxref_10_c_3774_p N_noxref_10_c_3775_p \
 N_noxref_10_c_3739_n N_noxref_10_c_3740_n N_noxref_10_c_3742_n \
 N_noxref_10_c_3657_n N_noxref_10_c_3658_n N_noxref_10_c_3660_n \
 N_noxref_10_c_3786_p N_noxref_10_c_3780_p N_noxref_10_c_3797_p \
 N_noxref_10_M24_noxref_d N_noxref_10_M98_noxref_d N_noxref_10_M100_noxref_d ) \
 PM_TMRDFFSNQX1\%noxref_10
x_PM_TMRDFFSNQX1\%noxref_11 ( N_noxref_11_c_4159_n N_noxref_11_c_4161_n \
 N_noxref_11_c_4164_n N_noxref_11_c_4216_n N_noxref_11_c_4272_n \
 N_noxref_11_c_4274_n N_noxref_11_c_4276_n N_noxref_11_c_4280_n \
 N_noxref_11_c_4217_n N_noxref_11_c_4291_n N_noxref_11_c_4218_n \
 N_noxref_11_c_4293_n N_noxref_11_c_4298_n N_noxref_11_c_4299_n \
 N_noxref_11_c_4304_n N_noxref_11_c_4305_n N_noxref_11_c_4500_p \
 N_noxref_11_c_4496_p N_noxref_11_c_4505_p N_noxref_11_c_4497_p \
 N_noxref_11_c_4507_p N_noxref_11_c_4499_p N_noxref_11_c_4574_p \
 N_noxref_11_c_4568_p N_noxref_11_c_4580_p N_noxref_11_c_4572_p \
 N_noxref_11_c_4168_n N_noxref_11_c_4171_n N_noxref_11_c_4221_n \
 N_noxref_11_c_4413_p N_noxref_11_c_4308_n N_noxref_11_c_4311_n \
 N_noxref_11_c_4226_n N_noxref_11_c_4509_p N_noxref_11_c_4510_p \
 N_noxref_11_c_4582_p N_noxref_11_c_4227_n N_noxref_11_c_4317_n \
 N_noxref_11_c_4339_p N_noxref_11_c_4340_p N_noxref_11_c_4357_p \
 N_noxref_11_c_4345_p N_noxref_11_c_4363_p N_noxref_11_c_4368_p \
 N_noxref_11_c_4369_p N_noxref_11_c_4372_p N_noxref_11_c_4373_p \
 N_noxref_11_c_4387_p N_noxref_11_c_4388_p N_noxref_11_c_4391_p \
 N_noxref_11_c_4393_p N_noxref_11_c_4173_n N_noxref_11_c_4320_n \
 N_noxref_11_c_4512_p N_noxref_11_c_4583_p N_noxref_11_c_4522_p \
 N_noxref_11_c_4175_n N_noxref_11_c_4179_n N_noxref_11_c_4233_n \
 N_noxref_11_c_4443_p N_noxref_11_c_4321_n N_noxref_11_c_4502_p \
 N_noxref_11_c_4542_p N_noxref_11_c_4577_p N_noxref_11_c_4585_p \
 N_noxref_11_M26_noxref_g N_noxref_11_M46_noxref_g N_noxref_11_M50_noxref_g \
 N_noxref_11_M104_noxref_g N_noxref_11_M105_noxref_g N_noxref_11_M144_noxref_g \
 N_noxref_11_M145_noxref_g N_noxref_11_M152_noxref_g N_noxref_11_M153_noxref_g \
 N_noxref_11_c_4185_n N_noxref_11_c_4188_n N_noxref_11_c_4190_n \
 N_noxref_11_c_4248_n N_noxref_11_c_4251_n N_noxref_11_c_4253_n \
 N_noxref_11_c_4193_n N_noxref_11_c_4194_n N_noxref_11_c_4547_p \
 N_noxref_11_c_4549_p N_noxref_11_c_4550_p N_noxref_11_c_4781_p \
 N_noxref_11_c_4694_p N_noxref_11_c_4695_p N_noxref_11_c_4559_p \
 N_noxref_11_c_4562_p N_noxref_11_c_4632_p N_noxref_11_c_4634_p \
 N_noxref_11_c_4635_p N_noxref_11_c_4687_p N_noxref_11_c_4664_p \
 N_noxref_11_c_4647_p N_noxref_11_c_4644_p N_noxref_11_c_4648_p \
 N_noxref_11_c_4195_n N_noxref_11_c_4264_n N_noxref_11_c_4198_n \
 N_noxref_11_c_4503_p N_noxref_11_c_4920_p N_noxref_11_c_4524_p \
 N_noxref_11_c_4578_p N_noxref_11_c_4673_p N_noxref_11_c_4586_p \
 N_noxref_11_M29_noxref_d N_noxref_11_M106_noxref_d N_noxref_11_M108_noxref_d \
 N_noxref_11_M110_noxref_d )  PM_TMRDFFSNQX1\%noxref_11
x_PM_TMRDFFSNQX1\%D ( D D D D D D D D D D D D D N_D_c_4936_n N_D_c_5072_n \
 N_D_c_5181_n N_D_c_5207_n N_D_c_4997_n N_D_c_4937_n N_D_c_5126_n N_D_c_5073_n \
 N_D_c_5211_n N_D_c_5212_n N_D_c_4939_n N_D_c_4947_n N_D_c_4950_n N_D_c_4954_n \
 N_D_c_4957_n N_D_c_4961_n N_D_c_4973_n N_D_c_4976_n N_D_c_4980_n N_D_c_4985_n \
 N_D_c_5018_n N_D_c_5343_p N_D_c_5075_n N_D_c_5046_n N_D_c_5081_n N_D_c_5085_n \
 N_D_c_5088_n N_D_c_5092_n N_D_c_5103_n N_D_c_5106_n N_D_c_5110_n N_D_c_5115_n \
 N_D_c_5138_n N_D_c_5168_n N_D_c_5172_n N_D_c_5177_n N_D_c_5196_n N_D_c_5218_n \
 N_D_c_4963_n N_D_c_5020_n N_D_c_4964_n N_D_c_5139_n N_D_c_5094_n N_D_c_5260_p \
 N_D_c_5229_p N_D_M0_noxref_g N_D_M15_noxref_g N_D_M30_noxref_g \
 N_D_M52_noxref_g N_D_M53_noxref_g N_D_M82_noxref_g N_D_M83_noxref_g \
 N_D_M112_noxref_g N_D_M113_noxref_g N_D_c_5030_n N_D_c_5031_n N_D_c_5032_n \
 N_D_c_5034_n N_D_c_5431_p N_D_c_5432_p N_D_c_5038_n N_D_c_5040_n N_D_c_5149_n \
 N_D_c_5150_n N_D_c_5151_n N_D_c_5153_n N_D_c_5444_p N_D_c_5445_p N_D_c_5157_n \
 N_D_c_5159_n N_D_c_5281_p N_D_c_5282_p N_D_c_5284_p N_D_c_5268_p N_D_c_5456_p \
 N_D_c_5457_p N_D_c_5283_p N_D_c_5285_p N_D_c_4971_n N_D_c_5101_n N_D_c_5232_p \
 )  PM_TMRDFFSNQX1\%D
x_PM_TMRDFFSNQX1\%noxref_13 ( N_noxref_13_c_5585_n N_noxref_13_c_5556_n \
 N_noxref_13_c_5703_p N_noxref_13_c_5672_p N_noxref_13_c_5557_n \
 N_noxref_13_c_5558_n N_noxref_13_c_5559_n N_noxref_13_c_5562_n \
 N_noxref_13_c_5617_p N_noxref_13_c_5610_p N_noxref_13_c_5566_n \
 N_noxref_13_c_5568_n N_noxref_13_c_5674_p N_noxref_13_c_5675_p \
 N_noxref_13_c_5570_n N_noxref_13_c_5572_n N_noxref_13_c_5574_n \
 N_noxref_13_c_5626_p N_noxref_13_c_5820_p N_noxref_13_c_5576_n \
 N_noxref_13_c_5661_p N_noxref_13_c_5613_p N_noxref_13_c_5604_p \
 N_noxref_13_c_5577_n N_noxref_13_c_5579_n N_noxref_13_c_5581_n \
 N_noxref_13_c_5582_n N_noxref_13_c_5583_n N_noxref_13_c_5595_n \
 N_noxref_13_c_5667_p N_noxref_13_c_5616_p N_noxref_13_c_5621_p \
 N_noxref_13_c_5740_p N_noxref_13_c_5737_p N_noxref_13_M32_noxref_g \
 N_noxref_13_M35_noxref_g N_noxref_13_M116_noxref_g N_noxref_13_M117_noxref_g \
 N_noxref_13_M122_noxref_g N_noxref_13_M123_noxref_g N_noxref_13_c_5642_p \
 N_noxref_13_c_5643_p N_noxref_13_c_5645_p N_noxref_13_c_5619_p \
 N_noxref_13_c_5881_p N_noxref_13_c_5897_p N_noxref_13_c_5644_p \
 N_noxref_13_c_5646_p N_noxref_13_c_5622_p N_noxref_13_c_5623_p \
 N_noxref_13_c_5784_p N_noxref_13_c_5785_p N_noxref_13_c_5787_p \
 N_noxref_13_c_5741_p N_noxref_13_c_5884_p N_noxref_13_c_5907_p \
 N_noxref_13_c_5786_p N_noxref_13_c_5788_p N_noxref_13_c_5603_p \
 N_noxref_13_c_5745_p N_noxref_13_M31_noxref_d N_noxref_13_M112_noxref_d \
 N_noxref_13_M114_noxref_d )  PM_TMRDFFSNQX1\%noxref_13
x_PM_TMRDFFSNQX1\%noxref_14 ( N_noxref_14_c_5999_n N_noxref_14_c_6082_p \
 N_noxref_14_c_6113_p N_noxref_14_c_6022_p N_noxref_14_c_6065_p \
 N_noxref_14_c_6105_p N_noxref_14_c_6106_p N_noxref_14_c_6056_p \
 N_noxref_14_c_6007_p N_noxref_14_c_5985_n N_noxref_14_c_5987_n \
 N_noxref_14_c_6009_p N_noxref_14_c_5990_n N_noxref_14_c_6000_n \
 N_noxref_14_c_6025_p N_noxref_14_c_6101_p N_noxref_14_c_6003_n \
 N_noxref_14_c_6011_p N_noxref_14_c_6015_p N_noxref_14_c_6018_p \
 N_noxref_14_c_5992_n N_noxref_14_c_5995_n N_noxref_14_c_5996_n \
 N_noxref_14_c_5997_n N_noxref_14_c_6004_n N_noxref_14_c_6064_p \
 N_noxref_14_c_6103_p N_noxref_14_c_6014_p N_noxref_14_c_6020_p \
 N_noxref_14_M38_noxref_g N_noxref_14_M128_noxref_g N_noxref_14_M129_noxref_g \
 N_noxref_14_c_6038_p N_noxref_14_c_6039_p N_noxref_14_c_6041_p \
 N_noxref_14_c_6017_p N_noxref_14_c_6242_p N_noxref_14_c_6243_p \
 N_noxref_14_c_6040_p N_noxref_14_c_6042_p N_noxref_14_c_6021_p \
 N_noxref_14_M37_noxref_d N_noxref_14_M122_noxref_d N_noxref_14_M124_noxref_d \
 N_noxref_14_M126_noxref_d )  PM_TMRDFFSNQX1\%noxref_14
x_PM_TMRDFFSNQX1\%CLK ( CLK CLK CLK CLK CLK CLK CLK CLK CLK CLK CLK CLK CLK \
 CLK CLK N_CLK_c_6294_n N_CLK_c_6544_n N_CLK_c_6819_n N_CLK_c_6298_n \
 N_CLK_c_6337_n N_CLK_c_6340_n N_CLK_c_6547_n N_CLK_c_6591_n N_CLK_c_6594_n \
 N_CLK_c_6822_n N_CLK_c_6866_n N_CLK_c_6869_n N_CLK_c_6387_n N_CLK_c_6393_n \
 N_CLK_c_6396_n N_CLK_c_6302_n N_CLK_c_6421_n N_CLK_c_6426_n N_CLK_c_6429_n \
 N_CLK_c_6434_n N_CLK_c_6476_n N_CLK_c_6553_n N_CLK_c_6648_n N_CLK_c_6554_n \
 N_CLK_c_6660_n N_CLK_c_6557_n N_CLK_c_6683_n N_CLK_c_6828_n N_CLK_c_6829_n \
 N_CLK_c_6830_n N_CLK_c_6303_n N_CLK_c_6304_n N_CLK_c_6308_n N_CLK_c_6350_n \
 N_CLK_c_6354_n N_CLK_c_6558_n N_CLK_c_6562_n N_CLK_c_6604_n N_CLK_c_6608_n \
 N_CLK_c_6833_n N_CLK_c_6837_n N_CLK_c_6879_n N_CLK_c_6883_n N_CLK_M3_noxref_g \
 N_CLK_M9_noxref_g N_CLK_M18_noxref_g N_CLK_M24_noxref_g N_CLK_M33_noxref_g \
 N_CLK_M39_noxref_g N_CLK_M58_noxref_g N_CLK_M59_noxref_g N_CLK_M70_noxref_g \
 N_CLK_M71_noxref_g N_CLK_M88_noxref_g N_CLK_M89_noxref_g N_CLK_M100_noxref_g \
 N_CLK_M101_noxref_g N_CLK_M118_noxref_g N_CLK_M119_noxref_g \
 N_CLK_M130_noxref_g N_CLK_M131_noxref_g N_CLK_c_6315_n N_CLK_c_6318_n \
 N_CLK_c_7157_p N_CLK_c_7158_p N_CLK_c_6320_n N_CLK_c_6321_n N_CLK_c_6322_n \
 N_CLK_c_6323_n N_CLK_c_6416_n N_CLK_c_6360_n N_CLK_c_6363_n N_CLK_c_6365_n \
 N_CLK_c_6513_n N_CLK_c_6517_n N_CLK_c_6519_n N_CLK_c_6368_n N_CLK_c_6369_n \
 N_CLK_c_6569_n N_CLK_c_6572_n N_CLK_c_7172_p N_CLK_c_7173_p N_CLK_c_6574_n \
 N_CLK_c_6575_n N_CLK_c_6576_n N_CLK_c_6577_n N_CLK_c_6677_n N_CLK_c_6614_n \
 N_CLK_c_6617_n N_CLK_c_6619_n N_CLK_c_6755_n N_CLK_c_6759_n N_CLK_c_6761_n \
 N_CLK_c_6622_n N_CLK_c_6623_n N_CLK_c_6844_n N_CLK_c_6847_n N_CLK_c_7187_p \
 N_CLK_c_7188_p N_CLK_c_6849_n N_CLK_c_6850_n N_CLK_c_6851_n N_CLK_c_6852_n \
 N_CLK_c_6930_p N_CLK_c_6889_n N_CLK_c_6892_n N_CLK_c_6894_n N_CLK_c_7004_p \
 N_CLK_c_7019_p N_CLK_c_6992_p N_CLK_c_6897_n N_CLK_c_6898_n N_CLK_c_6326_n \
 N_CLK_c_6370_n N_CLK_c_6532_n N_CLK_c_6373_n N_CLK_c_6580_n N_CLK_c_6624_n \
 N_CLK_c_6774_n N_CLK_c_6627_n N_CLK_c_6855_n N_CLK_c_6899_n N_CLK_c_6994_p \
 N_CLK_c_6902_n )  PM_TMRDFFSNQX1\%CLK
x_PM_TMRDFFSNQX1\%noxref_16 ( N_noxref_16_c_7276_n N_noxref_16_c_7297_n \
 N_noxref_16_c_7282_n N_noxref_16_c_7348_n N_noxref_16_c_7424_n \
 N_noxref_16_c_7409_n N_noxref_16_c_7410_n N_noxref_16_c_7477_p \
 N_noxref_16_c_7349_n N_noxref_16_c_7411_n N_noxref_16_c_7350_n \
 N_noxref_16_c_7283_n N_noxref_16_c_7357_n N_noxref_16_c_7358_n \
 N_noxref_16_c_7284_n N_noxref_16_c_7458_p N_noxref_16_c_7302_n \
 N_noxref_16_c_7285_n N_noxref_16_c_7361_n N_noxref_16_c_7434_n \
 N_noxref_16_c_7490_p N_noxref_16_c_7497_p N_noxref_16_c_7569_p \
 N_noxref_16_c_7481_p N_noxref_16_c_7459_p N_noxref_16_c_7440_n \
 N_noxref_16_c_7286_n N_noxref_16_c_7368_n N_noxref_16_c_7290_n \
 N_noxref_16_c_7460_p N_noxref_16_c_7370_n N_noxref_16_c_7307_n \
 N_noxref_16_c_7311_n N_noxref_16_c_7374_n N_noxref_16_c_7450_n \
 N_noxref_16_c_7500_p N_noxref_16_c_7482_p N_noxref_16_c_7461_p \
 N_noxref_16_M31_noxref_g N_noxref_16_M40_noxref_g N_noxref_16_M114_noxref_g \
 N_noxref_16_M115_noxref_g N_noxref_16_M132_noxref_g N_noxref_16_M133_noxref_g \
 N_noxref_16_c_7317_n N_noxref_16_c_7320_n N_noxref_16_c_7322_n \
 N_noxref_16_c_7389_n N_noxref_16_c_7392_n N_noxref_16_c_7394_n \
 N_noxref_16_c_7325_n N_noxref_16_c_7326_n N_noxref_16_c_7592_p \
 N_noxref_16_c_7593_p N_noxref_16_c_7595_p N_noxref_16_c_7483_p \
 N_noxref_16_c_7722_p N_noxref_16_c_7723_p N_noxref_16_c_7594_p \
 N_noxref_16_c_7596_p N_noxref_16_c_7327_n N_noxref_16_c_7405_n \
 N_noxref_16_c_7330_n N_noxref_16_c_7464_p N_noxref_16_M34_noxref_d \
 N_noxref_16_M116_noxref_d N_noxref_16_M118_noxref_d N_noxref_16_M120_noxref_d \
 )  PM_TMRDFFSNQX1\%noxref_16
x_PM_TMRDFFSNQX1\%noxref_17 ( N_noxref_17_c_7775_n N_noxref_17_c_7836_p \
 N_noxref_17_c_7891_p N_noxref_17_c_7853_p N_noxref_17_c_7804_p \
 N_noxref_17_c_7773_n N_noxref_17_c_7791_p N_noxref_17_c_7774_n \
 N_noxref_17_c_7778_n N_noxref_17_c_7860_p N_noxref_17_c_7929_p \
 N_noxref_17_c_7808_p N_noxref_17_c_7861_p N_noxref_17_c_7840_p \
 N_noxref_17_c_7797_p N_noxref_17_c_7877_p N_noxref_17_c_7798_p \
 N_noxref_17_c_7849_p N_noxref_17_c_7785_n N_noxref_17_c_7863_p \
 N_noxref_17_c_7793_p N_noxref_17_c_7799_p N_noxref_17_M42_noxref_g \
 N_noxref_17_M136_noxref_g N_noxref_17_M137_noxref_g N_noxref_17_c_7821_p \
 N_noxref_17_c_7822_p N_noxref_17_c_7824_p N_noxref_17_c_7794_p \
 N_noxref_17_c_7990_p N_noxref_17_c_8003_p N_noxref_17_c_7823_p \
 N_noxref_17_c_7825_p N_noxref_17_c_7800_p N_noxref_17_c_7801_p \
 N_noxref_17_M41_noxref_d N_noxref_17_M132_noxref_d N_noxref_17_M134_noxref_d ) \
 PM_TMRDFFSNQX1\%noxref_17
x_PM_TMRDFFSNQX1\%SN ( SN SN SN SN SN SN SN SN SN SN N_SN_c_8051_n \
 N_SN_c_8055_n N_SN_c_8130_n N_SN_c_8134_n N_SN_c_8253_n N_SN_c_8257_n \
 N_SN_c_8360_n N_SN_c_8364_n N_SN_c_8500_n N_SN_c_8591_n N_SN_c_8501_n \
 N_SN_c_8502_n N_SN_c_8092_n N_SN_c_8265_n N_SN_c_8145_n N_SN_c_8273_n \
 N_SN_c_8275_n N_SN_c_8282_n N_SN_c_8285_n N_SN_c_8324_n N_SN_c_8291_n \
 N_SN_c_8506_n N_SN_c_8385_n N_SN_c_8514_n N_SN_c_8515_n N_SN_c_8516_n \
 N_SN_c_8517_n N_SN_c_8518_n N_SN_c_8059_n N_SN_c_8520_n N_SN_c_8521_n \
 N_SN_c_8061_n N_SN_c_8064_n N_SN_c_8147_n N_SN_c_8150_n N_SN_c_8293_n \
 N_SN_c_8296_n N_SN_c_8387_n N_SN_c_8390_n N_SN_c_8623_n N_SN_c_8626_n \
 N_SN_c_8737_n N_SN_c_8740_n N_SN_M6_noxref_g N_SN_M13_noxref_g \
 N_SN_M21_noxref_g N_SN_M28_noxref_g N_SN_M36_noxref_g N_SN_M43_noxref_g \
 N_SN_M64_noxref_g N_SN_M65_noxref_g N_SN_M78_noxref_g N_SN_M79_noxref_g \
 N_SN_M94_noxref_g N_SN_M95_noxref_g N_SN_M108_noxref_g N_SN_M109_noxref_g \
 N_SN_M124_noxref_g N_SN_M125_noxref_g N_SN_M138_noxref_g N_SN_M139_noxref_g \
 N_SN_c_8071_n N_SN_c_8074_n N_SN_c_8945_p N_SN_c_8946_p N_SN_c_8076_n \
 N_SN_c_8077_n N_SN_c_8078_n N_SN_c_8079_n N_SN_c_8112_n N_SN_c_8157_n \
 N_SN_c_8160_n N_SN_c_8965_p N_SN_c_8966_p N_SN_c_8162_n N_SN_c_8163_n \
 N_SN_c_8164_n N_SN_c_8165_n N_SN_c_8246_n N_SN_c_8303_n N_SN_c_8306_n \
 N_SN_c_8988_p N_SN_c_8989_p N_SN_c_8308_n N_SN_c_8309_n N_SN_c_8310_n \
 N_SN_c_8311_n N_SN_c_8344_n N_SN_c_8397_n N_SN_c_8400_n N_SN_c_9008_p \
 N_SN_c_9009_p N_SN_c_8402_n N_SN_c_8403_n N_SN_c_8404_n N_SN_c_8405_n \
 N_SN_c_8483_n N_SN_c_8633_n N_SN_c_8636_n N_SN_c_9031_p N_SN_c_9032_p \
 N_SN_c_8638_n N_SN_c_8639_n N_SN_c_8640_n N_SN_c_8641_n N_SN_c_8674_n \
 N_SN_c_8748_n N_SN_c_8751_n N_SN_c_9049_p N_SN_c_9050_p N_SN_c_8753_n \
 N_SN_c_8754_n N_SN_c_8755_n N_SN_c_8756_n N_SN_c_8840_p N_SN_c_8082_n \
 N_SN_c_8168_n N_SN_c_8314_n N_SN_c_8408_n N_SN_c_8644_n N_SN_c_8759_n )  \
 PM_TMRDFFSNQX1\%SN
x_PM_TMRDFFSNQX1\%noxref_19 ( N_noxref_19_c_9362_n N_noxref_19_c_9261_n \
 N_noxref_19_c_9367_n N_noxref_19_c_9279_n N_noxref_19_c_9285_n \
 N_noxref_19_c_9262_n N_noxref_19_c_9293_n N_noxref_19_c_9283_n \
 N_noxref_19_c_9301_n N_noxref_19_c_9302_n N_noxref_19_c_9383_n \
 N_noxref_19_c_9384_n N_noxref_19_c_9303_n N_noxref_19_c_9263_n \
 N_noxref_19_c_9391_n N_noxref_19_c_9307_n N_noxref_19_c_9264_n \
 N_noxref_19_c_9265_n N_noxref_19_c_9572_n N_noxref_19_c_9539_n \
 N_noxref_19_c_9398_n N_noxref_19_c_9309_n N_noxref_19_c_9310_n \
 N_noxref_19_c_9400_n N_noxref_19_c_9541_n N_noxref_19_c_9318_n \
 N_noxref_19_c_9411_n N_noxref_19_c_9578_n N_noxref_19_c_9266_n \
 N_noxref_19_c_9413_n N_noxref_19_c_9267_n N_noxref_19_c_9415_n \
 N_noxref_19_c_9269_n N_noxref_19_c_9418_n N_noxref_19_c_9580_n \
 N_noxref_19_c_9273_n N_noxref_19_c_9419_n N_noxref_19_c_9423_n \
 N_noxref_19_c_9322_n N_noxref_19_c_9323_n N_noxref_19_c_9327_n \
 N_noxref_19_c_9426_n N_noxref_19_c_9590_n N_noxref_19_c_9593_n \
 N_noxref_19_M34_noxref_g N_noxref_19_M37_noxref_g N_noxref_19_M44_noxref_g \
 N_noxref_19_M120_noxref_g N_noxref_19_M121_noxref_g N_noxref_19_M126_noxref_g \
 N_noxref_19_M127_noxref_g N_noxref_19_M140_noxref_g N_noxref_19_M141_noxref_g \
 N_noxref_19_c_9433_n N_noxref_19_c_9434_n N_noxref_19_c_9435_n \
 N_noxref_19_c_9515_n N_noxref_19_c_9517_n N_noxref_19_c_9521_n \
 N_noxref_19_c_9523_n N_noxref_19_c_9338_n N_noxref_19_c_9340_n \
 N_noxref_19_c_9343_n N_noxref_19_c_9344_n N_noxref_19_c_9346_n \
 N_noxref_19_c_9350_n N_noxref_19_c_9352_n N_noxref_19_c_9605_n \
 N_noxref_19_c_9606_n N_noxref_19_c_9607_n N_noxref_19_c_9639_p \
 N_noxref_19_c_9640_p N_noxref_19_c_9641_p N_noxref_19_c_9642_p \
 N_noxref_19_c_9436_n N_noxref_19_c_9439_n N_noxref_19_c_9440_n \
 N_noxref_19_c_9356_n N_noxref_19_c_9357_n N_noxref_19_c_9359_n \
 N_noxref_19_c_9618_n N_noxref_19_c_9621_n N_noxref_19_c_9622_n \
 N_noxref_19_M39_noxref_d N_noxref_19_M128_noxref_d N_noxref_19_M130_noxref_d ) \
 PM_TMRDFFSNQX1\%noxref_19
x_PM_TMRDFFSNQX1\%noxref_20 ( N_noxref_20_c_9843_n N_noxref_20_c_9959_n \
 N_noxref_20_c_10036_n N_noxref_20_c_10056_n N_noxref_20_c_10058_n \
 N_noxref_20_c_9844_n N_noxref_20_c_9960_n N_noxref_20_c_10073_n \
 N_noxref_20_c_9845_n N_noxref_20_c_9846_n N_noxref_20_c_10084_n \
 N_noxref_20_c_9849_n N_noxref_20_c_9850_n N_noxref_20_c_9854_n \
 N_noxref_20_c_9864_n N_noxref_20_c_9865_n N_noxref_20_c_9922_n \
 N_noxref_20_c_9925_n N_noxref_20_c_9971_n N_noxref_20_c_10039_n \
 N_noxref_20_c_10093_n N_noxref_20_c_10096_n N_noxref_20_c_9873_n \
 N_noxref_20_c_9875_n N_noxref_20_c_9877_n N_noxref_20_c_9878_n \
 N_noxref_20_c_9929_n N_noxref_20_c_9879_n N_noxref_20_c_10104_n \
 N_noxref_20_c_9880_n N_noxref_20_c_9882_n N_noxref_20_c_9931_n \
 N_noxref_20_c_9935_n N_noxref_20_c_9992_n N_noxref_20_c_10046_n \
 N_noxref_20_c_10105_n N_noxref_20_c_9887_n N_noxref_20_c_9891_n \
 N_noxref_20_c_10118_p N_noxref_20_c_10124_p N_noxref_20_M41_noxref_g \
 N_noxref_20_M45_noxref_g N_noxref_20_M47_noxref_g N_noxref_20_M134_noxref_g \
 N_noxref_20_M135_noxref_g N_noxref_20_M142_noxref_g N_noxref_20_M143_noxref_g \
 N_noxref_20_M146_noxref_g N_noxref_20_M147_noxref_g N_noxref_20_c_9941_n \
 N_noxref_20_c_9944_n N_noxref_20_c_9946_n N_noxref_20_c_10008_n \
 N_noxref_20_c_10012_n N_noxref_20_c_10014_n N_noxref_20_c_9949_n \
 N_noxref_20_c_9950_n N_noxref_20_c_9897_n N_noxref_20_c_9898_n \
 N_noxref_20_c_9899_n N_noxref_20_c_9901_n N_noxref_20_c_10320_p \
 N_noxref_20_c_10321_p N_noxref_20_c_9902_n N_noxref_20_c_9905_n \
 N_noxref_20_c_9908_n N_noxref_20_c_9910_n N_noxref_20_c_10153_p \
 N_noxref_20_c_10154_p N_noxref_20_c_10156_p N_noxref_20_c_10146_p \
 N_noxref_20_c_10329_p N_noxref_20_c_10330_p N_noxref_20_c_10155_p \
 N_noxref_20_c_10157_p N_noxref_20_c_9951_n N_noxref_20_c_10025_n \
 N_noxref_20_c_9954_n N_noxref_20_c_9913_n N_noxref_20_c_10125_p \
 N_noxref_20_M44_noxref_d N_noxref_20_M136_noxref_d N_noxref_20_M138_noxref_d \
 N_noxref_20_M140_noxref_d )  PM_TMRDFFSNQX1\%noxref_20
x_PM_TMRDFFSNQX1\%noxref_21 ( N_noxref_21_c_10403_n N_noxref_21_c_10405_n \
 N_noxref_21_c_10406_n N_noxref_21_c_10461_n N_noxref_21_c_10517_n \
 N_noxref_21_c_10519_n N_noxref_21_c_10521_n N_noxref_21_c_10525_n \
 N_noxref_21_c_10462_n N_noxref_21_c_10536_n N_noxref_21_c_10463_n \
 N_noxref_21_c_10538_n N_noxref_21_c_10543_n N_noxref_21_c_10544_n \
 N_noxref_21_c_10636_n N_noxref_21_c_10637_n N_noxref_21_c_10639_n \
 N_noxref_21_c_10640_n N_noxref_21_c_10644_n N_noxref_21_c_10649_n \
 N_noxref_21_c_10414_n N_noxref_21_c_10417_n N_noxref_21_c_10466_n \
 N_noxref_21_c_10784_n N_noxref_21_c_10551_n N_noxref_21_c_10554_n \
 N_noxref_21_c_10901_n N_noxref_21_c_10471_n N_noxref_21_c_10558_n \
 N_noxref_21_c_10581_n N_noxref_21_c_10561_n N_noxref_21_c_10586_n \
 N_noxref_21_c_10587_n N_noxref_21_c_10588_n N_noxref_21_c_10604_n \
 N_noxref_21_c_10606_n N_noxref_21_c_10633_n N_noxref_21_c_10661_n \
 N_noxref_21_c_10665_n N_noxref_21_c_10666_n N_noxref_21_c_10672_n \
 N_noxref_21_c_10673_n N_noxref_21_c_10676_n N_noxref_21_c_10677_n \
 N_noxref_21_c_10680_n N_noxref_21_c_10681_n N_noxref_21_c_10682_n \
 N_noxref_21_c_10418_n N_noxref_21_c_10688_n N_noxref_21_c_10689_n \
 N_noxref_21_c_10692_n N_noxref_21_c_10419_n N_noxref_21_c_10423_n \
 N_noxref_21_c_10478_n N_noxref_21_c_10859_n N_noxref_21_c_10563_n \
 N_noxref_21_c_10917_n N_noxref_21_c_10921_n N_noxref_21_c_10693_n \
 N_noxref_21_c_10696_n N_noxref_21_M11_noxref_g N_noxref_21_M48_noxref_g \
 N_noxref_21_M49_noxref_g N_noxref_21_M74_noxref_g N_noxref_21_M75_noxref_g \
 N_noxref_21_M148_noxref_g N_noxref_21_M149_noxref_g N_noxref_21_M150_noxref_g \
 N_noxref_21_M151_noxref_g N_noxref_21_c_10429_n N_noxref_21_c_10432_n \
 N_noxref_21_c_10434_n N_noxref_21_c_10493_n N_noxref_21_c_10496_n \
 N_noxref_21_c_10498_n N_noxref_21_c_10437_n N_noxref_21_c_10438_n \
 N_noxref_21_c_10927_n N_noxref_21_c_10930_n N_noxref_21_c_11084_p \
 N_noxref_21_c_10932_n N_noxref_21_c_10949_p N_noxref_21_c_10950_p \
 N_noxref_21_c_10934_n N_noxref_21_c_10936_n N_noxref_21_c_10937_n \
 N_noxref_21_c_10938_n N_noxref_21_c_10939_n N_noxref_21_c_10702_n \
 N_noxref_21_c_10703_n N_noxref_21_c_10704_n N_noxref_21_c_10706_n \
 N_noxref_21_c_11103_p N_noxref_21_c_11104_p N_noxref_21_c_10707_n \
 N_noxref_21_c_10710_n N_noxref_21_c_10713_n N_noxref_21_c_10715_n \
 N_noxref_21_c_10439_n N_noxref_21_c_10509_n N_noxref_21_c_10442_n \
 N_noxref_21_c_10719_n N_noxref_21_M14_noxref_d N_noxref_21_M76_noxref_d \
 N_noxref_21_M78_noxref_d N_noxref_21_M80_noxref_d )  PM_TMRDFFSNQX1\%noxref_21
x_PM_TMRDFFSNQX1\%noxref_22 ( N_noxref_22_c_11183_n N_noxref_22_c_11190_n \
 N_noxref_22_c_11200_n N_noxref_22_c_11202_n N_noxref_22_c_11203_n \
 N_noxref_22_c_11204_n N_noxref_22_c_11205_n N_noxref_22_c_11212_n \
 N_noxref_22_c_11216_n N_noxref_22_c_11220_n N_noxref_22_c_11312_p \
 N_noxref_22_c_11221_n N_noxref_22_c_11222_n N_noxref_22_c_11273_n \
 N_noxref_22_c_11229_n N_noxref_22_c_11230_n N_noxref_22_c_11234_n \
 N_noxref_22_c_11330_p N_noxref_22_c_11405_p N_noxref_22_c_11284_n \
 N_noxref_22_c_11236_n N_noxref_22_c_11287_n N_noxref_22_c_11237_n \
 N_noxref_22_c_11239_n N_noxref_22_c_11242_n N_noxref_22_c_11344_p \
 N_noxref_22_c_11331_p N_noxref_22_c_11300_n N_noxref_22_c_11245_n \
 N_noxref_22_c_11408_p N_noxref_22_c_11314_p N_noxref_22_M51_noxref_g \
 N_noxref_22_M154_noxref_g N_noxref_22_M155_noxref_g N_noxref_22_c_11413_p \
 N_noxref_22_c_11459_p N_noxref_22_c_11436_p N_noxref_22_c_11427_p \
 N_noxref_22_c_11338_p N_noxref_22_c_11335_p N_noxref_22_c_11438_p \
 N_noxref_22_c_11462_p N_noxref_22_c_11415_p N_noxref_22_c_11440_p \
 N_noxref_22_c_11414_p N_noxref_22_M46_noxref_d N_noxref_22_M48_noxref_d \
 N_noxref_22_M50_noxref_d N_noxref_22_M150_noxref_d N_noxref_22_M152_noxref_d ) \
 PM_TMRDFFSNQX1\%noxref_22
x_PM_TMRDFFSNQX1\%VDD ( VDD N_VDD_c_11522_n N_VDD_c_12628_n N_VDD_c_12629_n \
 N_VDD_c_12804_p N_VDD_c_12121_n N_VDD_c_12122_n N_VDD_c_12806_p \
 N_VDD_c_12123_n N_VDD_c_12124_n N_VDD_c_12764_n N_VDD_c_11529_n \
 N_VDD_c_11532_n N_VDD_c_11537_n N_VDD_c_11651_n N_VDD_c_11655_n \
 N_VDD_c_11659_n N_VDD_c_11539_n N_VDD_c_11595_n N_VDD_c_11599_n \
 N_VDD_c_11603_n N_VDD_c_11604_n N_VDD_c_11781_n N_VDD_c_11661_n \
 N_VDD_c_11721_n N_VDD_c_11726_n N_VDD_c_11727_n N_VDD_c_11728_n \
 N_VDD_c_12537_n N_VDD_c_11786_n N_VDD_c_12723_n N_VDD_c_11829_n \
 N_VDD_c_11832_n N_VDD_c_11837_n N_VDD_c_11951_n N_VDD_c_11955_n \
 N_VDD_c_11959_n N_VDD_c_11839_n N_VDD_c_11895_n N_VDD_c_11899_n \
 N_VDD_c_11903_n N_VDD_c_11904_n N_VDD_c_12070_n N_VDD_c_11961_n \
 N_VDD_c_12017_n N_VDD_c_12022_n N_VDD_c_12130_n N_VDD_c_12075_n \
 N_VDD_c_12138_n N_VDD_c_12201_n N_VDD_c_12233_n N_VDD_c_12238_n \
 N_VDD_c_12341_n N_VDD_c_12421_n N_VDD_c_12425_n N_VDD_c_12240_n \
 N_VDD_c_12296_n N_VDD_c_12300_n N_VDD_c_12304_n N_VDD_c_12305_n \
 N_VDD_c_12343_n N_VDD_c_12427_n N_VDD_c_12491_n N_VDD_c_12496_n \
 N_VDD_c_12497_n N_VDD_c_12545_n N_VDD_c_12579_n N_VDD_c_12645_n \
 N_VDD_c_12139_n N_VDD_c_12649_n N_VDD_c_12141_n N_VDD_c_12773_n \
 N_VDD_c_11541_n N_VDD_c_11544_n N_VDD_c_11551_n N_VDD_c_11609_n \
 N_VDD_c_11679_n N_VDD_c_11733_n N_VDD_c_11799_n N_VDD_c_11844_n \
 N_VDD_c_11851_n N_VDD_c_11909_n N_VDD_c_11979_n N_VDD_c_12027_n \
 N_VDD_c_12088_n N_VDD_c_12245_n N_VDD_c_12252_n N_VDD_c_12310_n \
 N_VDD_c_12366_n N_VDD_c_12452_n N_VDD_c_12155_n N_VDD_c_12156_n \
 N_VDD_c_12163_n N_VDD_c_12167_n N_VDD_c_12790_n N_VDD_M52_noxref_s \
 N_VDD_M53_noxref_d N_VDD_M55_noxref_d N_VDD_M56_noxref_s N_VDD_M57_noxref_d \
 N_VDD_M59_noxref_d N_VDD_M61_noxref_d N_VDD_M62_noxref_s N_VDD_M63_noxref_d \
 N_VDD_M65_noxref_d N_VDD_M67_noxref_d N_VDD_M68_noxref_s N_VDD_M69_noxref_d \
 N_VDD_M71_noxref_d N_VDD_M72_noxref_s N_VDD_M73_noxref_d N_VDD_M75_noxref_d \
 N_VDD_M76_noxref_s N_VDD_M77_noxref_d N_VDD_M79_noxref_d N_VDD_M81_noxref_d \
 N_VDD_M82_noxref_s N_VDD_M83_noxref_d N_VDD_M85_noxref_d N_VDD_M86_noxref_s \
 N_VDD_M87_noxref_d N_VDD_M89_noxref_d N_VDD_M91_noxref_d N_VDD_M92_noxref_s \
 N_VDD_M93_noxref_d N_VDD_M95_noxref_d N_VDD_M97_noxref_d N_VDD_M98_noxref_s \
 N_VDD_M99_noxref_d N_VDD_M101_noxref_d N_VDD_M102_noxref_s \
 N_VDD_M103_noxref_d N_VDD_M105_noxref_d N_VDD_M106_noxref_s \
 N_VDD_M107_noxref_d N_VDD_M109_noxref_d N_VDD_M111_noxref_d \
 N_VDD_M112_noxref_s N_VDD_M113_noxref_d N_VDD_M115_noxref_d \
 N_VDD_M116_noxref_s N_VDD_M117_noxref_d N_VDD_M119_noxref_d \
 N_VDD_M121_noxref_d N_VDD_M122_noxref_s N_VDD_M123_noxref_d \
 N_VDD_M125_noxref_d N_VDD_M127_noxref_d N_VDD_M128_noxref_s \
 N_VDD_M129_noxref_d N_VDD_M131_noxref_d N_VDD_M132_noxref_s \
 N_VDD_M133_noxref_d N_VDD_M135_noxref_d N_VDD_M136_noxref_s \
 N_VDD_M137_noxref_d N_VDD_M139_noxref_d N_VDD_M141_noxref_d \
 N_VDD_M142_noxref_s N_VDD_M143_noxref_d N_VDD_M145_noxref_d \
 N_VDD_M154_noxref_s N_VDD_M155_noxref_d )  PM_TMRDFFSNQX1\%VDD
x_PM_TMRDFFSNQX1\%noxref_24 ( N_noxref_24_c_12950_n N_noxref_24_c_12992_p \
 N_noxref_24_c_12951_n N_noxref_24_c_12994_p N_noxref_24_c_12958_n \
 N_noxref_24_M3_noxref_d N_noxref_24_M4_noxref_s )  PM_TMRDFFSNQX1\%noxref_24
x_PM_TMRDFFSNQX1\%noxref_25 ( N_noxref_25_c_13041_n N_noxref_25_c_13061_p \
 N_noxref_25_c_13017_n N_noxref_25_c_13063_p N_noxref_25_c_13020_n \
 N_noxref_25_M6_noxref_d N_noxref_25_M7_noxref_s )  PM_TMRDFFSNQX1\%noxref_25
x_PM_TMRDFFSNQX1\%noxref_26 ( N_noxref_26_c_13098_n N_noxref_26_c_13130_p \
 N_noxref_26_c_13087_n N_noxref_26_c_13132_p N_noxref_26_c_13092_n \
 N_noxref_26_M13_noxref_d N_noxref_26_M14_noxref_s )  PM_TMRDFFSNQX1\%noxref_26
x_PM_TMRDFFSNQX1\%noxref_27 ( N_noxref_27_c_13177_n N_noxref_27_c_13197_p \
 N_noxref_27_c_13156_n N_noxref_27_c_13199_p N_noxref_27_c_13159_n \
 N_noxref_27_M18_noxref_d N_noxref_27_M19_noxref_s )  PM_TMRDFFSNQX1\%noxref_27
x_PM_TMRDFFSNQX1\%noxref_28 ( N_noxref_28_c_13245_n N_noxref_28_c_13265_p \
 N_noxref_28_c_13222_n N_noxref_28_c_13267_p N_noxref_28_c_13225_n \
 N_noxref_28_M21_noxref_d N_noxref_28_M22_noxref_s )  PM_TMRDFFSNQX1\%noxref_28
x_PM_TMRDFFSNQX1\%noxref_29 ( N_noxref_29_c_13313_n N_noxref_29_c_13334_p \
 N_noxref_29_c_13291_n N_noxref_29_c_13336_p N_noxref_29_c_13296_n \
 N_noxref_29_M28_noxref_d N_noxref_29_M29_noxref_s )  PM_TMRDFFSNQX1\%noxref_29
x_PM_TMRDFFSNQX1\%noxref_30 ( N_noxref_30_c_13360_n N_noxref_30_c_13401_p \
 N_noxref_30_c_13375_n N_noxref_30_c_13403_p N_noxref_30_c_13378_n \
 N_noxref_30_M33_noxref_d N_noxref_30_M34_noxref_s )  PM_TMRDFFSNQX1\%noxref_30
x_PM_TMRDFFSNQX1\%noxref_31 ( N_noxref_31_c_13438_n N_noxref_31_c_13469_p \
 N_noxref_31_c_13426_n N_noxref_31_c_13471_p N_noxref_31_c_13429_n \
 N_noxref_31_M36_noxref_d N_noxref_31_M37_noxref_s )  PM_TMRDFFSNQX1\%noxref_31
x_PM_TMRDFFSNQX1\%noxref_32 ( N_noxref_32_c_13494_n N_noxref_32_c_13538_p \
 N_noxref_32_c_13495_n N_noxref_32_c_13540_p N_noxref_32_c_13520_n \
 N_noxref_32_M43_noxref_d N_noxref_32_M44_noxref_s )  PM_TMRDFFSNQX1\%noxref_32
x_PM_TMRDFFSNQX1\%noxref_33 ( N_noxref_33_c_13563_n N_noxref_33_c_13570_n \
 N_noxref_33_c_13571_n N_noxref_33_c_13588_n N_noxref_33_c_13612_n \
 N_noxref_33_c_13594_n N_noxref_33_c_13600_n N_noxref_33_c_13601_n \
 N_noxref_33_c_13615_n N_noxref_33_c_13602_n N_noxref_33_c_13575_n \
 N_noxref_33_c_13606_n N_noxref_33_M142_noxref_d N_noxref_33_M144_noxref_d \
 N_noxref_33_M146_noxref_s N_noxref_33_M147_noxref_d N_noxref_33_M149_noxref_d \
 )  PM_TMRDFFSNQX1\%noxref_33
x_PM_TMRDFFSNQX1\%noxref_34 ( N_noxref_34_c_13737_n N_noxref_34_c_13725_n \
 N_noxref_34_c_13726_n N_noxref_34_c_13763_n N_noxref_34_c_13727_n \
 N_noxref_34_c_13729_n N_noxref_34_c_13730_n N_noxref_34_c_13768_n \
 N_noxref_34_c_13731_n N_noxref_34_c_13732_n N_noxref_34_c_13744_n \
 N_noxref_34_c_13733_n N_noxref_34_M146_noxref_d N_noxref_34_M150_noxref_s \
 N_noxref_34_M151_noxref_d N_noxref_34_M153_noxref_d )  \
 PM_TMRDFFSNQX1\%noxref_34
x_PM_TMRDFFSNQX1\%GND ( GND N_GND_c_14346_n N_GND_c_13858_n N_GND_c_13864_n \
 N_GND_c_13867_n N_GND_c_13868_n N_GND_c_13937_n N_GND_c_14058_n \
 N_GND_c_14017_n N_GND_c_14021_n N_GND_c_14061_n N_GND_c_14081_n \
 N_GND_c_14085_n N_GND_c_14198_n N_GND_c_14088_n N_GND_c_14155_n \
 N_GND_c_14284_n N_GND_c_14235_n N_GND_c_14239_n N_GND_c_14287_n \
 N_GND_c_14438_n N_GND_c_14442_n N_GND_c_14559_n N_GND_c_14445_n \
 N_GND_c_14513_n N_GND_c_14560_n N_GND_c_14611_n N_GND_c_14614_n \
 N_GND_c_14678_n N_GND_c_14313_n N_GND_c_14314_n N_GND_c_14753_n \
 N_GND_c_14798_n N_GND_c_14801_n N_GND_c_14316_n N_GND_c_13871_n \
 N_GND_c_14359_n N_GND_c_13873_n N_GND_c_13885_n N_GND_c_13941_n \
 N_GND_c_13952_n N_GND_c_13985_n N_GND_c_13994_n N_GND_c_14027_n \
 N_GND_c_14091_n N_GND_c_14372_n N_GND_c_14093_n N_GND_c_14104_n \
 N_GND_c_14159_n N_GND_c_14170_n N_GND_c_14203_n N_GND_c_14212_n \
 N_GND_c_14245_n N_GND_c_14317_n N_GND_c_14384_n N_GND_c_14451_n \
 N_GND_c_14462_n N_GND_c_14517_n N_GND_c_14528_n N_GND_c_14579_n \
 N_GND_c_14588_n N_GND_c_14620_n N_GND_c_13896_n N_GND_c_13898_n \
 N_GND_c_13900_n N_GND_c_13901_n N_GND_c_13957_n N_GND_c_13999_n \
 N_GND_c_14039_n N_GND_c_14114_n N_GND_c_14116_n N_GND_c_14117_n \
 N_GND_c_14175_n N_GND_c_14217_n N_GND_c_14258_n N_GND_c_14394_n \
 N_GND_c_14474_n N_GND_c_14475_n N_GND_c_14533_n N_GND_c_14593_n \
 N_GND_c_14632_n N_GND_c_14321_n N_GND_c_14765_n N_GND_c_14322_n \
 N_GND_c_15507_p N_GND_c_14871_n N_GND_c_14875_n N_GND_c_13902_n \
 N_GND_c_13914_n N_GND_c_13958_n N_GND_c_13971_n N_GND_c_14041_n \
 N_GND_c_14078_n N_GND_c_14120_n N_GND_c_14132_n N_GND_c_14176_n \
 N_GND_c_14189_n N_GND_c_14261_n N_GND_c_14304_n N_GND_c_14332_n \
 N_GND_c_14333_n N_GND_c_14334_n N_GND_c_14335_n N_GND_c_14336_n \
 N_GND_c_14337_n N_GND_c_14338_n N_GND_c_14342_n N_GND_c_14343_n \
 N_GND_c_14890_n N_GND_M0_noxref_d N_GND_M2_noxref_d N_GND_M5_noxref_d \
 N_GND_M8_noxref_d N_GND_M10_noxref_d N_GND_M12_noxref_d N_GND_M15_noxref_d \
 N_GND_M17_noxref_d N_GND_M20_noxref_d N_GND_M23_noxref_d N_GND_M25_noxref_d \
 N_GND_M27_noxref_d N_GND_M30_noxref_d N_GND_M32_noxref_d N_GND_M35_noxref_d \
 N_GND_M38_noxref_d N_GND_M40_noxref_d N_GND_M42_noxref_d N_GND_M45_noxref_d \
 N_GND_M47_noxref_d N_GND_M49_noxref_d N_GND_M51_noxref_s )  PM_TMRDFFSNQX1\%GND
x_PM_TMRDFFSNQX1\%Q ( Q Q Q Q Q Q Q N_Q_c_15529_n N_Q_c_15538_n N_Q_c_15542_n \
 N_Q_c_15543_n N_Q_c_15545_n N_Q_c_15546_n N_Q_c_15549_n N_Q_c_15557_n \
 N_Q_M51_noxref_d N_Q_M154_noxref_d )  PM_TMRDFFSNQX1\%Q
x_PM_TMRDFFSNQX1\%noxref_37 ( N_noxref_37_c_15618_n N_noxref_37_c_15619_n \
 N_noxref_37_c_15638_n N_noxref_37_c_15596_n N_noxref_37_c_15597_n \
 N_noxref_37_c_15646_n N_noxref_37_M0_noxref_s )  PM_TMRDFFSNQX1\%noxref_37
x_PM_TMRDFFSNQX1\%noxref_38 ( N_noxref_38_c_15659_n N_noxref_38_c_15661_n \
 N_noxref_38_c_15686_n N_noxref_38_c_15676_n N_noxref_38_c_15670_n \
 N_noxref_38_M2_noxref_s )  PM_TMRDFFSNQX1\%noxref_38
x_PM_TMRDFFSNQX1\%noxref_39 ( N_noxref_39_c_15718_n N_noxref_39_c_15720_n \
 N_noxref_39_c_15748_n N_noxref_39_c_15735_n N_noxref_39_c_15733_n \
 N_noxref_39_M5_noxref_s )  PM_TMRDFFSNQX1\%noxref_39
x_PM_TMRDFFSNQX1\%noxref_40 ( N_noxref_40_c_15777_n N_noxref_40_c_15778_n \
 N_noxref_40_c_15822_n N_noxref_40_c_15785_n N_noxref_40_c_15790_n \
 N_noxref_40_c_15830_n N_noxref_40_M8_noxref_s )  PM_TMRDFFSNQX1\%noxref_40
x_PM_TMRDFFSNQX1\%noxref_41 ( N_noxref_41_c_15843_n N_noxref_41_c_15844_n \
 N_noxref_41_c_15888_n N_noxref_41_c_15851_n N_noxref_41_c_15856_n \
 N_noxref_41_c_15896_n N_noxref_41_M10_noxref_s )  PM_TMRDFFSNQX1\%noxref_41
x_PM_TMRDFFSNQX1\%noxref_42 ( N_noxref_42_c_15912_n N_noxref_42_c_15913_n \
 N_noxref_42_c_15939_n N_noxref_42_c_15926_n N_noxref_42_c_15928_n \
 N_noxref_42_M12_noxref_s )  PM_TMRDFFSNQX1\%noxref_42
x_PM_TMRDFFSNQX1\%noxref_43 ( N_noxref_43_c_15993_n N_noxref_43_c_15994_n \
 N_noxref_43_c_16017_n N_noxref_43_c_15971_n N_noxref_43_c_15972_n \
 N_noxref_43_c_16025_n N_noxref_43_M15_noxref_s )  PM_TMRDFFSNQX1\%noxref_43
x_PM_TMRDFFSNQX1\%noxref_44 ( N_noxref_44_c_16038_n N_noxref_44_c_16039_n \
 N_noxref_44_c_16066_n N_noxref_44_c_16050_n N_noxref_44_c_16052_n \
 N_noxref_44_M17_noxref_s )  PM_TMRDFFSNQX1\%noxref_44
x_PM_TMRDFFSNQX1\%noxref_45 ( N_noxref_45_c_16098_n N_noxref_45_c_16099_n \
 N_noxref_45_c_16129_n N_noxref_45_c_16114_n N_noxref_45_c_16116_n \
 N_noxref_45_M20_noxref_s )  PM_TMRDFFSNQX1\%noxref_45
x_PM_TMRDFFSNQX1\%noxref_46 ( N_noxref_46_c_16158_n N_noxref_46_c_16159_n \
 N_noxref_46_c_16203_n N_noxref_46_c_16166_n N_noxref_46_c_16171_n \
 N_noxref_46_c_16211_n N_noxref_46_M23_noxref_s )  PM_TMRDFFSNQX1\%noxref_46
x_PM_TMRDFFSNQX1\%noxref_47 ( N_noxref_47_c_16224_n N_noxref_47_c_16225_n \
 N_noxref_47_c_16268_n N_noxref_47_c_16232_n N_noxref_47_c_16237_n \
 N_noxref_47_c_16276_n N_noxref_47_M25_noxref_s )  PM_TMRDFFSNQX1\%noxref_47
x_PM_TMRDFFSNQX1\%noxref_48 ( N_noxref_48_c_16292_n N_noxref_48_c_16293_n \
 N_noxref_48_c_16319_n N_noxref_48_c_16306_n N_noxref_48_c_16308_n \
 N_noxref_48_M27_noxref_s )  PM_TMRDFFSNQX1\%noxref_48
x_PM_TMRDFFSNQX1\%noxref_49 ( N_noxref_49_c_16351_n N_noxref_49_c_16352_n \
 N_noxref_49_c_16397_n N_noxref_49_c_16359_n N_noxref_49_c_16364_n \
 N_noxref_49_c_16405_n N_noxref_49_M30_noxref_s )  PM_TMRDFFSNQX1\%noxref_49
x_PM_TMRDFFSNQX1\%noxref_50 ( N_noxref_50_c_16418_n N_noxref_50_c_16419_n \
 N_noxref_50_c_16446_n N_noxref_50_c_16430_n N_noxref_50_c_16432_n \
 N_noxref_50_M32_noxref_s )  PM_TMRDFFSNQX1\%noxref_50
x_PM_TMRDFFSNQX1\%noxref_51 ( N_noxref_51_c_16478_n N_noxref_51_c_16479_n \
 N_noxref_51_c_16509_n N_noxref_51_c_16494_n N_noxref_51_c_16496_n \
 N_noxref_51_M35_noxref_s )  PM_TMRDFFSNQX1\%noxref_51
x_PM_TMRDFFSNQX1\%noxref_52 ( N_noxref_52_c_16538_n N_noxref_52_c_16539_n \
 N_noxref_52_c_16583_n N_noxref_52_c_16546_n N_noxref_52_c_16553_n \
 N_noxref_52_c_16591_n N_noxref_52_M38_noxref_s )  PM_TMRDFFSNQX1\%noxref_52
x_PM_TMRDFFSNQX1\%noxref_53 ( N_noxref_53_c_16604_n N_noxref_53_c_16605_n \
 N_noxref_53_c_16646_n N_noxref_53_c_16612_n N_noxref_53_c_16617_n \
 N_noxref_53_c_16654_n N_noxref_53_M40_noxref_s )  PM_TMRDFFSNQX1\%noxref_53
x_PM_TMRDFFSNQX1\%noxref_54 ( N_noxref_54_c_16672_n N_noxref_54_c_16673_n \
 N_noxref_54_c_16697_n N_noxref_54_c_16686_n N_noxref_54_c_16670_n \
 N_noxref_54_M42_noxref_s )  PM_TMRDFFSNQX1\%noxref_54
x_PM_TMRDFFSNQX1\%noxref_55 ( N_noxref_55_c_16729_n N_noxref_55_c_16730_n \
 N_noxref_55_c_16775_n N_noxref_55_c_16731_n N_noxref_55_c_16735_n \
 N_noxref_55_c_16783_n N_noxref_55_M45_noxref_s )  PM_TMRDFFSNQX1\%noxref_55
x_PM_TMRDFFSNQX1\%noxref_57 ( N_noxref_57_c_16804_n N_noxref_57_c_16805_n \
 N_noxref_57_c_16846_n N_noxref_57_c_16812_n N_noxref_57_c_16820_n \
 N_noxref_57_c_16854_n N_noxref_57_M47_noxref_s )  PM_TMRDFFSNQX1\%noxref_57
x_PM_TMRDFFSNQX1\%noxref_58 ( N_noxref_58_c_16880_n N_noxref_58_c_16867_n \
 N_noxref_58_c_16915_n N_noxref_58_c_16868_n N_noxref_58_c_16872_n \
 N_noxref_58_c_16923_n N_noxref_58_M49_noxref_s )  PM_TMRDFFSNQX1\%noxref_58
cc_1 ( N_noxref_1_M63_noxref_g N_noxref_2_c_414_n ) capacitor c=0.00893512f \
 //x=10.38 //y=6.2 //x2=10.92 //y2=5.335
cc_2 ( N_noxref_1_M62_noxref_g N_noxref_2_c_415_n ) capacitor c=0.00461408f \
 //x=9.94 //y=6.2 //x2=10.162 //y2=5.335
cc_3 ( N_noxref_1_M63_noxref_g N_noxref_2_c_415_n ) capacitor c=0.00229208f \
 //x=10.38 //y=6.2 //x2=10.162 //y2=5.335
cc_4 ( N_noxref_1_c_4_p N_noxref_2_c_415_n ) capacitor c=0.00171885f \
 //x=10.305 //y=4.97 //x2=10.162 //y2=5.335
cc_5 ( N_noxref_1_c_5_p N_noxref_2_c_418_n ) capacitor c=4.26537e-19 //x=9.74 \
 //y=2.77 //x2=12.7 //y2=2.77
cc_6 ( N_noxref_1_M62_noxref_g N_noxref_2_c_419_n ) capacitor c=0.0162284f \
 //x=9.94 //y=6.2 //x2=10.16 //y2=5.56
cc_7 ( N_noxref_1_M63_noxref_g N_noxref_2_c_419_n ) capacitor c=0.0179041f \
 //x=10.38 //y=6.2 //x2=10.16 //y2=5.56
cc_8 ( N_noxref_1_c_4_p N_noxref_2_c_419_n ) capacitor c=0.00291477f \
 //x=10.305 //y=4.97 //x2=10.16 //y2=5.56
cc_9 ( N_noxref_1_c_9_p N_noxref_3_c_711_n ) capacitor c=0.0092434f //x=3.08 \
 //y=2.61 //x2=2.34 //y2=4.085
cc_10 ( N_noxref_1_c_10_p N_noxref_3_c_711_n ) capacitor c=0.0148501f //x=3.08 \
 //y=2.93 //x2=2.34 //y2=4.085
cc_11 ( N_noxref_1_c_11_p N_noxref_3_c_711_n ) capacitor c=0.0514823f //x=3.08 \
 //y=5.295 //x2=2.34 //y2=4.085
cc_12 ( N_noxref_1_c_12_p N_noxref_3_c_711_n ) capacitor c=6.31188e-19 \
 //x=4.93 //y=2.61 //x2=2.34 //y2=4.085
cc_13 ( N_noxref_1_c_13_p N_noxref_3_c_711_n ) capacitor c=0.00116918f \
 //x=4.93 //y=4.755 //x2=2.34 //y2=4.085
cc_14 ( N_noxref_1_c_14_p N_noxref_3_c_711_n ) capacitor c=6.20144e-19 \
 //x=3.08 //y=2.77 //x2=2.34 //y2=4.085
cc_15 ( N_noxref_1_c_15_p N_noxref_3_c_711_n ) capacitor c=0.00686847f \
 //x=3.24 //y=2.77 //x2=2.34 //y2=4.085
cc_16 ( N_noxref_1_c_16_p N_noxref_3_c_718_n ) capacitor c=0.00212208f \
 //x=2.485 //y=5.38 //x2=2.34 //y2=4.405
cc_17 ( N_noxref_1_c_17_p N_noxref_3_c_718_n ) capacitor c=3.82061e-19 \
 //x=2.725 //y=1.835 //x2=2.34 //y2=4.405
cc_18 ( N_noxref_1_c_11_p N_noxref_3_c_718_n ) capacitor c=0.0173413f //x=3.08 \
 //y=5.295 //x2=2.34 //y2=4.405
cc_19 ( N_noxref_1_c_19_p N_noxref_3_c_718_n ) capacitor c=0.00245839f //x=2.6 \
 //y=5.38 //x2=2.34 //y2=4.405
cc_20 ( N_noxref_1_c_20_p N_noxref_3_c_718_n ) capacitor c=8.00244e-19 //x=2.6 \
 //y=5.56 //x2=2.34 //y2=4.405
cc_21 ( N_noxref_1_c_16_p N_noxref_3_c_723_n ) capacitor c=0.0222581f \
 //x=2.485 //y=5.38 //x2=2.34 //y2=4.735
cc_22 ( N_noxref_1_c_11_p N_noxref_3_c_723_n ) capacitor c=0.0306018f //x=3.08 \
 //y=5.295 //x2=2.34 //y2=4.735
cc_23 ( N_noxref_1_c_13_p N_noxref_3_c_723_n ) capacitor c=0.00105013f \
 //x=4.93 //y=4.755 //x2=2.34 //y2=4.735
cc_24 ( N_noxref_1_M57_noxref_g N_noxref_3_c_726_n ) capacitor c=0.00973141f \
 //x=5.57 //y=6.2 //x2=6.11 //y2=5.335
cc_25 ( N_noxref_1_c_25_p N_noxref_3_c_727_n ) capacitor c=5.30005e-19 \
 //x=9.58 //y=2.775 //x2=7.405 //y2=1.305
cc_26 ( N_noxref_1_c_26_p N_noxref_3_c_728_n ) capacitor c=8.09327e-19 \
 //x=2.995 //y=1.835 //x2=7.405 //y2=1.76
cc_27 ( N_noxref_1_c_9_p N_noxref_3_c_729_n ) capacitor c=8.09327e-19 //x=3.08 \
 //y=2.61 //x2=7.49 //y2=1.845
cc_28 ( N_noxref_1_c_25_p N_noxref_3_c_729_n ) capacitor c=0.0143136f //x=9.58 \
 //y=2.775 //x2=7.49 //y2=1.845
cc_29 ( N_noxref_1_c_29_p N_noxref_3_c_731_n ) capacitor c=0.00458539f \
 //x=9.74 //y=2.375 //x2=7.89 //y2=4.09
cc_30 ( N_noxref_1_c_30_p N_noxref_3_c_731_n ) capacitor c=0.0035808f //x=9.74 \
 //y=2.615 //x2=7.89 //y2=4.09
cc_31 ( N_noxref_1_c_31_p N_noxref_3_c_731_n ) capacitor c=0.00248106f \
 //x=9.74 //y=2.935 //x2=7.89 //y2=4.09
cc_32 ( N_noxref_1_c_32_p N_noxref_3_c_731_n ) capacitor c=0.0170488f //x=9.74 \
 //y=4.755 //x2=7.89 //y2=4.09
cc_33 ( N_noxref_1_c_33_p N_noxref_3_c_731_n ) capacitor c=0.0015808f //x=9.74 \
 //y=2.775 //x2=7.89 //y2=4.09
cc_34 ( N_noxref_1_c_25_p N_noxref_3_c_731_n ) capacitor c=0.0282561f //x=9.58 \
 //y=2.775 //x2=7.89 //y2=4.09
cc_35 ( N_noxref_1_c_32_p N_noxref_3_c_737_n ) capacitor c=0.00251118f \
 //x=9.74 //y=4.755 //x2=7.89 //y2=4.41
cc_36 ( N_noxref_1_c_32_p N_noxref_3_c_738_n ) capacitor c=0.00765202f \
 //x=9.74 //y=4.755 //x2=7.89 //y2=5.25
cc_37 ( N_noxref_1_c_9_p N_noxref_3_c_739_n ) capacitor c=0.015397f //x=3.08 \
 //y=2.61 //x2=2.34 //y2=2.26
cc_38 ( N_noxref_1_c_11_p N_noxref_3_c_740_n ) capacitor c=5.56185e-19 \
 //x=3.08 //y=5.295 //x2=2.34 //y2=4.25
cc_39 ( N_noxref_1_c_11_p N_noxref_3_c_741_n ) capacitor c=0.00261914f \
 //x=3.08 //y=5.295 //x2=5.352 //y2=5.335
cc_40 ( N_noxref_1_c_19_p N_noxref_3_c_741_n ) capacitor c=5.0812e-19 //x=2.6 \
 //y=5.38 //x2=5.352 //y2=5.335
cc_41 ( N_noxref_1_M56_noxref_g N_noxref_3_c_741_n ) capacitor c=0.00461408f \
 //x=5.13 //y=6.2 //x2=5.352 //y2=5.335
cc_42 ( N_noxref_1_M57_noxref_g N_noxref_3_c_741_n ) capacitor c=0.00229208f \
 //x=5.57 //y=6.2 //x2=5.352 //y2=5.335
cc_43 ( N_noxref_1_c_43_p N_noxref_3_c_741_n ) capacitor c=0.00171885f \
 //x=5.495 //y=4.97 //x2=5.352 //y2=5.335
cc_44 ( N_noxref_1_c_11_p N_noxref_3_c_746_n ) capacitor c=0.0322916f //x=3.08 \
 //y=5.295 //x2=7.725 //y2=4.25
cc_45 ( N_noxref_1_c_13_p N_noxref_3_c_746_n ) capacitor c=0.0367019f //x=4.93 \
 //y=4.755 //x2=7.725 //y2=4.25
cc_46 ( N_noxref_1_c_19_p N_noxref_3_c_746_n ) capacitor c=0.0147063f //x=2.6 \
 //y=5.38 //x2=7.725 //y2=4.25
cc_47 ( N_noxref_1_c_47_p N_noxref_3_c_746_n ) capacitor c=0.0045069f //x=4.77 \
 //y=2.77 //x2=7.725 //y2=4.25
cc_48 ( N_noxref_1_c_25_p N_noxref_3_c_746_n ) capacitor c=0.0106455f //x=9.58 \
 //y=2.775 //x2=7.725 //y2=4.25
cc_49 ( N_noxref_1_c_32_p N_noxref_3_c_751_n ) capacitor c=0.00157696f \
 //x=9.74 //y=4.755 //x2=8.045 //y2=4.25
cc_50 ( N_noxref_1_c_16_p N_noxref_3_c_752_n ) capacitor c=0.00119162f \
 //x=2.485 //y=5.38 //x2=2.5 //y2=4.245
cc_51 ( N_noxref_1_c_11_p N_noxref_3_c_752_n ) capacitor c=0.0032735f //x=3.08 \
 //y=5.295 //x2=2.5 //y2=4.245
cc_52 ( N_noxref_1_c_19_p N_noxref_3_c_752_n ) capacitor c=2.41886e-19 //x=2.6 \
 //y=5.38 //x2=2.5 //y2=4.245
cc_53 ( N_noxref_1_c_32_p N_noxref_3_c_755_n ) capacitor c=0.0245637f //x=9.74 \
 //y=4.755 //x2=17.72 //y2=4.265
cc_54 ( N_noxref_1_c_9_p N_noxref_3_c_756_n ) capacitor c=9.90728e-19 //x=3.08 \
 //y=2.61 //x2=2.34 //y2=2.26
cc_55 ( N_noxref_1_c_16_p N_noxref_3_c_757_n ) capacitor c=0.00469257f \
 //x=2.485 //y=5.38 //x2=2.37 //y2=4.88
cc_56 ( N_noxref_1_c_11_p N_noxref_3_c_757_n ) capacitor c=7.76118e-19 \
 //x=3.08 //y=5.295 //x2=2.37 //y2=4.88
cc_57 ( N_noxref_1_M56_noxref_g N_noxref_3_c_759_n ) capacitor c=0.0162284f \
 //x=5.13 //y=6.2 //x2=5.35 //y2=5.56
cc_58 ( N_noxref_1_M57_noxref_g N_noxref_3_c_759_n ) capacitor c=0.0179041f \
 //x=5.57 //y=6.2 //x2=5.35 //y2=5.56
cc_59 ( N_noxref_1_c_43_p N_noxref_3_c_759_n ) capacitor c=0.00291477f \
 //x=5.495 //y=4.97 //x2=5.35 //y2=5.56
cc_60 ( N_noxref_1_c_16_p N_noxref_3_M54_noxref_g ) capacitor c=0.00842859f \
 //x=2.485 //y=5.38 //x2=2.38 //y2=6.2
cc_61 ( N_noxref_1_c_19_p N_noxref_3_M54_noxref_g ) capacitor c=0.00192712f \
 //x=2.6 //y=5.38 //x2=2.38 //y2=6.2
cc_62 ( N_noxref_1_c_20_p N_noxref_3_M54_noxref_g ) capacitor c=0.0178987f \
 //x=2.6 //y=5.56 //x2=2.38 //y2=6.2
cc_63 ( N_noxref_1_c_63_p N_noxref_3_M55_noxref_g ) capacitor c=0.0110279f \
 //x=2.995 //y=5.38 //x2=2.82 //y2=6.2
cc_64 ( N_noxref_1_c_19_p N_noxref_3_M55_noxref_g ) capacitor c=0.00312463f \
 //x=2.6 //y=5.38 //x2=2.82 //y2=6.2
cc_65 ( N_noxref_1_c_20_p N_noxref_3_M55_noxref_g ) capacitor c=0.0178506f \
 //x=2.6 //y=5.56 //x2=2.82 //y2=6.2
cc_66 ( N_noxref_1_c_66_p N_noxref_3_c_768_n ) capacitor c=0.00120406f \
 //x=2.64 //y=1.18 //x2=2.375 //y2=1.085
cc_67 ( N_noxref_1_M1_noxref_d N_noxref_3_c_768_n ) capacitor c=0.00137165f \
 //x=2.45 //y=1.085 //x2=2.375 //y2=1.085
cc_68 ( N_noxref_1_c_68_p N_noxref_3_c_770_n ) capacitor c=0.00127432f \
 //x=2.64 //y=1.75 //x2=2.375 //y2=1.43
cc_69 ( N_noxref_1_c_66_p N_noxref_3_c_770_n ) capacitor c=0.00220847f \
 //x=2.64 //y=1.18 //x2=2.375 //y2=1.43
cc_70 ( N_noxref_1_M1_noxref_d N_noxref_3_c_770_n ) capacitor c=0.00237422f \
 //x=2.45 //y=1.085 //x2=2.375 //y2=1.43
cc_71 ( N_noxref_1_c_68_p N_noxref_3_c_773_n ) capacitor c=0.00454577f \
 //x=2.64 //y=1.75 //x2=2.375 //y2=1.74
cc_72 ( N_noxref_1_c_11_p N_noxref_3_c_774_n ) capacitor c=0.00874009f \
 //x=3.08 //y=5.295 //x2=2.745 //y2=4.97
cc_73 ( N_noxref_1_c_19_p N_noxref_3_c_774_n ) capacitor c=0.0020269f //x=2.6 \
 //y=5.38 //x2=2.745 //y2=4.97
cc_74 ( N_noxref_1_c_20_p N_noxref_3_c_774_n ) capacitor c=0.00302834f //x=2.6 \
 //y=5.56 //x2=2.745 //y2=4.97
cc_75 ( N_noxref_1_c_66_p N_noxref_3_c_777_n ) capacitor c=5.50523e-19 \
 //x=2.64 //y=1.18 //x2=2.75 //y2=0.93
cc_76 ( N_noxref_1_M1_noxref_d N_noxref_3_c_777_n ) capacitor c=0.0020782f \
 //x=2.45 //y=1.085 //x2=2.75 //y2=0.93
cc_77 ( N_noxref_1_c_68_p N_noxref_3_c_779_n ) capacitor c=0.00942306f \
 //x=2.64 //y=1.75 //x2=2.75 //y2=1.585
cc_78 ( N_noxref_1_c_26_p N_noxref_3_c_779_n ) capacitor c=0.00194324f \
 //x=2.995 //y=1.835 //x2=2.75 //y2=1.585
cc_79 ( N_noxref_1_c_66_p N_noxref_3_c_779_n ) capacitor c=5.43945e-19 \
 //x=2.64 //y=1.18 //x2=2.75 //y2=1.585
cc_80 ( N_noxref_1_M1_noxref_d N_noxref_3_c_779_n ) capacitor c=0.00356097f \
 //x=2.45 //y=1.085 //x2=2.75 //y2=1.585
cc_81 ( N_noxref_1_c_66_p N_noxref_3_c_783_n ) capacitor c=0.00108157f \
 //x=2.64 //y=1.18 //x2=2.905 //y2=1.085
cc_82 ( N_noxref_1_M1_noxref_d N_noxref_3_c_783_n ) capacitor c=8.50095e-19 \
 //x=2.45 //y=1.085 //x2=2.905 //y2=1.085
cc_83 ( N_noxref_1_c_68_p N_noxref_3_c_785_n ) capacitor c=0.00341295f \
 //x=2.64 //y=1.75 //x2=2.905 //y2=1.43
cc_84 ( N_noxref_1_c_26_p N_noxref_3_c_785_n ) capacitor c=0.00323005f \
 //x=2.995 //y=1.835 //x2=2.905 //y2=1.43
cc_85 ( N_noxref_1_c_66_p N_noxref_3_c_785_n ) capacitor c=0.00312028f \
 //x=2.64 //y=1.18 //x2=2.905 //y2=1.43
cc_86 ( N_noxref_1_M1_noxref_d N_noxref_3_c_785_n ) capacitor c=0.00237422f \
 //x=2.45 //y=1.085 //x2=2.905 //y2=1.43
cc_87 ( N_noxref_1_c_9_p N_noxref_3_c_789_n ) capacitor c=0.00285392f //x=3.08 \
 //y=2.61 //x2=2.34 //y2=2.26
cc_88 ( N_noxref_1_c_68_p N_noxref_3_c_790_n ) capacitor c=0.00371023f \
 //x=2.64 //y=1.75 //x2=2.34 //y2=2.095
cc_89 ( N_noxref_1_c_9_p N_noxref_3_c_790_n ) capacitor c=0.00341496f //x=3.08 \
 //y=2.61 //x2=2.34 //y2=2.095
cc_90 ( N_noxref_1_c_16_p N_noxref_3_c_792_n ) capacitor c=8.43115e-19 \
 //x=2.485 //y=5.38 //x2=2.37 //y2=4.88
cc_91 ( N_noxref_1_c_11_p N_noxref_3_c_792_n ) capacitor c=0.00142201f \
 //x=3.08 //y=5.295 //x2=2.37 //y2=4.88
cc_92 ( N_noxref_1_c_25_p N_noxref_5_c_1491_n ) capacitor c=0.00309104f \
 //x=9.58 //y=2.775 //x2=7.15 //y2=2.375
cc_93 ( N_noxref_1_c_12_p N_noxref_5_c_1492_n ) capacitor c=3.89313e-19 \
 //x=4.93 //y=2.61 //x2=7.15 //y2=3.705
cc_94 ( N_noxref_1_c_13_p N_noxref_5_c_1492_n ) capacitor c=5.79486e-19 \
 //x=4.93 //y=4.755 //x2=7.15 //y2=3.705
cc_95 ( N_noxref_1_c_30_p N_noxref_5_c_1492_n ) capacitor c=6.49065e-19 \
 //x=9.74 //y=2.615 //x2=7.15 //y2=3.705
cc_96 ( N_noxref_1_c_32_p N_noxref_5_c_1492_n ) capacitor c=6.59168e-19 \
 //x=9.74 //y=4.755 //x2=7.15 //y2=3.705
cc_97 ( N_noxref_1_c_25_p N_noxref_5_c_1492_n ) capacitor c=0.0259664f \
 //x=9.58 //y=2.775 //x2=7.15 //y2=3.705
cc_98 ( N_noxref_1_c_13_p N_noxref_5_c_1497_n ) capacitor c=0.00107139f \
 //x=4.93 //y=4.755 //x2=7.15 //y2=4.75
cc_99 ( N_noxref_1_c_32_p N_noxref_5_c_1497_n ) capacitor c=0.00104627f \
 //x=9.74 //y=4.755 //x2=7.15 //y2=4.75
cc_100 ( N_noxref_1_c_30_p N_noxref_5_c_1499_n ) capacitor c=4.47631e-19 \
 //x=9.74 //y=2.615 //x2=11.96 //y2=3.705
cc_101 ( N_noxref_1_c_32_p N_noxref_5_c_1499_n ) capacitor c=5.85646e-19 \
 //x=9.74 //y=4.755 //x2=11.96 //y2=3.705
cc_102 ( N_noxref_1_c_32_p N_noxref_5_c_1501_n ) capacitor c=5.89264e-19 \
 //x=9.74 //y=4.755 //x2=11.96 //y2=4.75
cc_103 ( N_noxref_1_c_25_p N_noxref_5_c_1502_n ) capacitor c=0.00470915f \
 //x=9.58 //y=2.775 //x2=7.5 //y2=3.88
cc_104 ( N_noxref_1_c_32_p N_noxref_5_c_1503_n ) capacitor c=0.0274638f \
 //x=9.74 //y=4.755 //x2=12.12 //y2=3.88
cc_105 ( N_noxref_1_c_25_p N_noxref_5_c_1503_n ) capacitor c=0.00489547f \
 //x=9.58 //y=2.775 //x2=12.12 //y2=3.88
cc_106 ( N_noxref_1_c_9_p D ) capacitor c=0.00102483f //x=3.08 //y=2.61 \
 //x2=1.6 //y2=2.77
cc_107 ( N_noxref_1_c_11_p D ) capacitor c=0.0040556f //x=3.08 //y=5.295 \
 //x2=1.6 //y2=3.51
cc_108 ( N_noxref_1_c_108_p N_D_c_4936_n ) capacitor c=0.00147917f //x=1.72 \
 //y=5.56 //x2=1.6 //y2=3.305
cc_109 ( N_noxref_1_c_108_p N_D_c_4937_n ) capacitor c=0.0118387f //x=1.72 \
 //y=5.56 //x2=1.6 //y2=4.88
cc_110 ( N_noxref_1_c_110_p N_D_c_4937_n ) capacitor c=0.00104426f //x=1.72 \
 //y=5.56 //x2=1.6 //y2=4.88
cc_111 ( N_noxref_1_c_16_p N_D_c_4939_n ) capacitor c=0.00837199f //x=2.485 \
 //y=5.38 //x2=2.695 //y2=3.14
cc_112 ( N_noxref_1_c_26_p N_D_c_4939_n ) capacitor c=0.00309259f //x=2.995 \
 //y=1.835 //x2=2.695 //y2=3.14
cc_113 ( N_noxref_1_c_17_p N_D_c_4939_n ) capacitor c=0.00533783f //x=2.725 \
 //y=1.835 //x2=2.695 //y2=3.14
cc_114 ( N_noxref_1_c_10_p N_D_c_4939_n ) capacitor c=0.0015398f //x=3.08 \
 //y=2.93 //x2=2.695 //y2=3.14
cc_115 ( N_noxref_1_c_11_p N_D_c_4939_n ) capacitor c=3.27267e-19 //x=3.08 \
 //y=5.295 //x2=2.695 //y2=3.14
cc_116 ( N_noxref_1_c_108_p N_D_c_4939_n ) capacitor c=8.60631e-19 //x=1.72 \
 //y=5.56 //x2=2.695 //y2=3.14
cc_117 ( N_noxref_1_c_66_p N_D_c_4939_n ) capacitor c=4.35456e-19 //x=2.64 \
 //y=1.18 //x2=2.695 //y2=3.14
cc_118 ( N_noxref_1_c_15_p N_D_c_4939_n ) capacitor c=0.0367952f //x=3.24 \
 //y=2.77 //x2=2.695 //y2=3.14
cc_119 ( N_noxref_1_c_10_p N_D_c_4947_n ) capacitor c=0.00956883f //x=3.08 \
 //y=2.93 //x2=3.295 //y2=3.155
cc_120 ( N_noxref_1_c_11_p N_D_c_4947_n ) capacitor c=0.0270222f //x=3.08 \
 //y=5.295 //x2=3.295 //y2=3.155
cc_121 ( N_noxref_1_c_47_p N_D_c_4947_n ) capacitor c=0.133854f //x=4.77 \
 //y=2.77 //x2=3.295 //y2=3.155
cc_122 ( N_noxref_1_c_122_p N_D_c_4950_n ) capacitor c=0.00179019f //x=4.93 \
 //y=2.93 //x2=4.545 //y2=3.14
cc_123 ( N_noxref_1_c_13_p N_D_c_4950_n ) capacitor c=5.02803e-19 //x=4.93 \
 //y=4.755 //x2=4.545 //y2=3.14
cc_124 ( N_noxref_1_c_47_p N_D_c_4950_n ) capacitor c=0.0126229f //x=4.77 \
 //y=2.77 //x2=4.545 //y2=3.14
cc_125 ( N_noxref_1_c_125_p N_D_c_4950_n ) capacitor c=0.0367952f //x=5.09 \
 //y=2.77 //x2=4.545 //y2=3.14
cc_126 ( N_noxref_1_c_122_p N_D_c_4954_n ) capacitor c=0.00693044f //x=4.93 \
 //y=2.93 //x2=5.145 //y2=3.155
cc_127 ( N_noxref_1_c_13_p N_D_c_4954_n ) capacitor c=0.028304f //x=4.93 \
 //y=4.755 //x2=5.145 //y2=3.155
cc_128 ( N_noxref_1_c_25_p N_D_c_4954_n ) capacitor c=0.396754f //x=9.58 \
 //y=2.775 //x2=5.145 //y2=3.155
cc_129 ( N_noxref_1_c_31_p N_D_c_4957_n ) capacitor c=0.00515354f //x=9.74 \
 //y=2.935 //x2=9.355 //y2=3.14
cc_130 ( N_noxref_1_c_32_p N_D_c_4957_n ) capacitor c=6.2418e-19 //x=9.74 \
 //y=4.755 //x2=9.355 //y2=3.14
cc_131 ( N_noxref_1_c_33_p N_D_c_4957_n ) capacitor c=0.0367952f //x=9.74 \
 //y=2.775 //x2=9.355 //y2=3.14
cc_132 ( N_noxref_1_c_25_p N_D_c_4957_n ) capacitor c=0.0112991f //x=9.58 \
 //y=2.775 //x2=9.355 //y2=3.14
cc_133 ( N_noxref_1_c_31_p N_D_c_4961_n ) capacitor c=0.00356853f //x=9.74 \
 //y=2.935 //x2=9.955 //y2=3.16
cc_134 ( N_noxref_1_c_32_p N_D_c_4961_n ) capacitor c=0.0269833f //x=9.74 \
 //y=4.755 //x2=9.955 //y2=3.16
cc_135 ( N_noxref_1_c_108_p N_D_c_4963_n ) capacitor c=4.19415e-19 //x=1.72 \
 //y=5.56 //x2=1.765 //y2=3.145
cc_136 ( N_noxref_1_c_108_p N_D_c_4964_n ) capacitor c=0.00277154f //x=1.72 \
 //y=5.56 //x2=1.6 //y2=4.88
cc_137 ( N_noxref_1_c_110_p N_D_c_4964_n ) capacitor c=0.00377369f //x=1.72 \
 //y=5.56 //x2=1.6 //y2=4.88
cc_138 ( N_noxref_1_c_108_p N_D_M52_noxref_g ) capacitor c=0.0020878f //x=1.72 \
 //y=5.56 //x2=1.5 //y2=6.2
cc_139 ( N_noxref_1_c_110_p N_D_M52_noxref_g ) capacitor c=0.0158358f //x=1.72 \
 //y=5.56 //x2=1.5 //y2=6.2
cc_140 ( N_noxref_1_c_16_p N_D_M53_noxref_g ) capacitor c=0.0112686f //x=2.485 \
 //y=5.38 //x2=1.94 //y2=6.2
cc_141 ( N_noxref_1_c_108_p N_D_M53_noxref_g ) capacitor c=0.00192712f \
 //x=1.72 //y=5.56 //x2=1.94 //y2=6.2
cc_142 ( N_noxref_1_c_110_p N_D_M53_noxref_g ) capacitor c=0.0178987f //x=1.72 \
 //y=5.56 //x2=1.94 //y2=6.2
cc_143 ( N_noxref_1_c_108_p N_D_c_4971_n ) capacitor c=0.00192899f //x=1.72 \
 //y=5.56 //x2=1.6 //y2=4.88
cc_144 ( N_noxref_1_c_110_p N_D_c_4971_n ) capacitor c=0.0043218f //x=1.72 \
 //y=5.56 //x2=1.6 //y2=4.88
cc_145 ( N_noxref_1_c_9_p CLK ) capacitor c=5.24004e-19 //x=3.08 //y=2.61 \
 //x2=6.04 //y2=2.4
cc_146 ( N_noxref_1_c_11_p CLK ) capacitor c=0.00128459f //x=3.08 //y=5.295 \
 //x2=6.04 //y2=2.4
cc_147 ( N_noxref_1_c_12_p CLK ) capacitor c=0.00648708f //x=4.93 //y=2.61 \
 //x2=6.04 //y2=2.4
cc_148 ( N_noxref_1_c_122_p CLK ) capacitor c=0.00765388f //x=4.93 //y=2.93 \
 //x2=6.04 //y2=2.4
cc_149 ( N_noxref_1_c_13_p CLK ) capacitor c=0.045347f //x=4.93 //y=4.755 \
 //x2=6.04 //y2=2.4
cc_150 ( N_noxref_1_c_150_p CLK ) capacitor c=2.98349e-19 //x=4.93 //y=2.765 \
 //x2=6.04 //y2=2.4
cc_151 ( N_noxref_1_c_125_p CLK ) capacitor c=0.00242466f //x=5.09 //y=2.77 \
 //x2=6.04 //y2=2.4
cc_152 ( N_noxref_1_c_25_p CLK ) capacitor c=0.0268373f //x=9.58 //y=2.775 \
 //x2=6.04 //y2=2.4
cc_153 ( N_noxref_1_c_153_p CLK ) capacitor c=4.16726e-19 //x=4.93 //y=2.26 \
 //x2=6.04 //y2=2.4
cc_154 ( N_noxref_1_c_154_p N_CLK_c_6294_n ) capacitor c=0.0115546f //x=4.93 \
 //y=2.375 //x2=6.04 //y2=2.375
cc_155 ( N_noxref_1_c_25_p N_CLK_c_6294_n ) capacitor c=0.00386237f //x=9.58 \
 //y=2.775 //x2=6.04 //y2=2.375
cc_156 ( N_noxref_1_c_153_p N_CLK_c_6294_n ) capacitor c=5.40058e-19 //x=4.93 \
 //y=2.26 //x2=6.04 //y2=2.375
cc_157 ( N_noxref_1_c_157_p N_CLK_c_6294_n ) capacitor c=0.00147006f //x=4.63 \
 //y=2.095 //x2=6.04 //y2=2.375
cc_158 ( N_noxref_1_c_13_p N_CLK_c_6298_n ) capacitor c=0.0119263f //x=4.93 \
 //y=4.755 //x2=6.04 //y2=4.755
cc_159 ( N_noxref_1_c_159_p N_CLK_c_6298_n ) capacitor c=8.35331e-19 //x=4.93 \
 //y=4.88 //x2=6.04 //y2=4.755
cc_160 ( N_noxref_1_c_43_p N_CLK_c_6298_n ) capacitor c=7.55789e-19 //x=5.495 \
 //y=4.97 //x2=6.04 //y2=4.755
cc_161 ( N_noxref_1_c_161_p N_CLK_c_6298_n ) capacitor c=8.63332e-19 //x=5.205 \
 //y=4.97 //x2=6.04 //y2=4.755
cc_162 ( N_noxref_1_c_32_p N_CLK_c_6302_n ) capacitor c=0.0332184f //x=9.74 \
 //y=4.755 //x2=17.75 //y2=4.65
cc_163 ( N_noxref_1_c_13_p N_CLK_c_6303_n ) capacitor c=0.00733425f //x=4.93 \
 //y=4.755 //x2=6.04 //y2=4.62
cc_164 ( N_noxref_1_c_154_p N_CLK_c_6304_n ) capacitor c=5.39999e-19 //x=4.93 \
 //y=2.375 //x2=6.04 //y2=2.26
cc_165 ( N_noxref_1_c_12_p N_CLK_c_6304_n ) capacitor c=4.16726e-19 //x=4.93 \
 //y=2.61 //x2=6.04 //y2=2.26
cc_166 ( N_noxref_1_c_153_p N_CLK_c_6304_n ) capacitor c=0.00125213f //x=4.93 \
 //y=2.26 //x2=6.04 //y2=2.26
cc_167 ( N_noxref_1_c_157_p N_CLK_c_6304_n ) capacitor c=0.00214573f //x=4.63 \
 //y=2.095 //x2=6.04 //y2=2.26
cc_168 ( N_noxref_1_c_13_p N_CLK_c_6308_n ) capacitor c=5.64453e-19 //x=4.93 \
 //y=4.755 //x2=6.04 //y2=4.88
cc_169 ( N_noxref_1_c_159_p N_CLK_c_6308_n ) capacitor c=0.00113668f //x=4.93 \
 //y=4.88 //x2=6.04 //y2=4.88
cc_170 ( N_noxref_1_c_43_p N_CLK_c_6308_n ) capacitor c=0.00116563f //x=5.495 \
 //y=4.97 //x2=6.04 //y2=4.88
cc_171 ( N_noxref_1_c_161_p N_CLK_c_6308_n ) capacitor c=0.0012974f //x=5.205 \
 //y=4.97 //x2=6.04 //y2=4.88
cc_172 ( N_noxref_1_M56_noxref_g N_CLK_M58_noxref_g ) capacitor c=0.0106276f \
 //x=5.13 //y=6.2 //x2=6.01 //y2=6.2
cc_173 ( N_noxref_1_M57_noxref_g N_CLK_M58_noxref_g ) capacitor c=0.107144f \
 //x=5.57 //y=6.2 //x2=6.01 //y2=6.2
cc_174 ( N_noxref_1_M57_noxref_g N_CLK_M59_noxref_g ) capacitor c=0.0101598f \
 //x=5.57 //y=6.2 //x2=6.45 //y2=6.2
cc_175 ( N_noxref_1_c_175_p N_CLK_c_6315_n ) capacitor c=5.72528e-19 //x=4.63 \
 //y=1.055 //x2=5.605 //y2=1.09
cc_176 ( N_noxref_1_c_176_p N_CLK_c_6315_n ) capacitor c=0.00150277f //x=4.63 \
 //y=1.4 //x2=5.605 //y2=1.09
cc_177 ( N_noxref_1_c_177_p N_CLK_c_6315_n ) capacitor c=0.0160123f //x=5.16 \
 //y=1.055 //x2=5.605 //y2=1.09
cc_178 ( N_noxref_1_c_178_p N_CLK_c_6318_n ) capacitor c=0.00111227f //x=4.63 \
 //y=1.71 //x2=5.605 //y2=1.4
cc_179 ( N_noxref_1_c_179_p N_CLK_c_6318_n ) capacitor c=0.0124075f //x=5.16 \
 //y=1.4 //x2=5.605 //y2=1.4
cc_180 ( N_noxref_1_c_177_p N_CLK_c_6320_n ) capacitor c=9.19165e-19 //x=5.16 \
 //y=1.055 //x2=6.13 //y2=1.09
cc_181 ( N_noxref_1_c_179_p N_CLK_c_6321_n ) capacitor c=0.0010154f //x=5.16 \
 //y=1.4 //x2=6.13 //y2=1.4
cc_182 ( N_noxref_1_c_179_p N_CLK_c_6322_n ) capacitor c=9.23422e-19 //x=5.16 \
 //y=1.4 //x2=6.13 //y2=1.63
cc_183 ( N_noxref_1_c_154_p N_CLK_c_6323_n ) capacitor c=0.00140534f //x=4.93 \
 //y=2.375 //x2=6.13 //y2=2.095
cc_184 ( N_noxref_1_c_153_p N_CLK_c_6323_n ) capacitor c=0.0020754f //x=4.93 \
 //y=2.26 //x2=6.13 //y2=2.095
cc_185 ( N_noxref_1_c_157_p N_CLK_c_6323_n ) capacitor c=0.00964411f //x=4.63 \
 //y=2.095 //x2=6.13 //y2=2.095
cc_186 ( N_noxref_1_c_159_p N_CLK_c_6326_n ) capacitor c=0.00123917f //x=4.93 \
 //y=4.88 //x2=6.04 //y2=4.88
cc_187 ( N_noxref_1_c_43_p N_CLK_c_6326_n ) capacitor c=0.0171228f //x=5.495 \
 //y=4.97 //x2=6.04 //y2=4.88
cc_188 ( N_noxref_1_c_161_p N_CLK_c_6326_n ) capacitor c=0.00406071f //x=5.205 \
 //y=4.97 //x2=6.04 //y2=4.88
cc_189 ( N_noxref_1_c_30_p SN ) capacitor c=0.00188309f //x=9.74 //y=2.615 \
 //x2=10.85 //y2=2.77
cc_190 ( N_noxref_1_c_31_p SN ) capacitor c=0.00775314f //x=9.74 //y=2.935 \
 //x2=10.85 //y2=2.77
cc_191 ( N_noxref_1_c_32_p SN ) capacitor c=0.0448639f //x=9.74 //y=4.755 \
 //x2=10.85 //y2=2.77
cc_192 ( N_noxref_1_c_5_p SN ) capacitor c=2.69051e-19 //x=9.74 //y=2.77 \
 //x2=10.85 //y2=2.77
cc_193 ( N_noxref_1_c_33_p SN ) capacitor c=0.00508119f //x=9.74 //y=2.775 \
 //x2=10.85 //y2=2.77
cc_194 ( N_noxref_1_c_194_p SN ) capacitor c=3.36194e-19 //x=9.74 //y=4.88 \
 //x2=10.85 //y2=2.77
cc_195 ( N_noxref_1_c_29_p N_SN_c_8051_n ) capacitor c=0.00840403f //x=9.74 \
 //y=2.375 //x2=10.85 //y2=2.55
cc_196 ( N_noxref_1_c_30_p N_SN_c_8051_n ) capacitor c=0.00398079f //x=9.74 \
 //y=2.615 //x2=10.85 //y2=2.55
cc_197 ( N_noxref_1_c_197_p N_SN_c_8051_n ) capacitor c=0.00116411f //x=9.74 \
 //y=2.26 //x2=10.85 //y2=2.55
cc_198 ( N_noxref_1_c_198_p N_SN_c_8051_n ) capacitor c=0.0015646f //x=9.44 \
 //y=2.095 //x2=10.85 //y2=2.55
cc_199 ( N_noxref_1_c_32_p N_SN_c_8055_n ) capacitor c=0.0110307f //x=9.74 \
 //y=4.755 //x2=10.85 //y2=4.765
cc_200 ( N_noxref_1_c_194_p N_SN_c_8055_n ) capacitor c=2.89813e-19 //x=9.74 \
 //y=4.88 //x2=10.85 //y2=4.765
cc_201 ( N_noxref_1_c_4_p N_SN_c_8055_n ) capacitor c=7.66769e-19 //x=10.305 \
 //y=4.97 //x2=10.85 //y2=4.765
cc_202 ( N_noxref_1_c_202_p N_SN_c_8055_n ) capacitor c=7.54501e-19 //x=10.015 \
 //y=4.97 //x2=10.85 //y2=4.765
cc_203 ( N_noxref_1_c_29_p N_SN_c_8059_n ) capacitor c=0.00331546f //x=9.74 \
 //y=2.375 //x2=11.01 //y2=2.39
cc_204 ( N_noxref_1_c_30_p N_SN_c_8059_n ) capacitor c=0.00308827f //x=9.74 \
 //y=2.615 //x2=11.01 //y2=2.39
cc_205 ( N_noxref_1_c_29_p N_SN_c_8061_n ) capacitor c=5.39999e-19 //x=9.74 \
 //y=2.375 //x2=10.85 //y2=2.26
cc_206 ( N_noxref_1_c_197_p N_SN_c_8061_n ) capacitor c=0.00124907f //x=9.74 \
 //y=2.26 //x2=10.85 //y2=2.26
cc_207 ( N_noxref_1_c_198_p N_SN_c_8061_n ) capacitor c=0.00214501f //x=9.44 \
 //y=2.095 //x2=10.85 //y2=2.26
cc_208 ( N_noxref_1_c_32_p N_SN_c_8064_n ) capacitor c=0.00103399f //x=9.74 \
 //y=4.755 //x2=10.85 //y2=4.88
cc_209 ( N_noxref_1_c_194_p N_SN_c_8064_n ) capacitor c=0.00113984f //x=9.74 \
 //y=4.88 //x2=10.85 //y2=4.88
cc_210 ( N_noxref_1_c_4_p N_SN_c_8064_n ) capacitor c=0.00116563f //x=10.305 \
 //y=4.97 //x2=10.85 //y2=4.88
cc_211 ( N_noxref_1_c_202_p N_SN_c_8064_n ) capacitor c=0.00129812f //x=10.015 \
 //y=4.97 //x2=10.85 //y2=4.88
cc_212 ( N_noxref_1_M62_noxref_g N_SN_M64_noxref_g ) capacitor c=0.0106276f \
 //x=9.94 //y=6.2 //x2=10.82 //y2=6.2
cc_213 ( N_noxref_1_M63_noxref_g N_SN_M64_noxref_g ) capacitor c=0.107144f \
 //x=10.38 //y=6.2 //x2=10.82 //y2=6.2
cc_214 ( N_noxref_1_M63_noxref_g N_SN_M65_noxref_g ) capacitor c=0.0101598f \
 //x=10.38 //y=6.2 //x2=11.26 //y2=6.2
cc_215 ( N_noxref_1_c_215_p N_SN_c_8071_n ) capacitor c=5.72528e-19 //x=9.44 \
 //y=1.055 //x2=10.415 //y2=1.09
cc_216 ( N_noxref_1_c_216_p N_SN_c_8071_n ) capacitor c=0.00150277f //x=9.44 \
 //y=1.4 //x2=10.415 //y2=1.09
cc_217 ( N_noxref_1_c_217_p N_SN_c_8071_n ) capacitor c=0.0160123f //x=9.97 \
 //y=1.055 //x2=10.415 //y2=1.09
cc_218 ( N_noxref_1_c_218_p N_SN_c_8074_n ) capacitor c=0.00111227f //x=9.44 \
 //y=1.71 //x2=10.415 //y2=1.4
cc_219 ( N_noxref_1_c_219_p N_SN_c_8074_n ) capacitor c=0.0124075f //x=9.97 \
 //y=1.4 //x2=10.415 //y2=1.4
cc_220 ( N_noxref_1_c_217_p N_SN_c_8076_n ) capacitor c=9.19165e-19 //x=9.97 \
 //y=1.055 //x2=10.94 //y2=1.09
cc_221 ( N_noxref_1_c_219_p N_SN_c_8077_n ) capacitor c=0.0010154f //x=9.97 \
 //y=1.4 //x2=10.94 //y2=1.4
cc_222 ( N_noxref_1_c_219_p N_SN_c_8078_n ) capacitor c=9.23422e-19 //x=9.97 \
 //y=1.4 //x2=10.94 //y2=1.63
cc_223 ( N_noxref_1_c_29_p N_SN_c_8079_n ) capacitor c=5.616e-19 //x=9.74 \
 //y=2.375 //x2=10.94 //y2=2.095
cc_224 ( N_noxref_1_c_197_p N_SN_c_8079_n ) capacitor c=0.0017273f //x=9.74 \
 //y=2.26 //x2=10.94 //y2=2.095
cc_225 ( N_noxref_1_c_198_p N_SN_c_8079_n ) capacitor c=0.00880777f //x=9.44 \
 //y=2.095 //x2=10.94 //y2=2.095
cc_226 ( N_noxref_1_c_32_p N_SN_c_8082_n ) capacitor c=0.00116212f //x=9.74 \
 //y=4.755 //x2=10.85 //y2=4.88
cc_227 ( N_noxref_1_c_194_p N_SN_c_8082_n ) capacitor c=0.00155973f //x=9.74 \
 //y=4.88 //x2=10.85 //y2=4.88
cc_228 ( N_noxref_1_c_4_p N_SN_c_8082_n ) capacitor c=0.0171374f //x=10.305 \
 //y=4.97 //x2=10.85 //y2=4.88
cc_229 ( N_noxref_1_c_202_p N_SN_c_8082_n ) capacitor c=0.00484466f //x=10.015 \
 //y=4.97 //x2=10.85 //y2=4.88
cc_230 ( N_noxref_1_c_16_p N_VDD_c_11522_n ) capacitor c=0.00648286f //x=2.485 \
 //y=5.38 //x2=74.455 //y2=7.585
cc_231 ( N_noxref_1_c_63_p N_VDD_c_11522_n ) capacitor c=0.00488503f //x=2.995 \
 //y=5.38 //x2=74.455 //y2=7.585
cc_232 ( N_noxref_1_c_108_p N_VDD_c_11522_n ) capacitor c=0.00368817f //x=1.72 \
 //y=5.56 //x2=74.455 //y2=7.585
cc_233 ( N_noxref_1_c_19_p N_VDD_c_11522_n ) capacitor c=8.42537e-19 //x=2.6 \
 //y=5.38 //x2=74.455 //y2=7.585
cc_234 ( N_noxref_1_c_234_p N_VDD_c_11522_n ) capacitor c=0.00285853f //x=2.6 \
 //y=5.56 //x2=74.455 //y2=7.585
cc_235 ( N_noxref_1_c_110_p N_VDD_c_11522_n ) capacitor c=0.00224881f //x=1.72 \
 //y=5.56 //x2=74.455 //y2=7.585
cc_236 ( N_noxref_1_c_20_p N_VDD_c_11522_n ) capacitor c=0.00224881f //x=2.6 \
 //y=5.56 //x2=74.455 //y2=7.585
cc_237 ( N_noxref_1_c_16_p N_VDD_c_11529_n ) capacitor c=0.00208087f //x=2.485 \
 //y=5.38 //x2=2.075 //y2=7.585
cc_238 ( N_noxref_1_c_108_p N_VDD_c_11529_n ) capacitor c=9.99055e-19 //x=1.72 \
 //y=5.56 //x2=2.075 //y2=7.585
cc_239 ( N_noxref_1_c_110_p N_VDD_c_11529_n ) capacitor c=0.0136705f //x=1.72 \
 //y=5.56 //x2=2.075 //y2=7.585
cc_240 ( N_noxref_1_c_16_p N_VDD_c_11532_n ) capacitor c=0.00180737f //x=2.485 \
 //y=5.38 //x2=2.955 //y2=7.585
cc_241 ( N_noxref_1_c_63_p N_VDD_c_11532_n ) capacitor c=0.00208087f //x=2.995 \
 //y=5.38 //x2=2.955 //y2=7.585
cc_242 ( N_noxref_1_c_19_p N_VDD_c_11532_n ) capacitor c=4.23719e-19 //x=2.6 \
 //y=5.38 //x2=2.955 //y2=7.585
cc_243 ( N_noxref_1_c_234_p N_VDD_c_11532_n ) capacitor c=5.77976e-19 //x=2.6 \
 //y=5.56 //x2=2.955 //y2=7.585
cc_244 ( N_noxref_1_c_20_p N_VDD_c_11532_n ) capacitor c=0.0136705f //x=2.6 \
 //y=5.56 //x2=2.955 //y2=7.585
cc_245 ( N_noxref_1_M56_noxref_g N_VDD_c_11537_n ) capacitor c=0.00755614f \
 //x=5.13 //y=6.2 //x2=5.705 //y2=7.585
cc_246 ( N_noxref_1_M57_noxref_g N_VDD_c_11537_n ) capacitor c=0.00755544f \
 //x=5.57 //y=6.2 //x2=5.705 //y2=7.585
cc_247 ( N_noxref_1_M62_noxref_g N_VDD_c_11539_n ) capacitor c=0.00755614f \
 //x=9.94 //y=6.2 //x2=10.515 //y2=7.585
cc_248 ( N_noxref_1_M63_noxref_g N_VDD_c_11539_n ) capacitor c=0.00755544f \
 //x=10.38 //y=6.2 //x2=10.515 //y2=7.585
cc_249 ( N_noxref_1_c_11_p N_VDD_c_11541_n ) capacitor c=0.00197052f //x=3.08 \
 //y=5.295 //x2=1.23 //y2=7.58
cc_250 ( N_noxref_1_c_108_p N_VDD_c_11541_n ) capacitor c=6.39392e-19 //x=1.72 \
 //y=5.56 //x2=1.23 //y2=7.58
cc_251 ( N_noxref_1_c_110_p N_VDD_c_11541_n ) capacitor c=0.0064135f //x=1.72 \
 //y=5.56 //x2=1.23 //y2=7.58
cc_252 ( N_noxref_1_c_11_p N_VDD_c_11544_n ) capacitor c=0.0306839f //x=3.08 \
 //y=5.295 //x2=3.82 //y2=7.585
cc_253 ( N_noxref_1_c_13_p N_VDD_c_11544_n ) capacitor c=0.0135962f //x=4.93 \
 //y=4.755 //x2=3.82 //y2=7.585
cc_254 ( N_noxref_1_c_19_p N_VDD_c_11544_n ) capacitor c=0.0025639f //x=2.6 \
 //y=5.38 //x2=3.82 //y2=7.585
cc_255 ( N_noxref_1_c_234_p N_VDD_c_11544_n ) capacitor c=4.19141e-19 //x=2.6 \
 //y=5.56 //x2=3.82 //y2=7.585
cc_256 ( N_noxref_1_c_20_p N_VDD_c_11544_n ) capacitor c=0.0101861f //x=2.6 \
 //y=5.56 //x2=3.82 //y2=7.585
cc_257 ( N_noxref_1_c_159_p N_VDD_c_11544_n ) capacitor c=0.00370784f //x=4.93 \
 //y=4.88 //x2=3.82 //y2=7.585
cc_258 ( N_noxref_1_c_161_p N_VDD_c_11544_n ) capacitor c=0.00590568f \
 //x=5.205 //y=4.97 //x2=3.82 //y2=7.585
cc_259 ( N_noxref_1_c_32_p N_VDD_c_11551_n ) capacitor c=0.0116769f //x=9.74 \
 //y=4.755 //x2=8.63 //y2=7.585
cc_260 ( N_noxref_1_c_194_p N_VDD_c_11551_n ) capacitor c=0.00370784f //x=9.74 \
 //y=4.88 //x2=8.63 //y2=7.585
cc_261 ( N_noxref_1_c_202_p N_VDD_c_11551_n ) capacitor c=0.00590568f \
 //x=10.015 //y=4.97 //x2=8.63 //y2=7.585
cc_262 ( N_noxref_1_c_108_p N_VDD_M52_noxref_s ) capacitor c=0.062494f \
 //x=1.72 //y=5.56 //x2=1.145 //y2=5.2
cc_263 ( N_noxref_1_c_19_p N_VDD_M52_noxref_s ) capacitor c=6.52457e-19 \
 //x=2.6 //y=5.38 //x2=1.145 //y2=5.2
cc_264 ( N_noxref_1_c_110_p N_VDD_M52_noxref_s ) capacitor c=0.0906717f \
 //x=1.72 //y=5.56 //x2=1.145 //y2=5.2
cc_265 ( N_noxref_1_c_16_p N_VDD_M53_noxref_d ) capacitor c=0.00727187f \
 //x=2.485 //y=5.38 //x2=2.015 //y2=5.2
cc_266 ( N_noxref_1_c_108_p N_VDD_M53_noxref_d ) capacitor c=0.0043528f \
 //x=1.72 //y=5.56 //x2=2.015 //y2=5.2
cc_267 ( N_noxref_1_c_234_p N_VDD_M53_noxref_d ) capacitor c=0.0043528f \
 //x=2.6 //y=5.56 //x2=2.015 //y2=5.2
cc_268 ( N_noxref_1_c_110_p N_VDD_M53_noxref_d ) capacitor c=0.065554f \
 //x=1.72 //y=5.56 //x2=2.015 //y2=5.2
cc_269 ( N_noxref_1_c_20_p N_VDD_M53_noxref_d ) capacitor c=0.065554f //x=2.6 \
 //y=5.56 //x2=2.015 //y2=5.2
cc_270 ( N_noxref_1_c_63_p N_VDD_M55_noxref_d ) capacitor c=0.00983727f \
 //x=2.995 //y=5.38 //x2=2.895 //y2=5.2
cc_271 ( N_noxref_1_c_234_p N_VDD_M55_noxref_d ) capacitor c=0.00955781f \
 //x=2.6 //y=5.56 //x2=2.895 //y2=5.2
cc_272 ( N_noxref_1_c_14_p N_VDD_M55_noxref_d ) capacitor c=6.87256e-19 \
 //x=3.08 //y=2.77 //x2=2.895 //y2=5.2
cc_273 ( N_noxref_1_c_20_p N_VDD_M55_noxref_d ) capacitor c=0.065554f //x=2.6 \
 //y=5.56 //x2=2.895 //y2=5.2
cc_274 ( N_noxref_1_c_63_p N_VDD_M56_noxref_s ) capacitor c=0.00220019f \
 //x=2.995 //y=5.38 //x2=4.775 //y2=5.2
cc_275 ( N_noxref_1_c_122_p N_VDD_M56_noxref_s ) capacitor c=4.47429e-19 \
 //x=4.93 //y=2.93 //x2=4.775 //y2=5.2
cc_276 ( N_noxref_1_c_13_p N_VDD_M56_noxref_s ) capacitor c=0.0224586f \
 //x=4.93 //y=4.755 //x2=4.775 //y2=5.2
cc_277 ( N_noxref_1_c_19_p N_VDD_M56_noxref_s ) capacitor c=0.00371125f \
 //x=2.6 //y=5.38 //x2=4.775 //y2=5.2
cc_278 ( N_noxref_1_c_234_p N_VDD_M56_noxref_s ) capacitor c=9.52042e-19 \
 //x=2.6 //y=5.56 //x2=4.775 //y2=5.2
cc_279 ( N_noxref_1_c_159_p N_VDD_M56_noxref_s ) capacitor c=0.00983413f \
 //x=4.93 //y=4.88 //x2=4.775 //y2=5.2
cc_280 ( N_noxref_1_M56_noxref_g N_VDD_M56_noxref_s ) capacitor c=0.053419f \
 //x=5.13 //y=6.2 //x2=4.775 //y2=5.2
cc_281 ( N_noxref_1_c_161_p N_VDD_M56_noxref_s ) capacitor c=0.00608913f \
 //x=5.205 //y=4.97 //x2=4.775 //y2=5.2
cc_282 ( N_noxref_1_M57_noxref_g N_VDD_M57_noxref_d ) capacitor c=0.015318f \
 //x=5.57 //y=6.2 //x2=5.645 //y2=5.2
cc_283 ( N_noxref_1_c_31_p N_VDD_M62_noxref_s ) capacitor c=4.33517e-19 \
 //x=9.74 //y=2.935 //x2=9.585 //y2=5.2
cc_284 ( N_noxref_1_c_32_p N_VDD_M62_noxref_s ) capacitor c=0.0217981f \
 //x=9.74 //y=4.755 //x2=9.585 //y2=5.2
cc_285 ( N_noxref_1_c_194_p N_VDD_M62_noxref_s ) capacitor c=0.00983846f \
 //x=9.74 //y=4.88 //x2=9.585 //y2=5.2
cc_286 ( N_noxref_1_M62_noxref_g N_VDD_M62_noxref_s ) capacitor c=0.053419f \
 //x=9.94 //y=6.2 //x2=9.585 //y2=5.2
cc_287 ( N_noxref_1_c_202_p N_VDD_M62_noxref_s ) capacitor c=0.00608899f \
 //x=10.015 //y=4.97 //x2=9.585 //y2=5.2
cc_288 ( N_noxref_1_M63_noxref_g N_VDD_M63_noxref_d ) capacitor c=0.015318f \
 //x=10.38 //y=6.2 //x2=10.455 //y2=5.2
cc_289 ( N_noxref_1_c_25_p N_noxref_24_c_12950_n ) capacitor c=0.00502763f \
 //x=9.58 //y=2.775 //x2=6.835 //y2=1.175
cc_290 ( N_noxref_1_c_25_p N_noxref_24_c_12951_n ) capacitor c=3.05316e-19 \
 //x=9.58 //y=2.775 //x2=7.805 //y2=0.72
cc_291 ( N_noxref_1_c_66_p N_noxref_24_M3_noxref_d ) capacitor c=3.39394e-19 \
 //x=2.64 //y=1.18 //x2=5.68 //y2=1.09
cc_292 ( N_noxref_1_c_25_p N_noxref_24_M3_noxref_d ) capacitor c=0.00581656f \
 //x=9.58 //y=2.775 //x2=5.68 //y2=1.09
cc_293 ( N_noxref_1_c_25_p N_noxref_24_M4_noxref_s ) capacitor c=0.00372255f \
 //x=9.58 //y=2.775 //x2=6.785 //y2=0.555
cc_294 ( N_noxref_1_c_26_p N_GND_c_13858_n ) capacitor c=0.00631641f //x=2.995 \
 //y=1.835 //x2=4.81 //y2=0.175
cc_295 ( N_noxref_1_c_10_p N_GND_c_13858_n ) capacitor c=4.3076e-19 //x=3.08 \
 //y=2.93 //x2=4.81 //y2=0.175
cc_296 ( N_noxref_1_c_66_p N_GND_c_13858_n ) capacitor c=0.00951288f //x=2.64 \
 //y=1.18 //x2=4.81 //y2=0.175
cc_297 ( N_noxref_1_c_47_p N_GND_c_13858_n ) capacitor c=0.0526569f //x=4.77 \
 //y=2.77 //x2=4.81 //y2=0.175
cc_298 ( N_noxref_1_c_15_p N_GND_c_13858_n ) capacitor c=0.00345543f //x=3.24 \
 //y=2.77 //x2=4.81 //y2=0.175
cc_299 ( N_noxref_1_M1_noxref_d N_GND_c_13858_n ) capacitor c=3.01769e-19 \
 //x=2.45 //y=1.085 //x2=4.81 //y2=0.175
cc_300 ( N_noxref_1_c_175_p N_GND_c_13864_n ) capacitor c=3.92414e-19 //x=4.63 \
 //y=1.055 //x2=4.895 //y2=1.015
cc_301 ( N_noxref_1_c_301_p N_GND_c_13864_n ) capacitor c=0.0085115f //x=5.005 \
 //y=0.9 //x2=4.895 //y2=1.015
cc_302 ( N_noxref_1_c_177_p N_GND_c_13864_n ) capacitor c=4.45447e-19 //x=5.16 \
 //y=1.055 //x2=4.895 //y2=1.015
cc_303 ( N_noxref_1_c_25_p N_GND_c_13867_n ) capacitor c=0.11215f //x=9.58 \
 //y=2.775 //x2=9.62 //y2=0.175
cc_304 ( N_noxref_1_c_215_p N_GND_c_13868_n ) capacitor c=3.97665e-19 //x=9.44 \
 //y=1.055 //x2=9.705 //y2=1.015
cc_305 ( N_noxref_1_c_305_p N_GND_c_13868_n ) capacitor c=0.00864776f \
 //x=9.815 //y=0.9 //x2=9.705 //y2=1.015
cc_306 ( N_noxref_1_c_217_p N_GND_c_13868_n ) capacitor c=4.45447e-19 //x=9.97 \
 //y=1.055 //x2=9.705 //y2=1.015
cc_307 ( N_noxref_1_c_66_p N_GND_c_13871_n ) capacitor c=0.0141894f //x=2.64 \
 //y=1.18 //x2=1.67 //y2=1.135
cc_308 ( N_noxref_1_M1_noxref_d N_GND_c_13871_n ) capacitor c=2.93544e-19 \
 //x=2.45 //y=1.085 //x2=1.67 //y2=1.135
cc_309 ( N_noxref_1_c_154_p N_GND_c_13873_n ) capacitor c=0.00794777f //x=4.93 \
 //y=2.375 //x2=4.895 //y2=1.145
cc_310 ( N_noxref_1_c_122_p N_GND_c_13873_n ) capacitor c=0.00108886f //x=4.93 \
 //y=2.93 //x2=4.895 //y2=1.145
cc_311 ( N_noxref_1_c_66_p N_GND_c_13873_n ) capacitor c=0.00606355f //x=2.64 \
 //y=1.18 //x2=4.895 //y2=1.145
cc_312 ( N_noxref_1_c_125_p N_GND_c_13873_n ) capacitor c=0.00335863f //x=5.09 \
 //y=2.77 //x2=4.895 //y2=1.145
cc_313 ( N_noxref_1_c_153_p N_GND_c_13873_n ) capacitor c=2.22883e-19 //x=4.93 \
 //y=2.26 //x2=4.895 //y2=1.145
cc_314 ( N_noxref_1_c_175_p N_GND_c_13873_n ) capacitor c=0.0015128f //x=4.63 \
 //y=1.055 //x2=4.895 //y2=1.145
cc_315 ( N_noxref_1_c_176_p N_GND_c_13873_n ) capacitor c=0.00350108f //x=4.63 \
 //y=1.4 //x2=4.895 //y2=1.145
cc_316 ( N_noxref_1_c_178_p N_GND_c_13873_n ) capacitor c=4.09667e-19 //x=4.63 \
 //y=1.71 //x2=4.895 //y2=1.145
cc_317 ( N_noxref_1_c_301_p N_GND_c_13873_n ) capacitor c=9.36995e-19 \
 //x=5.005 //y=0.9 //x2=4.895 //y2=1.145
cc_318 ( N_noxref_1_c_318_p N_GND_c_13873_n ) capacitor c=5.27793e-19 \
 //x=5.005 //y=1.555 //x2=4.895 //y2=1.145
cc_319 ( N_noxref_1_c_177_p N_GND_c_13873_n ) capacitor c=0.0017438f //x=5.16 \
 //y=1.055 //x2=4.895 //y2=1.145
cc_320 ( N_noxref_1_c_179_p N_GND_c_13873_n ) capacitor c=0.00276804f //x=5.16 \
 //y=1.4 //x2=4.895 //y2=1.145
cc_321 ( N_noxref_1_c_29_p N_GND_c_13885_n ) capacitor c=0.00795095f //x=9.74 \
 //y=2.375 //x2=9.705 //y2=1.145
cc_322 ( N_noxref_1_c_31_p N_GND_c_13885_n ) capacitor c=0.00120974f //x=9.74 \
 //y=2.935 //x2=9.705 //y2=1.145
cc_323 ( N_noxref_1_c_33_p N_GND_c_13885_n ) capacitor c=0.00334868f //x=9.74 \
 //y=2.775 //x2=9.705 //y2=1.145
cc_324 ( N_noxref_1_c_197_p N_GND_c_13885_n ) capacitor c=2.22883e-19 //x=9.74 \
 //y=2.26 //x2=9.705 //y2=1.145
cc_325 ( N_noxref_1_c_215_p N_GND_c_13885_n ) capacitor c=0.00156339f //x=9.44 \
 //y=1.055 //x2=9.705 //y2=1.145
cc_326 ( N_noxref_1_c_216_p N_GND_c_13885_n ) capacitor c=0.00352472f //x=9.44 \
 //y=1.4 //x2=9.705 //y2=1.145
cc_327 ( N_noxref_1_c_218_p N_GND_c_13885_n ) capacitor c=3.85805e-19 //x=9.44 \
 //y=1.71 //x2=9.705 //y2=1.145
cc_328 ( N_noxref_1_c_305_p N_GND_c_13885_n ) capacitor c=9.36995e-19 \
 //x=9.815 //y=0.9 //x2=9.705 //y2=1.145
cc_329 ( N_noxref_1_c_329_p N_GND_c_13885_n ) capacitor c=5.28241e-19 \
 //x=9.815 //y=1.555 //x2=9.705 //y2=1.145
cc_330 ( N_noxref_1_c_217_p N_GND_c_13885_n ) capacitor c=0.0017438f //x=9.97 \
 //y=1.055 //x2=9.705 //y2=1.145
cc_331 ( N_noxref_1_c_219_p N_GND_c_13885_n ) capacitor c=0.00276804f //x=9.97 \
 //y=1.4 //x2=9.705 //y2=1.145
cc_332 ( N_noxref_1_c_26_p N_GND_c_13896_n ) capacitor c=7.75992e-19 //x=2.995 \
 //y=1.835 //x2=3.65 //y2=0.175
cc_333 ( N_noxref_1_c_10_p N_GND_c_13896_n ) capacitor c=4.78337e-19 //x=3.08 \
 //y=2.93 //x2=3.65 //y2=0.175
cc_334 ( N_noxref_1_c_9_p N_GND_c_13898_n ) capacitor c=0.00139243f //x=3.08 \
 //y=2.61 //x2=1.23 //y2=0.18
cc_335 ( N_noxref_1_c_14_p N_GND_c_13898_n ) capacitor c=0.00133285f //x=3.08 \
 //y=2.77 //x2=1.23 //y2=0.18
cc_336 ( N_noxref_1_c_175_p N_GND_c_13900_n ) capacitor c=0.00677849f //x=4.63 \
 //y=1.055 //x2=8.46 //y2=0.175
cc_337 ( N_noxref_1_c_215_p N_GND_c_13901_n ) capacitor c=0.00677849f //x=9.44 \
 //y=1.055 //x2=13.27 //y2=0.175
cc_338 ( N_noxref_1_c_68_p N_GND_c_13902_n ) capacitor c=0.00460657f //x=2.64 \
 //y=1.75 //x2=3.82 //y2=0.175
cc_339 ( N_noxref_1_c_26_p N_GND_c_13902_n ) capacitor c=0.0229266f //x=2.995 \
 //y=1.835 //x2=3.82 //y2=0.175
cc_340 ( N_noxref_1_c_10_p N_GND_c_13902_n ) capacitor c=0.00430881f //x=3.08 \
 //y=2.93 //x2=3.82 //y2=0.175
cc_341 ( N_noxref_1_c_154_p N_GND_c_13902_n ) capacitor c=0.00407472f //x=4.93 \
 //y=2.375 //x2=3.82 //y2=0.175
cc_342 ( N_noxref_1_c_12_p N_GND_c_13902_n ) capacitor c=0.00468396f //x=4.93 \
 //y=2.61 //x2=3.82 //y2=0.175
cc_343 ( N_noxref_1_c_122_p N_GND_c_13902_n ) capacitor c=0.00272321f //x=4.93 \
 //y=2.93 //x2=3.82 //y2=0.175
cc_344 ( N_noxref_1_c_14_p N_GND_c_13902_n ) capacitor c=0.0101608f //x=3.08 \
 //y=2.77 //x2=3.82 //y2=0.175
cc_345 ( N_noxref_1_c_150_p N_GND_c_13902_n ) capacitor c=0.00539296f //x=4.93 \
 //y=2.765 //x2=3.82 //y2=0.175
cc_346 ( N_noxref_1_c_47_p N_GND_c_13902_n ) capacitor c=0.018242f //x=4.77 \
 //y=2.77 //x2=3.82 //y2=0.175
cc_347 ( N_noxref_1_c_153_p N_GND_c_13902_n ) capacitor c=0.00394652f //x=4.93 \
 //y=2.26 //x2=3.82 //y2=0.175
cc_348 ( N_noxref_1_c_178_p N_GND_c_13902_n ) capacitor c=0.00170145f //x=4.63 \
 //y=1.71 //x2=3.82 //y2=0.175
cc_349 ( N_noxref_1_c_157_p N_GND_c_13902_n ) capacitor c=0.0103608f //x=4.63 \
 //y=2.095 //x2=3.82 //y2=0.175
cc_350 ( N_noxref_1_c_29_p N_GND_c_13914_n ) capacitor c=0.00439019f //x=9.74 \
 //y=2.375 //x2=8.63 //y2=0.175
cc_351 ( N_noxref_1_c_30_p N_GND_c_13914_n ) capacitor c=0.00436709f //x=9.74 \
 //y=2.615 //x2=8.63 //y2=0.175
cc_352 ( N_noxref_1_c_31_p N_GND_c_13914_n ) capacitor c=0.00311095f //x=9.74 \
 //y=2.935 //x2=8.63 //y2=0.175
cc_353 ( N_noxref_1_c_5_p N_GND_c_13914_n ) capacitor c=0.00528672f //x=9.74 \
 //y=2.77 //x2=8.63 //y2=0.175
cc_354 ( N_noxref_1_c_25_p N_GND_c_13914_n ) capacitor c=0.0205907f //x=9.58 \
 //y=2.775 //x2=8.63 //y2=0.175
cc_355 ( N_noxref_1_c_197_p N_GND_c_13914_n ) capacitor c=0.00394651f //x=9.74 \
 //y=2.26 //x2=8.63 //y2=0.175
cc_356 ( N_noxref_1_c_218_p N_GND_c_13914_n ) capacitor c=0.00170145f //x=9.44 \
 //y=1.71 //x2=8.63 //y2=0.175
cc_357 ( N_noxref_1_c_198_p N_GND_c_13914_n ) capacitor c=0.0103608f //x=9.44 \
 //y=2.095 //x2=8.63 //y2=0.175
cc_358 ( N_noxref_1_c_66_p N_GND_M0_noxref_d ) capacitor c=2.82748e-19 \
 //x=2.64 //y=1.18 //x2=1.48 //y2=1.045
cc_359 ( N_noxref_1_c_154_p N_GND_M2_noxref_d ) capacitor c=4.4417e-19 \
 //x=4.93 //y=2.375 //x2=4.705 //y2=1.055
cc_360 ( N_noxref_1_c_175_p N_GND_M2_noxref_d ) capacitor c=0.00184354f \
 //x=4.63 //y=1.055 //x2=4.705 //y2=1.055
cc_361 ( N_noxref_1_c_176_p N_GND_M2_noxref_d ) capacitor c=0.00210798f \
 //x=4.63 //y=1.4 //x2=4.705 //y2=1.055
cc_362 ( N_noxref_1_c_301_p N_GND_M2_noxref_d ) capacitor c=0.00474029f \
 //x=5.005 //y=0.9 //x2=4.705 //y2=1.055
cc_363 ( N_noxref_1_c_318_p N_GND_M2_noxref_d ) capacitor c=0.00166857f \
 //x=5.005 //y=1.555 //x2=4.705 //y2=1.055
cc_364 ( N_noxref_1_c_177_p N_GND_M2_noxref_d ) capacitor c=0.00230174f \
 //x=5.16 //y=1.055 //x2=4.705 //y2=1.055
cc_365 ( N_noxref_1_c_179_p N_GND_M2_noxref_d ) capacitor c=0.00210798f \
 //x=5.16 //y=1.4 //x2=4.705 //y2=1.055
cc_366 ( N_noxref_1_c_29_p N_GND_M5_noxref_d ) capacitor c=4.4417e-19 //x=9.74 \
 //y=2.375 //x2=9.515 //y2=1.055
cc_367 ( N_noxref_1_c_215_p N_GND_M5_noxref_d ) capacitor c=0.00184354f \
 //x=9.44 //y=1.055 //x2=9.515 //y2=1.055
cc_368 ( N_noxref_1_c_216_p N_GND_M5_noxref_d ) capacitor c=0.00210798f \
 //x=9.44 //y=1.4 //x2=9.515 //y2=1.055
cc_369 ( N_noxref_1_c_305_p N_GND_M5_noxref_d ) capacitor c=0.00474029f \
 //x=9.815 //y=0.9 //x2=9.515 //y2=1.055
cc_370 ( N_noxref_1_c_329_p N_GND_M5_noxref_d ) capacitor c=0.00166857f \
 //x=9.815 //y=1.555 //x2=9.515 //y2=1.055
cc_371 ( N_noxref_1_c_217_p N_GND_M5_noxref_d ) capacitor c=0.00230174f \
 //x=9.97 //y=1.055 //x2=9.515 //y2=1.055
cc_372 ( N_noxref_1_c_219_p N_GND_M5_noxref_d ) capacitor c=0.00210798f \
 //x=9.97 //y=1.4 //x2=9.515 //y2=1.055
cc_373 ( N_noxref_1_c_17_p N_noxref_37_c_15596_n ) capacitor c=0.0103386f \
 //x=2.725 //y=1.835 //x2=2.155 //y2=1.675
cc_374 ( N_noxref_1_c_26_p N_noxref_37_c_15597_n ) capacitor c=0.00399245f \
 //x=2.995 //y=1.835 //x2=3.04 //y2=0.71
cc_375 ( N_noxref_1_c_66_p N_noxref_37_c_15597_n ) capacitor c=0.003751f \
 //x=2.64 //y=1.18 //x2=3.04 //y2=0.71
cc_376 ( N_noxref_1_M1_noxref_d N_noxref_37_c_15597_n ) capacitor \
 c=0.00910163f //x=2.45 //y=1.085 //x2=3.04 //y2=0.71
cc_377 ( N_noxref_1_c_68_p N_noxref_37_M0_noxref_s ) capacitor c=0.0190756f \
 //x=2.64 //y=1.75 //x2=1.05 //y2=0.545
cc_378 ( N_noxref_1_c_26_p N_noxref_37_M0_noxref_s ) capacitor c=0.0055349f \
 //x=2.995 //y=1.835 //x2=1.05 //y2=0.545
cc_379 ( N_noxref_1_c_10_p N_noxref_37_M0_noxref_s ) capacitor c=7.86324e-19 \
 //x=3.08 //y=2.93 //x2=1.05 //y2=0.545
cc_380 ( N_noxref_1_c_66_p N_noxref_37_M0_noxref_s ) capacitor c=0.00900047f \
 //x=2.64 //y=1.18 //x2=1.05 //y2=0.545
cc_381 ( N_noxref_1_c_14_p N_noxref_37_M0_noxref_s ) capacitor c=0.00202552f \
 //x=3.08 //y=2.77 //x2=1.05 //y2=0.545
cc_382 ( N_noxref_1_M1_noxref_d N_noxref_37_M0_noxref_s ) capacitor \
 c=0.0275552f //x=2.45 //y=1.085 //x2=1.05 //y2=0.545
cc_383 ( N_noxref_1_c_47_p N_noxref_38_c_15659_n ) capacitor c=0.00369947f \
 //x=4.77 //y=2.77 //x2=4.41 //y2=1.685
cc_384 ( N_noxref_1_c_157_p N_noxref_38_c_15659_n ) capacitor c=0.00262672f \
 //x=4.63 //y=2.095 //x2=4.41 //y2=1.685
cc_385 ( N_noxref_1_c_154_p N_noxref_38_c_15661_n ) capacitor c=0.00428451f \
 //x=4.93 //y=2.375 //x2=5.295 //y2=1.77
cc_386 ( N_noxref_1_c_122_p N_noxref_38_c_15661_n ) capacitor c=0.00374191f \
 //x=4.93 //y=2.93 //x2=5.295 //y2=1.77
cc_387 ( N_noxref_1_c_47_p N_noxref_38_c_15661_n ) capacitor c=0.00583017f \
 //x=4.77 //y=2.77 //x2=5.295 //y2=1.77
cc_388 ( N_noxref_1_c_25_p N_noxref_38_c_15661_n ) capacitor c=0.00184424f \
 //x=9.58 //y=2.775 //x2=5.295 //y2=1.77
cc_389 ( N_noxref_1_c_153_p N_noxref_38_c_15661_n ) capacitor c=0.0104666f \
 //x=4.93 //y=2.26 //x2=5.295 //y2=1.77
cc_390 ( N_noxref_1_c_178_p N_noxref_38_c_15661_n ) capacitor c=0.00705077f \
 //x=4.63 //y=1.71 //x2=5.295 //y2=1.77
cc_391 ( N_noxref_1_c_157_p N_noxref_38_c_15661_n ) capacitor c=0.0209271f \
 //x=4.63 //y=2.095 //x2=5.295 //y2=1.77
cc_392 ( N_noxref_1_c_318_p N_noxref_38_c_15661_n ) capacitor c=0.00588627f \
 //x=5.005 //y=1.555 //x2=5.295 //y2=1.77
cc_393 ( N_noxref_1_c_179_p N_noxref_38_c_15661_n ) capacitor c=0.00698822f \
 //x=5.16 //y=1.4 //x2=5.295 //y2=1.77
cc_394 ( N_noxref_1_c_25_p N_noxref_38_c_15670_n ) capacitor c=0.00995347f \
 //x=9.58 //y=2.775 //x2=6.265 //y2=1.77
cc_395 ( N_noxref_1_c_25_p N_noxref_38_M2_noxref_s ) capacitor c=0.0069245f \
 //x=9.58 //y=2.775 //x2=4.275 //y2=0.555
cc_396 ( N_noxref_1_c_175_p N_noxref_38_M2_noxref_s ) capacitor c=0.0295256f \
 //x=4.63 //y=1.055 //x2=4.275 //y2=0.555
cc_397 ( N_noxref_1_c_178_p N_noxref_38_M2_noxref_s ) capacitor c=7.99997e-19 \
 //x=4.63 //y=1.71 //x2=4.275 //y2=0.555
cc_398 ( N_noxref_1_c_157_p N_noxref_38_M2_noxref_s ) capacitor c=0.00122123f \
 //x=4.63 //y=2.095 //x2=4.275 //y2=0.555
cc_399 ( N_noxref_1_c_177_p N_noxref_38_M2_noxref_s ) capacitor c=0.0125924f \
 //x=5.16 //y=1.055 //x2=4.275 //y2=0.555
cc_400 ( N_noxref_1_c_25_p N_noxref_39_c_15718_n ) capacitor c=0.00369947f \
 //x=9.58 //y=2.775 //x2=9.22 //y2=1.685
cc_401 ( N_noxref_1_c_198_p N_noxref_39_c_15718_n ) capacitor c=0.00262672f \
 //x=9.44 //y=2.095 //x2=9.22 //y2=1.685
cc_402 ( N_noxref_1_c_29_p N_noxref_39_c_15720_n ) capacitor c=0.00428451f \
 //x=9.74 //y=2.375 //x2=10.105 //y2=1.77
cc_403 ( N_noxref_1_c_31_p N_noxref_39_c_15720_n ) capacitor c=0.00449871f \
 //x=9.74 //y=2.935 //x2=10.105 //y2=1.77
cc_404 ( N_noxref_1_c_25_p N_noxref_39_c_15720_n ) capacitor c=0.00374773f \
 //x=9.58 //y=2.775 //x2=10.105 //y2=1.77
cc_405 ( N_noxref_1_c_197_p N_noxref_39_c_15720_n ) capacitor c=0.0104666f \
 //x=9.74 //y=2.26 //x2=10.105 //y2=1.77
cc_406 ( N_noxref_1_c_218_p N_noxref_39_c_15720_n ) capacitor c=0.00705077f \
 //x=9.44 //y=1.71 //x2=10.105 //y2=1.77
cc_407 ( N_noxref_1_c_198_p N_noxref_39_c_15720_n ) capacitor c=0.0201014f \
 //x=9.44 //y=2.095 //x2=10.105 //y2=1.77
cc_408 ( N_noxref_1_c_329_p N_noxref_39_c_15720_n ) capacitor c=0.00588627f \
 //x=9.815 //y=1.555 //x2=10.105 //y2=1.77
cc_409 ( N_noxref_1_c_219_p N_noxref_39_c_15720_n ) capacitor c=0.00698822f \
 //x=9.97 //y=1.4 //x2=10.105 //y2=1.77
cc_410 ( N_noxref_1_c_215_p N_noxref_39_M5_noxref_s ) capacitor c=0.0295256f \
 //x=9.44 //y=1.055 //x2=9.085 //y2=0.555
cc_411 ( N_noxref_1_c_218_p N_noxref_39_M5_noxref_s ) capacitor c=7.99997e-19 \
 //x=9.44 //y=1.71 //x2=9.085 //y2=0.555
cc_412 ( N_noxref_1_c_198_p N_noxref_39_M5_noxref_s ) capacitor c=0.00122123f \
 //x=9.44 //y=2.095 //x2=9.085 //y2=0.555
cc_413 ( N_noxref_1_c_217_p N_noxref_39_M5_noxref_s ) capacitor c=0.0125924f \
 //x=9.97 //y=1.055 //x2=9.085 //y2=0.555
cc_414 ( N_noxref_2_c_415_n N_noxref_3_c_794_n ) capacitor c=6.09703e-19 \
 //x=10.162 //y=5.335 //x2=7.11 //y2=5.56
cc_415 ( N_noxref_2_c_415_n N_noxref_3_c_795_n ) capacitor c=0.00306432f \
 //x=10.162 //y=5.335 //x2=7.805 //y2=5.335
cc_416 ( N_noxref_2_c_424_p N_noxref_3_c_796_n ) capacitor c=0.00163399f \
 //x=12.3 //y=1.845 //x2=7.805 //y2=1.845
cc_417 ( N_noxref_2_c_425_p N_noxref_3_c_755_n ) capacitor c=0.0233658f \
 //x=12.7 //y=5.25 //x2=17.72 //y2=4.265
cc_418 ( N_noxref_2_c_426_p N_noxref_3_c_755_n ) capacitor c=0.0233519f \
 //x=14.552 //y=4.74 //x2=17.72 //y2=4.265
cc_419 ( N_noxref_2_c_427_p N_noxref_5_c_1505_n ) capacitor c=0.013943f \
 //x=12.7 //y=2.625 //x2=11.96 //y2=2.375
cc_420 ( N_noxref_2_c_427_p N_noxref_5_c_1499_n ) capacitor c=0.00898347f \
 //x=12.7 //y=2.625 //x2=11.96 //y2=3.705
cc_421 ( N_noxref_2_c_429_p N_noxref_5_c_1499_n ) capacitor c=0.0151188f \
 //x=12.7 //y=2.945 //x2=11.96 //y2=3.705
cc_422 ( N_noxref_2_c_425_p N_noxref_5_c_1499_n ) capacitor c=0.0330715f \
 //x=12.7 //y=5.25 //x2=11.96 //y2=3.705
cc_423 ( N_noxref_2_c_431_p N_noxref_5_c_1499_n ) capacitor c=4.63723e-19 \
 //x=14.55 //y=2.625 //x2=11.96 //y2=3.705
cc_424 ( N_noxref_2_c_418_n N_noxref_5_c_1499_n ) capacitor c=6.77171e-19 \
 //x=12.7 //y=2.77 //x2=11.96 //y2=3.705
cc_425 ( N_noxref_2_c_426_p N_noxref_5_c_1499_n ) capacitor c=6.62954e-19 \
 //x=14.552 //y=4.74 //x2=11.96 //y2=3.705
cc_426 ( N_noxref_2_c_434_p N_noxref_5_c_1499_n ) capacitor c=0.00687503f \
 //x=12.86 //y=2.785 //x2=11.96 //y2=3.705
cc_427 ( N_noxref_2_c_435_p N_noxref_5_c_1513_n ) capacitor c=0.00167286f \
 //x=11.805 //y=5.335 //x2=11.96 //y2=4.025
cc_428 ( N_noxref_2_c_436_p N_noxref_5_c_1513_n ) capacitor c=4.08809e-19 \
 //x=12.615 //y=5.335 //x2=11.96 //y2=4.025
cc_429 ( N_noxref_2_c_425_p N_noxref_5_c_1513_n ) capacitor c=0.0148932f \
 //x=12.7 //y=5.25 //x2=11.96 //y2=4.025
cc_430 ( N_noxref_2_c_436_p N_noxref_5_c_1501_n ) capacitor c=0.00228791f \
 //x=12.615 //y=5.335 //x2=11.96 //y2=4.75
cc_431 ( N_noxref_2_c_425_p N_noxref_5_c_1501_n ) capacitor c=0.042978f \
 //x=12.7 //y=5.25 //x2=11.96 //y2=4.75
cc_432 ( N_noxref_2_c_440_p N_noxref_5_c_1501_n ) capacitor c=0.0221235f \
 //x=11.92 //y=5.335 //x2=11.96 //y2=4.75
cc_433 ( N_noxref_2_c_426_p N_noxref_5_c_1501_n ) capacitor c=8.71319e-19 \
 //x=14.552 //y=4.74 //x2=11.96 //y2=4.75
cc_434 ( N_noxref_2_c_442_p N_noxref_5_c_1501_n ) capacitor c=0.00217653f \
 //x=11.92 //y=5.56 //x2=11.96 //y2=4.75
cc_435 ( N_noxref_2_M69_noxref_g N_noxref_5_c_1521_n ) capacitor c=0.00889217f \
 //x=14.89 //y=6.2 //x2=15.435 //y2=5.38
cc_436 ( N_noxref_2_c_444_p N_noxref_5_c_1522_n ) capacitor c=0.00326079f \
 //x=12.215 //y=1.76 //x2=15.59 //y2=1.75
cc_437 ( N_noxref_2_c_445_p N_noxref_5_c_1523_n ) capacitor c=0.00218808f \
 //x=12.615 //y=1.845 //x2=15.675 //y2=1.835
cc_438 ( N_noxref_2_c_445_p N_noxref_5_c_1524_n ) capacitor c=0.00203605f \
 //x=12.615 //y=1.845 //x2=16.03 //y2=3.705
cc_439 ( N_noxref_2_c_431_p N_noxref_5_c_1524_n ) capacitor c=6.61269e-19 \
 //x=14.55 //y=2.625 //x2=16.03 //y2=3.705
cc_440 ( N_noxref_2_c_426_p N_noxref_5_c_1524_n ) capacitor c=0.00107774f \
 //x=14.552 //y=4.74 //x2=16.03 //y2=3.705
cc_441 ( N_noxref_2_c_425_p N_noxref_5_c_1527_n ) capacitor c=0.00283621f \
 //x=12.7 //y=5.25 //x2=16.03 //y2=5.295
cc_442 ( N_noxref_2_c_426_p N_noxref_5_c_1527_n ) capacitor c=0.00152069f \
 //x=14.552 //y=4.74 //x2=16.03 //y2=5.295
cc_443 ( N_noxref_2_c_425_p N_noxref_5_c_1529_n ) capacitor c=9.19401e-19 \
 //x=12.7 //y=5.25 //x2=11.96 //y2=3.88
cc_444 ( N_noxref_2_c_452_p N_noxref_5_c_1530_n ) capacitor c=5.58535e-19 \
 //x=11.92 //y=5.56 //x2=14.67 //y2=5.56
cc_445 ( N_noxref_2_c_436_p N_noxref_5_c_1530_n ) capacitor c=0.00104762f \
 //x=12.615 //y=5.335 //x2=14.67 //y2=5.56
cc_446 ( N_noxref_2_c_454_p N_noxref_5_c_1530_n ) capacitor c=4.02865e-19 \
 //x=14.55 //y=2.945 //x2=14.67 //y2=5.56
cc_447 ( N_noxref_2_c_455_p N_noxref_5_c_1530_n ) capacitor c=0.0117744f \
 //x=14.55 //y=4.88 //x2=14.67 //y2=5.56
cc_448 ( N_noxref_2_c_456_p N_noxref_5_c_1530_n ) capacitor c=0.00277154f \
 //x=14.55 //y=4.88 //x2=14.67 //y2=5.56
cc_449 ( N_noxref_2_M68_noxref_g N_noxref_5_c_1530_n ) capacitor c=0.00201806f \
 //x=14.45 //y=6.2 //x2=14.67 //y2=5.56
cc_450 ( N_noxref_2_M69_noxref_g N_noxref_5_c_1530_n ) capacitor c=0.00192712f \
 //x=14.89 //y=6.2 //x2=14.67 //y2=5.56
cc_451 ( N_noxref_2_c_459_p N_noxref_5_c_1530_n ) capacitor c=0.00200677f \
 //x=14.55 //y=4.88 //x2=14.67 //y2=5.56
cc_452 ( N_noxref_2_c_460_p N_noxref_5_c_1538_n ) capacitor c=6.5615e-19 \
 //x=12.215 //y=1.305 //x2=15.59 //y2=1.18
cc_453 ( N_noxref_2_c_425_p N_noxref_5_c_1503_n ) capacitor c=0.00336755f \
 //x=12.7 //y=5.25 //x2=12.12 //y2=3.88
cc_454 ( N_noxref_2_c_425_p N_noxref_5_c_1540_n ) capacitor c=0.025435f \
 //x=12.7 //y=5.25 //x2=15.865 //y2=3.865
cc_455 ( N_noxref_2_c_426_p N_noxref_5_c_1540_n ) capacitor c=0.0258451f \
 //x=14.552 //y=4.74 //x2=15.865 //y2=3.865
cc_456 ( N_noxref_2_c_464_p N_noxref_5_c_1540_n ) capacitor c=0.0050752f \
 //x=14.385 //y=2.785 //x2=15.865 //y2=3.865
cc_457 ( N_noxref_2_c_427_p N_noxref_5_c_1543_n ) capacitor c=0.0015536f \
 //x=12.7 //y=2.625 //x2=11.96 //y2=2.26
cc_458 ( N_noxref_2_c_436_p N_noxref_5_c_1544_n ) capacitor c=0.00130631f \
 //x=12.615 //y=5.335 //x2=11.96 //y2=4.88
cc_459 ( N_noxref_2_c_425_p N_noxref_5_c_1544_n ) capacitor c=0.00131258f \
 //x=12.7 //y=5.25 //x2=11.96 //y2=4.88
cc_460 ( N_noxref_2_c_440_p N_noxref_5_c_1544_n ) capacitor c=0.00346456f \
 //x=11.92 //y=5.335 //x2=11.96 //y2=4.88
cc_461 ( N_noxref_2_c_442_p N_noxref_5_c_1544_n ) capacitor c=0.00624059f \
 //x=11.92 //y=5.56 //x2=11.96 //y2=4.88
cc_462 ( N_noxref_2_c_455_p N_noxref_5_c_1548_n ) capacitor c=0.00104426f \
 //x=14.55 //y=4.88 //x2=14.67 //y2=5.56
cc_463 ( N_noxref_2_c_456_p N_noxref_5_c_1548_n ) capacitor c=0.00377369f \
 //x=14.55 //y=4.88 //x2=14.67 //y2=5.56
cc_464 ( N_noxref_2_M68_noxref_g N_noxref_5_c_1548_n ) capacitor c=0.0158358f \
 //x=14.45 //y=6.2 //x2=14.67 //y2=5.56
cc_465 ( N_noxref_2_M69_noxref_g N_noxref_5_c_1548_n ) capacitor c=0.0178987f \
 //x=14.89 //y=6.2 //x2=14.67 //y2=5.56
cc_466 ( N_noxref_2_c_459_p N_noxref_5_c_1548_n ) capacitor c=0.0043218f \
 //x=14.55 //y=4.88 //x2=14.67 //y2=5.56
cc_467 ( N_noxref_2_c_435_p N_noxref_5_M66_noxref_g ) capacitor c=0.00952006f \
 //x=11.805 //y=5.335 //x2=11.7 //y2=6.2
cc_468 ( N_noxref_2_c_452_p N_noxref_5_M66_noxref_g ) capacitor c=0.00226521f \
 //x=11.92 //y=5.56 //x2=11.7 //y2=6.2
cc_469 ( N_noxref_2_c_442_p N_noxref_5_M66_noxref_g ) capacitor c=0.0178885f \
 //x=11.92 //y=5.56 //x2=11.7 //y2=6.2
cc_470 ( N_noxref_2_c_452_p N_noxref_5_M67_noxref_g ) capacitor c=0.00368945f \
 //x=11.92 //y=5.56 //x2=12.14 //y2=6.2
cc_471 ( N_noxref_2_c_436_p N_noxref_5_M67_noxref_g ) capacitor c=0.010861f \
 //x=12.615 //y=5.335 //x2=12.14 //y2=6.2
cc_472 ( N_noxref_2_c_442_p N_noxref_5_M67_noxref_g ) capacitor c=0.0188608f \
 //x=11.92 //y=5.56 //x2=12.14 //y2=6.2
cc_473 ( N_noxref_2_c_460_p N_noxref_5_c_1559_n ) capacitor c=4.64015e-19 \
 //x=12.215 //y=1.305 //x2=11.95 //y2=1.095
cc_474 ( N_noxref_2_M7_noxref_d N_noxref_5_c_1559_n ) capacitor c=0.00137165f \
 //x=12.025 //y=1.095 //x2=11.95 //y2=1.095
cc_475 ( N_noxref_2_c_460_p N_noxref_5_c_1561_n ) capacitor c=0.0026012f \
 //x=12.215 //y=1.305 //x2=11.95 //y2=1.44
cc_476 ( N_noxref_2_c_444_p N_noxref_5_c_1561_n ) capacitor c=0.00127432f \
 //x=12.215 //y=1.76 //x2=11.95 //y2=1.44
cc_477 ( N_noxref_2_M7_noxref_d N_noxref_5_c_1561_n ) capacitor c=0.00237422f \
 //x=12.025 //y=1.095 //x2=11.95 //y2=1.44
cc_478 ( N_noxref_2_c_444_p N_noxref_5_c_1564_n ) capacitor c=0.00429966f \
 //x=12.215 //y=1.76 //x2=11.95 //y2=1.75
cc_479 ( N_noxref_2_c_460_p N_noxref_5_c_1565_n ) capacitor c=5.29969e-19 \
 //x=12.215 //y=1.305 //x2=12.325 //y2=0.94
cc_480 ( N_noxref_2_M7_noxref_d N_noxref_5_c_1565_n ) capacitor c=0.0020782f \
 //x=12.025 //y=1.095 //x2=12.325 //y2=0.94
cc_481 ( N_noxref_2_c_460_p N_noxref_5_c_1567_n ) capacitor c=5.31507e-19 \
 //x=12.215 //y=1.305 //x2=12.325 //y2=1.595
cc_482 ( N_noxref_2_c_444_p N_noxref_5_c_1567_n ) capacitor c=0.00930387f \
 //x=12.215 //y=1.76 //x2=12.325 //y2=1.595
cc_483 ( N_noxref_2_c_445_p N_noxref_5_c_1567_n ) capacitor c=0.00194716f \
 //x=12.615 //y=1.845 //x2=12.325 //y2=1.595
cc_484 ( N_noxref_2_M7_noxref_d N_noxref_5_c_1567_n ) capacitor c=0.00356097f \
 //x=12.025 //y=1.095 //x2=12.325 //y2=1.595
cc_485 ( N_noxref_2_c_460_p N_noxref_5_c_1571_n ) capacitor c=5.28622e-19 \
 //x=12.215 //y=1.305 //x2=12.48 //y2=1.095
cc_486 ( N_noxref_2_M7_noxref_d N_noxref_5_c_1571_n ) capacitor c=0.00139206f \
 //x=12.025 //y=1.095 //x2=12.48 //y2=1.095
cc_487 ( N_noxref_2_c_460_p N_noxref_5_c_1573_n ) capacitor c=0.00312156f \
 //x=12.215 //y=1.305 //x2=12.48 //y2=1.44
cc_488 ( N_noxref_2_c_444_p N_noxref_5_c_1573_n ) capacitor c=0.00347599f \
 //x=12.215 //y=1.76 //x2=12.48 //y2=1.44
cc_489 ( N_noxref_2_c_445_p N_noxref_5_c_1573_n ) capacitor c=0.00323576f \
 //x=12.615 //y=1.845 //x2=12.48 //y2=1.44
cc_490 ( N_noxref_2_M7_noxref_d N_noxref_5_c_1573_n ) capacitor c=0.00237422f \
 //x=12.025 //y=1.095 //x2=12.48 //y2=1.44
cc_491 ( N_noxref_2_c_427_p N_noxref_5_c_1577_n ) capacitor c=0.0024584f \
 //x=12.7 //y=2.625 //x2=11.96 //y2=2.26
cc_492 ( N_noxref_2_c_444_p N_noxref_5_c_1578_n ) capacitor c=0.0036273f \
 //x=12.215 //y=1.76 //x2=11.96 //y2=2.095
cc_493 ( N_noxref_2_c_427_p N_noxref_5_c_1578_n ) capacitor c=0.00282067f \
 //x=12.7 //y=2.625 //x2=11.96 //y2=2.095
cc_494 ( N_noxref_2_c_425_p N_noxref_5_c_1580_n ) capacitor c=0.00739875f \
 //x=12.7 //y=5.25 //x2=11.96 //y2=4.88
cc_495 ( N_noxref_2_c_440_p N_noxref_5_c_1580_n ) capacitor c=0.00203307f \
 //x=11.92 //y=5.335 //x2=11.96 //y2=4.88
cc_496 ( N_noxref_2_c_442_p N_noxref_5_c_1580_n ) capacitor c=0.00375636f \
 //x=11.92 //y=5.56 //x2=11.96 //y2=4.88
cc_497 ( N_noxref_2_c_429_p N_D_c_4973_n ) capacitor c=0.00152841f //x=12.7 \
 //y=2.945 //x2=12.315 //y2=3.14
cc_498 ( N_noxref_2_c_425_p N_D_c_4973_n ) capacitor c=6.2241e-19 //x=12.7 \
 //y=5.25 //x2=12.315 //y2=3.14
cc_499 ( N_noxref_2_c_434_p N_D_c_4973_n ) capacitor c=0.0358254f //x=12.86 \
 //y=2.785 //x2=12.315 //y2=3.14
cc_500 ( N_noxref_2_c_429_p N_D_c_4976_n ) capacitor c=0.0101369f //x=12.7 \
 //y=2.945 //x2=12.915 //y2=3.17
cc_501 ( N_noxref_2_c_425_p N_D_c_4976_n ) capacitor c=0.0253031f //x=12.7 \
 //y=5.25 //x2=12.915 //y2=3.17
cc_502 ( N_noxref_2_c_426_p N_D_c_4976_n ) capacitor c=2.03225e-19 //x=14.552 \
 //y=4.74 //x2=12.915 //y2=3.17
cc_503 ( N_noxref_2_c_464_p N_D_c_4976_n ) capacitor c=0.127486f //x=14.385 \
 //y=2.785 //x2=12.915 //y2=3.17
cc_504 ( N_noxref_2_c_425_p N_D_c_4980_n ) capacitor c=2.04029e-19 //x=12.7 \
 //y=5.25 //x2=14.16 //y2=3.14
cc_505 ( N_noxref_2_c_454_p N_D_c_4980_n ) capacitor c=0.00485454f //x=14.55 \
 //y=2.945 //x2=14.16 //y2=3.14
cc_506 ( N_noxref_2_c_426_p N_D_c_4980_n ) capacitor c=9.97486e-19 //x=14.552 \
 //y=4.74 //x2=14.16 //y2=3.14
cc_507 ( N_noxref_2_c_515_p N_D_c_4980_n ) capacitor c=0.0358254f //x=14.545 \
 //y=2.785 //x2=14.16 //y2=3.14
cc_508 ( N_noxref_2_c_464_p N_D_c_4980_n ) capacitor c=0.0105193f //x=14.385 \
 //y=2.785 //x2=14.16 //y2=3.14
cc_509 ( N_noxref_2_c_454_p N_D_c_4985_n ) capacitor c=0.00267318f //x=14.55 \
 //y=2.945 //x2=14.76 //y2=3.17
cc_510 ( N_noxref_2_c_426_p N_D_c_4985_n ) capacitor c=0.024927f //x=14.552 \
 //y=4.74 //x2=14.76 //y2=3.17
cc_511 ( N_noxref_2_c_427_p CLK ) capacitor c=4.63397e-19 //x=12.7 //y=2.625 \
 //x2=15.29 //y2=2.77
cc_512 ( N_noxref_2_c_425_p CLK ) capacitor c=0.00206199f //x=12.7 //y=5.25 \
 //x2=15.29 //y2=2.77
cc_513 ( N_noxref_2_c_431_p CLK ) capacitor c=0.00839909f //x=14.55 //y=2.625 \
 //x2=15.29 //y2=2.77
cc_514 ( N_noxref_2_c_454_p CLK ) capacitor c=0.014957f //x=14.55 //y=2.945 \
 //x2=15.29 //y2=2.77
cc_515 ( N_noxref_2_c_523_p CLK ) capacitor c=6.6241e-19 //x=14.55 //y=2.77 \
 //x2=15.29 //y2=2.77
cc_516 ( N_noxref_2_c_426_p CLK ) capacitor c=0.0662547f //x=14.552 //y=4.74 \
 //x2=15.29 //y2=2.77
cc_517 ( N_noxref_2_c_515_p CLK ) capacitor c=0.00684101f //x=14.545 //y=2.785 \
 //x2=15.29 //y2=2.77
cc_518 ( N_noxref_2_c_526_p CLK ) capacitor c=3.30333e-19 //x=14.55 //y=2.26 \
 //x2=15.29 //y2=2.77
cc_519 ( N_noxref_2_c_527_p N_CLK_c_6337_n ) capacitor c=0.0179797f //x=14.55 \
 //y=2.26 //x2=15.29 //y2=2.26
cc_520 ( N_noxref_2_c_526_p N_CLK_c_6337_n ) capacitor c=5.16867e-19 //x=14.55 \
 //y=2.26 //x2=15.29 //y2=2.26
cc_521 ( N_noxref_2_c_529_p N_CLK_c_6337_n ) capacitor c=0.00161745f \
 //x=14.355 //y=2.095 //x2=15.29 //y2=2.26
cc_522 ( N_noxref_2_c_455_p N_CLK_c_6340_n ) capacitor c=0.0160977f //x=14.55 \
 //y=4.88 //x2=15.325 //y2=4.75
cc_523 ( N_noxref_2_c_426_p N_CLK_c_6340_n ) capacitor c=0.00638948f \
 //x=14.552 //y=4.74 //x2=15.325 //y2=4.75
cc_524 ( N_noxref_2_c_456_p N_CLK_c_6340_n ) capacitor c=0.00121956f //x=14.55 \
 //y=4.88 //x2=15.325 //y2=4.75
cc_525 ( N_noxref_2_c_459_p N_CLK_c_6340_n ) capacitor c=0.00177782f //x=14.55 \
 //y=4.88 //x2=15.325 //y2=4.75
cc_526 ( N_noxref_2_c_436_p N_CLK_c_6302_n ) capacitor c=0.0218207f //x=12.615 \
 //y=5.335 //x2=17.75 //y2=4.65
cc_527 ( N_noxref_2_c_425_p N_CLK_c_6302_n ) capacitor c=0.0300565f //x=12.7 \
 //y=5.25 //x2=17.75 //y2=4.65
cc_528 ( N_noxref_2_c_415_n N_CLK_c_6302_n ) capacitor c=0.0297837f //x=10.162 \
 //y=5.335 //x2=17.75 //y2=4.65
cc_529 ( N_noxref_2_c_537_p N_CLK_c_6302_n ) capacitor c=0.0379488f //x=11.04 \
 //y=5.335 //x2=17.75 //y2=4.65
cc_530 ( N_noxref_2_c_455_p N_CLK_c_6302_n ) capacitor c=0.00901811f //x=14.55 \
 //y=4.88 //x2=17.75 //y2=4.65
cc_531 ( N_noxref_2_c_426_p N_CLK_c_6302_n ) capacitor c=0.0273494f //x=14.552 \
 //y=4.74 //x2=17.75 //y2=4.65
cc_532 ( N_noxref_2_c_431_p N_CLK_c_6350_n ) capacitor c=3.30333e-19 //x=14.55 \
 //y=2.625 //x2=15.29 //y2=2.26
cc_533 ( N_noxref_2_c_527_p N_CLK_c_6350_n ) capacitor c=5.24723e-19 //x=14.55 \
 //y=2.26 //x2=15.29 //y2=2.26
cc_534 ( N_noxref_2_c_526_p N_CLK_c_6350_n ) capacitor c=0.00485709f //x=14.55 \
 //y=2.26 //x2=15.29 //y2=2.26
cc_535 ( N_noxref_2_c_529_p N_CLK_c_6350_n ) capacitor c=0.00190888f \
 //x=14.355 //y=2.095 //x2=15.29 //y2=2.26
cc_536 ( N_noxref_2_c_455_p N_CLK_c_6354_n ) capacitor c=4.80626e-19 //x=14.55 \
 //y=4.88 //x2=15.32 //y2=4.88
cc_537 ( N_noxref_2_c_456_p N_CLK_c_6354_n ) capacitor c=0.0039678f //x=14.55 \
 //y=4.88 //x2=15.32 //y2=4.88
cc_538 ( N_noxref_2_c_459_p N_CLK_c_6354_n ) capacitor c=0.0028411f //x=14.55 \
 //y=4.88 //x2=15.32 //y2=4.88
cc_539 ( N_noxref_2_M68_noxref_g N_CLK_M70_noxref_g ) capacitor c=0.0104892f \
 //x=14.45 //y=6.2 //x2=15.33 //y2=6.2
cc_540 ( N_noxref_2_M69_noxref_g N_CLK_M70_noxref_g ) capacitor c=0.107636f \
 //x=14.89 //y=6.2 //x2=15.33 //y2=6.2
cc_541 ( N_noxref_2_M69_noxref_g N_CLK_M71_noxref_g ) capacitor c=0.0100341f \
 //x=14.89 //y=6.2 //x2=15.77 //y2=6.2
cc_542 ( N_noxref_2_c_550_p N_CLK_c_6360_n ) capacitor c=4.86545e-19 \
 //x=14.355 //y=1.045 //x2=15.325 //y2=1.085
cc_543 ( N_noxref_2_c_551_p N_CLK_c_6360_n ) capacitor c=0.00152405f \
 //x=14.355 //y=1.39 //x2=15.325 //y2=1.085
cc_544 ( N_noxref_2_c_552_p N_CLK_c_6360_n ) capacitor c=0.0151475f //x=14.885 \
 //y=1.045 //x2=15.325 //y2=1.085
cc_545 ( N_noxref_2_c_553_p N_CLK_c_6363_n ) capacitor c=0.00109982f \
 //x=14.355 //y=1.7 //x2=15.325 //y2=1.43
cc_546 ( N_noxref_2_c_554_p N_CLK_c_6363_n ) capacitor c=0.0111064f //x=14.885 \
 //y=1.39 //x2=15.325 //y2=1.43
cc_547 ( N_noxref_2_c_553_p N_CLK_c_6365_n ) capacitor c=9.58243e-19 \
 //x=14.355 //y=1.7 //x2=15.325 //y2=1.74
cc_548 ( N_noxref_2_c_529_p N_CLK_c_6365_n ) capacitor c=0.00662747f \
 //x=14.355 //y=2.095 //x2=15.325 //y2=1.74
cc_549 ( N_noxref_2_c_554_p N_CLK_c_6365_n ) capacitor c=0.00862358f \
 //x=14.885 //y=1.39 //x2=15.325 //y2=1.74
cc_550 ( N_noxref_2_c_552_p N_CLK_c_6368_n ) capacitor c=0.00127211f \
 //x=14.885 //y=1.045 //x2=15.855 //y2=1.085
cc_551 ( N_noxref_2_c_554_p N_CLK_c_6369_n ) capacitor c=0.00204774f \
 //x=14.885 //y=1.39 //x2=15.855 //y2=1.43
cc_552 ( N_noxref_2_c_527_p N_CLK_c_6370_n ) capacitor c=0.00161167f //x=14.55 \
 //y=2.26 //x2=15.29 //y2=2.26
cc_553 ( N_noxref_2_c_526_p N_CLK_c_6370_n ) capacitor c=0.00266443f //x=14.55 \
 //y=2.26 //x2=15.29 //y2=2.26
cc_554 ( N_noxref_2_c_529_p N_CLK_c_6370_n ) capacitor c=0.0181449f //x=14.355 \
 //y=2.095 //x2=15.29 //y2=2.26
cc_555 ( N_noxref_2_c_455_p N_CLK_c_6373_n ) capacitor c=5.5856e-19 //x=14.55 \
 //y=4.88 //x2=15.32 //y2=4.88
cc_556 ( N_noxref_2_c_456_p N_CLK_c_6373_n ) capacitor c=0.00211091f //x=14.55 \
 //y=4.88 //x2=15.32 //y2=4.88
cc_557 ( N_noxref_2_c_459_p N_CLK_c_6373_n ) capacitor c=0.0291521f //x=14.55 \
 //y=4.88 //x2=15.32 //y2=4.88
cc_558 ( N_noxref_2_c_425_p SN ) capacitor c=0.0023149f //x=12.7 //y=5.25 \
 //x2=10.85 //y2=2.77
cc_559 ( N_noxref_2_c_414_n N_SN_c_8051_n ) capacitor c=3.40598e-19 //x=10.92 \
 //y=5.335 //x2=10.85 //y2=2.55
cc_560 ( N_noxref_2_c_537_p N_SN_c_8051_n ) capacitor c=4.44961e-19 //x=11.04 \
 //y=5.335 //x2=10.85 //y2=2.55
cc_561 ( N_noxref_2_c_414_n N_SN_c_8055_n ) capacitor c=0.0213631f //x=10.92 \
 //y=5.335 //x2=10.85 //y2=4.765
cc_562 ( N_noxref_2_c_537_p N_SN_c_8055_n ) capacitor c=0.00239361f //x=11.04 \
 //y=5.335 //x2=10.85 //y2=4.765
cc_563 ( N_noxref_2_c_571_p N_SN_c_8055_n ) capacitor c=7.85344e-19 //x=11.04 \
 //y=5.56 //x2=10.85 //y2=4.765
cc_564 ( N_noxref_2_c_460_p N_SN_c_8092_n ) capacitor c=7.08559e-19 //x=12.215 \
 //y=1.305 //x2=22.15 //y2=2.4
cc_565 ( N_noxref_2_c_424_p N_SN_c_8092_n ) capacitor c=0.0210985f //x=12.3 \
 //y=1.845 //x2=22.15 //y2=2.4
cc_566 ( N_noxref_2_c_427_p N_SN_c_8092_n ) capacitor c=0.0272596f //x=12.7 \
 //y=2.625 //x2=22.15 //y2=2.4
cc_567 ( N_noxref_2_c_429_p N_SN_c_8092_n ) capacitor c=0.00577069f //x=12.7 \
 //y=2.945 //x2=22.15 //y2=2.4
cc_568 ( N_noxref_2_c_431_p N_SN_c_8092_n ) capacitor c=0.0121034f //x=14.55 \
 //y=2.625 //x2=22.15 //y2=2.4
cc_569 ( N_noxref_2_c_454_p N_SN_c_8092_n ) capacitor c=0.00673157f //x=14.55 \
 //y=2.945 //x2=22.15 //y2=2.4
cc_570 ( N_noxref_2_c_527_p N_SN_c_8092_n ) capacitor c=0.0165635f //x=14.55 \
 //y=2.26 //x2=22.15 //y2=2.4
cc_571 ( N_noxref_2_c_434_p N_SN_c_8092_n ) capacitor c=0.0365231f //x=12.86 \
 //y=2.785 //x2=22.15 //y2=2.4
cc_572 ( N_noxref_2_c_515_p N_SN_c_8092_n ) capacitor c=0.0371276f //x=14.545 \
 //y=2.785 //x2=22.15 //y2=2.4
cc_573 ( N_noxref_2_c_464_p N_SN_c_8092_n ) capacitor c=0.13892f //x=14.385 \
 //y=2.785 //x2=22.15 //y2=2.4
cc_574 ( N_noxref_2_c_526_p N_SN_c_8092_n ) capacitor c=2.20453e-19 //x=14.55 \
 //y=2.26 //x2=22.15 //y2=2.4
cc_575 ( N_noxref_2_c_529_p N_SN_c_8092_n ) capacitor c=3.61358e-19 //x=14.355 \
 //y=2.095 //x2=22.15 //y2=2.4
cc_576 ( N_noxref_2_c_414_n N_SN_c_8064_n ) capacitor c=0.00492634f //x=10.92 \
 //y=5.335 //x2=10.85 //y2=4.88
cc_577 ( N_noxref_2_c_537_p N_SN_c_8064_n ) capacitor c=0.00132214f //x=11.04 \
 //y=5.335 //x2=10.85 //y2=4.88
cc_578 ( N_noxref_2_c_414_n N_SN_M64_noxref_g ) capacitor c=0.00858241f \
 //x=10.92 //y=5.335 //x2=10.82 //y2=6.2
cc_579 ( N_noxref_2_c_537_p N_SN_M64_noxref_g ) capacitor c=0.00229818f \
 //x=11.04 //y=5.335 //x2=10.82 //y2=6.2
cc_580 ( N_noxref_2_c_571_p N_SN_M64_noxref_g ) capacitor c=0.0179041f \
 //x=11.04 //y=5.56 //x2=10.82 //y2=6.2
cc_581 ( N_noxref_2_c_435_p N_SN_M65_noxref_g ) capacitor c=0.00955829f \
 //x=11.805 //y=5.335 //x2=11.26 //y2=6.2
cc_582 ( N_noxref_2_c_537_p N_SN_M65_noxref_g ) capacitor c=0.00230699f \
 //x=11.04 //y=5.335 //x2=11.26 //y2=6.2
cc_583 ( N_noxref_2_c_571_p N_SN_M65_noxref_g ) capacitor c=0.0179041f \
 //x=11.04 //y=5.56 //x2=11.26 //y2=6.2
cc_584 ( N_noxref_2_c_537_p N_SN_c_8112_n ) capacitor c=0.00181015f //x=11.04 \
 //y=5.335 //x2=11.185 //y2=4.97
cc_585 ( N_noxref_2_c_571_p N_SN_c_8112_n ) capacitor c=0.00290085f //x=11.04 \
 //y=5.56 //x2=11.185 //y2=4.97
cc_586 ( N_noxref_2_c_414_n N_SN_c_8082_n ) capacitor c=6.14744e-19 //x=10.92 \
 //y=5.335 //x2=10.85 //y2=4.88
cc_587 ( N_noxref_2_c_414_n N_VDD_c_11522_n ) capacitor c=0.00621363f \
 //x=10.92 //y=5.335 //x2=74.455 //y2=7.585
cc_588 ( N_noxref_2_c_435_p N_VDD_c_11522_n ) capacitor c=0.00627186f \
 //x=11.805 //y=5.335 //x2=74.455 //y2=7.585
cc_589 ( N_noxref_2_c_452_p N_VDD_c_11522_n ) capacitor c=0.00256019f \
 //x=11.92 //y=5.56 //x2=74.455 //y2=7.585
cc_590 ( N_noxref_2_c_436_p N_VDD_c_11522_n ) capacitor c=0.00824067f \
 //x=12.615 //y=5.335 //x2=74.455 //y2=7.585
cc_591 ( N_noxref_2_c_415_n N_VDD_c_11522_n ) capacitor c=0.00261804f \
 //x=10.162 //y=5.335 //x2=74.455 //y2=7.585
cc_592 ( N_noxref_2_c_537_p N_VDD_c_11522_n ) capacitor c=0.00270108f \
 //x=11.04 //y=5.335 //x2=74.455 //y2=7.585
cc_593 ( N_noxref_2_c_455_p N_VDD_c_11522_n ) capacitor c=9.07241e-19 \
 //x=14.55 //y=4.88 //x2=74.455 //y2=7.585
cc_594 ( N_noxref_2_c_419_n N_VDD_c_11522_n ) capacitor c=0.0024232f //x=10.16 \
 //y=5.56 //x2=74.455 //y2=7.585
cc_595 ( N_noxref_2_c_571_p N_VDD_c_11522_n ) capacitor c=0.0024232f //x=11.04 \
 //y=5.56 //x2=74.455 //y2=7.585
cc_596 ( N_noxref_2_c_442_p N_VDD_c_11522_n ) capacitor c=0.0024232f //x=11.92 \
 //y=5.56 //x2=74.455 //y2=7.585
cc_597 ( N_noxref_2_c_456_p N_VDD_c_11522_n ) capacitor c=6.22888e-19 \
 //x=14.55 //y=4.88 //x2=74.455 //y2=7.585
cc_598 ( N_noxref_2_c_414_n N_VDD_c_11539_n ) capacitor c=0.00202922f \
 //x=10.92 //y=5.335 //x2=10.515 //y2=7.585
cc_599 ( N_noxref_2_c_415_n N_VDD_c_11539_n ) capacitor c=9.3757e-19 \
 //x=10.162 //y=5.335 //x2=10.515 //y2=7.585
cc_600 ( N_noxref_2_c_419_n N_VDD_c_11539_n ) capacitor c=0.0138074f //x=10.16 \
 //y=5.56 //x2=10.515 //y2=7.585
cc_601 ( N_noxref_2_c_414_n N_VDD_c_11595_n ) capacitor c=0.0017708f //x=10.92 \
 //y=5.335 //x2=11.395 //y2=7.585
cc_602 ( N_noxref_2_c_435_p N_VDD_c_11595_n ) capacitor c=0.00202922f \
 //x=11.805 //y=5.335 //x2=11.395 //y2=7.585
cc_603 ( N_noxref_2_c_537_p N_VDD_c_11595_n ) capacitor c=9.4822e-19 //x=11.04 \
 //y=5.335 //x2=11.395 //y2=7.585
cc_604 ( N_noxref_2_c_571_p N_VDD_c_11595_n ) capacitor c=0.0138074f //x=11.04 \
 //y=5.56 //x2=11.395 //y2=7.585
cc_605 ( N_noxref_2_c_435_p N_VDD_c_11599_n ) capacitor c=0.00205906f \
 //x=11.805 //y=5.335 //x2=12.275 //y2=7.585
cc_606 ( N_noxref_2_c_452_p N_VDD_c_11599_n ) capacitor c=8.49654e-19 \
 //x=11.92 //y=5.56 //x2=12.275 //y2=7.585
cc_607 ( N_noxref_2_c_436_p N_VDD_c_11599_n ) capacitor c=0.00204238f \
 //x=12.615 //y=5.335 //x2=12.275 //y2=7.585
cc_608 ( N_noxref_2_c_442_p N_VDD_c_11599_n ) capacitor c=0.0135103f //x=11.92 \
 //y=5.56 //x2=12.275 //y2=7.585
cc_609 ( N_noxref_2_c_436_p N_VDD_c_11603_n ) capacitor c=0.00183742f \
 //x=12.615 //y=5.335 //x2=13.27 //y2=7.585
cc_610 ( N_noxref_2_c_455_p N_VDD_c_11604_n ) capacitor c=6.28113e-19 \
 //x=14.55 //y=4.88 //x2=15.025 //y2=7.585
cc_611 ( N_noxref_2_M68_noxref_g N_VDD_c_11604_n ) capacitor c=0.00732618f \
 //x=14.45 //y=6.2 //x2=15.025 //y2=7.585
cc_612 ( N_noxref_2_M69_noxref_g N_VDD_c_11604_n ) capacitor c=0.00755544f \
 //x=14.89 //y=6.2 //x2=15.025 //y2=7.585
cc_613 ( N_noxref_2_c_415_n N_VDD_c_11551_n ) capacitor c=0.0022955f \
 //x=10.162 //y=5.335 //x2=8.63 //y2=7.585
cc_614 ( N_noxref_2_c_419_n N_VDD_c_11551_n ) capacitor c=0.00509469f \
 //x=10.16 //y=5.56 //x2=8.63 //y2=7.585
cc_615 ( N_noxref_2_c_452_p N_VDD_c_11609_n ) capacitor c=0.00269779f \
 //x=11.92 //y=5.56 //x2=13.44 //y2=7.585
cc_616 ( N_noxref_2_c_425_p N_VDD_c_11609_n ) capacitor c=0.0316694f //x=12.7 \
 //y=5.25 //x2=13.44 //y2=7.585
cc_617 ( N_noxref_2_c_455_p N_VDD_c_11609_n ) capacitor c=0.00483853f \
 //x=14.55 //y=4.88 //x2=13.44 //y2=7.585
cc_618 ( N_noxref_2_c_426_p N_VDD_c_11609_n ) capacitor c=0.00593318f \
 //x=14.552 //y=4.74 //x2=13.44 //y2=7.585
cc_619 ( N_noxref_2_c_442_p N_VDD_c_11609_n ) capacitor c=0.00776541f \
 //x=11.92 //y=5.56 //x2=13.44 //y2=7.585
cc_620 ( N_noxref_2_c_456_p N_VDD_c_11609_n ) capacitor c=0.00370494f \
 //x=14.55 //y=4.88 //x2=13.44 //y2=7.585
cc_621 ( N_noxref_2_c_459_p N_VDD_c_11609_n ) capacitor c=0.0129564f //x=14.55 \
 //y=4.88 //x2=13.44 //y2=7.585
cc_622 ( N_noxref_2_c_415_n N_VDD_M62_noxref_s ) capacitor c=0.0441176f \
 //x=10.162 //y=5.335 //x2=9.585 //y2=5.2
cc_623 ( N_noxref_2_c_537_p N_VDD_M62_noxref_s ) capacitor c=7.80122e-19 \
 //x=11.04 //y=5.335 //x2=9.585 //y2=5.2
cc_624 ( N_noxref_2_c_419_n N_VDD_M62_noxref_s ) capacitor c=0.09305f \
 //x=10.16 //y=5.56 //x2=9.585 //y2=5.2
cc_625 ( N_noxref_2_c_414_n N_VDD_M63_noxref_d ) capacitor c=0.00700141f \
 //x=10.92 //y=5.335 //x2=10.455 //y2=5.2
cc_626 ( N_noxref_2_c_419_n N_VDD_M63_noxref_d ) capacitor c=0.0674491f \
 //x=10.16 //y=5.56 //x2=10.455 //y2=5.2
cc_627 ( N_noxref_2_c_571_p N_VDD_M63_noxref_d ) capacitor c=0.0674762f \
 //x=11.04 //y=5.56 //x2=10.455 //y2=5.2
cc_628 ( N_noxref_2_c_435_p N_VDD_M65_noxref_d ) capacitor c=0.00700141f \
 //x=11.805 //y=5.335 //x2=11.335 //y2=5.2
cc_629 ( N_noxref_2_c_571_p N_VDD_M65_noxref_d ) capacitor c=0.067493f \
 //x=11.04 //y=5.56 //x2=11.335 //y2=5.2
cc_630 ( N_noxref_2_c_442_p N_VDD_M65_noxref_d ) capacitor c=0.0674288f \
 //x=11.92 //y=5.56 //x2=11.335 //y2=5.2
cc_631 ( N_noxref_2_c_436_p N_VDD_M67_noxref_d ) capacitor c=0.00700141f \
 //x=12.615 //y=5.335 //x2=12.215 //y2=5.2
cc_632 ( N_noxref_2_c_442_p N_VDD_M67_noxref_d ) capacitor c=0.0673824f \
 //x=11.92 //y=5.56 //x2=12.215 //y2=5.2
cc_633 ( N_noxref_2_c_452_p N_VDD_M68_noxref_s ) capacitor c=0.00536022f \
 //x=11.92 //y=5.56 //x2=14.095 //y2=5.2
cc_634 ( N_noxref_2_c_436_p N_VDD_M68_noxref_s ) capacitor c=0.00211796f \
 //x=12.615 //y=5.335 //x2=14.095 //y2=5.2
cc_635 ( N_noxref_2_c_454_p N_VDD_M68_noxref_s ) capacitor c=7.65656e-19 \
 //x=14.55 //y=2.945 //x2=14.095 //y2=5.2
cc_636 ( N_noxref_2_M68_noxref_g N_VDD_M68_noxref_s ) capacitor c=0.0567929f \
 //x=14.45 //y=6.2 //x2=14.095 //y2=5.2
cc_637 ( N_noxref_2_M69_noxref_g N_VDD_M69_noxref_d ) capacitor c=0.015318f \
 //x=14.89 //y=6.2 //x2=14.965 //y2=5.2
cc_638 ( N_noxref_2_c_460_p N_noxref_25_c_13017_n ) capacitor c=0.0036878f \
 //x=12.215 //y=1.305 //x2=12.615 //y2=0.72
cc_639 ( N_noxref_2_c_445_p N_noxref_25_c_13017_n ) capacitor c=0.00399931f \
 //x=12.615 //y=1.845 //x2=12.615 //y2=0.72
cc_640 ( N_noxref_2_M7_noxref_d N_noxref_25_c_13017_n ) capacitor \
 c=0.00910163f //x=12.025 //y=1.095 //x2=12.615 //y2=0.72
cc_641 ( N_noxref_2_M7_noxref_d N_noxref_25_c_13020_n ) capacitor \
 c=0.00120711f //x=12.025 //y=1.095 //x2=11.73 //y2=1.175
cc_642 ( N_noxref_2_c_414_n N_noxref_25_M6_noxref_d ) capacitor c=0.00133196f \
 //x=10.92 //y=5.335 //x2=10.49 //y2=1.09
cc_643 ( N_noxref_2_c_460_p N_noxref_25_M6_noxref_d ) capacitor c=0.00802836f \
 //x=12.215 //y=1.305 //x2=10.49 //y2=1.09
cc_644 ( N_noxref_2_c_460_p N_noxref_25_M7_noxref_s ) capacitor c=0.00993092f \
 //x=12.215 //y=1.305 //x2=11.595 //y2=0.555
cc_645 ( N_noxref_2_c_444_p N_noxref_25_M7_noxref_s ) capacitor c=0.0270624f \
 //x=12.215 //y=1.76 //x2=11.595 //y2=0.555
cc_646 ( N_noxref_2_c_445_p N_noxref_25_M7_noxref_s ) capacitor c=0.00752108f \
 //x=12.615 //y=1.845 //x2=11.595 //y2=0.555
cc_647 ( N_noxref_2_c_418_n N_noxref_25_M7_noxref_s ) capacitor c=0.00309975f \
 //x=12.7 //y=2.77 //x2=11.595 //y2=0.555
cc_648 ( N_noxref_2_M7_noxref_d N_noxref_25_M7_noxref_s ) capacitor \
 c=0.0279003f //x=12.025 //y=1.095 //x2=11.595 //y2=0.555
cc_649 ( N_noxref_2_c_460_p N_GND_c_13937_n ) capacitor c=0.00878689f \
 //x=12.215 //y=1.305 //x2=14.535 //y2=0.175
cc_650 ( N_noxref_2_c_445_p N_GND_c_13937_n ) capacitor c=0.00662992f \
 //x=12.615 //y=1.845 //x2=14.535 //y2=0.175
cc_651 ( N_noxref_2_c_429_p N_GND_c_13937_n ) capacitor c=4.30498e-19 //x=12.7 \
 //y=2.945 //x2=14.535 //y2=0.175
cc_652 ( N_noxref_2_M7_noxref_d N_GND_c_13937_n ) capacitor c=2.9462e-19 \
 //x=12.025 //y=1.095 //x2=14.535 //y2=0.175
cc_653 ( N_noxref_2_c_460_p N_GND_c_13941_n ) capacitor c=0.00488628f \
 //x=12.215 //y=1.305 //x2=14.62 //y2=1.135
cc_654 ( N_noxref_2_c_454_p N_GND_c_13941_n ) capacitor c=2.00375e-19 \
 //x=14.55 //y=2.945 //x2=14.62 //y2=1.135
cc_655 ( N_noxref_2_c_527_p N_GND_c_13941_n ) capacitor c=0.00645051f \
 //x=14.55 //y=2.26 //x2=14.62 //y2=1.135
cc_656 ( N_noxref_2_c_526_p N_GND_c_13941_n ) capacitor c=2.13705e-19 \
 //x=14.55 //y=2.26 //x2=14.62 //y2=1.135
cc_657 ( N_noxref_2_c_550_p N_GND_c_13941_n ) capacitor c=0.00176535f \
 //x=14.355 //y=1.045 //x2=14.62 //y2=1.135
cc_658 ( N_noxref_2_c_551_p N_GND_c_13941_n ) capacitor c=0.0036005f \
 //x=14.355 //y=1.39 //x2=14.62 //y2=1.135
cc_659 ( N_noxref_2_c_553_p N_GND_c_13941_n ) capacitor c=4.2764e-19 \
 //x=14.355 //y=1.7 //x2=14.62 //y2=1.135
cc_660 ( N_noxref_2_c_668_p N_GND_c_13941_n ) capacitor c=9.36995e-19 \
 //x=14.73 //y=0.89 //x2=14.62 //y2=1.135
cc_661 ( N_noxref_2_c_669_p N_GND_c_13941_n ) capacitor c=6.38426e-19 \
 //x=14.73 //y=1.545 //x2=14.62 //y2=1.135
cc_662 ( N_noxref_2_c_552_p N_GND_c_13941_n ) capacitor c=0.00171721f \
 //x=14.885 //y=1.045 //x2=14.62 //y2=1.135
cc_663 ( N_noxref_2_c_554_p N_GND_c_13941_n ) capacitor c=0.00296337f \
 //x=14.885 //y=1.39 //x2=14.62 //y2=1.135
cc_664 ( N_noxref_2_c_550_p N_GND_c_13952_n ) capacitor c=3.51399e-19 \
 //x=14.355 //y=1.045 //x2=14.617 //y2=1.005
cc_665 ( N_noxref_2_c_668_p N_GND_c_13952_n ) capacitor c=0.00852202f \
 //x=14.73 //y=0.89 //x2=14.617 //y2=1.005
cc_666 ( N_noxref_2_c_552_p N_GND_c_13952_n ) capacitor c=4.40641e-19 \
 //x=14.885 //y=1.045 //x2=14.617 //y2=1.005
cc_667 ( N_noxref_2_c_445_p N_GND_c_13901_n ) capacitor c=6.86343e-19 \
 //x=12.615 //y=1.845 //x2=13.27 //y2=0.175
cc_668 ( N_noxref_2_c_429_p N_GND_c_13901_n ) capacitor c=6.00344e-19 //x=12.7 \
 //y=2.945 //x2=13.27 //y2=0.175
cc_669 ( N_noxref_2_c_550_p N_GND_c_13957_n ) capacitor c=0.00688027f \
 //x=14.355 //y=1.045 //x2=16.6 //y2=0.175
cc_670 ( N_noxref_2_c_444_p N_GND_c_13958_n ) capacitor c=0.00285697f \
 //x=12.215 //y=1.76 //x2=13.44 //y2=0.175
cc_671 ( N_noxref_2_c_445_p N_GND_c_13958_n ) capacitor c=0.022222f //x=12.615 \
 //y=1.845 //x2=13.44 //y2=0.175
cc_672 ( N_noxref_2_c_427_p N_GND_c_13958_n ) capacitor c=2.00878e-19 //x=12.7 \
 //y=2.625 //x2=13.44 //y2=0.175
cc_673 ( N_noxref_2_c_429_p N_GND_c_13958_n ) capacitor c=0.00401039f //x=12.7 \
 //y=2.945 //x2=13.44 //y2=0.175
cc_674 ( N_noxref_2_c_431_p N_GND_c_13958_n ) capacitor c=0.00301679f \
 //x=14.55 //y=2.625 //x2=13.44 //y2=0.175
cc_675 ( N_noxref_2_c_454_p N_GND_c_13958_n ) capacitor c=0.00293146f \
 //x=14.55 //y=2.945 //x2=13.44 //y2=0.175
cc_676 ( N_noxref_2_c_418_n N_GND_c_13958_n ) capacitor c=0.0103966f //x=12.7 \
 //y=2.77 //x2=13.44 //y2=0.175
cc_677 ( N_noxref_2_c_523_p N_GND_c_13958_n ) capacitor c=0.00512795f \
 //x=14.55 //y=2.77 //x2=13.44 //y2=0.175
cc_678 ( N_noxref_2_c_527_p N_GND_c_13958_n ) capacitor c=0.00351582f \
 //x=14.55 //y=2.26 //x2=13.44 //y2=0.175
cc_679 ( N_noxref_2_c_464_p N_GND_c_13958_n ) capacitor c=0.00947774f \
 //x=14.385 //y=2.785 //x2=13.44 //y2=0.175
cc_680 ( N_noxref_2_c_526_p N_GND_c_13958_n ) capacitor c=0.00371068f \
 //x=14.55 //y=2.26 //x2=13.44 //y2=0.175
cc_681 ( N_noxref_2_c_553_p N_GND_c_13958_n ) capacitor c=0.0015404f \
 //x=14.355 //y=1.7 //x2=13.44 //y2=0.175
cc_682 ( N_noxref_2_c_529_p N_GND_c_13958_n ) capacitor c=0.0093907f \
 //x=14.355 //y=2.095 //x2=13.44 //y2=0.175
cc_683 ( N_noxref_2_c_523_p N_GND_c_13971_n ) capacitor c=0.00159554f \
 //x=14.55 //y=2.77 //x2=16.77 //y2=0.175
cc_684 ( N_noxref_2_c_527_p N_GND_M8_noxref_d ) capacitor c=2.20438e-19 \
 //x=14.55 //y=2.26 //x2=14.43 //y2=1.045
cc_685 ( N_noxref_2_c_550_p N_GND_M8_noxref_d ) capacitor c=0.00192399f \
 //x=14.355 //y=1.045 //x2=14.43 //y2=1.045
cc_686 ( N_noxref_2_c_551_p N_GND_M8_noxref_d ) capacitor c=0.00210798f \
 //x=14.355 //y=1.39 //x2=14.43 //y2=1.045
cc_687 ( N_noxref_2_c_668_p N_GND_M8_noxref_d ) capacitor c=0.00472259f \
 //x=14.73 //y=0.89 //x2=14.43 //y2=1.045
cc_688 ( N_noxref_2_c_669_p N_GND_M8_noxref_d ) capacitor c=0.00166857f \
 //x=14.73 //y=1.545 //x2=14.43 //y2=1.045
cc_689 ( N_noxref_2_c_552_p N_GND_M8_noxref_d ) capacitor c=0.00230174f \
 //x=14.885 //y=1.045 //x2=14.43 //y2=1.045
cc_690 ( N_noxref_2_c_554_p N_GND_M8_noxref_d ) capacitor c=0.00210798f \
 //x=14.885 //y=1.39 //x2=14.43 //y2=1.045
cc_691 ( N_noxref_2_c_529_p N_noxref_40_c_15777_n ) capacitor c=0.00262672f \
 //x=14.355 //y=2.095 //x2=14.135 //y2=1.675
cc_692 ( N_noxref_2_c_454_p N_noxref_40_c_15778_n ) capacitor c=0.00530082f \
 //x=14.55 //y=2.945 //x2=15.02 //y2=1.76
cc_693 ( N_noxref_2_c_527_p N_noxref_40_c_15778_n ) capacitor c=0.00509504f \
 //x=14.55 //y=2.26 //x2=15.02 //y2=1.76
cc_694 ( N_noxref_2_c_526_p N_noxref_40_c_15778_n ) capacitor c=0.00763108f \
 //x=14.55 //y=2.26 //x2=15.02 //y2=1.76
cc_695 ( N_noxref_2_c_553_p N_noxref_40_c_15778_n ) capacitor c=0.00697076f \
 //x=14.355 //y=1.7 //x2=15.02 //y2=1.76
cc_696 ( N_noxref_2_c_529_p N_noxref_40_c_15778_n ) capacitor c=0.0165799f \
 //x=14.355 //y=2.095 //x2=15.02 //y2=1.76
cc_697 ( N_noxref_2_c_669_p N_noxref_40_c_15778_n ) capacitor c=0.00723574f \
 //x=14.73 //y=1.545 //x2=15.02 //y2=1.76
cc_698 ( N_noxref_2_c_554_p N_noxref_40_c_15778_n ) capacitor c=0.00339872f \
 //x=14.885 //y=1.39 //x2=15.02 //y2=1.76
cc_699 ( N_noxref_2_c_529_p N_noxref_40_c_15785_n ) capacitor c=6.71402e-19 \
 //x=14.355 //y=2.095 //x2=15.105 //y2=1.675
cc_700 ( N_noxref_2_c_550_p N_noxref_40_M8_noxref_s ) capacitor c=0.0295366f \
 //x=14.355 //y=1.045 //x2=14 //y2=0.545
cc_701 ( N_noxref_2_c_553_p N_noxref_40_M8_noxref_s ) capacitor c=3.48408e-19 \
 //x=14.355 //y=1.7 //x2=14 //y2=0.545
cc_702 ( N_noxref_2_c_552_p N_noxref_40_M8_noxref_s ) capacitor c=0.0125442f \
 //x=14.885 //y=1.045 //x2=14 //y2=0.545
cc_703 ( N_noxref_3_M73_noxref_g N_noxref_4_c_1199_n ) capacitor c=0.00887624f \
 //x=18.22 //y=6.2 //x2=18.765 //y2=5.38
cc_704 ( N_noxref_3_c_800_p N_noxref_4_c_1200_n ) capacitor c=0.00452653f \
 //x=17.88 //y=4.105 //x2=19.36 //y2=4.105
cc_705 ( N_noxref_3_c_801_p N_noxref_4_c_1201_n ) capacitor c=6.96118e-19 \
 //x=17.882 //y=4.74 //x2=19.36 //y2=5.295
cc_706 ( N_noxref_3_c_802_p N_noxref_4_c_1202_n ) capacitor c=0.00121594f \
 //x=17.88 //y=4.425 //x2=18 //y2=5.56
cc_707 ( N_noxref_3_c_803_p N_noxref_4_c_1202_n ) capacitor c=0.0117717f \
 //x=17.88 //y=4.88 //x2=18 //y2=5.56
cc_708 ( N_noxref_3_c_804_p N_noxref_4_c_1202_n ) capacitor c=0.00277154f \
 //x=17.88 //y=4.88 //x2=18 //y2=5.56
cc_709 ( N_noxref_3_M72_noxref_g N_noxref_4_c_1202_n ) capacitor c=0.00201806f \
 //x=17.78 //y=6.2 //x2=18 //y2=5.56
cc_710 ( N_noxref_3_M73_noxref_g N_noxref_4_c_1202_n ) capacitor c=0.00192712f \
 //x=18.22 //y=6.2 //x2=18 //y2=5.56
cc_711 ( N_noxref_3_c_807_p N_noxref_4_c_1202_n ) capacitor c=0.00201193f \
 //x=17.88 //y=4.88 //x2=18 //y2=5.56
cc_712 ( N_noxref_3_c_808_p N_noxref_4_c_1208_n ) capacitor c=0.00251935f \
 //x=17.88 //y=4.25 //x2=19.36 //y2=4.25
cc_713 ( N_noxref_3_c_809_p N_noxref_4_c_1209_n ) capacitor c=0.00541611f \
 //x=17.88 //y=4.265 //x2=19.52 //y2=4.265
cc_714 ( N_noxref_3_c_802_p N_noxref_4_c_1210_n ) capacitor c=4.87998e-19 \
 //x=17.88 //y=4.425 //x2=18 //y2=5.56
cc_715 ( N_noxref_3_c_803_p N_noxref_4_c_1210_n ) capacitor c=0.00104426f \
 //x=17.88 //y=4.88 //x2=18 //y2=5.56
cc_716 ( N_noxref_3_c_804_p N_noxref_4_c_1210_n ) capacitor c=0.00377369f \
 //x=17.88 //y=4.88 //x2=18 //y2=5.56
cc_717 ( N_noxref_3_M72_noxref_g N_noxref_4_c_1210_n ) capacitor c=0.0158358f \
 //x=17.78 //y=6.2 //x2=18 //y2=5.56
cc_718 ( N_noxref_3_M73_noxref_g N_noxref_4_c_1210_n ) capacitor c=0.0178987f \
 //x=18.22 //y=6.2 //x2=18 //y2=5.56
cc_719 ( N_noxref_3_c_807_p N_noxref_4_c_1210_n ) capacitor c=0.00319448f \
 //x=17.88 //y=4.88 //x2=18 //y2=5.56
cc_720 ( N_noxref_3_c_731_n N_noxref_5_c_1491_n ) capacitor c=0.0154269f \
 //x=7.89 //y=4.09 //x2=7.15 //y2=2.375
cc_721 ( N_noxref_3_c_731_n N_noxref_5_c_1492_n ) capacitor c=0.0557526f \
 //x=7.89 //y=4.09 //x2=7.15 //y2=3.705
cc_722 ( N_noxref_3_c_795_n N_noxref_5_c_1585_n ) capacitor c=0.00116878f \
 //x=7.805 //y=5.335 //x2=7.15 //y2=4.025
cc_723 ( N_noxref_3_c_727_n N_noxref_5_c_1585_n ) capacitor c=2.04829e-19 \
 //x=7.405 //y=1.305 //x2=7.15 //y2=4.025
cc_724 ( N_noxref_3_c_729_n N_noxref_5_c_1585_n ) capacitor c=8.43174e-19 \
 //x=7.49 //y=1.845 //x2=7.15 //y2=4.025
cc_725 ( N_noxref_3_c_731_n N_noxref_5_c_1585_n ) capacitor c=0.0176025f \
 //x=7.89 //y=4.09 //x2=7.15 //y2=4.025
cc_726 ( N_noxref_3_c_822_p N_noxref_5_c_1585_n ) capacitor c=7.66594e-19 \
 //x=7.11 //y=5.335 //x2=7.15 //y2=4.025
cc_727 ( N_noxref_3_c_746_n N_noxref_5_c_1585_n ) capacitor c=0.00522697f \
 //x=7.725 //y=4.25 //x2=7.15 //y2=4.025
cc_728 ( N_noxref_3_c_795_n N_noxref_5_c_1497_n ) capacitor c=0.00228791f \
 //x=7.805 //y=5.335 //x2=7.15 //y2=4.75
cc_729 ( N_noxref_3_c_731_n N_noxref_5_c_1497_n ) capacitor c=0.00283381f \
 //x=7.89 //y=4.09 //x2=7.15 //y2=4.75
cc_730 ( N_noxref_3_c_737_n N_noxref_5_c_1497_n ) capacitor c=0.0147947f \
 //x=7.89 //y=4.41 //x2=7.15 //y2=4.75
cc_731 ( N_noxref_3_c_738_n N_noxref_5_c_1497_n ) capacitor c=0.0275491f \
 //x=7.89 //y=5.25 //x2=7.15 //y2=4.75
cc_732 ( N_noxref_3_c_822_p N_noxref_5_c_1497_n ) capacitor c=0.0221235f \
 //x=7.11 //y=5.335 //x2=7.15 //y2=4.75
cc_733 ( N_noxref_3_c_829_p N_noxref_5_c_1497_n ) capacitor c=6.4807e-19 \
 //x=7.885 //y=4.25 //x2=7.15 //y2=4.75
cc_734 ( N_noxref_3_c_746_n N_noxref_5_c_1497_n ) capacitor c=0.0210332f \
 //x=7.725 //y=4.25 //x2=7.15 //y2=4.75
cc_735 ( N_noxref_3_c_751_n N_noxref_5_c_1497_n ) capacitor c=0.00328982f \
 //x=8.045 //y=4.25 //x2=7.15 //y2=4.75
cc_736 ( N_noxref_3_c_832_p N_noxref_5_c_1497_n ) capacitor c=0.00217653f \
 //x=7.11 //y=5.56 //x2=7.15 //y2=4.75
cc_737 ( N_noxref_3_c_755_n N_noxref_5_c_1513_n ) capacitor c=0.00531452f \
 //x=17.72 //y=4.265 //x2=11.96 //y2=4.025
cc_738 ( N_noxref_3_c_755_n N_noxref_5_c_1501_n ) capacitor c=0.0214777f \
 //x=17.72 //y=4.265 //x2=11.96 //y2=4.75
cc_739 ( N_noxref_3_c_800_p N_noxref_5_c_1524_n ) capacitor c=0.0196034f \
 //x=17.88 //y=4.105 //x2=16.03 //y2=3.705
cc_740 ( N_noxref_3_c_836_p N_noxref_5_c_1524_n ) capacitor c=0.00344372f \
 //x=17.88 //y=2.26 //x2=16.03 //y2=3.705
cc_741 ( N_noxref_3_c_800_p N_noxref_5_c_1604_n ) capacitor c=0.00238733f \
 //x=17.88 //y=4.105 //x2=16.03 //y2=4.025
cc_742 ( N_noxref_3_c_755_n N_noxref_5_c_1604_n ) capacitor c=0.00689641f \
 //x=17.72 //y=4.265 //x2=16.03 //y2=4.025
cc_743 ( N_noxref_3_c_800_p N_noxref_5_c_1527_n ) capacitor c=0.00129137f \
 //x=17.88 //y=4.105 //x2=16.03 //y2=5.295
cc_744 ( N_noxref_3_c_802_p N_noxref_5_c_1527_n ) capacitor c=0.00249513f \
 //x=17.88 //y=4.425 //x2=16.03 //y2=5.295
cc_745 ( N_noxref_3_c_803_p N_noxref_5_c_1527_n ) capacitor c=0.00440493f \
 //x=17.88 //y=4.88 //x2=16.03 //y2=5.295
cc_746 ( N_noxref_3_c_801_p N_noxref_5_c_1527_n ) capacitor c=0.0027491f \
 //x=17.882 //y=4.74 //x2=16.03 //y2=5.295
cc_747 ( N_noxref_3_c_809_p N_noxref_5_c_1527_n ) capacitor c=0.0015808f \
 //x=17.88 //y=4.265 //x2=16.03 //y2=5.295
cc_748 ( N_noxref_3_c_755_n N_noxref_5_c_1527_n ) capacitor c=0.0225411f \
 //x=17.72 //y=4.265 //x2=16.03 //y2=5.295
cc_749 ( N_noxref_3_c_731_n N_noxref_5_c_1612_n ) capacitor c=9.19401e-19 \
 //x=7.89 //y=4.09 //x2=7.15 //y2=3.88
cc_750 ( N_noxref_3_c_731_n N_noxref_5_c_1502_n ) capacitor c=2.73038e-19 \
 //x=7.89 //y=4.09 //x2=7.5 //y2=3.88
cc_751 ( N_noxref_3_c_746_n N_noxref_5_c_1502_n ) capacitor c=0.0338167f \
 //x=7.725 //y=4.25 //x2=7.5 //y2=3.88
cc_752 ( N_noxref_3_c_731_n N_noxref_5_c_1615_n ) capacitor c=0.0237432f \
 //x=7.89 //y=4.09 //x2=8.1 //y2=3.865
cc_753 ( N_noxref_3_c_737_n N_noxref_5_c_1615_n ) capacitor c=0.00912961f \
 //x=7.89 //y=4.41 //x2=8.1 //y2=3.865
cc_754 ( N_noxref_3_c_751_n N_noxref_5_c_1615_n ) capacitor c=0.0358834f \
 //x=8.045 //y=4.25 //x2=8.1 //y2=3.865
cc_755 ( N_noxref_3_c_755_n N_noxref_5_c_1615_n ) capacitor c=0.0109116f \
 //x=17.72 //y=4.265 //x2=8.1 //y2=3.865
cc_756 ( N_noxref_3_c_731_n N_noxref_5_c_1503_n ) capacitor c=4.72093e-19 \
 //x=7.89 //y=4.09 //x2=12.12 //y2=3.88
cc_757 ( N_noxref_3_c_755_n N_noxref_5_c_1503_n ) capacitor c=0.349297f \
 //x=17.72 //y=4.265 //x2=12.12 //y2=3.88
cc_758 ( N_noxref_3_c_731_n N_noxref_5_c_1621_n ) capacitor c=0.00317812f \
 //x=7.89 //y=4.09 //x2=7.315 //y2=3.865
cc_759 ( N_noxref_3_c_746_n N_noxref_5_c_1621_n ) capacitor c=0.0358686f \
 //x=7.725 //y=4.25 //x2=7.315 //y2=3.865
cc_760 ( N_noxref_3_c_755_n N_noxref_5_c_1540_n ) capacitor c=0.321887f \
 //x=17.72 //y=4.265 //x2=15.865 //y2=3.865
cc_761 ( N_noxref_3_c_800_p N_noxref_5_c_1624_n ) capacitor c=0.00159442f \
 //x=17.88 //y=4.105 //x2=16.185 //y2=3.865
cc_762 ( N_noxref_3_c_755_n N_noxref_5_c_1624_n ) capacitor c=0.0358686f \
 //x=17.72 //y=4.265 //x2=16.185 //y2=3.865
cc_763 ( N_noxref_3_c_800_p N_noxref_5_c_1626_n ) capacitor c=0.0253182f \
 //x=17.88 //y=4.105 //x2=23.27 //y2=3.885
cc_764 ( N_noxref_3_c_802_p N_noxref_5_c_1626_n ) capacitor c=0.00766477f \
 //x=17.88 //y=4.425 //x2=23.27 //y2=3.885
cc_765 ( N_noxref_3_c_809_p N_noxref_5_c_1626_n ) capacitor c=0.0358686f \
 //x=17.88 //y=4.265 //x2=23.27 //y2=3.885
cc_766 ( N_noxref_3_c_755_n N_noxref_5_c_1626_n ) capacitor c=0.135934f \
 //x=17.72 //y=4.265 //x2=23.27 //y2=3.885
cc_767 ( N_noxref_3_c_731_n N_noxref_5_c_1630_n ) capacitor c=0.00163444f \
 //x=7.89 //y=4.09 //x2=7.15 //y2=2.26
cc_768 ( N_noxref_3_c_795_n N_noxref_5_c_1631_n ) capacitor c=0.00130631f \
 //x=7.805 //y=5.335 //x2=7.15 //y2=4.88
cc_769 ( N_noxref_3_c_738_n N_noxref_5_c_1631_n ) capacitor c=0.0013045f \
 //x=7.89 //y=5.25 //x2=7.15 //y2=4.88
cc_770 ( N_noxref_3_c_822_p N_noxref_5_c_1631_n ) capacitor c=0.00346456f \
 //x=7.11 //y=5.335 //x2=7.15 //y2=4.88
cc_771 ( N_noxref_3_c_832_p N_noxref_5_c_1631_n ) capacitor c=0.00624059f \
 //x=7.11 //y=5.56 //x2=7.15 //y2=4.88
cc_772 ( N_noxref_3_c_868_p N_noxref_5_M60_noxref_g ) capacitor c=0.00955829f \
 //x=6.995 //y=5.335 //x2=6.89 //y2=6.2
cc_773 ( N_noxref_3_c_794_n N_noxref_5_M60_noxref_g ) capacitor c=0.00226521f \
 //x=7.11 //y=5.56 //x2=6.89 //y2=6.2
cc_774 ( N_noxref_3_c_832_p N_noxref_5_M60_noxref_g ) capacitor c=0.0178885f \
 //x=7.11 //y=5.56 //x2=6.89 //y2=6.2
cc_775 ( N_noxref_3_c_794_n N_noxref_5_M61_noxref_g ) capacitor c=0.00381703f \
 //x=7.11 //y=5.56 //x2=7.33 //y2=6.2
cc_776 ( N_noxref_3_c_795_n N_noxref_5_M61_noxref_g ) capacitor c=0.0109667f \
 //x=7.805 //y=5.335 //x2=7.33 //y2=6.2
cc_777 ( N_noxref_3_c_832_p N_noxref_5_M61_noxref_g ) capacitor c=0.0188608f \
 //x=7.11 //y=5.56 //x2=7.33 //y2=6.2
cc_778 ( N_noxref_3_c_727_n N_noxref_5_c_1641_n ) capacitor c=4.64015e-19 \
 //x=7.405 //y=1.305 //x2=7.14 //y2=1.095
cc_779 ( N_noxref_3_M4_noxref_d N_noxref_5_c_1641_n ) capacitor c=0.00137165f \
 //x=7.215 //y=1.095 //x2=7.14 //y2=1.095
cc_780 ( N_noxref_3_c_727_n N_noxref_5_c_1643_n ) capacitor c=0.0026012f \
 //x=7.405 //y=1.305 //x2=7.14 //y2=1.44
cc_781 ( N_noxref_3_c_728_n N_noxref_5_c_1643_n ) capacitor c=0.00127432f \
 //x=7.405 //y=1.76 //x2=7.14 //y2=1.44
cc_782 ( N_noxref_3_M4_noxref_d N_noxref_5_c_1643_n ) capacitor c=0.00237422f \
 //x=7.215 //y=1.095 //x2=7.14 //y2=1.44
cc_783 ( N_noxref_3_c_728_n N_noxref_5_c_1646_n ) capacitor c=0.00429966f \
 //x=7.405 //y=1.76 //x2=7.14 //y2=1.75
cc_784 ( N_noxref_3_c_727_n N_noxref_5_c_1647_n ) capacitor c=5.29969e-19 \
 //x=7.405 //y=1.305 //x2=7.515 //y2=0.94
cc_785 ( N_noxref_3_M4_noxref_d N_noxref_5_c_1647_n ) capacitor c=0.0020782f \
 //x=7.215 //y=1.095 //x2=7.515 //y2=0.94
cc_786 ( N_noxref_3_c_727_n N_noxref_5_c_1649_n ) capacitor c=5.16926e-19 \
 //x=7.405 //y=1.305 //x2=7.515 //y2=1.595
cc_787 ( N_noxref_3_c_728_n N_noxref_5_c_1649_n ) capacitor c=0.00942306f \
 //x=7.405 //y=1.76 //x2=7.515 //y2=1.595
cc_788 ( N_noxref_3_c_796_n N_noxref_5_c_1649_n ) capacitor c=0.00194716f \
 //x=7.805 //y=1.845 //x2=7.515 //y2=1.595
cc_789 ( N_noxref_3_M4_noxref_d N_noxref_5_c_1649_n ) capacitor c=0.00356097f \
 //x=7.215 //y=1.095 //x2=7.515 //y2=1.595
cc_790 ( N_noxref_3_c_727_n N_noxref_5_c_1653_n ) capacitor c=5.24634e-19 \
 //x=7.405 //y=1.305 //x2=7.67 //y2=1.095
cc_791 ( N_noxref_3_M4_noxref_d N_noxref_5_c_1653_n ) capacitor c=0.00139206f \
 //x=7.215 //y=1.095 //x2=7.67 //y2=1.095
cc_792 ( N_noxref_3_c_727_n N_noxref_5_c_1655_n ) capacitor c=0.00307978f \
 //x=7.405 //y=1.305 //x2=7.67 //y2=1.44
cc_793 ( N_noxref_3_c_728_n N_noxref_5_c_1655_n ) capacitor c=0.00363411f \
 //x=7.405 //y=1.76 //x2=7.67 //y2=1.44
cc_794 ( N_noxref_3_c_796_n N_noxref_5_c_1655_n ) capacitor c=0.00323576f \
 //x=7.805 //y=1.845 //x2=7.67 //y2=1.44
cc_795 ( N_noxref_3_M4_noxref_d N_noxref_5_c_1655_n ) capacitor c=0.00237422f \
 //x=7.215 //y=1.095 //x2=7.67 //y2=1.44
cc_796 ( N_noxref_3_c_731_n N_noxref_5_c_1659_n ) capacitor c=0.0025845f \
 //x=7.89 //y=4.09 //x2=7.15 //y2=2.26
cc_797 ( N_noxref_3_c_728_n N_noxref_5_c_1660_n ) capacitor c=0.00362297f \
 //x=7.405 //y=1.76 //x2=7.15 //y2=2.095
cc_798 ( N_noxref_3_c_731_n N_noxref_5_c_1660_n ) capacitor c=0.00282067f \
 //x=7.89 //y=4.09 //x2=7.15 //y2=2.095
cc_799 ( N_noxref_3_c_738_n N_noxref_5_c_1662_n ) capacitor c=0.00739287f \
 //x=7.89 //y=5.25 //x2=7.15 //y2=4.88
cc_800 ( N_noxref_3_c_822_p N_noxref_5_c_1662_n ) capacitor c=0.00203307f \
 //x=7.11 //y=5.335 //x2=7.15 //y2=4.88
cc_801 ( N_noxref_3_c_832_p N_noxref_5_c_1662_n ) capacitor c=0.00375636f \
 //x=7.11 //y=5.56 //x2=7.15 //y2=4.88
cc_802 ( N_noxref_3_c_711_n D ) capacitor c=0.0260257f //x=2.34 //y=4.085 \
 //x2=1.6 //y2=2.77
cc_803 ( N_noxref_3_c_756_n D ) capacitor c=3.49899e-19 //x=2.34 //y=2.26 \
 //x2=1.6 //y2=2.77
cc_804 ( N_noxref_3_c_711_n D ) capacitor c=0.0378324f //x=2.34 //y=4.085 \
 //x2=1.6 //y2=3.51
cc_805 ( N_noxref_3_c_718_n D ) capacitor c=0.0149195f //x=2.34 //y=4.405 \
 //x2=1.6 //y2=3.51
cc_806 ( N_noxref_3_c_723_n D ) capacitor c=0.0146931f //x=2.34 //y=4.735 \
 //x2=1.6 //y2=3.51
cc_807 ( N_noxref_3_c_740_n D ) capacitor c=0.00465739f //x=2.34 //y=4.25 \
 //x2=1.6 //y2=3.51
cc_808 ( N_noxref_3_c_752_n D ) capacitor c=0.00686827f //x=2.5 //y=4.245 \
 //x2=1.6 //y2=3.51
cc_809 ( N_noxref_3_c_757_n D ) capacitor c=2.1563e-19 //x=2.37 //y=4.88 \
 //x2=1.6 //y2=3.51
cc_810 ( N_noxref_3_c_711_n D ) capacitor c=6.89957e-19 //x=2.34 //y=4.085 \
 //x2=1.6 //y2=3.14
cc_811 ( N_noxref_3_c_711_n N_D_c_4936_n ) capacitor c=0.0177569f //x=2.34 \
 //y=4.085 //x2=1.6 //y2=3.305
cc_812 ( N_noxref_3_c_739_n N_D_c_4997_n ) capacitor c=0.0205342f //x=2.34 \
 //y=2.26 //x2=1.6 //y2=2.26
cc_813 ( N_noxref_3_c_756_n N_D_c_4997_n ) capacitor c=0.00370824f //x=2.34 \
 //y=2.26 //x2=1.6 //y2=2.26
cc_814 ( N_noxref_3_c_789_n N_D_c_4997_n ) capacitor c=0.00167305f //x=2.34 \
 //y=2.26 //x2=1.6 //y2=2.26
cc_815 ( N_noxref_3_c_723_n N_D_c_4937_n ) capacitor c=0.0172863f //x=2.34 \
 //y=4.735 //x2=1.6 //y2=4.88
cc_816 ( N_noxref_3_c_757_n N_D_c_4937_n ) capacitor c=0.00389736f //x=2.37 \
 //y=4.88 //x2=1.6 //y2=4.88
cc_817 ( N_noxref_3_c_792_n N_D_c_4937_n ) capacitor c=0.00158715f //x=2.37 \
 //y=4.88 //x2=1.6 //y2=4.88
cc_818 ( N_noxref_3_c_711_n N_D_c_4939_n ) capacitor c=0.02799f //x=2.34 \
 //y=4.085 //x2=2.695 //y2=3.14
cc_819 ( N_noxref_3_c_718_n N_D_c_4939_n ) capacitor c=0.00270078f //x=2.34 \
 //y=4.405 //x2=2.695 //y2=3.14
cc_820 ( N_noxref_3_c_739_n N_D_c_4939_n ) capacitor c=0.00275162f //x=2.34 \
 //y=2.26 //x2=2.695 //y2=3.14
cc_821 ( N_noxref_3_c_746_n N_D_c_4939_n ) capacitor c=0.0268304f //x=7.725 \
 //y=4.25 //x2=2.695 //y2=3.14
cc_822 ( N_noxref_3_c_752_n N_D_c_4939_n ) capacitor c=0.00844561f //x=2.5 \
 //y=4.245 //x2=2.695 //y2=3.14
cc_823 ( N_noxref_3_c_746_n N_D_c_4947_n ) capacitor c=0.0411221f //x=7.725 \
 //y=4.25 //x2=3.295 //y2=3.155
cc_824 ( N_noxref_3_c_746_n N_D_c_4950_n ) capacitor c=0.0186883f //x=7.725 \
 //y=4.25 //x2=4.545 //y2=3.14
cc_825 ( N_noxref_3_c_746_n N_D_c_4954_n ) capacitor c=0.0554236f //x=7.725 \
 //y=4.25 //x2=5.145 //y2=3.155
cc_826 ( N_noxref_3_c_731_n N_D_c_4957_n ) capacitor c=0.0262104f //x=7.89 \
 //y=4.09 //x2=9.355 //y2=3.14
cc_827 ( N_noxref_3_c_755_n N_D_c_4957_n ) capacitor c=0.00971687f //x=17.72 \
 //y=4.265 //x2=9.355 //y2=3.14
cc_828 ( N_noxref_3_c_755_n N_D_c_4961_n ) capacitor c=0.0145048f //x=17.72 \
 //y=4.265 //x2=9.955 //y2=3.16
cc_829 ( N_noxref_3_c_755_n N_D_c_4973_n ) capacitor c=0.0028996f //x=17.72 \
 //y=4.265 //x2=12.315 //y2=3.14
cc_830 ( N_noxref_3_c_755_n N_D_c_4976_n ) capacitor c=0.00642687f //x=17.72 \
 //y=4.265 //x2=12.915 //y2=3.17
cc_831 ( N_noxref_3_c_755_n N_D_c_4980_n ) capacitor c=0.00320973f //x=17.72 \
 //y=4.265 //x2=14.16 //y2=3.14
cc_832 ( N_noxref_3_c_755_n N_D_c_4985_n ) capacitor c=0.0149203f //x=17.72 \
 //y=4.265 //x2=14.76 //y2=3.17
cc_833 ( N_noxref_3_c_800_p N_D_c_5018_n ) capacitor c=0.0295735f //x=17.88 \
 //y=4.105 //x2=18.235 //y2=3.14
cc_834 ( N_noxref_3_c_711_n N_D_c_4963_n ) capacitor c=0.00312973f //x=2.34 \
 //y=4.085 //x2=1.765 //y2=3.145
cc_835 ( N_noxref_3_c_711_n N_D_c_5020_n ) capacitor c=3.49899e-19 //x=2.34 \
 //y=4.085 //x2=1.6 //y2=2.26
cc_836 ( N_noxref_3_c_739_n N_D_c_5020_n ) capacitor c=5.16867e-19 //x=2.34 \
 //y=2.26 //x2=1.6 //y2=2.26
cc_837 ( N_noxref_3_c_756_n N_D_c_5020_n ) capacitor c=0.00445529f //x=2.34 \
 //y=2.26 //x2=1.6 //y2=2.26
cc_838 ( N_noxref_3_c_789_n N_D_c_5020_n ) capacitor c=0.00266443f //x=2.34 \
 //y=2.26 //x2=1.6 //y2=2.26
cc_839 ( N_noxref_3_c_723_n N_D_c_4964_n ) capacitor c=7.76143e-19 //x=2.34 \
 //y=4.735 //x2=1.6 //y2=4.88
cc_840 ( N_noxref_3_c_757_n N_D_c_4964_n ) capacitor c=0.00397338f //x=2.37 \
 //y=4.88 //x2=1.6 //y2=4.88
cc_841 ( N_noxref_3_c_792_n N_D_c_4964_n ) capacitor c=0.00237977f //x=2.37 \
 //y=4.88 //x2=1.6 //y2=4.88
cc_842 ( N_noxref_3_M54_noxref_g N_D_M52_noxref_g ) capacitor c=0.0104892f \
 //x=2.38 //y=6.2 //x2=1.5 //y2=6.2
cc_843 ( N_noxref_3_M54_noxref_g N_D_M53_noxref_g ) capacitor c=0.107636f \
 //x=2.38 //y=6.2 //x2=1.94 //y2=6.2
cc_844 ( N_noxref_3_M55_noxref_g N_D_M53_noxref_g ) capacitor c=0.0100341f \
 //x=2.82 //y=6.2 //x2=1.94 //y2=6.2
cc_845 ( N_noxref_3_c_768_n N_D_c_5030_n ) capacitor c=4.86545e-19 //x=2.375 \
 //y=1.085 //x2=1.405 //y2=1.045
cc_846 ( N_noxref_3_c_768_n N_D_c_5031_n ) capacitor c=0.00152405f //x=2.375 \
 //y=1.085 //x2=1.405 //y2=1.39
cc_847 ( N_noxref_3_c_770_n N_D_c_5032_n ) capacitor c=0.00109982f //x=2.375 \
 //y=1.43 //x2=1.405 //y2=1.7
cc_848 ( N_noxref_3_c_773_n N_D_c_5032_n ) capacitor c=9.58243e-19 //x=2.375 \
 //y=1.74 //x2=1.405 //y2=1.7
cc_849 ( N_noxref_3_c_739_n N_D_c_5034_n ) capacitor c=0.00167888f //x=2.34 \
 //y=2.26 //x2=1.405 //y2=2.095
cc_850 ( N_noxref_3_c_756_n N_D_c_5034_n ) capacitor c=0.00267961f //x=2.34 \
 //y=2.26 //x2=1.405 //y2=2.095
cc_851 ( N_noxref_3_c_773_n N_D_c_5034_n ) capacitor c=0.00662747f //x=2.375 \
 //y=1.74 //x2=1.405 //y2=2.095
cc_852 ( N_noxref_3_c_789_n N_D_c_5034_n ) capacitor c=0.0181449f //x=2.34 \
 //y=2.26 //x2=1.405 //y2=2.095
cc_853 ( N_noxref_3_c_768_n N_D_c_5038_n ) capacitor c=0.0151475f //x=2.375 \
 //y=1.085 //x2=1.935 //y2=1.045
cc_854 ( N_noxref_3_c_783_n N_D_c_5038_n ) capacitor c=0.00127211f //x=2.905 \
 //y=1.085 //x2=1.935 //y2=1.045
cc_855 ( N_noxref_3_c_770_n N_D_c_5040_n ) capacitor c=0.0111064f //x=2.375 \
 //y=1.43 //x2=1.935 //y2=1.39
cc_856 ( N_noxref_3_c_773_n N_D_c_5040_n ) capacitor c=0.00862358f //x=2.375 \
 //y=1.74 //x2=1.935 //y2=1.39
cc_857 ( N_noxref_3_c_785_n N_D_c_5040_n ) capacitor c=0.00204774f //x=2.905 \
 //y=1.43 //x2=1.935 //y2=1.39
cc_858 ( N_noxref_3_c_723_n N_D_c_4971_n ) capacitor c=0.00201171f //x=2.34 \
 //y=4.735 //x2=1.6 //y2=4.88
cc_859 ( N_noxref_3_c_757_n N_D_c_4971_n ) capacitor c=0.00283894f //x=2.37 \
 //y=4.88 //x2=1.6 //y2=4.88
cc_860 ( N_noxref_3_c_792_n N_D_c_4971_n ) capacitor c=0.0297875f //x=2.37 \
 //y=4.88 //x2=1.6 //y2=4.88
cc_861 ( N_noxref_3_c_731_n CLK ) capacitor c=0.00299211f //x=7.89 //y=4.09 \
 //x2=6.04 //y2=2.4
cc_862 ( N_noxref_3_c_738_n CLK ) capacitor c=3.42225e-19 //x=7.89 //y=5.25 \
 //x2=6.04 //y2=2.4
cc_863 ( N_noxref_3_c_746_n CLK ) capacitor c=0.027785f //x=7.725 //y=4.25 \
 //x2=6.04 //y2=2.4
cc_864 ( N_noxref_3_c_800_p CLK ) capacitor c=0.00335133f //x=17.88 //y=4.105 \
 //x2=15.29 //y2=2.77
cc_865 ( N_noxref_3_c_801_p CLK ) capacitor c=4.0519e-19 //x=17.882 //y=4.74 \
 //x2=15.29 //y2=2.77
cc_866 ( N_noxref_3_c_755_n CLK ) capacitor c=0.020623f //x=17.72 //y=4.265 \
 //x2=15.29 //y2=2.77
cc_867 ( N_noxref_3_c_726_n N_CLK_c_6298_n ) capacitor c=0.0232953f //x=6.11 \
 //y=5.335 //x2=6.04 //y2=4.755
cc_868 ( N_noxref_3_c_964_p N_CLK_c_6298_n ) capacitor c=0.00519317f //x=6.23 \
 //y=5.335 //x2=6.04 //y2=4.755
cc_869 ( N_noxref_3_c_746_n N_CLK_c_6298_n ) capacitor c=0.00196208f //x=7.725 \
 //y=4.25 //x2=6.04 //y2=4.755
cc_870 ( N_noxref_3_c_966_p N_CLK_c_6298_n ) capacitor c=0.00185675f //x=6.23 \
 //y=5.56 //x2=6.04 //y2=4.755
cc_871 ( N_noxref_3_c_755_n N_CLK_c_6340_n ) capacitor c=6.97969e-19 //x=17.72 \
 //y=4.265 //x2=15.325 //y2=4.75
cc_872 ( N_noxref_3_c_795_n N_CLK_c_6387_n ) capacitor c=0.0194373f //x=7.805 \
 //y=5.335 //x2=7.5 //y2=4.62
cc_873 ( N_noxref_3_c_737_n N_CLK_c_6387_n ) capacitor c=0.00124799f //x=7.89 \
 //y=4.41 //x2=7.5 //y2=4.62
cc_874 ( N_noxref_3_c_738_n N_CLK_c_6387_n ) capacitor c=3.25767e-19 //x=7.89 \
 //y=5.25 //x2=7.5 //y2=4.62
cc_875 ( N_noxref_3_c_964_p N_CLK_c_6387_n ) capacitor c=0.0380295f //x=6.23 \
 //y=5.335 //x2=7.5 //y2=4.62
cc_876 ( N_noxref_3_c_746_n N_CLK_c_6387_n ) capacitor c=0.0124008f //x=7.725 \
 //y=4.25 //x2=7.5 //y2=4.62
cc_877 ( N_noxref_3_c_751_n N_CLK_c_6387_n ) capacitor c=0.0364871f //x=8.045 \
 //y=4.25 //x2=7.5 //y2=4.62
cc_878 ( N_noxref_3_c_737_n N_CLK_c_6393_n ) capacitor c=0.00726353f //x=7.89 \
 //y=4.41 //x2=8.1 //y2=4.635
cc_879 ( N_noxref_3_c_738_n N_CLK_c_6393_n ) capacitor c=0.02887f //x=7.89 \
 //y=5.25 //x2=8.1 //y2=4.635
cc_880 ( N_noxref_3_c_755_n N_CLK_c_6393_n ) capacitor c=0.0111206f //x=17.72 \
 //y=4.265 //x2=8.1 //y2=4.635
cc_881 ( N_noxref_3_c_802_p N_CLK_c_6396_n ) capacitor c=0.002329f //x=17.88 \
 //y=4.425 //x2=18.095 //y2=4.65
cc_882 ( N_noxref_3_c_803_p N_CLK_c_6396_n ) capacitor c=0.00362281f //x=17.88 \
 //y=4.88 //x2=18.095 //y2=4.65
cc_883 ( N_noxref_3_c_801_p N_CLK_c_6396_n ) capacitor c=0.0256408f //x=17.882 \
 //y=4.74 //x2=18.095 //y2=4.65
cc_884 ( N_noxref_3_c_807_p N_CLK_c_6396_n ) capacitor c=0.00111841f //x=17.88 \
 //y=4.88 //x2=18.095 //y2=4.65
cc_885 ( N_noxref_3_c_738_n N_CLK_c_6302_n ) capacitor c=4.72093e-19 //x=7.89 \
 //y=5.25 //x2=17.75 //y2=4.65
cc_886 ( N_noxref_3_c_802_p N_CLK_c_6302_n ) capacitor c=0.00418223f //x=17.88 \
 //y=4.425 //x2=17.75 //y2=4.65
cc_887 ( N_noxref_3_c_801_p N_CLK_c_6302_n ) capacitor c=9.36601e-19 \
 //x=17.882 //y=4.74 //x2=17.75 //y2=4.65
cc_888 ( N_noxref_3_c_809_p N_CLK_c_6302_n ) capacitor c=0.0364798f //x=17.88 \
 //y=4.265 //x2=17.75 //y2=4.65
cc_889 ( N_noxref_3_c_755_n N_CLK_c_6302_n ) capacitor c=0.8693f //x=17.72 \
 //y=4.265 //x2=17.75 //y2=4.65
cc_890 ( N_noxref_3_c_726_n N_CLK_c_6303_n ) capacitor c=0.00118283f //x=6.11 \
 //y=5.335 //x2=6.04 //y2=4.62
cc_891 ( N_noxref_3_c_964_p N_CLK_c_6303_n ) capacitor c=0.00118081f //x=6.23 \
 //y=5.335 //x2=6.04 //y2=4.62
cc_892 ( N_noxref_3_c_746_n N_CLK_c_6303_n ) capacitor c=0.155111f //x=7.725 \
 //y=4.25 //x2=6.04 //y2=4.62
cc_893 ( N_noxref_3_c_726_n N_CLK_c_6308_n ) capacitor c=0.00492634f //x=6.11 \
 //y=5.335 //x2=6.04 //y2=4.88
cc_894 ( N_noxref_3_c_964_p N_CLK_c_6308_n ) capacitor c=0.00132214f //x=6.23 \
 //y=5.335 //x2=6.04 //y2=4.88
cc_895 ( N_noxref_3_c_726_n N_CLK_M58_noxref_g ) capacitor c=0.00858236f \
 //x=6.11 //y=5.335 //x2=6.01 //y2=6.2
cc_896 ( N_noxref_3_c_964_p N_CLK_M58_noxref_g ) capacitor c=0.00229818f \
 //x=6.23 //y=5.335 //x2=6.01 //y2=6.2
cc_897 ( N_noxref_3_c_966_p N_CLK_M58_noxref_g ) capacitor c=0.0179041f \
 //x=6.23 //y=5.56 //x2=6.01 //y2=6.2
cc_898 ( N_noxref_3_c_868_p N_CLK_M59_noxref_g ) capacitor c=0.00955829f \
 //x=6.995 //y=5.335 //x2=6.45 //y2=6.2
cc_899 ( N_noxref_3_c_964_p N_CLK_M59_noxref_g ) capacitor c=0.00230699f \
 //x=6.23 //y=5.335 //x2=6.45 //y2=6.2
cc_900 ( N_noxref_3_c_966_p N_CLK_M59_noxref_g ) capacitor c=0.0179041f \
 //x=6.23 //y=5.56 //x2=6.45 //y2=6.2
cc_901 ( N_noxref_3_c_964_p N_CLK_c_6416_n ) capacitor c=0.00172334f //x=6.23 \
 //y=5.335 //x2=6.375 //y2=4.97
cc_902 ( N_noxref_3_c_966_p N_CLK_c_6416_n ) capacitor c=0.00294585f //x=6.23 \
 //y=5.56 //x2=6.375 //y2=4.97
cc_903 ( N_noxref_3_c_726_n N_CLK_c_6326_n ) capacitor c=3.67903e-19 //x=6.11 \
 //y=5.335 //x2=6.04 //y2=4.88
cc_904 ( N_noxref_3_c_731_n SN ) capacitor c=0.00137863f //x=7.89 //y=4.09 \
 //x2=10.85 //y2=2.77
cc_905 ( N_noxref_3_c_738_n SN ) capacitor c=3.83887e-19 //x=7.89 //y=5.25 \
 //x2=10.85 //y2=2.77
cc_906 ( N_noxref_3_c_755_n SN ) capacitor c=0.023508f //x=17.72 //y=4.265 \
 //x2=10.85 //y2=2.77
cc_907 ( N_noxref_3_c_800_p N_SN_c_8092_n ) capacitor c=0.0153133f //x=17.88 \
 //y=4.105 //x2=22.15 //y2=2.4
cc_908 ( N_noxref_3_c_836_p N_SN_c_8092_n ) capacitor c=0.0183918f //x=17.88 \
 //y=2.26 //x2=22.15 //y2=2.4
cc_909 ( N_noxref_3_c_1005_p N_SN_c_8092_n ) capacitor c=2.20453e-19 //x=17.88 \
 //y=2.26 //x2=22.15 //y2=2.4
cc_910 ( N_noxref_3_c_1006_p N_SN_c_8092_n ) capacitor c=3.61358e-19 \
 //x=17.685 //y=2.095 //x2=22.15 //y2=2.4
cc_911 ( N_noxref_3_c_800_p N_noxref_21_c_10403_n ) capacitor c=0.0376224f \
 //x=17.88 //y=4.105 //x2=18.62 //y2=3.335
cc_912 ( N_noxref_3_c_1005_p N_noxref_21_c_10403_n ) capacitor c=3.30333e-19 \
 //x=17.88 //y=2.26 //x2=18.62 //y2=3.335
cc_913 ( N_noxref_3_c_800_p N_noxref_21_c_10405_n ) capacitor c=0.0151188f \
 //x=17.88 //y=4.105 //x2=18.62 //y2=3.655
cc_914 ( N_noxref_3_c_800_p N_noxref_21_c_10406_n ) capacitor c=0.0177292f \
 //x=17.88 //y=4.105 //x2=18.62 //y2=4.735
cc_915 ( N_noxref_3_c_802_p N_noxref_21_c_10406_n ) capacitor c=0.0151156f \
 //x=17.88 //y=4.425 //x2=18.62 //y2=4.735
cc_916 ( N_noxref_3_c_808_p N_noxref_21_c_10406_n ) capacitor c=6.47554e-19 \
 //x=17.88 //y=4.25 //x2=18.62 //y2=4.735
cc_917 ( N_noxref_3_c_803_p N_noxref_21_c_10406_n ) capacitor c=0.0172939f \
 //x=17.88 //y=4.88 //x2=18.62 //y2=4.735
cc_918 ( N_noxref_3_c_801_p N_noxref_21_c_10406_n ) capacitor c=0.0108826f \
 //x=17.882 //y=4.74 //x2=18.62 //y2=4.735
cc_919 ( N_noxref_3_c_809_p N_noxref_21_c_10406_n ) capacitor c=0.00360246f \
 //x=17.88 //y=4.265 //x2=18.62 //y2=4.735
cc_920 ( N_noxref_3_c_804_p N_noxref_21_c_10406_n ) capacitor c=7.76099e-19 \
 //x=17.88 //y=4.88 //x2=18.62 //y2=4.735
cc_921 ( N_noxref_3_c_807_p N_noxref_21_c_10406_n ) capacitor c=0.00201171f \
 //x=17.88 //y=4.88 //x2=18.62 //y2=4.735
cc_922 ( N_noxref_3_c_836_p N_noxref_21_c_10414_n ) capacitor c=0.0179797f \
 //x=17.88 //y=2.26 //x2=18.62 //y2=2.26
cc_923 ( N_noxref_3_c_1005_p N_noxref_21_c_10414_n ) capacitor c=5.16867e-19 \
 //x=17.88 //y=2.26 //x2=18.62 //y2=2.26
cc_924 ( N_noxref_3_c_1006_p N_noxref_21_c_10414_n ) capacitor c=0.00161745f \
 //x=17.685 //y=2.095 //x2=18.62 //y2=2.26
cc_925 ( N_noxref_3_c_800_p N_noxref_21_c_10417_n ) capacitor c=9.19401e-19 \
 //x=17.88 //y=4.105 //x2=18.62 //y2=3.51
cc_926 ( N_noxref_3_c_800_p N_noxref_21_c_10418_n ) capacitor c=0.00696234f \
 //x=17.88 //y=4.105 //x2=18.78 //y2=3.495
cc_927 ( N_noxref_3_c_800_p N_noxref_21_c_10419_n ) capacitor c=3.30333e-19 \
 //x=17.88 //y=4.105 //x2=18.62 //y2=2.26
cc_928 ( N_noxref_3_c_836_p N_noxref_21_c_10419_n ) capacitor c=5.24723e-19 \
 //x=17.88 //y=2.26 //x2=18.62 //y2=2.26
cc_929 ( N_noxref_3_c_1005_p N_noxref_21_c_10419_n ) capacitor c=0.00485709f \
 //x=17.88 //y=2.26 //x2=18.62 //y2=2.26
cc_930 ( N_noxref_3_c_1006_p N_noxref_21_c_10419_n ) capacitor c=0.00267961f \
 //x=17.685 //y=2.095 //x2=18.62 //y2=2.26
cc_931 ( N_noxref_3_c_803_p N_noxref_21_c_10423_n ) capacitor c=4.80626e-19 \
 //x=17.88 //y=4.88 //x2=18.65 //y2=4.88
cc_932 ( N_noxref_3_c_804_p N_noxref_21_c_10423_n ) capacitor c=0.00397338f \
 //x=17.88 //y=4.88 //x2=18.65 //y2=4.88
cc_933 ( N_noxref_3_c_807_p N_noxref_21_c_10423_n ) capacitor c=0.00283894f \
 //x=17.88 //y=4.88 //x2=18.65 //y2=4.88
cc_934 ( N_noxref_3_M72_noxref_g N_noxref_21_M74_noxref_g ) capacitor \
 c=0.0104892f //x=17.78 //y=6.2 //x2=18.66 //y2=6.2
cc_935 ( N_noxref_3_M73_noxref_g N_noxref_21_M74_noxref_g ) capacitor \
 c=0.107636f //x=18.22 //y=6.2 //x2=18.66 //y2=6.2
cc_936 ( N_noxref_3_M73_noxref_g N_noxref_21_M75_noxref_g ) capacitor \
 c=0.0100341f //x=18.22 //y=6.2 //x2=19.1 //y2=6.2
cc_937 ( N_noxref_3_c_1033_p N_noxref_21_c_10429_n ) capacitor c=4.86545e-19 \
 //x=17.685 //y=1.045 //x2=18.655 //y2=1.085
cc_938 ( N_noxref_3_c_1034_p N_noxref_21_c_10429_n ) capacitor c=0.00152405f \
 //x=17.685 //y=1.39 //x2=18.655 //y2=1.085
cc_939 ( N_noxref_3_c_1035_p N_noxref_21_c_10429_n ) capacitor c=0.0151475f \
 //x=18.215 //y=1.045 //x2=18.655 //y2=1.085
cc_940 ( N_noxref_3_c_1036_p N_noxref_21_c_10432_n ) capacitor c=0.00109982f \
 //x=17.685 //y=1.7 //x2=18.655 //y2=1.43
cc_941 ( N_noxref_3_c_1037_p N_noxref_21_c_10432_n ) capacitor c=0.0111064f \
 //x=18.215 //y=1.39 //x2=18.655 //y2=1.43
cc_942 ( N_noxref_3_c_1036_p N_noxref_21_c_10434_n ) capacitor c=9.58243e-19 \
 //x=17.685 //y=1.7 //x2=18.655 //y2=1.74
cc_943 ( N_noxref_3_c_1006_p N_noxref_21_c_10434_n ) capacitor c=0.00662747f \
 //x=17.685 //y=2.095 //x2=18.655 //y2=1.74
cc_944 ( N_noxref_3_c_1037_p N_noxref_21_c_10434_n ) capacitor c=0.00862358f \
 //x=18.215 //y=1.39 //x2=18.655 //y2=1.74
cc_945 ( N_noxref_3_c_1035_p N_noxref_21_c_10437_n ) capacitor c=0.00127211f \
 //x=18.215 //y=1.045 //x2=19.185 //y2=1.085
cc_946 ( N_noxref_3_c_1037_p N_noxref_21_c_10438_n ) capacitor c=0.00204774f \
 //x=18.215 //y=1.39 //x2=19.185 //y2=1.43
cc_947 ( N_noxref_3_c_836_p N_noxref_21_c_10439_n ) capacitor c=0.00161167f \
 //x=17.88 //y=2.26 //x2=18.62 //y2=2.26
cc_948 ( N_noxref_3_c_1005_p N_noxref_21_c_10439_n ) capacitor c=0.0018937f \
 //x=17.88 //y=2.26 //x2=18.62 //y2=2.26
cc_949 ( N_noxref_3_c_1006_p N_noxref_21_c_10439_n ) capacitor c=0.0181449f \
 //x=17.685 //y=2.095 //x2=18.62 //y2=2.26
cc_950 ( N_noxref_3_c_803_p N_noxref_21_c_10442_n ) capacitor c=0.00158715f \
 //x=17.88 //y=4.88 //x2=18.65 //y2=4.88
cc_951 ( N_noxref_3_c_804_p N_noxref_21_c_10442_n ) capacitor c=0.00237977f \
 //x=17.88 //y=4.88 //x2=18.65 //y2=4.88
cc_952 ( N_noxref_3_c_807_p N_noxref_21_c_10442_n ) capacitor c=0.0297875f \
 //x=17.88 //y=4.88 //x2=18.65 //y2=4.88
cc_953 ( N_noxref_3_c_726_n N_VDD_c_11522_n ) capacitor c=0.00621353f //x=6.11 \
 //y=5.335 //x2=74.455 //y2=7.585
cc_954 ( N_noxref_3_c_868_p N_VDD_c_11522_n ) capacitor c=0.00627192f \
 //x=6.995 //y=5.335 //x2=74.455 //y2=7.585
cc_955 ( N_noxref_3_c_794_n N_VDD_c_11522_n ) capacitor c=0.00256019f //x=7.11 \
 //y=5.56 //x2=74.455 //y2=7.585
cc_956 ( N_noxref_3_c_795_n N_VDD_c_11522_n ) capacitor c=0.00829084f \
 //x=7.805 //y=5.335 //x2=74.455 //y2=7.585
cc_957 ( N_noxref_3_c_737_n N_VDD_c_11522_n ) capacitor c=4.85202e-19 //x=7.89 \
 //y=4.41 //x2=74.455 //y2=7.585
cc_958 ( N_noxref_3_c_802_p N_VDD_c_11522_n ) capacitor c=2.3602e-19 //x=17.88 \
 //y=4.425 //x2=74.455 //y2=7.585
cc_959 ( N_noxref_3_c_741_n N_VDD_c_11522_n ) capacitor c=0.00261804f \
 //x=5.352 //y=5.335 //x2=74.455 //y2=7.585
cc_960 ( N_noxref_3_c_964_p N_VDD_c_11522_n ) capacitor c=0.00270108f //x=6.23 \
 //y=5.335 //x2=74.455 //y2=7.585
cc_961 ( N_noxref_3_c_829_p N_VDD_c_11522_n ) capacitor c=3.82513e-19 \
 //x=7.885 //y=4.25 //x2=74.455 //y2=7.585
cc_962 ( N_noxref_3_c_803_p N_VDD_c_11522_n ) capacitor c=9.07241e-19 \
 //x=17.88 //y=4.88 //x2=74.455 //y2=7.585
cc_963 ( N_noxref_3_c_759_n N_VDD_c_11522_n ) capacitor c=0.0024232f //x=5.35 \
 //y=5.56 //x2=74.455 //y2=7.585
cc_964 ( N_noxref_3_c_966_p N_VDD_c_11522_n ) capacitor c=0.0024232f //x=6.23 \
 //y=5.56 //x2=74.455 //y2=7.585
cc_965 ( N_noxref_3_c_832_p N_VDD_c_11522_n ) capacitor c=0.0024232f //x=7.11 \
 //y=5.56 //x2=74.455 //y2=7.585
cc_966 ( N_noxref_3_c_804_p N_VDD_c_11522_n ) capacitor c=6.22888e-19 \
 //x=17.88 //y=4.88 //x2=74.455 //y2=7.585
cc_967 ( N_noxref_3_M54_noxref_g N_VDD_c_11532_n ) capacitor c=0.00697352f \
 //x=2.38 //y=6.2 //x2=2.955 //y2=7.585
cc_968 ( N_noxref_3_M55_noxref_g N_VDD_c_11532_n ) capacitor c=0.00755544f \
 //x=2.82 //y=6.2 //x2=2.955 //y2=7.585
cc_969 ( N_noxref_3_c_726_n N_VDD_c_11537_n ) capacitor c=0.00202922f //x=6.11 \
 //y=5.335 //x2=5.705 //y2=7.585
cc_970 ( N_noxref_3_c_741_n N_VDD_c_11537_n ) capacitor c=9.3757e-19 //x=5.352 \
 //y=5.335 //x2=5.705 //y2=7.585
cc_971 ( N_noxref_3_c_759_n N_VDD_c_11537_n ) capacitor c=0.0138074f //x=5.35 \
 //y=5.56 //x2=5.705 //y2=7.585
cc_972 ( N_noxref_3_c_726_n N_VDD_c_11651_n ) capacitor c=0.0017708f //x=6.11 \
 //y=5.335 //x2=6.585 //y2=7.585
cc_973 ( N_noxref_3_c_868_p N_VDD_c_11651_n ) capacitor c=0.00202922f \
 //x=6.995 //y=5.335 //x2=6.585 //y2=7.585
cc_974 ( N_noxref_3_c_964_p N_VDD_c_11651_n ) capacitor c=9.4822e-19 //x=6.23 \
 //y=5.335 //x2=6.585 //y2=7.585
cc_975 ( N_noxref_3_c_966_p N_VDD_c_11651_n ) capacitor c=0.0138074f //x=6.23 \
 //y=5.56 //x2=6.585 //y2=7.585
cc_976 ( N_noxref_3_c_868_p N_VDD_c_11655_n ) capacitor c=0.00205906f \
 //x=6.995 //y=5.335 //x2=7.465 //y2=7.585
cc_977 ( N_noxref_3_c_794_n N_VDD_c_11655_n ) capacitor c=8.49654e-19 //x=7.11 \
 //y=5.56 //x2=7.465 //y2=7.585
cc_978 ( N_noxref_3_c_795_n N_VDD_c_11655_n ) capacitor c=0.00204238f \
 //x=7.805 //y=5.335 //x2=7.465 //y2=7.585
cc_979 ( N_noxref_3_c_832_p N_VDD_c_11655_n ) capacitor c=0.0135103f //x=7.11 \
 //y=5.56 //x2=7.465 //y2=7.585
cc_980 ( N_noxref_3_c_795_n N_VDD_c_11659_n ) capacitor c=0.00157114f \
 //x=7.805 //y=5.335 //x2=8.46 //y2=7.585
cc_981 ( N_noxref_3_c_737_n N_VDD_c_11659_n ) capacitor c=3.91238e-19 //x=7.89 \
 //y=4.41 //x2=8.46 //y2=7.585
cc_982 ( N_noxref_3_c_803_p N_VDD_c_11661_n ) capacitor c=6.28113e-19 \
 //x=17.88 //y=4.88 //x2=18.355 //y2=7.585
cc_983 ( N_noxref_3_M72_noxref_g N_VDD_c_11661_n ) capacitor c=0.00732618f \
 //x=17.78 //y=6.2 //x2=18.355 //y2=7.585
cc_984 ( N_noxref_3_M73_noxref_g N_VDD_c_11661_n ) capacitor c=0.00755544f \
 //x=18.22 //y=6.2 //x2=18.355 //y2=7.585
cc_985 ( N_noxref_3_c_740_n N_VDD_c_11541_n ) capacitor c=9.76453e-19 //x=2.34 \
 //y=4.25 //x2=1.23 //y2=7.58
cc_986 ( N_noxref_3_c_740_n N_VDD_c_11544_n ) capacitor c=0.00133334f //x=2.34 \
 //y=4.25 //x2=3.82 //y2=7.585
cc_987 ( N_noxref_3_c_741_n N_VDD_c_11544_n ) capacitor c=0.0022955f //x=5.352 \
 //y=5.335 //x2=3.82 //y2=7.585
cc_988 ( N_noxref_3_c_746_n N_VDD_c_11544_n ) capacitor c=0.0195425f //x=7.725 \
 //y=4.25 //x2=3.82 //y2=7.585
cc_989 ( N_noxref_3_c_757_n N_VDD_c_11544_n ) capacitor c=0.00226427f //x=2.37 \
 //y=4.88 //x2=3.82 //y2=7.585
cc_990 ( N_noxref_3_c_759_n N_VDD_c_11544_n ) capacitor c=0.00508013f //x=5.35 \
 //y=5.56 //x2=3.82 //y2=7.585
cc_991 ( N_noxref_3_c_774_n N_VDD_c_11544_n ) capacitor c=0.0129149f //x=2.745 \
 //y=4.97 //x2=3.82 //y2=7.585
cc_992 ( N_noxref_3_c_792_n N_VDD_c_11544_n ) capacitor c=2.73429e-19 //x=2.37 \
 //y=4.88 //x2=3.82 //y2=7.585
cc_993 ( N_noxref_3_c_794_n N_VDD_c_11551_n ) capacitor c=0.00282782f //x=7.11 \
 //y=5.56 //x2=8.63 //y2=7.585
cc_994 ( N_noxref_3_c_737_n N_VDD_c_11551_n ) capacitor c=0.00177813f //x=7.89 \
 //y=4.41 //x2=8.63 //y2=7.585
cc_995 ( N_noxref_3_c_738_n N_VDD_c_11551_n ) capacitor c=0.0293445f //x=7.89 \
 //y=5.25 //x2=8.63 //y2=7.585
cc_996 ( N_noxref_3_c_829_p N_VDD_c_11551_n ) capacitor c=0.00499873f \
 //x=7.885 //y=4.25 //x2=8.63 //y2=7.585
cc_997 ( N_noxref_3_c_755_n N_VDD_c_11551_n ) capacitor c=0.00826669f \
 //x=17.72 //y=4.265 //x2=8.63 //y2=7.585
cc_998 ( N_noxref_3_c_832_p N_VDD_c_11551_n ) capacitor c=0.00777981f //x=7.11 \
 //y=5.56 //x2=8.63 //y2=7.585
cc_999 ( N_noxref_3_c_755_n N_VDD_c_11609_n ) capacitor c=0.00885867f \
 //x=17.72 //y=4.265 //x2=13.44 //y2=7.585
cc_1000 ( N_noxref_3_c_802_p N_VDD_c_11679_n ) capacitor c=0.00144835f \
 //x=17.88 //y=4.425 //x2=16.77 //y2=7.585
cc_1001 ( N_noxref_3_c_808_p N_VDD_c_11679_n ) capacitor c=0.00247508f \
 //x=17.88 //y=4.25 //x2=16.77 //y2=7.585
cc_1002 ( N_noxref_3_c_803_p N_VDD_c_11679_n ) capacitor c=0.00483853f \
 //x=17.88 //y=4.88 //x2=16.77 //y2=7.585
cc_1003 ( N_noxref_3_c_801_p N_VDD_c_11679_n ) capacitor c=0.00401745f \
 //x=17.882 //y=4.74 //x2=16.77 //y2=7.585
cc_1004 ( N_noxref_3_c_755_n N_VDD_c_11679_n ) capacitor c=0.00852871f \
 //x=17.72 //y=4.265 //x2=16.77 //y2=7.585
cc_1005 ( N_noxref_3_c_804_p N_VDD_c_11679_n ) capacitor c=0.00370494f \
 //x=17.88 //y=4.88 //x2=16.77 //y2=7.585
cc_1006 ( N_noxref_3_c_807_p N_VDD_c_11679_n ) capacitor c=0.0129564f \
 //x=17.88 //y=4.88 //x2=16.77 //y2=7.585
cc_1007 ( N_noxref_3_c_741_n N_VDD_M52_noxref_s ) capacitor c=4.22189e-19 \
 //x=5.352 //y=5.335 //x2=1.145 //y2=5.2
cc_1008 ( N_noxref_3_M54_noxref_g N_VDD_M53_noxref_d ) capacitor c=0.015318f \
 //x=2.38 //y=6.2 //x2=2.015 //y2=5.2
cc_1009 ( N_noxref_3_c_792_n N_VDD_M53_noxref_d ) capacitor c=3.50465e-19 \
 //x=2.37 //y=4.88 //x2=2.015 //y2=5.2
cc_1010 ( N_noxref_3_M55_noxref_g N_VDD_M55_noxref_d ) capacitor c=0.0430452f \
 //x=2.82 //y=6.2 //x2=2.895 //y2=5.2
cc_1011 ( N_noxref_3_c_741_n N_VDD_M56_noxref_s ) capacitor c=0.0442713f \
 //x=5.352 //y=5.335 //x2=4.775 //y2=5.2
cc_1012 ( N_noxref_3_c_964_p N_VDD_M56_noxref_s ) capacitor c=7.80122e-19 \
 //x=6.23 //y=5.335 //x2=4.775 //y2=5.2
cc_1013 ( N_noxref_3_c_746_n N_VDD_M56_noxref_s ) capacitor c=6.11819e-19 \
 //x=7.725 //y=4.25 //x2=4.775 //y2=5.2
cc_1014 ( N_noxref_3_c_759_n N_VDD_M56_noxref_s ) capacitor c=0.0908457f \
 //x=5.35 //y=5.56 //x2=4.775 //y2=5.2
cc_1015 ( N_noxref_3_c_726_n N_VDD_M57_noxref_d ) capacitor c=0.00700141f \
 //x=6.11 //y=5.335 //x2=5.645 //y2=5.2
cc_1016 ( N_noxref_3_c_759_n N_VDD_M57_noxref_d ) capacitor c=0.0673792f \
 //x=5.35 //y=5.56 //x2=5.645 //y2=5.2
cc_1017 ( N_noxref_3_c_966_p N_VDD_M57_noxref_d ) capacitor c=0.0674762f \
 //x=6.23 //y=5.56 //x2=5.645 //y2=5.2
cc_1018 ( N_noxref_3_c_868_p N_VDD_M59_noxref_d ) capacitor c=0.00700141f \
 //x=6.995 //y=5.335 //x2=6.525 //y2=5.2
cc_1019 ( N_noxref_3_c_966_p N_VDD_M59_noxref_d ) capacitor c=0.067493f \
 //x=6.23 //y=5.56 //x2=6.525 //y2=5.2
cc_1020 ( N_noxref_3_c_832_p N_VDD_M59_noxref_d ) capacitor c=0.0674979f \
 //x=7.11 //y=5.56 //x2=6.525 //y2=5.2
cc_1021 ( N_noxref_3_c_795_n N_VDD_M61_noxref_d ) capacitor c=0.00700141f \
 //x=7.805 //y=5.335 //x2=7.405 //y2=5.2
cc_1022 ( N_noxref_3_c_832_p N_VDD_M61_noxref_d ) capacitor c=0.0675002f \
 //x=7.11 //y=5.56 //x2=7.405 //y2=5.2
cc_1023 ( N_noxref_3_c_794_n N_VDD_M62_noxref_s ) capacitor c=0.00492616f \
 //x=7.11 //y=5.56 //x2=9.585 //y2=5.2
cc_1024 ( N_noxref_3_c_795_n N_VDD_M62_noxref_s ) capacitor c=9.42705e-19 \
 //x=7.805 //y=5.335 //x2=9.585 //y2=5.2
cc_1025 ( N_noxref_3_c_964_p N_VDD_M62_noxref_s ) capacitor c=2.11884e-19 \
 //x=6.23 //y=5.335 //x2=9.585 //y2=5.2
cc_1026 ( N_noxref_3_c_802_p N_VDD_M72_noxref_s ) capacitor c=0.00231402f \
 //x=17.88 //y=4.425 //x2=17.425 //y2=5.2
cc_1027 ( N_noxref_3_M72_noxref_g N_VDD_M72_noxref_s ) capacitor c=0.0567929f \
 //x=17.78 //y=6.2 //x2=17.425 //y2=5.2
cc_1028 ( N_noxref_3_M73_noxref_g N_VDD_M73_noxref_d ) capacitor c=0.015318f \
 //x=18.22 //y=6.2 //x2=18.295 //y2=5.2
cc_1029 ( N_noxref_3_c_727_n N_noxref_24_c_12951_n ) capacitor c=0.0036878f \
 //x=7.405 //y=1.305 //x2=7.805 //y2=0.72
cc_1030 ( N_noxref_3_c_796_n N_noxref_24_c_12951_n ) capacitor c=0.00399931f \
 //x=7.805 //y=1.845 //x2=7.805 //y2=0.72
cc_1031 ( N_noxref_3_M4_noxref_d N_noxref_24_c_12951_n ) capacitor \
 c=0.00910163f //x=7.215 //y=1.095 //x2=7.805 //y2=0.72
cc_1032 ( N_noxref_3_M4_noxref_d N_noxref_24_c_12958_n ) capacitor \
 c=0.00120711f //x=7.215 //y=1.095 //x2=6.92 //y2=1.175
cc_1033 ( N_noxref_3_c_726_n N_noxref_24_M3_noxref_d ) capacitor c=0.00148661f \
 //x=6.11 //y=5.335 //x2=5.68 //y2=1.09
cc_1034 ( N_noxref_3_c_727_n N_noxref_24_M3_noxref_d ) capacitor c=0.00802417f \
 //x=7.405 //y=1.305 //x2=5.68 //y2=1.09
cc_1035 ( N_noxref_3_c_727_n N_noxref_24_M4_noxref_s ) capacitor c=0.0098487f \
 //x=7.405 //y=1.305 //x2=6.785 //y2=0.555
cc_1036 ( N_noxref_3_c_728_n N_noxref_24_M4_noxref_s ) capacitor c=0.0283111f \
 //x=7.405 //y=1.76 //x2=6.785 //y2=0.555
cc_1037 ( N_noxref_3_c_796_n N_noxref_24_M4_noxref_s ) capacitor c=0.00946155f \
 //x=7.805 //y=1.845 //x2=6.785 //y2=0.555
cc_1038 ( N_noxref_3_c_829_p N_noxref_24_M4_noxref_s ) capacitor c=0.00104339f \
 //x=7.885 //y=4.25 //x2=6.785 //y2=0.555
cc_1039 ( N_noxref_3_M4_noxref_d N_noxref_24_M4_noxref_s ) capacitor \
 c=0.0279003f //x=7.215 //y=1.095 //x2=6.785 //y2=0.555
cc_1040 ( N_noxref_3_c_727_n N_noxref_25_M6_noxref_d ) capacitor c=3.20746e-19 \
 //x=7.405 //y=1.305 //x2=10.49 //y2=1.09
cc_1041 ( N_noxref_3_c_739_n N_GND_c_13858_n ) capacitor c=0.00234561f \
 //x=2.34 //y=2.26 //x2=4.81 //y2=0.175
cc_1042 ( N_noxref_3_c_727_n N_GND_c_13867_n ) capacitor c=0.00887838f \
 //x=7.405 //y=1.305 //x2=9.62 //y2=0.175
cc_1043 ( N_noxref_3_c_796_n N_GND_c_13867_n ) capacitor c=0.0067418f \
 //x=7.805 //y=1.845 //x2=9.62 //y2=0.175
cc_1044 ( N_noxref_3_c_737_n N_GND_c_13867_n ) capacitor c=2.68873e-19 \
 //x=7.89 //y=4.41 //x2=9.62 //y2=0.175
cc_1045 ( N_noxref_3_M4_noxref_d N_GND_c_13867_n ) capacitor c=2.9462e-19 \
 //x=7.215 //y=1.095 //x2=9.62 //y2=0.175
cc_1046 ( N_noxref_3_c_727_n N_GND_c_13885_n ) capacitor c=0.00543195f \
 //x=7.405 //y=1.305 //x2=9.705 //y2=1.145
cc_1047 ( N_noxref_3_c_836_p N_GND_c_13985_n ) capacitor c=0.00645051f \
 //x=17.88 //y=2.26 //x2=17.95 //y2=1.135
cc_1048 ( N_noxref_3_c_1005_p N_GND_c_13985_n ) capacitor c=2.13705e-19 \
 //x=17.88 //y=2.26 //x2=17.95 //y2=1.135
cc_1049 ( N_noxref_3_c_1033_p N_GND_c_13985_n ) capacitor c=0.00171023f \
 //x=17.685 //y=1.045 //x2=17.95 //y2=1.135
cc_1050 ( N_noxref_3_c_1034_p N_GND_c_13985_n ) capacitor c=0.00357815f \
 //x=17.685 //y=1.39 //x2=17.95 //y2=1.135
cc_1051 ( N_noxref_3_c_1036_p N_GND_c_13985_n ) capacitor c=4.2764e-19 \
 //x=17.685 //y=1.7 //x2=17.95 //y2=1.135
cc_1052 ( N_noxref_3_c_1148_p N_GND_c_13985_n ) capacitor c=9.36995e-19 \
 //x=18.06 //y=0.89 //x2=17.95 //y2=1.135
cc_1053 ( N_noxref_3_c_1149_p N_GND_c_13985_n ) capacitor c=6.33567e-19 \
 //x=18.06 //y=1.545 //x2=17.95 //y2=1.135
cc_1054 ( N_noxref_3_c_1035_p N_GND_c_13985_n ) capacitor c=0.00171483f \
 //x=18.215 //y=1.045 //x2=17.95 //y2=1.135
cc_1055 ( N_noxref_3_c_1037_p N_GND_c_13985_n ) capacitor c=0.00296337f \
 //x=18.215 //y=1.39 //x2=17.95 //y2=1.135
cc_1056 ( N_noxref_3_c_1033_p N_GND_c_13994_n ) capacitor c=3.46594e-19 \
 //x=17.685 //y=1.045 //x2=17.947 //y2=1.005
cc_1057 ( N_noxref_3_c_1148_p N_GND_c_13994_n ) capacitor c=0.00838576f \
 //x=18.06 //y=0.89 //x2=17.947 //y2=1.005
cc_1058 ( N_noxref_3_c_1035_p N_GND_c_13994_n ) capacitor c=4.40196e-19 \
 //x=18.215 //y=1.045 //x2=17.947 //y2=1.005
cc_1059 ( N_noxref_3_c_739_n N_GND_c_13896_n ) capacitor c=3.77328e-19 \
 //x=2.34 //y=2.26 //x2=3.65 //y2=0.175
cc_1060 ( N_noxref_3_c_796_n N_GND_c_13900_n ) capacitor c=6.86343e-19 \
 //x=7.805 //y=1.845 //x2=8.46 //y2=0.175
cc_1061 ( N_noxref_3_c_1033_p N_GND_c_13999_n ) capacitor c=0.00688027f \
 //x=17.685 //y=1.045 //x2=19.93 //y2=0.175
cc_1062 ( N_noxref_3_c_756_n N_GND_c_13902_n ) capacitor c=0.00224736f \
 //x=2.34 //y=2.26 //x2=3.82 //y2=0.175
cc_1063 ( N_noxref_3_c_785_n N_GND_c_13902_n ) capacitor c=0.00275184f \
 //x=2.905 //y=1.43 //x2=3.82 //y2=0.175
cc_1064 ( N_noxref_3_c_789_n N_GND_c_13902_n ) capacitor c=2.63786e-19 \
 //x=2.34 //y=2.26 //x2=3.82 //y2=0.175
cc_1065 ( N_noxref_3_c_728_n N_GND_c_13914_n ) capacitor c=0.0045138f \
 //x=7.405 //y=1.76 //x2=8.63 //y2=0.175
cc_1066 ( N_noxref_3_c_796_n N_GND_c_13914_n ) capacitor c=0.0316807f \
 //x=7.805 //y=1.845 //x2=8.63 //y2=0.175
cc_1067 ( N_noxref_3_c_800_p N_GND_c_13971_n ) capacitor c=0.00781993f \
 //x=17.88 //y=4.105 //x2=16.77 //y2=0.175
cc_1068 ( N_noxref_3_c_836_p N_GND_c_13971_n ) capacitor c=0.00351582f \
 //x=17.88 //y=2.26 //x2=16.77 //y2=0.175
cc_1069 ( N_noxref_3_c_1005_p N_GND_c_13971_n ) capacitor c=0.00371068f \
 //x=17.88 //y=2.26 //x2=16.77 //y2=0.175
cc_1070 ( N_noxref_3_c_1036_p N_GND_c_13971_n ) capacitor c=0.0015404f \
 //x=17.685 //y=1.7 //x2=16.77 //y2=0.175
cc_1071 ( N_noxref_3_c_1006_p N_GND_c_13971_n ) capacitor c=0.00936534f \
 //x=17.685 //y=2.095 //x2=16.77 //y2=0.175
cc_1072 ( N_noxref_3_c_836_p N_GND_M10_noxref_d ) capacitor c=2.20438e-19 \
 //x=17.88 //y=2.26 //x2=17.76 //y2=1.045
cc_1073 ( N_noxref_3_c_1033_p N_GND_M10_noxref_d ) capacitor c=0.00192399f \
 //x=17.685 //y=1.045 //x2=17.76 //y2=1.045
cc_1074 ( N_noxref_3_c_1034_p N_GND_M10_noxref_d ) capacitor c=0.00210798f \
 //x=17.685 //y=1.39 //x2=17.76 //y2=1.045
cc_1075 ( N_noxref_3_c_1148_p N_GND_M10_noxref_d ) capacitor c=0.00472259f \
 //x=18.06 //y=0.89 //x2=17.76 //y2=1.045
cc_1076 ( N_noxref_3_c_1149_p N_GND_M10_noxref_d ) capacitor c=0.00166857f \
 //x=18.06 //y=1.545 //x2=17.76 //y2=1.045
cc_1077 ( N_noxref_3_c_1035_p N_GND_M10_noxref_d ) capacitor c=0.00230174f \
 //x=18.215 //y=1.045 //x2=17.76 //y2=1.045
cc_1078 ( N_noxref_3_c_1037_p N_GND_M10_noxref_d ) capacitor c=0.00210798f \
 //x=18.215 //y=1.39 //x2=17.76 //y2=1.045
cc_1079 ( N_noxref_3_c_718_n N_noxref_37_c_15596_n ) capacitor c=3.23849e-19 \
 //x=2.34 //y=4.405 //x2=2.155 //y2=1.675
cc_1080 ( N_noxref_3_c_739_n N_noxref_37_c_15596_n ) capacitor c=7.50092e-19 \
 //x=2.34 //y=2.26 //x2=2.155 //y2=1.675
cc_1081 ( N_noxref_3_c_773_n N_noxref_37_c_15596_n ) capacitor c=0.00888238f \
 //x=2.375 //y=1.74 //x2=2.155 //y2=1.675
cc_1082 ( N_noxref_3_c_789_n N_noxref_37_c_15596_n ) capacitor c=0.00175171f \
 //x=2.34 //y=2.26 //x2=2.155 //y2=1.675
cc_1083 ( N_noxref_3_c_739_n N_noxref_37_c_15597_n ) capacitor c=0.001463f \
 //x=2.34 //y=2.26 //x2=3.04 //y2=0.71
cc_1084 ( N_noxref_3_c_756_n N_noxref_37_c_15597_n ) capacitor c=8.82141e-19 \
 //x=2.34 //y=2.26 //x2=3.04 //y2=0.71
cc_1085 ( N_noxref_3_c_768_n N_noxref_37_c_15597_n ) capacitor c=0.0200738f \
 //x=2.375 //y=1.085 //x2=3.04 //y2=0.71
cc_1086 ( N_noxref_3_c_783_n N_noxref_37_c_15597_n ) capacitor c=0.00825432f \
 //x=2.905 //y=1.085 //x2=3.04 //y2=0.71
cc_1087 ( N_noxref_3_c_789_n N_noxref_37_c_15597_n ) capacitor c=2.1838e-19 \
 //x=2.34 //y=2.26 //x2=3.04 //y2=0.71
cc_1088 ( N_noxref_3_c_768_n N_noxref_37_M0_noxref_s ) capacitor c=0.00888238f \
 //x=2.375 //y=1.085 //x2=1.05 //y2=0.545
cc_1089 ( N_noxref_3_c_783_n N_noxref_37_M0_noxref_s ) capacitor c=0.015333f \
 //x=2.905 //y=1.085 //x2=1.05 //y2=0.545
cc_1090 ( N_noxref_3_c_785_n N_noxref_37_M0_noxref_s ) capacitor c=0.00248746f \
 //x=2.905 //y=1.43 //x2=1.05 //y2=0.545
cc_1091 ( N_noxref_3_c_1006_p N_noxref_41_c_15843_n ) capacitor c=0.00262672f \
 //x=17.685 //y=2.095 //x2=17.465 //y2=1.675
cc_1092 ( N_noxref_3_c_802_p N_noxref_41_c_15844_n ) capacitor c=0.00330249f \
 //x=17.88 //y=4.425 //x2=18.35 //y2=1.76
cc_1093 ( N_noxref_3_c_836_p N_noxref_41_c_15844_n ) capacitor c=0.00509504f \
 //x=17.88 //y=2.26 //x2=18.35 //y2=1.76
cc_1094 ( N_noxref_3_c_1005_p N_noxref_41_c_15844_n ) capacitor c=0.00655412f \
 //x=17.88 //y=2.26 //x2=18.35 //y2=1.76
cc_1095 ( N_noxref_3_c_1036_p N_noxref_41_c_15844_n ) capacitor c=0.00697076f \
 //x=17.685 //y=1.7 //x2=18.35 //y2=1.76
cc_1096 ( N_noxref_3_c_1006_p N_noxref_41_c_15844_n ) capacitor c=0.0187046f \
 //x=17.685 //y=2.095 //x2=18.35 //y2=1.76
cc_1097 ( N_noxref_3_c_1149_p N_noxref_41_c_15844_n ) capacitor c=0.00723574f \
 //x=18.06 //y=1.545 //x2=18.35 //y2=1.76
cc_1098 ( N_noxref_3_c_1037_p N_noxref_41_c_15844_n ) capacitor c=0.00339872f \
 //x=18.215 //y=1.39 //x2=18.35 //y2=1.76
cc_1099 ( N_noxref_3_c_1006_p N_noxref_41_c_15851_n ) capacitor c=6.71402e-19 \
 //x=17.685 //y=2.095 //x2=18.435 //y2=1.675
cc_1100 ( N_noxref_3_c_1033_p N_noxref_41_M10_noxref_s ) capacitor \
 c=0.0294925f //x=17.685 //y=1.045 //x2=17.33 //y2=0.545
cc_1101 ( N_noxref_3_c_1036_p N_noxref_41_M10_noxref_s ) capacitor \
 c=3.48408e-19 //x=17.685 //y=1.7 //x2=17.33 //y2=0.545
cc_1102 ( N_noxref_3_c_1035_p N_noxref_41_M10_noxref_s ) capacitor \
 c=0.0125442f //x=18.215 //y=1.045 //x2=17.33 //y2=0.545
cc_1103 ( N_noxref_4_c_1216_p N_noxref_5_c_1522_n ) capacitor c=0.00324213f \
 //x=18.92 //y=1.75 //x2=15.59 //y2=1.75
cc_1104 ( N_noxref_4_c_1202_n N_noxref_5_c_1666_n ) capacitor c=0.00114153f \
 //x=18 //y=5.56 //x2=15.945 //y2=5.38
cc_1105 ( N_noxref_4_c_1218_p N_noxref_5_c_1667_n ) capacitor c=0.00231467f \
 //x=19.005 //y=1.835 //x2=15.945 //y2=1.835
cc_1106 ( N_noxref_4_c_1200_n N_noxref_5_c_1524_n ) capacitor c=0.00204244f \
 //x=19.36 //y=4.105 //x2=16.03 //y2=3.705
cc_1107 ( N_noxref_4_c_1201_n N_noxref_5_c_1527_n ) capacitor c=0.00281705f \
 //x=19.36 //y=5.295 //x2=16.03 //y2=5.295
cc_1108 ( N_noxref_4_c_1221_p N_noxref_5_c_1670_n ) capacitor c=0.00161177f \
 //x=21.21 //y=4.105 //x2=23.43 //y2=3.725
cc_1109 ( N_noxref_4_c_1222_p N_noxref_5_c_1671_n ) capacitor c=2.92422e-19 \
 //x=21.21 //y=4.755 //x2=23.43 //y2=4.75
cc_1110 ( N_noxref_4_c_1202_n N_noxref_5_c_1672_n ) capacitor c=5.29822e-19 \
 //x=18 //y=5.56 //x2=15.55 //y2=5.38
cc_1111 ( N_noxref_4_c_1202_n N_noxref_5_c_1673_n ) capacitor c=0.00147119f \
 //x=18 //y=5.56 //x2=15.55 //y2=5.56
cc_1112 ( N_noxref_4_c_1225_p N_noxref_5_c_1538_n ) capacitor c=6.99317e-19 \
 //x=18.92 //y=1.18 //x2=15.59 //y2=1.18
cc_1113 ( N_noxref_4_c_1200_n N_noxref_5_c_1626_n ) capacitor c=0.0227809f \
 //x=19.36 //y=4.105 //x2=23.27 //y2=3.885
cc_1114 ( N_noxref_4_c_1227_p N_noxref_5_c_1626_n ) capacitor c=0.00859089f \
 //x=19.36 //y=4.425 //x2=23.27 //y2=3.885
cc_1115 ( N_noxref_4_c_1221_p N_noxref_5_c_1626_n ) capacitor c=0.024225f \
 //x=21.21 //y=4.105 //x2=23.27 //y2=3.885
cc_1116 ( N_noxref_4_c_1229_p N_noxref_5_c_1626_n ) capacitor c=0.00867186f \
 //x=21.21 //y=4.425 //x2=23.27 //y2=3.885
cc_1117 ( N_noxref_4_c_1209_n N_noxref_5_c_1626_n ) capacitor c=0.0358686f \
 //x=19.52 //y=4.265 //x2=23.27 //y2=3.885
cc_1118 ( N_noxref_4_c_1231_p N_noxref_5_c_1626_n ) capacitor c=0.0358686f \
 //x=21.21 //y=4.265 //x2=23.27 //y2=3.885
cc_1119 ( N_noxref_4_c_1232_p N_noxref_5_c_1626_n ) capacitor c=0.134323f \
 //x=21.05 //y=4.265 //x2=23.27 //y2=3.885
cc_1120 ( N_noxref_4_c_1200_n N_D_c_5046_n ) capacitor c=0.0270018f //x=19.36 \
 //y=4.105 //x2=27.37 //y2=3.155
cc_1121 ( N_noxref_4_c_1221_p N_D_c_5046_n ) capacitor c=0.027438f //x=21.21 \
 //y=4.105 //x2=27.37 //y2=3.155
cc_1122 ( N_noxref_4_c_1199_n N_CLK_c_6396_n ) capacitor c=0.014912f \
 //x=18.765 //y=5.38 //x2=18.095 //y2=4.65
cc_1123 ( N_noxref_4_c_1202_n N_CLK_c_6396_n ) capacitor c=0.0077052f //x=18 \
 //y=5.56 //x2=18.095 //y2=4.65
cc_1124 ( N_noxref_4_c_1237_p N_CLK_c_6421_n ) capacitor c=0.00918249f \
 //x=19.275 //y=5.38 //x2=18.975 //y2=4.62
cc_1125 ( N_noxref_4_c_1227_p N_CLK_c_6421_n ) capacitor c=0.00116312f \
 //x=19.36 //y=4.425 //x2=18.975 //y2=4.62
cc_1126 ( N_noxref_4_c_1201_n N_CLK_c_6421_n ) capacitor c=6.46733e-19 \
 //x=19.36 //y=5.295 //x2=18.975 //y2=4.62
cc_1127 ( N_noxref_4_c_1240_p N_CLK_c_6421_n ) capacitor c=0.0114245f \
 //x=18.88 //y=5.38 //x2=18.975 //y2=4.62
cc_1128 ( N_noxref_4_c_1209_n N_CLK_c_6421_n ) capacitor c=0.0364799f \
 //x=19.52 //y=4.265 //x2=18.975 //y2=4.62
cc_1129 ( N_noxref_4_c_1227_p N_CLK_c_6426_n ) capacitor c=0.00737073f \
 //x=19.36 //y=4.425 //x2=19.575 //y2=4.65
cc_1130 ( N_noxref_4_c_1201_n N_CLK_c_6426_n ) capacitor c=0.0281791f \
 //x=19.36 //y=5.295 //x2=19.575 //y2=4.65
cc_1131 ( N_noxref_4_c_1232_p N_CLK_c_6426_n ) capacitor c=0.133364f //x=21.05 \
 //y=4.265 //x2=19.575 //y2=4.65
cc_1132 ( N_noxref_4_c_1201_n N_CLK_c_6429_n ) capacitor c=2.03593e-19 \
 //x=19.36 //y=5.295 //x2=20.825 //y2=4.62
cc_1133 ( N_noxref_4_c_1229_p N_CLK_c_6429_n ) capacitor c=0.00465295f \
 //x=21.21 //y=4.425 //x2=20.825 //y2=4.62
cc_1134 ( N_noxref_4_c_1222_p N_CLK_c_6429_n ) capacitor c=0.00100561f \
 //x=21.21 //y=4.755 //x2=20.825 //y2=4.62
cc_1135 ( N_noxref_4_c_1231_p N_CLK_c_6429_n ) capacitor c=0.0364798f \
 //x=21.21 //y=4.265 //x2=20.825 //y2=4.62
cc_1136 ( N_noxref_4_c_1232_p N_CLK_c_6429_n ) capacitor c=0.0107602f \
 //x=21.05 //y=4.265 //x2=20.825 //y2=4.62
cc_1137 ( N_noxref_4_c_1229_p N_CLK_c_6434_n ) capacitor c=0.00322252f \
 //x=21.21 //y=4.425 //x2=21.425 //y2=4.65
cc_1138 ( N_noxref_4_c_1222_p N_CLK_c_6434_n ) capacitor c=0.0312593f \
 //x=21.21 //y=4.755 //x2=21.425 //y2=4.65
cc_1139 ( N_noxref_4_c_1252_p N_CLK_c_6434_n ) capacitor c=0.00105879f \
 //x=21.485 //y=4.97 //x2=21.425 //y2=4.65
cc_1140 ( N_noxref_4_c_1200_n SN ) capacitor c=0.00137037f //x=19.36 //y=4.105 \
 //x2=22.32 //y2=2.77
cc_1141 ( N_noxref_4_c_1201_n SN ) capacitor c=3.53037e-19 //x=19.36 //y=5.295 \
 //x2=22.32 //y2=2.77
cc_1142 ( N_noxref_4_c_1221_p SN ) capacitor c=0.0390915f //x=21.21 //y=4.105 \
 //x2=22.32 //y2=2.77
cc_1143 ( N_noxref_4_c_1229_p SN ) capacitor c=0.00782592f //x=21.21 //y=4.425 \
 //x2=22.32 //y2=2.77
cc_1144 ( N_noxref_4_c_1222_p SN ) capacitor c=0.00678399f //x=21.21 //y=4.755 \
 //x2=22.32 //y2=2.77
cc_1145 ( N_noxref_4_c_1258_p SN ) capacitor c=4.11345e-19 //x=21.21 //y=4.25 \
 //x2=22.32 //y2=2.77
cc_1146 ( N_noxref_4_c_1231_p SN ) capacitor c=0.00508571f //x=21.21 //y=4.265 \
 //x2=22.32 //y2=2.77
cc_1147 ( N_noxref_4_c_1260_p SN ) capacitor c=3.36194e-19 //x=21.21 //y=4.88 \
 //x2=22.32 //y2=2.77
cc_1148 ( N_noxref_4_c_1261_p N_SN_c_8130_n ) capacitor c=0.00802132f \
 //x=21.21 //y=2.375 //x2=22.32 //y2=2.55
cc_1149 ( N_noxref_4_c_1221_p N_SN_c_8130_n ) capacitor c=0.00346868f \
 //x=21.21 //y=4.105 //x2=22.32 //y2=2.55
cc_1150 ( N_noxref_4_c_1263_p N_SN_c_8130_n ) capacitor c=0.00117245f \
 //x=21.21 //y=2.26 //x2=22.32 //y2=2.55
cc_1151 ( N_noxref_4_c_1264_p N_SN_c_8130_n ) capacitor c=0.00157323f \
 //x=20.91 //y=2.095 //x2=22.32 //y2=2.55
cc_1152 ( N_noxref_4_c_1222_p N_SN_c_8134_n ) capacitor c=0.0110307f //x=21.21 \
 //y=4.755 //x2=22.32 //y2=4.765
cc_1153 ( N_noxref_4_c_1260_p N_SN_c_8134_n ) capacitor c=2.89813e-19 \
 //x=21.21 //y=4.88 //x2=22.32 //y2=4.765
cc_1154 ( N_noxref_4_c_1267_p N_SN_c_8134_n ) capacitor c=7.66769e-19 \
 //x=21.775 //y=4.97 //x2=22.32 //y2=4.765
cc_1155 ( N_noxref_4_c_1252_p N_SN_c_8134_n ) capacitor c=7.54501e-19 \
 //x=21.485 //y=4.97 //x2=22.32 //y2=4.765
cc_1156 ( N_noxref_4_c_1218_p N_SN_c_8092_n ) capacitor c=0.0193893f \
 //x=19.005 //y=1.835 //x2=22.15 //y2=2.4
cc_1157 ( N_noxref_4_c_1200_n N_SN_c_8092_n ) capacitor c=0.0308515f //x=19.36 \
 //y=4.105 //x2=22.15 //y2=2.4
cc_1158 ( N_noxref_4_c_1261_p N_SN_c_8092_n ) capacitor c=0.0171118f //x=21.21 \
 //y=2.375 //x2=22.15 //y2=2.4
cc_1159 ( N_noxref_4_c_1221_p N_SN_c_8092_n ) capacitor c=0.016914f //x=21.21 \
 //y=4.105 //x2=22.15 //y2=2.4
cc_1160 ( N_noxref_4_c_1225_p N_SN_c_8092_n ) capacitor c=6.98242e-19 \
 //x=18.92 //y=1.18 //x2=22.15 //y2=2.4
cc_1161 ( N_noxref_4_c_1263_p N_SN_c_8092_n ) capacitor c=2.54369e-19 \
 //x=21.21 //y=2.26 //x2=22.15 //y2=2.4
cc_1162 ( N_noxref_4_c_1264_p N_SN_c_8092_n ) capacitor c=3.41298e-19 \
 //x=20.91 //y=2.095 //x2=22.15 //y2=2.4
cc_1163 ( N_noxref_4_c_1261_p N_SN_c_8145_n ) capacitor c=0.00196004f \
 //x=21.21 //y=2.375 //x2=27.285 //y2=2.385
cc_1164 ( N_noxref_4_c_1221_p N_SN_c_8145_n ) capacitor c=0.00105803f \
 //x=21.21 //y=4.105 //x2=27.285 //y2=2.385
cc_1165 ( N_noxref_4_c_1261_p N_SN_c_8147_n ) capacitor c=5.39999e-19 \
 //x=21.21 //y=2.375 //x2=22.32 //y2=2.26
cc_1166 ( N_noxref_4_c_1263_p N_SN_c_8147_n ) capacitor c=0.00124905f \
 //x=21.21 //y=2.26 //x2=22.32 //y2=2.26
cc_1167 ( N_noxref_4_c_1264_p N_SN_c_8147_n ) capacitor c=0.00214501f \
 //x=20.91 //y=2.095 //x2=22.32 //y2=2.26
cc_1168 ( N_noxref_4_c_1222_p N_SN_c_8150_n ) capacitor c=0.00102369f \
 //x=21.21 //y=4.755 //x2=22.32 //y2=4.88
cc_1169 ( N_noxref_4_c_1260_p N_SN_c_8150_n ) capacitor c=0.00113984f \
 //x=21.21 //y=4.88 //x2=22.32 //y2=4.88
cc_1170 ( N_noxref_4_c_1267_p N_SN_c_8150_n ) capacitor c=0.00116563f \
 //x=21.775 //y=4.97 //x2=22.32 //y2=4.88
cc_1171 ( N_noxref_4_c_1252_p N_SN_c_8150_n ) capacitor c=0.00129812f \
 //x=21.485 //y=4.97 //x2=22.32 //y2=4.88
cc_1172 ( N_noxref_4_M76_noxref_g N_SN_M78_noxref_g ) capacitor c=0.0106276f \
 //x=21.41 //y=6.2 //x2=22.29 //y2=6.2
cc_1173 ( N_noxref_4_M77_noxref_g N_SN_M78_noxref_g ) capacitor c=0.107144f \
 //x=21.85 //y=6.2 //x2=22.29 //y2=6.2
cc_1174 ( N_noxref_4_M77_noxref_g N_SN_M79_noxref_g ) capacitor c=0.0101598f \
 //x=21.85 //y=6.2 //x2=22.73 //y2=6.2
cc_1175 ( N_noxref_4_c_1288_p N_SN_c_8157_n ) capacitor c=5.72528e-19 \
 //x=20.91 //y=1.055 //x2=21.885 //y2=1.09
cc_1176 ( N_noxref_4_c_1289_p N_SN_c_8157_n ) capacitor c=0.00150277f \
 //x=20.91 //y=1.4 //x2=21.885 //y2=1.09
cc_1177 ( N_noxref_4_c_1290_p N_SN_c_8157_n ) capacitor c=0.0160123f //x=21.44 \
 //y=1.055 //x2=21.885 //y2=1.09
cc_1178 ( N_noxref_4_c_1291_p N_SN_c_8160_n ) capacitor c=0.00111227f \
 //x=20.91 //y=1.71 //x2=21.885 //y2=1.4
cc_1179 ( N_noxref_4_c_1292_p N_SN_c_8160_n ) capacitor c=0.0124075f //x=21.44 \
 //y=1.4 //x2=21.885 //y2=1.4
cc_1180 ( N_noxref_4_c_1290_p N_SN_c_8162_n ) capacitor c=9.19165e-19 \
 //x=21.44 //y=1.055 //x2=22.41 //y2=1.09
cc_1181 ( N_noxref_4_c_1292_p N_SN_c_8163_n ) capacitor c=0.0010154f //x=21.44 \
 //y=1.4 //x2=22.41 //y2=1.4
cc_1182 ( N_noxref_4_c_1292_p N_SN_c_8164_n ) capacitor c=9.23422e-19 \
 //x=21.44 //y=1.4 //x2=22.41 //y2=1.63
cc_1183 ( N_noxref_4_c_1261_p N_SN_c_8165_n ) capacitor c=5.616e-19 //x=21.21 \
 //y=2.375 //x2=22.41 //y2=2.095
cc_1184 ( N_noxref_4_c_1263_p N_SN_c_8165_n ) capacitor c=0.0017273f //x=21.21 \
 //y=2.26 //x2=22.41 //y2=2.095
cc_1185 ( N_noxref_4_c_1264_p N_SN_c_8165_n ) capacitor c=0.00880777f \
 //x=20.91 //y=2.095 //x2=22.41 //y2=2.095
cc_1186 ( N_noxref_4_c_1222_p N_SN_c_8168_n ) capacitor c=0.00116212f \
 //x=21.21 //y=4.755 //x2=22.32 //y2=4.88
cc_1187 ( N_noxref_4_c_1260_p N_SN_c_8168_n ) capacitor c=0.00155973f \
 //x=21.21 //y=4.88 //x2=22.32 //y2=4.88
cc_1188 ( N_noxref_4_c_1267_p N_SN_c_8168_n ) capacitor c=0.0171374f \
 //x=21.775 //y=4.97 //x2=22.32 //y2=4.88
cc_1189 ( N_noxref_4_c_1252_p N_SN_c_8168_n ) capacitor c=0.00484466f \
 //x=21.485 //y=4.97 //x2=22.32 //y2=4.88
cc_1190 ( N_noxref_4_c_1200_n N_noxref_21_c_10403_n ) capacitor c=0.0378011f \
 //x=19.36 //y=4.105 //x2=18.62 //y2=3.335
cc_1191 ( N_noxref_4_c_1221_p N_noxref_21_c_10403_n ) capacitor c=0.00177311f \
 //x=21.21 //y=4.105 //x2=18.62 //y2=3.335
cc_1192 ( N_noxref_4_c_1199_n N_noxref_21_c_10405_n ) capacitor c=0.001107f \
 //x=18.765 //y=5.38 //x2=18.62 //y2=3.655
cc_1193 ( N_noxref_4_c_1218_p N_noxref_21_c_10405_n ) capacitor c=5.38697e-19 \
 //x=19.005 //y=1.835 //x2=18.62 //y2=3.655
cc_1194 ( N_noxref_4_c_1200_n N_noxref_21_c_10405_n ) capacitor c=0.01761f \
 //x=19.36 //y=4.105 //x2=18.62 //y2=3.655
cc_1195 ( N_noxref_4_c_1240_p N_noxref_21_c_10405_n ) capacitor c=0.00130223f \
 //x=18.88 //y=5.38 //x2=18.62 //y2=3.655
cc_1196 ( N_noxref_4_c_1225_p N_noxref_21_c_10405_n ) capacitor c=2.20951e-19 \
 //x=18.92 //y=1.18 //x2=18.62 //y2=3.655
cc_1197 ( N_noxref_4_c_1310_p N_noxref_21_c_10405_n ) capacitor c=3.18838e-19 \
 //x=18.88 //y=5.56 //x2=18.62 //y2=3.655
cc_1198 ( N_noxref_4_c_1199_n N_noxref_21_c_10406_n ) capacitor c=0.0217631f \
 //x=18.765 //y=5.38 //x2=18.62 //y2=4.735
cc_1199 ( N_noxref_4_c_1200_n N_noxref_21_c_10406_n ) capacitor c=0.0178116f \
 //x=19.36 //y=4.105 //x2=18.62 //y2=4.735
cc_1200 ( N_noxref_4_c_1227_p N_noxref_21_c_10406_n ) capacitor c=0.0151131f \
 //x=19.36 //y=4.425 //x2=18.62 //y2=4.735
cc_1201 ( N_noxref_4_c_1201_n N_noxref_21_c_10406_n ) capacitor c=0.027654f \
 //x=19.36 //y=5.295 //x2=18.62 //y2=4.735
cc_1202 ( N_noxref_4_c_1221_p N_noxref_21_c_10406_n ) capacitor c=3.13322e-19 \
 //x=21.21 //y=4.105 //x2=18.62 //y2=4.735
cc_1203 ( N_noxref_4_c_1222_p N_noxref_21_c_10406_n ) capacitor c=4.26539e-19 \
 //x=21.21 //y=4.755 //x2=18.62 //y2=4.735
cc_1204 ( N_noxref_4_c_1208_n N_noxref_21_c_10406_n ) capacitor c=6.47554e-19 \
 //x=19.36 //y=4.25 //x2=18.62 //y2=4.735
cc_1205 ( N_noxref_4_c_1209_n N_noxref_21_c_10406_n ) capacitor c=0.00360492f \
 //x=19.52 //y=4.265 //x2=18.62 //y2=4.735
cc_1206 ( N_noxref_4_M77_noxref_g N_noxref_21_c_10461_n ) capacitor \
 c=0.00893512f //x=21.85 //y=6.2 //x2=22.39 //y2=5.335
cc_1207 ( N_noxref_4_c_1320_p N_noxref_21_c_10462_n ) capacitor c=8.25606e-19 \
 //x=19.275 //y=1.835 //x2=23.685 //y2=1.76
cc_1208 ( N_noxref_4_c_1200_n N_noxref_21_c_10463_n ) capacitor c=8.25606e-19 \
 //x=19.36 //y=4.105 //x2=23.77 //y2=1.845
cc_1209 ( N_noxref_4_c_1200_n N_noxref_21_c_10414_n ) capacitor c=0.0138368f \
 //x=19.36 //y=4.105 //x2=18.62 //y2=2.26
cc_1210 ( N_noxref_4_c_1200_n N_noxref_21_c_10417_n ) capacitor c=9.19401e-19 \
 //x=19.36 //y=4.105 //x2=18.62 //y2=3.51
cc_1211 ( N_noxref_4_c_1201_n N_noxref_21_c_10466_n ) capacitor c=0.00261914f \
 //x=19.36 //y=5.295 //x2=21.632 //y2=5.335
cc_1212 ( N_noxref_4_c_1240_p N_noxref_21_c_10466_n ) capacitor c=5.0812e-19 \
 //x=18.88 //y=5.38 //x2=21.632 //y2=5.335
cc_1213 ( N_noxref_4_M76_noxref_g N_noxref_21_c_10466_n ) capacitor \
 c=0.00461408f //x=21.41 //y=6.2 //x2=21.632 //y2=5.335
cc_1214 ( N_noxref_4_M77_noxref_g N_noxref_21_c_10466_n ) capacitor \
 c=0.00229208f //x=21.85 //y=6.2 //x2=21.632 //y2=5.335
cc_1215 ( N_noxref_4_c_1267_p N_noxref_21_c_10466_n ) capacitor c=0.00171885f \
 //x=21.775 //y=4.97 //x2=21.632 //y2=5.335
cc_1216 ( N_noxref_4_c_1200_n N_noxref_21_c_10471_n ) capacitor c=0.0222645f \
 //x=19.36 //y=4.105 //x2=23.045 //y2=3.51
cc_1217 ( N_noxref_4_c_1221_p N_noxref_21_c_10471_n ) capacitor c=0.024799f \
 //x=21.21 //y=4.105 //x2=23.045 //y2=3.51
cc_1218 ( N_noxref_4_c_1232_p N_noxref_21_c_10471_n ) capacitor c=0.0102694f \
 //x=21.05 //y=4.265 //x2=23.045 //y2=3.51
cc_1219 ( N_noxref_4_c_1200_n N_noxref_21_c_10418_n ) capacitor c=0.00336755f \
 //x=19.36 //y=4.105 //x2=18.78 //y2=3.495
cc_1220 ( N_noxref_4_c_1200_n N_noxref_21_c_10419_n ) capacitor c=9.26054e-19 \
 //x=19.36 //y=4.105 //x2=18.62 //y2=2.26
cc_1221 ( N_noxref_4_c_1199_n N_noxref_21_c_10423_n ) capacitor c=0.00469257f \
 //x=18.765 //y=5.38 //x2=18.65 //y2=4.88
cc_1222 ( N_noxref_4_c_1201_n N_noxref_21_c_10423_n ) capacitor c=7.43781e-19 \
 //x=19.36 //y=5.295 //x2=18.65 //y2=4.88
cc_1223 ( N_noxref_4_M76_noxref_g N_noxref_21_c_10478_n ) capacitor \
 c=0.0162284f //x=21.41 //y=6.2 //x2=21.63 //y2=5.56
cc_1224 ( N_noxref_4_M77_noxref_g N_noxref_21_c_10478_n ) capacitor \
 c=0.0179041f //x=21.85 //y=6.2 //x2=21.63 //y2=5.56
cc_1225 ( N_noxref_4_c_1267_p N_noxref_21_c_10478_n ) capacitor c=0.00291477f \
 //x=21.775 //y=4.97 //x2=21.63 //y2=5.56
cc_1226 ( N_noxref_4_c_1199_n N_noxref_21_M74_noxref_g ) capacitor \
 c=0.00842859f //x=18.765 //y=5.38 //x2=18.66 //y2=6.2
cc_1227 ( N_noxref_4_c_1240_p N_noxref_21_M74_noxref_g ) capacitor \
 c=0.00192712f //x=18.88 //y=5.38 //x2=18.66 //y2=6.2
cc_1228 ( N_noxref_4_c_1310_p N_noxref_21_M74_noxref_g ) capacitor \
 c=0.0178987f //x=18.88 //y=5.56 //x2=18.66 //y2=6.2
cc_1229 ( N_noxref_4_c_1237_p N_noxref_21_M75_noxref_g ) capacitor \
 c=0.0105755f //x=19.275 //y=5.38 //x2=19.1 //y2=6.2
cc_1230 ( N_noxref_4_c_1240_p N_noxref_21_M75_noxref_g ) capacitor \
 c=0.00312463f //x=18.88 //y=5.38 //x2=19.1 //y2=6.2
cc_1231 ( N_noxref_4_c_1310_p N_noxref_21_M75_noxref_g ) capacitor \
 c=0.0178506f //x=18.88 //y=5.56 //x2=19.1 //y2=6.2
cc_1232 ( N_noxref_4_c_1225_p N_noxref_21_c_10429_n ) capacitor c=0.00120406f \
 //x=18.92 //y=1.18 //x2=18.655 //y2=1.085
cc_1233 ( N_noxref_4_M11_noxref_d N_noxref_21_c_10429_n ) capacitor \
 c=0.00137165f //x=18.73 //y=1.085 //x2=18.655 //y2=1.085
cc_1234 ( N_noxref_4_c_1216_p N_noxref_21_c_10432_n ) capacitor c=0.00119008f \
 //x=18.92 //y=1.75 //x2=18.655 //y2=1.43
cc_1235 ( N_noxref_4_c_1225_p N_noxref_21_c_10432_n ) capacitor c=0.00218694f \
 //x=18.92 //y=1.18 //x2=18.655 //y2=1.43
cc_1236 ( N_noxref_4_M11_noxref_d N_noxref_21_c_10432_n ) capacitor \
 c=0.00237422f //x=18.73 //y=1.085 //x2=18.655 //y2=1.43
cc_1237 ( N_noxref_4_c_1216_p N_noxref_21_c_10434_n ) capacitor c=0.00438634f \
 //x=18.92 //y=1.75 //x2=18.655 //y2=1.74
cc_1238 ( N_noxref_4_c_1201_n N_noxref_21_c_10493_n ) capacitor c=0.00845606f \
 //x=19.36 //y=5.295 //x2=19.025 //y2=4.97
cc_1239 ( N_noxref_4_c_1240_p N_noxref_21_c_10493_n ) capacitor c=0.00191077f \
 //x=18.88 //y=5.38 //x2=19.025 //y2=4.97
cc_1240 ( N_noxref_4_c_1310_p N_noxref_21_c_10493_n ) capacitor c=0.00291714f \
 //x=18.88 //y=5.56 //x2=19.025 //y2=4.97
cc_1241 ( N_noxref_4_c_1225_p N_noxref_21_c_10496_n ) capacitor c=5.50523e-19 \
 //x=18.92 //y=1.18 //x2=19.03 //y2=0.93
cc_1242 ( N_noxref_4_M11_noxref_d N_noxref_21_c_10496_n ) capacitor \
 c=0.0020782f //x=18.73 //y=1.085 //x2=19.03 //y2=0.93
cc_1243 ( N_noxref_4_c_1216_p N_noxref_21_c_10498_n ) capacitor c=0.00929259f \
 //x=18.92 //y=1.75 //x2=19.03 //y2=1.585
cc_1244 ( N_noxref_4_c_1320_p N_noxref_21_c_10498_n ) capacitor c=0.00194324f \
 //x=19.275 //y=1.835 //x2=19.03 //y2=1.585
cc_1245 ( N_noxref_4_c_1225_p N_noxref_21_c_10498_n ) capacitor c=5.15106e-19 \
 //x=18.92 //y=1.18 //x2=19.03 //y2=1.585
cc_1246 ( N_noxref_4_M11_noxref_d N_noxref_21_c_10498_n ) capacitor \
 c=0.00356097f //x=18.73 //y=1.085 //x2=19.03 //y2=1.585
cc_1247 ( N_noxref_4_c_1225_p N_noxref_21_c_10437_n ) capacitor c=0.00108157f \
 //x=18.92 //y=1.18 //x2=19.185 //y2=1.085
cc_1248 ( N_noxref_4_M11_noxref_d N_noxref_21_c_10437_n ) capacitor \
 c=8.50095e-19 //x=18.73 //y=1.085 //x2=19.185 //y2=1.085
cc_1249 ( N_noxref_4_c_1216_p N_noxref_21_c_10438_n ) capacitor c=0.00341295f \
 //x=18.92 //y=1.75 //x2=19.185 //y2=1.43
cc_1250 ( N_noxref_4_c_1320_p N_noxref_21_c_10438_n ) capacitor c=0.00323005f \
 //x=19.275 //y=1.835 //x2=19.185 //y2=1.43
cc_1251 ( N_noxref_4_c_1225_p N_noxref_21_c_10438_n ) capacitor c=0.00312028f \
 //x=18.92 //y=1.18 //x2=19.185 //y2=1.43
cc_1252 ( N_noxref_4_M11_noxref_d N_noxref_21_c_10438_n ) capacitor \
 c=0.00237422f //x=18.73 //y=1.085 //x2=19.185 //y2=1.43
cc_1253 ( N_noxref_4_c_1200_n N_noxref_21_c_10439_n ) capacitor c=0.00268898f \
 //x=19.36 //y=4.105 //x2=18.62 //y2=2.26
cc_1254 ( N_noxref_4_c_1216_p N_noxref_21_c_10509_n ) capacitor c=0.00341114f \
 //x=18.92 //y=1.75 //x2=18.62 //y2=2.095
cc_1255 ( N_noxref_4_c_1200_n N_noxref_21_c_10509_n ) capacitor c=0.00309058f \
 //x=19.36 //y=4.105 //x2=18.62 //y2=2.095
cc_1256 ( N_noxref_4_c_1199_n N_noxref_21_c_10442_n ) capacitor c=9.11841e-19 \
 //x=18.765 //y=5.38 //x2=18.65 //y2=4.88
cc_1257 ( N_noxref_4_c_1201_n N_noxref_21_c_10442_n ) capacitor c=0.00139814f \
 //x=19.36 //y=5.295 //x2=18.65 //y2=4.88
cc_1258 ( N_noxref_4_c_1199_n N_VDD_c_11522_n ) capacitor c=0.00648288f \
 //x=18.765 //y=5.38 //x2=74.455 //y2=7.585
cc_1259 ( N_noxref_4_c_1237_p N_VDD_c_11522_n ) capacitor c=0.00492574f \
 //x=19.275 //y=5.38 //x2=74.455 //y2=7.585
cc_1260 ( N_noxref_4_c_1227_p N_VDD_c_11522_n ) capacitor c=5.05472e-19 \
 //x=19.36 //y=4.425 //x2=74.455 //y2=7.585
cc_1261 ( N_noxref_4_c_1229_p N_VDD_c_11522_n ) capacitor c=4.33432e-19 \
 //x=21.21 //y=4.425 //x2=74.455 //y2=7.585
cc_1262 ( N_noxref_4_c_1202_n N_VDD_c_11522_n ) capacitor c=0.00368834f //x=18 \
 //y=5.56 //x2=74.455 //y2=7.585
cc_1263 ( N_noxref_4_c_1240_p N_VDD_c_11522_n ) capacitor c=8.42537e-19 \
 //x=18.88 //y=5.38 //x2=74.455 //y2=7.585
cc_1264 ( N_noxref_4_c_1377_p N_VDD_c_11522_n ) capacitor c=0.00285853f \
 //x=18.88 //y=5.56 //x2=74.455 //y2=7.585
cc_1265 ( N_noxref_4_c_1208_n N_VDD_c_11522_n ) capacitor c=3.84946e-19 \
 //x=19.36 //y=4.25 //x2=74.455 //y2=7.585
cc_1266 ( N_noxref_4_c_1210_n N_VDD_c_11522_n ) capacitor c=0.00224881f //x=18 \
 //y=5.56 //x2=74.455 //y2=7.585
cc_1267 ( N_noxref_4_c_1310_p N_VDD_c_11522_n ) capacitor c=0.00224881f \
 //x=18.88 //y=5.56 //x2=74.455 //y2=7.585
cc_1268 ( N_noxref_4_c_1199_n N_VDD_c_11661_n ) capacitor c=0.00208087f \
 //x=18.765 //y=5.38 //x2=18.355 //y2=7.585
cc_1269 ( N_noxref_4_c_1202_n N_VDD_c_11661_n ) capacitor c=9.41185e-19 //x=18 \
 //y=5.56 //x2=18.355 //y2=7.585
cc_1270 ( N_noxref_4_c_1210_n N_VDD_c_11661_n ) capacitor c=0.0136705f //x=18 \
 //y=5.56 //x2=18.355 //y2=7.585
cc_1271 ( N_noxref_4_c_1199_n N_VDD_c_11721_n ) capacitor c=0.00180737f \
 //x=18.765 //y=5.38 //x2=19.235 //y2=7.585
cc_1272 ( N_noxref_4_c_1237_p N_VDD_c_11721_n ) capacitor c=0.00208087f \
 //x=19.275 //y=5.38 //x2=19.235 //y2=7.585
cc_1273 ( N_noxref_4_c_1240_p N_VDD_c_11721_n ) capacitor c=4.23719e-19 \
 //x=18.88 //y=5.38 //x2=19.235 //y2=7.585
cc_1274 ( N_noxref_4_c_1377_p N_VDD_c_11721_n ) capacitor c=5.77976e-19 \
 //x=18.88 //y=5.56 //x2=19.235 //y2=7.585
cc_1275 ( N_noxref_4_c_1310_p N_VDD_c_11721_n ) capacitor c=0.0136705f \
 //x=18.88 //y=5.56 //x2=19.235 //y2=7.585
cc_1276 ( N_noxref_4_c_1227_p N_VDD_c_11726_n ) capacitor c=3.81054e-19 \
 //x=19.36 //y=4.425 //x2=19.93 //y2=7.585
cc_1277 ( N_noxref_4_c_1229_p N_VDD_c_11727_n ) capacitor c=2.44541e-19 \
 //x=21.21 //y=4.425 //x2=21.105 //y2=7.585
cc_1278 ( N_noxref_4_M76_noxref_g N_VDD_c_11728_n ) capacitor c=0.00755614f \
 //x=21.41 //y=6.2 //x2=21.985 //y2=7.585
cc_1279 ( N_noxref_4_M77_noxref_g N_VDD_c_11728_n ) capacitor c=0.00755544f \
 //x=21.85 //y=6.2 //x2=21.985 //y2=7.585
cc_1280 ( N_noxref_4_c_1201_n N_VDD_c_11679_n ) capacitor c=0.0013228f \
 //x=19.36 //y=5.295 //x2=16.77 //y2=7.585
cc_1281 ( N_noxref_4_c_1202_n N_VDD_c_11679_n ) capacitor c=4.91377e-19 //x=18 \
 //y=5.56 //x2=16.77 //y2=7.585
cc_1282 ( N_noxref_4_c_1210_n N_VDD_c_11679_n ) capacitor c=0.0064135f //x=18 \
 //y=5.56 //x2=16.77 //y2=7.585
cc_1283 ( N_noxref_4_c_1227_p N_VDD_c_11733_n ) capacitor c=0.00207245f \
 //x=19.36 //y=4.425 //x2=20.1 //y2=7.585
cc_1284 ( N_noxref_4_c_1201_n N_VDD_c_11733_n ) capacitor c=0.0266752f \
 //x=19.36 //y=5.295 //x2=20.1 //y2=7.585
cc_1285 ( N_noxref_4_c_1229_p N_VDD_c_11733_n ) capacitor c=0.00145703f \
 //x=21.21 //y=4.425 //x2=20.1 //y2=7.585
cc_1286 ( N_noxref_4_c_1222_p N_VDD_c_11733_n ) capacitor c=0.00935846f \
 //x=21.21 //y=4.755 //x2=20.1 //y2=7.585
cc_1287 ( N_noxref_4_c_1240_p N_VDD_c_11733_n ) capacitor c=0.0025639f \
 //x=18.88 //y=5.38 //x2=20.1 //y2=7.585
cc_1288 ( N_noxref_4_c_1377_p N_VDD_c_11733_n ) capacitor c=4.19141e-19 \
 //x=18.88 //y=5.56 //x2=20.1 //y2=7.585
cc_1289 ( N_noxref_4_c_1208_n N_VDD_c_11733_n ) capacitor c=0.00492392f \
 //x=19.36 //y=4.25 //x2=20.1 //y2=7.585
cc_1290 ( N_noxref_4_c_1258_p N_VDD_c_11733_n ) capacitor c=0.00255753f \
 //x=21.21 //y=4.25 //x2=20.1 //y2=7.585
cc_1291 ( N_noxref_4_c_1232_p N_VDD_c_11733_n ) capacitor c=0.0079243f \
 //x=21.05 //y=4.265 //x2=20.1 //y2=7.585
cc_1292 ( N_noxref_4_c_1310_p N_VDD_c_11733_n ) capacitor c=0.0101861f \
 //x=18.88 //y=5.56 //x2=20.1 //y2=7.585
cc_1293 ( N_noxref_4_c_1260_p N_VDD_c_11733_n ) capacitor c=0.00370784f \
 //x=21.21 //y=4.88 //x2=20.1 //y2=7.585
cc_1294 ( N_noxref_4_c_1252_p N_VDD_c_11733_n ) capacitor c=0.00590568f \
 //x=21.485 //y=4.97 //x2=20.1 //y2=7.585
cc_1295 ( N_noxref_4_c_1202_n N_VDD_M72_noxref_s ) capacitor c=0.0572211f \
 //x=18 //y=5.56 //x2=17.425 //y2=5.2
cc_1296 ( N_noxref_4_c_1240_p N_VDD_M72_noxref_s ) capacitor c=6.52457e-19 \
 //x=18.88 //y=5.38 //x2=17.425 //y2=5.2
cc_1297 ( N_noxref_4_c_1210_n N_VDD_M72_noxref_s ) capacitor c=0.0887533f \
 //x=18 //y=5.56 //x2=17.425 //y2=5.2
cc_1298 ( N_noxref_4_c_1199_n N_VDD_M73_noxref_d ) capacitor c=0.00734094f \
 //x=18.765 //y=5.38 //x2=18.295 //y2=5.2
cc_1299 ( N_noxref_4_c_1202_n N_VDD_M73_noxref_d ) capacitor c=0.0043528f \
 //x=18 //y=5.56 //x2=18.295 //y2=5.2
cc_1300 ( N_noxref_4_c_1377_p N_VDD_M73_noxref_d ) capacitor c=0.0043528f \
 //x=18.88 //y=5.56 //x2=18.295 //y2=5.2
cc_1301 ( N_noxref_4_c_1210_n N_VDD_M73_noxref_d ) capacitor c=0.065554f \
 //x=18 //y=5.56 //x2=18.295 //y2=5.2
cc_1302 ( N_noxref_4_c_1310_p N_VDD_M73_noxref_d ) capacitor c=0.065554f \
 //x=18.88 //y=5.56 //x2=18.295 //y2=5.2
cc_1303 ( N_noxref_4_c_1237_p N_VDD_M75_noxref_d ) capacitor c=0.00852734f \
 //x=19.275 //y=5.38 //x2=19.175 //y2=5.2
cc_1304 ( N_noxref_4_c_1377_p N_VDD_M75_noxref_d ) capacitor c=0.00955781f \
 //x=18.88 //y=5.56 //x2=19.175 //y2=5.2
cc_1305 ( N_noxref_4_c_1208_n N_VDD_M75_noxref_d ) capacitor c=0.00167175f \
 //x=19.36 //y=4.25 //x2=19.175 //y2=5.2
cc_1306 ( N_noxref_4_c_1310_p N_VDD_M75_noxref_d ) capacitor c=0.065554f \
 //x=18.88 //y=5.56 //x2=19.175 //y2=5.2
cc_1307 ( N_noxref_4_c_1237_p N_VDD_M76_noxref_s ) capacitor c=0.00220019f \
 //x=19.275 //y=5.38 //x2=21.055 //y2=5.2
cc_1308 ( N_noxref_4_c_1229_p N_VDD_M76_noxref_s ) capacitor c=9.73784e-19 \
 //x=21.21 //y=4.425 //x2=21.055 //y2=5.2
cc_1309 ( N_noxref_4_c_1222_p N_VDD_M76_noxref_s ) capacitor c=0.0217185f \
 //x=21.21 //y=4.755 //x2=21.055 //y2=5.2
cc_1310 ( N_noxref_4_c_1240_p N_VDD_M76_noxref_s ) capacitor c=0.00371125f \
 //x=18.88 //y=5.38 //x2=21.055 //y2=5.2
cc_1311 ( N_noxref_4_c_1377_p N_VDD_M76_noxref_s ) capacitor c=9.52042e-19 \
 //x=18.88 //y=5.56 //x2=21.055 //y2=5.2
cc_1312 ( N_noxref_4_c_1260_p N_VDD_M76_noxref_s ) capacitor c=0.00983846f \
 //x=21.21 //y=4.88 //x2=21.055 //y2=5.2
cc_1313 ( N_noxref_4_M76_noxref_g N_VDD_M76_noxref_s ) capacitor c=0.053419f \
 //x=21.41 //y=6.2 //x2=21.055 //y2=5.2
cc_1314 ( N_noxref_4_c_1252_p N_VDD_M76_noxref_s ) capacitor c=0.00597549f \
 //x=21.485 //y=4.97 //x2=21.055 //y2=5.2
cc_1315 ( N_noxref_4_M77_noxref_g N_VDD_M77_noxref_d ) capacitor c=0.015318f \
 //x=21.85 //y=6.2 //x2=21.925 //y2=5.2
cc_1316 ( N_noxref_4_c_1225_p N_noxref_26_M13_noxref_d ) capacitor \
 c=3.39394e-19 //x=18.92 //y=1.18 //x2=21.96 //y2=1.09
cc_1317 ( N_noxref_4_c_1320_p N_GND_c_14017_n ) capacitor c=0.00608539f \
 //x=19.275 //y=1.835 //x2=21.09 //y2=0.175
cc_1318 ( N_noxref_4_c_1227_p N_GND_c_14017_n ) capacitor c=2.3239e-19 \
 //x=19.36 //y=4.425 //x2=21.09 //y2=0.175
cc_1319 ( N_noxref_4_c_1225_p N_GND_c_14017_n ) capacitor c=0.00928865f \
 //x=18.92 //y=1.18 //x2=21.09 //y2=0.175
cc_1320 ( N_noxref_4_M11_noxref_d N_GND_c_14017_n ) capacitor c=3.01769e-19 \
 //x=18.73 //y=1.085 //x2=21.09 //y2=0.175
cc_1321 ( N_noxref_4_c_1288_p N_GND_c_14021_n ) capacitor c=3.92414e-19 \
 //x=20.91 //y=1.055 //x2=21.175 //y2=1.015
cc_1322 ( N_noxref_4_c_1435_p N_GND_c_14021_n ) capacitor c=0.0085115f \
 //x=21.285 //y=0.9 //x2=21.175 //y2=1.015
cc_1323 ( N_noxref_4_c_1290_p N_GND_c_14021_n ) capacitor c=4.45447e-19 \
 //x=21.44 //y=1.055 //x2=21.175 //y2=1.015
cc_1324 ( N_noxref_4_c_1202_n N_GND_c_13985_n ) capacitor c=6.93965e-19 //x=18 \
 //y=5.56 //x2=17.95 //y2=1.135
cc_1325 ( N_noxref_4_c_1225_p N_GND_c_13985_n ) capacitor c=0.0140087f \
 //x=18.92 //y=1.18 //x2=17.95 //y2=1.135
cc_1326 ( N_noxref_4_M11_noxref_d N_GND_c_13985_n ) capacitor c=2.93544e-19 \
 //x=18.73 //y=1.085 //x2=17.95 //y2=1.135
cc_1327 ( N_noxref_4_c_1261_p N_GND_c_14027_n ) capacitor c=0.00772482f \
 //x=21.21 //y=2.375 //x2=21.175 //y2=1.145
cc_1328 ( N_noxref_4_c_1229_p N_GND_c_14027_n ) capacitor c=5.82923e-19 \
 //x=21.21 //y=4.425 //x2=21.175 //y2=1.145
cc_1329 ( N_noxref_4_c_1225_p N_GND_c_14027_n ) capacitor c=0.00606355f \
 //x=18.92 //y=1.18 //x2=21.175 //y2=1.145
cc_1330 ( N_noxref_4_c_1263_p N_GND_c_14027_n ) capacitor c=2.22883e-19 \
 //x=21.21 //y=2.26 //x2=21.175 //y2=1.145
cc_1331 ( N_noxref_4_c_1288_p N_GND_c_14027_n ) capacitor c=0.0015128f \
 //x=20.91 //y=1.055 //x2=21.175 //y2=1.145
cc_1332 ( N_noxref_4_c_1289_p N_GND_c_14027_n ) capacitor c=0.00350108f \
 //x=20.91 //y=1.4 //x2=21.175 //y2=1.145
cc_1333 ( N_noxref_4_c_1291_p N_GND_c_14027_n ) capacitor c=4.52105e-19 \
 //x=20.91 //y=1.71 //x2=21.175 //y2=1.145
cc_1334 ( N_noxref_4_c_1435_p N_GND_c_14027_n ) capacitor c=9.36995e-19 \
 //x=21.285 //y=0.9 //x2=21.175 //y2=1.145
cc_1335 ( N_noxref_4_c_1448_p N_GND_c_14027_n ) capacitor c=6.09966e-19 \
 //x=21.285 //y=1.555 //x2=21.175 //y2=1.145
cc_1336 ( N_noxref_4_c_1290_p N_GND_c_14027_n ) capacitor c=0.0017438f \
 //x=21.44 //y=1.055 //x2=21.175 //y2=1.145
cc_1337 ( N_noxref_4_c_1292_p N_GND_c_14027_n ) capacitor c=0.00276804f \
 //x=21.44 //y=1.4 //x2=21.175 //y2=1.145
cc_1338 ( N_noxref_4_c_1320_p N_GND_c_13999_n ) capacitor c=7.77585e-19 \
 //x=19.275 //y=1.835 //x2=19.93 //y2=0.175
cc_1339 ( N_noxref_4_c_1288_p N_GND_c_14039_n ) capacitor c=0.00677766f \
 //x=20.91 //y=1.055 //x2=24.74 //y2=0.175
cc_1340 ( N_noxref_4_c_1200_n N_GND_c_13971_n ) capacitor c=9.32616e-19 \
 //x=19.36 //y=4.105 //x2=16.77 //y2=0.175
cc_1341 ( N_noxref_4_c_1216_p N_GND_c_14041_n ) capacitor c=0.00460657f \
 //x=18.92 //y=1.75 //x2=20.1 //y2=0.175
cc_1342 ( N_noxref_4_c_1320_p N_GND_c_14041_n ) capacitor c=0.0300371f \
 //x=19.275 //y=1.835 //x2=20.1 //y2=0.175
cc_1343 ( N_noxref_4_c_1261_p N_GND_c_14041_n ) capacitor c=0.00361632f \
 //x=21.21 //y=2.375 //x2=20.1 //y2=0.175
cc_1344 ( N_noxref_4_c_1221_p N_GND_c_14041_n ) capacitor c=0.0107391f \
 //x=21.21 //y=4.105 //x2=20.1 //y2=0.175
cc_1345 ( N_noxref_4_c_1263_p N_GND_c_14041_n ) capacitor c=0.00379568f \
 //x=21.21 //y=2.26 //x2=20.1 //y2=0.175
cc_1346 ( N_noxref_4_c_1291_p N_GND_c_14041_n ) capacitor c=0.00170145f \
 //x=20.91 //y=1.71 //x2=20.1 //y2=0.175
cc_1347 ( N_noxref_4_c_1264_p N_GND_c_14041_n ) capacitor c=0.0102191f \
 //x=20.91 //y=2.095 //x2=20.1 //y2=0.175
cc_1348 ( N_noxref_4_c_1225_p N_GND_M10_noxref_d ) capacitor c=2.82748e-19 \
 //x=18.92 //y=1.18 //x2=17.76 //y2=1.045
cc_1349 ( N_noxref_4_c_1261_p N_GND_M12_noxref_d ) capacitor c=4.4417e-19 \
 //x=21.21 //y=2.375 //x2=20.985 //y2=1.055
cc_1350 ( N_noxref_4_c_1288_p N_GND_M12_noxref_d ) capacitor c=0.00184354f \
 //x=20.91 //y=1.055 //x2=20.985 //y2=1.055
cc_1351 ( N_noxref_4_c_1289_p N_GND_M12_noxref_d ) capacitor c=0.00210798f \
 //x=20.91 //y=1.4 //x2=20.985 //y2=1.055
cc_1352 ( N_noxref_4_c_1435_p N_GND_M12_noxref_d ) capacitor c=0.00474029f \
 //x=21.285 //y=0.9 //x2=20.985 //y2=1.055
cc_1353 ( N_noxref_4_c_1448_p N_GND_M12_noxref_d ) capacitor c=0.00166857f \
 //x=21.285 //y=1.555 //x2=20.985 //y2=1.055
cc_1354 ( N_noxref_4_c_1290_p N_GND_M12_noxref_d ) capacitor c=0.00230174f \
 //x=21.44 //y=1.055 //x2=20.985 //y2=1.055
cc_1355 ( N_noxref_4_c_1292_p N_GND_M12_noxref_d ) capacitor c=0.00210798f \
 //x=21.44 //y=1.4 //x2=20.985 //y2=1.055
cc_1356 ( N_noxref_4_c_1218_p N_noxref_41_c_15851_n ) capacitor c=0.00911498f \
 //x=19.005 //y=1.835 //x2=18.435 //y2=1.675
cc_1357 ( N_noxref_4_c_1320_p N_noxref_41_c_15856_n ) capacitor c=0.00399245f \
 //x=19.275 //y=1.835 //x2=19.32 //y2=0.71
cc_1358 ( N_noxref_4_c_1225_p N_noxref_41_c_15856_n ) capacitor c=0.003751f \
 //x=18.92 //y=1.18 //x2=19.32 //y2=0.71
cc_1359 ( N_noxref_4_M11_noxref_d N_noxref_41_c_15856_n ) capacitor \
 c=0.00910163f //x=18.73 //y=1.085 //x2=19.32 //y2=0.71
cc_1360 ( N_noxref_4_c_1216_p N_noxref_41_M10_noxref_s ) capacitor \
 c=0.0175047f //x=18.92 //y=1.75 //x2=17.33 //y2=0.545
cc_1361 ( N_noxref_4_c_1320_p N_noxref_41_M10_noxref_s ) capacitor \
 c=0.00692219f //x=19.275 //y=1.835 //x2=17.33 //y2=0.545
cc_1362 ( N_noxref_4_c_1227_p N_noxref_41_M10_noxref_s ) capacitor \
 c=2.52049e-19 //x=19.36 //y=4.425 //x2=17.33 //y2=0.545
cc_1363 ( N_noxref_4_c_1225_p N_noxref_41_M10_noxref_s ) capacitor \
 c=0.00894261f //x=18.92 //y=1.18 //x2=17.33 //y2=0.545
cc_1364 ( N_noxref_4_c_1208_n N_noxref_41_M10_noxref_s ) capacitor \
 c=7.05305e-19 //x=19.36 //y=4.25 //x2=17.33 //y2=0.545
cc_1365 ( N_noxref_4_M11_noxref_d N_noxref_41_M10_noxref_s ) capacitor \
 c=0.0275552f //x=18.73 //y=1.085 //x2=17.33 //y2=0.545
cc_1366 ( N_noxref_4_c_1264_p N_noxref_42_c_15912_n ) capacitor c=0.00262672f \
 //x=20.91 //y=2.095 //x2=20.69 //y2=1.685
cc_1367 ( N_noxref_4_c_1261_p N_noxref_42_c_15913_n ) capacitor c=0.00428451f \
 //x=21.21 //y=2.375 //x2=21.575 //y2=1.77
cc_1368 ( N_noxref_4_c_1229_p N_noxref_42_c_15913_n ) capacitor c=0.00173893f \
 //x=21.21 //y=4.425 //x2=21.575 //y2=1.77
cc_1369 ( N_noxref_4_c_1263_p N_noxref_42_c_15913_n ) capacitor c=0.0104666f \
 //x=21.21 //y=2.26 //x2=21.575 //y2=1.77
cc_1370 ( N_noxref_4_c_1291_p N_noxref_42_c_15913_n ) capacitor c=0.00705077f \
 //x=20.91 //y=1.71 //x2=21.575 //y2=1.77
cc_1371 ( N_noxref_4_c_1264_p N_noxref_42_c_15913_n ) capacitor c=0.020708f \
 //x=20.91 //y=2.095 //x2=21.575 //y2=1.77
cc_1372 ( N_noxref_4_c_1448_p N_noxref_42_c_15913_n ) capacitor c=0.00588627f \
 //x=21.285 //y=1.555 //x2=21.575 //y2=1.77
cc_1373 ( N_noxref_4_c_1292_p N_noxref_42_c_15913_n ) capacitor c=0.00698822f \
 //x=21.44 //y=1.4 //x2=21.575 //y2=1.77
cc_1374 ( N_noxref_4_c_1288_p N_noxref_42_M12_noxref_s ) capacitor \
 c=0.0295256f //x=20.91 //y=1.055 //x2=20.555 //y2=0.555
cc_1375 ( N_noxref_4_c_1291_p N_noxref_42_M12_noxref_s ) capacitor \
 c=7.99997e-19 //x=20.91 //y=1.71 //x2=20.555 //y2=0.555
cc_1376 ( N_noxref_4_c_1264_p N_noxref_42_M12_noxref_s ) capacitor \
 c=0.00122123f //x=20.91 //y=2.095 //x2=20.555 //y2=0.555
cc_1377 ( N_noxref_4_c_1290_p N_noxref_42_M12_noxref_s ) capacitor \
 c=0.0125924f //x=21.44 //y=1.055 //x2=20.555 //y2=0.555
cc_1378 ( N_noxref_5_c_1670_n D ) capacitor c=0.00150024f //x=23.43 //y=3.725 \
 //x2=26.02 //y2=2.77
cc_1379 ( N_noxref_5_c_1670_n D ) capacitor c=7.18759e-19 //x=23.43 //y=3.725 \
 //x2=26.02 //y2=3.88
cc_1380 ( N_noxref_5_c_1671_n D ) capacitor c=0.001485f //x=23.43 //y=4.75 \
 //x2=26.02 //y2=3.88
cc_1381 ( N_noxref_5_c_1492_n N_D_c_4957_n ) capacitor c=0.0241843f //x=7.15 \
 //y=3.705 //x2=9.355 //y2=3.14
cc_1382 ( N_noxref_5_c_1585_n N_D_c_4957_n ) capacitor c=0.00341036f //x=7.15 \
 //y=4.025 //x2=9.355 //y2=3.14
cc_1383 ( N_noxref_5_c_1502_n N_D_c_4957_n ) capacitor c=0.0386303f //x=7.5 \
 //y=3.88 //x2=9.355 //y2=3.14
cc_1384 ( N_noxref_5_c_1503_n N_D_c_4957_n ) capacitor c=0.08631f //x=12.12 \
 //y=3.88 //x2=9.355 //y2=3.14
cc_1385 ( N_noxref_5_c_1621_n N_D_c_4957_n ) capacitor c=0.0161282f //x=7.315 \
 //y=3.865 //x2=9.355 //y2=3.14
cc_1386 ( N_noxref_5_c_1503_n N_D_c_4961_n ) capacitor c=0.0756779f //x=12.12 \
 //y=3.88 //x2=9.955 //y2=3.16
cc_1387 ( N_noxref_5_c_1499_n N_D_c_4973_n ) capacitor c=0.0273365f //x=11.96 \
 //y=3.705 //x2=12.315 //y2=3.14
cc_1388 ( N_noxref_5_c_1513_n N_D_c_4973_n ) capacitor c=0.00363666f //x=11.96 \
 //y=4.025 //x2=12.315 //y2=3.14
cc_1389 ( N_noxref_5_c_1503_n N_D_c_4973_n ) capacitor c=0.0161264f //x=12.12 \
 //y=3.88 //x2=12.315 //y2=3.14
cc_1390 ( N_noxref_5_c_1540_n N_D_c_4973_n ) capacitor c=0.0404172f //x=15.865 \
 //y=3.865 //x2=12.315 //y2=3.14
cc_1391 ( N_noxref_5_c_1540_n N_D_c_4976_n ) capacitor c=0.0569843f //x=15.865 \
 //y=3.865 //x2=12.915 //y2=3.17
cc_1392 ( N_noxref_5_c_1540_n N_D_c_4980_n ) capacitor c=0.0278343f //x=15.865 \
 //y=3.865 //x2=14.16 //y2=3.14
cc_1393 ( N_noxref_5_c_1540_n N_D_c_4985_n ) capacitor c=0.0415894f //x=15.865 \
 //y=3.865 //x2=14.76 //y2=3.17
cc_1394 ( N_noxref_5_c_1524_n N_D_c_5018_n ) capacitor c=0.0280753f //x=16.03 \
 //y=3.705 //x2=18.235 //y2=3.14
cc_1395 ( N_noxref_5_c_1604_n N_D_c_5018_n ) capacitor c=0.00367965f //x=16.03 \
 //y=4.025 //x2=18.235 //y2=3.14
cc_1396 ( N_noxref_5_c_1624_n N_D_c_5018_n ) capacitor c=0.01611f //x=16.185 \
 //y=3.865 //x2=18.235 //y2=3.14
cc_1397 ( N_noxref_5_c_1626_n N_D_c_5018_n ) capacitor c=0.102608f //x=23.27 \
 //y=3.885 //x2=18.235 //y2=3.14
cc_1398 ( N_noxref_5_c_1670_n N_D_c_5046_n ) capacitor c=0.0246231f //x=23.43 \
 //y=3.725 //x2=27.37 //y2=3.155
cc_1399 ( N_noxref_5_c_1626_n N_D_c_5046_n ) capacitor c=0.0329697f //x=23.27 \
 //y=3.885 //x2=27.37 //y2=3.155
cc_1400 ( N_noxref_5_c_1492_n CLK ) capacitor c=0.0346539f //x=7.15 //y=3.705 \
 //x2=6.04 //y2=2.4
cc_1401 ( N_noxref_5_c_1585_n CLK ) capacitor c=0.00776638f //x=7.15 //y=4.025 \
 //x2=6.04 //y2=2.4
cc_1402 ( N_noxref_5_c_1497_n CLK ) capacitor c=0.0126059f //x=7.15 //y=4.75 \
 //x2=6.04 //y2=2.4
cc_1403 ( N_noxref_5_c_1612_n CLK ) capacitor c=5.01652e-19 //x=7.15 //y=3.88 \
 //x2=6.04 //y2=2.4
cc_1404 ( N_noxref_5_c_1621_n CLK ) capacitor c=0.00512566f //x=7.315 \
 //y=3.865 //x2=6.04 //y2=2.4
cc_1405 ( N_noxref_5_c_1630_n CLK ) capacitor c=4.16726e-19 //x=7.15 //y=2.26 \
 //x2=6.04 //y2=2.4
cc_1406 ( N_noxref_5_c_1524_n CLK ) capacitor c=0.0542447f //x=16.03 //y=3.705 \
 //x2=15.29 //y2=2.77
cc_1407 ( N_noxref_5_c_1604_n CLK ) capacitor c=0.0176724f //x=16.03 //y=4.025 \
 //x2=15.29 //y2=2.77
cc_1408 ( N_noxref_5_c_1527_n CLK ) capacitor c=0.0215525f //x=16.03 //y=5.295 \
 //x2=15.29 //y2=2.77
cc_1409 ( N_noxref_5_c_1713_p CLK ) capacitor c=9.19401e-19 //x=16.03 //y=3.88 \
 //x2=15.29 //y2=2.77
cc_1410 ( N_noxref_5_c_1540_n CLK ) capacitor c=0.0222087f //x=15.865 \
 //y=3.865 //x2=15.29 //y2=2.77
cc_1411 ( N_noxref_5_c_1624_n CLK ) capacitor c=0.00338457f //x=16.185 \
 //y=3.865 //x2=15.29 //y2=2.77
cc_1412 ( N_noxref_5_c_1491_n N_CLK_c_6294_n ) capacitor c=0.0116288f //x=7.15 \
 //y=2.375 //x2=6.04 //y2=2.375
cc_1413 ( N_noxref_5_c_1630_n N_CLK_c_6294_n ) capacitor c=5.42289e-19 \
 //x=7.15 //y=2.26 //x2=6.04 //y2=2.375
cc_1414 ( N_noxref_5_c_1659_n N_CLK_c_6294_n ) capacitor c=0.00139071f \
 //x=7.15 //y=2.26 //x2=6.04 //y2=2.375
cc_1415 ( N_noxref_5_c_1497_n N_CLK_c_6298_n ) capacitor c=0.0109762f //x=7.15 \
 //y=4.75 //x2=6.04 //y2=4.755
cc_1416 ( N_noxref_5_c_1631_n N_CLK_c_6298_n ) capacitor c=9.62855e-19 \
 //x=7.15 //y=4.88 //x2=6.04 //y2=4.755
cc_1417 ( N_noxref_5_c_1662_n N_CLK_c_6298_n ) capacitor c=0.00135081f \
 //x=7.15 //y=4.88 //x2=6.04 //y2=4.755
cc_1418 ( N_noxref_5_c_1524_n N_CLK_c_6337_n ) capacitor c=0.0138368f \
 //x=16.03 //y=3.705 //x2=15.29 //y2=2.26
cc_1419 ( N_noxref_5_c_1521_n N_CLK_c_6340_n ) capacitor c=0.0233476f \
 //x=15.435 //y=5.38 //x2=15.325 //y2=4.75
cc_1420 ( N_noxref_5_c_1527_n N_CLK_c_6340_n ) capacitor c=0.0216149f \
 //x=16.03 //y=5.295 //x2=15.325 //y2=4.75
cc_1421 ( N_noxref_5_c_1672_n N_CLK_c_6340_n ) capacitor c=0.00285789f \
 //x=15.55 //y=5.38 //x2=15.325 //y2=4.75
cc_1422 ( N_noxref_5_c_1726_p N_CLK_c_6340_n ) capacitor c=7.41644e-19 \
 //x=15.55 //y=5.56 //x2=15.325 //y2=4.75
cc_1423 ( N_noxref_5_c_1497_n N_CLK_c_6387_n ) capacitor c=0.0287277f //x=7.15 \
 //y=4.75 //x2=7.5 //y2=4.62
cc_1424 ( N_noxref_5_c_1502_n N_CLK_c_6387_n ) capacitor c=0.00295994f //x=7.5 \
 //y=3.88 //x2=7.5 //y2=4.62
cc_1425 ( N_noxref_5_c_1615_n N_CLK_c_6393_n ) capacitor c=0.0012014f //x=8.1 \
 //y=3.865 //x2=8.1 //y2=4.635
cc_1426 ( N_noxref_5_c_1626_n N_CLK_c_6396_n ) capacitor c=0.0411331f \
 //x=23.27 //y=3.885 //x2=18.095 //y2=4.65
cc_1427 ( N_noxref_5_c_1501_n N_CLK_c_6302_n ) capacitor c=0.0287127f \
 //x=11.96 //y=4.75 //x2=17.75 //y2=4.65
cc_1428 ( N_noxref_5_c_1521_n N_CLK_c_6302_n ) capacitor c=9.84751e-19 \
 //x=15.435 //y=5.38 //x2=17.75 //y2=4.65
cc_1429 ( N_noxref_5_c_1527_n N_CLK_c_6302_n ) capacitor c=0.0329011f \
 //x=16.03 //y=5.295 //x2=17.75 //y2=4.65
cc_1430 ( N_noxref_5_c_1530_n N_CLK_c_6302_n ) capacitor c=0.0211459f \
 //x=14.67 //y=5.56 //x2=17.75 //y2=4.65
cc_1431 ( N_noxref_5_c_1672_n N_CLK_c_6302_n ) capacitor c=0.0191541f \
 //x=15.55 //y=5.38 //x2=17.75 //y2=4.65
cc_1432 ( N_noxref_5_c_1503_n N_CLK_c_6302_n ) capacitor c=0.0225931f \
 //x=12.12 //y=3.88 //x2=17.75 //y2=4.65
cc_1433 ( N_noxref_5_c_1540_n N_CLK_c_6302_n ) capacitor c=0.0218372f \
 //x=15.865 //y=3.865 //x2=17.75 //y2=4.65
cc_1434 ( N_noxref_5_c_1626_n N_CLK_c_6302_n ) capacitor c=0.0162723f \
 //x=23.27 //y=3.885 //x2=17.75 //y2=4.65
cc_1435 ( N_noxref_5_c_1626_n N_CLK_c_6421_n ) capacitor c=0.0089349f \
 //x=23.27 //y=3.885 //x2=18.975 //y2=4.62
cc_1436 ( N_noxref_5_c_1626_n N_CLK_c_6426_n ) capacitor c=0.00618767f \
 //x=23.27 //y=3.885 //x2=19.575 //y2=4.65
cc_1437 ( N_noxref_5_c_1626_n N_CLK_c_6429_n ) capacitor c=0.0091109f \
 //x=23.27 //y=3.885 //x2=20.825 //y2=4.62
cc_1438 ( N_noxref_5_c_1626_n N_CLK_c_6434_n ) capacitor c=0.0807399f \
 //x=23.27 //y=3.885 //x2=21.425 //y2=4.65
cc_1439 ( N_noxref_5_c_1743_p N_CLK_c_6476_n ) capacitor c=0.00308009f \
 //x=23.43 //y=4.045 //x2=26.375 //y2=4.62
cc_1440 ( N_noxref_5_c_1671_n N_CLK_c_6476_n ) capacitor c=0.0308672f \
 //x=23.43 //y=4.75 //x2=26.375 //y2=4.62
cc_1441 ( N_noxref_5_c_1745_p N_CLK_c_6476_n ) capacitor c=0.015896f //x=23.43 \
 //y=3.885 //x2=26.375 //y2=4.62
cc_1442 ( N_noxref_5_c_1497_n N_CLK_c_6303_n ) capacitor c=0.00462738f \
 //x=7.15 //y=4.75 //x2=6.04 //y2=4.62
cc_1443 ( N_noxref_5_c_1491_n N_CLK_c_6304_n ) capacitor c=5.39999e-19 \
 //x=7.15 //y=2.375 //x2=6.04 //y2=2.26
cc_1444 ( N_noxref_5_c_1492_n N_CLK_c_6304_n ) capacitor c=4.16726e-19 \
 //x=7.15 //y=3.705 //x2=6.04 //y2=2.26
cc_1445 ( N_noxref_5_c_1630_n N_CLK_c_6304_n ) capacitor c=0.00125213f \
 //x=7.15 //y=2.26 //x2=6.04 //y2=2.26
cc_1446 ( N_noxref_5_c_1659_n N_CLK_c_6304_n ) capacitor c=0.00204868f \
 //x=7.15 //y=2.26 //x2=6.04 //y2=2.26
cc_1447 ( N_noxref_5_c_1497_n N_CLK_c_6308_n ) capacitor c=4.56604e-19 \
 //x=7.15 //y=4.75 //x2=6.04 //y2=4.88
cc_1448 ( N_noxref_5_c_1631_n N_CLK_c_6308_n ) capacitor c=0.00113668f \
 //x=7.15 //y=4.88 //x2=6.04 //y2=4.88
cc_1449 ( N_noxref_5_c_1662_n N_CLK_c_6308_n ) capacitor c=0.00186974f \
 //x=7.15 //y=4.88 //x2=6.04 //y2=4.88
cc_1450 ( N_noxref_5_c_1524_n N_CLK_c_6350_n ) capacitor c=9.26054e-19 \
 //x=16.03 //y=3.705 //x2=15.29 //y2=2.26
cc_1451 ( N_noxref_5_c_1521_n N_CLK_c_6354_n ) capacitor c=0.00469232f \
 //x=15.435 //y=5.38 //x2=15.32 //y2=4.88
cc_1452 ( N_noxref_5_c_1527_n N_CLK_c_6354_n ) capacitor c=5.14671e-19 \
 //x=16.03 //y=5.295 //x2=15.32 //y2=4.88
cc_1453 ( N_noxref_5_M60_noxref_g N_CLK_M58_noxref_g ) capacitor c=0.0101598f \
 //x=6.89 //y=6.2 //x2=6.01 //y2=6.2
cc_1454 ( N_noxref_5_M60_noxref_g N_CLK_M59_noxref_g ) capacitor c=0.0607518f \
 //x=6.89 //y=6.2 //x2=6.45 //y2=6.2
cc_1455 ( N_noxref_5_M61_noxref_g N_CLK_M59_noxref_g ) capacitor c=0.0101598f \
 //x=7.33 //y=6.2 //x2=6.45 //y2=6.2
cc_1456 ( N_noxref_5_c_1521_n N_CLK_M70_noxref_g ) capacitor c=0.00842852f \
 //x=15.435 //y=5.38 //x2=15.33 //y2=6.2
cc_1457 ( N_noxref_5_c_1672_n N_CLK_M70_noxref_g ) capacitor c=0.00192712f \
 //x=15.55 //y=5.38 //x2=15.33 //y2=6.2
cc_1458 ( N_noxref_5_c_1726_p N_CLK_M70_noxref_g ) capacitor c=0.0178987f \
 //x=15.55 //y=5.56 //x2=15.33 //y2=6.2
cc_1459 ( N_noxref_5_c_1666_n N_CLK_M71_noxref_g ) capacitor c=0.0106973f \
 //x=15.945 //y=5.38 //x2=15.77 //y2=6.2
cc_1460 ( N_noxref_5_c_1672_n N_CLK_M71_noxref_g ) capacitor c=0.00298276f \
 //x=15.55 //y=5.38 //x2=15.77 //y2=6.2
cc_1461 ( N_noxref_5_c_1726_p N_CLK_M71_noxref_g ) capacitor c=0.0178506f \
 //x=15.55 //y=5.56 //x2=15.77 //y2=6.2
cc_1462 ( N_noxref_5_c_1641_n N_CLK_c_6320_n ) capacitor c=0.00456962f \
 //x=7.14 //y=1.095 //x2=6.13 //y2=1.09
cc_1463 ( N_noxref_5_c_1643_n N_CLK_c_6321_n ) capacitor c=0.00438372f \
 //x=7.14 //y=1.44 //x2=6.13 //y2=1.4
cc_1464 ( N_noxref_5_c_1646_n N_CLK_c_6322_n ) capacitor c=0.00438372f \
 //x=7.14 //y=1.75 //x2=6.13 //y2=1.63
cc_1465 ( N_noxref_5_c_1491_n N_CLK_c_6323_n ) capacitor c=0.00141236f \
 //x=7.15 //y=2.375 //x2=6.13 //y2=2.095
cc_1466 ( N_noxref_5_c_1630_n N_CLK_c_6323_n ) capacitor c=0.00209664f \
 //x=7.15 //y=2.26 //x2=6.13 //y2=2.095
cc_1467 ( N_noxref_5_c_1659_n N_CLK_c_6323_n ) capacitor c=0.00933826f \
 //x=7.15 //y=2.26 //x2=6.13 //y2=2.095
cc_1468 ( N_noxref_5_c_1660_n N_CLK_c_6323_n ) capacitor c=0.00438372f \
 //x=7.15 //y=2.095 //x2=6.13 //y2=2.095
cc_1469 ( N_noxref_5_c_1662_n N_CLK_c_6416_n ) capacitor c=0.0616777f //x=7.15 \
 //y=4.88 //x2=6.375 //y2=4.97
cc_1470 ( N_noxref_5_c_1538_n N_CLK_c_6360_n ) capacitor c=0.00120406f \
 //x=15.59 //y=1.18 //x2=15.325 //y2=1.085
cc_1471 ( N_noxref_5_M9_noxref_d N_CLK_c_6360_n ) capacitor c=0.00137165f \
 //x=15.4 //y=1.085 //x2=15.325 //y2=1.085
cc_1472 ( N_noxref_5_c_1522_n N_CLK_c_6363_n ) capacitor c=0.00119302f \
 //x=15.59 //y=1.75 //x2=15.325 //y2=1.43
cc_1473 ( N_noxref_5_c_1538_n N_CLK_c_6363_n ) capacitor c=0.00218772f \
 //x=15.59 //y=1.18 //x2=15.325 //y2=1.43
cc_1474 ( N_noxref_5_M9_noxref_d N_CLK_c_6363_n ) capacitor c=0.00237422f \
 //x=15.4 //y=1.085 //x2=15.325 //y2=1.43
cc_1475 ( N_noxref_5_c_1522_n N_CLK_c_6365_n ) capacitor c=0.00439215f \
 //x=15.59 //y=1.75 //x2=15.325 //y2=1.74
cc_1476 ( N_noxref_5_c_1604_n N_CLK_c_6513_n ) capacitor c=0.00127572f \
 //x=16.03 //y=4.025 //x2=15.695 //y2=4.97
cc_1477 ( N_noxref_5_c_1527_n N_CLK_c_6513_n ) capacitor c=0.00844995f \
 //x=16.03 //y=5.295 //x2=15.695 //y2=4.97
cc_1478 ( N_noxref_5_c_1672_n N_CLK_c_6513_n ) capacitor c=0.0020909f \
 //x=15.55 //y=5.38 //x2=15.695 //y2=4.97
cc_1479 ( N_noxref_5_c_1726_p N_CLK_c_6513_n ) capacitor c=0.00291714f \
 //x=15.55 //y=5.56 //x2=15.695 //y2=4.97
cc_1480 ( N_noxref_5_c_1538_n N_CLK_c_6517_n ) capacitor c=5.50523e-19 \
 //x=15.59 //y=1.18 //x2=15.7 //y2=0.93
cc_1481 ( N_noxref_5_M9_noxref_d N_CLK_c_6517_n ) capacitor c=0.0020782f \
 //x=15.4 //y=1.085 //x2=15.7 //y2=0.93
cc_1482 ( N_noxref_5_c_1522_n N_CLK_c_6519_n ) capacitor c=0.00917366f \
 //x=15.59 //y=1.75 //x2=15.7 //y2=1.585
cc_1483 ( N_noxref_5_c_1667_n N_CLK_c_6519_n ) capacitor c=0.00194324f \
 //x=15.945 //y=1.835 //x2=15.7 //y2=1.585
cc_1484 ( N_noxref_5_c_1538_n N_CLK_c_6519_n ) capacitor c=5.64626e-19 \
 //x=15.59 //y=1.18 //x2=15.7 //y2=1.585
cc_1485 ( N_noxref_5_M9_noxref_d N_CLK_c_6519_n ) capacitor c=0.00356097f \
 //x=15.4 //y=1.085 //x2=15.7 //y2=1.585
cc_1486 ( N_noxref_5_c_1538_n N_CLK_c_6368_n ) capacitor c=0.00109205f \
 //x=15.59 //y=1.18 //x2=15.855 //y2=1.085
cc_1487 ( N_noxref_5_M9_noxref_d N_CLK_c_6368_n ) capacitor c=8.50095e-19 \
 //x=15.4 //y=1.085 //x2=15.855 //y2=1.085
cc_1488 ( N_noxref_5_c_1522_n N_CLK_c_6369_n ) capacitor c=0.003249f //x=15.59 \
 //y=1.75 //x2=15.855 //y2=1.43
cc_1489 ( N_noxref_5_c_1667_n N_CLK_c_6369_n ) capacitor c=0.00323005f \
 //x=15.945 //y=1.835 //x2=15.855 //y2=1.43
cc_1490 ( N_noxref_5_c_1538_n N_CLK_c_6369_n ) capacitor c=0.00317092f \
 //x=15.59 //y=1.18 //x2=15.855 //y2=1.43
cc_1491 ( N_noxref_5_M9_noxref_d N_CLK_c_6369_n ) capacitor c=0.00237422f \
 //x=15.4 //y=1.085 //x2=15.855 //y2=1.43
cc_1492 ( N_noxref_5_c_1631_n N_CLK_c_6326_n ) capacitor c=9.77556e-19 \
 //x=7.15 //y=4.88 //x2=6.04 //y2=4.88
cc_1493 ( N_noxref_5_c_1662_n N_CLK_c_6326_n ) capacitor c=0.0042693f //x=7.15 \
 //y=4.88 //x2=6.04 //y2=4.88
cc_1494 ( N_noxref_5_c_1524_n N_CLK_c_6370_n ) capacitor c=0.00268898f \
 //x=16.03 //y=3.705 //x2=15.29 //y2=2.26
cc_1495 ( N_noxref_5_c_1522_n N_CLK_c_6532_n ) capacitor c=0.00341688f \
 //x=15.59 //y=1.75 //x2=15.29 //y2=2.095
cc_1496 ( N_noxref_5_c_1524_n N_CLK_c_6532_n ) capacitor c=0.00309058f \
 //x=16.03 //y=3.705 //x2=15.29 //y2=2.095
cc_1497 ( N_noxref_5_c_1521_n N_CLK_c_6373_n ) capacitor c=7.94507e-19 \
 //x=15.435 //y=5.38 //x2=15.32 //y2=4.88
cc_1498 ( N_noxref_5_c_1499_n SN ) capacitor c=0.0323029f //x=11.96 //y=3.705 \
 //x2=10.85 //y2=2.77
cc_1499 ( N_noxref_5_c_1513_n SN ) capacitor c=0.0078001f //x=11.96 //y=4.025 \
 //x2=10.85 //y2=2.77
cc_1500 ( N_noxref_5_c_1501_n SN ) capacitor c=0.0158815f //x=11.96 //y=4.75 \
 //x2=10.85 //y2=2.77
cc_1501 ( N_noxref_5_c_1529_n SN ) capacitor c=5.01652e-19 //x=11.96 //y=3.88 \
 //x2=10.85 //y2=2.77
cc_1502 ( N_noxref_5_c_1503_n SN ) capacitor c=0.0280688f //x=12.12 //y=3.88 \
 //x2=10.85 //y2=2.77
cc_1503 ( N_noxref_5_c_1544_n SN ) capacitor c=2.94497e-19 //x=11.96 //y=4.88 \
 //x2=10.85 //y2=2.77
cc_1504 ( N_noxref_5_c_1670_n SN ) capacitor c=0.0294492f //x=23.43 //y=3.725 \
 //x2=22.32 //y2=2.77
cc_1505 ( N_noxref_5_c_1743_p SN ) capacitor c=0.00772613f //x=23.43 //y=4.045 \
 //x2=22.32 //y2=2.77
cc_1506 ( N_noxref_5_c_1671_n SN ) capacitor c=0.0179679f //x=23.43 //y=4.75 \
 //x2=22.32 //y2=2.77
cc_1507 ( N_noxref_5_c_1811_p SN ) capacitor c=3.43503e-19 //x=23.43 //y=3.88 \
 //x2=22.32 //y2=2.77
cc_1508 ( N_noxref_5_c_1745_p SN ) capacitor c=0.00242466f //x=23.43 //y=3.885 \
 //x2=22.32 //y2=2.77
cc_1509 ( N_noxref_5_c_1626_n SN ) capacitor c=0.0255807f //x=23.27 //y=3.885 \
 //x2=22.32 //y2=2.77
cc_1510 ( N_noxref_5_c_1814_p SN ) capacitor c=2.94497e-19 //x=23.43 //y=4.88 \
 //x2=22.32 //y2=2.77
cc_1511 ( N_noxref_5_c_1505_n N_SN_c_8051_n ) capacitor c=0.00790562f \
 //x=11.96 //y=2.375 //x2=10.85 //y2=2.55
cc_1512 ( N_noxref_5_c_1499_n N_SN_c_8051_n ) capacitor c=0.00339731f \
 //x=11.96 //y=3.705 //x2=10.85 //y2=2.55
cc_1513 ( N_noxref_5_c_1543_n N_SN_c_8051_n ) capacitor c=0.00116634f \
 //x=11.96 //y=2.26 //x2=10.85 //y2=2.55
cc_1514 ( N_noxref_5_c_1577_n N_SN_c_8051_n ) capacitor c=0.00149114f \
 //x=11.96 //y=2.26 //x2=10.85 //y2=2.55
cc_1515 ( N_noxref_5_c_1501_n N_SN_c_8055_n ) capacitor c=0.0107551f //x=11.96 \
 //y=4.75 //x2=10.85 //y2=4.765
cc_1516 ( N_noxref_5_c_1544_n N_SN_c_8055_n ) capacitor c=4.56604e-19 \
 //x=11.96 //y=4.88 //x2=10.85 //y2=4.765
cc_1517 ( N_noxref_5_c_1580_n N_SN_c_8055_n ) capacitor c=0.00124604f \
 //x=11.96 //y=4.88 //x2=10.85 //y2=4.765
cc_1518 ( N_noxref_5_c_1822_p N_SN_c_8130_n ) capacitor c=0.00782975f \
 //x=23.43 //y=2.375 //x2=22.32 //y2=2.55
cc_1519 ( N_noxref_5_c_1670_n N_SN_c_8130_n ) capacitor c=0.00332919f \
 //x=23.43 //y=3.725 //x2=22.32 //y2=2.55
cc_1520 ( N_noxref_5_c_1824_p N_SN_c_8130_n ) capacitor c=0.00115817f \
 //x=23.43 //y=2.26 //x2=22.32 //y2=2.55
cc_1521 ( N_noxref_5_c_1825_p N_SN_c_8130_n ) capacitor c=0.00148267f \
 //x=23.43 //y=2.26 //x2=22.32 //y2=2.55
cc_1522 ( N_noxref_5_c_1671_n N_SN_c_8134_n ) capacitor c=0.0107551f //x=23.43 \
 //y=4.75 //x2=22.32 //y2=4.765
cc_1523 ( N_noxref_5_c_1814_p N_SN_c_8134_n ) capacitor c=4.56604e-19 \
 //x=23.43 //y=4.88 //x2=22.32 //y2=4.765
cc_1524 ( N_noxref_5_c_1828_p N_SN_c_8134_n ) capacitor c=0.00124604f \
 //x=23.43 //y=4.88 //x2=22.32 //y2=4.765
cc_1525 ( N_noxref_5_c_1505_n N_SN_c_8092_n ) capacitor c=0.0160193f //x=11.96 \
 //y=2.375 //x2=22.15 //y2=2.4
cc_1526 ( N_noxref_5_c_1499_n N_SN_c_8092_n ) capacitor c=0.0155071f //x=11.96 \
 //y=3.705 //x2=22.15 //y2=2.4
cc_1527 ( N_noxref_5_c_1523_n N_SN_c_8092_n ) capacitor c=0.0192658f \
 //x=15.675 //y=1.835 //x2=22.15 //y2=2.4
cc_1528 ( N_noxref_5_c_1524_n N_SN_c_8092_n ) capacitor c=0.0307839f //x=16.03 \
 //y=3.705 //x2=22.15 //y2=2.4
cc_1529 ( N_noxref_5_c_1538_n N_SN_c_8092_n ) capacitor c=7.29202e-19 \
 //x=15.59 //y=1.18 //x2=22.15 //y2=2.4
cc_1530 ( N_noxref_5_c_1503_n N_SN_c_8092_n ) capacitor c=0.00199242f \
 //x=12.12 //y=3.88 //x2=22.15 //y2=2.4
cc_1531 ( N_noxref_5_c_1540_n N_SN_c_8092_n ) capacitor c=0.00478516f \
 //x=15.865 //y=3.865 //x2=22.15 //y2=2.4
cc_1532 ( N_noxref_5_c_1626_n N_SN_c_8092_n ) capacitor c=0.00588967f \
 //x=23.27 //y=3.885 //x2=22.15 //y2=2.4
cc_1533 ( N_noxref_5_c_1577_n N_SN_c_8092_n ) capacitor c=3.41298e-19 \
 //x=11.96 //y=2.26 //x2=22.15 //y2=2.4
cc_1534 ( N_noxref_5_c_1822_p N_SN_c_8145_n ) capacitor c=0.0179937f //x=23.43 \
 //y=2.375 //x2=27.285 //y2=2.385
cc_1535 ( N_noxref_5_c_1670_n N_SN_c_8145_n ) capacitor c=0.0165673f //x=23.43 \
 //y=3.725 //x2=27.285 //y2=2.385
cc_1536 ( N_noxref_5_c_1825_p N_SN_c_8145_n ) capacitor c=3.41298e-19 \
 //x=23.43 //y=2.26 //x2=27.285 //y2=2.385
cc_1537 ( N_noxref_5_c_1505_n N_SN_c_8059_n ) capacitor c=0.00195485f \
 //x=11.96 //y=2.375 //x2=11.01 //y2=2.39
cc_1538 ( N_noxref_5_c_1499_n N_SN_c_8059_n ) capacitor c=0.00105069f \
 //x=11.96 //y=3.705 //x2=11.01 //y2=2.39
cc_1539 ( N_noxref_5_c_1505_n N_SN_c_8061_n ) capacitor c=5.39999e-19 \
 //x=11.96 //y=2.375 //x2=10.85 //y2=2.26
cc_1540 ( N_noxref_5_c_1543_n N_SN_c_8061_n ) capacitor c=0.00124907f \
 //x=11.96 //y=2.26 //x2=10.85 //y2=2.26
cc_1541 ( N_noxref_5_c_1577_n N_SN_c_8061_n ) capacitor c=0.00204796f \
 //x=11.96 //y=2.26 //x2=10.85 //y2=2.26
cc_1542 ( N_noxref_5_c_1501_n N_SN_c_8064_n ) capacitor c=9.52396e-19 \
 //x=11.96 //y=4.75 //x2=10.85 //y2=4.88
cc_1543 ( N_noxref_5_c_1544_n N_SN_c_8064_n ) capacitor c=0.00113985f \
 //x=11.96 //y=4.88 //x2=10.85 //y2=4.88
cc_1544 ( N_noxref_5_c_1580_n N_SN_c_8064_n ) capacitor c=0.00187046f \
 //x=11.96 //y=4.88 //x2=10.85 //y2=4.88
cc_1545 ( N_noxref_5_c_1822_p N_SN_c_8147_n ) capacitor c=5.39999e-19 \
 //x=23.43 //y=2.375 //x2=22.32 //y2=2.26
cc_1546 ( N_noxref_5_c_1824_p N_SN_c_8147_n ) capacitor c=0.0012491f //x=23.43 \
 //y=2.26 //x2=22.32 //y2=2.26
cc_1547 ( N_noxref_5_c_1825_p N_SN_c_8147_n ) capacitor c=0.00204796f \
 //x=23.43 //y=2.26 //x2=22.32 //y2=2.26
cc_1548 ( N_noxref_5_c_1671_n N_SN_c_8150_n ) capacitor c=9.52396e-19 \
 //x=23.43 //y=4.75 //x2=22.32 //y2=4.88
cc_1549 ( N_noxref_5_c_1814_p N_SN_c_8150_n ) capacitor c=0.00113985f \
 //x=23.43 //y=4.88 //x2=22.32 //y2=4.88
cc_1550 ( N_noxref_5_c_1828_p N_SN_c_8150_n ) capacitor c=0.00187046f \
 //x=23.43 //y=4.88 //x2=22.32 //y2=4.88
cc_1551 ( N_noxref_5_M66_noxref_g N_SN_M64_noxref_g ) capacitor c=0.0101598f \
 //x=11.7 //y=6.2 //x2=10.82 //y2=6.2
cc_1552 ( N_noxref_5_M66_noxref_g N_SN_M65_noxref_g ) capacitor c=0.0607518f \
 //x=11.7 //y=6.2 //x2=11.26 //y2=6.2
cc_1553 ( N_noxref_5_M67_noxref_g N_SN_M65_noxref_g ) capacitor c=0.0101598f \
 //x=12.14 //y=6.2 //x2=11.26 //y2=6.2
cc_1554 ( N_noxref_5_M80_noxref_g N_SN_M78_noxref_g ) capacitor c=0.0101598f \
 //x=23.17 //y=6.2 //x2=22.29 //y2=6.2
cc_1555 ( N_noxref_5_M80_noxref_g N_SN_M79_noxref_g ) capacitor c=0.0607518f \
 //x=23.17 //y=6.2 //x2=22.73 //y2=6.2
cc_1556 ( N_noxref_5_M81_noxref_g N_SN_M79_noxref_g ) capacitor c=0.0101598f \
 //x=23.61 //y=6.2 //x2=22.73 //y2=6.2
cc_1557 ( N_noxref_5_c_1559_n N_SN_c_8076_n ) capacitor c=0.00456962f \
 //x=11.95 //y=1.095 //x2=10.94 //y2=1.09
cc_1558 ( N_noxref_5_c_1561_n N_SN_c_8077_n ) capacitor c=0.00438372f \
 //x=11.95 //y=1.44 //x2=10.94 //y2=1.4
cc_1559 ( N_noxref_5_c_1564_n N_SN_c_8078_n ) capacitor c=0.00438372f \
 //x=11.95 //y=1.75 //x2=10.94 //y2=1.63
cc_1560 ( N_noxref_5_c_1505_n N_SN_c_8079_n ) capacitor c=6.5732e-19 //x=11.96 \
 //y=2.375 //x2=10.94 //y2=2.095
cc_1561 ( N_noxref_5_c_1543_n N_SN_c_8079_n ) capacitor c=0.00177608f \
 //x=11.96 //y=2.26 //x2=10.94 //y2=2.095
cc_1562 ( N_noxref_5_c_1577_n N_SN_c_8079_n ) capacitor c=0.00873247f \
 //x=11.96 //y=2.26 //x2=10.94 //y2=2.095
cc_1563 ( N_noxref_5_c_1578_n N_SN_c_8079_n ) capacitor c=0.00438372f \
 //x=11.96 //y=2.095 //x2=10.94 //y2=2.095
cc_1564 ( N_noxref_5_c_1580_n N_SN_c_8112_n ) capacitor c=0.0616777f //x=11.96 \
 //y=4.88 //x2=11.185 //y2=4.97
cc_1565 ( N_noxref_5_c_1869_p N_SN_c_8162_n ) capacitor c=0.00456962f \
 //x=23.42 //y=1.095 //x2=22.41 //y2=1.09
cc_1566 ( N_noxref_5_c_1870_p N_SN_c_8163_n ) capacitor c=0.00438372f \
 //x=23.42 //y=1.44 //x2=22.41 //y2=1.4
cc_1567 ( N_noxref_5_c_1871_p N_SN_c_8164_n ) capacitor c=0.00438372f \
 //x=23.42 //y=1.75 //x2=22.41 //y2=1.63
cc_1568 ( N_noxref_5_c_1822_p N_SN_c_8165_n ) capacitor c=6.57457e-19 \
 //x=23.43 //y=2.375 //x2=22.41 //y2=2.095
cc_1569 ( N_noxref_5_c_1824_p N_SN_c_8165_n ) capacitor c=0.00177608f \
 //x=23.43 //y=2.26 //x2=22.41 //y2=2.095
cc_1570 ( N_noxref_5_c_1825_p N_SN_c_8165_n ) capacitor c=0.00873247f \
 //x=23.43 //y=2.26 //x2=22.41 //y2=2.095
cc_1571 ( N_noxref_5_c_1875_p N_SN_c_8165_n ) capacitor c=0.00438372f \
 //x=23.43 //y=2.095 //x2=22.41 //y2=2.095
cc_1572 ( N_noxref_5_c_1828_p N_SN_c_8246_n ) capacitor c=0.0616777f //x=23.43 \
 //y=4.88 //x2=22.655 //y2=4.97
cc_1573 ( N_noxref_5_c_1501_n N_SN_c_8082_n ) capacitor c=8.42568e-19 \
 //x=11.96 //y=4.75 //x2=10.85 //y2=4.88
cc_1574 ( N_noxref_5_c_1544_n N_SN_c_8082_n ) capacitor c=0.00129812f \
 //x=11.96 //y=4.88 //x2=10.85 //y2=4.88
cc_1575 ( N_noxref_5_c_1580_n N_SN_c_8082_n ) capacitor c=0.00487508f \
 //x=11.96 //y=4.88 //x2=10.85 //y2=4.88
cc_1576 ( N_noxref_5_c_1671_n N_SN_c_8168_n ) capacitor c=8.42568e-19 \
 //x=23.43 //y=4.75 //x2=22.32 //y2=4.88
cc_1577 ( N_noxref_5_c_1814_p N_SN_c_8168_n ) capacitor c=0.00129812f \
 //x=23.43 //y=4.88 //x2=22.32 //y2=4.88
cc_1578 ( N_noxref_5_c_1828_p N_SN_c_8168_n ) capacitor c=0.00487508f \
 //x=23.43 //y=4.88 //x2=22.32 //y2=4.88
cc_1579 ( N_noxref_5_c_1524_n N_noxref_21_c_10403_n ) capacitor c=0.00177198f \
 //x=16.03 //y=3.705 //x2=18.62 //y2=3.335
cc_1580 ( N_noxref_5_c_1626_n N_noxref_21_c_10405_n ) capacitor c=0.00565709f \
 //x=23.27 //y=3.885 //x2=18.62 //y2=3.655
cc_1581 ( N_noxref_5_c_1527_n N_noxref_21_c_10406_n ) capacitor c=0.00176814f \
 //x=16.03 //y=5.295 //x2=18.62 //y2=4.735
cc_1582 ( N_noxref_5_c_1626_n N_noxref_21_c_10406_n ) capacitor c=0.0227025f \
 //x=23.27 //y=3.885 //x2=18.62 //y2=4.735
cc_1583 ( N_noxref_5_c_1743_p N_noxref_21_c_10517_n ) capacitor c=0.00168386f \
 //x=23.43 //y=4.045 //x2=23.275 //y2=5.335
cc_1584 ( N_noxref_5_M80_noxref_g N_noxref_21_c_10517_n ) capacitor \
 c=0.00952006f //x=23.17 //y=6.2 //x2=23.275 //y2=5.335
cc_1585 ( N_noxref_5_M80_noxref_g N_noxref_21_c_10519_n ) capacitor \
 c=0.00226521f //x=23.17 //y=6.2 //x2=23.39 //y2=5.56
cc_1586 ( N_noxref_5_M81_noxref_g N_noxref_21_c_10519_n ) capacitor \
 c=0.00368945f //x=23.61 //y=6.2 //x2=23.39 //y2=5.56
cc_1587 ( N_noxref_5_c_1743_p N_noxref_21_c_10521_n ) capacitor c=4.21338e-19 \
 //x=23.43 //y=4.045 //x2=24.085 //y2=5.335
cc_1588 ( N_noxref_5_c_1671_n N_noxref_21_c_10521_n ) capacitor c=0.00228791f \
 //x=23.43 //y=4.75 //x2=24.085 //y2=5.335
cc_1589 ( N_noxref_5_c_1814_p N_noxref_21_c_10521_n ) capacitor c=0.00130631f \
 //x=23.43 //y=4.88 //x2=24.085 //y2=5.335
cc_1590 ( N_noxref_5_M81_noxref_g N_noxref_21_c_10521_n ) capacitor \
 c=0.0108585f //x=23.61 //y=6.2 //x2=24.085 //y2=5.335
cc_1591 ( N_noxref_5_c_1869_p N_noxref_21_c_10525_n ) capacitor c=4.64015e-19 \
 //x=23.42 //y=1.095 //x2=23.685 //y2=1.305
cc_1592 ( N_noxref_5_c_1870_p N_noxref_21_c_10525_n ) capacitor c=0.0026012f \
 //x=23.42 //y=1.44 //x2=23.685 //y2=1.305
cc_1593 ( N_noxref_5_c_1897_p N_noxref_21_c_10525_n ) capacitor c=5.29969e-19 \
 //x=23.795 //y=0.94 //x2=23.685 //y2=1.305
cc_1594 ( N_noxref_5_c_1898_p N_noxref_21_c_10525_n ) capacitor c=5.31989e-19 \
 //x=23.795 //y=1.595 //x2=23.685 //y2=1.305
cc_1595 ( N_noxref_5_c_1899_p N_noxref_21_c_10525_n ) capacitor c=5.28622e-19 \
 //x=23.95 //y=1.095 //x2=23.685 //y2=1.305
cc_1596 ( N_noxref_5_c_1900_p N_noxref_21_c_10525_n ) capacitor c=0.00312156f \
 //x=23.95 //y=1.44 //x2=23.685 //y2=1.305
cc_1597 ( N_noxref_5_c_1870_p N_noxref_21_c_10462_n ) capacitor c=0.00127432f \
 //x=23.42 //y=1.44 //x2=23.685 //y2=1.76
cc_1598 ( N_noxref_5_c_1871_p N_noxref_21_c_10462_n ) capacitor c=0.00429966f \
 //x=23.42 //y=1.75 //x2=23.685 //y2=1.76
cc_1599 ( N_noxref_5_c_1898_p N_noxref_21_c_10462_n ) capacitor c=0.00930387f \
 //x=23.795 //y=1.595 //x2=23.685 //y2=1.76
cc_1600 ( N_noxref_5_c_1900_p N_noxref_21_c_10462_n ) capacitor c=0.00347599f \
 //x=23.95 //y=1.44 //x2=23.685 //y2=1.76
cc_1601 ( N_noxref_5_c_1875_p N_noxref_21_c_10462_n ) capacitor c=0.00362297f \
 //x=23.43 //y=2.095 //x2=23.685 //y2=1.76
cc_1602 ( N_noxref_5_c_1898_p N_noxref_21_c_10536_n ) capacitor c=0.00194716f \
 //x=23.795 //y=1.595 //x2=24.085 //y2=1.845
cc_1603 ( N_noxref_5_c_1900_p N_noxref_21_c_10536_n ) capacitor c=0.00323576f \
 //x=23.95 //y=1.44 //x2=24.085 //y2=1.845
cc_1604 ( N_noxref_5_c_1822_p N_noxref_21_c_10538_n ) capacitor c=0.0139437f \
 //x=23.43 //y=2.375 //x2=24.17 //y2=3.365
cc_1605 ( N_noxref_5_c_1670_n N_noxref_21_c_10538_n ) capacitor c=0.0400418f \
 //x=23.43 //y=3.725 //x2=24.17 //y2=3.365
cc_1606 ( N_noxref_5_c_1824_p N_noxref_21_c_10538_n ) capacitor c=0.0015536f \
 //x=23.43 //y=2.26 //x2=24.17 //y2=3.365
cc_1607 ( N_noxref_5_c_1825_p N_noxref_21_c_10538_n ) capacitor c=0.0024584f \
 //x=23.43 //y=2.26 //x2=24.17 //y2=3.365
cc_1608 ( N_noxref_5_c_1875_p N_noxref_21_c_10538_n ) capacitor c=0.00282067f \
 //x=23.43 //y=2.095 //x2=24.17 //y2=3.365
cc_1609 ( N_noxref_5_c_1670_n N_noxref_21_c_10543_n ) capacitor c=0.014884f \
 //x=23.43 //y=3.725 //x2=24.17 //y2=3.685
cc_1610 ( N_noxref_5_c_1670_n N_noxref_21_c_10544_n ) capacitor c=0.00177543f \
 //x=23.43 //y=3.725 //x2=24.17 //y2=5.25
cc_1611 ( N_noxref_5_c_1743_p N_noxref_21_c_10544_n ) capacitor c=0.0148501f \
 //x=23.43 //y=4.045 //x2=24.17 //y2=5.25
cc_1612 ( N_noxref_5_c_1671_n N_noxref_21_c_10544_n ) capacitor c=0.0435121f \
 //x=23.43 //y=4.75 //x2=24.17 //y2=5.25
cc_1613 ( N_noxref_5_c_1811_p N_noxref_21_c_10544_n ) capacitor c=6.89957e-19 \
 //x=23.43 //y=3.88 //x2=24.17 //y2=5.25
cc_1614 ( N_noxref_5_c_1745_p N_noxref_21_c_10544_n ) capacitor c=0.00686827f \
 //x=23.43 //y=3.885 //x2=24.17 //y2=5.25
cc_1615 ( N_noxref_5_c_1814_p N_noxref_21_c_10544_n ) capacitor c=0.00131258f \
 //x=23.43 //y=4.88 //x2=24.17 //y2=5.25
cc_1616 ( N_noxref_5_c_1828_p N_noxref_21_c_10544_n ) capacitor c=0.00739875f \
 //x=23.43 //y=4.88 //x2=24.17 //y2=5.25
cc_1617 ( N_noxref_5_c_1671_n N_noxref_21_c_10551_n ) capacitor c=0.0221235f \
 //x=23.43 //y=4.75 //x2=23.39 //y2=5.335
cc_1618 ( N_noxref_5_c_1814_p N_noxref_21_c_10551_n ) capacitor c=0.00346456f \
 //x=23.43 //y=4.88 //x2=23.39 //y2=5.335
cc_1619 ( N_noxref_5_c_1828_p N_noxref_21_c_10551_n ) capacitor c=0.00203307f \
 //x=23.43 //y=4.88 //x2=23.39 //y2=5.335
cc_1620 ( N_noxref_5_c_1670_n N_noxref_21_c_10554_n ) capacitor c=9.19401e-19 \
 //x=23.43 //y=3.725 //x2=24.17 //y2=3.51
cc_1621 ( N_noxref_5_c_1670_n N_noxref_21_c_10471_n ) capacitor c=2.52001e-19 \
 //x=23.43 //y=3.725 //x2=23.045 //y2=3.51
cc_1622 ( N_noxref_5_c_1743_p N_noxref_21_c_10471_n ) capacitor c=0.00202106f \
 //x=23.43 //y=4.045 //x2=23.045 //y2=3.51
cc_1623 ( N_noxref_5_c_1626_n N_noxref_21_c_10471_n ) capacitor c=0.385771f \
 //x=23.27 //y=3.885 //x2=23.045 //y2=3.51
cc_1624 ( N_noxref_5_c_1670_n N_noxref_21_c_10558_n ) capacitor c=0.0206714f \
 //x=23.43 //y=3.725 //x2=23.645 //y2=3.5
cc_1625 ( N_noxref_5_c_1743_p N_noxref_21_c_10558_n ) capacitor c=0.00435339f \
 //x=23.43 //y=4.045 //x2=23.645 //y2=3.5
cc_1626 ( N_noxref_5_c_1745_p N_noxref_21_c_10558_n ) capacitor c=0.0358686f \
 //x=23.43 //y=3.885 //x2=23.645 //y2=3.5
cc_1627 ( N_noxref_5_c_1670_n N_noxref_21_c_10561_n ) capacitor c=0.00342869f \
 //x=23.43 //y=3.725 //x2=31.36 //y2=3.48
cc_1628 ( N_noxref_5_c_1626_n N_noxref_21_c_10418_n ) capacitor c=0.0358686f \
 //x=23.27 //y=3.885 //x2=18.78 //y2=3.495
cc_1629 ( N_noxref_5_c_1671_n N_noxref_21_c_10563_n ) capacitor c=0.00217653f \
 //x=23.43 //y=4.75 //x2=23.39 //y2=5.56
cc_1630 ( N_noxref_5_c_1814_p N_noxref_21_c_10563_n ) capacitor c=0.00624059f \
 //x=23.43 //y=4.88 //x2=23.39 //y2=5.56
cc_1631 ( N_noxref_5_M80_noxref_g N_noxref_21_c_10563_n ) capacitor \
 c=0.0178885f //x=23.17 //y=6.2 //x2=23.39 //y2=5.56
cc_1632 ( N_noxref_5_M81_noxref_g N_noxref_21_c_10563_n ) capacitor \
 c=0.0188608f //x=23.61 //y=6.2 //x2=23.39 //y2=5.56
cc_1633 ( N_noxref_5_c_1828_p N_noxref_21_c_10563_n ) capacitor c=0.00375636f \
 //x=23.43 //y=4.88 //x2=23.39 //y2=5.56
cc_1634 ( N_noxref_5_c_1869_p N_noxref_21_M14_noxref_d ) capacitor \
 c=0.00137165f //x=23.42 //y=1.095 //x2=23.495 //y2=1.095
cc_1635 ( N_noxref_5_c_1870_p N_noxref_21_M14_noxref_d ) capacitor \
 c=0.00237422f //x=23.42 //y=1.44 //x2=23.495 //y2=1.095
cc_1636 ( N_noxref_5_c_1897_p N_noxref_21_M14_noxref_d ) capacitor \
 c=0.0020782f //x=23.795 //y=0.94 //x2=23.495 //y2=1.095
cc_1637 ( N_noxref_5_c_1898_p N_noxref_21_M14_noxref_d ) capacitor \
 c=0.00356097f //x=23.795 //y=1.595 //x2=23.495 //y2=1.095
cc_1638 ( N_noxref_5_c_1899_p N_noxref_21_M14_noxref_d ) capacitor \
 c=0.00139206f //x=23.95 //y=1.095 //x2=23.495 //y2=1.095
cc_1639 ( N_noxref_5_c_1900_p N_noxref_21_M14_noxref_d ) capacitor \
 c=0.00237422f //x=23.95 //y=1.44 //x2=23.495 //y2=1.095
cc_1640 ( N_noxref_5_c_1521_n N_VDD_c_11522_n ) capacitor c=0.00648297f \
 //x=15.435 //y=5.38 //x2=74.455 //y2=7.585
cc_1641 ( N_noxref_5_c_1666_n N_VDD_c_11522_n ) capacitor c=0.00492578f \
 //x=15.945 //y=5.38 //x2=74.455 //y2=7.585
cc_1642 ( N_noxref_5_c_1604_n N_VDD_c_11522_n ) capacitor c=2.03815e-19 \
 //x=16.03 //y=4.025 //x2=74.455 //y2=7.585
cc_1643 ( N_noxref_5_c_1530_n N_VDD_c_11522_n ) capacitor c=0.00368834f \
 //x=14.67 //y=5.56 //x2=74.455 //y2=7.585
cc_1644 ( N_noxref_5_c_1672_n N_VDD_c_11522_n ) capacitor c=8.42537e-19 \
 //x=15.55 //y=5.38 //x2=74.455 //y2=7.585
cc_1645 ( N_noxref_5_c_1673_n N_VDD_c_11522_n ) capacitor c=0.00285853f \
 //x=15.55 //y=5.56 //x2=74.455 //y2=7.585
cc_1646 ( N_noxref_5_c_1548_n N_VDD_c_11522_n ) capacitor c=0.00224881f \
 //x=14.67 //y=5.56 //x2=74.455 //y2=7.585
cc_1647 ( N_noxref_5_c_1726_p N_VDD_c_11522_n ) capacitor c=0.00224881f \
 //x=15.55 //y=5.56 //x2=74.455 //y2=7.585
cc_1648 ( N_noxref_5_M60_noxref_g N_VDD_c_11655_n ) capacitor c=0.00755544f \
 //x=6.89 //y=6.2 //x2=7.465 //y2=7.585
cc_1649 ( N_noxref_5_M61_noxref_g N_VDD_c_11655_n ) capacitor c=0.00755754f \
 //x=7.33 //y=6.2 //x2=7.465 //y2=7.585
cc_1650 ( N_noxref_5_M66_noxref_g N_VDD_c_11599_n ) capacitor c=0.00755544f \
 //x=11.7 //y=6.2 //x2=12.275 //y2=7.585
cc_1651 ( N_noxref_5_M67_noxref_g N_VDD_c_11599_n ) capacitor c=0.00755754f \
 //x=12.14 //y=6.2 //x2=12.275 //y2=7.585
cc_1652 ( N_noxref_5_c_1521_n N_VDD_c_11604_n ) capacitor c=0.00208087f \
 //x=15.435 //y=5.38 //x2=15.025 //y2=7.585
cc_1653 ( N_noxref_5_c_1530_n N_VDD_c_11604_n ) capacitor c=9.41185e-19 \
 //x=14.67 //y=5.56 //x2=15.025 //y2=7.585
cc_1654 ( N_noxref_5_c_1548_n N_VDD_c_11604_n ) capacitor c=0.0136705f \
 //x=14.67 //y=5.56 //x2=15.025 //y2=7.585
cc_1655 ( N_noxref_5_c_1521_n N_VDD_c_11781_n ) capacitor c=0.00180737f \
 //x=15.435 //y=5.38 //x2=15.905 //y2=7.585
cc_1656 ( N_noxref_5_c_1666_n N_VDD_c_11781_n ) capacitor c=0.00208087f \
 //x=15.945 //y=5.38 //x2=15.905 //y2=7.585
cc_1657 ( N_noxref_5_c_1672_n N_VDD_c_11781_n ) capacitor c=4.23719e-19 \
 //x=15.55 //y=5.38 //x2=15.905 //y2=7.585
cc_1658 ( N_noxref_5_c_1673_n N_VDD_c_11781_n ) capacitor c=5.77976e-19 \
 //x=15.55 //y=5.56 //x2=15.905 //y2=7.585
cc_1659 ( N_noxref_5_c_1726_p N_VDD_c_11781_n ) capacitor c=0.0136705f \
 //x=15.55 //y=5.56 //x2=15.905 //y2=7.585
cc_1660 ( N_noxref_5_M80_noxref_g N_VDD_c_11786_n ) capacitor c=0.00755544f \
 //x=23.17 //y=6.2 //x2=23.745 //y2=7.585
cc_1661 ( N_noxref_5_M81_noxref_g N_VDD_c_11786_n ) capacitor c=0.00755754f \
 //x=23.61 //y=6.2 //x2=23.745 //y2=7.585
cc_1662 ( N_noxref_5_c_1631_n N_VDD_c_11551_n ) capacitor c=0.00224736f \
 //x=7.15 //y=4.88 //x2=8.63 //y2=7.585
cc_1663 ( N_noxref_5_c_1662_n N_VDD_c_11551_n ) capacitor c=2.63786e-19 \
 //x=7.15 //y=4.88 //x2=8.63 //y2=7.585
cc_1664 ( N_noxref_5_c_1527_n N_VDD_c_11609_n ) capacitor c=0.0013228f \
 //x=16.03 //y=5.295 //x2=13.44 //y2=7.585
cc_1665 ( N_noxref_5_c_1530_n N_VDD_c_11609_n ) capacitor c=4.91377e-19 \
 //x=14.67 //y=5.56 //x2=13.44 //y2=7.585
cc_1666 ( N_noxref_5_c_1544_n N_VDD_c_11609_n ) capacitor c=0.00224736f \
 //x=11.96 //y=4.88 //x2=13.44 //y2=7.585
cc_1667 ( N_noxref_5_c_1548_n N_VDD_c_11609_n ) capacitor c=0.0064135f \
 //x=14.67 //y=5.56 //x2=13.44 //y2=7.585
cc_1668 ( N_noxref_5_c_1580_n N_VDD_c_11609_n ) capacitor c=2.63786e-19 \
 //x=11.96 //y=4.88 //x2=13.44 //y2=7.585
cc_1669 ( N_noxref_5_c_1527_n N_VDD_c_11679_n ) capacitor c=0.029072f \
 //x=16.03 //y=5.295 //x2=16.77 //y2=7.585
cc_1670 ( N_noxref_5_c_1672_n N_VDD_c_11679_n ) capacitor c=0.00240948f \
 //x=15.55 //y=5.38 //x2=16.77 //y2=7.585
cc_1671 ( N_noxref_5_c_1673_n N_VDD_c_11679_n ) capacitor c=4.09141e-19 \
 //x=15.55 //y=5.56 //x2=16.77 //y2=7.585
cc_1672 ( N_noxref_5_c_1726_p N_VDD_c_11679_n ) capacitor c=0.0101861f \
 //x=15.55 //y=5.56 //x2=16.77 //y2=7.585
cc_1673 ( N_noxref_5_c_1814_p N_VDD_c_11799_n ) capacitor c=0.00224736f \
 //x=23.43 //y=4.88 //x2=24.91 //y2=7.585
cc_1674 ( N_noxref_5_c_1828_p N_VDD_c_11799_n ) capacitor c=2.63786e-19 \
 //x=23.43 //y=4.88 //x2=24.91 //y2=7.585
cc_1675 ( N_noxref_5_M60_noxref_g N_VDD_M59_noxref_d ) capacitor c=0.015318f \
 //x=6.89 //y=6.2 //x2=6.525 //y2=5.2
cc_1676 ( N_noxref_5_M61_noxref_g N_VDD_M61_noxref_d ) capacitor c=0.0394719f \
 //x=7.33 //y=6.2 //x2=7.405 //y2=5.2
cc_1677 ( N_noxref_5_M66_noxref_g N_VDD_M65_noxref_d ) capacitor c=0.015318f \
 //x=11.7 //y=6.2 //x2=11.335 //y2=5.2
cc_1678 ( N_noxref_5_M67_noxref_g N_VDD_M67_noxref_d ) capacitor c=0.0394719f \
 //x=12.14 //y=6.2 //x2=12.215 //y2=5.2
cc_1679 ( N_noxref_5_c_1530_n N_VDD_M68_noxref_s ) capacitor c=0.0611368f \
 //x=14.67 //y=5.56 //x2=14.095 //y2=5.2
cc_1680 ( N_noxref_5_c_1672_n N_VDD_M68_noxref_s ) capacitor c=6.52457e-19 \
 //x=15.55 //y=5.38 //x2=14.095 //y2=5.2
cc_1681 ( N_noxref_5_c_1548_n N_VDD_M68_noxref_s ) capacitor c=0.0887533f \
 //x=14.67 //y=5.56 //x2=14.095 //y2=5.2
cc_1682 ( N_noxref_5_c_1521_n N_VDD_M69_noxref_d ) capacitor c=0.00734094f \
 //x=15.435 //y=5.38 //x2=14.965 //y2=5.2
cc_1683 ( N_noxref_5_c_1530_n N_VDD_M69_noxref_d ) capacitor c=0.0043528f \
 //x=14.67 //y=5.56 //x2=14.965 //y2=5.2
cc_1684 ( N_noxref_5_c_1673_n N_VDD_M69_noxref_d ) capacitor c=0.0043528f \
 //x=15.55 //y=5.56 //x2=14.965 //y2=5.2
cc_1685 ( N_noxref_5_c_1548_n N_VDD_M69_noxref_d ) capacitor c=0.065554f \
 //x=14.67 //y=5.56 //x2=14.965 //y2=5.2
cc_1686 ( N_noxref_5_c_1726_p N_VDD_M69_noxref_d ) capacitor c=0.065554f \
 //x=15.55 //y=5.56 //x2=14.965 //y2=5.2
cc_1687 ( N_noxref_5_c_1666_n N_VDD_M71_noxref_d ) capacitor c=0.00898356f \
 //x=15.945 //y=5.38 //x2=15.845 //y2=5.2
cc_1688 ( N_noxref_5_c_1673_n N_VDD_M71_noxref_d ) capacitor c=0.00587834f \
 //x=15.55 //y=5.56 //x2=15.845 //y2=5.2
cc_1689 ( N_noxref_5_c_1713_p N_VDD_M71_noxref_d ) capacitor c=0.00122238f \
 //x=16.03 //y=3.88 //x2=15.845 //y2=5.2
cc_1690 ( N_noxref_5_c_1726_p N_VDD_M71_noxref_d ) capacitor c=0.065554f \
 //x=15.55 //y=5.56 //x2=15.845 //y2=5.2
cc_1691 ( N_noxref_5_c_1666_n N_VDD_M72_noxref_s ) capacitor c=0.00326953f \
 //x=15.945 //y=5.38 //x2=17.425 //y2=5.2
cc_1692 ( N_noxref_5_c_1672_n N_VDD_M72_noxref_s ) capacitor c=0.00515461f \
 //x=15.55 //y=5.38 //x2=17.425 //y2=5.2
cc_1693 ( N_noxref_5_c_1673_n N_VDD_M72_noxref_s ) capacitor c=3.28075e-19 \
 //x=15.55 //y=5.56 //x2=17.425 //y2=5.2
cc_1694 ( N_noxref_5_M80_noxref_g N_VDD_M79_noxref_d ) capacitor c=0.015318f \
 //x=23.17 //y=6.2 //x2=22.805 //y2=5.2
cc_1695 ( N_noxref_5_M81_noxref_g N_VDD_M81_noxref_d ) capacitor c=0.0394719f \
 //x=23.61 //y=6.2 //x2=23.685 //y2=5.2
cc_1696 ( N_noxref_5_c_1491_n N_noxref_24_c_12951_n ) capacitor c=0.00177186f \
 //x=7.15 //y=2.375 //x2=7.805 //y2=0.72
cc_1697 ( N_noxref_5_c_1630_n N_noxref_24_c_12951_n ) capacitor c=0.00117306f \
 //x=7.15 //y=2.26 //x2=7.805 //y2=0.72
cc_1698 ( N_noxref_5_c_1641_n N_noxref_24_c_12951_n ) capacitor c=0.0206349f \
 //x=7.14 //y=1.095 //x2=7.805 //y2=0.72
cc_1699 ( N_noxref_5_c_1653_n N_noxref_24_c_12951_n ) capacitor c=0.00825432f \
 //x=7.67 //y=1.095 //x2=7.805 //y2=0.72
cc_1700 ( N_noxref_5_c_1659_n N_noxref_24_c_12951_n ) capacitor c=2.20712e-19 \
 //x=7.15 //y=2.26 //x2=7.805 //y2=0.72
cc_1701 ( N_noxref_5_c_1643_n N_noxref_24_c_12958_n ) capacitor c=0.0071177f \
 //x=7.14 //y=1.44 //x2=6.92 //y2=1.175
cc_1702 ( N_noxref_5_c_1641_n N_noxref_24_M4_noxref_s ) capacitor c=0.0071177f \
 //x=7.14 //y=1.095 //x2=6.785 //y2=0.555
cc_1703 ( N_noxref_5_c_1646_n N_noxref_24_M4_noxref_s ) capacitor c=0.0071177f \
 //x=7.14 //y=1.75 //x2=6.785 //y2=0.555
cc_1704 ( N_noxref_5_c_1653_n N_noxref_24_M4_noxref_s ) capacitor c=0.015333f \
 //x=7.67 //y=1.095 //x2=6.785 //y2=0.555
cc_1705 ( N_noxref_5_c_1655_n N_noxref_24_M4_noxref_s ) capacitor \
 c=0.00248746f //x=7.67 //y=1.44 //x2=6.785 //y2=0.555
cc_1706 ( N_noxref_5_c_1505_n N_noxref_25_c_13017_n ) capacitor c=0.00177186f \
 //x=11.96 //y=2.375 //x2=12.615 //y2=0.72
cc_1707 ( N_noxref_5_c_1543_n N_noxref_25_c_13017_n ) capacitor c=0.00117306f \
 //x=11.96 //y=2.26 //x2=12.615 //y2=0.72
cc_1708 ( N_noxref_5_c_1559_n N_noxref_25_c_13017_n ) capacitor c=0.0206349f \
 //x=11.95 //y=1.095 //x2=12.615 //y2=0.72
cc_1709 ( N_noxref_5_c_1571_n N_noxref_25_c_13017_n ) capacitor c=0.00825432f \
 //x=12.48 //y=1.095 //x2=12.615 //y2=0.72
cc_1710 ( N_noxref_5_c_1577_n N_noxref_25_c_13017_n ) capacitor c=2.20712e-19 \
 //x=11.96 //y=2.26 //x2=12.615 //y2=0.72
cc_1711 ( N_noxref_5_c_1561_n N_noxref_25_c_13020_n ) capacitor c=0.0071177f \
 //x=11.95 //y=1.44 //x2=11.73 //y2=1.175
cc_1712 ( N_noxref_5_c_1513_n N_noxref_25_M7_noxref_s ) capacitor \
 c=9.75621e-19 //x=11.96 //y=4.025 //x2=11.595 //y2=0.555
cc_1713 ( N_noxref_5_c_1559_n N_noxref_25_M7_noxref_s ) capacitor c=0.0071177f \
 //x=11.95 //y=1.095 //x2=11.595 //y2=0.555
cc_1714 ( N_noxref_5_c_1564_n N_noxref_25_M7_noxref_s ) capacitor c=0.0071177f \
 //x=11.95 //y=1.75 //x2=11.595 //y2=0.555
cc_1715 ( N_noxref_5_c_1571_n N_noxref_25_M7_noxref_s ) capacitor c=0.015333f \
 //x=12.48 //y=1.095 //x2=11.595 //y2=0.555
cc_1716 ( N_noxref_5_c_1573_n N_noxref_25_M7_noxref_s ) capacitor \
 c=0.00248746f //x=12.48 //y=1.44 //x2=11.595 //y2=0.555
cc_1717 ( N_noxref_5_c_1822_p N_noxref_26_c_13087_n ) capacitor c=0.00177186f \
 //x=23.43 //y=2.375 //x2=24.085 //y2=0.72
cc_1718 ( N_noxref_5_c_1824_p N_noxref_26_c_13087_n ) capacitor c=0.00117306f \
 //x=23.43 //y=2.26 //x2=24.085 //y2=0.72
cc_1719 ( N_noxref_5_c_1869_p N_noxref_26_c_13087_n ) capacitor c=0.0206349f \
 //x=23.42 //y=1.095 //x2=24.085 //y2=0.72
cc_1720 ( N_noxref_5_c_1899_p N_noxref_26_c_13087_n ) capacitor c=0.00825432f \
 //x=23.95 //y=1.095 //x2=24.085 //y2=0.72
cc_1721 ( N_noxref_5_c_1825_p N_noxref_26_c_13087_n ) capacitor c=2.20712e-19 \
 //x=23.43 //y=2.26 //x2=24.085 //y2=0.72
cc_1722 ( N_noxref_5_c_1870_p N_noxref_26_c_13092_n ) capacitor c=0.0071177f \
 //x=23.42 //y=1.44 //x2=23.2 //y2=1.175
cc_1723 ( N_noxref_5_c_1743_p N_noxref_26_M14_noxref_s ) capacitor \
 c=9.72448e-19 //x=23.43 //y=4.045 //x2=23.065 //y2=0.555
cc_1724 ( N_noxref_5_c_1869_p N_noxref_26_M14_noxref_s ) capacitor \
 c=0.0071177f //x=23.42 //y=1.095 //x2=23.065 //y2=0.555
cc_1725 ( N_noxref_5_c_1871_p N_noxref_26_M14_noxref_s ) capacitor \
 c=0.0071177f //x=23.42 //y=1.75 //x2=23.065 //y2=0.555
cc_1726 ( N_noxref_5_c_1899_p N_noxref_26_M14_noxref_s ) capacitor c=0.015333f \
 //x=23.95 //y=1.095 //x2=23.065 //y2=0.555
cc_1727 ( N_noxref_5_c_1900_p N_noxref_26_M14_noxref_s ) capacitor \
 c=0.00248746f //x=23.95 //y=1.44 //x2=23.065 //y2=0.555
cc_1728 ( N_noxref_5_c_1491_n N_GND_c_13867_n ) capacitor c=0.00200766f \
 //x=7.15 //y=2.375 //x2=9.62 //y2=0.175
cc_1729 ( N_noxref_5_c_1505_n N_GND_c_13937_n ) capacitor c=0.00196498f \
 //x=11.96 //y=2.375 //x2=14.535 //y2=0.175
cc_1730 ( N_noxref_5_c_1667_n N_GND_c_14058_n ) capacitor c=0.00608539f \
 //x=15.945 //y=1.835 //x2=17.865 //y2=0.175
cc_1731 ( N_noxref_5_c_1538_n N_GND_c_14058_n ) capacitor c=0.00915339f \
 //x=15.59 //y=1.18 //x2=17.865 //y2=0.175
cc_1732 ( N_noxref_5_M9_noxref_d N_GND_c_14058_n ) capacitor c=3.01769e-19 \
 //x=15.4 //y=1.085 //x2=17.865 //y2=0.175
cc_1733 ( N_noxref_5_c_1822_p N_GND_c_14061_n ) capacitor c=0.00196498f \
 //x=23.43 //y=2.375 //x2=26.005 //y2=0.175
cc_1734 ( N_noxref_5_c_1530_n N_GND_c_13941_n ) capacitor c=7.42819e-19 \
 //x=14.67 //y=5.56 //x2=14.62 //y2=1.135
cc_1735 ( N_noxref_5_c_1538_n N_GND_c_13941_n ) capacitor c=0.0140211f \
 //x=15.59 //y=1.18 //x2=14.62 //y2=1.135
cc_1736 ( N_noxref_5_M9_noxref_d N_GND_c_13941_n ) capacitor c=2.93544e-19 \
 //x=15.4 //y=1.085 //x2=14.62 //y2=1.135
cc_1737 ( N_noxref_5_c_1538_n N_GND_c_13985_n ) capacitor c=0.00549186f \
 //x=15.59 //y=1.18 //x2=17.95 //y2=1.135
cc_1738 ( N_noxref_5_c_1491_n N_GND_c_13900_n ) capacitor c=2.016e-19 //x=7.15 \
 //y=2.375 //x2=8.46 //y2=0.175
cc_1739 ( N_noxref_5_c_1505_n N_GND_c_13901_n ) capacitor c=2.016e-19 \
 //x=11.96 //y=2.375 //x2=13.27 //y2=0.175
cc_1740 ( N_noxref_5_c_1667_n N_GND_c_13957_n ) capacitor c=7.77585e-19 \
 //x=15.945 //y=1.835 //x2=16.6 //y2=0.175
cc_1741 ( N_noxref_5_c_1822_p N_GND_c_14039_n ) capacitor c=2.016e-19 \
 //x=23.43 //y=2.375 //x2=24.74 //y2=0.175
cc_1742 ( N_noxref_5_c_1630_n N_GND_c_13914_n ) capacitor c=0.00239899f \
 //x=7.15 //y=2.26 //x2=8.63 //y2=0.175
cc_1743 ( N_noxref_5_c_1655_n N_GND_c_13914_n ) capacitor c=0.00262688f \
 //x=7.67 //y=1.44 //x2=8.63 //y2=0.175
cc_1744 ( N_noxref_5_c_1659_n N_GND_c_13914_n ) capacitor c=2.63786e-19 \
 //x=7.15 //y=2.26 //x2=8.63 //y2=0.175
cc_1745 ( N_noxref_5_c_1524_n N_GND_c_13958_n ) capacitor c=9.32616e-19 \
 //x=16.03 //y=3.705 //x2=13.44 //y2=0.175
cc_1746 ( N_noxref_5_c_1543_n N_GND_c_13958_n ) capacitor c=0.00222376f \
 //x=11.96 //y=2.26 //x2=13.44 //y2=0.175
cc_1747 ( N_noxref_5_c_1573_n N_GND_c_13958_n ) capacitor c=0.00262688f \
 //x=12.48 //y=1.44 //x2=13.44 //y2=0.175
cc_1748 ( N_noxref_5_c_1522_n N_GND_c_13971_n ) capacitor c=0.002973f \
 //x=15.59 //y=1.75 //x2=16.77 //y2=0.175
cc_1749 ( N_noxref_5_c_1667_n N_GND_c_13971_n ) capacitor c=0.028425f \
 //x=15.945 //y=1.835 //x2=16.77 //y2=0.175
cc_1750 ( N_noxref_5_c_1824_p N_GND_c_14078_n ) capacitor c=0.00222376f \
 //x=23.43 //y=2.26 //x2=24.91 //y2=0.175
cc_1751 ( N_noxref_5_c_1900_p N_GND_c_14078_n ) capacitor c=0.00262688f \
 //x=23.95 //y=1.44 //x2=24.91 //y2=0.175
cc_1752 ( N_noxref_5_c_1538_n N_GND_M8_noxref_d ) capacitor c=2.82748e-19 \
 //x=15.59 //y=1.18 //x2=14.43 //y2=1.045
cc_1753 ( N_noxref_5_c_1523_n N_noxref_40_c_15785_n ) capacitor c=0.00911405f \
 //x=15.675 //y=1.835 //x2=15.105 //y2=1.675
cc_1754 ( N_noxref_5_c_1667_n N_noxref_40_c_15790_n ) capacitor c=0.00399245f \
 //x=15.945 //y=1.835 //x2=15.99 //y2=0.71
cc_1755 ( N_noxref_5_c_1538_n N_noxref_40_c_15790_n ) capacitor c=0.003751f \
 //x=15.59 //y=1.18 //x2=15.99 //y2=0.71
cc_1756 ( N_noxref_5_M9_noxref_d N_noxref_40_c_15790_n ) capacitor \
 c=0.00910163f //x=15.4 //y=1.085 //x2=15.99 //y2=0.71
cc_1757 ( N_noxref_5_c_1522_n N_noxref_40_M8_noxref_s ) capacitor c=0.01625f \
 //x=15.59 //y=1.75 //x2=14 //y2=0.545
cc_1758 ( N_noxref_5_c_1667_n N_noxref_40_M8_noxref_s ) capacitor \
 c=0.00670006f //x=15.945 //y=1.835 //x2=14 //y2=0.545
cc_1759 ( N_noxref_5_c_1604_n N_noxref_40_M8_noxref_s ) capacitor \
 c=3.24398e-19 //x=16.03 //y=4.025 //x2=14 //y2=0.545
cc_1760 ( N_noxref_5_c_1538_n N_noxref_40_M8_noxref_s ) capacitor \
 c=0.00905337f //x=15.59 //y=1.18 //x2=14 //y2=0.545
cc_1761 ( N_noxref_5_c_1713_p N_noxref_40_M8_noxref_s ) capacitor \
 c=8.42257e-19 //x=16.03 //y=3.88 //x2=14 //y2=0.545
cc_1762 ( N_noxref_5_M9_noxref_d N_noxref_40_M8_noxref_s ) capacitor \
 c=0.0275552f //x=15.4 //y=1.085 //x2=14 //y2=0.545
cc_1763 ( N_noxref_6_M93_noxref_g N_noxref_7_c_2489_n ) capacitor \
 c=0.00893512f //x=34.8 //y=6.2 //x2=35.34 //y2=5.335
cc_1764 ( N_noxref_6_M92_noxref_g N_noxref_7_c_2490_n ) capacitor \
 c=0.00461408f //x=34.36 //y=6.2 //x2=34.582 //y2=5.335
cc_1765 ( N_noxref_6_M93_noxref_g N_noxref_7_c_2490_n ) capacitor \
 c=0.00229208f //x=34.8 //y=6.2 //x2=34.582 //y2=5.335
cc_1766 ( N_noxref_6_c_2070_p N_noxref_7_c_2490_n ) capacitor c=0.00171885f \
 //x=34.725 //y=4.97 //x2=34.582 //y2=5.335
cc_1767 ( N_noxref_6_c_2071_p N_noxref_7_c_2493_n ) capacitor c=4.26537e-19 \
 //x=34.16 //y=2.77 //x2=37.12 //y2=2.77
cc_1768 ( N_noxref_6_M92_noxref_g N_noxref_7_c_2494_n ) capacitor c=0.0162284f \
 //x=34.36 //y=6.2 //x2=34.58 //y2=5.56
cc_1769 ( N_noxref_6_M93_noxref_g N_noxref_7_c_2494_n ) capacitor c=0.0179041f \
 //x=34.8 //y=6.2 //x2=34.58 //y2=5.56
cc_1770 ( N_noxref_6_c_2070_p N_noxref_7_c_2494_n ) capacitor c=0.00291477f \
 //x=34.725 //y=4.97 //x2=34.58 //y2=5.56
cc_1771 ( N_noxref_6_c_2075_p N_noxref_8_c_2789_n ) capacitor c=0.00808595f \
 //x=27.5 //y=2.61 //x2=26.76 //y2=4.085
cc_1772 ( N_noxref_6_c_2076_p N_noxref_8_c_2789_n ) capacitor c=0.0148501f \
 //x=27.5 //y=2.93 //x2=26.76 //y2=4.085
cc_1773 ( N_noxref_6_c_2077_p N_noxref_8_c_2789_n ) capacitor c=0.0481495f \
 //x=27.5 //y=5.295 //x2=26.76 //y2=4.085
cc_1774 ( N_noxref_6_c_2078_p N_noxref_8_c_2789_n ) capacitor c=4.35484e-19 \
 //x=29.35 //y=2.61 //x2=26.76 //y2=4.085
cc_1775 ( N_noxref_6_c_2079_p N_noxref_8_c_2789_n ) capacitor c=9.95448e-19 \
 //x=29.35 //y=4.755 //x2=26.76 //y2=4.085
cc_1776 ( N_noxref_6_c_2080_p N_noxref_8_c_2789_n ) capacitor c=6.20144e-19 \
 //x=27.5 //y=2.77 //x2=26.76 //y2=4.085
cc_1777 ( N_noxref_6_c_2081_p N_noxref_8_c_2789_n ) capacitor c=0.00686847f \
 //x=27.66 //y=2.77 //x2=26.76 //y2=4.085
cc_1778 ( N_noxref_6_c_2082_p N_noxref_8_c_2796_n ) capacitor c=0.00206983f \
 //x=26.905 //y=5.38 //x2=26.76 //y2=4.405
cc_1779 ( N_noxref_6_c_2083_p N_noxref_8_c_2796_n ) capacitor c=3.54885e-19 \
 //x=27.145 //y=1.835 //x2=26.76 //y2=4.405
cc_1780 ( N_noxref_6_c_2077_p N_noxref_8_c_2796_n ) capacitor c=0.0173413f \
 //x=27.5 //y=5.295 //x2=26.76 //y2=4.405
cc_1781 ( N_noxref_6_c_2085_p N_noxref_8_c_2796_n ) capacitor c=0.00244912f \
 //x=27.02 //y=5.38 //x2=26.76 //y2=4.405
cc_1782 ( N_noxref_6_c_2086_p N_noxref_8_c_2796_n ) capacitor c=8.00244e-19 \
 //x=27.02 //y=5.56 //x2=26.76 //y2=4.405
cc_1783 ( N_noxref_6_c_2082_p N_noxref_8_c_2801_n ) capacitor c=0.0217388f \
 //x=26.905 //y=5.38 //x2=26.76 //y2=4.735
cc_1784 ( N_noxref_6_c_2077_p N_noxref_8_c_2801_n ) capacitor c=0.0286696f \
 //x=27.5 //y=5.295 //x2=26.76 //y2=4.735
cc_1785 ( N_noxref_6_c_2079_p N_noxref_8_c_2801_n ) capacitor c=4.5647e-19 \
 //x=29.35 //y=4.755 //x2=26.76 //y2=4.735
cc_1786 ( N_noxref_6_M87_noxref_g N_noxref_8_c_2804_n ) capacitor \
 c=0.00893512f //x=29.99 //y=6.2 //x2=30.53 //y2=5.335
cc_1787 ( N_noxref_6_c_2091_p N_noxref_8_c_2805_n ) capacitor c=8.29536e-19 \
 //x=27.415 //y=1.835 //x2=31.825 //y2=1.76
cc_1788 ( N_noxref_6_c_2075_p N_noxref_8_c_2806_n ) capacitor c=8.29536e-19 \
 //x=27.5 //y=2.61 //x2=31.91 //y2=1.845
cc_1789 ( N_noxref_6_c_2093_p N_noxref_8_c_2807_n ) capacitor c=0.00352213f \
 //x=34.16 //y=2.375 //x2=32.31 //y2=4.09
cc_1790 ( N_noxref_6_c_2094_p N_noxref_8_c_2807_n ) capacitor c=0.00236852f \
 //x=34.16 //y=2.615 //x2=32.31 //y2=4.09
cc_1791 ( N_noxref_6_c_2095_p N_noxref_8_c_2807_n ) capacitor c=0.00248106f \
 //x=34.16 //y=2.935 //x2=32.31 //y2=4.09
cc_1792 ( N_noxref_6_c_2096_p N_noxref_8_c_2807_n ) capacitor c=0.0140962f \
 //x=34.16 //y=4.755 //x2=32.31 //y2=4.09
cc_1793 ( N_noxref_6_c_2097_p N_noxref_8_c_2807_n ) capacitor c=0.0015808f \
 //x=34.16 //y=2.775 //x2=32.31 //y2=4.09
cc_1794 ( N_noxref_6_c_2098_p N_noxref_8_c_2807_n ) capacitor c=0.0231249f \
 //x=34 //y=2.775 //x2=32.31 //y2=4.09
cc_1795 ( N_noxref_6_c_2096_p N_noxref_8_c_2813_n ) capacitor c=0.00251118f \
 //x=34.16 //y=4.755 //x2=32.31 //y2=4.41
cc_1796 ( N_noxref_6_c_2096_p N_noxref_8_c_2814_n ) capacitor c=0.00765202f \
 //x=34.16 //y=4.755 //x2=32.31 //y2=5.25
cc_1797 ( N_noxref_6_c_2075_p N_noxref_8_c_2815_n ) capacitor c=0.0135969f \
 //x=27.5 //y=2.61 //x2=26.76 //y2=2.26
cc_1798 ( N_noxref_6_c_2077_p N_noxref_8_c_2816_n ) capacitor c=5.56185e-19 \
 //x=27.5 //y=5.295 //x2=26.76 //y2=4.25
cc_1799 ( N_noxref_6_c_2077_p N_noxref_8_c_2817_n ) capacitor c=0.00261914f \
 //x=27.5 //y=5.295 //x2=29.772 //y2=5.335
cc_1800 ( N_noxref_6_c_2085_p N_noxref_8_c_2817_n ) capacitor c=5.0812e-19 \
 //x=27.02 //y=5.38 //x2=29.772 //y2=5.335
cc_1801 ( N_noxref_6_M86_noxref_g N_noxref_8_c_2817_n ) capacitor \
 c=0.00461408f //x=29.55 //y=6.2 //x2=29.772 //y2=5.335
cc_1802 ( N_noxref_6_M87_noxref_g N_noxref_8_c_2817_n ) capacitor \
 c=0.00229208f //x=29.99 //y=6.2 //x2=29.772 //y2=5.335
cc_1803 ( N_noxref_6_c_2107_p N_noxref_8_c_2817_n ) capacitor c=0.00171885f \
 //x=29.915 //y=4.97 //x2=29.772 //y2=5.335
cc_1804 ( N_noxref_6_c_2077_p N_noxref_8_c_2822_n ) capacitor c=0.0249388f \
 //x=27.5 //y=5.295 //x2=32.145 //y2=4.25
cc_1805 ( N_noxref_6_c_2079_p N_noxref_8_c_2822_n ) capacitor c=0.0274592f \
 //x=29.35 //y=4.755 //x2=32.145 //y2=4.25
cc_1806 ( N_noxref_6_c_2096_p N_noxref_8_c_2824_n ) capacitor c=0.00157696f \
 //x=34.16 //y=4.755 //x2=32.465 //y2=4.25
cc_1807 ( N_noxref_6_c_2077_p N_noxref_8_c_2825_n ) capacitor c=0.0032735f \
 //x=27.5 //y=5.295 //x2=26.92 //y2=4.245
cc_1808 ( N_noxref_6_c_2096_p N_noxref_8_c_2826_n ) capacitor c=0.0245637f \
 //x=34.16 //y=4.755 //x2=42.14 //y2=4.265
cc_1809 ( N_noxref_6_c_2075_p N_noxref_8_c_2827_n ) capacitor c=9.26054e-19 \
 //x=27.5 //y=2.61 //x2=26.76 //y2=2.26
cc_1810 ( N_noxref_6_c_2082_p N_noxref_8_c_2828_n ) capacitor c=0.00469257f \
 //x=26.905 //y=5.38 //x2=26.79 //y2=4.88
cc_1811 ( N_noxref_6_c_2077_p N_noxref_8_c_2828_n ) capacitor c=7.76118e-19 \
 //x=27.5 //y=5.295 //x2=26.79 //y2=4.88
cc_1812 ( N_noxref_6_M86_noxref_g N_noxref_8_c_2830_n ) capacitor c=0.0162284f \
 //x=29.55 //y=6.2 //x2=29.77 //y2=5.56
cc_1813 ( N_noxref_6_M87_noxref_g N_noxref_8_c_2830_n ) capacitor c=0.0179041f \
 //x=29.99 //y=6.2 //x2=29.77 //y2=5.56
cc_1814 ( N_noxref_6_c_2107_p N_noxref_8_c_2830_n ) capacitor c=0.00291477f \
 //x=29.915 //y=4.97 //x2=29.77 //y2=5.56
cc_1815 ( N_noxref_6_c_2082_p N_noxref_8_M84_noxref_g ) capacitor \
 c=0.00842859f //x=26.905 //y=5.38 //x2=26.8 //y2=6.2
cc_1816 ( N_noxref_6_c_2085_p N_noxref_8_M84_noxref_g ) capacitor \
 c=0.00192712f //x=27.02 //y=5.38 //x2=26.8 //y2=6.2
cc_1817 ( N_noxref_6_c_2086_p N_noxref_8_M84_noxref_g ) capacitor c=0.0178987f \
 //x=27.02 //y=5.56 //x2=26.8 //y2=6.2
cc_1818 ( N_noxref_6_c_2122_p N_noxref_8_M85_noxref_g ) capacitor c=0.0106088f \
 //x=27.415 //y=5.38 //x2=27.24 //y2=6.2
cc_1819 ( N_noxref_6_c_2085_p N_noxref_8_M85_noxref_g ) capacitor \
 c=0.00312463f //x=27.02 //y=5.38 //x2=27.24 //y2=6.2
cc_1820 ( N_noxref_6_c_2086_p N_noxref_8_M85_noxref_g ) capacitor c=0.0178506f \
 //x=27.02 //y=5.56 //x2=27.24 //y2=6.2
cc_1821 ( N_noxref_6_c_2125_p N_noxref_8_c_2839_n ) capacitor c=0.00120406f \
 //x=27.06 //y=1.18 //x2=26.795 //y2=1.085
cc_1822 ( N_noxref_6_M16_noxref_d N_noxref_8_c_2839_n ) capacitor \
 c=0.00137165f //x=26.87 //y=1.085 //x2=26.795 //y2=1.085
cc_1823 ( N_noxref_6_c_2127_p N_noxref_8_c_2841_n ) capacitor c=0.00119302f \
 //x=27.06 //y=1.75 //x2=26.795 //y2=1.43
cc_1824 ( N_noxref_6_c_2125_p N_noxref_8_c_2841_n ) capacitor c=0.00218772f \
 //x=27.06 //y=1.18 //x2=26.795 //y2=1.43
cc_1825 ( N_noxref_6_M16_noxref_d N_noxref_8_c_2841_n ) capacitor \
 c=0.00237422f //x=26.87 //y=1.085 //x2=26.795 //y2=1.43
cc_1826 ( N_noxref_6_c_2127_p N_noxref_8_c_2844_n ) capacitor c=0.00439215f \
 //x=27.06 //y=1.75 //x2=26.795 //y2=1.74
cc_1827 ( N_noxref_6_c_2077_p N_noxref_8_c_2845_n ) capacitor c=0.00845606f \
 //x=27.5 //y=5.295 //x2=27.165 //y2=4.97
cc_1828 ( N_noxref_6_c_2085_p N_noxref_8_c_2845_n ) capacitor c=0.0020269f \
 //x=27.02 //y=5.38 //x2=27.165 //y2=4.97
cc_1829 ( N_noxref_6_c_2086_p N_noxref_8_c_2845_n ) capacitor c=0.00302834f \
 //x=27.02 //y=5.56 //x2=27.165 //y2=4.97
cc_1830 ( N_noxref_6_c_2125_p N_noxref_8_c_2848_n ) capacitor c=5.50523e-19 \
 //x=27.06 //y=1.18 //x2=27.17 //y2=0.93
cc_1831 ( N_noxref_6_M16_noxref_d N_noxref_8_c_2848_n ) capacitor c=0.0020782f \
 //x=26.87 //y=1.085 //x2=27.17 //y2=0.93
cc_1832 ( N_noxref_6_c_2127_p N_noxref_8_c_2850_n ) capacitor c=0.00929773f \
 //x=27.06 //y=1.75 //x2=27.17 //y2=1.585
cc_1833 ( N_noxref_6_c_2091_p N_noxref_8_c_2850_n ) capacitor c=0.00194324f \
 //x=27.415 //y=1.835 //x2=27.17 //y2=1.585
cc_1834 ( N_noxref_6_c_2125_p N_noxref_8_c_2850_n ) capacitor c=5.43945e-19 \
 //x=27.06 //y=1.18 //x2=27.17 //y2=1.585
cc_1835 ( N_noxref_6_M16_noxref_d N_noxref_8_c_2850_n ) capacitor \
 c=0.00356097f //x=26.87 //y=1.085 //x2=27.17 //y2=1.585
cc_1836 ( N_noxref_6_c_2125_p N_noxref_8_c_2854_n ) capacitor c=0.00108157f \
 //x=27.06 //y=1.18 //x2=27.325 //y2=1.085
cc_1837 ( N_noxref_6_M16_noxref_d N_noxref_8_c_2854_n ) capacitor \
 c=8.50095e-19 //x=26.87 //y=1.085 //x2=27.325 //y2=1.085
cc_1838 ( N_noxref_6_c_2127_p N_noxref_8_c_2856_n ) capacitor c=0.00341295f \
 //x=27.06 //y=1.75 //x2=27.325 //y2=1.43
cc_1839 ( N_noxref_6_c_2091_p N_noxref_8_c_2856_n ) capacitor c=0.00323005f \
 //x=27.415 //y=1.835 //x2=27.325 //y2=1.43
cc_1840 ( N_noxref_6_c_2125_p N_noxref_8_c_2856_n ) capacitor c=0.00312028f \
 //x=27.06 //y=1.18 //x2=27.325 //y2=1.43
cc_1841 ( N_noxref_6_M16_noxref_d N_noxref_8_c_2856_n ) capacitor \
 c=0.00237422f //x=26.87 //y=1.085 //x2=27.325 //y2=1.43
cc_1842 ( N_noxref_6_c_2075_p N_noxref_8_c_2860_n ) capacitor c=0.00267229f \
 //x=27.5 //y=2.61 //x2=26.76 //y2=2.26
cc_1843 ( N_noxref_6_c_2127_p N_noxref_8_c_2861_n ) capacitor c=0.00341688f \
 //x=27.06 //y=1.75 //x2=26.76 //y2=2.095
cc_1844 ( N_noxref_6_c_2075_p N_noxref_8_c_2861_n ) capacitor c=0.00309058f \
 //x=27.5 //y=2.61 //x2=26.76 //y2=2.095
cc_1845 ( N_noxref_6_c_2082_p N_noxref_8_c_2863_n ) capacitor c=8.43115e-19 \
 //x=26.905 //y=5.38 //x2=26.79 //y2=4.88
cc_1846 ( N_noxref_6_c_2077_p N_noxref_8_c_2863_n ) capacitor c=0.00142201f \
 //x=27.5 //y=5.295 //x2=26.79 //y2=4.88
cc_1847 ( N_noxref_6_c_2078_p N_noxref_10_c_3575_n ) capacitor c=2.8271e-19 \
 //x=29.35 //y=2.61 //x2=31.57 //y2=3.705
cc_1848 ( N_noxref_6_c_2079_p N_noxref_10_c_3575_n ) capacitor c=4.89542e-19 \
 //x=29.35 //y=4.755 //x2=31.57 //y2=3.705
cc_1849 ( N_noxref_6_c_2094_p N_noxref_10_c_3575_n ) capacitor c=4.4924e-19 \
 //x=34.16 //y=2.615 //x2=31.57 //y2=3.705
cc_1850 ( N_noxref_6_c_2096_p N_noxref_10_c_3575_n ) capacitor c=5.49506e-19 \
 //x=34.16 //y=4.755 //x2=31.57 //y2=3.705
cc_1851 ( N_noxref_6_c_2098_p N_noxref_10_c_3575_n ) capacitor c=0.0220649f \
 //x=34 //y=2.775 //x2=31.57 //y2=3.705
cc_1852 ( N_noxref_6_c_2079_p N_noxref_10_c_3580_n ) capacitor c=7.96468e-19 \
 //x=29.35 //y=4.755 //x2=31.57 //y2=4.75
cc_1853 ( N_noxref_6_c_2096_p N_noxref_10_c_3580_n ) capacitor c=0.00104627f \
 //x=34.16 //y=4.755 //x2=31.57 //y2=4.75
cc_1854 ( N_noxref_6_c_2094_p N_noxref_10_c_3582_n ) capacitor c=3.63603e-19 \
 //x=34.16 //y=2.615 //x2=36.38 //y2=3.705
cc_1855 ( N_noxref_6_c_2096_p N_noxref_10_c_3582_n ) capacitor c=4.95724e-19 \
 //x=34.16 //y=4.755 //x2=36.38 //y2=3.705
cc_1856 ( N_noxref_6_c_2096_p N_noxref_10_c_3584_n ) capacitor c=5.89264e-19 \
 //x=34.16 //y=4.755 //x2=36.38 //y2=4.75
cc_1857 ( N_noxref_6_c_2096_p N_noxref_10_c_3585_n ) capacitor c=0.02492f \
 //x=34.16 //y=4.755 //x2=36.54 //y2=3.88
cc_1858 ( N_noxref_6_c_2075_p D ) capacitor c=6.55865e-19 //x=27.5 //y=2.61 \
 //x2=26.02 //y2=2.77
cc_1859 ( N_noxref_6_c_2077_p D ) capacitor c=0.00323473f //x=27.5 //y=5.295 \
 //x2=26.02 //y2=3.88
cc_1860 ( N_noxref_6_c_2164_p N_D_c_5072_n ) capacitor c=0.00153139f //x=26.14 \
 //y=5.56 //x2=26.02 //y2=3.28
cc_1861 ( N_noxref_6_c_2164_p N_D_c_5073_n ) capacitor c=0.0117744f //x=26.14 \
 //y=5.56 //x2=26.02 //y2=4.88
cc_1862 ( N_noxref_6_c_2166_p N_D_c_5073_n ) capacitor c=0.00104426f //x=26.14 \
 //y=5.56 //x2=26.02 //y2=4.88
cc_1863 ( N_noxref_6_c_2076_p N_D_c_5075_n ) capacitor c=0.00956883f //x=27.5 \
 //y=2.93 //x2=27.715 //y2=3.155
cc_1864 ( N_noxref_6_c_2077_p N_D_c_5075_n ) capacitor c=0.0226562f //x=27.5 \
 //y=5.295 //x2=27.715 //y2=3.155
cc_1865 ( N_noxref_6_c_2169_p N_D_c_5075_n ) capacitor c=0.12796f //x=29.19 \
 //y=2.77 //x2=27.715 //y2=3.155
cc_1866 ( N_noxref_6_c_2076_p N_D_c_5046_n ) capacitor c=0.0015398f //x=27.5 \
 //y=2.93 //x2=27.37 //y2=3.155
cc_1867 ( N_noxref_6_c_2077_p N_D_c_5046_n ) capacitor c=3.12067e-19 //x=27.5 \
 //y=5.295 //x2=27.37 //y2=3.155
cc_1868 ( N_noxref_6_c_2081_p N_D_c_5046_n ) capacitor c=0.0358254f //x=27.66 \
 //y=2.77 //x2=27.37 //y2=3.155
cc_1869 ( N_noxref_6_c_2173_p N_D_c_5081_n ) capacitor c=0.00179019f //x=29.35 \
 //y=2.93 //x2=28.965 //y2=3.14
cc_1870 ( N_noxref_6_c_2079_p N_D_c_5081_n ) capacitor c=5.02803e-19 //x=29.35 \
 //y=4.755 //x2=28.965 //y2=3.14
cc_1871 ( N_noxref_6_c_2169_p N_D_c_5081_n ) capacitor c=0.011979f //x=29.19 \
 //y=2.77 //x2=28.965 //y2=3.14
cc_1872 ( N_noxref_6_c_2176_p N_D_c_5081_n ) capacitor c=0.0358254f //x=29.51 \
 //y=2.77 //x2=28.965 //y2=3.14
cc_1873 ( N_noxref_6_c_2173_p N_D_c_5085_n ) capacitor c=0.00693044f //x=29.35 \
 //y=2.93 //x2=29.565 //y2=3.155
cc_1874 ( N_noxref_6_c_2079_p N_D_c_5085_n ) capacitor c=0.0239409f //x=29.35 \
 //y=4.755 //x2=29.565 //y2=3.155
cc_1875 ( N_noxref_6_c_2098_p N_D_c_5085_n ) capacitor c=0.378965f //x=34 \
 //y=2.775 //x2=29.565 //y2=3.155
cc_1876 ( N_noxref_6_c_2095_p N_D_c_5088_n ) capacitor c=0.00515354f //x=34.16 \
 //y=2.935 //x2=33.775 //y2=3.14
cc_1877 ( N_noxref_6_c_2096_p N_D_c_5088_n ) capacitor c=6.2418e-19 //x=34.16 \
 //y=4.755 //x2=33.775 //y2=3.14
cc_1878 ( N_noxref_6_c_2097_p N_D_c_5088_n ) capacitor c=0.0358254f //x=34.16 \
 //y=2.775 //x2=33.775 //y2=3.14
cc_1879 ( N_noxref_6_c_2098_p N_D_c_5088_n ) capacitor c=0.0107141f //x=34 \
 //y=2.775 //x2=33.775 //y2=3.14
cc_1880 ( N_noxref_6_c_2095_p N_D_c_5092_n ) capacitor c=0.00356853f //x=34.16 \
 //y=2.935 //x2=34.375 //y2=3.16
cc_1881 ( N_noxref_6_c_2096_p N_D_c_5092_n ) capacitor c=0.0242471f //x=34.16 \
 //y=4.755 //x2=34.375 //y2=3.16
cc_1882 ( N_noxref_6_c_2164_p N_D_c_5094_n ) capacitor c=0.00277154f //x=26.14 \
 //y=5.56 //x2=26.02 //y2=4.88
cc_1883 ( N_noxref_6_c_2166_p N_D_c_5094_n ) capacitor c=0.00377369f //x=26.14 \
 //y=5.56 //x2=26.02 //y2=4.88
cc_1884 ( N_noxref_6_c_2164_p N_D_M82_noxref_g ) capacitor c=0.00201806f \
 //x=26.14 //y=5.56 //x2=25.92 //y2=6.2
cc_1885 ( N_noxref_6_c_2166_p N_D_M82_noxref_g ) capacitor c=0.0158358f \
 //x=26.14 //y=5.56 //x2=25.92 //y2=6.2
cc_1886 ( N_noxref_6_c_2082_p N_D_M83_noxref_g ) capacitor c=0.00889217f \
 //x=26.905 //y=5.38 //x2=26.36 //y2=6.2
cc_1887 ( N_noxref_6_c_2164_p N_D_M83_noxref_g ) capacitor c=0.00192712f \
 //x=26.14 //y=5.56 //x2=26.36 //y2=6.2
cc_1888 ( N_noxref_6_c_2166_p N_D_M83_noxref_g ) capacitor c=0.0178987f \
 //x=26.14 //y=5.56 //x2=26.36 //y2=6.2
cc_1889 ( N_noxref_6_c_2164_p N_D_c_5101_n ) capacitor c=0.00193167f //x=26.14 \
 //y=5.56 //x2=26.02 //y2=4.88
cc_1890 ( N_noxref_6_c_2166_p N_D_c_5101_n ) capacitor c=0.0043218f //x=26.14 \
 //y=5.56 //x2=26.02 //y2=4.88
cc_1891 ( N_noxref_6_c_2075_p CLK ) capacitor c=3.323e-19 //x=27.5 //y=2.61 \
 //x2=30.46 //y2=3.88
cc_1892 ( N_noxref_6_c_2077_p CLK ) capacitor c=0.00111996f //x=27.5 //y=5.295 \
 //x2=30.46 //y2=3.88
cc_1893 ( N_noxref_6_c_2078_p CLK ) capacitor c=0.00480066f //x=29.35 //y=2.61 \
 //x2=30.46 //y2=3.88
cc_1894 ( N_noxref_6_c_2173_p CLK ) capacitor c=0.00765388f //x=29.35 //y=2.93 \
 //x2=30.46 //y2=3.88
cc_1895 ( N_noxref_6_c_2079_p CLK ) capacitor c=0.041355f //x=29.35 //y=4.755 \
 //x2=30.46 //y2=3.88
cc_1896 ( N_noxref_6_c_2200_p CLK ) capacitor c=2.98349e-19 //x=29.35 \
 //y=2.765 //x2=30.46 //y2=3.88
cc_1897 ( N_noxref_6_c_2176_p CLK ) capacitor c=0.00242466f //x=29.51 //y=2.77 \
 //x2=30.46 //y2=3.88
cc_1898 ( N_noxref_6_c_2098_p CLK ) capacitor c=0.0229358f //x=34 //y=2.775 \
 //x2=30.46 //y2=3.88
cc_1899 ( N_noxref_6_c_2203_p CLK ) capacitor c=3.9149e-19 //x=29.35 //y=2.26 \
 //x2=30.46 //y2=3.88
cc_1900 ( N_noxref_6_c_2204_p N_CLK_c_6544_n ) capacitor c=0.0090811f \
 //x=29.35 //y=2.375 //x2=30.46 //y2=2.375
cc_1901 ( N_noxref_6_c_2203_p N_CLK_c_6544_n ) capacitor c=5.40058e-19 \
 //x=29.35 //y=2.26 //x2=30.46 //y2=2.375
cc_1902 ( N_noxref_6_c_2206_p N_CLK_c_6544_n ) capacitor c=0.00142893f \
 //x=29.05 //y=2.095 //x2=30.46 //y2=2.375
cc_1903 ( N_noxref_6_c_2079_p N_CLK_c_6547_n ) capacitor c=0.0112048f \
 //x=29.35 //y=4.755 //x2=30.46 //y2=4.755
cc_1904 ( N_noxref_6_c_2208_p N_CLK_c_6547_n ) capacitor c=8.35331e-19 \
 //x=29.35 //y=4.88 //x2=30.46 //y2=4.755
cc_1905 ( N_noxref_6_c_2107_p N_CLK_c_6547_n ) capacitor c=7.55789e-19 \
 //x=29.915 //y=4.97 //x2=30.46 //y2=4.755
cc_1906 ( N_noxref_6_c_2210_p N_CLK_c_6547_n ) capacitor c=8.63332e-19 \
 //x=29.625 //y=4.97 //x2=30.46 //y2=4.755
cc_1907 ( N_noxref_6_c_2082_p N_CLK_c_6476_n ) capacitor c=0.00721625f \
 //x=26.905 //y=5.38 //x2=26.375 //y2=4.62
cc_1908 ( N_noxref_6_c_2164_p N_CLK_c_6476_n ) capacitor c=0.0152375f \
 //x=26.14 //y=5.56 //x2=26.375 //y2=4.62
cc_1909 ( N_noxref_6_c_2085_p N_CLK_c_6553_n ) capacitor c=0.00542891f \
 //x=27.02 //y=5.38 //x2=26.975 //y2=4.63
cc_1910 ( N_noxref_6_c_2077_p N_CLK_c_6554_n ) capacitor c=0.0289828f //x=27.5 \
 //y=5.295 //x2=32.175 //y2=4.635
cc_1911 ( N_noxref_6_c_2079_p N_CLK_c_6554_n ) capacitor c=0.0375889f \
 //x=29.35 //y=4.755 //x2=32.175 //y2=4.635
cc_1912 ( N_noxref_6_c_2085_p N_CLK_c_6554_n ) capacitor c=0.0155304f \
 //x=27.02 //y=5.38 //x2=32.175 //y2=4.635
cc_1913 ( N_noxref_6_c_2096_p N_CLK_c_6557_n ) capacitor c=0.0332184f \
 //x=34.16 //y=4.755 //x2=42.17 //y2=4.65
cc_1914 ( N_noxref_6_c_2204_p N_CLK_c_6558_n ) capacitor c=5.39999e-19 \
 //x=29.35 //y=2.375 //x2=30.46 //y2=2.26
cc_1915 ( N_noxref_6_c_2078_p N_CLK_c_6558_n ) capacitor c=3.9149e-19 \
 //x=29.35 //y=2.61 //x2=30.46 //y2=2.26
cc_1916 ( N_noxref_6_c_2203_p N_CLK_c_6558_n ) capacitor c=0.00125213f \
 //x=29.35 //y=2.26 //x2=30.46 //y2=2.26
cc_1917 ( N_noxref_6_c_2206_p N_CLK_c_6558_n ) capacitor c=0.00214573f \
 //x=29.05 //y=2.095 //x2=30.46 //y2=2.26
cc_1918 ( N_noxref_6_c_2079_p N_CLK_c_6562_n ) capacitor c=5.64453e-19 \
 //x=29.35 //y=4.755 //x2=30.46 //y2=4.88
cc_1919 ( N_noxref_6_c_2208_p N_CLK_c_6562_n ) capacitor c=0.00113668f \
 //x=29.35 //y=4.88 //x2=30.46 //y2=4.88
cc_1920 ( N_noxref_6_c_2107_p N_CLK_c_6562_n ) capacitor c=0.00116563f \
 //x=29.915 //y=4.97 //x2=30.46 //y2=4.88
cc_1921 ( N_noxref_6_c_2210_p N_CLK_c_6562_n ) capacitor c=0.0012974f \
 //x=29.625 //y=4.97 //x2=30.46 //y2=4.88
cc_1922 ( N_noxref_6_M86_noxref_g N_CLK_M88_noxref_g ) capacitor c=0.0106276f \
 //x=29.55 //y=6.2 //x2=30.43 //y2=6.2
cc_1923 ( N_noxref_6_M87_noxref_g N_CLK_M88_noxref_g ) capacitor c=0.107144f \
 //x=29.99 //y=6.2 //x2=30.43 //y2=6.2
cc_1924 ( N_noxref_6_M87_noxref_g N_CLK_M89_noxref_g ) capacitor c=0.0101598f \
 //x=29.99 //y=6.2 //x2=30.87 //y2=6.2
cc_1925 ( N_noxref_6_c_2229_p N_CLK_c_6569_n ) capacitor c=5.72528e-19 \
 //x=29.05 //y=1.055 //x2=30.025 //y2=1.09
cc_1926 ( N_noxref_6_c_2230_p N_CLK_c_6569_n ) capacitor c=0.00150277f \
 //x=29.05 //y=1.4 //x2=30.025 //y2=1.09
cc_1927 ( N_noxref_6_c_2231_p N_CLK_c_6569_n ) capacitor c=0.0160123f \
 //x=29.58 //y=1.055 //x2=30.025 //y2=1.09
cc_1928 ( N_noxref_6_c_2232_p N_CLK_c_6572_n ) capacitor c=0.00111227f \
 //x=29.05 //y=1.71 //x2=30.025 //y2=1.4
cc_1929 ( N_noxref_6_c_2233_p N_CLK_c_6572_n ) capacitor c=0.0124075f \
 //x=29.58 //y=1.4 //x2=30.025 //y2=1.4
cc_1930 ( N_noxref_6_c_2231_p N_CLK_c_6574_n ) capacitor c=9.19165e-19 \
 //x=29.58 //y=1.055 //x2=30.55 //y2=1.09
cc_1931 ( N_noxref_6_c_2233_p N_CLK_c_6575_n ) capacitor c=0.0010154f \
 //x=29.58 //y=1.4 //x2=30.55 //y2=1.4
cc_1932 ( N_noxref_6_c_2233_p N_CLK_c_6576_n ) capacitor c=9.23422e-19 \
 //x=29.58 //y=1.4 //x2=30.55 //y2=1.63
cc_1933 ( N_noxref_6_c_2204_p N_CLK_c_6577_n ) capacitor c=0.0013537f \
 //x=29.35 //y=2.375 //x2=30.55 //y2=2.095
cc_1934 ( N_noxref_6_c_2203_p N_CLK_c_6577_n ) capacitor c=0.0020754f \
 //x=29.35 //y=2.26 //x2=30.55 //y2=2.095
cc_1935 ( N_noxref_6_c_2206_p N_CLK_c_6577_n ) capacitor c=0.00964411f \
 //x=29.05 //y=2.095 //x2=30.55 //y2=2.095
cc_1936 ( N_noxref_6_c_2208_p N_CLK_c_6580_n ) capacitor c=0.00123917f \
 //x=29.35 //y=4.88 //x2=30.46 //y2=4.88
cc_1937 ( N_noxref_6_c_2107_p N_CLK_c_6580_n ) capacitor c=0.0171228f \
 //x=29.915 //y=4.97 //x2=30.46 //y2=4.88
cc_1938 ( N_noxref_6_c_2210_p N_CLK_c_6580_n ) capacitor c=0.00406071f \
 //x=29.625 //y=4.97 //x2=30.46 //y2=4.88
cc_1939 ( N_noxref_6_c_2093_p N_SN_c_8253_n ) capacitor c=0.00790396f \
 //x=34.16 //y=2.375 //x2=35.27 //y2=2.55
cc_1940 ( N_noxref_6_c_2094_p N_SN_c_8253_n ) capacitor c=0.00345228f \
 //x=34.16 //y=2.615 //x2=35.27 //y2=2.55
cc_1941 ( N_noxref_6_c_2245_p N_SN_c_8253_n ) capacitor c=0.00116411f \
 //x=34.16 //y=2.26 //x2=35.27 //y2=2.55
cc_1942 ( N_noxref_6_c_2246_p N_SN_c_8253_n ) capacitor c=0.0015646f //x=33.86 \
 //y=2.095 //x2=35.27 //y2=2.55
cc_1943 ( N_noxref_6_c_2094_p N_SN_c_8257_n ) capacitor c=0.00188309f \
 //x=34.16 //y=2.615 //x2=35.27 //y2=4.765
cc_1944 ( N_noxref_6_c_2095_p N_SN_c_8257_n ) capacitor c=0.00775314f \
 //x=34.16 //y=2.935 //x2=35.27 //y2=4.765
cc_1945 ( N_noxref_6_c_2096_p N_SN_c_8257_n ) capacitor c=0.052298f //x=34.16 \
 //y=4.755 //x2=35.27 //y2=4.765
cc_1946 ( N_noxref_6_c_2071_p N_SN_c_8257_n ) capacitor c=2.69051e-19 \
 //x=34.16 //y=2.77 //x2=35.27 //y2=4.765
cc_1947 ( N_noxref_6_c_2097_p N_SN_c_8257_n ) capacitor c=0.00508119f \
 //x=34.16 //y=2.775 //x2=35.27 //y2=4.765
cc_1948 ( N_noxref_6_c_2252_p N_SN_c_8257_n ) capacitor c=6.26008e-19 \
 //x=34.16 //y=4.88 //x2=35.27 //y2=4.765
cc_1949 ( N_noxref_6_c_2070_p N_SN_c_8257_n ) capacitor c=7.66769e-19 \
 //x=34.725 //y=4.97 //x2=35.27 //y2=4.765
cc_1950 ( N_noxref_6_c_2254_p N_SN_c_8257_n ) capacitor c=7.54501e-19 \
 //x=34.435 //y=4.97 //x2=35.27 //y2=4.765
cc_1951 ( N_noxref_6_c_2075_p N_SN_c_8265_n ) capacitor c=0.0275808f //x=27.5 \
 //y=2.61 //x2=27.715 //y2=2.385
cc_1952 ( N_noxref_6_c_2076_p N_SN_c_8265_n ) capacitor c=0.00571217f //x=27.5 \
 //y=2.93 //x2=27.715 //y2=2.385
cc_1953 ( N_noxref_6_c_2169_p N_SN_c_8265_n ) capacitor c=0.132536f //x=29.19 \
 //y=2.77 //x2=27.715 //y2=2.385
cc_1954 ( N_noxref_6_c_2081_p N_SN_c_8265_n ) capacitor c=0.0365231f //x=27.66 \
 //y=2.77 //x2=27.715 //y2=2.385
cc_1955 ( N_noxref_6_c_2091_p N_SN_c_8145_n ) capacitor c=0.00854423f \
 //x=27.415 //y=1.835 //x2=27.285 //y2=2.385
cc_1956 ( N_noxref_6_c_2083_p N_SN_c_8145_n ) capacitor c=0.0104657f \
 //x=27.145 //y=1.835 //x2=27.285 //y2=2.385
cc_1957 ( N_noxref_6_c_2075_p N_SN_c_8145_n ) capacitor c=3.12067e-19 //x=27.5 \
 //y=2.61 //x2=27.285 //y2=2.385
cc_1958 ( N_noxref_6_c_2125_p N_SN_c_8145_n ) capacitor c=7.47115e-19 \
 //x=27.06 //y=1.18 //x2=27.285 //y2=2.385
cc_1959 ( N_noxref_6_c_2078_p N_SN_c_8273_n ) capacitor c=5.02803e-19 \
 //x=29.35 //y=2.61 //x2=28.965 //y2=2.4
cc_1960 ( N_noxref_6_c_2169_p N_SN_c_8273_n ) capacitor c=0.0124949f //x=29.19 \
 //y=2.77 //x2=28.965 //y2=2.4
cc_1961 ( N_noxref_6_c_2204_p N_SN_c_8275_n ) capacitor c=0.0168589f //x=29.35 \
 //y=2.375 //x2=29.565 //y2=2.385
cc_1962 ( N_noxref_6_c_2078_p N_SN_c_8275_n ) capacitor c=0.0125409f //x=29.35 \
 //y=2.61 //x2=29.565 //y2=2.385
cc_1963 ( N_noxref_6_c_2173_p N_SN_c_8275_n ) capacitor c=0.0074164f //x=29.35 \
 //y=2.93 //x2=29.565 //y2=2.385
cc_1964 ( N_noxref_6_c_2176_p N_SN_c_8275_n ) capacitor c=0.0370413f //x=29.51 \
 //y=2.77 //x2=29.565 //y2=2.385
cc_1965 ( N_noxref_6_c_2098_p N_SN_c_8275_n ) capacitor c=0.398778f //x=34 \
 //y=2.775 //x2=29.565 //y2=2.385
cc_1966 ( N_noxref_6_c_2203_p N_SN_c_8275_n ) capacitor c=5.18204e-19 \
 //x=29.35 //y=2.26 //x2=29.565 //y2=2.385
cc_1967 ( N_noxref_6_c_2206_p N_SN_c_8275_n ) capacitor c=3.41298e-19 \
 //x=29.05 //y=2.095 //x2=29.565 //y2=2.385
cc_1968 ( N_noxref_6_c_2094_p N_SN_c_8282_n ) capacitor c=3.12053e-19 \
 //x=34.16 //y=2.615 //x2=33.775 //y2=2.4
cc_1969 ( N_noxref_6_c_2095_p N_SN_c_8282_n ) capacitor c=0.00336759f \
 //x=34.16 //y=2.935 //x2=33.775 //y2=2.4
cc_1970 ( N_noxref_6_c_2098_p N_SN_c_8282_n ) capacitor c=0.0111801f //x=34 \
 //y=2.775 //x2=33.775 //y2=2.4
cc_1971 ( N_noxref_6_c_2093_p N_SN_c_8285_n ) capacitor c=0.0163574f //x=34.16 \
 //y=2.375 //x2=34.375 //y2=2.39
cc_1972 ( N_noxref_6_c_2094_p N_SN_c_8285_n ) capacitor c=0.012564f //x=34.16 \
 //y=2.615 //x2=34.375 //y2=2.39
cc_1973 ( N_noxref_6_c_2095_p N_SN_c_8285_n ) capacitor c=0.00455777f \
 //x=34.16 //y=2.935 //x2=34.375 //y2=2.39
cc_1974 ( N_noxref_6_c_2097_p N_SN_c_8285_n ) capacitor c=0.0370413f //x=34.16 \
 //y=2.775 //x2=34.375 //y2=2.39
cc_1975 ( N_noxref_6_c_2245_p N_SN_c_8285_n ) capacitor c=2.54369e-19 \
 //x=34.16 //y=2.26 //x2=34.375 //y2=2.39
cc_1976 ( N_noxref_6_c_2246_p N_SN_c_8285_n ) capacitor c=3.41298e-19 \
 //x=33.86 //y=2.095 //x2=34.375 //y2=2.39
cc_1977 ( N_noxref_6_c_2093_p N_SN_c_8291_n ) capacitor c=0.00183592f \
 //x=34.16 //y=2.375 //x2=35.43 //y2=2.4
cc_1978 ( N_noxref_6_c_2094_p N_SN_c_8291_n ) capacitor c=0.00129472f \
 //x=34.16 //y=2.615 //x2=35.43 //y2=2.4
cc_1979 ( N_noxref_6_c_2093_p N_SN_c_8293_n ) capacitor c=5.39999e-19 \
 //x=34.16 //y=2.375 //x2=35.27 //y2=2.26
cc_1980 ( N_noxref_6_c_2245_p N_SN_c_8293_n ) capacitor c=0.00124907f \
 //x=34.16 //y=2.26 //x2=35.27 //y2=2.26
cc_1981 ( N_noxref_6_c_2246_p N_SN_c_8293_n ) capacitor c=0.00214501f \
 //x=33.86 //y=2.095 //x2=35.27 //y2=2.26
cc_1982 ( N_noxref_6_c_2096_p N_SN_c_8296_n ) capacitor c=0.00103399f \
 //x=34.16 //y=4.755 //x2=35.27 //y2=4.88
cc_1983 ( N_noxref_6_c_2252_p N_SN_c_8296_n ) capacitor c=0.00113984f \
 //x=34.16 //y=4.88 //x2=35.27 //y2=4.88
cc_1984 ( N_noxref_6_c_2070_p N_SN_c_8296_n ) capacitor c=0.00116563f \
 //x=34.725 //y=4.97 //x2=35.27 //y2=4.88
cc_1985 ( N_noxref_6_c_2254_p N_SN_c_8296_n ) capacitor c=0.00129812f \
 //x=34.435 //y=4.97 //x2=35.27 //y2=4.88
cc_1986 ( N_noxref_6_M92_noxref_g N_SN_M94_noxref_g ) capacitor c=0.0106276f \
 //x=34.36 //y=6.2 //x2=35.24 //y2=6.2
cc_1987 ( N_noxref_6_M93_noxref_g N_SN_M94_noxref_g ) capacitor c=0.107144f \
 //x=34.8 //y=6.2 //x2=35.24 //y2=6.2
cc_1988 ( N_noxref_6_M93_noxref_g N_SN_M95_noxref_g ) capacitor c=0.0101598f \
 //x=34.8 //y=6.2 //x2=35.68 //y2=6.2
cc_1989 ( N_noxref_6_c_2293_p N_SN_c_8303_n ) capacitor c=5.72528e-19 \
 //x=33.86 //y=1.055 //x2=34.835 //y2=1.09
cc_1990 ( N_noxref_6_c_2294_p N_SN_c_8303_n ) capacitor c=0.00150277f \
 //x=33.86 //y=1.4 //x2=34.835 //y2=1.09
cc_1991 ( N_noxref_6_c_2295_p N_SN_c_8303_n ) capacitor c=0.0160123f //x=34.39 \
 //y=1.055 //x2=34.835 //y2=1.09
cc_1992 ( N_noxref_6_c_2296_p N_SN_c_8306_n ) capacitor c=0.00111227f \
 //x=33.86 //y=1.71 //x2=34.835 //y2=1.4
cc_1993 ( N_noxref_6_c_2297_p N_SN_c_8306_n ) capacitor c=0.0124075f //x=34.39 \
 //y=1.4 //x2=34.835 //y2=1.4
cc_1994 ( N_noxref_6_c_2295_p N_SN_c_8308_n ) capacitor c=9.19165e-19 \
 //x=34.39 //y=1.055 //x2=35.36 //y2=1.09
cc_1995 ( N_noxref_6_c_2297_p N_SN_c_8309_n ) capacitor c=0.0010154f //x=34.39 \
 //y=1.4 //x2=35.36 //y2=1.4
cc_1996 ( N_noxref_6_c_2297_p N_SN_c_8310_n ) capacitor c=9.23422e-19 \
 //x=34.39 //y=1.4 //x2=35.36 //y2=1.63
cc_1997 ( N_noxref_6_c_2093_p N_SN_c_8311_n ) capacitor c=5.616e-19 //x=34.16 \
 //y=2.375 //x2=35.36 //y2=2.095
cc_1998 ( N_noxref_6_c_2245_p N_SN_c_8311_n ) capacitor c=0.0017273f //x=34.16 \
 //y=2.26 //x2=35.36 //y2=2.095
cc_1999 ( N_noxref_6_c_2246_p N_SN_c_8311_n ) capacitor c=0.00880777f \
 //x=33.86 //y=2.095 //x2=35.36 //y2=2.095
cc_2000 ( N_noxref_6_c_2096_p N_SN_c_8314_n ) capacitor c=0.00116212f \
 //x=34.16 //y=4.755 //x2=35.27 //y2=4.88
cc_2001 ( N_noxref_6_c_2252_p N_SN_c_8314_n ) capacitor c=0.00155973f \
 //x=34.16 //y=4.88 //x2=35.27 //y2=4.88
cc_2002 ( N_noxref_6_c_2070_p N_SN_c_8314_n ) capacitor c=0.0171374f \
 //x=34.725 //y=4.97 //x2=35.27 //y2=4.88
cc_2003 ( N_noxref_6_c_2254_p N_SN_c_8314_n ) capacitor c=0.00484466f \
 //x=34.435 //y=4.97 //x2=35.27 //y2=4.88
cc_2004 ( N_noxref_6_c_2164_p N_noxref_21_c_10519_n ) capacitor c=5.58535e-19 \
 //x=26.14 //y=5.56 //x2=23.39 //y2=5.56
cc_2005 ( N_noxref_6_c_2164_p N_noxref_21_c_10521_n ) capacitor c=0.00104762f \
 //x=26.14 //y=5.56 //x2=24.085 //y2=5.335
cc_2006 ( N_noxref_6_c_2125_p N_noxref_21_c_10525_n ) capacitor c=6.5615e-19 \
 //x=27.06 //y=1.18 //x2=23.685 //y2=1.305
cc_2007 ( N_noxref_6_c_2127_p N_noxref_21_c_10462_n ) capacitor c=0.00326079f \
 //x=27.06 //y=1.75 //x2=23.685 //y2=1.76
cc_2008 ( N_noxref_6_c_2083_p N_noxref_21_c_10536_n ) capacitor c=0.00218808f \
 //x=27.145 //y=1.835 //x2=24.085 //y2=1.845
cc_2009 ( N_noxref_6_c_2075_p N_noxref_21_c_10536_n ) capacitor c=0.00203766f \
 //x=27.5 //y=2.61 //x2=24.085 //y2=1.845
cc_2010 ( N_noxref_6_c_2077_p N_noxref_21_c_10544_n ) capacitor c=0.0028534f \
 //x=27.5 //y=5.295 //x2=24.17 //y2=5.25
cc_2011 ( N_noxref_6_c_2098_p N_noxref_21_c_10581_n ) capacitor c=0.0129689f \
 //x=34 //y=2.775 //x2=31.79 //y2=3.48
cc_2012 ( N_noxref_6_c_2077_p N_noxref_21_c_10561_n ) capacitor c=0.0258715f \
 //x=27.5 //y=5.295 //x2=31.36 //y2=3.48
cc_2013 ( N_noxref_6_c_2079_p N_noxref_21_c_10561_n ) capacitor c=0.0273223f \
 //x=29.35 //y=4.755 //x2=31.36 //y2=3.48
cc_2014 ( N_noxref_6_c_2169_p N_noxref_21_c_10561_n ) capacitor c=0.00880217f \
 //x=29.19 //y=2.77 //x2=31.36 //y2=3.48
cc_2015 ( N_noxref_6_c_2098_p N_noxref_21_c_10561_n ) capacitor c=0.0197439f \
 //x=34 //y=2.775 //x2=31.36 //y2=3.48
cc_2016 ( N_noxref_6_c_2096_p N_noxref_21_c_10586_n ) capacitor c=0.0245532f \
 //x=34.16 //y=4.755 //x2=35.995 //y2=3.51
cc_2017 ( N_noxref_6_c_2082_p N_VDD_c_11522_n ) capacitor c=0.00648286f \
 //x=26.905 //y=5.38 //x2=74.455 //y2=7.585
cc_2018 ( N_noxref_6_c_2122_p N_VDD_c_11522_n ) capacitor c=0.00488503f \
 //x=27.415 //y=5.38 //x2=74.455 //y2=7.585
cc_2019 ( N_noxref_6_c_2164_p N_VDD_c_11522_n ) capacitor c=0.00368817f \
 //x=26.14 //y=5.56 //x2=74.455 //y2=7.585
cc_2020 ( N_noxref_6_c_2085_p N_VDD_c_11522_n ) capacitor c=8.42537e-19 \
 //x=27.02 //y=5.38 //x2=74.455 //y2=7.585
cc_2021 ( N_noxref_6_c_2325_p N_VDD_c_11522_n ) capacitor c=0.00285853f \
 //x=27.02 //y=5.56 //x2=74.455 //y2=7.585
cc_2022 ( N_noxref_6_c_2166_p N_VDD_c_11522_n ) capacitor c=0.00224881f \
 //x=26.14 //y=5.56 //x2=74.455 //y2=7.585
cc_2023 ( N_noxref_6_c_2086_p N_VDD_c_11522_n ) capacitor c=0.00224881f \
 //x=27.02 //y=5.56 //x2=74.455 //y2=7.585
cc_2024 ( N_noxref_6_c_2082_p N_VDD_c_11829_n ) capacitor c=0.00208087f \
 //x=26.905 //y=5.38 //x2=26.495 //y2=7.585
cc_2025 ( N_noxref_6_c_2164_p N_VDD_c_11829_n ) capacitor c=9.41185e-19 \
 //x=26.14 //y=5.56 //x2=26.495 //y2=7.585
cc_2026 ( N_noxref_6_c_2166_p N_VDD_c_11829_n ) capacitor c=0.0136705f \
 //x=26.14 //y=5.56 //x2=26.495 //y2=7.585
cc_2027 ( N_noxref_6_c_2082_p N_VDD_c_11832_n ) capacitor c=0.00180737f \
 //x=26.905 //y=5.38 //x2=27.375 //y2=7.585
cc_2028 ( N_noxref_6_c_2122_p N_VDD_c_11832_n ) capacitor c=0.00208087f \
 //x=27.415 //y=5.38 //x2=27.375 //y2=7.585
cc_2029 ( N_noxref_6_c_2085_p N_VDD_c_11832_n ) capacitor c=4.23719e-19 \
 //x=27.02 //y=5.38 //x2=27.375 //y2=7.585
cc_2030 ( N_noxref_6_c_2325_p N_VDD_c_11832_n ) capacitor c=5.77976e-19 \
 //x=27.02 //y=5.56 //x2=27.375 //y2=7.585
cc_2031 ( N_noxref_6_c_2086_p N_VDD_c_11832_n ) capacitor c=0.0136705f \
 //x=27.02 //y=5.56 //x2=27.375 //y2=7.585
cc_2032 ( N_noxref_6_M86_noxref_g N_VDD_c_11837_n ) capacitor c=0.00755614f \
 //x=29.55 //y=6.2 //x2=30.125 //y2=7.585
cc_2033 ( N_noxref_6_M87_noxref_g N_VDD_c_11837_n ) capacitor c=0.00755544f \
 //x=29.99 //y=6.2 //x2=30.125 //y2=7.585
cc_2034 ( N_noxref_6_M92_noxref_g N_VDD_c_11839_n ) capacitor c=0.00755614f \
 //x=34.36 //y=6.2 //x2=34.935 //y2=7.585
cc_2035 ( N_noxref_6_M93_noxref_g N_VDD_c_11839_n ) capacitor c=0.00755544f \
 //x=34.8 //y=6.2 //x2=34.935 //y2=7.585
cc_2036 ( N_noxref_6_c_2077_p N_VDD_c_11799_n ) capacitor c=0.0013228f \
 //x=27.5 //y=5.295 //x2=24.91 //y2=7.585
cc_2037 ( N_noxref_6_c_2164_p N_VDD_c_11799_n ) capacitor c=4.91377e-19 \
 //x=26.14 //y=5.56 //x2=24.91 //y2=7.585
cc_2038 ( N_noxref_6_c_2166_p N_VDD_c_11799_n ) capacitor c=0.0064135f \
 //x=26.14 //y=5.56 //x2=24.91 //y2=7.585
cc_2039 ( N_noxref_6_c_2077_p N_VDD_c_11844_n ) capacitor c=0.0294123f \
 //x=27.5 //y=5.295 //x2=28.24 //y2=7.585
cc_2040 ( N_noxref_6_c_2079_p N_VDD_c_11844_n ) capacitor c=0.0120355f \
 //x=29.35 //y=4.755 //x2=28.24 //y2=7.585
cc_2041 ( N_noxref_6_c_2085_p N_VDD_c_11844_n ) capacitor c=0.0025639f \
 //x=27.02 //y=5.38 //x2=28.24 //y2=7.585
cc_2042 ( N_noxref_6_c_2325_p N_VDD_c_11844_n ) capacitor c=4.19141e-19 \
 //x=27.02 //y=5.56 //x2=28.24 //y2=7.585
cc_2043 ( N_noxref_6_c_2086_p N_VDD_c_11844_n ) capacitor c=0.0101861f \
 //x=27.02 //y=5.56 //x2=28.24 //y2=7.585
cc_2044 ( N_noxref_6_c_2208_p N_VDD_c_11844_n ) capacitor c=0.00370784f \
 //x=29.35 //y=4.88 //x2=28.24 //y2=7.585
cc_2045 ( N_noxref_6_c_2210_p N_VDD_c_11844_n ) capacitor c=0.00590568f \
 //x=29.625 //y=4.97 //x2=28.24 //y2=7.585
cc_2046 ( N_noxref_6_c_2096_p N_VDD_c_11851_n ) capacitor c=0.0116769f \
 //x=34.16 //y=4.755 //x2=33.05 //y2=7.585
cc_2047 ( N_noxref_6_c_2252_p N_VDD_c_11851_n ) capacitor c=0.00370784f \
 //x=34.16 //y=4.88 //x2=33.05 //y2=7.585
cc_2048 ( N_noxref_6_c_2254_p N_VDD_c_11851_n ) capacitor c=0.00590568f \
 //x=34.435 //y=4.97 //x2=33.05 //y2=7.585
cc_2049 ( N_noxref_6_c_2164_p N_VDD_M82_noxref_s ) capacitor c=0.0611368f \
 //x=26.14 //y=5.56 //x2=25.565 //y2=5.2
cc_2050 ( N_noxref_6_c_2085_p N_VDD_M82_noxref_s ) capacitor c=6.52457e-19 \
 //x=27.02 //y=5.38 //x2=25.565 //y2=5.2
cc_2051 ( N_noxref_6_c_2166_p N_VDD_M82_noxref_s ) capacitor c=0.0887533f \
 //x=26.14 //y=5.56 //x2=25.565 //y2=5.2
cc_2052 ( N_noxref_6_c_2082_p N_VDD_M83_noxref_d ) capacitor c=0.00734094f \
 //x=26.905 //y=5.38 //x2=26.435 //y2=5.2
cc_2053 ( N_noxref_6_c_2164_p N_VDD_M83_noxref_d ) capacitor c=0.0043528f \
 //x=26.14 //y=5.56 //x2=26.435 //y2=5.2
cc_2054 ( N_noxref_6_c_2325_p N_VDD_M83_noxref_d ) capacitor c=0.0043528f \
 //x=27.02 //y=5.56 //x2=26.435 //y2=5.2
cc_2055 ( N_noxref_6_c_2166_p N_VDD_M83_noxref_d ) capacitor c=0.065554f \
 //x=26.14 //y=5.56 //x2=26.435 //y2=5.2
cc_2056 ( N_noxref_6_c_2086_p N_VDD_M83_noxref_d ) capacitor c=0.065554f \
 //x=27.02 //y=5.56 //x2=26.435 //y2=5.2
cc_2057 ( N_noxref_6_c_2122_p N_VDD_M85_noxref_d ) capacitor c=0.00983727f \
 //x=27.415 //y=5.38 //x2=27.315 //y2=5.2
cc_2058 ( N_noxref_6_c_2325_p N_VDD_M85_noxref_d ) capacitor c=0.00955781f \
 //x=27.02 //y=5.56 //x2=27.315 //y2=5.2
cc_2059 ( N_noxref_6_c_2080_p N_VDD_M85_noxref_d ) capacitor c=6.87256e-19 \
 //x=27.5 //y=2.77 //x2=27.315 //y2=5.2
cc_2060 ( N_noxref_6_c_2086_p N_VDD_M85_noxref_d ) capacitor c=0.065554f \
 //x=27.02 //y=5.56 //x2=27.315 //y2=5.2
cc_2061 ( N_noxref_6_c_2122_p N_VDD_M86_noxref_s ) capacitor c=0.00220019f \
 //x=27.415 //y=5.38 //x2=29.195 //y2=5.2
cc_2062 ( N_noxref_6_c_2173_p N_VDD_M86_noxref_s ) capacitor c=4.32734e-19 \
 //x=29.35 //y=2.93 //x2=29.195 //y2=5.2
cc_2063 ( N_noxref_6_c_2079_p N_VDD_M86_noxref_s ) capacitor c=0.0217981f \
 //x=29.35 //y=4.755 //x2=29.195 //y2=5.2
cc_2064 ( N_noxref_6_c_2085_p N_VDD_M86_noxref_s ) capacitor c=0.00371125f \
 //x=27.02 //y=5.38 //x2=29.195 //y2=5.2
cc_2065 ( N_noxref_6_c_2325_p N_VDD_M86_noxref_s ) capacitor c=9.52042e-19 \
 //x=27.02 //y=5.56 //x2=29.195 //y2=5.2
cc_2066 ( N_noxref_6_c_2208_p N_VDD_M86_noxref_s ) capacitor c=0.00983846f \
 //x=29.35 //y=4.88 //x2=29.195 //y2=5.2
cc_2067 ( N_noxref_6_M86_noxref_g N_VDD_M86_noxref_s ) capacitor c=0.053419f \
 //x=29.55 //y=6.2 //x2=29.195 //y2=5.2
cc_2068 ( N_noxref_6_c_2210_p N_VDD_M86_noxref_s ) capacitor c=0.00608913f \
 //x=29.625 //y=4.97 //x2=29.195 //y2=5.2
cc_2069 ( N_noxref_6_M87_noxref_g N_VDD_M87_noxref_d ) capacitor c=0.015318f \
 //x=29.99 //y=6.2 //x2=30.065 //y2=5.2
cc_2070 ( N_noxref_6_c_2095_p N_VDD_M92_noxref_s ) capacitor c=4.33517e-19 \
 //x=34.16 //y=2.935 //x2=34.005 //y2=5.2
cc_2071 ( N_noxref_6_c_2096_p N_VDD_M92_noxref_s ) capacitor c=0.0217981f \
 //x=34.16 //y=4.755 //x2=34.005 //y2=5.2
cc_2072 ( N_noxref_6_c_2252_p N_VDD_M92_noxref_s ) capacitor c=0.00983846f \
 //x=34.16 //y=4.88 //x2=34.005 //y2=5.2
cc_2073 ( N_noxref_6_M92_noxref_g N_VDD_M92_noxref_s ) capacitor c=0.053419f \
 //x=34.36 //y=6.2 //x2=34.005 //y2=5.2
cc_2074 ( N_noxref_6_c_2254_p N_VDD_M92_noxref_s ) capacitor c=0.00608899f \
 //x=34.435 //y=4.97 //x2=34.005 //y2=5.2
cc_2075 ( N_noxref_6_M93_noxref_g N_VDD_M93_noxref_d ) capacitor c=0.015318f \
 //x=34.8 //y=6.2 //x2=34.875 //y2=5.2
cc_2076 ( N_noxref_6_c_2125_p N_noxref_27_M18_noxref_d ) capacitor \
 c=3.39394e-19 //x=27.06 //y=1.18 //x2=30.1 //y2=1.09
cc_2077 ( N_noxref_6_c_2091_p N_GND_c_14081_n ) capacitor c=0.00608096f \
 //x=27.415 //y=1.835 //x2=29.23 //y2=0.175
cc_2078 ( N_noxref_6_c_2076_p N_GND_c_14081_n ) capacitor c=4.04148e-19 \
 //x=27.5 //y=2.93 //x2=29.23 //y2=0.175
cc_2079 ( N_noxref_6_c_2125_p N_GND_c_14081_n ) capacitor c=0.00928865f \
 //x=27.06 //y=1.18 //x2=29.23 //y2=0.175
cc_2080 ( N_noxref_6_M16_noxref_d N_GND_c_14081_n ) capacitor c=3.01769e-19 \
 //x=26.87 //y=1.085 //x2=29.23 //y2=0.175
cc_2081 ( N_noxref_6_c_2229_p N_GND_c_14085_n ) capacitor c=3.92414e-19 \
 //x=29.05 //y=1.055 //x2=29.315 //y2=1.015
cc_2082 ( N_noxref_6_c_2386_p N_GND_c_14085_n ) capacitor c=0.0085115f \
 //x=29.425 //y=0.9 //x2=29.315 //y2=1.015
cc_2083 ( N_noxref_6_c_2231_p N_GND_c_14085_n ) capacitor c=4.45447e-19 \
 //x=29.58 //y=1.055 //x2=29.315 //y2=1.015
cc_2084 ( N_noxref_6_c_2293_p N_GND_c_14088_n ) capacitor c=3.97665e-19 \
 //x=33.86 //y=1.055 //x2=34.125 //y2=1.015
cc_2085 ( N_noxref_6_c_2389_p N_GND_c_14088_n ) capacitor c=0.00864776f \
 //x=34.235 //y=0.9 //x2=34.125 //y2=1.015
cc_2086 ( N_noxref_6_c_2295_p N_GND_c_14088_n ) capacitor c=4.45447e-19 \
 //x=34.39 //y=1.055 //x2=34.125 //y2=1.015
cc_2087 ( N_noxref_6_c_2125_p N_GND_c_14091_n ) capacitor c=0.0140211f \
 //x=27.06 //y=1.18 //x2=26.09 //y2=1.135
cc_2088 ( N_noxref_6_M16_noxref_d N_GND_c_14091_n ) capacitor c=2.93544e-19 \
 //x=26.87 //y=1.085 //x2=26.09 //y2=1.135
cc_2089 ( N_noxref_6_c_2204_p N_GND_c_14093_n ) capacitor c=0.00771144f \
 //x=29.35 //y=2.375 //x2=29.315 //y2=1.145
cc_2090 ( N_noxref_6_c_2173_p N_GND_c_14093_n ) capacitor c=0.00106569f \
 //x=29.35 //y=2.93 //x2=29.315 //y2=1.145
cc_2091 ( N_noxref_6_c_2125_p N_GND_c_14093_n ) capacitor c=0.00606355f \
 //x=27.06 //y=1.18 //x2=29.315 //y2=1.145
cc_2092 ( N_noxref_6_c_2203_p N_GND_c_14093_n ) capacitor c=2.22883e-19 \
 //x=29.35 //y=2.26 //x2=29.315 //y2=1.145
cc_2093 ( N_noxref_6_c_2229_p N_GND_c_14093_n ) capacitor c=0.0015128f \
 //x=29.05 //y=1.055 //x2=29.315 //y2=1.145
cc_2094 ( N_noxref_6_c_2230_p N_GND_c_14093_n ) capacitor c=0.00350108f \
 //x=29.05 //y=1.4 //x2=29.315 //y2=1.145
cc_2095 ( N_noxref_6_c_2232_p N_GND_c_14093_n ) capacitor c=4.09667e-19 \
 //x=29.05 //y=1.71 //x2=29.315 //y2=1.145
cc_2096 ( N_noxref_6_c_2386_p N_GND_c_14093_n ) capacitor c=9.36995e-19 \
 //x=29.425 //y=0.9 //x2=29.315 //y2=1.145
cc_2097 ( N_noxref_6_c_2401_p N_GND_c_14093_n ) capacitor c=5.27793e-19 \
 //x=29.425 //y=1.555 //x2=29.315 //y2=1.145
cc_2098 ( N_noxref_6_c_2231_p N_GND_c_14093_n ) capacitor c=0.0017438f \
 //x=29.58 //y=1.055 //x2=29.315 //y2=1.145
cc_2099 ( N_noxref_6_c_2233_p N_GND_c_14093_n ) capacitor c=0.00276804f \
 //x=29.58 //y=1.4 //x2=29.315 //y2=1.145
cc_2100 ( N_noxref_6_c_2093_p N_GND_c_14104_n ) capacitor c=0.00771592f \
 //x=34.16 //y=2.375 //x2=34.125 //y2=1.145
cc_2101 ( N_noxref_6_c_2095_p N_GND_c_14104_n ) capacitor c=0.00118382f \
 //x=34.16 //y=2.935 //x2=34.125 //y2=1.145
cc_2102 ( N_noxref_6_c_2245_p N_GND_c_14104_n ) capacitor c=2.22883e-19 \
 //x=34.16 //y=2.26 //x2=34.125 //y2=1.145
cc_2103 ( N_noxref_6_c_2293_p N_GND_c_14104_n ) capacitor c=0.00156339f \
 //x=33.86 //y=1.055 //x2=34.125 //y2=1.145
cc_2104 ( N_noxref_6_c_2294_p N_GND_c_14104_n ) capacitor c=0.00352472f \
 //x=33.86 //y=1.4 //x2=34.125 //y2=1.145
cc_2105 ( N_noxref_6_c_2296_p N_GND_c_14104_n ) capacitor c=3.85805e-19 \
 //x=33.86 //y=1.71 //x2=34.125 //y2=1.145
cc_2106 ( N_noxref_6_c_2389_p N_GND_c_14104_n ) capacitor c=9.36995e-19 \
 //x=34.235 //y=0.9 //x2=34.125 //y2=1.145
cc_2107 ( N_noxref_6_c_2411_p N_GND_c_14104_n ) capacitor c=5.28241e-19 \
 //x=34.235 //y=1.555 //x2=34.125 //y2=1.145
cc_2108 ( N_noxref_6_c_2295_p N_GND_c_14104_n ) capacitor c=0.0017438f \
 //x=34.39 //y=1.055 //x2=34.125 //y2=1.145
cc_2109 ( N_noxref_6_c_2297_p N_GND_c_14104_n ) capacitor c=0.00276804f \
 //x=34.39 //y=1.4 //x2=34.125 //y2=1.145
cc_2110 ( N_noxref_6_c_2091_p N_GND_c_14114_n ) capacitor c=7.75992e-19 \
 //x=27.415 //y=1.835 //x2=28.07 //y2=0.175
cc_2111 ( N_noxref_6_c_2076_p N_GND_c_14114_n ) capacitor c=4.78337e-19 \
 //x=27.5 //y=2.93 //x2=28.07 //y2=0.175
cc_2112 ( N_noxref_6_c_2229_p N_GND_c_14116_n ) capacitor c=0.00677849f \
 //x=29.05 //y=1.055 //x2=32.88 //y2=0.175
cc_2113 ( N_noxref_6_c_2293_p N_GND_c_14117_n ) capacitor c=0.00677849f \
 //x=33.86 //y=1.055 //x2=37.69 //y2=0.175
cc_2114 ( N_noxref_6_c_2075_p N_GND_c_14078_n ) capacitor c=9.32616e-19 \
 //x=27.5 //y=2.61 //x2=24.91 //y2=0.175
cc_2115 ( N_noxref_6_c_2080_p N_GND_c_14078_n ) capacitor c=0.00133285f \
 //x=27.5 //y=2.77 //x2=24.91 //y2=0.175
cc_2116 ( N_noxref_6_c_2127_p N_GND_c_14120_n ) capacitor c=0.00460657f \
 //x=27.06 //y=1.75 //x2=28.24 //y2=0.175
cc_2117 ( N_noxref_6_c_2091_p N_GND_c_14120_n ) capacitor c=0.0221535f \
 //x=27.415 //y=1.835 //x2=28.24 //y2=0.175
cc_2118 ( N_noxref_6_c_2076_p N_GND_c_14120_n ) capacitor c=0.00430881f \
 //x=27.5 //y=2.93 //x2=28.24 //y2=0.175
cc_2119 ( N_noxref_6_c_2204_p N_GND_c_14120_n ) capacitor c=0.00330334f \
 //x=29.35 //y=2.375 //x2=28.24 //y2=0.175
cc_2120 ( N_noxref_6_c_2078_p N_GND_c_14120_n ) capacitor c=0.00386755f \
 //x=29.35 //y=2.61 //x2=28.24 //y2=0.175
cc_2121 ( N_noxref_6_c_2173_p N_GND_c_14120_n ) capacitor c=0.00272321f \
 //x=29.35 //y=2.93 //x2=28.24 //y2=0.175
cc_2122 ( N_noxref_6_c_2080_p N_GND_c_14120_n ) capacitor c=0.0101608f \
 //x=27.5 //y=2.77 //x2=28.24 //y2=0.175
cc_2123 ( N_noxref_6_c_2200_p N_GND_c_14120_n ) capacitor c=0.00539296f \
 //x=29.35 //y=2.765 //x2=28.24 //y2=0.175
cc_2124 ( N_noxref_6_c_2169_p N_GND_c_14120_n ) capacitor c=0.00947774f \
 //x=29.19 //y=2.77 //x2=28.24 //y2=0.175
cc_2125 ( N_noxref_6_c_2203_p N_GND_c_14120_n ) capacitor c=0.00396211f \
 //x=29.35 //y=2.26 //x2=28.24 //y2=0.175
cc_2126 ( N_noxref_6_c_2232_p N_GND_c_14120_n ) capacitor c=0.00170145f \
 //x=29.05 //y=1.71 //x2=28.24 //y2=0.175
cc_2127 ( N_noxref_6_c_2206_p N_GND_c_14120_n ) capacitor c=0.0102191f \
 //x=29.05 //y=2.095 //x2=28.24 //y2=0.175
cc_2128 ( N_noxref_6_c_2093_p N_GND_c_14132_n ) capacitor c=0.00350919f \
 //x=34.16 //y=2.375 //x2=33.05 //y2=0.175
cc_2129 ( N_noxref_6_c_2094_p N_GND_c_14132_n ) capacitor c=0.00374352f \
 //x=34.16 //y=2.615 //x2=33.05 //y2=0.175
cc_2130 ( N_noxref_6_c_2095_p N_GND_c_14132_n ) capacitor c=0.00311095f \
 //x=34.16 //y=2.935 //x2=33.05 //y2=0.175
cc_2131 ( N_noxref_6_c_2071_p N_GND_c_14132_n ) capacitor c=0.00528672f \
 //x=34.16 //y=2.77 //x2=33.05 //y2=0.175
cc_2132 ( N_noxref_6_c_2098_p N_GND_c_14132_n ) capacitor c=0.0118264f //x=34 \
 //y=2.775 //x2=33.05 //y2=0.175
cc_2133 ( N_noxref_6_c_2245_p N_GND_c_14132_n ) capacitor c=0.00379567f \
 //x=34.16 //y=2.26 //x2=33.05 //y2=0.175
cc_2134 ( N_noxref_6_c_2296_p N_GND_c_14132_n ) capacitor c=0.00170145f \
 //x=33.86 //y=1.71 //x2=33.05 //y2=0.175
cc_2135 ( N_noxref_6_c_2246_p N_GND_c_14132_n ) capacitor c=0.0102191f \
 //x=33.86 //y=2.095 //x2=33.05 //y2=0.175
cc_2136 ( N_noxref_6_c_2125_p N_GND_M15_noxref_d ) capacitor c=2.82748e-19 \
 //x=27.06 //y=1.18 //x2=25.9 //y2=1.045
cc_2137 ( N_noxref_6_c_2204_p N_GND_M17_noxref_d ) capacitor c=4.4417e-19 \
 //x=29.35 //y=2.375 //x2=29.125 //y2=1.055
cc_2138 ( N_noxref_6_c_2229_p N_GND_M17_noxref_d ) capacitor c=0.00184354f \
 //x=29.05 //y=1.055 //x2=29.125 //y2=1.055
cc_2139 ( N_noxref_6_c_2230_p N_GND_M17_noxref_d ) capacitor c=0.00210798f \
 //x=29.05 //y=1.4 //x2=29.125 //y2=1.055
cc_2140 ( N_noxref_6_c_2386_p N_GND_M17_noxref_d ) capacitor c=0.00474029f \
 //x=29.425 //y=0.9 //x2=29.125 //y2=1.055
cc_2141 ( N_noxref_6_c_2401_p N_GND_M17_noxref_d ) capacitor c=0.00166857f \
 //x=29.425 //y=1.555 //x2=29.125 //y2=1.055
cc_2142 ( N_noxref_6_c_2231_p N_GND_M17_noxref_d ) capacitor c=0.00230174f \
 //x=29.58 //y=1.055 //x2=29.125 //y2=1.055
cc_2143 ( N_noxref_6_c_2233_p N_GND_M17_noxref_d ) capacitor c=0.00210798f \
 //x=29.58 //y=1.4 //x2=29.125 //y2=1.055
cc_2144 ( N_noxref_6_c_2093_p N_GND_M20_noxref_d ) capacitor c=4.4417e-19 \
 //x=34.16 //y=2.375 //x2=33.935 //y2=1.055
cc_2145 ( N_noxref_6_c_2293_p N_GND_M20_noxref_d ) capacitor c=0.00184354f \
 //x=33.86 //y=1.055 //x2=33.935 //y2=1.055
cc_2146 ( N_noxref_6_c_2294_p N_GND_M20_noxref_d ) capacitor c=0.00210798f \
 //x=33.86 //y=1.4 //x2=33.935 //y2=1.055
cc_2147 ( N_noxref_6_c_2389_p N_GND_M20_noxref_d ) capacitor c=0.00474029f \
 //x=34.235 //y=0.9 //x2=33.935 //y2=1.055
cc_2148 ( N_noxref_6_c_2411_p N_GND_M20_noxref_d ) capacitor c=0.00166857f \
 //x=34.235 //y=1.555 //x2=33.935 //y2=1.055
cc_2149 ( N_noxref_6_c_2295_p N_GND_M20_noxref_d ) capacitor c=0.00230174f \
 //x=34.39 //y=1.055 //x2=33.935 //y2=1.055
cc_2150 ( N_noxref_6_c_2297_p N_GND_M20_noxref_d ) capacitor c=0.00210798f \
 //x=34.39 //y=1.4 //x2=33.935 //y2=1.055
cc_2151 ( N_noxref_6_c_2083_p N_noxref_43_c_15971_n ) capacitor c=0.00911405f \
 //x=27.145 //y=1.835 //x2=26.575 //y2=1.675
cc_2152 ( N_noxref_6_c_2091_p N_noxref_43_c_15972_n ) capacitor c=0.00399245f \
 //x=27.415 //y=1.835 //x2=27.46 //y2=0.71
cc_2153 ( N_noxref_6_c_2125_p N_noxref_43_c_15972_n ) capacitor c=0.003751f \
 //x=27.06 //y=1.18 //x2=27.46 //y2=0.71
cc_2154 ( N_noxref_6_M16_noxref_d N_noxref_43_c_15972_n ) capacitor \
 c=0.00910163f //x=26.87 //y=1.085 //x2=27.46 //y2=0.71
cc_2155 ( N_noxref_6_c_2127_p N_noxref_43_M15_noxref_s ) capacitor \
 c=0.0175063f //x=27.06 //y=1.75 //x2=25.47 //y2=0.545
cc_2156 ( N_noxref_6_c_2091_p N_noxref_43_M15_noxref_s ) capacitor \
 c=0.0055349f //x=27.415 //y=1.835 //x2=25.47 //y2=0.545
cc_2157 ( N_noxref_6_c_2076_p N_noxref_43_M15_noxref_s ) capacitor \
 c=7.86324e-19 //x=27.5 //y=2.93 //x2=25.47 //y2=0.545
cc_2158 ( N_noxref_6_c_2125_p N_noxref_43_M15_noxref_s ) capacitor \
 c=0.0089443f //x=27.06 //y=1.18 //x2=25.47 //y2=0.545
cc_2159 ( N_noxref_6_c_2080_p N_noxref_43_M15_noxref_s ) capacitor \
 c=0.00202552f //x=27.5 //y=2.77 //x2=25.47 //y2=0.545
cc_2160 ( N_noxref_6_M16_noxref_d N_noxref_43_M15_noxref_s ) capacitor \
 c=0.0275552f //x=26.87 //y=1.085 //x2=25.47 //y2=0.545
cc_2161 ( N_noxref_6_c_2206_p N_noxref_44_c_16038_n ) capacitor c=0.00262672f \
 //x=29.05 //y=2.095 //x2=28.83 //y2=1.685
cc_2162 ( N_noxref_6_c_2204_p N_noxref_44_c_16039_n ) capacitor c=0.00428451f \
 //x=29.35 //y=2.375 //x2=29.715 //y2=1.77
cc_2163 ( N_noxref_6_c_2173_p N_noxref_44_c_16039_n ) capacitor c=0.00372512f \
 //x=29.35 //y=2.93 //x2=29.715 //y2=1.77
cc_2164 ( N_noxref_6_c_2203_p N_noxref_44_c_16039_n ) capacitor c=0.0104666f \
 //x=29.35 //y=2.26 //x2=29.715 //y2=1.77
cc_2165 ( N_noxref_6_c_2232_p N_noxref_44_c_16039_n ) capacitor c=0.00705077f \
 //x=29.05 //y=1.71 //x2=29.715 //y2=1.77
cc_2166 ( N_noxref_6_c_2206_p N_noxref_44_c_16039_n ) capacitor c=0.020486f \
 //x=29.05 //y=2.095 //x2=29.715 //y2=1.77
cc_2167 ( N_noxref_6_c_2401_p N_noxref_44_c_16039_n ) capacitor c=0.00588627f \
 //x=29.425 //y=1.555 //x2=29.715 //y2=1.77
cc_2168 ( N_noxref_6_c_2233_p N_noxref_44_c_16039_n ) capacitor c=0.00698822f \
 //x=29.58 //y=1.4 //x2=29.715 //y2=1.77
cc_2169 ( N_noxref_6_c_2229_p N_noxref_44_M17_noxref_s ) capacitor \
 c=0.0295256f //x=29.05 //y=1.055 //x2=28.695 //y2=0.555
cc_2170 ( N_noxref_6_c_2232_p N_noxref_44_M17_noxref_s ) capacitor \
 c=7.99997e-19 //x=29.05 //y=1.71 //x2=28.695 //y2=0.555
cc_2171 ( N_noxref_6_c_2206_p N_noxref_44_M17_noxref_s ) capacitor \
 c=0.00122123f //x=29.05 //y=2.095 //x2=28.695 //y2=0.555
cc_2172 ( N_noxref_6_c_2231_p N_noxref_44_M17_noxref_s ) capacitor \
 c=0.0125924f //x=29.58 //y=1.055 //x2=28.695 //y2=0.555
cc_2173 ( N_noxref_6_c_2246_p N_noxref_45_c_16098_n ) capacitor c=0.00262672f \
 //x=33.86 //y=2.095 //x2=33.64 //y2=1.685
cc_2174 ( N_noxref_6_c_2093_p N_noxref_45_c_16099_n ) capacitor c=0.00428451f \
 //x=34.16 //y=2.375 //x2=34.525 //y2=1.77
cc_2175 ( N_noxref_6_c_2095_p N_noxref_45_c_16099_n ) capacitor c=0.00449457f \
 //x=34.16 //y=2.935 //x2=34.525 //y2=1.77
cc_2176 ( N_noxref_6_c_2245_p N_noxref_45_c_16099_n ) capacitor c=0.0104666f \
 //x=34.16 //y=2.26 //x2=34.525 //y2=1.77
cc_2177 ( N_noxref_6_c_2296_p N_noxref_45_c_16099_n ) capacitor c=0.00705077f \
 //x=33.86 //y=1.71 //x2=34.525 //y2=1.77
cc_2178 ( N_noxref_6_c_2246_p N_noxref_45_c_16099_n ) capacitor c=0.0197811f \
 //x=33.86 //y=2.095 //x2=34.525 //y2=1.77
cc_2179 ( N_noxref_6_c_2411_p N_noxref_45_c_16099_n ) capacitor c=0.00588627f \
 //x=34.235 //y=1.555 //x2=34.525 //y2=1.77
cc_2180 ( N_noxref_6_c_2297_p N_noxref_45_c_16099_n ) capacitor c=0.00698822f \
 //x=34.39 //y=1.4 //x2=34.525 //y2=1.77
cc_2181 ( N_noxref_6_c_2293_p N_noxref_45_M20_noxref_s ) capacitor \
 c=0.0295256f //x=33.86 //y=1.055 //x2=33.505 //y2=0.555
cc_2182 ( N_noxref_6_c_2296_p N_noxref_45_M20_noxref_s ) capacitor \
 c=7.99997e-19 //x=33.86 //y=1.71 //x2=33.505 //y2=0.555
cc_2183 ( N_noxref_6_c_2246_p N_noxref_45_M20_noxref_s ) capacitor \
 c=0.00122123f //x=33.86 //y=2.095 //x2=33.505 //y2=0.555
cc_2184 ( N_noxref_6_c_2295_p N_noxref_45_M20_noxref_s ) capacitor \
 c=0.0125924f //x=34.39 //y=1.055 //x2=33.505 //y2=0.555
cc_2185 ( N_noxref_7_c_2490_n N_noxref_8_c_2865_n ) capacitor c=6.09703e-19 \
 //x=34.582 //y=5.335 //x2=31.53 //y2=5.56
cc_2186 ( N_noxref_7_c_2490_n N_noxref_8_c_2866_n ) capacitor c=0.00306432f \
 //x=34.582 //y=5.335 //x2=32.225 //y2=5.335
cc_2187 ( N_noxref_7_c_2499_p N_noxref_8_c_2867_n ) capacitor c=0.00163399f \
 //x=36.72 //y=1.845 //x2=32.225 //y2=1.845
cc_2188 ( N_noxref_7_c_2500_p N_noxref_8_c_2826_n ) capacitor c=0.0233658f \
 //x=37.12 //y=5.25 //x2=42.14 //y2=4.265
cc_2189 ( N_noxref_7_c_2501_p N_noxref_8_c_2826_n ) capacitor c=0.0233519f \
 //x=38.972 //y=4.74 //x2=42.14 //y2=4.265
cc_2190 ( N_noxref_7_c_2502_p N_noxref_10_c_3586_n ) capacitor c=0.013943f \
 //x=37.12 //y=2.625 //x2=36.38 //y2=2.375
cc_2191 ( N_noxref_7_c_2502_p N_noxref_10_c_3582_n ) capacitor c=0.00898347f \
 //x=37.12 //y=2.625 //x2=36.38 //y2=3.705
cc_2192 ( N_noxref_7_c_2504_p N_noxref_10_c_3582_n ) capacitor c=0.0151188f \
 //x=37.12 //y=2.945 //x2=36.38 //y2=3.705
cc_2193 ( N_noxref_7_c_2500_p N_noxref_10_c_3582_n ) capacitor c=0.0298518f \
 //x=37.12 //y=5.25 //x2=36.38 //y2=3.705
cc_2194 ( N_noxref_7_c_2506_p N_noxref_10_c_3582_n ) capacitor c=4.63723e-19 \
 //x=38.97 //y=2.625 //x2=36.38 //y2=3.705
cc_2195 ( N_noxref_7_c_2493_n N_noxref_10_c_3582_n ) capacitor c=6.77171e-19 \
 //x=37.12 //y=2.77 //x2=36.38 //y2=3.705
cc_2196 ( N_noxref_7_c_2501_p N_noxref_10_c_3582_n ) capacitor c=5.53249e-19 \
 //x=38.972 //y=4.74 //x2=36.38 //y2=3.705
cc_2197 ( N_noxref_7_c_2509_p N_noxref_10_c_3582_n ) capacitor c=0.00687503f \
 //x=37.28 //y=2.785 //x2=36.38 //y2=3.705
cc_2198 ( N_noxref_7_c_2510_p N_noxref_10_c_3594_n ) capacitor c=0.00167286f \
 //x=36.225 //y=5.335 //x2=36.38 //y2=4.025
cc_2199 ( N_noxref_7_c_2511_p N_noxref_10_c_3594_n ) capacitor c=4.08809e-19 \
 //x=37.035 //y=5.335 //x2=36.38 //y2=4.025
cc_2200 ( N_noxref_7_c_2500_p N_noxref_10_c_3594_n ) capacitor c=0.0148932f \
 //x=37.12 //y=5.25 //x2=36.38 //y2=4.025
cc_2201 ( N_noxref_7_c_2511_p N_noxref_10_c_3584_n ) capacitor c=0.00228791f \
 //x=37.035 //y=5.335 //x2=36.38 //y2=4.75
cc_2202 ( N_noxref_7_c_2500_p N_noxref_10_c_3584_n ) capacitor c=0.042978f \
 //x=37.12 //y=5.25 //x2=36.38 //y2=4.75
cc_2203 ( N_noxref_7_c_2515_p N_noxref_10_c_3584_n ) capacitor c=0.0221235f \
 //x=36.34 //y=5.335 //x2=36.38 //y2=4.75
cc_2204 ( N_noxref_7_c_2501_p N_noxref_10_c_3584_n ) capacitor c=8.71319e-19 \
 //x=38.972 //y=4.74 //x2=36.38 //y2=4.75
cc_2205 ( N_noxref_7_c_2517_p N_noxref_10_c_3584_n ) capacitor c=0.00217653f \
 //x=36.34 //y=5.56 //x2=36.38 //y2=4.75
cc_2206 ( N_noxref_7_M99_noxref_g N_noxref_10_c_3602_n ) capacitor \
 c=0.00889217f //x=39.31 //y=6.2 //x2=39.855 //y2=5.38
cc_2207 ( N_noxref_7_c_2519_p N_noxref_10_c_3603_n ) capacitor c=0.00326079f \
 //x=36.635 //y=1.76 //x2=40.01 //y2=1.75
cc_2208 ( N_noxref_7_c_2520_p N_noxref_10_c_3604_n ) capacitor c=0.00218808f \
 //x=37.035 //y=1.845 //x2=40.095 //y2=1.835
cc_2209 ( N_noxref_7_c_2520_p N_noxref_10_c_3605_n ) capacitor c=0.00203605f \
 //x=37.035 //y=1.845 //x2=40.45 //y2=3.705
cc_2210 ( N_noxref_7_c_2506_p N_noxref_10_c_3605_n ) capacitor c=6.61269e-19 \
 //x=38.97 //y=2.625 //x2=40.45 //y2=3.705
cc_2211 ( N_noxref_7_c_2501_p N_noxref_10_c_3605_n ) capacitor c=8.77718e-19 \
 //x=38.972 //y=4.74 //x2=40.45 //y2=3.705
cc_2212 ( N_noxref_7_c_2500_p N_noxref_10_c_3608_n ) capacitor c=0.00283621f \
 //x=37.12 //y=5.25 //x2=40.45 //y2=5.295
cc_2213 ( N_noxref_7_c_2501_p N_noxref_10_c_3608_n ) capacitor c=0.00152069f \
 //x=38.972 //y=4.74 //x2=40.45 //y2=5.295
cc_2214 ( N_noxref_7_c_2500_p N_noxref_10_c_3610_n ) capacitor c=9.19401e-19 \
 //x=37.12 //y=5.25 //x2=36.38 //y2=3.88
cc_2215 ( N_noxref_7_c_2527_p N_noxref_10_c_3611_n ) capacitor c=5.58535e-19 \
 //x=36.34 //y=5.56 //x2=39.09 //y2=5.56
cc_2216 ( N_noxref_7_c_2511_p N_noxref_10_c_3611_n ) capacitor c=0.00104762f \
 //x=37.035 //y=5.335 //x2=39.09 //y2=5.56
cc_2217 ( N_noxref_7_c_2529_p N_noxref_10_c_3611_n ) capacitor c=4.02865e-19 \
 //x=38.97 //y=2.945 //x2=39.09 //y2=5.56
cc_2218 ( N_noxref_7_c_2530_p N_noxref_10_c_3611_n ) capacitor c=0.0117744f \
 //x=38.97 //y=4.88 //x2=39.09 //y2=5.56
cc_2219 ( N_noxref_7_c_2531_p N_noxref_10_c_3611_n ) capacitor c=0.00277154f \
 //x=38.97 //y=4.88 //x2=39.09 //y2=5.56
cc_2220 ( N_noxref_7_M98_noxref_g N_noxref_10_c_3611_n ) capacitor \
 c=0.00201806f //x=38.87 //y=6.2 //x2=39.09 //y2=5.56
cc_2221 ( N_noxref_7_M99_noxref_g N_noxref_10_c_3611_n ) capacitor \
 c=0.00192712f //x=39.31 //y=6.2 //x2=39.09 //y2=5.56
cc_2222 ( N_noxref_7_c_2534_p N_noxref_10_c_3611_n ) capacitor c=0.00200677f \
 //x=38.97 //y=4.88 //x2=39.09 //y2=5.56
cc_2223 ( N_noxref_7_c_2535_p N_noxref_10_c_3619_n ) capacitor c=6.5615e-19 \
 //x=36.635 //y=1.305 //x2=40.01 //y2=1.18
cc_2224 ( N_noxref_7_c_2500_p N_noxref_10_c_3585_n ) capacitor c=0.00336755f \
 //x=37.12 //y=5.25 //x2=36.54 //y2=3.88
cc_2225 ( N_noxref_7_c_2500_p N_noxref_10_c_3621_n ) capacitor c=0.0229483f \
 //x=37.12 //y=5.25 //x2=40.285 //y2=3.865
cc_2226 ( N_noxref_7_c_2501_p N_noxref_10_c_3621_n ) capacitor c=0.0233584f \
 //x=38.972 //y=4.74 //x2=40.285 //y2=3.865
cc_2227 ( N_noxref_7_c_2502_p N_noxref_10_c_3623_n ) capacitor c=0.0015536f \
 //x=37.12 //y=2.625 //x2=36.38 //y2=2.26
cc_2228 ( N_noxref_7_c_2511_p N_noxref_10_c_3624_n ) capacitor c=0.00130631f \
 //x=37.035 //y=5.335 //x2=36.38 //y2=4.88
cc_2229 ( N_noxref_7_c_2500_p N_noxref_10_c_3624_n ) capacitor c=0.00131258f \
 //x=37.12 //y=5.25 //x2=36.38 //y2=4.88
cc_2230 ( N_noxref_7_c_2515_p N_noxref_10_c_3624_n ) capacitor c=0.00346456f \
 //x=36.34 //y=5.335 //x2=36.38 //y2=4.88
cc_2231 ( N_noxref_7_c_2517_p N_noxref_10_c_3624_n ) capacitor c=0.00624059f \
 //x=36.34 //y=5.56 //x2=36.38 //y2=4.88
cc_2232 ( N_noxref_7_c_2530_p N_noxref_10_c_3628_n ) capacitor c=0.00104426f \
 //x=38.97 //y=4.88 //x2=39.09 //y2=5.56
cc_2233 ( N_noxref_7_c_2531_p N_noxref_10_c_3628_n ) capacitor c=0.00377369f \
 //x=38.97 //y=4.88 //x2=39.09 //y2=5.56
cc_2234 ( N_noxref_7_M98_noxref_g N_noxref_10_c_3628_n ) capacitor \
 c=0.0158358f //x=38.87 //y=6.2 //x2=39.09 //y2=5.56
cc_2235 ( N_noxref_7_M99_noxref_g N_noxref_10_c_3628_n ) capacitor \
 c=0.0178987f //x=39.31 //y=6.2 //x2=39.09 //y2=5.56
cc_2236 ( N_noxref_7_c_2534_p N_noxref_10_c_3628_n ) capacitor c=0.0043218f \
 //x=38.97 //y=4.88 //x2=39.09 //y2=5.56
cc_2237 ( N_noxref_7_c_2510_p N_noxref_10_M96_noxref_g ) capacitor \
 c=0.00952006f //x=36.225 //y=5.335 //x2=36.12 //y2=6.2
cc_2238 ( N_noxref_7_c_2527_p N_noxref_10_M96_noxref_g ) capacitor \
 c=0.00226521f //x=36.34 //y=5.56 //x2=36.12 //y2=6.2
cc_2239 ( N_noxref_7_c_2517_p N_noxref_10_M96_noxref_g ) capacitor \
 c=0.0178885f //x=36.34 //y=5.56 //x2=36.12 //y2=6.2
cc_2240 ( N_noxref_7_c_2527_p N_noxref_10_M97_noxref_g ) capacitor \
 c=0.00368945f //x=36.34 //y=5.56 //x2=36.56 //y2=6.2
cc_2241 ( N_noxref_7_c_2511_p N_noxref_10_M97_noxref_g ) capacitor c=0.010861f \
 //x=37.035 //y=5.335 //x2=36.56 //y2=6.2
cc_2242 ( N_noxref_7_c_2517_p N_noxref_10_M97_noxref_g ) capacitor \
 c=0.0188608f //x=36.34 //y=5.56 //x2=36.56 //y2=6.2
cc_2243 ( N_noxref_7_c_2535_p N_noxref_10_c_3639_n ) capacitor c=4.64015e-19 \
 //x=36.635 //y=1.305 //x2=36.37 //y2=1.095
cc_2244 ( N_noxref_7_M22_noxref_d N_noxref_10_c_3639_n ) capacitor \
 c=0.00137165f //x=36.445 //y=1.095 //x2=36.37 //y2=1.095
cc_2245 ( N_noxref_7_c_2535_p N_noxref_10_c_3641_n ) capacitor c=0.0026012f \
 //x=36.635 //y=1.305 //x2=36.37 //y2=1.44
cc_2246 ( N_noxref_7_c_2519_p N_noxref_10_c_3641_n ) capacitor c=0.00127432f \
 //x=36.635 //y=1.76 //x2=36.37 //y2=1.44
cc_2247 ( N_noxref_7_M22_noxref_d N_noxref_10_c_3641_n ) capacitor \
 c=0.00237422f //x=36.445 //y=1.095 //x2=36.37 //y2=1.44
cc_2248 ( N_noxref_7_c_2519_p N_noxref_10_c_3644_n ) capacitor c=0.00429966f \
 //x=36.635 //y=1.76 //x2=36.37 //y2=1.75
cc_2249 ( N_noxref_7_c_2535_p N_noxref_10_c_3645_n ) capacitor c=5.29969e-19 \
 //x=36.635 //y=1.305 //x2=36.745 //y2=0.94
cc_2250 ( N_noxref_7_M22_noxref_d N_noxref_10_c_3645_n ) capacitor \
 c=0.0020782f //x=36.445 //y=1.095 //x2=36.745 //y2=0.94
cc_2251 ( N_noxref_7_c_2535_p N_noxref_10_c_3647_n ) capacitor c=5.31507e-19 \
 //x=36.635 //y=1.305 //x2=36.745 //y2=1.595
cc_2252 ( N_noxref_7_c_2519_p N_noxref_10_c_3647_n ) capacitor c=0.00930387f \
 //x=36.635 //y=1.76 //x2=36.745 //y2=1.595
cc_2253 ( N_noxref_7_c_2520_p N_noxref_10_c_3647_n ) capacitor c=0.00194716f \
 //x=37.035 //y=1.845 //x2=36.745 //y2=1.595
cc_2254 ( N_noxref_7_M22_noxref_d N_noxref_10_c_3647_n ) capacitor \
 c=0.00356097f //x=36.445 //y=1.095 //x2=36.745 //y2=1.595
cc_2255 ( N_noxref_7_c_2535_p N_noxref_10_c_3651_n ) capacitor c=5.28622e-19 \
 //x=36.635 //y=1.305 //x2=36.9 //y2=1.095
cc_2256 ( N_noxref_7_M22_noxref_d N_noxref_10_c_3651_n ) capacitor \
 c=0.00139206f //x=36.445 //y=1.095 //x2=36.9 //y2=1.095
cc_2257 ( N_noxref_7_c_2535_p N_noxref_10_c_3653_n ) capacitor c=0.00312156f \
 //x=36.635 //y=1.305 //x2=36.9 //y2=1.44
cc_2258 ( N_noxref_7_c_2519_p N_noxref_10_c_3653_n ) capacitor c=0.00347599f \
 //x=36.635 //y=1.76 //x2=36.9 //y2=1.44
cc_2259 ( N_noxref_7_c_2520_p N_noxref_10_c_3653_n ) capacitor c=0.00323576f \
 //x=37.035 //y=1.845 //x2=36.9 //y2=1.44
cc_2260 ( N_noxref_7_M22_noxref_d N_noxref_10_c_3653_n ) capacitor \
 c=0.00237422f //x=36.445 //y=1.095 //x2=36.9 //y2=1.44
cc_2261 ( N_noxref_7_c_2502_p N_noxref_10_c_3657_n ) capacitor c=0.0024584f \
 //x=37.12 //y=2.625 //x2=36.38 //y2=2.26
cc_2262 ( N_noxref_7_c_2519_p N_noxref_10_c_3658_n ) capacitor c=0.0036273f \
 //x=36.635 //y=1.76 //x2=36.38 //y2=2.095
cc_2263 ( N_noxref_7_c_2502_p N_noxref_10_c_3658_n ) capacitor c=0.00282067f \
 //x=37.12 //y=2.625 //x2=36.38 //y2=2.095
cc_2264 ( N_noxref_7_c_2500_p N_noxref_10_c_3660_n ) capacitor c=0.00739875f \
 //x=37.12 //y=5.25 //x2=36.38 //y2=4.88
cc_2265 ( N_noxref_7_c_2515_p N_noxref_10_c_3660_n ) capacitor c=0.00203307f \
 //x=36.34 //y=5.335 //x2=36.38 //y2=4.88
cc_2266 ( N_noxref_7_c_2517_p N_noxref_10_c_3660_n ) capacitor c=0.00375636f \
 //x=36.34 //y=5.56 //x2=36.38 //y2=4.88
cc_2267 ( N_noxref_7_c_2504_p N_D_c_5103_n ) capacitor c=0.00152841f //x=37.12 \
 //y=2.945 //x2=36.735 //y2=3.14
cc_2268 ( N_noxref_7_c_2500_p N_D_c_5103_n ) capacitor c=6.2241e-19 //x=37.12 \
 //y=5.25 //x2=36.735 //y2=3.14
cc_2269 ( N_noxref_7_c_2509_p N_D_c_5103_n ) capacitor c=0.0358254f //x=37.28 \
 //y=2.785 //x2=36.735 //y2=3.14
cc_2270 ( N_noxref_7_c_2504_p N_D_c_5106_n ) capacitor c=0.0101369f //x=37.12 \
 //y=2.945 //x2=37.335 //y2=3.17
cc_2271 ( N_noxref_7_c_2500_p N_D_c_5106_n ) capacitor c=0.0225285f //x=37.12 \
 //y=5.25 //x2=37.335 //y2=3.17
cc_2272 ( N_noxref_7_c_2501_p N_D_c_5106_n ) capacitor c=2.03225e-19 \
 //x=38.972 //y=4.74 //x2=37.335 //y2=3.17
cc_2273 ( N_noxref_7_c_2585_p N_D_c_5106_n ) capacitor c=0.127486f //x=38.805 \
 //y=2.785 //x2=37.335 //y2=3.17
cc_2274 ( N_noxref_7_c_2500_p N_D_c_5110_n ) capacitor c=2.04029e-19 //x=37.12 \
 //y=5.25 //x2=38.58 //y2=3.14
cc_2275 ( N_noxref_7_c_2529_p N_D_c_5110_n ) capacitor c=0.00485454f //x=38.97 \
 //y=2.945 //x2=38.58 //y2=3.14
cc_2276 ( N_noxref_7_c_2501_p N_D_c_5110_n ) capacitor c=9.97486e-19 \
 //x=38.972 //y=4.74 //x2=38.58 //y2=3.14
cc_2277 ( N_noxref_7_c_2589_p N_D_c_5110_n ) capacitor c=0.0358254f //x=38.965 \
 //y=2.785 //x2=38.58 //y2=3.14
cc_2278 ( N_noxref_7_c_2585_p N_D_c_5110_n ) capacitor c=0.0105193f //x=38.805 \
 //y=2.785 //x2=38.58 //y2=3.14
cc_2279 ( N_noxref_7_c_2529_p N_D_c_5115_n ) capacitor c=0.00267318f //x=38.97 \
 //y=2.945 //x2=39.18 //y2=3.17
cc_2280 ( N_noxref_7_c_2501_p N_D_c_5115_n ) capacitor c=0.0221529f //x=38.972 \
 //y=4.74 //x2=39.18 //y2=3.17
cc_2281 ( N_noxref_7_c_2502_p CLK ) capacitor c=4.63397e-19 //x=37.12 \
 //y=2.625 //x2=39.71 //y2=2.77
cc_2282 ( N_noxref_7_c_2500_p CLK ) capacitor c=0.00188826f //x=37.12 //y=5.25 \
 //x2=39.71 //y2=2.77
cc_2283 ( N_noxref_7_c_2506_p CLK ) capacitor c=0.00839909f //x=38.97 \
 //y=2.625 //x2=39.71 //y2=2.77
cc_2284 ( N_noxref_7_c_2529_p CLK ) capacitor c=0.014957f //x=38.97 //y=2.945 \
 //x2=39.71 //y2=2.77
cc_2285 ( N_noxref_7_c_2597_p CLK ) capacitor c=6.6241e-19 //x=38.97 //y=2.77 \
 //x2=39.71 //y2=2.77
cc_2286 ( N_noxref_7_c_2501_p CLK ) capacitor c=0.0632653f //x=38.972 //y=4.74 \
 //x2=39.71 //y2=2.77
cc_2287 ( N_noxref_7_c_2589_p CLK ) capacitor c=0.00684101f //x=38.965 \
 //y=2.785 //x2=39.71 //y2=2.77
cc_2288 ( N_noxref_7_c_2600_p CLK ) capacitor c=3.30333e-19 //x=38.97 //y=2.26 \
 //x2=39.71 //y2=2.77
cc_2289 ( N_noxref_7_c_2601_p N_CLK_c_6591_n ) capacitor c=0.0179797f \
 //x=38.97 //y=2.26 //x2=39.71 //y2=2.26
cc_2290 ( N_noxref_7_c_2600_p N_CLK_c_6591_n ) capacitor c=5.16867e-19 \
 //x=38.97 //y=2.26 //x2=39.71 //y2=2.26
cc_2291 ( N_noxref_7_c_2603_p N_CLK_c_6591_n ) capacitor c=0.00161745f \
 //x=38.775 //y=2.095 //x2=39.71 //y2=2.26
cc_2292 ( N_noxref_7_c_2530_p N_CLK_c_6594_n ) capacitor c=0.0160977f \
 //x=38.97 //y=4.88 //x2=39.745 //y2=4.75
cc_2293 ( N_noxref_7_c_2501_p N_CLK_c_6594_n ) capacitor c=0.00638948f \
 //x=38.972 //y=4.74 //x2=39.745 //y2=4.75
cc_2294 ( N_noxref_7_c_2531_p N_CLK_c_6594_n ) capacitor c=0.00121956f \
 //x=38.97 //y=4.88 //x2=39.745 //y2=4.75
cc_2295 ( N_noxref_7_c_2534_p N_CLK_c_6594_n ) capacitor c=0.00177782f \
 //x=38.97 //y=4.88 //x2=39.745 //y2=4.75
cc_2296 ( N_noxref_7_c_2511_p N_CLK_c_6557_n ) capacitor c=0.0218207f \
 //x=37.035 //y=5.335 //x2=42.17 //y2=4.65
cc_2297 ( N_noxref_7_c_2500_p N_CLK_c_6557_n ) capacitor c=0.0300565f \
 //x=37.12 //y=5.25 //x2=42.17 //y2=4.65
cc_2298 ( N_noxref_7_c_2490_n N_CLK_c_6557_n ) capacitor c=0.0297837f \
 //x=34.582 //y=5.335 //x2=42.17 //y2=4.65
cc_2299 ( N_noxref_7_c_2611_p N_CLK_c_6557_n ) capacitor c=0.0379488f \
 //x=35.46 //y=5.335 //x2=42.17 //y2=4.65
cc_2300 ( N_noxref_7_c_2530_p N_CLK_c_6557_n ) capacitor c=0.00901811f \
 //x=38.97 //y=4.88 //x2=42.17 //y2=4.65
cc_2301 ( N_noxref_7_c_2501_p N_CLK_c_6557_n ) capacitor c=0.0273494f \
 //x=38.972 //y=4.74 //x2=42.17 //y2=4.65
cc_2302 ( N_noxref_7_c_2506_p N_CLK_c_6604_n ) capacitor c=3.30333e-19 \
 //x=38.97 //y=2.625 //x2=39.71 //y2=2.26
cc_2303 ( N_noxref_7_c_2601_p N_CLK_c_6604_n ) capacitor c=5.24723e-19 \
 //x=38.97 //y=2.26 //x2=39.71 //y2=2.26
cc_2304 ( N_noxref_7_c_2600_p N_CLK_c_6604_n ) capacitor c=0.00485709f \
 //x=38.97 //y=2.26 //x2=39.71 //y2=2.26
cc_2305 ( N_noxref_7_c_2603_p N_CLK_c_6604_n ) capacitor c=0.00190888f \
 //x=38.775 //y=2.095 //x2=39.71 //y2=2.26
cc_2306 ( N_noxref_7_c_2530_p N_CLK_c_6608_n ) capacitor c=4.80626e-19 \
 //x=38.97 //y=4.88 //x2=39.74 //y2=4.88
cc_2307 ( N_noxref_7_c_2531_p N_CLK_c_6608_n ) capacitor c=0.0039678f \
 //x=38.97 //y=4.88 //x2=39.74 //y2=4.88
cc_2308 ( N_noxref_7_c_2534_p N_CLK_c_6608_n ) capacitor c=0.0028411f \
 //x=38.97 //y=4.88 //x2=39.74 //y2=4.88
cc_2309 ( N_noxref_7_M98_noxref_g N_CLK_M100_noxref_g ) capacitor c=0.0104892f \
 //x=38.87 //y=6.2 //x2=39.75 //y2=6.2
cc_2310 ( N_noxref_7_M99_noxref_g N_CLK_M100_noxref_g ) capacitor c=0.107636f \
 //x=39.31 //y=6.2 //x2=39.75 //y2=6.2
cc_2311 ( N_noxref_7_M99_noxref_g N_CLK_M101_noxref_g ) capacitor c=0.0100341f \
 //x=39.31 //y=6.2 //x2=40.19 //y2=6.2
cc_2312 ( N_noxref_7_c_2624_p N_CLK_c_6614_n ) capacitor c=4.86545e-19 \
 //x=38.775 //y=1.045 //x2=39.745 //y2=1.085
cc_2313 ( N_noxref_7_c_2625_p N_CLK_c_6614_n ) capacitor c=0.00152405f \
 //x=38.775 //y=1.39 //x2=39.745 //y2=1.085
cc_2314 ( N_noxref_7_c_2626_p N_CLK_c_6614_n ) capacitor c=0.0151475f \
 //x=39.305 //y=1.045 //x2=39.745 //y2=1.085
cc_2315 ( N_noxref_7_c_2627_p N_CLK_c_6617_n ) capacitor c=0.00109982f \
 //x=38.775 //y=1.7 //x2=39.745 //y2=1.43
cc_2316 ( N_noxref_7_c_2628_p N_CLK_c_6617_n ) capacitor c=0.0111064f \
 //x=39.305 //y=1.39 //x2=39.745 //y2=1.43
cc_2317 ( N_noxref_7_c_2627_p N_CLK_c_6619_n ) capacitor c=9.58243e-19 \
 //x=38.775 //y=1.7 //x2=39.745 //y2=1.74
cc_2318 ( N_noxref_7_c_2603_p N_CLK_c_6619_n ) capacitor c=0.00662747f \
 //x=38.775 //y=2.095 //x2=39.745 //y2=1.74
cc_2319 ( N_noxref_7_c_2628_p N_CLK_c_6619_n ) capacitor c=0.00862358f \
 //x=39.305 //y=1.39 //x2=39.745 //y2=1.74
cc_2320 ( N_noxref_7_c_2626_p N_CLK_c_6622_n ) capacitor c=0.00127211f \
 //x=39.305 //y=1.045 //x2=40.275 //y2=1.085
cc_2321 ( N_noxref_7_c_2628_p N_CLK_c_6623_n ) capacitor c=0.00204774f \
 //x=39.305 //y=1.39 //x2=40.275 //y2=1.43
cc_2322 ( N_noxref_7_c_2601_p N_CLK_c_6624_n ) capacitor c=0.00161167f \
 //x=38.97 //y=2.26 //x2=39.71 //y2=2.26
cc_2323 ( N_noxref_7_c_2600_p N_CLK_c_6624_n ) capacitor c=0.00266443f \
 //x=38.97 //y=2.26 //x2=39.71 //y2=2.26
cc_2324 ( N_noxref_7_c_2603_p N_CLK_c_6624_n ) capacitor c=0.0181449f \
 //x=38.775 //y=2.095 //x2=39.71 //y2=2.26
cc_2325 ( N_noxref_7_c_2530_p N_CLK_c_6627_n ) capacitor c=5.5856e-19 \
 //x=38.97 //y=4.88 //x2=39.74 //y2=4.88
cc_2326 ( N_noxref_7_c_2531_p N_CLK_c_6627_n ) capacitor c=0.00211091f \
 //x=38.97 //y=4.88 //x2=39.74 //y2=4.88
cc_2327 ( N_noxref_7_c_2534_p N_CLK_c_6627_n ) capacitor c=0.0291521f \
 //x=38.97 //y=4.88 //x2=39.74 //y2=4.88
cc_2328 ( N_noxref_7_c_2489_n N_SN_c_8253_n ) capacitor c=3.40598e-19 \
 //x=35.34 //y=5.335 //x2=35.27 //y2=2.55
cc_2329 ( N_noxref_7_c_2611_p N_SN_c_8253_n ) capacitor c=4.44961e-19 \
 //x=35.46 //y=5.335 //x2=35.27 //y2=2.55
cc_2330 ( N_noxref_7_c_2489_n N_SN_c_8257_n ) capacitor c=0.0213631f //x=35.34 \
 //y=5.335 //x2=35.27 //y2=4.765
cc_2331 ( N_noxref_7_c_2500_p N_SN_c_8257_n ) capacitor c=0.00216749f \
 //x=37.12 //y=5.25 //x2=35.27 //y2=4.765
cc_2332 ( N_noxref_7_c_2611_p N_SN_c_8257_n ) capacitor c=0.00239361f \
 //x=35.46 //y=5.335 //x2=35.27 //y2=4.765
cc_2333 ( N_noxref_7_c_2645_p N_SN_c_8257_n ) capacitor c=7.85344e-19 \
 //x=35.46 //y=5.56 //x2=35.27 //y2=4.765
cc_2334 ( N_noxref_7_c_2535_p N_SN_c_8324_n ) capacitor c=7.08559e-19 \
 //x=36.635 //y=1.305 //x2=46.57 //y2=2.4
cc_2335 ( N_noxref_7_c_2499_p N_SN_c_8324_n ) capacitor c=0.0210985f //x=36.72 \
 //y=1.845 //x2=46.57 //y2=2.4
cc_2336 ( N_noxref_7_c_2502_p N_SN_c_8324_n ) capacitor c=0.0272596f //x=37.12 \
 //y=2.625 //x2=46.57 //y2=2.4
cc_2337 ( N_noxref_7_c_2504_p N_SN_c_8324_n ) capacitor c=0.00577069f \
 //x=37.12 //y=2.945 //x2=46.57 //y2=2.4
cc_2338 ( N_noxref_7_c_2506_p N_SN_c_8324_n ) capacitor c=0.0121034f //x=38.97 \
 //y=2.625 //x2=46.57 //y2=2.4
cc_2339 ( N_noxref_7_c_2529_p N_SN_c_8324_n ) capacitor c=0.00673157f \
 //x=38.97 //y=2.945 //x2=46.57 //y2=2.4
cc_2340 ( N_noxref_7_c_2601_p N_SN_c_8324_n ) capacitor c=0.0165635f //x=38.97 \
 //y=2.26 //x2=46.57 //y2=2.4
cc_2341 ( N_noxref_7_c_2509_p N_SN_c_8324_n ) capacitor c=0.0365231f //x=37.28 \
 //y=2.785 //x2=46.57 //y2=2.4
cc_2342 ( N_noxref_7_c_2589_p N_SN_c_8324_n ) capacitor c=0.0371276f \
 //x=38.965 //y=2.785 //x2=46.57 //y2=2.4
cc_2343 ( N_noxref_7_c_2585_p N_SN_c_8324_n ) capacitor c=0.13892f //x=38.805 \
 //y=2.785 //x2=46.57 //y2=2.4
cc_2344 ( N_noxref_7_c_2600_p N_SN_c_8324_n ) capacitor c=2.20453e-19 \
 //x=38.97 //y=2.26 //x2=46.57 //y2=2.4
cc_2345 ( N_noxref_7_c_2603_p N_SN_c_8324_n ) capacitor c=3.61358e-19 \
 //x=38.775 //y=2.095 //x2=46.57 //y2=2.4
cc_2346 ( N_noxref_7_c_2489_n N_SN_c_8296_n ) capacitor c=0.00492634f \
 //x=35.34 //y=5.335 //x2=35.27 //y2=4.88
cc_2347 ( N_noxref_7_c_2611_p N_SN_c_8296_n ) capacitor c=0.00132214f \
 //x=35.46 //y=5.335 //x2=35.27 //y2=4.88
cc_2348 ( N_noxref_7_c_2489_n N_SN_M94_noxref_g ) capacitor c=0.00858241f \
 //x=35.34 //y=5.335 //x2=35.24 //y2=6.2
cc_2349 ( N_noxref_7_c_2611_p N_SN_M94_noxref_g ) capacitor c=0.00229818f \
 //x=35.46 //y=5.335 //x2=35.24 //y2=6.2
cc_2350 ( N_noxref_7_c_2645_p N_SN_M94_noxref_g ) capacitor c=0.0179041f \
 //x=35.46 //y=5.56 //x2=35.24 //y2=6.2
cc_2351 ( N_noxref_7_c_2510_p N_SN_M95_noxref_g ) capacitor c=0.00955829f \
 //x=36.225 //y=5.335 //x2=35.68 //y2=6.2
cc_2352 ( N_noxref_7_c_2611_p N_SN_M95_noxref_g ) capacitor c=0.00230699f \
 //x=35.46 //y=5.335 //x2=35.68 //y2=6.2
cc_2353 ( N_noxref_7_c_2645_p N_SN_M95_noxref_g ) capacitor c=0.0179041f \
 //x=35.46 //y=5.56 //x2=35.68 //y2=6.2
cc_2354 ( N_noxref_7_c_2611_p N_SN_c_8344_n ) capacitor c=0.00181015f \
 //x=35.46 //y=5.335 //x2=35.605 //y2=4.97
cc_2355 ( N_noxref_7_c_2645_p N_SN_c_8344_n ) capacitor c=0.00290085f \
 //x=35.46 //y=5.56 //x2=35.605 //y2=4.97
cc_2356 ( N_noxref_7_c_2489_n N_SN_c_8314_n ) capacitor c=6.14744e-19 \
 //x=35.34 //y=5.335 //x2=35.27 //y2=4.88
cc_2357 ( N_noxref_7_c_2500_p N_noxref_21_c_10587_n ) capacitor c=0.00141294f \
 //x=37.12 //y=5.25 //x2=36.595 //y2=3.48
cc_2358 ( N_noxref_7_c_2500_p N_noxref_21_c_10588_n ) capacitor c=0.022629f \
 //x=37.12 //y=5.25 //x2=40.06 //y2=3.51
cc_2359 ( N_noxref_7_c_2501_p N_noxref_21_c_10588_n ) capacitor c=0.0230653f \
 //x=38.972 //y=4.74 //x2=40.06 //y2=3.51
cc_2360 ( N_noxref_7_c_2585_p N_noxref_21_c_10588_n ) capacitor c=0.00823341f \
 //x=38.805 //y=2.785 //x2=40.06 //y2=3.51
cc_2361 ( N_noxref_7_c_2489_n N_VDD_c_11522_n ) capacitor c=0.00621363f \
 //x=35.34 //y=5.335 //x2=74.455 //y2=7.585
cc_2362 ( N_noxref_7_c_2510_p N_VDD_c_11522_n ) capacitor c=0.00627186f \
 //x=36.225 //y=5.335 //x2=74.455 //y2=7.585
cc_2363 ( N_noxref_7_c_2527_p N_VDD_c_11522_n ) capacitor c=0.00256019f \
 //x=36.34 //y=5.56 //x2=74.455 //y2=7.585
cc_2364 ( N_noxref_7_c_2511_p N_VDD_c_11522_n ) capacitor c=0.00824067f \
 //x=37.035 //y=5.335 //x2=74.455 //y2=7.585
cc_2365 ( N_noxref_7_c_2490_n N_VDD_c_11522_n ) capacitor c=0.00261804f \
 //x=34.582 //y=5.335 //x2=74.455 //y2=7.585
cc_2366 ( N_noxref_7_c_2611_p N_VDD_c_11522_n ) capacitor c=0.00270108f \
 //x=35.46 //y=5.335 //x2=74.455 //y2=7.585
cc_2367 ( N_noxref_7_c_2530_p N_VDD_c_11522_n ) capacitor c=9.07241e-19 \
 //x=38.97 //y=4.88 //x2=74.455 //y2=7.585
cc_2368 ( N_noxref_7_c_2494_n N_VDD_c_11522_n ) capacitor c=0.0024232f \
 //x=34.58 //y=5.56 //x2=74.455 //y2=7.585
cc_2369 ( N_noxref_7_c_2645_p N_VDD_c_11522_n ) capacitor c=0.0024232f \
 //x=35.46 //y=5.56 //x2=74.455 //y2=7.585
cc_2370 ( N_noxref_7_c_2517_p N_VDD_c_11522_n ) capacitor c=0.0024232f \
 //x=36.34 //y=5.56 //x2=74.455 //y2=7.585
cc_2371 ( N_noxref_7_c_2531_p N_VDD_c_11522_n ) capacitor c=6.22888e-19 \
 //x=38.97 //y=4.88 //x2=74.455 //y2=7.585
cc_2372 ( N_noxref_7_c_2489_n N_VDD_c_11839_n ) capacitor c=0.00202922f \
 //x=35.34 //y=5.335 //x2=34.935 //y2=7.585
cc_2373 ( N_noxref_7_c_2490_n N_VDD_c_11839_n ) capacitor c=9.3757e-19 \
 //x=34.582 //y=5.335 //x2=34.935 //y2=7.585
cc_2374 ( N_noxref_7_c_2494_n N_VDD_c_11839_n ) capacitor c=0.0138074f \
 //x=34.58 //y=5.56 //x2=34.935 //y2=7.585
cc_2375 ( N_noxref_7_c_2489_n N_VDD_c_11895_n ) capacitor c=0.0017708f \
 //x=35.34 //y=5.335 //x2=35.815 //y2=7.585
cc_2376 ( N_noxref_7_c_2510_p N_VDD_c_11895_n ) capacitor c=0.00202922f \
 //x=36.225 //y=5.335 //x2=35.815 //y2=7.585
cc_2377 ( N_noxref_7_c_2611_p N_VDD_c_11895_n ) capacitor c=9.4822e-19 \
 //x=35.46 //y=5.335 //x2=35.815 //y2=7.585
cc_2378 ( N_noxref_7_c_2645_p N_VDD_c_11895_n ) capacitor c=0.0138074f \
 //x=35.46 //y=5.56 //x2=35.815 //y2=7.585
cc_2379 ( N_noxref_7_c_2510_p N_VDD_c_11899_n ) capacitor c=0.00205906f \
 //x=36.225 //y=5.335 //x2=36.695 //y2=7.585
cc_2380 ( N_noxref_7_c_2527_p N_VDD_c_11899_n ) capacitor c=8.49654e-19 \
 //x=36.34 //y=5.56 //x2=36.695 //y2=7.585
cc_2381 ( N_noxref_7_c_2511_p N_VDD_c_11899_n ) capacitor c=0.00204238f \
 //x=37.035 //y=5.335 //x2=36.695 //y2=7.585
cc_2382 ( N_noxref_7_c_2517_p N_VDD_c_11899_n ) capacitor c=0.0135103f \
 //x=36.34 //y=5.56 //x2=36.695 //y2=7.585
cc_2383 ( N_noxref_7_c_2511_p N_VDD_c_11903_n ) capacitor c=0.00183742f \
 //x=37.035 //y=5.335 //x2=37.69 //y2=7.585
cc_2384 ( N_noxref_7_c_2530_p N_VDD_c_11904_n ) capacitor c=6.28113e-19 \
 //x=38.97 //y=4.88 //x2=39.445 //y2=7.585
cc_2385 ( N_noxref_7_M98_noxref_g N_VDD_c_11904_n ) capacitor c=0.00732618f \
 //x=38.87 //y=6.2 //x2=39.445 //y2=7.585
cc_2386 ( N_noxref_7_M99_noxref_g N_VDD_c_11904_n ) capacitor c=0.00755544f \
 //x=39.31 //y=6.2 //x2=39.445 //y2=7.585
cc_2387 ( N_noxref_7_c_2490_n N_VDD_c_11851_n ) capacitor c=0.0022955f \
 //x=34.582 //y=5.335 //x2=33.05 //y2=7.585
cc_2388 ( N_noxref_7_c_2494_n N_VDD_c_11851_n ) capacitor c=0.00509469f \
 //x=34.58 //y=5.56 //x2=33.05 //y2=7.585
cc_2389 ( N_noxref_7_c_2527_p N_VDD_c_11909_n ) capacitor c=0.00269779f \
 //x=36.34 //y=5.56 //x2=37.86 //y2=7.585
cc_2390 ( N_noxref_7_c_2500_p N_VDD_c_11909_n ) capacitor c=0.0316694f \
 //x=37.12 //y=5.25 //x2=37.86 //y2=7.585
cc_2391 ( N_noxref_7_c_2530_p N_VDD_c_11909_n ) capacitor c=0.00483853f \
 //x=38.97 //y=4.88 //x2=37.86 //y2=7.585
cc_2392 ( N_noxref_7_c_2501_p N_VDD_c_11909_n ) capacitor c=0.00593318f \
 //x=38.972 //y=4.74 //x2=37.86 //y2=7.585
cc_2393 ( N_noxref_7_c_2517_p N_VDD_c_11909_n ) capacitor c=0.00776541f \
 //x=36.34 //y=5.56 //x2=37.86 //y2=7.585
cc_2394 ( N_noxref_7_c_2531_p N_VDD_c_11909_n ) capacitor c=0.00370494f \
 //x=38.97 //y=4.88 //x2=37.86 //y2=7.585
cc_2395 ( N_noxref_7_c_2534_p N_VDD_c_11909_n ) capacitor c=0.0129564f \
 //x=38.97 //y=4.88 //x2=37.86 //y2=7.585
cc_2396 ( N_noxref_7_c_2490_n N_VDD_M92_noxref_s ) capacitor c=0.0441176f \
 //x=34.582 //y=5.335 //x2=34.005 //y2=5.2
cc_2397 ( N_noxref_7_c_2611_p N_VDD_M92_noxref_s ) capacitor c=7.80122e-19 \
 //x=35.46 //y=5.335 //x2=34.005 //y2=5.2
cc_2398 ( N_noxref_7_c_2494_n N_VDD_M92_noxref_s ) capacitor c=0.09305f \
 //x=34.58 //y=5.56 //x2=34.005 //y2=5.2
cc_2399 ( N_noxref_7_c_2489_n N_VDD_M93_noxref_d ) capacitor c=0.00700141f \
 //x=35.34 //y=5.335 //x2=34.875 //y2=5.2
cc_2400 ( N_noxref_7_c_2494_n N_VDD_M93_noxref_d ) capacitor c=0.0674491f \
 //x=34.58 //y=5.56 //x2=34.875 //y2=5.2
cc_2401 ( N_noxref_7_c_2645_p N_VDD_M93_noxref_d ) capacitor c=0.0674762f \
 //x=35.46 //y=5.56 //x2=34.875 //y2=5.2
cc_2402 ( N_noxref_7_c_2510_p N_VDD_M95_noxref_d ) capacitor c=0.00700141f \
 //x=36.225 //y=5.335 //x2=35.755 //y2=5.2
cc_2403 ( N_noxref_7_c_2645_p N_VDD_M95_noxref_d ) capacitor c=0.067493f \
 //x=35.46 //y=5.56 //x2=35.755 //y2=5.2
cc_2404 ( N_noxref_7_c_2517_p N_VDD_M95_noxref_d ) capacitor c=0.0674288f \
 //x=36.34 //y=5.56 //x2=35.755 //y2=5.2
cc_2405 ( N_noxref_7_c_2511_p N_VDD_M97_noxref_d ) capacitor c=0.00700141f \
 //x=37.035 //y=5.335 //x2=36.635 //y2=5.2
cc_2406 ( N_noxref_7_c_2517_p N_VDD_M97_noxref_d ) capacitor c=0.0673824f \
 //x=36.34 //y=5.56 //x2=36.635 //y2=5.2
cc_2407 ( N_noxref_7_c_2527_p N_VDD_M98_noxref_s ) capacitor c=0.00536022f \
 //x=36.34 //y=5.56 //x2=38.515 //y2=5.2
cc_2408 ( N_noxref_7_c_2511_p N_VDD_M98_noxref_s ) capacitor c=0.00211796f \
 //x=37.035 //y=5.335 //x2=38.515 //y2=5.2
cc_2409 ( N_noxref_7_c_2529_p N_VDD_M98_noxref_s ) capacitor c=7.65656e-19 \
 //x=38.97 //y=2.945 //x2=38.515 //y2=5.2
cc_2410 ( N_noxref_7_M98_noxref_g N_VDD_M98_noxref_s ) capacitor c=0.0567929f \
 //x=38.87 //y=6.2 //x2=38.515 //y2=5.2
cc_2411 ( N_noxref_7_M99_noxref_g N_VDD_M99_noxref_d ) capacitor c=0.015318f \
 //x=39.31 //y=6.2 //x2=39.385 //y2=5.2
cc_2412 ( N_noxref_7_c_2535_p N_noxref_28_c_13222_n ) capacitor c=0.0036878f \
 //x=36.635 //y=1.305 //x2=37.035 //y2=0.72
cc_2413 ( N_noxref_7_c_2520_p N_noxref_28_c_13222_n ) capacitor c=0.00399931f \
 //x=37.035 //y=1.845 //x2=37.035 //y2=0.72
cc_2414 ( N_noxref_7_M22_noxref_d N_noxref_28_c_13222_n ) capacitor \
 c=0.00910163f //x=36.445 //y=1.095 //x2=37.035 //y2=0.72
cc_2415 ( N_noxref_7_M22_noxref_d N_noxref_28_c_13225_n ) capacitor \
 c=0.00120711f //x=36.445 //y=1.095 //x2=36.15 //y2=1.175
cc_2416 ( N_noxref_7_c_2489_n N_noxref_28_M21_noxref_d ) capacitor \
 c=0.00129815f //x=35.34 //y=5.335 //x2=34.91 //y2=1.09
cc_2417 ( N_noxref_7_c_2535_p N_noxref_28_M21_noxref_d ) capacitor \
 c=0.00802836f //x=36.635 //y=1.305 //x2=34.91 //y2=1.09
cc_2418 ( N_noxref_7_c_2535_p N_noxref_28_M22_noxref_s ) capacitor \
 c=0.00993092f //x=36.635 //y=1.305 //x2=36.015 //y2=0.555
cc_2419 ( N_noxref_7_c_2519_p N_noxref_28_M22_noxref_s ) capacitor \
 c=0.0270624f //x=36.635 //y=1.76 //x2=36.015 //y2=0.555
cc_2420 ( N_noxref_7_c_2520_p N_noxref_28_M22_noxref_s ) capacitor \
 c=0.00752108f //x=37.035 //y=1.845 //x2=36.015 //y2=0.555
cc_2421 ( N_noxref_7_c_2493_n N_noxref_28_M22_noxref_s ) capacitor \
 c=0.00309975f //x=37.12 //y=2.77 //x2=36.015 //y2=0.555
cc_2422 ( N_noxref_7_M22_noxref_d N_noxref_28_M22_noxref_s ) capacitor \
 c=0.0279003f //x=36.445 //y=1.095 //x2=36.015 //y2=0.555
cc_2423 ( N_noxref_7_c_2535_p N_GND_c_14155_n ) capacitor c=0.00884249f \
 //x=36.635 //y=1.305 //x2=38.955 //y2=0.175
cc_2424 ( N_noxref_7_c_2520_p N_GND_c_14155_n ) capacitor c=0.00662992f \
 //x=37.035 //y=1.845 //x2=38.955 //y2=0.175
cc_2425 ( N_noxref_7_c_2504_p N_GND_c_14155_n ) capacitor c=4.30498e-19 \
 //x=37.12 //y=2.945 //x2=38.955 //y2=0.175
cc_2426 ( N_noxref_7_M22_noxref_d N_GND_c_14155_n ) capacitor c=2.9462e-19 \
 //x=36.445 //y=1.095 //x2=38.955 //y2=0.175
cc_2427 ( N_noxref_7_c_2535_p N_GND_c_14159_n ) capacitor c=0.00488628f \
 //x=36.635 //y=1.305 //x2=39.04 //y2=1.135
cc_2428 ( N_noxref_7_c_2529_p N_GND_c_14159_n ) capacitor c=2.00375e-19 \
 //x=38.97 //y=2.945 //x2=39.04 //y2=1.135
cc_2429 ( N_noxref_7_c_2601_p N_GND_c_14159_n ) capacitor c=0.00645051f \
 //x=38.97 //y=2.26 //x2=39.04 //y2=1.135
cc_2430 ( N_noxref_7_c_2600_p N_GND_c_14159_n ) capacitor c=2.13705e-19 \
 //x=38.97 //y=2.26 //x2=39.04 //y2=1.135
cc_2431 ( N_noxref_7_c_2624_p N_GND_c_14159_n ) capacitor c=0.00176535f \
 //x=38.775 //y=1.045 //x2=39.04 //y2=1.135
cc_2432 ( N_noxref_7_c_2625_p N_GND_c_14159_n ) capacitor c=0.0036005f \
 //x=38.775 //y=1.39 //x2=39.04 //y2=1.135
cc_2433 ( N_noxref_7_c_2627_p N_GND_c_14159_n ) capacitor c=4.2764e-19 \
 //x=38.775 //y=1.7 //x2=39.04 //y2=1.135
cc_2434 ( N_noxref_7_c_2746_p N_GND_c_14159_n ) capacitor c=9.36995e-19 \
 //x=39.15 //y=0.89 //x2=39.04 //y2=1.135
cc_2435 ( N_noxref_7_c_2747_p N_GND_c_14159_n ) capacitor c=6.38426e-19 \
 //x=39.15 //y=1.545 //x2=39.04 //y2=1.135
cc_2436 ( N_noxref_7_c_2626_p N_GND_c_14159_n ) capacitor c=0.00171721f \
 //x=39.305 //y=1.045 //x2=39.04 //y2=1.135
cc_2437 ( N_noxref_7_c_2628_p N_GND_c_14159_n ) capacitor c=0.00296337f \
 //x=39.305 //y=1.39 //x2=39.04 //y2=1.135
cc_2438 ( N_noxref_7_c_2624_p N_GND_c_14170_n ) capacitor c=3.51399e-19 \
 //x=38.775 //y=1.045 //x2=39.037 //y2=1.005
cc_2439 ( N_noxref_7_c_2746_p N_GND_c_14170_n ) capacitor c=0.00852202f \
 //x=39.15 //y=0.89 //x2=39.037 //y2=1.005
cc_2440 ( N_noxref_7_c_2626_p N_GND_c_14170_n ) capacitor c=4.40641e-19 \
 //x=39.305 //y=1.045 //x2=39.037 //y2=1.005
cc_2441 ( N_noxref_7_c_2520_p N_GND_c_14117_n ) capacitor c=6.86343e-19 \
 //x=37.035 //y=1.845 //x2=37.69 //y2=0.175
cc_2442 ( N_noxref_7_c_2504_p N_GND_c_14117_n ) capacitor c=6.00344e-19 \
 //x=37.12 //y=2.945 //x2=37.69 //y2=0.175
cc_2443 ( N_noxref_7_c_2624_p N_GND_c_14175_n ) capacitor c=0.00688027f \
 //x=38.775 //y=1.045 //x2=41.02 //y2=0.175
cc_2444 ( N_noxref_7_c_2519_p N_GND_c_14176_n ) capacitor c=0.00285697f \
 //x=36.635 //y=1.76 //x2=37.86 //y2=0.175
cc_2445 ( N_noxref_7_c_2520_p N_GND_c_14176_n ) capacitor c=0.022222f \
 //x=37.035 //y=1.845 //x2=37.86 //y2=0.175
cc_2446 ( N_noxref_7_c_2502_p N_GND_c_14176_n ) capacitor c=2.00878e-19 \
 //x=37.12 //y=2.625 //x2=37.86 //y2=0.175
cc_2447 ( N_noxref_7_c_2504_p N_GND_c_14176_n ) capacitor c=0.00401039f \
 //x=37.12 //y=2.945 //x2=37.86 //y2=0.175
cc_2448 ( N_noxref_7_c_2506_p N_GND_c_14176_n ) capacitor c=0.00301679f \
 //x=38.97 //y=2.625 //x2=37.86 //y2=0.175
cc_2449 ( N_noxref_7_c_2529_p N_GND_c_14176_n ) capacitor c=0.00293146f \
 //x=38.97 //y=2.945 //x2=37.86 //y2=0.175
cc_2450 ( N_noxref_7_c_2493_n N_GND_c_14176_n ) capacitor c=0.0103966f \
 //x=37.12 //y=2.77 //x2=37.86 //y2=0.175
cc_2451 ( N_noxref_7_c_2597_p N_GND_c_14176_n ) capacitor c=0.00512795f \
 //x=38.97 //y=2.77 //x2=37.86 //y2=0.175
cc_2452 ( N_noxref_7_c_2601_p N_GND_c_14176_n ) capacitor c=0.00351582f \
 //x=38.97 //y=2.26 //x2=37.86 //y2=0.175
cc_2453 ( N_noxref_7_c_2585_p N_GND_c_14176_n ) capacitor c=0.00947774f \
 //x=38.805 //y=2.785 //x2=37.86 //y2=0.175
cc_2454 ( N_noxref_7_c_2600_p N_GND_c_14176_n ) capacitor c=0.00354425f \
 //x=38.97 //y=2.26 //x2=37.86 //y2=0.175
cc_2455 ( N_noxref_7_c_2627_p N_GND_c_14176_n ) capacitor c=0.0015404f \
 //x=38.775 //y=1.7 //x2=37.86 //y2=0.175
cc_2456 ( N_noxref_7_c_2603_p N_GND_c_14176_n ) capacitor c=0.0093907f \
 //x=38.775 //y=2.095 //x2=37.86 //y2=0.175
cc_2457 ( N_noxref_7_c_2597_p N_GND_c_14189_n ) capacitor c=0.00159554f \
 //x=38.97 //y=2.77 //x2=41.19 //y2=0.175
cc_2458 ( N_noxref_7_c_2601_p N_GND_M23_noxref_d ) capacitor c=2.20438e-19 \
 //x=38.97 //y=2.26 //x2=38.85 //y2=1.045
cc_2459 ( N_noxref_7_c_2624_p N_GND_M23_noxref_d ) capacitor c=0.00192399f \
 //x=38.775 //y=1.045 //x2=38.85 //y2=1.045
cc_2460 ( N_noxref_7_c_2625_p N_GND_M23_noxref_d ) capacitor c=0.00210798f \
 //x=38.775 //y=1.39 //x2=38.85 //y2=1.045
cc_2461 ( N_noxref_7_c_2746_p N_GND_M23_noxref_d ) capacitor c=0.00472259f \
 //x=39.15 //y=0.89 //x2=38.85 //y2=1.045
cc_2462 ( N_noxref_7_c_2747_p N_GND_M23_noxref_d ) capacitor c=0.00166857f \
 //x=39.15 //y=1.545 //x2=38.85 //y2=1.045
cc_2463 ( N_noxref_7_c_2626_p N_GND_M23_noxref_d ) capacitor c=0.00230174f \
 //x=39.305 //y=1.045 //x2=38.85 //y2=1.045
cc_2464 ( N_noxref_7_c_2628_p N_GND_M23_noxref_d ) capacitor c=0.00210798f \
 //x=39.305 //y=1.39 //x2=38.85 //y2=1.045
cc_2465 ( N_noxref_7_c_2603_p N_noxref_46_c_16158_n ) capacitor c=0.00262672f \
 //x=38.775 //y=2.095 //x2=38.555 //y2=1.675
cc_2466 ( N_noxref_7_c_2529_p N_noxref_46_c_16159_n ) capacitor c=0.00530082f \
 //x=38.97 //y=2.945 //x2=39.44 //y2=1.76
cc_2467 ( N_noxref_7_c_2601_p N_noxref_46_c_16159_n ) capacitor c=0.00509504f \
 //x=38.97 //y=2.26 //x2=39.44 //y2=1.76
cc_2468 ( N_noxref_7_c_2600_p N_noxref_46_c_16159_n ) capacitor c=0.00763108f \
 //x=38.97 //y=2.26 //x2=39.44 //y2=1.76
cc_2469 ( N_noxref_7_c_2627_p N_noxref_46_c_16159_n ) capacitor c=0.00697076f \
 //x=38.775 //y=1.7 //x2=39.44 //y2=1.76
cc_2470 ( N_noxref_7_c_2603_p N_noxref_46_c_16159_n ) capacitor c=0.0165799f \
 //x=38.775 //y=2.095 //x2=39.44 //y2=1.76
cc_2471 ( N_noxref_7_c_2747_p N_noxref_46_c_16159_n ) capacitor c=0.00723574f \
 //x=39.15 //y=1.545 //x2=39.44 //y2=1.76
cc_2472 ( N_noxref_7_c_2628_p N_noxref_46_c_16159_n ) capacitor c=0.00339872f \
 //x=39.305 //y=1.39 //x2=39.44 //y2=1.76
cc_2473 ( N_noxref_7_c_2603_p N_noxref_46_c_16166_n ) capacitor c=6.71402e-19 \
 //x=38.775 //y=2.095 //x2=39.525 //y2=1.675
cc_2474 ( N_noxref_7_c_2624_p N_noxref_46_M23_noxref_s ) capacitor \
 c=0.0295366f //x=38.775 //y=1.045 //x2=38.42 //y2=0.545
cc_2475 ( N_noxref_7_c_2627_p N_noxref_46_M23_noxref_s ) capacitor \
 c=3.48408e-19 //x=38.775 //y=1.7 //x2=38.42 //y2=0.545
cc_2476 ( N_noxref_7_c_2626_p N_noxref_46_M23_noxref_s ) capacitor \
 c=0.0125442f //x=39.305 //y=1.045 //x2=38.42 //y2=0.545
cc_2477 ( N_noxref_8_M103_noxref_g N_noxref_9_c_3286_n ) capacitor \
 c=0.00882387f //x=42.64 //y=6.2 //x2=43.185 //y2=5.38
cc_2478 ( N_noxref_8_c_2871_p N_noxref_9_c_3287_n ) capacitor c=6.61269e-19 \
 //x=42.3 //y=4.105 //x2=43.78 //y2=2.625
cc_2479 ( N_noxref_8_c_2871_p N_noxref_9_c_3288_n ) capacitor c=0.00146865f \
 //x=42.3 //y=4.105 //x2=43.78 //y2=5.295
cc_2480 ( N_noxref_8_c_2873_p N_noxref_9_c_3288_n ) capacitor c=7.03792e-19 \
 //x=42.302 //y=4.74 //x2=43.78 //y2=5.295
cc_2481 ( N_noxref_8_c_2874_p N_noxref_9_c_3290_n ) capacitor c=0.00121594f \
 //x=42.3 //y=4.425 //x2=42.42 //y2=5.56
cc_2482 ( N_noxref_8_c_2875_p N_noxref_9_c_3290_n ) capacitor c=0.0117717f \
 //x=42.3 //y=4.88 //x2=42.42 //y2=5.56
cc_2483 ( N_noxref_8_c_2876_p N_noxref_9_c_3290_n ) capacitor c=0.00277154f \
 //x=42.3 //y=4.88 //x2=42.42 //y2=5.56
cc_2484 ( N_noxref_8_M102_noxref_g N_noxref_9_c_3290_n ) capacitor \
 c=0.00201806f //x=42.2 //y=6.2 //x2=42.42 //y2=5.56
cc_2485 ( N_noxref_8_M103_noxref_g N_noxref_9_c_3290_n ) capacitor \
 c=0.00192712f //x=42.64 //y=6.2 //x2=42.42 //y2=5.56
cc_2486 ( N_noxref_8_c_2879_p N_noxref_9_c_3290_n ) capacitor c=0.00201193f \
 //x=42.3 //y=4.88 //x2=42.42 //y2=5.56
cc_2487 ( N_noxref_8_c_2874_p N_noxref_9_c_3296_n ) capacitor c=4.87998e-19 \
 //x=42.3 //y=4.425 //x2=42.42 //y2=5.56
cc_2488 ( N_noxref_8_c_2875_p N_noxref_9_c_3296_n ) capacitor c=0.00104426f \
 //x=42.3 //y=4.88 //x2=42.42 //y2=5.56
cc_2489 ( N_noxref_8_c_2876_p N_noxref_9_c_3296_n ) capacitor c=0.00377369f \
 //x=42.3 //y=4.88 //x2=42.42 //y2=5.56
cc_2490 ( N_noxref_8_M102_noxref_g N_noxref_9_c_3296_n ) capacitor \
 c=0.0158358f //x=42.2 //y=6.2 //x2=42.42 //y2=5.56
cc_2491 ( N_noxref_8_M103_noxref_g N_noxref_9_c_3296_n ) capacitor \
 c=0.0178987f //x=42.64 //y=6.2 //x2=42.42 //y2=5.56
cc_2492 ( N_noxref_8_c_2879_p N_noxref_9_c_3296_n ) capacitor c=0.00319448f \
 //x=42.3 //y=4.88 //x2=42.42 //y2=5.56
cc_2493 ( N_noxref_8_c_2807_n N_noxref_10_c_3663_n ) capacitor c=0.0140008f \
 //x=32.31 //y=4.09 //x2=31.57 //y2=2.375
cc_2494 ( N_noxref_8_c_2807_n N_noxref_10_c_3575_n ) capacitor c=0.0510418f \
 //x=32.31 //y=4.09 //x2=31.57 //y2=3.705
cc_2495 ( N_noxref_8_c_2866_n N_noxref_10_c_3665_n ) capacitor c=0.00116878f \
 //x=32.225 //y=5.335 //x2=31.57 //y2=4.025
cc_2496 ( N_noxref_8_c_2889_p N_noxref_10_c_3665_n ) capacitor c=2.00238e-19 \
 //x=31.825 //y=1.305 //x2=31.57 //y2=4.025
cc_2497 ( N_noxref_8_c_2806_n N_noxref_10_c_3665_n ) capacitor c=8.07658e-19 \
 //x=31.91 //y=1.845 //x2=31.57 //y2=4.025
cc_2498 ( N_noxref_8_c_2807_n N_noxref_10_c_3665_n ) capacitor c=0.0176025f \
 //x=32.31 //y=4.09 //x2=31.57 //y2=4.025
cc_2499 ( N_noxref_8_c_2892_p N_noxref_10_c_3665_n ) capacitor c=7.66594e-19 \
 //x=31.53 //y=5.335 //x2=31.57 //y2=4.025
cc_2500 ( N_noxref_8_c_2822_n N_noxref_10_c_3665_n ) capacitor c=0.00522697f \
 //x=32.145 //y=4.25 //x2=31.57 //y2=4.025
cc_2501 ( N_noxref_8_c_2866_n N_noxref_10_c_3580_n ) capacitor c=0.00228791f \
 //x=32.225 //y=5.335 //x2=31.57 //y2=4.75
cc_2502 ( N_noxref_8_c_2807_n N_noxref_10_c_3580_n ) capacitor c=0.00283381f \
 //x=32.31 //y=4.09 //x2=31.57 //y2=4.75
cc_2503 ( N_noxref_8_c_2813_n N_noxref_10_c_3580_n ) capacitor c=0.0147947f \
 //x=32.31 //y=4.41 //x2=31.57 //y2=4.75
cc_2504 ( N_noxref_8_c_2814_n N_noxref_10_c_3580_n ) capacitor c=0.0275491f \
 //x=32.31 //y=5.25 //x2=31.57 //y2=4.75
cc_2505 ( N_noxref_8_c_2892_p N_noxref_10_c_3580_n ) capacitor c=0.0221235f \
 //x=31.53 //y=5.335 //x2=31.57 //y2=4.75
cc_2506 ( N_noxref_8_c_2899_p N_noxref_10_c_3580_n ) capacitor c=6.4807e-19 \
 //x=32.305 //y=4.25 //x2=31.57 //y2=4.75
cc_2507 ( N_noxref_8_c_2822_n N_noxref_10_c_3580_n ) capacitor c=0.0210332f \
 //x=32.145 //y=4.25 //x2=31.57 //y2=4.75
cc_2508 ( N_noxref_8_c_2824_n N_noxref_10_c_3580_n ) capacitor c=0.00328982f \
 //x=32.465 //y=4.25 //x2=31.57 //y2=4.75
cc_2509 ( N_noxref_8_c_2902_p N_noxref_10_c_3580_n ) capacitor c=0.00217653f \
 //x=31.53 //y=5.56 //x2=31.57 //y2=4.75
cc_2510 ( N_noxref_8_c_2826_n N_noxref_10_c_3594_n ) capacitor c=0.00531452f \
 //x=42.14 //y=4.265 //x2=36.38 //y2=4.025
cc_2511 ( N_noxref_8_c_2826_n N_noxref_10_c_3584_n ) capacitor c=0.0214777f \
 //x=42.14 //y=4.265 //x2=36.38 //y2=4.75
cc_2512 ( N_noxref_8_c_2871_p N_noxref_10_c_3605_n ) capacitor c=0.0171285f \
 //x=42.3 //y=4.105 //x2=40.45 //y2=3.705
cc_2513 ( N_noxref_8_c_2906_p N_noxref_10_c_3605_n ) capacitor c=0.00344372f \
 //x=42.3 //y=2.26 //x2=40.45 //y2=3.705
cc_2514 ( N_noxref_8_c_2871_p N_noxref_10_c_3684_n ) capacitor c=0.00238733f \
 //x=42.3 //y=4.105 //x2=40.45 //y2=4.025
cc_2515 ( N_noxref_8_c_2826_n N_noxref_10_c_3684_n ) capacitor c=0.00689641f \
 //x=42.14 //y=4.265 //x2=40.45 //y2=4.025
cc_2516 ( N_noxref_8_c_2871_p N_noxref_10_c_3608_n ) capacitor c=0.00129137f \
 //x=42.3 //y=4.105 //x2=40.45 //y2=5.295
cc_2517 ( N_noxref_8_c_2874_p N_noxref_10_c_3608_n ) capacitor c=0.00249513f \
 //x=42.3 //y=4.425 //x2=40.45 //y2=5.295
cc_2518 ( N_noxref_8_c_2875_p N_noxref_10_c_3608_n ) capacitor c=0.00440493f \
 //x=42.3 //y=4.88 //x2=40.45 //y2=5.295
cc_2519 ( N_noxref_8_c_2873_p N_noxref_10_c_3608_n ) capacitor c=0.0027491f \
 //x=42.302 //y=4.74 //x2=40.45 //y2=5.295
cc_2520 ( N_noxref_8_c_2913_p N_noxref_10_c_3608_n ) capacitor c=0.0015808f \
 //x=42.3 //y=4.265 //x2=40.45 //y2=5.295
cc_2521 ( N_noxref_8_c_2826_n N_noxref_10_c_3608_n ) capacitor c=0.0225411f \
 //x=42.14 //y=4.265 //x2=40.45 //y2=5.295
cc_2522 ( N_noxref_8_c_2807_n N_noxref_10_c_3692_n ) capacitor c=9.19401e-19 \
 //x=32.31 //y=4.09 //x2=31.57 //y2=3.88
cc_2523 ( N_noxref_8_c_2807_n N_noxref_10_c_3693_n ) capacitor c=2.73038e-19 \
 //x=32.31 //y=4.09 //x2=31.92 //y2=3.88
cc_2524 ( N_noxref_8_c_2822_n N_noxref_10_c_3693_n ) capacitor c=0.0338167f \
 //x=32.145 //y=4.25 //x2=31.92 //y2=3.88
cc_2525 ( N_noxref_8_c_2807_n N_noxref_10_c_3695_n ) capacitor c=0.0210245f \
 //x=32.31 //y=4.09 //x2=32.52 //y2=3.865
cc_2526 ( N_noxref_8_c_2813_n N_noxref_10_c_3695_n ) capacitor c=0.00912961f \
 //x=32.31 //y=4.41 //x2=32.52 //y2=3.865
cc_2527 ( N_noxref_8_c_2824_n N_noxref_10_c_3695_n ) capacitor c=0.0358834f \
 //x=32.465 //y=4.25 //x2=32.52 //y2=3.865
cc_2528 ( N_noxref_8_c_2826_n N_noxref_10_c_3695_n ) capacitor c=0.0109116f \
 //x=42.14 //y=4.265 //x2=32.52 //y2=3.865
cc_2529 ( N_noxref_8_c_2807_n N_noxref_10_c_3585_n ) capacitor c=4.72093e-19 \
 //x=32.31 //y=4.09 //x2=36.54 //y2=3.88
cc_2530 ( N_noxref_8_c_2826_n N_noxref_10_c_3585_n ) capacitor c=0.349297f \
 //x=42.14 //y=4.265 //x2=36.54 //y2=3.88
cc_2531 ( N_noxref_8_c_2807_n N_noxref_10_c_3701_n ) capacitor c=0.00317812f \
 //x=32.31 //y=4.09 //x2=31.735 //y2=3.865
cc_2532 ( N_noxref_8_c_2822_n N_noxref_10_c_3701_n ) capacitor c=0.0358686f \
 //x=32.145 //y=4.25 //x2=31.735 //y2=3.865
cc_2533 ( N_noxref_8_c_2826_n N_noxref_10_c_3621_n ) capacitor c=0.321887f \
 //x=42.14 //y=4.265 //x2=40.285 //y2=3.865
cc_2534 ( N_noxref_8_c_2871_p N_noxref_10_c_3704_n ) capacitor c=0.00159442f \
 //x=42.3 //y=4.105 //x2=40.605 //y2=3.865
cc_2535 ( N_noxref_8_c_2826_n N_noxref_10_c_3704_n ) capacitor c=0.0358686f \
 //x=42.14 //y=4.265 //x2=40.605 //y2=3.865
cc_2536 ( N_noxref_8_c_2871_p N_noxref_10_c_3706_n ) capacitor c=0.0226556f \
 //x=42.3 //y=4.105 //x2=47.69 //y2=3.885
cc_2537 ( N_noxref_8_c_2874_p N_noxref_10_c_3706_n ) capacitor c=0.00766477f \
 //x=42.3 //y=4.425 //x2=47.69 //y2=3.885
cc_2538 ( N_noxref_8_c_2913_p N_noxref_10_c_3706_n ) capacitor c=0.0358686f \
 //x=42.3 //y=4.265 //x2=47.69 //y2=3.885
cc_2539 ( N_noxref_8_c_2826_n N_noxref_10_c_3706_n ) capacitor c=0.135934f \
 //x=42.14 //y=4.265 //x2=47.69 //y2=3.885
cc_2540 ( N_noxref_8_c_2807_n N_noxref_10_c_3710_n ) capacitor c=0.0015536f \
 //x=32.31 //y=4.09 //x2=31.57 //y2=2.26
cc_2541 ( N_noxref_8_c_2866_n N_noxref_10_c_3711_n ) capacitor c=0.00130631f \
 //x=32.225 //y=5.335 //x2=31.57 //y2=4.88
cc_2542 ( N_noxref_8_c_2814_n N_noxref_10_c_3711_n ) capacitor c=0.0013045f \
 //x=32.31 //y=5.25 //x2=31.57 //y2=4.88
cc_2543 ( N_noxref_8_c_2892_p N_noxref_10_c_3711_n ) capacitor c=0.00346456f \
 //x=31.53 //y=5.335 //x2=31.57 //y2=4.88
cc_2544 ( N_noxref_8_c_2902_p N_noxref_10_c_3711_n ) capacitor c=0.00624059f \
 //x=31.53 //y=5.56 //x2=31.57 //y2=4.88
cc_2545 ( N_noxref_8_c_2938_p N_noxref_10_M90_noxref_g ) capacitor \
 c=0.00955829f //x=31.415 //y=5.335 //x2=31.31 //y2=6.2
cc_2546 ( N_noxref_8_c_2865_n N_noxref_10_M90_noxref_g ) capacitor \
 c=0.00226521f //x=31.53 //y=5.56 //x2=31.31 //y2=6.2
cc_2547 ( N_noxref_8_c_2902_p N_noxref_10_M90_noxref_g ) capacitor \
 c=0.0178885f //x=31.53 //y=5.56 //x2=31.31 //y2=6.2
cc_2548 ( N_noxref_8_c_2865_n N_noxref_10_M91_noxref_g ) capacitor \
 c=0.00381703f //x=31.53 //y=5.56 //x2=31.75 //y2=6.2
cc_2549 ( N_noxref_8_c_2866_n N_noxref_10_M91_noxref_g ) capacitor \
 c=0.0109667f //x=32.225 //y=5.335 //x2=31.75 //y2=6.2
cc_2550 ( N_noxref_8_c_2902_p N_noxref_10_M91_noxref_g ) capacitor \
 c=0.0188608f //x=31.53 //y=5.56 //x2=31.75 //y2=6.2
cc_2551 ( N_noxref_8_c_2889_p N_noxref_10_c_3721_n ) capacitor c=4.64015e-19 \
 //x=31.825 //y=1.305 //x2=31.56 //y2=1.095
cc_2552 ( N_noxref_8_M19_noxref_d N_noxref_10_c_3721_n ) capacitor \
 c=0.00137165f //x=31.635 //y=1.095 //x2=31.56 //y2=1.095
cc_2553 ( N_noxref_8_c_2889_p N_noxref_10_c_3723_n ) capacitor c=0.0026012f \
 //x=31.825 //y=1.305 //x2=31.56 //y2=1.44
cc_2554 ( N_noxref_8_c_2805_n N_noxref_10_c_3723_n ) capacitor c=0.00127432f \
 //x=31.825 //y=1.76 //x2=31.56 //y2=1.44
cc_2555 ( N_noxref_8_M19_noxref_d N_noxref_10_c_3723_n ) capacitor \
 c=0.00237422f //x=31.635 //y=1.095 //x2=31.56 //y2=1.44
cc_2556 ( N_noxref_8_c_2805_n N_noxref_10_c_3726_n ) capacitor c=0.00429966f \
 //x=31.825 //y=1.76 //x2=31.56 //y2=1.75
cc_2557 ( N_noxref_8_c_2889_p N_noxref_10_c_3727_n ) capacitor c=5.29969e-19 \
 //x=31.825 //y=1.305 //x2=31.935 //y2=0.94
cc_2558 ( N_noxref_8_M19_noxref_d N_noxref_10_c_3727_n ) capacitor \
 c=0.0020782f //x=31.635 //y=1.095 //x2=31.935 //y2=0.94
cc_2559 ( N_noxref_8_c_2889_p N_noxref_10_c_3729_n ) capacitor c=5.16926e-19 \
 //x=31.825 //y=1.305 //x2=31.935 //y2=1.595
cc_2560 ( N_noxref_8_c_2805_n N_noxref_10_c_3729_n ) capacitor c=0.00942306f \
 //x=31.825 //y=1.76 //x2=31.935 //y2=1.595
cc_2561 ( N_noxref_8_c_2867_n N_noxref_10_c_3729_n ) capacitor c=0.00194716f \
 //x=32.225 //y=1.845 //x2=31.935 //y2=1.595
cc_2562 ( N_noxref_8_M19_noxref_d N_noxref_10_c_3729_n ) capacitor \
 c=0.00356097f //x=31.635 //y=1.095 //x2=31.935 //y2=1.595
cc_2563 ( N_noxref_8_c_2889_p N_noxref_10_c_3733_n ) capacitor c=5.24634e-19 \
 //x=31.825 //y=1.305 //x2=32.09 //y2=1.095
cc_2564 ( N_noxref_8_M19_noxref_d N_noxref_10_c_3733_n ) capacitor \
 c=0.00139206f //x=31.635 //y=1.095 //x2=32.09 //y2=1.095
cc_2565 ( N_noxref_8_c_2889_p N_noxref_10_c_3735_n ) capacitor c=0.00307978f \
 //x=31.825 //y=1.305 //x2=32.09 //y2=1.44
cc_2566 ( N_noxref_8_c_2805_n N_noxref_10_c_3735_n ) capacitor c=0.00363411f \
 //x=31.825 //y=1.76 //x2=32.09 //y2=1.44
cc_2567 ( N_noxref_8_c_2867_n N_noxref_10_c_3735_n ) capacitor c=0.00323576f \
 //x=32.225 //y=1.845 //x2=32.09 //y2=1.44
cc_2568 ( N_noxref_8_M19_noxref_d N_noxref_10_c_3735_n ) capacitor \
 c=0.00237422f //x=31.635 //y=1.095 //x2=32.09 //y2=1.44
cc_2569 ( N_noxref_8_c_2807_n N_noxref_10_c_3739_n ) capacitor c=0.0024584f \
 //x=32.31 //y=4.09 //x2=31.57 //y2=2.26
cc_2570 ( N_noxref_8_c_2805_n N_noxref_10_c_3740_n ) capacitor c=0.00362297f \
 //x=31.825 //y=1.76 //x2=31.57 //y2=2.095
cc_2571 ( N_noxref_8_c_2807_n N_noxref_10_c_3740_n ) capacitor c=0.00282067f \
 //x=32.31 //y=4.09 //x2=31.57 //y2=2.095
cc_2572 ( N_noxref_8_c_2814_n N_noxref_10_c_3742_n ) capacitor c=0.00739287f \
 //x=32.31 //y=5.25 //x2=31.57 //y2=4.88
cc_2573 ( N_noxref_8_c_2892_p N_noxref_10_c_3742_n ) capacitor c=0.00203307f \
 //x=31.53 //y=5.335 //x2=31.57 //y2=4.88
cc_2574 ( N_noxref_8_c_2902_p N_noxref_10_c_3742_n ) capacitor c=0.00375636f \
 //x=31.53 //y=5.56 //x2=31.57 //y2=4.88
cc_2575 ( N_noxref_8_c_2871_p N_noxref_11_c_4159_n ) capacitor c=0.0675244f \
 //x=42.3 //y=4.105 //x2=43.04 //y2=4.105
cc_2576 ( N_noxref_8_c_2969_p N_noxref_11_c_4159_n ) capacitor c=3.30333e-19 \
 //x=42.3 //y=2.26 //x2=43.04 //y2=4.105
cc_2577 ( N_noxref_8_c_2874_p N_noxref_11_c_4161_n ) capacitor c=0.0221457f \
 //x=42.3 //y=4.425 //x2=43.04 //y2=4.425
cc_2578 ( N_noxref_8_c_2971_p N_noxref_11_c_4161_n ) capacitor c=6.16601e-19 \
 //x=42.3 //y=4.25 //x2=43.04 //y2=4.425
cc_2579 ( N_noxref_8_c_2913_p N_noxref_11_c_4161_n ) capacitor c=0.00327794f \
 //x=42.3 //y=4.265 //x2=43.04 //y2=4.425
cc_2580 ( N_noxref_8_c_2875_p N_noxref_11_c_4164_n ) capacitor c=0.0172939f \
 //x=42.3 //y=4.88 //x2=43.04 //y2=4.735
cc_2581 ( N_noxref_8_c_2873_p N_noxref_11_c_4164_n ) capacitor c=0.0110353f \
 //x=42.302 //y=4.74 //x2=43.04 //y2=4.735
cc_2582 ( N_noxref_8_c_2876_p N_noxref_11_c_4164_n ) capacitor c=6.80711e-19 \
 //x=42.3 //y=4.88 //x2=43.04 //y2=4.735
cc_2583 ( N_noxref_8_c_2879_p N_noxref_11_c_4164_n ) capacitor c=0.001995f \
 //x=42.3 //y=4.88 //x2=43.04 //y2=4.735
cc_2584 ( N_noxref_8_c_2906_p N_noxref_11_c_4168_n ) capacitor c=0.0179797f \
 //x=42.3 //y=2.26 //x2=43.04 //y2=2.26
cc_2585 ( N_noxref_8_c_2969_p N_noxref_11_c_4168_n ) capacitor c=5.16867e-19 \
 //x=42.3 //y=2.26 //x2=43.04 //y2=2.26
cc_2586 ( N_noxref_8_c_2979_p N_noxref_11_c_4168_n ) capacitor c=0.00161745f \
 //x=42.105 //y=2.095 //x2=43.04 //y2=2.26
cc_2587 ( N_noxref_8_c_2874_p N_noxref_11_c_4171_n ) capacitor c=5.9727e-19 \
 //x=42.3 //y=4.425 //x2=43.04 //y2=4.25
cc_2588 ( N_noxref_8_c_2971_p N_noxref_11_c_4171_n ) capacitor c=0.0102199f \
 //x=42.3 //y=4.25 //x2=43.04 //y2=4.25
cc_2589 ( N_noxref_8_c_2874_p N_noxref_11_c_4173_n ) capacitor c=0.00327998f \
 //x=42.3 //y=4.425 //x2=43.19 //y2=4.265
cc_2590 ( N_noxref_8_c_2913_p N_noxref_11_c_4173_n ) capacitor c=0.0242355f \
 //x=42.3 //y=4.265 //x2=43.19 //y2=4.265
cc_2591 ( N_noxref_8_c_2871_p N_noxref_11_c_4175_n ) capacitor c=3.30333e-19 \
 //x=42.3 //y=4.105 //x2=43.04 //y2=2.26
cc_2592 ( N_noxref_8_c_2906_p N_noxref_11_c_4175_n ) capacitor c=5.24723e-19 \
 //x=42.3 //y=2.26 //x2=43.04 //y2=2.26
cc_2593 ( N_noxref_8_c_2969_p N_noxref_11_c_4175_n ) capacitor c=0.00485709f \
 //x=42.3 //y=2.26 //x2=43.04 //y2=2.26
cc_2594 ( N_noxref_8_c_2979_p N_noxref_11_c_4175_n ) capacitor c=0.00267961f \
 //x=42.105 //y=2.095 //x2=43.04 //y2=2.26
cc_2595 ( N_noxref_8_c_2875_p N_noxref_11_c_4179_n ) capacitor c=4.80626e-19 \
 //x=42.3 //y=4.88 //x2=43.07 //y2=4.88
cc_2596 ( N_noxref_8_c_2876_p N_noxref_11_c_4179_n ) capacitor c=0.00397338f \
 //x=42.3 //y=4.88 //x2=43.07 //y2=4.88
cc_2597 ( N_noxref_8_c_2879_p N_noxref_11_c_4179_n ) capacitor c=0.00283894f \
 //x=42.3 //y=4.88 //x2=43.07 //y2=4.88
cc_2598 ( N_noxref_8_M102_noxref_g N_noxref_11_M104_noxref_g ) capacitor \
 c=0.0104892f //x=42.2 //y=6.2 //x2=43.08 //y2=6.2
cc_2599 ( N_noxref_8_M103_noxref_g N_noxref_11_M104_noxref_g ) capacitor \
 c=0.107636f //x=42.64 //y=6.2 //x2=43.08 //y2=6.2
cc_2600 ( N_noxref_8_M103_noxref_g N_noxref_11_M105_noxref_g ) capacitor \
 c=0.0100341f //x=42.64 //y=6.2 //x2=43.52 //y2=6.2
cc_2601 ( N_noxref_8_c_2994_p N_noxref_11_c_4185_n ) capacitor c=4.86545e-19 \
 //x=42.105 //y=1.045 //x2=43.075 //y2=1.085
cc_2602 ( N_noxref_8_c_2995_p N_noxref_11_c_4185_n ) capacitor c=0.00152405f \
 //x=42.105 //y=1.39 //x2=43.075 //y2=1.085
cc_2603 ( N_noxref_8_c_2996_p N_noxref_11_c_4185_n ) capacitor c=0.0151475f \
 //x=42.635 //y=1.045 //x2=43.075 //y2=1.085
cc_2604 ( N_noxref_8_c_2997_p N_noxref_11_c_4188_n ) capacitor c=0.00109982f \
 //x=42.105 //y=1.7 //x2=43.075 //y2=1.43
cc_2605 ( N_noxref_8_c_2998_p N_noxref_11_c_4188_n ) capacitor c=0.0111064f \
 //x=42.635 //y=1.39 //x2=43.075 //y2=1.43
cc_2606 ( N_noxref_8_c_2997_p N_noxref_11_c_4190_n ) capacitor c=9.58243e-19 \
 //x=42.105 //y=1.7 //x2=43.075 //y2=1.74
cc_2607 ( N_noxref_8_c_2979_p N_noxref_11_c_4190_n ) capacitor c=0.00662747f \
 //x=42.105 //y=2.095 //x2=43.075 //y2=1.74
cc_2608 ( N_noxref_8_c_2998_p N_noxref_11_c_4190_n ) capacitor c=0.00862358f \
 //x=42.635 //y=1.39 //x2=43.075 //y2=1.74
cc_2609 ( N_noxref_8_c_2996_p N_noxref_11_c_4193_n ) capacitor c=0.00127211f \
 //x=42.635 //y=1.045 //x2=43.605 //y2=1.085
cc_2610 ( N_noxref_8_c_2998_p N_noxref_11_c_4194_n ) capacitor c=0.00204774f \
 //x=42.635 //y=1.39 //x2=43.605 //y2=1.43
cc_2611 ( N_noxref_8_c_2906_p N_noxref_11_c_4195_n ) capacitor c=0.00161167f \
 //x=42.3 //y=2.26 //x2=43.04 //y2=2.26
cc_2612 ( N_noxref_8_c_2969_p N_noxref_11_c_4195_n ) capacitor c=0.0018937f \
 //x=42.3 //y=2.26 //x2=43.04 //y2=2.26
cc_2613 ( N_noxref_8_c_2979_p N_noxref_11_c_4195_n ) capacitor c=0.0181449f \
 //x=42.105 //y=2.095 //x2=43.04 //y2=2.26
cc_2614 ( N_noxref_8_c_2875_p N_noxref_11_c_4198_n ) capacitor c=0.00158715f \
 //x=42.3 //y=4.88 //x2=43.07 //y2=4.88
cc_2615 ( N_noxref_8_c_2876_p N_noxref_11_c_4198_n ) capacitor c=0.00237977f \
 //x=42.3 //y=4.88 //x2=43.07 //y2=4.88
cc_2616 ( N_noxref_8_c_2879_p N_noxref_11_c_4198_n ) capacitor c=0.0297875f \
 //x=42.3 //y=4.88 //x2=43.07 //y2=4.88
cc_2617 ( N_noxref_8_c_2789_n D ) capacitor c=0.0223529f //x=26.76 //y=4.085 \
 //x2=26.02 //y2=2.77
cc_2618 ( N_noxref_8_c_2827_n D ) capacitor c=3.30333e-19 //x=26.76 //y=2.26 \
 //x2=26.02 //y2=2.77
cc_2619 ( N_noxref_8_c_2789_n D ) capacitor c=0.0339634f //x=26.76 //y=4.085 \
 //x2=26.02 //y2=3.88
cc_2620 ( N_noxref_8_c_2796_n D ) capacitor c=0.0148501f //x=26.76 //y=4.405 \
 //x2=26.02 //y2=3.88
cc_2621 ( N_noxref_8_c_2801_n D ) capacitor c=0.0120338f //x=26.76 //y=4.735 \
 //x2=26.02 //y2=3.88
cc_2622 ( N_noxref_8_c_2816_n D ) capacitor c=5.60537e-19 //x=26.76 //y=4.25 \
 //x2=26.02 //y2=3.88
cc_2623 ( N_noxref_8_c_2825_n D ) capacitor c=0.00686827f //x=26.92 //y=4.245 \
 //x2=26.02 //y2=3.88
cc_2624 ( N_noxref_8_c_2789_n D ) capacitor c=0.00103412f //x=26.76 //y=4.085 \
 //x2=26.02 //y2=3.14
cc_2625 ( N_noxref_8_c_2789_n N_D_c_5072_n ) capacitor c=0.0176983f //x=26.76 \
 //y=4.085 //x2=26.02 //y2=3.28
cc_2626 ( N_noxref_8_c_2815_n N_D_c_5126_n ) capacitor c=0.0179301f //x=26.76 \
 //y=2.26 //x2=26.02 //y2=2.26
cc_2627 ( N_noxref_8_c_2827_n N_D_c_5126_n ) capacitor c=5.24723e-19 //x=26.76 \
 //y=2.26 //x2=26.02 //y2=2.26
cc_2628 ( N_noxref_8_c_2860_n N_D_c_5126_n ) capacitor c=0.00161167f //x=26.76 \
 //y=2.26 //x2=26.02 //y2=2.26
cc_2629 ( N_noxref_8_c_2801_n N_D_c_5073_n ) capacitor c=0.0172939f //x=26.76 \
 //y=4.735 //x2=26.02 //y2=4.88
cc_2630 ( N_noxref_8_c_2828_n N_D_c_5073_n ) capacitor c=4.80626e-19 //x=26.79 \
 //y=4.88 //x2=26.02 //y2=4.88
cc_2631 ( N_noxref_8_c_2863_n N_D_c_5073_n ) capacitor c=0.00158715f //x=26.79 \
 //y=4.88 //x2=26.02 //y2=4.88
cc_2632 ( N_noxref_8_c_2822_n N_D_c_5075_n ) capacitor c=0.00618755f \
 //x=32.145 //y=4.25 //x2=27.715 //y2=3.155
cc_2633 ( N_noxref_8_c_2789_n N_D_c_5046_n ) capacitor c=0.025556f //x=26.76 \
 //y=4.085 //x2=27.37 //y2=3.155
cc_2634 ( N_noxref_8_c_2822_n N_D_c_5046_n ) capacitor c=0.00462322f \
 //x=32.145 //y=4.25 //x2=27.37 //y2=3.155
cc_2635 ( N_noxref_8_c_2822_n N_D_c_5081_n ) capacitor c=0.00245741f \
 //x=32.145 //y=4.25 //x2=28.965 //y2=3.14
cc_2636 ( N_noxref_8_c_2822_n N_D_c_5085_n ) capacitor c=0.0117661f //x=32.145 \
 //y=4.25 //x2=29.565 //y2=3.155
cc_2637 ( N_noxref_8_c_2807_n N_D_c_5088_n ) capacitor c=0.0236395f //x=32.31 \
 //y=4.09 //x2=33.775 //y2=3.14
cc_2638 ( N_noxref_8_c_2871_p N_D_c_5138_n ) capacitor c=0.0259425f //x=42.3 \
 //y=4.105 //x2=43.39 //y2=3.14
cc_2639 ( N_noxref_8_c_2789_n N_D_c_5139_n ) capacitor c=3.30333e-19 //x=26.76 \
 //y=4.085 //x2=26.02 //y2=2.26
cc_2640 ( N_noxref_8_c_2815_n N_D_c_5139_n ) capacitor c=5.16867e-19 //x=26.76 \
 //y=2.26 //x2=26.02 //y2=2.26
cc_2641 ( N_noxref_8_c_2827_n N_D_c_5139_n ) capacitor c=0.00445529f //x=26.76 \
 //y=2.26 //x2=26.02 //y2=2.26
cc_2642 ( N_noxref_8_c_2860_n N_D_c_5139_n ) capacitor c=0.00266443f //x=26.76 \
 //y=2.26 //x2=26.02 //y2=2.26
cc_2643 ( N_noxref_8_c_2801_n N_D_c_5094_n ) capacitor c=7.76143e-19 //x=26.76 \
 //y=4.735 //x2=26.02 //y2=4.88
cc_2644 ( N_noxref_8_c_2828_n N_D_c_5094_n ) capacitor c=0.00397338f //x=26.79 \
 //y=4.88 //x2=26.02 //y2=4.88
cc_2645 ( N_noxref_8_c_2863_n N_D_c_5094_n ) capacitor c=0.00237977f //x=26.79 \
 //y=4.88 //x2=26.02 //y2=4.88
cc_2646 ( N_noxref_8_M84_noxref_g N_D_M82_noxref_g ) capacitor c=0.0104892f \
 //x=26.8 //y=6.2 //x2=25.92 //y2=6.2
cc_2647 ( N_noxref_8_M84_noxref_g N_D_M83_noxref_g ) capacitor c=0.107636f \
 //x=26.8 //y=6.2 //x2=26.36 //y2=6.2
cc_2648 ( N_noxref_8_M85_noxref_g N_D_M83_noxref_g ) capacitor c=0.0100341f \
 //x=27.24 //y=6.2 //x2=26.36 //y2=6.2
cc_2649 ( N_noxref_8_c_2839_n N_D_c_5149_n ) capacitor c=4.86545e-19 \
 //x=26.795 //y=1.085 //x2=25.825 //y2=1.045
cc_2650 ( N_noxref_8_c_2839_n N_D_c_5150_n ) capacitor c=0.00152405f \
 //x=26.795 //y=1.085 //x2=25.825 //y2=1.39
cc_2651 ( N_noxref_8_c_2841_n N_D_c_5151_n ) capacitor c=0.00109982f \
 //x=26.795 //y=1.43 //x2=25.825 //y2=1.7
cc_2652 ( N_noxref_8_c_2844_n N_D_c_5151_n ) capacitor c=9.58243e-19 \
 //x=26.795 //y=1.74 //x2=25.825 //y2=1.7
cc_2653 ( N_noxref_8_c_2815_n N_D_c_5153_n ) capacitor c=0.00161745f //x=26.76 \
 //y=2.26 //x2=25.825 //y2=2.095
cc_2654 ( N_noxref_8_c_2827_n N_D_c_5153_n ) capacitor c=0.00267961f //x=26.76 \
 //y=2.26 //x2=25.825 //y2=2.095
cc_2655 ( N_noxref_8_c_2844_n N_D_c_5153_n ) capacitor c=0.00662747f \
 //x=26.795 //y=1.74 //x2=25.825 //y2=2.095
cc_2656 ( N_noxref_8_c_2860_n N_D_c_5153_n ) capacitor c=0.0181449f //x=26.76 \
 //y=2.26 //x2=25.825 //y2=2.095
cc_2657 ( N_noxref_8_c_2839_n N_D_c_5157_n ) capacitor c=0.0151475f //x=26.795 \
 //y=1.085 //x2=26.355 //y2=1.045
cc_2658 ( N_noxref_8_c_2854_n N_D_c_5157_n ) capacitor c=0.00127211f \
 //x=27.325 //y=1.085 //x2=26.355 //y2=1.045
cc_2659 ( N_noxref_8_c_2841_n N_D_c_5159_n ) capacitor c=0.0111064f //x=26.795 \
 //y=1.43 //x2=26.355 //y2=1.39
cc_2660 ( N_noxref_8_c_2844_n N_D_c_5159_n ) capacitor c=0.00862358f \
 //x=26.795 //y=1.74 //x2=26.355 //y2=1.39
cc_2661 ( N_noxref_8_c_2856_n N_D_c_5159_n ) capacitor c=0.00204774f \
 //x=27.325 //y=1.43 //x2=26.355 //y2=1.39
cc_2662 ( N_noxref_8_c_2801_n N_D_c_5101_n ) capacitor c=0.00201171f //x=26.76 \
 //y=4.735 //x2=26.02 //y2=4.88
cc_2663 ( N_noxref_8_c_2828_n N_D_c_5101_n ) capacitor c=0.00283894f //x=26.79 \
 //y=4.88 //x2=26.02 //y2=4.88
cc_2664 ( N_noxref_8_c_2863_n N_D_c_5101_n ) capacitor c=0.0297875f //x=26.79 \
 //y=4.88 //x2=26.02 //y2=4.88
cc_2665 ( N_noxref_8_c_2807_n CLK ) capacitor c=0.00257456f //x=32.31 //y=4.09 \
 //x2=30.46 //y2=3.88
cc_2666 ( N_noxref_8_c_2814_n CLK ) capacitor c=3.42225e-19 //x=32.31 //y=5.25 \
 //x2=30.46 //y2=3.88
cc_2667 ( N_noxref_8_c_2822_n CLK ) capacitor c=0.0261717f //x=32.145 //y=4.25 \
 //x2=30.46 //y2=3.88
cc_2668 ( N_noxref_8_c_2871_p CLK ) capacitor c=0.00267689f //x=42.3 //y=4.105 \
 //x2=39.71 //y2=2.77
cc_2669 ( N_noxref_8_c_2873_p CLK ) capacitor c=4.0519e-19 //x=42.302 //y=4.74 \
 //x2=39.71 //y2=2.77
cc_2670 ( N_noxref_8_c_2826_n CLK ) capacitor c=0.020623f //x=42.14 //y=4.265 \
 //x2=39.71 //y2=2.77
cc_2671 ( N_noxref_8_c_2804_n N_CLK_c_6547_n ) capacitor c=0.0232953f \
 //x=30.53 //y=5.335 //x2=30.46 //y2=4.755
cc_2672 ( N_noxref_8_c_3065_p N_CLK_c_6547_n ) capacitor c=0.00519317f \
 //x=30.65 //y=5.335 //x2=30.46 //y2=4.755
cc_2673 ( N_noxref_8_c_2822_n N_CLK_c_6547_n ) capacitor c=6.81418e-19 \
 //x=32.145 //y=4.25 //x2=30.46 //y2=4.755
cc_2674 ( N_noxref_8_c_3067_p N_CLK_c_6547_n ) capacitor c=0.00185675f \
 //x=30.65 //y=5.56 //x2=30.46 //y2=4.755
cc_2675 ( N_noxref_8_c_2826_n N_CLK_c_6594_n ) capacitor c=6.97969e-19 \
 //x=42.14 //y=4.265 //x2=39.745 //y2=4.75
cc_2676 ( N_noxref_8_c_2796_n N_CLK_c_6476_n ) capacitor c=0.00117033f \
 //x=26.76 //y=4.405 //x2=26.375 //y2=4.62
cc_2677 ( N_noxref_8_c_2801_n N_CLK_c_6476_n ) capacitor c=2.08037e-19 \
 //x=26.76 //y=4.735 //x2=26.375 //y2=4.62
cc_2678 ( N_noxref_8_c_2825_n N_CLK_c_6476_n ) capacitor c=0.0364798f \
 //x=26.92 //y=4.245 //x2=26.375 //y2=4.62
cc_2679 ( N_noxref_8_c_2796_n N_CLK_c_6553_n ) capacitor c=0.00370399f \
 //x=26.76 //y=4.405 //x2=26.975 //y2=4.63
cc_2680 ( N_noxref_8_c_2801_n N_CLK_c_6553_n ) capacitor c=0.0263725f \
 //x=26.76 //y=4.735 //x2=26.975 //y2=4.63
cc_2681 ( N_noxref_8_c_2822_n N_CLK_c_6553_n ) capacitor c=0.0111504f \
 //x=32.145 //y=4.25 //x2=26.975 //y2=4.63
cc_2682 ( N_noxref_8_c_2863_n N_CLK_c_6553_n ) capacitor c=7.58668e-19 \
 //x=26.79 //y=4.88 //x2=26.975 //y2=4.63
cc_2683 ( N_noxref_8_c_2813_n N_CLK_c_6648_n ) capacitor c=0.00726353f \
 //x=32.31 //y=4.41 //x2=32.52 //y2=4.635
cc_2684 ( N_noxref_8_c_2814_n N_CLK_c_6648_n ) capacitor c=0.02887f //x=32.31 \
 //y=5.25 //x2=32.52 //y2=4.635
cc_2685 ( N_noxref_8_c_2826_n N_CLK_c_6648_n ) capacitor c=0.0111206f \
 //x=42.14 //y=4.265 //x2=32.52 //y2=4.635
cc_2686 ( N_noxref_8_c_2801_n N_CLK_c_6554_n ) capacitor c=2.08036e-19 \
 //x=26.76 //y=4.735 //x2=32.175 //y2=4.635
cc_2687 ( N_noxref_8_c_2804_n N_CLK_c_6554_n ) capacitor c=0.00118242f \
 //x=30.53 //y=5.335 //x2=32.175 //y2=4.635
cc_2688 ( N_noxref_8_c_2866_n N_CLK_c_6554_n ) capacitor c=0.0194557f \
 //x=32.225 //y=5.335 //x2=32.175 //y2=4.635
cc_2689 ( N_noxref_8_c_2813_n N_CLK_c_6554_n ) capacitor c=0.00124799f \
 //x=32.31 //y=4.41 //x2=32.175 //y2=4.635
cc_2690 ( N_noxref_8_c_2814_n N_CLK_c_6554_n ) capacitor c=3.09276e-19 \
 //x=32.31 //y=5.25 //x2=32.175 //y2=4.635
cc_2691 ( N_noxref_8_c_2817_n N_CLK_c_6554_n ) capacitor c=0.028072f \
 //x=29.772 //y=5.335 //x2=32.175 //y2=4.635
cc_2692 ( N_noxref_8_c_3065_p N_CLK_c_6554_n ) capacitor c=0.0392307f \
 //x=30.65 //y=5.335 //x2=32.175 //y2=4.635
cc_2693 ( N_noxref_8_c_2822_n N_CLK_c_6554_n ) capacitor c=0.465811f \
 //x=32.145 //y=4.25 //x2=32.175 //y2=4.635
cc_2694 ( N_noxref_8_c_2824_n N_CLK_c_6554_n ) capacitor c=0.0364871f \
 //x=32.465 //y=4.25 //x2=32.175 //y2=4.635
cc_2695 ( N_noxref_8_c_2874_p N_CLK_c_6660_n ) capacitor c=0.002329f //x=42.3 \
 //y=4.425 //x2=43.245 //y2=4.65
cc_2696 ( N_noxref_8_c_2875_p N_CLK_c_6660_n ) capacitor c=0.00362281f \
 //x=42.3 //y=4.88 //x2=43.245 //y2=4.65
cc_2697 ( N_noxref_8_c_2873_p N_CLK_c_6660_n ) capacitor c=0.0253642f \
 //x=42.302 //y=4.74 //x2=43.245 //y2=4.65
cc_2698 ( N_noxref_8_c_2879_p N_CLK_c_6660_n ) capacitor c=0.00111841f \
 //x=42.3 //y=4.88 //x2=43.245 //y2=4.65
cc_2699 ( N_noxref_8_c_2814_n N_CLK_c_6557_n ) capacitor c=4.72093e-19 \
 //x=32.31 //y=5.25 //x2=42.17 //y2=4.65
cc_2700 ( N_noxref_8_c_2874_p N_CLK_c_6557_n ) capacitor c=0.00418223f \
 //x=42.3 //y=4.425 //x2=42.17 //y2=4.65
cc_2701 ( N_noxref_8_c_2873_p N_CLK_c_6557_n ) capacitor c=0.00119715f \
 //x=42.302 //y=4.74 //x2=42.17 //y2=4.65
cc_2702 ( N_noxref_8_c_2913_p N_CLK_c_6557_n ) capacitor c=0.0364798f //x=42.3 \
 //y=4.265 //x2=42.17 //y2=4.65
cc_2703 ( N_noxref_8_c_2826_n N_CLK_c_6557_n ) capacitor c=0.8693f //x=42.14 \
 //y=4.265 //x2=42.17 //y2=4.65
cc_2704 ( N_noxref_8_c_2804_n N_CLK_c_6562_n ) capacitor c=0.00492634f \
 //x=30.53 //y=5.335 //x2=30.46 //y2=4.88
cc_2705 ( N_noxref_8_c_3065_p N_CLK_c_6562_n ) capacitor c=0.00132214f \
 //x=30.65 //y=5.335 //x2=30.46 //y2=4.88
cc_2706 ( N_noxref_8_c_2804_n N_CLK_M88_noxref_g ) capacitor c=0.00858236f \
 //x=30.53 //y=5.335 //x2=30.43 //y2=6.2
cc_2707 ( N_noxref_8_c_3065_p N_CLK_M88_noxref_g ) capacitor c=0.00229818f \
 //x=30.65 //y=5.335 //x2=30.43 //y2=6.2
cc_2708 ( N_noxref_8_c_3067_p N_CLK_M88_noxref_g ) capacitor c=0.0179041f \
 //x=30.65 //y=5.56 //x2=30.43 //y2=6.2
cc_2709 ( N_noxref_8_c_2938_p N_CLK_M89_noxref_g ) capacitor c=0.00955829f \
 //x=31.415 //y=5.335 //x2=30.87 //y2=6.2
cc_2710 ( N_noxref_8_c_3065_p N_CLK_M89_noxref_g ) capacitor c=0.00230699f \
 //x=30.65 //y=5.335 //x2=30.87 //y2=6.2
cc_2711 ( N_noxref_8_c_3067_p N_CLK_M89_noxref_g ) capacitor c=0.0179041f \
 //x=30.65 //y=5.56 //x2=30.87 //y2=6.2
cc_2712 ( N_noxref_8_c_3065_p N_CLK_c_6677_n ) capacitor c=0.00172334f \
 //x=30.65 //y=5.335 //x2=30.795 //y2=4.97
cc_2713 ( N_noxref_8_c_3067_p N_CLK_c_6677_n ) capacitor c=0.00294585f \
 //x=30.65 //y=5.56 //x2=30.795 //y2=4.97
cc_2714 ( N_noxref_8_c_2804_n N_CLK_c_6580_n ) capacitor c=3.67903e-19 \
 //x=30.53 //y=5.335 //x2=30.46 //y2=4.88
cc_2715 ( N_noxref_8_c_2807_n N_SN_c_8257_n ) capacitor c=0.0012708f //x=32.31 \
 //y=4.09 //x2=35.27 //y2=4.765
cc_2716 ( N_noxref_8_c_2814_n N_SN_c_8257_n ) capacitor c=3.83887e-19 \
 //x=32.31 //y=5.25 //x2=35.27 //y2=4.765
cc_2717 ( N_noxref_8_c_2826_n N_SN_c_8257_n ) capacitor c=0.023508f //x=42.14 \
 //y=4.265 //x2=35.27 //y2=4.765
cc_2718 ( N_noxref_8_c_2789_n N_SN_c_8145_n ) capacitor c=0.0138058f //x=26.76 \
 //y=4.085 //x2=27.285 //y2=2.385
cc_2719 ( N_noxref_8_c_2815_n N_SN_c_8145_n ) capacitor c=0.017633f //x=26.76 \
 //y=2.26 //x2=27.285 //y2=2.385
cc_2720 ( N_noxref_8_c_2860_n N_SN_c_8145_n ) capacitor c=2.98635e-19 \
 //x=26.76 //y=2.26 //x2=27.285 //y2=2.385
cc_2721 ( N_noxref_8_c_2889_p N_SN_c_8282_n ) capacitor c=7.13469e-19 \
 //x=31.825 //y=1.305 //x2=33.775 //y2=2.4
cc_2722 ( N_noxref_8_c_2806_n N_SN_c_8282_n ) capacitor c=0.0214668f //x=31.91 \
 //y=1.845 //x2=33.775 //y2=2.4
cc_2723 ( N_noxref_8_c_2807_n N_SN_c_8282_n ) capacitor c=0.0279371f //x=32.31 \
 //y=4.09 //x2=33.775 //y2=2.4
cc_2724 ( N_noxref_8_c_2871_p N_SN_c_8324_n ) capacitor c=0.0153133f //x=42.3 \
 //y=4.105 //x2=46.57 //y2=2.4
cc_2725 ( N_noxref_8_c_2906_p N_SN_c_8324_n ) capacitor c=0.0183918f //x=42.3 \
 //y=2.26 //x2=46.57 //y2=2.4
cc_2726 ( N_noxref_8_c_2969_p N_SN_c_8324_n ) capacitor c=2.20453e-19 //x=42.3 \
 //y=2.26 //x2=46.57 //y2=2.4
cc_2727 ( N_noxref_8_c_2979_p N_SN_c_8324_n ) capacitor c=3.61358e-19 \
 //x=42.105 //y=2.095 //x2=46.57 //y2=2.4
cc_2728 ( N_noxref_8_c_2789_n N_noxref_21_c_10538_n ) capacitor c=0.00221516f \
 //x=26.76 //y=4.085 //x2=24.17 //y2=3.365
cc_2729 ( N_noxref_8_c_2789_n N_noxref_21_c_10544_n ) capacitor c=9.73084e-19 \
 //x=26.76 //y=4.085 //x2=24.17 //y2=5.25
cc_2730 ( N_noxref_8_c_2801_n N_noxref_21_c_10544_n ) capacitor c=7.5403e-19 \
 //x=26.76 //y=4.735 //x2=24.17 //y2=5.25
cc_2731 ( N_noxref_8_c_2807_n N_noxref_21_c_10581_n ) capacitor c=0.0014211f \
 //x=32.31 //y=4.09 //x2=31.79 //y2=3.48
cc_2732 ( N_noxref_8_c_2822_n N_noxref_21_c_10581_n ) capacitor c=0.00280056f \
 //x=32.145 //y=4.25 //x2=31.79 //y2=3.48
cc_2733 ( N_noxref_8_c_2789_n N_noxref_21_c_10561_n ) capacitor c=0.0228063f \
 //x=26.76 //y=4.085 //x2=31.36 //y2=3.48
cc_2734 ( N_noxref_8_c_2796_n N_noxref_21_c_10561_n ) capacitor c=0.00361218f \
 //x=26.76 //y=4.405 //x2=31.36 //y2=3.48
cc_2735 ( N_noxref_8_c_2822_n N_noxref_21_c_10561_n ) capacitor c=0.19552f \
 //x=32.145 //y=4.25 //x2=31.36 //y2=3.48
cc_2736 ( N_noxref_8_c_2825_n N_noxref_21_c_10561_n ) capacitor c=0.0157826f \
 //x=26.92 //y=4.245 //x2=31.36 //y2=3.48
cc_2737 ( N_noxref_8_c_2807_n N_noxref_21_c_10586_n ) capacitor c=0.0227143f \
 //x=32.31 //y=4.09 //x2=35.995 //y2=3.51
cc_2738 ( N_noxref_8_c_2826_n N_noxref_21_c_10586_n ) capacitor c=0.0312032f \
 //x=42.14 //y=4.265 //x2=35.995 //y2=3.51
cc_2739 ( N_noxref_8_c_2826_n N_noxref_21_c_10587_n ) capacitor c=0.0253534f \
 //x=42.14 //y=4.265 //x2=36.595 //y2=3.48
cc_2740 ( N_noxref_8_c_2826_n N_noxref_21_c_10588_n ) capacitor c=0.00344922f \
 //x=42.14 //y=4.265 //x2=40.06 //y2=3.51
cc_2741 ( N_noxref_8_c_2871_p N_noxref_21_c_10604_n ) capacitor c=5.43383e-19 \
 //x=42.3 //y=4.105 //x2=40.66 //y2=3.48
cc_2742 ( N_noxref_8_c_2826_n N_noxref_21_c_10604_n ) capacitor c=0.00978337f \
 //x=42.14 //y=4.265 //x2=40.66 //y2=3.48
cc_2743 ( N_noxref_8_c_2871_p N_noxref_21_c_10606_n ) capacitor c=0.023256f \
 //x=42.3 //y=4.105 //x2=47.465 //y2=3.51
cc_2744 ( N_noxref_8_c_2804_n N_VDD_c_11522_n ) capacitor c=0.00621353f \
 //x=30.53 //y=5.335 //x2=74.455 //y2=7.585
cc_2745 ( N_noxref_8_c_2938_p N_VDD_c_11522_n ) capacitor c=0.00627192f \
 //x=31.415 //y=5.335 //x2=74.455 //y2=7.585
cc_2746 ( N_noxref_8_c_2865_n N_VDD_c_11522_n ) capacitor c=0.00256019f \
 //x=31.53 //y=5.56 //x2=74.455 //y2=7.585
cc_2747 ( N_noxref_8_c_2866_n N_VDD_c_11522_n ) capacitor c=0.00829084f \
 //x=32.225 //y=5.335 //x2=74.455 //y2=7.585
cc_2748 ( N_noxref_8_c_2813_n N_VDD_c_11522_n ) capacitor c=4.85202e-19 \
 //x=32.31 //y=4.41 //x2=74.455 //y2=7.585
cc_2749 ( N_noxref_8_c_2874_p N_VDD_c_11522_n ) capacitor c=2.3602e-19 \
 //x=42.3 //y=4.425 //x2=74.455 //y2=7.585
cc_2750 ( N_noxref_8_c_2817_n N_VDD_c_11522_n ) capacitor c=0.00261804f \
 //x=29.772 //y=5.335 //x2=74.455 //y2=7.585
cc_2751 ( N_noxref_8_c_3065_p N_VDD_c_11522_n ) capacitor c=0.00270108f \
 //x=30.65 //y=5.335 //x2=74.455 //y2=7.585
cc_2752 ( N_noxref_8_c_2899_p N_VDD_c_11522_n ) capacitor c=3.82513e-19 \
 //x=32.305 //y=4.25 //x2=74.455 //y2=7.585
cc_2753 ( N_noxref_8_c_2875_p N_VDD_c_11522_n ) capacitor c=9.07241e-19 \
 //x=42.3 //y=4.88 //x2=74.455 //y2=7.585
cc_2754 ( N_noxref_8_c_2830_n N_VDD_c_11522_n ) capacitor c=0.0024232f \
 //x=29.77 //y=5.56 //x2=74.455 //y2=7.585
cc_2755 ( N_noxref_8_c_3067_p N_VDD_c_11522_n ) capacitor c=0.0024232f \
 //x=30.65 //y=5.56 //x2=74.455 //y2=7.585
cc_2756 ( N_noxref_8_c_2902_p N_VDD_c_11522_n ) capacitor c=0.0024232f \
 //x=31.53 //y=5.56 //x2=74.455 //y2=7.585
cc_2757 ( N_noxref_8_c_2876_p N_VDD_c_11522_n ) capacitor c=6.22888e-19 \
 //x=42.3 //y=4.88 //x2=74.455 //y2=7.585
cc_2758 ( N_noxref_8_M84_noxref_g N_VDD_c_11832_n ) capacitor c=0.00697352f \
 //x=26.8 //y=6.2 //x2=27.375 //y2=7.585
cc_2759 ( N_noxref_8_M85_noxref_g N_VDD_c_11832_n ) capacitor c=0.00755544f \
 //x=27.24 //y=6.2 //x2=27.375 //y2=7.585
cc_2760 ( N_noxref_8_c_2804_n N_VDD_c_11837_n ) capacitor c=0.00202922f \
 //x=30.53 //y=5.335 //x2=30.125 //y2=7.585
cc_2761 ( N_noxref_8_c_2817_n N_VDD_c_11837_n ) capacitor c=9.3757e-19 \
 //x=29.772 //y=5.335 //x2=30.125 //y2=7.585
cc_2762 ( N_noxref_8_c_2830_n N_VDD_c_11837_n ) capacitor c=0.0138074f \
 //x=29.77 //y=5.56 //x2=30.125 //y2=7.585
cc_2763 ( N_noxref_8_c_2804_n N_VDD_c_11951_n ) capacitor c=0.0017708f \
 //x=30.53 //y=5.335 //x2=31.005 //y2=7.585
cc_2764 ( N_noxref_8_c_2938_p N_VDD_c_11951_n ) capacitor c=0.00202922f \
 //x=31.415 //y=5.335 //x2=31.005 //y2=7.585
cc_2765 ( N_noxref_8_c_3065_p N_VDD_c_11951_n ) capacitor c=9.4822e-19 \
 //x=30.65 //y=5.335 //x2=31.005 //y2=7.585
cc_2766 ( N_noxref_8_c_3067_p N_VDD_c_11951_n ) capacitor c=0.0138074f \
 //x=30.65 //y=5.56 //x2=31.005 //y2=7.585
cc_2767 ( N_noxref_8_c_2938_p N_VDD_c_11955_n ) capacitor c=0.00205906f \
 //x=31.415 //y=5.335 //x2=31.885 //y2=7.585
cc_2768 ( N_noxref_8_c_2865_n N_VDD_c_11955_n ) capacitor c=8.49654e-19 \
 //x=31.53 //y=5.56 //x2=31.885 //y2=7.585
cc_2769 ( N_noxref_8_c_2866_n N_VDD_c_11955_n ) capacitor c=0.00204238f \
 //x=32.225 //y=5.335 //x2=31.885 //y2=7.585
cc_2770 ( N_noxref_8_c_2902_p N_VDD_c_11955_n ) capacitor c=0.0135103f \
 //x=31.53 //y=5.56 //x2=31.885 //y2=7.585
cc_2771 ( N_noxref_8_c_2866_n N_VDD_c_11959_n ) capacitor c=0.00157114f \
 //x=32.225 //y=5.335 //x2=32.88 //y2=7.585
cc_2772 ( N_noxref_8_c_2813_n N_VDD_c_11959_n ) capacitor c=3.91238e-19 \
 //x=32.31 //y=4.41 //x2=32.88 //y2=7.585
cc_2773 ( N_noxref_8_c_2875_p N_VDD_c_11961_n ) capacitor c=6.28113e-19 \
 //x=42.3 //y=4.88 //x2=42.775 //y2=7.585
cc_2774 ( N_noxref_8_M102_noxref_g N_VDD_c_11961_n ) capacitor c=0.00732618f \
 //x=42.2 //y=6.2 //x2=42.775 //y2=7.585
cc_2775 ( N_noxref_8_M103_noxref_g N_VDD_c_11961_n ) capacitor c=0.00755544f \
 //x=42.64 //y=6.2 //x2=42.775 //y2=7.585
cc_2776 ( N_noxref_8_c_2816_n N_VDD_c_11799_n ) capacitor c=9.76453e-19 \
 //x=26.76 //y=4.25 //x2=24.91 //y2=7.585
cc_2777 ( N_noxref_8_c_2816_n N_VDD_c_11844_n ) capacitor c=0.00133334f \
 //x=26.76 //y=4.25 //x2=28.24 //y2=7.585
cc_2778 ( N_noxref_8_c_2817_n N_VDD_c_11844_n ) capacitor c=0.0022955f \
 //x=29.772 //y=5.335 //x2=28.24 //y2=7.585
cc_2779 ( N_noxref_8_c_2822_n N_VDD_c_11844_n ) capacitor c=0.00867154f \
 //x=32.145 //y=4.25 //x2=28.24 //y2=7.585
cc_2780 ( N_noxref_8_c_2828_n N_VDD_c_11844_n ) capacitor c=0.00226427f \
 //x=26.79 //y=4.88 //x2=28.24 //y2=7.585
cc_2781 ( N_noxref_8_c_2830_n N_VDD_c_11844_n ) capacitor c=0.00508013f \
 //x=29.77 //y=5.56 //x2=28.24 //y2=7.585
cc_2782 ( N_noxref_8_c_2845_n N_VDD_c_11844_n ) capacitor c=0.0129149f \
 //x=27.165 //y=4.97 //x2=28.24 //y2=7.585
cc_2783 ( N_noxref_8_c_2863_n N_VDD_c_11844_n ) capacitor c=2.73429e-19 \
 //x=26.79 //y=4.88 //x2=28.24 //y2=7.585
cc_2784 ( N_noxref_8_c_2865_n N_VDD_c_11851_n ) capacitor c=0.00282782f \
 //x=31.53 //y=5.56 //x2=33.05 //y2=7.585
cc_2785 ( N_noxref_8_c_2813_n N_VDD_c_11851_n ) capacitor c=0.00177813f \
 //x=32.31 //y=4.41 //x2=33.05 //y2=7.585
cc_2786 ( N_noxref_8_c_2814_n N_VDD_c_11851_n ) capacitor c=0.0293445f \
 //x=32.31 //y=5.25 //x2=33.05 //y2=7.585
cc_2787 ( N_noxref_8_c_2899_p N_VDD_c_11851_n ) capacitor c=0.00499873f \
 //x=32.305 //y=4.25 //x2=33.05 //y2=7.585
cc_2788 ( N_noxref_8_c_2826_n N_VDD_c_11851_n ) capacitor c=0.00826669f \
 //x=42.14 //y=4.265 //x2=33.05 //y2=7.585
cc_2789 ( N_noxref_8_c_2902_p N_VDD_c_11851_n ) capacitor c=0.00777981f \
 //x=31.53 //y=5.56 //x2=33.05 //y2=7.585
cc_2790 ( N_noxref_8_c_2826_n N_VDD_c_11909_n ) capacitor c=0.00885867f \
 //x=42.14 //y=4.265 //x2=37.86 //y2=7.585
cc_2791 ( N_noxref_8_c_2874_p N_VDD_c_11979_n ) capacitor c=0.00144835f \
 //x=42.3 //y=4.425 //x2=41.19 //y2=7.585
cc_2792 ( N_noxref_8_c_2971_p N_VDD_c_11979_n ) capacitor c=0.00247508f \
 //x=42.3 //y=4.25 //x2=41.19 //y2=7.585
cc_2793 ( N_noxref_8_c_2875_p N_VDD_c_11979_n ) capacitor c=0.00483853f \
 //x=42.3 //y=4.88 //x2=41.19 //y2=7.585
cc_2794 ( N_noxref_8_c_2873_p N_VDD_c_11979_n ) capacitor c=0.00401745f \
 //x=42.302 //y=4.74 //x2=41.19 //y2=7.585
cc_2795 ( N_noxref_8_c_2826_n N_VDD_c_11979_n ) capacitor c=0.00852871f \
 //x=42.14 //y=4.265 //x2=41.19 //y2=7.585
cc_2796 ( N_noxref_8_c_2876_p N_VDD_c_11979_n ) capacitor c=0.00370494f \
 //x=42.3 //y=4.88 //x2=41.19 //y2=7.585
cc_2797 ( N_noxref_8_c_2879_p N_VDD_c_11979_n ) capacitor c=0.0129564f \
 //x=42.3 //y=4.88 //x2=41.19 //y2=7.585
cc_2798 ( N_noxref_8_c_2817_n N_VDD_M82_noxref_s ) capacitor c=4.22189e-19 \
 //x=29.772 //y=5.335 //x2=25.565 //y2=5.2
cc_2799 ( N_noxref_8_M84_noxref_g N_VDD_M83_noxref_d ) capacitor c=0.015318f \
 //x=26.8 //y=6.2 //x2=26.435 //y2=5.2
cc_2800 ( N_noxref_8_c_2863_n N_VDD_M83_noxref_d ) capacitor c=3.50465e-19 \
 //x=26.79 //y=4.88 //x2=26.435 //y2=5.2
cc_2801 ( N_noxref_8_M85_noxref_g N_VDD_M85_noxref_d ) capacitor c=0.0430452f \
 //x=27.24 //y=6.2 //x2=27.315 //y2=5.2
cc_2802 ( N_noxref_8_c_2817_n N_VDD_M86_noxref_s ) capacitor c=0.0442713f \
 //x=29.772 //y=5.335 //x2=29.195 //y2=5.2
cc_2803 ( N_noxref_8_c_3065_p N_VDD_M86_noxref_s ) capacitor c=7.80122e-19 \
 //x=30.65 //y=5.335 //x2=29.195 //y2=5.2
cc_2804 ( N_noxref_8_c_2830_n N_VDD_M86_noxref_s ) capacitor c=0.0908457f \
 //x=29.77 //y=5.56 //x2=29.195 //y2=5.2
cc_2805 ( N_noxref_8_c_2804_n N_VDD_M87_noxref_d ) capacitor c=0.00700141f \
 //x=30.53 //y=5.335 //x2=30.065 //y2=5.2
cc_2806 ( N_noxref_8_c_2830_n N_VDD_M87_noxref_d ) capacitor c=0.0673792f \
 //x=29.77 //y=5.56 //x2=30.065 //y2=5.2
cc_2807 ( N_noxref_8_c_3067_p N_VDD_M87_noxref_d ) capacitor c=0.0674762f \
 //x=30.65 //y=5.56 //x2=30.065 //y2=5.2
cc_2808 ( N_noxref_8_c_2938_p N_VDD_M89_noxref_d ) capacitor c=0.00700141f \
 //x=31.415 //y=5.335 //x2=30.945 //y2=5.2
cc_2809 ( N_noxref_8_c_3067_p N_VDD_M89_noxref_d ) capacitor c=0.067493f \
 //x=30.65 //y=5.56 //x2=30.945 //y2=5.2
cc_2810 ( N_noxref_8_c_2902_p N_VDD_M89_noxref_d ) capacitor c=0.0674979f \
 //x=31.53 //y=5.56 //x2=30.945 //y2=5.2
cc_2811 ( N_noxref_8_c_2866_n N_VDD_M91_noxref_d ) capacitor c=0.00700141f \
 //x=32.225 //y=5.335 //x2=31.825 //y2=5.2
cc_2812 ( N_noxref_8_c_2902_p N_VDD_M91_noxref_d ) capacitor c=0.0675002f \
 //x=31.53 //y=5.56 //x2=31.825 //y2=5.2
cc_2813 ( N_noxref_8_c_2865_n N_VDD_M92_noxref_s ) capacitor c=0.00492616f \
 //x=31.53 //y=5.56 //x2=34.005 //y2=5.2
cc_2814 ( N_noxref_8_c_2866_n N_VDD_M92_noxref_s ) capacitor c=9.42705e-19 \
 //x=32.225 //y=5.335 //x2=34.005 //y2=5.2
cc_2815 ( N_noxref_8_c_3065_p N_VDD_M92_noxref_s ) capacitor c=2.11884e-19 \
 //x=30.65 //y=5.335 //x2=34.005 //y2=5.2
cc_2816 ( N_noxref_8_c_2874_p N_VDD_M102_noxref_s ) capacitor c=0.00231402f \
 //x=42.3 //y=4.425 //x2=41.845 //y2=5.2
cc_2817 ( N_noxref_8_M102_noxref_g N_VDD_M102_noxref_s ) capacitor \
 c=0.0567929f //x=42.2 //y=6.2 //x2=41.845 //y2=5.2
cc_2818 ( N_noxref_8_M103_noxref_g N_VDD_M103_noxref_d ) capacitor c=0.015318f \
 //x=42.64 //y=6.2 //x2=42.715 //y2=5.2
cc_2819 ( N_noxref_8_c_2889_p N_noxref_27_c_13156_n ) capacitor c=0.0036878f \
 //x=31.825 //y=1.305 //x2=32.225 //y2=0.72
cc_2820 ( N_noxref_8_c_2867_n N_noxref_27_c_13156_n ) capacitor c=0.00399931f \
 //x=32.225 //y=1.845 //x2=32.225 //y2=0.72
cc_2821 ( N_noxref_8_M19_noxref_d N_noxref_27_c_13156_n ) capacitor \
 c=0.00910163f //x=31.635 //y=1.095 //x2=32.225 //y2=0.72
cc_2822 ( N_noxref_8_M19_noxref_d N_noxref_27_c_13159_n ) capacitor \
 c=0.00120711f //x=31.635 //y=1.095 //x2=31.34 //y2=1.175
cc_2823 ( N_noxref_8_c_2804_n N_noxref_27_M18_noxref_d ) capacitor \
 c=0.00143559f //x=30.53 //y=5.335 //x2=30.1 //y2=1.09
cc_2824 ( N_noxref_8_c_2889_p N_noxref_27_M18_noxref_d ) capacitor \
 c=0.00802417f //x=31.825 //y=1.305 //x2=30.1 //y2=1.09
cc_2825 ( N_noxref_8_c_2889_p N_noxref_27_M19_noxref_s ) capacitor \
 c=0.0098487f //x=31.825 //y=1.305 //x2=31.205 //y2=0.555
cc_2826 ( N_noxref_8_c_2805_n N_noxref_27_M19_noxref_s ) capacitor \
 c=0.0283111f //x=31.825 //y=1.76 //x2=31.205 //y2=0.555
cc_2827 ( N_noxref_8_c_2867_n N_noxref_27_M19_noxref_s ) capacitor \
 c=0.00946155f //x=32.225 //y=1.845 //x2=31.205 //y2=0.555
cc_2828 ( N_noxref_8_c_2899_p N_noxref_27_M19_noxref_s ) capacitor \
 c=0.00104339f //x=32.305 //y=4.25 //x2=31.205 //y2=0.555
cc_2829 ( N_noxref_8_M19_noxref_d N_noxref_27_M19_noxref_s ) capacitor \
 c=0.0279003f //x=31.635 //y=1.095 //x2=31.205 //y2=0.555
cc_2830 ( N_noxref_8_c_2889_p N_noxref_28_M21_noxref_d ) capacitor \
 c=3.20746e-19 //x=31.825 //y=1.305 //x2=34.91 //y2=1.09
cc_2831 ( N_noxref_8_c_2815_n N_GND_c_14081_n ) capacitor c=0.00210951f \
 //x=26.76 //y=2.26 //x2=29.23 //y2=0.175
cc_2832 ( N_noxref_8_c_2889_p N_GND_c_14198_n ) capacitor c=0.00884249f \
 //x=31.825 //y=1.305 //x2=34.04 //y2=0.175
cc_2833 ( N_noxref_8_c_2867_n N_GND_c_14198_n ) capacitor c=0.00662952f \
 //x=32.225 //y=1.845 //x2=34.04 //y2=0.175
cc_2834 ( N_noxref_8_c_2813_n N_GND_c_14198_n ) capacitor c=2.51625e-19 \
 //x=32.31 //y=4.41 //x2=34.04 //y2=0.175
cc_2835 ( N_noxref_8_M19_noxref_d N_GND_c_14198_n ) capacitor c=2.9462e-19 \
 //x=31.635 //y=1.095 //x2=34.04 //y2=0.175
cc_2836 ( N_noxref_8_c_2889_p N_GND_c_14104_n ) capacitor c=0.00543195f \
 //x=31.825 //y=1.305 //x2=34.125 //y2=1.145
cc_2837 ( N_noxref_8_c_2906_p N_GND_c_14203_n ) capacitor c=0.00645051f \
 //x=42.3 //y=2.26 //x2=42.37 //y2=1.135
cc_2838 ( N_noxref_8_c_2969_p N_GND_c_14203_n ) capacitor c=2.13705e-19 \
 //x=42.3 //y=2.26 //x2=42.37 //y2=1.135
cc_2839 ( N_noxref_8_c_2994_p N_GND_c_14203_n ) capacitor c=0.00171023f \
 //x=42.105 //y=1.045 //x2=42.37 //y2=1.135
cc_2840 ( N_noxref_8_c_2995_p N_GND_c_14203_n ) capacitor c=0.00357815f \
 //x=42.105 //y=1.39 //x2=42.37 //y2=1.135
cc_2841 ( N_noxref_8_c_2997_p N_GND_c_14203_n ) capacitor c=4.2764e-19 \
 //x=42.105 //y=1.7 //x2=42.37 //y2=1.135
cc_2842 ( N_noxref_8_c_3235_p N_GND_c_14203_n ) capacitor c=9.36995e-19 \
 //x=42.48 //y=0.89 //x2=42.37 //y2=1.135
cc_2843 ( N_noxref_8_c_3236_p N_GND_c_14203_n ) capacitor c=6.33567e-19 \
 //x=42.48 //y=1.545 //x2=42.37 //y2=1.135
cc_2844 ( N_noxref_8_c_2996_p N_GND_c_14203_n ) capacitor c=0.00171483f \
 //x=42.635 //y=1.045 //x2=42.37 //y2=1.135
cc_2845 ( N_noxref_8_c_2998_p N_GND_c_14203_n ) capacitor c=0.00296337f \
 //x=42.635 //y=1.39 //x2=42.37 //y2=1.135
cc_2846 ( N_noxref_8_c_2994_p N_GND_c_14212_n ) capacitor c=3.46594e-19 \
 //x=42.105 //y=1.045 //x2=42.367 //y2=1.005
cc_2847 ( N_noxref_8_c_3235_p N_GND_c_14212_n ) capacitor c=0.00838576f \
 //x=42.48 //y=0.89 //x2=42.367 //y2=1.005
cc_2848 ( N_noxref_8_c_2996_p N_GND_c_14212_n ) capacitor c=4.40196e-19 \
 //x=42.635 //y=1.045 //x2=42.367 //y2=1.005
cc_2849 ( N_noxref_8_c_2815_n N_GND_c_14114_n ) capacitor c=3.77328e-19 \
 //x=26.76 //y=2.26 //x2=28.07 //y2=0.175
cc_2850 ( N_noxref_8_c_2867_n N_GND_c_14116_n ) capacitor c=6.86343e-19 \
 //x=32.225 //y=1.845 //x2=32.88 //y2=0.175
cc_2851 ( N_noxref_8_c_2994_p N_GND_c_14217_n ) capacitor c=0.00688027f \
 //x=42.105 //y=1.045 //x2=44.35 //y2=0.175
cc_2852 ( N_noxref_8_c_2827_n N_GND_c_14120_n ) capacitor c=0.00207214f \
 //x=26.76 //y=2.26 //x2=28.24 //y2=0.175
cc_2853 ( N_noxref_8_c_2856_n N_GND_c_14120_n ) capacitor c=0.00275184f \
 //x=27.325 //y=1.43 //x2=28.24 //y2=0.175
cc_2854 ( N_noxref_8_c_2860_n N_GND_c_14120_n ) capacitor c=2.63786e-19 \
 //x=26.76 //y=2.26 //x2=28.24 //y2=0.175
cc_2855 ( N_noxref_8_c_2805_n N_GND_c_14132_n ) capacitor c=0.0045138f \
 //x=31.825 //y=1.76 //x2=33.05 //y2=0.175
cc_2856 ( N_noxref_8_c_2867_n N_GND_c_14132_n ) capacitor c=0.0304548f \
 //x=32.225 //y=1.845 //x2=33.05 //y2=0.175
cc_2857 ( N_noxref_8_c_2871_p N_GND_c_14189_n ) capacitor c=0.00745875f \
 //x=42.3 //y=4.105 //x2=41.19 //y2=0.175
cc_2858 ( N_noxref_8_c_2906_p N_GND_c_14189_n ) capacitor c=0.00351582f \
 //x=42.3 //y=2.26 //x2=41.19 //y2=0.175
cc_2859 ( N_noxref_8_c_2969_p N_GND_c_14189_n ) capacitor c=0.00354425f \
 //x=42.3 //y=2.26 //x2=41.19 //y2=0.175
cc_2860 ( N_noxref_8_c_2997_p N_GND_c_14189_n ) capacitor c=0.0015404f \
 //x=42.105 //y=1.7 //x2=41.19 //y2=0.175
cc_2861 ( N_noxref_8_c_2979_p N_GND_c_14189_n ) capacitor c=0.00936534f \
 //x=42.105 //y=2.095 //x2=41.19 //y2=0.175
cc_2862 ( N_noxref_8_c_2906_p N_GND_M25_noxref_d ) capacitor c=2.20438e-19 \
 //x=42.3 //y=2.26 //x2=42.18 //y2=1.045
cc_2863 ( N_noxref_8_c_2994_p N_GND_M25_noxref_d ) capacitor c=0.00192399f \
 //x=42.105 //y=1.045 //x2=42.18 //y2=1.045
cc_2864 ( N_noxref_8_c_2995_p N_GND_M25_noxref_d ) capacitor c=0.00210798f \
 //x=42.105 //y=1.39 //x2=42.18 //y2=1.045
cc_2865 ( N_noxref_8_c_3235_p N_GND_M25_noxref_d ) capacitor c=0.00472259f \
 //x=42.48 //y=0.89 //x2=42.18 //y2=1.045
cc_2866 ( N_noxref_8_c_3236_p N_GND_M25_noxref_d ) capacitor c=0.00166857f \
 //x=42.48 //y=1.545 //x2=42.18 //y2=1.045
cc_2867 ( N_noxref_8_c_2996_p N_GND_M25_noxref_d ) capacitor c=0.00230174f \
 //x=42.635 //y=1.045 //x2=42.18 //y2=1.045
cc_2868 ( N_noxref_8_c_2998_p N_GND_M25_noxref_d ) capacitor c=0.00210798f \
 //x=42.635 //y=1.39 //x2=42.18 //y2=1.045
cc_2869 ( N_noxref_8_c_2796_n N_noxref_43_c_15971_n ) capacitor c=3.23849e-19 \
 //x=26.76 //y=4.405 //x2=26.575 //y2=1.675
cc_2870 ( N_noxref_8_c_2815_n N_noxref_43_c_15971_n ) capacitor c=7.50092e-19 \
 //x=26.76 //y=2.26 //x2=26.575 //y2=1.675
cc_2871 ( N_noxref_8_c_2844_n N_noxref_43_c_15971_n ) capacitor c=0.00888238f \
 //x=26.795 //y=1.74 //x2=26.575 //y2=1.675
cc_2872 ( N_noxref_8_c_2860_n N_noxref_43_c_15971_n ) capacitor c=0.00175171f \
 //x=26.76 //y=2.26 //x2=26.575 //y2=1.675
cc_2873 ( N_noxref_8_c_2815_n N_noxref_43_c_15972_n ) capacitor c=0.001463f \
 //x=26.76 //y=2.26 //x2=27.46 //y2=0.71
cc_2874 ( N_noxref_8_c_2827_n N_noxref_43_c_15972_n ) capacitor c=8.82141e-19 \
 //x=26.76 //y=2.26 //x2=27.46 //y2=0.71
cc_2875 ( N_noxref_8_c_2839_n N_noxref_43_c_15972_n ) capacitor c=0.0200738f \
 //x=26.795 //y=1.085 //x2=27.46 //y2=0.71
cc_2876 ( N_noxref_8_c_2854_n N_noxref_43_c_15972_n ) capacitor c=0.00825432f \
 //x=27.325 //y=1.085 //x2=27.46 //y2=0.71
cc_2877 ( N_noxref_8_c_2860_n N_noxref_43_c_15972_n ) capacitor c=2.1838e-19 \
 //x=26.76 //y=2.26 //x2=27.46 //y2=0.71
cc_2878 ( N_noxref_8_c_2839_n N_noxref_43_M15_noxref_s ) capacitor \
 c=0.00888238f //x=26.795 //y=1.085 //x2=25.47 //y2=0.545
cc_2879 ( N_noxref_8_c_2854_n N_noxref_43_M15_noxref_s ) capacitor c=0.015333f \
 //x=27.325 //y=1.085 //x2=25.47 //y2=0.545
cc_2880 ( N_noxref_8_c_2856_n N_noxref_43_M15_noxref_s ) capacitor \
 c=0.00248746f //x=27.325 //y=1.43 //x2=25.47 //y2=0.545
cc_2881 ( N_noxref_8_c_2979_p N_noxref_47_c_16224_n ) capacitor c=0.00262672f \
 //x=42.105 //y=2.095 //x2=41.885 //y2=1.675
cc_2882 ( N_noxref_8_c_2874_p N_noxref_47_c_16225_n ) capacitor c=0.00330249f \
 //x=42.3 //y=4.425 //x2=42.77 //y2=1.76
cc_2883 ( N_noxref_8_c_2906_p N_noxref_47_c_16225_n ) capacitor c=0.00509504f \
 //x=42.3 //y=2.26 //x2=42.77 //y2=1.76
cc_2884 ( N_noxref_8_c_2969_p N_noxref_47_c_16225_n ) capacitor c=0.00763108f \
 //x=42.3 //y=2.26 //x2=42.77 //y2=1.76
cc_2885 ( N_noxref_8_c_2997_p N_noxref_47_c_16225_n ) capacitor c=0.00697076f \
 //x=42.105 //y=1.7 //x2=42.77 //y2=1.76
cc_2886 ( N_noxref_8_c_2979_p N_noxref_47_c_16225_n ) capacitor c=0.0170561f \
 //x=42.105 //y=2.095 //x2=42.77 //y2=1.76
cc_2887 ( N_noxref_8_c_3236_p N_noxref_47_c_16225_n ) capacitor c=0.00723574f \
 //x=42.48 //y=1.545 //x2=42.77 //y2=1.76
cc_2888 ( N_noxref_8_c_2998_p N_noxref_47_c_16225_n ) capacitor c=0.00339872f \
 //x=42.635 //y=1.39 //x2=42.77 //y2=1.76
cc_2889 ( N_noxref_8_c_2979_p N_noxref_47_c_16232_n ) capacitor c=6.71402e-19 \
 //x=42.105 //y=2.095 //x2=42.855 //y2=1.675
cc_2890 ( N_noxref_8_c_2994_p N_noxref_47_M25_noxref_s ) capacitor \
 c=0.0294925f //x=42.105 //y=1.045 //x2=41.75 //y2=0.545
cc_2891 ( N_noxref_8_c_2997_p N_noxref_47_M25_noxref_s ) capacitor \
 c=3.48408e-19 //x=42.105 //y=1.7 //x2=41.75 //y2=0.545
cc_2892 ( N_noxref_8_c_2996_p N_noxref_47_M25_noxref_s ) capacitor \
 c=0.0125442f //x=42.635 //y=1.045 //x2=41.75 //y2=0.545
cc_2893 ( N_noxref_9_c_3302_p N_noxref_10_c_3603_n ) capacitor c=0.00324213f \
 //x=43.34 //y=1.75 //x2=40.01 //y2=1.75
cc_2894 ( N_noxref_9_c_3290_n N_noxref_10_c_3746_n ) capacitor c=0.00114153f \
 //x=42.42 //y=5.56 //x2=40.365 //y2=5.38
cc_2895 ( N_noxref_9_c_3304_p N_noxref_10_c_3747_n ) capacitor c=0.00231467f \
 //x=43.425 //y=1.835 //x2=40.365 //y2=1.835
cc_2896 ( N_noxref_9_c_3287_n N_noxref_10_c_3605_n ) capacitor c=0.00204244f \
 //x=43.78 //y=2.625 //x2=40.45 //y2=3.705
cc_2897 ( N_noxref_9_c_3288_n N_noxref_10_c_3608_n ) capacitor c=0.00281705f \
 //x=43.78 //y=5.295 //x2=40.45 //y2=5.295
cc_2898 ( N_noxref_9_c_3307_p N_noxref_10_c_3750_n ) capacitor c=3.65155e-19 \
 //x=45.63 //y=2.625 //x2=47.85 //y2=3.725
cc_2899 ( N_noxref_9_c_3308_p N_noxref_10_c_3750_n ) capacitor c=5.0215e-19 \
 //x=45.63 //y=4.755 //x2=47.85 //y2=3.725
cc_2900 ( N_noxref_9_c_3308_p N_noxref_10_c_3752_n ) capacitor c=7.44751e-19 \
 //x=45.63 //y=4.755 //x2=47.85 //y2=4.75
cc_2901 ( N_noxref_9_c_3290_n N_noxref_10_c_3753_n ) capacitor c=5.29822e-19 \
 //x=42.42 //y=5.56 //x2=39.97 //y2=5.38
cc_2902 ( N_noxref_9_c_3290_n N_noxref_10_c_3754_n ) capacitor c=0.00147119f \
 //x=42.42 //y=5.56 //x2=39.97 //y2=5.56
cc_2903 ( N_noxref_9_c_3312_p N_noxref_10_c_3619_n ) capacitor c=6.99317e-19 \
 //x=43.34 //y=1.18 //x2=40.01 //y2=1.18
cc_2904 ( N_noxref_9_c_3288_n N_noxref_10_c_3706_n ) capacitor c=0.0233632f \
 //x=43.78 //y=5.295 //x2=47.69 //y2=3.885
cc_2905 ( N_noxref_9_c_3308_p N_noxref_10_c_3706_n ) capacitor c=0.024803f \
 //x=45.63 //y=4.755 //x2=47.69 //y2=3.885
cc_2906 ( N_noxref_9_c_3287_n N_noxref_11_c_4159_n ) capacitor c=0.00862591f \
 //x=43.78 //y=2.625 //x2=43.04 //y2=4.105
cc_2907 ( N_noxref_9_c_3316_p N_noxref_11_c_4159_n ) capacitor c=0.015283f \
 //x=43.78 //y=2.945 //x2=43.04 //y2=4.105
cc_2908 ( N_noxref_9_c_3288_n N_noxref_11_c_4159_n ) capacitor c=0.0458496f \
 //x=43.78 //y=5.295 //x2=43.04 //y2=4.105
cc_2909 ( N_noxref_9_c_3307_p N_noxref_11_c_4159_n ) capacitor c=4.63723e-19 \
 //x=45.63 //y=2.625 //x2=43.04 //y2=4.105
cc_2910 ( N_noxref_9_c_3308_p N_noxref_11_c_4159_n ) capacitor c=7.25062e-19 \
 //x=45.63 //y=4.755 //x2=43.04 //y2=4.105
cc_2911 ( N_noxref_9_c_3320_p N_noxref_11_c_4159_n ) capacitor c=6.69436e-19 \
 //x=43.78 //y=2.77 //x2=43.04 //y2=4.105
cc_2912 ( N_noxref_9_c_3321_p N_noxref_11_c_4159_n ) capacitor c=0.00690943f \
 //x=43.935 //y=2.785 //x2=43.04 //y2=4.105
cc_2913 ( N_noxref_9_c_3286_n N_noxref_11_c_4161_n ) capacitor c=0.00217823f \
 //x=43.185 //y=5.38 //x2=43.04 //y2=4.425
cc_2914 ( N_noxref_9_c_3304_p N_noxref_11_c_4161_n ) capacitor c=3.54885e-19 \
 //x=43.425 //y=1.835 //x2=43.04 //y2=4.425
cc_2915 ( N_noxref_9_c_3288_n N_noxref_11_c_4161_n ) capacitor c=0.017487f \
 //x=43.78 //y=5.295 //x2=43.04 //y2=4.425
cc_2916 ( N_noxref_9_c_3325_p N_noxref_11_c_4161_n ) capacitor c=0.00265093f \
 //x=43.3 //y=5.38 //x2=43.04 //y2=4.425
cc_2917 ( N_noxref_9_c_3326_p N_noxref_11_c_4161_n ) capacitor c=8.00244e-19 \
 //x=43.3 //y=5.56 //x2=43.04 //y2=4.425
cc_2918 ( N_noxref_9_c_3286_n N_noxref_11_c_4164_n ) capacitor c=0.0216883f \
 //x=43.185 //y=5.38 //x2=43.04 //y2=4.735
cc_2919 ( N_noxref_9_c_3288_n N_noxref_11_c_4164_n ) capacitor c=0.0276714f \
 //x=43.78 //y=5.295 //x2=43.04 //y2=4.735
cc_2920 ( N_noxref_9_c_3308_p N_noxref_11_c_4164_n ) capacitor c=4.51221e-19 \
 //x=45.63 //y=4.755 //x2=43.04 //y2=4.735
cc_2921 ( N_noxref_9_M107_noxref_g N_noxref_11_c_4216_n ) capacitor \
 c=0.00893512f //x=46.27 //y=6.2 //x2=46.81 //y2=5.335
cc_2922 ( N_noxref_9_c_3331_p N_noxref_11_c_4217_n ) capacitor c=8.25606e-19 \
 //x=43.695 //y=1.835 //x2=48.105 //y2=1.76
cc_2923 ( N_noxref_9_c_3287_n N_noxref_11_c_4218_n ) capacitor c=8.25606e-19 \
 //x=43.78 //y=2.625 //x2=48.19 //y2=1.845
cc_2924 ( N_noxref_9_c_3287_n N_noxref_11_c_4168_n ) capacitor c=0.0138368f \
 //x=43.78 //y=2.625 //x2=43.04 //y2=2.26
cc_2925 ( N_noxref_9_c_3288_n N_noxref_11_c_4171_n ) capacitor c=7.6985e-19 \
 //x=43.78 //y=5.295 //x2=43.04 //y2=4.25
cc_2926 ( N_noxref_9_c_3288_n N_noxref_11_c_4221_n ) capacitor c=0.00261914f \
 //x=43.78 //y=5.295 //x2=46.052 //y2=5.335
cc_2927 ( N_noxref_9_c_3325_p N_noxref_11_c_4221_n ) capacitor c=5.0812e-19 \
 //x=43.3 //y=5.38 //x2=46.052 //y2=5.335
cc_2928 ( N_noxref_9_M106_noxref_g N_noxref_11_c_4221_n ) capacitor \
 c=0.00461408f //x=45.83 //y=6.2 //x2=46.052 //y2=5.335
cc_2929 ( N_noxref_9_M107_noxref_g N_noxref_11_c_4221_n ) capacitor \
 c=0.00229208f //x=46.27 //y=6.2 //x2=46.052 //y2=5.335
cc_2930 ( N_noxref_9_c_3339_p N_noxref_11_c_4221_n ) capacitor c=0.00171885f \
 //x=46.195 //y=4.97 //x2=46.052 //y2=5.335
cc_2931 ( N_noxref_9_c_3340_p N_noxref_11_c_4226_n ) capacitor c=4.26537e-19 \
 //x=45.63 //y=2.77 //x2=48.59 //y2=2.77
cc_2932 ( N_noxref_9_c_3288_n N_noxref_11_c_4227_n ) capacitor c=0.0222699f \
 //x=43.78 //y=5.295 //x2=47.465 //y2=4.25
cc_2933 ( N_noxref_9_c_3308_p N_noxref_11_c_4227_n ) capacitor c=0.0247975f \
 //x=45.63 //y=4.755 //x2=47.465 //y2=4.25
cc_2934 ( N_noxref_9_c_3288_n N_noxref_11_c_4173_n ) capacitor c=0.00324148f \
 //x=43.78 //y=5.295 //x2=43.19 //y2=4.265
cc_2935 ( N_noxref_9_c_3287_n N_noxref_11_c_4175_n ) capacitor c=9.26054e-19 \
 //x=43.78 //y=2.625 //x2=43.04 //y2=2.26
cc_2936 ( N_noxref_9_c_3286_n N_noxref_11_c_4179_n ) capacitor c=0.00469257f \
 //x=43.185 //y=5.38 //x2=43.07 //y2=4.88
cc_2937 ( N_noxref_9_c_3288_n N_noxref_11_c_4179_n ) capacitor c=7.76118e-19 \
 //x=43.78 //y=5.295 //x2=43.07 //y2=4.88
cc_2938 ( N_noxref_9_M106_noxref_g N_noxref_11_c_4233_n ) capacitor \
 c=0.0162284f //x=45.83 //y=6.2 //x2=46.05 //y2=5.56
cc_2939 ( N_noxref_9_M107_noxref_g N_noxref_11_c_4233_n ) capacitor \
 c=0.0179041f //x=46.27 //y=6.2 //x2=46.05 //y2=5.56
cc_2940 ( N_noxref_9_c_3339_p N_noxref_11_c_4233_n ) capacitor c=0.00291477f \
 //x=46.195 //y=4.97 //x2=46.05 //y2=5.56
cc_2941 ( N_noxref_9_c_3286_n N_noxref_11_M104_noxref_g ) capacitor \
 c=0.00842859f //x=43.185 //y=5.38 //x2=43.08 //y2=6.2
cc_2942 ( N_noxref_9_c_3325_p N_noxref_11_M104_noxref_g ) capacitor \
 c=0.00192712f //x=43.3 //y=5.38 //x2=43.08 //y2=6.2
cc_2943 ( N_noxref_9_c_3326_p N_noxref_11_M104_noxref_g ) capacitor \
 c=0.0178987f //x=43.3 //y=5.56 //x2=43.08 //y2=6.2
cc_2944 ( N_noxref_9_c_3353_p N_noxref_11_M105_noxref_g ) capacitor \
 c=0.0106088f //x=43.695 //y=5.38 //x2=43.52 //y2=6.2
cc_2945 ( N_noxref_9_c_3325_p N_noxref_11_M105_noxref_g ) capacitor \
 c=0.00312463f //x=43.3 //y=5.38 //x2=43.52 //y2=6.2
cc_2946 ( N_noxref_9_c_3326_p N_noxref_11_M105_noxref_g ) capacitor \
 c=0.0178506f //x=43.3 //y=5.56 //x2=43.52 //y2=6.2
cc_2947 ( N_noxref_9_c_3312_p N_noxref_11_c_4185_n ) capacitor c=0.00120406f \
 //x=43.34 //y=1.18 //x2=43.075 //y2=1.085
cc_2948 ( N_noxref_9_M26_noxref_d N_noxref_11_c_4185_n ) capacitor \
 c=0.00137165f //x=43.15 //y=1.085 //x2=43.075 //y2=1.085
cc_2949 ( N_noxref_9_c_3302_p N_noxref_11_c_4188_n ) capacitor c=0.00119008f \
 //x=43.34 //y=1.75 //x2=43.075 //y2=1.43
cc_2950 ( N_noxref_9_c_3312_p N_noxref_11_c_4188_n ) capacitor c=0.00218694f \
 //x=43.34 //y=1.18 //x2=43.075 //y2=1.43
cc_2951 ( N_noxref_9_M26_noxref_d N_noxref_11_c_4188_n ) capacitor \
 c=0.00237422f //x=43.15 //y=1.085 //x2=43.075 //y2=1.43
cc_2952 ( N_noxref_9_c_3302_p N_noxref_11_c_4190_n ) capacitor c=0.00438634f \
 //x=43.34 //y=1.75 //x2=43.075 //y2=1.74
cc_2953 ( N_noxref_9_c_3288_n N_noxref_11_c_4248_n ) capacitor c=0.00845606f \
 //x=43.78 //y=5.295 //x2=43.445 //y2=4.97
cc_2954 ( N_noxref_9_c_3325_p N_noxref_11_c_4248_n ) capacitor c=0.0020269f \
 //x=43.3 //y=5.38 //x2=43.445 //y2=4.97
cc_2955 ( N_noxref_9_c_3326_p N_noxref_11_c_4248_n ) capacitor c=0.00302834f \
 //x=43.3 //y=5.56 //x2=43.445 //y2=4.97
cc_2956 ( N_noxref_9_c_3312_p N_noxref_11_c_4251_n ) capacitor c=5.50523e-19 \
 //x=43.34 //y=1.18 //x2=43.45 //y2=0.93
cc_2957 ( N_noxref_9_M26_noxref_d N_noxref_11_c_4251_n ) capacitor \
 c=0.0020782f //x=43.15 //y=1.085 //x2=43.45 //y2=0.93
cc_2958 ( N_noxref_9_c_3302_p N_noxref_11_c_4253_n ) capacitor c=0.00929259f \
 //x=43.34 //y=1.75 //x2=43.45 //y2=1.585
cc_2959 ( N_noxref_9_c_3331_p N_noxref_11_c_4253_n ) capacitor c=0.00194324f \
 //x=43.695 //y=1.835 //x2=43.45 //y2=1.585
cc_2960 ( N_noxref_9_c_3312_p N_noxref_11_c_4253_n ) capacitor c=5.43945e-19 \
 //x=43.34 //y=1.18 //x2=43.45 //y2=1.585
cc_2961 ( N_noxref_9_M26_noxref_d N_noxref_11_c_4253_n ) capacitor \
 c=0.00356097f //x=43.15 //y=1.085 //x2=43.45 //y2=1.585
cc_2962 ( N_noxref_9_c_3312_p N_noxref_11_c_4193_n ) capacitor c=0.00108157f \
 //x=43.34 //y=1.18 //x2=43.605 //y2=1.085
cc_2963 ( N_noxref_9_M26_noxref_d N_noxref_11_c_4193_n ) capacitor \
 c=8.50095e-19 //x=43.15 //y=1.085 //x2=43.605 //y2=1.085
cc_2964 ( N_noxref_9_c_3302_p N_noxref_11_c_4194_n ) capacitor c=0.00341295f \
 //x=43.34 //y=1.75 //x2=43.605 //y2=1.43
cc_2965 ( N_noxref_9_c_3331_p N_noxref_11_c_4194_n ) capacitor c=0.00323005f \
 //x=43.695 //y=1.835 //x2=43.605 //y2=1.43
cc_2966 ( N_noxref_9_c_3312_p N_noxref_11_c_4194_n ) capacitor c=0.00312028f \
 //x=43.34 //y=1.18 //x2=43.605 //y2=1.43
cc_2967 ( N_noxref_9_M26_noxref_d N_noxref_11_c_4194_n ) capacitor \
 c=0.00237422f //x=43.15 //y=1.085 //x2=43.605 //y2=1.43
cc_2968 ( N_noxref_9_c_3287_n N_noxref_11_c_4195_n ) capacitor c=0.00268898f \
 //x=43.78 //y=2.625 //x2=43.04 //y2=2.26
cc_2969 ( N_noxref_9_c_3302_p N_noxref_11_c_4264_n ) capacitor c=0.00341114f \
 //x=43.34 //y=1.75 //x2=43.04 //y2=2.095
cc_2970 ( N_noxref_9_c_3287_n N_noxref_11_c_4264_n ) capacitor c=0.00309058f \
 //x=43.78 //y=2.625 //x2=43.04 //y2=2.095
cc_2971 ( N_noxref_9_c_3286_n N_noxref_11_c_4198_n ) capacitor c=8.40673e-19 \
 //x=43.185 //y=5.38 //x2=43.07 //y2=4.88
cc_2972 ( N_noxref_9_c_3288_n N_noxref_11_c_4198_n ) capacitor c=0.00142201f \
 //x=43.78 //y=5.295 //x2=43.07 //y2=4.88
cc_2973 ( N_noxref_9_c_3316_p N_D_c_5138_n ) capacitor c=0.00163966f //x=43.78 \
 //y=2.945 //x2=43.39 //y2=3.14
cc_2974 ( N_noxref_9_c_3288_n N_D_c_5138_n ) capacitor c=6.18131e-19 //x=43.78 \
 //y=5.295 //x2=43.39 //y2=3.14
cc_2975 ( N_noxref_9_c_3321_p N_D_c_5138_n ) capacitor c=0.0358254f //x=43.935 \
 //y=2.785 //x2=43.39 //y2=3.14
cc_2976 ( N_noxref_9_c_3316_p N_D_c_5168_n ) capacitor c=0.009371f //x=43.78 \
 //y=2.945 //x2=43.99 //y2=3.17
cc_2977 ( N_noxref_9_c_3288_n N_D_c_5168_n ) capacitor c=0.0225359f //x=43.78 \
 //y=5.295 //x2=43.99 //y2=3.17
cc_2978 ( N_noxref_9_c_3308_p N_D_c_5168_n ) capacitor c=2.03158e-19 //x=45.63 \
 //y=4.755 //x2=43.99 //y2=3.17
cc_2979 ( N_noxref_9_c_3388_p N_D_c_5168_n ) capacitor c=0.127972f //x=45.47 \
 //y=2.785 //x2=43.99 //y2=3.17
cc_2980 ( N_noxref_9_c_3288_n N_D_c_5172_n ) capacitor c=2.0396e-19 //x=43.78 \
 //y=5.295 //x2=45.245 //y2=3.14
cc_2981 ( N_noxref_9_c_3390_p N_D_c_5172_n ) capacitor c=0.00507903f //x=45.63 \
 //y=2.945 //x2=45.245 //y2=3.14
cc_2982 ( N_noxref_9_c_3308_p N_D_c_5172_n ) capacitor c=0.00100571f //x=45.63 \
 //y=4.755 //x2=45.245 //y2=3.14
cc_2983 ( N_noxref_9_c_3392_p N_D_c_5172_n ) capacitor c=0.0358254f //x=45.63 \
 //y=2.785 //x2=45.245 //y2=3.14
cc_2984 ( N_noxref_9_c_3388_p N_D_c_5172_n ) capacitor c=0.0104657f //x=45.47 \
 //y=2.785 //x2=45.245 //y2=3.14
cc_2985 ( N_noxref_9_c_3390_p N_D_c_5177_n ) capacitor c=0.00356749f //x=45.63 \
 //y=2.945 //x2=45.845 //y2=3.17
cc_2986 ( N_noxref_9_c_3308_p N_D_c_5177_n ) capacitor c=0.0236515f //x=45.63 \
 //y=4.755 //x2=45.845 //y2=3.17
cc_2987 ( N_noxref_9_c_3288_n N_CLK_c_6660_n ) capacitor c=0.0010879f \
 //x=43.78 //y=5.295 //x2=43.245 //y2=4.65
cc_2988 ( N_noxref_9_c_3290_n N_CLK_c_6660_n ) capacitor c=0.022991f //x=42.42 \
 //y=5.56 //x2=43.245 //y2=4.65
cc_2989 ( N_noxref_9_c_3325_p N_CLK_c_6660_n ) capacitor c=0.0131052f //x=43.3 \
 //y=5.38 //x2=43.245 //y2=4.65
cc_2990 ( N_noxref_9_c_3353_p N_CLK_c_6683_n ) capacitor c=0.00796393f \
 //x=43.695 //y=5.38 //x2=50.795 //y2=4.62
cc_2991 ( N_noxref_9_c_3288_n N_CLK_c_6683_n ) capacitor c=0.0285633f \
 //x=43.78 //y=5.295 //x2=50.795 //y2=4.62
cc_2992 ( N_noxref_9_c_3308_p N_CLK_c_6683_n ) capacitor c=0.032993f //x=45.63 \
 //y=4.755 //x2=50.795 //y2=4.62
cc_2993 ( N_noxref_9_c_3402_p N_SN_c_8360_n ) capacitor c=0.00802132f \
 //x=45.63 //y=2.375 //x2=46.74 //y2=2.55
cc_2994 ( N_noxref_9_c_3307_p N_SN_c_8360_n ) capacitor c=0.00346868f \
 //x=45.63 //y=2.625 //x2=46.74 //y2=2.55
cc_2995 ( N_noxref_9_c_3404_p N_SN_c_8360_n ) capacitor c=0.00117245f \
 //x=45.63 //y=2.26 //x2=46.74 //y2=2.55
cc_2996 ( N_noxref_9_c_3405_p N_SN_c_8360_n ) capacitor c=0.00157323f \
 //x=45.33 //y=2.095 //x2=46.74 //y2=2.55
cc_2997 ( N_noxref_9_c_3288_n N_SN_c_8364_n ) capacitor c=0.00109688f \
 //x=43.78 //y=5.295 //x2=46.74 //y2=4.765
cc_2998 ( N_noxref_9_c_3307_p N_SN_c_8364_n ) capacitor c=0.00211259f \
 //x=45.63 //y=2.625 //x2=46.74 //y2=4.765
cc_2999 ( N_noxref_9_c_3390_p N_SN_c_8364_n ) capacitor c=0.00782712f \
 //x=45.63 //y=2.945 //x2=46.74 //y2=4.765
cc_3000 ( N_noxref_9_c_3308_p N_SN_c_8364_n ) capacitor c=0.0517254f //x=45.63 \
 //y=4.755 //x2=46.74 //y2=4.765
cc_3001 ( N_noxref_9_c_3340_p N_SN_c_8364_n ) capacitor c=3.49492e-19 \
 //x=45.63 //y=2.77 //x2=46.74 //y2=4.765
cc_3002 ( N_noxref_9_c_3392_p N_SN_c_8364_n ) capacitor c=0.00508569f \
 //x=45.63 //y=2.785 //x2=46.74 //y2=4.765
cc_3003 ( N_noxref_9_c_3412_p N_SN_c_8364_n ) capacitor c=6.26008e-19 \
 //x=45.63 //y=4.88 //x2=46.74 //y2=4.765
cc_3004 ( N_noxref_9_c_3339_p N_SN_c_8364_n ) capacitor c=7.66769e-19 \
 //x=46.195 //y=4.97 //x2=46.74 //y2=4.765
cc_3005 ( N_noxref_9_c_3414_p N_SN_c_8364_n ) capacitor c=7.54501e-19 \
 //x=45.905 //y=4.97 //x2=46.74 //y2=4.765
cc_3006 ( N_noxref_9_c_3304_p N_SN_c_8324_n ) capacitor c=0.0188451f \
 //x=43.425 //y=1.835 //x2=46.57 //y2=2.4
cc_3007 ( N_noxref_9_c_3287_n N_SN_c_8324_n ) capacitor c=0.0276025f //x=43.78 \
 //y=2.625 //x2=46.57 //y2=2.4
cc_3008 ( N_noxref_9_c_3316_p N_SN_c_8324_n ) capacitor c=0.00583576f \
 //x=43.78 //y=2.945 //x2=46.57 //y2=2.4
cc_3009 ( N_noxref_9_c_3402_p N_SN_c_8324_n ) capacitor c=0.0155336f //x=45.63 \
 //y=2.375 //x2=46.57 //y2=2.4
cc_3010 ( N_noxref_9_c_3307_p N_SN_c_8324_n ) capacitor c=0.0136649f //x=45.63 \
 //y=2.625 //x2=46.57 //y2=2.4
cc_3011 ( N_noxref_9_c_3390_p N_SN_c_8324_n ) capacitor c=0.00802015f \
 //x=45.63 //y=2.945 //x2=46.57 //y2=2.4
cc_3012 ( N_noxref_9_c_3312_p N_SN_c_8324_n ) capacitor c=7.47115e-19 \
 //x=43.34 //y=1.18 //x2=46.57 //y2=2.4
cc_3013 ( N_noxref_9_c_3321_p N_SN_c_8324_n ) capacitor c=0.0365231f \
 //x=43.935 //y=2.785 //x2=46.57 //y2=2.4
cc_3014 ( N_noxref_9_c_3392_p N_SN_c_8324_n ) capacitor c=0.0370413f //x=45.63 \
 //y=2.785 //x2=46.57 //y2=2.4
cc_3015 ( N_noxref_9_c_3388_p N_SN_c_8324_n ) capacitor c=0.139543f //x=45.47 \
 //y=2.785 //x2=46.57 //y2=2.4
cc_3016 ( N_noxref_9_c_3404_p N_SN_c_8324_n ) capacitor c=2.54369e-19 \
 //x=45.63 //y=2.26 //x2=46.57 //y2=2.4
cc_3017 ( N_noxref_9_c_3405_p N_SN_c_8324_n ) capacitor c=3.41298e-19 \
 //x=45.33 //y=2.095 //x2=46.57 //y2=2.4
cc_3018 ( N_noxref_9_c_3402_p N_SN_c_8385_n ) capacitor c=0.00196004f \
 //x=45.63 //y=2.375 //x2=51.705 //y2=2.385
cc_3019 ( N_noxref_9_c_3307_p N_SN_c_8385_n ) capacitor c=0.00105803f \
 //x=45.63 //y=2.625 //x2=51.705 //y2=2.385
cc_3020 ( N_noxref_9_c_3402_p N_SN_c_8387_n ) capacitor c=5.39999e-19 \
 //x=45.63 //y=2.375 //x2=46.74 //y2=2.26
cc_3021 ( N_noxref_9_c_3404_p N_SN_c_8387_n ) capacitor c=0.00124905f \
 //x=45.63 //y=2.26 //x2=46.74 //y2=2.26
cc_3022 ( N_noxref_9_c_3405_p N_SN_c_8387_n ) capacitor c=0.00214501f \
 //x=45.33 //y=2.095 //x2=46.74 //y2=2.26
cc_3023 ( N_noxref_9_c_3308_p N_SN_c_8390_n ) capacitor c=0.00103399f \
 //x=45.63 //y=4.755 //x2=46.74 //y2=4.88
cc_3024 ( N_noxref_9_c_3412_p N_SN_c_8390_n ) capacitor c=0.00113984f \
 //x=45.63 //y=4.88 //x2=46.74 //y2=4.88
cc_3025 ( N_noxref_9_c_3339_p N_SN_c_8390_n ) capacitor c=0.00116563f \
 //x=46.195 //y=4.97 //x2=46.74 //y2=4.88
cc_3026 ( N_noxref_9_c_3414_p N_SN_c_8390_n ) capacitor c=0.00129812f \
 //x=45.905 //y=4.97 //x2=46.74 //y2=4.88
cc_3027 ( N_noxref_9_M106_noxref_g N_SN_M108_noxref_g ) capacitor c=0.0106276f \
 //x=45.83 //y=6.2 //x2=46.71 //y2=6.2
cc_3028 ( N_noxref_9_M107_noxref_g N_SN_M108_noxref_g ) capacitor c=0.107144f \
 //x=46.27 //y=6.2 //x2=46.71 //y2=6.2
cc_3029 ( N_noxref_9_M107_noxref_g N_SN_M109_noxref_g ) capacitor c=0.0101598f \
 //x=46.27 //y=6.2 //x2=47.15 //y2=6.2
cc_3030 ( N_noxref_9_c_3439_p N_SN_c_8397_n ) capacitor c=5.72528e-19 \
 //x=45.33 //y=1.055 //x2=46.305 //y2=1.09
cc_3031 ( N_noxref_9_c_3440_p N_SN_c_8397_n ) capacitor c=0.00150277f \
 //x=45.33 //y=1.4 //x2=46.305 //y2=1.09
cc_3032 ( N_noxref_9_c_3441_p N_SN_c_8397_n ) capacitor c=0.0160123f //x=45.86 \
 //y=1.055 //x2=46.305 //y2=1.09
cc_3033 ( N_noxref_9_c_3442_p N_SN_c_8400_n ) capacitor c=0.00111227f \
 //x=45.33 //y=1.71 //x2=46.305 //y2=1.4
cc_3034 ( N_noxref_9_c_3443_p N_SN_c_8400_n ) capacitor c=0.0124075f //x=45.86 \
 //y=1.4 //x2=46.305 //y2=1.4
cc_3035 ( N_noxref_9_c_3441_p N_SN_c_8402_n ) capacitor c=9.19165e-19 \
 //x=45.86 //y=1.055 //x2=46.83 //y2=1.09
cc_3036 ( N_noxref_9_c_3443_p N_SN_c_8403_n ) capacitor c=0.0010154f //x=45.86 \
 //y=1.4 //x2=46.83 //y2=1.4
cc_3037 ( N_noxref_9_c_3443_p N_SN_c_8404_n ) capacitor c=9.23422e-19 \
 //x=45.86 //y=1.4 //x2=46.83 //y2=1.63
cc_3038 ( N_noxref_9_c_3402_p N_SN_c_8405_n ) capacitor c=5.616e-19 //x=45.63 \
 //y=2.375 //x2=46.83 //y2=2.095
cc_3039 ( N_noxref_9_c_3404_p N_SN_c_8405_n ) capacitor c=0.0017273f //x=45.63 \
 //y=2.26 //x2=46.83 //y2=2.095
cc_3040 ( N_noxref_9_c_3405_p N_SN_c_8405_n ) capacitor c=0.00880777f \
 //x=45.33 //y=2.095 //x2=46.83 //y2=2.095
cc_3041 ( N_noxref_9_c_3308_p N_SN_c_8408_n ) capacitor c=0.00116212f \
 //x=45.63 //y=4.755 //x2=46.74 //y2=4.88
cc_3042 ( N_noxref_9_c_3412_p N_SN_c_8408_n ) capacitor c=0.00155973f \
 //x=45.63 //y=4.88 //x2=46.74 //y2=4.88
cc_3043 ( N_noxref_9_c_3339_p N_SN_c_8408_n ) capacitor c=0.0171374f \
 //x=46.195 //y=4.97 //x2=46.74 //y2=4.88
cc_3044 ( N_noxref_9_c_3414_p N_SN_c_8408_n ) capacitor c=0.00484466f \
 //x=45.905 //y=4.97 //x2=46.74 //y2=4.88
cc_3045 ( N_noxref_9_c_3288_n N_noxref_21_c_10606_n ) capacitor c=0.023072f \
 //x=43.78 //y=5.295 //x2=47.465 //y2=3.51
cc_3046 ( N_noxref_9_c_3308_p N_noxref_21_c_10606_n ) capacitor c=0.0245208f \
 //x=45.63 //y=4.755 //x2=47.465 //y2=3.51
cc_3047 ( N_noxref_9_c_3388_p N_noxref_21_c_10606_n ) capacitor c=0.00857041f \
 //x=45.47 //y=2.785 //x2=47.465 //y2=3.51
cc_3048 ( N_noxref_9_c_3286_n N_VDD_c_11522_n ) capacitor c=0.00648291f \
 //x=43.185 //y=5.38 //x2=74.455 //y2=7.585
cc_3049 ( N_noxref_9_c_3353_p N_VDD_c_11522_n ) capacitor c=0.00488503f \
 //x=43.695 //y=5.38 //x2=74.455 //y2=7.585
cc_3050 ( N_noxref_9_c_3290_n N_VDD_c_11522_n ) capacitor c=0.00368834f \
 //x=42.42 //y=5.56 //x2=74.455 //y2=7.585
cc_3051 ( N_noxref_9_c_3325_p N_VDD_c_11522_n ) capacitor c=8.42537e-19 \
 //x=43.3 //y=5.38 //x2=74.455 //y2=7.585
cc_3052 ( N_noxref_9_c_3461_p N_VDD_c_11522_n ) capacitor c=0.00285853f \
 //x=43.3 //y=5.56 //x2=74.455 //y2=7.585
cc_3053 ( N_noxref_9_c_3296_n N_VDD_c_11522_n ) capacitor c=0.00224881f \
 //x=42.42 //y=5.56 //x2=74.455 //y2=7.585
cc_3054 ( N_noxref_9_c_3326_p N_VDD_c_11522_n ) capacitor c=0.00224881f \
 //x=43.3 //y=5.56 //x2=74.455 //y2=7.585
cc_3055 ( N_noxref_9_c_3286_n N_VDD_c_11961_n ) capacitor c=0.00208087f \
 //x=43.185 //y=5.38 //x2=42.775 //y2=7.585
cc_3056 ( N_noxref_9_c_3290_n N_VDD_c_11961_n ) capacitor c=9.41185e-19 \
 //x=42.42 //y=5.56 //x2=42.775 //y2=7.585
cc_3057 ( N_noxref_9_c_3296_n N_VDD_c_11961_n ) capacitor c=0.0136705f \
 //x=42.42 //y=5.56 //x2=42.775 //y2=7.585
cc_3058 ( N_noxref_9_c_3286_n N_VDD_c_12017_n ) capacitor c=0.00180737f \
 //x=43.185 //y=5.38 //x2=43.655 //y2=7.585
cc_3059 ( N_noxref_9_c_3353_p N_VDD_c_12017_n ) capacitor c=0.00208087f \
 //x=43.695 //y=5.38 //x2=43.655 //y2=7.585
cc_3060 ( N_noxref_9_c_3325_p N_VDD_c_12017_n ) capacitor c=4.23719e-19 \
 //x=43.3 //y=5.38 //x2=43.655 //y2=7.585
cc_3061 ( N_noxref_9_c_3461_p N_VDD_c_12017_n ) capacitor c=5.77976e-19 \
 //x=43.3 //y=5.56 //x2=43.655 //y2=7.585
cc_3062 ( N_noxref_9_c_3326_p N_VDD_c_12017_n ) capacitor c=0.0136705f \
 //x=43.3 //y=5.56 //x2=43.655 //y2=7.585
cc_3063 ( N_noxref_9_M106_noxref_g N_VDD_c_12022_n ) capacitor c=0.00755614f \
 //x=45.83 //y=6.2 //x2=46.405 //y2=7.585
cc_3064 ( N_noxref_9_M107_noxref_g N_VDD_c_12022_n ) capacitor c=0.00755544f \
 //x=46.27 //y=6.2 //x2=46.405 //y2=7.585
cc_3065 ( N_noxref_9_c_3288_n N_VDD_c_11979_n ) capacitor c=0.0013228f \
 //x=43.78 //y=5.295 //x2=41.19 //y2=7.585
cc_3066 ( N_noxref_9_c_3290_n N_VDD_c_11979_n ) capacitor c=4.91377e-19 \
 //x=42.42 //y=5.56 //x2=41.19 //y2=7.585
cc_3067 ( N_noxref_9_c_3296_n N_VDD_c_11979_n ) capacitor c=0.0064135f \
 //x=42.42 //y=5.56 //x2=41.19 //y2=7.585
cc_3068 ( N_noxref_9_c_3288_n N_VDD_c_12027_n ) capacitor c=0.0294123f \
 //x=43.78 //y=5.295 //x2=44.52 //y2=7.585
cc_3069 ( N_noxref_9_c_3308_p N_VDD_c_12027_n ) capacitor c=0.0116689f \
 //x=45.63 //y=4.755 //x2=44.52 //y2=7.585
cc_3070 ( N_noxref_9_c_3325_p N_VDD_c_12027_n ) capacitor c=0.0025639f \
 //x=43.3 //y=5.38 //x2=44.52 //y2=7.585
cc_3071 ( N_noxref_9_c_3461_p N_VDD_c_12027_n ) capacitor c=4.19141e-19 \
 //x=43.3 //y=5.56 //x2=44.52 //y2=7.585
cc_3072 ( N_noxref_9_c_3326_p N_VDD_c_12027_n ) capacitor c=0.0101861f \
 //x=43.3 //y=5.56 //x2=44.52 //y2=7.585
cc_3073 ( N_noxref_9_c_3412_p N_VDD_c_12027_n ) capacitor c=0.00370784f \
 //x=45.63 //y=4.88 //x2=44.52 //y2=7.585
cc_3074 ( N_noxref_9_c_3414_p N_VDD_c_12027_n ) capacitor c=0.00590568f \
 //x=45.905 //y=4.97 //x2=44.52 //y2=7.585
cc_3075 ( N_noxref_9_c_3290_n N_VDD_M102_noxref_s ) capacitor c=0.0572211f \
 //x=42.42 //y=5.56 //x2=41.845 //y2=5.2
cc_3076 ( N_noxref_9_c_3325_p N_VDD_M102_noxref_s ) capacitor c=6.52457e-19 \
 //x=43.3 //y=5.38 //x2=41.845 //y2=5.2
cc_3077 ( N_noxref_9_c_3296_n N_VDD_M102_noxref_s ) capacitor c=0.0887533f \
 //x=42.42 //y=5.56 //x2=41.845 //y2=5.2
cc_3078 ( N_noxref_9_c_3286_n N_VDD_M103_noxref_d ) capacitor c=0.00734094f \
 //x=43.185 //y=5.38 //x2=42.715 //y2=5.2
cc_3079 ( N_noxref_9_c_3290_n N_VDD_M103_noxref_d ) capacitor c=0.0043528f \
 //x=42.42 //y=5.56 //x2=42.715 //y2=5.2
cc_3080 ( N_noxref_9_c_3461_p N_VDD_M103_noxref_d ) capacitor c=0.0043528f \
 //x=43.3 //y=5.56 //x2=42.715 //y2=5.2
cc_3081 ( N_noxref_9_c_3296_n N_VDD_M103_noxref_d ) capacitor c=0.065554f \
 //x=42.42 //y=5.56 //x2=42.715 //y2=5.2
cc_3082 ( N_noxref_9_c_3326_p N_VDD_M103_noxref_d ) capacitor c=0.065554f \
 //x=43.3 //y=5.56 //x2=42.715 //y2=5.2
cc_3083 ( N_noxref_9_c_3353_p N_VDD_M105_noxref_d ) capacitor c=0.00983727f \
 //x=43.695 //y=5.38 //x2=43.595 //y2=5.2
cc_3084 ( N_noxref_9_c_3461_p N_VDD_M105_noxref_d ) capacitor c=0.00955781f \
 //x=43.3 //y=5.56 //x2=43.595 //y2=5.2
cc_3085 ( N_noxref_9_c_3320_p N_VDD_M105_noxref_d ) capacitor c=6.87256e-19 \
 //x=43.78 //y=2.77 //x2=43.595 //y2=5.2
cc_3086 ( N_noxref_9_c_3326_p N_VDD_M105_noxref_d ) capacitor c=0.065554f \
 //x=43.3 //y=5.56 //x2=43.595 //y2=5.2
cc_3087 ( N_noxref_9_c_3353_p N_VDD_M106_noxref_s ) capacitor c=0.00220019f \
 //x=43.695 //y=5.38 //x2=45.475 //y2=5.2
cc_3088 ( N_noxref_9_c_3390_p N_VDD_M106_noxref_s ) capacitor c=4.35094e-19 \
 //x=45.63 //y=2.945 //x2=45.475 //y2=5.2
cc_3089 ( N_noxref_9_c_3308_p N_VDD_M106_noxref_s ) capacitor c=0.0217981f \
 //x=45.63 //y=4.755 //x2=45.475 //y2=5.2
cc_3090 ( N_noxref_9_c_3325_p N_VDD_M106_noxref_s ) capacitor c=0.00371125f \
 //x=43.3 //y=5.38 //x2=45.475 //y2=5.2
cc_3091 ( N_noxref_9_c_3461_p N_VDD_M106_noxref_s ) capacitor c=9.52042e-19 \
 //x=43.3 //y=5.56 //x2=45.475 //y2=5.2
cc_3092 ( N_noxref_9_c_3412_p N_VDD_M106_noxref_s ) capacitor c=0.00983846f \
 //x=45.63 //y=4.88 //x2=45.475 //y2=5.2
cc_3093 ( N_noxref_9_M106_noxref_g N_VDD_M106_noxref_s ) capacitor c=0.053419f \
 //x=45.83 //y=6.2 //x2=45.475 //y2=5.2
cc_3094 ( N_noxref_9_c_3414_p N_VDD_M106_noxref_s ) capacitor c=0.0060887f \
 //x=45.905 //y=4.97 //x2=45.475 //y2=5.2
cc_3095 ( N_noxref_9_M107_noxref_g N_VDD_M107_noxref_d ) capacitor c=0.015318f \
 //x=46.27 //y=6.2 //x2=46.345 //y2=5.2
cc_3096 ( N_noxref_9_c_3312_p N_noxref_29_M28_noxref_d ) capacitor \
 c=3.39394e-19 //x=43.34 //y=1.18 //x2=46.38 //y2=1.09
cc_3097 ( N_noxref_9_c_3331_p N_GND_c_14235_n ) capacitor c=0.00608539f \
 //x=43.695 //y=1.835 //x2=45.51 //y2=0.175
cc_3098 ( N_noxref_9_c_3316_p N_GND_c_14235_n ) capacitor c=4.02586e-19 \
 //x=43.78 //y=2.945 //x2=45.51 //y2=0.175
cc_3099 ( N_noxref_9_c_3312_p N_GND_c_14235_n ) capacitor c=0.00928865f \
 //x=43.34 //y=1.18 //x2=45.51 //y2=0.175
cc_3100 ( N_noxref_9_M26_noxref_d N_GND_c_14235_n ) capacitor c=3.01769e-19 \
 //x=43.15 //y=1.085 //x2=45.51 //y2=0.175
cc_3101 ( N_noxref_9_c_3439_p N_GND_c_14239_n ) capacitor c=3.92414e-19 \
 //x=45.33 //y=1.055 //x2=45.595 //y2=1.015
cc_3102 ( N_noxref_9_c_3511_p N_GND_c_14239_n ) capacitor c=0.0085115f \
 //x=45.705 //y=0.9 //x2=45.595 //y2=1.015
cc_3103 ( N_noxref_9_c_3441_p N_GND_c_14239_n ) capacitor c=4.45447e-19 \
 //x=45.86 //y=1.055 //x2=45.595 //y2=1.015
cc_3104 ( N_noxref_9_c_3290_n N_GND_c_14203_n ) capacitor c=6.93965e-19 \
 //x=42.42 //y=5.56 //x2=42.37 //y2=1.135
cc_3105 ( N_noxref_9_c_3312_p N_GND_c_14203_n ) capacitor c=0.0140087f \
 //x=43.34 //y=1.18 //x2=42.37 //y2=1.135
cc_3106 ( N_noxref_9_M26_noxref_d N_GND_c_14203_n ) capacitor c=2.93544e-19 \
 //x=43.15 //y=1.085 //x2=42.37 //y2=1.135
cc_3107 ( N_noxref_9_c_3402_p N_GND_c_14245_n ) capacitor c=0.00772482f \
 //x=45.63 //y=2.375 //x2=45.595 //y2=1.145
cc_3108 ( N_noxref_9_c_3390_p N_GND_c_14245_n ) capacitor c=0.00117625f \
 //x=45.63 //y=2.945 //x2=45.595 //y2=1.145
cc_3109 ( N_noxref_9_c_3312_p N_GND_c_14245_n ) capacitor c=0.00606355f \
 //x=43.34 //y=1.18 //x2=45.595 //y2=1.145
cc_3110 ( N_noxref_9_c_3404_p N_GND_c_14245_n ) capacitor c=2.22883e-19 \
 //x=45.63 //y=2.26 //x2=45.595 //y2=1.145
cc_3111 ( N_noxref_9_c_3439_p N_GND_c_14245_n ) capacitor c=0.0015128f \
 //x=45.33 //y=1.055 //x2=45.595 //y2=1.145
cc_3112 ( N_noxref_9_c_3440_p N_GND_c_14245_n ) capacitor c=0.00350108f \
 //x=45.33 //y=1.4 //x2=45.595 //y2=1.145
cc_3113 ( N_noxref_9_c_3442_p N_GND_c_14245_n ) capacitor c=3.86356e-19 \
 //x=45.33 //y=1.71 //x2=45.595 //y2=1.145
cc_3114 ( N_noxref_9_c_3511_p N_GND_c_14245_n ) capacitor c=9.36995e-19 \
 //x=45.705 //y=0.9 //x2=45.595 //y2=1.145
cc_3115 ( N_noxref_9_c_3524_p N_GND_c_14245_n ) capacitor c=5.29132e-19 \
 //x=45.705 //y=1.555 //x2=45.595 //y2=1.145
cc_3116 ( N_noxref_9_c_3441_p N_GND_c_14245_n ) capacitor c=0.0017438f \
 //x=45.86 //y=1.055 //x2=45.595 //y2=1.145
cc_3117 ( N_noxref_9_c_3443_p N_GND_c_14245_n ) capacitor c=0.00276804f \
 //x=45.86 //y=1.4 //x2=45.595 //y2=1.145
cc_3118 ( N_noxref_9_c_3331_p N_GND_c_14217_n ) capacitor c=7.75992e-19 \
 //x=43.695 //y=1.835 //x2=44.35 //y2=0.175
cc_3119 ( N_noxref_9_c_3316_p N_GND_c_14217_n ) capacitor c=4.76835e-19 \
 //x=43.78 //y=2.945 //x2=44.35 //y2=0.175
cc_3120 ( N_noxref_9_c_3439_p N_GND_c_14258_n ) capacitor c=0.00677849f \
 //x=45.33 //y=1.055 //x2=49.16 //y2=0.175
cc_3121 ( N_noxref_9_c_3287_n N_GND_c_14189_n ) capacitor c=9.32616e-19 \
 //x=43.78 //y=2.625 //x2=41.19 //y2=0.175
cc_3122 ( N_noxref_9_c_3320_p N_GND_c_14189_n ) capacitor c=0.00133285f \
 //x=43.78 //y=2.77 //x2=41.19 //y2=0.175
cc_3123 ( N_noxref_9_c_3302_p N_GND_c_14261_n ) capacitor c=0.00460657f \
 //x=43.34 //y=1.75 //x2=44.52 //y2=0.175
cc_3124 ( N_noxref_9_c_3331_p N_GND_c_14261_n ) capacitor c=0.0221528f \
 //x=43.695 //y=1.835 //x2=44.52 //y2=0.175
cc_3125 ( N_noxref_9_c_3287_n N_GND_c_14261_n ) capacitor c=2.00878e-19 \
 //x=43.78 //y=2.625 //x2=44.52 //y2=0.175
cc_3126 ( N_noxref_9_c_3316_p N_GND_c_14261_n ) capacitor c=0.00400293f \
 //x=43.78 //y=2.945 //x2=44.52 //y2=0.175
cc_3127 ( N_noxref_9_c_3402_p N_GND_c_14261_n ) capacitor c=0.00361632f \
 //x=45.63 //y=2.375 //x2=44.52 //y2=0.175
cc_3128 ( N_noxref_9_c_3307_p N_GND_c_14261_n ) capacitor c=0.00378881f \
 //x=45.63 //y=2.625 //x2=44.52 //y2=0.175
cc_3129 ( N_noxref_9_c_3390_p N_GND_c_14261_n ) capacitor c=0.00292762f \
 //x=45.63 //y=2.945 //x2=44.52 //y2=0.175
cc_3130 ( N_noxref_9_c_3320_p N_GND_c_14261_n ) capacitor c=0.0101522f \
 //x=43.78 //y=2.77 //x2=44.52 //y2=0.175
cc_3131 ( N_noxref_9_c_3340_p N_GND_c_14261_n ) capacitor c=0.00527234f \
 //x=45.63 //y=2.77 //x2=44.52 //y2=0.175
cc_3132 ( N_noxref_9_c_3388_p N_GND_c_14261_n ) capacitor c=0.00947774f \
 //x=45.47 //y=2.785 //x2=44.52 //y2=0.175
cc_3133 ( N_noxref_9_c_3404_p N_GND_c_14261_n ) capacitor c=0.00396211f \
 //x=45.63 //y=2.26 //x2=44.52 //y2=0.175
cc_3134 ( N_noxref_9_c_3442_p N_GND_c_14261_n ) capacitor c=0.00170145f \
 //x=45.33 //y=1.71 //x2=44.52 //y2=0.175
cc_3135 ( N_noxref_9_c_3405_p N_GND_c_14261_n ) capacitor c=0.0102191f \
 //x=45.33 //y=2.095 //x2=44.52 //y2=0.175
cc_3136 ( N_noxref_9_c_3312_p N_GND_M25_noxref_d ) capacitor c=2.82748e-19 \
 //x=43.34 //y=1.18 //x2=42.18 //y2=1.045
cc_3137 ( N_noxref_9_c_3402_p N_GND_M27_noxref_d ) capacitor c=4.4417e-19 \
 //x=45.63 //y=2.375 //x2=45.405 //y2=1.055
cc_3138 ( N_noxref_9_c_3439_p N_GND_M27_noxref_d ) capacitor c=0.00184354f \
 //x=45.33 //y=1.055 //x2=45.405 //y2=1.055
cc_3139 ( N_noxref_9_c_3440_p N_GND_M27_noxref_d ) capacitor c=0.00210798f \
 //x=45.33 //y=1.4 //x2=45.405 //y2=1.055
cc_3140 ( N_noxref_9_c_3511_p N_GND_M27_noxref_d ) capacitor c=0.00474029f \
 //x=45.705 //y=0.9 //x2=45.405 //y2=1.055
cc_3141 ( N_noxref_9_c_3524_p N_GND_M27_noxref_d ) capacitor c=0.00166857f \
 //x=45.705 //y=1.555 //x2=45.405 //y2=1.055
cc_3142 ( N_noxref_9_c_3441_p N_GND_M27_noxref_d ) capacitor c=0.00230174f \
 //x=45.86 //y=1.055 //x2=45.405 //y2=1.055
cc_3143 ( N_noxref_9_c_3443_p N_GND_M27_noxref_d ) capacitor c=0.00210798f \
 //x=45.86 //y=1.4 //x2=45.405 //y2=1.055
cc_3144 ( N_noxref_9_c_3304_p N_noxref_47_c_16232_n ) capacitor c=0.00911498f \
 //x=43.425 //y=1.835 //x2=42.855 //y2=1.675
cc_3145 ( N_noxref_9_c_3331_p N_noxref_47_c_16237_n ) capacitor c=0.00399245f \
 //x=43.695 //y=1.835 //x2=43.74 //y2=0.71
cc_3146 ( N_noxref_9_c_3312_p N_noxref_47_c_16237_n ) capacitor c=0.003751f \
 //x=43.34 //y=1.18 //x2=43.74 //y2=0.71
cc_3147 ( N_noxref_9_M26_noxref_d N_noxref_47_c_16237_n ) capacitor \
 c=0.00910163f //x=43.15 //y=1.085 //x2=43.74 //y2=0.71
cc_3148 ( N_noxref_9_c_3302_p N_noxref_47_M25_noxref_s ) capacitor \
 c=0.0175047f //x=43.34 //y=1.75 //x2=41.75 //y2=0.545
cc_3149 ( N_noxref_9_c_3331_p N_noxref_47_M25_noxref_s ) capacitor \
 c=0.0055349f //x=43.695 //y=1.835 //x2=41.75 //y2=0.545
cc_3150 ( N_noxref_9_c_3316_p N_noxref_47_M25_noxref_s ) capacitor \
 c=7.7509e-19 //x=43.78 //y=2.945 //x2=41.75 //y2=0.545
cc_3151 ( N_noxref_9_c_3312_p N_noxref_47_M25_noxref_s ) capacitor \
 c=0.00894261f //x=43.34 //y=1.18 //x2=41.75 //y2=0.545
cc_3152 ( N_noxref_9_c_3320_p N_noxref_47_M25_noxref_s ) capacitor \
 c=0.00202552f //x=43.78 //y=2.77 //x2=41.75 //y2=0.545
cc_3153 ( N_noxref_9_M26_noxref_d N_noxref_47_M25_noxref_s ) capacitor \
 c=0.0275552f //x=43.15 //y=1.085 //x2=41.75 //y2=0.545
cc_3154 ( N_noxref_9_c_3405_p N_noxref_48_c_16292_n ) capacitor c=0.00262672f \
 //x=45.33 //y=2.095 //x2=45.11 //y2=1.685
cc_3155 ( N_noxref_9_c_3402_p N_noxref_48_c_16293_n ) capacitor c=0.00428451f \
 //x=45.63 //y=2.375 //x2=45.995 //y2=1.77
cc_3156 ( N_noxref_9_c_3390_p N_noxref_48_c_16293_n ) capacitor c=0.00447635f \
 //x=45.63 //y=2.945 //x2=45.995 //y2=1.77
cc_3157 ( N_noxref_9_c_3404_p N_noxref_48_c_16293_n ) capacitor c=0.0104666f \
 //x=45.63 //y=2.26 //x2=45.995 //y2=1.77
cc_3158 ( N_noxref_9_c_3442_p N_noxref_48_c_16293_n ) capacitor c=0.00705077f \
 //x=45.33 //y=1.71 //x2=45.995 //y2=1.77
cc_3159 ( N_noxref_9_c_3405_p N_noxref_48_c_16293_n ) capacitor c=0.0197834f \
 //x=45.33 //y=2.095 //x2=45.995 //y2=1.77
cc_3160 ( N_noxref_9_c_3524_p N_noxref_48_c_16293_n ) capacitor c=0.00588627f \
 //x=45.705 //y=1.555 //x2=45.995 //y2=1.77
cc_3161 ( N_noxref_9_c_3443_p N_noxref_48_c_16293_n ) capacitor c=0.00698822f \
 //x=45.86 //y=1.4 //x2=45.995 //y2=1.77
cc_3162 ( N_noxref_9_c_3439_p N_noxref_48_M27_noxref_s ) capacitor \
 c=0.0295256f //x=45.33 //y=1.055 //x2=44.975 //y2=0.555
cc_3163 ( N_noxref_9_c_3442_p N_noxref_48_M27_noxref_s ) capacitor \
 c=7.99997e-19 //x=45.33 //y=1.71 //x2=44.975 //y2=0.555
cc_3164 ( N_noxref_9_c_3405_p N_noxref_48_M27_noxref_s ) capacitor \
 c=0.00122123f //x=45.33 //y=2.095 //x2=44.975 //y2=0.555
cc_3165 ( N_noxref_9_c_3441_p N_noxref_48_M27_noxref_s ) capacitor \
 c=0.0125924f //x=45.86 //y=1.055 //x2=44.975 //y2=0.555
cc_3166 ( N_noxref_10_c_3605_n N_noxref_11_c_4159_n ) capacitor c=0.002013f \
 //x=40.45 //y=3.705 //x2=43.04 //y2=4.105
cc_3167 ( N_noxref_10_c_3706_n N_noxref_11_c_4159_n ) capacitor c=0.0200531f \
 //x=47.69 //y=3.885 //x2=43.04 //y2=4.105
cc_3168 ( N_noxref_10_c_3706_n N_noxref_11_c_4161_n ) capacitor c=0.00665561f \
 //x=47.69 //y=3.885 //x2=43.04 //y2=4.425
cc_3169 ( N_noxref_10_c_3608_n N_noxref_11_c_4164_n ) capacitor c=7.55107e-19 \
 //x=40.45 //y=5.295 //x2=43.04 //y2=4.735
cc_3170 ( N_noxref_10_c_3762_p N_noxref_11_c_4272_n ) capacitor c=0.00168386f \
 //x=47.85 //y=4.045 //x2=47.695 //y2=5.335
cc_3171 ( N_noxref_10_M110_noxref_g N_noxref_11_c_4272_n ) capacitor \
 c=0.00952006f //x=47.59 //y=6.2 //x2=47.695 //y2=5.335
cc_3172 ( N_noxref_10_M110_noxref_g N_noxref_11_c_4274_n ) capacitor \
 c=0.00226521f //x=47.59 //y=6.2 //x2=47.81 //y2=5.56
cc_3173 ( N_noxref_10_M111_noxref_g N_noxref_11_c_4274_n ) capacitor \
 c=0.00368945f //x=48.03 //y=6.2 //x2=47.81 //y2=5.56
cc_3174 ( N_noxref_10_c_3762_p N_noxref_11_c_4276_n ) capacitor c=4.21338e-19 \
 //x=47.85 //y=4.045 //x2=48.505 //y2=5.335
cc_3175 ( N_noxref_10_c_3752_n N_noxref_11_c_4276_n ) capacitor c=0.00228791f \
 //x=47.85 //y=4.75 //x2=48.505 //y2=5.335
cc_3176 ( N_noxref_10_c_3768_p N_noxref_11_c_4276_n ) capacitor c=0.00130631f \
 //x=47.85 //y=4.88 //x2=48.505 //y2=5.335
cc_3177 ( N_noxref_10_M111_noxref_g N_noxref_11_c_4276_n ) capacitor \
 c=0.0108585f //x=48.03 //y=6.2 //x2=48.505 //y2=5.335
cc_3178 ( N_noxref_10_c_3770_p N_noxref_11_c_4280_n ) capacitor c=4.64015e-19 \
 //x=47.84 //y=1.095 //x2=48.105 //y2=1.305
cc_3179 ( N_noxref_10_c_3771_p N_noxref_11_c_4280_n ) capacitor c=0.0026012f \
 //x=47.84 //y=1.44 //x2=48.105 //y2=1.305
cc_3180 ( N_noxref_10_c_3772_p N_noxref_11_c_4280_n ) capacitor c=5.29969e-19 \
 //x=48.215 //y=0.94 //x2=48.105 //y2=1.305
cc_3181 ( N_noxref_10_c_3773_p N_noxref_11_c_4280_n ) capacitor c=5.31989e-19 \
 //x=48.215 //y=1.595 //x2=48.105 //y2=1.305
cc_3182 ( N_noxref_10_c_3774_p N_noxref_11_c_4280_n ) capacitor c=5.28622e-19 \
 //x=48.37 //y=1.095 //x2=48.105 //y2=1.305
cc_3183 ( N_noxref_10_c_3775_p N_noxref_11_c_4280_n ) capacitor c=0.00312156f \
 //x=48.37 //y=1.44 //x2=48.105 //y2=1.305
cc_3184 ( N_noxref_10_c_3771_p N_noxref_11_c_4217_n ) capacitor c=0.00127432f \
 //x=47.84 //y=1.44 //x2=48.105 //y2=1.76
cc_3185 ( N_noxref_10_c_3777_p N_noxref_11_c_4217_n ) capacitor c=0.00429966f \
 //x=47.84 //y=1.75 //x2=48.105 //y2=1.76
cc_3186 ( N_noxref_10_c_3773_p N_noxref_11_c_4217_n ) capacitor c=0.00930387f \
 //x=48.215 //y=1.595 //x2=48.105 //y2=1.76
cc_3187 ( N_noxref_10_c_3775_p N_noxref_11_c_4217_n ) capacitor c=0.00347599f \
 //x=48.37 //y=1.44 //x2=48.105 //y2=1.76
cc_3188 ( N_noxref_10_c_3780_p N_noxref_11_c_4217_n ) capacitor c=0.00362297f \
 //x=47.85 //y=2.095 //x2=48.105 //y2=1.76
cc_3189 ( N_noxref_10_c_3773_p N_noxref_11_c_4291_n ) capacitor c=0.00194716f \
 //x=48.215 //y=1.595 //x2=48.505 //y2=1.845
cc_3190 ( N_noxref_10_c_3775_p N_noxref_11_c_4291_n ) capacitor c=0.00323576f \
 //x=48.37 //y=1.44 //x2=48.505 //y2=1.845
cc_3191 ( N_noxref_10_c_3783_p N_noxref_11_c_4293_n ) capacitor c=0.0139437f \
 //x=47.85 //y=2.375 //x2=48.59 //y2=2.625
cc_3192 ( N_noxref_10_c_3750_n N_noxref_11_c_4293_n ) capacitor c=0.00898403f \
 //x=47.85 //y=3.725 //x2=48.59 //y2=2.625
cc_3193 ( N_noxref_10_c_3785_p N_noxref_11_c_4293_n ) capacitor c=0.0015536f \
 //x=47.85 //y=2.26 //x2=48.59 //y2=2.625
cc_3194 ( N_noxref_10_c_3786_p N_noxref_11_c_4293_n ) capacitor c=0.0024584f \
 //x=47.85 //y=2.26 //x2=48.59 //y2=2.625
cc_3195 ( N_noxref_10_c_3780_p N_noxref_11_c_4293_n ) capacitor c=0.00282067f \
 //x=47.85 //y=2.095 //x2=48.59 //y2=2.625
cc_3196 ( N_noxref_10_c_3750_n N_noxref_11_c_4298_n ) capacitor c=0.015283f \
 //x=47.85 //y=3.725 //x2=48.59 //y2=2.945
cc_3197 ( N_noxref_10_c_3750_n N_noxref_11_c_4299_n ) capacitor c=0.030386f \
 //x=47.85 //y=3.725 //x2=48.59 //y2=4.075
cc_3198 ( N_noxref_10_c_3762_p N_noxref_11_c_4299_n ) capacitor c=0.0148501f \
 //x=47.85 //y=4.045 //x2=48.59 //y2=4.075
cc_3199 ( N_noxref_10_c_3752_n N_noxref_11_c_4299_n ) capacitor c=0.00138662f \
 //x=47.85 //y=4.75 //x2=48.59 //y2=4.075
cc_3200 ( N_noxref_10_c_3792_p N_noxref_11_c_4299_n ) capacitor c=6.89957e-19 \
 //x=47.85 //y=3.88 //x2=48.59 //y2=4.075
cc_3201 ( N_noxref_10_c_3793_p N_noxref_11_c_4299_n ) capacitor c=0.00686827f \
 //x=47.85 //y=3.885 //x2=48.59 //y2=4.075
cc_3202 ( N_noxref_10_c_3752_n N_noxref_11_c_4304_n ) capacitor c=0.0176431f \
 //x=47.85 //y=4.75 //x2=48.59 //y2=4.395
cc_3203 ( N_noxref_10_c_3752_n N_noxref_11_c_4305_n ) capacitor c=0.0284109f \
 //x=47.85 //y=4.75 //x2=48.59 //y2=5.25
cc_3204 ( N_noxref_10_c_3768_p N_noxref_11_c_4305_n ) capacitor c=0.00131258f \
 //x=47.85 //y=4.88 //x2=48.59 //y2=5.25
cc_3205 ( N_noxref_10_c_3797_p N_noxref_11_c_4305_n ) capacitor c=0.00739875f \
 //x=47.85 //y=4.88 //x2=48.59 //y2=5.25
cc_3206 ( N_noxref_10_c_3752_n N_noxref_11_c_4308_n ) capacitor c=0.0221235f \
 //x=47.85 //y=4.75 //x2=47.81 //y2=5.335
cc_3207 ( N_noxref_10_c_3768_p N_noxref_11_c_4308_n ) capacitor c=0.00346456f \
 //x=47.85 //y=4.88 //x2=47.81 //y2=5.335
cc_3208 ( N_noxref_10_c_3797_p N_noxref_11_c_4308_n ) capacitor c=0.00203307f \
 //x=47.85 //y=4.88 //x2=47.81 //y2=5.335
cc_3209 ( N_noxref_10_c_3752_n N_noxref_11_c_4311_n ) capacitor c=7.6985e-19 \
 //x=47.85 //y=4.75 //x2=48.59 //y2=4.25
cc_3210 ( N_noxref_10_c_3750_n N_noxref_11_c_4226_n ) capacitor c=6.77171e-19 \
 //x=47.85 //y=3.725 //x2=48.59 //y2=2.77
cc_3211 ( N_noxref_10_c_3762_p N_noxref_11_c_4227_n ) capacitor c=0.00274241f \
 //x=47.85 //y=4.045 //x2=47.465 //y2=4.25
cc_3212 ( N_noxref_10_c_3752_n N_noxref_11_c_4227_n ) capacitor c=5.04006e-19 \
 //x=47.85 //y=4.75 //x2=47.465 //y2=4.25
cc_3213 ( N_noxref_10_c_3793_p N_noxref_11_c_4227_n ) capacitor c=0.0358254f \
 //x=47.85 //y=3.885 //x2=47.465 //y2=4.25
cc_3214 ( N_noxref_10_c_3706_n N_noxref_11_c_4227_n ) capacitor c=0.38725f \
 //x=47.69 //y=3.885 //x2=47.465 //y2=4.25
cc_3215 ( N_noxref_10_c_3762_p N_noxref_11_c_4317_n ) capacitor c=0.002495f \
 //x=47.85 //y=4.045 //x2=48.065 //y2=4.27
cc_3216 ( N_noxref_10_c_3752_n N_noxref_11_c_4317_n ) capacitor c=0.023136f \
 //x=47.85 //y=4.75 //x2=48.065 //y2=4.27
cc_3217 ( N_noxref_10_c_3706_n N_noxref_11_c_4173_n ) capacitor c=0.0358686f \
 //x=47.69 //y=3.885 //x2=43.19 //y2=4.265
cc_3218 ( N_noxref_10_c_3750_n N_noxref_11_c_4320_n ) capacitor c=0.00690666f \
 //x=47.85 //y=3.725 //x2=48.745 //y2=2.785
cc_3219 ( N_noxref_10_c_3752_n N_noxref_11_c_4321_n ) capacitor c=0.00217653f \
 //x=47.85 //y=4.75 //x2=47.81 //y2=5.56
cc_3220 ( N_noxref_10_c_3768_p N_noxref_11_c_4321_n ) capacitor c=0.00624059f \
 //x=47.85 //y=4.88 //x2=47.81 //y2=5.56
cc_3221 ( N_noxref_10_M110_noxref_g N_noxref_11_c_4321_n ) capacitor \
 c=0.0178885f //x=47.59 //y=6.2 //x2=47.81 //y2=5.56
cc_3222 ( N_noxref_10_M111_noxref_g N_noxref_11_c_4321_n ) capacitor \
 c=0.0188608f //x=48.03 //y=6.2 //x2=47.81 //y2=5.56
cc_3223 ( N_noxref_10_c_3797_p N_noxref_11_c_4321_n ) capacitor c=0.00375636f \
 //x=47.85 //y=4.88 //x2=47.81 //y2=5.56
cc_3224 ( N_noxref_10_c_3770_p N_noxref_11_M29_noxref_d ) capacitor \
 c=0.00137165f //x=47.84 //y=1.095 //x2=47.915 //y2=1.095
cc_3225 ( N_noxref_10_c_3771_p N_noxref_11_M29_noxref_d ) capacitor \
 c=0.00237422f //x=47.84 //y=1.44 //x2=47.915 //y2=1.095
cc_3226 ( N_noxref_10_c_3772_p N_noxref_11_M29_noxref_d ) capacitor \
 c=0.0020782f //x=48.215 //y=0.94 //x2=47.915 //y2=1.095
cc_3227 ( N_noxref_10_c_3773_p N_noxref_11_M29_noxref_d ) capacitor \
 c=0.00356097f //x=48.215 //y=1.595 //x2=47.915 //y2=1.095
cc_3228 ( N_noxref_10_c_3774_p N_noxref_11_M29_noxref_d ) capacitor \
 c=0.00139206f //x=48.37 //y=1.095 //x2=47.915 //y2=1.095
cc_3229 ( N_noxref_10_c_3775_p N_noxref_11_M29_noxref_d ) capacitor \
 c=0.00237422f //x=48.37 //y=1.44 //x2=47.915 //y2=1.095
cc_3230 ( N_noxref_10_c_3750_n D ) capacitor c=3.47668e-19 //x=47.85 //y=3.725 \
 //x2=50.44 //y2=3.88
cc_3231 ( N_noxref_10_c_3752_n D ) capacitor c=0.00117996f //x=47.85 //y=4.75 \
 //x2=50.44 //y2=3.88
cc_3232 ( N_noxref_10_c_3750_n N_D_c_5181_n ) capacitor c=0.00147237f \
 //x=47.85 //y=3.725 //x2=50.44 //y2=2.995
cc_3233 ( N_noxref_10_c_3575_n N_D_c_5088_n ) capacitor c=0.0217878f //x=31.57 \
 //y=3.705 //x2=33.775 //y2=3.14
cc_3234 ( N_noxref_10_c_3693_n N_D_c_5088_n ) capacitor c=0.0060755f //x=31.92 \
 //y=3.88 //x2=33.775 //y2=3.14
cc_3235 ( N_noxref_10_c_3585_n N_D_c_5088_n ) capacitor c=0.0124018f //x=36.54 \
 //y=3.88 //x2=33.775 //y2=3.14
cc_3236 ( N_noxref_10_c_3585_n N_D_c_5092_n ) capacitor c=0.0149083f //x=36.54 \
 //y=3.88 //x2=34.375 //y2=3.16
cc_3237 ( N_noxref_10_c_3582_n N_D_c_5103_n ) capacitor c=0.02494f //x=36.38 \
 //y=3.705 //x2=36.735 //y2=3.14
cc_3238 ( N_noxref_10_c_3621_n N_D_c_5103_n ) capacitor c=0.00672419f \
 //x=40.285 //y=3.865 //x2=36.735 //y2=3.14
cc_3239 ( N_noxref_10_c_3621_n N_D_c_5106_n ) capacitor c=0.00883326f \
 //x=40.285 //y=3.865 //x2=37.335 //y2=3.17
cc_3240 ( N_noxref_10_c_3621_n N_D_c_5110_n ) capacitor c=0.00429414f \
 //x=40.285 //y=3.865 //x2=38.58 //y2=3.14
cc_3241 ( N_noxref_10_c_3621_n N_D_c_5115_n ) capacitor c=0.00805392f \
 //x=40.285 //y=3.865 //x2=39.18 //y2=3.17
cc_3242 ( N_noxref_10_c_3605_n N_D_c_5138_n ) capacitor c=0.0256788f //x=40.45 \
 //y=3.705 //x2=43.39 //y2=3.14
cc_3243 ( N_noxref_10_c_3706_n N_D_c_5138_n ) capacitor c=0.0249252f //x=47.69 \
 //y=3.885 //x2=43.39 //y2=3.14
cc_3244 ( N_noxref_10_c_3706_n N_D_c_5168_n ) capacitor c=0.0088303f //x=47.69 \
 //y=3.885 //x2=43.99 //y2=3.17
cc_3245 ( N_noxref_10_c_3706_n N_D_c_5172_n ) capacitor c=0.00359897f \
 //x=47.69 //y=3.885 //x2=45.245 //y2=3.14
cc_3246 ( N_noxref_10_c_3706_n N_D_c_5177_n ) capacitor c=0.0148946f //x=47.69 \
 //y=3.885 //x2=45.845 //y2=3.17
cc_3247 ( N_noxref_10_c_3750_n N_D_c_5196_n ) capacitor c=0.0250218f //x=47.85 \
 //y=3.725 //x2=48.2 //y2=3.14
cc_3248 ( N_noxref_10_c_3575_n CLK ) capacitor c=0.0292717f //x=31.57 \
 //y=3.705 //x2=30.46 //y2=3.88
cc_3249 ( N_noxref_10_c_3665_n CLK ) capacitor c=0.00776638f //x=31.57 \
 //y=4.025 //x2=30.46 //y2=3.88
cc_3250 ( N_noxref_10_c_3580_n CLK ) capacitor c=0.0126059f //x=31.57 //y=4.75 \
 //x2=30.46 //y2=3.88
cc_3251 ( N_noxref_10_c_3692_n CLK ) capacitor c=5.01652e-19 //x=31.57 \
 //y=3.88 //x2=30.46 //y2=3.88
cc_3252 ( N_noxref_10_c_3701_n CLK ) capacitor c=0.00512566f //x=31.735 \
 //y=3.865 //x2=30.46 //y2=3.88
cc_3253 ( N_noxref_10_c_3710_n CLK ) capacitor c=3.9149e-19 //x=31.57 //y=2.26 \
 //x2=30.46 //y2=3.88
cc_3254 ( N_noxref_10_c_3605_n CLK ) capacitor c=0.0518972f //x=40.45 \
 //y=3.705 //x2=39.71 //y2=2.77
cc_3255 ( N_noxref_10_c_3684_n CLK ) capacitor c=0.0176724f //x=40.45 \
 //y=4.025 //x2=39.71 //y2=2.77
cc_3256 ( N_noxref_10_c_3608_n CLK ) capacitor c=0.0215525f //x=40.45 \
 //y=5.295 //x2=39.71 //y2=2.77
cc_3257 ( N_noxref_10_c_3849_p CLK ) capacitor c=9.19401e-19 //x=40.45 \
 //y=3.88 //x2=39.71 //y2=2.77
cc_3258 ( N_noxref_10_c_3621_n CLK ) capacitor c=0.0195461f //x=40.285 \
 //y=3.865 //x2=39.71 //y2=2.77
cc_3259 ( N_noxref_10_c_3704_n CLK ) capacitor c=0.00338457f //x=40.605 \
 //y=3.865 //x2=39.71 //y2=2.77
cc_3260 ( N_noxref_10_c_3663_n N_CLK_c_6544_n ) capacitor c=0.00936037f \
 //x=31.57 //y=2.375 //x2=30.46 //y2=2.375
cc_3261 ( N_noxref_10_c_3710_n N_CLK_c_6544_n ) capacitor c=5.42289e-19 \
 //x=31.57 //y=2.26 //x2=30.46 //y2=2.375
cc_3262 ( N_noxref_10_c_3739_n N_CLK_c_6544_n ) capacitor c=0.00134951f \
 //x=31.57 //y=2.26 //x2=30.46 //y2=2.375
cc_3263 ( N_noxref_10_c_3580_n N_CLK_c_6547_n ) capacitor c=0.0109762f \
 //x=31.57 //y=4.75 //x2=30.46 //y2=4.755
cc_3264 ( N_noxref_10_c_3711_n N_CLK_c_6547_n ) capacitor c=9.62855e-19 \
 //x=31.57 //y=4.88 //x2=30.46 //y2=4.755
cc_3265 ( N_noxref_10_c_3742_n N_CLK_c_6547_n ) capacitor c=0.00135081f \
 //x=31.57 //y=4.88 //x2=30.46 //y2=4.755
cc_3266 ( N_noxref_10_c_3605_n N_CLK_c_6591_n ) capacitor c=0.0138368f \
 //x=40.45 //y=3.705 //x2=39.71 //y2=2.26
cc_3267 ( N_noxref_10_c_3602_n N_CLK_c_6594_n ) capacitor c=0.0233476f \
 //x=39.855 //y=5.38 //x2=39.745 //y2=4.75
cc_3268 ( N_noxref_10_c_3608_n N_CLK_c_6594_n ) capacitor c=0.0216149f \
 //x=40.45 //y=5.295 //x2=39.745 //y2=4.75
cc_3269 ( N_noxref_10_c_3753_n N_CLK_c_6594_n ) capacitor c=0.00285789f \
 //x=39.97 //y=5.38 //x2=39.745 //y2=4.75
cc_3270 ( N_noxref_10_c_3862_p N_CLK_c_6594_n ) capacitor c=7.41644e-19 \
 //x=39.97 //y=5.56 //x2=39.745 //y2=4.75
cc_3271 ( N_noxref_10_c_3695_n N_CLK_c_6648_n ) capacitor c=0.0012014f \
 //x=32.52 //y=3.865 //x2=32.52 //y2=4.635
cc_3272 ( N_noxref_10_c_3580_n N_CLK_c_6554_n ) capacitor c=0.0333551f \
 //x=31.57 //y=4.75 //x2=32.175 //y2=4.635
cc_3273 ( N_noxref_10_c_3693_n N_CLK_c_6554_n ) capacitor c=0.00296241f \
 //x=31.92 //y=3.88 //x2=32.175 //y2=4.635
cc_3274 ( N_noxref_10_c_3706_n N_CLK_c_6660_n ) capacitor c=0.0259108f \
 //x=47.69 //y=3.885 //x2=43.245 //y2=4.65
cc_3275 ( N_noxref_10_c_3584_n N_CLK_c_6557_n ) capacitor c=0.0287127f \
 //x=36.38 //y=4.75 //x2=42.17 //y2=4.65
cc_3276 ( N_noxref_10_c_3602_n N_CLK_c_6557_n ) capacitor c=9.84751e-19 \
 //x=39.855 //y=5.38 //x2=42.17 //y2=4.65
cc_3277 ( N_noxref_10_c_3608_n N_CLK_c_6557_n ) capacitor c=0.032893f \
 //x=40.45 //y=5.295 //x2=42.17 //y2=4.65
cc_3278 ( N_noxref_10_c_3611_n N_CLK_c_6557_n ) capacitor c=0.0211459f \
 //x=39.09 //y=5.56 //x2=42.17 //y2=4.65
cc_3279 ( N_noxref_10_c_3753_n N_CLK_c_6557_n ) capacitor c=0.0191541f \
 //x=39.97 //y=5.38 //x2=42.17 //y2=4.65
cc_3280 ( N_noxref_10_c_3585_n N_CLK_c_6557_n ) capacitor c=0.0225931f \
 //x=36.54 //y=3.88 //x2=42.17 //y2=4.65
cc_3281 ( N_noxref_10_c_3621_n N_CLK_c_6557_n ) capacitor c=0.0218372f \
 //x=40.285 //y=3.865 //x2=42.17 //y2=4.65
cc_3282 ( N_noxref_10_c_3706_n N_CLK_c_6557_n ) capacitor c=0.0312304f \
 //x=47.69 //y=3.885 //x2=42.17 //y2=4.65
cc_3283 ( N_noxref_10_c_3752_n N_CLK_c_6683_n ) capacitor c=0.0285034f \
 //x=47.85 //y=4.75 //x2=50.795 //y2=4.62
cc_3284 ( N_noxref_10_c_3663_n N_CLK_c_6558_n ) capacitor c=5.39999e-19 \
 //x=31.57 //y=2.375 //x2=30.46 //y2=2.26
cc_3285 ( N_noxref_10_c_3575_n N_CLK_c_6558_n ) capacitor c=3.9149e-19 \
 //x=31.57 //y=3.705 //x2=30.46 //y2=2.26
cc_3286 ( N_noxref_10_c_3710_n N_CLK_c_6558_n ) capacitor c=0.00125213f \
 //x=31.57 //y=2.26 //x2=30.46 //y2=2.26
cc_3287 ( N_noxref_10_c_3739_n N_CLK_c_6558_n ) capacitor c=0.00204868f \
 //x=31.57 //y=2.26 //x2=30.46 //y2=2.26
cc_3288 ( N_noxref_10_c_3580_n N_CLK_c_6562_n ) capacitor c=4.56604e-19 \
 //x=31.57 //y=4.75 //x2=30.46 //y2=4.88
cc_3289 ( N_noxref_10_c_3711_n N_CLK_c_6562_n ) capacitor c=0.00113668f \
 //x=31.57 //y=4.88 //x2=30.46 //y2=4.88
cc_3290 ( N_noxref_10_c_3742_n N_CLK_c_6562_n ) capacitor c=0.00186974f \
 //x=31.57 //y=4.88 //x2=30.46 //y2=4.88
cc_3291 ( N_noxref_10_c_3605_n N_CLK_c_6604_n ) capacitor c=9.26054e-19 \
 //x=40.45 //y=3.705 //x2=39.71 //y2=2.26
cc_3292 ( N_noxref_10_c_3602_n N_CLK_c_6608_n ) capacitor c=0.00469232f \
 //x=39.855 //y=5.38 //x2=39.74 //y2=4.88
cc_3293 ( N_noxref_10_c_3608_n N_CLK_c_6608_n ) capacitor c=5.14671e-19 \
 //x=40.45 //y=5.295 //x2=39.74 //y2=4.88
cc_3294 ( N_noxref_10_M90_noxref_g N_CLK_M88_noxref_g ) capacitor c=0.0101598f \
 //x=31.31 //y=6.2 //x2=30.43 //y2=6.2
cc_3295 ( N_noxref_10_M90_noxref_g N_CLK_M89_noxref_g ) capacitor c=0.0607518f \
 //x=31.31 //y=6.2 //x2=30.87 //y2=6.2
cc_3296 ( N_noxref_10_M91_noxref_g N_CLK_M89_noxref_g ) capacitor c=0.0101598f \
 //x=31.75 //y=6.2 //x2=30.87 //y2=6.2
cc_3297 ( N_noxref_10_c_3602_n N_CLK_M100_noxref_g ) capacitor c=0.00842852f \
 //x=39.855 //y=5.38 //x2=39.75 //y2=6.2
cc_3298 ( N_noxref_10_c_3753_n N_CLK_M100_noxref_g ) capacitor c=0.00192712f \
 //x=39.97 //y=5.38 //x2=39.75 //y2=6.2
cc_3299 ( N_noxref_10_c_3862_p N_CLK_M100_noxref_g ) capacitor c=0.0178987f \
 //x=39.97 //y=5.56 //x2=39.75 //y2=6.2
cc_3300 ( N_noxref_10_c_3746_n N_CLK_M101_noxref_g ) capacitor c=0.0106973f \
 //x=40.365 //y=5.38 //x2=40.19 //y2=6.2
cc_3301 ( N_noxref_10_c_3753_n N_CLK_M101_noxref_g ) capacitor c=0.00298276f \
 //x=39.97 //y=5.38 //x2=40.19 //y2=6.2
cc_3302 ( N_noxref_10_c_3862_p N_CLK_M101_noxref_g ) capacitor c=0.0178506f \
 //x=39.97 //y=5.56 //x2=40.19 //y2=6.2
cc_3303 ( N_noxref_10_c_3721_n N_CLK_c_6574_n ) capacitor c=0.00456962f \
 //x=31.56 //y=1.095 //x2=30.55 //y2=1.09
cc_3304 ( N_noxref_10_c_3723_n N_CLK_c_6575_n ) capacitor c=0.00438372f \
 //x=31.56 //y=1.44 //x2=30.55 //y2=1.4
cc_3305 ( N_noxref_10_c_3726_n N_CLK_c_6576_n ) capacitor c=0.00438372f \
 //x=31.56 //y=1.75 //x2=30.55 //y2=1.63
cc_3306 ( N_noxref_10_c_3663_n N_CLK_c_6577_n ) capacitor c=0.00137098f \
 //x=31.57 //y=2.375 //x2=30.55 //y2=2.095
cc_3307 ( N_noxref_10_c_3710_n N_CLK_c_6577_n ) capacitor c=0.00209664f \
 //x=31.57 //y=2.26 //x2=30.55 //y2=2.095
cc_3308 ( N_noxref_10_c_3739_n N_CLK_c_6577_n ) capacitor c=0.00933826f \
 //x=31.57 //y=2.26 //x2=30.55 //y2=2.095
cc_3309 ( N_noxref_10_c_3740_n N_CLK_c_6577_n ) capacitor c=0.00438372f \
 //x=31.57 //y=2.095 //x2=30.55 //y2=2.095
cc_3310 ( N_noxref_10_c_3742_n N_CLK_c_6677_n ) capacitor c=0.0616777f \
 //x=31.57 //y=4.88 //x2=30.795 //y2=4.97
cc_3311 ( N_noxref_10_c_3619_n N_CLK_c_6614_n ) capacitor c=0.00120406f \
 //x=40.01 //y=1.18 //x2=39.745 //y2=1.085
cc_3312 ( N_noxref_10_M24_noxref_d N_CLK_c_6614_n ) capacitor c=0.00137165f \
 //x=39.82 //y=1.085 //x2=39.745 //y2=1.085
cc_3313 ( N_noxref_10_c_3603_n N_CLK_c_6617_n ) capacitor c=0.00119302f \
 //x=40.01 //y=1.75 //x2=39.745 //y2=1.43
cc_3314 ( N_noxref_10_c_3619_n N_CLK_c_6617_n ) capacitor c=0.00218772f \
 //x=40.01 //y=1.18 //x2=39.745 //y2=1.43
cc_3315 ( N_noxref_10_M24_noxref_d N_CLK_c_6617_n ) capacitor c=0.00237422f \
 //x=39.82 //y=1.085 //x2=39.745 //y2=1.43
cc_3316 ( N_noxref_10_c_3603_n N_CLK_c_6619_n ) capacitor c=0.00439215f \
 //x=40.01 //y=1.75 //x2=39.745 //y2=1.74
cc_3317 ( N_noxref_10_c_3684_n N_CLK_c_6755_n ) capacitor c=0.00127572f \
 //x=40.45 //y=4.025 //x2=40.115 //y2=4.97
cc_3318 ( N_noxref_10_c_3608_n N_CLK_c_6755_n ) capacitor c=0.00844995f \
 //x=40.45 //y=5.295 //x2=40.115 //y2=4.97
cc_3319 ( N_noxref_10_c_3753_n N_CLK_c_6755_n ) capacitor c=0.0020909f \
 //x=39.97 //y=5.38 //x2=40.115 //y2=4.97
cc_3320 ( N_noxref_10_c_3862_p N_CLK_c_6755_n ) capacitor c=0.00291714f \
 //x=39.97 //y=5.56 //x2=40.115 //y2=4.97
cc_3321 ( N_noxref_10_c_3619_n N_CLK_c_6759_n ) capacitor c=5.50523e-19 \
 //x=40.01 //y=1.18 //x2=40.12 //y2=0.93
cc_3322 ( N_noxref_10_M24_noxref_d N_CLK_c_6759_n ) capacitor c=0.0020782f \
 //x=39.82 //y=1.085 //x2=40.12 //y2=0.93
cc_3323 ( N_noxref_10_c_3603_n N_CLK_c_6761_n ) capacitor c=0.00917366f \
 //x=40.01 //y=1.75 //x2=40.12 //y2=1.585
cc_3324 ( N_noxref_10_c_3747_n N_CLK_c_6761_n ) capacitor c=0.00194324f \
 //x=40.365 //y=1.835 //x2=40.12 //y2=1.585
cc_3325 ( N_noxref_10_c_3619_n N_CLK_c_6761_n ) capacitor c=5.64626e-19 \
 //x=40.01 //y=1.18 //x2=40.12 //y2=1.585
cc_3326 ( N_noxref_10_M24_noxref_d N_CLK_c_6761_n ) capacitor c=0.00356097f \
 //x=39.82 //y=1.085 //x2=40.12 //y2=1.585
cc_3327 ( N_noxref_10_c_3619_n N_CLK_c_6622_n ) capacitor c=0.00109205f \
 //x=40.01 //y=1.18 //x2=40.275 //y2=1.085
cc_3328 ( N_noxref_10_M24_noxref_d N_CLK_c_6622_n ) capacitor c=8.50095e-19 \
 //x=39.82 //y=1.085 //x2=40.275 //y2=1.085
cc_3329 ( N_noxref_10_c_3603_n N_CLK_c_6623_n ) capacitor c=0.003249f \
 //x=40.01 //y=1.75 //x2=40.275 //y2=1.43
cc_3330 ( N_noxref_10_c_3747_n N_CLK_c_6623_n ) capacitor c=0.00323005f \
 //x=40.365 //y=1.835 //x2=40.275 //y2=1.43
cc_3331 ( N_noxref_10_c_3619_n N_CLK_c_6623_n ) capacitor c=0.00317092f \
 //x=40.01 //y=1.18 //x2=40.275 //y2=1.43
cc_3332 ( N_noxref_10_M24_noxref_d N_CLK_c_6623_n ) capacitor c=0.00237422f \
 //x=39.82 //y=1.085 //x2=40.275 //y2=1.43
cc_3333 ( N_noxref_10_c_3711_n N_CLK_c_6580_n ) capacitor c=9.77556e-19 \
 //x=31.57 //y=4.88 //x2=30.46 //y2=4.88
cc_3334 ( N_noxref_10_c_3742_n N_CLK_c_6580_n ) capacitor c=0.0042693f \
 //x=31.57 //y=4.88 //x2=30.46 //y2=4.88
cc_3335 ( N_noxref_10_c_3605_n N_CLK_c_6624_n ) capacitor c=0.00268898f \
 //x=40.45 //y=3.705 //x2=39.71 //y2=2.26
cc_3336 ( N_noxref_10_c_3603_n N_CLK_c_6774_n ) capacitor c=0.00341688f \
 //x=40.01 //y=1.75 //x2=39.71 //y2=2.095
cc_3337 ( N_noxref_10_c_3605_n N_CLK_c_6774_n ) capacitor c=0.00309058f \
 //x=40.45 //y=3.705 //x2=39.71 //y2=2.095
cc_3338 ( N_noxref_10_c_3602_n N_CLK_c_6627_n ) capacitor c=7.94507e-19 \
 //x=39.855 //y=5.38 //x2=39.74 //y2=4.88
cc_3339 ( N_noxref_10_c_3586_n N_SN_c_8253_n ) capacitor c=0.00790562f \
 //x=36.38 //y=2.375 //x2=35.27 //y2=2.55
cc_3340 ( N_noxref_10_c_3582_n N_SN_c_8253_n ) capacitor c=0.00339731f \
 //x=36.38 //y=3.705 //x2=35.27 //y2=2.55
cc_3341 ( N_noxref_10_c_3623_n N_SN_c_8253_n ) capacitor c=0.00116634f \
 //x=36.38 //y=2.26 //x2=35.27 //y2=2.55
cc_3342 ( N_noxref_10_c_3657_n N_SN_c_8253_n ) capacitor c=0.00149114f \
 //x=36.38 //y=2.26 //x2=35.27 //y2=2.55
cc_3343 ( N_noxref_10_c_3582_n N_SN_c_8257_n ) capacitor c=0.0285304f \
 //x=36.38 //y=3.705 //x2=35.27 //y2=4.765
cc_3344 ( N_noxref_10_c_3594_n N_SN_c_8257_n ) capacitor c=0.0078001f \
 //x=36.38 //y=4.025 //x2=35.27 //y2=4.765
cc_3345 ( N_noxref_10_c_3584_n N_SN_c_8257_n ) capacitor c=0.0266367f \
 //x=36.38 //y=4.75 //x2=35.27 //y2=4.765
cc_3346 ( N_noxref_10_c_3610_n N_SN_c_8257_n ) capacitor c=5.01652e-19 \
 //x=36.38 //y=3.88 //x2=35.27 //y2=4.765
cc_3347 ( N_noxref_10_c_3585_n N_SN_c_8257_n ) capacitor c=0.0254062f \
 //x=36.54 //y=3.88 //x2=35.27 //y2=4.765
cc_3348 ( N_noxref_10_c_3624_n N_SN_c_8257_n ) capacitor c=7.51101e-19 \
 //x=36.38 //y=4.88 //x2=35.27 //y2=4.765
cc_3349 ( N_noxref_10_c_3660_n N_SN_c_8257_n ) capacitor c=0.00124604f \
 //x=36.38 //y=4.88 //x2=35.27 //y2=4.765
cc_3350 ( N_noxref_10_c_3783_p N_SN_c_8360_n ) capacitor c=0.00782975f \
 //x=47.85 //y=2.375 //x2=46.74 //y2=2.55
cc_3351 ( N_noxref_10_c_3750_n N_SN_c_8360_n ) capacitor c=0.00332919f \
 //x=47.85 //y=3.725 //x2=46.74 //y2=2.55
cc_3352 ( N_noxref_10_c_3785_p N_SN_c_8360_n ) capacitor c=0.00115817f \
 //x=47.85 //y=2.26 //x2=46.74 //y2=2.55
cc_3353 ( N_noxref_10_c_3786_p N_SN_c_8360_n ) capacitor c=0.00148267f \
 //x=47.85 //y=2.26 //x2=46.74 //y2=2.55
cc_3354 ( N_noxref_10_c_3750_n N_SN_c_8364_n ) capacitor c=0.0291747f \
 //x=47.85 //y=3.725 //x2=46.74 //y2=4.765
cc_3355 ( N_noxref_10_c_3762_p N_SN_c_8364_n ) capacitor c=0.00772613f \
 //x=47.85 //y=4.045 //x2=46.74 //y2=4.765
cc_3356 ( N_noxref_10_c_3752_n N_SN_c_8364_n ) capacitor c=0.0257737f \
 //x=47.85 //y=4.75 //x2=46.74 //y2=4.765
cc_3357 ( N_noxref_10_c_3792_p N_SN_c_8364_n ) capacitor c=3.43503e-19 \
 //x=47.85 //y=3.88 //x2=46.74 //y2=4.765
cc_3358 ( N_noxref_10_c_3793_p N_SN_c_8364_n ) capacitor c=0.00242466f \
 //x=47.85 //y=3.885 //x2=46.74 //y2=4.765
cc_3359 ( N_noxref_10_c_3706_n N_SN_c_8364_n ) capacitor c=0.0229283f \
 //x=47.69 //y=3.885 //x2=46.74 //y2=4.765
cc_3360 ( N_noxref_10_c_3768_p N_SN_c_8364_n ) capacitor c=7.51101e-19 \
 //x=47.85 //y=4.88 //x2=46.74 //y2=4.765
cc_3361 ( N_noxref_10_c_3797_p N_SN_c_8364_n ) capacitor c=0.00124604f \
 //x=47.85 //y=4.88 //x2=46.74 //y2=4.765
cc_3362 ( N_noxref_10_c_3663_n N_SN_c_8282_n ) capacitor c=0.0160589f \
 //x=31.57 //y=2.375 //x2=33.775 //y2=2.4
cc_3363 ( N_noxref_10_c_3575_n N_SN_c_8282_n ) capacitor c=0.0129637f \
 //x=31.57 //y=3.705 //x2=33.775 //y2=2.4
cc_3364 ( N_noxref_10_c_3710_n N_SN_c_8282_n ) capacitor c=2.63835e-19 \
 //x=31.57 //y=2.26 //x2=33.775 //y2=2.4
cc_3365 ( N_noxref_10_c_3739_n N_SN_c_8282_n ) capacitor c=3.41298e-19 \
 //x=31.57 //y=2.26 //x2=33.775 //y2=2.4
cc_3366 ( N_noxref_10_c_3586_n N_SN_c_8324_n ) capacitor c=0.0160193f \
 //x=36.38 //y=2.375 //x2=46.57 //y2=2.4
cc_3367 ( N_noxref_10_c_3582_n N_SN_c_8324_n ) capacitor c=0.0155071f \
 //x=36.38 //y=3.705 //x2=46.57 //y2=2.4
cc_3368 ( N_noxref_10_c_3604_n N_SN_c_8324_n ) capacitor c=0.0192658f \
 //x=40.095 //y=1.835 //x2=46.57 //y2=2.4
cc_3369 ( N_noxref_10_c_3605_n N_SN_c_8324_n ) capacitor c=0.0307839f \
 //x=40.45 //y=3.705 //x2=46.57 //y2=2.4
cc_3370 ( N_noxref_10_c_3619_n N_SN_c_8324_n ) capacitor c=7.29202e-19 \
 //x=40.01 //y=1.18 //x2=46.57 //y2=2.4
cc_3371 ( N_noxref_10_c_3657_n N_SN_c_8324_n ) capacitor c=3.41298e-19 \
 //x=36.38 //y=2.26 //x2=46.57 //y2=2.4
cc_3372 ( N_noxref_10_c_3586_n N_SN_c_8291_n ) capacitor c=0.00195485f \
 //x=36.38 //y=2.375 //x2=35.43 //y2=2.4
cc_3373 ( N_noxref_10_c_3582_n N_SN_c_8291_n ) capacitor c=0.00105069f \
 //x=36.38 //y=3.705 //x2=35.43 //y2=2.4
cc_3374 ( N_noxref_10_c_3783_p N_SN_c_8385_n ) capacitor c=0.0179937f \
 //x=47.85 //y=2.375 //x2=51.705 //y2=2.385
cc_3375 ( N_noxref_10_c_3750_n N_SN_c_8385_n ) capacitor c=0.0165673f \
 //x=47.85 //y=3.725 //x2=51.705 //y2=2.385
cc_3376 ( N_noxref_10_c_3786_p N_SN_c_8385_n ) capacitor c=3.41298e-19 \
 //x=47.85 //y=2.26 //x2=51.705 //y2=2.385
cc_3377 ( N_noxref_10_c_3586_n N_SN_c_8293_n ) capacitor c=5.39999e-19 \
 //x=36.38 //y=2.375 //x2=35.27 //y2=2.26
cc_3378 ( N_noxref_10_c_3623_n N_SN_c_8293_n ) capacitor c=0.00124907f \
 //x=36.38 //y=2.26 //x2=35.27 //y2=2.26
cc_3379 ( N_noxref_10_c_3657_n N_SN_c_8293_n ) capacitor c=0.00204796f \
 //x=36.38 //y=2.26 //x2=35.27 //y2=2.26
cc_3380 ( N_noxref_10_c_3584_n N_SN_c_8296_n ) capacitor c=9.52396e-19 \
 //x=36.38 //y=4.75 //x2=35.27 //y2=4.88
cc_3381 ( N_noxref_10_c_3624_n N_SN_c_8296_n ) capacitor c=0.00113985f \
 //x=36.38 //y=4.88 //x2=35.27 //y2=4.88
cc_3382 ( N_noxref_10_c_3660_n N_SN_c_8296_n ) capacitor c=0.00187046f \
 //x=36.38 //y=4.88 //x2=35.27 //y2=4.88
cc_3383 ( N_noxref_10_c_3783_p N_SN_c_8387_n ) capacitor c=5.39999e-19 \
 //x=47.85 //y=2.375 //x2=46.74 //y2=2.26
cc_3384 ( N_noxref_10_c_3785_p N_SN_c_8387_n ) capacitor c=0.0012491f \
 //x=47.85 //y=2.26 //x2=46.74 //y2=2.26
cc_3385 ( N_noxref_10_c_3786_p N_SN_c_8387_n ) capacitor c=0.00204796f \
 //x=47.85 //y=2.26 //x2=46.74 //y2=2.26
cc_3386 ( N_noxref_10_c_3752_n N_SN_c_8390_n ) capacitor c=9.52396e-19 \
 //x=47.85 //y=4.75 //x2=46.74 //y2=4.88
cc_3387 ( N_noxref_10_c_3768_p N_SN_c_8390_n ) capacitor c=0.00113985f \
 //x=47.85 //y=4.88 //x2=46.74 //y2=4.88
cc_3388 ( N_noxref_10_c_3797_p N_SN_c_8390_n ) capacitor c=0.00187046f \
 //x=47.85 //y=4.88 //x2=46.74 //y2=4.88
cc_3389 ( N_noxref_10_M96_noxref_g N_SN_M94_noxref_g ) capacitor c=0.0101598f \
 //x=36.12 //y=6.2 //x2=35.24 //y2=6.2
cc_3390 ( N_noxref_10_M96_noxref_g N_SN_M95_noxref_g ) capacitor c=0.0607518f \
 //x=36.12 //y=6.2 //x2=35.68 //y2=6.2
cc_3391 ( N_noxref_10_M97_noxref_g N_SN_M95_noxref_g ) capacitor c=0.0101598f \
 //x=36.56 //y=6.2 //x2=35.68 //y2=6.2
cc_3392 ( N_noxref_10_M110_noxref_g N_SN_M108_noxref_g ) capacitor \
 c=0.0101598f //x=47.59 //y=6.2 //x2=46.71 //y2=6.2
cc_3393 ( N_noxref_10_M110_noxref_g N_SN_M109_noxref_g ) capacitor \
 c=0.0607518f //x=47.59 //y=6.2 //x2=47.15 //y2=6.2
cc_3394 ( N_noxref_10_M111_noxref_g N_SN_M109_noxref_g ) capacitor \
 c=0.0101598f //x=48.03 //y=6.2 //x2=47.15 //y2=6.2
cc_3395 ( N_noxref_10_c_3639_n N_SN_c_8308_n ) capacitor c=0.00456962f \
 //x=36.37 //y=1.095 //x2=35.36 //y2=1.09
cc_3396 ( N_noxref_10_c_3641_n N_SN_c_8309_n ) capacitor c=0.00438372f \
 //x=36.37 //y=1.44 //x2=35.36 //y2=1.4
cc_3397 ( N_noxref_10_c_3644_n N_SN_c_8310_n ) capacitor c=0.00438372f \
 //x=36.37 //y=1.75 //x2=35.36 //y2=1.63
cc_3398 ( N_noxref_10_c_3586_n N_SN_c_8311_n ) capacitor c=6.5732e-19 \
 //x=36.38 //y=2.375 //x2=35.36 //y2=2.095
cc_3399 ( N_noxref_10_c_3623_n N_SN_c_8311_n ) capacitor c=0.00177608f \
 //x=36.38 //y=2.26 //x2=35.36 //y2=2.095
cc_3400 ( N_noxref_10_c_3657_n N_SN_c_8311_n ) capacitor c=0.00873247f \
 //x=36.38 //y=2.26 //x2=35.36 //y2=2.095
cc_3401 ( N_noxref_10_c_3658_n N_SN_c_8311_n ) capacitor c=0.00438372f \
 //x=36.38 //y=2.095 //x2=35.36 //y2=2.095
cc_3402 ( N_noxref_10_c_3660_n N_SN_c_8344_n ) capacitor c=0.0616777f \
 //x=36.38 //y=4.88 //x2=35.605 //y2=4.97
cc_3403 ( N_noxref_10_c_3770_p N_SN_c_8402_n ) capacitor c=0.00456962f \
 //x=47.84 //y=1.095 //x2=46.83 //y2=1.09
cc_3404 ( N_noxref_10_c_3771_p N_SN_c_8403_n ) capacitor c=0.00438372f \
 //x=47.84 //y=1.44 //x2=46.83 //y2=1.4
cc_3405 ( N_noxref_10_c_3777_p N_SN_c_8404_n ) capacitor c=0.00438372f \
 //x=47.84 //y=1.75 //x2=46.83 //y2=1.63
cc_3406 ( N_noxref_10_c_3783_p N_SN_c_8405_n ) capacitor c=6.57457e-19 \
 //x=47.85 //y=2.375 //x2=46.83 //y2=2.095
cc_3407 ( N_noxref_10_c_3785_p N_SN_c_8405_n ) capacitor c=0.00177608f \
 //x=47.85 //y=2.26 //x2=46.83 //y2=2.095
cc_3408 ( N_noxref_10_c_3786_p N_SN_c_8405_n ) capacitor c=0.00873247f \
 //x=47.85 //y=2.26 //x2=46.83 //y2=2.095
cc_3409 ( N_noxref_10_c_3780_p N_SN_c_8405_n ) capacitor c=0.00438372f \
 //x=47.85 //y=2.095 //x2=46.83 //y2=2.095
cc_3410 ( N_noxref_10_c_3797_p N_SN_c_8483_n ) capacitor c=0.0616777f \
 //x=47.85 //y=4.88 //x2=47.075 //y2=4.97
cc_3411 ( N_noxref_10_c_3584_n N_SN_c_8314_n ) capacitor c=8.42568e-19 \
 //x=36.38 //y=4.75 //x2=35.27 //y2=4.88
cc_3412 ( N_noxref_10_c_3624_n N_SN_c_8314_n ) capacitor c=0.00129812f \
 //x=36.38 //y=4.88 //x2=35.27 //y2=4.88
cc_3413 ( N_noxref_10_c_3660_n N_SN_c_8314_n ) capacitor c=0.00487508f \
 //x=36.38 //y=4.88 //x2=35.27 //y2=4.88
cc_3414 ( N_noxref_10_c_3752_n N_SN_c_8408_n ) capacitor c=8.42568e-19 \
 //x=47.85 //y=4.75 //x2=46.74 //y2=4.88
cc_3415 ( N_noxref_10_c_3768_p N_SN_c_8408_n ) capacitor c=0.00129812f \
 //x=47.85 //y=4.88 //x2=46.74 //y2=4.88
cc_3416 ( N_noxref_10_c_3797_p N_SN_c_8408_n ) capacitor c=0.00487508f \
 //x=47.85 //y=4.88 //x2=46.74 //y2=4.88
cc_3417 ( N_noxref_10_c_3575_n N_noxref_21_c_10581_n ) capacitor c=0.0217531f \
 //x=31.57 //y=3.705 //x2=31.79 //y2=3.48
cc_3418 ( N_noxref_10_c_3665_n N_noxref_21_c_10581_n ) capacitor c=0.00592109f \
 //x=31.57 //y=4.025 //x2=31.79 //y2=3.48
cc_3419 ( N_noxref_10_c_3693_n N_noxref_21_c_10581_n ) capacitor c=0.0527444f \
 //x=31.92 //y=3.88 //x2=31.79 //y2=3.48
cc_3420 ( N_noxref_10_c_3701_n N_noxref_21_c_10581_n ) capacitor c=0.0358686f \
 //x=31.735 //y=3.865 //x2=31.79 //y2=3.48
cc_3421 ( N_noxref_10_c_3575_n N_noxref_21_c_10561_n ) capacitor c=7.62769e-19 \
 //x=31.57 //y=3.705 //x2=31.36 //y2=3.48
cc_3422 ( N_noxref_10_c_3582_n N_noxref_21_c_10586_n ) capacitor c=7.55725e-19 \
 //x=36.38 //y=3.705 //x2=35.995 //y2=3.51
cc_3423 ( N_noxref_10_c_3594_n N_noxref_21_c_10586_n ) capacitor c=0.00196428f \
 //x=36.38 //y=4.025 //x2=35.995 //y2=3.51
cc_3424 ( N_noxref_10_c_3695_n N_noxref_21_c_10586_n ) capacitor c=0.028687f \
 //x=32.52 //y=3.865 //x2=35.995 //y2=3.51
cc_3425 ( N_noxref_10_c_3585_n N_noxref_21_c_10586_n ) capacitor c=0.315523f \
 //x=36.54 //y=3.88 //x2=35.995 //y2=3.51
cc_3426 ( N_noxref_10_c_3582_n N_noxref_21_c_10587_n ) capacitor c=0.0217584f \
 //x=36.38 //y=3.705 //x2=36.595 //y2=3.48
cc_3427 ( N_noxref_10_c_3594_n N_noxref_21_c_10587_n ) capacitor c=0.00434524f \
 //x=36.38 //y=4.025 //x2=36.595 //y2=3.48
cc_3428 ( N_noxref_10_c_3585_n N_noxref_21_c_10587_n ) capacitor c=0.0358686f \
 //x=36.54 //y=3.88 //x2=36.595 //y2=3.48
cc_3429 ( N_noxref_10_c_3621_n N_noxref_21_c_10587_n ) capacitor c=0.315141f \
 //x=40.285 //y=3.865 //x2=36.595 //y2=3.48
cc_3430 ( N_noxref_10_c_3605_n N_noxref_21_c_10588_n ) capacitor c=6.1754e-19 \
 //x=40.45 //y=3.705 //x2=40.06 //y2=3.51
cc_3431 ( N_noxref_10_c_3684_n N_noxref_21_c_10588_n ) capacitor c=0.00158365f \
 //x=40.45 //y=4.025 //x2=40.06 //y2=3.51
cc_3432 ( N_noxref_10_c_3621_n N_noxref_21_c_10588_n ) capacitor c=0.010394f \
 //x=40.285 //y=3.865 //x2=40.06 //y2=3.51
cc_3433 ( N_noxref_10_c_3605_n N_noxref_21_c_10604_n ) capacitor c=0.023179f \
 //x=40.45 //y=3.705 //x2=40.66 //y2=3.48
cc_3434 ( N_noxref_10_c_3684_n N_noxref_21_c_10604_n ) capacitor c=0.00479601f \
 //x=40.45 //y=4.025 //x2=40.66 //y2=3.48
cc_3435 ( N_noxref_10_c_3704_n N_noxref_21_c_10604_n ) capacitor c=0.0358686f \
 //x=40.605 //y=3.865 //x2=40.66 //y2=3.48
cc_3436 ( N_noxref_10_c_3706_n N_noxref_21_c_10604_n ) capacitor c=0.605856f \
 //x=47.69 //y=3.885 //x2=40.66 //y2=3.48
cc_3437 ( N_noxref_10_c_3750_n N_noxref_21_c_10606_n ) capacitor c=3.78085e-19 \
 //x=47.85 //y=3.725 //x2=47.465 //y2=3.51
cc_3438 ( N_noxref_10_c_3762_p N_noxref_21_c_10606_n ) capacitor c=0.00200219f \
 //x=47.85 //y=4.045 //x2=47.465 //y2=3.51
cc_3439 ( N_noxref_10_c_3706_n N_noxref_21_c_10606_n ) capacitor c=0.0107232f \
 //x=47.69 //y=3.885 //x2=47.465 //y2=3.51
cc_3440 ( N_noxref_10_c_3750_n N_noxref_21_c_10633_n ) capacitor c=0.0216783f \
 //x=47.85 //y=3.725 //x2=48.065 //y2=3.495
cc_3441 ( N_noxref_10_c_3762_p N_noxref_21_c_10633_n ) capacitor c=0.00427115f \
 //x=47.85 //y=4.045 //x2=48.065 //y2=3.495
cc_3442 ( N_noxref_10_c_3793_p N_noxref_21_c_10633_n ) capacitor c=0.0353757f \
 //x=47.85 //y=3.885 //x2=48.065 //y2=3.495
cc_3443 ( N_noxref_10_c_3602_n N_VDD_c_11522_n ) capacitor c=0.00648297f \
 //x=39.855 //y=5.38 //x2=74.455 //y2=7.585
cc_3444 ( N_noxref_10_c_3746_n N_VDD_c_11522_n ) capacitor c=0.00492578f \
 //x=40.365 //y=5.38 //x2=74.455 //y2=7.585
cc_3445 ( N_noxref_10_c_3684_n N_VDD_c_11522_n ) capacitor c=2.03815e-19 \
 //x=40.45 //y=4.025 //x2=74.455 //y2=7.585
cc_3446 ( N_noxref_10_c_3611_n N_VDD_c_11522_n ) capacitor c=0.00368834f \
 //x=39.09 //y=5.56 //x2=74.455 //y2=7.585
cc_3447 ( N_noxref_10_c_3753_n N_VDD_c_11522_n ) capacitor c=8.42537e-19 \
 //x=39.97 //y=5.38 //x2=74.455 //y2=7.585
cc_3448 ( N_noxref_10_c_3754_n N_VDD_c_11522_n ) capacitor c=0.00285853f \
 //x=39.97 //y=5.56 //x2=74.455 //y2=7.585
cc_3449 ( N_noxref_10_c_3628_n N_VDD_c_11522_n ) capacitor c=0.00224881f \
 //x=39.09 //y=5.56 //x2=74.455 //y2=7.585
cc_3450 ( N_noxref_10_c_3862_p N_VDD_c_11522_n ) capacitor c=0.00224881f \
 //x=39.97 //y=5.56 //x2=74.455 //y2=7.585
cc_3451 ( N_noxref_10_M90_noxref_g N_VDD_c_11955_n ) capacitor c=0.00755544f \
 //x=31.31 //y=6.2 //x2=31.885 //y2=7.585
cc_3452 ( N_noxref_10_M91_noxref_g N_VDD_c_11955_n ) capacitor c=0.00755754f \
 //x=31.75 //y=6.2 //x2=31.885 //y2=7.585
cc_3453 ( N_noxref_10_M96_noxref_g N_VDD_c_11899_n ) capacitor c=0.00755544f \
 //x=36.12 //y=6.2 //x2=36.695 //y2=7.585
cc_3454 ( N_noxref_10_M97_noxref_g N_VDD_c_11899_n ) capacitor c=0.00755754f \
 //x=36.56 //y=6.2 //x2=36.695 //y2=7.585
cc_3455 ( N_noxref_10_c_3602_n N_VDD_c_11904_n ) capacitor c=0.00208087f \
 //x=39.855 //y=5.38 //x2=39.445 //y2=7.585
cc_3456 ( N_noxref_10_c_3611_n N_VDD_c_11904_n ) capacitor c=9.41185e-19 \
 //x=39.09 //y=5.56 //x2=39.445 //y2=7.585
cc_3457 ( N_noxref_10_c_3628_n N_VDD_c_11904_n ) capacitor c=0.0136705f \
 //x=39.09 //y=5.56 //x2=39.445 //y2=7.585
cc_3458 ( N_noxref_10_c_3602_n N_VDD_c_12070_n ) capacitor c=0.00180737f \
 //x=39.855 //y=5.38 //x2=40.325 //y2=7.585
cc_3459 ( N_noxref_10_c_3746_n N_VDD_c_12070_n ) capacitor c=0.00208087f \
 //x=40.365 //y=5.38 //x2=40.325 //y2=7.585
cc_3460 ( N_noxref_10_c_3753_n N_VDD_c_12070_n ) capacitor c=4.23719e-19 \
 //x=39.97 //y=5.38 //x2=40.325 //y2=7.585
cc_3461 ( N_noxref_10_c_3754_n N_VDD_c_12070_n ) capacitor c=5.77976e-19 \
 //x=39.97 //y=5.56 //x2=40.325 //y2=7.585
cc_3462 ( N_noxref_10_c_3862_p N_VDD_c_12070_n ) capacitor c=0.0136705f \
 //x=39.97 //y=5.56 //x2=40.325 //y2=7.585
cc_3463 ( N_noxref_10_M110_noxref_g N_VDD_c_12075_n ) capacitor c=0.00755544f \
 //x=47.59 //y=6.2 //x2=48.165 //y2=7.585
cc_3464 ( N_noxref_10_M111_noxref_g N_VDD_c_12075_n ) capacitor c=0.00755754f \
 //x=48.03 //y=6.2 //x2=48.165 //y2=7.585
cc_3465 ( N_noxref_10_c_3711_n N_VDD_c_11851_n ) capacitor c=0.00224736f \
 //x=31.57 //y=4.88 //x2=33.05 //y2=7.585
cc_3466 ( N_noxref_10_c_3742_n N_VDD_c_11851_n ) capacitor c=2.63786e-19 \
 //x=31.57 //y=4.88 //x2=33.05 //y2=7.585
cc_3467 ( N_noxref_10_c_3608_n N_VDD_c_11909_n ) capacitor c=0.0013228f \
 //x=40.45 //y=5.295 //x2=37.86 //y2=7.585
cc_3468 ( N_noxref_10_c_3611_n N_VDD_c_11909_n ) capacitor c=4.91377e-19 \
 //x=39.09 //y=5.56 //x2=37.86 //y2=7.585
cc_3469 ( N_noxref_10_c_3624_n N_VDD_c_11909_n ) capacitor c=0.00224736f \
 //x=36.38 //y=4.88 //x2=37.86 //y2=7.585
cc_3470 ( N_noxref_10_c_3628_n N_VDD_c_11909_n ) capacitor c=0.0064135f \
 //x=39.09 //y=5.56 //x2=37.86 //y2=7.585
cc_3471 ( N_noxref_10_c_3660_n N_VDD_c_11909_n ) capacitor c=2.63786e-19 \
 //x=36.38 //y=4.88 //x2=37.86 //y2=7.585
cc_3472 ( N_noxref_10_c_3608_n N_VDD_c_11979_n ) capacitor c=0.029072f \
 //x=40.45 //y=5.295 //x2=41.19 //y2=7.585
cc_3473 ( N_noxref_10_c_3753_n N_VDD_c_11979_n ) capacitor c=0.00240948f \
 //x=39.97 //y=5.38 //x2=41.19 //y2=7.585
cc_3474 ( N_noxref_10_c_3754_n N_VDD_c_11979_n ) capacitor c=4.09141e-19 \
 //x=39.97 //y=5.56 //x2=41.19 //y2=7.585
cc_3475 ( N_noxref_10_c_3862_p N_VDD_c_11979_n ) capacitor c=0.0101861f \
 //x=39.97 //y=5.56 //x2=41.19 //y2=7.585
cc_3476 ( N_noxref_10_c_3768_p N_VDD_c_12088_n ) capacitor c=0.00224736f \
 //x=47.85 //y=4.88 //x2=49.33 //y2=7.585
cc_3477 ( N_noxref_10_c_3797_p N_VDD_c_12088_n ) capacitor c=2.63786e-19 \
 //x=47.85 //y=4.88 //x2=49.33 //y2=7.585
cc_3478 ( N_noxref_10_M90_noxref_g N_VDD_M89_noxref_d ) capacitor c=0.015318f \
 //x=31.31 //y=6.2 //x2=30.945 //y2=5.2
cc_3479 ( N_noxref_10_M91_noxref_g N_VDD_M91_noxref_d ) capacitor c=0.0394719f \
 //x=31.75 //y=6.2 //x2=31.825 //y2=5.2
cc_3480 ( N_noxref_10_M96_noxref_g N_VDD_M95_noxref_d ) capacitor c=0.015318f \
 //x=36.12 //y=6.2 //x2=35.755 //y2=5.2
cc_3481 ( N_noxref_10_M97_noxref_g N_VDD_M97_noxref_d ) capacitor c=0.0394719f \
 //x=36.56 //y=6.2 //x2=36.635 //y2=5.2
cc_3482 ( N_noxref_10_c_3611_n N_VDD_M98_noxref_s ) capacitor c=0.0611368f \
 //x=39.09 //y=5.56 //x2=38.515 //y2=5.2
cc_3483 ( N_noxref_10_c_3753_n N_VDD_M98_noxref_s ) capacitor c=6.52457e-19 \
 //x=39.97 //y=5.38 //x2=38.515 //y2=5.2
cc_3484 ( N_noxref_10_c_3628_n N_VDD_M98_noxref_s ) capacitor c=0.0887533f \
 //x=39.09 //y=5.56 //x2=38.515 //y2=5.2
cc_3485 ( N_noxref_10_c_3602_n N_VDD_M99_noxref_d ) capacitor c=0.00734094f \
 //x=39.855 //y=5.38 //x2=39.385 //y2=5.2
cc_3486 ( N_noxref_10_c_3611_n N_VDD_M99_noxref_d ) capacitor c=0.0043528f \
 //x=39.09 //y=5.56 //x2=39.385 //y2=5.2
cc_3487 ( N_noxref_10_c_3754_n N_VDD_M99_noxref_d ) capacitor c=0.0043528f \
 //x=39.97 //y=5.56 //x2=39.385 //y2=5.2
cc_3488 ( N_noxref_10_c_3628_n N_VDD_M99_noxref_d ) capacitor c=0.065554f \
 //x=39.09 //y=5.56 //x2=39.385 //y2=5.2
cc_3489 ( N_noxref_10_c_3862_p N_VDD_M99_noxref_d ) capacitor c=0.065554f \
 //x=39.97 //y=5.56 //x2=39.385 //y2=5.2
cc_3490 ( N_noxref_10_c_3746_n N_VDD_M101_noxref_d ) capacitor c=0.00898356f \
 //x=40.365 //y=5.38 //x2=40.265 //y2=5.2
cc_3491 ( N_noxref_10_c_3754_n N_VDD_M101_noxref_d ) capacitor c=0.00587834f \
 //x=39.97 //y=5.56 //x2=40.265 //y2=5.2
cc_3492 ( N_noxref_10_c_3849_p N_VDD_M101_noxref_d ) capacitor c=0.00122238f \
 //x=40.45 //y=3.88 //x2=40.265 //y2=5.2
cc_3493 ( N_noxref_10_c_3862_p N_VDD_M101_noxref_d ) capacitor c=0.065554f \
 //x=39.97 //y=5.56 //x2=40.265 //y2=5.2
cc_3494 ( N_noxref_10_c_3746_n N_VDD_M102_noxref_s ) capacitor c=0.00326953f \
 //x=40.365 //y=5.38 //x2=41.845 //y2=5.2
cc_3495 ( N_noxref_10_c_3753_n N_VDD_M102_noxref_s ) capacitor c=0.00515461f \
 //x=39.97 //y=5.38 //x2=41.845 //y2=5.2
cc_3496 ( N_noxref_10_c_3754_n N_VDD_M102_noxref_s ) capacitor c=3.28075e-19 \
 //x=39.97 //y=5.56 //x2=41.845 //y2=5.2
cc_3497 ( N_noxref_10_M110_noxref_g N_VDD_M109_noxref_d ) capacitor \
 c=0.015318f //x=47.59 //y=6.2 //x2=47.225 //y2=5.2
cc_3498 ( N_noxref_10_M111_noxref_g N_VDD_M111_noxref_d ) capacitor \
 c=0.0394719f //x=48.03 //y=6.2 //x2=48.105 //y2=5.2
cc_3499 ( N_noxref_10_c_3663_n N_noxref_27_c_13156_n ) capacitor c=0.00177186f \
 //x=31.57 //y=2.375 //x2=32.225 //y2=0.72
cc_3500 ( N_noxref_10_c_3710_n N_noxref_27_c_13156_n ) capacitor c=0.00117306f \
 //x=31.57 //y=2.26 //x2=32.225 //y2=0.72
cc_3501 ( N_noxref_10_c_3721_n N_noxref_27_c_13156_n ) capacitor c=0.0206349f \
 //x=31.56 //y=1.095 //x2=32.225 //y2=0.72
cc_3502 ( N_noxref_10_c_3733_n N_noxref_27_c_13156_n ) capacitor c=0.00825432f \
 //x=32.09 //y=1.095 //x2=32.225 //y2=0.72
cc_3503 ( N_noxref_10_c_3739_n N_noxref_27_c_13156_n ) capacitor c=2.20712e-19 \
 //x=31.57 //y=2.26 //x2=32.225 //y2=0.72
cc_3504 ( N_noxref_10_c_3723_n N_noxref_27_c_13159_n ) capacitor c=0.0071177f \
 //x=31.56 //y=1.44 //x2=31.34 //y2=1.175
cc_3505 ( N_noxref_10_c_3721_n N_noxref_27_M19_noxref_s ) capacitor \
 c=0.0071177f //x=31.56 //y=1.095 //x2=31.205 //y2=0.555
cc_3506 ( N_noxref_10_c_3726_n N_noxref_27_M19_noxref_s ) capacitor \
 c=0.0071177f //x=31.56 //y=1.75 //x2=31.205 //y2=0.555
cc_3507 ( N_noxref_10_c_3733_n N_noxref_27_M19_noxref_s ) capacitor \
 c=0.015333f //x=32.09 //y=1.095 //x2=31.205 //y2=0.555
cc_3508 ( N_noxref_10_c_3735_n N_noxref_27_M19_noxref_s ) capacitor \
 c=0.00248746f //x=32.09 //y=1.44 //x2=31.205 //y2=0.555
cc_3509 ( N_noxref_10_c_3586_n N_noxref_28_c_13222_n ) capacitor c=0.00177186f \
 //x=36.38 //y=2.375 //x2=37.035 //y2=0.72
cc_3510 ( N_noxref_10_c_3623_n N_noxref_28_c_13222_n ) capacitor c=0.00117306f \
 //x=36.38 //y=2.26 //x2=37.035 //y2=0.72
cc_3511 ( N_noxref_10_c_3639_n N_noxref_28_c_13222_n ) capacitor c=0.0206349f \
 //x=36.37 //y=1.095 //x2=37.035 //y2=0.72
cc_3512 ( N_noxref_10_c_3651_n N_noxref_28_c_13222_n ) capacitor c=0.00825432f \
 //x=36.9 //y=1.095 //x2=37.035 //y2=0.72
cc_3513 ( N_noxref_10_c_3657_n N_noxref_28_c_13222_n ) capacitor c=2.20712e-19 \
 //x=36.38 //y=2.26 //x2=37.035 //y2=0.72
cc_3514 ( N_noxref_10_c_3641_n N_noxref_28_c_13225_n ) capacitor c=0.0071177f \
 //x=36.37 //y=1.44 //x2=36.15 //y2=1.175
cc_3515 ( N_noxref_10_c_3594_n N_noxref_28_M22_noxref_s ) capacitor \
 c=9.75621e-19 //x=36.38 //y=4.025 //x2=36.015 //y2=0.555
cc_3516 ( N_noxref_10_c_3639_n N_noxref_28_M22_noxref_s ) capacitor \
 c=0.0071177f //x=36.37 //y=1.095 //x2=36.015 //y2=0.555
cc_3517 ( N_noxref_10_c_3644_n N_noxref_28_M22_noxref_s ) capacitor \
 c=0.0071177f //x=36.37 //y=1.75 //x2=36.015 //y2=0.555
cc_3518 ( N_noxref_10_c_3651_n N_noxref_28_M22_noxref_s ) capacitor \
 c=0.015333f //x=36.9 //y=1.095 //x2=36.015 //y2=0.555
cc_3519 ( N_noxref_10_c_3653_n N_noxref_28_M22_noxref_s ) capacitor \
 c=0.00248746f //x=36.9 //y=1.44 //x2=36.015 //y2=0.555
cc_3520 ( N_noxref_10_c_3783_p N_noxref_29_c_13291_n ) capacitor c=0.00177186f \
 //x=47.85 //y=2.375 //x2=48.505 //y2=0.72
cc_3521 ( N_noxref_10_c_3785_p N_noxref_29_c_13291_n ) capacitor c=0.00117306f \
 //x=47.85 //y=2.26 //x2=48.505 //y2=0.72
cc_3522 ( N_noxref_10_c_3770_p N_noxref_29_c_13291_n ) capacitor c=0.0206349f \
 //x=47.84 //y=1.095 //x2=48.505 //y2=0.72
cc_3523 ( N_noxref_10_c_3774_p N_noxref_29_c_13291_n ) capacitor c=0.00825432f \
 //x=48.37 //y=1.095 //x2=48.505 //y2=0.72
cc_3524 ( N_noxref_10_c_3786_p N_noxref_29_c_13291_n ) capacitor c=2.20712e-19 \
 //x=47.85 //y=2.26 //x2=48.505 //y2=0.72
cc_3525 ( N_noxref_10_c_3771_p N_noxref_29_c_13296_n ) capacitor c=0.0071177f \
 //x=47.84 //y=1.44 //x2=47.62 //y2=1.175
cc_3526 ( N_noxref_10_c_3762_p N_noxref_29_M29_noxref_s ) capacitor \
 c=9.72448e-19 //x=47.85 //y=4.045 //x2=47.485 //y2=0.555
cc_3527 ( N_noxref_10_c_3770_p N_noxref_29_M29_noxref_s ) capacitor \
 c=0.0071177f //x=47.84 //y=1.095 //x2=47.485 //y2=0.555
cc_3528 ( N_noxref_10_c_3777_p N_noxref_29_M29_noxref_s ) capacitor \
 c=0.0071177f //x=47.84 //y=1.75 //x2=47.485 //y2=0.555
cc_3529 ( N_noxref_10_c_3774_p N_noxref_29_M29_noxref_s ) capacitor \
 c=0.015333f //x=48.37 //y=1.095 //x2=47.485 //y2=0.555
cc_3530 ( N_noxref_10_c_3775_p N_noxref_29_M29_noxref_s ) capacitor \
 c=0.00248746f //x=48.37 //y=1.44 //x2=47.485 //y2=0.555
cc_3531 ( N_noxref_10_c_3663_n N_GND_c_14198_n ) capacitor c=0.00196498f \
 //x=31.57 //y=2.375 //x2=34.04 //y2=0.175
cc_3532 ( N_noxref_10_c_3586_n N_GND_c_14155_n ) capacitor c=0.00196498f \
 //x=36.38 //y=2.375 //x2=38.955 //y2=0.175
cc_3533 ( N_noxref_10_c_3747_n N_GND_c_14284_n ) capacitor c=0.00608539f \
 //x=40.365 //y=1.835 //x2=42.285 //y2=0.175
cc_3534 ( N_noxref_10_c_3619_n N_GND_c_14284_n ) capacitor c=0.00915339f \
 //x=40.01 //y=1.18 //x2=42.285 //y2=0.175
cc_3535 ( N_noxref_10_M24_noxref_d N_GND_c_14284_n ) capacitor c=3.01769e-19 \
 //x=39.82 //y=1.085 //x2=42.285 //y2=0.175
cc_3536 ( N_noxref_10_c_3783_p N_GND_c_14287_n ) capacitor c=0.00196498f \
 //x=47.85 //y=2.375 //x2=50.425 //y2=0.175
cc_3537 ( N_noxref_10_c_3611_n N_GND_c_14159_n ) capacitor c=7.42819e-19 \
 //x=39.09 //y=5.56 //x2=39.04 //y2=1.135
cc_3538 ( N_noxref_10_c_3619_n N_GND_c_14159_n ) capacitor c=0.0140211f \
 //x=40.01 //y=1.18 //x2=39.04 //y2=1.135
cc_3539 ( N_noxref_10_M24_noxref_d N_GND_c_14159_n ) capacitor c=2.93544e-19 \
 //x=39.82 //y=1.085 //x2=39.04 //y2=1.135
cc_3540 ( N_noxref_10_c_3619_n N_GND_c_14203_n ) capacitor c=0.00549186f \
 //x=40.01 //y=1.18 //x2=42.37 //y2=1.135
cc_3541 ( N_noxref_10_c_3663_n N_GND_c_14116_n ) capacitor c=2.016e-19 \
 //x=31.57 //y=2.375 //x2=32.88 //y2=0.175
cc_3542 ( N_noxref_10_c_3586_n N_GND_c_14117_n ) capacitor c=2.016e-19 \
 //x=36.38 //y=2.375 //x2=37.69 //y2=0.175
cc_3543 ( N_noxref_10_c_3747_n N_GND_c_14175_n ) capacitor c=7.77585e-19 \
 //x=40.365 //y=1.835 //x2=41.02 //y2=0.175
cc_3544 ( N_noxref_10_c_3783_p N_GND_c_14258_n ) capacitor c=2.016e-19 \
 //x=47.85 //y=2.375 //x2=49.16 //y2=0.175
cc_3545 ( N_noxref_10_c_3710_n N_GND_c_14132_n ) capacitor c=0.00216084f \
 //x=31.57 //y=2.26 //x2=33.05 //y2=0.175
cc_3546 ( N_noxref_10_c_3735_n N_GND_c_14132_n ) capacitor c=0.00262688f \
 //x=32.09 //y=1.44 //x2=33.05 //y2=0.175
cc_3547 ( N_noxref_10_c_3739_n N_GND_c_14132_n ) capacitor c=2.63786e-19 \
 //x=31.57 //y=2.26 //x2=33.05 //y2=0.175
cc_3548 ( N_noxref_10_c_3605_n N_GND_c_14176_n ) capacitor c=9.32616e-19 \
 //x=40.45 //y=3.705 //x2=37.86 //y2=0.175
cc_3549 ( N_noxref_10_c_3623_n N_GND_c_14176_n ) capacitor c=0.00222376f \
 //x=36.38 //y=2.26 //x2=37.86 //y2=0.175
cc_3550 ( N_noxref_10_c_3653_n N_GND_c_14176_n ) capacitor c=0.00262688f \
 //x=36.9 //y=1.44 //x2=37.86 //y2=0.175
cc_3551 ( N_noxref_10_c_3603_n N_GND_c_14189_n ) capacitor c=0.002973f \
 //x=40.01 //y=1.75 //x2=41.19 //y2=0.175
cc_3552 ( N_noxref_10_c_3747_n N_GND_c_14189_n ) capacitor c=0.028425f \
 //x=40.365 //y=1.835 //x2=41.19 //y2=0.175
cc_3553 ( N_noxref_10_c_3785_p N_GND_c_14304_n ) capacitor c=0.00222376f \
 //x=47.85 //y=2.26 //x2=49.33 //y2=0.175
cc_3554 ( N_noxref_10_c_3775_p N_GND_c_14304_n ) capacitor c=0.00262688f \
 //x=48.37 //y=1.44 //x2=49.33 //y2=0.175
cc_3555 ( N_noxref_10_c_3786_p N_GND_c_14304_n ) capacitor c=2.63786e-19 \
 //x=47.85 //y=2.26 //x2=49.33 //y2=0.175
cc_3556 ( N_noxref_10_c_3619_n N_GND_M23_noxref_d ) capacitor c=2.82748e-19 \
 //x=40.01 //y=1.18 //x2=38.85 //y2=1.045
cc_3557 ( N_noxref_10_c_3604_n N_noxref_46_c_16166_n ) capacitor c=0.00911405f \
 //x=40.095 //y=1.835 //x2=39.525 //y2=1.675
cc_3558 ( N_noxref_10_c_3747_n N_noxref_46_c_16171_n ) capacitor c=0.00399245f \
 //x=40.365 //y=1.835 //x2=40.41 //y2=0.71
cc_3559 ( N_noxref_10_c_3619_n N_noxref_46_c_16171_n ) capacitor c=0.003751f \
 //x=40.01 //y=1.18 //x2=40.41 //y2=0.71
cc_3560 ( N_noxref_10_M24_noxref_d N_noxref_46_c_16171_n ) capacitor \
 c=0.00910163f //x=39.82 //y=1.085 //x2=40.41 //y2=0.71
cc_3561 ( N_noxref_10_c_3603_n N_noxref_46_M23_noxref_s ) capacitor c=0.01625f \
 //x=40.01 //y=1.75 //x2=38.42 //y2=0.545
cc_3562 ( N_noxref_10_c_3747_n N_noxref_46_M23_noxref_s ) capacitor \
 c=0.00670006f //x=40.365 //y=1.835 //x2=38.42 //y2=0.545
cc_3563 ( N_noxref_10_c_3684_n N_noxref_46_M23_noxref_s ) capacitor \
 c=3.24398e-19 //x=40.45 //y=4.025 //x2=38.42 //y2=0.545
cc_3564 ( N_noxref_10_c_3619_n N_noxref_46_M23_noxref_s ) capacitor \
 c=0.00905337f //x=40.01 //y=1.18 //x2=38.42 //y2=0.545
cc_3565 ( N_noxref_10_c_3849_p N_noxref_46_M23_noxref_s ) capacitor \
 c=8.42257e-19 //x=40.45 //y=3.88 //x2=38.42 //y2=0.545
cc_3566 ( N_noxref_10_M24_noxref_d N_noxref_46_M23_noxref_s ) capacitor \
 c=0.0275552f //x=39.82 //y=1.085 //x2=38.42 //y2=0.545
cc_3567 ( N_noxref_11_c_4299_n D ) capacitor c=0.0117045f //x=48.59 //y=4.075 \
 //x2=50.44 //y2=3.88
cc_3568 ( N_noxref_11_c_4304_n D ) capacitor c=0.00353345f //x=48.59 //y=4.395 \
 //x2=50.44 //y2=3.88
cc_3569 ( N_noxref_11_c_4305_n D ) capacitor c=0.00312554f //x=48.59 //y=5.25 \
 //x2=50.44 //y2=3.88
cc_3570 ( N_noxref_11_c_4317_n D ) capacitor c=0.0022461f //x=48.065 //y=4.27 \
 //x2=50.44 //y2=3.88
cc_3571 ( N_noxref_11_c_4293_n N_D_c_5181_n ) capacitor c=0.0024124f //x=48.59 \
 //y=2.625 //x2=50.44 //y2=2.995
cc_3572 ( N_noxref_11_c_4298_n N_D_c_5181_n ) capacitor c=0.00254429f \
 //x=48.59 //y=2.945 //x2=50.44 //y2=2.995
cc_3573 ( N_noxref_11_c_4299_n N_D_c_5181_n ) capacitor c=7.874e-19 //x=48.59 \
 //y=4.075 //x2=50.44 //y2=2.995
cc_3574 ( N_noxref_11_c_4339_p N_D_c_5181_n ) capacitor c=0.0225257f \
 //x=51.095 //y=2.77 //x2=50.44 //y2=2.995
cc_3575 ( N_noxref_11_c_4340_p N_D_c_5181_n ) capacitor c=0.00243037f \
 //x=51.18 //y=3.055 //x2=50.44 //y2=2.995
cc_3576 ( N_noxref_11_c_4320_n N_D_c_5181_n ) capacitor c=0.0012577f \
 //x=48.745 //y=2.785 //x2=50.44 //y2=2.995
cc_3577 ( N_noxref_11_c_4299_n N_D_c_5207_n ) capacitor c=0.00262144f \
 //x=48.59 //y=4.075 //x2=50.44 //y2=3.315
cc_3578 ( N_noxref_11_c_4339_p N_D_c_5207_n ) capacitor c=0.00700192f \
 //x=51.095 //y=2.77 //x2=50.44 //y2=3.315
cc_3579 ( N_noxref_11_c_4340_p N_D_c_5207_n ) capacitor c=0.001948f //x=51.18 \
 //y=3.055 //x2=50.44 //y2=3.315
cc_3580 ( N_noxref_11_c_4345_p N_D_c_5207_n ) capacitor c=2.5289e-19 \
 //x=51.265 //y=3.14 //x2=50.44 //y2=3.315
cc_3581 ( N_noxref_11_c_4293_n N_D_c_5211_n ) capacitor c=0.00344372f \
 //x=48.59 //y=2.625 //x2=50.44 //y2=2.26
cc_3582 ( N_noxref_11_c_4305_n N_D_c_5212_n ) capacitor c=0.00476843f \
 //x=48.59 //y=5.25 //x2=50.44 //y2=4.88
cc_3583 ( N_noxref_11_c_4159_n N_D_c_5138_n ) capacitor c=0.0239156f //x=43.04 \
 //y=4.105 //x2=43.39 //y2=3.14
cc_3584 ( N_noxref_11_c_4298_n N_D_c_5196_n ) capacitor c=0.00133301f \
 //x=48.59 //y=2.945 //x2=48.2 //y2=3.14
cc_3585 ( N_noxref_11_c_4299_n N_D_c_5196_n ) capacitor c=6.15995e-19 \
 //x=48.59 //y=4.075 //x2=48.2 //y2=3.14
cc_3586 ( N_noxref_11_c_4317_n N_D_c_5196_n ) capacitor c=0.00294713f \
 //x=48.065 //y=4.27 //x2=48.2 //y2=3.14
cc_3587 ( N_noxref_11_c_4320_n N_D_c_5196_n ) capacitor c=0.0358254f \
 //x=48.745 //y=2.785 //x2=48.2 //y2=3.14
cc_3588 ( N_noxref_11_c_4298_n N_D_c_5218_n ) capacitor c=0.0075229f //x=48.59 \
 //y=2.945 //x2=48.8 //y2=3.17
cc_3589 ( N_noxref_11_c_4299_n N_D_c_5218_n ) capacitor c=0.0236934f //x=48.59 \
 //y=4.075 //x2=48.8 //y2=3.17
cc_3590 ( N_noxref_11_c_4339_p N_D_c_5218_n ) capacitor c=0.169565f //x=51.095 \
 //y=2.77 //x2=48.8 //y2=3.17
cc_3591 ( N_noxref_11_c_4340_p N_D_c_5218_n ) capacitor c=0.0119385f //x=51.18 \
 //y=3.055 //x2=48.8 //y2=3.17
cc_3592 ( N_noxref_11_c_4357_p N_D_c_5218_n ) capacitor c=3.36983e-19 \
 //x=51.535 //y=3.14 //x2=48.8 //y2=3.17
cc_3593 ( N_noxref_11_c_4217_n N_noxref_13_c_5556_n ) capacitor c=0.00326079f \
 //x=48.105 //y=1.76 //x2=51.48 //y2=1.75
cc_3594 ( N_noxref_11_c_4291_n N_noxref_13_c_5557_n ) capacitor c=0.00218808f \
 //x=48.505 //y=1.845 //x2=51.565 //y2=1.835
cc_3595 ( N_noxref_11_c_4291_n N_noxref_13_c_5558_n ) capacitor c=0.00203766f \
 //x=48.505 //y=1.845 //x2=51.92 //y2=2.61
cc_3596 ( N_noxref_11_c_4339_p N_noxref_13_c_5559_n ) capacitor c=0.00235471f \
 //x=51.095 //y=2.77 //x2=51.92 //y2=2.93
cc_3597 ( N_noxref_11_c_4357_p N_noxref_13_c_5559_n ) capacitor c=0.0015398f \
 //x=51.535 //y=3.14 //x2=51.92 //y2=2.93
cc_3598 ( N_noxref_11_c_4363_p N_noxref_13_c_5559_n ) capacitor c=0.00956883f \
 //x=52.135 //y=3.155 //x2=51.92 //y2=2.93
cc_3599 ( N_noxref_11_c_4305_n N_noxref_13_c_5562_n ) capacitor c=0.0028534f \
 //x=48.59 //y=5.25 //x2=51.92 //y2=5.295
cc_3600 ( N_noxref_11_c_4340_p N_noxref_13_c_5562_n ) capacitor c=0.00284831f \
 //x=51.18 //y=3.055 //x2=51.92 //y2=5.295
cc_3601 ( N_noxref_11_c_4357_p N_noxref_13_c_5562_n ) capacitor c=3.16346e-19 \
 //x=51.535 //y=3.14 //x2=51.92 //y2=5.295
cc_3602 ( N_noxref_11_c_4363_p N_noxref_13_c_5562_n ) capacitor c=0.0226562f \
 //x=52.135 //y=3.155 //x2=51.92 //y2=5.295
cc_3603 ( N_noxref_11_c_4368_p N_noxref_13_c_5566_n ) capacitor c=0.00179019f \
 //x=53.385 //y=3.14 //x2=53.77 //y2=2.93
cc_3604 ( N_noxref_11_c_4369_p N_noxref_13_c_5566_n ) capacitor c=0.00693044f \
 //x=53.985 //y=3.155 //x2=53.77 //y2=2.93
cc_3605 ( N_noxref_11_c_4368_p N_noxref_13_c_5568_n ) capacitor c=5.02803e-19 \
 //x=53.385 //y=3.14 //x2=53.77 //y2=4.755
cc_3606 ( N_noxref_11_c_4369_p N_noxref_13_c_5568_n ) capacitor c=0.0239409f \
 //x=53.985 //y=3.155 //x2=53.77 //y2=4.755
cc_3607 ( N_noxref_11_c_4372_p N_noxref_13_c_5570_n ) capacitor c=0.00515354f \
 //x=58.195 //y=3.14 //x2=58.58 //y2=2.935
cc_3608 ( N_noxref_11_c_4373_p N_noxref_13_c_5570_n ) capacitor c=0.00356853f \
 //x=58.795 //y=3.16 //x2=58.58 //y2=2.935
cc_3609 ( N_noxref_11_c_4372_p N_noxref_13_c_5572_n ) capacitor c=6.2418e-19 \
 //x=58.195 //y=3.14 //x2=58.58 //y2=4.755
cc_3610 ( N_noxref_11_c_4373_p N_noxref_13_c_5572_n ) capacitor c=0.0242471f \
 //x=58.795 //y=3.16 //x2=58.58 //y2=4.755
cc_3611 ( N_noxref_11_c_4274_n N_noxref_13_c_5574_n ) capacitor c=5.58535e-19 \
 //x=47.81 //y=5.56 //x2=50.56 //y2=5.56
cc_3612 ( N_noxref_11_c_4276_n N_noxref_13_c_5574_n ) capacitor c=0.00104762f \
 //x=48.505 //y=5.335 //x2=50.56 //y2=5.56
cc_3613 ( N_noxref_11_c_4280_n N_noxref_13_c_5576_n ) capacitor c=6.5615e-19 \
 //x=48.105 //y=1.305 //x2=51.48 //y2=1.18
cc_3614 ( N_noxref_11_c_4363_p N_noxref_13_c_5577_n ) capacitor c=0.12796f \
 //x=52.135 //y=3.155 //x2=53.61 //y2=2.77
cc_3615 ( N_noxref_11_c_4368_p N_noxref_13_c_5577_n ) capacitor c=0.011979f \
 //x=53.385 //y=3.14 //x2=53.61 //y2=2.77
cc_3616 ( N_noxref_11_c_4339_p N_noxref_13_c_5579_n ) capacitor c=0.0129247f \
 //x=51.095 //y=2.77 //x2=52.08 //y2=2.77
cc_3617 ( N_noxref_11_c_4357_p N_noxref_13_c_5579_n ) capacitor c=0.0358254f \
 //x=51.535 //y=3.14 //x2=52.08 //y2=2.77
cc_3618 ( N_noxref_11_c_4368_p N_noxref_13_c_5581_n ) capacitor c=0.0358254f \
 //x=53.385 //y=3.14 //x2=53.93 //y2=2.77
cc_3619 ( N_noxref_11_c_4372_p N_noxref_13_c_5582_n ) capacitor c=0.0358254f \
 //x=58.195 //y=3.14 //x2=58.58 //y2=2.775
cc_3620 ( N_noxref_11_c_4369_p N_noxref_13_c_5583_n ) capacitor c=0.378965f \
 //x=53.985 //y=3.155 //x2=58.42 //y2=2.775
cc_3621 ( N_noxref_11_c_4372_p N_noxref_13_c_5583_n ) capacitor c=0.0107141f \
 //x=58.195 //y=3.14 //x2=58.42 //y2=2.775
cc_3622 ( N_noxref_11_c_4387_p N_noxref_14_c_5985_n ) capacitor c=0.00152841f \
 //x=61.155 //y=3.14 //x2=61.54 //y2=2.945
cc_3623 ( N_noxref_11_c_4388_p N_noxref_14_c_5985_n ) capacitor c=0.0101369f \
 //x=61.755 //y=3.17 //x2=61.54 //y2=2.945
cc_3624 ( N_noxref_11_c_4387_p N_noxref_14_c_5987_n ) capacitor c=6.2241e-19 \
 //x=61.155 //y=3.14 //x2=61.54 //y2=5.25
cc_3625 ( N_noxref_11_c_4388_p N_noxref_14_c_5987_n ) capacitor c=0.0225285f \
 //x=61.755 //y=3.17 //x2=61.54 //y2=5.25
cc_3626 ( N_noxref_11_c_4391_p N_noxref_14_c_5987_n ) capacitor c=2.04029e-19 \
 //x=63 //y=3.14 //x2=61.54 //y2=5.25
cc_3627 ( N_noxref_11_c_4391_p N_noxref_14_c_5990_n ) capacitor c=0.00485454f \
 //x=63 //y=3.14 //x2=63.39 //y2=2.945
cc_3628 ( N_noxref_11_c_4393_p N_noxref_14_c_5990_n ) capacitor c=0.00267318f \
 //x=63.6 //y=3.17 //x2=63.39 //y2=2.945
cc_3629 ( N_noxref_11_c_4388_p N_noxref_14_c_5992_n ) capacitor c=2.03225e-19 \
 //x=61.755 //y=3.17 //x2=63.392 //y2=4.74
cc_3630 ( N_noxref_11_c_4391_p N_noxref_14_c_5992_n ) capacitor c=9.97486e-19 \
 //x=63 //y=3.14 //x2=63.392 //y2=4.74
cc_3631 ( N_noxref_11_c_4393_p N_noxref_14_c_5992_n ) capacitor c=0.0221534f \
 //x=63.6 //y=3.17 //x2=63.392 //y2=4.74
cc_3632 ( N_noxref_11_c_4387_p N_noxref_14_c_5995_n ) capacitor c=0.0358254f \
 //x=61.155 //y=3.14 //x2=61.7 //y2=2.785
cc_3633 ( N_noxref_11_c_4391_p N_noxref_14_c_5996_n ) capacitor c=0.0358254f \
 //x=63 //y=3.14 //x2=63.385 //y2=2.785
cc_3634 ( N_noxref_11_c_4388_p N_noxref_14_c_5997_n ) capacitor c=0.127486f \
 //x=61.755 //y=3.17 //x2=63.225 //y2=2.785
cc_3635 ( N_noxref_11_c_4391_p N_noxref_14_c_5997_n ) capacitor c=0.0105193f \
 //x=63 //y=3.14 //x2=63.225 //y2=2.785
cc_3636 ( N_noxref_11_c_4369_p CLK ) capacitor c=4.9496e-19 //x=53.985 \
 //y=3.155 //x2=54.88 //y2=3.88
cc_3637 ( N_noxref_11_c_4372_p CLK ) capacitor c=0.023535f //x=58.195 //y=3.14 \
 //x2=54.88 //y2=3.88
cc_3638 ( N_noxref_11_c_4393_p CLK ) capacitor c=0.0239076f //x=63.6 //y=3.17 \
 //x2=64.13 //y2=2.77
cc_3639 ( N_noxref_11_c_4161_n N_CLK_c_6660_n ) capacitor c=0.00495455f \
 //x=43.04 //y=4.425 //x2=43.245 //y2=4.65
cc_3640 ( N_noxref_11_c_4164_n N_CLK_c_6660_n ) capacitor c=0.0267838f \
 //x=43.04 //y=4.735 //x2=43.245 //y2=4.65
cc_3641 ( N_noxref_11_c_4227_n N_CLK_c_6660_n ) capacitor c=0.397118f \
 //x=47.465 //y=4.25 //x2=43.245 //y2=4.65
cc_3642 ( N_noxref_11_c_4173_n N_CLK_c_6660_n ) capacitor c=0.036523f \
 //x=43.19 //y=4.265 //x2=43.245 //y2=4.65
cc_3643 ( N_noxref_11_c_4198_n N_CLK_c_6660_n ) capacitor c=5.51291e-19 \
 //x=43.07 //y=4.88 //x2=43.245 //y2=4.65
cc_3644 ( N_noxref_11_c_4276_n N_CLK_c_6683_n ) capacitor c=0.0195611f \
 //x=48.505 //y=5.335 //x2=50.795 //y2=4.62
cc_3645 ( N_noxref_11_c_4304_n N_CLK_c_6683_n ) capacitor c=0.00536827f \
 //x=48.59 //y=4.395 //x2=50.795 //y2=4.62
cc_3646 ( N_noxref_11_c_4305_n N_CLK_c_6683_n ) capacitor c=0.0294091f \
 //x=48.59 //y=5.25 //x2=50.795 //y2=4.62
cc_3647 ( N_noxref_11_c_4221_n N_CLK_c_6683_n ) capacitor c=0.0297774f \
 //x=46.052 //y=5.335 //x2=50.795 //y2=4.62
cc_3648 ( N_noxref_11_c_4413_p N_CLK_c_6683_n ) capacitor c=0.0379688f \
 //x=46.93 //y=5.335 //x2=50.795 //y2=4.62
cc_3649 ( N_noxref_11_c_4227_n N_CLK_c_6683_n ) capacitor c=0.059199f \
 //x=47.465 //y=4.25 //x2=50.795 //y2=4.62
cc_3650 ( N_noxref_11_c_4317_n N_CLK_c_6683_n ) capacitor c=0.060088f \
 //x=48.065 //y=4.27 //x2=50.795 //y2=4.62
cc_3651 ( N_noxref_11_c_4339_p N_CLK_c_6683_n ) capacitor c=6.05116e-19 \
 //x=51.095 //y=2.77 //x2=50.795 //y2=4.62
cc_3652 ( N_noxref_11_c_4293_n N_noxref_16_c_7276_n ) capacitor c=4.66127e-19 \
 //x=48.59 //y=2.625 //x2=51.18 //y2=4.085
cc_3653 ( N_noxref_11_c_4299_n N_noxref_16_c_7276_n ) capacitor c=0.00164288f \
 //x=48.59 //y=4.075 //x2=51.18 //y2=4.085
cc_3654 ( N_noxref_11_c_4339_p N_noxref_16_c_7276_n ) capacitor c=0.0145019f \
 //x=51.095 //y=2.77 //x2=51.18 //y2=4.085
cc_3655 ( N_noxref_11_c_4340_p N_noxref_16_c_7276_n ) capacitor c=0.0103166f \
 //x=51.18 //y=3.055 //x2=51.18 //y2=4.085
cc_3656 ( N_noxref_11_c_4357_p N_noxref_16_c_7276_n ) capacitor c=3.16156e-19 \
 //x=51.535 //y=3.14 //x2=51.18 //y2=4.085
cc_3657 ( N_noxref_11_c_4345_p N_noxref_16_c_7276_n ) capacitor c=0.0143092f \
 //x=51.265 //y=3.14 //x2=51.18 //y2=4.085
cc_3658 ( N_noxref_11_c_4305_n N_noxref_16_c_7282_n ) capacitor c=7.44542e-19 \
 //x=48.59 //y=5.25 //x2=51.18 //y2=4.735
cc_3659 ( N_noxref_11_c_4372_p N_noxref_16_c_7283_n ) capacitor c=0.0236395f \
 //x=58.195 //y=3.14 //x2=56.73 //y2=4.09
cc_3660 ( N_noxref_11_c_4393_p N_noxref_16_c_7284_n ) capacitor c=0.0259425f \
 //x=63.6 //y=3.17 //x2=66.72 //y2=4.105
cc_3661 ( N_noxref_11_c_4311_n N_noxref_16_c_7285_n ) capacitor c=3.60181e-19 \
 //x=48.59 //y=4.25 //x2=51.18 //y2=4.25
cc_3662 ( N_noxref_11_c_4357_p N_noxref_16_c_7286_n ) capacitor c=0.00461801f \
 //x=51.535 //y=3.14 //x2=56.565 //y2=4.25
cc_3663 ( N_noxref_11_c_4363_p N_noxref_16_c_7286_n ) capacitor c=0.00618755f \
 //x=52.135 //y=3.155 //x2=56.565 //y2=4.25
cc_3664 ( N_noxref_11_c_4368_p N_noxref_16_c_7286_n ) capacitor c=0.00245741f \
 //x=53.385 //y=3.14 //x2=56.565 //y2=4.25
cc_3665 ( N_noxref_11_c_4369_p N_noxref_16_c_7286_n ) capacitor c=0.0117661f \
 //x=53.985 //y=3.155 //x2=56.565 //y2=4.25
cc_3666 ( N_noxref_11_c_4317_n N_noxref_16_c_7290_n ) capacitor c=0.00172831f \
 //x=48.065 //y=4.27 //x2=51.34 //y2=4.245
cc_3667 ( N_noxref_11_c_4393_p N_noxref_17_c_7773_n ) capacitor c=0.0260296f \
 //x=63.6 //y=3.17 //x2=68.2 //y2=4.87
cc_3668 ( N_noxref_11_c_4393_p N_noxref_17_c_7774_n ) capacitor c=0.027452f \
 //x=63.6 //y=3.17 //x2=70.05 //y2=4.755
cc_3669 ( N_noxref_11_c_4373_p SN ) capacitor c=4.03048e-19 //x=58.795 \
 //y=3.16 //x2=59.69 //y2=2.77
cc_3670 ( N_noxref_11_c_4387_p SN ) capacitor c=0.0258143f //x=61.155 //y=3.14 \
 //x2=59.69 //y2=2.77
cc_3671 ( N_noxref_11_c_4216_n N_SN_c_8360_n ) capacitor c=4.04373e-19 \
 //x=46.81 //y=5.335 //x2=46.74 //y2=2.55
cc_3672 ( N_noxref_11_c_4413_p N_SN_c_8360_n ) capacitor c=3.78118e-19 \
 //x=46.93 //y=5.335 //x2=46.74 //y2=2.55
cc_3673 ( N_noxref_11_c_4216_n N_SN_c_8364_n ) capacitor c=0.0213631f \
 //x=46.81 //y=5.335 //x2=46.74 //y2=4.765
cc_3674 ( N_noxref_11_c_4299_n N_SN_c_8364_n ) capacitor c=0.00173572f \
 //x=48.59 //y=4.075 //x2=46.74 //y2=4.765
cc_3675 ( N_noxref_11_c_4305_n N_SN_c_8364_n ) capacitor c=4.809e-19 //x=48.59 \
 //y=5.25 //x2=46.74 //y2=4.765
cc_3676 ( N_noxref_11_c_4413_p N_SN_c_8364_n ) capacitor c=0.00239361f \
 //x=46.93 //y=5.335 //x2=46.74 //y2=4.765
cc_3677 ( N_noxref_11_c_4227_n N_SN_c_8364_n ) capacitor c=0.0240612f \
 //x=47.465 //y=4.25 //x2=46.74 //y2=4.765
cc_3678 ( N_noxref_11_c_4443_p N_SN_c_8364_n ) capacitor c=7.85344e-19 \
 //x=46.93 //y=5.56 //x2=46.74 //y2=4.765
cc_3679 ( N_noxref_11_c_4387_p N_SN_c_8500_n ) capacitor c=0.00222448f \
 //x=61.155 //y=3.14 //x2=59.69 //y2=2.55
cc_3680 ( N_noxref_11_c_4393_p N_SN_c_8501_n ) capacitor c=0.00222448f \
 //x=63.6 //y=3.17 //x2=71.16 //y2=2.55
cc_3681 ( N_noxref_11_c_4393_p N_SN_c_8502_n ) capacitor c=0.0257959f //x=63.6 \
 //y=3.17 //x2=71.16 //y2=4.765
cc_3682 ( N_noxref_11_c_4159_n N_SN_c_8324_n ) capacitor c=0.0140246f \
 //x=43.04 //y=4.105 //x2=46.57 //y2=2.4
cc_3683 ( N_noxref_11_c_4168_n N_SN_c_8324_n ) capacitor c=0.0170109f \
 //x=43.04 //y=2.26 //x2=46.57 //y2=2.4
cc_3684 ( N_noxref_11_c_4195_n N_SN_c_8324_n ) capacitor c=2.98635e-19 \
 //x=43.04 //y=2.26 //x2=46.57 //y2=2.4
cc_3685 ( N_noxref_11_c_4363_p N_SN_c_8506_n ) capacitor c=0.00793317f \
 //x=52.135 //y=3.155 //x2=52.135 //y2=2.385
cc_3686 ( N_noxref_11_c_4280_n N_SN_c_8385_n ) capacitor c=7.09459e-19 \
 //x=48.105 //y=1.305 //x2=51.705 //y2=2.385
cc_3687 ( N_noxref_11_c_4218_n N_SN_c_8385_n ) capacitor c=0.0209481f \
 //x=48.19 //y=1.845 //x2=51.705 //y2=2.385
cc_3688 ( N_noxref_11_c_4293_n N_SN_c_8385_n ) capacitor c=0.0271978f \
 //x=48.59 //y=2.625 //x2=51.705 //y2=2.385
cc_3689 ( N_noxref_11_c_4298_n N_SN_c_8385_n ) capacitor c=0.0058313f \
 //x=48.59 //y=2.945 //x2=51.705 //y2=2.385
cc_3690 ( N_noxref_11_c_4339_p N_SN_c_8385_n ) capacitor c=0.227342f \
 //x=51.095 //y=2.77 //x2=51.705 //y2=2.385
cc_3691 ( N_noxref_11_c_4357_p N_SN_c_8385_n ) capacitor c=0.0207518f \
 //x=51.535 //y=3.14 //x2=51.705 //y2=2.385
cc_3692 ( N_noxref_11_c_4320_n N_SN_c_8385_n ) capacitor c=0.0365231f \
 //x=48.745 //y=2.785 //x2=51.705 //y2=2.385
cc_3693 ( N_noxref_11_c_4368_p N_SN_c_8514_n ) capacitor c=0.00528191f \
 //x=53.385 //y=3.14 //x2=53.385 //y2=2.4
cc_3694 ( N_noxref_11_c_4369_p N_SN_c_8515_n ) capacitor c=0.0149645f \
 //x=53.985 //y=3.155 //x2=53.985 //y2=2.385
cc_3695 ( N_noxref_11_c_4372_p N_SN_c_8516_n ) capacitor c=0.0176182f \
 //x=58.195 //y=3.14 //x2=58.195 //y2=2.4
cc_3696 ( N_noxref_11_c_4373_p N_SN_c_8517_n ) capacitor c=0.00444087f \
 //x=58.795 //y=3.16 //x2=58.795 //y2=2.39
cc_3697 ( N_noxref_11_c_4373_p N_SN_c_8518_n ) capacitor c=0.0322598f \
 //x=58.795 //y=3.16 //x2=59.85 //y2=2.4
cc_3698 ( N_noxref_11_c_4387_p N_SN_c_8518_n ) capacitor c=0.0156796f \
 //x=61.155 //y=3.14 //x2=59.85 //y2=2.4
cc_3699 ( N_noxref_11_c_4393_p N_SN_c_8520_n ) capacitor c=0.0156796f //x=63.6 \
 //y=3.17 //x2=71.15 //y2=2.39
cc_3700 ( N_noxref_11_c_4387_p N_SN_c_8521_n ) capacitor c=0.0733104f \
 //x=61.155 //y=3.14 //x2=70.99 //y2=2.39
cc_3701 ( N_noxref_11_c_4388_p N_SN_c_8521_n ) capacitor c=0.00667543f \
 //x=61.755 //y=3.17 //x2=70.99 //y2=2.39
cc_3702 ( N_noxref_11_c_4391_p N_SN_c_8521_n ) capacitor c=0.00888094f //x=63 \
 //y=3.14 //x2=70.99 //y2=2.39
cc_3703 ( N_noxref_11_c_4393_p N_SN_c_8521_n ) capacitor c=0.331336f //x=63.6 \
 //y=3.17 //x2=70.99 //y2=2.39
cc_3704 ( N_noxref_11_c_4216_n N_SN_c_8390_n ) capacitor c=0.00492634f \
 //x=46.81 //y=5.335 //x2=46.74 //y2=4.88
cc_3705 ( N_noxref_11_c_4413_p N_SN_c_8390_n ) capacitor c=0.00132214f \
 //x=46.93 //y=5.335 //x2=46.74 //y2=4.88
cc_3706 ( N_noxref_11_c_4216_n N_SN_M108_noxref_g ) capacitor c=0.00858241f \
 //x=46.81 //y=5.335 //x2=46.71 //y2=6.2
cc_3707 ( N_noxref_11_c_4413_p N_SN_M108_noxref_g ) capacitor c=0.00229818f \
 //x=46.93 //y=5.335 //x2=46.71 //y2=6.2
cc_3708 ( N_noxref_11_c_4443_p N_SN_M108_noxref_g ) capacitor c=0.0179041f \
 //x=46.93 //y=5.56 //x2=46.71 //y2=6.2
cc_3709 ( N_noxref_11_c_4272_n N_SN_M109_noxref_g ) capacitor c=0.00955829f \
 //x=47.695 //y=5.335 //x2=47.15 //y2=6.2
cc_3710 ( N_noxref_11_c_4413_p N_SN_M109_noxref_g ) capacitor c=0.00230699f \
 //x=46.93 //y=5.335 //x2=47.15 //y2=6.2
cc_3711 ( N_noxref_11_c_4443_p N_SN_M109_noxref_g ) capacitor c=0.0179041f \
 //x=46.93 //y=5.56 //x2=47.15 //y2=6.2
cc_3712 ( N_noxref_11_c_4413_p N_SN_c_8483_n ) capacitor c=0.00177039f \
 //x=46.93 //y=5.335 //x2=47.075 //y2=4.97
cc_3713 ( N_noxref_11_c_4443_p N_SN_c_8483_n ) capacitor c=0.00290085f \
 //x=46.93 //y=5.56 //x2=47.075 //y2=4.97
cc_3714 ( N_noxref_11_c_4216_n N_SN_c_8408_n ) capacitor c=6.14744e-19 \
 //x=46.81 //y=5.335 //x2=46.74 //y2=4.88
cc_3715 ( N_noxref_11_c_4372_p N_noxref_19_c_9261_n ) capacitor c=0.0217878f \
 //x=58.195 //y=3.14 //x2=55.99 //y2=3.705
cc_3716 ( N_noxref_11_c_4387_p N_noxref_19_c_9262_n ) capacitor c=0.02494f \
 //x=61.155 //y=3.14 //x2=60.8 //y2=3.705
cc_3717 ( N_noxref_11_c_4393_p N_noxref_19_c_9263_n ) capacitor c=0.0256788f \
 //x=63.6 //y=3.17 //x2=64.87 //y2=3.705
cc_3718 ( N_noxref_11_c_4393_p N_noxref_19_c_9264_n ) capacitor c=0.00229495f \
 //x=63.6 //y=3.17 //x2=72.27 //y2=2.375
cc_3719 ( N_noxref_11_c_4393_p N_noxref_19_c_9265_n ) capacitor c=0.0263535f \
 //x=63.6 //y=3.17 //x2=72.27 //y2=3.725
cc_3720 ( N_noxref_11_c_4372_p N_noxref_19_c_9266_n ) capacitor c=0.0060755f \
 //x=58.195 //y=3.14 //x2=56.34 //y2=3.88
cc_3721 ( N_noxref_11_c_4372_p N_noxref_19_c_9267_n ) capacitor c=0.0124018f \
 //x=58.195 //y=3.14 //x2=60.96 //y2=3.88
cc_3722 ( N_noxref_11_c_4373_p N_noxref_19_c_9267_n ) capacitor c=0.0149083f \
 //x=58.795 //y=3.16 //x2=60.96 //y2=3.88
cc_3723 ( N_noxref_11_c_4387_p N_noxref_19_c_9269_n ) capacitor c=0.00672419f \
 //x=61.155 //y=3.14 //x2=64.705 //y2=3.865
cc_3724 ( N_noxref_11_c_4388_p N_noxref_19_c_9269_n ) capacitor c=0.00883326f \
 //x=61.755 //y=3.17 //x2=64.705 //y2=3.865
cc_3725 ( N_noxref_11_c_4391_p N_noxref_19_c_9269_n ) capacitor c=0.00429414f \
 //x=63 //y=3.14 //x2=64.705 //y2=3.865
cc_3726 ( N_noxref_11_c_4393_p N_noxref_19_c_9269_n ) capacitor c=0.00805915f \
 //x=63.6 //y=3.17 //x2=64.705 //y2=3.865
cc_3727 ( N_noxref_11_c_4393_p N_noxref_19_c_9273_n ) capacitor c=0.0524884f \
 //x=63.6 //y=3.17 //x2=72.11 //y2=3.885
cc_3728 ( N_noxref_11_c_4393_p N_noxref_20_c_9843_n ) capacitor c=0.0232802f \
 //x=63.6 //y=3.17 //x2=67.46 //y2=4.48
cc_3729 ( N_noxref_11_c_4393_p N_noxref_20_c_9844_n ) capacitor c=4.31296e-19 \
 //x=63.6 //y=3.17 //x2=72.525 //y2=1.305
cc_3730 ( N_noxref_11_c_4393_p N_noxref_20_c_9845_n ) capacitor c=0.0111399f \
 //x=63.6 //y=3.17 //x2=72.61 //y2=1.845
cc_3731 ( N_noxref_11_c_4496_p N_noxref_20_c_9846_n ) capacitor c=0.00144557f \
 //x=75.6 //y=2.965 //x2=73.01 //y2=4.455
cc_3732 ( N_noxref_11_c_4497_p N_noxref_20_c_9846_n ) capacitor c=8.42002e-19 \
 //x=75.6 //y=4.045 //x2=73.01 //y2=4.455
cc_3733 ( N_noxref_11_c_4393_p N_noxref_20_c_9846_n ) capacitor c=0.0285401f \
 //x=63.6 //y=3.17 //x2=73.01 //y2=4.455
cc_3734 ( N_noxref_11_c_4499_p N_noxref_20_c_9849_n ) capacitor c=0.00151908f \
 //x=75.6 //y=4.71 //x2=73.01 //y2=5.25
cc_3735 ( N_noxref_11_c_4500_p N_noxref_20_c_9850_n ) capacitor c=0.0110499f \
 //x=75.6 //y=2.375 //x2=74.49 //y2=2.375
cc_3736 ( N_noxref_11_c_4393_p N_noxref_20_c_9850_n ) capacitor c=0.0026766f \
 //x=63.6 //y=3.17 //x2=74.49 //y2=2.375
cc_3737 ( N_noxref_11_c_4502_p N_noxref_20_c_9850_n ) capacitor c=4.56604e-19 \
 //x=75.6 //y=2.26 //x2=74.49 //y2=2.375
cc_3738 ( N_noxref_11_c_4503_p N_noxref_20_c_9850_n ) capacitor c=0.00130136f \
 //x=75.6 //y=2.26 //x2=74.49 //y2=2.375
cc_3739 ( N_noxref_11_c_4496_p N_noxref_20_c_9854_n ) capacitor c=0.0162212f \
 //x=75.6 //y=2.965 //x2=74.49 //y2=4.46
cc_3740 ( N_noxref_11_c_4505_p N_noxref_20_c_9854_n ) capacitor c=0.00784585f \
 //x=75.6 //y=3.285 //x2=74.49 //y2=4.46
cc_3741 ( N_noxref_11_c_4497_p N_noxref_20_c_9854_n ) capacitor c=0.0206649f \
 //x=75.6 //y=4.045 //x2=74.49 //y2=4.46
cc_3742 ( N_noxref_11_c_4507_p N_noxref_20_c_9854_n ) capacitor c=0.00784519f \
 //x=75.6 //y=4.365 //x2=74.49 //y2=4.46
cc_3743 ( N_noxref_11_c_4499_p N_noxref_20_c_9854_n ) capacitor c=0.00234897f \
 //x=75.6 //y=4.71 //x2=74.49 //y2=4.46
cc_3744 ( N_noxref_11_c_4509_p N_noxref_20_c_9854_n ) capacitor c=5.01652e-19 \
 //x=75.6 //y=3.14 //x2=74.49 //y2=4.46
cc_3745 ( N_noxref_11_c_4510_p N_noxref_20_c_9854_n ) capacitor c=5.51775e-19 \
 //x=75.6 //y=4.25 //x2=74.49 //y2=4.46
cc_3746 ( N_noxref_11_c_4393_p N_noxref_20_c_9854_n ) capacitor c=0.030646f \
 //x=63.6 //y=3.17 //x2=74.49 //y2=4.46
cc_3747 ( N_noxref_11_c_4512_p N_noxref_20_c_9854_n ) capacitor c=0.00529413f \
 //x=75.76 //y=4.205 //x2=74.49 //y2=4.46
cc_3748 ( N_noxref_11_c_4502_p N_noxref_20_c_9854_n ) capacitor c=4.16726e-19 \
 //x=75.6 //y=2.26 //x2=74.49 //y2=4.46
cc_3749 ( N_noxref_11_c_4500_p N_noxref_20_c_9864_n ) capacitor c=0.00273775f \
 //x=75.6 //y=2.375 //x2=78.19 //y2=2.385
cc_3750 ( N_noxref_11_c_4496_p N_noxref_20_c_9865_n ) capacitor c=0.0068529f \
 //x=75.6 //y=2.965 //x2=78.19 //y2=4.475
cc_3751 ( N_noxref_11_c_4505_p N_noxref_20_c_9865_n ) capacitor c=0.00246047f \
 //x=75.6 //y=3.285 //x2=78.19 //y2=4.475
cc_3752 ( N_noxref_11_c_4497_p N_noxref_20_c_9865_n ) capacitor c=0.00845489f \
 //x=75.6 //y=4.045 //x2=78.19 //y2=4.475
cc_3753 ( N_noxref_11_c_4507_p N_noxref_20_c_9865_n ) capacitor c=0.00149249f \
 //x=75.6 //y=4.365 //x2=78.19 //y2=4.475
cc_3754 ( N_noxref_11_c_4499_p N_noxref_20_c_9865_n ) capacitor c=0.00106529f \
 //x=75.6 //y=4.71 //x2=78.19 //y2=4.475
cc_3755 ( N_noxref_11_c_4393_p N_noxref_20_c_9865_n ) capacitor c=0.00226742f \
 //x=63.6 //y=3.17 //x2=78.19 //y2=4.475
cc_3756 ( N_noxref_11_c_4512_p N_noxref_20_c_9865_n ) capacitor c=0.00110824f \
 //x=75.76 //y=4.205 //x2=78.19 //y2=4.475
cc_3757 ( N_noxref_11_c_4522_p N_noxref_20_c_9865_n ) capacitor c=0.0280836f \
 //x=82.115 //y=4.21 //x2=78.19 //y2=4.475
cc_3758 ( N_noxref_11_c_4499_p N_noxref_20_c_9873_n ) capacitor c=0.0101017f \
 //x=75.6 //y=4.71 //x2=74.49 //y2=4.62
cc_3759 ( N_noxref_11_c_4524_p N_noxref_20_c_9873_n ) capacitor c=2.84639e-19 \
 //x=75.64 //y=4.885 //x2=74.49 //y2=4.62
cc_3760 ( N_noxref_11_c_4499_p N_noxref_20_c_9875_n ) capacitor c=0.00146299f \
 //x=75.6 //y=4.71 //x2=78.19 //y2=4.62
cc_3761 ( N_noxref_11_c_4522_p N_noxref_20_c_9875_n ) capacitor c=0.0102464f \
 //x=82.115 //y=4.21 //x2=78.19 //y2=4.62
cc_3762 ( N_noxref_11_c_4393_p N_noxref_20_c_9877_n ) capacitor c=0.00419331f \
 //x=63.6 //y=3.17 //x2=74.335 //y2=4.62
cc_3763 ( N_noxref_11_c_4499_p N_noxref_20_c_9878_n ) capacitor c=0.00282565f \
 //x=75.6 //y=4.71 //x2=74.655 //y2=4.62
cc_3764 ( N_noxref_11_c_4393_p N_noxref_20_c_9879_n ) capacitor c=0.00231677f \
 //x=63.6 //y=3.17 //x2=72.845 //y2=4.615
cc_3765 ( N_noxref_11_c_4499_p N_noxref_20_c_9880_n ) capacitor c=0.00206738f \
 //x=75.6 //y=4.71 //x2=78.195 //y2=4.64
cc_3766 ( N_noxref_11_c_4522_p N_noxref_20_c_9880_n ) capacitor c=0.0369071f \
 //x=82.115 //y=4.21 //x2=78.195 //y2=4.64
cc_3767 ( N_noxref_11_c_4507_p N_noxref_20_c_9882_n ) capacitor c=0.00452722f \
 //x=75.6 //y=4.365 //x2=78.035 //y2=4.64
cc_3768 ( N_noxref_11_c_4499_p N_noxref_20_c_9882_n ) capacitor c=0.0312701f \
 //x=75.6 //y=4.71 //x2=78.035 //y2=4.64
cc_3769 ( N_noxref_11_c_4393_p N_noxref_20_c_9882_n ) capacitor c=0.0036911f \
 //x=63.6 //y=3.17 //x2=78.035 //y2=4.64
cc_3770 ( N_noxref_11_c_4512_p N_noxref_20_c_9882_n ) capacitor c=0.0336481f \
 //x=75.76 //y=4.205 //x2=78.035 //y2=4.64
cc_3771 ( N_noxref_11_c_4522_p N_noxref_20_c_9882_n ) capacitor c=0.208741f \
 //x=82.115 //y=4.21 //x2=78.035 //y2=4.64
cc_3772 ( N_noxref_11_c_4500_p N_noxref_20_c_9887_n ) capacitor c=0.00353903f \
 //x=75.6 //y=2.375 //x2=74.49 //y2=2.26
cc_3773 ( N_noxref_11_c_4496_p N_noxref_20_c_9887_n ) capacitor c=4.16726e-19 \
 //x=75.6 //y=2.965 //x2=74.49 //y2=2.26
cc_3774 ( N_noxref_11_c_4502_p N_noxref_20_c_9887_n ) capacitor c=0.00113699f \
 //x=75.6 //y=2.26 //x2=74.49 //y2=2.26
cc_3775 ( N_noxref_11_c_4503_p N_noxref_20_c_9887_n ) capacitor c=0.00191372f \
 //x=75.6 //y=2.26 //x2=74.49 //y2=2.26
cc_3776 ( N_noxref_11_c_4499_p N_noxref_20_c_9891_n ) capacitor c=0.00670492f \
 //x=75.6 //y=4.71 //x2=74.49 //y2=4.62
cc_3777 ( N_noxref_11_c_4542_p N_noxref_20_c_9891_n ) capacitor c=0.00133991f \
 //x=75.64 //y=4.885 //x2=74.49 //y2=4.62
cc_3778 ( N_noxref_11_c_4524_p N_noxref_20_c_9891_n ) capacitor c=0.00197201f \
 //x=75.64 //y=4.885 //x2=74.49 //y2=4.62
cc_3779 ( N_noxref_11_M144_noxref_g N_noxref_20_M142_noxref_g ) capacitor \
 c=0.0106808f //x=75.64 //y=6.205 //x2=74.76 //y2=6.205
cc_3780 ( N_noxref_11_M144_noxref_g N_noxref_20_M143_noxref_g ) capacitor \
 c=0.108153f //x=75.64 //y=6.205 //x2=75.2 //y2=6.205
cc_3781 ( N_noxref_11_M145_noxref_g N_noxref_20_M143_noxref_g ) capacitor \
 c=0.0103194f //x=76.08 //y=6.205 //x2=75.2 //y2=6.205
cc_3782 ( N_noxref_11_c_4547_p N_noxref_20_c_9897_n ) capacitor c=4.86545e-19 \
 //x=75.635 //y=1.085 //x2=74.665 //y2=1.045
cc_3783 ( N_noxref_11_c_4547_p N_noxref_20_c_9898_n ) capacitor c=0.00152405f \
 //x=75.635 //y=1.085 //x2=74.665 //y2=1.39
cc_3784 ( N_noxref_11_c_4549_p N_noxref_20_c_9899_n ) capacitor c=0.00109982f \
 //x=75.635 //y=1.43 //x2=74.665 //y2=1.7
cc_3785 ( N_noxref_11_c_4550_p N_noxref_20_c_9899_n ) capacitor c=0.00179029f \
 //x=75.635 //y=1.74 //x2=74.665 //y2=1.7
cc_3786 ( N_noxref_11_c_4550_p N_noxref_20_c_9901_n ) capacitor c=0.00662747f \
 //x=75.635 //y=1.74 //x2=74.665 //y2=2.095
cc_3787 ( N_noxref_11_c_4499_p N_noxref_20_c_9902_n ) capacitor c=0.00117926f \
 //x=75.6 //y=4.71 //x2=75.125 //y2=4.975
cc_3788 ( N_noxref_11_c_4542_p N_noxref_20_c_9902_n ) capacitor c=0.00122675f \
 //x=75.64 //y=4.885 //x2=75.125 //y2=4.975
cc_3789 ( N_noxref_11_c_4524_p N_noxref_20_c_9902_n ) capacitor c=0.0203213f \
 //x=75.64 //y=4.885 //x2=75.125 //y2=4.975
cc_3790 ( N_noxref_11_c_4499_p N_noxref_20_c_9905_n ) capacitor c=0.00104403f \
 //x=75.6 //y=4.71 //x2=74.835 //y2=4.975
cc_3791 ( N_noxref_11_c_4542_p N_noxref_20_c_9905_n ) capacitor c=0.00114302f \
 //x=75.64 //y=4.885 //x2=74.835 //y2=4.975
cc_3792 ( N_noxref_11_c_4524_p N_noxref_20_c_9905_n ) capacitor c=0.00427779f \
 //x=75.64 //y=4.885 //x2=74.835 //y2=4.975
cc_3793 ( N_noxref_11_c_4547_p N_noxref_20_c_9908_n ) capacitor c=0.0151475f \
 //x=75.635 //y=1.085 //x2=75.195 //y2=1.045
cc_3794 ( N_noxref_11_c_4559_p N_noxref_20_c_9908_n ) capacitor c=0.00124846f \
 //x=76.165 //y=1.085 //x2=75.195 //y2=1.045
cc_3795 ( N_noxref_11_c_4549_p N_noxref_20_c_9910_n ) capacitor c=0.0111064f \
 //x=75.635 //y=1.43 //x2=75.195 //y2=1.39
cc_3796 ( N_noxref_11_c_4550_p N_noxref_20_c_9910_n ) capacitor c=0.00862358f \
 //x=75.635 //y=1.74 //x2=75.195 //y2=1.39
cc_3797 ( N_noxref_11_c_4562_p N_noxref_20_c_9910_n ) capacitor c=0.00161183f \
 //x=76.165 //y=1.43 //x2=75.195 //y2=1.39
cc_3798 ( N_noxref_11_c_4500_p N_noxref_20_c_9913_n ) capacitor c=0.00140055f \
 //x=75.6 //y=2.375 //x2=74.49 //y2=2.26
cc_3799 ( N_noxref_11_c_4502_p N_noxref_20_c_9913_n ) capacitor c=0.00201914f \
 //x=75.6 //y=2.26 //x2=74.49 //y2=2.26
cc_3800 ( N_noxref_11_c_4503_p N_noxref_20_c_9913_n ) capacitor c=0.00949697f \
 //x=75.6 //y=2.26 //x2=74.49 //y2=2.26
cc_3801 ( N_noxref_11_c_4522_p N_noxref_21_c_10636_n ) capacitor c=7.0928e-19 \
 //x=82.115 //y=4.21 //x2=79.67 //y2=2.43
cc_3802 ( N_noxref_11_c_4496_p N_noxref_21_c_10637_n ) capacitor c=9.36391e-19 \
 //x=75.6 //y=2.965 //x2=79.67 //y2=3.355
cc_3803 ( N_noxref_11_c_4568_p N_noxref_21_c_10637_n ) capacitor c=0.00166576f \
 //x=82.26 //y=4.05 //x2=79.67 //y2=3.355
cc_3804 ( N_noxref_11_c_4522_p N_noxref_21_c_10639_n ) capacitor c=0.00317492f \
 //x=82.115 //y=4.21 //x2=79.67 //y2=3.675
cc_3805 ( N_noxref_11_c_4499_p N_noxref_21_c_10640_n ) capacitor c=0.00166637f \
 //x=75.6 //y=4.71 //x2=79.67 //y2=4.76
cc_3806 ( N_noxref_11_c_4568_p N_noxref_21_c_10640_n ) capacitor c=2.72459e-19 \
 //x=82.26 //y=4.05 //x2=79.67 //y2=4.76
cc_3807 ( N_noxref_11_c_4572_p N_noxref_21_c_10640_n ) capacitor c=9.13182e-19 \
 //x=82.26 //y=4.74 //x2=79.67 //y2=4.76
cc_3808 ( N_noxref_11_c_4522_p N_noxref_21_c_10640_n ) capacitor c=0.0357488f \
 //x=82.115 //y=4.21 //x2=79.67 //y2=4.76
cc_3809 ( N_noxref_11_c_4574_p N_noxref_21_c_10644_n ) capacitor c=0.0061363f \
 //x=82.26 //y=2.38 //x2=81.15 //y2=2.43
cc_3810 ( N_noxref_11_c_4568_p N_noxref_21_c_10644_n ) capacitor c=0.0011922f \
 //x=82.26 //y=4.05 //x2=81.15 //y2=2.43
cc_3811 ( N_noxref_11_c_4522_p N_noxref_21_c_10644_n ) capacitor c=0.00231693f \
 //x=82.115 //y=4.21 //x2=81.15 //y2=2.43
cc_3812 ( N_noxref_11_c_4577_p N_noxref_21_c_10644_n ) capacitor c=7.58956e-19 \
 //x=82.26 //y=2.26 //x2=81.15 //y2=2.43
cc_3813 ( N_noxref_11_c_4578_p N_noxref_21_c_10644_n ) capacitor c=0.00157228f \
 //x=82.26 //y=2.26 //x2=81.15 //y2=2.43
cc_3814 ( N_noxref_11_c_4568_p N_noxref_21_c_10649_n ) capacitor c=0.0502818f \
 //x=82.26 //y=4.05 //x2=81.15 //y2=4.755
cc_3815 ( N_noxref_11_c_4580_p N_noxref_21_c_10649_n ) capacitor c=0.00771726f \
 //x=82.26 //y=4.37 //x2=81.15 //y2=4.755
cc_3816 ( N_noxref_11_c_4572_p N_noxref_21_c_10649_n ) capacitor c=0.021848f \
 //x=82.26 //y=4.74 //x2=81.15 //y2=4.755
cc_3817 ( N_noxref_11_c_4582_p N_noxref_21_c_10649_n ) capacitor c=5.15538e-19 \
 //x=82.26 //y=4.25 //x2=81.15 //y2=4.755
cc_3818 ( N_noxref_11_c_4583_p N_noxref_21_c_10649_n ) capacitor c=0.00250167f \
 //x=82.275 //y=4.21 //x2=81.15 //y2=4.755
cc_3819 ( N_noxref_11_c_4522_p N_noxref_21_c_10649_n ) capacitor c=0.0387859f \
 //x=82.115 //y=4.21 //x2=81.15 //y2=4.755
cc_3820 ( N_noxref_11_c_4585_p N_noxref_21_c_10649_n ) capacitor c=2.02321e-19 \
 //x=82.28 //y=4.885 //x2=81.15 //y2=4.755
cc_3821 ( N_noxref_11_c_4586_p N_noxref_21_c_10649_n ) capacitor c=0.00132485f \
 //x=82.28 //y=4.885 //x2=81.15 //y2=4.755
cc_3822 ( N_noxref_11_c_4159_n N_noxref_21_c_10606_n ) capacitor c=0.0206271f \
 //x=43.04 //y=4.105 //x2=47.465 //y2=3.51
cc_3823 ( N_noxref_11_c_4227_n N_noxref_21_c_10606_n ) capacitor c=0.0366834f \
 //x=47.465 //y=4.25 //x2=47.465 //y2=3.51
cc_3824 ( N_noxref_11_c_4299_n N_noxref_21_c_10633_n ) capacitor c=7.06471e-19 \
 //x=48.59 //y=4.075 //x2=48.065 //y2=3.495
cc_3825 ( N_noxref_11_c_4317_n N_noxref_21_c_10633_n ) capacitor c=0.01514f \
 //x=48.065 //y=4.27 //x2=48.065 //y2=3.495
cc_3826 ( N_noxref_11_c_4299_n N_noxref_21_c_10661_n ) capacitor c=0.0254167f \
 //x=48.59 //y=4.075 //x2=50.045 //y2=3.51
cc_3827 ( N_noxref_11_c_4304_n N_noxref_21_c_10661_n ) capacitor c=0.00315939f \
 //x=48.59 //y=4.395 //x2=50.045 //y2=3.51
cc_3828 ( N_noxref_11_c_4317_n N_noxref_21_c_10661_n ) capacitor c=0.0162263f \
 //x=48.065 //y=4.27 //x2=50.045 //y2=3.51
cc_3829 ( N_noxref_11_c_4339_p N_noxref_21_c_10661_n ) capacitor c=0.0161344f \
 //x=51.095 //y=2.77 //x2=50.045 //y2=3.51
cc_3830 ( N_noxref_11_c_4339_p N_noxref_21_c_10665_n ) capacitor c=0.0162668f \
 //x=51.095 //y=2.77 //x2=50.645 //y2=3.54
cc_3831 ( N_noxref_11_c_4357_p N_noxref_21_c_10666_n ) capacitor c=0.0574506f \
 //x=51.535 //y=3.14 //x2=55.61 //y2=3.51
cc_3832 ( N_noxref_11_c_4345_p N_noxref_21_c_10666_n ) capacitor c=0.0443034f \
 //x=51.265 //y=3.14 //x2=55.61 //y2=3.51
cc_3833 ( N_noxref_11_c_4363_p N_noxref_21_c_10666_n ) capacitor c=0.111467f \
 //x=52.135 //y=3.155 //x2=55.61 //y2=3.51
cc_3834 ( N_noxref_11_c_4368_p N_noxref_21_c_10666_n ) capacitor c=0.0578814f \
 //x=53.385 //y=3.14 //x2=55.61 //y2=3.51
cc_3835 ( N_noxref_11_c_4369_p N_noxref_21_c_10666_n ) capacitor c=0.139156f \
 //x=53.985 //y=3.155 //x2=55.61 //y2=3.51
cc_3836 ( N_noxref_11_c_4372_p N_noxref_21_c_10666_n ) capacitor c=0.0582439f \
 //x=58.195 //y=3.14 //x2=55.61 //y2=3.51
cc_3837 ( N_noxref_11_c_4372_p N_noxref_21_c_10672_n ) capacitor c=0.173837f \
 //x=58.195 //y=3.14 //x2=56.21 //y2=3.48
cc_3838 ( N_noxref_11_c_4372_p N_noxref_21_c_10673_n ) capacitor c=0.0585155f \
 //x=58.195 //y=3.14 //x2=60.415 //y2=3.51
cc_3839 ( N_noxref_11_c_4373_p N_noxref_21_c_10673_n ) capacitor c=0.138615f \
 //x=58.795 //y=3.16 //x2=60.415 //y2=3.51
cc_3840 ( N_noxref_11_c_4387_p N_noxref_21_c_10673_n ) capacitor c=0.0582276f \
 //x=61.155 //y=3.14 //x2=60.415 //y2=3.51
cc_3841 ( N_noxref_11_c_4387_p N_noxref_21_c_10676_n ) capacitor c=0.0415403f \
 //x=61.155 //y=3.14 //x2=61.015 //y2=3.48
cc_3842 ( N_noxref_11_c_4388_p N_noxref_21_c_10677_n ) capacitor c=0.140531f \
 //x=61.755 //y=3.17 //x2=64.48 //y2=3.51
cc_3843 ( N_noxref_11_c_4391_p N_noxref_21_c_10677_n ) capacitor c=0.0585881f \
 //x=63 //y=3.14 //x2=64.48 //y2=3.51
cc_3844 ( N_noxref_11_c_4393_p N_noxref_21_c_10677_n ) capacitor c=0.133918f \
 //x=63.6 //y=3.17 //x2=64.48 //y2=3.51
cc_3845 ( N_noxref_11_c_4393_p N_noxref_21_c_10680_n ) capacitor c=0.592413f \
 //x=63.6 //y=3.17 //x2=65.08 //y2=3.48
cc_3846 ( N_noxref_11_c_4393_p N_noxref_21_c_10681_n ) capacitor c=0.0586507f \
 //x=63.6 //y=3.17 //x2=71.885 //y2=3.51
cc_3847 ( N_noxref_11_c_4505_p N_noxref_21_c_10682_n ) capacitor c=0.00522677f \
 //x=75.6 //y=3.285 //x2=72.485 //y2=3.5
cc_3848 ( N_noxref_11_c_4497_p N_noxref_21_c_10682_n ) capacitor c=0.0264449f \
 //x=75.6 //y=4.045 //x2=72.485 //y2=3.5
cc_3849 ( N_noxref_11_c_4507_p N_noxref_21_c_10682_n ) capacitor c=0.00327917f \
 //x=75.6 //y=4.365 //x2=72.485 //y2=3.5
cc_3850 ( N_noxref_11_c_4393_p N_noxref_21_c_10682_n ) capacitor c=0.295361f \
 //x=63.6 //y=3.17 //x2=72.485 //y2=3.5
cc_3851 ( N_noxref_11_c_4512_p N_noxref_21_c_10682_n ) capacitor c=0.0172874f \
 //x=75.76 //y=4.205 //x2=72.485 //y2=3.5
cc_3852 ( N_noxref_11_c_4522_p N_noxref_21_c_10682_n ) capacitor c=0.185887f \
 //x=82.115 //y=4.21 //x2=72.485 //y2=3.5
cc_3853 ( N_noxref_11_c_4522_p N_noxref_21_c_10688_n ) capacitor c=5.98311e-19 \
 //x=82.115 //y=4.21 //x2=79.835 //y2=2.27
cc_3854 ( N_noxref_11_c_4574_p N_noxref_21_c_10689_n ) capacitor c=0.00602448f \
 //x=82.26 //y=2.38 //x2=81.145 //y2=2.27
cc_3855 ( N_noxref_11_c_4568_p N_noxref_21_c_10689_n ) capacitor c=0.00107415f \
 //x=82.26 //y=4.05 //x2=81.145 //y2=2.27
cc_3856 ( N_noxref_11_c_4522_p N_noxref_21_c_10689_n ) capacitor c=0.00472291f \
 //x=82.115 //y=4.21 //x2=81.145 //y2=2.27
cc_3857 ( N_noxref_11_c_4522_p N_noxref_21_c_10692_n ) capacitor c=0.0202481f \
 //x=82.115 //y=4.21 //x2=80.985 //y2=2.27
cc_3858 ( N_noxref_11_c_4574_p N_noxref_21_c_10693_n ) capacitor c=2.06418e-19 \
 //x=82.26 //y=2.38 //x2=81.15 //y2=2.26
cc_3859 ( N_noxref_11_c_4577_p N_noxref_21_c_10693_n ) capacitor c=0.00113671f \
 //x=82.26 //y=2.26 //x2=81.15 //y2=2.26
cc_3860 ( N_noxref_11_c_4578_p N_noxref_21_c_10693_n ) capacitor c=0.00194209f \
 //x=82.26 //y=2.26 //x2=81.15 //y2=2.26
cc_3861 ( N_noxref_11_c_4572_p N_noxref_21_c_10696_n ) capacitor c=8.06413e-19 \
 //x=82.26 //y=4.74 //x2=81.15 //y2=4.885
cc_3862 ( N_noxref_11_c_4585_p N_noxref_21_c_10696_n ) capacitor c=0.00106454f \
 //x=82.28 //y=4.885 //x2=81.15 //y2=4.885
cc_3863 ( N_noxref_11_c_4586_p N_noxref_21_c_10696_n ) capacitor c=0.00167042f \
 //x=82.28 //y=4.885 //x2=81.15 //y2=4.885
cc_3864 ( N_noxref_11_M152_noxref_g N_noxref_21_M150_noxref_g ) capacitor \
 c=0.00935155f //x=82.3 //y=6.205 //x2=81.42 //y2=6.205
cc_3865 ( N_noxref_11_M152_noxref_g N_noxref_21_M151_noxref_g ) capacitor \
 c=0.111828f //x=82.3 //y=6.205 //x2=81.86 //y2=6.205
cc_3866 ( N_noxref_11_M153_noxref_g N_noxref_21_M151_noxref_g ) capacitor \
 c=0.00876656f //x=82.74 //y=6.205 //x2=81.86 //y2=6.205
cc_3867 ( N_noxref_11_c_4632_p N_noxref_21_c_10702_n ) capacitor c=4.86545e-19 \
 //x=82.295 //y=1.085 //x2=81.325 //y2=1.045
cc_3868 ( N_noxref_11_c_4632_p N_noxref_21_c_10703_n ) capacitor c=0.00152405f \
 //x=82.295 //y=1.085 //x2=81.325 //y2=1.39
cc_3869 ( N_noxref_11_c_4634_p N_noxref_21_c_10704_n ) capacitor c=0.00109722f \
 //x=82.295 //y=1.435 //x2=81.325 //y2=1.7
cc_3870 ( N_noxref_11_c_4635_p N_noxref_21_c_10704_n ) capacitor c=0.00179029f \
 //x=82.295 //y=1.74 //x2=81.325 //y2=1.7
cc_3871 ( N_noxref_11_c_4635_p N_noxref_21_c_10706_n ) capacitor c=0.00662747f \
 //x=82.295 //y=1.74 //x2=81.325 //y2=2.095
cc_3872 ( N_noxref_11_c_4572_p N_noxref_21_c_10707_n ) capacitor c=0.00125146f \
 //x=82.26 //y=4.74 //x2=81.785 //y2=4.975
cc_3873 ( N_noxref_11_c_4585_p N_noxref_21_c_10707_n ) capacitor c=0.00147609f \
 //x=82.28 //y=4.885 //x2=81.785 //y2=4.975
cc_3874 ( N_noxref_11_c_4586_p N_noxref_21_c_10707_n ) capacitor c=0.022796f \
 //x=82.28 //y=4.885 //x2=81.785 //y2=4.975
cc_3875 ( N_noxref_11_c_4572_p N_noxref_21_c_10710_n ) capacitor c=0.00103195f \
 //x=82.26 //y=4.74 //x2=81.495 //y2=4.975
cc_3876 ( N_noxref_11_c_4585_p N_noxref_21_c_10710_n ) capacitor c=0.00127381f \
 //x=82.28 //y=4.885 //x2=81.495 //y2=4.975
cc_3877 ( N_noxref_11_c_4586_p N_noxref_21_c_10710_n ) capacitor c=0.00470299f \
 //x=82.28 //y=4.885 //x2=81.495 //y2=4.975
cc_3878 ( N_noxref_11_c_4632_p N_noxref_21_c_10713_n ) capacitor c=0.0151424f \
 //x=82.295 //y=1.085 //x2=81.855 //y2=1.045
cc_3879 ( N_noxref_11_c_4644_p N_noxref_21_c_10713_n ) capacitor c=0.00130607f \
 //x=82.825 //y=1.085 //x2=81.855 //y2=1.045
cc_3880 ( N_noxref_11_c_4634_p N_noxref_21_c_10715_n ) capacitor c=0.0111013f \
 //x=82.295 //y=1.435 //x2=81.855 //y2=1.39
cc_3881 ( N_noxref_11_c_4635_p N_noxref_21_c_10715_n ) capacitor c=0.00862358f \
 //x=82.295 //y=1.74 //x2=81.855 //y2=1.39
cc_3882 ( N_noxref_11_c_4647_p N_noxref_21_c_10715_n ) capacitor c=4.75927e-19 \
 //x=82.67 //y=1.585 //x2=81.855 //y2=1.39
cc_3883 ( N_noxref_11_c_4648_p N_noxref_21_c_10715_n ) capacitor c=0.00153205f \
 //x=82.825 //y=1.435 //x2=81.855 //y2=1.39
cc_3884 ( N_noxref_11_c_4574_p N_noxref_21_c_10719_n ) capacitor c=6.73725e-19 \
 //x=82.26 //y=2.38 //x2=81.15 //y2=2.26
cc_3885 ( N_noxref_11_c_4577_p N_noxref_21_c_10719_n ) capacitor c=0.00169858f \
 //x=82.26 //y=2.26 //x2=81.15 //y2=2.26
cc_3886 ( N_noxref_11_c_4578_p N_noxref_21_c_10719_n ) capacitor c=0.00887988f \
 //x=82.26 //y=2.26 //x2=81.15 //y2=2.26
cc_3887 ( N_noxref_11_c_4580_p N_noxref_22_c_11183_n ) capacitor c=0.00435926f \
 //x=82.26 //y=4.37 //x2=82.395 //y2=5.39
cc_3888 ( N_noxref_11_c_4572_p N_noxref_22_c_11183_n ) capacitor c=0.0223378f \
 //x=82.26 //y=4.74 //x2=82.395 //y2=5.39
cc_3889 ( N_noxref_11_c_4583_p N_noxref_22_c_11183_n ) capacitor c=7.70643e-19 \
 //x=82.275 //y=4.21 //x2=82.395 //y2=5.39
cc_3890 ( N_noxref_11_c_4522_p N_noxref_22_c_11183_n ) capacitor c=0.0017832f \
 //x=82.115 //y=4.21 //x2=82.395 //y2=5.39
cc_3891 ( N_noxref_11_c_4585_p N_noxref_22_c_11183_n ) capacitor c=0.00459858f \
 //x=82.28 //y=4.885 //x2=82.395 //y2=5.39
cc_3892 ( N_noxref_11_M152_noxref_g N_noxref_22_c_11183_n ) capacitor \
 c=0.00846675f //x=82.3 //y=6.205 //x2=82.395 //y2=5.39
cc_3893 ( N_noxref_11_c_4586_p N_noxref_22_c_11183_n ) capacitor c=7.28626e-19 \
 //x=82.28 //y=4.885 //x2=82.395 //y2=5.39
cc_3894 ( N_noxref_11_c_4574_p N_noxref_22_c_11190_n ) capacitor c=0.00233055f \
 //x=82.26 //y=2.38 //x2=82.56 //y2=1.535
cc_3895 ( N_noxref_11_c_4577_p N_noxref_22_c_11190_n ) capacitor c=8.15893e-19 \
 //x=82.26 //y=2.26 //x2=82.56 //y2=1.535
cc_3896 ( N_noxref_11_c_4632_p N_noxref_22_c_11190_n ) capacitor c=5.01861e-19 \
 //x=82.295 //y=1.085 //x2=82.56 //y2=1.535
cc_3897 ( N_noxref_11_c_4634_p N_noxref_22_c_11190_n ) capacitor c=0.00397521f \
 //x=82.295 //y=1.435 //x2=82.56 //y2=1.535
cc_3898 ( N_noxref_11_c_4635_p N_noxref_22_c_11190_n ) capacitor c=0.00205332f \
 //x=82.295 //y=1.74 //x2=82.56 //y2=1.535
cc_3899 ( N_noxref_11_c_4664_p N_noxref_22_c_11190_n ) capacitor c=3.72732e-19 \
 //x=82.67 //y=0.93 //x2=82.56 //y2=1.535
cc_3900 ( N_noxref_11_c_4647_p N_noxref_22_c_11190_n ) capacitor c=0.00187911f \
 //x=82.67 //y=1.585 //x2=82.56 //y2=1.535
cc_3901 ( N_noxref_11_c_4644_p N_noxref_22_c_11190_n ) capacitor c=2.0901e-19 \
 //x=82.825 //y=1.085 //x2=82.56 //y2=1.535
cc_3902 ( N_noxref_11_c_4648_p N_noxref_22_c_11190_n ) capacitor c=0.00241403f \
 //x=82.825 //y=1.435 //x2=82.56 //y2=1.535
cc_3903 ( N_noxref_11_c_4578_p N_noxref_22_c_11190_n ) capacitor c=2.48891e-19 \
 //x=82.26 //y=2.26 //x2=82.56 //y2=1.535
cc_3904 ( N_noxref_11_c_4635_p N_noxref_22_c_11200_n ) capacitor c=0.0018678f \
 //x=82.295 //y=1.74 //x2=82.56 //y2=1.74
cc_3905 ( N_noxref_11_c_4647_p N_noxref_22_c_11200_n ) capacitor c=0.00592669f \
 //x=82.67 //y=1.585 //x2=82.56 //y2=1.74
cc_3906 ( N_noxref_11_M153_noxref_g N_noxref_22_c_11202_n ) capacitor \
 c=0.0116091f //x=82.74 //y=6.205 //x2=82.915 //y2=5.39
cc_3907 ( N_noxref_11_c_4647_p N_noxref_22_c_11203_n ) capacitor c=0.0048413f \
 //x=82.67 //y=1.585 //x2=82.915 //y2=1.825
cc_3908 ( N_noxref_11_c_4673_p N_noxref_22_c_11204_n ) capacitor c=0.00368358f \
 //x=82.26 //y=2.095 //x2=82.645 //y2=1.825
cc_3909 ( N_noxref_11_c_4574_p N_noxref_22_c_11205_n ) capacitor c=0.0146548f \
 //x=82.26 //y=2.38 //x2=83 //y2=4.095
cc_3910 ( N_noxref_11_c_4568_p N_noxref_22_c_11205_n ) capacitor c=0.0756865f \
 //x=82.26 //y=4.05 //x2=83 //y2=4.095
cc_3911 ( N_noxref_11_c_4580_p N_noxref_22_c_11205_n ) capacitor c=0.0029642f \
 //x=82.26 //y=4.37 //x2=83 //y2=4.095
cc_3912 ( N_noxref_11_c_4583_p N_noxref_22_c_11205_n ) capacitor c=0.00136148f \
 //x=82.275 //y=4.21 //x2=83 //y2=4.095
cc_3913 ( N_noxref_11_c_4577_p N_noxref_22_c_11205_n ) capacitor c=0.00137695f \
 //x=82.26 //y=2.26 //x2=83 //y2=4.095
cc_3914 ( N_noxref_11_c_4578_p N_noxref_22_c_11205_n ) capacitor c=0.00284078f \
 //x=82.26 //y=2.26 //x2=83 //y2=4.095
cc_3915 ( N_noxref_11_c_4673_p N_noxref_22_c_11205_n ) capacitor c=0.00356275f \
 //x=82.26 //y=2.095 //x2=83 //y2=4.095
cc_3916 ( N_noxref_11_c_4580_p N_noxref_22_c_11212_n ) capacitor c=0.0169977f \
 //x=82.26 //y=4.37 //x2=83 //y2=4.415
cc_3917 ( N_noxref_11_c_4572_p N_noxref_22_c_11212_n ) capacitor c=0.00262509f \
 //x=82.26 //y=4.74 //x2=83 //y2=4.415
cc_3918 ( N_noxref_11_c_4582_p N_noxref_22_c_11212_n ) capacitor c=8.95907e-19 \
 //x=82.26 //y=4.25 //x2=83 //y2=4.415
cc_3919 ( N_noxref_11_c_4583_p N_noxref_22_c_11212_n ) capacitor c=0.00288053f \
 //x=82.275 //y=4.21 //x2=83 //y2=4.415
cc_3920 ( N_noxref_11_c_4572_p N_noxref_22_c_11216_n ) capacitor c=0.0305973f \
 //x=82.26 //y=4.74 //x2=83 //y2=5.305
cc_3921 ( N_noxref_11_c_4585_p N_noxref_22_c_11216_n ) capacitor c=0.00179503f \
 //x=82.28 //y=4.885 //x2=83 //y2=5.305
cc_3922 ( N_noxref_11_c_4687_p N_noxref_22_c_11216_n ) capacitor c=0.00864287f \
 //x=82.665 //y=4.975 //x2=83 //y2=5.305
cc_3923 ( N_noxref_11_c_4586_p N_noxref_22_c_11216_n ) capacitor c=0.00141883f \
 //x=82.28 //y=4.885 //x2=83 //y2=5.305
cc_3924 ( N_noxref_11_c_4568_p N_noxref_22_c_11220_n ) capacitor c=0.00300359f \
 //x=82.26 //y=4.05 //x2=84.48 //y2=4.095
cc_3925 ( N_noxref_11_c_4572_p N_noxref_22_c_11221_n ) capacitor c=0.00111022f \
 //x=82.26 //y=4.74 //x2=84.48 //y2=4.76
cc_3926 ( N_noxref_11_c_4547_p N_noxref_22_c_11222_n ) capacitor c=3.77121e-19 \
 //x=75.635 //y=1.085 //x2=75.9 //y2=1.36
cc_3927 ( N_noxref_11_c_4549_p N_noxref_22_c_11222_n ) capacitor c=0.00245317f \
 //x=75.635 //y=1.43 //x2=75.9 //y2=1.36
cc_3928 ( N_noxref_11_c_4550_p N_noxref_22_c_11222_n ) capacitor c=0.00149443f \
 //x=75.635 //y=1.74 //x2=75.9 //y2=1.36
cc_3929 ( N_noxref_11_c_4694_p N_noxref_22_c_11222_n ) capacitor c=3.38306e-19 \
 //x=76.01 //y=0.93 //x2=75.9 //y2=1.36
cc_3930 ( N_noxref_11_c_4695_p N_noxref_22_c_11222_n ) capacitor c=0.0022369f \
 //x=76.01 //y=1.585 //x2=75.9 //y2=1.36
cc_3931 ( N_noxref_11_c_4559_p N_noxref_22_c_11222_n ) capacitor c=3.16128e-19 \
 //x=76.165 //y=1.085 //x2=75.9 //y2=1.36
cc_3932 ( N_noxref_11_c_4562_p N_noxref_22_c_11222_n ) capacitor c=0.00792546f \
 //x=76.165 //y=1.43 //x2=75.9 //y2=1.36
cc_3933 ( N_noxref_11_c_4522_p N_noxref_22_c_11229_n ) capacitor c=0.0169094f \
 //x=82.115 //y=4.21 //x2=81.64 //y2=5.39
cc_3934 ( N_noxref_11_c_4583_p N_noxref_22_c_11230_n ) capacitor c=6.25661e-19 \
 //x=82.275 //y=4.21 //x2=82.517 //y2=5.39
cc_3935 ( N_noxref_11_M152_noxref_g N_noxref_22_c_11230_n ) capacitor \
 c=0.00180711f //x=82.3 //y=6.205 //x2=82.517 //y2=5.39
cc_3936 ( N_noxref_11_M153_noxref_g N_noxref_22_c_11230_n ) capacitor \
 c=0.0027483f //x=82.74 //y=6.205 //x2=82.517 //y2=5.39
cc_3937 ( N_noxref_11_c_4687_p N_noxref_22_c_11230_n ) capacitor c=0.00216603f \
 //x=82.665 //y=4.975 //x2=82.517 //y2=5.39
cc_3938 ( N_noxref_11_c_4580_p N_noxref_22_c_11234_n ) capacitor c=6.9092e-19 \
 //x=82.26 //y=4.37 //x2=83 //y2=4.25
cc_3939 ( N_noxref_11_c_4582_p N_noxref_22_c_11234_n ) capacitor c=0.0102219f \
 //x=82.26 //y=4.25 //x2=83 //y2=4.25
cc_3940 ( N_noxref_11_c_4562_p N_noxref_22_c_11236_n ) capacitor c=0.0016073f \
 //x=76.165 //y=1.43 //x2=79.1 //y2=1.405
cc_3941 ( N_noxref_11_c_4635_p N_noxref_22_c_11237_n ) capacitor c=0.00131018f \
 //x=82.295 //y=1.74 //x2=82.555 //y2=1.405
cc_3942 ( N_noxref_11_c_4647_p N_noxref_22_c_11237_n ) capacitor c=0.00184285f \
 //x=82.67 //y=1.585 //x2=82.555 //y2=1.405
cc_3943 ( N_noxref_11_c_4574_p N_noxref_22_c_11239_n ) capacitor c=0.00997796f \
 //x=82.26 //y=2.38 //x2=82.395 //y2=1.405
cc_3944 ( N_noxref_11_c_4634_p N_noxref_22_c_11239_n ) capacitor c=0.00107668f \
 //x=82.295 //y=1.435 //x2=82.395 //y2=1.405
cc_3945 ( N_noxref_11_c_4635_p N_noxref_22_c_11239_n ) capacitor c=8.64037e-19 \
 //x=82.295 //y=1.74 //x2=82.395 //y2=1.405
cc_3946 ( N_noxref_11_c_4580_p N_noxref_22_c_11242_n ) capacitor c=0.0028493f \
 //x=82.26 //y=4.37 //x2=83.16 //y2=4.255
cc_3947 ( N_noxref_11_c_4572_p N_noxref_22_c_11242_n ) capacitor c=0.00114496f \
 //x=82.26 //y=4.74 //x2=83.16 //y2=4.255
cc_3948 ( N_noxref_11_c_4583_p N_noxref_22_c_11242_n ) capacitor c=0.018987f \
 //x=82.275 //y=4.21 //x2=83.16 //y2=4.255
cc_3949 ( N_noxref_11_M152_noxref_g N_noxref_22_c_11245_n ) capacitor \
 c=0.0141401f //x=82.3 //y=6.205 //x2=82.52 //y2=5.56
cc_3950 ( N_noxref_11_M153_noxref_g N_noxref_22_c_11245_n ) capacitor \
 c=0.0139971f //x=82.74 //y=6.205 //x2=82.52 //y2=5.56
cc_3951 ( N_noxref_11_c_4687_p N_noxref_22_c_11245_n ) capacitor c=0.00293135f \
 //x=82.665 //y=4.975 //x2=82.52 //y2=5.56
cc_3952 ( N_noxref_11_c_4547_p N_noxref_22_M46_noxref_d ) capacitor \
 c=0.00218556f //x=75.635 //y=1.085 //x2=75.71 //y2=1.085
cc_3953 ( N_noxref_11_c_4549_p N_noxref_22_M46_noxref_d ) capacitor \
 c=0.00327871f //x=75.635 //y=1.43 //x2=75.71 //y2=1.085
cc_3954 ( N_noxref_11_c_4550_p N_noxref_22_M46_noxref_d ) capacitor \
 c=0.00254845f //x=75.635 //y=1.74 //x2=75.71 //y2=1.085
cc_3955 ( N_noxref_11_c_4694_p N_noxref_22_M46_noxref_d ) capacitor \
 c=0.00235569f //x=76.01 //y=0.93 //x2=75.71 //y2=1.085
cc_3956 ( N_noxref_11_c_4695_p N_noxref_22_M46_noxref_d ) capacitor \
 c=0.00523156f //x=76.01 //y=1.585 //x2=75.71 //y2=1.085
cc_3957 ( N_noxref_11_c_4559_p N_noxref_22_M46_noxref_d ) capacitor \
 c=0.00131413f //x=76.165 //y=1.085 //x2=75.71 //y2=1.085
cc_3958 ( N_noxref_11_c_4562_p N_noxref_22_M46_noxref_d ) capacitor \
 c=0.0065758f //x=76.165 //y=1.43 //x2=75.71 //y2=1.085
cc_3959 ( N_noxref_11_c_4632_p N_noxref_22_M50_noxref_d ) capacitor \
 c=0.00226395f //x=82.295 //y=1.085 //x2=82.37 //y2=1.085
cc_3960 ( N_noxref_11_c_4634_p N_noxref_22_M50_noxref_d ) capacitor \
 c=0.004517f //x=82.295 //y=1.435 //x2=82.37 //y2=1.085
cc_3961 ( N_noxref_11_c_4635_p N_noxref_22_M50_noxref_d ) capacitor \
 c=0.00275912f //x=82.295 //y=1.74 //x2=82.37 //y2=1.085
cc_3962 ( N_noxref_11_c_4664_p N_noxref_22_M50_noxref_d ) capacitor \
 c=0.00234223f //x=82.67 //y=0.93 //x2=82.37 //y2=1.085
cc_3963 ( N_noxref_11_c_4647_p N_noxref_22_M50_noxref_d ) capacitor \
 c=0.00707878f //x=82.67 //y=1.585 //x2=82.37 //y2=1.085
cc_3964 ( N_noxref_11_c_4644_p N_noxref_22_M50_noxref_d ) capacitor \
 c=0.00132831f //x=82.825 //y=1.085 //x2=82.37 //y2=1.085
cc_3965 ( N_noxref_11_c_4648_p N_noxref_22_M50_noxref_d ) capacitor \
 c=0.00330743f //x=82.825 //y=1.435 //x2=82.37 //y2=1.085
cc_3966 ( N_noxref_11_c_4216_n N_VDD_c_11522_n ) capacitor c=0.00621363f \
 //x=46.81 //y=5.335 //x2=74.455 //y2=7.585
cc_3967 ( N_noxref_11_c_4272_n N_VDD_c_11522_n ) capacitor c=0.00627186f \
 //x=47.695 //y=5.335 //x2=74.455 //y2=7.585
cc_3968 ( N_noxref_11_c_4274_n N_VDD_c_11522_n ) capacitor c=0.00256019f \
 //x=47.81 //y=5.56 //x2=74.455 //y2=7.585
cc_3969 ( N_noxref_11_c_4276_n N_VDD_c_11522_n ) capacitor c=0.00829214f \
 //x=48.505 //y=5.335 //x2=74.455 //y2=7.585
cc_3970 ( N_noxref_11_c_4221_n N_VDD_c_11522_n ) capacitor c=0.00261804f \
 //x=46.052 //y=5.335 //x2=74.455 //y2=7.585
cc_3971 ( N_noxref_11_c_4413_p N_VDD_c_11522_n ) capacitor c=0.00270108f \
 //x=46.93 //y=5.335 //x2=74.455 //y2=7.585
cc_3972 ( N_noxref_11_c_4311_n N_VDD_c_11522_n ) capacitor c=3.94104e-19 \
 //x=48.59 //y=4.25 //x2=74.455 //y2=7.585
cc_3973 ( N_noxref_11_c_4233_n N_VDD_c_11522_n ) capacitor c=0.0024232f \
 //x=46.05 //y=5.56 //x2=74.455 //y2=7.585
cc_3974 ( N_noxref_11_c_4443_p N_VDD_c_11522_n ) capacitor c=0.0024232f \
 //x=46.93 //y=5.56 //x2=74.455 //y2=7.585
cc_3975 ( N_noxref_11_c_4321_n N_VDD_c_11522_n ) capacitor c=0.0024232f \
 //x=47.81 //y=5.56 //x2=74.455 //y2=7.585
cc_3976 ( N_noxref_11_M144_noxref_g N_VDD_c_12121_n ) capacitor c=0.00125343f \
 //x=75.64 //y=6.205 //x2=75.42 //y2=7.035
cc_3977 ( N_noxref_11_M144_noxref_g N_VDD_c_12122_n ) capacitor c=0.00137209f \
 //x=75.64 //y=6.205 //x2=75.42 //y2=7.41
cc_3978 ( N_noxref_11_M145_noxref_g N_VDD_c_12123_n ) capacitor c=0.00373588f \
 //x=76.08 //y=6.205 //x2=76.3 //y2=7.035
cc_3979 ( N_noxref_11_M145_noxref_g N_VDD_c_12124_n ) capacitor c=0.00300944f \
 //x=76.08 //y=6.205 //x2=76.3 //y2=7.41
cc_3980 ( N_noxref_11_M104_noxref_g N_VDD_c_12017_n ) capacitor c=0.00697352f \
 //x=43.08 //y=6.2 //x2=43.655 //y2=7.585
cc_3981 ( N_noxref_11_M105_noxref_g N_VDD_c_12017_n ) capacitor c=0.00755544f \
 //x=43.52 //y=6.2 //x2=43.655 //y2=7.585
cc_3982 ( N_noxref_11_c_4216_n N_VDD_c_12022_n ) capacitor c=0.00202922f \
 //x=46.81 //y=5.335 //x2=46.405 //y2=7.585
cc_3983 ( N_noxref_11_c_4221_n N_VDD_c_12022_n ) capacitor c=9.3757e-19 \
 //x=46.052 //y=5.335 //x2=46.405 //y2=7.585
cc_3984 ( N_noxref_11_c_4233_n N_VDD_c_12022_n ) capacitor c=0.0138074f \
 //x=46.05 //y=5.56 //x2=46.405 //y2=7.585
cc_3985 ( N_noxref_11_c_4216_n N_VDD_c_12130_n ) capacitor c=0.0017708f \
 //x=46.81 //y=5.335 //x2=47.285 //y2=7.585
cc_3986 ( N_noxref_11_c_4272_n N_VDD_c_12130_n ) capacitor c=0.00202922f \
 //x=47.695 //y=5.335 //x2=47.285 //y2=7.585
cc_3987 ( N_noxref_11_c_4413_p N_VDD_c_12130_n ) capacitor c=9.4822e-19 \
 //x=46.93 //y=5.335 //x2=47.285 //y2=7.585
cc_3988 ( N_noxref_11_c_4443_p N_VDD_c_12130_n ) capacitor c=0.0138074f \
 //x=46.93 //y=5.56 //x2=47.285 //y2=7.585
cc_3989 ( N_noxref_11_c_4272_n N_VDD_c_12075_n ) capacitor c=0.00205906f \
 //x=47.695 //y=5.335 //x2=48.165 //y2=7.585
cc_3990 ( N_noxref_11_c_4274_n N_VDD_c_12075_n ) capacitor c=8.49654e-19 \
 //x=47.81 //y=5.56 //x2=48.165 //y2=7.585
cc_3991 ( N_noxref_11_c_4276_n N_VDD_c_12075_n ) capacitor c=0.00204238f \
 //x=48.505 //y=5.335 //x2=48.165 //y2=7.585
cc_3992 ( N_noxref_11_c_4321_n N_VDD_c_12075_n ) capacitor c=0.0135103f \
 //x=47.81 //y=5.56 //x2=48.165 //y2=7.585
cc_3993 ( N_noxref_11_c_4276_n N_VDD_c_12138_n ) capacitor c=0.00157252f \
 //x=48.505 //y=5.335 //x2=49.16 //y2=7.585
cc_3994 ( N_noxref_11_M144_noxref_g N_VDD_c_12139_n ) capacitor c=0.007206f \
 //x=75.64 //y=6.205 //x2=76.91 //y2=7.585
cc_3995 ( N_noxref_11_M145_noxref_g N_VDD_c_12139_n ) capacitor c=0.00778439f \
 //x=76.08 //y=6.205 //x2=76.91 //y2=7.585
cc_3996 ( N_noxref_11_M152_noxref_g N_VDD_c_12141_n ) capacitor c=0.00728344f \
 //x=82.3 //y=6.205 //x2=83.57 //y2=7.585
cc_3997 ( N_noxref_11_M153_noxref_g N_VDD_c_12141_n ) capacitor c=0.00782837f \
 //x=82.74 //y=6.205 //x2=83.57 //y2=7.585
cc_3998 ( N_noxref_11_c_4171_n N_VDD_c_12027_n ) capacitor c=0.00133985f \
 //x=43.04 //y=4.25 //x2=44.52 //y2=7.585
cc_3999 ( N_noxref_11_c_4221_n N_VDD_c_12027_n ) capacitor c=0.0022955f \
 //x=46.052 //y=5.335 //x2=44.52 //y2=7.585
cc_4000 ( N_noxref_11_c_4227_n N_VDD_c_12027_n ) capacitor c=0.00867114f \
 //x=47.465 //y=4.25 //x2=44.52 //y2=7.585
cc_4001 ( N_noxref_11_c_4179_n N_VDD_c_12027_n ) capacitor c=0.00226427f \
 //x=43.07 //y=4.88 //x2=44.52 //y2=7.585
cc_4002 ( N_noxref_11_c_4233_n N_VDD_c_12027_n ) capacitor c=0.00508013f \
 //x=46.05 //y=5.56 //x2=44.52 //y2=7.585
cc_4003 ( N_noxref_11_c_4248_n N_VDD_c_12027_n ) capacitor c=0.0129149f \
 //x=43.445 //y=4.97 //x2=44.52 //y2=7.585
cc_4004 ( N_noxref_11_c_4198_n N_VDD_c_12027_n ) capacitor c=2.73429e-19 \
 //x=43.07 //y=4.88 //x2=44.52 //y2=7.585
cc_4005 ( N_noxref_11_c_4274_n N_VDD_c_12088_n ) capacitor c=0.00269779f \
 //x=47.81 //y=5.56 //x2=49.33 //y2=7.585
cc_4006 ( N_noxref_11_c_4304_n N_VDD_c_12088_n ) capacitor c=0.00150923f \
 //x=48.59 //y=4.395 //x2=49.33 //y2=7.585
cc_4007 ( N_noxref_11_c_4305_n N_VDD_c_12088_n ) capacitor c=0.028134f \
 //x=48.59 //y=5.25 //x2=49.33 //y2=7.585
cc_4008 ( N_noxref_11_c_4311_n N_VDD_c_12088_n ) capacitor c=0.00507644f \
 //x=48.59 //y=4.25 //x2=49.33 //y2=7.585
cc_4009 ( N_noxref_11_c_4321_n N_VDD_c_12088_n ) capacitor c=0.00776541f \
 //x=47.81 //y=5.56 //x2=49.33 //y2=7.585
cc_4010 ( N_noxref_11_c_4510_p N_VDD_c_12155_n ) capacitor c=9.52781e-19 \
 //x=75.6 //y=4.25 //x2=73.75 //y2=7.585
cc_4011 ( N_noxref_11_c_4507_p N_VDD_c_12156_n ) capacitor c=5.31543e-19 \
 //x=75.6 //y=4.365 //x2=77.08 //y2=7.585
cc_4012 ( N_noxref_11_c_4499_p N_VDD_c_12156_n ) capacitor c=0.00746843f \
 //x=75.6 //y=4.71 //x2=77.08 //y2=7.585
cc_4013 ( N_noxref_11_c_4510_p N_VDD_c_12156_n ) capacitor c=0.00144593f \
 //x=75.6 //y=4.25 //x2=77.08 //y2=7.585
cc_4014 ( N_noxref_11_c_4522_p N_VDD_c_12156_n ) capacitor c=0.00818703f \
 //x=82.115 //y=4.21 //x2=77.08 //y2=7.585
cc_4015 ( N_noxref_11_c_4542_p N_VDD_c_12156_n ) capacitor c=0.00250302f \
 //x=75.64 //y=4.885 //x2=77.08 //y2=7.585
cc_4016 ( N_noxref_11_c_4781_p N_VDD_c_12156_n ) capacitor c=0.0117152f \
 //x=76.005 //y=4.975 //x2=77.08 //y2=7.585
cc_4017 ( N_noxref_11_c_4524_p N_VDD_c_12156_n ) capacitor c=2.76772e-19 \
 //x=75.64 //y=4.885 //x2=77.08 //y2=7.585
cc_4018 ( N_noxref_11_c_4572_p N_VDD_c_12163_n ) capacitor c=5.18027e-19 \
 //x=82.26 //y=4.74 //x2=80.41 //y2=7.585
cc_4019 ( N_noxref_11_c_4582_p N_VDD_c_12163_n ) capacitor c=8.21577e-19 \
 //x=82.26 //y=4.25 //x2=80.41 //y2=7.585
cc_4020 ( N_noxref_11_c_4522_p N_VDD_c_12163_n ) capacitor c=0.0135112f \
 //x=82.115 //y=4.21 //x2=80.41 //y2=7.585
cc_4021 ( N_noxref_11_c_4585_p N_VDD_c_12163_n ) capacitor c=6.64651e-19 \
 //x=82.28 //y=4.885 //x2=80.41 //y2=7.585
cc_4022 ( N_noxref_11_c_4585_p N_VDD_c_12167_n ) capacitor c=0.00237807f \
 //x=82.28 //y=4.885 //x2=83.74 //y2=7.585
cc_4023 ( N_noxref_11_c_4687_p N_VDD_c_12167_n ) capacitor c=0.0170421f \
 //x=82.665 //y=4.975 //x2=83.74 //y2=7.585
cc_4024 ( N_noxref_11_c_4586_p N_VDD_c_12167_n ) capacitor c=2.70151e-19 \
 //x=82.28 //y=4.885 //x2=83.74 //y2=7.585
cc_4025 ( N_noxref_11_c_4221_n N_VDD_M102_noxref_s ) capacitor c=4.22189e-19 \
 //x=46.052 //y=5.335 //x2=41.845 //y2=5.2
cc_4026 ( N_noxref_11_M104_noxref_g N_VDD_M103_noxref_d ) capacitor \
 c=0.015318f //x=43.08 //y=6.2 //x2=42.715 //y2=5.2
cc_4027 ( N_noxref_11_c_4198_n N_VDD_M103_noxref_d ) capacitor c=3.50465e-19 \
 //x=43.07 //y=4.88 //x2=42.715 //y2=5.2
cc_4028 ( N_noxref_11_M105_noxref_g N_VDD_M105_noxref_d ) capacitor \
 c=0.0430452f //x=43.52 //y=6.2 //x2=43.595 //y2=5.2
cc_4029 ( N_noxref_11_c_4221_n N_VDD_M106_noxref_s ) capacitor c=0.0441176f \
 //x=46.052 //y=5.335 //x2=45.475 //y2=5.2
cc_4030 ( N_noxref_11_c_4413_p N_VDD_M106_noxref_s ) capacitor c=7.80122e-19 \
 //x=46.93 //y=5.335 //x2=45.475 //y2=5.2
cc_4031 ( N_noxref_11_c_4233_n N_VDD_M106_noxref_s ) capacitor c=0.0908457f \
 //x=46.05 //y=5.56 //x2=45.475 //y2=5.2
cc_4032 ( N_noxref_11_c_4216_n N_VDD_M107_noxref_d ) capacitor c=0.00700141f \
 //x=46.81 //y=5.335 //x2=46.345 //y2=5.2
cc_4033 ( N_noxref_11_c_4233_n N_VDD_M107_noxref_d ) capacitor c=0.0673792f \
 //x=46.05 //y=5.56 //x2=46.345 //y2=5.2
cc_4034 ( N_noxref_11_c_4443_p N_VDD_M107_noxref_d ) capacitor c=0.0674762f \
 //x=46.93 //y=5.56 //x2=46.345 //y2=5.2
cc_4035 ( N_noxref_11_c_4272_n N_VDD_M109_noxref_d ) capacitor c=0.00700141f \
 //x=47.695 //y=5.335 //x2=47.225 //y2=5.2
cc_4036 ( N_noxref_11_c_4443_p N_VDD_M109_noxref_d ) capacitor c=0.067493f \
 //x=46.93 //y=5.56 //x2=47.225 //y2=5.2
cc_4037 ( N_noxref_11_c_4321_n N_VDD_M109_noxref_d ) capacitor c=0.0674288f \
 //x=47.81 //y=5.56 //x2=47.225 //y2=5.2
cc_4038 ( N_noxref_11_c_4276_n N_VDD_M111_noxref_d ) capacitor c=0.00700141f \
 //x=48.505 //y=5.335 //x2=48.105 //y2=5.2
cc_4039 ( N_noxref_11_c_4321_n N_VDD_M111_noxref_d ) capacitor c=0.0673824f \
 //x=47.81 //y=5.56 //x2=48.105 //y2=5.2
cc_4040 ( N_noxref_11_c_4274_n N_VDD_M112_noxref_s ) capacitor c=0.00536022f \
 //x=47.81 //y=5.56 //x2=49.985 //y2=5.2
cc_4041 ( N_noxref_11_c_4276_n N_VDD_M112_noxref_s ) capacitor c=0.00211796f \
 //x=48.505 //y=5.335 //x2=49.985 //y2=5.2
cc_4042 ( N_noxref_11_M144_noxref_g N_VDD_M143_noxref_d ) capacitor \
 c=0.0127979f //x=75.64 //y=6.205 //x2=75.275 //y2=5.205
cc_4043 ( N_noxref_11_M145_noxref_g N_VDD_M145_noxref_d ) capacitor \
 c=0.0463918f //x=76.08 //y=6.205 //x2=76.155 //y2=5.205
cc_4044 ( N_noxref_11_c_4280_n N_noxref_29_c_13291_n ) capacitor c=0.0036878f \
 //x=48.105 //y=1.305 //x2=48.505 //y2=0.72
cc_4045 ( N_noxref_11_c_4291_n N_noxref_29_c_13291_n ) capacitor c=0.00399931f \
 //x=48.505 //y=1.845 //x2=48.505 //y2=0.72
cc_4046 ( N_noxref_11_M29_noxref_d N_noxref_29_c_13291_n ) capacitor \
 c=0.00910163f //x=47.915 //y=1.095 //x2=48.505 //y2=0.72
cc_4047 ( N_noxref_11_M29_noxref_d N_noxref_29_c_13296_n ) capacitor \
 c=0.00120711f //x=47.915 //y=1.095 //x2=47.62 //y2=1.175
cc_4048 ( N_noxref_11_c_4216_n N_noxref_29_M28_noxref_d ) capacitor \
 c=0.00125456f //x=46.81 //y=5.335 //x2=46.38 //y2=1.09
cc_4049 ( N_noxref_11_c_4280_n N_noxref_29_M28_noxref_d ) capacitor \
 c=0.00802836f //x=48.105 //y=1.305 //x2=46.38 //y2=1.09
cc_4050 ( N_noxref_11_c_4280_n N_noxref_29_M29_noxref_s ) capacitor \
 c=0.00993092f //x=48.105 //y=1.305 //x2=47.485 //y2=0.555
cc_4051 ( N_noxref_11_c_4217_n N_noxref_29_M29_noxref_s ) capacitor \
 c=0.0270492f //x=48.105 //y=1.76 //x2=47.485 //y2=0.555
cc_4052 ( N_noxref_11_c_4291_n N_noxref_29_M29_noxref_s ) capacitor \
 c=0.00752108f //x=48.505 //y=1.845 //x2=47.485 //y2=0.555
cc_4053 ( N_noxref_11_c_4226_n N_noxref_29_M29_noxref_s ) capacitor \
 c=0.00309975f //x=48.59 //y=2.77 //x2=47.485 //y2=0.555
cc_4054 ( N_noxref_11_M29_noxref_d N_noxref_29_M29_noxref_s ) capacitor \
 c=0.0279003f //x=47.915 //y=1.095 //x2=47.485 //y2=0.555
cc_4055 ( N_noxref_11_c_4393_p N_noxref_32_c_13494_n ) capacitor c=0.0049601f \
 //x=63.6 //y=3.17 //x2=71.955 //y2=1.175
cc_4056 ( N_noxref_11_c_4393_p N_noxref_32_c_13495_n ) capacitor c=2.36456e-19 \
 //x=63.6 //y=3.17 //x2=72.925 //y2=0.72
cc_4057 ( N_noxref_11_c_4393_p N_noxref_32_M44_noxref_s ) capacitor \
 c=0.00292256f //x=63.6 //y=3.17 //x2=71.905 //y2=0.555
cc_4058 ( N_noxref_11_c_4505_p N_noxref_33_c_13563_n ) capacitor c=9.64357e-19 \
 //x=75.6 //y=3.285 //x2=75.745 //y2=5.39
cc_4059 ( N_noxref_11_c_4507_p N_noxref_33_c_13563_n ) capacitor c=0.00144109f \
 //x=75.6 //y=4.365 //x2=75.745 //y2=5.39
cc_4060 ( N_noxref_11_c_4499_p N_noxref_33_c_13563_n ) capacitor c=0.0211744f \
 //x=75.6 //y=4.71 //x2=75.745 //y2=5.39
cc_4061 ( N_noxref_11_c_4510_p N_noxref_33_c_13563_n ) capacitor c=3.71828e-19 \
 //x=75.6 //y=4.25 //x2=75.745 //y2=5.39
cc_4062 ( N_noxref_11_c_4542_p N_noxref_33_c_13563_n ) capacitor c=0.004587f \
 //x=75.64 //y=4.885 //x2=75.745 //y2=5.39
cc_4063 ( N_noxref_11_M144_noxref_g N_noxref_33_c_13563_n ) capacitor \
 c=0.00913391f //x=75.64 //y=6.205 //x2=75.745 //y2=5.39
cc_4064 ( N_noxref_11_c_4524_p N_noxref_33_c_13563_n ) capacitor c=6.87087e-19 \
 //x=75.64 //y=4.885 //x2=75.745 //y2=5.39
cc_4065 ( N_noxref_11_M145_noxref_g N_noxref_33_c_13570_n ) capacitor \
 c=0.011434f //x=76.08 //y=6.205 //x2=77.745 //y2=5.39
cc_4066 ( N_noxref_11_c_4507_p N_noxref_33_c_13571_n ) capacitor c=0.00145195f \
 //x=75.6 //y=4.365 //x2=75.975 //y2=5.39
cc_4067 ( N_noxref_11_c_4499_p N_noxref_33_c_13571_n ) capacitor c=0.00252287f \
 //x=75.6 //y=4.71 //x2=75.975 //y2=5.39
cc_4068 ( N_noxref_11_M144_noxref_g N_noxref_33_c_13571_n ) capacitor \
 c=7.30299e-19 //x=75.64 //y=6.205 //x2=75.975 //y2=5.39
cc_4069 ( N_noxref_11_M145_noxref_g N_noxref_33_c_13571_n ) capacitor \
 c=8.30848e-19 //x=76.08 //y=6.205 //x2=75.975 //y2=5.39
cc_4070 ( N_noxref_11_c_4507_p N_noxref_33_c_13575_n ) capacitor c=0.00167023f \
 //x=75.6 //y=4.365 //x2=75.86 //y2=5.39
cc_4071 ( N_noxref_11_M144_noxref_g N_noxref_33_c_13575_n ) capacitor \
 c=0.021802f //x=75.64 //y=6.205 //x2=75.86 //y2=5.39
cc_4072 ( N_noxref_11_M145_noxref_g N_noxref_33_c_13575_n ) capacitor \
 c=0.0189969f //x=76.08 //y=6.205 //x2=75.86 //y2=5.39
cc_4073 ( N_noxref_11_c_4781_p N_noxref_33_c_13575_n ) capacitor c=0.00449628f \
 //x=76.005 //y=4.975 //x2=75.86 //y2=5.39
cc_4074 ( N_noxref_11_M144_noxref_g N_noxref_33_M144_noxref_d ) capacitor \
 c=0.00122946f //x=75.64 //y=6.205 //x2=75.715 //y2=5.205
cc_4075 ( N_noxref_11_M145_noxref_g N_noxref_33_M144_noxref_d ) capacitor \
 c=0.00123972f //x=76.08 //y=6.205 //x2=75.715 //y2=5.205
cc_4076 ( N_noxref_11_c_4522_p N_noxref_34_c_13725_n ) capacitor c=0.0601635f \
 //x=82.115 //y=4.21 //x2=81.085 //y2=5.39
cc_4077 ( N_noxref_11_c_4522_p N_noxref_34_c_13726_n ) capacitor c=0.00869836f \
 //x=82.115 //y=4.21 //x2=79.295 //y2=5.39
cc_4078 ( N_noxref_11_M152_noxref_g N_noxref_34_c_13727_n ) capacitor \
 c=0.00793695f //x=82.3 //y=6.205 //x2=82.83 //y2=7.09
cc_4079 ( N_noxref_11_M153_noxref_g N_noxref_34_c_13727_n ) capacitor \
 c=0.00937408f //x=82.74 //y=6.205 //x2=82.83 //y2=7.09
cc_4080 ( N_noxref_11_c_4522_p N_noxref_34_c_13729_n ) capacitor c=0.0262206f \
 //x=82.115 //y=4.21 //x2=78.3 //y2=5.39
cc_4081 ( N_noxref_11_c_4522_p N_noxref_34_c_13730_n ) capacitor c=0.00272496f \
 //x=82.115 //y=4.21 //x2=79.18 //y2=5.39
cc_4082 ( N_noxref_11_M152_noxref_g N_noxref_34_c_13731_n ) capacitor \
 c=0.00177216f //x=82.3 //y=6.205 //x2=82.08 //y2=7.09
cc_4083 ( N_noxref_11_M153_noxref_g N_noxref_34_c_13732_n ) capacitor \
 c=0.00422002f //x=82.74 //y=6.205 //x2=82.96 //y2=6.92
cc_4084 ( N_noxref_11_c_4522_p N_noxref_34_c_13733_n ) capacitor c=2.11035e-19 \
 //x=82.115 //y=4.21 //x2=81.2 //y2=5.39
cc_4085 ( N_noxref_11_M152_noxref_g N_noxref_34_M151_noxref_d ) capacitor \
 c=0.0142133f //x=82.3 //y=6.205 //x2=81.935 //y2=5.205
cc_4086 ( N_noxref_11_c_4586_p N_noxref_34_M151_noxref_d ) capacitor \
 c=6.61209e-19 //x=82.28 //y=4.885 //x2=81.935 //y2=5.205
cc_4087 ( N_noxref_11_M153_noxref_g N_noxref_34_M153_noxref_d ) capacitor \
 c=0.0365939f //x=82.74 //y=6.205 //x2=82.815 //y2=5.205
cc_4088 ( N_noxref_11_c_4168_n N_GND_c_14235_n ) capacitor c=0.00210951f \
 //x=43.04 //y=2.26 //x2=45.51 //y2=0.175
cc_4089 ( N_noxref_11_c_4280_n N_GND_c_14287_n ) capacitor c=0.00884249f \
 //x=48.105 //y=1.305 //x2=50.425 //y2=0.175
cc_4090 ( N_noxref_11_c_4291_n N_GND_c_14287_n ) capacitor c=0.00662992f \
 //x=48.505 //y=1.845 //x2=50.425 //y2=0.175
cc_4091 ( N_noxref_11_c_4298_n N_GND_c_14287_n ) capacitor c=4.29616e-19 \
 //x=48.59 //y=2.945 //x2=50.425 //y2=0.175
cc_4092 ( N_noxref_11_M29_noxref_d N_GND_c_14287_n ) capacitor c=2.9462e-19 \
 //x=47.915 //y=1.095 //x2=50.425 //y2=0.175
cc_4093 ( N_noxref_11_c_4393_p N_GND_c_14313_n ) capacitor c=0.00653833f \
 //x=63.6 //y=3.17 //x2=74.93 //y2=1.015
cc_4094 ( N_noxref_11_c_4500_p N_GND_c_14314_n ) capacitor c=0.00214826f \
 //x=75.6 //y=2.375 //x2=78.175 //y2=0.175
cc_4095 ( N_noxref_11_c_4505_p N_GND_c_14314_n ) capacitor c=3.77909e-19 \
 //x=75.6 //y=3.285 //x2=78.175 //y2=0.175
cc_4096 ( N_noxref_11_c_4574_p N_GND_c_14316_n ) capacitor c=4.6307e-19 \
 //x=82.26 //y=2.38 //x2=85.22 //y2=0.18
cc_4097 ( N_noxref_11_c_4280_n N_GND_c_14317_n ) capacitor c=0.00488628f \
 //x=48.105 //y=1.305 //x2=50.51 //y2=1.135
cc_4098 ( N_noxref_11_c_4168_n N_GND_c_14217_n ) capacitor c=3.77328e-19 \
 //x=43.04 //y=2.26 //x2=44.35 //y2=0.175
cc_4099 ( N_noxref_11_c_4291_n N_GND_c_14258_n ) capacitor c=6.86343e-19 \
 //x=48.505 //y=1.845 //x2=49.16 //y2=0.175
cc_4100 ( N_noxref_11_c_4298_n N_GND_c_14258_n ) capacitor c=5.99995e-19 \
 //x=48.59 //y=2.945 //x2=49.16 //y2=0.175
cc_4101 ( N_noxref_11_c_4500_p N_GND_c_14321_n ) capacitor c=3.76947e-19 \
 //x=75.6 //y=2.375 //x2=76.91 //y2=0.175
cc_4102 ( N_noxref_11_c_4574_p N_GND_c_14322_n ) capacitor c=3.29013e-19 \
 //x=82.26 //y=2.38 //x2=83.57 //y2=0.175
cc_4103 ( N_noxref_11_c_4175_n N_GND_c_14261_n ) capacitor c=0.00207214f \
 //x=43.04 //y=2.26 //x2=44.52 //y2=0.175
cc_4104 ( N_noxref_11_c_4194_n N_GND_c_14261_n ) capacitor c=0.00275184f \
 //x=43.605 //y=1.43 //x2=44.52 //y2=0.175
cc_4105 ( N_noxref_11_c_4195_n N_GND_c_14261_n ) capacitor c=2.63786e-19 \
 //x=43.04 //y=2.26 //x2=44.52 //y2=0.175
cc_4106 ( N_noxref_11_c_4217_n N_GND_c_14304_n ) capacitor c=0.00285697f \
 //x=48.105 //y=1.76 //x2=49.33 //y2=0.175
cc_4107 ( N_noxref_11_c_4291_n N_GND_c_14304_n ) capacitor c=0.022222f \
 //x=48.505 //y=1.845 //x2=49.33 //y2=0.175
cc_4108 ( N_noxref_11_c_4293_n N_GND_c_14304_n ) capacitor c=2.00878e-19 \
 //x=48.59 //y=2.625 //x2=49.33 //y2=0.175
cc_4109 ( N_noxref_11_c_4298_n N_GND_c_14304_n ) capacitor c=0.00417021f \
 //x=48.59 //y=2.945 //x2=49.33 //y2=0.175
cc_4110 ( N_noxref_11_c_4226_n N_GND_c_14304_n ) capacitor c=0.0104325f \
 //x=48.59 //y=2.77 //x2=49.33 //y2=0.175
cc_4111 ( N_noxref_11_c_4339_p N_GND_c_14304_n ) capacitor c=0.0104061f \
 //x=51.095 //y=2.77 //x2=49.33 //y2=0.175
cc_4112 ( N_noxref_11_c_4368_p N_GND_c_14332_n ) capacitor c=0.00411812f \
 //x=53.385 //y=3.14 //x2=52.66 //y2=0.175
cc_4113 ( N_noxref_11_c_4372_p N_GND_c_14333_n ) capacitor c=0.00411812f \
 //x=58.195 //y=3.14 //x2=57.47 //y2=0.175
cc_4114 ( N_noxref_11_c_4391_p N_GND_c_14334_n ) capacitor c=0.00411812f \
 //x=63 //y=3.14 //x2=62.28 //y2=0.175
cc_4115 ( N_noxref_11_c_4393_p N_GND_c_14335_n ) capacitor c=0.00504399f \
 //x=63.6 //y=3.17 //x2=65.61 //y2=0.175
cc_4116 ( N_noxref_11_c_4393_p N_GND_c_14336_n ) capacitor c=0.00504399f \
 //x=63.6 //y=3.17 //x2=68.94 //y2=0.175
cc_4117 ( N_noxref_11_c_4393_p N_GND_c_14337_n ) capacitor c=0.00725442f \
 //x=63.6 //y=3.17 //x2=73.75 //y2=0.175
cc_4118 ( N_noxref_11_c_4500_p N_GND_c_14338_n ) capacitor c=0.00295886f \
 //x=75.6 //y=2.375 //x2=77.08 //y2=0.175
cc_4119 ( N_noxref_11_c_4496_p N_GND_c_14338_n ) capacitor c=0.00617359f \
 //x=75.6 //y=2.965 //x2=77.08 //y2=0.175
cc_4120 ( N_noxref_11_c_4502_p N_GND_c_14338_n ) capacitor c=0.00245228f \
 //x=75.6 //y=2.26 //x2=77.08 //y2=0.175
cc_4121 ( N_noxref_11_c_4503_p N_GND_c_14338_n ) capacitor c=2.63786e-19 \
 //x=75.6 //y=2.26 //x2=77.08 //y2=0.175
cc_4122 ( N_noxref_11_c_4522_p N_GND_c_14342_n ) capacitor c=0.0025451f \
 //x=82.115 //y=4.21 //x2=80.41 //y2=0.175
cc_4123 ( N_noxref_11_c_4577_p N_GND_c_14343_n ) capacitor c=0.00224736f \
 //x=82.26 //y=2.26 //x2=83.74 //y2=0.175
cc_4124 ( N_noxref_11_c_4647_p N_GND_c_14343_n ) capacitor c=0.00264662f \
 //x=82.67 //y=1.585 //x2=83.74 //y2=0.175
cc_4125 ( N_noxref_11_c_4578_p N_GND_c_14343_n ) capacitor c=2.63786e-19 \
 //x=82.26 //y=2.26 //x2=83.74 //y2=0.175
cc_4126 ( N_noxref_11_c_4161_n N_noxref_47_c_16232_n ) capacitor c=3.9067e-19 \
 //x=43.04 //y=4.425 //x2=42.855 //y2=1.675
cc_4127 ( N_noxref_11_c_4168_n N_noxref_47_c_16232_n ) capacitor c=7.50092e-19 \
 //x=43.04 //y=2.26 //x2=42.855 //y2=1.675
cc_4128 ( N_noxref_11_c_4190_n N_noxref_47_c_16232_n ) capacitor c=0.00888238f \
 //x=43.075 //y=1.74 //x2=42.855 //y2=1.675
cc_4129 ( N_noxref_11_c_4195_n N_noxref_47_c_16232_n ) capacitor c=0.00175171f \
 //x=43.04 //y=2.26 //x2=42.855 //y2=1.675
cc_4130 ( N_noxref_11_c_4168_n N_noxref_47_c_16237_n ) capacitor c=0.001463f \
 //x=43.04 //y=2.26 //x2=43.74 //y2=0.71
cc_4131 ( N_noxref_11_c_4175_n N_noxref_47_c_16237_n ) capacitor c=8.82141e-19 \
 //x=43.04 //y=2.26 //x2=43.74 //y2=0.71
cc_4132 ( N_noxref_11_c_4185_n N_noxref_47_c_16237_n ) capacitor c=0.0200738f \
 //x=43.075 //y=1.085 //x2=43.74 //y2=0.71
cc_4133 ( N_noxref_11_c_4193_n N_noxref_47_c_16237_n ) capacitor c=0.00825432f \
 //x=43.605 //y=1.085 //x2=43.74 //y2=0.71
cc_4134 ( N_noxref_11_c_4195_n N_noxref_47_c_16237_n ) capacitor c=2.1838e-19 \
 //x=43.04 //y=2.26 //x2=43.74 //y2=0.71
cc_4135 ( N_noxref_11_c_4185_n N_noxref_47_M25_noxref_s ) capacitor \
 c=0.00888238f //x=43.075 //y=1.085 //x2=41.75 //y2=0.545
cc_4136 ( N_noxref_11_c_4193_n N_noxref_47_M25_noxref_s ) capacitor \
 c=0.015333f //x=43.605 //y=1.085 //x2=41.75 //y2=0.545
cc_4137 ( N_noxref_11_c_4194_n N_noxref_47_M25_noxref_s ) capacitor \
 c=0.00248746f //x=43.605 //y=1.43 //x2=41.75 //y2=0.545
cc_4138 ( N_noxref_11_c_4393_p N_noxref_54_c_16670_n ) capacitor c=0.00133266f \
 //x=63.6 //y=3.17 //x2=71.385 //y2=1.77
cc_4139 ( N_noxref_11_c_4393_p N_noxref_54_M42_noxref_s ) capacitor \
 c=0.00316687f //x=63.6 //y=3.17 //x2=69.395 //y2=0.555
cc_4140 ( N_noxref_11_c_4393_p N_noxref_55_c_16729_n ) capacitor c=2.6577e-19 \
 //x=63.6 //y=3.17 //x2=74.445 //y2=1.675
cc_4141 ( N_noxref_11_c_4393_p N_noxref_55_c_16730_n ) capacitor c=0.0120738f \
 //x=63.6 //y=3.17 //x2=75.33 //y2=1.76
cc_4142 ( N_noxref_11_c_4500_p N_noxref_55_c_16731_n ) capacitor c=7.20375e-19 \
 //x=75.6 //y=2.375 //x2=75.415 //y2=1.675
cc_4143 ( N_noxref_11_c_4505_p N_noxref_55_c_16731_n ) capacitor c=0.00239605f \
 //x=75.6 //y=3.285 //x2=75.415 //y2=1.675
cc_4144 ( N_noxref_11_c_4550_p N_noxref_55_c_16731_n ) capacitor c=0.00746306f \
 //x=75.635 //y=1.74 //x2=75.415 //y2=1.675
cc_4145 ( N_noxref_11_c_4503_p N_noxref_55_c_16731_n ) capacitor c=0.00173976f \
 //x=75.6 //y=2.26 //x2=75.415 //y2=1.675
cc_4146 ( N_noxref_11_c_4500_p N_noxref_55_c_16735_n ) capacitor c=0.00135256f \
 //x=75.6 //y=2.375 //x2=76.3 //y2=0.71
cc_4147 ( N_noxref_11_c_4502_p N_noxref_55_c_16735_n ) capacitor c=8.82141e-19 \
 //x=75.6 //y=2.26 //x2=76.3 //y2=0.71
cc_4148 ( N_noxref_11_c_4547_p N_noxref_55_c_16735_n ) capacitor c=0.0200392f \
 //x=75.635 //y=1.085 //x2=76.3 //y2=0.71
cc_4149 ( N_noxref_11_c_4559_p N_noxref_55_c_16735_n ) capacitor c=0.00825432f \
 //x=76.165 //y=1.085 //x2=76.3 //y2=0.71
cc_4150 ( N_noxref_11_c_4503_p N_noxref_55_c_16735_n ) capacitor c=2.1838e-19 \
 //x=75.6 //y=2.26 //x2=76.3 //y2=0.71
cc_4151 ( N_noxref_11_c_4547_p N_noxref_55_M45_noxref_s ) capacitor \
 c=0.00746306f //x=75.635 //y=1.085 //x2=74.31 //y2=0.545
cc_4152 ( N_noxref_11_c_4550_p N_noxref_55_M45_noxref_s ) capacitor \
 c=0.00211573f //x=75.635 //y=1.74 //x2=74.31 //y2=0.545
cc_4153 ( N_noxref_11_c_4559_p N_noxref_55_M45_noxref_s ) capacitor \
 c=0.014227f //x=76.165 //y=1.085 //x2=74.31 //y2=0.545
cc_4154 ( N_noxref_11_c_4562_p N_noxref_55_M45_noxref_s ) capacitor \
 c=0.00733269f //x=76.165 //y=1.43 //x2=74.31 //y2=0.545
cc_4155 ( N_noxref_11_c_4920_p N_noxref_55_M45_noxref_s ) capacitor \
 c=0.00293287f //x=75.6 //y=2.095 //x2=74.31 //y2=0.545
cc_4156 ( N_noxref_11_c_4522_p N_noxref_58_c_16867_n ) capacitor c=0.00782785f \
 //x=82.115 //y=4.21 //x2=81.99 //y2=1.76
cc_4157 ( N_noxref_11_c_4574_p N_noxref_58_c_16868_n ) capacitor c=7.26555e-19 \
 //x=82.26 //y=2.38 //x2=82.075 //y2=1.675
cc_4158 ( N_noxref_11_c_4580_p N_noxref_58_c_16868_n ) capacitor c=9.42734e-19 \
 //x=82.26 //y=4.37 //x2=82.075 //y2=1.675
cc_4159 ( N_noxref_11_c_4635_p N_noxref_58_c_16868_n ) capacitor c=0.00830822f \
 //x=82.295 //y=1.74 //x2=82.075 //y2=1.675
cc_4160 ( N_noxref_11_c_4578_p N_noxref_58_c_16868_n ) capacitor c=0.00175172f \
 //x=82.26 //y=2.26 //x2=82.075 //y2=1.675
cc_4161 ( N_noxref_11_c_4574_p N_noxref_58_c_16872_n ) capacitor c=5.72205e-19 \
 //x=82.26 //y=2.38 //x2=82.96 //y2=0.71
cc_4162 ( N_noxref_11_c_4577_p N_noxref_58_c_16872_n ) capacitor c=8.37879e-19 \
 //x=82.26 //y=2.26 //x2=82.96 //y2=0.71
cc_4163 ( N_noxref_11_c_4632_p N_noxref_58_c_16872_n ) capacitor c=0.0202024f \
 //x=82.295 //y=1.085 //x2=82.96 //y2=0.71
cc_4164 ( N_noxref_11_c_4644_p N_noxref_58_c_16872_n ) capacitor c=0.00825432f \
 //x=82.825 //y=1.085 //x2=82.96 //y2=0.71
cc_4165 ( N_noxref_11_c_4578_p N_noxref_58_c_16872_n ) capacitor c=2.1838e-19 \
 //x=82.26 //y=2.26 //x2=82.96 //y2=0.71
cc_4166 ( N_noxref_11_c_4632_p N_noxref_58_M49_noxref_s ) capacitor \
 c=0.00830822f //x=82.295 //y=1.085 //x2=80.97 //y2=0.545
cc_4167 ( N_noxref_11_c_4647_p N_noxref_58_M49_noxref_s ) capacitor \
 c=0.00271091f //x=82.67 //y=1.585 //x2=80.97 //y2=0.545
cc_4168 ( N_noxref_11_c_4644_p N_noxref_58_M49_noxref_s ) capacitor \
 c=0.0142835f //x=82.825 //y=1.085 //x2=80.97 //y2=0.545
cc_4169 ( N_D_M113_noxref_g N_noxref_13_c_5585_n ) capacitor c=0.00889217f \
 //x=50.78 //y=6.2 //x2=51.325 //y2=5.38
cc_4170 ( N_D_c_5181_n N_noxref_13_c_5558_n ) capacitor c=6.55865e-19 \
 //x=50.44 //y=2.995 //x2=51.92 //y2=2.61
cc_4171 ( D N_noxref_13_c_5562_n ) capacitor c=0.00296564f //x=50.44 //y=3.88 \
 //x2=51.92 //y2=5.295
cc_4172 ( N_D_c_5181_n N_noxref_13_c_5562_n ) capacitor c=2.37206e-19 \
 //x=50.44 //y=2.995 //x2=51.92 //y2=5.295
cc_4173 ( N_D_c_5207_n N_noxref_13_c_5574_n ) capacitor c=3.98127e-19 \
 //x=50.44 //y=3.315 //x2=50.56 //y2=5.56
cc_4174 ( N_D_c_5212_n N_noxref_13_c_5574_n ) capacitor c=0.0117744f //x=50.44 \
 //y=4.88 //x2=50.56 //y2=5.56
cc_4175 ( N_D_c_5229_p N_noxref_13_c_5574_n ) capacitor c=0.00277154f \
 //x=50.44 //y=4.88 //x2=50.56 //y2=5.56
cc_4176 ( N_D_M112_noxref_g N_noxref_13_c_5574_n ) capacitor c=0.00201806f \
 //x=50.34 //y=6.2 //x2=50.56 //y2=5.56
cc_4177 ( N_D_M113_noxref_g N_noxref_13_c_5574_n ) capacitor c=0.00192712f \
 //x=50.78 //y=6.2 //x2=50.56 //y2=5.56
cc_4178 ( N_D_c_5232_p N_noxref_13_c_5574_n ) capacitor c=0.00199244f \
 //x=50.44 //y=4.88 //x2=50.56 //y2=5.56
cc_4179 ( N_D_c_5212_n N_noxref_13_c_5595_n ) capacitor c=0.00104426f \
 //x=50.44 //y=4.88 //x2=50.56 //y2=5.56
cc_4180 ( N_D_c_5229_p N_noxref_13_c_5595_n ) capacitor c=0.00377369f \
 //x=50.44 //y=4.88 //x2=50.56 //y2=5.56
cc_4181 ( N_D_M112_noxref_g N_noxref_13_c_5595_n ) capacitor c=0.0158358f \
 //x=50.34 //y=6.2 //x2=50.56 //y2=5.56
cc_4182 ( N_D_M113_noxref_g N_noxref_13_c_5595_n ) capacitor c=0.0178987f \
 //x=50.78 //y=6.2 //x2=50.56 //y2=5.56
cc_4183 ( N_D_c_5232_p N_noxref_13_c_5595_n ) capacitor c=0.0043218f //x=50.44 \
 //y=4.88 //x2=50.56 //y2=5.56
cc_4184 ( N_D_c_4954_n CLK ) capacitor c=4.9496e-19 //x=5.145 //y=3.155 \
 //x2=6.04 //y2=2.4
cc_4185 ( N_D_c_4957_n CLK ) capacitor c=0.0278104f //x=9.355 //y=3.14 \
 //x2=6.04 //y2=2.4
cc_4186 ( N_D_c_4985_n CLK ) capacitor c=0.00106453f //x=14.76 //y=3.17 \
 //x2=15.29 //y2=2.77
cc_4187 ( N_D_c_5018_n CLK ) capacitor c=0.0255063f //x=18.235 //y=3.14 \
 //x2=15.29 //y2=2.77
cc_4188 ( N_D_c_5085_n CLK ) capacitor c=4.9496e-19 //x=29.565 //y=3.155 \
 //x2=30.46 //y2=3.88
cc_4189 ( N_D_c_5088_n CLK ) capacitor c=0.023535f //x=33.775 //y=3.14 \
 //x2=30.46 //y2=3.88
cc_4190 ( N_D_c_5115_n CLK ) capacitor c=0.00106453f //x=39.18 //y=3.17 \
 //x2=39.71 //y2=2.77
cc_4191 ( N_D_c_5138_n CLK ) capacitor c=0.0228431f //x=43.39 //y=3.14 \
 //x2=39.71 //y2=2.77
cc_4192 ( N_D_c_5018_n N_CLK_c_6396_n ) capacitor c=9.61891e-19 //x=18.235 \
 //y=3.14 //x2=18.095 //y2=4.65
cc_4193 ( N_D_c_5018_n N_CLK_c_6421_n ) capacitor c=4.71333e-19 //x=18.235 \
 //y=3.14 //x2=18.975 //y2=4.62
cc_4194 ( D N_CLK_c_6476_n ) capacitor c=0.0310834f //x=26.02 //y=3.88 \
 //x2=26.375 //y2=4.62
cc_4195 ( N_D_c_5073_n N_CLK_c_6476_n ) capacitor c=0.00439681f //x=26.02 \
 //y=4.88 //x2=26.375 //y2=4.62
cc_4196 ( N_D_c_5046_n N_CLK_c_6476_n ) capacitor c=0.0116373f //x=27.37 \
 //y=3.155 //x2=26.375 //y2=4.62
cc_4197 ( D N_CLK_c_6683_n ) capacitor c=0.030981f //x=50.44 //y=3.88 \
 //x2=50.795 //y2=4.62
cc_4198 ( N_D_c_5212_n N_CLK_c_6683_n ) capacitor c=0.00437057f //x=50.44 \
 //y=4.88 //x2=50.795 //y2=4.62
cc_4199 ( N_D_c_5218_n N_CLK_c_6683_n ) capacitor c=0.00576766f //x=48.8 \
 //y=3.17 //x2=50.795 //y2=4.62
cc_4200 ( N_D_c_4957_n N_CLK_c_6303_n ) capacitor c=0.0036479f //x=9.355 \
 //y=3.14 //x2=6.04 //y2=4.62
cc_4201 ( D N_noxref_16_c_7276_n ) capacitor c=0.0326512f //x=50.44 //y=3.88 \
 //x2=51.18 //y2=4.085
cc_4202 ( D N_noxref_16_c_7276_n ) capacitor c=7.37513e-19 //x=50.44 //y=3.14 \
 //x2=51.18 //y2=4.085
cc_4203 ( N_D_c_5181_n N_noxref_16_c_7276_n ) capacitor c=0.0207981f //x=50.44 \
 //y=2.995 //x2=51.18 //y2=4.085
cc_4204 ( N_D_c_5207_n N_noxref_16_c_7276_n ) capacitor c=0.0145922f //x=50.44 \
 //y=3.315 //x2=51.18 //y2=4.085
cc_4205 ( N_D_c_5218_n N_noxref_16_c_7276_n ) capacitor c=0.00387669f //x=48.8 \
 //y=3.17 //x2=51.18 //y2=4.085
cc_4206 ( N_D_c_5260_p N_noxref_16_c_7276_n ) capacitor c=3.30333e-19 \
 //x=50.44 //y=2.26 //x2=51.18 //y2=4.085
cc_4207 ( D N_noxref_16_c_7297_n ) capacitor c=0.0148501f //x=50.44 //y=3.88 \
 //x2=51.18 //y2=4.405
cc_4208 ( D N_noxref_16_c_7282_n ) capacitor c=0.0120338f //x=50.44 //y=3.88 \
 //x2=51.18 //y2=4.735
cc_4209 ( N_D_c_5212_n N_noxref_16_c_7282_n ) capacitor c=0.0172939f //x=50.44 \
 //y=4.88 //x2=51.18 //y2=4.735
cc_4210 ( N_D_c_5229_p N_noxref_16_c_7282_n ) capacitor c=7.76143e-19 \
 //x=50.44 //y=4.88 //x2=51.18 //y2=4.735
cc_4211 ( N_D_c_5232_p N_noxref_16_c_7282_n ) capacitor c=0.00201171f \
 //x=50.44 //y=4.88 //x2=51.18 //y2=4.735
cc_4212 ( N_D_c_5211_n N_noxref_16_c_7302_n ) capacitor c=0.0179301f //x=50.44 \
 //y=2.26 //x2=51.18 //y2=2.26
cc_4213 ( N_D_c_5260_p N_noxref_16_c_7302_n ) capacitor c=5.16867e-19 \
 //x=50.44 //y=2.26 //x2=51.18 //y2=2.26
cc_4214 ( N_D_c_5268_p N_noxref_16_c_7302_n ) capacitor c=0.00161745f \
 //x=50.245 //y=2.095 //x2=51.18 //y2=2.26
cc_4215 ( D N_noxref_16_c_7285_n ) capacitor c=5.60537e-19 //x=50.44 //y=3.88 \
 //x2=51.18 //y2=4.25
cc_4216 ( D N_noxref_16_c_7290_n ) capacitor c=0.00418208f //x=50.44 //y=3.88 \
 //x2=51.34 //y2=4.245
cc_4217 ( N_D_c_5181_n N_noxref_16_c_7307_n ) capacitor c=3.30333e-19 \
 //x=50.44 //y=2.995 //x2=51.18 //y2=2.26
cc_4218 ( N_D_c_5211_n N_noxref_16_c_7307_n ) capacitor c=5.24723e-19 \
 //x=50.44 //y=2.26 //x2=51.18 //y2=2.26
cc_4219 ( N_D_c_5260_p N_noxref_16_c_7307_n ) capacitor c=0.00445529f \
 //x=50.44 //y=2.26 //x2=51.18 //y2=2.26
cc_4220 ( N_D_c_5268_p N_noxref_16_c_7307_n ) capacitor c=0.00267961f \
 //x=50.245 //y=2.095 //x2=51.18 //y2=2.26
cc_4221 ( N_D_c_5212_n N_noxref_16_c_7311_n ) capacitor c=4.80626e-19 \
 //x=50.44 //y=4.88 //x2=51.21 //y2=4.88
cc_4222 ( N_D_c_5229_p N_noxref_16_c_7311_n ) capacitor c=0.00397338f \
 //x=50.44 //y=4.88 //x2=51.21 //y2=4.88
cc_4223 ( N_D_c_5232_p N_noxref_16_c_7311_n ) capacitor c=0.00283894f \
 //x=50.44 //y=4.88 //x2=51.21 //y2=4.88
cc_4224 ( N_D_M112_noxref_g N_noxref_16_M114_noxref_g ) capacitor c=0.0104892f \
 //x=50.34 //y=6.2 //x2=51.22 //y2=6.2
cc_4225 ( N_D_M113_noxref_g N_noxref_16_M114_noxref_g ) capacitor c=0.107636f \
 //x=50.78 //y=6.2 //x2=51.22 //y2=6.2
cc_4226 ( N_D_M113_noxref_g N_noxref_16_M115_noxref_g ) capacitor c=0.0100341f \
 //x=50.78 //y=6.2 //x2=51.66 //y2=6.2
cc_4227 ( N_D_c_5281_p N_noxref_16_c_7317_n ) capacitor c=4.86545e-19 \
 //x=50.245 //y=1.045 //x2=51.215 //y2=1.085
cc_4228 ( N_D_c_5282_p N_noxref_16_c_7317_n ) capacitor c=0.00152405f \
 //x=50.245 //y=1.39 //x2=51.215 //y2=1.085
cc_4229 ( N_D_c_5283_p N_noxref_16_c_7317_n ) capacitor c=0.0151475f \
 //x=50.775 //y=1.045 //x2=51.215 //y2=1.085
cc_4230 ( N_D_c_5284_p N_noxref_16_c_7320_n ) capacitor c=0.00109982f \
 //x=50.245 //y=1.7 //x2=51.215 //y2=1.43
cc_4231 ( N_D_c_5285_p N_noxref_16_c_7320_n ) capacitor c=0.0111064f \
 //x=50.775 //y=1.39 //x2=51.215 //y2=1.43
cc_4232 ( N_D_c_5284_p N_noxref_16_c_7322_n ) capacitor c=9.58243e-19 \
 //x=50.245 //y=1.7 //x2=51.215 //y2=1.74
cc_4233 ( N_D_c_5268_p N_noxref_16_c_7322_n ) capacitor c=0.00662747f \
 //x=50.245 //y=2.095 //x2=51.215 //y2=1.74
cc_4234 ( N_D_c_5285_p N_noxref_16_c_7322_n ) capacitor c=0.00862358f \
 //x=50.775 //y=1.39 //x2=51.215 //y2=1.74
cc_4235 ( N_D_c_5283_p N_noxref_16_c_7325_n ) capacitor c=0.00127211f \
 //x=50.775 //y=1.045 //x2=51.745 //y2=1.085
cc_4236 ( N_D_c_5285_p N_noxref_16_c_7326_n ) capacitor c=0.00204774f \
 //x=50.775 //y=1.39 //x2=51.745 //y2=1.43
cc_4237 ( N_D_c_5211_n N_noxref_16_c_7327_n ) capacitor c=0.00161167f \
 //x=50.44 //y=2.26 //x2=51.18 //y2=2.26
cc_4238 ( N_D_c_5260_p N_noxref_16_c_7327_n ) capacitor c=0.00266443f \
 //x=50.44 //y=2.26 //x2=51.18 //y2=2.26
cc_4239 ( N_D_c_5268_p N_noxref_16_c_7327_n ) capacitor c=0.0181449f \
 //x=50.245 //y=2.095 //x2=51.18 //y2=2.26
cc_4240 ( N_D_c_5212_n N_noxref_16_c_7330_n ) capacitor c=0.00158715f \
 //x=50.44 //y=4.88 //x2=51.21 //y2=4.88
cc_4241 ( N_D_c_5229_p N_noxref_16_c_7330_n ) capacitor c=0.00237977f \
 //x=50.44 //y=4.88 //x2=51.21 //y2=4.88
cc_4242 ( N_D_c_5232_p N_noxref_16_c_7330_n ) capacitor c=0.0297875f //x=50.44 \
 //y=4.88 //x2=51.21 //y2=4.88
cc_4243 ( N_D_c_4961_n SN ) capacitor c=4.03048e-19 //x=9.955 //y=3.16 \
 //x2=10.85 //y2=2.77
cc_4244 ( N_D_c_4973_n SN ) capacitor c=0.0284774f //x=12.315 //y=3.14 \
 //x2=10.85 //y2=2.77
cc_4245 ( N_D_c_5046_n SN ) capacitor c=0.0257959f //x=27.37 //y=3.155 \
 //x2=22.32 //y2=2.77
cc_4246 ( N_D_c_4973_n N_SN_c_8051_n ) capacitor c=0.00222448f //x=12.315 \
 //y=3.14 //x2=10.85 //y2=2.55
cc_4247 ( N_D_c_5046_n N_SN_c_8130_n ) capacitor c=0.00222448f //x=27.37 \
 //y=3.155 //x2=22.32 //y2=2.55
cc_4248 ( N_D_c_5103_n N_SN_c_8253_n ) capacitor c=0.00222448f //x=36.735 \
 //y=3.14 //x2=35.27 //y2=2.55
cc_4249 ( N_D_c_5092_n N_SN_c_8257_n ) capacitor c=4.03048e-19 //x=34.375 \
 //y=3.16 //x2=35.27 //y2=4.765
cc_4250 ( N_D_c_5103_n N_SN_c_8257_n ) capacitor c=0.0258143f //x=36.735 \
 //y=3.14 //x2=35.27 //y2=4.765
cc_4251 ( N_D_c_5196_n N_SN_c_8360_n ) capacitor c=0.00222448f //x=48.2 \
 //y=3.14 //x2=46.74 //y2=2.55
cc_4252 ( N_D_c_5177_n N_SN_c_8364_n ) capacitor c=6.04112e-19 //x=45.845 \
 //y=3.17 //x2=46.74 //y2=4.765
cc_4253 ( N_D_c_5196_n N_SN_c_8364_n ) capacitor c=0.0258235f //x=48.2 \
 //y=3.14 //x2=46.74 //y2=4.765
cc_4254 ( N_D_c_4973_n N_SN_c_8092_n ) capacitor c=0.0733104f //x=12.315 \
 //y=3.14 //x2=22.15 //y2=2.4
cc_4255 ( N_D_c_4976_n N_SN_c_8092_n ) capacitor c=0.00667543f //x=12.915 \
 //y=3.17 //x2=22.15 //y2=2.4
cc_4256 ( N_D_c_4980_n N_SN_c_8092_n ) capacitor c=0.00888094f //x=14.16 \
 //y=3.14 //x2=22.15 //y2=2.4
cc_4257 ( N_D_c_4985_n N_SN_c_8092_n ) capacitor c=0.157036f //x=14.76 \
 //y=3.17 //x2=22.15 //y2=2.4
cc_4258 ( N_D_c_5018_n N_SN_c_8092_n ) capacitor c=0.0294075f //x=18.235 \
 //y=3.14 //x2=22.15 //y2=2.4
cc_4259 ( N_D_c_5046_n N_SN_c_8092_n ) capacitor c=0.147965f //x=27.37 \
 //y=3.155 //x2=22.15 //y2=2.4
cc_4260 ( N_D_c_5075_n N_SN_c_8265_n ) capacitor c=0.00793317f //x=27.715 \
 //y=3.155 //x2=27.715 //y2=2.385
cc_4261 ( D N_SN_c_8145_n ) capacitor c=0.0147263f //x=26.02 //y=2.77 \
 //x2=27.285 //y2=2.385
cc_4262 ( N_D_c_5072_n N_SN_c_8145_n ) capacitor c=0.00405958f //x=26.02 \
 //y=3.28 //x2=27.285 //y2=2.385
cc_4263 ( N_D_c_5126_n N_SN_c_8145_n ) capacitor c=0.0171889f //x=26.02 \
 //y=2.26 //x2=27.285 //y2=2.385
cc_4264 ( N_D_c_5046_n N_SN_c_8145_n ) capacitor c=0.236961f //x=27.37 \
 //y=3.155 //x2=27.285 //y2=2.385
cc_4265 ( N_D_c_5139_n N_SN_c_8145_n ) capacitor c=2.20453e-19 //x=26.02 \
 //y=2.26 //x2=27.285 //y2=2.385
cc_4266 ( N_D_c_5153_n N_SN_c_8145_n ) capacitor c=3.61358e-19 //x=25.825 \
 //y=2.095 //x2=27.285 //y2=2.385
cc_4267 ( N_D_c_5081_n N_SN_c_8273_n ) capacitor c=0.00528191f //x=28.965 \
 //y=3.14 //x2=28.965 //y2=2.4
cc_4268 ( N_D_c_5085_n N_SN_c_8275_n ) capacitor c=0.0149645f //x=29.565 \
 //y=3.155 //x2=29.565 //y2=2.385
cc_4269 ( N_D_c_5088_n N_SN_c_8282_n ) capacitor c=0.0176182f //x=33.775 \
 //y=3.14 //x2=33.775 //y2=2.4
cc_4270 ( N_D_c_5092_n N_SN_c_8285_n ) capacitor c=0.00444087f //x=34.375 \
 //y=3.16 //x2=34.375 //y2=2.39
cc_4271 ( N_D_c_5103_n N_SN_c_8324_n ) capacitor c=0.0733104f //x=36.735 \
 //y=3.14 //x2=46.57 //y2=2.4
cc_4272 ( N_D_c_5106_n N_SN_c_8324_n ) capacitor c=0.00667543f //x=37.335 \
 //y=3.17 //x2=46.57 //y2=2.4
cc_4273 ( N_D_c_5110_n N_SN_c_8324_n ) capacitor c=0.00888094f //x=38.58 \
 //y=3.14 //x2=46.57 //y2=2.4
cc_4274 ( N_D_c_5115_n N_SN_c_8324_n ) capacitor c=0.1916f //x=39.18 //y=3.17 \
 //x2=46.57 //y2=2.4
cc_4275 ( N_D_c_5138_n N_SN_c_8324_n ) capacitor c=0.00892806f //x=43.39 \
 //y=3.14 //x2=46.57 //y2=2.4
cc_4276 ( N_D_c_5168_n N_SN_c_8324_n ) capacitor c=0.00701918f //x=43.99 \
 //y=3.17 //x2=46.57 //y2=2.4
cc_4277 ( N_D_c_5172_n N_SN_c_8324_n ) capacitor c=0.00890914f //x=45.245 \
 //y=3.14 //x2=46.57 //y2=2.4
cc_4278 ( N_D_c_5177_n N_SN_c_8324_n ) capacitor c=0.03176f //x=45.845 \
 //y=3.17 //x2=46.57 //y2=2.4
cc_4279 ( N_D_c_5092_n N_SN_c_8291_n ) capacitor c=0.0322598f //x=34.375 \
 //y=3.16 //x2=35.43 //y2=2.4
cc_4280 ( N_D_c_5103_n N_SN_c_8291_n ) capacitor c=0.0156796f //x=36.735 \
 //y=3.14 //x2=35.43 //y2=2.4
cc_4281 ( N_D_c_5181_n N_SN_c_8385_n ) capacitor c=0.0126399f //x=50.44 \
 //y=2.995 //x2=51.705 //y2=2.385
cc_4282 ( N_D_c_5211_n N_SN_c_8385_n ) capacitor c=0.0172467f //x=50.44 \
 //y=2.26 //x2=51.705 //y2=2.385
cc_4283 ( N_D_c_5196_n N_SN_c_8385_n ) capacitor c=0.0890223f //x=48.2 \
 //y=3.14 //x2=51.705 //y2=2.385
cc_4284 ( N_D_c_5218_n N_SN_c_8385_n ) capacitor c=0.00746888f //x=48.8 \
 //y=3.17 //x2=51.705 //y2=2.385
cc_4285 ( N_D_c_5260_p N_SN_c_8385_n ) capacitor c=2.20453e-19 //x=50.44 \
 //y=2.26 //x2=51.705 //y2=2.385
cc_4286 ( N_D_c_5268_p N_SN_c_8385_n ) capacitor c=3.61358e-19 //x=50.245 \
 //y=2.095 //x2=51.705 //y2=2.385
cc_4287 ( N_D_c_4973_n N_SN_c_8059_n ) capacitor c=0.0156796f //x=12.315 \
 //y=3.14 //x2=11.01 //y2=2.39
cc_4288 ( N_D_c_5018_n N_noxref_21_c_10403_n ) capacitor c=6.24134e-19 \
 //x=18.235 //y=3.14 //x2=18.62 //y2=3.335
cc_4289 ( N_D_c_5343_p N_noxref_21_c_10403_n ) capacitor c=0.0225903f \
 //x=18.835 //y=3.11 //x2=18.62 //y2=3.335
cc_4290 ( N_D_c_5046_n N_noxref_21_c_10403_n ) capacitor c=6.24134e-19 \
 //x=27.37 //y=3.155 //x2=18.62 //y2=3.335
cc_4291 ( N_D_c_5343_p N_noxref_21_c_10405_n ) capacitor c=0.00588416f \
 //x=18.835 //y=3.11 //x2=18.62 //y2=3.655
cc_4292 ( D N_noxref_21_c_10538_n ) capacitor c=0.00807871f //x=26.02 //y=2.77 \
 //x2=24.17 //y2=3.365
cc_4293 ( D N_noxref_21_c_10538_n ) capacitor c=0.00135272f //x=26.02 //y=3.88 \
 //x2=24.17 //y2=3.365
cc_4294 ( D N_noxref_21_c_10538_n ) capacitor c=2.11402e-19 //x=26.02 //y=3.14 \
 //x2=24.17 //y2=3.365
cc_4295 ( N_D_c_5072_n N_noxref_21_c_10538_n ) capacitor c=0.0023879f \
 //x=26.02 //y=3.28 //x2=24.17 //y2=3.365
cc_4296 ( N_D_c_5126_n N_noxref_21_c_10538_n ) capacitor c=0.00344372f \
 //x=26.02 //y=2.26 //x2=24.17 //y2=3.365
cc_4297 ( N_D_c_5046_n N_noxref_21_c_10538_n ) capacitor c=0.026922f //x=27.37 \
 //y=3.155 //x2=24.17 //y2=3.365
cc_4298 ( D N_noxref_21_c_10543_n ) capacitor c=0.00254697f //x=26.02 //y=3.88 \
 //x2=24.17 //y2=3.685
cc_4299 ( N_D_c_5046_n N_noxref_21_c_10543_n ) capacitor c=0.00891276f \
 //x=27.37 //y=3.155 //x2=24.17 //y2=3.685
cc_4300 ( D N_noxref_21_c_10544_n ) capacitor c=0.0162099f //x=26.02 //y=3.88 \
 //x2=24.17 //y2=5.25
cc_4301 ( N_D_c_5073_n N_noxref_21_c_10544_n ) capacitor c=0.00476843f \
 //x=26.02 //y=4.88 //x2=24.17 //y2=5.25
cc_4302 ( N_D_c_5343_p N_noxref_21_c_10471_n ) capacitor c=0.0103481f \
 //x=18.835 //y=3.11 //x2=23.045 //y2=3.51
cc_4303 ( N_D_c_5046_n N_noxref_21_c_10471_n ) capacitor c=0.419314f //x=27.37 \
 //y=3.155 //x2=23.045 //y2=3.51
cc_4304 ( N_D_c_5088_n N_noxref_21_c_10581_n ) capacitor c=0.173837f \
 //x=33.775 //y=3.14 //x2=31.79 //y2=3.48
cc_4305 ( D N_noxref_21_c_10561_n ) capacitor c=0.0284558f //x=26.02 //y=3.88 \
 //x2=31.36 //y2=3.48
cc_4306 ( N_D_c_5072_n N_noxref_21_c_10561_n ) capacitor c=0.00595255f \
 //x=26.02 //y=3.28 //x2=31.36 //y2=3.48
cc_4307 ( N_D_c_5075_n N_noxref_21_c_10561_n ) capacitor c=0.111467f \
 //x=27.715 //y=3.155 //x2=31.36 //y2=3.48
cc_4308 ( N_D_c_5046_n N_noxref_21_c_10561_n ) capacitor c=0.373487f //x=27.37 \
 //y=3.155 //x2=31.36 //y2=3.48
cc_4309 ( N_D_c_5081_n N_noxref_21_c_10561_n ) capacitor c=0.0578814f \
 //x=28.965 //y=3.14 //x2=31.36 //y2=3.48
cc_4310 ( N_D_c_5085_n N_noxref_21_c_10561_n ) capacitor c=0.139199f \
 //x=29.565 //y=3.155 //x2=31.36 //y2=3.48
cc_4311 ( N_D_c_5088_n N_noxref_21_c_10561_n ) capacitor c=0.0582439f \
 //x=33.775 //y=3.14 //x2=31.36 //y2=3.48
cc_4312 ( N_D_c_5088_n N_noxref_21_c_10586_n ) capacitor c=0.0585155f \
 //x=33.775 //y=3.14 //x2=35.995 //y2=3.51
cc_4313 ( N_D_c_5092_n N_noxref_21_c_10586_n ) capacitor c=0.138615f \
 //x=34.375 //y=3.16 //x2=35.995 //y2=3.51
cc_4314 ( N_D_c_5103_n N_noxref_21_c_10586_n ) capacitor c=0.0582276f \
 //x=36.735 //y=3.14 //x2=35.995 //y2=3.51
cc_4315 ( N_D_c_5103_n N_noxref_21_c_10587_n ) capacitor c=0.0415403f \
 //x=36.735 //y=3.14 //x2=36.595 //y2=3.48
cc_4316 ( N_D_c_5106_n N_noxref_21_c_10588_n ) capacitor c=0.140531f \
 //x=37.335 //y=3.17 //x2=40.06 //y2=3.51
cc_4317 ( N_D_c_5110_n N_noxref_21_c_10588_n ) capacitor c=0.0585881f \
 //x=38.58 //y=3.14 //x2=40.06 //y2=3.51
cc_4318 ( N_D_c_5115_n N_noxref_21_c_10588_n ) capacitor c=0.0746746f \
 //x=39.18 //y=3.17 //x2=40.06 //y2=3.51
cc_4319 ( N_D_c_5138_n N_noxref_21_c_10588_n ) capacitor c=0.0591998f \
 //x=43.39 //y=3.14 //x2=40.06 //y2=3.51
cc_4320 ( N_D_c_5138_n N_noxref_21_c_10604_n ) capacitor c=0.235817f //x=43.39 \
 //y=3.14 //x2=40.66 //y2=3.48
cc_4321 ( N_D_c_5138_n N_noxref_21_c_10606_n ) capacitor c=0.059097f //x=43.39 \
 //y=3.14 //x2=47.465 //y2=3.51
cc_4322 ( N_D_c_5168_n N_noxref_21_c_10606_n ) capacitor c=0.111927f //x=43.99 \
 //y=3.17 //x2=47.465 //y2=3.51
cc_4323 ( N_D_c_5172_n N_noxref_21_c_10606_n ) capacitor c=0.0595405f \
 //x=45.245 //y=3.14 //x2=47.465 //y2=3.51
cc_4324 ( N_D_c_5177_n N_noxref_21_c_10606_n ) capacitor c=0.138615f \
 //x=45.845 //y=3.17 //x2=47.465 //y2=3.51
cc_4325 ( N_D_c_5196_n N_noxref_21_c_10606_n ) capacitor c=0.056498f //x=48.2 \
 //y=3.14 //x2=47.465 //y2=3.51
cc_4326 ( N_D_c_5196_n N_noxref_21_c_10633_n ) capacitor c=0.0406992f //x=48.2 \
 //y=3.14 //x2=48.065 //y2=3.495
cc_4327 ( D N_noxref_21_c_10661_n ) capacitor c=9.21654e-19 //x=50.44 //y=3.88 \
 //x2=50.045 //y2=3.51
cc_4328 ( N_D_c_5207_n N_noxref_21_c_10661_n ) capacitor c=0.00354587f \
 //x=50.44 //y=3.315 //x2=50.045 //y2=3.51
cc_4329 ( N_D_c_5218_n N_noxref_21_c_10661_n ) capacitor c=0.186542f //x=48.8 \
 //y=3.17 //x2=50.045 //y2=3.51
cc_4330 ( D N_noxref_21_c_10665_n ) capacitor c=0.0273152f //x=50.44 //y=3.88 \
 //x2=50.645 //y2=3.54
cc_4331 ( N_D_c_5207_n N_noxref_21_c_10665_n ) capacitor c=0.00249901f \
 //x=50.44 //y=3.315 //x2=50.645 //y2=3.54
cc_4332 ( N_D_c_5343_p N_noxref_21_c_10418_n ) capacitor c=0.0358686f \
 //x=18.835 //y=3.11 //x2=18.78 //y2=3.495
cc_4333 ( N_D_c_4937_n N_VDD_c_11522_n ) capacitor c=9.07241e-19 //x=1.6 \
 //y=4.88 //x2=74.455 //y2=7.585
cc_4334 ( N_D_c_5073_n N_VDD_c_11522_n ) capacitor c=9.07241e-19 //x=26.02 \
 //y=4.88 //x2=74.455 //y2=7.585
cc_4335 ( N_D_c_5212_n N_VDD_c_11522_n ) capacitor c=9.07241e-19 //x=50.44 \
 //y=4.88 //x2=74.455 //y2=7.585
cc_4336 ( N_D_c_4964_n N_VDD_c_11522_n ) capacitor c=6.22888e-19 //x=1.6 \
 //y=4.88 //x2=74.455 //y2=7.585
cc_4337 ( N_D_c_5094_n N_VDD_c_11522_n ) capacitor c=6.22888e-19 //x=26.02 \
 //y=4.88 //x2=74.455 //y2=7.585
cc_4338 ( N_D_c_5229_p N_VDD_c_11522_n ) capacitor c=6.22888e-19 //x=50.44 \
 //y=4.88 //x2=74.455 //y2=7.585
cc_4339 ( N_D_c_4937_n N_VDD_c_11529_n ) capacitor c=6.28113e-19 //x=1.6 \
 //y=4.88 //x2=2.075 //y2=7.585
cc_4340 ( N_D_M52_noxref_g N_VDD_c_11529_n ) capacitor c=0.00732618f //x=1.5 \
 //y=6.2 //x2=2.075 //y2=7.585
cc_4341 ( N_D_M53_noxref_g N_VDD_c_11529_n ) capacitor c=0.00755544f //x=1.94 \
 //y=6.2 //x2=2.075 //y2=7.585
cc_4342 ( N_D_c_5073_n N_VDD_c_11829_n ) capacitor c=6.28113e-19 //x=26.02 \
 //y=4.88 //x2=26.495 //y2=7.585
cc_4343 ( N_D_M82_noxref_g N_VDD_c_11829_n ) capacitor c=0.00732618f //x=25.92 \
 //y=6.2 //x2=26.495 //y2=7.585
cc_4344 ( N_D_M83_noxref_g N_VDD_c_11829_n ) capacitor c=0.00755544f //x=26.36 \
 //y=6.2 //x2=26.495 //y2=7.585
cc_4345 ( N_D_c_5212_n N_VDD_c_12201_n ) capacitor c=6.28113e-19 //x=50.44 \
 //y=4.88 //x2=50.915 //y2=7.585
cc_4346 ( N_D_M112_noxref_g N_VDD_c_12201_n ) capacitor c=0.00732618f \
 //x=50.34 //y=6.2 //x2=50.915 //y2=7.585
cc_4347 ( N_D_M113_noxref_g N_VDD_c_12201_n ) capacitor c=0.00755544f \
 //x=50.78 //y=6.2 //x2=50.915 //y2=7.585
cc_4348 ( D N_VDD_c_11541_n ) capacitor c=0.00998287f //x=1.6 //y=3.51 \
 //x2=1.23 //y2=7.58
cc_4349 ( N_D_c_4937_n N_VDD_c_11541_n ) capacitor c=0.00867681f //x=1.6 \
 //y=4.88 //x2=1.23 //y2=7.58
cc_4350 ( N_D_c_4964_n N_VDD_c_11541_n ) capacitor c=0.00370735f //x=1.6 \
 //y=4.88 //x2=1.23 //y2=7.58
cc_4351 ( N_D_c_4971_n N_VDD_c_11541_n ) capacitor c=0.0234764f //x=1.6 \
 //y=4.88 //x2=1.23 //y2=7.58
cc_4352 ( D N_VDD_c_11799_n ) capacitor c=0.00584083f //x=26.02 //y=3.88 \
 //x2=24.91 //y2=7.585
cc_4353 ( N_D_c_5073_n N_VDD_c_11799_n ) capacitor c=0.00447349f //x=26.02 \
 //y=4.88 //x2=24.91 //y2=7.585
cc_4354 ( N_D_c_5094_n N_VDD_c_11799_n ) capacitor c=0.00370494f //x=26.02 \
 //y=4.88 //x2=24.91 //y2=7.585
cc_4355 ( N_D_c_5101_n N_VDD_c_11799_n ) capacitor c=0.0129564f //x=26.02 \
 //y=4.88 //x2=24.91 //y2=7.585
cc_4356 ( D N_VDD_c_12088_n ) capacitor c=0.00582118f //x=50.44 //y=3.88 \
 //x2=49.33 //y2=7.585
cc_4357 ( N_D_c_5212_n N_VDD_c_12088_n ) capacitor c=0.00447349f //x=50.44 \
 //y=4.88 //x2=49.33 //y2=7.585
cc_4358 ( N_D_c_5229_p N_VDD_c_12088_n ) capacitor c=0.00370494f //x=50.44 \
 //y=4.88 //x2=49.33 //y2=7.585
cc_4359 ( N_D_c_5232_p N_VDD_c_12088_n ) capacitor c=0.0129564f //x=50.44 \
 //y=4.88 //x2=49.33 //y2=7.585
cc_4360 ( N_D_M52_noxref_g N_VDD_M52_noxref_s ) capacitor c=0.0567929f //x=1.5 \
 //y=6.2 //x2=1.145 //y2=5.2
cc_4361 ( N_D_M53_noxref_g N_VDD_M53_noxref_d ) capacitor c=0.015318f //x=1.94 \
 //y=6.2 //x2=2.015 //y2=5.2
cc_4362 ( N_D_M82_noxref_g N_VDD_M82_noxref_s ) capacitor c=0.0567929f \
 //x=25.92 //y=6.2 //x2=25.565 //y2=5.2
cc_4363 ( N_D_M83_noxref_g N_VDD_M83_noxref_d ) capacitor c=0.015318f \
 //x=26.36 //y=6.2 //x2=26.435 //y2=5.2
cc_4364 ( N_D_c_5207_n N_VDD_M112_noxref_s ) capacitor c=8.88776e-19 //x=50.44 \
 //y=3.315 //x2=49.985 //y2=5.2
cc_4365 ( N_D_M112_noxref_g N_VDD_M112_noxref_s ) capacitor c=0.0567929f \
 //x=50.34 //y=6.2 //x2=49.985 //y2=5.2
cc_4366 ( N_D_M113_noxref_g N_VDD_M113_noxref_d ) capacitor c=0.015318f \
 //x=50.78 //y=6.2 //x2=50.855 //y2=5.2
cc_4367 ( N_D_c_4973_n N_noxref_25_M6_noxref_d ) capacitor c=0.00407176f \
 //x=12.315 //y=3.14 //x2=10.49 //y2=1.09
cc_4368 ( N_D_c_4997_n N_GND_c_14346_n ) capacitor c=6.6172e-19 //x=1.6 \
 //y=2.26 //x2=1.585 //y2=0.175
cc_4369 ( N_D_c_4936_n N_GND_c_13871_n ) capacitor c=9.80392e-19 //x=1.6 \
 //y=3.305 //x2=1.67 //y2=1.135
cc_4370 ( N_D_c_4997_n N_GND_c_13871_n ) capacitor c=0.00679038f //x=1.6 \
 //y=2.26 //x2=1.67 //y2=1.135
cc_4371 ( N_D_c_4939_n N_GND_c_13871_n ) capacitor c=3.3366e-19 //x=2.695 \
 //y=3.14 //x2=1.67 //y2=1.135
cc_4372 ( N_D_c_4963_n N_GND_c_13871_n ) capacitor c=0.0025956f //x=1.765 \
 //y=3.145 //x2=1.67 //y2=1.135
cc_4373 ( N_D_c_5020_n N_GND_c_13871_n ) capacitor c=2.13705e-19 //x=1.6 \
 //y=2.26 //x2=1.67 //y2=1.135
cc_4374 ( N_D_c_5030_n N_GND_c_13871_n ) capacitor c=0.00156094f //x=1.405 \
 //y=1.045 //x2=1.67 //y2=1.135
cc_4375 ( N_D_c_5031_n N_GND_c_13871_n ) capacitor c=0.00413828f //x=1.405 \
 //y=1.39 //x2=1.67 //y2=1.135
cc_4376 ( N_D_c_5032_n N_GND_c_13871_n ) capacitor c=4.2764e-19 //x=1.405 \
 //y=1.7 //x2=1.67 //y2=1.135
cc_4377 ( N_D_c_5431_p N_GND_c_13871_n ) capacitor c=7.35788e-19 //x=1.78 \
 //y=0.89 //x2=1.67 //y2=1.135
cc_4378 ( N_D_c_5432_p N_GND_c_13871_n ) capacitor c=5.64606e-19 //x=1.78 \
 //y=1.545 //x2=1.67 //y2=1.135
cc_4379 ( N_D_c_5038_n N_GND_c_13871_n ) capacitor c=0.00171483f //x=1.935 \
 //y=1.045 //x2=1.67 //y2=1.135
cc_4380 ( N_D_c_5040_n N_GND_c_13871_n ) capacitor c=0.00290521f //x=1.935 \
 //y=1.39 //x2=1.67 //y2=1.135
cc_4381 ( N_D_c_5030_n N_GND_c_14359_n ) capacitor c=3.51399e-19 //x=1.405 \
 //y=1.045 //x2=1.667 //y2=1.005
cc_4382 ( N_D_c_5431_p N_GND_c_14359_n ) capacitor c=0.00850983f //x=1.78 \
 //y=0.89 //x2=1.667 //y2=1.005
cc_4383 ( N_D_c_5038_n N_GND_c_14359_n ) capacitor c=4.40196e-19 //x=1.935 \
 //y=1.045 //x2=1.667 //y2=1.005
cc_4384 ( N_D_c_5072_n N_GND_c_14091_n ) capacitor c=9.37307e-19 //x=26.02 \
 //y=3.28 //x2=26.09 //y2=1.135
cc_4385 ( N_D_c_5126_n N_GND_c_14091_n ) capacitor c=0.00645051f //x=26.02 \
 //y=2.26 //x2=26.09 //y2=1.135
cc_4386 ( N_D_c_5139_n N_GND_c_14091_n ) capacitor c=2.13705e-19 //x=26.02 \
 //y=2.26 //x2=26.09 //y2=1.135
cc_4387 ( N_D_c_5149_n N_GND_c_14091_n ) capacitor c=0.00176535f //x=25.825 \
 //y=1.045 //x2=26.09 //y2=1.135
cc_4388 ( N_D_c_5150_n N_GND_c_14091_n ) capacitor c=0.0036005f //x=25.825 \
 //y=1.39 //x2=26.09 //y2=1.135
cc_4389 ( N_D_c_5151_n N_GND_c_14091_n ) capacitor c=4.2764e-19 //x=25.825 \
 //y=1.7 //x2=26.09 //y2=1.135
cc_4390 ( N_D_c_5444_p N_GND_c_14091_n ) capacitor c=9.36995e-19 //x=26.2 \
 //y=0.89 //x2=26.09 //y2=1.135
cc_4391 ( N_D_c_5445_p N_GND_c_14091_n ) capacitor c=5.6392e-19 //x=26.2 \
 //y=1.545 //x2=26.09 //y2=1.135
cc_4392 ( N_D_c_5157_n N_GND_c_14091_n ) capacitor c=0.00171483f //x=26.355 \
 //y=1.045 //x2=26.09 //y2=1.135
cc_4393 ( N_D_c_5159_n N_GND_c_14091_n ) capacitor c=0.00290521f //x=26.355 \
 //y=1.39 //x2=26.09 //y2=1.135
cc_4394 ( N_D_c_5149_n N_GND_c_14372_n ) capacitor c=3.51399e-19 //x=25.825 \
 //y=1.045 //x2=26.087 //y2=1.005
cc_4395 ( N_D_c_5444_p N_GND_c_14372_n ) capacitor c=0.00850983f //x=26.2 \
 //y=0.89 //x2=26.087 //y2=1.005
cc_4396 ( N_D_c_5157_n N_GND_c_14372_n ) capacitor c=4.40196e-19 //x=26.355 \
 //y=1.045 //x2=26.087 //y2=1.005
cc_4397 ( N_D_c_5211_n N_GND_c_14317_n ) capacitor c=0.00645051f //x=50.44 \
 //y=2.26 //x2=50.51 //y2=1.135
cc_4398 ( N_D_c_5260_p N_GND_c_14317_n ) capacitor c=2.13705e-19 //x=50.44 \
 //y=2.26 //x2=50.51 //y2=1.135
cc_4399 ( N_D_c_5281_p N_GND_c_14317_n ) capacitor c=0.00176535f //x=50.245 \
 //y=1.045 //x2=50.51 //y2=1.135
cc_4400 ( N_D_c_5282_p N_GND_c_14317_n ) capacitor c=0.0036005f //x=50.245 \
 //y=1.39 //x2=50.51 //y2=1.135
cc_4401 ( N_D_c_5284_p N_GND_c_14317_n ) capacitor c=4.2764e-19 //x=50.245 \
 //y=1.7 //x2=50.51 //y2=1.135
cc_4402 ( N_D_c_5456_p N_GND_c_14317_n ) capacitor c=9.36995e-19 //x=50.62 \
 //y=0.89 //x2=50.51 //y2=1.135
cc_4403 ( N_D_c_5457_p N_GND_c_14317_n ) capacitor c=6.38426e-19 //x=50.62 \
 //y=1.545 //x2=50.51 //y2=1.135
cc_4404 ( N_D_c_5283_p N_GND_c_14317_n ) capacitor c=0.00171483f //x=50.775 \
 //y=1.045 //x2=50.51 //y2=1.135
cc_4405 ( N_D_c_5285_p N_GND_c_14317_n ) capacitor c=0.00296337f //x=50.775 \
 //y=1.39 //x2=50.51 //y2=1.135
cc_4406 ( N_D_c_5281_p N_GND_c_14384_n ) capacitor c=3.51399e-19 //x=50.245 \
 //y=1.045 //x2=50.507 //y2=1.005
cc_4407 ( N_D_c_5456_p N_GND_c_14384_n ) capacitor c=0.00850983f //x=50.62 \
 //y=0.89 //x2=50.507 //y2=1.005
cc_4408 ( N_D_c_5283_p N_GND_c_14384_n ) capacitor c=4.40196e-19 //x=50.775 \
 //y=1.045 //x2=50.507 //y2=1.005
cc_4409 ( N_D_c_5030_n N_GND_c_13896_n ) capacitor c=0.00690758f //x=1.405 \
 //y=1.045 //x2=3.65 //y2=0.175
cc_4410 ( D N_GND_c_13898_n ) capacitor c=0.0113215f //x=1.6 //y=2.77 \
 //x2=1.23 //y2=0.18
cc_4411 ( N_D_c_4997_n N_GND_c_13898_n ) capacitor c=0.0082376f //x=1.6 \
 //y=2.26 //x2=1.23 //y2=0.18
cc_4412 ( N_D_c_5020_n N_GND_c_13898_n ) capacitor c=0.00369668f //x=1.6 \
 //y=2.26 //x2=1.23 //y2=0.18
cc_4413 ( N_D_c_5032_n N_GND_c_13898_n ) capacitor c=0.0015404f //x=1.405 \
 //y=1.7 //x2=1.23 //y2=0.18
cc_4414 ( N_D_c_5034_n N_GND_c_13898_n ) capacitor c=0.00950704f //x=1.405 \
 //y=2.095 //x2=1.23 //y2=0.18
cc_4415 ( N_D_c_5149_n N_GND_c_14114_n ) capacitor c=0.00688027f //x=25.825 \
 //y=1.045 //x2=28.07 //y2=0.175
cc_4416 ( N_D_c_5281_p N_GND_c_14394_n ) capacitor c=0.00688027f //x=50.245 \
 //y=1.045 //x2=52.49 //y2=0.175
cc_4417 ( N_D_c_4950_n N_GND_c_13902_n ) capacitor c=0.00411812f //x=4.545 \
 //y=3.14 //x2=3.82 //y2=0.175
cc_4418 ( N_D_c_4957_n N_GND_c_13914_n ) capacitor c=0.00411812f //x=9.355 \
 //y=3.14 //x2=8.63 //y2=0.175
cc_4419 ( N_D_c_4980_n N_GND_c_13958_n ) capacitor c=0.00411812f //x=14.16 \
 //y=3.14 //x2=13.44 //y2=0.175
cc_4420 ( N_D_c_5018_n N_GND_c_13971_n ) capacitor c=0.00504399f //x=18.235 \
 //y=3.14 //x2=16.77 //y2=0.175
cc_4421 ( N_D_c_5046_n N_GND_c_14041_n ) capacitor c=0.00504399f //x=27.37 \
 //y=3.155 //x2=20.1 //y2=0.175
cc_4422 ( D N_GND_c_14078_n ) capacitor c=0.00745875f //x=26.02 //y=2.77 \
 //x2=24.91 //y2=0.175
cc_4423 ( N_D_c_5126_n N_GND_c_14078_n ) capacitor c=0.00354691f //x=26.02 \
 //y=2.26 //x2=24.91 //y2=0.175
cc_4424 ( N_D_c_5046_n N_GND_c_14078_n ) capacitor c=0.00504399f //x=27.37 \
 //y=3.155 //x2=24.91 //y2=0.175
cc_4425 ( N_D_c_5139_n N_GND_c_14078_n ) capacitor c=0.00354425f //x=26.02 \
 //y=2.26 //x2=24.91 //y2=0.175
cc_4426 ( N_D_c_5151_n N_GND_c_14078_n ) capacitor c=0.0015404f //x=25.825 \
 //y=1.7 //x2=24.91 //y2=0.175
cc_4427 ( N_D_c_5153_n N_GND_c_14078_n ) capacitor c=0.0093907f //x=25.825 \
 //y=2.095 //x2=24.91 //y2=0.175
cc_4428 ( N_D_c_5081_n N_GND_c_14120_n ) capacitor c=0.00411812f //x=28.965 \
 //y=3.14 //x2=28.24 //y2=0.175
cc_4429 ( N_D_c_5088_n N_GND_c_14132_n ) capacitor c=0.00411812f //x=33.775 \
 //y=3.14 //x2=33.05 //y2=0.175
cc_4430 ( N_D_c_5110_n N_GND_c_14176_n ) capacitor c=0.00411812f //x=38.58 \
 //y=3.14 //x2=37.86 //y2=0.175
cc_4431 ( N_D_c_5138_n N_GND_c_14189_n ) capacitor c=0.00504399f //x=43.39 \
 //y=3.14 //x2=41.19 //y2=0.175
cc_4432 ( N_D_c_5172_n N_GND_c_14261_n ) capacitor c=0.00411812f //x=45.245 \
 //y=3.14 //x2=44.52 //y2=0.175
cc_4433 ( N_D_c_5181_n N_GND_c_14304_n ) capacitor c=0.00643886f //x=50.44 \
 //y=2.995 //x2=49.33 //y2=0.175
cc_4434 ( N_D_c_5211_n N_GND_c_14304_n ) capacitor c=0.00354691f //x=50.44 \
 //y=2.26 //x2=49.33 //y2=0.175
cc_4435 ( N_D_c_5218_n N_GND_c_14304_n ) capacitor c=0.00411812f //x=48.8 \
 //y=3.17 //x2=49.33 //y2=0.175
cc_4436 ( N_D_c_5260_p N_GND_c_14304_n ) capacitor c=0.00354425f //x=50.44 \
 //y=2.26 //x2=49.33 //y2=0.175
cc_4437 ( N_D_c_5284_p N_GND_c_14304_n ) capacitor c=0.0015404f //x=50.245 \
 //y=1.7 //x2=49.33 //y2=0.175
cc_4438 ( N_D_c_5268_p N_GND_c_14304_n ) capacitor c=0.0093907f //x=50.245 \
 //y=2.095 //x2=49.33 //y2=0.175
cc_4439 ( N_D_c_4997_n N_GND_M0_noxref_d ) capacitor c=2.20438e-19 //x=1.6 \
 //y=2.26 //x2=1.48 //y2=1.045
cc_4440 ( N_D_c_5030_n N_GND_M0_noxref_d ) capacitor c=0.00192399f //x=1.405 \
 //y=1.045 //x2=1.48 //y2=1.045
cc_4441 ( N_D_c_5031_n N_GND_M0_noxref_d ) capacitor c=0.00210798f //x=1.405 \
 //y=1.39 //x2=1.48 //y2=1.045
cc_4442 ( N_D_c_5431_p N_GND_M0_noxref_d ) capacitor c=0.00472259f //x=1.78 \
 //y=0.89 //x2=1.48 //y2=1.045
cc_4443 ( N_D_c_5432_p N_GND_M0_noxref_d ) capacitor c=0.00166857f //x=1.78 \
 //y=1.545 //x2=1.48 //y2=1.045
cc_4444 ( N_D_c_5038_n N_GND_M0_noxref_d ) capacitor c=0.00230174f //x=1.935 \
 //y=1.045 //x2=1.48 //y2=1.045
cc_4445 ( N_D_c_5040_n N_GND_M0_noxref_d ) capacitor c=0.00210798f //x=1.935 \
 //y=1.39 //x2=1.48 //y2=1.045
cc_4446 ( N_D_c_5126_n N_GND_M15_noxref_d ) capacitor c=2.20438e-19 //x=26.02 \
 //y=2.26 //x2=25.9 //y2=1.045
cc_4447 ( N_D_c_5149_n N_GND_M15_noxref_d ) capacitor c=0.00192399f //x=25.825 \
 //y=1.045 //x2=25.9 //y2=1.045
cc_4448 ( N_D_c_5150_n N_GND_M15_noxref_d ) capacitor c=0.00210798f //x=25.825 \
 //y=1.39 //x2=25.9 //y2=1.045
cc_4449 ( N_D_c_5444_p N_GND_M15_noxref_d ) capacitor c=0.00472259f //x=26.2 \
 //y=0.89 //x2=25.9 //y2=1.045
cc_4450 ( N_D_c_5445_p N_GND_M15_noxref_d ) capacitor c=0.00166857f //x=26.2 \
 //y=1.545 //x2=25.9 //y2=1.045
cc_4451 ( N_D_c_5157_n N_GND_M15_noxref_d ) capacitor c=0.00230174f //x=26.355 \
 //y=1.045 //x2=25.9 //y2=1.045
cc_4452 ( N_D_c_5159_n N_GND_M15_noxref_d ) capacitor c=0.00210798f //x=26.355 \
 //y=1.39 //x2=25.9 //y2=1.045
cc_4453 ( N_D_c_5211_n N_GND_M30_noxref_d ) capacitor c=2.20438e-19 //x=50.44 \
 //y=2.26 //x2=50.32 //y2=1.045
cc_4454 ( N_D_c_5281_p N_GND_M30_noxref_d ) capacitor c=0.00192399f //x=50.245 \
 //y=1.045 //x2=50.32 //y2=1.045
cc_4455 ( N_D_c_5282_p N_GND_M30_noxref_d ) capacitor c=0.00210798f //x=50.245 \
 //y=1.39 //x2=50.32 //y2=1.045
cc_4456 ( N_D_c_5456_p N_GND_M30_noxref_d ) capacitor c=0.00472259f //x=50.62 \
 //y=0.89 //x2=50.32 //y2=1.045
cc_4457 ( N_D_c_5457_p N_GND_M30_noxref_d ) capacitor c=0.00166857f //x=50.62 \
 //y=1.545 //x2=50.32 //y2=1.045
cc_4458 ( N_D_c_5283_p N_GND_M30_noxref_d ) capacitor c=0.00230174f //x=50.775 \
 //y=1.045 //x2=50.32 //y2=1.045
cc_4459 ( N_D_c_5285_p N_GND_M30_noxref_d ) capacitor c=0.00210798f //x=50.775 \
 //y=1.39 //x2=50.32 //y2=1.045
cc_4460 ( N_D_c_5034_n N_noxref_37_c_15618_n ) capacitor c=0.00262672f \
 //x=1.405 //y=2.095 //x2=1.185 //y2=1.675
cc_4461 ( N_D_c_4936_n N_noxref_37_c_15619_n ) capacitor c=0.00278098f //x=1.6 \
 //y=3.305 //x2=2.07 //y2=1.76
cc_4462 ( N_D_c_4997_n N_noxref_37_c_15619_n ) capacitor c=0.00459552f //x=1.6 \
 //y=2.26 //x2=2.07 //y2=1.76
cc_4463 ( N_D_c_4939_n N_noxref_37_c_15619_n ) capacitor c=0.00321697f \
 //x=2.695 //y=3.14 //x2=2.07 //y2=1.76
cc_4464 ( N_D_c_5020_n N_noxref_37_c_15619_n ) capacitor c=0.00763108f //x=1.6 \
 //y=2.26 //x2=2.07 //y2=1.76
cc_4465 ( N_D_c_5032_n N_noxref_37_c_15619_n ) capacitor c=0.00695869f \
 //x=1.405 //y=1.7 //x2=2.07 //y2=1.76
cc_4466 ( N_D_c_5034_n N_noxref_37_c_15619_n ) capacitor c=0.0190134f \
 //x=1.405 //y=2.095 //x2=2.07 //y2=1.76
cc_4467 ( N_D_c_5432_p N_noxref_37_c_15619_n ) capacitor c=0.00723574f \
 //x=1.78 //y=1.545 //x2=2.07 //y2=1.76
cc_4468 ( N_D_c_5040_n N_noxref_37_c_15619_n ) capacitor c=0.00339872f \
 //x=1.935 //y=1.39 //x2=2.07 //y2=1.76
cc_4469 ( N_D_c_4939_n N_noxref_37_c_15596_n ) capacitor c=0.00264522f \
 //x=2.695 //y=3.14 //x2=2.155 //y2=1.675
cc_4470 ( N_D_c_5034_n N_noxref_37_c_15596_n ) capacitor c=6.71402e-19 \
 //x=1.405 //y=2.095 //x2=2.155 //y2=1.675
cc_4471 ( N_D_c_4939_n N_noxref_37_c_15597_n ) capacitor c=5.92247e-19 \
 //x=2.695 //y=3.14 //x2=3.04 //y2=0.71
cc_4472 ( N_D_c_5030_n N_noxref_37_M0_noxref_s ) capacitor c=0.0294925f \
 //x=1.405 //y=1.045 //x2=1.05 //y2=0.545
cc_4473 ( N_D_c_5032_n N_noxref_37_M0_noxref_s ) capacitor c=3.48408e-19 \
 //x=1.405 //y=1.7 //x2=1.05 //y2=0.545
cc_4474 ( N_D_c_5038_n N_noxref_37_M0_noxref_s ) capacitor c=0.0125442f \
 //x=1.935 //y=1.045 //x2=1.05 //y2=0.545
cc_4475 ( N_D_c_4961_n N_noxref_39_c_15720_n ) capacitor c=0.00327335f \
 //x=9.955 //y=3.16 //x2=10.105 //y2=1.77
cc_4476 ( N_D_c_4973_n N_noxref_39_c_15733_n ) capacitor c=0.0068407f \
 //x=12.315 //y=3.14 //x2=11.075 //y2=1.77
cc_4477 ( N_D_c_4961_n N_noxref_39_M5_noxref_s ) capacitor c=0.00305443f \
 //x=9.955 //y=3.16 //x2=9.085 //y2=0.555
cc_4478 ( N_D_c_5153_n N_noxref_43_c_15993_n ) capacitor c=0.00262672f \
 //x=25.825 //y=2.095 //x2=25.605 //y2=1.675
cc_4479 ( N_D_c_5072_n N_noxref_43_c_15994_n ) capacitor c=0.00285877f \
 //x=26.02 //y=3.28 //x2=26.49 //y2=1.76
cc_4480 ( N_D_c_5126_n N_noxref_43_c_15994_n ) capacitor c=0.00509504f \
 //x=26.02 //y=2.26 //x2=26.49 //y2=1.76
cc_4481 ( N_D_c_5139_n N_noxref_43_c_15994_n ) capacitor c=0.00763108f \
 //x=26.02 //y=2.26 //x2=26.49 //y2=1.76
cc_4482 ( N_D_c_5151_n N_noxref_43_c_15994_n ) capacitor c=0.00697076f \
 //x=25.825 //y=1.7 //x2=26.49 //y2=1.76
cc_4483 ( N_D_c_5153_n N_noxref_43_c_15994_n ) capacitor c=0.0170561f \
 //x=25.825 //y=2.095 //x2=26.49 //y2=1.76
cc_4484 ( N_D_c_5445_p N_noxref_43_c_15994_n ) capacitor c=0.00723574f \
 //x=26.2 //y=1.545 //x2=26.49 //y2=1.76
cc_4485 ( N_D_c_5159_n N_noxref_43_c_15994_n ) capacitor c=0.00339872f \
 //x=26.355 //y=1.39 //x2=26.49 //y2=1.76
cc_4486 ( N_D_c_5153_n N_noxref_43_c_15971_n ) capacitor c=6.71402e-19 \
 //x=25.825 //y=2.095 //x2=26.575 //y2=1.675
cc_4487 ( N_D_c_5149_n N_noxref_43_M15_noxref_s ) capacitor c=0.0295366f \
 //x=25.825 //y=1.045 //x2=25.47 //y2=0.545
cc_4488 ( N_D_c_5151_n N_noxref_43_M15_noxref_s ) capacitor c=3.48408e-19 \
 //x=25.825 //y=1.7 //x2=25.47 //y2=0.545
cc_4489 ( N_D_c_5157_n N_noxref_43_M15_noxref_s ) capacitor c=0.0125442f \
 //x=26.355 //y=1.045 //x2=25.47 //y2=0.545
cc_4490 ( N_D_c_5268_p N_noxref_49_c_16351_n ) capacitor c=0.00262672f \
 //x=50.245 //y=2.095 //x2=50.025 //y2=1.675
cc_4491 ( N_D_c_5207_n N_noxref_49_c_16352_n ) capacitor c=0.00444966f \
 //x=50.44 //y=3.315 //x2=50.91 //y2=1.76
cc_4492 ( N_D_c_5211_n N_noxref_49_c_16352_n ) capacitor c=0.00509504f \
 //x=50.44 //y=2.26 //x2=50.91 //y2=1.76
cc_4493 ( N_D_c_5260_p N_noxref_49_c_16352_n ) capacitor c=0.00763108f \
 //x=50.44 //y=2.26 //x2=50.91 //y2=1.76
cc_4494 ( N_D_c_5284_p N_noxref_49_c_16352_n ) capacitor c=0.00697076f \
 //x=50.245 //y=1.7 //x2=50.91 //y2=1.76
cc_4495 ( N_D_c_5268_p N_noxref_49_c_16352_n ) capacitor c=0.0170561f \
 //x=50.245 //y=2.095 //x2=50.91 //y2=1.76
cc_4496 ( N_D_c_5457_p N_noxref_49_c_16352_n ) capacitor c=0.00723574f \
 //x=50.62 //y=1.545 //x2=50.91 //y2=1.76
cc_4497 ( N_D_c_5285_p N_noxref_49_c_16352_n ) capacitor c=0.00339872f \
 //x=50.775 //y=1.39 //x2=50.91 //y2=1.76
cc_4498 ( N_D_c_5268_p N_noxref_49_c_16359_n ) capacitor c=6.71402e-19 \
 //x=50.245 //y=2.095 //x2=50.995 //y2=1.675
cc_4499 ( N_D_c_5281_p N_noxref_49_M30_noxref_s ) capacitor c=0.0295366f \
 //x=50.245 //y=1.045 //x2=49.89 //y2=0.545
cc_4500 ( N_D_c_5284_p N_noxref_49_M30_noxref_s ) capacitor c=3.48408e-19 \
 //x=50.245 //y=1.7 //x2=49.89 //y2=0.545
cc_4501 ( N_D_c_5283_p N_noxref_49_M30_noxref_s ) capacitor c=0.0125442f \
 //x=50.775 //y=1.045 //x2=49.89 //y2=0.545
cc_4502 ( N_noxref_13_M123_noxref_g N_noxref_14_c_5999_n ) capacitor \
 c=0.00893512f //x=59.22 //y=6.2 //x2=59.76 //y2=5.335
cc_4503 ( N_noxref_13_M122_noxref_g N_noxref_14_c_6000_n ) capacitor \
 c=0.00461408f //x=58.78 //y=6.2 //x2=59.002 //y2=5.335
cc_4504 ( N_noxref_13_M123_noxref_g N_noxref_14_c_6000_n ) capacitor \
 c=0.00229208f //x=59.22 //y=6.2 //x2=59.002 //y2=5.335
cc_4505 ( N_noxref_13_c_5603_p N_noxref_14_c_6000_n ) capacitor c=0.00171885f \
 //x=59.145 //y=4.97 //x2=59.002 //y2=5.335
cc_4506 ( N_noxref_13_c_5604_p N_noxref_14_c_6003_n ) capacitor c=4.26537e-19 \
 //x=58.58 //y=2.77 //x2=61.54 //y2=2.77
cc_4507 ( N_noxref_13_M122_noxref_g N_noxref_14_c_6004_n ) capacitor \
 c=0.0162284f //x=58.78 //y=6.2 //x2=59 //y2=5.56
cc_4508 ( N_noxref_13_M123_noxref_g N_noxref_14_c_6004_n ) capacitor \
 c=0.0179041f //x=59.22 //y=6.2 //x2=59 //y2=5.56
cc_4509 ( N_noxref_13_c_5603_p N_noxref_14_c_6004_n ) capacitor c=0.00291477f \
 //x=59.145 //y=4.97 //x2=59 //y2=5.56
cc_4510 ( N_noxref_13_c_5558_n CLK ) capacitor c=3.323e-19 //x=51.92 //y=2.61 \
 //x2=54.88 //y2=3.88
cc_4511 ( N_noxref_13_c_5562_n CLK ) capacitor c=0.00111996f //x=51.92 \
 //y=5.295 //x2=54.88 //y2=3.88
cc_4512 ( N_noxref_13_c_5610_p CLK ) capacitor c=0.00480066f //x=53.77 \
 //y=2.61 //x2=54.88 //y2=3.88
cc_4513 ( N_noxref_13_c_5566_n CLK ) capacitor c=0.00765388f //x=53.77 \
 //y=2.93 //x2=54.88 //y2=3.88
cc_4514 ( N_noxref_13_c_5568_n CLK ) capacitor c=0.041355f //x=53.77 //y=4.755 \
 //x2=54.88 //y2=3.88
cc_4515 ( N_noxref_13_c_5613_p CLK ) capacitor c=2.98349e-19 //x=53.77 \
 //y=2.765 //x2=54.88 //y2=3.88
cc_4516 ( N_noxref_13_c_5581_n CLK ) capacitor c=0.00242466f //x=53.93 \
 //y=2.77 //x2=54.88 //y2=3.88
cc_4517 ( N_noxref_13_c_5583_n CLK ) capacitor c=0.0229358f //x=58.42 \
 //y=2.775 //x2=54.88 //y2=3.88
cc_4518 ( N_noxref_13_c_5616_p CLK ) capacitor c=3.9149e-19 //x=53.77 //y=2.26 \
 //x2=54.88 //y2=3.88
cc_4519 ( N_noxref_13_c_5617_p N_CLK_c_6819_n ) capacitor c=0.0090811f \
 //x=53.77 //y=2.375 //x2=54.88 //y2=2.375
cc_4520 ( N_noxref_13_c_5616_p N_CLK_c_6819_n ) capacitor c=5.40058e-19 \
 //x=53.77 //y=2.26 //x2=54.88 //y2=2.375
cc_4521 ( N_noxref_13_c_5619_p N_CLK_c_6819_n ) capacitor c=0.00142893f \
 //x=53.47 //y=2.095 //x2=54.88 //y2=2.375
cc_4522 ( N_noxref_13_c_5568_n N_CLK_c_6822_n ) capacitor c=0.0112048f \
 //x=53.77 //y=4.755 //x2=54.88 //y2=4.755
cc_4523 ( N_noxref_13_c_5621_p N_CLK_c_6822_n ) capacitor c=8.35331e-19 \
 //x=53.77 //y=4.88 //x2=54.88 //y2=4.755
cc_4524 ( N_noxref_13_c_5622_p N_CLK_c_6822_n ) capacitor c=7.55789e-19 \
 //x=54.335 //y=4.97 //x2=54.88 //y2=4.755
cc_4525 ( N_noxref_13_c_5623_p N_CLK_c_6822_n ) capacitor c=8.63332e-19 \
 //x=54.045 //y=4.97 //x2=54.88 //y2=4.755
cc_4526 ( N_noxref_13_c_5585_n N_CLK_c_6683_n ) capacitor c=0.00721625f \
 //x=51.325 //y=5.38 //x2=50.795 //y2=4.62
cc_4527 ( N_noxref_13_c_5574_n N_CLK_c_6683_n ) capacitor c=0.0154295f \
 //x=50.56 //y=5.56 //x2=50.795 //y2=4.62
cc_4528 ( N_noxref_13_c_5626_p N_CLK_c_6828_n ) capacitor c=0.00542891f \
 //x=51.44 //y=5.38 //x2=51.395 //y2=4.63
cc_4529 ( N_noxref_13_c_5572_n N_CLK_c_6829_n ) capacitor c=0.0332184f \
 //x=58.58 //y=4.755 //x2=56.94 //y2=4.635
cc_4530 ( N_noxref_13_c_5562_n N_CLK_c_6830_n ) capacitor c=0.0289828f \
 //x=51.92 //y=5.295 //x2=56.595 //y2=4.635
cc_4531 ( N_noxref_13_c_5568_n N_CLK_c_6830_n ) capacitor c=0.0375889f \
 //x=53.77 //y=4.755 //x2=56.595 //y2=4.635
cc_4532 ( N_noxref_13_c_5626_p N_CLK_c_6830_n ) capacitor c=0.0155304f \
 //x=51.44 //y=5.38 //x2=56.595 //y2=4.635
cc_4533 ( N_noxref_13_c_5617_p N_CLK_c_6833_n ) capacitor c=5.39999e-19 \
 //x=53.77 //y=2.375 //x2=54.88 //y2=2.26
cc_4534 ( N_noxref_13_c_5610_p N_CLK_c_6833_n ) capacitor c=3.9149e-19 \
 //x=53.77 //y=2.61 //x2=54.88 //y2=2.26
cc_4535 ( N_noxref_13_c_5616_p N_CLK_c_6833_n ) capacitor c=0.00125213f \
 //x=53.77 //y=2.26 //x2=54.88 //y2=2.26
cc_4536 ( N_noxref_13_c_5619_p N_CLK_c_6833_n ) capacitor c=0.00214573f \
 //x=53.47 //y=2.095 //x2=54.88 //y2=2.26
cc_4537 ( N_noxref_13_c_5568_n N_CLK_c_6837_n ) capacitor c=5.64453e-19 \
 //x=53.77 //y=4.755 //x2=54.88 //y2=4.88
cc_4538 ( N_noxref_13_c_5621_p N_CLK_c_6837_n ) capacitor c=0.00113668f \
 //x=53.77 //y=4.88 //x2=54.88 //y2=4.88
cc_4539 ( N_noxref_13_c_5622_p N_CLK_c_6837_n ) capacitor c=0.00116563f \
 //x=54.335 //y=4.97 //x2=54.88 //y2=4.88
cc_4540 ( N_noxref_13_c_5623_p N_CLK_c_6837_n ) capacitor c=0.0012974f \
 //x=54.045 //y=4.97 //x2=54.88 //y2=4.88
cc_4541 ( N_noxref_13_M116_noxref_g N_CLK_M118_noxref_g ) capacitor \
 c=0.0106276f //x=53.97 //y=6.2 //x2=54.85 //y2=6.2
cc_4542 ( N_noxref_13_M117_noxref_g N_CLK_M118_noxref_g ) capacitor \
 c=0.107144f //x=54.41 //y=6.2 //x2=54.85 //y2=6.2
cc_4543 ( N_noxref_13_M117_noxref_g N_CLK_M119_noxref_g ) capacitor \
 c=0.0101598f //x=54.41 //y=6.2 //x2=55.29 //y2=6.2
cc_4544 ( N_noxref_13_c_5642_p N_CLK_c_6844_n ) capacitor c=5.72528e-19 \
 //x=53.47 //y=1.055 //x2=54.445 //y2=1.09
cc_4545 ( N_noxref_13_c_5643_p N_CLK_c_6844_n ) capacitor c=0.00150277f \
 //x=53.47 //y=1.4 //x2=54.445 //y2=1.09
cc_4546 ( N_noxref_13_c_5644_p N_CLK_c_6844_n ) capacitor c=0.0160123f //x=54 \
 //y=1.055 //x2=54.445 //y2=1.09
cc_4547 ( N_noxref_13_c_5645_p N_CLK_c_6847_n ) capacitor c=0.00111227f \
 //x=53.47 //y=1.71 //x2=54.445 //y2=1.4
cc_4548 ( N_noxref_13_c_5646_p N_CLK_c_6847_n ) capacitor c=0.0124075f //x=54 \
 //y=1.4 //x2=54.445 //y2=1.4
cc_4549 ( N_noxref_13_c_5644_p N_CLK_c_6849_n ) capacitor c=9.19165e-19 //x=54 \
 //y=1.055 //x2=54.97 //y2=1.09
cc_4550 ( N_noxref_13_c_5646_p N_CLK_c_6850_n ) capacitor c=0.0010154f //x=54 \
 //y=1.4 //x2=54.97 //y2=1.4
cc_4551 ( N_noxref_13_c_5646_p N_CLK_c_6851_n ) capacitor c=9.23422e-19 //x=54 \
 //y=1.4 //x2=54.97 //y2=1.63
cc_4552 ( N_noxref_13_c_5617_p N_CLK_c_6852_n ) capacitor c=0.0013537f \
 //x=53.77 //y=2.375 //x2=54.97 //y2=2.095
cc_4553 ( N_noxref_13_c_5616_p N_CLK_c_6852_n ) capacitor c=0.0020754f \
 //x=53.77 //y=2.26 //x2=54.97 //y2=2.095
cc_4554 ( N_noxref_13_c_5619_p N_CLK_c_6852_n ) capacitor c=0.00964411f \
 //x=53.47 //y=2.095 //x2=54.97 //y2=2.095
cc_4555 ( N_noxref_13_c_5621_p N_CLK_c_6855_n ) capacitor c=0.00123917f \
 //x=53.77 //y=4.88 //x2=54.88 //y2=4.88
cc_4556 ( N_noxref_13_c_5622_p N_CLK_c_6855_n ) capacitor c=0.0171228f \
 //x=54.335 //y=4.97 //x2=54.88 //y2=4.88
cc_4557 ( N_noxref_13_c_5623_p N_CLK_c_6855_n ) capacitor c=0.00406071f \
 //x=54.045 //y=4.97 //x2=54.88 //y2=4.88
cc_4558 ( N_noxref_13_c_5558_n N_noxref_16_c_7276_n ) capacitor c=0.00808595f \
 //x=51.92 //y=2.61 //x2=51.18 //y2=4.085
cc_4559 ( N_noxref_13_c_5559_n N_noxref_16_c_7276_n ) capacitor c=0.0145146f \
 //x=51.92 //y=2.93 //x2=51.18 //y2=4.085
cc_4560 ( N_noxref_13_c_5562_n N_noxref_16_c_7276_n ) capacitor c=0.0470699f \
 //x=51.92 //y=5.295 //x2=51.18 //y2=4.085
cc_4561 ( N_noxref_13_c_5610_p N_noxref_16_c_7276_n ) capacitor c=4.35484e-19 \
 //x=53.77 //y=2.61 //x2=51.18 //y2=4.085
cc_4562 ( N_noxref_13_c_5568_n N_noxref_16_c_7276_n ) capacitor c=9.15031e-19 \
 //x=53.77 //y=4.755 //x2=51.18 //y2=4.085
cc_4563 ( N_noxref_13_c_5661_p N_noxref_16_c_7276_n ) capacitor c=5.56364e-19 \
 //x=51.92 //y=2.77 //x2=51.18 //y2=4.085
cc_4564 ( N_noxref_13_c_5579_n N_noxref_16_c_7276_n ) capacitor c=0.00380567f \
 //x=52.08 //y=2.77 //x2=51.18 //y2=4.085
cc_4565 ( N_noxref_13_c_5585_n N_noxref_16_c_7297_n ) capacitor c=0.00206983f \
 //x=51.325 //y=5.38 //x2=51.18 //y2=4.405
cc_4566 ( N_noxref_13_c_5557_n N_noxref_16_c_7297_n ) capacitor c=3.54885e-19 \
 //x=51.565 //y=1.835 //x2=51.18 //y2=4.405
cc_4567 ( N_noxref_13_c_5562_n N_noxref_16_c_7297_n ) capacitor c=0.0173413f \
 //x=51.92 //y=5.295 //x2=51.18 //y2=4.405
cc_4568 ( N_noxref_13_c_5626_p N_noxref_16_c_7297_n ) capacitor c=0.00244912f \
 //x=51.44 //y=5.38 //x2=51.18 //y2=4.405
cc_4569 ( N_noxref_13_c_5667_p N_noxref_16_c_7297_n ) capacitor c=8.00244e-19 \
 //x=51.44 //y=5.56 //x2=51.18 //y2=4.405
cc_4570 ( N_noxref_13_c_5585_n N_noxref_16_c_7282_n ) capacitor c=0.0215498f \
 //x=51.325 //y=5.38 //x2=51.18 //y2=4.735
cc_4571 ( N_noxref_13_c_5562_n N_noxref_16_c_7282_n ) capacitor c=0.0286696f \
 //x=51.92 //y=5.295 //x2=51.18 //y2=4.735
cc_4572 ( N_noxref_13_c_5568_n N_noxref_16_c_7282_n ) capacitor c=4.5647e-19 \
 //x=53.77 //y=4.755 //x2=51.18 //y2=4.735
cc_4573 ( N_noxref_13_M117_noxref_g N_noxref_16_c_7348_n ) capacitor \
 c=0.00893512f //x=54.41 //y=6.2 //x2=54.95 //y2=5.335
cc_4574 ( N_noxref_13_c_5672_p N_noxref_16_c_7349_n ) capacitor c=8.29536e-19 \
 //x=51.835 //y=1.835 //x2=56.245 //y2=1.76
cc_4575 ( N_noxref_13_c_5558_n N_noxref_16_c_7350_n ) capacitor c=8.29536e-19 \
 //x=51.92 //y=2.61 //x2=56.33 //y2=1.845
cc_4576 ( N_noxref_13_c_5674_p N_noxref_16_c_7283_n ) capacitor c=0.00352213f \
 //x=58.58 //y=2.375 //x2=56.73 //y2=4.09
cc_4577 ( N_noxref_13_c_5675_p N_noxref_16_c_7283_n ) capacitor c=0.00236852f \
 //x=58.58 //y=2.615 //x2=56.73 //y2=4.09
cc_4578 ( N_noxref_13_c_5570_n N_noxref_16_c_7283_n ) capacitor c=0.00248106f \
 //x=58.58 //y=2.935 //x2=56.73 //y2=4.09
cc_4579 ( N_noxref_13_c_5572_n N_noxref_16_c_7283_n ) capacitor c=0.0140962f \
 //x=58.58 //y=4.755 //x2=56.73 //y2=4.09
cc_4580 ( N_noxref_13_c_5582_n N_noxref_16_c_7283_n ) capacitor c=0.0015808f \
 //x=58.58 //y=2.775 //x2=56.73 //y2=4.09
cc_4581 ( N_noxref_13_c_5583_n N_noxref_16_c_7283_n ) capacitor c=0.0231249f \
 //x=58.42 //y=2.775 //x2=56.73 //y2=4.09
cc_4582 ( N_noxref_13_c_5572_n N_noxref_16_c_7357_n ) capacitor c=0.00251118f \
 //x=58.58 //y=4.755 //x2=56.73 //y2=4.41
cc_4583 ( N_noxref_13_c_5572_n N_noxref_16_c_7358_n ) capacitor c=0.00765202f \
 //x=58.58 //y=4.755 //x2=56.73 //y2=5.25
cc_4584 ( N_noxref_13_c_5558_n N_noxref_16_c_7302_n ) capacitor c=0.0135969f \
 //x=51.92 //y=2.61 //x2=51.18 //y2=2.26
cc_4585 ( N_noxref_13_c_5562_n N_noxref_16_c_7285_n ) capacitor c=5.56185e-19 \
 //x=51.92 //y=5.295 //x2=51.18 //y2=4.25
cc_4586 ( N_noxref_13_c_5562_n N_noxref_16_c_7361_n ) capacitor c=0.00261914f \
 //x=51.92 //y=5.295 //x2=54.192 //y2=5.335
cc_4587 ( N_noxref_13_c_5626_p N_noxref_16_c_7361_n ) capacitor c=5.0812e-19 \
 //x=51.44 //y=5.38 //x2=54.192 //y2=5.335
cc_4588 ( N_noxref_13_M116_noxref_g N_noxref_16_c_7361_n ) capacitor \
 c=0.00461408f //x=53.97 //y=6.2 //x2=54.192 //y2=5.335
cc_4589 ( N_noxref_13_M117_noxref_g N_noxref_16_c_7361_n ) capacitor \
 c=0.00229208f //x=54.41 //y=6.2 //x2=54.192 //y2=5.335
cc_4590 ( N_noxref_13_c_5622_p N_noxref_16_c_7361_n ) capacitor c=0.00171885f \
 //x=54.335 //y=4.97 //x2=54.192 //y2=5.335
cc_4591 ( N_noxref_13_c_5562_n N_noxref_16_c_7286_n ) capacitor c=0.0249388f \
 //x=51.92 //y=5.295 //x2=56.565 //y2=4.25
cc_4592 ( N_noxref_13_c_5568_n N_noxref_16_c_7286_n ) capacitor c=0.0274592f \
 //x=53.77 //y=4.755 //x2=56.565 //y2=4.25
cc_4593 ( N_noxref_13_c_5572_n N_noxref_16_c_7368_n ) capacitor c=0.00157696f \
 //x=58.58 //y=4.755 //x2=56.885 //y2=4.25
cc_4594 ( N_noxref_13_c_5562_n N_noxref_16_c_7290_n ) capacitor c=0.0032735f \
 //x=51.92 //y=5.295 //x2=51.34 //y2=4.245
cc_4595 ( N_noxref_13_c_5572_n N_noxref_16_c_7370_n ) capacitor c=0.0245637f \
 //x=58.58 //y=4.755 //x2=66.56 //y2=4.265
cc_4596 ( N_noxref_13_c_5558_n N_noxref_16_c_7307_n ) capacitor c=9.26054e-19 \
 //x=51.92 //y=2.61 //x2=51.18 //y2=2.26
cc_4597 ( N_noxref_13_c_5585_n N_noxref_16_c_7311_n ) capacitor c=0.00469257f \
 //x=51.325 //y=5.38 //x2=51.21 //y2=4.88
cc_4598 ( N_noxref_13_c_5562_n N_noxref_16_c_7311_n ) capacitor c=7.76118e-19 \
 //x=51.92 //y=5.295 //x2=51.21 //y2=4.88
cc_4599 ( N_noxref_13_M116_noxref_g N_noxref_16_c_7374_n ) capacitor \
 c=0.0162284f //x=53.97 //y=6.2 //x2=54.19 //y2=5.56
cc_4600 ( N_noxref_13_M117_noxref_g N_noxref_16_c_7374_n ) capacitor \
 c=0.0179041f //x=54.41 //y=6.2 //x2=54.19 //y2=5.56
cc_4601 ( N_noxref_13_c_5622_p N_noxref_16_c_7374_n ) capacitor c=0.00291477f \
 //x=54.335 //y=4.97 //x2=54.19 //y2=5.56
cc_4602 ( N_noxref_13_c_5585_n N_noxref_16_M114_noxref_g ) capacitor \
 c=0.00842859f //x=51.325 //y=5.38 //x2=51.22 //y2=6.2
cc_4603 ( N_noxref_13_c_5626_p N_noxref_16_M114_noxref_g ) capacitor \
 c=0.00192712f //x=51.44 //y=5.38 //x2=51.22 //y2=6.2
cc_4604 ( N_noxref_13_c_5667_p N_noxref_16_M114_noxref_g ) capacitor \
 c=0.0178987f //x=51.44 //y=5.56 //x2=51.22 //y2=6.2
cc_4605 ( N_noxref_13_c_5703_p N_noxref_16_M115_noxref_g ) capacitor \
 c=0.0106088f //x=51.835 //y=5.38 //x2=51.66 //y2=6.2
cc_4606 ( N_noxref_13_c_5626_p N_noxref_16_M115_noxref_g ) capacitor \
 c=0.00312463f //x=51.44 //y=5.38 //x2=51.66 //y2=6.2
cc_4607 ( N_noxref_13_c_5667_p N_noxref_16_M115_noxref_g ) capacitor \
 c=0.0178506f //x=51.44 //y=5.56 //x2=51.66 //y2=6.2
cc_4608 ( N_noxref_13_c_5576_n N_noxref_16_c_7317_n ) capacitor c=0.00120406f \
 //x=51.48 //y=1.18 //x2=51.215 //y2=1.085
cc_4609 ( N_noxref_13_M31_noxref_d N_noxref_16_c_7317_n ) capacitor \
 c=0.00137165f //x=51.29 //y=1.085 //x2=51.215 //y2=1.085
cc_4610 ( N_noxref_13_c_5556_n N_noxref_16_c_7320_n ) capacitor c=0.00119302f \
 //x=51.48 //y=1.75 //x2=51.215 //y2=1.43
cc_4611 ( N_noxref_13_c_5576_n N_noxref_16_c_7320_n ) capacitor c=0.00218772f \
 //x=51.48 //y=1.18 //x2=51.215 //y2=1.43
cc_4612 ( N_noxref_13_M31_noxref_d N_noxref_16_c_7320_n ) capacitor \
 c=0.00237422f //x=51.29 //y=1.085 //x2=51.215 //y2=1.43
cc_4613 ( N_noxref_13_c_5556_n N_noxref_16_c_7322_n ) capacitor c=0.00439215f \
 //x=51.48 //y=1.75 //x2=51.215 //y2=1.74
cc_4614 ( N_noxref_13_c_5562_n N_noxref_16_c_7389_n ) capacitor c=0.00845606f \
 //x=51.92 //y=5.295 //x2=51.585 //y2=4.97
cc_4615 ( N_noxref_13_c_5626_p N_noxref_16_c_7389_n ) capacitor c=0.0020269f \
 //x=51.44 //y=5.38 //x2=51.585 //y2=4.97
cc_4616 ( N_noxref_13_c_5667_p N_noxref_16_c_7389_n ) capacitor c=0.00302834f \
 //x=51.44 //y=5.56 //x2=51.585 //y2=4.97
cc_4617 ( N_noxref_13_c_5576_n N_noxref_16_c_7392_n ) capacitor c=5.50523e-19 \
 //x=51.48 //y=1.18 //x2=51.59 //y2=0.93
cc_4618 ( N_noxref_13_M31_noxref_d N_noxref_16_c_7392_n ) capacitor \
 c=0.0020782f //x=51.29 //y=1.085 //x2=51.59 //y2=0.93
cc_4619 ( N_noxref_13_c_5556_n N_noxref_16_c_7394_n ) capacitor c=0.00929773f \
 //x=51.48 //y=1.75 //x2=51.59 //y2=1.585
cc_4620 ( N_noxref_13_c_5672_p N_noxref_16_c_7394_n ) capacitor c=0.00194324f \
 //x=51.835 //y=1.835 //x2=51.59 //y2=1.585
cc_4621 ( N_noxref_13_c_5576_n N_noxref_16_c_7394_n ) capacitor c=5.43945e-19 \
 //x=51.48 //y=1.18 //x2=51.59 //y2=1.585
cc_4622 ( N_noxref_13_M31_noxref_d N_noxref_16_c_7394_n ) capacitor \
 c=0.00356097f //x=51.29 //y=1.085 //x2=51.59 //y2=1.585
cc_4623 ( N_noxref_13_c_5576_n N_noxref_16_c_7325_n ) capacitor c=0.00108157f \
 //x=51.48 //y=1.18 //x2=51.745 //y2=1.085
cc_4624 ( N_noxref_13_M31_noxref_d N_noxref_16_c_7325_n ) capacitor \
 c=8.50095e-19 //x=51.29 //y=1.085 //x2=51.745 //y2=1.085
cc_4625 ( N_noxref_13_c_5556_n N_noxref_16_c_7326_n ) capacitor c=0.00341295f \
 //x=51.48 //y=1.75 //x2=51.745 //y2=1.43
cc_4626 ( N_noxref_13_c_5672_p N_noxref_16_c_7326_n ) capacitor c=0.00323005f \
 //x=51.835 //y=1.835 //x2=51.745 //y2=1.43
cc_4627 ( N_noxref_13_c_5576_n N_noxref_16_c_7326_n ) capacitor c=0.00312028f \
 //x=51.48 //y=1.18 //x2=51.745 //y2=1.43
cc_4628 ( N_noxref_13_M31_noxref_d N_noxref_16_c_7326_n ) capacitor \
 c=0.00237422f //x=51.29 //y=1.085 //x2=51.745 //y2=1.43
cc_4629 ( N_noxref_13_c_5558_n N_noxref_16_c_7327_n ) capacitor c=0.00267229f \
 //x=51.92 //y=2.61 //x2=51.18 //y2=2.26
cc_4630 ( N_noxref_13_c_5556_n N_noxref_16_c_7405_n ) capacitor c=0.00341688f \
 //x=51.48 //y=1.75 //x2=51.18 //y2=2.095
cc_4631 ( N_noxref_13_c_5558_n N_noxref_16_c_7405_n ) capacitor c=0.00309058f \
 //x=51.92 //y=2.61 //x2=51.18 //y2=2.095
cc_4632 ( N_noxref_13_c_5585_n N_noxref_16_c_7330_n ) capacitor c=8.43115e-19 \
 //x=51.325 //y=5.38 //x2=51.21 //y2=4.88
cc_4633 ( N_noxref_13_c_5562_n N_noxref_16_c_7330_n ) capacitor c=0.00142201f \
 //x=51.92 //y=5.295 //x2=51.21 //y2=4.88
cc_4634 ( N_noxref_13_c_5675_p SN ) capacitor c=0.00188309f //x=58.58 \
 //y=2.615 //x2=59.69 //y2=2.77
cc_4635 ( N_noxref_13_c_5570_n SN ) capacitor c=0.00775314f //x=58.58 \
 //y=2.935 //x2=59.69 //y2=2.77
cc_4636 ( N_noxref_13_c_5572_n SN ) capacitor c=0.0412673f //x=58.58 //y=4.755 \
 //x2=59.69 //y2=2.77
cc_4637 ( N_noxref_13_c_5604_p SN ) capacitor c=2.69051e-19 //x=58.58 //y=2.77 \
 //x2=59.69 //y2=2.77
cc_4638 ( N_noxref_13_c_5582_n SN ) capacitor c=0.00508119f //x=58.58 \
 //y=2.775 //x2=59.69 //y2=2.77
cc_4639 ( N_noxref_13_c_5737_p SN ) capacitor c=3.36194e-19 //x=58.58 //y=4.88 \
 //x2=59.69 //y2=2.77
cc_4640 ( N_noxref_13_c_5674_p N_SN_c_8500_n ) capacitor c=0.00790396f \
 //x=58.58 //y=2.375 //x2=59.69 //y2=2.55
cc_4641 ( N_noxref_13_c_5675_p N_SN_c_8500_n ) capacitor c=0.00345228f \
 //x=58.58 //y=2.615 //x2=59.69 //y2=2.55
cc_4642 ( N_noxref_13_c_5740_p N_SN_c_8500_n ) capacitor c=0.00116411f \
 //x=58.58 //y=2.26 //x2=59.69 //y2=2.55
cc_4643 ( N_noxref_13_c_5741_p N_SN_c_8500_n ) capacitor c=0.0015646f \
 //x=58.28 //y=2.095 //x2=59.69 //y2=2.55
cc_4644 ( N_noxref_13_c_5572_n N_SN_c_8591_n ) capacitor c=0.0110307f \
 //x=58.58 //y=4.755 //x2=59.69 //y2=4.765
cc_4645 ( N_noxref_13_c_5737_p N_SN_c_8591_n ) capacitor c=2.89813e-19 \
 //x=58.58 //y=4.88 //x2=59.69 //y2=4.765
cc_4646 ( N_noxref_13_c_5603_p N_SN_c_8591_n ) capacitor c=7.66769e-19 \
 //x=59.145 //y=4.97 //x2=59.69 //y2=4.765
cc_4647 ( N_noxref_13_c_5745_p N_SN_c_8591_n ) capacitor c=7.54501e-19 \
 //x=58.855 //y=4.97 //x2=59.69 //y2=4.765
cc_4648 ( N_noxref_13_c_5558_n N_SN_c_8506_n ) capacitor c=0.0275808f \
 //x=51.92 //y=2.61 //x2=52.135 //y2=2.385
cc_4649 ( N_noxref_13_c_5559_n N_SN_c_8506_n ) capacitor c=0.00571217f \
 //x=51.92 //y=2.93 //x2=52.135 //y2=2.385
cc_4650 ( N_noxref_13_c_5577_n N_SN_c_8506_n ) capacitor c=0.132536f //x=53.61 \
 //y=2.77 //x2=52.135 //y2=2.385
cc_4651 ( N_noxref_13_c_5579_n N_SN_c_8506_n ) capacitor c=0.0365231f \
 //x=52.08 //y=2.77 //x2=52.135 //y2=2.385
cc_4652 ( N_noxref_13_c_5672_p N_SN_c_8385_n ) capacitor c=0.00854423f \
 //x=51.835 //y=1.835 //x2=51.705 //y2=2.385
cc_4653 ( N_noxref_13_c_5557_n N_SN_c_8385_n ) capacitor c=0.0104657f \
 //x=51.565 //y=1.835 //x2=51.705 //y2=2.385
cc_4654 ( N_noxref_13_c_5558_n N_SN_c_8385_n ) capacitor c=3.12067e-19 \
 //x=51.92 //y=2.61 //x2=51.705 //y2=2.385
cc_4655 ( N_noxref_13_c_5576_n N_SN_c_8385_n ) capacitor c=7.47115e-19 \
 //x=51.48 //y=1.18 //x2=51.705 //y2=2.385
cc_4656 ( N_noxref_13_c_5610_p N_SN_c_8514_n ) capacitor c=5.02803e-19 \
 //x=53.77 //y=2.61 //x2=53.385 //y2=2.4
cc_4657 ( N_noxref_13_c_5577_n N_SN_c_8514_n ) capacitor c=0.0124949f \
 //x=53.61 //y=2.77 //x2=53.385 //y2=2.4
cc_4658 ( N_noxref_13_c_5617_p N_SN_c_8515_n ) capacitor c=0.0168589f \
 //x=53.77 //y=2.375 //x2=53.985 //y2=2.385
cc_4659 ( N_noxref_13_c_5610_p N_SN_c_8515_n ) capacitor c=0.0125409f \
 //x=53.77 //y=2.61 //x2=53.985 //y2=2.385
cc_4660 ( N_noxref_13_c_5566_n N_SN_c_8515_n ) capacitor c=0.0074164f \
 //x=53.77 //y=2.93 //x2=53.985 //y2=2.385
cc_4661 ( N_noxref_13_c_5581_n N_SN_c_8515_n ) capacitor c=0.0370413f \
 //x=53.93 //y=2.77 //x2=53.985 //y2=2.385
cc_4662 ( N_noxref_13_c_5583_n N_SN_c_8515_n ) capacitor c=0.398778f //x=58.42 \
 //y=2.775 //x2=53.985 //y2=2.385
cc_4663 ( N_noxref_13_c_5616_p N_SN_c_8515_n ) capacitor c=5.18204e-19 \
 //x=53.77 //y=2.26 //x2=53.985 //y2=2.385
cc_4664 ( N_noxref_13_c_5619_p N_SN_c_8515_n ) capacitor c=3.41298e-19 \
 //x=53.47 //y=2.095 //x2=53.985 //y2=2.385
cc_4665 ( N_noxref_13_c_5675_p N_SN_c_8516_n ) capacitor c=3.12053e-19 \
 //x=58.58 //y=2.615 //x2=58.195 //y2=2.4
cc_4666 ( N_noxref_13_c_5570_n N_SN_c_8516_n ) capacitor c=0.00336759f \
 //x=58.58 //y=2.935 //x2=58.195 //y2=2.4
cc_4667 ( N_noxref_13_c_5583_n N_SN_c_8516_n ) capacitor c=0.0111801f \
 //x=58.42 //y=2.775 //x2=58.195 //y2=2.4
cc_4668 ( N_noxref_13_c_5674_p N_SN_c_8517_n ) capacitor c=0.0163574f \
 //x=58.58 //y=2.375 //x2=58.795 //y2=2.39
cc_4669 ( N_noxref_13_c_5675_p N_SN_c_8517_n ) capacitor c=0.012564f //x=58.58 \
 //y=2.615 //x2=58.795 //y2=2.39
cc_4670 ( N_noxref_13_c_5570_n N_SN_c_8517_n ) capacitor c=0.00455777f \
 //x=58.58 //y=2.935 //x2=58.795 //y2=2.39
cc_4671 ( N_noxref_13_c_5582_n N_SN_c_8517_n ) capacitor c=0.0370413f \
 //x=58.58 //y=2.775 //x2=58.795 //y2=2.39
cc_4672 ( N_noxref_13_c_5740_p N_SN_c_8517_n ) capacitor c=2.54369e-19 \
 //x=58.58 //y=2.26 //x2=58.795 //y2=2.39
cc_4673 ( N_noxref_13_c_5741_p N_SN_c_8517_n ) capacitor c=3.41298e-19 \
 //x=58.28 //y=2.095 //x2=58.795 //y2=2.39
cc_4674 ( N_noxref_13_c_5674_p N_SN_c_8518_n ) capacitor c=0.00183592f \
 //x=58.58 //y=2.375 //x2=59.85 //y2=2.4
cc_4675 ( N_noxref_13_c_5675_p N_SN_c_8518_n ) capacitor c=0.00129472f \
 //x=58.58 //y=2.615 //x2=59.85 //y2=2.4
cc_4676 ( N_noxref_13_c_5674_p N_SN_c_8623_n ) capacitor c=5.39999e-19 \
 //x=58.58 //y=2.375 //x2=59.69 //y2=2.26
cc_4677 ( N_noxref_13_c_5740_p N_SN_c_8623_n ) capacitor c=0.00124907f \
 //x=58.58 //y=2.26 //x2=59.69 //y2=2.26
cc_4678 ( N_noxref_13_c_5741_p N_SN_c_8623_n ) capacitor c=0.00214501f \
 //x=58.28 //y=2.095 //x2=59.69 //y2=2.26
cc_4679 ( N_noxref_13_c_5572_n N_SN_c_8626_n ) capacitor c=0.00103399f \
 //x=58.58 //y=4.755 //x2=59.69 //y2=4.88
cc_4680 ( N_noxref_13_c_5737_p N_SN_c_8626_n ) capacitor c=0.00113984f \
 //x=58.58 //y=4.88 //x2=59.69 //y2=4.88
cc_4681 ( N_noxref_13_c_5603_p N_SN_c_8626_n ) capacitor c=0.00116563f \
 //x=59.145 //y=4.97 //x2=59.69 //y2=4.88
cc_4682 ( N_noxref_13_c_5745_p N_SN_c_8626_n ) capacitor c=0.00129812f \
 //x=58.855 //y=4.97 //x2=59.69 //y2=4.88
cc_4683 ( N_noxref_13_M122_noxref_g N_SN_M124_noxref_g ) capacitor \
 c=0.0106276f //x=58.78 //y=6.2 //x2=59.66 //y2=6.2
cc_4684 ( N_noxref_13_M123_noxref_g N_SN_M124_noxref_g ) capacitor c=0.107144f \
 //x=59.22 //y=6.2 //x2=59.66 //y2=6.2
cc_4685 ( N_noxref_13_M123_noxref_g N_SN_M125_noxref_g ) capacitor \
 c=0.0101598f //x=59.22 //y=6.2 //x2=60.1 //y2=6.2
cc_4686 ( N_noxref_13_c_5784_p N_SN_c_8633_n ) capacitor c=5.72528e-19 \
 //x=58.28 //y=1.055 //x2=59.255 //y2=1.09
cc_4687 ( N_noxref_13_c_5785_p N_SN_c_8633_n ) capacitor c=0.00150277f \
 //x=58.28 //y=1.4 //x2=59.255 //y2=1.09
cc_4688 ( N_noxref_13_c_5786_p N_SN_c_8633_n ) capacitor c=0.0160123f \
 //x=58.81 //y=1.055 //x2=59.255 //y2=1.09
cc_4689 ( N_noxref_13_c_5787_p N_SN_c_8636_n ) capacitor c=0.00111227f \
 //x=58.28 //y=1.71 //x2=59.255 //y2=1.4
cc_4690 ( N_noxref_13_c_5788_p N_SN_c_8636_n ) capacitor c=0.0124075f \
 //x=58.81 //y=1.4 //x2=59.255 //y2=1.4
cc_4691 ( N_noxref_13_c_5786_p N_SN_c_8638_n ) capacitor c=9.19165e-19 \
 //x=58.81 //y=1.055 //x2=59.78 //y2=1.09
cc_4692 ( N_noxref_13_c_5788_p N_SN_c_8639_n ) capacitor c=0.0010154f \
 //x=58.81 //y=1.4 //x2=59.78 //y2=1.4
cc_4693 ( N_noxref_13_c_5788_p N_SN_c_8640_n ) capacitor c=9.23422e-19 \
 //x=58.81 //y=1.4 //x2=59.78 //y2=1.63
cc_4694 ( N_noxref_13_c_5674_p N_SN_c_8641_n ) capacitor c=5.616e-19 //x=58.58 \
 //y=2.375 //x2=59.78 //y2=2.095
cc_4695 ( N_noxref_13_c_5740_p N_SN_c_8641_n ) capacitor c=0.0017273f \
 //x=58.58 //y=2.26 //x2=59.78 //y2=2.095
cc_4696 ( N_noxref_13_c_5741_p N_SN_c_8641_n ) capacitor c=0.00880777f \
 //x=58.28 //y=2.095 //x2=59.78 //y2=2.095
cc_4697 ( N_noxref_13_c_5572_n N_SN_c_8644_n ) capacitor c=0.00116212f \
 //x=58.58 //y=4.755 //x2=59.69 //y2=4.88
cc_4698 ( N_noxref_13_c_5737_p N_SN_c_8644_n ) capacitor c=0.00155973f \
 //x=58.58 //y=4.88 //x2=59.69 //y2=4.88
cc_4699 ( N_noxref_13_c_5603_p N_SN_c_8644_n ) capacitor c=0.0171374f \
 //x=59.145 //y=4.97 //x2=59.69 //y2=4.88
cc_4700 ( N_noxref_13_c_5745_p N_SN_c_8644_n ) capacitor c=0.00484466f \
 //x=58.855 //y=4.97 //x2=59.69 //y2=4.88
cc_4701 ( N_noxref_13_c_5610_p N_noxref_19_c_9261_n ) capacitor c=2.8271e-19 \
 //x=53.77 //y=2.61 //x2=55.99 //y2=3.705
cc_4702 ( N_noxref_13_c_5568_n N_noxref_19_c_9261_n ) capacitor c=4.89542e-19 \
 //x=53.77 //y=4.755 //x2=55.99 //y2=3.705
cc_4703 ( N_noxref_13_c_5675_p N_noxref_19_c_9261_n ) capacitor c=4.4924e-19 \
 //x=58.58 //y=2.615 //x2=55.99 //y2=3.705
cc_4704 ( N_noxref_13_c_5572_n N_noxref_19_c_9261_n ) capacitor c=5.49506e-19 \
 //x=58.58 //y=4.755 //x2=55.99 //y2=3.705
cc_4705 ( N_noxref_13_c_5583_n N_noxref_19_c_9261_n ) capacitor c=0.0220649f \
 //x=58.42 //y=2.775 //x2=55.99 //y2=3.705
cc_4706 ( N_noxref_13_c_5568_n N_noxref_19_c_9279_n ) capacitor c=7.96468e-19 \
 //x=53.77 //y=4.755 //x2=55.99 //y2=4.75
cc_4707 ( N_noxref_13_c_5572_n N_noxref_19_c_9279_n ) capacitor c=0.00104627f \
 //x=58.58 //y=4.755 //x2=55.99 //y2=4.75
cc_4708 ( N_noxref_13_c_5675_p N_noxref_19_c_9262_n ) capacitor c=3.63603e-19 \
 //x=58.58 //y=2.615 //x2=60.8 //y2=3.705
cc_4709 ( N_noxref_13_c_5572_n N_noxref_19_c_9262_n ) capacitor c=4.95724e-19 \
 //x=58.58 //y=4.755 //x2=60.8 //y2=3.705
cc_4710 ( N_noxref_13_c_5572_n N_noxref_19_c_9283_n ) capacitor c=5.89264e-19 \
 //x=58.58 //y=4.755 //x2=60.8 //y2=4.75
cc_4711 ( N_noxref_13_c_5572_n N_noxref_19_c_9267_n ) capacitor c=0.02492f \
 //x=58.58 //y=4.755 //x2=60.96 //y2=3.88
cc_4712 ( N_noxref_13_c_5562_n N_noxref_21_c_10666_n ) capacitor c=0.0258715f \
 //x=51.92 //y=5.295 //x2=55.61 //y2=3.51
cc_4713 ( N_noxref_13_c_5568_n N_noxref_21_c_10666_n ) capacitor c=0.0273114f \
 //x=53.77 //y=4.755 //x2=55.61 //y2=3.51
cc_4714 ( N_noxref_13_c_5577_n N_noxref_21_c_10666_n ) capacitor c=0.00880217f \
 //x=53.61 //y=2.77 //x2=55.61 //y2=3.51
cc_4715 ( N_noxref_13_c_5583_n N_noxref_21_c_10666_n ) capacitor c=0.0197386f \
 //x=58.42 //y=2.775 //x2=55.61 //y2=3.51
cc_4716 ( N_noxref_13_c_5583_n N_noxref_21_c_10672_n ) capacitor c=0.0129689f \
 //x=58.42 //y=2.775 //x2=56.21 //y2=3.48
cc_4717 ( N_noxref_13_c_5572_n N_noxref_21_c_10673_n ) capacitor c=0.0245532f \
 //x=58.58 //y=4.755 //x2=60.415 //y2=3.51
cc_4718 ( N_noxref_13_c_5585_n N_VDD_c_11522_n ) capacitor c=0.00648294f \
 //x=51.325 //y=5.38 //x2=74.455 //y2=7.585
cc_4719 ( N_noxref_13_c_5703_p N_VDD_c_11522_n ) capacitor c=0.00488503f \
 //x=51.835 //y=5.38 //x2=74.455 //y2=7.585
cc_4720 ( N_noxref_13_c_5574_n N_VDD_c_11522_n ) capacitor c=0.00368834f \
 //x=50.56 //y=5.56 //x2=74.455 //y2=7.585
cc_4721 ( N_noxref_13_c_5626_p N_VDD_c_11522_n ) capacitor c=8.42537e-19 \
 //x=51.44 //y=5.38 //x2=74.455 //y2=7.585
cc_4722 ( N_noxref_13_c_5820_p N_VDD_c_11522_n ) capacitor c=0.00285853f \
 //x=51.44 //y=5.56 //x2=74.455 //y2=7.585
cc_4723 ( N_noxref_13_c_5595_n N_VDD_c_11522_n ) capacitor c=0.00224881f \
 //x=50.56 //y=5.56 //x2=74.455 //y2=7.585
cc_4724 ( N_noxref_13_c_5667_p N_VDD_c_11522_n ) capacitor c=0.00224881f \
 //x=51.44 //y=5.56 //x2=74.455 //y2=7.585
cc_4725 ( N_noxref_13_c_5585_n N_VDD_c_12201_n ) capacitor c=0.00208087f \
 //x=51.325 //y=5.38 //x2=50.915 //y2=7.585
cc_4726 ( N_noxref_13_c_5574_n N_VDD_c_12201_n ) capacitor c=9.41185e-19 \
 //x=50.56 //y=5.56 //x2=50.915 //y2=7.585
cc_4727 ( N_noxref_13_c_5595_n N_VDD_c_12201_n ) capacitor c=0.0136705f \
 //x=50.56 //y=5.56 //x2=50.915 //y2=7.585
cc_4728 ( N_noxref_13_c_5585_n N_VDD_c_12233_n ) capacitor c=0.00180737f \
 //x=51.325 //y=5.38 //x2=51.795 //y2=7.585
cc_4729 ( N_noxref_13_c_5703_p N_VDD_c_12233_n ) capacitor c=0.00208087f \
 //x=51.835 //y=5.38 //x2=51.795 //y2=7.585
cc_4730 ( N_noxref_13_c_5626_p N_VDD_c_12233_n ) capacitor c=4.23719e-19 \
 //x=51.44 //y=5.38 //x2=51.795 //y2=7.585
cc_4731 ( N_noxref_13_c_5820_p N_VDD_c_12233_n ) capacitor c=5.77976e-19 \
 //x=51.44 //y=5.56 //x2=51.795 //y2=7.585
cc_4732 ( N_noxref_13_c_5667_p N_VDD_c_12233_n ) capacitor c=0.0136705f \
 //x=51.44 //y=5.56 //x2=51.795 //y2=7.585
cc_4733 ( N_noxref_13_M116_noxref_g N_VDD_c_12238_n ) capacitor c=0.00755614f \
 //x=53.97 //y=6.2 //x2=54.545 //y2=7.585
cc_4734 ( N_noxref_13_M117_noxref_g N_VDD_c_12238_n ) capacitor c=0.00755544f \
 //x=54.41 //y=6.2 //x2=54.545 //y2=7.585
cc_4735 ( N_noxref_13_M122_noxref_g N_VDD_c_12240_n ) capacitor c=0.00755614f \
 //x=58.78 //y=6.2 //x2=59.355 //y2=7.585
cc_4736 ( N_noxref_13_M123_noxref_g N_VDD_c_12240_n ) capacitor c=0.00755544f \
 //x=59.22 //y=6.2 //x2=59.355 //y2=7.585
cc_4737 ( N_noxref_13_c_5562_n N_VDD_c_12088_n ) capacitor c=0.0013228f \
 //x=51.92 //y=5.295 //x2=49.33 //y2=7.585
cc_4738 ( N_noxref_13_c_5574_n N_VDD_c_12088_n ) capacitor c=4.91377e-19 \
 //x=50.56 //y=5.56 //x2=49.33 //y2=7.585
cc_4739 ( N_noxref_13_c_5595_n N_VDD_c_12088_n ) capacitor c=0.0064135f \
 //x=50.56 //y=5.56 //x2=49.33 //y2=7.585
cc_4740 ( N_noxref_13_c_5562_n N_VDD_c_12245_n ) capacitor c=0.0294123f \
 //x=51.92 //y=5.295 //x2=52.66 //y2=7.585
cc_4741 ( N_noxref_13_c_5568_n N_VDD_c_12245_n ) capacitor c=0.0120355f \
 //x=53.77 //y=4.755 //x2=52.66 //y2=7.585
cc_4742 ( N_noxref_13_c_5626_p N_VDD_c_12245_n ) capacitor c=0.0025639f \
 //x=51.44 //y=5.38 //x2=52.66 //y2=7.585
cc_4743 ( N_noxref_13_c_5820_p N_VDD_c_12245_n ) capacitor c=4.19141e-19 \
 //x=51.44 //y=5.56 //x2=52.66 //y2=7.585
cc_4744 ( N_noxref_13_c_5667_p N_VDD_c_12245_n ) capacitor c=0.0101861f \
 //x=51.44 //y=5.56 //x2=52.66 //y2=7.585
cc_4745 ( N_noxref_13_c_5621_p N_VDD_c_12245_n ) capacitor c=0.00370784f \
 //x=53.77 //y=4.88 //x2=52.66 //y2=7.585
cc_4746 ( N_noxref_13_c_5623_p N_VDD_c_12245_n ) capacitor c=0.00590568f \
 //x=54.045 //y=4.97 //x2=52.66 //y2=7.585
cc_4747 ( N_noxref_13_c_5572_n N_VDD_c_12252_n ) capacitor c=0.0116769f \
 //x=58.58 //y=4.755 //x2=57.47 //y2=7.585
cc_4748 ( N_noxref_13_c_5737_p N_VDD_c_12252_n ) capacitor c=0.00370784f \
 //x=58.58 //y=4.88 //x2=57.47 //y2=7.585
cc_4749 ( N_noxref_13_c_5745_p N_VDD_c_12252_n ) capacitor c=0.00590568f \
 //x=58.855 //y=4.97 //x2=57.47 //y2=7.585
cc_4750 ( N_noxref_13_c_5574_n N_VDD_M112_noxref_s ) capacitor c=0.0611368f \
 //x=50.56 //y=5.56 //x2=49.985 //y2=5.2
cc_4751 ( N_noxref_13_c_5626_p N_VDD_M112_noxref_s ) capacitor c=6.52457e-19 \
 //x=51.44 //y=5.38 //x2=49.985 //y2=5.2
cc_4752 ( N_noxref_13_c_5595_n N_VDD_M112_noxref_s ) capacitor c=0.0887533f \
 //x=50.56 //y=5.56 //x2=49.985 //y2=5.2
cc_4753 ( N_noxref_13_c_5585_n N_VDD_M113_noxref_d ) capacitor c=0.00734094f \
 //x=51.325 //y=5.38 //x2=50.855 //y2=5.2
cc_4754 ( N_noxref_13_c_5574_n N_VDD_M113_noxref_d ) capacitor c=0.0043528f \
 //x=50.56 //y=5.56 //x2=50.855 //y2=5.2
cc_4755 ( N_noxref_13_c_5820_p N_VDD_M113_noxref_d ) capacitor c=0.0043528f \
 //x=51.44 //y=5.56 //x2=50.855 //y2=5.2
cc_4756 ( N_noxref_13_c_5595_n N_VDD_M113_noxref_d ) capacitor c=0.065554f \
 //x=50.56 //y=5.56 //x2=50.855 //y2=5.2
cc_4757 ( N_noxref_13_c_5667_p N_VDD_M113_noxref_d ) capacitor c=0.065554f \
 //x=51.44 //y=5.56 //x2=50.855 //y2=5.2
cc_4758 ( N_noxref_13_c_5703_p N_VDD_M115_noxref_d ) capacitor c=0.00983727f \
 //x=51.835 //y=5.38 //x2=51.735 //y2=5.2
cc_4759 ( N_noxref_13_c_5820_p N_VDD_M115_noxref_d ) capacitor c=0.00955781f \
 //x=51.44 //y=5.56 //x2=51.735 //y2=5.2
cc_4760 ( N_noxref_13_c_5661_p N_VDD_M115_noxref_d ) capacitor c=6.87256e-19 \
 //x=51.92 //y=2.77 //x2=51.735 //y2=5.2
cc_4761 ( N_noxref_13_c_5667_p N_VDD_M115_noxref_d ) capacitor c=0.065554f \
 //x=51.44 //y=5.56 //x2=51.735 //y2=5.2
cc_4762 ( N_noxref_13_c_5703_p N_VDD_M116_noxref_s ) capacitor c=0.00220019f \
 //x=51.835 //y=5.38 //x2=53.615 //y2=5.2
cc_4763 ( N_noxref_13_c_5566_n N_VDD_M116_noxref_s ) capacitor c=4.32734e-19 \
 //x=53.77 //y=2.93 //x2=53.615 //y2=5.2
cc_4764 ( N_noxref_13_c_5568_n N_VDD_M116_noxref_s ) capacitor c=0.0217981f \
 //x=53.77 //y=4.755 //x2=53.615 //y2=5.2
cc_4765 ( N_noxref_13_c_5626_p N_VDD_M116_noxref_s ) capacitor c=0.00371125f \
 //x=51.44 //y=5.38 //x2=53.615 //y2=5.2
cc_4766 ( N_noxref_13_c_5820_p N_VDD_M116_noxref_s ) capacitor c=9.52042e-19 \
 //x=51.44 //y=5.56 //x2=53.615 //y2=5.2
cc_4767 ( N_noxref_13_c_5621_p N_VDD_M116_noxref_s ) capacitor c=0.00983846f \
 //x=53.77 //y=4.88 //x2=53.615 //y2=5.2
cc_4768 ( N_noxref_13_M116_noxref_g N_VDD_M116_noxref_s ) capacitor \
 c=0.053419f //x=53.97 //y=6.2 //x2=53.615 //y2=5.2
cc_4769 ( N_noxref_13_c_5623_p N_VDD_M116_noxref_s ) capacitor c=0.00608913f \
 //x=54.045 //y=4.97 //x2=53.615 //y2=5.2
cc_4770 ( N_noxref_13_M117_noxref_g N_VDD_M117_noxref_d ) capacitor \
 c=0.015318f //x=54.41 //y=6.2 //x2=54.485 //y2=5.2
cc_4771 ( N_noxref_13_c_5570_n N_VDD_M122_noxref_s ) capacitor c=4.33517e-19 \
 //x=58.58 //y=2.935 //x2=58.425 //y2=5.2
cc_4772 ( N_noxref_13_c_5572_n N_VDD_M122_noxref_s ) capacitor c=0.0217981f \
 //x=58.58 //y=4.755 //x2=58.425 //y2=5.2
cc_4773 ( N_noxref_13_c_5737_p N_VDD_M122_noxref_s ) capacitor c=0.00983846f \
 //x=58.58 //y=4.88 //x2=58.425 //y2=5.2
cc_4774 ( N_noxref_13_M122_noxref_g N_VDD_M122_noxref_s ) capacitor \
 c=0.053419f //x=58.78 //y=6.2 //x2=58.425 //y2=5.2
cc_4775 ( N_noxref_13_c_5745_p N_VDD_M122_noxref_s ) capacitor c=0.00608899f \
 //x=58.855 //y=4.97 //x2=58.425 //y2=5.2
cc_4776 ( N_noxref_13_M123_noxref_g N_VDD_M123_noxref_d ) capacitor \
 c=0.015318f //x=59.22 //y=6.2 //x2=59.295 //y2=5.2
cc_4777 ( N_noxref_13_c_5576_n N_noxref_30_M33_noxref_d ) capacitor \
 c=3.39394e-19 //x=51.48 //y=1.18 //x2=54.52 //y2=1.09
cc_4778 ( N_noxref_13_c_5672_p N_GND_c_14438_n ) capacitor c=0.00608096f \
 //x=51.835 //y=1.835 //x2=53.65 //y2=0.175
cc_4779 ( N_noxref_13_c_5559_n N_GND_c_14438_n ) capacitor c=4.04148e-19 \
 //x=51.92 //y=2.93 //x2=53.65 //y2=0.175
cc_4780 ( N_noxref_13_c_5576_n N_GND_c_14438_n ) capacitor c=0.00928865f \
 //x=51.48 //y=1.18 //x2=53.65 //y2=0.175
cc_4781 ( N_noxref_13_M31_noxref_d N_GND_c_14438_n ) capacitor c=3.01769e-19 \
 //x=51.29 //y=1.085 //x2=53.65 //y2=0.175
cc_4782 ( N_noxref_13_c_5642_p N_GND_c_14442_n ) capacitor c=3.92414e-19 \
 //x=53.47 //y=1.055 //x2=53.735 //y2=1.015
cc_4783 ( N_noxref_13_c_5881_p N_GND_c_14442_n ) capacitor c=0.0085115f \
 //x=53.845 //y=0.9 //x2=53.735 //y2=1.015
cc_4784 ( N_noxref_13_c_5644_p N_GND_c_14442_n ) capacitor c=4.45447e-19 \
 //x=54 //y=1.055 //x2=53.735 //y2=1.015
cc_4785 ( N_noxref_13_c_5784_p N_GND_c_14445_n ) capacitor c=3.97665e-19 \
 //x=58.28 //y=1.055 //x2=58.545 //y2=1.015
cc_4786 ( N_noxref_13_c_5884_p N_GND_c_14445_n ) capacitor c=0.00864776f \
 //x=58.655 //y=0.9 //x2=58.545 //y2=1.015
cc_4787 ( N_noxref_13_c_5786_p N_GND_c_14445_n ) capacitor c=4.45447e-19 \
 //x=58.81 //y=1.055 //x2=58.545 //y2=1.015
cc_4788 ( N_noxref_13_c_5574_n N_GND_c_14317_n ) capacitor c=7.66715e-19 \
 //x=50.56 //y=5.56 //x2=50.51 //y2=1.135
cc_4789 ( N_noxref_13_c_5576_n N_GND_c_14317_n ) capacitor c=0.0140211f \
 //x=51.48 //y=1.18 //x2=50.51 //y2=1.135
cc_4790 ( N_noxref_13_M31_noxref_d N_GND_c_14317_n ) capacitor c=2.93544e-19 \
 //x=51.29 //y=1.085 //x2=50.51 //y2=1.135
cc_4791 ( N_noxref_13_c_5617_p N_GND_c_14451_n ) capacitor c=0.00771144f \
 //x=53.77 //y=2.375 //x2=53.735 //y2=1.145
cc_4792 ( N_noxref_13_c_5566_n N_GND_c_14451_n ) capacitor c=0.00106569f \
 //x=53.77 //y=2.93 //x2=53.735 //y2=1.145
cc_4793 ( N_noxref_13_c_5576_n N_GND_c_14451_n ) capacitor c=0.00606355f \
 //x=51.48 //y=1.18 //x2=53.735 //y2=1.145
cc_4794 ( N_noxref_13_c_5616_p N_GND_c_14451_n ) capacitor c=2.22883e-19 \
 //x=53.77 //y=2.26 //x2=53.735 //y2=1.145
cc_4795 ( N_noxref_13_c_5642_p N_GND_c_14451_n ) capacitor c=0.0015128f \
 //x=53.47 //y=1.055 //x2=53.735 //y2=1.145
cc_4796 ( N_noxref_13_c_5643_p N_GND_c_14451_n ) capacitor c=0.00350108f \
 //x=53.47 //y=1.4 //x2=53.735 //y2=1.145
cc_4797 ( N_noxref_13_c_5645_p N_GND_c_14451_n ) capacitor c=4.09667e-19 \
 //x=53.47 //y=1.71 //x2=53.735 //y2=1.145
cc_4798 ( N_noxref_13_c_5881_p N_GND_c_14451_n ) capacitor c=9.36995e-19 \
 //x=53.845 //y=0.9 //x2=53.735 //y2=1.145
cc_4799 ( N_noxref_13_c_5897_p N_GND_c_14451_n ) capacitor c=5.27793e-19 \
 //x=53.845 //y=1.555 //x2=53.735 //y2=1.145
cc_4800 ( N_noxref_13_c_5644_p N_GND_c_14451_n ) capacitor c=0.0017438f //x=54 \
 //y=1.055 //x2=53.735 //y2=1.145
cc_4801 ( N_noxref_13_c_5646_p N_GND_c_14451_n ) capacitor c=0.00276804f \
 //x=54 //y=1.4 //x2=53.735 //y2=1.145
cc_4802 ( N_noxref_13_c_5674_p N_GND_c_14462_n ) capacitor c=0.00771592f \
 //x=58.58 //y=2.375 //x2=58.545 //y2=1.145
cc_4803 ( N_noxref_13_c_5570_n N_GND_c_14462_n ) capacitor c=0.00118382f \
 //x=58.58 //y=2.935 //x2=58.545 //y2=1.145
cc_4804 ( N_noxref_13_c_5740_p N_GND_c_14462_n ) capacitor c=2.22883e-19 \
 //x=58.58 //y=2.26 //x2=58.545 //y2=1.145
cc_4805 ( N_noxref_13_c_5784_p N_GND_c_14462_n ) capacitor c=0.00156339f \
 //x=58.28 //y=1.055 //x2=58.545 //y2=1.145
cc_4806 ( N_noxref_13_c_5785_p N_GND_c_14462_n ) capacitor c=0.00352472f \
 //x=58.28 //y=1.4 //x2=58.545 //y2=1.145
cc_4807 ( N_noxref_13_c_5787_p N_GND_c_14462_n ) capacitor c=3.85805e-19 \
 //x=58.28 //y=1.71 //x2=58.545 //y2=1.145
cc_4808 ( N_noxref_13_c_5884_p N_GND_c_14462_n ) capacitor c=9.36995e-19 \
 //x=58.655 //y=0.9 //x2=58.545 //y2=1.145
cc_4809 ( N_noxref_13_c_5907_p N_GND_c_14462_n ) capacitor c=5.28241e-19 \
 //x=58.655 //y=1.555 //x2=58.545 //y2=1.145
cc_4810 ( N_noxref_13_c_5786_p N_GND_c_14462_n ) capacitor c=0.0017438f \
 //x=58.81 //y=1.055 //x2=58.545 //y2=1.145
cc_4811 ( N_noxref_13_c_5788_p N_GND_c_14462_n ) capacitor c=0.00276804f \
 //x=58.81 //y=1.4 //x2=58.545 //y2=1.145
cc_4812 ( N_noxref_13_c_5672_p N_GND_c_14394_n ) capacitor c=7.75992e-19 \
 //x=51.835 //y=1.835 //x2=52.49 //y2=0.175
cc_4813 ( N_noxref_13_c_5559_n N_GND_c_14394_n ) capacitor c=4.78337e-19 \
 //x=51.92 //y=2.93 //x2=52.49 //y2=0.175
cc_4814 ( N_noxref_13_c_5642_p N_GND_c_14474_n ) capacitor c=0.00677849f \
 //x=53.47 //y=1.055 //x2=57.3 //y2=0.175
cc_4815 ( N_noxref_13_c_5784_p N_GND_c_14475_n ) capacitor c=0.00677849f \
 //x=58.28 //y=1.055 //x2=62.11 //y2=0.175
cc_4816 ( N_noxref_13_c_5558_n N_GND_c_14304_n ) capacitor c=9.32616e-19 \
 //x=51.92 //y=2.61 //x2=49.33 //y2=0.175
cc_4817 ( N_noxref_13_c_5661_p N_GND_c_14304_n ) capacitor c=8.5697e-19 \
 //x=51.92 //y=2.77 //x2=49.33 //y2=0.175
cc_4818 ( N_noxref_13_c_5556_n N_GND_c_14332_n ) capacitor c=0.00460657f \
 //x=51.48 //y=1.75 //x2=52.66 //y2=0.175
cc_4819 ( N_noxref_13_c_5672_p N_GND_c_14332_n ) capacitor c=0.0221535f \
 //x=51.835 //y=1.835 //x2=52.66 //y2=0.175
cc_4820 ( N_noxref_13_c_5559_n N_GND_c_14332_n ) capacitor c=0.00430881f \
 //x=51.92 //y=2.93 //x2=52.66 //y2=0.175
cc_4821 ( N_noxref_13_c_5617_p N_GND_c_14332_n ) capacitor c=0.00330334f \
 //x=53.77 //y=2.375 //x2=52.66 //y2=0.175
cc_4822 ( N_noxref_13_c_5610_p N_GND_c_14332_n ) capacitor c=0.00386755f \
 //x=53.77 //y=2.61 //x2=52.66 //y2=0.175
cc_4823 ( N_noxref_13_c_5566_n N_GND_c_14332_n ) capacitor c=0.00272321f \
 //x=53.77 //y=2.93 //x2=52.66 //y2=0.175
cc_4824 ( N_noxref_13_c_5661_p N_GND_c_14332_n ) capacitor c=0.0101608f \
 //x=51.92 //y=2.77 //x2=52.66 //y2=0.175
cc_4825 ( N_noxref_13_c_5613_p N_GND_c_14332_n ) capacitor c=0.00539296f \
 //x=53.77 //y=2.765 //x2=52.66 //y2=0.175
cc_4826 ( N_noxref_13_c_5577_n N_GND_c_14332_n ) capacitor c=0.00947774f \
 //x=53.61 //y=2.77 //x2=52.66 //y2=0.175
cc_4827 ( N_noxref_13_c_5616_p N_GND_c_14332_n ) capacitor c=0.00379568f \
 //x=53.77 //y=2.26 //x2=52.66 //y2=0.175
cc_4828 ( N_noxref_13_c_5645_p N_GND_c_14332_n ) capacitor c=0.00170145f \
 //x=53.47 //y=1.71 //x2=52.66 //y2=0.175
cc_4829 ( N_noxref_13_c_5619_p N_GND_c_14332_n ) capacitor c=0.0102191f \
 //x=53.47 //y=2.095 //x2=52.66 //y2=0.175
cc_4830 ( N_noxref_13_c_5674_p N_GND_c_14333_n ) capacitor c=0.00350919f \
 //x=58.58 //y=2.375 //x2=57.47 //y2=0.175
cc_4831 ( N_noxref_13_c_5675_p N_GND_c_14333_n ) capacitor c=0.00374352f \
 //x=58.58 //y=2.615 //x2=57.47 //y2=0.175
cc_4832 ( N_noxref_13_c_5570_n N_GND_c_14333_n ) capacitor c=0.00311095f \
 //x=58.58 //y=2.935 //x2=57.47 //y2=0.175
cc_4833 ( N_noxref_13_c_5604_p N_GND_c_14333_n ) capacitor c=0.00528672f \
 //x=58.58 //y=2.77 //x2=57.47 //y2=0.175
cc_4834 ( N_noxref_13_c_5583_n N_GND_c_14333_n ) capacitor c=0.0118264f \
 //x=58.42 //y=2.775 //x2=57.47 //y2=0.175
cc_4835 ( N_noxref_13_c_5740_p N_GND_c_14333_n ) capacitor c=0.0039621f \
 //x=58.58 //y=2.26 //x2=57.47 //y2=0.175
cc_4836 ( N_noxref_13_c_5787_p N_GND_c_14333_n ) capacitor c=0.00170145f \
 //x=58.28 //y=1.71 //x2=57.47 //y2=0.175
cc_4837 ( N_noxref_13_c_5741_p N_GND_c_14333_n ) capacitor c=0.0102191f \
 //x=58.28 //y=2.095 //x2=57.47 //y2=0.175
cc_4838 ( N_noxref_13_c_5576_n N_GND_M30_noxref_d ) capacitor c=2.82748e-19 \
 //x=51.48 //y=1.18 //x2=50.32 //y2=1.045
cc_4839 ( N_noxref_13_c_5617_p N_GND_M32_noxref_d ) capacitor c=4.4417e-19 \
 //x=53.77 //y=2.375 //x2=53.545 //y2=1.055
cc_4840 ( N_noxref_13_c_5642_p N_GND_M32_noxref_d ) capacitor c=0.00184354f \
 //x=53.47 //y=1.055 //x2=53.545 //y2=1.055
cc_4841 ( N_noxref_13_c_5643_p N_GND_M32_noxref_d ) capacitor c=0.00210798f \
 //x=53.47 //y=1.4 //x2=53.545 //y2=1.055
cc_4842 ( N_noxref_13_c_5881_p N_GND_M32_noxref_d ) capacitor c=0.00474029f \
 //x=53.845 //y=0.9 //x2=53.545 //y2=1.055
cc_4843 ( N_noxref_13_c_5897_p N_GND_M32_noxref_d ) capacitor c=0.00166857f \
 //x=53.845 //y=1.555 //x2=53.545 //y2=1.055
cc_4844 ( N_noxref_13_c_5644_p N_GND_M32_noxref_d ) capacitor c=0.00230174f \
 //x=54 //y=1.055 //x2=53.545 //y2=1.055
cc_4845 ( N_noxref_13_c_5646_p N_GND_M32_noxref_d ) capacitor c=0.00210798f \
 //x=54 //y=1.4 //x2=53.545 //y2=1.055
cc_4846 ( N_noxref_13_c_5674_p N_GND_M35_noxref_d ) capacitor c=4.4417e-19 \
 //x=58.58 //y=2.375 //x2=58.355 //y2=1.055
cc_4847 ( N_noxref_13_c_5784_p N_GND_M35_noxref_d ) capacitor c=0.00184354f \
 //x=58.28 //y=1.055 //x2=58.355 //y2=1.055
cc_4848 ( N_noxref_13_c_5785_p N_GND_M35_noxref_d ) capacitor c=0.00210798f \
 //x=58.28 //y=1.4 //x2=58.355 //y2=1.055
cc_4849 ( N_noxref_13_c_5884_p N_GND_M35_noxref_d ) capacitor c=0.00474029f \
 //x=58.655 //y=0.9 //x2=58.355 //y2=1.055
cc_4850 ( N_noxref_13_c_5907_p N_GND_M35_noxref_d ) capacitor c=0.00166857f \
 //x=58.655 //y=1.555 //x2=58.355 //y2=1.055
cc_4851 ( N_noxref_13_c_5786_p N_GND_M35_noxref_d ) capacitor c=0.00230174f \
 //x=58.81 //y=1.055 //x2=58.355 //y2=1.055
cc_4852 ( N_noxref_13_c_5788_p N_GND_M35_noxref_d ) capacitor c=0.00210798f \
 //x=58.81 //y=1.4 //x2=58.355 //y2=1.055
cc_4853 ( N_noxref_13_c_5557_n N_noxref_49_c_16359_n ) capacitor c=0.00911405f \
 //x=51.565 //y=1.835 //x2=50.995 //y2=1.675
cc_4854 ( N_noxref_13_c_5672_p N_noxref_49_c_16364_n ) capacitor c=0.00399245f \
 //x=51.835 //y=1.835 //x2=51.88 //y2=0.71
cc_4855 ( N_noxref_13_c_5576_n N_noxref_49_c_16364_n ) capacitor c=0.003751f \
 //x=51.48 //y=1.18 //x2=51.88 //y2=0.71
cc_4856 ( N_noxref_13_M31_noxref_d N_noxref_49_c_16364_n ) capacitor \
 c=0.00910163f //x=51.29 //y=1.085 //x2=51.88 //y2=0.71
cc_4857 ( N_noxref_13_c_5556_n N_noxref_49_M30_noxref_s ) capacitor \
 c=0.0175063f //x=51.48 //y=1.75 //x2=49.89 //y2=0.545
cc_4858 ( N_noxref_13_c_5672_p N_noxref_49_M30_noxref_s ) capacitor \
 c=0.0055349f //x=51.835 //y=1.835 //x2=49.89 //y2=0.545
cc_4859 ( N_noxref_13_c_5559_n N_noxref_49_M30_noxref_s ) capacitor \
 c=7.86324e-19 //x=51.92 //y=2.93 //x2=49.89 //y2=0.545
cc_4860 ( N_noxref_13_c_5576_n N_noxref_49_M30_noxref_s ) capacitor \
 c=0.0089443f //x=51.48 //y=1.18 //x2=49.89 //y2=0.545
cc_4861 ( N_noxref_13_c_5661_p N_noxref_49_M30_noxref_s ) capacitor \
 c=0.00202552f //x=51.92 //y=2.77 //x2=49.89 //y2=0.545
cc_4862 ( N_noxref_13_M31_noxref_d N_noxref_49_M30_noxref_s ) capacitor \
 c=0.0275552f //x=51.29 //y=1.085 //x2=49.89 //y2=0.545
cc_4863 ( N_noxref_13_c_5619_p N_noxref_50_c_16418_n ) capacitor c=0.00262672f \
 //x=53.47 //y=2.095 //x2=53.25 //y2=1.685
cc_4864 ( N_noxref_13_c_5617_p N_noxref_50_c_16419_n ) capacitor c=0.00428451f \
 //x=53.77 //y=2.375 //x2=54.135 //y2=1.77
cc_4865 ( N_noxref_13_c_5566_n N_noxref_50_c_16419_n ) capacitor c=0.00372512f \
 //x=53.77 //y=2.93 //x2=54.135 //y2=1.77
cc_4866 ( N_noxref_13_c_5616_p N_noxref_50_c_16419_n ) capacitor c=0.0104666f \
 //x=53.77 //y=2.26 //x2=54.135 //y2=1.77
cc_4867 ( N_noxref_13_c_5645_p N_noxref_50_c_16419_n ) capacitor c=0.00705077f \
 //x=53.47 //y=1.71 //x2=54.135 //y2=1.77
cc_4868 ( N_noxref_13_c_5619_p N_noxref_50_c_16419_n ) capacitor c=0.020486f \
 //x=53.47 //y=2.095 //x2=54.135 //y2=1.77
cc_4869 ( N_noxref_13_c_5897_p N_noxref_50_c_16419_n ) capacitor c=0.00588627f \
 //x=53.845 //y=1.555 //x2=54.135 //y2=1.77
cc_4870 ( N_noxref_13_c_5646_p N_noxref_50_c_16419_n ) capacitor c=0.00698822f \
 //x=54 //y=1.4 //x2=54.135 //y2=1.77
cc_4871 ( N_noxref_13_c_5642_p N_noxref_50_M32_noxref_s ) capacitor \
 c=0.0295256f //x=53.47 //y=1.055 //x2=53.115 //y2=0.555
cc_4872 ( N_noxref_13_c_5645_p N_noxref_50_M32_noxref_s ) capacitor \
 c=7.99997e-19 //x=53.47 //y=1.71 //x2=53.115 //y2=0.555
cc_4873 ( N_noxref_13_c_5619_p N_noxref_50_M32_noxref_s ) capacitor \
 c=0.00122123f //x=53.47 //y=2.095 //x2=53.115 //y2=0.555
cc_4874 ( N_noxref_13_c_5644_p N_noxref_50_M32_noxref_s ) capacitor \
 c=0.0125924f //x=54 //y=1.055 //x2=53.115 //y2=0.555
cc_4875 ( N_noxref_13_c_5741_p N_noxref_51_c_16478_n ) capacitor c=0.00262672f \
 //x=58.28 //y=2.095 //x2=58.06 //y2=1.685
cc_4876 ( N_noxref_13_c_5674_p N_noxref_51_c_16479_n ) capacitor c=0.00428451f \
 //x=58.58 //y=2.375 //x2=58.945 //y2=1.77
cc_4877 ( N_noxref_13_c_5570_n N_noxref_51_c_16479_n ) capacitor c=0.00449457f \
 //x=58.58 //y=2.935 //x2=58.945 //y2=1.77
cc_4878 ( N_noxref_13_c_5740_p N_noxref_51_c_16479_n ) capacitor c=0.0104666f \
 //x=58.58 //y=2.26 //x2=58.945 //y2=1.77
cc_4879 ( N_noxref_13_c_5787_p N_noxref_51_c_16479_n ) capacitor c=0.00705077f \
 //x=58.28 //y=1.71 //x2=58.945 //y2=1.77
cc_4880 ( N_noxref_13_c_5741_p N_noxref_51_c_16479_n ) capacitor c=0.0197811f \
 //x=58.28 //y=2.095 //x2=58.945 //y2=1.77
cc_4881 ( N_noxref_13_c_5907_p N_noxref_51_c_16479_n ) capacitor c=0.00588627f \
 //x=58.655 //y=1.555 //x2=58.945 //y2=1.77
cc_4882 ( N_noxref_13_c_5788_p N_noxref_51_c_16479_n ) capacitor c=0.00698822f \
 //x=58.81 //y=1.4 //x2=58.945 //y2=1.77
cc_4883 ( N_noxref_13_c_5784_p N_noxref_51_M35_noxref_s ) capacitor \
 c=0.0295256f //x=58.28 //y=1.055 //x2=57.925 //y2=0.555
cc_4884 ( N_noxref_13_c_5787_p N_noxref_51_M35_noxref_s ) capacitor \
 c=7.99997e-19 //x=58.28 //y=1.71 //x2=57.925 //y2=0.555
cc_4885 ( N_noxref_13_c_5741_p N_noxref_51_M35_noxref_s ) capacitor \
 c=0.00122123f //x=58.28 //y=2.095 //x2=57.925 //y2=0.555
cc_4886 ( N_noxref_13_c_5786_p N_noxref_51_M35_noxref_s ) capacitor \
 c=0.0125924f //x=58.81 //y=1.055 //x2=57.925 //y2=0.555
cc_4887 ( N_noxref_14_c_6007_p CLK ) capacitor c=4.63397e-19 //x=61.54 \
 //y=2.625 //x2=64.13 //y2=2.77
cc_4888 ( N_noxref_14_c_5987_n CLK ) capacitor c=0.00188826f //x=61.54 \
 //y=5.25 //x2=64.13 //y2=2.77
cc_4889 ( N_noxref_14_c_6009_p CLK ) capacitor c=0.00839909f //x=63.39 \
 //y=2.625 //x2=64.13 //y2=2.77
cc_4890 ( N_noxref_14_c_5990_n CLK ) capacitor c=0.014957f //x=63.39 //y=2.945 \
 //x2=64.13 //y2=2.77
cc_4891 ( N_noxref_14_c_6011_p CLK ) capacitor c=6.6241e-19 //x=63.39 //y=2.77 \
 //x2=64.13 //y2=2.77
cc_4892 ( N_noxref_14_c_5992_n CLK ) capacitor c=0.0632653f //x=63.392 \
 //y=4.74 //x2=64.13 //y2=2.77
cc_4893 ( N_noxref_14_c_5996_n CLK ) capacitor c=0.00684101f //x=63.385 \
 //y=2.785 //x2=64.13 //y2=2.77
cc_4894 ( N_noxref_14_c_6014_p CLK ) capacitor c=3.30333e-19 //x=63.39 \
 //y=2.26 //x2=64.13 //y2=2.77
cc_4895 ( N_noxref_14_c_6015_p N_CLK_c_6866_n ) capacitor c=0.0179797f \
 //x=63.39 //y=2.26 //x2=64.13 //y2=2.26
cc_4896 ( N_noxref_14_c_6014_p N_CLK_c_6866_n ) capacitor c=5.16867e-19 \
 //x=63.39 //y=2.26 //x2=64.13 //y2=2.26
cc_4897 ( N_noxref_14_c_6017_p N_CLK_c_6866_n ) capacitor c=0.00161745f \
 //x=63.195 //y=2.095 //x2=64.13 //y2=2.26
cc_4898 ( N_noxref_14_c_6018_p N_CLK_c_6869_n ) capacitor c=0.0160977f \
 //x=63.39 //y=4.88 //x2=64.165 //y2=4.75
cc_4899 ( N_noxref_14_c_5992_n N_CLK_c_6869_n ) capacitor c=0.00638948f \
 //x=63.392 //y=4.74 //x2=64.165 //y2=4.75
cc_4900 ( N_noxref_14_c_6020_p N_CLK_c_6869_n ) capacitor c=0.00121956f \
 //x=63.39 //y=4.88 //x2=64.165 //y2=4.75
cc_4901 ( N_noxref_14_c_6021_p N_CLK_c_6869_n ) capacitor c=0.00177782f \
 //x=63.39 //y=4.88 //x2=64.165 //y2=4.75
cc_4902 ( N_noxref_14_c_6022_p N_CLK_c_6829_n ) capacitor c=0.0218207f \
 //x=61.455 //y=5.335 //x2=56.94 //y2=4.635
cc_4903 ( N_noxref_14_c_5987_n N_CLK_c_6829_n ) capacitor c=0.0300365f \
 //x=61.54 //y=5.25 //x2=56.94 //y2=4.635
cc_4904 ( N_noxref_14_c_6000_n N_CLK_c_6829_n ) capacitor c=0.0297837f \
 //x=59.002 //y=5.335 //x2=56.94 //y2=4.635
cc_4905 ( N_noxref_14_c_6025_p N_CLK_c_6829_n ) capacitor c=0.0379488f \
 //x=59.88 //y=5.335 //x2=56.94 //y2=4.635
cc_4906 ( N_noxref_14_c_6018_p N_CLK_c_6829_n ) capacitor c=0.00901811f \
 //x=63.39 //y=4.88 //x2=56.94 //y2=4.635
cc_4907 ( N_noxref_14_c_5992_n N_CLK_c_6829_n ) capacitor c=0.0273494f \
 //x=63.392 //y=4.74 //x2=56.94 //y2=4.635
cc_4908 ( N_noxref_14_c_6009_p N_CLK_c_6879_n ) capacitor c=3.30333e-19 \
 //x=63.39 //y=2.625 //x2=64.13 //y2=2.26
cc_4909 ( N_noxref_14_c_6015_p N_CLK_c_6879_n ) capacitor c=5.24723e-19 \
 //x=63.39 //y=2.26 //x2=64.13 //y2=2.26
cc_4910 ( N_noxref_14_c_6014_p N_CLK_c_6879_n ) capacitor c=0.00485709f \
 //x=63.39 //y=2.26 //x2=64.13 //y2=2.26
cc_4911 ( N_noxref_14_c_6017_p N_CLK_c_6879_n ) capacitor c=0.00190888f \
 //x=63.195 //y=2.095 //x2=64.13 //y2=2.26
cc_4912 ( N_noxref_14_c_6018_p N_CLK_c_6883_n ) capacitor c=4.80626e-19 \
 //x=63.39 //y=4.88 //x2=64.16 //y2=4.88
cc_4913 ( N_noxref_14_c_6020_p N_CLK_c_6883_n ) capacitor c=0.0039678f \
 //x=63.39 //y=4.88 //x2=64.16 //y2=4.88
cc_4914 ( N_noxref_14_c_6021_p N_CLK_c_6883_n ) capacitor c=0.0028411f \
 //x=63.39 //y=4.88 //x2=64.16 //y2=4.88
cc_4915 ( N_noxref_14_M128_noxref_g N_CLK_M130_noxref_g ) capacitor \
 c=0.0104892f //x=63.29 //y=6.2 //x2=64.17 //y2=6.2
cc_4916 ( N_noxref_14_M129_noxref_g N_CLK_M130_noxref_g ) capacitor \
 c=0.107636f //x=63.73 //y=6.2 //x2=64.17 //y2=6.2
cc_4917 ( N_noxref_14_M129_noxref_g N_CLK_M131_noxref_g ) capacitor \
 c=0.0100341f //x=63.73 //y=6.2 //x2=64.61 //y2=6.2
cc_4918 ( N_noxref_14_c_6038_p N_CLK_c_6889_n ) capacitor c=4.86545e-19 \
 //x=63.195 //y=1.045 //x2=64.165 //y2=1.085
cc_4919 ( N_noxref_14_c_6039_p N_CLK_c_6889_n ) capacitor c=0.00152405f \
 //x=63.195 //y=1.39 //x2=64.165 //y2=1.085
cc_4920 ( N_noxref_14_c_6040_p N_CLK_c_6889_n ) capacitor c=0.0151475f \
 //x=63.725 //y=1.045 //x2=64.165 //y2=1.085
cc_4921 ( N_noxref_14_c_6041_p N_CLK_c_6892_n ) capacitor c=0.00109982f \
 //x=63.195 //y=1.7 //x2=64.165 //y2=1.43
cc_4922 ( N_noxref_14_c_6042_p N_CLK_c_6892_n ) capacitor c=0.0111064f \
 //x=63.725 //y=1.39 //x2=64.165 //y2=1.43
cc_4923 ( N_noxref_14_c_6041_p N_CLK_c_6894_n ) capacitor c=9.58243e-19 \
 //x=63.195 //y=1.7 //x2=64.165 //y2=1.74
cc_4924 ( N_noxref_14_c_6017_p N_CLK_c_6894_n ) capacitor c=0.00662747f \
 //x=63.195 //y=2.095 //x2=64.165 //y2=1.74
cc_4925 ( N_noxref_14_c_6042_p N_CLK_c_6894_n ) capacitor c=0.00862358f \
 //x=63.725 //y=1.39 //x2=64.165 //y2=1.74
cc_4926 ( N_noxref_14_c_6040_p N_CLK_c_6897_n ) capacitor c=0.00127211f \
 //x=63.725 //y=1.045 //x2=64.695 //y2=1.085
cc_4927 ( N_noxref_14_c_6042_p N_CLK_c_6898_n ) capacitor c=0.00204774f \
 //x=63.725 //y=1.39 //x2=64.695 //y2=1.43
cc_4928 ( N_noxref_14_c_6015_p N_CLK_c_6899_n ) capacitor c=0.00161167f \
 //x=63.39 //y=2.26 //x2=64.13 //y2=2.26
cc_4929 ( N_noxref_14_c_6014_p N_CLK_c_6899_n ) capacitor c=0.00266443f \
 //x=63.39 //y=2.26 //x2=64.13 //y2=2.26
cc_4930 ( N_noxref_14_c_6017_p N_CLK_c_6899_n ) capacitor c=0.0181449f \
 //x=63.195 //y=2.095 //x2=64.13 //y2=2.26
cc_4931 ( N_noxref_14_c_6018_p N_CLK_c_6902_n ) capacitor c=5.5856e-19 \
 //x=63.39 //y=4.88 //x2=64.16 //y2=4.88
cc_4932 ( N_noxref_14_c_6020_p N_CLK_c_6902_n ) capacitor c=0.00211091f \
 //x=63.39 //y=4.88 //x2=64.16 //y2=4.88
cc_4933 ( N_noxref_14_c_6021_p N_CLK_c_6902_n ) capacitor c=0.0291521f \
 //x=63.39 //y=4.88 //x2=64.16 //y2=4.88
cc_4934 ( N_noxref_14_c_6000_n N_noxref_16_c_7409_n ) capacitor c=6.09703e-19 \
 //x=59.002 //y=5.335 //x2=55.95 //y2=5.56
cc_4935 ( N_noxref_14_c_6000_n N_noxref_16_c_7410_n ) capacitor c=0.00306432f \
 //x=59.002 //y=5.335 //x2=56.645 //y2=5.335
cc_4936 ( N_noxref_14_c_6056_p N_noxref_16_c_7411_n ) capacitor c=0.00163399f \
 //x=61.14 //y=1.845 //x2=56.645 //y2=1.845
cc_4937 ( N_noxref_14_c_5987_n N_noxref_16_c_7370_n ) capacitor c=0.0233658f \
 //x=61.54 //y=5.25 //x2=66.56 //y2=4.265
cc_4938 ( N_noxref_14_c_5992_n N_noxref_16_c_7370_n ) capacitor c=0.0233519f \
 //x=63.392 //y=4.74 //x2=66.56 //y2=4.265
cc_4939 ( N_noxref_14_c_5987_n SN ) capacitor c=0.00216749f //x=61.54 //y=5.25 \
 //x2=59.69 //y2=2.77
cc_4940 ( N_noxref_14_c_5999_n N_SN_c_8500_n ) capacitor c=3.40598e-19 \
 //x=59.76 //y=5.335 //x2=59.69 //y2=2.55
cc_4941 ( N_noxref_14_c_6025_p N_SN_c_8500_n ) capacitor c=4.44961e-19 \
 //x=59.88 //y=5.335 //x2=59.69 //y2=2.55
cc_4942 ( N_noxref_14_c_5999_n N_SN_c_8591_n ) capacitor c=0.0213631f \
 //x=59.76 //y=5.335 //x2=59.69 //y2=4.765
cc_4943 ( N_noxref_14_c_6025_p N_SN_c_8591_n ) capacitor c=0.00239361f \
 //x=59.88 //y=5.335 //x2=59.69 //y2=4.765
cc_4944 ( N_noxref_14_c_6064_p N_SN_c_8591_n ) capacitor c=7.85344e-19 \
 //x=59.88 //y=5.56 //x2=59.69 //y2=4.765
cc_4945 ( N_noxref_14_c_6065_p N_SN_c_8521_n ) capacitor c=7.08559e-19 \
 //x=61.055 //y=1.305 //x2=70.99 //y2=2.39
cc_4946 ( N_noxref_14_c_6056_p N_SN_c_8521_n ) capacitor c=0.0210985f \
 //x=61.14 //y=1.845 //x2=70.99 //y2=2.39
cc_4947 ( N_noxref_14_c_6007_p N_SN_c_8521_n ) capacitor c=0.0272596f \
 //x=61.54 //y=2.625 //x2=70.99 //y2=2.39
cc_4948 ( N_noxref_14_c_5985_n N_SN_c_8521_n ) capacitor c=0.00577069f \
 //x=61.54 //y=2.945 //x2=70.99 //y2=2.39
cc_4949 ( N_noxref_14_c_6009_p N_SN_c_8521_n ) capacitor c=0.0121034f \
 //x=63.39 //y=2.625 //x2=70.99 //y2=2.39
cc_4950 ( N_noxref_14_c_5990_n N_SN_c_8521_n ) capacitor c=0.00673157f \
 //x=63.39 //y=2.945 //x2=70.99 //y2=2.39
cc_4951 ( N_noxref_14_c_6015_p N_SN_c_8521_n ) capacitor c=0.0165635f \
 //x=63.39 //y=2.26 //x2=70.99 //y2=2.39
cc_4952 ( N_noxref_14_c_5995_n N_SN_c_8521_n ) capacitor c=0.0365231f //x=61.7 \
 //y=2.785 //x2=70.99 //y2=2.39
cc_4953 ( N_noxref_14_c_5996_n N_SN_c_8521_n ) capacitor c=0.0371276f \
 //x=63.385 //y=2.785 //x2=70.99 //y2=2.39
cc_4954 ( N_noxref_14_c_5997_n N_SN_c_8521_n ) capacitor c=0.13892f //x=63.225 \
 //y=2.785 //x2=70.99 //y2=2.39
cc_4955 ( N_noxref_14_c_6014_p N_SN_c_8521_n ) capacitor c=2.20453e-19 \
 //x=63.39 //y=2.26 //x2=70.99 //y2=2.39
cc_4956 ( N_noxref_14_c_6017_p N_SN_c_8521_n ) capacitor c=3.61358e-19 \
 //x=63.195 //y=2.095 //x2=70.99 //y2=2.39
cc_4957 ( N_noxref_14_c_5999_n N_SN_c_8626_n ) capacitor c=0.00492634f \
 //x=59.76 //y=5.335 //x2=59.69 //y2=4.88
cc_4958 ( N_noxref_14_c_6025_p N_SN_c_8626_n ) capacitor c=0.00132214f \
 //x=59.88 //y=5.335 //x2=59.69 //y2=4.88
cc_4959 ( N_noxref_14_c_5999_n N_SN_M124_noxref_g ) capacitor c=0.00858241f \
 //x=59.76 //y=5.335 //x2=59.66 //y2=6.2
cc_4960 ( N_noxref_14_c_6025_p N_SN_M124_noxref_g ) capacitor c=0.00229818f \
 //x=59.88 //y=5.335 //x2=59.66 //y2=6.2
cc_4961 ( N_noxref_14_c_6064_p N_SN_M124_noxref_g ) capacitor c=0.0179041f \
 //x=59.88 //y=5.56 //x2=59.66 //y2=6.2
cc_4962 ( N_noxref_14_c_6082_p N_SN_M125_noxref_g ) capacitor c=0.00955829f \
 //x=60.645 //y=5.335 //x2=60.1 //y2=6.2
cc_4963 ( N_noxref_14_c_6025_p N_SN_M125_noxref_g ) capacitor c=0.00230699f \
 //x=59.88 //y=5.335 //x2=60.1 //y2=6.2
cc_4964 ( N_noxref_14_c_6064_p N_SN_M125_noxref_g ) capacitor c=0.0179041f \
 //x=59.88 //y=5.56 //x2=60.1 //y2=6.2
cc_4965 ( N_noxref_14_c_6025_p N_SN_c_8674_n ) capacitor c=0.00181015f \
 //x=59.88 //y=5.335 //x2=60.025 //y2=4.97
cc_4966 ( N_noxref_14_c_6064_p N_SN_c_8674_n ) capacitor c=0.00290085f \
 //x=59.88 //y=5.56 //x2=60.025 //y2=4.97
cc_4967 ( N_noxref_14_c_5999_n N_SN_c_8644_n ) capacitor c=6.14744e-19 \
 //x=59.76 //y=5.335 //x2=59.69 //y2=4.88
cc_4968 ( N_noxref_14_c_6007_p N_noxref_19_c_9285_n ) capacitor c=0.013943f \
 //x=61.54 //y=2.625 //x2=60.8 //y2=2.375
cc_4969 ( N_noxref_14_c_6007_p N_noxref_19_c_9262_n ) capacitor c=0.00898347f \
 //x=61.54 //y=2.625 //x2=60.8 //y2=3.705
cc_4970 ( N_noxref_14_c_5985_n N_noxref_19_c_9262_n ) capacitor c=0.0151188f \
 //x=61.54 //y=2.945 //x2=60.8 //y2=3.705
cc_4971 ( N_noxref_14_c_5987_n N_noxref_19_c_9262_n ) capacitor c=0.0298518f \
 //x=61.54 //y=5.25 //x2=60.8 //y2=3.705
cc_4972 ( N_noxref_14_c_6009_p N_noxref_19_c_9262_n ) capacitor c=4.63723e-19 \
 //x=63.39 //y=2.625 //x2=60.8 //y2=3.705
cc_4973 ( N_noxref_14_c_6003_n N_noxref_19_c_9262_n ) capacitor c=6.77171e-19 \
 //x=61.54 //y=2.77 //x2=60.8 //y2=3.705
cc_4974 ( N_noxref_14_c_5992_n N_noxref_19_c_9262_n ) capacitor c=5.53249e-19 \
 //x=63.392 //y=4.74 //x2=60.8 //y2=3.705
cc_4975 ( N_noxref_14_c_5995_n N_noxref_19_c_9262_n ) capacitor c=0.00687503f \
 //x=61.7 //y=2.785 //x2=60.8 //y2=3.705
cc_4976 ( N_noxref_14_c_6082_p N_noxref_19_c_9293_n ) capacitor c=0.00167286f \
 //x=60.645 //y=5.335 //x2=60.8 //y2=4.025
cc_4977 ( N_noxref_14_c_6022_p N_noxref_19_c_9293_n ) capacitor c=4.08809e-19 \
 //x=61.455 //y=5.335 //x2=60.8 //y2=4.025
cc_4978 ( N_noxref_14_c_5987_n N_noxref_19_c_9293_n ) capacitor c=0.0148932f \
 //x=61.54 //y=5.25 //x2=60.8 //y2=4.025
cc_4979 ( N_noxref_14_c_6022_p N_noxref_19_c_9283_n ) capacitor c=0.00228791f \
 //x=61.455 //y=5.335 //x2=60.8 //y2=4.75
cc_4980 ( N_noxref_14_c_5987_n N_noxref_19_c_9283_n ) capacitor c=0.042978f \
 //x=61.54 //y=5.25 //x2=60.8 //y2=4.75
cc_4981 ( N_noxref_14_c_6101_p N_noxref_19_c_9283_n ) capacitor c=0.0221235f \
 //x=60.76 //y=5.335 //x2=60.8 //y2=4.75
cc_4982 ( N_noxref_14_c_5992_n N_noxref_19_c_9283_n ) capacitor c=8.71319e-19 \
 //x=63.392 //y=4.74 //x2=60.8 //y2=4.75
cc_4983 ( N_noxref_14_c_6103_p N_noxref_19_c_9283_n ) capacitor c=0.00217653f \
 //x=60.76 //y=5.56 //x2=60.8 //y2=4.75
cc_4984 ( N_noxref_14_M129_noxref_g N_noxref_19_c_9301_n ) capacitor \
 c=0.00889217f //x=63.73 //y=6.2 //x2=64.275 //y2=5.38
cc_4985 ( N_noxref_14_c_6105_p N_noxref_19_c_9302_n ) capacitor c=0.00326079f \
 //x=61.055 //y=1.76 //x2=64.43 //y2=1.75
cc_4986 ( N_noxref_14_c_6106_p N_noxref_19_c_9303_n ) capacitor c=0.00218808f \
 //x=61.455 //y=1.845 //x2=64.515 //y2=1.835
cc_4987 ( N_noxref_14_c_6106_p N_noxref_19_c_9263_n ) capacitor c=0.00203605f \
 //x=61.455 //y=1.845 //x2=64.87 //y2=3.705
cc_4988 ( N_noxref_14_c_6009_p N_noxref_19_c_9263_n ) capacitor c=6.61269e-19 \
 //x=63.39 //y=2.625 //x2=64.87 //y2=3.705
cc_4989 ( N_noxref_14_c_5992_n N_noxref_19_c_9263_n ) capacitor c=8.77718e-19 \
 //x=63.392 //y=4.74 //x2=64.87 //y2=3.705
cc_4990 ( N_noxref_14_c_5987_n N_noxref_19_c_9307_n ) capacitor c=0.00283621f \
 //x=61.54 //y=5.25 //x2=64.87 //y2=5.295
cc_4991 ( N_noxref_14_c_5992_n N_noxref_19_c_9307_n ) capacitor c=0.00195062f \
 //x=63.392 //y=4.74 //x2=64.87 //y2=5.295
cc_4992 ( N_noxref_14_c_5987_n N_noxref_19_c_9309_n ) capacitor c=9.19401e-19 \
 //x=61.54 //y=5.25 //x2=60.8 //y2=3.88
cc_4993 ( N_noxref_14_c_6113_p N_noxref_19_c_9310_n ) capacitor c=5.58535e-19 \
 //x=60.76 //y=5.56 //x2=63.51 //y2=5.56
cc_4994 ( N_noxref_14_c_6022_p N_noxref_19_c_9310_n ) capacitor c=0.00104762f \
 //x=61.455 //y=5.335 //x2=63.51 //y2=5.56
cc_4995 ( N_noxref_14_c_5990_n N_noxref_19_c_9310_n ) capacitor c=4.02865e-19 \
 //x=63.39 //y=2.945 //x2=63.51 //y2=5.56
cc_4996 ( N_noxref_14_c_6018_p N_noxref_19_c_9310_n ) capacitor c=0.0117744f \
 //x=63.39 //y=4.88 //x2=63.51 //y2=5.56
cc_4997 ( N_noxref_14_c_6020_p N_noxref_19_c_9310_n ) capacitor c=0.00277154f \
 //x=63.39 //y=4.88 //x2=63.51 //y2=5.56
cc_4998 ( N_noxref_14_M128_noxref_g N_noxref_19_c_9310_n ) capacitor \
 c=0.00201806f //x=63.29 //y=6.2 //x2=63.51 //y2=5.56
cc_4999 ( N_noxref_14_M129_noxref_g N_noxref_19_c_9310_n ) capacitor \
 c=0.00192712f //x=63.73 //y=6.2 //x2=63.51 //y2=5.56
cc_5000 ( N_noxref_14_c_6021_p N_noxref_19_c_9310_n ) capacitor c=0.00200677f \
 //x=63.39 //y=4.88 //x2=63.51 //y2=5.56
cc_5001 ( N_noxref_14_c_6065_p N_noxref_19_c_9318_n ) capacitor c=6.5615e-19 \
 //x=61.055 //y=1.305 //x2=64.43 //y2=1.18
cc_5002 ( N_noxref_14_c_5987_n N_noxref_19_c_9267_n ) capacitor c=0.00336755f \
 //x=61.54 //y=5.25 //x2=60.96 //y2=3.88
cc_5003 ( N_noxref_14_c_5987_n N_noxref_19_c_9269_n ) capacitor c=0.0229483f \
 //x=61.54 //y=5.25 //x2=64.705 //y2=3.865
cc_5004 ( N_noxref_14_c_5992_n N_noxref_19_c_9269_n ) capacitor c=0.0233584f \
 //x=63.392 //y=4.74 //x2=64.705 //y2=3.865
cc_5005 ( N_noxref_14_c_6007_p N_noxref_19_c_9322_n ) capacitor c=0.0015536f \
 //x=61.54 //y=2.625 //x2=60.8 //y2=2.26
cc_5006 ( N_noxref_14_c_6022_p N_noxref_19_c_9323_n ) capacitor c=0.00130631f \
 //x=61.455 //y=5.335 //x2=60.8 //y2=4.88
cc_5007 ( N_noxref_14_c_5987_n N_noxref_19_c_9323_n ) capacitor c=0.00131258f \
 //x=61.54 //y=5.25 //x2=60.8 //y2=4.88
cc_5008 ( N_noxref_14_c_6101_p N_noxref_19_c_9323_n ) capacitor c=0.00346456f \
 //x=60.76 //y=5.335 //x2=60.8 //y2=4.88
cc_5009 ( N_noxref_14_c_6103_p N_noxref_19_c_9323_n ) capacitor c=0.00624059f \
 //x=60.76 //y=5.56 //x2=60.8 //y2=4.88
cc_5010 ( N_noxref_14_c_6018_p N_noxref_19_c_9327_n ) capacitor c=0.00104426f \
 //x=63.39 //y=4.88 //x2=63.51 //y2=5.56
cc_5011 ( N_noxref_14_c_6020_p N_noxref_19_c_9327_n ) capacitor c=0.00377369f \
 //x=63.39 //y=4.88 //x2=63.51 //y2=5.56
cc_5012 ( N_noxref_14_M128_noxref_g N_noxref_19_c_9327_n ) capacitor \
 c=0.0158358f //x=63.29 //y=6.2 //x2=63.51 //y2=5.56
cc_5013 ( N_noxref_14_M129_noxref_g N_noxref_19_c_9327_n ) capacitor \
 c=0.0178987f //x=63.73 //y=6.2 //x2=63.51 //y2=5.56
cc_5014 ( N_noxref_14_c_6021_p N_noxref_19_c_9327_n ) capacitor c=0.0043218f \
 //x=63.39 //y=4.88 //x2=63.51 //y2=5.56
cc_5015 ( N_noxref_14_c_6082_p N_noxref_19_M126_noxref_g ) capacitor \
 c=0.00952006f //x=60.645 //y=5.335 //x2=60.54 //y2=6.2
cc_5016 ( N_noxref_14_c_6113_p N_noxref_19_M126_noxref_g ) capacitor \
 c=0.00226521f //x=60.76 //y=5.56 //x2=60.54 //y2=6.2
cc_5017 ( N_noxref_14_c_6103_p N_noxref_19_M126_noxref_g ) capacitor \
 c=0.0178885f //x=60.76 //y=5.56 //x2=60.54 //y2=6.2
cc_5018 ( N_noxref_14_c_6113_p N_noxref_19_M127_noxref_g ) capacitor \
 c=0.00368945f //x=60.76 //y=5.56 //x2=60.98 //y2=6.2
cc_5019 ( N_noxref_14_c_6022_p N_noxref_19_M127_noxref_g ) capacitor \
 c=0.010861f //x=61.455 //y=5.335 //x2=60.98 //y2=6.2
cc_5020 ( N_noxref_14_c_6103_p N_noxref_19_M127_noxref_g ) capacitor \
 c=0.0188608f //x=60.76 //y=5.56 //x2=60.98 //y2=6.2
cc_5021 ( N_noxref_14_c_6065_p N_noxref_19_c_9338_n ) capacitor c=4.64015e-19 \
 //x=61.055 //y=1.305 //x2=60.79 //y2=1.095
cc_5022 ( N_noxref_14_M37_noxref_d N_noxref_19_c_9338_n ) capacitor \
 c=0.00137165f //x=60.865 //y=1.095 //x2=60.79 //y2=1.095
cc_5023 ( N_noxref_14_c_6065_p N_noxref_19_c_9340_n ) capacitor c=0.0026012f \
 //x=61.055 //y=1.305 //x2=60.79 //y2=1.44
cc_5024 ( N_noxref_14_c_6105_p N_noxref_19_c_9340_n ) capacitor c=0.00127432f \
 //x=61.055 //y=1.76 //x2=60.79 //y2=1.44
cc_5025 ( N_noxref_14_M37_noxref_d N_noxref_19_c_9340_n ) capacitor \
 c=0.00237422f //x=60.865 //y=1.095 //x2=60.79 //y2=1.44
cc_5026 ( N_noxref_14_c_6105_p N_noxref_19_c_9343_n ) capacitor c=0.00429966f \
 //x=61.055 //y=1.76 //x2=60.79 //y2=1.75
cc_5027 ( N_noxref_14_c_6065_p N_noxref_19_c_9344_n ) capacitor c=5.29969e-19 \
 //x=61.055 //y=1.305 //x2=61.165 //y2=0.94
cc_5028 ( N_noxref_14_M37_noxref_d N_noxref_19_c_9344_n ) capacitor \
 c=0.0020782f //x=60.865 //y=1.095 //x2=61.165 //y2=0.94
cc_5029 ( N_noxref_14_c_6065_p N_noxref_19_c_9346_n ) capacitor c=5.31507e-19 \
 //x=61.055 //y=1.305 //x2=61.165 //y2=1.595
cc_5030 ( N_noxref_14_c_6105_p N_noxref_19_c_9346_n ) capacitor c=0.00930387f \
 //x=61.055 //y=1.76 //x2=61.165 //y2=1.595
cc_5031 ( N_noxref_14_c_6106_p N_noxref_19_c_9346_n ) capacitor c=0.00194716f \
 //x=61.455 //y=1.845 //x2=61.165 //y2=1.595
cc_5032 ( N_noxref_14_M37_noxref_d N_noxref_19_c_9346_n ) capacitor \
 c=0.00356097f //x=60.865 //y=1.095 //x2=61.165 //y2=1.595
cc_5033 ( N_noxref_14_c_6065_p N_noxref_19_c_9350_n ) capacitor c=5.28622e-19 \
 //x=61.055 //y=1.305 //x2=61.32 //y2=1.095
cc_5034 ( N_noxref_14_M37_noxref_d N_noxref_19_c_9350_n ) capacitor \
 c=0.00139206f //x=60.865 //y=1.095 //x2=61.32 //y2=1.095
cc_5035 ( N_noxref_14_c_6065_p N_noxref_19_c_9352_n ) capacitor c=0.00312156f \
 //x=61.055 //y=1.305 //x2=61.32 //y2=1.44
cc_5036 ( N_noxref_14_c_6105_p N_noxref_19_c_9352_n ) capacitor c=0.00347599f \
 //x=61.055 //y=1.76 //x2=61.32 //y2=1.44
cc_5037 ( N_noxref_14_c_6106_p N_noxref_19_c_9352_n ) capacitor c=0.00323576f \
 //x=61.455 //y=1.845 //x2=61.32 //y2=1.44
cc_5038 ( N_noxref_14_M37_noxref_d N_noxref_19_c_9352_n ) capacitor \
 c=0.00237422f //x=60.865 //y=1.095 //x2=61.32 //y2=1.44
cc_5039 ( N_noxref_14_c_6007_p N_noxref_19_c_9356_n ) capacitor c=0.0024584f \
 //x=61.54 //y=2.625 //x2=60.8 //y2=2.26
cc_5040 ( N_noxref_14_c_6105_p N_noxref_19_c_9357_n ) capacitor c=0.0036273f \
 //x=61.055 //y=1.76 //x2=60.8 //y2=2.095
cc_5041 ( N_noxref_14_c_6007_p N_noxref_19_c_9357_n ) capacitor c=0.00282067f \
 //x=61.54 //y=2.625 //x2=60.8 //y2=2.095
cc_5042 ( N_noxref_14_c_5987_n N_noxref_19_c_9359_n ) capacitor c=0.00739875f \
 //x=61.54 //y=5.25 //x2=60.8 //y2=4.88
cc_5043 ( N_noxref_14_c_6101_p N_noxref_19_c_9359_n ) capacitor c=0.00203307f \
 //x=60.76 //y=5.335 //x2=60.8 //y2=4.88
cc_5044 ( N_noxref_14_c_6103_p N_noxref_19_c_9359_n ) capacitor c=0.00375636f \
 //x=60.76 //y=5.56 //x2=60.8 //y2=4.88
cc_5045 ( N_noxref_14_c_5987_n N_noxref_21_c_10676_n ) capacitor c=0.00141294f \
 //x=61.54 //y=5.25 //x2=61.015 //y2=3.48
cc_5046 ( N_noxref_14_c_5987_n N_noxref_21_c_10677_n ) capacitor c=0.022629f \
 //x=61.54 //y=5.25 //x2=64.48 //y2=3.51
cc_5047 ( N_noxref_14_c_5992_n N_noxref_21_c_10677_n ) capacitor c=0.0230653f \
 //x=63.392 //y=4.74 //x2=64.48 //y2=3.51
cc_5048 ( N_noxref_14_c_5997_n N_noxref_21_c_10677_n ) capacitor c=0.00823341f \
 //x=63.225 //y=2.785 //x2=64.48 //y2=3.51
cc_5049 ( N_noxref_14_c_5999_n N_VDD_c_11522_n ) capacitor c=0.00621363f \
 //x=59.76 //y=5.335 //x2=74.455 //y2=7.585
cc_5050 ( N_noxref_14_c_6082_p N_VDD_c_11522_n ) capacitor c=0.00627186f \
 //x=60.645 //y=5.335 //x2=74.455 //y2=7.585
cc_5051 ( N_noxref_14_c_6113_p N_VDD_c_11522_n ) capacitor c=0.00256019f \
 //x=60.76 //y=5.56 //x2=74.455 //y2=7.585
cc_5052 ( N_noxref_14_c_6022_p N_VDD_c_11522_n ) capacitor c=0.00824067f \
 //x=61.455 //y=5.335 //x2=74.455 //y2=7.585
cc_5053 ( N_noxref_14_c_6000_n N_VDD_c_11522_n ) capacitor c=0.00261804f \
 //x=59.002 //y=5.335 //x2=74.455 //y2=7.585
cc_5054 ( N_noxref_14_c_6025_p N_VDD_c_11522_n ) capacitor c=0.00270108f \
 //x=59.88 //y=5.335 //x2=74.455 //y2=7.585
cc_5055 ( N_noxref_14_c_6018_p N_VDD_c_11522_n ) capacitor c=9.07241e-19 \
 //x=63.39 //y=4.88 //x2=74.455 //y2=7.585
cc_5056 ( N_noxref_14_c_6004_n N_VDD_c_11522_n ) capacitor c=0.0024232f //x=59 \
 //y=5.56 //x2=74.455 //y2=7.585
cc_5057 ( N_noxref_14_c_6064_p N_VDD_c_11522_n ) capacitor c=0.0024232f \
 //x=59.88 //y=5.56 //x2=74.455 //y2=7.585
cc_5058 ( N_noxref_14_c_6103_p N_VDD_c_11522_n ) capacitor c=0.0024232f \
 //x=60.76 //y=5.56 //x2=74.455 //y2=7.585
cc_5059 ( N_noxref_14_c_6020_p N_VDD_c_11522_n ) capacitor c=6.22888e-19 \
 //x=63.39 //y=4.88 //x2=74.455 //y2=7.585
cc_5060 ( N_noxref_14_c_5999_n N_VDD_c_12240_n ) capacitor c=0.00202922f \
 //x=59.76 //y=5.335 //x2=59.355 //y2=7.585
cc_5061 ( N_noxref_14_c_6000_n N_VDD_c_12240_n ) capacitor c=9.3757e-19 \
 //x=59.002 //y=5.335 //x2=59.355 //y2=7.585
cc_5062 ( N_noxref_14_c_6004_n N_VDD_c_12240_n ) capacitor c=0.0138074f //x=59 \
 //y=5.56 //x2=59.355 //y2=7.585
cc_5063 ( N_noxref_14_c_5999_n N_VDD_c_12296_n ) capacitor c=0.0017708f \
 //x=59.76 //y=5.335 //x2=60.235 //y2=7.585
cc_5064 ( N_noxref_14_c_6082_p N_VDD_c_12296_n ) capacitor c=0.00202922f \
 //x=60.645 //y=5.335 //x2=60.235 //y2=7.585
cc_5065 ( N_noxref_14_c_6025_p N_VDD_c_12296_n ) capacitor c=9.4822e-19 \
 //x=59.88 //y=5.335 //x2=60.235 //y2=7.585
cc_5066 ( N_noxref_14_c_6064_p N_VDD_c_12296_n ) capacitor c=0.0138074f \
 //x=59.88 //y=5.56 //x2=60.235 //y2=7.585
cc_5067 ( N_noxref_14_c_6082_p N_VDD_c_12300_n ) capacitor c=0.00205906f \
 //x=60.645 //y=5.335 //x2=61.115 //y2=7.585
cc_5068 ( N_noxref_14_c_6113_p N_VDD_c_12300_n ) capacitor c=8.49654e-19 \
 //x=60.76 //y=5.56 //x2=61.115 //y2=7.585
cc_5069 ( N_noxref_14_c_6022_p N_VDD_c_12300_n ) capacitor c=0.00204238f \
 //x=61.455 //y=5.335 //x2=61.115 //y2=7.585
cc_5070 ( N_noxref_14_c_6103_p N_VDD_c_12300_n ) capacitor c=0.0135103f \
 //x=60.76 //y=5.56 //x2=61.115 //y2=7.585
cc_5071 ( N_noxref_14_c_6022_p N_VDD_c_12304_n ) capacitor c=0.00183742f \
 //x=61.455 //y=5.335 //x2=62.11 //y2=7.585
cc_5072 ( N_noxref_14_c_6018_p N_VDD_c_12305_n ) capacitor c=6.28113e-19 \
 //x=63.39 //y=4.88 //x2=63.865 //y2=7.585
cc_5073 ( N_noxref_14_M128_noxref_g N_VDD_c_12305_n ) capacitor c=0.00732618f \
 //x=63.29 //y=6.2 //x2=63.865 //y2=7.585
cc_5074 ( N_noxref_14_M129_noxref_g N_VDD_c_12305_n ) capacitor c=0.00755544f \
 //x=63.73 //y=6.2 //x2=63.865 //y2=7.585
cc_5075 ( N_noxref_14_c_6000_n N_VDD_c_12252_n ) capacitor c=0.0022955f \
 //x=59.002 //y=5.335 //x2=57.47 //y2=7.585
cc_5076 ( N_noxref_14_c_6004_n N_VDD_c_12252_n ) capacitor c=0.00509469f \
 //x=59 //y=5.56 //x2=57.47 //y2=7.585
cc_5077 ( N_noxref_14_c_6113_p N_VDD_c_12310_n ) capacitor c=0.00269779f \
 //x=60.76 //y=5.56 //x2=62.28 //y2=7.585
cc_5078 ( N_noxref_14_c_5987_n N_VDD_c_12310_n ) capacitor c=0.0316694f \
 //x=61.54 //y=5.25 //x2=62.28 //y2=7.585
cc_5079 ( N_noxref_14_c_6018_p N_VDD_c_12310_n ) capacitor c=0.00483853f \
 //x=63.39 //y=4.88 //x2=62.28 //y2=7.585
cc_5080 ( N_noxref_14_c_5992_n N_VDD_c_12310_n ) capacitor c=0.00593318f \
 //x=63.392 //y=4.74 //x2=62.28 //y2=7.585
cc_5081 ( N_noxref_14_c_6103_p N_VDD_c_12310_n ) capacitor c=0.00776541f \
 //x=60.76 //y=5.56 //x2=62.28 //y2=7.585
cc_5082 ( N_noxref_14_c_6020_p N_VDD_c_12310_n ) capacitor c=0.00370494f \
 //x=63.39 //y=4.88 //x2=62.28 //y2=7.585
cc_5083 ( N_noxref_14_c_6021_p N_VDD_c_12310_n ) capacitor c=0.0129564f \
 //x=63.39 //y=4.88 //x2=62.28 //y2=7.585
cc_5084 ( N_noxref_14_c_6000_n N_VDD_M122_noxref_s ) capacitor c=0.0441176f \
 //x=59.002 //y=5.335 //x2=58.425 //y2=5.2
cc_5085 ( N_noxref_14_c_6025_p N_VDD_M122_noxref_s ) capacitor c=7.80122e-19 \
 //x=59.88 //y=5.335 //x2=58.425 //y2=5.2
cc_5086 ( N_noxref_14_c_6004_n N_VDD_M122_noxref_s ) capacitor c=0.09305f \
 //x=59 //y=5.56 //x2=58.425 //y2=5.2
cc_5087 ( N_noxref_14_c_5999_n N_VDD_M123_noxref_d ) capacitor c=0.00700141f \
 //x=59.76 //y=5.335 //x2=59.295 //y2=5.2
cc_5088 ( N_noxref_14_c_6004_n N_VDD_M123_noxref_d ) capacitor c=0.0674491f \
 //x=59 //y=5.56 //x2=59.295 //y2=5.2
cc_5089 ( N_noxref_14_c_6064_p N_VDD_M123_noxref_d ) capacitor c=0.0674762f \
 //x=59.88 //y=5.56 //x2=59.295 //y2=5.2
cc_5090 ( N_noxref_14_c_6082_p N_VDD_M125_noxref_d ) capacitor c=0.00700141f \
 //x=60.645 //y=5.335 //x2=60.175 //y2=5.2
cc_5091 ( N_noxref_14_c_6064_p N_VDD_M125_noxref_d ) capacitor c=0.067493f \
 //x=59.88 //y=5.56 //x2=60.175 //y2=5.2
cc_5092 ( N_noxref_14_c_6103_p N_VDD_M125_noxref_d ) capacitor c=0.0674288f \
 //x=60.76 //y=5.56 //x2=60.175 //y2=5.2
cc_5093 ( N_noxref_14_c_6022_p N_VDD_M127_noxref_d ) capacitor c=0.00700141f \
 //x=61.455 //y=5.335 //x2=61.055 //y2=5.2
cc_5094 ( N_noxref_14_c_6103_p N_VDD_M127_noxref_d ) capacitor c=0.0673824f \
 //x=60.76 //y=5.56 //x2=61.055 //y2=5.2
cc_5095 ( N_noxref_14_c_6113_p N_VDD_M128_noxref_s ) capacitor c=0.00536022f \
 //x=60.76 //y=5.56 //x2=62.935 //y2=5.2
cc_5096 ( N_noxref_14_c_6022_p N_VDD_M128_noxref_s ) capacitor c=0.00211796f \
 //x=61.455 //y=5.335 //x2=62.935 //y2=5.2
cc_5097 ( N_noxref_14_c_5990_n N_VDD_M128_noxref_s ) capacitor c=7.65656e-19 \
 //x=63.39 //y=2.945 //x2=62.935 //y2=5.2
cc_5098 ( N_noxref_14_M128_noxref_g N_VDD_M128_noxref_s ) capacitor \
 c=0.0567929f //x=63.29 //y=6.2 //x2=62.935 //y2=5.2
cc_5099 ( N_noxref_14_M129_noxref_g N_VDD_M129_noxref_d ) capacitor \
 c=0.015318f //x=63.73 //y=6.2 //x2=63.805 //y2=5.2
cc_5100 ( N_noxref_14_c_6065_p N_noxref_31_c_13426_n ) capacitor c=0.0036878f \
 //x=61.055 //y=1.305 //x2=61.455 //y2=0.72
cc_5101 ( N_noxref_14_c_6106_p N_noxref_31_c_13426_n ) capacitor c=0.00399931f \
 //x=61.455 //y=1.845 //x2=61.455 //y2=0.72
cc_5102 ( N_noxref_14_M37_noxref_d N_noxref_31_c_13426_n ) capacitor \
 c=0.00910163f //x=60.865 //y=1.095 //x2=61.455 //y2=0.72
cc_5103 ( N_noxref_14_M37_noxref_d N_noxref_31_c_13429_n ) capacitor \
 c=0.00120711f //x=60.865 //y=1.095 //x2=60.57 //y2=1.175
cc_5104 ( N_noxref_14_c_5999_n N_noxref_31_M36_noxref_d ) capacitor \
 c=0.00129815f //x=59.76 //y=5.335 //x2=59.33 //y2=1.09
cc_5105 ( N_noxref_14_c_6065_p N_noxref_31_M36_noxref_d ) capacitor \
 c=0.00802836f //x=61.055 //y=1.305 //x2=59.33 //y2=1.09
cc_5106 ( N_noxref_14_c_6065_p N_noxref_31_M37_noxref_s ) capacitor \
 c=0.00993092f //x=61.055 //y=1.305 //x2=60.435 //y2=0.555
cc_5107 ( N_noxref_14_c_6105_p N_noxref_31_M37_noxref_s ) capacitor \
 c=0.0270624f //x=61.055 //y=1.76 //x2=60.435 //y2=0.555
cc_5108 ( N_noxref_14_c_6106_p N_noxref_31_M37_noxref_s ) capacitor \
 c=0.00752108f //x=61.455 //y=1.845 //x2=60.435 //y2=0.555
cc_5109 ( N_noxref_14_c_6003_n N_noxref_31_M37_noxref_s ) capacitor \
 c=0.00309975f //x=61.54 //y=2.77 //x2=60.435 //y2=0.555
cc_5110 ( N_noxref_14_M37_noxref_d N_noxref_31_M37_noxref_s ) capacitor \
 c=0.0279003f //x=60.865 //y=1.095 //x2=60.435 //y2=0.555
cc_5111 ( N_noxref_14_c_6065_p N_GND_c_14513_n ) capacitor c=0.00884249f \
 //x=61.055 //y=1.305 //x2=63.375 //y2=0.175
cc_5112 ( N_noxref_14_c_6106_p N_GND_c_14513_n ) capacitor c=0.00662992f \
 //x=61.455 //y=1.845 //x2=63.375 //y2=0.175
cc_5113 ( N_noxref_14_c_5985_n N_GND_c_14513_n ) capacitor c=4.30498e-19 \
 //x=61.54 //y=2.945 //x2=63.375 //y2=0.175
cc_5114 ( N_noxref_14_M37_noxref_d N_GND_c_14513_n ) capacitor c=2.9462e-19 \
 //x=60.865 //y=1.095 //x2=63.375 //y2=0.175
cc_5115 ( N_noxref_14_c_6065_p N_GND_c_14517_n ) capacitor c=0.00488628f \
 //x=61.055 //y=1.305 //x2=63.46 //y2=1.135
cc_5116 ( N_noxref_14_c_5990_n N_GND_c_14517_n ) capacitor c=2.00375e-19 \
 //x=63.39 //y=2.945 //x2=63.46 //y2=1.135
cc_5117 ( N_noxref_14_c_6015_p N_GND_c_14517_n ) capacitor c=0.00645051f \
 //x=63.39 //y=2.26 //x2=63.46 //y2=1.135
cc_5118 ( N_noxref_14_c_6014_p N_GND_c_14517_n ) capacitor c=2.13705e-19 \
 //x=63.39 //y=2.26 //x2=63.46 //y2=1.135
cc_5119 ( N_noxref_14_c_6038_p N_GND_c_14517_n ) capacitor c=0.00176535f \
 //x=63.195 //y=1.045 //x2=63.46 //y2=1.135
cc_5120 ( N_noxref_14_c_6039_p N_GND_c_14517_n ) capacitor c=0.0036005f \
 //x=63.195 //y=1.39 //x2=63.46 //y2=1.135
cc_5121 ( N_noxref_14_c_6041_p N_GND_c_14517_n ) capacitor c=4.2764e-19 \
 //x=63.195 //y=1.7 //x2=63.46 //y2=1.135
cc_5122 ( N_noxref_14_c_6242_p N_GND_c_14517_n ) capacitor c=9.36995e-19 \
 //x=63.57 //y=0.89 //x2=63.46 //y2=1.135
cc_5123 ( N_noxref_14_c_6243_p N_GND_c_14517_n ) capacitor c=6.38426e-19 \
 //x=63.57 //y=1.545 //x2=63.46 //y2=1.135
cc_5124 ( N_noxref_14_c_6040_p N_GND_c_14517_n ) capacitor c=0.00171721f \
 //x=63.725 //y=1.045 //x2=63.46 //y2=1.135
cc_5125 ( N_noxref_14_c_6042_p N_GND_c_14517_n ) capacitor c=0.00296337f \
 //x=63.725 //y=1.39 //x2=63.46 //y2=1.135
cc_5126 ( N_noxref_14_c_6038_p N_GND_c_14528_n ) capacitor c=3.51399e-19 \
 //x=63.195 //y=1.045 //x2=63.457 //y2=1.005
cc_5127 ( N_noxref_14_c_6242_p N_GND_c_14528_n ) capacitor c=0.00852202f \
 //x=63.57 //y=0.89 //x2=63.457 //y2=1.005
cc_5128 ( N_noxref_14_c_6040_p N_GND_c_14528_n ) capacitor c=4.40641e-19 \
 //x=63.725 //y=1.045 //x2=63.457 //y2=1.005
cc_5129 ( N_noxref_14_c_6106_p N_GND_c_14475_n ) capacitor c=6.86343e-19 \
 //x=61.455 //y=1.845 //x2=62.11 //y2=0.175
cc_5130 ( N_noxref_14_c_5985_n N_GND_c_14475_n ) capacitor c=6.00344e-19 \
 //x=61.54 //y=2.945 //x2=62.11 //y2=0.175
cc_5131 ( N_noxref_14_c_6038_p N_GND_c_14533_n ) capacitor c=0.00688027f \
 //x=63.195 //y=1.045 //x2=65.44 //y2=0.175
cc_5132 ( N_noxref_14_c_6105_p N_GND_c_14334_n ) capacitor c=0.00285697f \
 //x=61.055 //y=1.76 //x2=62.28 //y2=0.175
cc_5133 ( N_noxref_14_c_6106_p N_GND_c_14334_n ) capacitor c=0.022222f \
 //x=61.455 //y=1.845 //x2=62.28 //y2=0.175
cc_5134 ( N_noxref_14_c_6007_p N_GND_c_14334_n ) capacitor c=2.00878e-19 \
 //x=61.54 //y=2.625 //x2=62.28 //y2=0.175
cc_5135 ( N_noxref_14_c_5985_n N_GND_c_14334_n ) capacitor c=0.00401039f \
 //x=61.54 //y=2.945 //x2=62.28 //y2=0.175
cc_5136 ( N_noxref_14_c_6009_p N_GND_c_14334_n ) capacitor c=0.00301679f \
 //x=63.39 //y=2.625 //x2=62.28 //y2=0.175
cc_5137 ( N_noxref_14_c_5990_n N_GND_c_14334_n ) capacitor c=0.00293146f \
 //x=63.39 //y=2.945 //x2=62.28 //y2=0.175
cc_5138 ( N_noxref_14_c_6003_n N_GND_c_14334_n ) capacitor c=0.0103966f \
 //x=61.54 //y=2.77 //x2=62.28 //y2=0.175
cc_5139 ( N_noxref_14_c_6011_p N_GND_c_14334_n ) capacitor c=0.00512795f \
 //x=63.39 //y=2.77 //x2=62.28 //y2=0.175
cc_5140 ( N_noxref_14_c_6015_p N_GND_c_14334_n ) capacitor c=0.00351582f \
 //x=63.39 //y=2.26 //x2=62.28 //y2=0.175
cc_5141 ( N_noxref_14_c_5997_n N_GND_c_14334_n ) capacitor c=0.00947774f \
 //x=63.225 //y=2.785 //x2=62.28 //y2=0.175
cc_5142 ( N_noxref_14_c_6014_p N_GND_c_14334_n ) capacitor c=0.00354425f \
 //x=63.39 //y=2.26 //x2=62.28 //y2=0.175
cc_5143 ( N_noxref_14_c_6041_p N_GND_c_14334_n ) capacitor c=0.0015404f \
 //x=63.195 //y=1.7 //x2=62.28 //y2=0.175
cc_5144 ( N_noxref_14_c_6017_p N_GND_c_14334_n ) capacitor c=0.0093907f \
 //x=63.195 //y=2.095 //x2=62.28 //y2=0.175
cc_5145 ( N_noxref_14_c_6011_p N_GND_c_14335_n ) capacitor c=0.00159554f \
 //x=63.39 //y=2.77 //x2=65.61 //y2=0.175
cc_5146 ( N_noxref_14_c_6015_p N_GND_M38_noxref_d ) capacitor c=2.20438e-19 \
 //x=63.39 //y=2.26 //x2=63.27 //y2=1.045
cc_5147 ( N_noxref_14_c_6038_p N_GND_M38_noxref_d ) capacitor c=0.00192399f \
 //x=63.195 //y=1.045 //x2=63.27 //y2=1.045
cc_5148 ( N_noxref_14_c_6039_p N_GND_M38_noxref_d ) capacitor c=0.00210798f \
 //x=63.195 //y=1.39 //x2=63.27 //y2=1.045
cc_5149 ( N_noxref_14_c_6242_p N_GND_M38_noxref_d ) capacitor c=0.00472259f \
 //x=63.57 //y=0.89 //x2=63.27 //y2=1.045
cc_5150 ( N_noxref_14_c_6243_p N_GND_M38_noxref_d ) capacitor c=0.00166857f \
 //x=63.57 //y=1.545 //x2=63.27 //y2=1.045
cc_5151 ( N_noxref_14_c_6040_p N_GND_M38_noxref_d ) capacitor c=0.00230174f \
 //x=63.725 //y=1.045 //x2=63.27 //y2=1.045
cc_5152 ( N_noxref_14_c_6042_p N_GND_M38_noxref_d ) capacitor c=0.00210798f \
 //x=63.725 //y=1.39 //x2=63.27 //y2=1.045
cc_5153 ( N_noxref_14_c_6017_p N_noxref_52_c_16538_n ) capacitor c=0.00262672f \
 //x=63.195 //y=2.095 //x2=62.975 //y2=1.675
cc_5154 ( N_noxref_14_c_5990_n N_noxref_52_c_16539_n ) capacitor c=0.00530082f \
 //x=63.39 //y=2.945 //x2=63.86 //y2=1.76
cc_5155 ( N_noxref_14_c_6015_p N_noxref_52_c_16539_n ) capacitor c=0.00509504f \
 //x=63.39 //y=2.26 //x2=63.86 //y2=1.76
cc_5156 ( N_noxref_14_c_6014_p N_noxref_52_c_16539_n ) capacitor c=0.00763108f \
 //x=63.39 //y=2.26 //x2=63.86 //y2=1.76
cc_5157 ( N_noxref_14_c_6041_p N_noxref_52_c_16539_n ) capacitor c=0.00697076f \
 //x=63.195 //y=1.7 //x2=63.86 //y2=1.76
cc_5158 ( N_noxref_14_c_6017_p N_noxref_52_c_16539_n ) capacitor c=0.0165799f \
 //x=63.195 //y=2.095 //x2=63.86 //y2=1.76
cc_5159 ( N_noxref_14_c_6243_p N_noxref_52_c_16539_n ) capacitor c=0.00723574f \
 //x=63.57 //y=1.545 //x2=63.86 //y2=1.76
cc_5160 ( N_noxref_14_c_6042_p N_noxref_52_c_16539_n ) capacitor c=0.00339872f \
 //x=63.725 //y=1.39 //x2=63.86 //y2=1.76
cc_5161 ( N_noxref_14_c_6017_p N_noxref_52_c_16546_n ) capacitor c=6.71402e-19 \
 //x=63.195 //y=2.095 //x2=63.945 //y2=1.675
cc_5162 ( N_noxref_14_c_6038_p N_noxref_52_M38_noxref_s ) capacitor \
 c=0.0295366f //x=63.195 //y=1.045 //x2=62.84 //y2=0.545
cc_5163 ( N_noxref_14_c_6041_p N_noxref_52_M38_noxref_s ) capacitor \
 c=3.48408e-19 //x=63.195 //y=1.7 //x2=62.84 //y2=0.545
cc_5164 ( N_noxref_14_c_6040_p N_noxref_52_M38_noxref_s ) capacitor \
 c=0.0125442f //x=63.725 //y=1.045 //x2=62.84 //y2=0.545
cc_5165 ( N_CLK_c_6683_n N_noxref_16_c_7297_n ) capacitor c=0.00117033f \
 //x=50.795 //y=4.62 //x2=51.18 //y2=4.405
cc_5166 ( N_CLK_c_6828_n N_noxref_16_c_7297_n ) capacitor c=0.00370399f \
 //x=51.395 //y=4.63 //x2=51.18 //y2=4.405
cc_5167 ( N_CLK_c_6683_n N_noxref_16_c_7282_n ) capacitor c=2.08045e-19 \
 //x=50.795 //y=4.62 //x2=51.18 //y2=4.735
cc_5168 ( N_CLK_c_6828_n N_noxref_16_c_7282_n ) capacitor c=0.0263725f \
 //x=51.395 //y=4.63 //x2=51.18 //y2=4.735
cc_5169 ( N_CLK_c_6830_n N_noxref_16_c_7282_n ) capacitor c=2.08036e-19 \
 //x=56.595 //y=4.635 //x2=51.18 //y2=4.735
cc_5170 ( N_CLK_c_6822_n N_noxref_16_c_7348_n ) capacitor c=0.0232953f \
 //x=54.88 //y=4.755 //x2=54.95 //y2=5.335
cc_5171 ( N_CLK_c_6830_n N_noxref_16_c_7348_n ) capacitor c=0.00118242f \
 //x=56.595 //y=4.635 //x2=54.95 //y2=5.335
cc_5172 ( N_CLK_c_6837_n N_noxref_16_c_7348_n ) capacitor c=0.00492634f \
 //x=54.88 //y=4.88 //x2=54.95 //y2=5.335
cc_5173 ( N_CLK_M118_noxref_g N_noxref_16_c_7348_n ) capacitor c=0.00858236f \
 //x=54.85 //y=6.2 //x2=54.95 //y2=5.335
cc_5174 ( N_CLK_c_6855_n N_noxref_16_c_7348_n ) capacitor c=3.67903e-19 \
 //x=54.88 //y=4.88 //x2=54.95 //y2=5.335
cc_5175 ( N_CLK_M119_noxref_g N_noxref_16_c_7424_n ) capacitor c=0.00955829f \
 //x=55.29 //y=6.2 //x2=55.835 //y2=5.335
cc_5176 ( N_CLK_c_6830_n N_noxref_16_c_7410_n ) capacitor c=0.0194557f \
 //x=56.595 //y=4.635 //x2=56.645 //y2=5.335
cc_5177 ( CLK N_noxref_16_c_7283_n ) capacitor c=0.00257456f //x=54.88 \
 //y=3.88 //x2=56.73 //y2=4.09
cc_5178 ( N_CLK_c_6829_n N_noxref_16_c_7357_n ) capacitor c=0.00726353f \
 //x=56.94 //y=4.635 //x2=56.73 //y2=4.41
cc_5179 ( N_CLK_c_6830_n N_noxref_16_c_7357_n ) capacitor c=0.00124799f \
 //x=56.595 //y=4.635 //x2=56.73 //y2=4.41
cc_5180 ( CLK N_noxref_16_c_7358_n ) capacitor c=3.42225e-19 //x=54.88 \
 //y=3.88 //x2=56.73 //y2=5.25
cc_5181 ( N_CLK_c_6829_n N_noxref_16_c_7358_n ) capacitor c=0.0293421f \
 //x=56.94 //y=4.635 //x2=56.73 //y2=5.25
cc_5182 ( N_CLK_c_6830_n N_noxref_16_c_7358_n ) capacitor c=3.09276e-19 \
 //x=56.595 //y=4.635 //x2=56.73 //y2=5.25
cc_5183 ( CLK N_noxref_16_c_7284_n ) capacitor c=0.00267689f //x=64.13 \
 //y=2.77 //x2=66.72 //y2=4.105
cc_5184 ( N_CLK_c_6830_n N_noxref_16_c_7361_n ) capacitor c=0.028072f \
 //x=56.595 //y=4.635 //x2=54.192 //y2=5.335
cc_5185 ( N_CLK_c_6822_n N_noxref_16_c_7434_n ) capacitor c=0.00519317f \
 //x=54.88 //y=4.755 //x2=55.07 //y2=5.335
cc_5186 ( N_CLK_c_6830_n N_noxref_16_c_7434_n ) capacitor c=0.0392307f \
 //x=56.595 //y=4.635 //x2=55.07 //y2=5.335
cc_5187 ( N_CLK_c_6837_n N_noxref_16_c_7434_n ) capacitor c=0.00132214f \
 //x=54.88 //y=4.88 //x2=55.07 //y2=5.335
cc_5188 ( N_CLK_M118_noxref_g N_noxref_16_c_7434_n ) capacitor c=0.00229818f \
 //x=54.85 //y=6.2 //x2=55.07 //y2=5.335
cc_5189 ( N_CLK_M119_noxref_g N_noxref_16_c_7434_n ) capacitor c=0.00230699f \
 //x=55.29 //y=6.2 //x2=55.07 //y2=5.335
cc_5190 ( N_CLK_c_6930_p N_noxref_16_c_7434_n ) capacitor c=0.00172334f \
 //x=55.215 //y=4.97 //x2=55.07 //y2=5.335
cc_5191 ( CLK N_noxref_16_c_7440_n ) capacitor c=4.33654e-19 //x=64.13 \
 //y=2.77 //x2=66.722 //y2=4.74
cc_5192 ( CLK N_noxref_16_c_7286_n ) capacitor c=0.0261717f //x=54.88 //y=3.88 \
 //x2=56.565 //y2=4.25
cc_5193 ( N_CLK_c_6822_n N_noxref_16_c_7286_n ) capacitor c=6.81418e-19 \
 //x=54.88 //y=4.755 //x2=56.565 //y2=4.25
cc_5194 ( N_CLK_c_6828_n N_noxref_16_c_7286_n ) capacitor c=0.0111504f \
 //x=51.395 //y=4.63 //x2=56.565 //y2=4.25
cc_5195 ( N_CLK_c_6830_n N_noxref_16_c_7286_n ) capacitor c=0.465811f \
 //x=56.595 //y=4.635 //x2=56.565 //y2=4.25
cc_5196 ( N_CLK_c_6830_n N_noxref_16_c_7368_n ) capacitor c=0.0364871f \
 //x=56.595 //y=4.635 //x2=56.885 //y2=4.25
cc_5197 ( N_CLK_c_6683_n N_noxref_16_c_7290_n ) capacitor c=0.0364798f \
 //x=50.795 //y=4.62 //x2=51.34 //y2=4.245
cc_5198 ( CLK N_noxref_16_c_7370_n ) capacitor c=0.020623f //x=64.13 //y=2.77 \
 //x2=66.56 //y2=4.265
cc_5199 ( N_CLK_c_6869_n N_noxref_16_c_7370_n ) capacitor c=0.00235509f \
 //x=64.165 //y=4.75 //x2=66.56 //y2=4.265
cc_5200 ( N_CLK_c_6829_n N_noxref_16_c_7370_n ) capacitor c=0.676145f \
 //x=56.94 //y=4.635 //x2=66.56 //y2=4.265
cc_5201 ( N_CLK_c_6822_n N_noxref_16_c_7450_n ) capacitor c=0.00185675f \
 //x=54.88 //y=4.755 //x2=55.07 //y2=5.56
cc_5202 ( N_CLK_M118_noxref_g N_noxref_16_c_7450_n ) capacitor c=0.0179041f \
 //x=54.85 //y=6.2 //x2=55.07 //y2=5.56
cc_5203 ( N_CLK_M119_noxref_g N_noxref_16_c_7450_n ) capacitor c=0.0179041f \
 //x=55.29 //y=6.2 //x2=55.07 //y2=5.56
cc_5204 ( N_CLK_c_6930_p N_noxref_16_c_7450_n ) capacitor c=0.00294585f \
 //x=55.215 //y=4.97 //x2=55.07 //y2=5.56
cc_5205 ( N_CLK_c_6828_n N_noxref_16_c_7330_n ) capacitor c=7.58668e-19 \
 //x=51.395 //y=4.63 //x2=51.21 //y2=4.88
cc_5206 ( N_CLK_c_6302_n SN ) capacitor c=0.0268258f //x=17.75 //y=4.65 \
 //x2=10.85 //y2=2.77
cc_5207 ( N_CLK_c_6434_n SN ) capacitor c=9.31077e-19 //x=21.425 //y=4.65 \
 //x2=22.32 //y2=2.77
cc_5208 ( N_CLK_c_6476_n SN ) capacitor c=0.0295174f //x=26.375 //y=4.62 \
 //x2=22.32 //y2=2.77
cc_5209 ( N_CLK_c_6829_n SN ) capacitor c=0.0268258f //x=56.94 //y=4.635 \
 //x2=59.69 //y2=2.77
cc_5210 ( N_CLK_c_6302_n N_SN_c_8055_n ) capacitor c=0.00431511f //x=17.75 \
 //y=4.65 //x2=10.85 //y2=4.765
cc_5211 ( N_CLK_c_6476_n N_SN_c_8134_n ) capacitor c=0.00431511f //x=26.375 \
 //y=4.62 //x2=22.32 //y2=4.765
cc_5212 ( N_CLK_c_6557_n N_SN_c_8257_n ) capacitor c=0.0311409f //x=42.17 \
 //y=4.65 //x2=35.27 //y2=4.765
cc_5213 ( N_CLK_c_6683_n N_SN_c_8364_n ) capacitor c=0.0311409f //x=50.795 \
 //y=4.62 //x2=46.74 //y2=4.765
cc_5214 ( N_CLK_c_6829_n N_SN_c_8591_n ) capacitor c=0.00431511f //x=56.94 \
 //y=4.635 //x2=59.69 //y2=4.765
cc_5215 ( CLK N_SN_c_8092_n ) capacitor c=0.0140253f //x=15.29 //y=2.77 \
 //x2=22.15 //y2=2.4
cc_5216 ( N_CLK_c_6337_n N_SN_c_8092_n ) capacitor c=0.0172004f //x=15.29 \
 //y=2.26 //x2=22.15 //y2=2.4
cc_5217 ( N_CLK_c_6370_n N_SN_c_8092_n ) capacitor c=2.5407e-19 //x=15.29 \
 //y=2.26 //x2=22.15 //y2=2.4
cc_5218 ( N_CLK_c_6544_n N_SN_c_8275_n ) capacitor c=5.2488e-19 //x=30.46 \
 //y=2.375 //x2=29.565 //y2=2.385
cc_5219 ( CLK N_SN_c_8282_n ) capacitor c=0.013772f //x=30.46 //y=3.88 \
 //x2=33.775 //y2=2.4
cc_5220 ( N_CLK_c_6544_n N_SN_c_8282_n ) capacitor c=0.0173773f //x=30.46 \
 //y=2.375 //x2=33.775 //y2=2.4
cc_5221 ( N_CLK_c_6558_n N_SN_c_8282_n ) capacitor c=5.2767e-19 //x=30.46 \
 //y=2.26 //x2=33.775 //y2=2.4
cc_5222 ( N_CLK_c_6577_n N_SN_c_8282_n ) capacitor c=4.03361e-19 //x=30.55 \
 //y=2.095 //x2=33.775 //y2=2.4
cc_5223 ( CLK N_SN_c_8324_n ) capacitor c=0.0140253f //x=39.71 //y=2.77 \
 //x2=46.57 //y2=2.4
cc_5224 ( N_CLK_c_6591_n N_SN_c_8324_n ) capacitor c=0.0172004f //x=39.71 \
 //y=2.26 //x2=46.57 //y2=2.4
cc_5225 ( N_CLK_c_6624_n N_SN_c_8324_n ) capacitor c=2.5407e-19 //x=39.71 \
 //y=2.26 //x2=46.57 //y2=2.4
cc_5226 ( N_CLK_c_6819_n N_SN_c_8515_n ) capacitor c=5.2488e-19 //x=54.88 \
 //y=2.375 //x2=53.985 //y2=2.385
cc_5227 ( CLK N_SN_c_8516_n ) capacitor c=0.013772f //x=54.88 //y=3.88 \
 //x2=58.195 //y2=2.4
cc_5228 ( N_CLK_c_6819_n N_SN_c_8516_n ) capacitor c=0.0173773f //x=54.88 \
 //y=2.375 //x2=58.195 //y2=2.4
cc_5229 ( N_CLK_c_6833_n N_SN_c_8516_n ) capacitor c=5.2767e-19 //x=54.88 \
 //y=2.26 //x2=58.195 //y2=2.4
cc_5230 ( N_CLK_c_6852_n N_SN_c_8516_n ) capacitor c=4.03361e-19 //x=54.97 \
 //y=2.095 //x2=58.195 //y2=2.4
cc_5231 ( CLK N_SN_c_8521_n ) capacitor c=0.0140253f //x=64.13 //y=2.77 \
 //x2=70.99 //y2=2.39
cc_5232 ( N_CLK_c_6866_n N_SN_c_8521_n ) capacitor c=0.0172004f //x=64.13 \
 //y=2.26 //x2=70.99 //y2=2.39
cc_5233 ( N_CLK_c_6899_n N_SN_c_8521_n ) capacitor c=2.5407e-19 //x=64.13 \
 //y=2.26 //x2=70.99 //y2=2.39
cc_5234 ( N_CLK_c_6819_n N_noxref_19_c_9362_n ) capacitor c=0.00936037f \
 //x=54.88 //y=2.375 //x2=55.99 //y2=2.375
cc_5235 ( N_CLK_c_6833_n N_noxref_19_c_9362_n ) capacitor c=5.39999e-19 \
 //x=54.88 //y=2.26 //x2=55.99 //y2=2.375
cc_5236 ( N_CLK_c_6852_n N_noxref_19_c_9362_n ) capacitor c=0.00137098f \
 //x=54.97 //y=2.095 //x2=55.99 //y2=2.375
cc_5237 ( CLK N_noxref_19_c_9261_n ) capacitor c=0.0292717f //x=54.88 //y=3.88 \
 //x2=55.99 //y2=3.705
cc_5238 ( N_CLK_c_6833_n N_noxref_19_c_9261_n ) capacitor c=3.9149e-19 \
 //x=54.88 //y=2.26 //x2=55.99 //y2=3.705
cc_5239 ( CLK N_noxref_19_c_9367_n ) capacitor c=0.00776638f //x=54.88 \
 //y=3.88 //x2=55.99 //y2=4.025
cc_5240 ( CLK N_noxref_19_c_9279_n ) capacitor c=0.0126059f //x=54.88 //y=3.88 \
 //x2=55.99 //y2=4.75
cc_5241 ( N_CLK_c_6822_n N_noxref_19_c_9279_n ) capacitor c=0.0109762f \
 //x=54.88 //y=4.755 //x2=55.99 //y2=4.75
cc_5242 ( N_CLK_c_6830_n N_noxref_19_c_9279_n ) capacitor c=0.0333551f \
 //x=56.595 //y=4.635 //x2=55.99 //y2=4.75
cc_5243 ( N_CLK_c_6837_n N_noxref_19_c_9279_n ) capacitor c=4.56604e-19 \
 //x=54.88 //y=4.88 //x2=55.99 //y2=4.75
cc_5244 ( N_CLK_c_6829_n N_noxref_19_c_9283_n ) capacitor c=0.0287127f \
 //x=56.94 //y=4.635 //x2=60.8 //y2=4.75
cc_5245 ( N_CLK_c_6869_n N_noxref_19_c_9301_n ) capacitor c=0.0233476f \
 //x=64.165 //y=4.75 //x2=64.275 //y2=5.38
cc_5246 ( N_CLK_c_6829_n N_noxref_19_c_9301_n ) capacitor c=9.84751e-19 \
 //x=56.94 //y=4.635 //x2=64.275 //y2=5.38
cc_5247 ( N_CLK_c_6883_n N_noxref_19_c_9301_n ) capacitor c=0.00469232f \
 //x=64.16 //y=4.88 //x2=64.275 //y2=5.38
cc_5248 ( N_CLK_M130_noxref_g N_noxref_19_c_9301_n ) capacitor c=0.00842852f \
 //x=64.17 //y=6.2 //x2=64.275 //y2=5.38
cc_5249 ( N_CLK_c_6902_n N_noxref_19_c_9301_n ) capacitor c=7.94507e-19 \
 //x=64.16 //y=4.88 //x2=64.275 //y2=5.38
cc_5250 ( N_CLK_c_6892_n N_noxref_19_c_9302_n ) capacitor c=0.00119302f \
 //x=64.165 //y=1.43 //x2=64.43 //y2=1.75
cc_5251 ( N_CLK_c_6894_n N_noxref_19_c_9302_n ) capacitor c=0.00439215f \
 //x=64.165 //y=1.74 //x2=64.43 //y2=1.75
cc_5252 ( N_CLK_c_6992_p N_noxref_19_c_9302_n ) capacitor c=0.00917366f \
 //x=64.54 //y=1.585 //x2=64.43 //y2=1.75
cc_5253 ( N_CLK_c_6898_n N_noxref_19_c_9302_n ) capacitor c=0.003249f \
 //x=64.695 //y=1.43 //x2=64.43 //y2=1.75
cc_5254 ( N_CLK_c_6994_p N_noxref_19_c_9302_n ) capacitor c=0.00341688f \
 //x=64.13 //y=2.095 //x2=64.43 //y2=1.75
cc_5255 ( N_CLK_M131_noxref_g N_noxref_19_c_9383_n ) capacitor c=0.0109545f \
 //x=64.61 //y=6.2 //x2=64.785 //y2=5.38
cc_5256 ( N_CLK_c_6992_p N_noxref_19_c_9384_n ) capacitor c=0.00194324f \
 //x=64.54 //y=1.585 //x2=64.785 //y2=1.835
cc_5257 ( N_CLK_c_6898_n N_noxref_19_c_9384_n ) capacitor c=0.00323005f \
 //x=64.695 //y=1.43 //x2=64.785 //y2=1.835
cc_5258 ( CLK N_noxref_19_c_9263_n ) capacitor c=0.0518972f //x=64.13 //y=2.77 \
 //x2=64.87 //y2=3.705
cc_5259 ( N_CLK_c_6866_n N_noxref_19_c_9263_n ) capacitor c=0.0138368f \
 //x=64.13 //y=2.26 //x2=64.87 //y2=3.705
cc_5260 ( N_CLK_c_6879_n N_noxref_19_c_9263_n ) capacitor c=9.26054e-19 \
 //x=64.13 //y=2.26 //x2=64.87 //y2=3.705
cc_5261 ( N_CLK_c_6899_n N_noxref_19_c_9263_n ) capacitor c=0.00268898f \
 //x=64.13 //y=2.26 //x2=64.87 //y2=3.705
cc_5262 ( N_CLK_c_6994_p N_noxref_19_c_9263_n ) capacitor c=0.00309058f \
 //x=64.13 //y=2.095 //x2=64.87 //y2=3.705
cc_5263 ( CLK N_noxref_19_c_9391_n ) capacitor c=0.0176724f //x=64.13 //y=2.77 \
 //x2=64.87 //y2=4.025
cc_5264 ( N_CLK_c_7004_p N_noxref_19_c_9391_n ) capacitor c=0.00127572f \
 //x=64.535 //y=4.97 //x2=64.87 //y2=4.025
cc_5265 ( CLK N_noxref_19_c_9307_n ) capacitor c=0.0217318f //x=64.13 //y=2.77 \
 //x2=64.87 //y2=5.295
cc_5266 ( N_CLK_c_6869_n N_noxref_19_c_9307_n ) capacitor c=0.0218509f \
 //x=64.165 //y=4.75 //x2=64.87 //y2=5.295
cc_5267 ( N_CLK_c_6829_n N_noxref_19_c_9307_n ) capacitor c=0.00878819f \
 //x=56.94 //y=4.635 //x2=64.87 //y2=5.295
cc_5268 ( N_CLK_c_6883_n N_noxref_19_c_9307_n ) capacitor c=5.14671e-19 \
 //x=64.16 //y=4.88 //x2=64.87 //y2=5.295
cc_5269 ( N_CLK_c_7004_p N_noxref_19_c_9307_n ) capacitor c=0.00844995f \
 //x=64.535 //y=4.97 //x2=64.87 //y2=5.295
cc_5270 ( CLK N_noxref_19_c_9398_n ) capacitor c=5.01652e-19 //x=54.88 \
 //y=3.88 //x2=55.99 //y2=3.88
cc_5271 ( N_CLK_c_6829_n N_noxref_19_c_9310_n ) capacitor c=0.0211459f \
 //x=56.94 //y=4.635 //x2=63.51 //y2=5.56
cc_5272 ( N_CLK_c_6869_n N_noxref_19_c_9400_n ) capacitor c=0.00285789f \
 //x=64.165 //y=4.75 //x2=64.39 //y2=5.38
cc_5273 ( N_CLK_c_6829_n N_noxref_19_c_9400_n ) capacitor c=0.00123315f \
 //x=56.94 //y=4.635 //x2=64.39 //y2=5.38
cc_5274 ( N_CLK_M130_noxref_g N_noxref_19_c_9400_n ) capacitor c=0.00192712f \
 //x=64.17 //y=6.2 //x2=64.39 //y2=5.38
cc_5275 ( N_CLK_M131_noxref_g N_noxref_19_c_9400_n ) capacitor c=0.00298276f \
 //x=64.61 //y=6.2 //x2=64.39 //y2=5.38
cc_5276 ( N_CLK_c_7004_p N_noxref_19_c_9400_n ) capacitor c=0.0020909f \
 //x=64.535 //y=4.97 //x2=64.39 //y2=5.38
cc_5277 ( N_CLK_c_6889_n N_noxref_19_c_9318_n ) capacitor c=0.00120406f \
 //x=64.165 //y=1.085 //x2=64.43 //y2=1.18
cc_5278 ( N_CLK_c_6892_n N_noxref_19_c_9318_n ) capacitor c=0.00218772f \
 //x=64.165 //y=1.43 //x2=64.43 //y2=1.18
cc_5279 ( N_CLK_c_7019_p N_noxref_19_c_9318_n ) capacitor c=5.50523e-19 \
 //x=64.54 //y=0.93 //x2=64.43 //y2=1.18
cc_5280 ( N_CLK_c_6992_p N_noxref_19_c_9318_n ) capacitor c=5.64626e-19 \
 //x=64.54 //y=1.585 //x2=64.43 //y2=1.18
cc_5281 ( N_CLK_c_6897_n N_noxref_19_c_9318_n ) capacitor c=0.00109205f \
 //x=64.695 //y=1.085 //x2=64.43 //y2=1.18
cc_5282 ( N_CLK_c_6898_n N_noxref_19_c_9318_n ) capacitor c=0.00317092f \
 //x=64.695 //y=1.43 //x2=64.43 //y2=1.18
cc_5283 ( CLK N_noxref_19_c_9411_n ) capacitor c=9.19401e-19 //x=64.13 \
 //y=2.77 //x2=64.87 //y2=3.88
cc_5284 ( N_CLK_c_6830_n N_noxref_19_c_9266_n ) capacitor c=0.0035631f \
 //x=56.595 //y=4.635 //x2=56.34 //y2=3.88
cc_5285 ( N_CLK_c_6829_n N_noxref_19_c_9413_n ) capacitor c=0.0018021f \
 //x=56.94 //y=4.635 //x2=56.94 //y2=3.865
cc_5286 ( N_CLK_c_6829_n N_noxref_19_c_9267_n ) capacitor c=0.0213917f \
 //x=56.94 //y=4.635 //x2=60.96 //y2=3.88
cc_5287 ( CLK N_noxref_19_c_9415_n ) capacitor c=0.00512566f //x=54.88 \
 //y=3.88 //x2=56.155 //y2=3.865
cc_5288 ( CLK N_noxref_19_c_9269_n ) capacitor c=0.0195461f //x=64.13 //y=2.77 \
 //x2=64.705 //y2=3.865
cc_5289 ( N_CLK_c_6829_n N_noxref_19_c_9269_n ) capacitor c=0.0185585f \
 //x=56.94 //y=4.635 //x2=64.705 //y2=3.865
cc_5290 ( CLK N_noxref_19_c_9418_n ) capacitor c=0.00338457f //x=64.13 \
 //y=2.77 //x2=65.025 //y2=3.865
cc_5291 ( CLK N_noxref_19_c_9419_n ) capacitor c=3.9149e-19 //x=54.88 //y=3.88 \
 //x2=55.99 //y2=2.26
cc_5292 ( N_CLK_c_6819_n N_noxref_19_c_9419_n ) capacitor c=5.42289e-19 \
 //x=54.88 //y=2.375 //x2=55.99 //y2=2.26
cc_5293 ( N_CLK_c_6833_n N_noxref_19_c_9419_n ) capacitor c=0.00125213f \
 //x=54.88 //y=2.26 //x2=55.99 //y2=2.26
cc_5294 ( N_CLK_c_6852_n N_noxref_19_c_9419_n ) capacitor c=0.00209664f \
 //x=54.97 //y=2.095 //x2=55.99 //y2=2.26
cc_5295 ( N_CLK_c_6822_n N_noxref_19_c_9423_n ) capacitor c=9.62855e-19 \
 //x=54.88 //y=4.755 //x2=55.99 //y2=4.88
cc_5296 ( N_CLK_c_6837_n N_noxref_19_c_9423_n ) capacitor c=0.00113668f \
 //x=54.88 //y=4.88 //x2=55.99 //y2=4.88
cc_5297 ( N_CLK_c_6855_n N_noxref_19_c_9423_n ) capacitor c=9.77556e-19 \
 //x=54.88 //y=4.88 //x2=55.99 //y2=4.88
cc_5298 ( N_CLK_c_6869_n N_noxref_19_c_9426_n ) capacitor c=7.41644e-19 \
 //x=64.165 //y=4.75 //x2=64.39 //y2=5.56
cc_5299 ( N_CLK_M130_noxref_g N_noxref_19_c_9426_n ) capacitor c=0.0178987f \
 //x=64.17 //y=6.2 //x2=64.39 //y2=5.56
cc_5300 ( N_CLK_M131_noxref_g N_noxref_19_c_9426_n ) capacitor c=0.0178506f \
 //x=64.61 //y=6.2 //x2=64.39 //y2=5.56
cc_5301 ( N_CLK_c_7004_p N_noxref_19_c_9426_n ) capacitor c=0.00291714f \
 //x=64.535 //y=4.97 //x2=64.39 //y2=5.56
cc_5302 ( N_CLK_M118_noxref_g N_noxref_19_M120_noxref_g ) capacitor \
 c=0.0101598f //x=54.85 //y=6.2 //x2=55.73 //y2=6.2
cc_5303 ( N_CLK_M119_noxref_g N_noxref_19_M120_noxref_g ) capacitor \
 c=0.0607518f //x=55.29 //y=6.2 //x2=55.73 //y2=6.2
cc_5304 ( N_CLK_M119_noxref_g N_noxref_19_M121_noxref_g ) capacitor \
 c=0.0101598f //x=55.29 //y=6.2 //x2=56.17 //y2=6.2
cc_5305 ( N_CLK_c_6849_n N_noxref_19_c_9433_n ) capacitor c=0.00456962f \
 //x=54.97 //y=1.09 //x2=55.98 //y2=1.095
cc_5306 ( N_CLK_c_6850_n N_noxref_19_c_9434_n ) capacitor c=0.00438372f \
 //x=54.97 //y=1.4 //x2=55.98 //y2=1.44
cc_5307 ( N_CLK_c_6851_n N_noxref_19_c_9435_n ) capacitor c=0.00438372f \
 //x=54.97 //y=1.63 //x2=55.98 //y2=1.75
cc_5308 ( N_CLK_c_6819_n N_noxref_19_c_9436_n ) capacitor c=0.00134951f \
 //x=54.88 //y=2.375 //x2=55.99 //y2=2.26
cc_5309 ( N_CLK_c_6833_n N_noxref_19_c_9436_n ) capacitor c=0.00204868f \
 //x=54.88 //y=2.26 //x2=55.99 //y2=2.26
cc_5310 ( N_CLK_c_6852_n N_noxref_19_c_9436_n ) capacitor c=0.00933826f \
 //x=54.97 //y=2.095 //x2=55.99 //y2=2.26
cc_5311 ( N_CLK_c_6852_n N_noxref_19_c_9439_n ) capacitor c=0.00438372f \
 //x=54.97 //y=2.095 //x2=55.99 //y2=2.095
cc_5312 ( N_CLK_c_6822_n N_noxref_19_c_9440_n ) capacitor c=0.00135081f \
 //x=54.88 //y=4.755 //x2=55.99 //y2=4.88
cc_5313 ( N_CLK_c_6837_n N_noxref_19_c_9440_n ) capacitor c=0.00186974f \
 //x=54.88 //y=4.88 //x2=55.99 //y2=4.88
cc_5314 ( N_CLK_c_6930_p N_noxref_19_c_9440_n ) capacitor c=0.0616777f \
 //x=55.215 //y=4.97 //x2=55.99 //y2=4.88
cc_5315 ( N_CLK_c_6855_n N_noxref_19_c_9440_n ) capacitor c=0.0042693f \
 //x=54.88 //y=4.88 //x2=55.99 //y2=4.88
cc_5316 ( N_CLK_c_6889_n N_noxref_19_M39_noxref_d ) capacitor c=0.00137165f \
 //x=64.165 //y=1.085 //x2=64.24 //y2=1.085
cc_5317 ( N_CLK_c_6892_n N_noxref_19_M39_noxref_d ) capacitor c=0.00237422f \
 //x=64.165 //y=1.43 //x2=64.24 //y2=1.085
cc_5318 ( N_CLK_c_7019_p N_noxref_19_M39_noxref_d ) capacitor c=0.0020782f \
 //x=64.54 //y=0.93 //x2=64.24 //y2=1.085
cc_5319 ( N_CLK_c_6992_p N_noxref_19_M39_noxref_d ) capacitor c=0.00356097f \
 //x=64.54 //y=1.585 //x2=64.24 //y2=1.085
cc_5320 ( N_CLK_c_6897_n N_noxref_19_M39_noxref_d ) capacitor c=8.50095e-19 \
 //x=64.695 //y=1.085 //x2=64.24 //y2=1.085
cc_5321 ( N_CLK_c_6898_n N_noxref_19_M39_noxref_d ) capacitor c=0.00237422f \
 //x=64.695 //y=1.43 //x2=64.24 //y2=1.085
cc_5322 ( N_CLK_c_6396_n N_noxref_21_c_10406_n ) capacitor c=6.64958e-19 \
 //x=18.095 //y=4.65 //x2=18.62 //y2=4.735
cc_5323 ( N_CLK_c_6421_n N_noxref_21_c_10406_n ) capacitor c=0.0300946f \
 //x=18.975 //y=4.62 //x2=18.62 //y2=4.735
cc_5324 ( N_CLK_c_6476_n N_noxref_21_c_10461_n ) capacitor c=0.0144395f \
 //x=26.375 //y=4.62 //x2=22.39 //y2=5.335
cc_5325 ( N_CLK_c_6476_n N_noxref_21_c_10521_n ) capacitor c=0.0215428f \
 //x=26.375 //y=4.62 //x2=24.085 //y2=5.335
cc_5326 ( N_CLK_c_6476_n N_noxref_21_c_10543_n ) capacitor c=0.00363437f \
 //x=26.375 //y=4.62 //x2=24.17 //y2=3.685
cc_5327 ( N_CLK_c_6476_n N_noxref_21_c_10544_n ) capacitor c=0.0339297f \
 //x=26.375 //y=4.62 //x2=24.17 //y2=5.25
cc_5328 ( N_CLK_c_6434_n N_noxref_21_c_10466_n ) capacitor c=0.0154299f \
 //x=21.425 //y=4.65 //x2=21.632 //y2=5.335
cc_5329 ( N_CLK_c_6476_n N_noxref_21_c_10784_n ) capacitor c=0.0381732f \
 //x=26.375 //y=4.62 //x2=22.51 //y2=5.335
cc_5330 ( N_CLK_c_6421_n N_noxref_21_c_10471_n ) capacitor c=0.00216605f \
 //x=18.975 //y=4.62 //x2=23.045 //y2=3.51
cc_5331 ( N_CLK_c_6434_n N_noxref_21_c_10471_n ) capacitor c=0.0095076f \
 //x=21.425 //y=4.65 //x2=23.045 //y2=3.51
cc_5332 ( N_CLK_c_6476_n N_noxref_21_c_10471_n ) capacitor c=0.00665882f \
 //x=26.375 //y=4.62 //x2=23.045 //y2=3.51
cc_5333 ( CLK N_noxref_21_c_10561_n ) capacitor c=0.0272f //x=30.46 //y=3.88 \
 //x2=31.36 //y2=3.48
cc_5334 ( N_CLK_c_6476_n N_noxref_21_c_10561_n ) capacitor c=0.0914293f \
 //x=26.375 //y=4.62 //x2=31.36 //y2=3.48
cc_5335 ( N_CLK_c_6554_n N_noxref_21_c_10561_n ) capacitor c=0.0174071f \
 //x=32.175 //y=4.635 //x2=31.36 //y2=3.48
cc_5336 ( CLK N_noxref_21_c_10588_n ) capacitor c=0.0216193f //x=39.71 \
 //y=2.77 //x2=40.06 //y2=3.51
cc_5337 ( N_CLK_c_6660_n N_noxref_21_c_10606_n ) capacitor c=0.00246913f \
 //x=43.245 //y=4.65 //x2=47.465 //y2=3.51
cc_5338 ( N_CLK_c_6683_n N_noxref_21_c_10633_n ) capacitor c=0.049535f \
 //x=50.795 //y=4.62 //x2=48.065 //y2=3.495
cc_5339 ( N_CLK_c_6683_n N_noxref_21_c_10661_n ) capacitor c=0.0188157f \
 //x=50.795 //y=4.62 //x2=50.045 //y2=3.51
cc_5340 ( N_CLK_c_6683_n N_noxref_21_c_10665_n ) capacitor c=0.00595586f \
 //x=50.795 //y=4.62 //x2=50.645 //y2=3.54
cc_5341 ( CLK N_noxref_21_c_10666_n ) capacitor c=0.0272f //x=54.88 //y=3.88 \
 //x2=55.61 //y2=3.51
cc_5342 ( N_CLK_c_6683_n N_noxref_21_c_10666_n ) capacitor c=0.0066354f \
 //x=50.795 //y=4.62 //x2=55.61 //y2=3.51
cc_5343 ( N_CLK_c_6830_n N_noxref_21_c_10666_n ) capacitor c=0.0174045f \
 //x=56.595 //y=4.635 //x2=55.61 //y2=3.51
cc_5344 ( CLK N_noxref_21_c_10677_n ) capacitor c=0.0216193f //x=64.13 \
 //y=2.77 //x2=64.48 //y2=3.51
cc_5345 ( N_CLK_M58_noxref_g N_VDD_c_11651_n ) capacitor c=0.00705252f \
 //x=6.01 //y=6.2 //x2=6.585 //y2=7.585
cc_5346 ( N_CLK_M59_noxref_g N_VDD_c_11651_n ) capacitor c=0.00755544f \
 //x=6.45 //y=6.2 //x2=6.585 //y2=7.585
cc_5347 ( N_CLK_M70_noxref_g N_VDD_c_11781_n ) capacitor c=0.00697352f \
 //x=15.33 //y=6.2 //x2=15.905 //y2=7.585
cc_5348 ( N_CLK_M71_noxref_g N_VDD_c_11781_n ) capacitor c=0.00755544f \
 //x=15.77 //y=6.2 //x2=15.905 //y2=7.585
cc_5349 ( N_CLK_M88_noxref_g N_VDD_c_11951_n ) capacitor c=0.00705252f \
 //x=30.43 //y=6.2 //x2=31.005 //y2=7.585
cc_5350 ( N_CLK_M89_noxref_g N_VDD_c_11951_n ) capacitor c=0.00755544f \
 //x=30.87 //y=6.2 //x2=31.005 //y2=7.585
cc_5351 ( N_CLK_M100_noxref_g N_VDD_c_12070_n ) capacitor c=0.00697352f \
 //x=39.75 //y=6.2 //x2=40.325 //y2=7.585
cc_5352 ( N_CLK_M101_noxref_g N_VDD_c_12070_n ) capacitor c=0.00755544f \
 //x=40.19 //y=6.2 //x2=40.325 //y2=7.585
cc_5353 ( N_CLK_M118_noxref_g N_VDD_c_12341_n ) capacitor c=0.00705252f \
 //x=54.85 //y=6.2 //x2=55.425 //y2=7.585
cc_5354 ( N_CLK_M119_noxref_g N_VDD_c_12341_n ) capacitor c=0.00755544f \
 //x=55.29 //y=6.2 //x2=55.425 //y2=7.585
cc_5355 ( N_CLK_M130_noxref_g N_VDD_c_12343_n ) capacitor c=0.00697352f \
 //x=64.17 //y=6.2 //x2=64.745 //y2=7.585
cc_5356 ( N_CLK_M131_noxref_g N_VDD_c_12343_n ) capacitor c=0.00755544f \
 //x=64.61 //y=6.2 //x2=64.745 //y2=7.585
cc_5357 ( N_CLK_c_6302_n N_VDD_c_11551_n ) capacitor c=0.0264761f //x=17.75 \
 //y=4.65 //x2=8.63 //y2=7.585
cc_5358 ( N_CLK_c_6302_n N_VDD_c_11609_n ) capacitor c=0.02652f //x=17.75 \
 //y=4.65 //x2=13.44 //y2=7.585
cc_5359 ( N_CLK_c_6302_n N_VDD_c_11679_n ) capacitor c=0.0267992f //x=17.75 \
 //y=4.65 //x2=16.77 //y2=7.585
cc_5360 ( N_CLK_c_6354_n N_VDD_c_11679_n ) capacitor c=0.00228191f //x=15.32 \
 //y=4.88 //x2=16.77 //y2=7.585
cc_5361 ( N_CLK_c_6513_n N_VDD_c_11679_n ) capacitor c=0.0129149f //x=15.695 \
 //y=4.97 //x2=16.77 //y2=7.585
cc_5362 ( N_CLK_c_6373_n N_VDD_c_11679_n ) capacitor c=2.73429e-19 //x=15.32 \
 //y=4.88 //x2=16.77 //y2=7.585
cc_5363 ( N_CLK_c_6426_n N_VDD_c_11733_n ) capacitor c=6.10685e-19 //x=19.575 \
 //y=4.65 //x2=20.1 //y2=7.585
cc_5364 ( N_CLK_c_6429_n N_VDD_c_11733_n ) capacitor c=0.0263335f //x=20.825 \
 //y=4.62 //x2=20.1 //y2=7.585
cc_5365 ( N_CLK_c_6476_n N_VDD_c_11799_n ) capacitor c=0.026315f //x=26.375 \
 //y=4.62 //x2=24.91 //y2=7.585
cc_5366 ( N_CLK_c_6554_n N_VDD_c_11844_n ) capacitor c=0.0264937f //x=32.175 \
 //y=4.635 //x2=28.24 //y2=7.585
cc_5367 ( N_CLK_c_6557_n N_VDD_c_11851_n ) capacitor c=0.0266706f //x=42.17 \
 //y=4.65 //x2=33.05 //y2=7.585
cc_5368 ( N_CLK_c_6557_n N_VDD_c_11909_n ) capacitor c=0.02652f //x=42.17 \
 //y=4.65 //x2=37.86 //y2=7.585
cc_5369 ( N_CLK_c_6557_n N_VDD_c_11979_n ) capacitor c=0.026833f //x=42.17 \
 //y=4.65 //x2=41.19 //y2=7.585
cc_5370 ( N_CLK_c_6608_n N_VDD_c_11979_n ) capacitor c=0.00228191f //x=39.74 \
 //y=4.88 //x2=41.19 //y2=7.585
cc_5371 ( N_CLK_c_6755_n N_VDD_c_11979_n ) capacitor c=0.0129149f //x=40.115 \
 //y=4.97 //x2=41.19 //y2=7.585
cc_5372 ( N_CLK_c_6627_n N_VDD_c_11979_n ) capacitor c=2.73429e-19 //x=39.74 \
 //y=4.88 //x2=41.19 //y2=7.585
cc_5373 ( N_CLK_c_6683_n N_VDD_c_12027_n ) capacitor c=0.026442f //x=50.795 \
 //y=4.62 //x2=44.52 //y2=7.585
cc_5374 ( N_CLK_c_6683_n N_VDD_c_12088_n ) capacitor c=0.0263527f //x=50.795 \
 //y=4.62 //x2=49.33 //y2=7.585
cc_5375 ( N_CLK_c_6830_n N_VDD_c_12245_n ) capacitor c=0.0264937f //x=56.595 \
 //y=4.635 //x2=52.66 //y2=7.585
cc_5376 ( N_CLK_c_6829_n N_VDD_c_12252_n ) capacitor c=0.0266706f //x=56.94 \
 //y=4.635 //x2=57.47 //y2=7.585
cc_5377 ( N_CLK_c_6829_n N_VDD_c_12310_n ) capacitor c=0.0263497f //x=56.94 \
 //y=4.635 //x2=62.28 //y2=7.585
cc_5378 ( N_CLK_c_6883_n N_VDD_c_12366_n ) capacitor c=0.00228191f //x=64.16 \
 //y=4.88 //x2=65.61 //y2=7.585
cc_5379 ( N_CLK_c_7004_p N_VDD_c_12366_n ) capacitor c=0.0129149f //x=64.535 \
 //y=4.97 //x2=65.61 //y2=7.585
cc_5380 ( N_CLK_c_6902_n N_VDD_c_12366_n ) capacitor c=2.73429e-19 //x=64.16 \
 //y=4.88 //x2=65.61 //y2=7.585
cc_5381 ( N_CLK_M58_noxref_g N_VDD_M57_noxref_d ) capacitor c=0.015318f \
 //x=6.01 //y=6.2 //x2=5.645 //y2=5.2
cc_5382 ( N_CLK_M59_noxref_g N_VDD_M59_noxref_d ) capacitor c=0.015318f \
 //x=6.45 //y=6.2 //x2=6.525 //y2=5.2
cc_5383 ( N_CLK_c_6302_n N_VDD_M62_noxref_s ) capacitor c=8.5753e-19 //x=17.75 \
 //y=4.65 //x2=9.585 //y2=5.2
cc_5384 ( N_CLK_c_6302_n N_VDD_M68_noxref_s ) capacitor c=0.00781443f \
 //x=17.75 //y=4.65 //x2=14.095 //y2=5.2
cc_5385 ( N_CLK_M70_noxref_g N_VDD_M69_noxref_d ) capacitor c=0.015318f \
 //x=15.33 //y=6.2 //x2=14.965 //y2=5.2
cc_5386 ( N_CLK_c_6373_n N_VDD_M69_noxref_d ) capacitor c=3.50465e-19 \
 //x=15.32 //y=4.88 //x2=14.965 //y2=5.2
cc_5387 ( N_CLK_M71_noxref_g N_VDD_M71_noxref_d ) capacitor c=0.0430452f \
 //x=15.77 //y=6.2 //x2=15.845 //y2=5.2
cc_5388 ( N_CLK_c_6302_n N_VDD_M72_noxref_s ) capacitor c=0.0074185f //x=17.75 \
 //y=4.65 //x2=17.425 //y2=5.2
cc_5389 ( N_CLK_c_6429_n N_VDD_M76_noxref_s ) capacitor c=9.13376e-19 \
 //x=20.825 //y=4.62 //x2=21.055 //y2=5.2
cc_5390 ( N_CLK_c_6476_n N_VDD_M82_noxref_s ) capacitor c=0.00787647f \
 //x=26.375 //y=4.62 //x2=25.565 //y2=5.2
cc_5391 ( N_CLK_c_6554_n N_VDD_M86_noxref_s ) capacitor c=8.57911e-19 \
 //x=32.175 //y=4.635 //x2=29.195 //y2=5.2
cc_5392 ( N_CLK_M88_noxref_g N_VDD_M87_noxref_d ) capacitor c=0.015318f \
 //x=30.43 //y=6.2 //x2=30.065 //y2=5.2
cc_5393 ( N_CLK_M89_noxref_g N_VDD_M89_noxref_d ) capacitor c=0.015318f \
 //x=30.87 //y=6.2 //x2=30.945 //y2=5.2
cc_5394 ( N_CLK_c_6557_n N_VDD_M92_noxref_s ) capacitor c=8.5753e-19 //x=42.17 \
 //y=4.65 //x2=34.005 //y2=5.2
cc_5395 ( N_CLK_c_6557_n N_VDD_M98_noxref_s ) capacitor c=0.00781443f \
 //x=42.17 //y=4.65 //x2=38.515 //y2=5.2
cc_5396 ( N_CLK_M100_noxref_g N_VDD_M99_noxref_d ) capacitor c=0.015318f \
 //x=39.75 //y=6.2 //x2=39.385 //y2=5.2
cc_5397 ( N_CLK_c_6627_n N_VDD_M99_noxref_d ) capacitor c=3.50465e-19 \
 //x=39.74 //y=4.88 //x2=39.385 //y2=5.2
cc_5398 ( N_CLK_M101_noxref_g N_VDD_M101_noxref_d ) capacitor c=0.0430452f \
 //x=40.19 //y=6.2 //x2=40.265 //y2=5.2
cc_5399 ( N_CLK_c_6557_n N_VDD_M102_noxref_s ) capacitor c=0.0074185f \
 //x=42.17 //y=4.65 //x2=41.845 //y2=5.2
cc_5400 ( N_CLK_c_6683_n N_VDD_M106_noxref_s ) capacitor c=8.56765e-19 \
 //x=50.795 //y=4.62 //x2=45.475 //y2=5.2
cc_5401 ( N_CLK_c_6683_n N_VDD_M112_noxref_s ) capacitor c=0.00785244f \
 //x=50.795 //y=4.62 //x2=49.985 //y2=5.2
cc_5402 ( N_CLK_c_6830_n N_VDD_M116_noxref_s ) capacitor c=8.57911e-19 \
 //x=56.595 //y=4.635 //x2=53.615 //y2=5.2
cc_5403 ( N_CLK_M118_noxref_g N_VDD_M117_noxref_d ) capacitor c=0.015318f \
 //x=54.85 //y=6.2 //x2=54.485 //y2=5.2
cc_5404 ( N_CLK_M119_noxref_g N_VDD_M119_noxref_d ) capacitor c=0.015318f \
 //x=55.29 //y=6.2 //x2=55.365 //y2=5.2
cc_5405 ( N_CLK_c_6829_n N_VDD_M122_noxref_s ) capacitor c=8.5753e-19 \
 //x=56.94 //y=4.635 //x2=58.425 //y2=5.2
cc_5406 ( N_CLK_c_6829_n N_VDD_M128_noxref_s ) capacitor c=0.00781443f \
 //x=56.94 //y=4.635 //x2=62.935 //y2=5.2
cc_5407 ( N_CLK_M130_noxref_g N_VDD_M129_noxref_d ) capacitor c=0.015318f \
 //x=64.17 //y=6.2 //x2=63.805 //y2=5.2
cc_5408 ( N_CLK_c_6902_n N_VDD_M129_noxref_d ) capacitor c=3.50465e-19 \
 //x=64.16 //y=4.88 //x2=63.805 //y2=5.2
cc_5409 ( N_CLK_M131_noxref_g N_VDD_M131_noxref_d ) capacitor c=0.0430452f \
 //x=64.61 //y=6.2 //x2=64.685 //y2=5.2
cc_5410 ( N_CLK_c_6320_n N_noxref_24_c_12950_n ) capacitor c=0.00123426f \
 //x=6.13 //y=1.09 //x2=6.835 //y2=1.175
cc_5411 ( N_CLK_c_6321_n N_noxref_24_c_12950_n ) capacitor c=0.0129288f \
 //x=6.13 //y=1.4 //x2=6.835 //y2=1.175
cc_5412 ( N_CLK_c_6322_n N_noxref_24_c_12950_n ) capacitor c=0.00132209f \
 //x=6.13 //y=1.63 //x2=6.835 //y2=1.175
cc_5413 ( N_CLK_c_6294_n N_noxref_24_M3_noxref_d ) capacitor c=0.00604066f \
 //x=6.04 //y=2.375 //x2=5.68 //y2=1.09
cc_5414 ( N_CLK_c_6304_n N_noxref_24_M3_noxref_d ) capacitor c=2.2052e-19 \
 //x=6.04 //y=2.26 //x2=5.68 //y2=1.09
cc_5415 ( N_CLK_c_6315_n N_noxref_24_M3_noxref_d ) capacitor c=0.00253592f \
 //x=5.605 //y=1.09 //x2=5.68 //y2=1.09
cc_5416 ( N_CLK_c_6318_n N_noxref_24_M3_noxref_d ) capacitor c=0.00604066f \
 //x=5.605 //y=1.4 //x2=5.68 //y2=1.09
cc_5417 ( N_CLK_c_7157_p N_noxref_24_M3_noxref_d ) capacitor c=0.002686f \
 //x=5.975 //y=0.935 //x2=5.68 //y2=1.09
cc_5418 ( N_CLK_c_7158_p N_noxref_24_M3_noxref_d ) capacitor c=0.00251995f \
 //x=5.975 //y=1.555 //x2=5.68 //y2=1.09
cc_5419 ( N_CLK_c_6320_n N_noxref_24_M3_noxref_d ) capacitor c=0.00314523f \
 //x=6.13 //y=1.09 //x2=5.68 //y2=1.09
cc_5420 ( N_CLK_c_6321_n N_noxref_24_M3_noxref_d ) capacitor c=0.00168289f \
 //x=6.13 //y=1.4 //x2=5.68 //y2=1.09
cc_5421 ( N_CLK_c_6322_n N_noxref_24_M3_noxref_d ) capacitor c=0.00111165f \
 //x=6.13 //y=1.63 //x2=5.68 //y2=1.09
cc_5422 ( N_CLK_c_6320_n N_noxref_24_M4_noxref_s ) capacitor c=7.21316e-19 \
 //x=6.13 //y=1.09 //x2=6.785 //y2=0.555
cc_5423 ( N_CLK_c_6321_n N_noxref_24_M4_noxref_s ) capacitor c=0.00365271f \
 //x=6.13 //y=1.4 //x2=6.785 //y2=0.555
cc_5424 ( N_CLK_c_6323_n N_noxref_24_M4_noxref_s ) capacitor c=9.86711e-19 \
 //x=6.13 //y=2.095 //x2=6.785 //y2=0.555
cc_5425 ( N_CLK_c_6574_n N_noxref_27_c_13177_n ) capacitor c=0.00123426f \
 //x=30.55 //y=1.09 //x2=31.255 //y2=1.175
cc_5426 ( N_CLK_c_6575_n N_noxref_27_c_13177_n ) capacitor c=0.0129288f \
 //x=30.55 //y=1.4 //x2=31.255 //y2=1.175
cc_5427 ( N_CLK_c_6576_n N_noxref_27_c_13177_n ) capacitor c=0.00132209f \
 //x=30.55 //y=1.63 //x2=31.255 //y2=1.175
cc_5428 ( N_CLK_c_6544_n N_noxref_27_M18_noxref_d ) capacitor c=0.00600656f \
 //x=30.46 //y=2.375 //x2=30.1 //y2=1.09
cc_5429 ( N_CLK_c_6558_n N_noxref_27_M18_noxref_d ) capacitor c=2.2052e-19 \
 //x=30.46 //y=2.26 //x2=30.1 //y2=1.09
cc_5430 ( N_CLK_c_6569_n N_noxref_27_M18_noxref_d ) capacitor c=0.00253592f \
 //x=30.025 //y=1.09 //x2=30.1 //y2=1.09
cc_5431 ( N_CLK_c_6572_n N_noxref_27_M18_noxref_d ) capacitor c=0.00604066f \
 //x=30.025 //y=1.4 //x2=30.1 //y2=1.09
cc_5432 ( N_CLK_c_7172_p N_noxref_27_M18_noxref_d ) capacitor c=0.002686f \
 //x=30.395 //y=0.935 //x2=30.1 //y2=1.09
cc_5433 ( N_CLK_c_7173_p N_noxref_27_M18_noxref_d ) capacitor c=0.00251995f \
 //x=30.395 //y=1.555 //x2=30.1 //y2=1.09
cc_5434 ( N_CLK_c_6574_n N_noxref_27_M18_noxref_d ) capacitor c=0.00314523f \
 //x=30.55 //y=1.09 //x2=30.1 //y2=1.09
cc_5435 ( N_CLK_c_6575_n N_noxref_27_M18_noxref_d ) capacitor c=0.00168289f \
 //x=30.55 //y=1.4 //x2=30.1 //y2=1.09
cc_5436 ( N_CLK_c_6576_n N_noxref_27_M18_noxref_d ) capacitor c=0.00111165f \
 //x=30.55 //y=1.63 //x2=30.1 //y2=1.09
cc_5437 ( N_CLK_c_6574_n N_noxref_27_M19_noxref_s ) capacitor c=7.21316e-19 \
 //x=30.55 //y=1.09 //x2=31.205 //y2=0.555
cc_5438 ( N_CLK_c_6575_n N_noxref_27_M19_noxref_s ) capacitor c=0.00365271f \
 //x=30.55 //y=1.4 //x2=31.205 //y2=0.555
cc_5439 ( N_CLK_c_6577_n N_noxref_27_M19_noxref_s ) capacitor c=9.86711e-19 \
 //x=30.55 //y=2.095 //x2=31.205 //y2=0.555
cc_5440 ( N_CLK_c_6849_n N_noxref_30_c_13360_n ) capacitor c=0.00123426f \
 //x=54.97 //y=1.09 //x2=55.675 //y2=1.175
cc_5441 ( N_CLK_c_6850_n N_noxref_30_c_13360_n ) capacitor c=0.0129288f \
 //x=54.97 //y=1.4 //x2=55.675 //y2=1.175
cc_5442 ( N_CLK_c_6851_n N_noxref_30_c_13360_n ) capacitor c=0.00132209f \
 //x=54.97 //y=1.63 //x2=55.675 //y2=1.175
cc_5443 ( N_CLK_c_6819_n N_noxref_30_M33_noxref_d ) capacitor c=0.00600656f \
 //x=54.88 //y=2.375 //x2=54.52 //y2=1.09
cc_5444 ( N_CLK_c_6833_n N_noxref_30_M33_noxref_d ) capacitor c=2.2052e-19 \
 //x=54.88 //y=2.26 //x2=54.52 //y2=1.09
cc_5445 ( N_CLK_c_6844_n N_noxref_30_M33_noxref_d ) capacitor c=0.00253592f \
 //x=54.445 //y=1.09 //x2=54.52 //y2=1.09
cc_5446 ( N_CLK_c_6847_n N_noxref_30_M33_noxref_d ) capacitor c=0.00604066f \
 //x=54.445 //y=1.4 //x2=54.52 //y2=1.09
cc_5447 ( N_CLK_c_7187_p N_noxref_30_M33_noxref_d ) capacitor c=0.002686f \
 //x=54.815 //y=0.935 //x2=54.52 //y2=1.09
cc_5448 ( N_CLK_c_7188_p N_noxref_30_M33_noxref_d ) capacitor c=0.00251995f \
 //x=54.815 //y=1.555 //x2=54.52 //y2=1.09
cc_5449 ( N_CLK_c_6849_n N_noxref_30_M33_noxref_d ) capacitor c=0.00314523f \
 //x=54.97 //y=1.09 //x2=54.52 //y2=1.09
cc_5450 ( N_CLK_c_6850_n N_noxref_30_M33_noxref_d ) capacitor c=0.00168289f \
 //x=54.97 //y=1.4 //x2=54.52 //y2=1.09
cc_5451 ( N_CLK_c_6851_n N_noxref_30_M33_noxref_d ) capacitor c=0.00111165f \
 //x=54.97 //y=1.63 //x2=54.52 //y2=1.09
cc_5452 ( N_CLK_c_6849_n N_noxref_30_M34_noxref_s ) capacitor c=7.21316e-19 \
 //x=54.97 //y=1.09 //x2=55.625 //y2=0.555
cc_5453 ( N_CLK_c_6850_n N_noxref_30_M34_noxref_s ) capacitor c=0.00365271f \
 //x=54.97 //y=1.4 //x2=55.625 //y2=0.555
cc_5454 ( N_CLK_c_6852_n N_noxref_30_M34_noxref_s ) capacitor c=9.86711e-19 \
 //x=54.97 //y=2.095 //x2=55.625 //y2=0.555
cc_5455 ( N_CLK_c_6294_n N_GND_c_13867_n ) capacitor c=8.21177e-19 //x=6.04 \
 //y=2.375 //x2=9.62 //y2=0.175
cc_5456 ( N_CLK_c_6337_n N_GND_c_14058_n ) capacitor c=0.00210951f //x=15.29 \
 //y=2.26 //x2=17.865 //y2=0.175
cc_5457 ( N_CLK_c_6544_n N_GND_c_14198_n ) capacitor c=7.99941e-19 //x=30.46 \
 //y=2.375 //x2=34.04 //y2=0.175
cc_5458 ( N_CLK_c_6591_n N_GND_c_14284_n ) capacitor c=0.00210951f //x=39.71 \
 //y=2.26 //x2=42.285 //y2=0.175
cc_5459 ( N_CLK_c_6819_n N_GND_c_14559_n ) capacitor c=7.99941e-19 //x=54.88 \
 //y=2.375 //x2=58.46 //y2=0.175
cc_5460 ( N_CLK_c_6866_n N_GND_c_14560_n ) capacitor c=0.00210951f //x=64.13 \
 //y=2.26 //x2=66.705 //y2=0.175
cc_5461 ( N_CLK_c_6337_n N_GND_c_13957_n ) capacitor c=3.77328e-19 //x=15.29 \
 //y=2.26 //x2=16.6 //y2=0.175
cc_5462 ( N_CLK_c_6591_n N_GND_c_14175_n ) capacitor c=3.77328e-19 //x=39.71 \
 //y=2.26 //x2=41.02 //y2=0.175
cc_5463 ( N_CLK_c_6866_n N_GND_c_14533_n ) capacitor c=3.77328e-19 //x=64.13 \
 //y=2.26 //x2=65.44 //y2=0.175
cc_5464 ( N_CLK_c_6350_n N_GND_c_13971_n ) capacitor c=0.00207214f //x=15.29 \
 //y=2.26 //x2=16.77 //y2=0.175
cc_5465 ( N_CLK_c_6369_n N_GND_c_13971_n ) capacitor c=0.00275184f //x=15.855 \
 //y=1.43 //x2=16.77 //y2=0.175
cc_5466 ( N_CLK_c_6370_n N_GND_c_13971_n ) capacitor c=2.63786e-19 //x=15.29 \
 //y=2.26 //x2=16.77 //y2=0.175
cc_5467 ( N_CLK_c_6604_n N_GND_c_14189_n ) capacitor c=0.00207214f //x=39.71 \
 //y=2.26 //x2=41.19 //y2=0.175
cc_5468 ( N_CLK_c_6623_n N_GND_c_14189_n ) capacitor c=0.00275184f //x=40.275 \
 //y=1.43 //x2=41.19 //y2=0.175
cc_5469 ( N_CLK_c_6624_n N_GND_c_14189_n ) capacitor c=2.63786e-19 //x=39.71 \
 //y=2.26 //x2=41.19 //y2=0.175
cc_5470 ( N_CLK_c_6879_n N_GND_c_14335_n ) capacitor c=0.00200922f //x=64.13 \
 //y=2.26 //x2=65.61 //y2=0.175
cc_5471 ( N_CLK_c_6898_n N_GND_c_14335_n ) capacitor c=0.00275184f //x=64.695 \
 //y=1.43 //x2=65.61 //y2=0.175
cc_5472 ( N_CLK_c_6899_n N_GND_c_14335_n ) capacitor c=2.63786e-19 //x=64.13 \
 //y=2.26 //x2=65.61 //y2=0.175
cc_5473 ( N_CLK_c_6315_n N_noxref_38_c_15676_n ) capacitor c=0.0167228f \
 //x=5.605 //y=1.09 //x2=6.265 //y2=0.72
cc_5474 ( N_CLK_c_6320_n N_noxref_38_c_15676_n ) capacitor c=0.00534519f \
 //x=6.13 //y=1.09 //x2=6.265 //y2=0.72
cc_5475 ( N_CLK_c_6294_n N_noxref_38_c_15670_n ) capacitor c=0.0048147f \
 //x=6.04 //y=2.375 //x2=6.265 //y2=1.77
cc_5476 ( N_CLK_c_6298_n N_noxref_38_c_15670_n ) capacitor c=9.66785e-19 \
 //x=6.04 //y=4.755 //x2=6.265 //y2=1.77
cc_5477 ( N_CLK_c_6304_n N_noxref_38_c_15670_n ) capacitor c=0.0105652f \
 //x=6.04 //y=2.26 //x2=6.265 //y2=1.77
cc_5478 ( N_CLK_c_6318_n N_noxref_38_c_15670_n ) capacitor c=0.0153476f \
 //x=5.605 //y=1.4 //x2=6.265 //y2=1.77
cc_5479 ( N_CLK_c_6323_n N_noxref_38_c_15670_n ) capacitor c=0.0200931f \
 //x=6.13 //y=2.095 //x2=6.265 //y2=1.77
cc_5480 ( N_CLK_c_6315_n N_noxref_38_M2_noxref_s ) capacitor c=0.00798959f \
 //x=5.605 //y=1.09 //x2=4.275 //y2=0.555
cc_5481 ( N_CLK_c_6322_n N_noxref_38_M2_noxref_s ) capacitor c=0.00212176f \
 //x=6.13 //y=1.63 //x2=4.275 //y2=0.555
cc_5482 ( N_CLK_c_6323_n N_noxref_38_M2_noxref_s ) capacitor c=0.00298115f \
 //x=6.13 //y=2.095 //x2=4.275 //y2=0.555
cc_5483 ( N_CLK_c_6337_n N_noxref_40_c_15785_n ) capacitor c=7.50092e-19 \
 //x=15.29 //y=2.26 //x2=15.105 //y2=1.675
cc_5484 ( N_CLK_c_6365_n N_noxref_40_c_15785_n ) capacitor c=0.00888238f \
 //x=15.325 //y=1.74 //x2=15.105 //y2=1.675
cc_5485 ( N_CLK_c_6370_n N_noxref_40_c_15785_n ) capacitor c=0.00175171f \
 //x=15.29 //y=2.26 //x2=15.105 //y2=1.675
cc_5486 ( N_CLK_c_6337_n N_noxref_40_c_15790_n ) capacitor c=0.001463f \
 //x=15.29 //y=2.26 //x2=15.99 //y2=0.71
cc_5487 ( N_CLK_c_6350_n N_noxref_40_c_15790_n ) capacitor c=8.82141e-19 \
 //x=15.29 //y=2.26 //x2=15.99 //y2=0.71
cc_5488 ( N_CLK_c_6360_n N_noxref_40_c_15790_n ) capacitor c=0.0200738f \
 //x=15.325 //y=1.085 //x2=15.99 //y2=0.71
cc_5489 ( N_CLK_c_6368_n N_noxref_40_c_15790_n ) capacitor c=0.00825432f \
 //x=15.855 //y=1.085 //x2=15.99 //y2=0.71
cc_5490 ( N_CLK_c_6370_n N_noxref_40_c_15790_n ) capacitor c=2.1838e-19 \
 //x=15.29 //y=2.26 //x2=15.99 //y2=0.71
cc_5491 ( N_CLK_c_6360_n N_noxref_40_M8_noxref_s ) capacitor c=0.00888238f \
 //x=15.325 //y=1.085 //x2=14 //y2=0.545
cc_5492 ( N_CLK_c_6368_n N_noxref_40_M8_noxref_s ) capacitor c=0.015333f \
 //x=15.855 //y=1.085 //x2=14 //y2=0.545
cc_5493 ( N_CLK_c_6369_n N_noxref_40_M8_noxref_s ) capacitor c=0.00248746f \
 //x=15.855 //y=1.43 //x2=14 //y2=0.545
cc_5494 ( N_CLK_c_6569_n N_noxref_44_c_16050_n ) capacitor c=0.0167228f \
 //x=30.025 //y=1.09 //x2=30.685 //y2=0.72
cc_5495 ( N_CLK_c_6574_n N_noxref_44_c_16050_n ) capacitor c=0.00534519f \
 //x=30.55 //y=1.09 //x2=30.685 //y2=0.72
cc_5496 ( N_CLK_c_6544_n N_noxref_44_c_16052_n ) capacitor c=0.0048147f \
 //x=30.46 //y=2.375 //x2=30.685 //y2=1.77
cc_5497 ( N_CLK_c_6547_n N_noxref_44_c_16052_n ) capacitor c=9.66785e-19 \
 //x=30.46 //y=4.755 //x2=30.685 //y2=1.77
cc_5498 ( N_CLK_c_6558_n N_noxref_44_c_16052_n ) capacitor c=0.0105652f \
 //x=30.46 //y=2.26 //x2=30.685 //y2=1.77
cc_5499 ( N_CLK_c_6572_n N_noxref_44_c_16052_n ) capacitor c=0.0153476f \
 //x=30.025 //y=1.4 //x2=30.685 //y2=1.77
cc_5500 ( N_CLK_c_6577_n N_noxref_44_c_16052_n ) capacitor c=0.019963f \
 //x=30.55 //y=2.095 //x2=30.685 //y2=1.77
cc_5501 ( N_CLK_c_6569_n N_noxref_44_M17_noxref_s ) capacitor c=0.00798959f \
 //x=30.025 //y=1.09 //x2=28.695 //y2=0.555
cc_5502 ( N_CLK_c_6576_n N_noxref_44_M17_noxref_s ) capacitor c=0.00212176f \
 //x=30.55 //y=1.63 //x2=28.695 //y2=0.555
cc_5503 ( N_CLK_c_6577_n N_noxref_44_M17_noxref_s ) capacitor c=0.00298115f \
 //x=30.55 //y=2.095 //x2=28.695 //y2=0.555
cc_5504 ( N_CLK_c_6591_n N_noxref_46_c_16166_n ) capacitor c=7.50092e-19 \
 //x=39.71 //y=2.26 //x2=39.525 //y2=1.675
cc_5505 ( N_CLK_c_6619_n N_noxref_46_c_16166_n ) capacitor c=0.00888238f \
 //x=39.745 //y=1.74 //x2=39.525 //y2=1.675
cc_5506 ( N_CLK_c_6624_n N_noxref_46_c_16166_n ) capacitor c=0.00175171f \
 //x=39.71 //y=2.26 //x2=39.525 //y2=1.675
cc_5507 ( N_CLK_c_6591_n N_noxref_46_c_16171_n ) capacitor c=0.001463f \
 //x=39.71 //y=2.26 //x2=40.41 //y2=0.71
cc_5508 ( N_CLK_c_6604_n N_noxref_46_c_16171_n ) capacitor c=8.82141e-19 \
 //x=39.71 //y=2.26 //x2=40.41 //y2=0.71
cc_5509 ( N_CLK_c_6614_n N_noxref_46_c_16171_n ) capacitor c=0.0200738f \
 //x=39.745 //y=1.085 //x2=40.41 //y2=0.71
cc_5510 ( N_CLK_c_6622_n N_noxref_46_c_16171_n ) capacitor c=0.00825432f \
 //x=40.275 //y=1.085 //x2=40.41 //y2=0.71
cc_5511 ( N_CLK_c_6624_n N_noxref_46_c_16171_n ) capacitor c=2.1838e-19 \
 //x=39.71 //y=2.26 //x2=40.41 //y2=0.71
cc_5512 ( N_CLK_c_6614_n N_noxref_46_M23_noxref_s ) capacitor c=0.00888238f \
 //x=39.745 //y=1.085 //x2=38.42 //y2=0.545
cc_5513 ( N_CLK_c_6622_n N_noxref_46_M23_noxref_s ) capacitor c=0.015333f \
 //x=40.275 //y=1.085 //x2=38.42 //y2=0.545
cc_5514 ( N_CLK_c_6623_n N_noxref_46_M23_noxref_s ) capacitor c=0.00248746f \
 //x=40.275 //y=1.43 //x2=38.42 //y2=0.545
cc_5515 ( N_CLK_c_6844_n N_noxref_50_c_16430_n ) capacitor c=0.0167228f \
 //x=54.445 //y=1.09 //x2=55.105 //y2=0.72
cc_5516 ( N_CLK_c_6849_n N_noxref_50_c_16430_n ) capacitor c=0.00534519f \
 //x=54.97 //y=1.09 //x2=55.105 //y2=0.72
cc_5517 ( N_CLK_c_6819_n N_noxref_50_c_16432_n ) capacitor c=0.0048147f \
 //x=54.88 //y=2.375 //x2=55.105 //y2=1.77
cc_5518 ( N_CLK_c_6822_n N_noxref_50_c_16432_n ) capacitor c=9.66785e-19 \
 //x=54.88 //y=4.755 //x2=55.105 //y2=1.77
cc_5519 ( N_CLK_c_6833_n N_noxref_50_c_16432_n ) capacitor c=0.0105652f \
 //x=54.88 //y=2.26 //x2=55.105 //y2=1.77
cc_5520 ( N_CLK_c_6847_n N_noxref_50_c_16432_n ) capacitor c=0.0153476f \
 //x=54.445 //y=1.4 //x2=55.105 //y2=1.77
cc_5521 ( N_CLK_c_6852_n N_noxref_50_c_16432_n ) capacitor c=0.019963f \
 //x=54.97 //y=2.095 //x2=55.105 //y2=1.77
cc_5522 ( N_CLK_c_6844_n N_noxref_50_M32_noxref_s ) capacitor c=0.00798959f \
 //x=54.445 //y=1.09 //x2=53.115 //y2=0.555
cc_5523 ( N_CLK_c_6851_n N_noxref_50_M32_noxref_s ) capacitor c=0.00212176f \
 //x=54.97 //y=1.63 //x2=53.115 //y2=0.555
cc_5524 ( N_CLK_c_6852_n N_noxref_50_M32_noxref_s ) capacitor c=0.00298115f \
 //x=54.97 //y=2.095 //x2=53.115 //y2=0.555
cc_5525 ( N_CLK_c_6866_n N_noxref_52_c_16546_n ) capacitor c=7.50092e-19 \
 //x=64.13 //y=2.26 //x2=63.945 //y2=1.675
cc_5526 ( N_CLK_c_6894_n N_noxref_52_c_16546_n ) capacitor c=0.00888238f \
 //x=64.165 //y=1.74 //x2=63.945 //y2=1.675
cc_5527 ( N_CLK_c_6899_n N_noxref_52_c_16546_n ) capacitor c=0.00175171f \
 //x=64.13 //y=2.26 //x2=63.945 //y2=1.675
cc_5528 ( N_CLK_c_6866_n N_noxref_52_c_16553_n ) capacitor c=0.001463f \
 //x=64.13 //y=2.26 //x2=64.83 //y2=0.71
cc_5529 ( N_CLK_c_6879_n N_noxref_52_c_16553_n ) capacitor c=8.82141e-19 \
 //x=64.13 //y=2.26 //x2=64.83 //y2=0.71
cc_5530 ( N_CLK_c_6889_n N_noxref_52_c_16553_n ) capacitor c=0.0200738f \
 //x=64.165 //y=1.085 //x2=64.83 //y2=0.71
cc_5531 ( N_CLK_c_6897_n N_noxref_52_c_16553_n ) capacitor c=0.00825432f \
 //x=64.695 //y=1.085 //x2=64.83 //y2=0.71
cc_5532 ( N_CLK_c_6899_n N_noxref_52_c_16553_n ) capacitor c=2.1838e-19 \
 //x=64.13 //y=2.26 //x2=64.83 //y2=0.71
cc_5533 ( N_CLK_c_6889_n N_noxref_52_M38_noxref_s ) capacitor c=0.00888238f \
 //x=64.165 //y=1.085 //x2=62.84 //y2=0.545
cc_5534 ( N_CLK_c_6897_n N_noxref_52_M38_noxref_s ) capacitor c=0.015333f \
 //x=64.695 //y=1.085 //x2=62.84 //y2=0.545
cc_5535 ( N_CLK_c_6898_n N_noxref_52_M38_noxref_s ) capacitor c=0.00248746f \
 //x=64.695 //y=1.43 //x2=62.84 //y2=0.545
cc_5536 ( N_noxref_16_M133_noxref_g N_noxref_17_c_7775_n ) capacitor \
 c=0.0103227f //x=67.06 //y=6.2 //x2=67.605 //y2=5.38
cc_5537 ( N_noxref_16_c_7284_n N_noxref_17_c_7773_n ) capacitor c=0.00357506f \
 //x=66.72 //y=4.105 //x2=68.2 //y2=4.87
cc_5538 ( N_noxref_16_c_7440_n N_noxref_17_c_7773_n ) capacitor c=0.00107873f \
 //x=66.722 //y=4.74 //x2=68.2 //y2=4.87
cc_5539 ( N_noxref_16_c_7458_p N_noxref_17_c_7778_n ) capacitor c=0.00121594f \
 //x=66.72 //y=4.425 //x2=66.84 //y2=5.56
cc_5540 ( N_noxref_16_c_7459_p N_noxref_17_c_7778_n ) capacitor c=0.0117962f \
 //x=66.72 //y=4.88 //x2=66.84 //y2=5.56
cc_5541 ( N_noxref_16_c_7460_p N_noxref_17_c_7778_n ) capacitor c=6.61088e-19 \
 //x=66.72 //y=4.265 //x2=66.84 //y2=5.56
cc_5542 ( N_noxref_16_c_7461_p N_noxref_17_c_7778_n ) capacitor c=0.00277154f \
 //x=66.72 //y=4.88 //x2=66.84 //y2=5.56
cc_5543 ( N_noxref_16_M132_noxref_g N_noxref_17_c_7778_n ) capacitor \
 c=0.00201806f //x=66.62 //y=6.2 //x2=66.84 //y2=5.56
cc_5544 ( N_noxref_16_M133_noxref_g N_noxref_17_c_7778_n ) capacitor \
 c=0.00192712f //x=67.06 //y=6.2 //x2=66.84 //y2=5.56
cc_5545 ( N_noxref_16_c_7464_p N_noxref_17_c_7778_n ) capacitor c=0.00201193f \
 //x=66.72 //y=4.88 //x2=66.84 //y2=5.56
cc_5546 ( N_noxref_16_c_7458_p N_noxref_17_c_7785_n ) capacitor c=4.87998e-19 \
 //x=66.72 //y=4.425 //x2=66.84 //y2=5.56
cc_5547 ( N_noxref_16_c_7459_p N_noxref_17_c_7785_n ) capacitor c=0.00104426f \
 //x=66.72 //y=4.88 //x2=66.84 //y2=5.56
cc_5548 ( N_noxref_16_c_7461_p N_noxref_17_c_7785_n ) capacitor c=0.00377369f \
 //x=66.72 //y=4.88 //x2=66.84 //y2=5.56
cc_5549 ( N_noxref_16_M132_noxref_g N_noxref_17_c_7785_n ) capacitor \
 c=0.0158358f //x=66.62 //y=6.2 //x2=66.84 //y2=5.56
cc_5550 ( N_noxref_16_M133_noxref_g N_noxref_17_c_7785_n ) capacitor \
 c=0.0178987f //x=67.06 //y=6.2 //x2=66.84 //y2=5.56
cc_5551 ( N_noxref_16_c_7464_p N_noxref_17_c_7785_n ) capacitor c=0.00319448f \
 //x=66.72 //y=4.88 //x2=66.84 //y2=5.56
cc_5552 ( N_noxref_16_c_7283_n SN ) capacitor c=0.0012708f //x=56.73 //y=4.09 \
 //x2=59.69 //y2=2.77
cc_5553 ( N_noxref_16_c_7358_n SN ) capacitor c=3.83887e-19 //x=56.73 //y=5.25 \
 //x2=59.69 //y2=2.77
cc_5554 ( N_noxref_16_c_7370_n SN ) capacitor c=0.023508f //x=66.56 //y=4.265 \
 //x2=59.69 //y2=2.77
cc_5555 ( N_noxref_16_c_7276_n N_SN_c_8385_n ) capacitor c=0.0111423f \
 //x=51.18 //y=4.085 //x2=51.705 //y2=2.385
cc_5556 ( N_noxref_16_c_7302_n N_SN_c_8385_n ) capacitor c=0.017633f //x=51.18 \
 //y=2.26 //x2=51.705 //y2=2.385
cc_5557 ( N_noxref_16_c_7327_n N_SN_c_8385_n ) capacitor c=2.98635e-19 \
 //x=51.18 //y=2.26 //x2=51.705 //y2=2.385
cc_5558 ( N_noxref_16_c_7477_p N_SN_c_8516_n ) capacitor c=7.13469e-19 \
 //x=56.245 //y=1.305 //x2=58.195 //y2=2.4
cc_5559 ( N_noxref_16_c_7350_n N_SN_c_8516_n ) capacitor c=0.0214668f \
 //x=56.33 //y=1.845 //x2=58.195 //y2=2.4
cc_5560 ( N_noxref_16_c_7283_n N_SN_c_8516_n ) capacitor c=0.0279371f \
 //x=56.73 //y=4.09 //x2=58.195 //y2=2.4
cc_5561 ( N_noxref_16_c_7284_n N_SN_c_8521_n ) capacitor c=0.0153133f \
 //x=66.72 //y=4.105 //x2=70.99 //y2=2.39
cc_5562 ( N_noxref_16_c_7481_p N_SN_c_8521_n ) capacitor c=0.0183918f \
 //x=66.72 //y=2.26 //x2=70.99 //y2=2.39
cc_5563 ( N_noxref_16_c_7482_p N_SN_c_8521_n ) capacitor c=2.20453e-19 \
 //x=66.72 //y=2.26 //x2=70.99 //y2=2.39
cc_5564 ( N_noxref_16_c_7483_p N_SN_c_8521_n ) capacitor c=3.61358e-19 \
 //x=66.525 //y=2.095 //x2=70.99 //y2=2.39
cc_5565 ( N_noxref_16_c_7283_n N_noxref_19_c_9362_n ) capacitor c=0.0140008f \
 //x=56.73 //y=4.09 //x2=55.99 //y2=2.375
cc_5566 ( N_noxref_16_c_7283_n N_noxref_19_c_9261_n ) capacitor c=0.0510418f \
 //x=56.73 //y=4.09 //x2=55.99 //y2=3.705
cc_5567 ( N_noxref_16_c_7410_n N_noxref_19_c_9367_n ) capacitor c=0.00116878f \
 //x=56.645 //y=5.335 //x2=55.99 //y2=4.025
cc_5568 ( N_noxref_16_c_7477_p N_noxref_19_c_9367_n ) capacitor c=2.00238e-19 \
 //x=56.245 //y=1.305 //x2=55.99 //y2=4.025
cc_5569 ( N_noxref_16_c_7350_n N_noxref_19_c_9367_n ) capacitor c=8.07658e-19 \
 //x=56.33 //y=1.845 //x2=55.99 //y2=4.025
cc_5570 ( N_noxref_16_c_7283_n N_noxref_19_c_9367_n ) capacitor c=0.0176025f \
 //x=56.73 //y=4.09 //x2=55.99 //y2=4.025
cc_5571 ( N_noxref_16_c_7490_p N_noxref_19_c_9367_n ) capacitor c=7.66594e-19 \
 //x=55.95 //y=5.335 //x2=55.99 //y2=4.025
cc_5572 ( N_noxref_16_c_7286_n N_noxref_19_c_9367_n ) capacitor c=0.00522697f \
 //x=56.565 //y=4.25 //x2=55.99 //y2=4.025
cc_5573 ( N_noxref_16_c_7410_n N_noxref_19_c_9279_n ) capacitor c=0.00228791f \
 //x=56.645 //y=5.335 //x2=55.99 //y2=4.75
cc_5574 ( N_noxref_16_c_7283_n N_noxref_19_c_9279_n ) capacitor c=0.00283381f \
 //x=56.73 //y=4.09 //x2=55.99 //y2=4.75
cc_5575 ( N_noxref_16_c_7357_n N_noxref_19_c_9279_n ) capacitor c=0.0147947f \
 //x=56.73 //y=4.41 //x2=55.99 //y2=4.75
cc_5576 ( N_noxref_16_c_7358_n N_noxref_19_c_9279_n ) capacitor c=0.0275491f \
 //x=56.73 //y=5.25 //x2=55.99 //y2=4.75
cc_5577 ( N_noxref_16_c_7490_p N_noxref_19_c_9279_n ) capacitor c=0.0221235f \
 //x=55.95 //y=5.335 //x2=55.99 //y2=4.75
cc_5578 ( N_noxref_16_c_7497_p N_noxref_19_c_9279_n ) capacitor c=6.4807e-19 \
 //x=56.725 //y=4.25 //x2=55.99 //y2=4.75
cc_5579 ( N_noxref_16_c_7286_n N_noxref_19_c_9279_n ) capacitor c=0.0210332f \
 //x=56.565 //y=4.25 //x2=55.99 //y2=4.75
cc_5580 ( N_noxref_16_c_7368_n N_noxref_19_c_9279_n ) capacitor c=0.00328982f \
 //x=56.885 //y=4.25 //x2=55.99 //y2=4.75
cc_5581 ( N_noxref_16_c_7500_p N_noxref_19_c_9279_n ) capacitor c=0.00217653f \
 //x=55.95 //y=5.56 //x2=55.99 //y2=4.75
cc_5582 ( N_noxref_16_c_7370_n N_noxref_19_c_9293_n ) capacitor c=0.00531452f \
 //x=66.56 //y=4.265 //x2=60.8 //y2=4.025
cc_5583 ( N_noxref_16_c_7370_n N_noxref_19_c_9283_n ) capacitor c=0.0214777f \
 //x=66.56 //y=4.265 //x2=60.8 //y2=4.75
cc_5584 ( N_noxref_16_c_7284_n N_noxref_19_c_9263_n ) capacitor c=0.0171827f \
 //x=66.72 //y=4.105 //x2=64.87 //y2=3.705
cc_5585 ( N_noxref_16_c_7481_p N_noxref_19_c_9263_n ) capacitor c=0.00344372f \
 //x=66.72 //y=2.26 //x2=64.87 //y2=3.705
cc_5586 ( N_noxref_16_c_7284_n N_noxref_19_c_9391_n ) capacitor c=0.00238733f \
 //x=66.72 //y=4.105 //x2=64.87 //y2=4.025
cc_5587 ( N_noxref_16_c_7370_n N_noxref_19_c_9391_n ) capacitor c=0.00689641f \
 //x=66.56 //y=4.265 //x2=64.87 //y2=4.025
cc_5588 ( N_noxref_16_c_7284_n N_noxref_19_c_9307_n ) capacitor c=0.00129137f \
 //x=66.72 //y=4.105 //x2=64.87 //y2=5.295
cc_5589 ( N_noxref_16_c_7458_p N_noxref_19_c_9307_n ) capacitor c=0.00249513f \
 //x=66.72 //y=4.425 //x2=64.87 //y2=5.295
cc_5590 ( N_noxref_16_c_7459_p N_noxref_19_c_9307_n ) capacitor c=0.00439788f \
 //x=66.72 //y=4.88 //x2=64.87 //y2=5.295
cc_5591 ( N_noxref_16_c_7440_n N_noxref_19_c_9307_n ) capacitor c=0.00486648f \
 //x=66.722 //y=4.74 //x2=64.87 //y2=5.295
cc_5592 ( N_noxref_16_c_7460_p N_noxref_19_c_9307_n ) capacitor c=0.0015808f \
 //x=66.72 //y=4.265 //x2=64.87 //y2=5.295
cc_5593 ( N_noxref_16_c_7370_n N_noxref_19_c_9307_n ) capacitor c=0.028335f \
 //x=66.56 //y=4.265 //x2=64.87 //y2=5.295
cc_5594 ( N_noxref_16_c_7283_n N_noxref_19_c_9398_n ) capacitor c=9.19401e-19 \
 //x=56.73 //y=4.09 //x2=55.99 //y2=3.88
cc_5595 ( N_noxref_16_c_7370_n N_noxref_19_c_9400_n ) capacitor c=0.0132406f \
 //x=66.56 //y=4.265 //x2=64.39 //y2=5.38
cc_5596 ( N_noxref_16_c_7283_n N_noxref_19_c_9266_n ) capacitor c=2.73038e-19 \
 //x=56.73 //y=4.09 //x2=56.34 //y2=3.88
cc_5597 ( N_noxref_16_c_7286_n N_noxref_19_c_9266_n ) capacitor c=0.0338167f \
 //x=56.565 //y=4.25 //x2=56.34 //y2=3.88
cc_5598 ( N_noxref_16_c_7283_n N_noxref_19_c_9413_n ) capacitor c=0.0210245f \
 //x=56.73 //y=4.09 //x2=56.94 //y2=3.865
cc_5599 ( N_noxref_16_c_7357_n N_noxref_19_c_9413_n ) capacitor c=0.00912961f \
 //x=56.73 //y=4.41 //x2=56.94 //y2=3.865
cc_5600 ( N_noxref_16_c_7368_n N_noxref_19_c_9413_n ) capacitor c=0.0358834f \
 //x=56.885 //y=4.25 //x2=56.94 //y2=3.865
cc_5601 ( N_noxref_16_c_7370_n N_noxref_19_c_9413_n ) capacitor c=0.0109116f \
 //x=66.56 //y=4.265 //x2=56.94 //y2=3.865
cc_5602 ( N_noxref_16_c_7283_n N_noxref_19_c_9267_n ) capacitor c=4.72093e-19 \
 //x=56.73 //y=4.09 //x2=60.96 //y2=3.88
cc_5603 ( N_noxref_16_c_7370_n N_noxref_19_c_9267_n ) capacitor c=0.349297f \
 //x=66.56 //y=4.265 //x2=60.96 //y2=3.88
cc_5604 ( N_noxref_16_c_7283_n N_noxref_19_c_9415_n ) capacitor c=0.00317812f \
 //x=56.73 //y=4.09 //x2=56.155 //y2=3.865
cc_5605 ( N_noxref_16_c_7286_n N_noxref_19_c_9415_n ) capacitor c=0.0358686f \
 //x=56.565 //y=4.25 //x2=56.155 //y2=3.865
cc_5606 ( N_noxref_16_c_7370_n N_noxref_19_c_9269_n ) capacitor c=0.323315f \
 //x=66.56 //y=4.265 //x2=64.705 //y2=3.865
cc_5607 ( N_noxref_16_c_7284_n N_noxref_19_c_9418_n ) capacitor c=0.00159442f \
 //x=66.72 //y=4.105 //x2=65.025 //y2=3.865
cc_5608 ( N_noxref_16_c_7370_n N_noxref_19_c_9418_n ) capacitor c=0.0365231f \
 //x=66.56 //y=4.265 //x2=65.025 //y2=3.865
cc_5609 ( N_noxref_16_c_7284_n N_noxref_19_c_9273_n ) capacitor c=0.0226556f \
 //x=66.72 //y=4.105 //x2=72.11 //y2=3.885
cc_5610 ( N_noxref_16_c_7458_p N_noxref_19_c_9273_n ) capacitor c=0.00766477f \
 //x=66.72 //y=4.425 //x2=72.11 //y2=3.885
cc_5611 ( N_noxref_16_c_7460_p N_noxref_19_c_9273_n ) capacitor c=0.0368432f \
 //x=66.72 //y=4.265 //x2=72.11 //y2=3.885
cc_5612 ( N_noxref_16_c_7370_n N_noxref_19_c_9273_n ) capacitor c=0.141636f \
 //x=66.56 //y=4.265 //x2=72.11 //y2=3.885
cc_5613 ( N_noxref_16_c_7283_n N_noxref_19_c_9419_n ) capacitor c=0.0015536f \
 //x=56.73 //y=4.09 //x2=55.99 //y2=2.26
cc_5614 ( N_noxref_16_c_7410_n N_noxref_19_c_9423_n ) capacitor c=0.00130631f \
 //x=56.645 //y=5.335 //x2=55.99 //y2=4.88
cc_5615 ( N_noxref_16_c_7358_n N_noxref_19_c_9423_n ) capacitor c=0.0013045f \
 //x=56.73 //y=5.25 //x2=55.99 //y2=4.88
cc_5616 ( N_noxref_16_c_7490_p N_noxref_19_c_9423_n ) capacitor c=0.00346456f \
 //x=55.95 //y=5.335 //x2=55.99 //y2=4.88
cc_5617 ( N_noxref_16_c_7500_p N_noxref_19_c_9423_n ) capacitor c=0.00624059f \
 //x=55.95 //y=5.56 //x2=55.99 //y2=4.88
cc_5618 ( N_noxref_16_c_7424_n N_noxref_19_M120_noxref_g ) capacitor \
 c=0.00955829f //x=55.835 //y=5.335 //x2=55.73 //y2=6.2
cc_5619 ( N_noxref_16_c_7409_n N_noxref_19_M120_noxref_g ) capacitor \
 c=0.00226521f //x=55.95 //y=5.56 //x2=55.73 //y2=6.2
cc_5620 ( N_noxref_16_c_7500_p N_noxref_19_M120_noxref_g ) capacitor \
 c=0.0178885f //x=55.95 //y=5.56 //x2=55.73 //y2=6.2
cc_5621 ( N_noxref_16_c_7409_n N_noxref_19_M121_noxref_g ) capacitor \
 c=0.00381703f //x=55.95 //y=5.56 //x2=56.17 //y2=6.2
cc_5622 ( N_noxref_16_c_7410_n N_noxref_19_M121_noxref_g ) capacitor \
 c=0.0109667f //x=56.645 //y=5.335 //x2=56.17 //y2=6.2
cc_5623 ( N_noxref_16_c_7500_p N_noxref_19_M121_noxref_g ) capacitor \
 c=0.0188608f //x=55.95 //y=5.56 //x2=56.17 //y2=6.2
cc_5624 ( N_noxref_16_c_7477_p N_noxref_19_c_9433_n ) capacitor c=4.64015e-19 \
 //x=56.245 //y=1.305 //x2=55.98 //y2=1.095
cc_5625 ( N_noxref_16_M34_noxref_d N_noxref_19_c_9433_n ) capacitor \
 c=0.00137165f //x=56.055 //y=1.095 //x2=55.98 //y2=1.095
cc_5626 ( N_noxref_16_c_7477_p N_noxref_19_c_9434_n ) capacitor c=0.0026012f \
 //x=56.245 //y=1.305 //x2=55.98 //y2=1.44
cc_5627 ( N_noxref_16_c_7349_n N_noxref_19_c_9434_n ) capacitor c=0.00127432f \
 //x=56.245 //y=1.76 //x2=55.98 //y2=1.44
cc_5628 ( N_noxref_16_M34_noxref_d N_noxref_19_c_9434_n ) capacitor \
 c=0.00237422f //x=56.055 //y=1.095 //x2=55.98 //y2=1.44
cc_5629 ( N_noxref_16_c_7349_n N_noxref_19_c_9435_n ) capacitor c=0.00429966f \
 //x=56.245 //y=1.76 //x2=55.98 //y2=1.75
cc_5630 ( N_noxref_16_c_7477_p N_noxref_19_c_9515_n ) capacitor c=5.29969e-19 \
 //x=56.245 //y=1.305 //x2=56.355 //y2=0.94
cc_5631 ( N_noxref_16_M34_noxref_d N_noxref_19_c_9515_n ) capacitor \
 c=0.0020782f //x=56.055 //y=1.095 //x2=56.355 //y2=0.94
cc_5632 ( N_noxref_16_c_7477_p N_noxref_19_c_9517_n ) capacitor c=5.16926e-19 \
 //x=56.245 //y=1.305 //x2=56.355 //y2=1.595
cc_5633 ( N_noxref_16_c_7349_n N_noxref_19_c_9517_n ) capacitor c=0.00942306f \
 //x=56.245 //y=1.76 //x2=56.355 //y2=1.595
cc_5634 ( N_noxref_16_c_7411_n N_noxref_19_c_9517_n ) capacitor c=0.00194716f \
 //x=56.645 //y=1.845 //x2=56.355 //y2=1.595
cc_5635 ( N_noxref_16_M34_noxref_d N_noxref_19_c_9517_n ) capacitor \
 c=0.00356097f //x=56.055 //y=1.095 //x2=56.355 //y2=1.595
cc_5636 ( N_noxref_16_c_7477_p N_noxref_19_c_9521_n ) capacitor c=5.24634e-19 \
 //x=56.245 //y=1.305 //x2=56.51 //y2=1.095
cc_5637 ( N_noxref_16_M34_noxref_d N_noxref_19_c_9521_n ) capacitor \
 c=0.00139206f //x=56.055 //y=1.095 //x2=56.51 //y2=1.095
cc_5638 ( N_noxref_16_c_7477_p N_noxref_19_c_9523_n ) capacitor c=0.00307978f \
 //x=56.245 //y=1.305 //x2=56.51 //y2=1.44
cc_5639 ( N_noxref_16_c_7349_n N_noxref_19_c_9523_n ) capacitor c=0.00363411f \
 //x=56.245 //y=1.76 //x2=56.51 //y2=1.44
cc_5640 ( N_noxref_16_c_7411_n N_noxref_19_c_9523_n ) capacitor c=0.00323576f \
 //x=56.645 //y=1.845 //x2=56.51 //y2=1.44
cc_5641 ( N_noxref_16_M34_noxref_d N_noxref_19_c_9523_n ) capacitor \
 c=0.00237422f //x=56.055 //y=1.095 //x2=56.51 //y2=1.44
cc_5642 ( N_noxref_16_c_7283_n N_noxref_19_c_9436_n ) capacitor c=0.0024584f \
 //x=56.73 //y=4.09 //x2=55.99 //y2=2.26
cc_5643 ( N_noxref_16_c_7349_n N_noxref_19_c_9439_n ) capacitor c=0.00362297f \
 //x=56.245 //y=1.76 //x2=55.99 //y2=2.095
cc_5644 ( N_noxref_16_c_7283_n N_noxref_19_c_9439_n ) capacitor c=0.00282067f \
 //x=56.73 //y=4.09 //x2=55.99 //y2=2.095
cc_5645 ( N_noxref_16_c_7358_n N_noxref_19_c_9440_n ) capacitor c=0.00739287f \
 //x=56.73 //y=5.25 //x2=55.99 //y2=4.88
cc_5646 ( N_noxref_16_c_7490_p N_noxref_19_c_9440_n ) capacitor c=0.00203307f \
 //x=55.95 //y=5.335 //x2=55.99 //y2=4.88
cc_5647 ( N_noxref_16_c_7500_p N_noxref_19_c_9440_n ) capacitor c=0.00375636f \
 //x=55.95 //y=5.56 //x2=55.99 //y2=4.88
cc_5648 ( N_noxref_16_c_7284_n N_noxref_20_c_9843_n ) capacitor c=0.0682696f \
 //x=66.72 //y=4.105 //x2=67.46 //y2=4.48
cc_5649 ( N_noxref_16_c_7458_p N_noxref_20_c_9843_n ) capacitor c=0.0151156f \
 //x=66.72 //y=4.425 //x2=67.46 //y2=4.48
cc_5650 ( N_noxref_16_c_7569_p N_noxref_20_c_9843_n ) capacitor c=9.19401e-19 \
 //x=66.72 //y=4.25 //x2=67.46 //y2=4.48
cc_5651 ( N_noxref_16_c_7440_n N_noxref_20_c_9843_n ) capacitor c=0.00227275f \
 //x=66.722 //y=4.74 //x2=67.46 //y2=4.48
cc_5652 ( N_noxref_16_c_7460_p N_noxref_20_c_9843_n ) capacitor c=0.00686827f \
 //x=66.72 //y=4.265 //x2=67.46 //y2=4.48
cc_5653 ( N_noxref_16_c_7482_p N_noxref_20_c_9843_n ) capacitor c=3.30333e-19 \
 //x=66.72 //y=2.26 //x2=67.46 //y2=4.48
cc_5654 ( N_noxref_16_c_7481_p N_noxref_20_c_9922_n ) capacitor c=0.0179797f \
 //x=66.72 //y=2.26 //x2=67.46 //y2=2.26
cc_5655 ( N_noxref_16_c_7482_p N_noxref_20_c_9922_n ) capacitor c=5.16867e-19 \
 //x=66.72 //y=2.26 //x2=67.46 //y2=2.26
cc_5656 ( N_noxref_16_c_7483_p N_noxref_20_c_9922_n ) capacitor c=0.00161745f \
 //x=66.525 //y=2.095 //x2=67.46 //y2=2.26
cc_5657 ( N_noxref_16_c_7459_p N_noxref_20_c_9925_n ) capacitor c=0.0168942f \
 //x=66.72 //y=4.88 //x2=67.48 //y2=4.64
cc_5658 ( N_noxref_16_c_7440_n N_noxref_20_c_9925_n ) capacitor c=0.0112479f \
 //x=66.722 //y=4.74 //x2=67.48 //y2=4.64
cc_5659 ( N_noxref_16_c_7461_p N_noxref_20_c_9925_n ) capacitor c=0.00124701f \
 //x=66.72 //y=4.88 //x2=67.48 //y2=4.64
cc_5660 ( N_noxref_16_c_7464_p N_noxref_20_c_9925_n ) capacitor c=0.00192285f \
 //x=66.72 //y=4.88 //x2=67.48 //y2=4.64
cc_5661 ( N_noxref_16_c_7459_p N_noxref_20_c_9929_n ) capacitor c=0.00156832f \
 //x=66.72 //y=4.88 //x2=67.64 //y2=4.64
cc_5662 ( N_noxref_16_c_7440_n N_noxref_20_c_9929_n ) capacitor c=0.00558493f \
 //x=66.722 //y=4.74 //x2=67.64 //y2=4.64
cc_5663 ( N_noxref_16_c_7284_n N_noxref_20_c_9931_n ) capacitor c=3.30333e-19 \
 //x=66.72 //y=4.105 //x2=67.46 //y2=2.26
cc_5664 ( N_noxref_16_c_7481_p N_noxref_20_c_9931_n ) capacitor c=5.24723e-19 \
 //x=66.72 //y=2.26 //x2=67.46 //y2=2.26
cc_5665 ( N_noxref_16_c_7482_p N_noxref_20_c_9931_n ) capacitor c=0.00485709f \
 //x=66.72 //y=2.26 //x2=67.46 //y2=2.26
cc_5666 ( N_noxref_16_c_7483_p N_noxref_20_c_9931_n ) capacitor c=0.00267961f \
 //x=66.525 //y=2.095 //x2=67.46 //y2=2.26
cc_5667 ( N_noxref_16_c_7459_p N_noxref_20_c_9935_n ) capacitor c=4.80626e-19 \
 //x=66.72 //y=4.88 //x2=67.49 //y2=4.88
cc_5668 ( N_noxref_16_c_7461_p N_noxref_20_c_9935_n ) capacitor c=0.00396763f \
 //x=66.72 //y=4.88 //x2=67.49 //y2=4.88
cc_5669 ( N_noxref_16_c_7464_p N_noxref_20_c_9935_n ) capacitor c=0.0028411f \
 //x=66.72 //y=4.88 //x2=67.49 //y2=4.88
cc_5670 ( N_noxref_16_M132_noxref_g N_noxref_20_M134_noxref_g ) capacitor \
 c=0.0104892f //x=66.62 //y=6.2 //x2=67.5 //y2=6.2
cc_5671 ( N_noxref_16_M133_noxref_g N_noxref_20_M134_noxref_g ) capacitor \
 c=0.107442f //x=67.06 //y=6.2 //x2=67.5 //y2=6.2
cc_5672 ( N_noxref_16_M133_noxref_g N_noxref_20_M135_noxref_g ) capacitor \
 c=0.0101362f //x=67.06 //y=6.2 //x2=67.94 //y2=6.2
cc_5673 ( N_noxref_16_c_7592_p N_noxref_20_c_9941_n ) capacitor c=4.86545e-19 \
 //x=66.525 //y=1.045 //x2=67.495 //y2=1.085
cc_5674 ( N_noxref_16_c_7593_p N_noxref_20_c_9941_n ) capacitor c=0.00152405f \
 //x=66.525 //y=1.39 //x2=67.495 //y2=1.085
cc_5675 ( N_noxref_16_c_7594_p N_noxref_20_c_9941_n ) capacitor c=0.0151475f \
 //x=67.055 //y=1.045 //x2=67.495 //y2=1.085
cc_5676 ( N_noxref_16_c_7595_p N_noxref_20_c_9944_n ) capacitor c=0.00109982f \
 //x=66.525 //y=1.7 //x2=67.495 //y2=1.43
cc_5677 ( N_noxref_16_c_7596_p N_noxref_20_c_9944_n ) capacitor c=0.0111064f \
 //x=67.055 //y=1.39 //x2=67.495 //y2=1.43
cc_5678 ( N_noxref_16_c_7595_p N_noxref_20_c_9946_n ) capacitor c=9.58243e-19 \
 //x=66.525 //y=1.7 //x2=67.495 //y2=1.74
cc_5679 ( N_noxref_16_c_7483_p N_noxref_20_c_9946_n ) capacitor c=0.00662747f \
 //x=66.525 //y=2.095 //x2=67.495 //y2=1.74
cc_5680 ( N_noxref_16_c_7596_p N_noxref_20_c_9946_n ) capacitor c=0.00862358f \
 //x=67.055 //y=1.39 //x2=67.495 //y2=1.74
cc_5681 ( N_noxref_16_c_7594_p N_noxref_20_c_9949_n ) capacitor c=0.00127211f \
 //x=67.055 //y=1.045 //x2=68.025 //y2=1.085
cc_5682 ( N_noxref_16_c_7596_p N_noxref_20_c_9950_n ) capacitor c=0.00204774f \
 //x=67.055 //y=1.39 //x2=68.025 //y2=1.43
cc_5683 ( N_noxref_16_c_7481_p N_noxref_20_c_9951_n ) capacitor c=0.00161167f \
 //x=66.72 //y=2.26 //x2=67.46 //y2=2.26
cc_5684 ( N_noxref_16_c_7482_p N_noxref_20_c_9951_n ) capacitor c=0.0018937f \
 //x=66.72 //y=2.26 //x2=67.46 //y2=2.26
cc_5685 ( N_noxref_16_c_7483_p N_noxref_20_c_9951_n ) capacitor c=0.0181449f \
 //x=66.525 //y=2.095 //x2=67.46 //y2=2.26
cc_5686 ( N_noxref_16_c_7459_p N_noxref_20_c_9954_n ) capacitor c=0.00121719f \
 //x=66.72 //y=4.88 //x2=67.49 //y2=4.88
cc_5687 ( N_noxref_16_c_7461_p N_noxref_20_c_9954_n ) capacitor c=0.002258f \
 //x=66.72 //y=4.88 //x2=67.49 //y2=4.88
cc_5688 ( N_noxref_16_c_7464_p N_noxref_20_c_9954_n ) capacitor c=0.029352f \
 //x=66.72 //y=4.88 //x2=67.49 //y2=4.88
cc_5689 ( N_noxref_16_c_7276_n N_noxref_21_c_10665_n ) capacitor c=0.0013968f \
 //x=51.18 //y=4.085 //x2=50.645 //y2=3.54
cc_5690 ( N_noxref_16_c_7276_n N_noxref_21_c_10666_n ) capacitor c=0.0225977f \
 //x=51.18 //y=4.085 //x2=55.61 //y2=3.51
cc_5691 ( N_noxref_16_c_7297_n N_noxref_21_c_10666_n ) capacitor c=0.00361218f \
 //x=51.18 //y=4.405 //x2=55.61 //y2=3.51
cc_5692 ( N_noxref_16_c_7286_n N_noxref_21_c_10666_n ) capacitor c=0.195499f \
 //x=56.565 //y=4.25 //x2=55.61 //y2=3.51
cc_5693 ( N_noxref_16_c_7290_n N_noxref_21_c_10666_n ) capacitor c=0.0157826f \
 //x=51.34 //y=4.245 //x2=55.61 //y2=3.51
cc_5694 ( N_noxref_16_c_7283_n N_noxref_21_c_10672_n ) capacitor c=0.0014211f \
 //x=56.73 //y=4.09 //x2=56.21 //y2=3.48
cc_5695 ( N_noxref_16_c_7286_n N_noxref_21_c_10672_n ) capacitor c=0.00280056f \
 //x=56.565 //y=4.25 //x2=56.21 //y2=3.48
cc_5696 ( N_noxref_16_c_7283_n N_noxref_21_c_10673_n ) capacitor c=0.0227143f \
 //x=56.73 //y=4.09 //x2=60.415 //y2=3.51
cc_5697 ( N_noxref_16_c_7370_n N_noxref_21_c_10673_n ) capacitor c=0.0312032f \
 //x=66.56 //y=4.265 //x2=60.415 //y2=3.51
cc_5698 ( N_noxref_16_c_7370_n N_noxref_21_c_10676_n ) capacitor c=0.0253534f \
 //x=66.56 //y=4.265 //x2=61.015 //y2=3.48
cc_5699 ( N_noxref_16_c_7370_n N_noxref_21_c_10677_n ) capacitor c=0.00344922f \
 //x=66.56 //y=4.265 //x2=64.48 //y2=3.51
cc_5700 ( N_noxref_16_c_7284_n N_noxref_21_c_10680_n ) capacitor c=5.43383e-19 \
 //x=66.72 //y=4.105 //x2=65.08 //y2=3.48
cc_5701 ( N_noxref_16_c_7370_n N_noxref_21_c_10680_n ) capacitor c=0.00978337f \
 //x=66.56 //y=4.265 //x2=65.08 //y2=3.48
cc_5702 ( N_noxref_16_c_7284_n N_noxref_21_c_10681_n ) capacitor c=0.023256f \
 //x=66.72 //y=4.105 //x2=71.885 //y2=3.51
cc_5703 ( N_noxref_16_c_7348_n N_VDD_c_11522_n ) capacitor c=0.00621353f \
 //x=54.95 //y=5.335 //x2=74.455 //y2=7.585
cc_5704 ( N_noxref_16_c_7424_n N_VDD_c_11522_n ) capacitor c=0.00627192f \
 //x=55.835 //y=5.335 //x2=74.455 //y2=7.585
cc_5705 ( N_noxref_16_c_7409_n N_VDD_c_11522_n ) capacitor c=0.00256019f \
 //x=55.95 //y=5.56 //x2=74.455 //y2=7.585
cc_5706 ( N_noxref_16_c_7410_n N_VDD_c_11522_n ) capacitor c=0.00829084f \
 //x=56.645 //y=5.335 //x2=74.455 //y2=7.585
cc_5707 ( N_noxref_16_c_7357_n N_VDD_c_11522_n ) capacitor c=4.85202e-19 \
 //x=56.73 //y=4.41 //x2=74.455 //y2=7.585
cc_5708 ( N_noxref_16_c_7458_p N_VDD_c_11522_n ) capacitor c=2.26187e-19 \
 //x=66.72 //y=4.425 //x2=74.455 //y2=7.585
cc_5709 ( N_noxref_16_c_7361_n N_VDD_c_11522_n ) capacitor c=0.00261804f \
 //x=54.192 //y=5.335 //x2=74.455 //y2=7.585
cc_5710 ( N_noxref_16_c_7434_n N_VDD_c_11522_n ) capacitor c=0.00270108f \
 //x=55.07 //y=5.335 //x2=74.455 //y2=7.585
cc_5711 ( N_noxref_16_c_7497_p N_VDD_c_11522_n ) capacitor c=3.82513e-19 \
 //x=56.725 //y=4.25 //x2=74.455 //y2=7.585
cc_5712 ( N_noxref_16_c_7459_p N_VDD_c_11522_n ) capacitor c=9.07241e-19 \
 //x=66.72 //y=4.88 //x2=74.455 //y2=7.585
cc_5713 ( N_noxref_16_c_7374_n N_VDD_c_11522_n ) capacitor c=0.0024232f \
 //x=54.19 //y=5.56 //x2=74.455 //y2=7.585
cc_5714 ( N_noxref_16_c_7450_n N_VDD_c_11522_n ) capacitor c=0.0024232f \
 //x=55.07 //y=5.56 //x2=74.455 //y2=7.585
cc_5715 ( N_noxref_16_c_7500_p N_VDD_c_11522_n ) capacitor c=0.0024232f \
 //x=55.95 //y=5.56 //x2=74.455 //y2=7.585
cc_5716 ( N_noxref_16_c_7461_p N_VDD_c_11522_n ) capacitor c=6.22888e-19 \
 //x=66.72 //y=4.88 //x2=74.455 //y2=7.585
cc_5717 ( N_noxref_16_M114_noxref_g N_VDD_c_12233_n ) capacitor c=0.00697352f \
 //x=51.22 //y=6.2 //x2=51.795 //y2=7.585
cc_5718 ( N_noxref_16_M115_noxref_g N_VDD_c_12233_n ) capacitor c=0.00755544f \
 //x=51.66 //y=6.2 //x2=51.795 //y2=7.585
cc_5719 ( N_noxref_16_c_7348_n N_VDD_c_12238_n ) capacitor c=0.00202922f \
 //x=54.95 //y=5.335 //x2=54.545 //y2=7.585
cc_5720 ( N_noxref_16_c_7361_n N_VDD_c_12238_n ) capacitor c=9.3757e-19 \
 //x=54.192 //y=5.335 //x2=54.545 //y2=7.585
cc_5721 ( N_noxref_16_c_7374_n N_VDD_c_12238_n ) capacitor c=0.0138074f \
 //x=54.19 //y=5.56 //x2=54.545 //y2=7.585
cc_5722 ( N_noxref_16_c_7348_n N_VDD_c_12341_n ) capacitor c=0.0017708f \
 //x=54.95 //y=5.335 //x2=55.425 //y2=7.585
cc_5723 ( N_noxref_16_c_7424_n N_VDD_c_12341_n ) capacitor c=0.00202922f \
 //x=55.835 //y=5.335 //x2=55.425 //y2=7.585
cc_5724 ( N_noxref_16_c_7434_n N_VDD_c_12341_n ) capacitor c=9.4822e-19 \
 //x=55.07 //y=5.335 //x2=55.425 //y2=7.585
cc_5725 ( N_noxref_16_c_7450_n N_VDD_c_12341_n ) capacitor c=0.0138074f \
 //x=55.07 //y=5.56 //x2=55.425 //y2=7.585
cc_5726 ( N_noxref_16_c_7424_n N_VDD_c_12421_n ) capacitor c=0.00205906f \
 //x=55.835 //y=5.335 //x2=56.305 //y2=7.585
cc_5727 ( N_noxref_16_c_7409_n N_VDD_c_12421_n ) capacitor c=8.49654e-19 \
 //x=55.95 //y=5.56 //x2=56.305 //y2=7.585
cc_5728 ( N_noxref_16_c_7410_n N_VDD_c_12421_n ) capacitor c=0.00204238f \
 //x=56.645 //y=5.335 //x2=56.305 //y2=7.585
cc_5729 ( N_noxref_16_c_7500_p N_VDD_c_12421_n ) capacitor c=0.0135103f \
 //x=55.95 //y=5.56 //x2=56.305 //y2=7.585
cc_5730 ( N_noxref_16_c_7410_n N_VDD_c_12425_n ) capacitor c=0.00157114f \
 //x=56.645 //y=5.335 //x2=57.3 //y2=7.585
cc_5731 ( N_noxref_16_c_7357_n N_VDD_c_12425_n ) capacitor c=3.91238e-19 \
 //x=56.73 //y=4.41 //x2=57.3 //y2=7.585
cc_5732 ( N_noxref_16_c_7459_p N_VDD_c_12427_n ) capacitor c=6.28113e-19 \
 //x=66.72 //y=4.88 //x2=67.195 //y2=7.585
cc_5733 ( N_noxref_16_M132_noxref_g N_VDD_c_12427_n ) capacitor c=0.00732618f \
 //x=66.62 //y=6.2 //x2=67.195 //y2=7.585
cc_5734 ( N_noxref_16_M133_noxref_g N_VDD_c_12427_n ) capacitor c=0.00755544f \
 //x=67.06 //y=6.2 //x2=67.195 //y2=7.585
cc_5735 ( N_noxref_16_c_7285_n N_VDD_c_12088_n ) capacitor c=9.76453e-19 \
 //x=51.18 //y=4.25 //x2=49.33 //y2=7.585
cc_5736 ( N_noxref_16_c_7285_n N_VDD_c_12245_n ) capacitor c=0.00133334f \
 //x=51.18 //y=4.25 //x2=52.66 //y2=7.585
cc_5737 ( N_noxref_16_c_7361_n N_VDD_c_12245_n ) capacitor c=0.0022955f \
 //x=54.192 //y=5.335 //x2=52.66 //y2=7.585
cc_5738 ( N_noxref_16_c_7286_n N_VDD_c_12245_n ) capacitor c=0.00867154f \
 //x=56.565 //y=4.25 //x2=52.66 //y2=7.585
cc_5739 ( N_noxref_16_c_7311_n N_VDD_c_12245_n ) capacitor c=0.00226427f \
 //x=51.21 //y=4.88 //x2=52.66 //y2=7.585
cc_5740 ( N_noxref_16_c_7374_n N_VDD_c_12245_n ) capacitor c=0.00508013f \
 //x=54.19 //y=5.56 //x2=52.66 //y2=7.585
cc_5741 ( N_noxref_16_c_7389_n N_VDD_c_12245_n ) capacitor c=0.0129149f \
 //x=51.585 //y=4.97 //x2=52.66 //y2=7.585
cc_5742 ( N_noxref_16_c_7330_n N_VDD_c_12245_n ) capacitor c=2.73429e-19 \
 //x=51.21 //y=4.88 //x2=52.66 //y2=7.585
cc_5743 ( N_noxref_16_c_7409_n N_VDD_c_12252_n ) capacitor c=0.00282782f \
 //x=55.95 //y=5.56 //x2=57.47 //y2=7.585
cc_5744 ( N_noxref_16_c_7357_n N_VDD_c_12252_n ) capacitor c=0.00177813f \
 //x=56.73 //y=4.41 //x2=57.47 //y2=7.585
cc_5745 ( N_noxref_16_c_7358_n N_VDD_c_12252_n ) capacitor c=0.0293445f \
 //x=56.73 //y=5.25 //x2=57.47 //y2=7.585
cc_5746 ( N_noxref_16_c_7497_p N_VDD_c_12252_n ) capacitor c=0.00499873f \
 //x=56.725 //y=4.25 //x2=57.47 //y2=7.585
cc_5747 ( N_noxref_16_c_7370_n N_VDD_c_12252_n ) capacitor c=0.00826669f \
 //x=66.56 //y=4.265 //x2=57.47 //y2=7.585
cc_5748 ( N_noxref_16_c_7500_p N_VDD_c_12252_n ) capacitor c=0.00777981f \
 //x=55.95 //y=5.56 //x2=57.47 //y2=7.585
cc_5749 ( N_noxref_16_c_7370_n N_VDD_c_12310_n ) capacitor c=0.00885867f \
 //x=66.56 //y=4.265 //x2=62.28 //y2=7.585
cc_5750 ( N_noxref_16_c_7458_p N_VDD_c_12366_n ) capacitor c=0.00144835f \
 //x=66.72 //y=4.425 //x2=65.61 //y2=7.585
cc_5751 ( N_noxref_16_c_7569_p N_VDD_c_12366_n ) capacitor c=0.00247508f \
 //x=66.72 //y=4.25 //x2=65.61 //y2=7.585
cc_5752 ( N_noxref_16_c_7459_p N_VDD_c_12366_n ) capacitor c=0.00508547f \
 //x=66.72 //y=4.88 //x2=65.61 //y2=7.585
cc_5753 ( N_noxref_16_c_7440_n N_VDD_c_12366_n ) capacitor c=0.00506192f \
 //x=66.722 //y=4.74 //x2=65.61 //y2=7.585
cc_5754 ( N_noxref_16_c_7370_n N_VDD_c_12366_n ) capacitor c=0.0193991f \
 //x=66.56 //y=4.265 //x2=65.61 //y2=7.585
cc_5755 ( N_noxref_16_c_7461_p N_VDD_c_12366_n ) capacitor c=0.00370494f \
 //x=66.72 //y=4.88 //x2=65.61 //y2=7.585
cc_5756 ( N_noxref_16_c_7464_p N_VDD_c_12366_n ) capacitor c=0.0128285f \
 //x=66.72 //y=4.88 //x2=65.61 //y2=7.585
cc_5757 ( N_noxref_16_c_7569_p N_VDD_c_12452_n ) capacitor c=7.01473e-19 \
 //x=66.72 //y=4.25 //x2=68.94 //y2=7.585
cc_5758 ( N_noxref_16_c_7361_n N_VDD_M112_noxref_s ) capacitor c=4.22189e-19 \
 //x=54.192 //y=5.335 //x2=49.985 //y2=5.2
cc_5759 ( N_noxref_16_M114_noxref_g N_VDD_M113_noxref_d ) capacitor \
 c=0.015318f //x=51.22 //y=6.2 //x2=50.855 //y2=5.2
cc_5760 ( N_noxref_16_c_7330_n N_VDD_M113_noxref_d ) capacitor c=3.50465e-19 \
 //x=51.21 //y=4.88 //x2=50.855 //y2=5.2
cc_5761 ( N_noxref_16_M115_noxref_g N_VDD_M115_noxref_d ) capacitor \
 c=0.0430452f //x=51.66 //y=6.2 //x2=51.735 //y2=5.2
cc_5762 ( N_noxref_16_c_7361_n N_VDD_M116_noxref_s ) capacitor c=0.0442713f \
 //x=54.192 //y=5.335 //x2=53.615 //y2=5.2
cc_5763 ( N_noxref_16_c_7434_n N_VDD_M116_noxref_s ) capacitor c=7.80122e-19 \
 //x=55.07 //y=5.335 //x2=53.615 //y2=5.2
cc_5764 ( N_noxref_16_c_7374_n N_VDD_M116_noxref_s ) capacitor c=0.0908457f \
 //x=54.19 //y=5.56 //x2=53.615 //y2=5.2
cc_5765 ( N_noxref_16_c_7348_n N_VDD_M117_noxref_d ) capacitor c=0.00700141f \
 //x=54.95 //y=5.335 //x2=54.485 //y2=5.2
cc_5766 ( N_noxref_16_c_7374_n N_VDD_M117_noxref_d ) capacitor c=0.0673792f \
 //x=54.19 //y=5.56 //x2=54.485 //y2=5.2
cc_5767 ( N_noxref_16_c_7450_n N_VDD_M117_noxref_d ) capacitor c=0.0674762f \
 //x=55.07 //y=5.56 //x2=54.485 //y2=5.2
cc_5768 ( N_noxref_16_c_7424_n N_VDD_M119_noxref_d ) capacitor c=0.00700141f \
 //x=55.835 //y=5.335 //x2=55.365 //y2=5.2
cc_5769 ( N_noxref_16_c_7450_n N_VDD_M119_noxref_d ) capacitor c=0.067493f \
 //x=55.07 //y=5.56 //x2=55.365 //y2=5.2
cc_5770 ( N_noxref_16_c_7500_p N_VDD_M119_noxref_d ) capacitor c=0.0674979f \
 //x=55.95 //y=5.56 //x2=55.365 //y2=5.2
cc_5771 ( N_noxref_16_c_7410_n N_VDD_M121_noxref_d ) capacitor c=0.00700141f \
 //x=56.645 //y=5.335 //x2=56.245 //y2=5.2
cc_5772 ( N_noxref_16_c_7500_p N_VDD_M121_noxref_d ) capacitor c=0.0675002f \
 //x=55.95 //y=5.56 //x2=56.245 //y2=5.2
cc_5773 ( N_noxref_16_c_7409_n N_VDD_M122_noxref_s ) capacitor c=0.00492616f \
 //x=55.95 //y=5.56 //x2=58.425 //y2=5.2
cc_5774 ( N_noxref_16_c_7410_n N_VDD_M122_noxref_s ) capacitor c=9.42705e-19 \
 //x=56.645 //y=5.335 //x2=58.425 //y2=5.2
cc_5775 ( N_noxref_16_c_7434_n N_VDD_M122_noxref_s ) capacitor c=2.11884e-19 \
 //x=55.07 //y=5.335 //x2=58.425 //y2=5.2
cc_5776 ( N_noxref_16_c_7458_p N_VDD_M132_noxref_s ) capacitor c=0.00222454f \
 //x=66.72 //y=4.425 //x2=66.265 //y2=5.2
cc_5777 ( N_noxref_16_c_7370_n N_VDD_M132_noxref_s ) capacitor c=0.00535656f \
 //x=66.56 //y=4.265 //x2=66.265 //y2=5.2
cc_5778 ( N_noxref_16_M132_noxref_g N_VDD_M132_noxref_s ) capacitor \
 c=0.0567929f //x=66.62 //y=6.2 //x2=66.265 //y2=5.2
cc_5779 ( N_noxref_16_M133_noxref_g N_VDD_M133_noxref_d ) capacitor \
 c=0.015318f //x=67.06 //y=6.2 //x2=67.135 //y2=5.2
cc_5780 ( N_noxref_16_c_7477_p N_noxref_30_c_13375_n ) capacitor c=0.0036878f \
 //x=56.245 //y=1.305 //x2=56.645 //y2=0.72
cc_5781 ( N_noxref_16_c_7411_n N_noxref_30_c_13375_n ) capacitor c=0.00399931f \
 //x=56.645 //y=1.845 //x2=56.645 //y2=0.72
cc_5782 ( N_noxref_16_M34_noxref_d N_noxref_30_c_13375_n ) capacitor \
 c=0.00910163f //x=56.055 //y=1.095 //x2=56.645 //y2=0.72
cc_5783 ( N_noxref_16_M34_noxref_d N_noxref_30_c_13378_n ) capacitor \
 c=0.00120711f //x=56.055 //y=1.095 //x2=55.76 //y2=1.175
cc_5784 ( N_noxref_16_c_7348_n N_noxref_30_M33_noxref_d ) capacitor \
 c=0.00143559f //x=54.95 //y=5.335 //x2=54.52 //y2=1.09
cc_5785 ( N_noxref_16_c_7477_p N_noxref_30_M33_noxref_d ) capacitor \
 c=0.00802417f //x=56.245 //y=1.305 //x2=54.52 //y2=1.09
cc_5786 ( N_noxref_16_c_7477_p N_noxref_30_M34_noxref_s ) capacitor \
 c=0.0098487f //x=56.245 //y=1.305 //x2=55.625 //y2=0.555
cc_5787 ( N_noxref_16_c_7349_n N_noxref_30_M34_noxref_s ) capacitor \
 c=0.0283111f //x=56.245 //y=1.76 //x2=55.625 //y2=0.555
cc_5788 ( N_noxref_16_c_7411_n N_noxref_30_M34_noxref_s ) capacitor \
 c=0.00946155f //x=56.645 //y=1.845 //x2=55.625 //y2=0.555
cc_5789 ( N_noxref_16_c_7497_p N_noxref_30_M34_noxref_s ) capacitor \
 c=0.00104339f //x=56.725 //y=4.25 //x2=55.625 //y2=0.555
cc_5790 ( N_noxref_16_M34_noxref_d N_noxref_30_M34_noxref_s ) capacitor \
 c=0.0279003f //x=56.055 //y=1.095 //x2=55.625 //y2=0.555
cc_5791 ( N_noxref_16_c_7477_p N_noxref_31_M36_noxref_d ) capacitor \
 c=3.20746e-19 //x=56.245 //y=1.305 //x2=59.33 //y2=1.09
cc_5792 ( N_noxref_16_c_7302_n N_GND_c_14438_n ) capacitor c=0.00210951f \
 //x=51.18 //y=2.26 //x2=53.65 //y2=0.175
cc_5793 ( N_noxref_16_c_7477_p N_GND_c_14559_n ) capacitor c=0.00884249f \
 //x=56.245 //y=1.305 //x2=58.46 //y2=0.175
cc_5794 ( N_noxref_16_c_7411_n N_GND_c_14559_n ) capacitor c=0.00662952f \
 //x=56.645 //y=1.845 //x2=58.46 //y2=0.175
cc_5795 ( N_noxref_16_c_7357_n N_GND_c_14559_n ) capacitor c=2.51625e-19 \
 //x=56.73 //y=4.41 //x2=58.46 //y2=0.175
cc_5796 ( N_noxref_16_M34_noxref_d N_GND_c_14559_n ) capacitor c=2.9462e-19 \
 //x=56.055 //y=1.095 //x2=58.46 //y2=0.175
cc_5797 ( N_noxref_16_c_7477_p N_GND_c_14462_n ) capacitor c=0.00543195f \
 //x=56.245 //y=1.305 //x2=58.545 //y2=1.145
cc_5798 ( N_noxref_16_c_7481_p N_GND_c_14579_n ) capacitor c=0.00645051f \
 //x=66.72 //y=2.26 //x2=66.79 //y2=1.135
cc_5799 ( N_noxref_16_c_7482_p N_GND_c_14579_n ) capacitor c=2.13705e-19 \
 //x=66.72 //y=2.26 //x2=66.79 //y2=1.135
cc_5800 ( N_noxref_16_c_7592_p N_GND_c_14579_n ) capacitor c=0.00171023f \
 //x=66.525 //y=1.045 //x2=66.79 //y2=1.135
cc_5801 ( N_noxref_16_c_7593_p N_GND_c_14579_n ) capacitor c=0.00357815f \
 //x=66.525 //y=1.39 //x2=66.79 //y2=1.135
cc_5802 ( N_noxref_16_c_7595_p N_GND_c_14579_n ) capacitor c=4.2764e-19 \
 //x=66.525 //y=1.7 //x2=66.79 //y2=1.135
cc_5803 ( N_noxref_16_c_7722_p N_GND_c_14579_n ) capacitor c=9.36995e-19 \
 //x=66.9 //y=0.89 //x2=66.79 //y2=1.135
cc_5804 ( N_noxref_16_c_7723_p N_GND_c_14579_n ) capacitor c=6.33567e-19 \
 //x=66.9 //y=1.545 //x2=66.79 //y2=1.135
cc_5805 ( N_noxref_16_c_7594_p N_GND_c_14579_n ) capacitor c=0.00171483f \
 //x=67.055 //y=1.045 //x2=66.79 //y2=1.135
cc_5806 ( N_noxref_16_c_7596_p N_GND_c_14579_n ) capacitor c=0.00296337f \
 //x=67.055 //y=1.39 //x2=66.79 //y2=1.135
cc_5807 ( N_noxref_16_c_7592_p N_GND_c_14588_n ) capacitor c=3.46594e-19 \
 //x=66.525 //y=1.045 //x2=66.787 //y2=1.005
cc_5808 ( N_noxref_16_c_7722_p N_GND_c_14588_n ) capacitor c=0.00838576f \
 //x=66.9 //y=0.89 //x2=66.787 //y2=1.005
cc_5809 ( N_noxref_16_c_7594_p N_GND_c_14588_n ) capacitor c=4.40196e-19 \
 //x=67.055 //y=1.045 //x2=66.787 //y2=1.005
cc_5810 ( N_noxref_16_c_7302_n N_GND_c_14394_n ) capacitor c=3.77328e-19 \
 //x=51.18 //y=2.26 //x2=52.49 //y2=0.175
cc_5811 ( N_noxref_16_c_7411_n N_GND_c_14474_n ) capacitor c=6.86343e-19 \
 //x=56.645 //y=1.845 //x2=57.3 //y2=0.175
cc_5812 ( N_noxref_16_c_7592_p N_GND_c_14593_n ) capacitor c=0.00688027f \
 //x=66.525 //y=1.045 //x2=68.77 //y2=0.175
cc_5813 ( N_noxref_16_c_7307_n N_GND_c_14332_n ) capacitor c=0.00200922f \
 //x=51.18 //y=2.26 //x2=52.66 //y2=0.175
cc_5814 ( N_noxref_16_c_7326_n N_GND_c_14332_n ) capacitor c=0.00275184f \
 //x=51.745 //y=1.43 //x2=52.66 //y2=0.175
cc_5815 ( N_noxref_16_c_7327_n N_GND_c_14332_n ) capacitor c=2.63786e-19 \
 //x=51.18 //y=2.26 //x2=52.66 //y2=0.175
cc_5816 ( N_noxref_16_c_7349_n N_GND_c_14333_n ) capacitor c=0.0045138f \
 //x=56.245 //y=1.76 //x2=57.47 //y2=0.175
cc_5817 ( N_noxref_16_c_7411_n N_GND_c_14333_n ) capacitor c=0.0304548f \
 //x=56.645 //y=1.845 //x2=57.47 //y2=0.175
cc_5818 ( N_noxref_16_c_7284_n N_GND_c_14335_n ) capacitor c=0.00781993f \
 //x=66.72 //y=4.105 //x2=65.61 //y2=0.175
cc_5819 ( N_noxref_16_c_7481_p N_GND_c_14335_n ) capacitor c=0.00351582f \
 //x=66.72 //y=2.26 //x2=65.61 //y2=0.175
cc_5820 ( N_noxref_16_c_7482_p N_GND_c_14335_n ) capacitor c=0.00371068f \
 //x=66.72 //y=2.26 //x2=65.61 //y2=0.175
cc_5821 ( N_noxref_16_c_7595_p N_GND_c_14335_n ) capacitor c=0.0015404f \
 //x=66.525 //y=1.7 //x2=65.61 //y2=0.175
cc_5822 ( N_noxref_16_c_7483_p N_GND_c_14335_n ) capacitor c=0.00936534f \
 //x=66.525 //y=2.095 //x2=65.61 //y2=0.175
cc_5823 ( N_noxref_16_c_7481_p N_GND_M40_noxref_d ) capacitor c=2.20438e-19 \
 //x=66.72 //y=2.26 //x2=66.6 //y2=1.045
cc_5824 ( N_noxref_16_c_7592_p N_GND_M40_noxref_d ) capacitor c=0.00192399f \
 //x=66.525 //y=1.045 //x2=66.6 //y2=1.045
cc_5825 ( N_noxref_16_c_7593_p N_GND_M40_noxref_d ) capacitor c=0.00210798f \
 //x=66.525 //y=1.39 //x2=66.6 //y2=1.045
cc_5826 ( N_noxref_16_c_7722_p N_GND_M40_noxref_d ) capacitor c=0.00472259f \
 //x=66.9 //y=0.89 //x2=66.6 //y2=1.045
cc_5827 ( N_noxref_16_c_7723_p N_GND_M40_noxref_d ) capacitor c=0.00166857f \
 //x=66.9 //y=1.545 //x2=66.6 //y2=1.045
cc_5828 ( N_noxref_16_c_7594_p N_GND_M40_noxref_d ) capacitor c=0.00230174f \
 //x=67.055 //y=1.045 //x2=66.6 //y2=1.045
cc_5829 ( N_noxref_16_c_7596_p N_GND_M40_noxref_d ) capacitor c=0.00210798f \
 //x=67.055 //y=1.39 //x2=66.6 //y2=1.045
cc_5830 ( N_noxref_16_c_7297_n N_noxref_49_c_16359_n ) capacitor c=3.23849e-19 \
 //x=51.18 //y=4.405 //x2=50.995 //y2=1.675
cc_5831 ( N_noxref_16_c_7302_n N_noxref_49_c_16359_n ) capacitor c=7.50092e-19 \
 //x=51.18 //y=2.26 //x2=50.995 //y2=1.675
cc_5832 ( N_noxref_16_c_7322_n N_noxref_49_c_16359_n ) capacitor c=0.00888238f \
 //x=51.215 //y=1.74 //x2=50.995 //y2=1.675
cc_5833 ( N_noxref_16_c_7327_n N_noxref_49_c_16359_n ) capacitor c=0.00175171f \
 //x=51.18 //y=2.26 //x2=50.995 //y2=1.675
cc_5834 ( N_noxref_16_c_7302_n N_noxref_49_c_16364_n ) capacitor c=0.001463f \
 //x=51.18 //y=2.26 //x2=51.88 //y2=0.71
cc_5835 ( N_noxref_16_c_7307_n N_noxref_49_c_16364_n ) capacitor c=8.82141e-19 \
 //x=51.18 //y=2.26 //x2=51.88 //y2=0.71
cc_5836 ( N_noxref_16_c_7317_n N_noxref_49_c_16364_n ) capacitor c=0.0200738f \
 //x=51.215 //y=1.085 //x2=51.88 //y2=0.71
cc_5837 ( N_noxref_16_c_7325_n N_noxref_49_c_16364_n ) capacitor c=0.00825432f \
 //x=51.745 //y=1.085 //x2=51.88 //y2=0.71
cc_5838 ( N_noxref_16_c_7327_n N_noxref_49_c_16364_n ) capacitor c=2.1838e-19 \
 //x=51.18 //y=2.26 //x2=51.88 //y2=0.71
cc_5839 ( N_noxref_16_c_7317_n N_noxref_49_M30_noxref_s ) capacitor \
 c=0.00888238f //x=51.215 //y=1.085 //x2=49.89 //y2=0.545
cc_5840 ( N_noxref_16_c_7325_n N_noxref_49_M30_noxref_s ) capacitor \
 c=0.015333f //x=51.745 //y=1.085 //x2=49.89 //y2=0.545
cc_5841 ( N_noxref_16_c_7326_n N_noxref_49_M30_noxref_s ) capacitor \
 c=0.00248746f //x=51.745 //y=1.43 //x2=49.89 //y2=0.545
cc_5842 ( N_noxref_16_c_7483_p N_noxref_53_c_16604_n ) capacitor c=0.00262672f \
 //x=66.525 //y=2.095 //x2=66.305 //y2=1.675
cc_5843 ( N_noxref_16_c_7458_p N_noxref_53_c_16605_n ) capacitor c=0.00330249f \
 //x=66.72 //y=4.425 //x2=67.19 //y2=1.76
cc_5844 ( N_noxref_16_c_7481_p N_noxref_53_c_16605_n ) capacitor c=0.00509504f \
 //x=66.72 //y=2.26 //x2=67.19 //y2=1.76
cc_5845 ( N_noxref_16_c_7482_p N_noxref_53_c_16605_n ) capacitor c=0.00763108f \
 //x=66.72 //y=2.26 //x2=67.19 //y2=1.76
cc_5846 ( N_noxref_16_c_7595_p N_noxref_53_c_16605_n ) capacitor c=0.00697076f \
 //x=66.525 //y=1.7 //x2=67.19 //y2=1.76
cc_5847 ( N_noxref_16_c_7483_p N_noxref_53_c_16605_n ) capacitor c=0.0170561f \
 //x=66.525 //y=2.095 //x2=67.19 //y2=1.76
cc_5848 ( N_noxref_16_c_7723_p N_noxref_53_c_16605_n ) capacitor c=0.00723574f \
 //x=66.9 //y=1.545 //x2=67.19 //y2=1.76
cc_5849 ( N_noxref_16_c_7596_p N_noxref_53_c_16605_n ) capacitor c=0.00339872f \
 //x=67.055 //y=1.39 //x2=67.19 //y2=1.76
cc_5850 ( N_noxref_16_c_7483_p N_noxref_53_c_16612_n ) capacitor c=6.71402e-19 \
 //x=66.525 //y=2.095 //x2=67.275 //y2=1.675
cc_5851 ( N_noxref_16_c_7592_p N_noxref_53_M40_noxref_s ) capacitor \
 c=0.0294925f //x=66.525 //y=1.045 //x2=66.17 //y2=0.545
cc_5852 ( N_noxref_16_c_7595_p N_noxref_53_M40_noxref_s ) capacitor \
 c=3.48408e-19 //x=66.525 //y=1.7 //x2=66.17 //y2=0.545
cc_5853 ( N_noxref_16_c_7594_p N_noxref_53_M40_noxref_s ) capacitor \
 c=0.0125442f //x=67.055 //y=1.045 //x2=66.17 //y2=0.545
cc_5854 ( N_noxref_17_c_7791_p N_SN_c_8501_n ) capacitor c=0.00802132f \
 //x=70.05 //y=2.375 //x2=71.16 //y2=2.55
cc_5855 ( N_noxref_17_c_7774_n N_SN_c_8501_n ) capacitor c=0.00346868f \
 //x=70.05 //y=4.755 //x2=71.16 //y2=2.55
cc_5856 ( N_noxref_17_c_7793_p N_SN_c_8501_n ) capacitor c=0.00117245f \
 //x=70.05 //y=2.26 //x2=71.16 //y2=2.55
cc_5857 ( N_noxref_17_c_7794_p N_SN_c_8501_n ) capacitor c=0.00157323f \
 //x=69.75 //y=2.095 //x2=71.16 //y2=2.55
cc_5858 ( N_noxref_17_c_7773_n N_SN_c_8502_n ) capacitor c=0.00218009f \
 //x=68.2 //y=4.87 //x2=71.16 //y2=4.765
cc_5859 ( N_noxref_17_c_7774_n N_SN_c_8502_n ) capacitor c=0.0563027f \
 //x=70.05 //y=4.755 //x2=71.16 //y2=4.765
cc_5860 ( N_noxref_17_c_7797_p N_SN_c_8502_n ) capacitor c=0.00773254f \
 //x=70.05 //y=4.88 //x2=71.16 //y2=4.765
cc_5861 ( N_noxref_17_c_7798_p N_SN_c_8502_n ) capacitor c=0.00407792f \
 //x=70.04 //y=5.005 //x2=71.16 //y2=4.765
cc_5862 ( N_noxref_17_c_7799_p N_SN_c_8502_n ) capacitor c=5.42612e-19 \
 //x=70.05 //y=4.88 //x2=71.16 //y2=4.765
cc_5863 ( N_noxref_17_c_7800_p N_SN_c_8502_n ) capacitor c=7.61868e-19 \
 //x=70.615 //y=4.97 //x2=71.16 //y2=4.765
cc_5864 ( N_noxref_17_c_7801_p N_SN_c_8502_n ) capacitor c=4.64309e-19 \
 //x=70.325 //y=4.97 //x2=71.16 //y2=4.765
cc_5865 ( N_noxref_17_c_7791_p N_SN_c_8520_n ) capacitor c=0.00196004f \
 //x=70.05 //y=2.375 //x2=71.15 //y2=2.39
cc_5866 ( N_noxref_17_c_7774_n N_SN_c_8520_n ) capacitor c=0.00105803f \
 //x=70.05 //y=4.755 //x2=71.15 //y2=2.39
cc_5867 ( N_noxref_17_c_7804_p N_SN_c_8521_n ) capacitor c=0.0197047f \
 //x=67.845 //y=1.835 //x2=70.99 //y2=2.39
cc_5868 ( N_noxref_17_c_7773_n N_SN_c_8521_n ) capacitor c=0.0308523f //x=68.2 \
 //y=4.87 //x2=70.99 //y2=2.39
cc_5869 ( N_noxref_17_c_7791_p N_SN_c_8521_n ) capacitor c=0.0172176f \
 //x=70.05 //y=2.375 //x2=70.99 //y2=2.39
cc_5870 ( N_noxref_17_c_7774_n N_SN_c_8521_n ) capacitor c=0.0169147f \
 //x=70.05 //y=4.755 //x2=70.99 //y2=2.39
cc_5871 ( N_noxref_17_c_7808_p N_SN_c_8521_n ) capacitor c=7.09092e-19 \
 //x=67.76 //y=1.18 //x2=70.99 //y2=2.39
cc_5872 ( N_noxref_17_c_7793_p N_SN_c_8521_n ) capacitor c=2.54369e-19 \
 //x=70.05 //y=2.26 //x2=70.99 //y2=2.39
cc_5873 ( N_noxref_17_c_7791_p N_SN_c_8737_n ) capacitor c=5.39999e-19 \
 //x=70.05 //y=2.375 //x2=71.16 //y2=2.26
cc_5874 ( N_noxref_17_c_7793_p N_SN_c_8737_n ) capacitor c=0.00124905f \
 //x=70.05 //y=2.26 //x2=71.16 //y2=2.26
cc_5875 ( N_noxref_17_c_7794_p N_SN_c_8737_n ) capacitor c=0.00214501f \
 //x=69.75 //y=2.095 //x2=71.16 //y2=2.26
cc_5876 ( N_noxref_17_c_7774_n N_SN_c_8740_n ) capacitor c=3.30718e-19 \
 //x=70.05 //y=4.755 //x2=71.16 //y2=4.88
cc_5877 ( N_noxref_17_c_7797_p N_SN_c_8740_n ) capacitor c=7.83116e-19 \
 //x=70.05 //y=4.88 //x2=71.16 //y2=4.88
cc_5878 ( N_noxref_17_c_7799_p N_SN_c_8740_n ) capacitor c=0.00113984f \
 //x=70.05 //y=4.88 //x2=71.16 //y2=4.88
cc_5879 ( N_noxref_17_c_7800_p N_SN_c_8740_n ) capacitor c=0.00116563f \
 //x=70.615 //y=4.97 //x2=71.16 //y2=4.88
cc_5880 ( N_noxref_17_c_7801_p N_SN_c_8740_n ) capacitor c=0.00120907f \
 //x=70.325 //y=4.97 //x2=71.16 //y2=4.88
cc_5881 ( N_noxref_17_M136_noxref_g N_SN_M138_noxref_g ) capacitor \
 c=0.0108317f //x=70.25 //y=6.2 //x2=71.13 //y2=6.2
cc_5882 ( N_noxref_17_M137_noxref_g N_SN_M138_noxref_g ) capacitor c=0.106739f \
 //x=70.69 //y=6.2 //x2=71.13 //y2=6.2
cc_5883 ( N_noxref_17_M137_noxref_g N_SN_M139_noxref_g ) capacitor \
 c=0.0101598f //x=70.69 //y=6.2 //x2=71.57 //y2=6.2
cc_5884 ( N_noxref_17_c_7821_p N_SN_c_8748_n ) capacitor c=5.72528e-19 \
 //x=69.75 //y=1.055 //x2=70.725 //y2=1.09
cc_5885 ( N_noxref_17_c_7822_p N_SN_c_8748_n ) capacitor c=0.00150277f \
 //x=69.75 //y=1.4 //x2=70.725 //y2=1.09
cc_5886 ( N_noxref_17_c_7823_p N_SN_c_8748_n ) capacitor c=0.0160123f \
 //x=70.28 //y=1.055 //x2=70.725 //y2=1.09
cc_5887 ( N_noxref_17_c_7824_p N_SN_c_8751_n ) capacitor c=0.00111227f \
 //x=69.75 //y=1.71 //x2=70.725 //y2=1.4
cc_5888 ( N_noxref_17_c_7825_p N_SN_c_8751_n ) capacitor c=0.0124075f \
 //x=70.28 //y=1.4 //x2=70.725 //y2=1.4
cc_5889 ( N_noxref_17_c_7823_p N_SN_c_8753_n ) capacitor c=9.19165e-19 \
 //x=70.28 //y=1.055 //x2=71.25 //y2=1.09
cc_5890 ( N_noxref_17_c_7825_p N_SN_c_8754_n ) capacitor c=0.0010154f \
 //x=70.28 //y=1.4 //x2=71.25 //y2=1.4
cc_5891 ( N_noxref_17_c_7825_p N_SN_c_8755_n ) capacitor c=9.23422e-19 \
 //x=70.28 //y=1.4 //x2=71.25 //y2=1.63
cc_5892 ( N_noxref_17_c_7791_p N_SN_c_8756_n ) capacitor c=5.616e-19 //x=70.05 \
 //y=2.375 //x2=71.25 //y2=2.095
cc_5893 ( N_noxref_17_c_7793_p N_SN_c_8756_n ) capacitor c=0.0017273f \
 //x=70.05 //y=2.26 //x2=71.25 //y2=2.095
cc_5894 ( N_noxref_17_c_7794_p N_SN_c_8756_n ) capacitor c=0.00880777f \
 //x=69.75 //y=2.095 //x2=71.25 //y2=2.095
cc_5895 ( N_noxref_17_c_7797_p N_SN_c_8759_n ) capacitor c=7.63277e-19 \
 //x=70.05 //y=4.88 //x2=71.16 //y2=4.88
cc_5896 ( N_noxref_17_c_7799_p N_SN_c_8759_n ) capacitor c=0.00165793f \
 //x=70.05 //y=4.88 //x2=71.16 //y2=4.88
cc_5897 ( N_noxref_17_c_7800_p N_SN_c_8759_n ) capacitor c=0.0169928f \
 //x=70.615 //y=4.97 //x2=71.16 //y2=4.88
cc_5898 ( N_noxref_17_c_7801_p N_SN_c_8759_n ) capacitor c=0.00467639f \
 //x=70.325 //y=4.97 //x2=71.16 //y2=4.88
cc_5899 ( N_noxref_17_c_7836_p N_noxref_19_c_9302_n ) capacitor c=0.00324213f \
 //x=67.76 //y=1.75 //x2=64.43 //y2=1.75
cc_5900 ( N_noxref_17_c_7778_n N_noxref_19_c_9383_n ) capacitor c=0.00114153f \
 //x=66.84 //y=5.56 //x2=64.785 //y2=5.38
cc_5901 ( N_noxref_17_c_7804_p N_noxref_19_c_9384_n ) capacitor c=0.00231467f \
 //x=67.845 //y=1.835 //x2=64.785 //y2=1.835
cc_5902 ( N_noxref_17_c_7773_n N_noxref_19_c_9263_n ) capacitor c=0.00204244f \
 //x=68.2 //y=4.87 //x2=64.87 //y2=3.705
cc_5903 ( N_noxref_17_c_7840_p N_noxref_19_c_9307_n ) capacitor c=0.002769f \
 //x=68.275 //y=5.03 //x2=64.87 //y2=5.295
cc_5904 ( N_noxref_17_c_7774_n N_noxref_19_c_9265_n ) capacitor c=0.00152671f \
 //x=70.05 //y=4.755 //x2=72.27 //y2=3.725
cc_5905 ( N_noxref_17_c_7774_n N_noxref_19_c_9539_n ) capacitor c=8.74549e-19 \
 //x=70.05 //y=4.755 //x2=72.27 //y2=4.75
cc_5906 ( N_noxref_17_c_7778_n N_noxref_19_c_9400_n ) capacitor c=5.29822e-19 \
 //x=66.84 //y=5.56 //x2=64.39 //y2=5.38
cc_5907 ( N_noxref_17_c_7778_n N_noxref_19_c_9541_n ) capacitor c=0.00147119f \
 //x=66.84 //y=5.56 //x2=64.39 //y2=5.56
cc_5908 ( N_noxref_17_c_7808_p N_noxref_19_c_9318_n ) capacitor c=6.99317e-19 \
 //x=67.76 //y=1.18 //x2=64.43 //y2=1.18
cc_5909 ( N_noxref_17_c_7773_n N_noxref_19_c_9273_n ) capacitor c=0.0260189f \
 //x=68.2 //y=4.87 //x2=72.11 //y2=3.885
cc_5910 ( N_noxref_17_c_7774_n N_noxref_19_c_9273_n ) capacitor c=0.0274584f \
 //x=70.05 //y=4.755 //x2=72.11 //y2=3.885
cc_5911 ( N_noxref_17_c_7778_n N_noxref_19_c_9273_n ) capacitor c=0.0135317f \
 //x=66.84 //y=5.56 //x2=72.11 //y2=3.885
cc_5912 ( N_noxref_17_c_7849_p N_noxref_19_c_9273_n ) capacitor c=0.00455063f \
 //x=69.88 //y=5.005 //x2=72.11 //y2=3.885
cc_5913 ( N_noxref_17_c_7773_n N_noxref_20_c_9843_n ) capacitor c=0.0845748f \
 //x=68.2 //y=4.87 //x2=67.46 //y2=4.48
cc_5914 ( N_noxref_17_c_7774_n N_noxref_20_c_9843_n ) capacitor c=0.00316738f \
 //x=70.05 //y=4.755 //x2=67.46 //y2=4.48
cc_5915 ( N_noxref_17_M137_noxref_g N_noxref_20_c_9959_n ) capacitor \
 c=0.00893512f //x=70.69 //y=6.2 //x2=71.23 //y2=5.335
cc_5916 ( N_noxref_17_c_7853_p N_noxref_20_c_9960_n ) capacitor c=8.09327e-19 \
 //x=68.115 //y=1.835 //x2=72.525 //y2=1.76
cc_5917 ( N_noxref_17_c_7773_n N_noxref_20_c_9845_n ) capacitor c=8.09327e-19 \
 //x=68.2 //y=4.87 //x2=72.61 //y2=1.845
cc_5918 ( N_noxref_17_c_7797_p N_noxref_20_c_9849_n ) capacitor c=9.33758e-19 \
 //x=70.05 //y=4.88 //x2=73.01 //y2=5.25
cc_5919 ( N_noxref_17_c_7799_p N_noxref_20_c_9849_n ) capacitor c=2.45751e-19 \
 //x=70.05 //y=4.88 //x2=73.01 //y2=5.25
cc_5920 ( N_noxref_17_c_7773_n N_noxref_20_c_9922_n ) capacitor c=0.0138368f \
 //x=68.2 //y=4.87 //x2=67.46 //y2=2.26
cc_5921 ( N_noxref_17_c_7775_n N_noxref_20_c_9925_n ) capacitor c=0.0239872f \
 //x=67.605 //y=5.38 //x2=67.48 //y2=4.64
cc_5922 ( N_noxref_17_c_7773_n N_noxref_20_c_9925_n ) capacitor c=0.0190843f \
 //x=68.2 //y=4.87 //x2=67.48 //y2=4.64
cc_5923 ( N_noxref_17_c_7860_p N_noxref_20_c_9925_n ) capacitor c=0.00156965f \
 //x=67.72 //y=5.38 //x2=67.48 //y2=4.64
cc_5924 ( N_noxref_17_c_7861_p N_noxref_20_c_9925_n ) capacitor c=0.0010786f \
 //x=68.2 //y=4.99 //x2=67.48 //y2=4.64
cc_5925 ( N_noxref_17_c_7840_p N_noxref_20_c_9925_n ) capacitor c=0.00953582f \
 //x=68.275 //y=5.03 //x2=67.48 //y2=4.64
cc_5926 ( N_noxref_17_c_7863_p N_noxref_20_c_9925_n ) capacitor c=4.18782e-19 \
 //x=67.72 //y=5.56 //x2=67.48 //y2=4.64
cc_5927 ( N_noxref_17_c_7860_p N_noxref_20_c_9971_n ) capacitor c=5.0812e-19 \
 //x=67.72 //y=5.38 //x2=70.472 //y2=5.335
cc_5928 ( N_noxref_17_c_7840_p N_noxref_20_c_9971_n ) capacitor c=0.00280625f \
 //x=68.275 //y=5.03 //x2=70.472 //y2=5.335
cc_5929 ( N_noxref_17_M136_noxref_g N_noxref_20_c_9971_n ) capacitor \
 c=0.00461408f //x=70.25 //y=6.2 //x2=70.472 //y2=5.335
cc_5930 ( N_noxref_17_M137_noxref_g N_noxref_20_c_9971_n ) capacitor \
 c=0.00229208f //x=70.69 //y=6.2 //x2=70.472 //y2=5.335
cc_5931 ( N_noxref_17_c_7800_p N_noxref_20_c_9971_n ) capacitor c=0.00171885f \
 //x=70.615 //y=4.97 //x2=70.472 //y2=5.335
cc_5932 ( N_noxref_17_c_7775_n N_noxref_20_c_9929_n ) capacitor c=0.00120028f \
 //x=67.605 //y=5.38 //x2=67.64 //y2=4.64
cc_5933 ( N_noxref_17_c_7773_n N_noxref_20_c_9929_n ) capacitor c=0.00334007f \
 //x=68.2 //y=4.87 //x2=67.64 //y2=4.64
cc_5934 ( N_noxref_17_c_7860_p N_noxref_20_c_9929_n ) capacitor c=7.68782e-19 \
 //x=67.72 //y=5.38 //x2=67.64 //y2=4.64
cc_5935 ( N_noxref_17_c_7773_n N_noxref_20_c_9879_n ) capacitor c=0.0251527f \
 //x=68.2 //y=4.87 //x2=72.845 //y2=4.615
cc_5936 ( N_noxref_17_c_7774_n N_noxref_20_c_9879_n ) capacitor c=0.0268549f \
 //x=70.05 //y=4.755 //x2=72.845 //y2=4.615
cc_5937 ( N_noxref_17_c_7860_p N_noxref_20_c_9879_n ) capacitor c=0.0181079f \
 //x=67.72 //y=5.38 //x2=72.845 //y2=4.615
cc_5938 ( N_noxref_17_c_7840_p N_noxref_20_c_9879_n ) capacitor c=0.0134881f \
 //x=68.275 //y=5.03 //x2=72.845 //y2=4.615
cc_5939 ( N_noxref_17_c_7797_p N_noxref_20_c_9879_n ) capacitor c=0.00793095f \
 //x=70.05 //y=4.88 //x2=72.845 //y2=4.615
cc_5940 ( N_noxref_17_c_7877_p N_noxref_20_c_9879_n ) capacitor c=0.0344319f \
 //x=68.435 //y=5.03 //x2=72.845 //y2=4.615
cc_5941 ( N_noxref_17_c_7798_p N_noxref_20_c_9879_n ) capacitor c=0.0368222f \
 //x=70.04 //y=5.005 //x2=72.845 //y2=4.615
cc_5942 ( N_noxref_17_c_7849_p N_noxref_20_c_9879_n ) capacitor c=0.13542f \
 //x=69.88 //y=5.005 //x2=72.845 //y2=4.615
cc_5943 ( N_noxref_17_c_7773_n N_noxref_20_c_9931_n ) capacitor c=9.26054e-19 \
 //x=68.2 //y=4.87 //x2=67.46 //y2=2.26
cc_5944 ( N_noxref_17_c_7775_n N_noxref_20_c_9935_n ) capacitor c=0.00469232f \
 //x=67.605 //y=5.38 //x2=67.49 //y2=4.88
cc_5945 ( N_noxref_17_c_7773_n N_noxref_20_c_9935_n ) capacitor c=5.14671e-19 \
 //x=68.2 //y=4.87 //x2=67.49 //y2=4.88
cc_5946 ( N_noxref_17_c_7861_p N_noxref_20_c_9935_n ) capacitor c=0.00487735f \
 //x=68.2 //y=4.99 //x2=67.49 //y2=4.88
cc_5947 ( N_noxref_17_c_7840_p N_noxref_20_c_9935_n ) capacitor c=0.00171367f \
 //x=68.275 //y=5.03 //x2=67.49 //y2=4.88
cc_5948 ( N_noxref_17_M136_noxref_g N_noxref_20_c_9992_n ) capacitor \
 c=0.0162284f //x=70.25 //y=6.2 //x2=70.47 //y2=5.56
cc_5949 ( N_noxref_17_M137_noxref_g N_noxref_20_c_9992_n ) capacitor \
 c=0.0179041f //x=70.69 //y=6.2 //x2=70.47 //y2=5.56
cc_5950 ( N_noxref_17_c_7800_p N_noxref_20_c_9992_n ) capacitor c=0.00291477f \
 //x=70.615 //y=4.97 //x2=70.47 //y2=5.56
cc_5951 ( N_noxref_17_c_7775_n N_noxref_20_M134_noxref_g ) capacitor \
 c=0.00842858f //x=67.605 //y=5.38 //x2=67.5 //y2=6.2
cc_5952 ( N_noxref_17_c_7860_p N_noxref_20_M134_noxref_g ) capacitor \
 c=0.00192712f //x=67.72 //y=5.38 //x2=67.5 //y2=6.2
cc_5953 ( N_noxref_17_c_7863_p N_noxref_20_M134_noxref_g ) capacitor \
 c=0.0178987f //x=67.72 //y=5.56 //x2=67.5 //y2=6.2
cc_5954 ( N_noxref_17_c_7891_p N_noxref_20_M135_noxref_g ) capacitor \
 c=0.0106088f //x=68.115 //y=5.38 //x2=67.94 //y2=6.2
cc_5955 ( N_noxref_17_c_7860_p N_noxref_20_M135_noxref_g ) capacitor \
 c=0.00312463f //x=67.72 //y=5.38 //x2=67.94 //y2=6.2
cc_5956 ( N_noxref_17_c_7840_p N_noxref_20_M135_noxref_g ) capacitor \
 c=0.00352166f //x=68.275 //y=5.03 //x2=67.94 //y2=6.2
cc_5957 ( N_noxref_17_c_7863_p N_noxref_20_M135_noxref_g ) capacitor \
 c=0.0178506f //x=67.72 //y=5.56 //x2=67.94 //y2=6.2
cc_5958 ( N_noxref_17_c_7808_p N_noxref_20_c_9941_n ) capacitor c=0.00120406f \
 //x=67.76 //y=1.18 //x2=67.495 //y2=1.085
cc_5959 ( N_noxref_17_M41_noxref_d N_noxref_20_c_9941_n ) capacitor \
 c=0.00137165f //x=67.57 //y=1.085 //x2=67.495 //y2=1.085
cc_5960 ( N_noxref_17_c_7836_p N_noxref_20_c_9944_n ) capacitor c=0.00119008f \
 //x=67.76 //y=1.75 //x2=67.495 //y2=1.43
cc_5961 ( N_noxref_17_c_7808_p N_noxref_20_c_9944_n ) capacitor c=0.00218694f \
 //x=67.76 //y=1.18 //x2=67.495 //y2=1.43
cc_5962 ( N_noxref_17_M41_noxref_d N_noxref_20_c_9944_n ) capacitor \
 c=0.00237422f //x=67.57 //y=1.085 //x2=67.495 //y2=1.43
cc_5963 ( N_noxref_17_c_7836_p N_noxref_20_c_9946_n ) capacitor c=0.00438634f \
 //x=67.76 //y=1.75 //x2=67.495 //y2=1.74
cc_5964 ( N_noxref_17_c_7860_p N_noxref_20_c_10008_n ) capacitor c=0.0020909f \
 //x=67.72 //y=5.38 //x2=67.865 //y2=4.97
cc_5965 ( N_noxref_17_c_7861_p N_noxref_20_c_10008_n ) capacitor c=0.00839095f \
 //x=68.2 //y=4.99 //x2=67.865 //y2=4.97
cc_5966 ( N_noxref_17_c_7840_p N_noxref_20_c_10008_n ) capacitor c=0.00447191f \
 //x=68.275 //y=5.03 //x2=67.865 //y2=4.97
cc_5967 ( N_noxref_17_c_7863_p N_noxref_20_c_10008_n ) capacitor c=0.00291714f \
 //x=67.72 //y=5.56 //x2=67.865 //y2=4.97
cc_5968 ( N_noxref_17_c_7808_p N_noxref_20_c_10012_n ) capacitor c=5.50523e-19 \
 //x=67.76 //y=1.18 //x2=67.87 //y2=0.93
cc_5969 ( N_noxref_17_M41_noxref_d N_noxref_20_c_10012_n ) capacitor \
 c=0.0020782f //x=67.57 //y=1.085 //x2=67.87 //y2=0.93
cc_5970 ( N_noxref_17_c_7836_p N_noxref_20_c_10014_n ) capacitor c=0.00929259f \
 //x=67.76 //y=1.75 //x2=67.87 //y2=1.585
cc_5971 ( N_noxref_17_c_7853_p N_noxref_20_c_10014_n ) capacitor c=0.00194324f \
 //x=68.115 //y=1.835 //x2=67.87 //y2=1.585
cc_5972 ( N_noxref_17_c_7808_p N_noxref_20_c_10014_n ) capacitor c=5.67071e-19 \
 //x=67.76 //y=1.18 //x2=67.87 //y2=1.585
cc_5973 ( N_noxref_17_M41_noxref_d N_noxref_20_c_10014_n ) capacitor \
 c=0.00356097f //x=67.57 //y=1.085 //x2=67.87 //y2=1.585
cc_5974 ( N_noxref_17_c_7808_p N_noxref_20_c_9949_n ) capacitor c=0.00108157f \
 //x=67.76 //y=1.18 //x2=68.025 //y2=1.085
cc_5975 ( N_noxref_17_M41_noxref_d N_noxref_20_c_9949_n ) capacitor \
 c=8.50095e-19 //x=67.57 //y=1.085 //x2=68.025 //y2=1.085
cc_5976 ( N_noxref_17_c_7836_p N_noxref_20_c_9950_n ) capacitor c=0.00341295f \
 //x=67.76 //y=1.75 //x2=68.025 //y2=1.43
cc_5977 ( N_noxref_17_c_7853_p N_noxref_20_c_9950_n ) capacitor c=0.00323005f \
 //x=68.115 //y=1.835 //x2=68.025 //y2=1.43
cc_5978 ( N_noxref_17_c_7808_p N_noxref_20_c_9950_n ) capacitor c=0.00312028f \
 //x=67.76 //y=1.18 //x2=68.025 //y2=1.43
cc_5979 ( N_noxref_17_M41_noxref_d N_noxref_20_c_9950_n ) capacitor \
 c=0.00237422f //x=67.57 //y=1.085 //x2=68.025 //y2=1.43
cc_5980 ( N_noxref_17_c_7773_n N_noxref_20_c_9951_n ) capacitor c=0.00268898f \
 //x=68.2 //y=4.87 //x2=67.46 //y2=2.26
cc_5981 ( N_noxref_17_c_7836_p N_noxref_20_c_10025_n ) capacitor c=0.00341114f \
 //x=67.76 //y=1.75 //x2=67.46 //y2=2.095
cc_5982 ( N_noxref_17_c_7773_n N_noxref_20_c_10025_n ) capacitor c=0.00309058f \
 //x=68.2 //y=4.87 //x2=67.46 //y2=2.095
cc_5983 ( N_noxref_17_c_7775_n N_noxref_20_c_9954_n ) capacitor c=8.10229e-19 \
 //x=67.605 //y=5.38 //x2=67.49 //y2=4.88
cc_5984 ( N_noxref_17_c_7861_p N_noxref_20_c_9954_n ) capacitor c=0.0020182f \
 //x=68.2 //y=4.99 //x2=67.49 //y2=4.88
cc_5985 ( N_noxref_17_c_7840_p N_noxref_20_c_9954_n ) capacitor c=3.1708e-19 \
 //x=68.275 //y=5.03 //x2=67.49 //y2=4.88
cc_5986 ( N_noxref_17_c_7773_n N_noxref_21_c_10681_n ) capacitor c=0.0233621f \
 //x=68.2 //y=4.87 //x2=71.885 //y2=3.51
cc_5987 ( N_noxref_17_c_7774_n N_noxref_21_c_10681_n ) capacitor c=0.0248079f \
 //x=70.05 //y=4.755 //x2=71.885 //y2=3.51
cc_5988 ( N_noxref_17_c_7775_n N_VDD_c_11522_n ) capacitor c=0.00648293f \
 //x=67.605 //y=5.38 //x2=74.455 //y2=7.585
cc_5989 ( N_noxref_17_c_7891_p N_VDD_c_11522_n ) capacitor c=0.0047268f \
 //x=68.115 //y=5.38 //x2=74.455 //y2=7.585
cc_5990 ( N_noxref_17_c_7778_n N_VDD_c_11522_n ) capacitor c=0.00368834f \
 //x=66.84 //y=5.56 //x2=74.455 //y2=7.585
cc_5991 ( N_noxref_17_c_7860_p N_VDD_c_11522_n ) capacitor c=8.42537e-19 \
 //x=67.72 //y=5.38 //x2=74.455 //y2=7.585
cc_5992 ( N_noxref_17_c_7929_p N_VDD_c_11522_n ) capacitor c=0.00285853f \
 //x=67.72 //y=5.56 //x2=74.455 //y2=7.585
cc_5993 ( N_noxref_17_c_7861_p N_VDD_c_11522_n ) capacitor c=5.02492e-19 \
 //x=68.2 //y=4.99 //x2=74.455 //y2=7.585
cc_5994 ( N_noxref_17_c_7840_p N_VDD_c_11522_n ) capacitor c=4.82818e-19 \
 //x=68.275 //y=5.03 //x2=74.455 //y2=7.585
cc_5995 ( N_noxref_17_c_7797_p N_VDD_c_11522_n ) capacitor c=2.64197e-19 \
 //x=70.05 //y=4.88 //x2=74.455 //y2=7.585
cc_5996 ( N_noxref_17_c_7877_p N_VDD_c_11522_n ) capacitor c=0.00519637f \
 //x=68.435 //y=5.03 //x2=74.455 //y2=7.585
cc_5997 ( N_noxref_17_c_7798_p N_VDD_c_11522_n ) capacitor c=0.00360457f \
 //x=70.04 //y=5.005 //x2=74.455 //y2=7.585
cc_5998 ( N_noxref_17_c_7849_p N_VDD_c_11522_n ) capacitor c=0.0556597f \
 //x=69.88 //y=5.005 //x2=74.455 //y2=7.585
cc_5999 ( N_noxref_17_c_7785_n N_VDD_c_11522_n ) capacitor c=0.00224881f \
 //x=66.84 //y=5.56 //x2=74.455 //y2=7.585
cc_6000 ( N_noxref_17_c_7863_p N_VDD_c_11522_n ) capacitor c=0.00224881f \
 //x=67.72 //y=5.56 //x2=74.455 //y2=7.585
cc_6001 ( N_noxref_17_c_7775_n N_VDD_c_12427_n ) capacitor c=0.00208087f \
 //x=67.605 //y=5.38 //x2=67.195 //y2=7.585
cc_6002 ( N_noxref_17_c_7778_n N_VDD_c_12427_n ) capacitor c=9.41185e-19 \
 //x=66.84 //y=5.56 //x2=67.195 //y2=7.585
cc_6003 ( N_noxref_17_c_7785_n N_VDD_c_12427_n ) capacitor c=0.0136705f \
 //x=66.84 //y=5.56 //x2=67.195 //y2=7.585
cc_6004 ( N_noxref_17_c_7775_n N_VDD_c_12491_n ) capacitor c=0.00180737f \
 //x=67.605 //y=5.38 //x2=68.075 //y2=7.585
cc_6005 ( N_noxref_17_c_7891_p N_VDD_c_12491_n ) capacitor c=0.00208087f \
 //x=68.115 //y=5.38 //x2=68.075 //y2=7.585
cc_6006 ( N_noxref_17_c_7860_p N_VDD_c_12491_n ) capacitor c=4.23719e-19 \
 //x=67.72 //y=5.38 //x2=68.075 //y2=7.585
cc_6007 ( N_noxref_17_c_7929_p N_VDD_c_12491_n ) capacitor c=5.77976e-19 \
 //x=67.72 //y=5.56 //x2=68.075 //y2=7.585
cc_6008 ( N_noxref_17_c_7863_p N_VDD_c_12491_n ) capacitor c=0.0136705f \
 //x=67.72 //y=5.56 //x2=68.075 //y2=7.585
cc_6009 ( N_noxref_17_c_7840_p N_VDD_c_12496_n ) capacitor c=5.88033e-19 \
 //x=68.275 //y=5.03 //x2=68.77 //y2=7.585
cc_6010 ( N_noxref_17_M136_noxref_g N_VDD_c_12497_n ) capacitor c=0.00755614f \
 //x=70.25 //y=6.2 //x2=70.825 //y2=7.585
cc_6011 ( N_noxref_17_M137_noxref_g N_VDD_c_12497_n ) capacitor c=0.00755544f \
 //x=70.69 //y=6.2 //x2=70.825 //y2=7.585
cc_6012 ( N_noxref_17_c_7778_n N_VDD_c_12366_n ) capacitor c=4.91377e-19 \
 //x=66.84 //y=5.56 //x2=65.61 //y2=7.585
cc_6013 ( N_noxref_17_c_7861_p N_VDD_c_12366_n ) capacitor c=5.63829e-19 \
 //x=68.2 //y=4.99 //x2=65.61 //y2=7.585
cc_6014 ( N_noxref_17_c_7840_p N_VDD_c_12366_n ) capacitor c=0.0012012f \
 //x=68.275 //y=5.03 //x2=65.61 //y2=7.585
cc_6015 ( N_noxref_17_c_7785_n N_VDD_c_12366_n ) capacitor c=0.0064135f \
 //x=66.84 //y=5.56 //x2=65.61 //y2=7.585
cc_6016 ( N_noxref_17_c_7773_n N_VDD_c_12452_n ) capacitor c=0.0124512f \
 //x=68.2 //y=4.87 //x2=68.94 //y2=7.585
cc_6017 ( N_noxref_17_c_7774_n N_VDD_c_12452_n ) capacitor c=0.00764275f \
 //x=70.05 //y=4.755 //x2=68.94 //y2=7.585
cc_6018 ( N_noxref_17_c_7860_p N_VDD_c_12452_n ) capacitor c=0.0025639f \
 //x=67.72 //y=5.38 //x2=68.94 //y2=7.585
cc_6019 ( N_noxref_17_c_7929_p N_VDD_c_12452_n ) capacitor c=4.19141e-19 \
 //x=67.72 //y=5.56 //x2=68.94 //y2=7.585
cc_6020 ( N_noxref_17_c_7861_p N_VDD_c_12452_n ) capacitor c=0.0116293f \
 //x=68.2 //y=4.99 //x2=68.94 //y2=7.585
cc_6021 ( N_noxref_17_c_7840_p N_VDD_c_12452_n ) capacitor c=0.014033f \
 //x=68.275 //y=5.03 //x2=68.94 //y2=7.585
cc_6022 ( N_noxref_17_c_7797_p N_VDD_c_12452_n ) capacitor c=0.00523837f \
 //x=70.05 //y=4.88 //x2=68.94 //y2=7.585
cc_6023 ( N_noxref_17_c_7849_p N_VDD_c_12452_n ) capacitor c=0.0210463f \
 //x=69.88 //y=5.005 //x2=68.94 //y2=7.585
cc_6024 ( N_noxref_17_c_7863_p N_VDD_c_12452_n ) capacitor c=0.0101861f \
 //x=67.72 //y=5.56 //x2=68.94 //y2=7.585
cc_6025 ( N_noxref_17_c_7799_p N_VDD_c_12452_n ) capacitor c=0.00378489f \
 //x=70.05 //y=4.88 //x2=68.94 //y2=7.585
cc_6026 ( N_noxref_17_c_7801_p N_VDD_c_12452_n ) capacitor c=0.00408882f \
 //x=70.325 //y=4.97 //x2=68.94 //y2=7.585
cc_6027 ( N_noxref_17_c_7778_n N_VDD_M132_noxref_s ) capacitor c=0.0572211f \
 //x=66.84 //y=5.56 //x2=66.265 //y2=5.2
cc_6028 ( N_noxref_17_c_7860_p N_VDD_M132_noxref_s ) capacitor c=6.52457e-19 \
 //x=67.72 //y=5.38 //x2=66.265 //y2=5.2
cc_6029 ( N_noxref_17_c_7785_n N_VDD_M132_noxref_s ) capacitor c=0.0887533f \
 //x=66.84 //y=5.56 //x2=66.265 //y2=5.2
cc_6030 ( N_noxref_17_c_7775_n N_VDD_M133_noxref_d ) capacitor c=0.00734094f \
 //x=67.605 //y=5.38 //x2=67.135 //y2=5.2
cc_6031 ( N_noxref_17_c_7778_n N_VDD_M133_noxref_d ) capacitor c=0.0043528f \
 //x=66.84 //y=5.56 //x2=67.135 //y2=5.2
cc_6032 ( N_noxref_17_c_7929_p N_VDD_M133_noxref_d ) capacitor c=0.0043528f \
 //x=67.72 //y=5.56 //x2=67.135 //y2=5.2
cc_6033 ( N_noxref_17_c_7785_n N_VDD_M133_noxref_d ) capacitor c=0.065554f \
 //x=66.84 //y=5.56 //x2=67.135 //y2=5.2
cc_6034 ( N_noxref_17_c_7863_p N_VDD_M133_noxref_d ) capacitor c=0.065554f \
 //x=67.72 //y=5.56 //x2=67.135 //y2=5.2
cc_6035 ( N_noxref_17_c_7891_p N_VDD_M135_noxref_d ) capacitor c=0.00719762f \
 //x=68.115 //y=5.38 //x2=68.015 //y2=5.2
cc_6036 ( N_noxref_17_c_7929_p N_VDD_M135_noxref_d ) capacitor c=0.00955781f \
 //x=67.72 //y=5.56 //x2=68.015 //y2=5.2
cc_6037 ( N_noxref_17_c_7861_p N_VDD_M135_noxref_d ) capacitor c=0.00467245f \
 //x=68.2 //y=4.99 //x2=68.015 //y2=5.2
cc_6038 ( N_noxref_17_c_7863_p N_VDD_M135_noxref_d ) capacitor c=0.065554f \
 //x=67.72 //y=5.56 //x2=68.015 //y2=5.2
cc_6039 ( N_noxref_17_c_7860_p N_VDD_M136_noxref_s ) capacitor c=0.00371125f \
 //x=67.72 //y=5.38 //x2=69.895 //y2=5.2
cc_6040 ( N_noxref_17_c_7929_p N_VDD_M136_noxref_s ) capacitor c=9.52042e-19 \
 //x=67.72 //y=5.56 //x2=69.895 //y2=5.2
cc_6041 ( N_noxref_17_c_7840_p N_VDD_M136_noxref_s ) capacitor c=0.00220019f \
 //x=68.275 //y=5.03 //x2=69.895 //y2=5.2
cc_6042 ( N_noxref_17_c_7797_p N_VDD_M136_noxref_s ) capacitor c=0.0271647f \
 //x=70.05 //y=4.88 //x2=69.895 //y2=5.2
cc_6043 ( N_noxref_17_c_7798_p N_VDD_M136_noxref_s ) capacitor c=0.00768878f \
 //x=70.04 //y=5.005 //x2=69.895 //y2=5.2
cc_6044 ( N_noxref_17_c_7799_p N_VDD_M136_noxref_s ) capacitor c=0.00946856f \
 //x=70.05 //y=4.88 //x2=69.895 //y2=5.2
cc_6045 ( N_noxref_17_M136_noxref_g N_VDD_M136_noxref_s ) capacitor \
 c=0.053419f //x=70.25 //y=6.2 //x2=69.895 //y2=5.2
cc_6046 ( N_noxref_17_c_7801_p N_VDD_M136_noxref_s ) capacitor c=0.0031049f \
 //x=70.325 //y=4.97 //x2=69.895 //y2=5.2
cc_6047 ( N_noxref_17_M137_noxref_g N_VDD_M137_noxref_d ) capacitor \
 c=0.015318f //x=70.69 //y=6.2 //x2=70.765 //y2=5.2
cc_6048 ( N_noxref_17_c_7808_p N_noxref_32_M43_noxref_d ) capacitor \
 c=3.39394e-19 //x=67.76 //y=1.18 //x2=70.8 //y2=1.09
cc_6049 ( N_noxref_17_c_7853_p N_GND_c_14611_n ) capacitor c=0.00608539f \
 //x=68.115 //y=1.835 //x2=69.93 //y2=0.175
cc_6050 ( N_noxref_17_c_7808_p N_GND_c_14611_n ) capacitor c=0.00928865f \
 //x=67.76 //y=1.18 //x2=69.93 //y2=0.175
cc_6051 ( N_noxref_17_M41_noxref_d N_GND_c_14611_n ) capacitor c=3.01769e-19 \
 //x=67.57 //y=1.085 //x2=69.93 //y2=0.175
cc_6052 ( N_noxref_17_c_7821_p N_GND_c_14614_n ) capacitor c=3.92414e-19 \
 //x=69.75 //y=1.055 //x2=70.015 //y2=1.015
cc_6053 ( N_noxref_17_c_7990_p N_GND_c_14614_n ) capacitor c=0.0085115f \
 //x=70.125 //y=0.9 //x2=70.015 //y2=1.015
cc_6054 ( N_noxref_17_c_7823_p N_GND_c_14614_n ) capacitor c=4.45447e-19 \
 //x=70.28 //y=1.055 //x2=70.015 //y2=1.015
cc_6055 ( N_noxref_17_c_7778_n N_GND_c_14579_n ) capacitor c=6.93965e-19 \
 //x=66.84 //y=5.56 //x2=66.79 //y2=1.135
cc_6056 ( N_noxref_17_c_7808_p N_GND_c_14579_n ) capacitor c=0.0140087f \
 //x=67.76 //y=1.18 //x2=66.79 //y2=1.135
cc_6057 ( N_noxref_17_M41_noxref_d N_GND_c_14579_n ) capacitor c=2.93544e-19 \
 //x=67.57 //y=1.085 //x2=66.79 //y2=1.135
cc_6058 ( N_noxref_17_c_7791_p N_GND_c_14620_n ) capacitor c=0.00773152f \
 //x=70.05 //y=2.375 //x2=70.015 //y2=1.145
cc_6059 ( N_noxref_17_c_7808_p N_GND_c_14620_n ) capacitor c=0.00606355f \
 //x=67.76 //y=1.18 //x2=70.015 //y2=1.145
cc_6060 ( N_noxref_17_c_7797_p N_GND_c_14620_n ) capacitor c=4.75564e-19 \
 //x=70.05 //y=4.88 //x2=70.015 //y2=1.145
cc_6061 ( N_noxref_17_c_7793_p N_GND_c_14620_n ) capacitor c=2.22883e-19 \
 //x=70.05 //y=2.26 //x2=70.015 //y2=1.145
cc_6062 ( N_noxref_17_c_7821_p N_GND_c_14620_n ) capacitor c=0.0015128f \
 //x=69.75 //y=1.055 //x2=70.015 //y2=1.145
cc_6063 ( N_noxref_17_c_7822_p N_GND_c_14620_n ) capacitor c=0.00350108f \
 //x=69.75 //y=1.4 //x2=70.015 //y2=1.145
cc_6064 ( N_noxref_17_c_7824_p N_GND_c_14620_n ) capacitor c=4.6605e-19 \
 //x=69.75 //y=1.71 //x2=70.015 //y2=1.145
cc_6065 ( N_noxref_17_c_7990_p N_GND_c_14620_n ) capacitor c=9.36995e-19 \
 //x=70.125 //y=0.9 //x2=70.015 //y2=1.145
cc_6066 ( N_noxref_17_c_8003_p N_GND_c_14620_n ) capacitor c=6.2753e-19 \
 //x=70.125 //y=1.555 //x2=70.015 //y2=1.145
cc_6067 ( N_noxref_17_c_7823_p N_GND_c_14620_n ) capacitor c=0.0017438f \
 //x=70.28 //y=1.055 //x2=70.015 //y2=1.145
cc_6068 ( N_noxref_17_c_7825_p N_GND_c_14620_n ) capacitor c=0.00276804f \
 //x=70.28 //y=1.4 //x2=70.015 //y2=1.145
cc_6069 ( N_noxref_17_c_7853_p N_GND_c_14593_n ) capacitor c=7.77585e-19 \
 //x=68.115 //y=1.835 //x2=68.77 //y2=0.175
cc_6070 ( N_noxref_17_c_7821_p N_GND_c_14632_n ) capacitor c=0.00677766f \
 //x=69.75 //y=1.055 //x2=73.58 //y2=0.175
cc_6071 ( N_noxref_17_c_7773_n N_GND_c_14335_n ) capacitor c=9.32616e-19 \
 //x=68.2 //y=4.87 //x2=65.61 //y2=0.175
cc_6072 ( N_noxref_17_c_7836_p N_GND_c_14336_n ) capacitor c=0.00460657f \
 //x=67.76 //y=1.75 //x2=68.94 //y2=0.175
cc_6073 ( N_noxref_17_c_7853_p N_GND_c_14336_n ) capacitor c=0.0300371f \
 //x=68.115 //y=1.835 //x2=68.94 //y2=0.175
cc_6074 ( N_noxref_17_c_7791_p N_GND_c_14336_n ) capacitor c=0.00361632f \
 //x=70.05 //y=2.375 //x2=68.94 //y2=0.175
cc_6075 ( N_noxref_17_c_7774_n N_GND_c_14336_n ) capacitor c=0.0107391f \
 //x=70.05 //y=4.755 //x2=68.94 //y2=0.175
cc_6076 ( N_noxref_17_c_7793_p N_GND_c_14336_n ) capacitor c=0.00379568f \
 //x=70.05 //y=2.26 //x2=68.94 //y2=0.175
cc_6077 ( N_noxref_17_c_7824_p N_GND_c_14336_n ) capacitor c=0.00170145f \
 //x=69.75 //y=1.71 //x2=68.94 //y2=0.175
cc_6078 ( N_noxref_17_c_7794_p N_GND_c_14336_n ) capacitor c=0.0102191f \
 //x=69.75 //y=2.095 //x2=68.94 //y2=0.175
cc_6079 ( N_noxref_17_c_7808_p N_GND_M40_noxref_d ) capacitor c=2.82748e-19 \
 //x=67.76 //y=1.18 //x2=66.6 //y2=1.045
cc_6080 ( N_noxref_17_c_7791_p N_GND_M42_noxref_d ) capacitor c=4.44315e-19 \
 //x=70.05 //y=2.375 //x2=69.825 //y2=1.055
cc_6081 ( N_noxref_17_c_7821_p N_GND_M42_noxref_d ) capacitor c=0.00184354f \
 //x=69.75 //y=1.055 //x2=69.825 //y2=1.055
cc_6082 ( N_noxref_17_c_7822_p N_GND_M42_noxref_d ) capacitor c=0.00210798f \
 //x=69.75 //y=1.4 //x2=69.825 //y2=1.055
cc_6083 ( N_noxref_17_c_7990_p N_GND_M42_noxref_d ) capacitor c=0.00474029f \
 //x=70.125 //y=0.9 //x2=69.825 //y2=1.055
cc_6084 ( N_noxref_17_c_8003_p N_GND_M42_noxref_d ) capacitor c=0.00166857f \
 //x=70.125 //y=1.555 //x2=69.825 //y2=1.055
cc_6085 ( N_noxref_17_c_7823_p N_GND_M42_noxref_d ) capacitor c=0.00230174f \
 //x=70.28 //y=1.055 //x2=69.825 //y2=1.055
cc_6086 ( N_noxref_17_c_7825_p N_GND_M42_noxref_d ) capacitor c=0.00210798f \
 //x=70.28 //y=1.4 //x2=69.825 //y2=1.055
cc_6087 ( N_noxref_17_c_7804_p N_noxref_53_c_16612_n ) capacitor c=0.00911498f \
 //x=67.845 //y=1.835 //x2=67.275 //y2=1.675
cc_6088 ( N_noxref_17_c_7853_p N_noxref_53_c_16617_n ) capacitor c=0.00399245f \
 //x=68.115 //y=1.835 //x2=68.16 //y2=0.71
cc_6089 ( N_noxref_17_c_7808_p N_noxref_53_c_16617_n ) capacitor c=0.003751f \
 //x=67.76 //y=1.18 //x2=68.16 //y2=0.71
cc_6090 ( N_noxref_17_M41_noxref_d N_noxref_53_c_16617_n ) capacitor \
 c=0.00910163f //x=67.57 //y=1.085 //x2=68.16 //y2=0.71
cc_6091 ( N_noxref_17_c_7836_p N_noxref_53_M40_noxref_s ) capacitor \
 c=0.0175047f //x=67.76 //y=1.75 //x2=66.17 //y2=0.545
cc_6092 ( N_noxref_17_c_7853_p N_noxref_53_M40_noxref_s ) capacitor \
 c=0.00722228f //x=68.115 //y=1.835 //x2=66.17 //y2=0.545
cc_6093 ( N_noxref_17_c_7808_p N_noxref_53_M40_noxref_s ) capacitor \
 c=0.00894261f //x=67.76 //y=1.18 //x2=66.17 //y2=0.545
cc_6094 ( N_noxref_17_c_7861_p N_noxref_53_M40_noxref_s ) capacitor \
 c=5.93513e-19 //x=68.2 //y=4.99 //x2=66.17 //y2=0.545
cc_6095 ( N_noxref_17_M41_noxref_d N_noxref_53_M40_noxref_s ) capacitor \
 c=0.0275552f //x=67.57 //y=1.085 //x2=66.17 //y2=0.545
cc_6096 ( N_noxref_17_c_7794_p N_noxref_54_c_16672_n ) capacitor c=0.00262672f \
 //x=69.75 //y=2.095 //x2=69.53 //y2=1.685
cc_6097 ( N_noxref_17_c_7791_p N_noxref_54_c_16673_n ) capacitor c=0.00419199f \
 //x=70.05 //y=2.375 //x2=70.415 //y2=1.77
cc_6098 ( N_noxref_17_c_7797_p N_noxref_54_c_16673_n ) capacitor c=5.98322e-19 \
 //x=70.05 //y=4.88 //x2=70.415 //y2=1.77
cc_6099 ( N_noxref_17_c_7793_p N_noxref_54_c_16673_n ) capacitor c=0.0104666f \
 //x=70.05 //y=2.26 //x2=70.415 //y2=1.77
cc_6100 ( N_noxref_17_c_7824_p N_noxref_54_c_16673_n ) capacitor c=0.00705077f \
 //x=69.75 //y=1.71 //x2=70.415 //y2=1.77
cc_6101 ( N_noxref_17_c_7794_p N_noxref_54_c_16673_n ) capacitor c=0.020708f \
 //x=69.75 //y=2.095 //x2=70.415 //y2=1.77
cc_6102 ( N_noxref_17_c_8003_p N_noxref_54_c_16673_n ) capacitor c=0.00588627f \
 //x=70.125 //y=1.555 //x2=70.415 //y2=1.77
cc_6103 ( N_noxref_17_c_7825_p N_noxref_54_c_16673_n ) capacitor c=0.00698822f \
 //x=70.28 //y=1.4 //x2=70.415 //y2=1.77
cc_6104 ( N_noxref_17_c_7821_p N_noxref_54_M42_noxref_s ) capacitor \
 c=0.0295256f //x=69.75 //y=1.055 //x2=69.395 //y2=0.555
cc_6105 ( N_noxref_17_c_7824_p N_noxref_54_M42_noxref_s ) capacitor \
 c=7.99997e-19 //x=69.75 //y=1.71 //x2=69.395 //y2=0.555
cc_6106 ( N_noxref_17_c_7794_p N_noxref_54_M42_noxref_s ) capacitor \
 c=0.00122123f //x=69.75 //y=2.095 //x2=69.395 //y2=0.555
cc_6107 ( N_noxref_17_c_7823_p N_noxref_54_M42_noxref_s ) capacitor \
 c=0.0125924f //x=70.28 //y=1.055 //x2=69.395 //y2=0.555
cc_6108 ( N_SN_c_8516_n N_noxref_19_c_9362_n ) capacitor c=0.0160589f \
 //x=58.195 //y=2.4 //x2=55.99 //y2=2.375
cc_6109 ( N_SN_c_8516_n N_noxref_19_c_9261_n ) capacitor c=0.0129637f \
 //x=58.195 //y=2.4 //x2=55.99 //y2=3.705
cc_6110 ( N_SN_c_8500_n N_noxref_19_c_9285_n ) capacitor c=0.00790562f \
 //x=59.69 //y=2.55 //x2=60.8 //y2=2.375
cc_6111 ( N_SN_c_8518_n N_noxref_19_c_9285_n ) capacitor c=0.00195485f \
 //x=59.85 //y=2.4 //x2=60.8 //y2=2.375
cc_6112 ( N_SN_c_8521_n N_noxref_19_c_9285_n ) capacitor c=0.0160193f \
 //x=70.99 //y=2.39 //x2=60.8 //y2=2.375
cc_6113 ( N_SN_c_8623_n N_noxref_19_c_9285_n ) capacitor c=5.39999e-19 \
 //x=59.69 //y=2.26 //x2=60.8 //y2=2.375
cc_6114 ( N_SN_c_8641_n N_noxref_19_c_9285_n ) capacitor c=6.5732e-19 \
 //x=59.78 //y=2.095 //x2=60.8 //y2=2.375
cc_6115 ( SN N_noxref_19_c_9262_n ) capacitor c=0.0285304f //x=59.69 //y=2.77 \
 //x2=60.8 //y2=3.705
cc_6116 ( N_SN_c_8500_n N_noxref_19_c_9262_n ) capacitor c=0.00339731f \
 //x=59.69 //y=2.55 //x2=60.8 //y2=3.705
cc_6117 ( N_SN_c_8518_n N_noxref_19_c_9262_n ) capacitor c=0.00105069f \
 //x=59.85 //y=2.4 //x2=60.8 //y2=3.705
cc_6118 ( N_SN_c_8521_n N_noxref_19_c_9262_n ) capacitor c=0.0155071f \
 //x=70.99 //y=2.39 //x2=60.8 //y2=3.705
cc_6119 ( SN N_noxref_19_c_9293_n ) capacitor c=0.0078001f //x=59.69 //y=2.77 \
 //x2=60.8 //y2=4.025
cc_6120 ( SN N_noxref_19_c_9283_n ) capacitor c=0.0158815f //x=59.69 //y=2.77 \
 //x2=60.8 //y2=4.75
cc_6121 ( N_SN_c_8591_n N_noxref_19_c_9283_n ) capacitor c=0.0107551f \
 //x=59.69 //y=4.765 //x2=60.8 //y2=4.75
cc_6122 ( N_SN_c_8626_n N_noxref_19_c_9283_n ) capacitor c=9.52396e-19 \
 //x=59.69 //y=4.88 //x2=60.8 //y2=4.75
cc_6123 ( N_SN_c_8644_n N_noxref_19_c_9283_n ) capacitor c=8.42568e-19 \
 //x=59.69 //y=4.88 //x2=60.8 //y2=4.75
cc_6124 ( N_SN_c_8521_n N_noxref_19_c_9303_n ) capacitor c=0.0192658f \
 //x=70.99 //y=2.39 //x2=64.515 //y2=1.835
cc_6125 ( N_SN_c_8521_n N_noxref_19_c_9263_n ) capacitor c=0.0307839f \
 //x=70.99 //y=2.39 //x2=64.87 //y2=3.705
cc_6126 ( N_SN_c_8501_n N_noxref_19_c_9264_n ) capacitor c=0.00829422f \
 //x=71.16 //y=2.55 //x2=72.27 //y2=2.375
cc_6127 ( N_SN_c_8520_n N_noxref_19_c_9264_n ) capacitor c=0.00330689f \
 //x=71.15 //y=2.39 //x2=72.27 //y2=2.375
cc_6128 ( N_SN_c_8737_n N_noxref_19_c_9264_n ) capacitor c=5.39999e-19 \
 //x=71.16 //y=2.26 //x2=72.27 //y2=2.375
cc_6129 ( N_SN_c_8756_n N_noxref_19_c_9264_n ) capacitor c=6.57457e-19 \
 //x=71.25 //y=2.095 //x2=72.27 //y2=2.375
cc_6130 ( N_SN_c_8501_n N_noxref_19_c_9265_n ) capacitor c=0.00391297f \
 //x=71.16 //y=2.55 //x2=72.27 //y2=3.725
cc_6131 ( N_SN_c_8502_n N_noxref_19_c_9265_n ) capacitor c=0.029972f //x=71.16 \
 //y=4.765 //x2=72.27 //y2=3.725
cc_6132 ( N_SN_c_8520_n N_noxref_19_c_9265_n ) capacitor c=0.00307154f \
 //x=71.15 //y=2.39 //x2=72.27 //y2=3.725
cc_6133 ( N_SN_c_8502_n N_noxref_19_c_9572_n ) capacitor c=0.00772613f \
 //x=71.16 //y=4.765 //x2=72.27 //y2=4.045
cc_6134 ( N_SN_c_8502_n N_noxref_19_c_9539_n ) capacitor c=0.0288282f \
 //x=71.16 //y=4.765 //x2=72.27 //y2=4.75
cc_6135 ( N_SN_c_8740_n N_noxref_19_c_9539_n ) capacitor c=9.52396e-19 \
 //x=71.16 //y=4.88 //x2=72.27 //y2=4.75
cc_6136 ( N_SN_c_8759_n N_noxref_19_c_9539_n ) capacitor c=8.42568e-19 \
 //x=71.16 //y=4.88 //x2=72.27 //y2=4.75
cc_6137 ( SN N_noxref_19_c_9309_n ) capacitor c=5.01652e-19 //x=59.69 //y=2.77 \
 //x2=60.8 //y2=3.88
cc_6138 ( N_SN_c_8521_n N_noxref_19_c_9318_n ) capacitor c=7.29202e-19 \
 //x=70.99 //y=2.39 //x2=64.43 //y2=1.18
cc_6139 ( N_SN_c_8502_n N_noxref_19_c_9578_n ) capacitor c=3.43503e-19 \
 //x=71.16 //y=4.765 //x2=72.27 //y2=3.88
cc_6140 ( SN N_noxref_19_c_9267_n ) capacitor c=0.0254062f //x=59.69 //y=2.77 \
 //x2=60.96 //y2=3.88
cc_6141 ( N_SN_c_8502_n N_noxref_19_c_9580_n ) capacitor c=0.00242466f \
 //x=71.16 //y=4.765 //x2=72.27 //y2=3.885
cc_6142 ( N_SN_c_8502_n N_noxref_19_c_9273_n ) capacitor c=0.0255807f \
 //x=71.16 //y=4.765 //x2=72.11 //y2=3.885
cc_6143 ( N_SN_c_8516_n N_noxref_19_c_9419_n ) capacitor c=2.63835e-19 \
 //x=58.195 //y=2.4 //x2=55.99 //y2=2.26
cc_6144 ( N_SN_c_8500_n N_noxref_19_c_9322_n ) capacitor c=0.00116634f \
 //x=59.69 //y=2.55 //x2=60.8 //y2=2.26
cc_6145 ( N_SN_c_8623_n N_noxref_19_c_9322_n ) capacitor c=0.00124907f \
 //x=59.69 //y=2.26 //x2=60.8 //y2=2.26
cc_6146 ( N_SN_c_8641_n N_noxref_19_c_9322_n ) capacitor c=0.00177608f \
 //x=59.78 //y=2.095 //x2=60.8 //y2=2.26
cc_6147 ( SN N_noxref_19_c_9323_n ) capacitor c=2.94497e-19 //x=59.69 //y=2.77 \
 //x2=60.8 //y2=4.88
cc_6148 ( N_SN_c_8591_n N_noxref_19_c_9323_n ) capacitor c=4.56604e-19 \
 //x=59.69 //y=4.765 //x2=60.8 //y2=4.88
cc_6149 ( N_SN_c_8626_n N_noxref_19_c_9323_n ) capacitor c=0.00113985f \
 //x=59.69 //y=4.88 //x2=60.8 //y2=4.88
cc_6150 ( N_SN_c_8644_n N_noxref_19_c_9323_n ) capacitor c=0.00129812f \
 //x=59.69 //y=4.88 //x2=60.8 //y2=4.88
cc_6151 ( N_SN_c_8501_n N_noxref_19_c_9590_n ) capacitor c=0.00115817f \
 //x=71.16 //y=2.55 //x2=72.27 //y2=2.26
cc_6152 ( N_SN_c_8737_n N_noxref_19_c_9590_n ) capacitor c=0.0012491f \
 //x=71.16 //y=2.26 //x2=72.27 //y2=2.26
cc_6153 ( N_SN_c_8756_n N_noxref_19_c_9590_n ) capacitor c=0.00177608f \
 //x=71.25 //y=2.095 //x2=72.27 //y2=2.26
cc_6154 ( N_SN_c_8502_n N_noxref_19_c_9593_n ) capacitor c=7.51101e-19 \
 //x=71.16 //y=4.765 //x2=72.27 //y2=4.88
cc_6155 ( N_SN_c_8740_n N_noxref_19_c_9593_n ) capacitor c=0.00113985f \
 //x=71.16 //y=4.88 //x2=72.27 //y2=4.88
cc_6156 ( N_SN_c_8759_n N_noxref_19_c_9593_n ) capacitor c=0.00129812f \
 //x=71.16 //y=4.88 //x2=72.27 //y2=4.88
cc_6157 ( N_SN_M124_noxref_g N_noxref_19_M126_noxref_g ) capacitor \
 c=0.0101598f //x=59.66 //y=6.2 //x2=60.54 //y2=6.2
cc_6158 ( N_SN_M125_noxref_g N_noxref_19_M126_noxref_g ) capacitor \
 c=0.0607518f //x=60.1 //y=6.2 //x2=60.54 //y2=6.2
cc_6159 ( N_SN_M125_noxref_g N_noxref_19_M127_noxref_g ) capacitor \
 c=0.0101598f //x=60.1 //y=6.2 //x2=60.98 //y2=6.2
cc_6160 ( N_SN_M138_noxref_g N_noxref_19_M140_noxref_g ) capacitor \
 c=0.0101598f //x=71.13 //y=6.2 //x2=72.01 //y2=6.2
cc_6161 ( N_SN_M139_noxref_g N_noxref_19_M140_noxref_g ) capacitor \
 c=0.0607518f //x=71.57 //y=6.2 //x2=72.01 //y2=6.2
cc_6162 ( N_SN_M139_noxref_g N_noxref_19_M141_noxref_g ) capacitor \
 c=0.0101598f //x=71.57 //y=6.2 //x2=72.45 //y2=6.2
cc_6163 ( N_SN_c_8638_n N_noxref_19_c_9338_n ) capacitor c=0.00456962f \
 //x=59.78 //y=1.09 //x2=60.79 //y2=1.095
cc_6164 ( N_SN_c_8639_n N_noxref_19_c_9340_n ) capacitor c=0.00438372f \
 //x=59.78 //y=1.4 //x2=60.79 //y2=1.44
cc_6165 ( N_SN_c_8640_n N_noxref_19_c_9343_n ) capacitor c=0.00438372f \
 //x=59.78 //y=1.63 //x2=60.79 //y2=1.75
cc_6166 ( N_SN_c_8753_n N_noxref_19_c_9605_n ) capacitor c=0.00456962f \
 //x=71.25 //y=1.09 //x2=72.26 //y2=1.095
cc_6167 ( N_SN_c_8754_n N_noxref_19_c_9606_n ) capacitor c=0.00438372f \
 //x=71.25 //y=1.4 //x2=72.26 //y2=1.44
cc_6168 ( N_SN_c_8755_n N_noxref_19_c_9607_n ) capacitor c=0.00438372f \
 //x=71.25 //y=1.63 //x2=72.26 //y2=1.75
cc_6169 ( N_SN_c_8516_n N_noxref_19_c_9436_n ) capacitor c=3.41298e-19 \
 //x=58.195 //y=2.4 //x2=55.99 //y2=2.26
cc_6170 ( N_SN_c_8500_n N_noxref_19_c_9356_n ) capacitor c=0.00149114f \
 //x=59.69 //y=2.55 //x2=60.8 //y2=2.26
cc_6171 ( N_SN_c_8521_n N_noxref_19_c_9356_n ) capacitor c=3.41298e-19 \
 //x=70.99 //y=2.39 //x2=60.8 //y2=2.26
cc_6172 ( N_SN_c_8623_n N_noxref_19_c_9356_n ) capacitor c=0.00204796f \
 //x=59.69 //y=2.26 //x2=60.8 //y2=2.26
cc_6173 ( N_SN_c_8641_n N_noxref_19_c_9356_n ) capacitor c=0.00873247f \
 //x=59.78 //y=2.095 //x2=60.8 //y2=2.26
cc_6174 ( N_SN_c_8641_n N_noxref_19_c_9357_n ) capacitor c=0.00438372f \
 //x=59.78 //y=2.095 //x2=60.8 //y2=2.095
cc_6175 ( N_SN_c_8591_n N_noxref_19_c_9359_n ) capacitor c=0.00124604f \
 //x=59.69 //y=4.765 //x2=60.8 //y2=4.88
cc_6176 ( N_SN_c_8626_n N_noxref_19_c_9359_n ) capacitor c=0.00187046f \
 //x=59.69 //y=4.88 //x2=60.8 //y2=4.88
cc_6177 ( N_SN_c_8674_n N_noxref_19_c_9359_n ) capacitor c=0.0616777f \
 //x=60.025 //y=4.97 //x2=60.8 //y2=4.88
cc_6178 ( N_SN_c_8644_n N_noxref_19_c_9359_n ) capacitor c=0.00487508f \
 //x=59.69 //y=4.88 //x2=60.8 //y2=4.88
cc_6179 ( N_SN_c_8501_n N_noxref_19_c_9618_n ) capacitor c=0.00148267f \
 //x=71.16 //y=2.55 //x2=72.27 //y2=2.26
cc_6180 ( N_SN_c_8737_n N_noxref_19_c_9618_n ) capacitor c=0.00204796f \
 //x=71.16 //y=2.26 //x2=72.27 //y2=2.26
cc_6181 ( N_SN_c_8756_n N_noxref_19_c_9618_n ) capacitor c=0.00873247f \
 //x=71.25 //y=2.095 //x2=72.27 //y2=2.26
cc_6182 ( N_SN_c_8756_n N_noxref_19_c_9621_n ) capacitor c=0.00438372f \
 //x=71.25 //y=2.095 //x2=72.27 //y2=2.095
cc_6183 ( N_SN_c_8502_n N_noxref_19_c_9622_n ) capacitor c=0.00124604f \
 //x=71.16 //y=4.765 //x2=72.27 //y2=4.88
cc_6184 ( N_SN_c_8740_n N_noxref_19_c_9622_n ) capacitor c=0.00187046f \
 //x=71.16 //y=4.88 //x2=72.27 //y2=4.88
cc_6185 ( N_SN_c_8840_p N_noxref_19_c_9622_n ) capacitor c=0.0616777f \
 //x=71.495 //y=4.97 //x2=72.27 //y2=4.88
cc_6186 ( N_SN_c_8759_n N_noxref_19_c_9622_n ) capacitor c=0.00487508f \
 //x=71.16 //y=4.88 //x2=72.27 //y2=4.88
cc_6187 ( N_SN_c_8521_n N_noxref_20_c_9843_n ) capacitor c=0.0140253f \
 //x=70.99 //y=2.39 //x2=67.46 //y2=4.48
cc_6188 ( N_SN_c_8501_n N_noxref_20_c_9959_n ) capacitor c=4.04373e-19 \
 //x=71.16 //y=2.55 //x2=71.23 //y2=5.335
cc_6189 ( N_SN_c_8502_n N_noxref_20_c_9959_n ) capacitor c=0.0213631f \
 //x=71.16 //y=4.765 //x2=71.23 //y2=5.335
cc_6190 ( N_SN_c_8740_n N_noxref_20_c_9959_n ) capacitor c=0.00492634f \
 //x=71.16 //y=4.88 //x2=71.23 //y2=5.335
cc_6191 ( N_SN_M138_noxref_g N_noxref_20_c_9959_n ) capacitor c=0.00858241f \
 //x=71.13 //y=6.2 //x2=71.23 //y2=5.335
cc_6192 ( N_SN_c_8759_n N_noxref_20_c_9959_n ) capacitor c=6.14744e-19 \
 //x=71.16 //y=4.88 //x2=71.23 //y2=5.335
cc_6193 ( N_SN_M139_noxref_g N_noxref_20_c_10036_n ) capacitor c=0.00955829f \
 //x=71.57 //y=6.2 //x2=72.115 //y2=5.335
cc_6194 ( N_SN_c_8502_n N_noxref_20_c_9846_n ) capacitor c=0.00327974f \
 //x=71.16 //y=4.765 //x2=73.01 //y2=4.455
cc_6195 ( N_SN_c_8521_n N_noxref_20_c_9922_n ) capacitor c=0.0171584f \
 //x=70.99 //y=2.39 //x2=67.46 //y2=2.26
cc_6196 ( N_SN_c_8501_n N_noxref_20_c_10039_n ) capacitor c=3.78118e-19 \
 //x=71.16 //y=2.55 //x2=71.35 //y2=5.335
cc_6197 ( N_SN_c_8502_n N_noxref_20_c_10039_n ) capacitor c=0.00239361f \
 //x=71.16 //y=4.765 //x2=71.35 //y2=5.335
cc_6198 ( N_SN_c_8740_n N_noxref_20_c_10039_n ) capacitor c=0.00132214f \
 //x=71.16 //y=4.88 //x2=71.35 //y2=5.335
cc_6199 ( N_SN_M138_noxref_g N_noxref_20_c_10039_n ) capacitor c=0.00229818f \
 //x=71.13 //y=6.2 //x2=71.35 //y2=5.335
cc_6200 ( N_SN_M139_noxref_g N_noxref_20_c_10039_n ) capacitor c=0.00230699f \
 //x=71.57 //y=6.2 //x2=71.35 //y2=5.335
cc_6201 ( N_SN_c_8840_p N_noxref_20_c_10039_n ) capacitor c=0.00177039f \
 //x=71.495 //y=4.97 //x2=71.35 //y2=5.335
cc_6202 ( N_SN_c_8502_n N_noxref_20_c_9879_n ) capacitor c=0.0338049f \
 //x=71.16 //y=4.765 //x2=72.845 //y2=4.615
cc_6203 ( N_SN_c_8502_n N_noxref_20_c_10046_n ) capacitor c=7.85344e-19 \
 //x=71.16 //y=4.765 //x2=71.35 //y2=5.56
cc_6204 ( N_SN_M138_noxref_g N_noxref_20_c_10046_n ) capacitor c=0.0179041f \
 //x=71.13 //y=6.2 //x2=71.35 //y2=5.56
cc_6205 ( N_SN_M139_noxref_g N_noxref_20_c_10046_n ) capacitor c=0.0179041f \
 //x=71.57 //y=6.2 //x2=71.35 //y2=5.56
cc_6206 ( N_SN_c_8840_p N_noxref_20_c_10046_n ) capacitor c=0.00290085f \
 //x=71.495 //y=4.97 //x2=71.35 //y2=5.56
cc_6207 ( N_SN_c_8521_n N_noxref_20_c_9951_n ) capacitor c=2.98635e-19 \
 //x=70.99 //y=2.39 //x2=67.46 //y2=2.26
cc_6208 ( N_SN_c_8092_n N_noxref_21_c_10403_n ) capacitor c=0.0138446f \
 //x=22.15 //y=2.4 //x2=18.62 //y2=3.335
cc_6209 ( N_SN_c_8130_n N_noxref_21_c_10461_n ) capacitor c=4.04373e-19 \
 //x=22.32 //y=2.55 //x2=22.39 //y2=5.335
cc_6210 ( N_SN_c_8134_n N_noxref_21_c_10461_n ) capacitor c=0.0213631f \
 //x=22.32 //y=4.765 //x2=22.39 //y2=5.335
cc_6211 ( N_SN_c_8150_n N_noxref_21_c_10461_n ) capacitor c=0.00492634f \
 //x=22.32 //y=4.88 //x2=22.39 //y2=5.335
cc_6212 ( N_SN_M78_noxref_g N_noxref_21_c_10461_n ) capacitor c=0.00858241f \
 //x=22.29 //y=6.2 //x2=22.39 //y2=5.335
cc_6213 ( N_SN_c_8168_n N_noxref_21_c_10461_n ) capacitor c=6.14744e-19 \
 //x=22.32 //y=4.88 //x2=22.39 //y2=5.335
cc_6214 ( N_SN_M79_noxref_g N_noxref_21_c_10517_n ) capacitor c=0.00955829f \
 //x=22.73 //y=6.2 //x2=23.275 //y2=5.335
cc_6215 ( N_SN_c_8145_n N_noxref_21_c_10525_n ) capacitor c=7.09459e-19 \
 //x=27.285 //y=2.385 //x2=23.685 //y2=1.305
cc_6216 ( N_SN_c_8145_n N_noxref_21_c_10463_n ) capacitor c=0.0215245f \
 //x=27.285 //y=2.385 //x2=23.77 //y2=1.845
cc_6217 ( SN N_noxref_21_c_10538_n ) capacitor c=0.00126727f //x=22.32 \
 //y=2.77 //x2=24.17 //y2=3.365
cc_6218 ( N_SN_c_8145_n N_noxref_21_c_10538_n ) capacitor c=0.0304358f \
 //x=27.285 //y=2.385 //x2=24.17 //y2=3.365
cc_6219 ( SN N_noxref_21_c_10544_n ) capacitor c=0.00271428f //x=22.32 \
 //y=2.77 //x2=24.17 //y2=5.25
cc_6220 ( N_SN_c_8092_n N_noxref_21_c_10414_n ) capacitor c=0.0163902f \
 //x=22.15 //y=2.4 //x2=18.62 //y2=2.26
cc_6221 ( N_SN_c_8130_n N_noxref_21_c_10784_n ) capacitor c=3.78118e-19 \
 //x=22.32 //y=2.55 //x2=22.51 //y2=5.335
cc_6222 ( N_SN_c_8134_n N_noxref_21_c_10784_n ) capacitor c=0.00239361f \
 //x=22.32 //y=4.765 //x2=22.51 //y2=5.335
cc_6223 ( N_SN_c_8150_n N_noxref_21_c_10784_n ) capacitor c=0.00132214f \
 //x=22.32 //y=4.88 //x2=22.51 //y2=5.335
cc_6224 ( N_SN_M78_noxref_g N_noxref_21_c_10784_n ) capacitor c=0.00229818f \
 //x=22.29 //y=6.2 //x2=22.51 //y2=5.335
cc_6225 ( N_SN_M79_noxref_g N_noxref_21_c_10784_n ) capacitor c=0.00230699f \
 //x=22.73 //y=6.2 //x2=22.51 //y2=5.335
cc_6226 ( N_SN_c_8246_n N_noxref_21_c_10784_n ) capacitor c=0.00177039f \
 //x=22.655 //y=4.97 //x2=22.51 //y2=5.335
cc_6227 ( SN N_noxref_21_c_10471_n ) capacitor c=0.0238018f //x=22.32 //y=2.77 \
 //x2=23.045 //y2=3.51
cc_6228 ( N_SN_c_8092_n N_noxref_21_c_10471_n ) capacitor c=0.016346f \
 //x=22.15 //y=2.4 //x2=23.045 //y2=3.51
cc_6229 ( N_SN_c_8145_n N_noxref_21_c_10471_n ) capacitor c=0.00684839f \
 //x=27.285 //y=2.385 //x2=23.045 //y2=3.51
cc_6230 ( N_SN_c_8145_n N_noxref_21_c_10561_n ) capacitor c=0.0155461f \
 //x=27.285 //y=2.385 //x2=31.36 //y2=3.48
cc_6231 ( N_SN_c_8257_n N_noxref_21_c_10586_n ) capacitor c=0.0245428f \
 //x=35.27 //y=4.765 //x2=35.995 //y2=3.51
cc_6232 ( N_SN_c_8285_n N_noxref_21_c_10586_n ) capacitor c=8.74263e-19 \
 //x=34.375 //y=2.39 //x2=35.995 //y2=3.51
cc_6233 ( N_SN_c_8324_n N_noxref_21_c_10586_n ) capacitor c=0.00686698f \
 //x=46.57 //y=2.4 //x2=35.995 //y2=3.51
cc_6234 ( N_SN_c_8291_n N_noxref_21_c_10586_n ) capacitor c=0.00397006f \
 //x=35.43 //y=2.4 //x2=35.995 //y2=3.51
cc_6235 ( N_SN_c_8324_n N_noxref_21_c_10587_n ) capacitor c=0.00688482f \
 //x=46.57 //y=2.4 //x2=36.595 //y2=3.48
cc_6236 ( N_SN_c_8324_n N_noxref_21_c_10588_n ) capacitor c=0.00267286f \
 //x=46.57 //y=2.4 //x2=40.06 //y2=3.51
cc_6237 ( N_SN_c_8324_n N_noxref_21_c_10604_n ) capacitor c=0.0183706f \
 //x=46.57 //y=2.4 //x2=40.66 //y2=3.48
cc_6238 ( N_SN_c_8364_n N_noxref_21_c_10606_n ) capacitor c=0.024034f \
 //x=46.74 //y=4.765 //x2=47.465 //y2=3.51
cc_6239 ( N_SN_c_8385_n N_noxref_21_c_10606_n ) capacitor c=0.00686967f \
 //x=51.705 //y=2.385 //x2=47.465 //y2=3.51
cc_6240 ( N_SN_c_8385_n N_noxref_21_c_10633_n ) capacitor c=0.00185167f \
 //x=51.705 //y=2.385 //x2=48.065 //y2=3.495
cc_6241 ( N_SN_c_8385_n N_noxref_21_c_10665_n ) capacitor c=0.00484556f \
 //x=51.705 //y=2.385 //x2=50.645 //y2=3.54
cc_6242 ( N_SN_c_8385_n N_noxref_21_c_10666_n ) capacitor c=8.59419e-19 \
 //x=51.705 //y=2.385 //x2=55.61 //y2=3.51
cc_6243 ( SN N_noxref_21_c_10673_n ) capacitor c=0.0245428f //x=59.69 //y=2.77 \
 //x2=60.415 //y2=3.51
cc_6244 ( N_SN_c_8517_n N_noxref_21_c_10673_n ) capacitor c=8.74263e-19 \
 //x=58.795 //y=2.39 //x2=60.415 //y2=3.51
cc_6245 ( N_SN_c_8518_n N_noxref_21_c_10673_n ) capacitor c=0.00397006f \
 //x=59.85 //y=2.4 //x2=60.415 //y2=3.51
cc_6246 ( N_SN_c_8521_n N_noxref_21_c_10673_n ) capacitor c=0.00686698f \
 //x=70.99 //y=2.39 //x2=60.415 //y2=3.51
cc_6247 ( N_SN_c_8521_n N_noxref_21_c_10676_n ) capacitor c=0.00688482f \
 //x=70.99 //y=2.39 //x2=61.015 //y2=3.48
cc_6248 ( N_SN_c_8521_n N_noxref_21_c_10677_n ) capacitor c=0.00267286f \
 //x=70.99 //y=2.39 //x2=64.48 //y2=3.51
cc_6249 ( N_SN_c_8521_n N_noxref_21_c_10680_n ) capacitor c=0.0273834f \
 //x=70.99 //y=2.39 //x2=65.08 //y2=3.48
cc_6250 ( N_SN_c_8502_n N_noxref_21_c_10681_n ) capacitor c=0.0238644f \
 //x=71.16 //y=4.765 //x2=71.885 //y2=3.51
cc_6251 ( N_SN_c_8134_n N_noxref_21_c_10859_n ) capacitor c=7.85344e-19 \
 //x=22.32 //y=4.765 //x2=22.51 //y2=5.56
cc_6252 ( N_SN_M78_noxref_g N_noxref_21_c_10859_n ) capacitor c=0.0179041f \
 //x=22.29 //y=6.2 //x2=22.51 //y2=5.56
cc_6253 ( N_SN_M79_noxref_g N_noxref_21_c_10859_n ) capacitor c=0.0179041f \
 //x=22.73 //y=6.2 //x2=22.51 //y2=5.56
cc_6254 ( N_SN_c_8246_n N_noxref_21_c_10859_n ) capacitor c=0.00290085f \
 //x=22.655 //y=4.97 //x2=22.51 //y2=5.56
cc_6255 ( N_SN_c_8092_n N_noxref_21_c_10439_n ) capacitor c=2.98635e-19 \
 //x=22.15 //y=2.4 //x2=18.62 //y2=2.26
cc_6256 ( N_SN_M64_noxref_g N_VDD_c_11595_n ) capacitor c=0.00705252f \
 //x=10.82 //y=6.2 //x2=11.395 //y2=7.585
cc_6257 ( N_SN_M65_noxref_g N_VDD_c_11595_n ) capacitor c=0.00755544f \
 //x=11.26 //y=6.2 //x2=11.395 //y2=7.585
cc_6258 ( N_SN_M78_noxref_g N_VDD_c_12537_n ) capacitor c=0.00705252f \
 //x=22.29 //y=6.2 //x2=22.865 //y2=7.585
cc_6259 ( N_SN_M79_noxref_g N_VDD_c_12537_n ) capacitor c=0.00755544f \
 //x=22.73 //y=6.2 //x2=22.865 //y2=7.585
cc_6260 ( N_SN_M94_noxref_g N_VDD_c_11895_n ) capacitor c=0.00705252f \
 //x=35.24 //y=6.2 //x2=35.815 //y2=7.585
cc_6261 ( N_SN_M95_noxref_g N_VDD_c_11895_n ) capacitor c=0.00755544f \
 //x=35.68 //y=6.2 //x2=35.815 //y2=7.585
cc_6262 ( N_SN_M108_noxref_g N_VDD_c_12130_n ) capacitor c=0.00705252f \
 //x=46.71 //y=6.2 //x2=47.285 //y2=7.585
cc_6263 ( N_SN_M109_noxref_g N_VDD_c_12130_n ) capacitor c=0.00755544f \
 //x=47.15 //y=6.2 //x2=47.285 //y2=7.585
cc_6264 ( N_SN_M124_noxref_g N_VDD_c_12296_n ) capacitor c=0.00705252f \
 //x=59.66 //y=6.2 //x2=60.235 //y2=7.585
cc_6265 ( N_SN_M125_noxref_g N_VDD_c_12296_n ) capacitor c=0.00755544f \
 //x=60.1 //y=6.2 //x2=60.235 //y2=7.585
cc_6266 ( N_SN_M138_noxref_g N_VDD_c_12545_n ) capacitor c=0.00705252f \
 //x=71.13 //y=6.2 //x2=71.705 //y2=7.585
cc_6267 ( N_SN_M139_noxref_g N_VDD_c_12545_n ) capacitor c=0.00755544f \
 //x=71.57 //y=6.2 //x2=71.705 //y2=7.585
cc_6268 ( N_SN_M64_noxref_g N_VDD_M63_noxref_d ) capacitor c=0.015318f \
 //x=10.82 //y=6.2 //x2=10.455 //y2=5.2
cc_6269 ( N_SN_M65_noxref_g N_VDD_M65_noxref_d ) capacitor c=0.015318f \
 //x=11.26 //y=6.2 //x2=11.335 //y2=5.2
cc_6270 ( N_SN_M78_noxref_g N_VDD_M77_noxref_d ) capacitor c=0.015318f \
 //x=22.29 //y=6.2 //x2=21.925 //y2=5.2
cc_6271 ( N_SN_M79_noxref_g N_VDD_M79_noxref_d ) capacitor c=0.015318f \
 //x=22.73 //y=6.2 //x2=22.805 //y2=5.2
cc_6272 ( N_SN_M94_noxref_g N_VDD_M93_noxref_d ) capacitor c=0.015318f \
 //x=35.24 //y=6.2 //x2=34.875 //y2=5.2
cc_6273 ( N_SN_M95_noxref_g N_VDD_M95_noxref_d ) capacitor c=0.015318f \
 //x=35.68 //y=6.2 //x2=35.755 //y2=5.2
cc_6274 ( N_SN_M108_noxref_g N_VDD_M107_noxref_d ) capacitor c=0.015318f \
 //x=46.71 //y=6.2 //x2=46.345 //y2=5.2
cc_6275 ( N_SN_M109_noxref_g N_VDD_M109_noxref_d ) capacitor c=0.015318f \
 //x=47.15 //y=6.2 //x2=47.225 //y2=5.2
cc_6276 ( N_SN_M124_noxref_g N_VDD_M123_noxref_d ) capacitor c=0.015318f \
 //x=59.66 //y=6.2 //x2=59.295 //y2=5.2
cc_6277 ( N_SN_M125_noxref_g N_VDD_M125_noxref_d ) capacitor c=0.015318f \
 //x=60.1 //y=6.2 //x2=60.175 //y2=5.2
cc_6278 ( N_SN_M138_noxref_g N_VDD_M137_noxref_d ) capacitor c=0.015318f \
 //x=71.13 //y=6.2 //x2=70.765 //y2=5.2
cc_6279 ( N_SN_M139_noxref_g N_VDD_M139_noxref_d ) capacitor c=0.015318f \
 //x=71.57 //y=6.2 //x2=71.645 //y2=5.2
cc_6280 ( N_SN_c_8092_n N_noxref_25_c_13041_n ) capacitor c=0.00601428f \
 //x=22.15 //y=2.4 //x2=11.645 //y2=1.175
cc_6281 ( N_SN_c_8076_n N_noxref_25_c_13041_n ) capacitor c=0.00123426f \
 //x=10.94 //y=1.09 //x2=11.645 //y2=1.175
cc_6282 ( N_SN_c_8077_n N_noxref_25_c_13041_n ) capacitor c=0.0129287f \
 //x=10.94 //y=1.4 //x2=11.645 //y2=1.175
cc_6283 ( N_SN_c_8078_n N_noxref_25_c_13041_n ) capacitor c=0.00132209f \
 //x=10.94 //y=1.63 //x2=11.645 //y2=1.175
cc_6284 ( N_SN_c_8092_n N_noxref_25_c_13017_n ) capacitor c=5.06634e-19 \
 //x=22.15 //y=2.4 //x2=12.615 //y2=0.72
cc_6285 ( N_SN_c_8051_n N_noxref_25_M6_noxref_d ) capacitor c=0.0067342f \
 //x=10.85 //y=2.55 //x2=10.49 //y2=1.09
cc_6286 ( N_SN_c_8059_n N_noxref_25_M6_noxref_d ) capacitor c=9.81665e-19 \
 //x=11.01 //y=2.39 //x2=10.49 //y2=1.09
cc_6287 ( N_SN_c_8061_n N_noxref_25_M6_noxref_d ) capacitor c=2.2052e-19 \
 //x=10.85 //y=2.26 //x2=10.49 //y2=1.09
cc_6288 ( N_SN_c_8071_n N_noxref_25_M6_noxref_d ) capacitor c=0.00253592f \
 //x=10.415 //y=1.09 //x2=10.49 //y2=1.09
cc_6289 ( N_SN_c_8074_n N_noxref_25_M6_noxref_d ) capacitor c=0.00604087f \
 //x=10.415 //y=1.4 //x2=10.49 //y2=1.09
cc_6290 ( N_SN_c_8945_p N_noxref_25_M6_noxref_d ) capacitor c=0.002686f \
 //x=10.785 //y=0.935 //x2=10.49 //y2=1.09
cc_6291 ( N_SN_c_8946_p N_noxref_25_M6_noxref_d ) capacitor c=0.00251995f \
 //x=10.785 //y=1.555 //x2=10.49 //y2=1.09
cc_6292 ( N_SN_c_8076_n N_noxref_25_M6_noxref_d ) capacitor c=0.00314523f \
 //x=10.94 //y=1.09 //x2=10.49 //y2=1.09
cc_6293 ( N_SN_c_8077_n N_noxref_25_M6_noxref_d ) capacitor c=0.00168289f \
 //x=10.94 //y=1.4 //x2=10.49 //y2=1.09
cc_6294 ( N_SN_c_8078_n N_noxref_25_M6_noxref_d ) capacitor c=0.00111165f \
 //x=10.94 //y=1.63 //x2=10.49 //y2=1.09
cc_6295 ( N_SN_c_8092_n N_noxref_25_M7_noxref_s ) capacitor c=0.00471087f \
 //x=22.15 //y=2.4 //x2=11.595 //y2=0.555
cc_6296 ( N_SN_c_8076_n N_noxref_25_M7_noxref_s ) capacitor c=7.21316e-19 \
 //x=10.94 //y=1.09 //x2=11.595 //y2=0.555
cc_6297 ( N_SN_c_8077_n N_noxref_25_M7_noxref_s ) capacitor c=0.00365271f \
 //x=10.94 //y=1.4 //x2=11.595 //y2=0.555
cc_6298 ( N_SN_c_8079_n N_noxref_25_M7_noxref_s ) capacitor c=9.86711e-19 \
 //x=10.94 //y=2.095 //x2=11.595 //y2=0.555
cc_6299 ( N_SN_c_8145_n N_noxref_26_c_13098_n ) capacitor c=0.00601428f \
 //x=27.285 //y=2.385 //x2=23.115 //y2=1.175
cc_6300 ( N_SN_c_8162_n N_noxref_26_c_13098_n ) capacitor c=0.00123426f \
 //x=22.41 //y=1.09 //x2=23.115 //y2=1.175
cc_6301 ( N_SN_c_8163_n N_noxref_26_c_13098_n ) capacitor c=0.0129287f \
 //x=22.41 //y=1.4 //x2=23.115 //y2=1.175
cc_6302 ( N_SN_c_8164_n N_noxref_26_c_13098_n ) capacitor c=0.00132209f \
 //x=22.41 //y=1.63 //x2=23.115 //y2=1.175
cc_6303 ( N_SN_c_8145_n N_noxref_26_c_13087_n ) capacitor c=5.06634e-19 \
 //x=27.285 //y=2.385 //x2=24.085 //y2=0.72
cc_6304 ( N_SN_c_8130_n N_noxref_26_M13_noxref_d ) capacitor c=0.00686082f \
 //x=22.32 //y=2.55 //x2=21.96 //y2=1.09
cc_6305 ( N_SN_c_8092_n N_noxref_26_M13_noxref_d ) capacitor c=0.00508822f \
 //x=22.15 //y=2.4 //x2=21.96 //y2=1.09
cc_6306 ( N_SN_c_8145_n N_noxref_26_M13_noxref_d ) capacitor c=0.00119981f \
 //x=27.285 //y=2.385 //x2=21.96 //y2=1.09
cc_6307 ( N_SN_c_8147_n N_noxref_26_M13_noxref_d ) capacitor c=2.2052e-19 \
 //x=22.32 //y=2.26 //x2=21.96 //y2=1.09
cc_6308 ( N_SN_c_8157_n N_noxref_26_M13_noxref_d ) capacitor c=0.00253592f \
 //x=21.885 //y=1.09 //x2=21.96 //y2=1.09
cc_6309 ( N_SN_c_8160_n N_noxref_26_M13_noxref_d ) capacitor c=0.00604066f \
 //x=21.885 //y=1.4 //x2=21.96 //y2=1.09
cc_6310 ( N_SN_c_8965_p N_noxref_26_M13_noxref_d ) capacitor c=0.002686f \
 //x=22.255 //y=0.935 //x2=21.96 //y2=1.09
cc_6311 ( N_SN_c_8966_p N_noxref_26_M13_noxref_d ) capacitor c=0.00251995f \
 //x=22.255 //y=1.555 //x2=21.96 //y2=1.09
cc_6312 ( N_SN_c_8162_n N_noxref_26_M13_noxref_d ) capacitor c=0.00314523f \
 //x=22.41 //y=1.09 //x2=21.96 //y2=1.09
cc_6313 ( N_SN_c_8163_n N_noxref_26_M13_noxref_d ) capacitor c=0.00168289f \
 //x=22.41 //y=1.4 //x2=21.96 //y2=1.09
cc_6314 ( N_SN_c_8164_n N_noxref_26_M13_noxref_d ) capacitor c=0.00111165f \
 //x=22.41 //y=1.63 //x2=21.96 //y2=1.09
cc_6315 ( N_SN_c_8145_n N_noxref_26_M14_noxref_s ) capacitor c=0.00471087f \
 //x=27.285 //y=2.385 //x2=23.065 //y2=0.555
cc_6316 ( N_SN_c_8162_n N_noxref_26_M14_noxref_s ) capacitor c=7.21316e-19 \
 //x=22.41 //y=1.09 //x2=23.065 //y2=0.555
cc_6317 ( N_SN_c_8163_n N_noxref_26_M14_noxref_s ) capacitor c=0.00365271f \
 //x=22.41 //y=1.4 //x2=23.065 //y2=0.555
cc_6318 ( N_SN_c_8165_n N_noxref_26_M14_noxref_s ) capacitor c=9.86711e-19 \
 //x=22.41 //y=2.095 //x2=23.065 //y2=0.555
cc_6319 ( N_SN_c_8282_n N_noxref_27_c_13177_n ) capacitor c=0.00601428f \
 //x=33.775 //y=2.4 //x2=31.255 //y2=1.175
cc_6320 ( N_SN_c_8282_n N_noxref_27_c_13156_n ) capacitor c=5.06634e-19 \
 //x=33.775 //y=2.4 //x2=32.225 //y2=0.72
cc_6321 ( N_SN_c_8282_n N_noxref_27_M18_noxref_d ) capacitor c=0.00780264f \
 //x=33.775 //y=2.4 //x2=30.1 //y2=1.09
cc_6322 ( N_SN_c_8282_n N_noxref_27_M19_noxref_s ) capacitor c=0.00447031f \
 //x=33.775 //y=2.4 //x2=31.205 //y2=0.555
cc_6323 ( N_SN_c_8324_n N_noxref_28_c_13245_n ) capacitor c=0.00601428f \
 //x=46.57 //y=2.4 //x2=36.065 //y2=1.175
cc_6324 ( N_SN_c_8308_n N_noxref_28_c_13245_n ) capacitor c=0.00123426f \
 //x=35.36 //y=1.09 //x2=36.065 //y2=1.175
cc_6325 ( N_SN_c_8309_n N_noxref_28_c_13245_n ) capacitor c=0.0129287f \
 //x=35.36 //y=1.4 //x2=36.065 //y2=1.175
cc_6326 ( N_SN_c_8310_n N_noxref_28_c_13245_n ) capacitor c=0.00132209f \
 //x=35.36 //y=1.63 //x2=36.065 //y2=1.175
cc_6327 ( N_SN_c_8324_n N_noxref_28_c_13222_n ) capacitor c=5.06634e-19 \
 //x=46.57 //y=2.4 //x2=37.035 //y2=0.72
cc_6328 ( N_SN_c_8253_n N_noxref_28_M21_noxref_d ) capacitor c=0.0067342f \
 //x=35.27 //y=2.55 //x2=34.91 //y2=1.09
cc_6329 ( N_SN_c_8291_n N_noxref_28_M21_noxref_d ) capacitor c=0.00647878f \
 //x=35.43 //y=2.4 //x2=34.91 //y2=1.09
cc_6330 ( N_SN_c_8293_n N_noxref_28_M21_noxref_d ) capacitor c=2.2052e-19 \
 //x=35.27 //y=2.26 //x2=34.91 //y2=1.09
cc_6331 ( N_SN_c_8303_n N_noxref_28_M21_noxref_d ) capacitor c=0.00253592f \
 //x=34.835 //y=1.09 //x2=34.91 //y2=1.09
cc_6332 ( N_SN_c_8306_n N_noxref_28_M21_noxref_d ) capacitor c=0.00604087f \
 //x=34.835 //y=1.4 //x2=34.91 //y2=1.09
cc_6333 ( N_SN_c_8988_p N_noxref_28_M21_noxref_d ) capacitor c=0.002686f \
 //x=35.205 //y=0.935 //x2=34.91 //y2=1.09
cc_6334 ( N_SN_c_8989_p N_noxref_28_M21_noxref_d ) capacitor c=0.00251995f \
 //x=35.205 //y=1.555 //x2=34.91 //y2=1.09
cc_6335 ( N_SN_c_8308_n N_noxref_28_M21_noxref_d ) capacitor c=0.00314523f \
 //x=35.36 //y=1.09 //x2=34.91 //y2=1.09
cc_6336 ( N_SN_c_8309_n N_noxref_28_M21_noxref_d ) capacitor c=0.00168289f \
 //x=35.36 //y=1.4 //x2=34.91 //y2=1.09
cc_6337 ( N_SN_c_8310_n N_noxref_28_M21_noxref_d ) capacitor c=0.00111165f \
 //x=35.36 //y=1.63 //x2=34.91 //y2=1.09
cc_6338 ( N_SN_c_8324_n N_noxref_28_M22_noxref_s ) capacitor c=0.00471087f \
 //x=46.57 //y=2.4 //x2=36.015 //y2=0.555
cc_6339 ( N_SN_c_8308_n N_noxref_28_M22_noxref_s ) capacitor c=7.21316e-19 \
 //x=35.36 //y=1.09 //x2=36.015 //y2=0.555
cc_6340 ( N_SN_c_8309_n N_noxref_28_M22_noxref_s ) capacitor c=0.00365271f \
 //x=35.36 //y=1.4 //x2=36.015 //y2=0.555
cc_6341 ( N_SN_c_8311_n N_noxref_28_M22_noxref_s ) capacitor c=9.86711e-19 \
 //x=35.36 //y=2.095 //x2=36.015 //y2=0.555
cc_6342 ( N_SN_c_8385_n N_noxref_29_c_13313_n ) capacitor c=0.00601428f \
 //x=51.705 //y=2.385 //x2=47.535 //y2=1.175
cc_6343 ( N_SN_c_8402_n N_noxref_29_c_13313_n ) capacitor c=0.00123426f \
 //x=46.83 //y=1.09 //x2=47.535 //y2=1.175
cc_6344 ( N_SN_c_8403_n N_noxref_29_c_13313_n ) capacitor c=0.0129287f \
 //x=46.83 //y=1.4 //x2=47.535 //y2=1.175
cc_6345 ( N_SN_c_8404_n N_noxref_29_c_13313_n ) capacitor c=0.00132209f \
 //x=46.83 //y=1.63 //x2=47.535 //y2=1.175
cc_6346 ( N_SN_c_8385_n N_noxref_29_c_13291_n ) capacitor c=5.06634e-19 \
 //x=51.705 //y=2.385 //x2=48.505 //y2=0.72
cc_6347 ( N_SN_c_8360_n N_noxref_29_M28_noxref_d ) capacitor c=0.00686082f \
 //x=46.74 //y=2.55 //x2=46.38 //y2=1.09
cc_6348 ( N_SN_c_8324_n N_noxref_29_M28_noxref_d ) capacitor c=0.00508822f \
 //x=46.57 //y=2.4 //x2=46.38 //y2=1.09
cc_6349 ( N_SN_c_8385_n N_noxref_29_M28_noxref_d ) capacitor c=0.00119981f \
 //x=51.705 //y=2.385 //x2=46.38 //y2=1.09
cc_6350 ( N_SN_c_8387_n N_noxref_29_M28_noxref_d ) capacitor c=2.2052e-19 \
 //x=46.74 //y=2.26 //x2=46.38 //y2=1.09
cc_6351 ( N_SN_c_8397_n N_noxref_29_M28_noxref_d ) capacitor c=0.00253592f \
 //x=46.305 //y=1.09 //x2=46.38 //y2=1.09
cc_6352 ( N_SN_c_8400_n N_noxref_29_M28_noxref_d ) capacitor c=0.00604066f \
 //x=46.305 //y=1.4 //x2=46.38 //y2=1.09
cc_6353 ( N_SN_c_9008_p N_noxref_29_M28_noxref_d ) capacitor c=0.002686f \
 //x=46.675 //y=0.935 //x2=46.38 //y2=1.09
cc_6354 ( N_SN_c_9009_p N_noxref_29_M28_noxref_d ) capacitor c=0.00251995f \
 //x=46.675 //y=1.555 //x2=46.38 //y2=1.09
cc_6355 ( N_SN_c_8402_n N_noxref_29_M28_noxref_d ) capacitor c=0.00314523f \
 //x=46.83 //y=1.09 //x2=46.38 //y2=1.09
cc_6356 ( N_SN_c_8403_n N_noxref_29_M28_noxref_d ) capacitor c=0.00168289f \
 //x=46.83 //y=1.4 //x2=46.38 //y2=1.09
cc_6357 ( N_SN_c_8404_n N_noxref_29_M28_noxref_d ) capacitor c=0.00111165f \
 //x=46.83 //y=1.63 //x2=46.38 //y2=1.09
cc_6358 ( N_SN_c_8385_n N_noxref_29_M29_noxref_s ) capacitor c=0.00471087f \
 //x=51.705 //y=2.385 //x2=47.485 //y2=0.555
cc_6359 ( N_SN_c_8402_n N_noxref_29_M29_noxref_s ) capacitor c=7.21316e-19 \
 //x=46.83 //y=1.09 //x2=47.485 //y2=0.555
cc_6360 ( N_SN_c_8403_n N_noxref_29_M29_noxref_s ) capacitor c=0.00365271f \
 //x=46.83 //y=1.4 //x2=47.485 //y2=0.555
cc_6361 ( N_SN_c_8405_n N_noxref_29_M29_noxref_s ) capacitor c=9.86711e-19 \
 //x=46.83 //y=2.095 //x2=47.485 //y2=0.555
cc_6362 ( N_SN_c_8516_n N_noxref_30_c_13360_n ) capacitor c=0.00601428f \
 //x=58.195 //y=2.4 //x2=55.675 //y2=1.175
cc_6363 ( N_SN_c_8516_n N_noxref_30_c_13375_n ) capacitor c=5.06634e-19 \
 //x=58.195 //y=2.4 //x2=56.645 //y2=0.72
cc_6364 ( N_SN_c_8516_n N_noxref_30_M33_noxref_d ) capacitor c=0.00780264f \
 //x=58.195 //y=2.4 //x2=54.52 //y2=1.09
cc_6365 ( N_SN_c_8516_n N_noxref_30_M34_noxref_s ) capacitor c=0.00447031f \
 //x=58.195 //y=2.4 //x2=55.625 //y2=0.555
cc_6366 ( N_SN_c_8521_n N_noxref_31_c_13438_n ) capacitor c=0.00601428f \
 //x=70.99 //y=2.39 //x2=60.485 //y2=1.175
cc_6367 ( N_SN_c_8638_n N_noxref_31_c_13438_n ) capacitor c=0.00123426f \
 //x=59.78 //y=1.09 //x2=60.485 //y2=1.175
cc_6368 ( N_SN_c_8639_n N_noxref_31_c_13438_n ) capacitor c=0.0129287f \
 //x=59.78 //y=1.4 //x2=60.485 //y2=1.175
cc_6369 ( N_SN_c_8640_n N_noxref_31_c_13438_n ) capacitor c=0.00132209f \
 //x=59.78 //y=1.63 //x2=60.485 //y2=1.175
cc_6370 ( N_SN_c_8521_n N_noxref_31_c_13426_n ) capacitor c=5.06634e-19 \
 //x=70.99 //y=2.39 //x2=61.455 //y2=0.72
cc_6371 ( N_SN_c_8500_n N_noxref_31_M36_noxref_d ) capacitor c=0.0067342f \
 //x=59.69 //y=2.55 //x2=59.33 //y2=1.09
cc_6372 ( N_SN_c_8518_n N_noxref_31_M36_noxref_d ) capacitor c=0.00647878f \
 //x=59.85 //y=2.4 //x2=59.33 //y2=1.09
cc_6373 ( N_SN_c_8623_n N_noxref_31_M36_noxref_d ) capacitor c=2.2052e-19 \
 //x=59.69 //y=2.26 //x2=59.33 //y2=1.09
cc_6374 ( N_SN_c_8633_n N_noxref_31_M36_noxref_d ) capacitor c=0.00253592f \
 //x=59.255 //y=1.09 //x2=59.33 //y2=1.09
cc_6375 ( N_SN_c_8636_n N_noxref_31_M36_noxref_d ) capacitor c=0.00604087f \
 //x=59.255 //y=1.4 //x2=59.33 //y2=1.09
cc_6376 ( N_SN_c_9031_p N_noxref_31_M36_noxref_d ) capacitor c=0.002686f \
 //x=59.625 //y=0.935 //x2=59.33 //y2=1.09
cc_6377 ( N_SN_c_9032_p N_noxref_31_M36_noxref_d ) capacitor c=0.00251995f \
 //x=59.625 //y=1.555 //x2=59.33 //y2=1.09
cc_6378 ( N_SN_c_8638_n N_noxref_31_M36_noxref_d ) capacitor c=0.00314523f \
 //x=59.78 //y=1.09 //x2=59.33 //y2=1.09
cc_6379 ( N_SN_c_8639_n N_noxref_31_M36_noxref_d ) capacitor c=0.00168289f \
 //x=59.78 //y=1.4 //x2=59.33 //y2=1.09
cc_6380 ( N_SN_c_8640_n N_noxref_31_M36_noxref_d ) capacitor c=0.00111165f \
 //x=59.78 //y=1.63 //x2=59.33 //y2=1.09
cc_6381 ( N_SN_c_8521_n N_noxref_31_M37_noxref_s ) capacitor c=0.00471087f \
 //x=70.99 //y=2.39 //x2=60.435 //y2=0.555
cc_6382 ( N_SN_c_8638_n N_noxref_31_M37_noxref_s ) capacitor c=7.21316e-19 \
 //x=59.78 //y=1.09 //x2=60.435 //y2=0.555
cc_6383 ( N_SN_c_8639_n N_noxref_31_M37_noxref_s ) capacitor c=0.00365271f \
 //x=59.78 //y=1.4 //x2=60.435 //y2=0.555
cc_6384 ( N_SN_c_8641_n N_noxref_31_M37_noxref_s ) capacitor c=9.86711e-19 \
 //x=59.78 //y=2.095 //x2=60.435 //y2=0.555
cc_6385 ( N_SN_c_8753_n N_noxref_32_c_13494_n ) capacitor c=0.00123426f \
 //x=71.25 //y=1.09 //x2=71.955 //y2=1.175
cc_6386 ( N_SN_c_8754_n N_noxref_32_c_13494_n ) capacitor c=0.0129287f \
 //x=71.25 //y=1.4 //x2=71.955 //y2=1.175
cc_6387 ( N_SN_c_8755_n N_noxref_32_c_13494_n ) capacitor c=0.00132209f \
 //x=71.25 //y=1.63 //x2=71.955 //y2=1.175
cc_6388 ( N_SN_c_8501_n N_noxref_32_M43_noxref_d ) capacitor c=0.00686082f \
 //x=71.16 //y=2.55 //x2=70.8 //y2=1.09
cc_6389 ( N_SN_c_8520_n N_noxref_32_M43_noxref_d ) capacitor c=0.00119981f \
 //x=71.15 //y=2.39 //x2=70.8 //y2=1.09
cc_6390 ( N_SN_c_8521_n N_noxref_32_M43_noxref_d ) capacitor c=0.00508822f \
 //x=70.99 //y=2.39 //x2=70.8 //y2=1.09
cc_6391 ( N_SN_c_8737_n N_noxref_32_M43_noxref_d ) capacitor c=2.2052e-19 \
 //x=71.16 //y=2.26 //x2=70.8 //y2=1.09
cc_6392 ( N_SN_c_8748_n N_noxref_32_M43_noxref_d ) capacitor c=0.00253592f \
 //x=70.725 //y=1.09 //x2=70.8 //y2=1.09
cc_6393 ( N_SN_c_8751_n N_noxref_32_M43_noxref_d ) capacitor c=0.00604066f \
 //x=70.725 //y=1.4 //x2=70.8 //y2=1.09
cc_6394 ( N_SN_c_9049_p N_noxref_32_M43_noxref_d ) capacitor c=0.002686f \
 //x=71.095 //y=0.935 //x2=70.8 //y2=1.09
cc_6395 ( N_SN_c_9050_p N_noxref_32_M43_noxref_d ) capacitor c=0.00251995f \
 //x=71.095 //y=1.555 //x2=70.8 //y2=1.09
cc_6396 ( N_SN_c_8753_n N_noxref_32_M43_noxref_d ) capacitor c=0.00314523f \
 //x=71.25 //y=1.09 //x2=70.8 //y2=1.09
cc_6397 ( N_SN_c_8754_n N_noxref_32_M43_noxref_d ) capacitor c=0.00168289f \
 //x=71.25 //y=1.4 //x2=70.8 //y2=1.09
cc_6398 ( N_SN_c_8755_n N_noxref_32_M43_noxref_d ) capacitor c=0.00111165f \
 //x=71.25 //y=1.63 //x2=70.8 //y2=1.09
cc_6399 ( N_SN_c_8753_n N_noxref_32_M44_noxref_s ) capacitor c=7.21316e-19 \
 //x=71.25 //y=1.09 //x2=71.905 //y2=0.555
cc_6400 ( N_SN_c_8754_n N_noxref_32_M44_noxref_s ) capacitor c=0.00365271f \
 //x=71.25 //y=1.4 //x2=71.905 //y2=0.555
cc_6401 ( N_SN_c_8756_n N_noxref_32_M44_noxref_s ) capacitor c=9.86711e-19 \
 //x=71.25 //y=2.095 //x2=71.905 //y2=0.555
cc_6402 ( N_SN_c_8051_n N_GND_c_13937_n ) capacitor c=8.88339e-19 //x=10.85 \
 //y=2.55 //x2=14.535 //y2=0.175
cc_6403 ( N_SN_c_8092_n N_GND_c_13937_n ) capacitor c=0.102621f //x=22.15 \
 //y=2.4 //x2=14.535 //y2=0.175
cc_6404 ( N_SN_c_8059_n N_GND_c_13937_n ) capacitor c=0.00334285f //x=11.01 \
 //y=2.39 //x2=14.535 //y2=0.175
cc_6405 ( N_SN_c_8092_n N_GND_c_14058_n ) capacitor c=0.0873057f //x=22.15 \
 //y=2.4 //x2=17.865 //y2=0.175
cc_6406 ( N_SN_c_8092_n N_GND_c_14017_n ) capacitor c=0.0825955f //x=22.15 \
 //y=2.4 //x2=21.09 //y2=0.175
cc_6407 ( N_SN_c_8130_n N_GND_c_14061_n ) capacitor c=8.66523e-19 //x=22.32 \
 //y=2.55 //x2=26.005 //y2=0.175
cc_6408 ( N_SN_c_8092_n N_GND_c_14061_n ) capacitor c=0.020457f //x=22.15 \
 //y=2.4 //x2=26.005 //y2=0.175
cc_6409 ( N_SN_c_8145_n N_GND_c_14061_n ) capacitor c=0.107602f //x=27.285 \
 //y=2.385 //x2=26.005 //y2=0.175
cc_6410 ( N_SN_c_8265_n N_GND_c_14081_n ) capacitor c=0.0619148f //x=27.715 \
 //y=2.385 //x2=29.23 //y2=0.175
cc_6411 ( N_SN_c_8145_n N_GND_c_14081_n ) capacitor c=0.0180008f //x=27.285 \
 //y=2.385 //x2=29.23 //y2=0.175
cc_6412 ( N_SN_c_8275_n N_GND_c_14198_n ) capacitor c=0.020281f //x=29.565 \
 //y=2.385 //x2=34.04 //y2=0.175
cc_6413 ( N_SN_c_8282_n N_GND_c_14198_n ) capacitor c=0.10583f //x=33.775 \
 //y=2.4 //x2=34.04 //y2=0.175
cc_6414 ( N_SN_c_8253_n N_GND_c_14155_n ) capacitor c=8.88339e-19 //x=35.27 \
 //y=2.55 //x2=38.955 //y2=0.175
cc_6415 ( N_SN_c_8324_n N_GND_c_14155_n ) capacitor c=0.102621f //x=46.57 \
 //y=2.4 //x2=38.955 //y2=0.175
cc_6416 ( N_SN_c_8291_n N_GND_c_14155_n ) capacitor c=0.0238566f //x=35.43 \
 //y=2.4 //x2=38.955 //y2=0.175
cc_6417 ( N_SN_c_8324_n N_GND_c_14284_n ) capacitor c=0.0873057f //x=46.57 \
 //y=2.4 //x2=42.285 //y2=0.175
cc_6418 ( N_SN_c_8324_n N_GND_c_14235_n ) capacitor c=0.0818257f //x=46.57 \
 //y=2.4 //x2=45.51 //y2=0.175
cc_6419 ( N_SN_c_8360_n N_GND_c_14287_n ) capacitor c=8.66523e-19 //x=46.74 \
 //y=2.55 //x2=50.425 //y2=0.175
cc_6420 ( N_SN_c_8324_n N_GND_c_14287_n ) capacitor c=0.020457f //x=46.57 \
 //y=2.4 //x2=50.425 //y2=0.175
cc_6421 ( N_SN_c_8385_n N_GND_c_14287_n ) capacitor c=0.10626f //x=51.705 \
 //y=2.385 //x2=50.425 //y2=0.175
cc_6422 ( N_SN_c_8506_n N_GND_c_14438_n ) capacitor c=0.0619148f //x=52.135 \
 //y=2.385 //x2=53.65 //y2=0.175
cc_6423 ( N_SN_c_8385_n N_GND_c_14438_n ) capacitor c=0.0180008f //x=51.705 \
 //y=2.385 //x2=53.65 //y2=0.175
cc_6424 ( N_SN_c_8515_n N_GND_c_14559_n ) capacitor c=0.020281f //x=53.985 \
 //y=2.385 //x2=58.46 //y2=0.175
cc_6425 ( N_SN_c_8516_n N_GND_c_14559_n ) capacitor c=0.10583f //x=58.195 \
 //y=2.4 //x2=58.46 //y2=0.175
cc_6426 ( N_SN_c_8500_n N_GND_c_14513_n ) capacitor c=8.88339e-19 //x=59.69 \
 //y=2.55 //x2=63.375 //y2=0.175
cc_6427 ( N_SN_c_8518_n N_GND_c_14513_n ) capacitor c=0.0238566f //x=59.85 \
 //y=2.4 //x2=63.375 //y2=0.175
cc_6428 ( N_SN_c_8521_n N_GND_c_14513_n ) capacitor c=0.102621f //x=70.99 \
 //y=2.39 //x2=63.375 //y2=0.175
cc_6429 ( N_SN_c_8521_n N_GND_c_14560_n ) capacitor c=0.0873057f //x=70.99 \
 //y=2.39 //x2=66.705 //y2=0.175
cc_6430 ( N_SN_c_8521_n N_GND_c_14611_n ) capacitor c=0.0845962f //x=70.99 \
 //y=2.39 //x2=69.93 //y2=0.175
cc_6431 ( N_SN_c_8501_n N_GND_c_14678_n ) capacitor c=8.66523e-19 //x=71.16 \
 //y=2.55 //x2=74.845 //y2=0.175
cc_6432 ( N_SN_c_8520_n N_GND_c_14678_n ) capacitor c=0.0031634f //x=71.15 \
 //y=2.39 //x2=74.845 //y2=0.175
cc_6433 ( N_SN_c_8521_n N_GND_c_14678_n ) capacitor c=0.020457f //x=70.99 \
 //y=2.39 //x2=74.845 //y2=0.175
cc_6434 ( N_SN_c_8092_n N_GND_c_13941_n ) capacitor c=0.00576502f //x=22.15 \
 //y=2.4 //x2=14.62 //y2=1.135
cc_6435 ( N_SN_c_8092_n N_GND_c_13985_n ) capacitor c=0.00609997f //x=22.15 \
 //y=2.4 //x2=17.95 //y2=1.135
cc_6436 ( N_SN_c_8092_n N_GND_c_14027_n ) capacitor c=0.00561198f //x=22.15 \
 //y=2.4 //x2=21.175 //y2=1.145
cc_6437 ( N_SN_c_8145_n N_GND_c_14091_n ) capacitor c=0.00581402f //x=27.285 \
 //y=2.385 //x2=26.09 //y2=1.135
cc_6438 ( N_SN_c_8275_n N_GND_c_14093_n ) capacitor c=0.00546999f //x=29.565 \
 //y=2.385 //x2=29.315 //y2=1.145
cc_6439 ( N_SN_c_8285_n N_GND_c_14104_n ) capacitor c=0.00542624f //x=34.375 \
 //y=2.39 //x2=34.125 //y2=1.145
cc_6440 ( N_SN_c_8324_n N_GND_c_14159_n ) capacitor c=0.00576502f //x=46.57 \
 //y=2.4 //x2=39.04 //y2=1.135
cc_6441 ( N_SN_c_8324_n N_GND_c_14203_n ) capacitor c=0.00609997f //x=46.57 \
 //y=2.4 //x2=42.37 //y2=1.135
cc_6442 ( N_SN_c_8324_n N_GND_c_14245_n ) capacitor c=0.00539184f //x=46.57 \
 //y=2.4 //x2=45.595 //y2=1.145
cc_6443 ( N_SN_c_8385_n N_GND_c_14317_n ) capacitor c=0.00590289f //x=51.705 \
 //y=2.385 //x2=50.51 //y2=1.135
cc_6444 ( N_SN_c_8515_n N_GND_c_14451_n ) capacitor c=0.00546999f //x=53.985 \
 //y=2.385 //x2=53.735 //y2=1.145
cc_6445 ( N_SN_c_8517_n N_GND_c_14462_n ) capacitor c=0.00542624f //x=58.795 \
 //y=2.39 //x2=58.545 //y2=1.145
cc_6446 ( N_SN_c_8521_n N_GND_c_14517_n ) capacitor c=0.00576502f //x=70.99 \
 //y=2.39 //x2=63.46 //y2=1.135
cc_6447 ( N_SN_c_8521_n N_GND_c_14579_n ) capacitor c=0.00609997f //x=70.99 \
 //y=2.39 //x2=66.79 //y2=1.135
cc_6448 ( N_SN_c_8521_n N_GND_c_14620_n ) capacitor c=0.00557841f //x=70.99 \
 //y=2.39 //x2=70.015 //y2=1.145
cc_6449 ( N_SN_c_8092_n N_GND_c_13958_n ) capacitor c=0.0208838f //x=22.15 \
 //y=2.4 //x2=13.44 //y2=0.175
cc_6450 ( N_SN_c_8092_n N_GND_c_13971_n ) capacitor c=0.0205396f //x=22.15 \
 //y=2.4 //x2=16.77 //y2=0.175
cc_6451 ( N_SN_c_8092_n N_GND_c_14041_n ) capacitor c=0.0205648f //x=22.15 \
 //y=2.4 //x2=20.1 //y2=0.175
cc_6452 ( N_SN_c_8145_n N_GND_c_14078_n ) capacitor c=0.0205532f //x=27.285 \
 //y=2.385 //x2=24.91 //y2=0.175
cc_6453 ( N_SN_c_8265_n N_GND_c_14120_n ) capacitor c=2.79898e-19 //x=27.715 \
 //y=2.385 //x2=28.24 //y2=0.175
cc_6454 ( N_SN_c_8273_n N_GND_c_14120_n ) capacitor c=0.0210001f //x=28.965 \
 //y=2.4 //x2=28.24 //y2=0.175
cc_6455 ( N_SN_c_8282_n N_GND_c_14132_n ) capacitor c=0.0215006f //x=33.775 \
 //y=2.4 //x2=33.05 //y2=0.175
cc_6456 ( N_SN_c_8324_n N_GND_c_14176_n ) capacitor c=0.0209465f //x=46.57 \
 //y=2.4 //x2=37.86 //y2=0.175
cc_6457 ( N_SN_c_8324_n N_GND_c_14189_n ) capacitor c=0.0205396f //x=46.57 \
 //y=2.4 //x2=41.19 //y2=0.175
cc_6458 ( N_SN_c_8324_n N_GND_c_14261_n ) capacitor c=0.0209591f //x=46.57 \
 //y=2.4 //x2=44.52 //y2=0.175
cc_6459 ( N_SN_c_8385_n N_GND_c_14304_n ) capacitor c=0.0209475f //x=51.705 \
 //y=2.385 //x2=49.33 //y2=0.175
cc_6460 ( N_SN_c_8506_n N_GND_c_14332_n ) capacitor c=2.79898e-19 //x=52.135 \
 //y=2.385 //x2=52.66 //y2=0.175
cc_6461 ( N_SN_c_8514_n N_GND_c_14332_n ) capacitor c=0.0210001f //x=53.385 \
 //y=2.4 //x2=52.66 //y2=0.175
cc_6462 ( N_SN_c_8516_n N_GND_c_14333_n ) capacitor c=0.0215006f //x=58.195 \
 //y=2.4 //x2=57.47 //y2=0.175
cc_6463 ( N_SN_c_8521_n N_GND_c_14334_n ) capacitor c=0.0209465f //x=70.99 \
 //y=2.39 //x2=62.28 //y2=0.175
cc_6464 ( N_SN_c_8521_n N_GND_c_14335_n ) capacitor c=0.0205396f //x=70.99 \
 //y=2.39 //x2=65.61 //y2=0.175
cc_6465 ( N_SN_c_8521_n N_GND_c_14336_n ) capacitor c=0.0204896f //x=70.99 \
 //y=2.39 //x2=68.94 //y2=0.175
cc_6466 ( N_SN_c_8071_n N_noxref_39_c_15735_n ) capacitor c=0.0167228f \
 //x=10.415 //y=1.09 //x2=11.075 //y2=0.72
cc_6467 ( N_SN_c_8076_n N_noxref_39_c_15735_n ) capacitor c=0.00534519f \
 //x=10.94 //y=1.09 //x2=11.075 //y2=0.72
cc_6468 ( N_SN_c_8051_n N_noxref_39_c_15733_n ) capacitor c=0.00751795f \
 //x=10.85 //y=2.55 //x2=11.075 //y2=1.77
cc_6469 ( N_SN_c_8092_n N_noxref_39_c_15733_n ) capacitor c=0.00129557f \
 //x=22.15 //y=2.4 //x2=11.075 //y2=1.77
cc_6470 ( N_SN_c_8061_n N_noxref_39_c_15733_n ) capacitor c=0.0105652f \
 //x=10.85 //y=2.26 //x2=11.075 //y2=1.77
cc_6471 ( N_SN_c_8074_n N_noxref_39_c_15733_n ) capacitor c=0.0154024f \
 //x=10.415 //y=1.4 //x2=11.075 //y2=1.77
cc_6472 ( N_SN_c_8079_n N_noxref_39_c_15733_n ) capacitor c=0.0194754f \
 //x=10.94 //y=2.095 //x2=11.075 //y2=1.77
cc_6473 ( N_SN_c_8092_n N_noxref_39_M5_noxref_s ) capacitor c=0.00383739f \
 //x=22.15 //y=2.4 //x2=9.085 //y2=0.555
cc_6474 ( N_SN_c_8071_n N_noxref_39_M5_noxref_s ) capacitor c=0.00798959f \
 //x=10.415 //y=1.09 //x2=9.085 //y2=0.555
cc_6475 ( N_SN_c_8078_n N_noxref_39_M5_noxref_s ) capacitor c=0.00212176f \
 //x=10.94 //y=1.63 //x2=9.085 //y2=0.555
cc_6476 ( N_SN_c_8079_n N_noxref_39_M5_noxref_s ) capacitor c=0.00298115f \
 //x=10.94 //y=2.095 //x2=9.085 //y2=0.555
cc_6477 ( N_SN_c_8092_n N_noxref_40_c_15777_n ) capacitor c=0.00442321f \
 //x=22.15 //y=2.4 //x2=14.135 //y2=1.675
cc_6478 ( N_SN_c_8092_n N_noxref_40_c_15778_n ) capacitor c=0.0128878f \
 //x=22.15 //y=2.4 //x2=15.02 //y2=1.76
cc_6479 ( N_SN_c_8092_n N_noxref_40_c_15785_n ) capacitor c=0.00413037f \
 //x=22.15 //y=2.4 //x2=15.105 //y2=1.675
cc_6480 ( N_SN_c_8092_n N_noxref_40_c_15790_n ) capacitor c=0.00104143f \
 //x=22.15 //y=2.4 //x2=15.99 //y2=0.71
cc_6481 ( N_SN_c_8092_n N_noxref_40_M8_noxref_s ) capacitor c=0.0010705f \
 //x=22.15 //y=2.4 //x2=14 //y2=0.545
cc_6482 ( N_SN_c_8092_n N_noxref_41_c_15843_n ) capacitor c=0.00442321f \
 //x=22.15 //y=2.4 //x2=17.465 //y2=1.675
cc_6483 ( N_SN_c_8092_n N_noxref_41_c_15844_n ) capacitor c=0.0129704f \
 //x=22.15 //y=2.4 //x2=18.35 //y2=1.76
cc_6484 ( N_SN_c_8092_n N_noxref_41_c_15851_n ) capacitor c=0.00418562f \
 //x=22.15 //y=2.4 //x2=18.435 //y2=1.675
cc_6485 ( N_SN_c_8092_n N_noxref_41_c_15856_n ) capacitor c=0.00104143f \
 //x=22.15 //y=2.4 //x2=19.32 //y2=0.71
cc_6486 ( N_SN_c_8092_n N_noxref_41_M10_noxref_s ) capacitor c=0.0010705f \
 //x=22.15 //y=2.4 //x2=17.33 //y2=0.545
cc_6487 ( N_SN_c_8092_n N_noxref_42_c_15912_n ) capacitor c=0.00444844f \
 //x=22.15 //y=2.4 //x2=20.69 //y2=1.685
cc_6488 ( N_SN_c_8092_n N_noxref_42_c_15913_n ) capacitor c=0.0133675f \
 //x=22.15 //y=2.4 //x2=21.575 //y2=1.77
cc_6489 ( N_SN_c_8157_n N_noxref_42_c_15926_n ) capacitor c=0.0167228f \
 //x=21.885 //y=1.09 //x2=22.545 //y2=0.72
cc_6490 ( N_SN_c_8162_n N_noxref_42_c_15926_n ) capacitor c=0.00534519f \
 //x=22.41 //y=1.09 //x2=22.545 //y2=0.72
cc_6491 ( N_SN_c_8130_n N_noxref_42_c_15928_n ) capacitor c=0.00743214f \
 //x=22.32 //y=2.55 //x2=22.545 //y2=1.77
cc_6492 ( N_SN_c_8092_n N_noxref_42_c_15928_n ) capacitor c=0.00803439f \
 //x=22.15 //y=2.4 //x2=22.545 //y2=1.77
cc_6493 ( N_SN_c_8145_n N_noxref_42_c_15928_n ) capacitor c=0.0015541f \
 //x=27.285 //y=2.385 //x2=22.545 //y2=1.77
cc_6494 ( N_SN_c_8147_n N_noxref_42_c_15928_n ) capacitor c=0.0105652f \
 //x=22.32 //y=2.26 //x2=22.545 //y2=1.77
cc_6495 ( N_SN_c_8160_n N_noxref_42_c_15928_n ) capacitor c=0.0154243f \
 //x=21.885 //y=1.4 //x2=22.545 //y2=1.77
cc_6496 ( N_SN_c_8165_n N_noxref_42_c_15928_n ) capacitor c=0.0195973f \
 //x=22.41 //y=2.095 //x2=22.545 //y2=1.77
cc_6497 ( N_SN_c_8092_n N_noxref_42_M12_noxref_s ) capacitor c=0.00444844f \
 //x=22.15 //y=2.4 //x2=20.555 //y2=0.555
cc_6498 ( N_SN_c_8145_n N_noxref_42_M12_noxref_s ) capacitor c=0.00383739f \
 //x=27.285 //y=2.385 //x2=20.555 //y2=0.555
cc_6499 ( N_SN_c_8157_n N_noxref_42_M12_noxref_s ) capacitor c=0.00798959f \
 //x=21.885 //y=1.09 //x2=20.555 //y2=0.555
cc_6500 ( N_SN_c_8164_n N_noxref_42_M12_noxref_s ) capacitor c=0.00212176f \
 //x=22.41 //y=1.63 //x2=20.555 //y2=0.555
cc_6501 ( N_SN_c_8165_n N_noxref_42_M12_noxref_s ) capacitor c=0.00298115f \
 //x=22.41 //y=2.095 //x2=20.555 //y2=0.555
cc_6502 ( N_SN_c_8145_n N_noxref_43_c_15993_n ) capacitor c=0.00442321f \
 //x=27.285 //y=2.385 //x2=25.605 //y2=1.675
cc_6503 ( N_SN_c_8145_n N_noxref_43_c_15994_n ) capacitor c=0.0129476f \
 //x=27.285 //y=2.385 //x2=26.49 //y2=1.76
cc_6504 ( N_SN_c_8145_n N_noxref_43_c_15971_n ) capacitor c=0.00418562f \
 //x=27.285 //y=2.385 //x2=26.575 //y2=1.675
cc_6505 ( N_SN_c_8145_n N_noxref_43_c_15972_n ) capacitor c=0.00104143f \
 //x=27.285 //y=2.385 //x2=27.46 //y2=0.71
cc_6506 ( N_SN_c_8265_n N_noxref_43_M15_noxref_s ) capacitor c=0.00107763f \
 //x=27.715 //y=2.385 //x2=25.47 //y2=0.545
cc_6507 ( N_SN_c_8273_n N_noxref_44_c_16038_n ) capacitor c=0.00444844f \
 //x=28.965 //y=2.4 //x2=28.83 //y2=1.685
cc_6508 ( N_SN_c_8273_n N_noxref_44_c_16039_n ) capacitor c=0.00792781f \
 //x=28.965 //y=2.4 //x2=29.715 //y2=1.77
cc_6509 ( N_SN_c_8275_n N_noxref_44_c_16039_n ) capacitor c=0.00538132f \
 //x=29.565 //y=2.385 //x2=29.715 //y2=1.77
cc_6510 ( N_SN_c_8282_n N_noxref_44_c_16052_n ) capacitor c=0.0118677f \
 //x=33.775 //y=2.4 //x2=30.685 //y2=1.77
cc_6511 ( N_SN_c_8275_n N_noxref_44_M17_noxref_s ) capacitor c=0.00443645f \
 //x=29.565 //y=2.385 //x2=28.695 //y2=0.555
cc_6512 ( N_SN_c_8282_n N_noxref_44_M17_noxref_s ) capacitor c=0.00383739f \
 //x=33.775 //y=2.4 //x2=28.695 //y2=0.555
cc_6513 ( N_SN_c_8282_n N_noxref_45_c_16098_n ) capacitor c=0.00444844f \
 //x=33.775 //y=2.4 //x2=33.64 //y2=1.685
cc_6514 ( N_SN_c_8282_n N_noxref_45_c_16099_n ) capacitor c=0.00809728f \
 //x=33.775 //y=2.4 //x2=34.525 //y2=1.77
cc_6515 ( N_SN_c_8285_n N_noxref_45_c_16099_n ) capacitor c=0.00383928f \
 //x=34.375 //y=2.39 //x2=34.525 //y2=1.77
cc_6516 ( N_SN_c_8291_n N_noxref_45_c_16099_n ) capacitor c=0.00147953f \
 //x=35.43 //y=2.4 //x2=34.525 //y2=1.77
cc_6517 ( N_SN_c_8303_n N_noxref_45_c_16114_n ) capacitor c=0.0167228f \
 //x=34.835 //y=1.09 //x2=35.495 //y2=0.72
cc_6518 ( N_SN_c_8308_n N_noxref_45_c_16114_n ) capacitor c=0.00534519f \
 //x=35.36 //y=1.09 //x2=35.495 //y2=0.72
cc_6519 ( N_SN_c_8253_n N_noxref_45_c_16116_n ) capacitor c=0.00751795f \
 //x=35.27 //y=2.55 //x2=35.495 //y2=1.77
cc_6520 ( N_SN_c_8324_n N_noxref_45_c_16116_n ) capacitor c=0.00129557f \
 //x=46.57 //y=2.4 //x2=35.495 //y2=1.77
cc_6521 ( N_SN_c_8291_n N_noxref_45_c_16116_n ) capacitor c=0.00822881f \
 //x=35.43 //y=2.4 //x2=35.495 //y2=1.77
cc_6522 ( N_SN_c_8293_n N_noxref_45_c_16116_n ) capacitor c=0.0105652f \
 //x=35.27 //y=2.26 //x2=35.495 //y2=1.77
cc_6523 ( N_SN_c_8306_n N_noxref_45_c_16116_n ) capacitor c=0.0154024f \
 //x=34.835 //y=1.4 //x2=35.495 //y2=1.77
cc_6524 ( N_SN_c_8311_n N_noxref_45_c_16116_n ) capacitor c=0.0211955f \
 //x=35.36 //y=2.095 //x2=35.495 //y2=1.77
cc_6525 ( N_SN_c_8324_n N_noxref_45_M20_noxref_s ) capacitor c=0.00383739f \
 //x=46.57 //y=2.4 //x2=33.505 //y2=0.555
cc_6526 ( N_SN_c_8291_n N_noxref_45_M20_noxref_s ) capacitor c=0.00444844f \
 //x=35.43 //y=2.4 //x2=33.505 //y2=0.555
cc_6527 ( N_SN_c_8303_n N_noxref_45_M20_noxref_s ) capacitor c=0.00798959f \
 //x=34.835 //y=1.09 //x2=33.505 //y2=0.555
cc_6528 ( N_SN_c_8310_n N_noxref_45_M20_noxref_s ) capacitor c=0.00212176f \
 //x=35.36 //y=1.63 //x2=33.505 //y2=0.555
cc_6529 ( N_SN_c_8311_n N_noxref_45_M20_noxref_s ) capacitor c=0.00298115f \
 //x=35.36 //y=2.095 //x2=33.505 //y2=0.555
cc_6530 ( N_SN_c_8324_n N_noxref_46_c_16158_n ) capacitor c=0.00442321f \
 //x=46.57 //y=2.4 //x2=38.555 //y2=1.675
cc_6531 ( N_SN_c_8324_n N_noxref_46_c_16159_n ) capacitor c=0.0128878f \
 //x=46.57 //y=2.4 //x2=39.44 //y2=1.76
cc_6532 ( N_SN_c_8324_n N_noxref_46_c_16166_n ) capacitor c=0.00413037f \
 //x=46.57 //y=2.4 //x2=39.525 //y2=1.675
cc_6533 ( N_SN_c_8324_n N_noxref_46_c_16171_n ) capacitor c=0.00104143f \
 //x=46.57 //y=2.4 //x2=40.41 //y2=0.71
cc_6534 ( N_SN_c_8324_n N_noxref_46_M23_noxref_s ) capacitor c=0.0010705f \
 //x=46.57 //y=2.4 //x2=38.42 //y2=0.545
cc_6535 ( N_SN_c_8324_n N_noxref_47_c_16224_n ) capacitor c=0.00442321f \
 //x=46.57 //y=2.4 //x2=41.885 //y2=1.675
cc_6536 ( N_SN_c_8324_n N_noxref_47_c_16225_n ) capacitor c=0.0129144f \
 //x=46.57 //y=2.4 //x2=42.77 //y2=1.76
cc_6537 ( N_SN_c_8324_n N_noxref_47_c_16232_n ) capacitor c=0.00420772f \
 //x=46.57 //y=2.4 //x2=42.855 //y2=1.675
cc_6538 ( N_SN_c_8324_n N_noxref_47_c_16237_n ) capacitor c=0.00104143f \
 //x=46.57 //y=2.4 //x2=43.74 //y2=0.71
cc_6539 ( N_SN_c_8324_n N_noxref_47_M25_noxref_s ) capacitor c=0.0010705f \
 //x=46.57 //y=2.4 //x2=41.75 //y2=0.545
cc_6540 ( N_SN_c_8324_n N_noxref_48_c_16292_n ) capacitor c=0.00444844f \
 //x=46.57 //y=2.4 //x2=45.11 //y2=1.685
cc_6541 ( N_SN_c_8324_n N_noxref_48_c_16293_n ) capacitor c=0.0133215f \
 //x=46.57 //y=2.4 //x2=45.995 //y2=1.77
cc_6542 ( N_SN_c_8397_n N_noxref_48_c_16306_n ) capacitor c=0.0167228f \
 //x=46.305 //y=1.09 //x2=46.965 //y2=0.72
cc_6543 ( N_SN_c_8402_n N_noxref_48_c_16306_n ) capacitor c=0.00534519f \
 //x=46.83 //y=1.09 //x2=46.965 //y2=0.72
cc_6544 ( N_SN_c_8360_n N_noxref_48_c_16308_n ) capacitor c=0.00743214f \
 //x=46.74 //y=2.55 //x2=46.965 //y2=1.77
cc_6545 ( N_SN_c_8324_n N_noxref_48_c_16308_n ) capacitor c=0.00803439f \
 //x=46.57 //y=2.4 //x2=46.965 //y2=1.77
cc_6546 ( N_SN_c_8385_n N_noxref_48_c_16308_n ) capacitor c=0.0015541f \
 //x=51.705 //y=2.385 //x2=46.965 //y2=1.77
cc_6547 ( N_SN_c_8387_n N_noxref_48_c_16308_n ) capacitor c=0.0105652f \
 //x=46.74 //y=2.26 //x2=46.965 //y2=1.77
cc_6548 ( N_SN_c_8400_n N_noxref_48_c_16308_n ) capacitor c=0.0154243f \
 //x=46.305 //y=1.4 //x2=46.965 //y2=1.77
cc_6549 ( N_SN_c_8405_n N_noxref_48_c_16308_n ) capacitor c=0.0213174f \
 //x=46.83 //y=2.095 //x2=46.965 //y2=1.77
cc_6550 ( N_SN_c_8324_n N_noxref_48_M27_noxref_s ) capacitor c=0.00444844f \
 //x=46.57 //y=2.4 //x2=44.975 //y2=0.555
cc_6551 ( N_SN_c_8385_n N_noxref_48_M27_noxref_s ) capacitor c=0.00383739f \
 //x=51.705 //y=2.385 //x2=44.975 //y2=0.555
cc_6552 ( N_SN_c_8397_n N_noxref_48_M27_noxref_s ) capacitor c=0.00798959f \
 //x=46.305 //y=1.09 //x2=44.975 //y2=0.555
cc_6553 ( N_SN_c_8404_n N_noxref_48_M27_noxref_s ) capacitor c=0.00212176f \
 //x=46.83 //y=1.63 //x2=44.975 //y2=0.555
cc_6554 ( N_SN_c_8405_n N_noxref_48_M27_noxref_s ) capacitor c=0.00298115f \
 //x=46.83 //y=2.095 //x2=44.975 //y2=0.555
cc_6555 ( N_SN_c_8385_n N_noxref_49_c_16351_n ) capacitor c=0.00442321f \
 //x=51.705 //y=2.385 //x2=50.025 //y2=1.675
cc_6556 ( N_SN_c_8385_n N_noxref_49_c_16352_n ) capacitor c=0.0128409f \
 //x=51.705 //y=2.385 //x2=50.91 //y2=1.76
cc_6557 ( N_SN_c_8385_n N_noxref_49_c_16359_n ) capacitor c=0.00418562f \
 //x=51.705 //y=2.385 //x2=50.995 //y2=1.675
cc_6558 ( N_SN_c_8385_n N_noxref_49_c_16364_n ) capacitor c=0.00104143f \
 //x=51.705 //y=2.385 //x2=51.88 //y2=0.71
cc_6559 ( N_SN_c_8506_n N_noxref_49_M30_noxref_s ) capacitor c=0.00107763f \
 //x=52.135 //y=2.385 //x2=49.89 //y2=0.545
cc_6560 ( N_SN_c_8514_n N_noxref_50_c_16418_n ) capacitor c=0.00444844f \
 //x=53.385 //y=2.4 //x2=53.25 //y2=1.685
cc_6561 ( N_SN_c_8514_n N_noxref_50_c_16419_n ) capacitor c=0.00792781f \
 //x=53.385 //y=2.4 //x2=54.135 //y2=1.77
cc_6562 ( N_SN_c_8515_n N_noxref_50_c_16419_n ) capacitor c=0.00538132f \
 //x=53.985 //y=2.385 //x2=54.135 //y2=1.77
cc_6563 ( N_SN_c_8516_n N_noxref_50_c_16432_n ) capacitor c=0.0118677f \
 //x=58.195 //y=2.4 //x2=55.105 //y2=1.77
cc_6564 ( N_SN_c_8515_n N_noxref_50_M32_noxref_s ) capacitor c=0.00443645f \
 //x=53.985 //y=2.385 //x2=53.115 //y2=0.555
cc_6565 ( N_SN_c_8516_n N_noxref_50_M32_noxref_s ) capacitor c=0.00383739f \
 //x=58.195 //y=2.4 //x2=53.115 //y2=0.555
cc_6566 ( N_SN_c_8516_n N_noxref_51_c_16478_n ) capacitor c=0.00444844f \
 //x=58.195 //y=2.4 //x2=58.06 //y2=1.685
cc_6567 ( N_SN_c_8516_n N_noxref_51_c_16479_n ) capacitor c=0.00809728f \
 //x=58.195 //y=2.4 //x2=58.945 //y2=1.77
cc_6568 ( N_SN_c_8517_n N_noxref_51_c_16479_n ) capacitor c=0.00383928f \
 //x=58.795 //y=2.39 //x2=58.945 //y2=1.77
cc_6569 ( N_SN_c_8518_n N_noxref_51_c_16479_n ) capacitor c=0.00147953f \
 //x=59.85 //y=2.4 //x2=58.945 //y2=1.77
cc_6570 ( N_SN_c_8633_n N_noxref_51_c_16494_n ) capacitor c=0.0167228f \
 //x=59.255 //y=1.09 //x2=59.915 //y2=0.72
cc_6571 ( N_SN_c_8638_n N_noxref_51_c_16494_n ) capacitor c=0.00534519f \
 //x=59.78 //y=1.09 //x2=59.915 //y2=0.72
cc_6572 ( N_SN_c_8500_n N_noxref_51_c_16496_n ) capacitor c=0.00751795f \
 //x=59.69 //y=2.55 //x2=59.915 //y2=1.77
cc_6573 ( N_SN_c_8518_n N_noxref_51_c_16496_n ) capacitor c=0.00822881f \
 //x=59.85 //y=2.4 //x2=59.915 //y2=1.77
cc_6574 ( N_SN_c_8521_n N_noxref_51_c_16496_n ) capacitor c=0.00129557f \
 //x=70.99 //y=2.39 //x2=59.915 //y2=1.77
cc_6575 ( N_SN_c_8623_n N_noxref_51_c_16496_n ) capacitor c=0.0105652f \
 //x=59.69 //y=2.26 //x2=59.915 //y2=1.77
cc_6576 ( N_SN_c_8636_n N_noxref_51_c_16496_n ) capacitor c=0.0154024f \
 //x=59.255 //y=1.4 //x2=59.915 //y2=1.77
cc_6577 ( N_SN_c_8641_n N_noxref_51_c_16496_n ) capacitor c=0.0211955f \
 //x=59.78 //y=2.095 //x2=59.915 //y2=1.77
cc_6578 ( N_SN_c_8518_n N_noxref_51_M35_noxref_s ) capacitor c=0.00444844f \
 //x=59.85 //y=2.4 //x2=57.925 //y2=0.555
cc_6579 ( N_SN_c_8521_n N_noxref_51_M35_noxref_s ) capacitor c=0.00383739f \
 //x=70.99 //y=2.39 //x2=57.925 //y2=0.555
cc_6580 ( N_SN_c_8633_n N_noxref_51_M35_noxref_s ) capacitor c=0.00798959f \
 //x=59.255 //y=1.09 //x2=57.925 //y2=0.555
cc_6581 ( N_SN_c_8640_n N_noxref_51_M35_noxref_s ) capacitor c=0.00212176f \
 //x=59.78 //y=1.63 //x2=57.925 //y2=0.555
cc_6582 ( N_SN_c_8641_n N_noxref_51_M35_noxref_s ) capacitor c=0.00298115f \
 //x=59.78 //y=2.095 //x2=57.925 //y2=0.555
cc_6583 ( N_SN_c_8521_n N_noxref_52_c_16538_n ) capacitor c=0.00442321f \
 //x=70.99 //y=2.39 //x2=62.975 //y2=1.675
cc_6584 ( N_SN_c_8521_n N_noxref_52_c_16539_n ) capacitor c=0.0128878f \
 //x=70.99 //y=2.39 //x2=63.86 //y2=1.76
cc_6585 ( N_SN_c_8521_n N_noxref_52_c_16546_n ) capacitor c=0.00413037f \
 //x=70.99 //y=2.39 //x2=63.945 //y2=1.675
cc_6586 ( N_SN_c_8521_n N_noxref_52_c_16553_n ) capacitor c=0.00104143f \
 //x=70.99 //y=2.39 //x2=64.83 //y2=0.71
cc_6587 ( N_SN_c_8521_n N_noxref_52_M38_noxref_s ) capacitor c=0.0010705f \
 //x=70.99 //y=2.39 //x2=62.84 //y2=0.545
cc_6588 ( N_SN_c_8521_n N_noxref_53_c_16604_n ) capacitor c=0.00442321f \
 //x=70.99 //y=2.39 //x2=66.305 //y2=1.675
cc_6589 ( N_SN_c_8521_n N_noxref_53_c_16605_n ) capacitor c=0.0128584f \
 //x=70.99 //y=2.39 //x2=67.19 //y2=1.76
cc_6590 ( N_SN_c_8521_n N_noxref_53_c_16612_n ) capacitor c=0.00414142f \
 //x=70.99 //y=2.39 //x2=67.275 //y2=1.675
cc_6591 ( N_SN_c_8521_n N_noxref_53_c_16617_n ) capacitor c=0.00102833f \
 //x=70.99 //y=2.39 //x2=68.16 //y2=0.71
cc_6592 ( N_SN_c_8521_n N_noxref_53_M40_noxref_s ) capacitor c=9.44975e-19 \
 //x=70.99 //y=2.39 //x2=66.17 //y2=0.545
cc_6593 ( N_SN_c_8521_n N_noxref_54_c_16672_n ) capacitor c=0.00444844f \
 //x=70.99 //y=2.39 //x2=69.53 //y2=1.685
cc_6594 ( N_SN_c_8521_n N_noxref_54_c_16673_n ) capacitor c=0.0130435f \
 //x=70.99 //y=2.39 //x2=70.415 //y2=1.77
cc_6595 ( N_SN_c_8748_n N_noxref_54_c_16686_n ) capacitor c=0.0167228f \
 //x=70.725 //y=1.09 //x2=71.385 //y2=0.72
cc_6596 ( N_SN_c_8753_n N_noxref_54_c_16686_n ) capacitor c=0.00534519f \
 //x=71.25 //y=1.09 //x2=71.385 //y2=0.72
cc_6597 ( N_SN_c_8501_n N_noxref_54_c_16670_n ) capacitor c=0.00743214f \
 //x=71.16 //y=2.55 //x2=71.385 //y2=1.77
cc_6598 ( N_SN_c_8521_n N_noxref_54_c_16670_n ) capacitor c=0.00803439f \
 //x=70.99 //y=2.39 //x2=71.385 //y2=1.77
cc_6599 ( N_SN_c_8737_n N_noxref_54_c_16670_n ) capacitor c=0.0105652f \
 //x=71.16 //y=2.26 //x2=71.385 //y2=1.77
cc_6600 ( N_SN_c_8751_n N_noxref_54_c_16670_n ) capacitor c=0.0154243f \
 //x=70.725 //y=1.4 //x2=71.385 //y2=1.77
cc_6601 ( N_SN_c_8756_n N_noxref_54_c_16670_n ) capacitor c=0.0196853f \
 //x=71.25 //y=2.095 //x2=71.385 //y2=1.77
cc_6602 ( N_SN_c_8521_n N_noxref_54_M42_noxref_s ) capacitor c=0.00444844f \
 //x=70.99 //y=2.39 //x2=69.395 //y2=0.555
cc_6603 ( N_SN_c_8748_n N_noxref_54_M42_noxref_s ) capacitor c=0.00798959f \
 //x=70.725 //y=1.09 //x2=69.395 //y2=0.555
cc_6604 ( N_SN_c_8755_n N_noxref_54_M42_noxref_s ) capacitor c=0.00212176f \
 //x=71.25 //y=1.63 //x2=69.395 //y2=0.555
cc_6605 ( N_SN_c_8756_n N_noxref_54_M42_noxref_s ) capacitor c=0.00298115f \
 //x=71.25 //y=2.095 //x2=69.395 //y2=0.555
cc_6606 ( N_noxref_19_c_9263_n N_noxref_20_c_9843_n ) capacitor c=0.00198353f \
 //x=64.87 //y=3.705 //x2=67.46 //y2=4.48
cc_6607 ( N_noxref_19_c_9307_n N_noxref_20_c_9843_n ) capacitor c=0.00124686f \
 //x=64.87 //y=5.295 //x2=67.46 //y2=4.48
cc_6608 ( N_noxref_19_c_9273_n N_noxref_20_c_9843_n ) capacitor c=0.0229731f \
 //x=72.11 //y=3.885 //x2=67.46 //y2=4.48
cc_6609 ( N_noxref_19_c_9572_n N_noxref_20_c_10036_n ) capacitor c=0.00168386f \
 //x=72.27 //y=4.045 //x2=72.115 //y2=5.335
cc_6610 ( N_noxref_19_M140_noxref_g N_noxref_20_c_10036_n ) capacitor \
 c=0.00952006f //x=72.01 //y=6.2 //x2=72.115 //y2=5.335
cc_6611 ( N_noxref_19_M140_noxref_g N_noxref_20_c_10056_n ) capacitor \
 c=0.00226521f //x=72.01 //y=6.2 //x2=72.23 //y2=5.56
cc_6612 ( N_noxref_19_M141_noxref_g N_noxref_20_c_10056_n ) capacitor \
 c=0.00368717f //x=72.45 //y=6.2 //x2=72.23 //y2=5.56
cc_6613 ( N_noxref_19_c_9572_n N_noxref_20_c_10058_n ) capacitor c=4.21338e-19 \
 //x=72.27 //y=4.045 //x2=72.925 //y2=5.335
cc_6614 ( N_noxref_19_c_9539_n N_noxref_20_c_10058_n ) capacitor c=0.00228791f \
 //x=72.27 //y=4.75 //x2=72.925 //y2=5.335
cc_6615 ( N_noxref_19_c_9593_n N_noxref_20_c_10058_n ) capacitor c=0.00130631f \
 //x=72.27 //y=4.88 //x2=72.925 //y2=5.335
cc_6616 ( N_noxref_19_M141_noxref_g N_noxref_20_c_10058_n ) capacitor \
 c=0.0108585f //x=72.45 //y=6.2 //x2=72.925 //y2=5.335
cc_6617 ( N_noxref_19_c_9605_n N_noxref_20_c_9844_n ) capacitor c=4.64015e-19 \
 //x=72.26 //y=1.095 //x2=72.525 //y2=1.305
cc_6618 ( N_noxref_19_c_9606_n N_noxref_20_c_9844_n ) capacitor c=0.0026012f \
 //x=72.26 //y=1.44 //x2=72.525 //y2=1.305
cc_6619 ( N_noxref_19_c_9639_p N_noxref_20_c_9844_n ) capacitor c=5.29969e-19 \
 //x=72.635 //y=0.94 //x2=72.525 //y2=1.305
cc_6620 ( N_noxref_19_c_9640_p N_noxref_20_c_9844_n ) capacitor c=5.31989e-19 \
 //x=72.635 //y=1.595 //x2=72.525 //y2=1.305
cc_6621 ( N_noxref_19_c_9641_p N_noxref_20_c_9844_n ) capacitor c=5.29003e-19 \
 //x=72.79 //y=1.095 //x2=72.525 //y2=1.305
cc_6622 ( N_noxref_19_c_9642_p N_noxref_20_c_9844_n ) capacitor c=0.00312555f \
 //x=72.79 //y=1.44 //x2=72.525 //y2=1.305
cc_6623 ( N_noxref_19_c_9606_n N_noxref_20_c_9960_n ) capacitor c=0.00127432f \
 //x=72.26 //y=1.44 //x2=72.525 //y2=1.76
cc_6624 ( N_noxref_19_c_9607_n N_noxref_20_c_9960_n ) capacitor c=0.00429966f \
 //x=72.26 //y=1.75 //x2=72.525 //y2=1.76
cc_6625 ( N_noxref_19_c_9640_p N_noxref_20_c_9960_n ) capacitor c=0.009385f \
 //x=72.635 //y=1.595 //x2=72.525 //y2=1.76
cc_6626 ( N_noxref_19_c_9642_p N_noxref_20_c_9960_n ) capacitor c=0.00346682f \
 //x=72.79 //y=1.44 //x2=72.525 //y2=1.76
cc_6627 ( N_noxref_19_c_9621_n N_noxref_20_c_9960_n ) capacitor c=0.00362297f \
 //x=72.27 //y=2.095 //x2=72.525 //y2=1.76
cc_6628 ( N_noxref_19_c_9640_p N_noxref_20_c_10073_n ) capacitor c=0.00194716f \
 //x=72.635 //y=1.595 //x2=72.925 //y2=1.845
cc_6629 ( N_noxref_19_c_9642_p N_noxref_20_c_10073_n ) capacitor c=0.00323576f \
 //x=72.79 //y=1.44 //x2=72.925 //y2=1.845
cc_6630 ( N_noxref_19_c_9264_n N_noxref_20_c_9846_n ) capacitor c=0.0153209f \
 //x=72.27 //y=2.375 //x2=73.01 //y2=4.455
cc_6631 ( N_noxref_19_c_9265_n N_noxref_20_c_9846_n ) capacitor c=0.0557141f \
 //x=72.27 //y=3.725 //x2=73.01 //y2=4.455
cc_6632 ( N_noxref_19_c_9572_n N_noxref_20_c_9846_n ) capacitor c=0.0148501f \
 //x=72.27 //y=4.045 //x2=73.01 //y2=4.455
cc_6633 ( N_noxref_19_c_9539_n N_noxref_20_c_9846_n ) capacitor c=0.0184906f \
 //x=72.27 //y=4.75 //x2=73.01 //y2=4.455
cc_6634 ( N_noxref_19_c_9578_n N_noxref_20_c_9846_n ) capacitor c=6.89957e-19 \
 //x=72.27 //y=3.88 //x2=73.01 //y2=4.455
cc_6635 ( N_noxref_19_c_9580_n N_noxref_20_c_9846_n ) capacitor c=0.00686827f \
 //x=72.27 //y=3.885 //x2=73.01 //y2=4.455
cc_6636 ( N_noxref_19_c_9590_n N_noxref_20_c_9846_n ) capacitor c=0.00163444f \
 //x=72.27 //y=2.26 //x2=73.01 //y2=4.455
cc_6637 ( N_noxref_19_c_9618_n N_noxref_20_c_9846_n ) capacitor c=0.0025845f \
 //x=72.27 //y=2.26 //x2=73.01 //y2=4.455
cc_6638 ( N_noxref_19_c_9621_n N_noxref_20_c_9846_n ) capacitor c=0.00282067f \
 //x=72.27 //y=2.095 //x2=73.01 //y2=4.455
cc_6639 ( N_noxref_19_c_9539_n N_noxref_20_c_10084_n ) capacitor c=0.0178544f \
 //x=72.27 //y=4.75 //x2=73.01 //y2=4.775
cc_6640 ( N_noxref_19_c_9593_n N_noxref_20_c_10084_n ) capacitor c=2.98004e-19 \
 //x=72.27 //y=4.88 //x2=73.01 //y2=4.775
cc_6641 ( N_noxref_19_c_9622_n N_noxref_20_c_10084_n ) capacitor c=8.81038e-19 \
 //x=72.27 //y=4.88 //x2=73.01 //y2=4.775
cc_6642 ( N_noxref_19_c_9539_n N_noxref_20_c_9849_n ) capacitor c=0.0132784f \
 //x=72.27 //y=4.75 //x2=73.01 //y2=5.25
cc_6643 ( N_noxref_19_c_9593_n N_noxref_20_c_9849_n ) capacitor c=0.00310255f \
 //x=72.27 //y=4.88 //x2=73.01 //y2=5.25
cc_6644 ( N_noxref_19_c_9622_n N_noxref_20_c_9849_n ) capacitor c=0.00659589f \
 //x=72.27 //y=4.88 //x2=73.01 //y2=5.25
cc_6645 ( N_noxref_19_c_9265_n N_noxref_20_c_9854_n ) capacitor c=0.00258005f \
 //x=72.27 //y=3.725 //x2=74.49 //y2=4.46
cc_6646 ( N_noxref_19_c_9539_n N_noxref_20_c_9854_n ) capacitor c=0.00124061f \
 //x=72.27 //y=4.75 //x2=74.49 //y2=4.46
cc_6647 ( N_noxref_19_c_9273_n N_noxref_20_c_9925_n ) capacitor c=0.00229177f \
 //x=72.11 //y=3.885 //x2=67.48 //y2=4.64
cc_6648 ( N_noxref_19_c_9539_n N_noxref_20_c_10093_n ) capacitor c=0.0221235f \
 //x=72.27 //y=4.75 //x2=72.23 //y2=5.335
cc_6649 ( N_noxref_19_c_9593_n N_noxref_20_c_10093_n ) capacitor c=0.00346456f \
 //x=72.27 //y=4.88 //x2=72.23 //y2=5.335
cc_6650 ( N_noxref_19_c_9622_n N_noxref_20_c_10093_n ) capacitor c=0.00203307f \
 //x=72.27 //y=4.88 //x2=72.23 //y2=5.335
cc_6651 ( N_noxref_19_c_9539_n N_noxref_20_c_10096_n ) capacitor c=5.72272e-19 \
 //x=72.27 //y=4.75 //x2=73.01 //y2=4.62
cc_6652 ( N_noxref_19_c_9593_n N_noxref_20_c_10096_n ) capacitor c=0.00168306f \
 //x=72.27 //y=4.88 //x2=73.01 //y2=4.62
cc_6653 ( N_noxref_19_c_9622_n N_noxref_20_c_10096_n ) capacitor c=0.00114985f \
 //x=72.27 //y=4.88 //x2=73.01 //y2=4.62
cc_6654 ( N_noxref_19_c_9273_n N_noxref_20_c_9929_n ) capacitor c=0.0153694f \
 //x=72.11 //y=3.885 //x2=67.64 //y2=4.64
cc_6655 ( N_noxref_19_c_9572_n N_noxref_20_c_9879_n ) capacitor c=0.00308009f \
 //x=72.27 //y=4.045 //x2=72.845 //y2=4.615
cc_6656 ( N_noxref_19_c_9539_n N_noxref_20_c_9879_n ) capacitor c=0.0297789f \
 //x=72.27 //y=4.75 //x2=72.845 //y2=4.615
cc_6657 ( N_noxref_19_c_9580_n N_noxref_20_c_9879_n ) capacitor c=0.015896f \
 //x=72.27 //y=3.885 //x2=72.845 //y2=4.615
cc_6658 ( N_noxref_19_c_9273_n N_noxref_20_c_9879_n ) capacitor c=0.201811f \
 //x=72.11 //y=3.885 //x2=72.845 //y2=4.615
cc_6659 ( N_noxref_19_c_9539_n N_noxref_20_c_10104_n ) capacitor c=0.00352589f \
 //x=72.27 //y=4.75 //x2=73.165 //y2=4.615
cc_6660 ( N_noxref_19_c_9539_n N_noxref_20_c_10105_n ) capacitor c=0.00217653f \
 //x=72.27 //y=4.75 //x2=72.23 //y2=5.56
cc_6661 ( N_noxref_19_c_9593_n N_noxref_20_c_10105_n ) capacitor c=0.00624059f \
 //x=72.27 //y=4.88 //x2=72.23 //y2=5.56
cc_6662 ( N_noxref_19_M140_noxref_g N_noxref_20_c_10105_n ) capacitor \
 c=0.0178885f //x=72.01 //y=6.2 //x2=72.23 //y2=5.56
cc_6663 ( N_noxref_19_M141_noxref_g N_noxref_20_c_10105_n ) capacitor \
 c=0.0188608f //x=72.45 //y=6.2 //x2=72.23 //y2=5.56
cc_6664 ( N_noxref_19_c_9622_n N_noxref_20_c_10105_n ) capacitor c=0.00375636f \
 //x=72.27 //y=4.88 //x2=72.23 //y2=5.56
cc_6665 ( N_noxref_19_c_9605_n N_noxref_20_M44_noxref_d ) capacitor \
 c=0.00137165f //x=72.26 //y=1.095 //x2=72.335 //y2=1.095
cc_6666 ( N_noxref_19_c_9606_n N_noxref_20_M44_noxref_d ) capacitor \
 c=0.00237422f //x=72.26 //y=1.44 //x2=72.335 //y2=1.095
cc_6667 ( N_noxref_19_c_9639_p N_noxref_20_M44_noxref_d ) capacitor \
 c=0.0020782f //x=72.635 //y=0.94 //x2=72.335 //y2=1.095
cc_6668 ( N_noxref_19_c_9640_p N_noxref_20_M44_noxref_d ) capacitor \
 c=0.00356097f //x=72.635 //y=1.595 //x2=72.335 //y2=1.095
cc_6669 ( N_noxref_19_c_9641_p N_noxref_20_M44_noxref_d ) capacitor \
 c=0.00139206f //x=72.79 //y=1.095 //x2=72.335 //y2=1.095
cc_6670 ( N_noxref_19_c_9642_p N_noxref_20_M44_noxref_d ) capacitor \
 c=0.00237422f //x=72.79 //y=1.44 //x2=72.335 //y2=1.095
cc_6671 ( N_noxref_19_c_9261_n N_noxref_21_c_10666_n ) capacitor c=7.62769e-19 \
 //x=55.99 //y=3.705 //x2=55.61 //y2=3.51
cc_6672 ( N_noxref_19_c_9261_n N_noxref_21_c_10672_n ) capacitor c=0.0217531f \
 //x=55.99 //y=3.705 //x2=56.21 //y2=3.48
cc_6673 ( N_noxref_19_c_9367_n N_noxref_21_c_10672_n ) capacitor c=0.00592109f \
 //x=55.99 //y=4.025 //x2=56.21 //y2=3.48
cc_6674 ( N_noxref_19_c_9266_n N_noxref_21_c_10672_n ) capacitor c=0.0527444f \
 //x=56.34 //y=3.88 //x2=56.21 //y2=3.48
cc_6675 ( N_noxref_19_c_9415_n N_noxref_21_c_10672_n ) capacitor c=0.0358686f \
 //x=56.155 //y=3.865 //x2=56.21 //y2=3.48
cc_6676 ( N_noxref_19_c_9262_n N_noxref_21_c_10673_n ) capacitor c=7.55725e-19 \
 //x=60.8 //y=3.705 //x2=60.415 //y2=3.51
cc_6677 ( N_noxref_19_c_9293_n N_noxref_21_c_10673_n ) capacitor c=0.00196428f \
 //x=60.8 //y=4.025 //x2=60.415 //y2=3.51
cc_6678 ( N_noxref_19_c_9413_n N_noxref_21_c_10673_n ) capacitor c=0.028687f \
 //x=56.94 //y=3.865 //x2=60.415 //y2=3.51
cc_6679 ( N_noxref_19_c_9267_n N_noxref_21_c_10673_n ) capacitor c=0.315523f \
 //x=60.96 //y=3.88 //x2=60.415 //y2=3.51
cc_6680 ( N_noxref_19_c_9262_n N_noxref_21_c_10676_n ) capacitor c=0.0217584f \
 //x=60.8 //y=3.705 //x2=61.015 //y2=3.48
cc_6681 ( N_noxref_19_c_9293_n N_noxref_21_c_10676_n ) capacitor c=0.00434524f \
 //x=60.8 //y=4.025 //x2=61.015 //y2=3.48
cc_6682 ( N_noxref_19_c_9267_n N_noxref_21_c_10676_n ) capacitor c=0.0358686f \
 //x=60.96 //y=3.88 //x2=61.015 //y2=3.48
cc_6683 ( N_noxref_19_c_9269_n N_noxref_21_c_10676_n ) capacitor c=0.315141f \
 //x=64.705 //y=3.865 //x2=61.015 //y2=3.48
cc_6684 ( N_noxref_19_c_9263_n N_noxref_21_c_10677_n ) capacitor c=6.1754e-19 \
 //x=64.87 //y=3.705 //x2=64.48 //y2=3.51
cc_6685 ( N_noxref_19_c_9391_n N_noxref_21_c_10677_n ) capacitor c=0.00158365f \
 //x=64.87 //y=4.025 //x2=64.48 //y2=3.51
cc_6686 ( N_noxref_19_c_9269_n N_noxref_21_c_10677_n ) capacitor c=0.010394f \
 //x=64.705 //y=3.865 //x2=64.48 //y2=3.51
cc_6687 ( N_noxref_19_c_9263_n N_noxref_21_c_10680_n ) capacitor c=0.023179f \
 //x=64.87 //y=3.705 //x2=65.08 //y2=3.48
cc_6688 ( N_noxref_19_c_9391_n N_noxref_21_c_10680_n ) capacitor c=0.00479601f \
 //x=64.87 //y=4.025 //x2=65.08 //y2=3.48
cc_6689 ( N_noxref_19_c_9418_n N_noxref_21_c_10680_n ) capacitor c=0.0358686f \
 //x=65.025 //y=3.865 //x2=65.08 //y2=3.48
cc_6690 ( N_noxref_19_c_9273_n N_noxref_21_c_10680_n ) capacitor c=0.609053f \
 //x=72.11 //y=3.885 //x2=65.08 //y2=3.48
cc_6691 ( N_noxref_19_c_9265_n N_noxref_21_c_10681_n ) capacitor c=2.52057e-19 \
 //x=72.27 //y=3.725 //x2=71.885 //y2=3.51
cc_6692 ( N_noxref_19_c_9572_n N_noxref_21_c_10681_n ) capacitor c=0.00202106f \
 //x=72.27 //y=4.045 //x2=71.885 //y2=3.51
cc_6693 ( N_noxref_19_c_9273_n N_noxref_21_c_10681_n ) capacitor c=0.0108473f \
 //x=72.11 //y=3.885 //x2=71.885 //y2=3.51
cc_6694 ( N_noxref_19_c_9265_n N_noxref_21_c_10682_n ) capacitor c=0.0215852f \
 //x=72.27 //y=3.725 //x2=72.485 //y2=3.5
cc_6695 ( N_noxref_19_c_9572_n N_noxref_21_c_10682_n ) capacitor c=0.00435339f \
 //x=72.27 //y=4.045 //x2=72.485 //y2=3.5
cc_6696 ( N_noxref_19_c_9580_n N_noxref_21_c_10682_n ) capacitor c=0.0358686f \
 //x=72.27 //y=3.885 //x2=72.485 //y2=3.5
cc_6697 ( N_noxref_19_c_9301_n N_VDD_c_11522_n ) capacitor c=0.00648297f \
 //x=64.275 //y=5.38 //x2=74.455 //y2=7.585
cc_6698 ( N_noxref_19_c_9383_n N_VDD_c_11522_n ) capacitor c=0.00492578f \
 //x=64.785 //y=5.38 //x2=74.455 //y2=7.585
cc_6699 ( N_noxref_19_c_9391_n N_VDD_c_11522_n ) capacitor c=2.03815e-19 \
 //x=64.87 //y=4.025 //x2=74.455 //y2=7.585
cc_6700 ( N_noxref_19_c_9310_n N_VDD_c_11522_n ) capacitor c=0.00368834f \
 //x=63.51 //y=5.56 //x2=74.455 //y2=7.585
cc_6701 ( N_noxref_19_c_9400_n N_VDD_c_11522_n ) capacitor c=8.42537e-19 \
 //x=64.39 //y=5.38 //x2=74.455 //y2=7.585
cc_6702 ( N_noxref_19_c_9541_n N_VDD_c_11522_n ) capacitor c=0.00285853f \
 //x=64.39 //y=5.56 //x2=74.455 //y2=7.585
cc_6703 ( N_noxref_19_c_9327_n N_VDD_c_11522_n ) capacitor c=0.00224881f \
 //x=63.51 //y=5.56 //x2=74.455 //y2=7.585
cc_6704 ( N_noxref_19_c_9426_n N_VDD_c_11522_n ) capacitor c=0.00224881f \
 //x=64.39 //y=5.56 //x2=74.455 //y2=7.585
cc_6705 ( N_noxref_19_M120_noxref_g N_VDD_c_12421_n ) capacitor c=0.00755544f \
 //x=55.73 //y=6.2 //x2=56.305 //y2=7.585
cc_6706 ( N_noxref_19_M121_noxref_g N_VDD_c_12421_n ) capacitor c=0.00755754f \
 //x=56.17 //y=6.2 //x2=56.305 //y2=7.585
cc_6707 ( N_noxref_19_M126_noxref_g N_VDD_c_12300_n ) capacitor c=0.00755544f \
 //x=60.54 //y=6.2 //x2=61.115 //y2=7.585
cc_6708 ( N_noxref_19_M127_noxref_g N_VDD_c_12300_n ) capacitor c=0.00755754f \
 //x=60.98 //y=6.2 //x2=61.115 //y2=7.585
cc_6709 ( N_noxref_19_c_9301_n N_VDD_c_12305_n ) capacitor c=0.00208087f \
 //x=64.275 //y=5.38 //x2=63.865 //y2=7.585
cc_6710 ( N_noxref_19_c_9310_n N_VDD_c_12305_n ) capacitor c=9.41185e-19 \
 //x=63.51 //y=5.56 //x2=63.865 //y2=7.585
cc_6711 ( N_noxref_19_c_9327_n N_VDD_c_12305_n ) capacitor c=0.0136705f \
 //x=63.51 //y=5.56 //x2=63.865 //y2=7.585
cc_6712 ( N_noxref_19_c_9301_n N_VDD_c_12343_n ) capacitor c=0.00180737f \
 //x=64.275 //y=5.38 //x2=64.745 //y2=7.585
cc_6713 ( N_noxref_19_c_9383_n N_VDD_c_12343_n ) capacitor c=0.00208087f \
 //x=64.785 //y=5.38 //x2=64.745 //y2=7.585
cc_6714 ( N_noxref_19_c_9400_n N_VDD_c_12343_n ) capacitor c=4.23719e-19 \
 //x=64.39 //y=5.38 //x2=64.745 //y2=7.585
cc_6715 ( N_noxref_19_c_9541_n N_VDD_c_12343_n ) capacitor c=5.77976e-19 \
 //x=64.39 //y=5.56 //x2=64.745 //y2=7.585
cc_6716 ( N_noxref_19_c_9426_n N_VDD_c_12343_n ) capacitor c=0.0136705f \
 //x=64.39 //y=5.56 //x2=64.745 //y2=7.585
cc_6717 ( N_noxref_19_M140_noxref_g N_VDD_c_12579_n ) capacitor c=0.00755544f \
 //x=72.01 //y=6.2 //x2=72.585 //y2=7.585
cc_6718 ( N_noxref_19_M141_noxref_g N_VDD_c_12579_n ) capacitor c=0.00755754f \
 //x=72.45 //y=6.2 //x2=72.585 //y2=7.585
cc_6719 ( N_noxref_19_c_9423_n N_VDD_c_12252_n ) capacitor c=0.00224736f \
 //x=55.99 //y=4.88 //x2=57.47 //y2=7.585
cc_6720 ( N_noxref_19_c_9440_n N_VDD_c_12252_n ) capacitor c=2.63786e-19 \
 //x=55.99 //y=4.88 //x2=57.47 //y2=7.585
cc_6721 ( N_noxref_19_c_9307_n N_VDD_c_12310_n ) capacitor c=0.0013228f \
 //x=64.87 //y=5.295 //x2=62.28 //y2=7.585
cc_6722 ( N_noxref_19_c_9310_n N_VDD_c_12310_n ) capacitor c=4.91377e-19 \
 //x=63.51 //y=5.56 //x2=62.28 //y2=7.585
cc_6723 ( N_noxref_19_c_9323_n N_VDD_c_12310_n ) capacitor c=0.00224736f \
 //x=60.8 //y=4.88 //x2=62.28 //y2=7.585
cc_6724 ( N_noxref_19_c_9327_n N_VDD_c_12310_n ) capacitor c=0.0064135f \
 //x=63.51 //y=5.56 //x2=62.28 //y2=7.585
cc_6725 ( N_noxref_19_c_9359_n N_VDD_c_12310_n ) capacitor c=2.63786e-19 \
 //x=60.8 //y=4.88 //x2=62.28 //y2=7.585
cc_6726 ( N_noxref_19_c_9307_n N_VDD_c_12366_n ) capacitor c=0.0303363f \
 //x=64.87 //y=5.295 //x2=65.61 //y2=7.585
cc_6727 ( N_noxref_19_c_9400_n N_VDD_c_12366_n ) capacitor c=0.00240948f \
 //x=64.39 //y=5.38 //x2=65.61 //y2=7.585
cc_6728 ( N_noxref_19_c_9541_n N_VDD_c_12366_n ) capacitor c=4.09141e-19 \
 //x=64.39 //y=5.56 //x2=65.61 //y2=7.585
cc_6729 ( N_noxref_19_c_9426_n N_VDD_c_12366_n ) capacitor c=0.0101861f \
 //x=64.39 //y=5.56 //x2=65.61 //y2=7.585
cc_6730 ( N_noxref_19_c_9273_n N_VDD_c_12452_n ) capacitor c=0.00419973f \
 //x=72.11 //y=3.885 //x2=68.94 //y2=7.585
cc_6731 ( N_noxref_19_c_9593_n N_VDD_c_12155_n ) capacitor c=0.0018566f \
 //x=72.27 //y=4.88 //x2=73.75 //y2=7.585
cc_6732 ( N_noxref_19_c_9622_n N_VDD_c_12155_n ) capacitor c=2.63786e-19 \
 //x=72.27 //y=4.88 //x2=73.75 //y2=7.585
cc_6733 ( N_noxref_19_M120_noxref_g N_VDD_M119_noxref_d ) capacitor \
 c=0.015318f //x=55.73 //y=6.2 //x2=55.365 //y2=5.2
cc_6734 ( N_noxref_19_M121_noxref_g N_VDD_M121_noxref_d ) capacitor \
 c=0.0394719f //x=56.17 //y=6.2 //x2=56.245 //y2=5.2
cc_6735 ( N_noxref_19_M126_noxref_g N_VDD_M125_noxref_d ) capacitor \
 c=0.015318f //x=60.54 //y=6.2 //x2=60.175 //y2=5.2
cc_6736 ( N_noxref_19_M127_noxref_g N_VDD_M127_noxref_d ) capacitor \
 c=0.0394719f //x=60.98 //y=6.2 //x2=61.055 //y2=5.2
cc_6737 ( N_noxref_19_c_9310_n N_VDD_M128_noxref_s ) capacitor c=0.0611368f \
 //x=63.51 //y=5.56 //x2=62.935 //y2=5.2
cc_6738 ( N_noxref_19_c_9400_n N_VDD_M128_noxref_s ) capacitor c=6.52457e-19 \
 //x=64.39 //y=5.38 //x2=62.935 //y2=5.2
cc_6739 ( N_noxref_19_c_9327_n N_VDD_M128_noxref_s ) capacitor c=0.0887533f \
 //x=63.51 //y=5.56 //x2=62.935 //y2=5.2
cc_6740 ( N_noxref_19_c_9301_n N_VDD_M129_noxref_d ) capacitor c=0.00734094f \
 //x=64.275 //y=5.38 //x2=63.805 //y2=5.2
cc_6741 ( N_noxref_19_c_9310_n N_VDD_M129_noxref_d ) capacitor c=0.0043528f \
 //x=63.51 //y=5.56 //x2=63.805 //y2=5.2
cc_6742 ( N_noxref_19_c_9541_n N_VDD_M129_noxref_d ) capacitor c=0.0043528f \
 //x=64.39 //y=5.56 //x2=63.805 //y2=5.2
cc_6743 ( N_noxref_19_c_9327_n N_VDD_M129_noxref_d ) capacitor c=0.065554f \
 //x=63.51 //y=5.56 //x2=63.805 //y2=5.2
cc_6744 ( N_noxref_19_c_9426_n N_VDD_M129_noxref_d ) capacitor c=0.065554f \
 //x=64.39 //y=5.56 //x2=63.805 //y2=5.2
cc_6745 ( N_noxref_19_c_9383_n N_VDD_M131_noxref_d ) capacitor c=0.00898356f \
 //x=64.785 //y=5.38 //x2=64.685 //y2=5.2
cc_6746 ( N_noxref_19_c_9541_n N_VDD_M131_noxref_d ) capacitor c=0.00587834f \
 //x=64.39 //y=5.56 //x2=64.685 //y2=5.2
cc_6747 ( N_noxref_19_c_9411_n N_VDD_M131_noxref_d ) capacitor c=0.00122238f \
 //x=64.87 //y=3.88 //x2=64.685 //y2=5.2
cc_6748 ( N_noxref_19_c_9426_n N_VDD_M131_noxref_d ) capacitor c=0.065554f \
 //x=64.39 //y=5.56 //x2=64.685 //y2=5.2
cc_6749 ( N_noxref_19_c_9383_n N_VDD_M132_noxref_s ) capacitor c=0.00326953f \
 //x=64.785 //y=5.38 //x2=66.265 //y2=5.2
cc_6750 ( N_noxref_19_c_9400_n N_VDD_M132_noxref_s ) capacitor c=0.00515461f \
 //x=64.39 //y=5.38 //x2=66.265 //y2=5.2
cc_6751 ( N_noxref_19_c_9541_n N_VDD_M132_noxref_s ) capacitor c=3.28075e-19 \
 //x=64.39 //y=5.56 //x2=66.265 //y2=5.2
cc_6752 ( N_noxref_19_M140_noxref_g N_VDD_M139_noxref_d ) capacitor \
 c=0.015318f //x=72.01 //y=6.2 //x2=71.645 //y2=5.2
cc_6753 ( N_noxref_19_M141_noxref_g N_VDD_M141_noxref_d ) capacitor \
 c=0.0394719f //x=72.45 //y=6.2 //x2=72.525 //y2=5.2
cc_6754 ( N_noxref_19_c_9362_n N_noxref_30_c_13375_n ) capacitor c=0.00177186f \
 //x=55.99 //y=2.375 //x2=56.645 //y2=0.72
cc_6755 ( N_noxref_19_c_9419_n N_noxref_30_c_13375_n ) capacitor c=0.00117306f \
 //x=55.99 //y=2.26 //x2=56.645 //y2=0.72
cc_6756 ( N_noxref_19_c_9433_n N_noxref_30_c_13375_n ) capacitor c=0.0206349f \
 //x=55.98 //y=1.095 //x2=56.645 //y2=0.72
cc_6757 ( N_noxref_19_c_9521_n N_noxref_30_c_13375_n ) capacitor c=0.00825432f \
 //x=56.51 //y=1.095 //x2=56.645 //y2=0.72
cc_6758 ( N_noxref_19_c_9436_n N_noxref_30_c_13375_n ) capacitor c=2.20712e-19 \
 //x=55.99 //y=2.26 //x2=56.645 //y2=0.72
cc_6759 ( N_noxref_19_c_9434_n N_noxref_30_c_13378_n ) capacitor c=0.0071177f \
 //x=55.98 //y=1.44 //x2=55.76 //y2=1.175
cc_6760 ( N_noxref_19_c_9433_n N_noxref_30_M34_noxref_s ) capacitor \
 c=0.0071177f //x=55.98 //y=1.095 //x2=55.625 //y2=0.555
cc_6761 ( N_noxref_19_c_9435_n N_noxref_30_M34_noxref_s ) capacitor \
 c=0.0071177f //x=55.98 //y=1.75 //x2=55.625 //y2=0.555
cc_6762 ( N_noxref_19_c_9521_n N_noxref_30_M34_noxref_s ) capacitor \
 c=0.015333f //x=56.51 //y=1.095 //x2=55.625 //y2=0.555
cc_6763 ( N_noxref_19_c_9523_n N_noxref_30_M34_noxref_s ) capacitor \
 c=0.00248746f //x=56.51 //y=1.44 //x2=55.625 //y2=0.555
cc_6764 ( N_noxref_19_c_9285_n N_noxref_31_c_13426_n ) capacitor c=0.00177186f \
 //x=60.8 //y=2.375 //x2=61.455 //y2=0.72
cc_6765 ( N_noxref_19_c_9322_n N_noxref_31_c_13426_n ) capacitor c=0.00117306f \
 //x=60.8 //y=2.26 //x2=61.455 //y2=0.72
cc_6766 ( N_noxref_19_c_9338_n N_noxref_31_c_13426_n ) capacitor c=0.0206349f \
 //x=60.79 //y=1.095 //x2=61.455 //y2=0.72
cc_6767 ( N_noxref_19_c_9350_n N_noxref_31_c_13426_n ) capacitor c=0.00825432f \
 //x=61.32 //y=1.095 //x2=61.455 //y2=0.72
cc_6768 ( N_noxref_19_c_9356_n N_noxref_31_c_13426_n ) capacitor c=2.20712e-19 \
 //x=60.8 //y=2.26 //x2=61.455 //y2=0.72
cc_6769 ( N_noxref_19_c_9340_n N_noxref_31_c_13429_n ) capacitor c=0.0071177f \
 //x=60.79 //y=1.44 //x2=60.57 //y2=1.175
cc_6770 ( N_noxref_19_c_9293_n N_noxref_31_M37_noxref_s ) capacitor \
 c=9.75621e-19 //x=60.8 //y=4.025 //x2=60.435 //y2=0.555
cc_6771 ( N_noxref_19_c_9338_n N_noxref_31_M37_noxref_s ) capacitor \
 c=0.0071177f //x=60.79 //y=1.095 //x2=60.435 //y2=0.555
cc_6772 ( N_noxref_19_c_9343_n N_noxref_31_M37_noxref_s ) capacitor \
 c=0.0071177f //x=60.79 //y=1.75 //x2=60.435 //y2=0.555
cc_6773 ( N_noxref_19_c_9350_n N_noxref_31_M37_noxref_s ) capacitor \
 c=0.015333f //x=61.32 //y=1.095 //x2=60.435 //y2=0.555
cc_6774 ( N_noxref_19_c_9352_n N_noxref_31_M37_noxref_s ) capacitor \
 c=0.00248746f //x=61.32 //y=1.44 //x2=60.435 //y2=0.555
cc_6775 ( N_noxref_19_c_9264_n N_noxref_32_c_13495_n ) capacitor c=0.00177186f \
 //x=72.27 //y=2.375 //x2=72.925 //y2=0.72
cc_6776 ( N_noxref_19_c_9590_n N_noxref_32_c_13495_n ) capacitor c=0.00117306f \
 //x=72.27 //y=2.26 //x2=72.925 //y2=0.72
cc_6777 ( N_noxref_19_c_9605_n N_noxref_32_c_13495_n ) capacitor c=0.0206349f \
 //x=72.26 //y=1.095 //x2=72.925 //y2=0.72
cc_6778 ( N_noxref_19_c_9641_p N_noxref_32_c_13495_n ) capacitor c=0.00825432f \
 //x=72.79 //y=1.095 //x2=72.925 //y2=0.72
cc_6779 ( N_noxref_19_c_9618_n N_noxref_32_c_13495_n ) capacitor c=2.20712e-19 \
 //x=72.27 //y=2.26 //x2=72.925 //y2=0.72
cc_6780 ( N_noxref_19_c_9606_n N_noxref_32_c_13520_n ) capacitor c=0.0071177f \
 //x=72.26 //y=1.44 //x2=72.04 //y2=1.175
cc_6781 ( N_noxref_19_c_9572_n N_noxref_32_M44_noxref_s ) capacitor \
 c=9.72448e-19 //x=72.27 //y=4.045 //x2=71.905 //y2=0.555
cc_6782 ( N_noxref_19_c_9605_n N_noxref_32_M44_noxref_s ) capacitor \
 c=0.0071177f //x=72.26 //y=1.095 //x2=71.905 //y2=0.555
cc_6783 ( N_noxref_19_c_9607_n N_noxref_32_M44_noxref_s ) capacitor \
 c=0.0071177f //x=72.26 //y=1.75 //x2=71.905 //y2=0.555
cc_6784 ( N_noxref_19_c_9641_p N_noxref_32_M44_noxref_s ) capacitor \
 c=0.015333f //x=72.79 //y=1.095 //x2=71.905 //y2=0.555
cc_6785 ( N_noxref_19_c_9642_p N_noxref_32_M44_noxref_s ) capacitor \
 c=0.00248746f //x=72.79 //y=1.44 //x2=71.905 //y2=0.555
cc_6786 ( N_noxref_19_c_9362_n N_GND_c_14559_n ) capacitor c=0.00196498f \
 //x=55.99 //y=2.375 //x2=58.46 //y2=0.175
cc_6787 ( N_noxref_19_c_9285_n N_GND_c_14513_n ) capacitor c=0.00196498f \
 //x=60.8 //y=2.375 //x2=63.375 //y2=0.175
cc_6788 ( N_noxref_19_c_9384_n N_GND_c_14560_n ) capacitor c=0.00608539f \
 //x=64.785 //y=1.835 //x2=66.705 //y2=0.175
cc_6789 ( N_noxref_19_c_9318_n N_GND_c_14560_n ) capacitor c=0.00915339f \
 //x=64.43 //y=1.18 //x2=66.705 //y2=0.175
cc_6790 ( N_noxref_19_M39_noxref_d N_GND_c_14560_n ) capacitor c=3.01769e-19 \
 //x=64.24 //y=1.085 //x2=66.705 //y2=0.175
cc_6791 ( N_noxref_19_c_9264_n N_GND_c_14678_n ) capacitor c=0.0021992f \
 //x=72.27 //y=2.375 //x2=74.845 //y2=0.175
cc_6792 ( N_noxref_19_c_9572_n N_GND_c_14678_n ) capacitor c=2.82819e-19 \
 //x=72.27 //y=4.045 //x2=74.845 //y2=0.175
cc_6793 ( N_noxref_19_c_9310_n N_GND_c_14517_n ) capacitor c=7.42819e-19 \
 //x=63.51 //y=5.56 //x2=63.46 //y2=1.135
cc_6794 ( N_noxref_19_c_9318_n N_GND_c_14517_n ) capacitor c=0.0140211f \
 //x=64.43 //y=1.18 //x2=63.46 //y2=1.135
cc_6795 ( N_noxref_19_M39_noxref_d N_GND_c_14517_n ) capacitor c=2.93544e-19 \
 //x=64.24 //y=1.085 //x2=63.46 //y2=1.135
cc_6796 ( N_noxref_19_c_9318_n N_GND_c_14579_n ) capacitor c=0.00549186f \
 //x=64.43 //y=1.18 //x2=66.79 //y2=1.135
cc_6797 ( N_noxref_19_c_9362_n N_GND_c_14474_n ) capacitor c=2.016e-19 \
 //x=55.99 //y=2.375 //x2=57.3 //y2=0.175
cc_6798 ( N_noxref_19_c_9285_n N_GND_c_14475_n ) capacitor c=2.016e-19 \
 //x=60.8 //y=2.375 //x2=62.11 //y2=0.175
cc_6799 ( N_noxref_19_c_9384_n N_GND_c_14533_n ) capacitor c=7.77585e-19 \
 //x=64.785 //y=1.835 //x2=65.44 //y2=0.175
cc_6800 ( N_noxref_19_c_9264_n N_GND_c_14632_n ) capacitor c=2.016e-19 \
 //x=72.27 //y=2.375 //x2=73.58 //y2=0.175
cc_6801 ( N_noxref_19_c_9419_n N_GND_c_14333_n ) capacitor c=0.00216084f \
 //x=55.99 //y=2.26 //x2=57.47 //y2=0.175
cc_6802 ( N_noxref_19_c_9523_n N_GND_c_14333_n ) capacitor c=0.00262688f \
 //x=56.51 //y=1.44 //x2=57.47 //y2=0.175
cc_6803 ( N_noxref_19_c_9436_n N_GND_c_14333_n ) capacitor c=2.63786e-19 \
 //x=55.99 //y=2.26 //x2=57.47 //y2=0.175
cc_6804 ( N_noxref_19_c_9263_n N_GND_c_14334_n ) capacitor c=9.32616e-19 \
 //x=64.87 //y=3.705 //x2=62.28 //y2=0.175
cc_6805 ( N_noxref_19_c_9322_n N_GND_c_14334_n ) capacitor c=0.00222376f \
 //x=60.8 //y=2.26 //x2=62.28 //y2=0.175
cc_6806 ( N_noxref_19_c_9352_n N_GND_c_14334_n ) capacitor c=0.00262688f \
 //x=61.32 //y=1.44 //x2=62.28 //y2=0.175
cc_6807 ( N_noxref_19_c_9356_n N_GND_c_14334_n ) capacitor c=2.63786e-19 \
 //x=60.8 //y=2.26 //x2=62.28 //y2=0.175
cc_6808 ( N_noxref_19_c_9302_n N_GND_c_14335_n ) capacitor c=0.002973f \
 //x=64.43 //y=1.75 //x2=65.61 //y2=0.175
cc_6809 ( N_noxref_19_c_9384_n N_GND_c_14335_n ) capacitor c=0.028425f \
 //x=64.785 //y=1.835 //x2=65.61 //y2=0.175
cc_6810 ( N_noxref_19_c_9590_n N_GND_c_14337_n ) capacitor c=0.00246191f \
 //x=72.27 //y=2.26 //x2=73.75 //y2=0.175
cc_6811 ( N_noxref_19_c_9642_p N_GND_c_14337_n ) capacitor c=0.00262688f \
 //x=72.79 //y=1.44 //x2=73.75 //y2=0.175
cc_6812 ( N_noxref_19_c_9318_n N_GND_M38_noxref_d ) capacitor c=2.82748e-19 \
 //x=64.43 //y=1.18 //x2=63.27 //y2=1.045
cc_6813 ( N_noxref_19_c_9303_n N_noxref_52_c_16546_n ) capacitor c=0.00911405f \
 //x=64.515 //y=1.835 //x2=63.945 //y2=1.675
cc_6814 ( N_noxref_19_c_9384_n N_noxref_52_c_16553_n ) capacitor c=0.00399245f \
 //x=64.785 //y=1.835 //x2=64.83 //y2=0.71
cc_6815 ( N_noxref_19_c_9318_n N_noxref_52_c_16553_n ) capacitor c=0.003751f \
 //x=64.43 //y=1.18 //x2=64.83 //y2=0.71
cc_6816 ( N_noxref_19_M39_noxref_d N_noxref_52_c_16553_n ) capacitor \
 c=0.00910163f //x=64.24 //y=1.085 //x2=64.83 //y2=0.71
cc_6817 ( N_noxref_19_c_9302_n N_noxref_52_M38_noxref_s ) capacitor c=0.01625f \
 //x=64.43 //y=1.75 //x2=62.84 //y2=0.545
cc_6818 ( N_noxref_19_c_9384_n N_noxref_52_M38_noxref_s ) capacitor \
 c=0.00670006f //x=64.785 //y=1.835 //x2=62.84 //y2=0.545
cc_6819 ( N_noxref_19_c_9391_n N_noxref_52_M38_noxref_s ) capacitor \
 c=3.24398e-19 //x=64.87 //y=4.025 //x2=62.84 //y2=0.545
cc_6820 ( N_noxref_19_c_9318_n N_noxref_52_M38_noxref_s ) capacitor \
 c=0.00905337f //x=64.43 //y=1.18 //x2=62.84 //y2=0.545
cc_6821 ( N_noxref_19_c_9411_n N_noxref_52_M38_noxref_s ) capacitor \
 c=8.42257e-19 //x=64.87 //y=3.88 //x2=62.84 //y2=0.545
cc_6822 ( N_noxref_19_M39_noxref_d N_noxref_52_M38_noxref_s ) capacitor \
 c=0.0275552f //x=64.24 //y=1.085 //x2=62.84 //y2=0.545
cc_6823 ( N_noxref_20_c_9864_n N_noxref_21_c_10636_n ) capacitor c=0.0033801f \
 //x=78.19 //y=2.385 //x2=79.67 //y2=2.43
cc_6824 ( N_noxref_20_c_9865_n N_noxref_21_c_10636_n ) capacitor c=5.52227e-19 \
 //x=78.19 //y=4.475 //x2=79.67 //y2=2.43
cc_6825 ( N_noxref_20_c_10118_p N_noxref_21_c_10636_n ) capacitor \
 c=5.86738e-19 //x=78.19 //y=2.26 //x2=79.67 //y2=2.43
cc_6826 ( N_noxref_20_c_9865_n N_noxref_21_c_10637_n ) capacitor c=0.0212137f \
 //x=78.19 //y=4.475 //x2=79.67 //y2=3.355
cc_6827 ( N_noxref_20_c_9865_n N_noxref_21_c_10639_n ) capacitor c=0.00405919f \
 //x=78.19 //y=4.475 //x2=79.67 //y2=3.675
cc_6828 ( N_noxref_20_c_9865_n N_noxref_21_c_10640_n ) capacitor c=0.0160593f \
 //x=78.19 //y=4.475 //x2=79.67 //y2=4.76
cc_6829 ( N_noxref_20_c_9875_n N_noxref_21_c_10640_n ) capacitor c=0.0047666f \
 //x=78.19 //y=4.62 //x2=79.67 //y2=4.76
cc_6830 ( N_noxref_20_c_9880_n N_noxref_21_c_10640_n ) capacitor c=0.00487822f \
 //x=78.195 //y=4.64 //x2=79.67 //y2=4.76
cc_6831 ( N_noxref_20_c_10124_p N_noxref_21_c_10640_n ) capacitor \
 c=0.00414268f //x=78.19 //y=4.62 //x2=79.67 //y2=4.76
cc_6832 ( N_noxref_20_c_10125_p N_noxref_21_c_10640_n ) capacitor \
 c=5.58186e-19 //x=78.19 //y=4.885 //x2=79.67 //y2=4.76
cc_6833 ( N_noxref_20_c_9865_n N_noxref_21_c_10649_n ) capacitor c=0.00234682f \
 //x=78.19 //y=4.475 //x2=81.15 //y2=4.755
cc_6834 ( N_noxref_20_c_9865_n N_noxref_21_c_10901_n ) capacitor c=0.00262054f \
 //x=78.19 //y=4.475 //x2=79.67 //y2=3.51
cc_6835 ( N_noxref_20_c_9843_n N_noxref_21_c_10681_n ) capacitor c=0.0206362f \
 //x=67.46 //y=4.48 //x2=71.885 //y2=3.51
cc_6836 ( N_noxref_20_c_9879_n N_noxref_21_c_10681_n ) capacitor c=0.0265343f \
 //x=72.845 //y=4.615 //x2=71.885 //y2=3.51
cc_6837 ( N_noxref_20_c_9846_n N_noxref_21_c_10682_n ) capacitor c=0.0272273f \
 //x=73.01 //y=4.455 //x2=72.485 //y2=3.5
cc_6838 ( N_noxref_20_c_10084_n N_noxref_21_c_10682_n ) capacitor \
 c=0.00306357f //x=73.01 //y=4.775 //x2=72.485 //y2=3.5
cc_6839 ( N_noxref_20_c_9854_n N_noxref_21_c_10682_n ) capacitor c=0.0283599f \
 //x=74.49 //y=4.46 //x2=72.485 //y2=3.5
cc_6840 ( N_noxref_20_c_9864_n N_noxref_21_c_10682_n ) capacitor c=0.00215162f \
 //x=78.19 //y=2.385 //x2=72.485 //y2=3.5
cc_6841 ( N_noxref_20_c_9865_n N_noxref_21_c_10682_n ) capacitor c=0.0348272f \
 //x=78.19 //y=4.475 //x2=72.485 //y2=3.5
cc_6842 ( N_noxref_20_c_9873_n N_noxref_21_c_10682_n ) capacitor c=0.00330809f \
 //x=74.49 //y=4.62 //x2=72.485 //y2=3.5
cc_6843 ( N_noxref_20_c_9877_n N_noxref_21_c_10682_n ) capacitor c=0.038991f \
 //x=74.335 //y=4.62 //x2=72.485 //y2=3.5
cc_6844 ( N_noxref_20_c_9878_n N_noxref_21_c_10682_n ) capacitor c=0.00837148f \
 //x=74.655 //y=4.62 //x2=72.485 //y2=3.5
cc_6845 ( N_noxref_20_c_9879_n N_noxref_21_c_10682_n ) capacitor c=0.00815078f \
 //x=72.845 //y=4.615 //x2=72.485 //y2=3.5
cc_6846 ( N_noxref_20_c_10104_n N_noxref_21_c_10682_n ) capacitor \
 c=0.00842199f //x=73.165 //y=4.615 //x2=72.485 //y2=3.5
cc_6847 ( N_noxref_20_c_9882_n N_noxref_21_c_10682_n ) capacitor c=0.0366247f \
 //x=78.035 //y=4.64 //x2=72.485 //y2=3.5
cc_6848 ( N_noxref_20_c_9864_n N_noxref_21_c_10688_n ) capacitor c=0.00564826f \
 //x=78.19 //y=2.385 //x2=79.835 //y2=2.27
cc_6849 ( N_noxref_20_c_9865_n N_noxref_21_c_10688_n ) capacitor c=8.70657e-19 \
 //x=78.19 //y=4.475 //x2=79.835 //y2=2.27
cc_6850 ( N_noxref_20_c_9864_n N_noxref_21_c_10917_n ) capacitor c=0.00362942f \
 //x=78.19 //y=2.385 //x2=79.67 //y2=2.26
cc_6851 ( N_noxref_20_c_9865_n N_noxref_21_c_10917_n ) capacitor c=3.10803e-19 \
 //x=78.19 //y=4.475 //x2=79.67 //y2=2.26
cc_6852 ( N_noxref_20_c_10118_p N_noxref_21_c_10917_n ) capacitor \
 c=3.19688e-19 //x=78.19 //y=2.26 //x2=79.67 //y2=2.26
cc_6853 ( N_noxref_20_c_10146_p N_noxref_21_c_10917_n ) capacitor \
 c=2.35599e-19 //x=77.995 //y=2.095 //x2=79.67 //y2=2.26
cc_6854 ( N_noxref_20_c_9875_n N_noxref_21_c_10921_n ) capacitor c=5.34267e-19 \
 //x=78.19 //y=4.62 //x2=79.67 //y2=4.885
cc_6855 ( N_noxref_20_c_10124_p N_noxref_21_c_10921_n ) capacitor c=8.5191e-19 \
 //x=78.19 //y=4.62 //x2=79.67 //y2=4.885
cc_6856 ( N_noxref_20_c_10125_p N_noxref_21_c_10921_n ) capacitor \
 c=2.35599e-19 //x=78.19 //y=4.885 //x2=79.67 //y2=4.885
cc_6857 ( N_noxref_20_M146_noxref_g N_noxref_21_M148_noxref_g ) capacitor \
 c=0.00948424f //x=78.08 //y=6.205 //x2=78.96 //y2=6.205
cc_6858 ( N_noxref_20_M147_noxref_g N_noxref_21_M148_noxref_g ) capacitor \
 c=0.0638434f //x=78.52 //y=6.205 //x2=78.96 //y2=6.205
cc_6859 ( N_noxref_20_M147_noxref_g N_noxref_21_M149_noxref_g ) capacitor \
 c=0.00878567f //x=78.52 //y=6.205 //x2=79.4 //y2=6.205
cc_6860 ( N_noxref_20_c_10153_p N_noxref_21_c_10927_n ) capacitor \
 c=4.86545e-19 //x=77.995 //y=1.045 //x2=78.965 //y2=1.085
cc_6861 ( N_noxref_20_c_10154_p N_noxref_21_c_10927_n ) capacitor \
 c=0.00152104f //x=77.995 //y=1.39 //x2=78.965 //y2=1.085
cc_6862 ( N_noxref_20_c_10155_p N_noxref_21_c_10927_n ) capacitor c=0.0159151f \
 //x=78.525 //y=1.045 //x2=78.965 //y2=1.085
cc_6863 ( N_noxref_20_c_10156_p N_noxref_21_c_10930_n ) capacitor \
 c=0.00109982f //x=77.995 //y=1.7 //x2=78.965 //y2=1.43
cc_6864 ( N_noxref_20_c_10157_p N_noxref_21_c_10930_n ) capacitor c=0.0158526f \
 //x=78.525 //y=1.39 //x2=78.965 //y2=1.43
cc_6865 ( N_noxref_20_c_10124_p N_noxref_21_c_10932_n ) capacitor \
 c=0.00110488f //x=78.19 //y=4.62 //x2=79.035 //y2=4.975
cc_6866 ( N_noxref_20_c_10125_p N_noxref_21_c_10932_n ) capacitor c=0.064577f \
 //x=78.19 //y=4.885 //x2=79.035 //y2=4.975
cc_6867 ( N_noxref_20_c_10124_p N_noxref_21_c_10934_n ) capacitor \
 c=2.35599e-19 //x=78.19 //y=4.62 //x2=79.4 //y2=5.05
cc_6868 ( N_noxref_20_c_10125_p N_noxref_21_c_10934_n ) capacitor \
 c=5.35364e-19 //x=78.19 //y=4.885 //x2=79.4 //y2=5.05
cc_6869 ( N_noxref_20_c_10155_p N_noxref_21_c_10936_n ) capacitor \
 c=0.00124821f //x=78.525 //y=1.045 //x2=79.495 //y2=1.085
cc_6870 ( N_noxref_20_c_10157_p N_noxref_21_c_10937_n ) capacitor \
 c=0.00150765f //x=78.525 //y=1.39 //x2=79.495 //y2=1.43
cc_6871 ( N_noxref_20_c_10157_p N_noxref_21_c_10938_n ) capacitor \
 c=4.38654e-19 //x=78.525 //y=1.39 //x2=79.495 //y2=1.74
cc_6872 ( N_noxref_20_c_10118_p N_noxref_21_c_10939_n ) capacitor \
 c=2.35599e-19 //x=78.19 //y=2.26 //x2=79.495 //y2=2.095
cc_6873 ( N_noxref_20_c_10146_p N_noxref_21_c_10939_n ) capacitor \
 c=4.61972e-19 //x=77.995 //y=2.095 //x2=79.495 //y2=2.095
cc_6874 ( N_noxref_20_c_9844_n N_noxref_22_c_11222_n ) capacitor c=3.61332e-19 \
 //x=72.525 //y=1.305 //x2=75.9 //y2=1.36
cc_6875 ( N_noxref_20_c_9960_n N_noxref_22_c_11222_n ) capacitor c=0.00113094f \
 //x=72.525 //y=1.76 //x2=75.9 //y2=1.36
cc_6876 ( N_noxref_20_c_9864_n N_noxref_22_c_11236_n ) capacitor c=0.00827671f \
 //x=78.19 //y=2.385 //x2=79.1 //y2=1.405
cc_6877 ( N_noxref_20_c_10154_p N_noxref_22_c_11236_n ) capacitor \
 c=0.00242807f //x=77.995 //y=1.39 //x2=79.1 //y2=1.405
cc_6878 ( N_noxref_20_c_10156_p N_noxref_22_c_11236_n ) capacitor \
 c=0.00151541f //x=77.995 //y=1.7 //x2=79.1 //y2=1.405
cc_6879 ( N_noxref_20_c_10157_p N_noxref_22_c_11236_n ) capacitor \
 c=0.00383702f //x=78.525 //y=1.39 //x2=79.1 //y2=1.405
cc_6880 ( N_noxref_20_c_9959_n N_VDD_c_11522_n ) capacitor c=0.00621363f \
 //x=71.23 //y=5.335 //x2=74.455 //y2=7.585
cc_6881 ( N_noxref_20_c_10036_n N_VDD_c_11522_n ) capacitor c=0.00627186f \
 //x=72.115 //y=5.335 //x2=74.455 //y2=7.585
cc_6882 ( N_noxref_20_c_10056_n N_VDD_c_11522_n ) capacitor c=0.00256019f \
 //x=72.23 //y=5.56 //x2=74.455 //y2=7.585
cc_6883 ( N_noxref_20_c_10058_n N_VDD_c_11522_n ) capacitor c=0.00829192f \
 //x=72.925 //y=5.335 //x2=74.455 //y2=7.585
cc_6884 ( N_noxref_20_c_10084_n N_VDD_c_11522_n ) capacitor c=2.23591e-19 \
 //x=73.01 //y=4.775 //x2=74.455 //y2=7.585
cc_6885 ( N_noxref_20_c_9971_n N_VDD_c_11522_n ) capacitor c=0.00261804f \
 //x=70.472 //y=5.335 //x2=74.455 //y2=7.585
cc_6886 ( N_noxref_20_c_10039_n N_VDD_c_11522_n ) capacitor c=0.00270108f \
 //x=71.35 //y=5.335 //x2=74.455 //y2=7.585
cc_6887 ( N_noxref_20_c_10096_n N_VDD_c_11522_n ) capacitor c=4.55286e-19 \
 //x=73.01 //y=4.62 //x2=74.455 //y2=7.585
cc_6888 ( N_noxref_20_c_9873_n N_VDD_c_11522_n ) capacitor c=2.89886e-19 \
 //x=74.49 //y=4.62 //x2=74.455 //y2=7.585
cc_6889 ( N_noxref_20_c_9992_n N_VDD_c_11522_n ) capacitor c=0.0024232f \
 //x=70.47 //y=5.56 //x2=74.455 //y2=7.585
cc_6890 ( N_noxref_20_c_10046_n N_VDD_c_11522_n ) capacitor c=0.0024232f \
 //x=71.35 //y=5.56 //x2=74.455 //y2=7.585
cc_6891 ( N_noxref_20_c_10105_n N_VDD_c_11522_n ) capacitor c=0.0024232f \
 //x=72.23 //y=5.56 //x2=74.455 //y2=7.585
cc_6892 ( N_noxref_20_M142_noxref_g N_VDD_c_12628_n ) capacitor c=0.00374549f \
 //x=74.76 //y=6.205 //x2=74.54 //y2=7.035
cc_6893 ( N_noxref_20_M142_noxref_g N_VDD_c_12629_n ) capacitor c=0.00441594f \
 //x=74.76 //y=6.205 //x2=74.54 //y2=7.41
cc_6894 ( N_noxref_20_M143_noxref_g N_VDD_c_12121_n ) capacitor c=0.00123273f \
 //x=75.2 //y=6.205 //x2=75.42 //y2=7.035
cc_6895 ( N_noxref_20_M143_noxref_g N_VDD_c_12122_n ) capacitor c=0.00137209f \
 //x=75.2 //y=6.205 //x2=75.42 //y2=7.41
cc_6896 ( N_noxref_20_M134_noxref_g N_VDD_c_12491_n ) capacitor c=0.00697352f \
 //x=67.5 //y=6.2 //x2=68.075 //y2=7.585
cc_6897 ( N_noxref_20_M135_noxref_g N_VDD_c_12491_n ) capacitor c=0.00755544f \
 //x=67.94 //y=6.2 //x2=68.075 //y2=7.585
cc_6898 ( N_noxref_20_c_9959_n N_VDD_c_12497_n ) capacitor c=0.00202922f \
 //x=71.23 //y=5.335 //x2=70.825 //y2=7.585
cc_6899 ( N_noxref_20_c_9971_n N_VDD_c_12497_n ) capacitor c=9.3757e-19 \
 //x=70.472 //y=5.335 //x2=70.825 //y2=7.585
cc_6900 ( N_noxref_20_c_9992_n N_VDD_c_12497_n ) capacitor c=0.0138074f \
 //x=70.47 //y=5.56 //x2=70.825 //y2=7.585
cc_6901 ( N_noxref_20_c_9959_n N_VDD_c_12545_n ) capacitor c=0.0017708f \
 //x=71.23 //y=5.335 //x2=71.705 //y2=7.585
cc_6902 ( N_noxref_20_c_10036_n N_VDD_c_12545_n ) capacitor c=0.00202922f \
 //x=72.115 //y=5.335 //x2=71.705 //y2=7.585
cc_6903 ( N_noxref_20_c_10039_n N_VDD_c_12545_n ) capacitor c=9.4822e-19 \
 //x=71.35 //y=5.335 //x2=71.705 //y2=7.585
cc_6904 ( N_noxref_20_c_10046_n N_VDD_c_12545_n ) capacitor c=0.0138074f \
 //x=71.35 //y=5.56 //x2=71.705 //y2=7.585
cc_6905 ( N_noxref_20_c_10036_n N_VDD_c_12579_n ) capacitor c=0.00205906f \
 //x=72.115 //y=5.335 //x2=72.585 //y2=7.585
cc_6906 ( N_noxref_20_c_10056_n N_VDD_c_12579_n ) capacitor c=8.49654e-19 \
 //x=72.23 //y=5.56 //x2=72.585 //y2=7.585
cc_6907 ( N_noxref_20_c_10058_n N_VDD_c_12579_n ) capacitor c=0.00204238f \
 //x=72.925 //y=5.335 //x2=72.585 //y2=7.585
cc_6908 ( N_noxref_20_c_10105_n N_VDD_c_12579_n ) capacitor c=0.0135103f \
 //x=72.23 //y=5.56 //x2=72.585 //y2=7.585
cc_6909 ( N_noxref_20_c_10058_n N_VDD_c_12645_n ) capacitor c=0.00155611f \
 //x=72.925 //y=5.335 //x2=73.58 //y2=7.585
cc_6910 ( N_noxref_20_c_9873_n N_VDD_c_12139_n ) capacitor c=5.35585e-19 \
 //x=74.49 //y=4.62 //x2=76.91 //y2=7.585
cc_6911 ( N_noxref_20_M142_noxref_g N_VDD_c_12139_n ) capacitor c=0.00778439f \
 //x=74.76 //y=6.205 //x2=76.91 //y2=7.585
cc_6912 ( N_noxref_20_M143_noxref_g N_VDD_c_12139_n ) capacitor c=0.00778439f \
 //x=75.2 //y=6.205 //x2=76.91 //y2=7.585
cc_6913 ( N_noxref_20_c_10124_p N_VDD_c_12649_n ) capacitor c=2.11259e-19 \
 //x=78.19 //y=4.62 //x2=80.24 //y2=7.585
cc_6914 ( N_noxref_20_M146_noxref_g N_VDD_c_12649_n ) capacitor c=0.00763665f \
 //x=78.08 //y=6.205 //x2=80.24 //y2=7.585
cc_6915 ( N_noxref_20_M147_noxref_g N_VDD_c_12649_n ) capacitor c=0.00782837f \
 //x=78.52 //y=6.205 //x2=80.24 //y2=7.585
cc_6916 ( N_noxref_20_c_9971_n N_VDD_c_12452_n ) capacitor c=0.0022955f \
 //x=70.472 //y=5.335 //x2=68.94 //y2=7.585
cc_6917 ( N_noxref_20_c_9879_n N_VDD_c_12452_n ) capacitor c=0.0140164f \
 //x=72.845 //y=4.615 //x2=68.94 //y2=7.585
cc_6918 ( N_noxref_20_c_9935_n N_VDD_c_12452_n ) capacitor c=9.87311e-19 \
 //x=67.49 //y=4.88 //x2=68.94 //y2=7.585
cc_6919 ( N_noxref_20_c_9992_n N_VDD_c_12452_n ) capacitor c=0.00508013f \
 //x=70.47 //y=5.56 //x2=68.94 //y2=7.585
cc_6920 ( N_noxref_20_M135_noxref_g N_VDD_c_12452_n ) capacitor c=0.00819375f \
 //x=67.94 //y=6.2 //x2=68.94 //y2=7.585
cc_6921 ( N_noxref_20_c_9954_n N_VDD_c_12452_n ) capacitor c=2.73429e-19 \
 //x=67.49 //y=4.88 //x2=68.94 //y2=7.585
cc_6922 ( N_noxref_20_c_10056_n N_VDD_c_12155_n ) capacitor c=0.00269575f \
 //x=72.23 //y=5.56 //x2=73.75 //y2=7.585
cc_6923 ( N_noxref_20_c_9846_n N_VDD_c_12155_n ) capacitor c=0.00496353f \
 //x=73.01 //y=4.455 //x2=73.75 //y2=7.585
cc_6924 ( N_noxref_20_c_10084_n N_VDD_c_12155_n ) capacitor c=0.00465012f \
 //x=73.01 //y=4.775 //x2=73.75 //y2=7.585
cc_6925 ( N_noxref_20_c_9849_n N_VDD_c_12155_n ) capacitor c=0.0198307f \
 //x=73.01 //y=5.25 //x2=73.75 //y2=7.585
cc_6926 ( N_noxref_20_c_9854_n N_VDD_c_12155_n ) capacitor c=0.00364726f \
 //x=74.49 //y=4.46 //x2=73.75 //y2=7.585
cc_6927 ( N_noxref_20_c_10096_n N_VDD_c_12155_n ) capacitor c=0.0117537f \
 //x=73.01 //y=4.62 //x2=73.75 //y2=7.585
cc_6928 ( N_noxref_20_c_9873_n N_VDD_c_12155_n ) capacitor c=0.00573055f \
 //x=74.49 //y=4.62 //x2=73.75 //y2=7.585
cc_6929 ( N_noxref_20_c_9877_n N_VDD_c_12155_n ) capacitor c=0.0224986f \
 //x=74.335 //y=4.62 //x2=73.75 //y2=7.585
cc_6930 ( N_noxref_20_c_10105_n N_VDD_c_12155_n ) capacitor c=0.00775197f \
 //x=72.23 //y=5.56 //x2=73.75 //y2=7.585
cc_6931 ( N_noxref_20_c_9891_n N_VDD_c_12155_n ) capacitor c=0.0181264f \
 //x=74.49 //y=4.62 //x2=73.75 //y2=7.585
cc_6932 ( N_noxref_20_M142_noxref_g N_VDD_c_12155_n ) capacitor c=0.00973553f \
 //x=74.76 //y=6.205 //x2=73.75 //y2=7.585
cc_6933 ( N_noxref_20_c_9905_n N_VDD_c_12155_n ) capacitor c=0.00774458f \
 //x=74.835 //y=4.975 //x2=73.75 //y2=7.585
cc_6934 ( N_noxref_20_c_9865_n N_VDD_c_12156_n ) capacitor c=0.00285166f \
 //x=78.19 //y=4.475 //x2=77.08 //y2=7.585
cc_6935 ( N_noxref_20_c_9875_n N_VDD_c_12156_n ) capacitor c=0.00331684f \
 //x=78.19 //y=4.62 //x2=77.08 //y2=7.585
cc_6936 ( N_noxref_20_c_9882_n N_VDD_c_12156_n ) capacitor c=0.0167947f \
 //x=78.035 //y=4.64 //x2=77.08 //y2=7.585
cc_6937 ( N_noxref_20_c_9891_n N_VDD_c_12156_n ) capacitor c=0.00117386f \
 //x=74.49 //y=4.62 //x2=77.08 //y2=7.585
cc_6938 ( N_noxref_20_c_10124_p N_VDD_c_12156_n ) capacitor c=0.0104424f \
 //x=78.19 //y=4.62 //x2=77.08 //y2=7.585
cc_6939 ( N_noxref_20_c_10125_p N_VDD_c_12156_n ) capacitor c=0.0137051f \
 //x=78.19 //y=4.885 //x2=77.08 //y2=7.585
cc_6940 ( N_noxref_20_c_10124_p N_VDD_c_12163_n ) capacitor c=0.00221916f \
 //x=78.19 //y=4.62 //x2=80.41 //y2=7.585
cc_6941 ( N_noxref_20_c_9971_n N_VDD_M132_noxref_s ) capacitor c=4.22189e-19 \
 //x=70.472 //y=5.335 //x2=66.265 //y2=5.2
cc_6942 ( N_noxref_20_M134_noxref_g N_VDD_M133_noxref_d ) capacitor \
 c=0.015318f //x=67.5 //y=6.2 //x2=67.135 //y2=5.2
cc_6943 ( N_noxref_20_c_9954_n N_VDD_M133_noxref_d ) capacitor c=3.50465e-19 \
 //x=67.49 //y=4.88 //x2=67.135 //y2=5.2
cc_6944 ( N_noxref_20_M135_noxref_g N_VDD_M135_noxref_d ) capacitor \
 c=0.0430452f //x=67.94 //y=6.2 //x2=68.015 //y2=5.2
cc_6945 ( N_noxref_20_c_9971_n N_VDD_M136_noxref_s ) capacitor c=0.0441176f \
 //x=70.472 //y=5.335 //x2=69.895 //y2=5.2
cc_6946 ( N_noxref_20_c_10039_n N_VDD_M136_noxref_s ) capacitor c=7.80122e-19 \
 //x=71.35 //y=5.335 //x2=69.895 //y2=5.2
cc_6947 ( N_noxref_20_c_9992_n N_VDD_M136_noxref_s ) capacitor c=0.0908457f \
 //x=70.47 //y=5.56 //x2=69.895 //y2=5.2
cc_6948 ( N_noxref_20_c_9959_n N_VDD_M137_noxref_d ) capacitor c=0.00700141f \
 //x=71.23 //y=5.335 //x2=70.765 //y2=5.2
cc_6949 ( N_noxref_20_c_9992_n N_VDD_M137_noxref_d ) capacitor c=0.0673792f \
 //x=70.47 //y=5.56 //x2=70.765 //y2=5.2
cc_6950 ( N_noxref_20_c_10046_n N_VDD_M137_noxref_d ) capacitor c=0.0674762f \
 //x=71.35 //y=5.56 //x2=70.765 //y2=5.2
cc_6951 ( N_noxref_20_c_10036_n N_VDD_M139_noxref_d ) capacitor c=0.00700141f \
 //x=72.115 //y=5.335 //x2=71.645 //y2=5.2
cc_6952 ( N_noxref_20_c_10046_n N_VDD_M139_noxref_d ) capacitor c=0.0674034f \
 //x=71.35 //y=5.56 //x2=71.645 //y2=5.2
cc_6953 ( N_noxref_20_c_10105_n N_VDD_M139_noxref_d ) capacitor c=0.067364f \
 //x=72.23 //y=5.56 //x2=71.645 //y2=5.2
cc_6954 ( N_noxref_20_c_10058_n N_VDD_M141_noxref_d ) capacitor c=0.00700141f \
 //x=72.925 //y=5.335 //x2=72.525 //y2=5.2
cc_6955 ( N_noxref_20_c_10105_n N_VDD_M141_noxref_d ) capacitor c=0.067249f \
 //x=72.23 //y=5.56 //x2=72.525 //y2=5.2
cc_6956 ( N_noxref_20_c_10056_n N_VDD_M142_noxref_s ) capacitor c=0.00539362f \
 //x=72.23 //y=5.56 //x2=74.405 //y2=5.205
cc_6957 ( N_noxref_20_c_10058_n N_VDD_M142_noxref_s ) capacitor c=0.00177198f \
 //x=72.925 //y=5.335 //x2=74.405 //y2=5.205
cc_6958 ( N_noxref_20_c_9873_n N_VDD_M142_noxref_s ) capacitor c=0.0165427f \
 //x=74.49 //y=4.62 //x2=74.405 //y2=5.205
cc_6959 ( N_noxref_20_c_9878_n N_VDD_M142_noxref_s ) capacitor c=0.00180521f \
 //x=74.655 //y=4.62 //x2=74.405 //y2=5.205
cc_6960 ( N_noxref_20_c_9891_n N_VDD_M142_noxref_s ) capacitor c=0.0122195f \
 //x=74.49 //y=4.62 //x2=74.405 //y2=5.205
cc_6961 ( N_noxref_20_M142_noxref_g N_VDD_M142_noxref_s ) capacitor \
 c=0.0510401f //x=74.76 //y=6.205 //x2=74.405 //y2=5.205
cc_6962 ( N_noxref_20_c_9905_n N_VDD_M142_noxref_s ) capacitor c=0.00621646f \
 //x=74.835 //y=4.975 //x2=74.405 //y2=5.205
cc_6963 ( N_noxref_20_M143_noxref_g N_VDD_M143_noxref_d ) capacitor \
 c=0.0127979f //x=75.2 //y=6.205 //x2=75.275 //y2=5.205
cc_6964 ( N_noxref_20_c_9844_n N_noxref_32_c_13495_n ) capacitor c=0.0036878f \
 //x=72.525 //y=1.305 //x2=72.925 //y2=0.72
cc_6965 ( N_noxref_20_c_10073_n N_noxref_32_c_13495_n ) capacitor \
 c=0.00399931f //x=72.925 //y=1.845 //x2=72.925 //y2=0.72
cc_6966 ( N_noxref_20_M44_noxref_d N_noxref_32_c_13495_n ) capacitor \
 c=0.00949319f //x=72.335 //y=1.095 //x2=72.925 //y2=0.72
cc_6967 ( N_noxref_20_M44_noxref_d N_noxref_32_c_13520_n ) capacitor \
 c=0.00120711f //x=72.335 //y=1.095 //x2=72.04 //y2=1.175
cc_6968 ( N_noxref_20_c_9959_n N_noxref_32_M43_noxref_d ) capacitor \
 c=0.00125456f //x=71.23 //y=5.335 //x2=70.8 //y2=1.09
cc_6969 ( N_noxref_20_c_9844_n N_noxref_32_M43_noxref_d ) capacitor \
 c=0.00802836f //x=72.525 //y=1.305 //x2=70.8 //y2=1.09
cc_6970 ( N_noxref_20_c_9844_n N_noxref_32_M44_noxref_s ) capacitor \
 c=0.00993921f //x=72.525 //y=1.305 //x2=71.905 //y2=0.555
cc_6971 ( N_noxref_20_c_9960_n N_noxref_32_M44_noxref_s ) capacitor \
 c=0.0271097f //x=72.525 //y=1.76 //x2=71.905 //y2=0.555
cc_6972 ( N_noxref_20_c_10073_n N_noxref_32_M44_noxref_s ) capacitor \
 c=0.00965435f //x=72.925 //y=1.845 //x2=71.905 //y2=0.555
cc_6973 ( N_noxref_20_c_10096_n N_noxref_32_M44_noxref_s ) capacitor \
 c=9.34699e-19 //x=73.01 //y=4.62 //x2=71.905 //y2=0.555
cc_6974 ( N_noxref_20_M44_noxref_d N_noxref_32_M44_noxref_s ) capacitor \
 c=0.0279003f //x=72.335 //y=1.095 //x2=71.905 //y2=0.555
cc_6975 ( N_noxref_20_c_9882_n N_noxref_33_c_13563_n ) capacitor c=0.00314988f \
 //x=78.035 //y=4.64 //x2=75.745 //y2=5.39
cc_6976 ( N_noxref_20_M143_noxref_g N_noxref_33_c_13563_n ) capacitor \
 c=0.00962216f //x=75.2 //y=6.205 //x2=75.745 //y2=5.39
cc_6977 ( N_noxref_20_c_9875_n N_noxref_33_c_13570_n ) capacitor c=0.00378061f \
 //x=78.19 //y=4.62 //x2=77.745 //y2=5.39
cc_6978 ( N_noxref_20_c_9882_n N_noxref_33_c_13570_n ) capacitor c=0.0894443f \
 //x=78.035 //y=4.64 //x2=77.745 //y2=5.39
cc_6979 ( N_noxref_20_M146_noxref_g N_noxref_33_c_13570_n ) capacitor \
 c=0.00366801f //x=78.08 //y=6.205 //x2=77.745 //y2=5.39
cc_6980 ( N_noxref_20_c_10058_n N_noxref_33_c_13571_n ) capacitor \
 c=4.26706e-19 //x=72.925 //y=5.335 //x2=75.975 //y2=5.39
cc_6981 ( N_noxref_20_c_9882_n N_noxref_33_c_13571_n ) capacitor c=0.00878121f \
 //x=78.035 //y=4.64 //x2=75.975 //y2=5.39
cc_6982 ( N_noxref_20_c_9875_n N_noxref_33_c_13588_n ) capacitor c=8.16607e-19 \
 //x=78.19 //y=4.62 //x2=78.62 //y2=7.09
cc_6983 ( N_noxref_20_c_9880_n N_noxref_33_c_13588_n ) capacitor c=0.00566393f \
 //x=78.195 //y=4.64 //x2=78.62 //y2=7.09
cc_6984 ( N_noxref_20_c_9882_n N_noxref_33_c_13588_n ) capacitor c=5.18143e-19 \
 //x=78.035 //y=4.64 //x2=78.62 //y2=7.09
cc_6985 ( N_noxref_20_c_10124_p N_noxref_33_c_13588_n ) capacitor \
 c=0.00134225f //x=78.19 //y=4.62 //x2=78.62 //y2=7.09
cc_6986 ( N_noxref_20_M146_noxref_g N_noxref_33_c_13588_n ) capacitor \
 c=0.00985075f //x=78.08 //y=6.205 //x2=78.62 //y2=7.09
cc_6987 ( N_noxref_20_M147_noxref_g N_noxref_33_c_13588_n ) capacitor \
 c=0.00814026f //x=78.52 //y=6.205 //x2=78.62 //y2=7.09
cc_6988 ( N_noxref_20_c_10056_n N_noxref_33_c_13594_n ) capacitor \
 c=5.91187e-19 //x=72.23 //y=5.56 //x2=74.982 //y2=5.39
cc_6989 ( N_noxref_20_c_10058_n N_noxref_33_c_13594_n ) capacitor \
 c=6.63525e-19 //x=72.925 //y=5.335 //x2=74.982 //y2=5.39
cc_6990 ( N_noxref_20_c_9882_n N_noxref_33_c_13594_n ) capacitor c=0.0263046f \
 //x=78.035 //y=4.64 //x2=74.982 //y2=5.39
cc_6991 ( N_noxref_20_M142_noxref_g N_noxref_33_c_13594_n ) capacitor \
 c=0.0018075f //x=74.76 //y=6.205 //x2=74.982 //y2=5.39
cc_6992 ( N_noxref_20_M143_noxref_g N_noxref_33_c_13594_n ) capacitor \
 c=0.00310294f //x=75.2 //y=6.205 //x2=74.982 //y2=5.39
cc_6993 ( N_noxref_20_c_9902_n N_noxref_33_c_13594_n ) capacitor c=0.00218288f \
 //x=75.125 //y=4.975 //x2=74.982 //y2=5.39
cc_6994 ( N_noxref_20_M146_noxref_g N_noxref_33_c_13600_n ) capacitor \
 c=0.00395967f //x=78.08 //y=6.205 //x2=77.86 //y2=6.92
cc_6995 ( N_noxref_20_M147_noxref_g N_noxref_33_c_13601_n ) capacitor \
 c=0.00179771f //x=78.52 //y=6.205 //x2=78.737 //y2=7.09
cc_6996 ( N_noxref_20_M142_noxref_g N_noxref_33_c_13602_n ) capacitor \
 c=0.0161645f //x=74.76 //y=6.205 //x2=74.98 //y2=5.56
cc_6997 ( N_noxref_20_M143_noxref_g N_noxref_33_c_13602_n ) capacitor \
 c=0.0177598f //x=75.2 //y=6.205 //x2=74.98 //y2=5.56
cc_6998 ( N_noxref_20_c_9902_n N_noxref_33_c_13602_n ) capacitor c=0.00293723f \
 //x=75.125 //y=4.975 //x2=74.98 //y2=5.56
cc_6999 ( N_noxref_20_c_9882_n N_noxref_33_c_13575_n ) capacitor c=0.00371683f \
 //x=78.035 //y=4.64 //x2=75.86 //y2=5.39
cc_7000 ( N_noxref_20_c_9875_n N_noxref_33_c_13606_n ) capacitor c=8.93089e-19 \
 //x=78.19 //y=4.62 //x2=77.86 //y2=5.39
cc_7001 ( N_noxref_20_c_9882_n N_noxref_33_c_13606_n ) capacitor c=0.00277723f \
 //x=78.035 //y=4.64 //x2=77.86 //y2=5.39
cc_7002 ( N_noxref_20_M146_noxref_g N_noxref_33_c_13606_n ) capacitor \
 c=0.0503042f //x=78.08 //y=6.205 //x2=77.86 //y2=5.39
cc_7003 ( N_noxref_20_M142_noxref_g N_noxref_33_M142_noxref_d ) capacitor \
 c=0.00124621f //x=74.76 //y=6.205 //x2=74.835 //y2=5.205
cc_7004 ( N_noxref_20_M143_noxref_g N_noxref_33_M142_noxref_d ) capacitor \
 c=0.00125665f //x=75.2 //y=6.205 //x2=74.835 //y2=5.205
cc_7005 ( N_noxref_20_M147_noxref_g N_noxref_33_M147_noxref_d ) capacitor \
 c=0.0142133f //x=78.52 //y=6.205 //x2=78.595 //y2=5.205
cc_7006 ( N_noxref_20_M147_noxref_g N_noxref_34_c_13737_n ) capacitor \
 c=0.00969072f //x=78.52 //y=6.205 //x2=79.065 //y2=5.39
cc_7007 ( N_noxref_20_c_9875_n N_noxref_34_c_13729_n ) capacitor c=0.00879697f \
 //x=78.19 //y=4.62 //x2=78.3 //y2=5.39
cc_7008 ( N_noxref_20_c_9880_n N_noxref_34_c_13729_n ) capacitor c=0.00708476f \
 //x=78.195 //y=4.64 //x2=78.3 //y2=5.39
cc_7009 ( N_noxref_20_c_10124_p N_noxref_34_c_13729_n ) capacitor \
 c=0.00212816f //x=78.19 //y=4.62 //x2=78.3 //y2=5.39
cc_7010 ( N_noxref_20_M146_noxref_g N_noxref_34_c_13729_n ) capacitor \
 c=0.00349804f //x=78.08 //y=6.205 //x2=78.3 //y2=5.39
cc_7011 ( N_noxref_20_M147_noxref_g N_noxref_34_c_13729_n ) capacitor \
 c=0.00297228f //x=78.52 //y=6.205 //x2=78.3 //y2=5.39
cc_7012 ( N_noxref_20_c_10125_p N_noxref_34_c_13729_n ) capacitor \
 c=0.00149603f //x=78.19 //y=4.885 //x2=78.3 //y2=5.39
cc_7013 ( N_noxref_20_c_9875_n N_noxref_34_c_13744_n ) capacitor c=0.0012994f \
 //x=78.19 //y=4.62 //x2=78.3 //y2=5.56
cc_7014 ( N_noxref_20_c_10124_p N_noxref_34_c_13744_n ) capacitor \
 c=0.00447469f //x=78.19 //y=4.62 //x2=78.3 //y2=5.56
cc_7015 ( N_noxref_20_M146_noxref_g N_noxref_34_c_13744_n ) capacitor \
 c=0.0120591f //x=78.08 //y=6.205 //x2=78.3 //y2=5.56
cc_7016 ( N_noxref_20_M147_noxref_g N_noxref_34_c_13744_n ) capacitor \
 c=0.015288f //x=78.52 //y=6.205 //x2=78.3 //y2=5.56
cc_7017 ( N_noxref_20_c_10125_p N_noxref_34_c_13744_n ) capacitor \
 c=0.00417478f //x=78.19 //y=4.885 //x2=78.3 //y2=5.56
cc_7018 ( N_noxref_20_c_9922_n N_GND_c_14611_n ) capacitor c=0.00210951f \
 //x=67.46 //y=2.26 //x2=69.93 //y2=0.175
cc_7019 ( N_noxref_20_c_9844_n N_GND_c_14678_n ) capacitor c=0.00901861f \
 //x=72.525 //y=1.305 //x2=74.845 //y2=0.175
cc_7020 ( N_noxref_20_c_10073_n N_GND_c_14678_n ) capacitor c=0.00713708f \
 //x=72.925 //y=1.845 //x2=74.845 //y2=0.175
cc_7021 ( N_noxref_20_c_9850_n N_GND_c_14678_n ) capacitor c=0.0018156f \
 //x=74.49 //y=2.375 //x2=74.845 //y2=0.175
cc_7022 ( N_noxref_20_M44_noxref_d N_GND_c_14678_n ) capacitor c=2.9462e-19 \
 //x=72.335 //y=1.095 //x2=74.845 //y2=0.175
cc_7023 ( N_noxref_20_c_9844_n N_GND_c_14313_n ) capacitor c=0.00482429f \
 //x=72.525 //y=1.305 //x2=74.93 //y2=1.015
cc_7024 ( N_noxref_20_c_9897_n N_GND_c_14313_n ) capacitor c=0.00178846f \
 //x=74.665 //y=1.045 //x2=74.93 //y2=1.015
cc_7025 ( N_noxref_20_c_9898_n N_GND_c_14313_n ) capacitor c=0.00324602f \
 //x=74.665 //y=1.39 //x2=74.93 //y2=1.015
cc_7026 ( N_noxref_20_c_9899_n N_GND_c_14313_n ) capacitor c=3.46977e-19 \
 //x=74.665 //y=1.7 //x2=74.93 //y2=1.015
cc_7027 ( N_noxref_20_c_10320_p N_GND_c_14313_n ) capacitor c=0.00943875f \
 //x=75.04 //y=0.89 //x2=74.93 //y2=1.015
cc_7028 ( N_noxref_20_c_10321_p N_GND_c_14313_n ) capacitor c=7.91264e-19 \
 //x=75.04 //y=1.545 //x2=74.93 //y2=1.015
cc_7029 ( N_noxref_20_c_9908_n N_GND_c_14313_n ) capacitor c=0.00205853f \
 //x=75.195 //y=1.045 //x2=74.93 //y2=1.015
cc_7030 ( N_noxref_20_c_9910_n N_GND_c_14313_n ) capacitor c=0.00402706f \
 //x=75.195 //y=1.39 //x2=74.93 //y2=1.015
cc_7031 ( N_noxref_20_c_9864_n N_GND_c_14753_n ) capacitor c=0.00456909f \
 //x=78.19 //y=2.385 //x2=78.26 //y2=1.015
cc_7032 ( N_noxref_20_c_10118_p N_GND_c_14753_n ) capacitor c=4.35087e-19 \
 //x=78.19 //y=2.26 //x2=78.26 //y2=1.015
cc_7033 ( N_noxref_20_c_10153_p N_GND_c_14753_n ) capacitor c=0.00174776f \
 //x=77.995 //y=1.045 //x2=78.26 //y2=1.015
cc_7034 ( N_noxref_20_c_10154_p N_GND_c_14753_n ) capacitor c=0.00349898f \
 //x=77.995 //y=1.39 //x2=78.26 //y2=1.015
cc_7035 ( N_noxref_20_c_10156_p N_GND_c_14753_n ) capacitor c=2.39384e-19 \
 //x=77.995 //y=1.7 //x2=78.26 //y2=1.015
cc_7036 ( N_noxref_20_c_10329_p N_GND_c_14753_n ) capacitor c=0.00936969f \
 //x=78.37 //y=0.89 //x2=78.26 //y2=1.015
cc_7037 ( N_noxref_20_c_10330_p N_GND_c_14753_n ) capacitor c=0.00220551f \
 //x=78.37 //y=1.545 //x2=78.26 //y2=1.015
cc_7038 ( N_noxref_20_c_10155_p N_GND_c_14753_n ) capacitor c=0.00190243f \
 //x=78.525 //y=1.045 //x2=78.26 //y2=1.015
cc_7039 ( N_noxref_20_c_10157_p N_GND_c_14753_n ) capacitor c=0.00369501f \
 //x=78.525 //y=1.39 //x2=78.26 //y2=1.015
cc_7040 ( N_noxref_20_c_9922_n N_GND_c_14593_n ) capacitor c=3.77328e-19 \
 //x=67.46 //y=2.26 //x2=68.77 //y2=0.175
cc_7041 ( N_noxref_20_c_10073_n N_GND_c_14632_n ) capacitor c=6.86343e-19 \
 //x=72.925 //y=1.845 //x2=73.58 //y2=0.175
cc_7042 ( N_noxref_20_c_9897_n N_GND_c_14321_n ) capacitor c=0.00694747f \
 //x=74.665 //y=1.045 //x2=76.91 //y2=0.175
cc_7043 ( N_noxref_20_c_10153_p N_GND_c_14765_n ) capacitor c=0.00688488f \
 //x=77.995 //y=1.045 //x2=80.24 //y2=0.175
cc_7044 ( N_noxref_20_c_9931_n N_GND_c_14336_n ) capacitor c=0.00207214f \
 //x=67.46 //y=2.26 //x2=68.94 //y2=0.175
cc_7045 ( N_noxref_20_c_9950_n N_GND_c_14336_n ) capacitor c=0.00275184f \
 //x=68.025 //y=1.43 //x2=68.94 //y2=0.175
cc_7046 ( N_noxref_20_c_9960_n N_GND_c_14337_n ) capacitor c=0.00484127f \
 //x=72.525 //y=1.76 //x2=73.75 //y2=0.175
cc_7047 ( N_noxref_20_c_10073_n N_GND_c_14337_n ) capacitor c=0.0354337f \
 //x=72.925 //y=1.845 //x2=73.75 //y2=0.175
cc_7048 ( N_noxref_20_c_9850_n N_GND_c_14337_n ) capacitor c=0.00524403f \
 //x=74.49 //y=2.375 //x2=73.75 //y2=0.175
cc_7049 ( N_noxref_20_c_9854_n N_GND_c_14337_n ) capacitor c=0.0123753f \
 //x=74.49 //y=4.46 //x2=73.75 //y2=0.175
cc_7050 ( N_noxref_20_c_9887_n N_GND_c_14337_n ) capacitor c=0.00735219f \
 //x=74.49 //y=2.26 //x2=73.75 //y2=0.175
cc_7051 ( N_noxref_20_c_9899_n N_GND_c_14337_n ) capacitor c=0.0015404f \
 //x=74.665 //y=1.7 //x2=73.75 //y2=0.175
cc_7052 ( N_noxref_20_c_9901_n N_GND_c_14337_n ) capacitor c=0.00366398f \
 //x=74.665 //y=2.095 //x2=73.75 //y2=0.175
cc_7053 ( N_noxref_20_c_9913_n N_GND_c_14337_n ) capacitor c=0.00801885f \
 //x=74.49 //y=2.26 //x2=73.75 //y2=0.175
cc_7054 ( N_noxref_20_c_9864_n N_GND_c_14338_n ) capacitor c=0.00537602f \
 //x=78.19 //y=2.385 //x2=77.08 //y2=0.175
cc_7055 ( N_noxref_20_c_9865_n N_GND_c_14338_n ) capacitor c=0.00917348f \
 //x=78.19 //y=4.475 //x2=77.08 //y2=0.175
cc_7056 ( N_noxref_20_c_10118_p N_GND_c_14338_n ) capacitor c=0.00369534f \
 //x=78.19 //y=2.26 //x2=77.08 //y2=0.175
cc_7057 ( N_noxref_20_c_10146_p N_GND_c_14338_n ) capacitor c=0.00956283f \
 //x=77.995 //y=2.095 //x2=77.08 //y2=0.175
cc_7058 ( N_noxref_20_c_9897_n N_GND_M45_noxref_d ) capacitor c=0.00192399f \
 //x=74.665 //y=1.045 //x2=74.74 //y2=1.045
cc_7059 ( N_noxref_20_c_9898_n N_GND_M45_noxref_d ) capacitor c=0.00210798f \
 //x=74.665 //y=1.39 //x2=74.74 //y2=1.045
cc_7060 ( N_noxref_20_c_10320_p N_GND_M45_noxref_d ) capacitor c=0.00472259f \
 //x=75.04 //y=0.89 //x2=74.74 //y2=1.045
cc_7061 ( N_noxref_20_c_10321_p N_GND_M45_noxref_d ) capacitor c=0.00166857f \
 //x=75.04 //y=1.545 //x2=74.74 //y2=1.045
cc_7062 ( N_noxref_20_c_9908_n N_GND_M45_noxref_d ) capacitor c=0.00230174f \
 //x=75.195 //y=1.045 //x2=74.74 //y2=1.045
cc_7063 ( N_noxref_20_c_9910_n N_GND_M45_noxref_d ) capacitor c=0.00210798f \
 //x=75.195 //y=1.39 //x2=74.74 //y2=1.045
cc_7064 ( N_noxref_20_c_9864_n N_GND_M47_noxref_d ) capacitor c=4.20217e-19 \
 //x=78.19 //y=2.385 //x2=78.07 //y2=1.045
cc_7065 ( N_noxref_20_c_10153_p N_GND_M47_noxref_d ) capacitor c=0.00192399f \
 //x=77.995 //y=1.045 //x2=78.07 //y2=1.045
cc_7066 ( N_noxref_20_c_10154_p N_GND_M47_noxref_d ) capacitor c=0.00228784f \
 //x=77.995 //y=1.39 //x2=78.07 //y2=1.045
cc_7067 ( N_noxref_20_c_10329_p N_GND_M47_noxref_d ) capacitor c=0.0047434f \
 //x=78.37 //y=0.89 //x2=78.07 //y2=1.045
cc_7068 ( N_noxref_20_c_10330_p N_GND_M47_noxref_d ) capacitor c=0.00172481f \
 //x=78.37 //y=1.545 //x2=78.07 //y2=1.045
cc_7069 ( N_noxref_20_c_10155_p N_GND_M47_noxref_d ) capacitor c=0.00230174f \
 //x=78.525 //y=1.045 //x2=78.07 //y2=1.045
cc_7070 ( N_noxref_20_c_10157_p N_GND_M47_noxref_d ) capacitor c=0.00228784f \
 //x=78.525 //y=1.39 //x2=78.07 //y2=1.045
cc_7071 ( N_noxref_20_c_9922_n N_noxref_53_c_16612_n ) capacitor c=7.50092e-19 \
 //x=67.46 //y=2.26 //x2=67.275 //y2=1.675
cc_7072 ( N_noxref_20_c_9946_n N_noxref_53_c_16612_n ) capacitor c=0.00888238f \
 //x=67.495 //y=1.74 //x2=67.275 //y2=1.675
cc_7073 ( N_noxref_20_c_9951_n N_noxref_53_c_16612_n ) capacitor c=0.00175171f \
 //x=67.46 //y=2.26 //x2=67.275 //y2=1.675
cc_7074 ( N_noxref_20_c_9922_n N_noxref_53_c_16617_n ) capacitor c=0.001463f \
 //x=67.46 //y=2.26 //x2=68.16 //y2=0.71
cc_7075 ( N_noxref_20_c_9931_n N_noxref_53_c_16617_n ) capacitor c=8.82141e-19 \
 //x=67.46 //y=2.26 //x2=68.16 //y2=0.71
cc_7076 ( N_noxref_20_c_9941_n N_noxref_53_c_16617_n ) capacitor c=0.0200738f \
 //x=67.495 //y=1.085 //x2=68.16 //y2=0.71
cc_7077 ( N_noxref_20_c_9949_n N_noxref_53_c_16617_n ) capacitor c=0.00825432f \
 //x=68.025 //y=1.085 //x2=68.16 //y2=0.71
cc_7078 ( N_noxref_20_c_9951_n N_noxref_53_c_16617_n ) capacitor c=2.1838e-19 \
 //x=67.46 //y=2.26 //x2=68.16 //y2=0.71
cc_7079 ( N_noxref_20_c_9941_n N_noxref_53_M40_noxref_s ) capacitor \
 c=0.00888238f //x=67.495 //y=1.085 //x2=66.17 //y2=0.545
cc_7080 ( N_noxref_20_c_9949_n N_noxref_53_M40_noxref_s ) capacitor \
 c=0.015333f //x=68.025 //y=1.085 //x2=66.17 //y2=0.545
cc_7081 ( N_noxref_20_c_9950_n N_noxref_53_M40_noxref_s ) capacitor \
 c=0.00248746f //x=68.025 //y=1.43 //x2=66.17 //y2=0.545
cc_7082 ( N_noxref_20_c_9850_n N_noxref_55_c_16729_n ) capacitor c=0.0033606f \
 //x=74.49 //y=2.375 //x2=74.445 //y2=1.675
cc_7083 ( N_noxref_20_c_9887_n N_noxref_55_c_16729_n ) capacitor c=0.00844774f \
 //x=74.49 //y=2.26 //x2=74.445 //y2=1.675
cc_7084 ( N_noxref_20_c_9901_n N_noxref_55_c_16729_n ) capacitor c=0.00262672f \
 //x=74.665 //y=2.095 //x2=74.445 //y2=1.675
cc_7085 ( N_noxref_20_c_9913_n N_noxref_55_c_16729_n ) capacitor c=0.0079898f \
 //x=74.49 //y=2.26 //x2=74.445 //y2=1.675
cc_7086 ( N_noxref_20_c_9850_n N_noxref_55_c_16730_n ) capacitor c=0.00202154f \
 //x=74.49 //y=2.375 //x2=75.33 //y2=1.76
cc_7087 ( N_noxref_20_c_9873_n N_noxref_55_c_16730_n ) capacitor c=0.00277238f \
 //x=74.49 //y=4.62 //x2=75.33 //y2=1.76
cc_7088 ( N_noxref_20_c_9887_n N_noxref_55_c_16730_n ) capacitor c=0.00302338f \
 //x=74.49 //y=2.26 //x2=75.33 //y2=1.76
cc_7089 ( N_noxref_20_c_9899_n N_noxref_55_c_16730_n ) capacitor c=0.0072172f \
 //x=74.665 //y=1.7 //x2=75.33 //y2=1.76
cc_7090 ( N_noxref_20_c_9901_n N_noxref_55_c_16730_n ) capacitor c=0.0142349f \
 //x=74.665 //y=2.095 //x2=75.33 //y2=1.76
cc_7091 ( N_noxref_20_c_10321_p N_noxref_55_c_16730_n ) capacitor c=0.0094838f \
 //x=75.04 //y=1.545 //x2=75.33 //y2=1.76
cc_7092 ( N_noxref_20_c_9910_n N_noxref_55_c_16730_n ) capacitor c=0.00339872f \
 //x=75.195 //y=1.39 //x2=75.33 //y2=1.76
cc_7093 ( N_noxref_20_c_9913_n N_noxref_55_c_16730_n ) capacitor c=0.00168953f \
 //x=74.49 //y=2.26 //x2=75.33 //y2=1.76
cc_7094 ( N_noxref_20_c_9901_n N_noxref_55_c_16731_n ) capacitor c=6.71402e-19 \
 //x=74.665 //y=2.095 //x2=75.415 //y2=1.675
cc_7095 ( N_noxref_20_c_9897_n N_noxref_55_M45_noxref_s ) capacitor \
 c=0.0295366f //x=74.665 //y=1.045 //x2=74.31 //y2=0.545
cc_7096 ( N_noxref_20_c_9899_n N_noxref_55_M45_noxref_s ) capacitor \
 c=0.00110192f //x=74.665 //y=1.7 //x2=74.31 //y2=0.545
cc_7097 ( N_noxref_20_c_9908_n N_noxref_55_M45_noxref_s ) capacitor \
 c=0.0125442f //x=75.195 //y=1.045 //x2=74.31 //y2=0.545
cc_7098 ( N_noxref_20_c_10146_p N_noxref_57_c_16804_n ) capacitor c=0.0034165f \
 //x=77.995 //y=2.095 //x2=77.775 //y2=1.675
cc_7099 ( N_noxref_20_c_9864_n N_noxref_57_c_16805_n ) capacitor c=0.00541004f \
 //x=78.19 //y=2.385 //x2=78.66 //y2=1.76
cc_7100 ( N_noxref_20_c_9875_n N_noxref_57_c_16805_n ) capacitor c=0.00299239f \
 //x=78.19 //y=4.62 //x2=78.66 //y2=1.76
cc_7101 ( N_noxref_20_c_10118_p N_noxref_57_c_16805_n ) capacitor \
 c=0.00763108f //x=78.19 //y=2.26 //x2=78.66 //y2=1.76
cc_7102 ( N_noxref_20_c_10156_p N_noxref_57_c_16805_n ) capacitor \
 c=0.00688171f //x=77.995 //y=1.7 //x2=78.66 //y2=1.76
cc_7103 ( N_noxref_20_c_10146_p N_noxref_57_c_16805_n ) capacitor c=0.018763f \
 //x=77.995 //y=2.095 //x2=78.66 //y2=1.76
cc_7104 ( N_noxref_20_c_10330_p N_noxref_57_c_16805_n ) capacitor \
 c=0.00720053f //x=78.37 //y=1.545 //x2=78.66 //y2=1.76
cc_7105 ( N_noxref_20_c_10157_p N_noxref_57_c_16805_n ) capacitor c=0.0059368f \
 //x=78.525 //y=1.39 //x2=78.66 //y2=1.76
cc_7106 ( N_noxref_20_c_10146_p N_noxref_57_c_16812_n ) capacitor \
 c=0.00122123f //x=77.995 //y=2.095 //x2=78.745 //y2=1.675
cc_7107 ( N_noxref_20_c_10153_p N_noxref_57_M47_noxref_s ) capacitor \
 c=0.0303347f //x=77.995 //y=1.045 //x2=77.64 //y2=0.545
cc_7108 ( N_noxref_20_c_10156_p N_noxref_57_M47_noxref_s ) capacitor \
 c=3.48408e-19 //x=77.995 //y=1.7 //x2=77.64 //y2=0.545
cc_7109 ( N_noxref_20_c_10155_p N_noxref_57_M47_noxref_s ) capacitor \
 c=0.012348f //x=78.525 //y=1.045 //x2=77.64 //y2=0.545
cc_7110 ( N_noxref_21_M151_noxref_g N_noxref_22_c_11183_n ) capacitor \
 c=0.00969448f //x=81.86 //y=6.205 //x2=82.395 //y2=5.39
cc_7111 ( N_noxref_21_c_10644_n N_noxref_22_c_11205_n ) capacitor \
 c=8.05281e-19 //x=81.15 //y=2.43 //x2=83 //y2=4.095
cc_7112 ( N_noxref_21_c_10649_n N_noxref_22_c_11205_n ) capacitor \
 c=0.00420142f //x=81.15 //y=4.755 //x2=83 //y2=4.095
cc_7113 ( N_noxref_21_c_10649_n N_noxref_22_c_11216_n ) capacitor \
 c=0.00136963f //x=81.15 //y=4.755 //x2=83 //y2=5.305
cc_7114 ( N_noxref_21_c_10682_n N_noxref_22_c_11222_n ) capacitor \
 c=0.00600657f //x=72.485 //y=3.5 //x2=75.9 //y2=1.36
cc_7115 ( N_noxref_21_c_10682_n N_noxref_22_c_11273_n ) capacitor \
 c=0.00568872f //x=72.485 //y=3.5 //x2=79.23 //y2=1.36
cc_7116 ( N_noxref_21_c_10927_n N_noxref_22_c_11273_n ) capacitor \
 c=5.10033e-19 //x=78.965 //y=1.085 //x2=79.23 //y2=1.36
cc_7117 ( N_noxref_21_c_10930_n N_noxref_22_c_11273_n ) capacitor \
 c=0.00606934f //x=78.965 //y=1.43 //x2=79.23 //y2=1.36
cc_7118 ( N_noxref_21_c_10949_p N_noxref_22_c_11273_n ) capacitor \
 c=4.65567e-19 //x=79.34 //y=0.93 //x2=79.23 //y2=1.36
cc_7119 ( N_noxref_21_c_10950_p N_noxref_22_c_11273_n ) capacitor \
 c=0.00247382f //x=79.34 //y=1.585 //x2=79.23 //y2=1.36
cc_7120 ( N_noxref_21_c_10936_n N_noxref_22_c_11273_n ) capacitor \
 c=2.15736e-19 //x=79.495 //y=1.085 //x2=79.23 //y2=1.36
cc_7121 ( N_noxref_21_c_10937_n N_noxref_22_c_11273_n ) capacitor \
 c=0.00259159f //x=79.495 //y=1.43 //x2=79.23 //y2=1.36
cc_7122 ( N_noxref_21_c_10938_n N_noxref_22_c_11273_n ) capacitor \
 c=0.00150348f //x=79.495 //y=1.74 //x2=79.23 //y2=1.36
cc_7123 ( N_noxref_21_M150_noxref_g N_noxref_22_c_11229_n ) capacitor \
 c=0.00363978f //x=81.42 //y=6.205 //x2=81.64 //y2=5.39
cc_7124 ( N_noxref_21_M151_noxref_g N_noxref_22_c_11229_n ) capacitor \
 c=0.00185829f //x=81.86 //y=6.205 //x2=81.64 //y2=5.39
cc_7125 ( N_noxref_21_c_10707_n N_noxref_22_c_11229_n ) capacitor c=0.0021827f \
 //x=81.785 //y=4.975 //x2=81.64 //y2=5.39
cc_7126 ( N_noxref_21_c_10682_n N_noxref_22_c_11284_n ) capacitor \
 c=0.00434161f //x=72.485 //y=3.5 //x2=76.065 //y2=1.405
cc_7127 ( N_noxref_21_c_10682_n N_noxref_22_c_11236_n ) capacitor c=0.0477486f \
 //x=72.485 //y=3.5 //x2=79.1 //y2=1.405
cc_7128 ( N_noxref_21_c_10930_n N_noxref_22_c_11236_n ) capacitor c=0.0016073f \
 //x=78.965 //y=1.43 //x2=79.1 //y2=1.405
cc_7129 ( N_noxref_21_c_10682_n N_noxref_22_c_11287_n ) capacitor \
 c=0.00355475f //x=72.485 //y=3.5 //x2=79.36 //y2=1.405
cc_7130 ( N_noxref_21_c_10636_n N_noxref_22_c_11239_n ) capacitor \
 c=0.00831558f //x=79.67 //y=2.43 //x2=82.395 //y2=1.405
cc_7131 ( N_noxref_21_c_10639_n N_noxref_22_c_11239_n ) capacitor \
 c=0.00172927f //x=79.67 //y=3.675 //x2=82.395 //y2=1.405
cc_7132 ( N_noxref_21_c_10644_n N_noxref_22_c_11239_n ) capacitor \
 c=0.00831552f //x=81.15 //y=2.43 //x2=82.395 //y2=1.405
cc_7133 ( N_noxref_21_c_10682_n N_noxref_22_c_11239_n ) capacitor \
 c=0.00197622f //x=72.485 //y=3.5 //x2=82.395 //y2=1.405
cc_7134 ( N_noxref_21_c_10688_n N_noxref_22_c_11239_n ) capacitor c=0.0126877f \
 //x=79.835 //y=2.27 //x2=82.395 //y2=1.405
cc_7135 ( N_noxref_21_c_10689_n N_noxref_22_c_11239_n ) capacitor c=0.0128597f \
 //x=81.145 //y=2.27 //x2=82.395 //y2=1.405
cc_7136 ( N_noxref_21_c_10692_n N_noxref_22_c_11239_n ) capacitor c=0.0434154f \
 //x=80.985 //y=2.27 //x2=82.395 //y2=1.405
cc_7137 ( N_noxref_21_c_10937_n N_noxref_22_c_11239_n ) capacitor \
 c=0.00215337f //x=79.495 //y=1.43 //x2=82.395 //y2=1.405
cc_7138 ( N_noxref_21_c_10938_n N_noxref_22_c_11239_n ) capacitor \
 c=0.00148084f //x=79.495 //y=1.74 //x2=82.395 //y2=1.405
cc_7139 ( N_noxref_21_c_10703_n N_noxref_22_c_11239_n ) capacitor \
 c=0.00277413f //x=81.325 //y=1.39 //x2=82.395 //y2=1.405
cc_7140 ( N_noxref_21_c_10704_n N_noxref_22_c_11239_n ) capacitor \
 c=0.00245466f //x=81.325 //y=1.7 //x2=82.395 //y2=1.405
cc_7141 ( N_noxref_21_c_10715_n N_noxref_22_c_11239_n ) capacitor \
 c=0.00460244f //x=81.855 //y=1.39 //x2=82.395 //y2=1.405
cc_7142 ( N_noxref_21_M150_noxref_g N_noxref_22_c_11300_n ) capacitor \
 c=0.0120591f //x=81.42 //y=6.205 //x2=81.64 //y2=5.56
cc_7143 ( N_noxref_21_M151_noxref_g N_noxref_22_c_11300_n ) capacitor \
 c=0.0142133f //x=81.86 //y=6.205 //x2=81.64 //y2=5.56
cc_7144 ( N_noxref_21_c_10707_n N_noxref_22_c_11300_n ) capacitor \
 c=0.00293135f //x=81.785 //y=4.975 //x2=81.64 //y2=5.56
cc_7145 ( N_noxref_21_c_10927_n N_noxref_22_M48_noxref_d ) capacitor \
 c=0.00217566f //x=78.965 //y=1.085 //x2=79.04 //y2=1.085
cc_7146 ( N_noxref_21_c_10930_n N_noxref_22_M48_noxref_d ) capacitor \
 c=0.00693963f //x=78.965 //y=1.43 //x2=79.04 //y2=1.085
cc_7147 ( N_noxref_21_c_10949_p N_noxref_22_M48_noxref_d ) capacitor \
 c=0.00234223f //x=79.34 //y=0.93 //x2=79.04 //y2=1.085
cc_7148 ( N_noxref_21_c_10950_p N_noxref_22_M48_noxref_d ) capacitor \
 c=0.00513213f //x=79.34 //y=1.585 //x2=79.04 //y2=1.085
cc_7149 ( N_noxref_21_c_10936_n N_noxref_22_M48_noxref_d ) capacitor \
 c=0.00132245f //x=79.495 //y=1.085 //x2=79.04 //y2=1.085
cc_7150 ( N_noxref_21_c_10937_n N_noxref_22_M48_noxref_d ) capacitor \
 c=0.00326247f //x=79.495 //y=1.43 //x2=79.04 //y2=1.085
cc_7151 ( N_noxref_21_c_10938_n N_noxref_22_M48_noxref_d ) capacitor \
 c=0.00231463f //x=79.495 //y=1.74 //x2=79.04 //y2=1.085
cc_7152 ( N_noxref_21_c_10461_n N_VDD_c_11522_n ) capacitor c=0.00621363f \
 //x=22.39 //y=5.335 //x2=74.455 //y2=7.585
cc_7153 ( N_noxref_21_c_10517_n N_VDD_c_11522_n ) capacitor c=0.00627186f \
 //x=23.275 //y=5.335 //x2=74.455 //y2=7.585
cc_7154 ( N_noxref_21_c_10519_n N_VDD_c_11522_n ) capacitor c=0.00256019f \
 //x=23.39 //y=5.56 //x2=74.455 //y2=7.585
cc_7155 ( N_noxref_21_c_10521_n N_VDD_c_11522_n ) capacitor c=0.00829249f \
 //x=24.085 //y=5.335 //x2=74.455 //y2=7.585
cc_7156 ( N_noxref_21_c_10543_n N_VDD_c_11522_n ) capacitor c=4.708e-19 \
 //x=24.17 //y=3.685 //x2=74.455 //y2=7.585
cc_7157 ( N_noxref_21_c_10466_n N_VDD_c_11522_n ) capacitor c=0.00261804f \
 //x=21.632 //y=5.335 //x2=74.455 //y2=7.585
cc_7158 ( N_noxref_21_c_10784_n N_VDD_c_11522_n ) capacitor c=0.00270108f \
 //x=22.51 //y=5.335 //x2=74.455 //y2=7.585
cc_7159 ( N_noxref_21_c_10478_n N_VDD_c_11522_n ) capacitor c=0.0024232f \
 //x=21.63 //y=5.56 //x2=74.455 //y2=7.585
cc_7160 ( N_noxref_21_c_10859_n N_VDD_c_11522_n ) capacitor c=0.0024232f \
 //x=22.51 //y=5.56 //x2=74.455 //y2=7.585
cc_7161 ( N_noxref_21_c_10563_n N_VDD_c_11522_n ) capacitor c=0.0024232f \
 //x=23.39 //y=5.56 //x2=74.455 //y2=7.585
cc_7162 ( N_noxref_21_M74_noxref_g N_VDD_c_11721_n ) capacitor c=0.00697352f \
 //x=18.66 //y=6.2 //x2=19.235 //y2=7.585
cc_7163 ( N_noxref_21_M75_noxref_g N_VDD_c_11721_n ) capacitor c=0.00755544f \
 //x=19.1 //y=6.2 //x2=19.235 //y2=7.585
cc_7164 ( N_noxref_21_c_10461_n N_VDD_c_11728_n ) capacitor c=0.00202922f \
 //x=22.39 //y=5.335 //x2=21.985 //y2=7.585
cc_7165 ( N_noxref_21_c_10466_n N_VDD_c_11728_n ) capacitor c=9.3757e-19 \
 //x=21.632 //y=5.335 //x2=21.985 //y2=7.585
cc_7166 ( N_noxref_21_c_10478_n N_VDD_c_11728_n ) capacitor c=0.0138074f \
 //x=21.63 //y=5.56 //x2=21.985 //y2=7.585
cc_7167 ( N_noxref_21_c_10461_n N_VDD_c_12537_n ) capacitor c=0.0017708f \
 //x=22.39 //y=5.335 //x2=22.865 //y2=7.585
cc_7168 ( N_noxref_21_c_10517_n N_VDD_c_12537_n ) capacitor c=0.00202922f \
 //x=23.275 //y=5.335 //x2=22.865 //y2=7.585
cc_7169 ( N_noxref_21_c_10784_n N_VDD_c_12537_n ) capacitor c=9.4822e-19 \
 //x=22.51 //y=5.335 //x2=22.865 //y2=7.585
cc_7170 ( N_noxref_21_c_10859_n N_VDD_c_12537_n ) capacitor c=0.0138074f \
 //x=22.51 //y=5.56 //x2=22.865 //y2=7.585
cc_7171 ( N_noxref_21_c_10517_n N_VDD_c_11786_n ) capacitor c=0.00205906f \
 //x=23.275 //y=5.335 //x2=23.745 //y2=7.585
cc_7172 ( N_noxref_21_c_10519_n N_VDD_c_11786_n ) capacitor c=8.49654e-19 \
 //x=23.39 //y=5.56 //x2=23.745 //y2=7.585
cc_7173 ( N_noxref_21_c_10521_n N_VDD_c_11786_n ) capacitor c=0.00204238f \
 //x=24.085 //y=5.335 //x2=23.745 //y2=7.585
cc_7174 ( N_noxref_21_c_10563_n N_VDD_c_11786_n ) capacitor c=0.0135103f \
 //x=23.39 //y=5.56 //x2=23.745 //y2=7.585
cc_7175 ( N_noxref_21_c_10521_n N_VDD_c_12723_n ) capacitor c=0.00183742f \
 //x=24.085 //y=5.335 //x2=24.74 //y2=7.585
cc_7176 ( N_noxref_21_M148_noxref_g N_VDD_c_12649_n ) capacitor c=0.00782837f \
 //x=78.96 //y=6.205 //x2=80.24 //y2=7.585
cc_7177 ( N_noxref_21_M149_noxref_g N_VDD_c_12649_n ) capacitor c=0.00782837f \
 //x=79.4 //y=6.205 //x2=80.24 //y2=7.585
cc_7178 ( N_noxref_21_M150_noxref_g N_VDD_c_12141_n ) capacitor c=0.00782837f \
 //x=81.42 //y=6.205 //x2=83.57 //y2=7.585
cc_7179 ( N_noxref_21_M151_noxref_g N_VDD_c_12141_n ) capacitor c=0.00782837f \
 //x=81.86 //y=6.205 //x2=83.57 //y2=7.585
cc_7180 ( N_noxref_21_c_10466_n N_VDD_c_11733_n ) capacitor c=0.0022955f \
 //x=21.632 //y=5.335 //x2=20.1 //y2=7.585
cc_7181 ( N_noxref_21_c_10423_n N_VDD_c_11733_n ) capacitor c=0.00226427f \
 //x=18.65 //y=4.88 //x2=20.1 //y2=7.585
cc_7182 ( N_noxref_21_c_10478_n N_VDD_c_11733_n ) capacitor c=0.00508013f \
 //x=21.63 //y=5.56 //x2=20.1 //y2=7.585
cc_7183 ( N_noxref_21_c_10493_n N_VDD_c_11733_n ) capacitor c=0.0129149f \
 //x=19.025 //y=4.97 //x2=20.1 //y2=7.585
cc_7184 ( N_noxref_21_c_10442_n N_VDD_c_11733_n ) capacitor c=2.73429e-19 \
 //x=18.65 //y=4.88 //x2=20.1 //y2=7.585
cc_7185 ( N_noxref_21_c_10519_n N_VDD_c_11799_n ) capacitor c=0.00269779f \
 //x=23.39 //y=5.56 //x2=24.91 //y2=7.585
cc_7186 ( N_noxref_21_c_10544_n N_VDD_c_11799_n ) capacitor c=0.0317266f \
 //x=24.17 //y=5.25 //x2=24.91 //y2=7.585
cc_7187 ( N_noxref_21_c_10561_n N_VDD_c_11799_n ) capacitor c=0.00333061f \
 //x=31.36 //y=3.48 //x2=24.91 //y2=7.585
cc_7188 ( N_noxref_21_c_10563_n N_VDD_c_11799_n ) capacitor c=0.00776541f \
 //x=23.39 //y=5.56 //x2=24.91 //y2=7.585
cc_7189 ( N_noxref_21_c_10661_n N_VDD_c_12088_n ) capacitor c=0.00333061f \
 //x=50.045 //y=3.51 //x2=49.33 //y2=7.585
cc_7190 ( N_noxref_21_c_10682_n N_VDD_c_12155_n ) capacitor c=0.00333061f \
 //x=72.485 //y=3.5 //x2=73.75 //y2=7.585
cc_7191 ( N_noxref_21_c_10640_n N_VDD_c_12163_n ) capacitor c=0.0156004f \
 //x=79.67 //y=4.76 //x2=80.41 //y2=7.585
cc_7192 ( N_noxref_21_c_10649_n N_VDD_c_12163_n ) capacitor c=0.0163412f \
 //x=81.15 //y=4.755 //x2=80.41 //y2=7.585
cc_7193 ( N_noxref_21_c_10921_n N_VDD_c_12163_n ) capacitor c=0.00790417f \
 //x=79.67 //y=4.885 //x2=80.41 //y2=7.585
cc_7194 ( N_noxref_21_c_10696_n N_VDD_c_12163_n ) capacitor c=0.00790205f \
 //x=81.15 //y=4.885 //x2=80.41 //y2=7.585
cc_7195 ( N_noxref_21_M149_noxref_g N_VDD_c_12163_n ) capacitor c=0.0138263f \
 //x=79.4 //y=6.205 //x2=80.41 //y2=7.585
cc_7196 ( N_noxref_21_M150_noxref_g N_VDD_c_12163_n ) capacitor c=0.00855037f \
 //x=81.42 //y=6.205 //x2=80.41 //y2=7.585
cc_7197 ( N_noxref_21_c_10934_n N_VDD_c_12163_n ) capacitor c=0.00722671f \
 //x=79.4 //y=5.05 //x2=80.41 //y2=7.585
cc_7198 ( N_noxref_21_c_10710_n N_VDD_c_12163_n ) capacitor c=0.00720105f \
 //x=81.495 //y=4.975 //x2=80.41 //y2=7.585
cc_7199 ( N_noxref_21_c_10466_n N_VDD_M72_noxref_s ) capacitor c=4.22189e-19 \
 //x=21.632 //y=5.335 //x2=17.425 //y2=5.2
cc_7200 ( N_noxref_21_M74_noxref_g N_VDD_M73_noxref_d ) capacitor c=0.015318f \
 //x=18.66 //y=6.2 //x2=18.295 //y2=5.2
cc_7201 ( N_noxref_21_c_10442_n N_VDD_M73_noxref_d ) capacitor c=3.32552e-19 \
 //x=18.65 //y=4.88 //x2=18.295 //y2=5.2
cc_7202 ( N_noxref_21_M75_noxref_g N_VDD_M75_noxref_d ) capacitor c=0.0430452f \
 //x=19.1 //y=6.2 //x2=19.175 //y2=5.2
cc_7203 ( N_noxref_21_c_10466_n N_VDD_M76_noxref_s ) capacitor c=0.0441176f \
 //x=21.632 //y=5.335 //x2=21.055 //y2=5.2
cc_7204 ( N_noxref_21_c_10784_n N_VDD_M76_noxref_s ) capacitor c=7.80122e-19 \
 //x=22.51 //y=5.335 //x2=21.055 //y2=5.2
cc_7205 ( N_noxref_21_c_10478_n N_VDD_M76_noxref_s ) capacitor c=0.0908457f \
 //x=21.63 //y=5.56 //x2=21.055 //y2=5.2
cc_7206 ( N_noxref_21_c_10461_n N_VDD_M77_noxref_d ) capacitor c=0.00700141f \
 //x=22.39 //y=5.335 //x2=21.925 //y2=5.2
cc_7207 ( N_noxref_21_c_10478_n N_VDD_M77_noxref_d ) capacitor c=0.0673792f \
 //x=21.63 //y=5.56 //x2=21.925 //y2=5.2
cc_7208 ( N_noxref_21_c_10859_n N_VDD_M77_noxref_d ) capacitor c=0.0674762f \
 //x=22.51 //y=5.56 //x2=21.925 //y2=5.2
cc_7209 ( N_noxref_21_c_10517_n N_VDD_M79_noxref_d ) capacitor c=0.00700141f \
 //x=23.275 //y=5.335 //x2=22.805 //y2=5.2
cc_7210 ( N_noxref_21_c_10859_n N_VDD_M79_noxref_d ) capacitor c=0.067493f \
 //x=22.51 //y=5.56 //x2=22.805 //y2=5.2
cc_7211 ( N_noxref_21_c_10563_n N_VDD_M79_noxref_d ) capacitor c=0.0674288f \
 //x=23.39 //y=5.56 //x2=22.805 //y2=5.2
cc_7212 ( N_noxref_21_c_10521_n N_VDD_M81_noxref_d ) capacitor c=0.00700141f \
 //x=24.085 //y=5.335 //x2=23.685 //y2=5.2
cc_7213 ( N_noxref_21_c_10563_n N_VDD_M81_noxref_d ) capacitor c=0.0673824f \
 //x=23.39 //y=5.56 //x2=23.685 //y2=5.2
cc_7214 ( N_noxref_21_c_10519_n N_VDD_M82_noxref_s ) capacitor c=0.00536022f \
 //x=23.39 //y=5.56 //x2=25.565 //y2=5.2
cc_7215 ( N_noxref_21_c_10521_n N_VDD_M82_noxref_s ) capacitor c=0.00211796f \
 //x=24.085 //y=5.335 //x2=25.565 //y2=5.2
cc_7216 ( N_noxref_21_c_10525_n N_noxref_26_c_13087_n ) capacitor c=0.0036878f \
 //x=23.685 //y=1.305 //x2=24.085 //y2=0.72
cc_7217 ( N_noxref_21_c_10536_n N_noxref_26_c_13087_n ) capacitor \
 c=0.00399931f //x=24.085 //y=1.845 //x2=24.085 //y2=0.72
cc_7218 ( N_noxref_21_M14_noxref_d N_noxref_26_c_13087_n ) capacitor \
 c=0.00910163f //x=23.495 //y=1.095 //x2=24.085 //y2=0.72
cc_7219 ( N_noxref_21_M14_noxref_d N_noxref_26_c_13092_n ) capacitor \
 c=0.00120711f //x=23.495 //y=1.095 //x2=23.2 //y2=1.175
cc_7220 ( N_noxref_21_c_10461_n N_noxref_26_M13_noxref_d ) capacitor \
 c=0.00125456f //x=22.39 //y=5.335 //x2=21.96 //y2=1.09
cc_7221 ( N_noxref_21_c_10525_n N_noxref_26_M13_noxref_d ) capacitor \
 c=0.00802836f //x=23.685 //y=1.305 //x2=21.96 //y2=1.09
cc_7222 ( N_noxref_21_c_10525_n N_noxref_26_M14_noxref_s ) capacitor \
 c=0.00993092f //x=23.685 //y=1.305 //x2=23.065 //y2=0.555
cc_7223 ( N_noxref_21_c_10462_n N_noxref_26_M14_noxref_s ) capacitor \
 c=0.0270492f //x=23.685 //y=1.76 //x2=23.065 //y2=0.555
cc_7224 ( N_noxref_21_c_10536_n N_noxref_26_M14_noxref_s ) capacitor \
 c=0.00871957f //x=24.085 //y=1.845 //x2=23.065 //y2=0.555
cc_7225 ( N_noxref_21_c_10554_n N_noxref_26_M14_noxref_s ) capacitor \
 c=0.0016218f //x=24.17 //y=3.51 //x2=23.065 //y2=0.555
cc_7226 ( N_noxref_21_M14_noxref_d N_noxref_26_M14_noxref_s ) capacitor \
 c=0.0279003f //x=23.495 //y=1.095 //x2=23.065 //y2=0.555
cc_7227 ( N_noxref_21_M148_noxref_g N_noxref_33_c_13612_n ) capacitor \
 c=0.00814026f //x=78.96 //y=6.205 //x2=79.505 //y2=7.09
cc_7228 ( N_noxref_21_M149_noxref_g N_noxref_33_c_13612_n ) capacitor \
 c=0.00937408f //x=79.4 //y=6.205 //x2=79.505 //y2=7.09
cc_7229 ( N_noxref_21_M148_noxref_g N_noxref_33_c_13601_n ) capacitor \
 c=0.0017976f //x=78.96 //y=6.205 //x2=78.737 //y2=7.09
cc_7230 ( N_noxref_21_M149_noxref_g N_noxref_33_c_13615_n ) capacitor \
 c=0.00395674f //x=79.4 //y=6.205 //x2=79.62 //y2=6.92
cc_7231 ( N_noxref_21_M148_noxref_g N_noxref_33_M147_noxref_d ) capacitor \
 c=0.0142133f //x=78.96 //y=6.205 //x2=78.595 //y2=5.205
cc_7232 ( N_noxref_21_c_10921_n N_noxref_33_M149_noxref_d ) capacitor \
 c=0.00256087f //x=79.67 //y=4.885 //x2=79.475 //y2=5.205
cc_7233 ( N_noxref_21_M149_noxref_g N_noxref_33_M149_noxref_d ) capacitor \
 c=0.0365939f //x=79.4 //y=6.205 //x2=79.475 //y2=5.205
cc_7234 ( N_noxref_21_c_10934_n N_noxref_33_M149_noxref_d ) capacitor \
 c=0.00447202f //x=79.4 //y=5.05 //x2=79.475 //y2=5.205
cc_7235 ( N_noxref_21_M148_noxref_g N_noxref_34_c_13737_n ) capacitor \
 c=0.00998198f //x=78.96 //y=6.205 //x2=79.065 //y2=5.39
cc_7236 ( N_noxref_21_c_10636_n N_noxref_34_c_13725_n ) capacitor \
 c=7.77474e-19 //x=79.67 //y=2.43 //x2=81.085 //y2=5.39
cc_7237 ( N_noxref_21_c_10639_n N_noxref_34_c_13725_n ) capacitor \
 c=0.00192695f //x=79.67 //y=3.675 //x2=81.085 //y2=5.39
cc_7238 ( N_noxref_21_c_10640_n N_noxref_34_c_13725_n ) capacitor c=0.0227143f \
 //x=79.67 //y=4.76 //x2=81.085 //y2=5.39
cc_7239 ( N_noxref_21_c_10644_n N_noxref_34_c_13725_n ) capacitor \
 c=0.00141341f //x=81.15 //y=2.43 //x2=81.085 //y2=5.39
cc_7240 ( N_noxref_21_c_10649_n N_noxref_34_c_13725_n ) capacitor c=0.0274606f \
 //x=81.15 //y=4.755 //x2=81.085 //y2=5.39
cc_7241 ( N_noxref_21_c_10921_n N_noxref_34_c_13725_n ) capacitor c=0.0035251f \
 //x=79.67 //y=4.885 //x2=81.085 //y2=5.39
cc_7242 ( N_noxref_21_c_10696_n N_noxref_34_c_13725_n ) capacitor \
 c=0.00429429f //x=81.15 //y=4.885 //x2=81.085 //y2=5.39
cc_7243 ( N_noxref_21_M149_noxref_g N_noxref_34_c_13725_n ) capacitor \
 c=0.011693f //x=79.4 //y=6.205 //x2=81.085 //y2=5.39
cc_7244 ( N_noxref_21_M150_noxref_g N_noxref_34_c_13725_n ) capacitor \
 c=0.00372569f //x=81.42 //y=6.205 //x2=81.085 //y2=5.39
cc_7245 ( N_noxref_21_c_10934_n N_noxref_34_c_13725_n ) capacitor \
 c=0.00482959f //x=79.4 //y=5.05 //x2=81.085 //y2=5.39
cc_7246 ( N_noxref_21_c_10710_n N_noxref_34_c_13725_n ) capacitor \
 c=0.00243015f //x=81.495 //y=4.975 //x2=81.085 //y2=5.39
cc_7247 ( N_noxref_21_M148_noxref_g N_noxref_34_c_13726_n ) capacitor \
 c=6.12451e-19 //x=78.96 //y=6.205 //x2=79.295 //y2=5.39
cc_7248 ( N_noxref_21_M149_noxref_g N_noxref_34_c_13726_n ) capacitor \
 c=8.33934e-19 //x=79.4 //y=6.205 //x2=79.295 //y2=5.39
cc_7249 ( N_noxref_21_M150_noxref_g N_noxref_34_c_13763_n ) capacitor \
 c=0.0109238f //x=81.42 //y=6.205 //x2=81.965 //y2=7.09
cc_7250 ( N_noxref_21_M151_noxref_g N_noxref_34_c_13763_n ) capacitor \
 c=0.00814026f //x=81.86 //y=6.205 //x2=81.965 //y2=7.09
cc_7251 ( N_noxref_21_M148_noxref_g N_noxref_34_c_13730_n ) capacitor \
 c=0.00610004f //x=78.96 //y=6.205 //x2=79.18 //y2=5.39
cc_7252 ( N_noxref_21_M149_noxref_g N_noxref_34_c_13730_n ) capacitor \
 c=0.00485827f //x=79.4 //y=6.205 //x2=79.18 //y2=5.39
cc_7253 ( N_noxref_21_c_11084_p N_noxref_34_c_13730_n ) capacitor \
 c=0.00435703f //x=79.325 //y=4.975 //x2=79.18 //y2=5.39
cc_7254 ( N_noxref_21_M150_noxref_g N_noxref_34_c_13768_n ) capacitor \
 c=0.00394587f //x=81.42 //y=6.205 //x2=81.2 //y2=6.92
cc_7255 ( N_noxref_21_M151_noxref_g N_noxref_34_c_13731_n ) capacitor \
 c=0.00179267f //x=81.86 //y=6.205 //x2=82.08 //y2=7.09
cc_7256 ( N_noxref_21_c_10649_n N_noxref_34_c_13733_n ) capacitor \
 c=0.00533094f //x=81.15 //y=4.755 //x2=81.2 //y2=5.39
cc_7257 ( N_noxref_21_c_10696_n N_noxref_34_c_13733_n ) capacitor c=0.013929f \
 //x=81.15 //y=4.885 //x2=81.2 //y2=5.39
cc_7258 ( N_noxref_21_M150_noxref_g N_noxref_34_c_13733_n ) capacitor \
 c=0.0510602f //x=81.42 //y=6.205 //x2=81.2 //y2=5.39
cc_7259 ( N_noxref_21_c_10710_n N_noxref_34_c_13733_n ) capacitor \
 c=0.00827092f //x=81.495 //y=4.975 //x2=81.2 //y2=5.39
cc_7260 ( N_noxref_21_M151_noxref_g N_noxref_34_M151_noxref_d ) capacitor \
 c=0.0142133f //x=81.86 //y=6.205 //x2=81.935 //y2=5.205
cc_7261 ( N_noxref_21_c_10414_n N_GND_c_14017_n ) capacitor c=0.00210951f \
 //x=18.62 //y=2.26 //x2=21.09 //y2=0.175
cc_7262 ( N_noxref_21_c_10525_n N_GND_c_14061_n ) capacitor c=0.00884249f \
 //x=23.685 //y=1.305 //x2=26.005 //y2=0.175
cc_7263 ( N_noxref_21_c_10536_n N_GND_c_14061_n ) capacitor c=0.00662992f \
 //x=24.085 //y=1.845 //x2=26.005 //y2=0.175
cc_7264 ( N_noxref_21_c_10543_n N_GND_c_14061_n ) capacitor c=2.94169e-19 \
 //x=24.17 //y=3.685 //x2=26.005 //y2=0.175
cc_7265 ( N_noxref_21_M14_noxref_d N_GND_c_14061_n ) capacitor c=2.9462e-19 \
 //x=23.495 //y=1.095 //x2=26.005 //y2=0.175
cc_7266 ( N_noxref_21_c_10636_n N_GND_c_14798_n ) capacitor c=9.61983e-19 \
 //x=79.67 //y=2.43 //x2=81.505 //y2=0.175
cc_7267 ( N_noxref_21_c_10644_n N_GND_c_14798_n ) capacitor c=0.00100426f \
 //x=81.15 //y=2.43 //x2=81.505 //y2=0.175
cc_7268 ( N_noxref_21_c_10693_n N_GND_c_14798_n ) capacitor c=2.64659e-19 \
 //x=81.15 //y=2.26 //x2=81.505 //y2=0.175
cc_7269 ( N_noxref_21_c_10702_n N_GND_c_14801_n ) capacitor c=0.00175529f \
 //x=81.325 //y=1.045 //x2=81.59 //y2=1.02
cc_7270 ( N_noxref_21_c_10703_n N_GND_c_14801_n ) capacitor c=0.00373063f \
 //x=81.325 //y=1.39 //x2=81.59 //y2=1.02
cc_7271 ( N_noxref_21_c_10704_n N_GND_c_14801_n ) capacitor c=3.99385e-19 \
 //x=81.325 //y=1.7 //x2=81.59 //y2=1.02
cc_7272 ( N_noxref_21_c_11103_p N_GND_c_14801_n ) capacitor c=0.00924233f \
 //x=81.7 //y=0.89 //x2=81.59 //y2=1.02
cc_7273 ( N_noxref_21_c_11104_p N_GND_c_14801_n ) capacitor c=6.20182e-19 \
 //x=81.7 //y=1.545 //x2=81.59 //y2=1.02
cc_7274 ( N_noxref_21_c_10713_n N_GND_c_14801_n ) capacitor c=0.00181395f \
 //x=81.855 //y=1.045 //x2=81.59 //y2=1.02
cc_7275 ( N_noxref_21_c_10715_n N_GND_c_14801_n ) capacitor c=0.00394995f \
 //x=81.855 //y=1.39 //x2=81.59 //y2=1.02
cc_7276 ( N_noxref_21_c_10525_n N_GND_c_14091_n ) capacitor c=0.00488628f \
 //x=23.685 //y=1.305 //x2=26.09 //y2=1.135
cc_7277 ( N_noxref_21_c_10414_n N_GND_c_13999_n ) capacitor c=3.77328e-19 \
 //x=18.62 //y=2.26 //x2=19.93 //y2=0.175
cc_7278 ( N_noxref_21_c_10536_n N_GND_c_14039_n ) capacitor c=6.86343e-19 \
 //x=24.085 //y=1.845 //x2=24.74 //y2=0.175
cc_7279 ( N_noxref_21_c_10543_n N_GND_c_14039_n ) capacitor c=4.01367e-19 \
 //x=24.17 //y=3.685 //x2=24.74 //y2=0.175
cc_7280 ( N_noxref_21_c_10636_n N_GND_c_14765_n ) capacitor c=9.41767e-19 \
 //x=79.67 //y=2.43 //x2=80.24 //y2=0.175
cc_7281 ( N_noxref_21_c_10644_n N_GND_c_14322_n ) capacitor c=6.59434e-19 \
 //x=81.15 //y=2.43 //x2=83.57 //y2=0.175
cc_7282 ( N_noxref_21_c_10702_n N_GND_c_14322_n ) capacitor c=0.00698682f \
 //x=81.325 //y=1.045 //x2=83.57 //y2=0.175
cc_7283 ( N_noxref_21_c_10419_n N_GND_c_14041_n ) capacitor c=0.00207214f \
 //x=18.62 //y=2.26 //x2=20.1 //y2=0.175
cc_7284 ( N_noxref_21_c_10438_n N_GND_c_14041_n ) capacitor c=0.00275184f \
 //x=19.185 //y=1.43 //x2=20.1 //y2=0.175
cc_7285 ( N_noxref_21_c_10462_n N_GND_c_14078_n ) capacitor c=0.00285697f \
 //x=23.685 //y=1.76 //x2=24.91 //y2=0.175
cc_7286 ( N_noxref_21_c_10536_n N_GND_c_14078_n ) capacitor c=0.0311746f \
 //x=24.085 //y=1.845 //x2=24.91 //y2=0.175
cc_7287 ( N_noxref_21_c_10682_n N_GND_c_14338_n ) capacitor c=0.0048919f \
 //x=72.485 //y=3.5 //x2=77.08 //y2=0.175
cc_7288 ( N_noxref_21_c_10917_n N_GND_c_14338_n ) capacitor c=3.88707e-19 \
 //x=79.67 //y=2.26 //x2=77.08 //y2=0.175
cc_7289 ( N_noxref_21_c_10636_n N_GND_c_14342_n ) capacitor c=0.00414357f \
 //x=79.67 //y=2.43 //x2=80.41 //y2=0.175
cc_7290 ( N_noxref_21_c_10637_n N_GND_c_14342_n ) capacitor c=0.0117547f \
 //x=79.67 //y=3.355 //x2=80.41 //y2=0.175
cc_7291 ( N_noxref_21_c_10644_n N_GND_c_14342_n ) capacitor c=0.00414357f \
 //x=81.15 //y=2.43 //x2=80.41 //y2=0.175
cc_7292 ( N_noxref_21_c_10649_n N_GND_c_14342_n ) capacitor c=0.0117547f \
 //x=81.15 //y=4.755 //x2=80.41 //y2=0.175
cc_7293 ( N_noxref_21_c_10692_n N_GND_c_14342_n ) capacitor c=0.0153655f \
 //x=80.985 //y=2.27 //x2=80.41 //y2=0.175
cc_7294 ( N_noxref_21_c_10917_n N_GND_c_14342_n ) capacitor c=0.00780676f \
 //x=79.67 //y=2.26 //x2=80.41 //y2=0.175
cc_7295 ( N_noxref_21_c_10693_n N_GND_c_14342_n ) capacitor c=0.00780676f \
 //x=81.15 //y=2.26 //x2=80.41 //y2=0.175
cc_7296 ( N_noxref_21_c_10939_n N_GND_c_14342_n ) capacitor c=0.00967557f \
 //x=79.495 //y=2.095 //x2=80.41 //y2=0.175
cc_7297 ( N_noxref_21_c_10706_n N_GND_c_14342_n ) capacitor c=0.00347725f \
 //x=81.325 //y=2.095 //x2=80.41 //y2=0.175
cc_7298 ( N_noxref_21_c_10719_n N_GND_c_14342_n ) capacitor c=0.00619832f \
 //x=81.15 //y=2.26 //x2=80.41 //y2=0.175
cc_7299 ( N_noxref_21_c_10693_n N_GND_c_14343_n ) capacitor c=2.74348e-19 \
 //x=81.15 //y=2.26 //x2=83.74 //y2=0.175
cc_7300 ( N_noxref_21_c_10702_n N_GND_M49_noxref_d ) capacitor c=0.00192399f \
 //x=81.325 //y=1.045 //x2=81.4 //y2=1.045
cc_7301 ( N_noxref_21_c_10703_n N_GND_M49_noxref_d ) capacitor c=0.00210798f \
 //x=81.325 //y=1.39 //x2=81.4 //y2=1.045
cc_7302 ( N_noxref_21_c_11103_p N_GND_M49_noxref_d ) capacitor c=0.00472259f \
 //x=81.7 //y=0.89 //x2=81.4 //y2=1.045
cc_7303 ( N_noxref_21_c_11104_p N_GND_M49_noxref_d ) capacitor c=0.00166857f \
 //x=81.7 //y=1.545 //x2=81.4 //y2=1.045
cc_7304 ( N_noxref_21_c_10713_n N_GND_M49_noxref_d ) capacitor c=0.00230174f \
 //x=81.855 //y=1.045 //x2=81.4 //y2=1.045
cc_7305 ( N_noxref_21_c_10715_n N_GND_M49_noxref_d ) capacitor c=0.00210798f \
 //x=81.855 //y=1.39 //x2=81.4 //y2=1.045
cc_7306 ( N_noxref_21_c_10405_n N_noxref_41_c_15851_n ) capacitor \
 c=5.80222e-19 //x=18.62 //y=3.655 //x2=18.435 //y2=1.675
cc_7307 ( N_noxref_21_c_10414_n N_noxref_41_c_15851_n ) capacitor \
 c=7.50092e-19 //x=18.62 //y=2.26 //x2=18.435 //y2=1.675
cc_7308 ( N_noxref_21_c_10434_n N_noxref_41_c_15851_n ) capacitor \
 c=0.00888238f //x=18.655 //y=1.74 //x2=18.435 //y2=1.675
cc_7309 ( N_noxref_21_c_10439_n N_noxref_41_c_15851_n ) capacitor \
 c=0.00175171f //x=18.62 //y=2.26 //x2=18.435 //y2=1.675
cc_7310 ( N_noxref_21_c_10405_n N_noxref_41_c_15856_n ) capacitor \
 c=2.89531e-19 //x=18.62 //y=3.655 //x2=19.32 //y2=0.71
cc_7311 ( N_noxref_21_c_10414_n N_noxref_41_c_15856_n ) capacitor c=0.001463f \
 //x=18.62 //y=2.26 //x2=19.32 //y2=0.71
cc_7312 ( N_noxref_21_c_10419_n N_noxref_41_c_15856_n ) capacitor \
 c=8.82141e-19 //x=18.62 //y=2.26 //x2=19.32 //y2=0.71
cc_7313 ( N_noxref_21_c_10429_n N_noxref_41_c_15856_n ) capacitor c=0.0200738f \
 //x=18.655 //y=1.085 //x2=19.32 //y2=0.71
cc_7314 ( N_noxref_21_c_10437_n N_noxref_41_c_15856_n ) capacitor \
 c=0.00825432f //x=19.185 //y=1.085 //x2=19.32 //y2=0.71
cc_7315 ( N_noxref_21_c_10439_n N_noxref_41_c_15856_n ) capacitor c=2.1838e-19 \
 //x=18.62 //y=2.26 //x2=19.32 //y2=0.71
cc_7316 ( N_noxref_21_c_10429_n N_noxref_41_M10_noxref_s ) capacitor \
 c=0.00888238f //x=18.655 //y=1.085 //x2=17.33 //y2=0.545
cc_7317 ( N_noxref_21_c_10437_n N_noxref_41_M10_noxref_s ) capacitor \
 c=0.015333f //x=19.185 //y=1.085 //x2=17.33 //y2=0.545
cc_7318 ( N_noxref_21_c_10438_n N_noxref_41_M10_noxref_s ) capacitor \
 c=0.00248746f //x=19.185 //y=1.43 //x2=17.33 //y2=0.545
cc_7319 ( N_noxref_21_c_10682_n N_noxref_55_M45_noxref_s ) capacitor \
 c=0.00202811f //x=72.485 //y=3.5 //x2=74.31 //y2=0.545
cc_7320 ( N_noxref_21_M148_noxref_g noxref_56 ) capacitor c=0.00925495f \
 //x=78.96 //y=6.205 //x2=79.035 //y2=5.205
cc_7321 ( N_noxref_21_M149_noxref_g noxref_56 ) capacitor c=0.00925495f \
 //x=79.4 //y=6.205 //x2=79.035 //y2=5.205
cc_7322 ( N_noxref_21_c_10682_n N_noxref_57_c_16804_n ) capacitor \
 c=0.00176222f //x=72.485 //y=3.5 //x2=77.775 //y2=1.675
cc_7323 ( N_noxref_21_c_10682_n N_noxref_57_c_16805_n ) capacitor \
 c=0.00681141f //x=72.485 //y=3.5 //x2=78.66 //y2=1.76
cc_7324 ( N_noxref_21_c_10682_n N_noxref_57_c_16812_n ) capacitor \
 c=0.00202811f //x=72.485 //y=3.5 //x2=78.745 //y2=1.675
cc_7325 ( N_noxref_21_c_10939_n N_noxref_57_c_16812_n ) capacitor c=0.0028747f \
 //x=79.495 //y=2.095 //x2=78.745 //y2=1.675
cc_7326 ( N_noxref_21_c_10636_n N_noxref_57_c_16820_n ) capacitor \
 c=6.64536e-19 //x=79.67 //y=2.43 //x2=79.63 //y2=0.71
cc_7327 ( N_noxref_21_c_10639_n N_noxref_57_c_16820_n ) capacitor \
 c=4.61392e-19 //x=79.67 //y=3.675 //x2=79.63 //y2=0.71
cc_7328 ( N_noxref_21_c_10927_n N_noxref_57_c_16820_n ) capacitor c=0.0214576f \
 //x=78.965 //y=1.085 //x2=79.63 //y2=0.71
cc_7329 ( N_noxref_21_c_10936_n N_noxref_57_c_16820_n ) capacitor \
 c=0.00781103f //x=79.495 //y=1.085 //x2=79.63 //y2=0.71
cc_7330 ( N_noxref_21_c_10636_n N_noxref_57_M47_noxref_s ) capacitor \
 c=0.00472586f //x=79.67 //y=2.43 //x2=77.64 //y2=0.545
cc_7331 ( N_noxref_21_c_10917_n N_noxref_57_M47_noxref_s ) capacitor \
 c=0.00867158f //x=79.67 //y=2.26 //x2=77.64 //y2=0.545
cc_7332 ( N_noxref_21_c_10927_n N_noxref_57_M47_noxref_s ) capacitor \
 c=0.00506846f //x=78.965 //y=1.085 //x2=77.64 //y2=0.545
cc_7333 ( N_noxref_21_c_10930_n N_noxref_57_M47_noxref_s ) capacitor \
 c=0.00602248f //x=78.965 //y=1.43 //x2=77.64 //y2=0.545
cc_7334 ( N_noxref_21_c_10936_n N_noxref_57_M47_noxref_s ) capacitor \
 c=0.028957f //x=79.495 //y=1.085 //x2=77.64 //y2=0.545
cc_7335 ( N_noxref_21_c_10938_n N_noxref_57_M47_noxref_s ) capacitor \
 c=0.00369225f //x=79.495 //y=1.74 //x2=77.64 //y2=0.545
cc_7336 ( N_noxref_21_c_10939_n N_noxref_57_M47_noxref_s ) capacitor \
 c=0.00797698f //x=79.495 //y=2.095 //x2=77.64 //y2=0.545
cc_7337 ( N_noxref_21_c_10644_n N_noxref_58_c_16880_n ) capacitor \
 c=0.00472586f //x=81.15 //y=2.43 //x2=81.105 //y2=1.675
cc_7338 ( N_noxref_21_c_10693_n N_noxref_58_c_16880_n ) capacitor c=0.010408f \
 //x=81.15 //y=2.26 //x2=81.105 //y2=1.675
cc_7339 ( N_noxref_21_c_10706_n N_noxref_58_c_16880_n ) capacitor \
 c=0.00262672f //x=81.325 //y=2.095 //x2=81.105 //y2=1.675
cc_7340 ( N_noxref_21_c_10719_n N_noxref_58_c_16880_n ) capacitor \
 c=0.00544234f //x=81.15 //y=2.26 //x2=81.105 //y2=1.675
cc_7341 ( N_noxref_21_c_10644_n N_noxref_58_c_16867_n ) capacitor \
 c=0.00350518f //x=81.15 //y=2.43 //x2=81.99 //y2=1.76
cc_7342 ( N_noxref_21_c_10693_n N_noxref_58_c_16867_n ) capacitor \
 c=0.00305795f //x=81.15 //y=2.26 //x2=81.99 //y2=1.76
cc_7343 ( N_noxref_21_c_10704_n N_noxref_58_c_16867_n ) capacitor \
 c=0.00712798f //x=81.325 //y=1.7 //x2=81.99 //y2=1.76
cc_7344 ( N_noxref_21_c_10706_n N_noxref_58_c_16867_n ) capacitor c=0.013968f \
 //x=81.325 //y=2.095 //x2=81.99 //y2=1.76
cc_7345 ( N_noxref_21_c_11104_p N_noxref_58_c_16867_n ) capacitor \
 c=0.00948889f //x=81.7 //y=1.545 //x2=81.99 //y2=1.76
cc_7346 ( N_noxref_21_c_10715_n N_noxref_58_c_16867_n ) capacitor \
 c=0.00339872f //x=81.855 //y=1.39 //x2=81.99 //y2=1.76
cc_7347 ( N_noxref_21_c_10719_n N_noxref_58_c_16867_n ) capacitor \
 c=0.00168631f //x=81.15 //y=2.26 //x2=81.99 //y2=1.76
cc_7348 ( N_noxref_21_c_10706_n N_noxref_58_c_16868_n ) capacitor \
 c=6.71402e-19 //x=81.325 //y=2.095 //x2=82.075 //y2=1.675
cc_7349 ( N_noxref_21_c_10702_n N_noxref_58_M49_noxref_s ) capacitor \
 c=0.0293163f //x=81.325 //y=1.045 //x2=80.97 //y2=0.545
cc_7350 ( N_noxref_21_c_10704_n N_noxref_58_M49_noxref_s ) capacitor \
 c=0.00110192f //x=81.325 //y=1.7 //x2=80.97 //y2=0.545
cc_7351 ( N_noxref_21_c_10713_n N_noxref_58_M49_noxref_s ) capacitor \
 c=0.0123625f //x=81.855 //y=1.045 //x2=80.97 //y2=0.545
cc_7352 ( N_noxref_22_c_11202_n N_VDD_c_12764_n ) capacitor c=2.26208e-19 \
 //x=82.915 //y=5.39 //x2=85.22 //y2=7.58
cc_7353 ( N_noxref_22_c_11212_n N_VDD_c_12764_n ) capacitor c=4.99801e-19 \
 //x=83 //y=4.415 //x2=85.22 //y2=7.58
cc_7354 ( N_noxref_22_c_11312_p N_VDD_c_12764_n ) capacitor c=3.0454e-19 \
 //x=84.48 //y=4.415 //x2=85.22 //y2=7.58
cc_7355 ( N_noxref_22_c_11221_n N_VDD_c_12764_n ) capacitor c=5.73169e-19 \
 //x=84.48 //y=4.76 //x2=85.22 //y2=7.58
cc_7356 ( N_noxref_22_c_11314_p N_VDD_c_12764_n ) capacitor c=3.40755e-19 \
 //x=84.48 //y=4.88 //x2=85.22 //y2=7.58
cc_7357 ( N_noxref_22_c_11202_n N_VDD_c_12141_n ) capacitor c=0.00135523f \
 //x=82.915 //y=5.39 //x2=83.57 //y2=7.585
cc_7358 ( N_noxref_22_c_11212_n N_VDD_c_12141_n ) capacitor c=4.02953e-19 \
 //x=83 //y=4.415 //x2=83.57 //y2=7.585
cc_7359 ( N_noxref_22_c_11300_n N_VDD_c_12141_n ) capacitor c=0.00488797f \
 //x=81.64 //y=5.56 //x2=83.57 //y2=7.585
cc_7360 ( N_noxref_22_c_11245_n N_VDD_c_12141_n ) capacitor c=0.00513429f \
 //x=82.52 //y=5.56 //x2=83.57 //y2=7.585
cc_7361 ( N_noxref_22_c_11221_n N_VDD_c_12773_n ) capacitor c=5.48929e-19 \
 //x=84.48 //y=4.76 //x2=85.21 //y2=7.585
cc_7362 ( N_noxref_22_M154_noxref_g N_VDD_c_12773_n ) capacitor c=0.00753931f \
 //x=84.635 //y=6.2 //x2=85.21 //y2=7.585
cc_7363 ( N_noxref_22_M155_noxref_g N_VDD_c_12773_n ) capacitor c=0.00755544f \
 //x=85.075 //y=6.2 //x2=85.21 //y2=7.585
cc_7364 ( N_noxref_22_c_11216_n N_VDD_c_12163_n ) capacitor c=0.00128037f \
 //x=83 //y=5.305 //x2=80.41 //y2=7.585
cc_7365 ( N_noxref_22_c_11300_n N_VDD_c_12163_n ) capacitor c=0.00535462f \
 //x=81.64 //y=5.56 //x2=80.41 //y2=7.585
cc_7366 ( N_noxref_22_c_11212_n N_VDD_c_12167_n ) capacitor c=0.0019054f \
 //x=83 //y=4.415 //x2=83.74 //y2=7.585
cc_7367 ( N_noxref_22_c_11216_n N_VDD_c_12167_n ) capacitor c=0.0249794f \
 //x=83 //y=5.305 //x2=83.74 //y2=7.585
cc_7368 ( N_noxref_22_c_11312_p N_VDD_c_12167_n ) capacitor c=0.0019054f \
 //x=84.48 //y=4.415 //x2=83.74 //y2=7.585
cc_7369 ( N_noxref_22_c_11221_n N_VDD_c_12167_n ) capacitor c=0.0128286f \
 //x=84.48 //y=4.76 //x2=83.74 //y2=7.585
cc_7370 ( N_noxref_22_c_11230_n N_VDD_c_12167_n ) capacitor c=0.00265362f \
 //x=82.517 //y=5.39 //x2=83.74 //y2=7.585
cc_7371 ( N_noxref_22_c_11234_n N_VDD_c_12167_n ) capacitor c=0.00486566f \
 //x=83 //y=4.25 //x2=83.74 //y2=7.585
cc_7372 ( N_noxref_22_c_11330_p N_VDD_c_12167_n ) capacitor c=0.00486566f \
 //x=84.48 //y=4.25 //x2=83.74 //y2=7.585
cc_7373 ( N_noxref_22_c_11331_p N_VDD_c_12167_n ) capacitor c=0.0183218f \
 //x=84.32 //y=4.255 //x2=83.74 //y2=7.585
cc_7374 ( N_noxref_22_c_11245_n N_VDD_c_12167_n ) capacitor c=0.00899475f \
 //x=82.52 //y=5.56 //x2=83.74 //y2=7.585
cc_7375 ( N_noxref_22_c_11314_p N_VDD_c_12167_n ) capacitor c=0.0079528f \
 //x=84.48 //y=4.88 //x2=83.74 //y2=7.585
cc_7376 ( N_noxref_22_M154_noxref_g N_VDD_c_12167_n ) capacitor c=0.00873815f \
 //x=84.635 //y=6.2 //x2=83.74 //y2=7.585
cc_7377 ( N_noxref_22_c_11335_p N_VDD_c_12167_n ) capacitor c=0.00799922f \
 //x=84.71 //y=4.97 //x2=83.74 //y2=7.585
cc_7378 ( N_noxref_22_c_11330_p N_VDD_c_12790_n ) capacitor c=0.00143727f \
 //x=84.48 //y=4.25 //x2=85.22 //y2=7.58
cc_7379 ( N_noxref_22_c_11314_p N_VDD_c_12790_n ) capacitor c=0.00235165f \
 //x=84.48 //y=4.88 //x2=85.22 //y2=7.58
cc_7380 ( N_noxref_22_c_11338_p N_VDD_c_12790_n ) capacitor c=0.0195827f \
 //x=85 //y=4.97 //x2=85.22 //y2=7.58
cc_7381 ( N_noxref_22_c_11335_p N_VDD_c_12790_n ) capacitor c=2.63786e-19 \
 //x=84.71 //y=4.97 //x2=85.22 //y2=7.58
cc_7382 ( N_noxref_22_c_11202_n N_VDD_M154_noxref_s ) capacitor c=0.00343522f \
 //x=82.915 //y=5.39 //x2=84.28 //y2=5.2
cc_7383 ( N_noxref_22_c_11312_p N_VDD_M154_noxref_s ) capacitor c=0.00247632f \
 //x=84.48 //y=4.415 //x2=84.28 //y2=5.2
cc_7384 ( N_noxref_22_c_11221_n N_VDD_M154_noxref_s ) capacitor c=0.0208734f \
 //x=84.48 //y=4.76 //x2=84.28 //y2=5.2
cc_7385 ( N_noxref_22_c_11230_n N_VDD_M154_noxref_s ) capacitor c=0.00575207f \
 //x=82.517 //y=5.39 //x2=84.28 //y2=5.2
cc_7386 ( N_noxref_22_c_11344_p N_VDD_M154_noxref_s ) capacitor c=6.60267e-19 \
 //x=84.48 //y=4.255 //x2=84.28 //y2=5.2
cc_7387 ( N_noxref_22_c_11331_p N_VDD_M154_noxref_s ) capacitor c=3.46335e-19 \
 //x=84.32 //y=4.255 //x2=84.28 //y2=5.2
cc_7388 ( N_noxref_22_c_11314_p N_VDD_M154_noxref_s ) capacitor c=0.00986169f \
 //x=84.48 //y=4.88 //x2=84.28 //y2=5.2
cc_7389 ( N_noxref_22_M154_noxref_g N_VDD_M154_noxref_s ) capacitor \
 c=0.0573441f //x=84.635 //y=6.2 //x2=84.28 //y2=5.2
cc_7390 ( N_noxref_22_c_11335_p N_VDD_M154_noxref_s ) capacitor c=0.0053173f \
 //x=84.71 //y=4.97 //x2=84.28 //y2=5.2
cc_7391 ( N_noxref_22_M155_noxref_g N_VDD_M155_noxref_d ) capacitor \
 c=0.0572684f //x=85.075 //y=6.2 //x2=85.15 //y2=5.2
cc_7392 ( N_noxref_22_c_11222_n N_noxref_33_c_13570_n ) capacitor \
 c=2.95128e-19 //x=75.9 //y=1.36 //x2=77.745 //y2=5.39
cc_7393 ( N_noxref_22_c_11222_n N_noxref_33_c_13571_n ) capacitor \
 c=3.81263e-19 //x=75.9 //y=1.36 //x2=75.975 //y2=5.39
cc_7394 ( N_noxref_22_c_11216_n N_noxref_34_c_13725_n ) capacitor \
 c=5.76261e-19 //x=83 //y=5.305 //x2=81.085 //y2=5.39
cc_7395 ( N_noxref_22_c_11273_n N_noxref_34_c_13725_n ) capacitor \
 c=2.00473e-19 //x=79.23 //y=1.36 //x2=81.085 //y2=5.39
cc_7396 ( N_noxref_22_c_11229_n N_noxref_34_c_13725_n ) capacitor c=0.0327245f \
 //x=81.64 //y=5.39 //x2=81.085 //y2=5.39
cc_7397 ( N_noxref_22_c_11300_n N_noxref_34_c_13725_n ) capacitor \
 c=0.00238429f //x=81.64 //y=5.56 //x2=81.085 //y2=5.39
cc_7398 ( N_noxref_22_c_11273_n N_noxref_34_c_13726_n ) capacitor \
 c=7.95563e-19 //x=79.23 //y=1.36 //x2=79.295 //y2=5.39
cc_7399 ( N_noxref_22_c_11183_n N_noxref_34_c_13763_n ) capacitor \
 c=0.00311493f //x=82.395 //y=5.39 //x2=81.965 //y2=7.09
cc_7400 ( N_noxref_22_c_11229_n N_noxref_34_c_13763_n ) capacitor \
 c=0.00538798f //x=81.64 //y=5.39 //x2=81.965 //y2=7.09
cc_7401 ( N_noxref_22_c_11300_n N_noxref_34_c_13763_n ) capacitor \
 c=0.00406191f //x=81.64 //y=5.56 //x2=81.965 //y2=7.09
cc_7402 ( N_noxref_22_c_11183_n N_noxref_34_c_13727_n ) capacitor \
 c=0.00305195f //x=82.395 //y=5.39 //x2=82.83 //y2=7.09
cc_7403 ( N_noxref_22_c_11202_n N_noxref_34_c_13727_n ) capacitor \
 c=0.00291085f //x=82.915 //y=5.39 //x2=82.83 //y2=7.09
cc_7404 ( N_noxref_22_c_11230_n N_noxref_34_c_13727_n ) capacitor \
 c=0.00559082f //x=82.517 //y=5.39 //x2=82.83 //y2=7.09
cc_7405 ( N_noxref_22_c_11245_n N_noxref_34_c_13727_n ) capacitor \
 c=0.00396177f //x=82.52 //y=5.56 //x2=82.83 //y2=7.09
cc_7406 ( N_noxref_22_c_11229_n N_noxref_34_c_13729_n ) capacitor \
 c=0.00240034f //x=81.64 //y=5.39 //x2=78.3 //y2=5.39
cc_7407 ( N_noxref_22_c_11183_n N_noxref_34_c_13731_n ) capacitor \
 c=0.00459659f //x=82.395 //y=5.39 //x2=82.08 //y2=7.09
cc_7408 ( N_noxref_22_c_11202_n N_noxref_34_c_13732_n ) capacitor \
 c=0.00536247f //x=82.915 //y=5.39 //x2=82.96 //y2=6.92
cc_7409 ( N_noxref_22_c_11216_n N_noxref_34_c_13733_n ) capacitor \
 c=5.23099e-19 //x=83 //y=5.305 //x2=81.2 //y2=5.39
cc_7410 ( N_noxref_22_c_11229_n N_noxref_34_c_13733_n ) capacitor c=0.010446f \
 //x=81.64 //y=5.39 //x2=81.2 //y2=5.39
cc_7411 ( N_noxref_22_c_11300_n N_noxref_34_c_13733_n ) capacitor c=0.0649815f \
 //x=81.64 //y=5.56 //x2=81.2 //y2=5.39
cc_7412 ( N_noxref_22_c_11183_n N_noxref_34_M151_noxref_d ) capacitor \
 c=0.00678641f //x=82.395 //y=5.39 //x2=81.935 //y2=5.205
cc_7413 ( N_noxref_22_c_11230_n N_noxref_34_M151_noxref_d ) capacitor \
 c=0.00184359f //x=82.517 //y=5.39 //x2=81.935 //y2=5.205
cc_7414 ( N_noxref_22_c_11300_n N_noxref_34_M151_noxref_d ) capacitor \
 c=0.0476949f //x=81.64 //y=5.56 //x2=81.935 //y2=5.205
cc_7415 ( N_noxref_22_c_11245_n N_noxref_34_M151_noxref_d ) capacitor \
 c=0.0473507f //x=82.52 //y=5.56 //x2=81.935 //y2=5.205
cc_7416 ( N_noxref_22_c_11202_n N_noxref_34_M153_noxref_d ) capacitor \
 c=0.00735506f //x=82.915 //y=5.39 //x2=82.815 //y2=5.205
cc_7417 ( N_noxref_22_c_11230_n N_noxref_34_M153_noxref_d ) capacitor \
 c=0.0012641f //x=82.517 //y=5.39 //x2=82.815 //y2=5.205
cc_7418 ( N_noxref_22_c_11234_n N_noxref_34_M153_noxref_d ) capacitor \
 c=0.00165396f //x=83 //y=4.25 //x2=82.815 //y2=5.205
cc_7419 ( N_noxref_22_c_11245_n N_noxref_34_M153_noxref_d ) capacitor \
 c=0.0473507f //x=82.52 //y=5.56 //x2=82.815 //y2=5.205
cc_7420 ( N_noxref_22_c_11222_n N_GND_c_14313_n ) capacitor c=0.00185137f \
 //x=75.9 //y=1.36 //x2=74.93 //y2=1.015
cc_7421 ( N_noxref_22_c_11284_n N_GND_c_14313_n ) capacitor c=7.42708e-19 \
 //x=76.065 //y=1.405 //x2=74.93 //y2=1.015
cc_7422 ( N_noxref_22_M46_noxref_d N_GND_c_14313_n ) capacitor c=2.62581e-19 \
 //x=75.71 //y=1.085 //x2=74.93 //y2=1.015
cc_7423 ( N_noxref_22_c_11222_n N_GND_c_14314_n ) capacitor c=0.00560939f \
 //x=75.9 //y=1.36 //x2=78.175 //y2=0.175
cc_7424 ( N_noxref_22_c_11284_n N_GND_c_14314_n ) capacitor c=0.00701775f \
 //x=76.065 //y=1.405 //x2=78.175 //y2=0.175
cc_7425 ( N_noxref_22_c_11236_n N_GND_c_14314_n ) capacitor c=0.113183f \
 //x=79.1 //y=1.405 //x2=78.175 //y2=0.175
cc_7426 ( N_noxref_22_M46_noxref_d N_GND_c_14314_n ) capacitor c=2.01013e-19 \
 //x=75.71 //y=1.085 //x2=78.175 //y2=0.175
cc_7427 ( N_noxref_22_c_11222_n N_GND_c_14753_n ) capacitor c=3.05541e-19 \
 //x=75.9 //y=1.36 //x2=78.26 //y2=1.015
cc_7428 ( N_noxref_22_c_11273_n N_GND_c_14753_n ) capacitor c=0.00263562f \
 //x=79.23 //y=1.36 //x2=78.26 //y2=1.015
cc_7429 ( N_noxref_22_c_11284_n N_GND_c_14753_n ) capacitor c=4.33523e-19 \
 //x=76.065 //y=1.405 //x2=78.26 //y2=1.015
cc_7430 ( N_noxref_22_c_11236_n N_GND_c_14753_n ) capacitor c=0.0203963f \
 //x=79.1 //y=1.405 //x2=78.26 //y2=1.015
cc_7431 ( N_noxref_22_M48_noxref_d N_GND_c_14753_n ) capacitor c=2.62581e-19 \
 //x=79.04 //y=1.085 //x2=78.26 //y2=1.015
cc_7432 ( N_noxref_22_c_11273_n N_GND_c_14798_n ) capacitor c=0.00848351f \
 //x=79.23 //y=1.36 //x2=81.505 //y2=0.175
cc_7433 ( N_noxref_22_c_11236_n N_GND_c_14798_n ) capacitor c=0.0330907f \
 //x=79.1 //y=1.405 //x2=81.505 //y2=0.175
cc_7434 ( N_noxref_22_c_11287_n N_GND_c_14798_n ) capacitor c=0.00561615f \
 //x=79.36 //y=1.405 //x2=81.505 //y2=0.175
cc_7435 ( N_noxref_22_c_11239_n N_GND_c_14798_n ) capacitor c=0.104531f \
 //x=82.395 //y=1.405 //x2=81.505 //y2=0.175
cc_7436 ( N_noxref_22_M48_noxref_d N_GND_c_14798_n ) capacitor c=2.01013e-19 \
 //x=79.04 //y=1.085 //x2=81.505 //y2=0.175
cc_7437 ( N_noxref_22_c_11190_n N_GND_c_14801_n ) capacitor c=0.00195467f \
 //x=82.56 //y=1.535 //x2=81.59 //y2=1.02
cc_7438 ( N_noxref_22_c_11273_n N_GND_c_14801_n ) capacitor c=8.32974e-19 \
 //x=79.23 //y=1.36 //x2=81.59 //y2=1.02
cc_7439 ( N_noxref_22_c_11229_n N_GND_c_14801_n ) capacitor c=9.01285e-19 \
 //x=81.64 //y=5.39 //x2=81.59 //y2=1.02
cc_7440 ( N_noxref_22_c_11237_n N_GND_c_14801_n ) capacitor c=8.08914e-19 \
 //x=82.555 //y=1.405 //x2=81.59 //y2=1.02
cc_7441 ( N_noxref_22_c_11239_n N_GND_c_14801_n ) capacitor c=0.0204811f \
 //x=82.395 //y=1.405 //x2=81.59 //y2=1.02
cc_7442 ( N_noxref_22_M50_noxref_d N_GND_c_14801_n ) capacitor c=2.62581e-19 \
 //x=82.37 //y=1.085 //x2=81.59 //y2=1.02
cc_7443 ( N_noxref_22_c_11190_n N_GND_c_14316_n ) capacitor c=0.00524308f \
 //x=82.56 //y=1.535 //x2=85.22 //y2=0.18
cc_7444 ( N_noxref_22_c_11203_n N_GND_c_14316_n ) capacitor c=0.0062416f \
 //x=82.915 //y=1.825 //x2=85.22 //y2=0.18
cc_7445 ( N_noxref_22_c_11212_n N_GND_c_14316_n ) capacitor c=3.81645e-19 \
 //x=83 //y=4.415 //x2=85.22 //y2=0.18
cc_7446 ( N_noxref_22_c_11312_p N_GND_c_14316_n ) capacitor c=3.80542e-19 \
 //x=84.48 //y=4.415 //x2=85.22 //y2=0.18
cc_7447 ( N_noxref_22_c_11405_p N_GND_c_14316_n ) capacitor c=0.00249122f \
 //x=84.48 //y=2.265 //x2=85.22 //y2=0.18
cc_7448 ( N_noxref_22_c_11237_n N_GND_c_14316_n ) capacitor c=0.00777895f \
 //x=82.555 //y=1.405 //x2=85.22 //y2=0.18
cc_7449 ( N_noxref_22_c_11239_n N_GND_c_14316_n ) capacitor c=0.038217f \
 //x=82.395 //y=1.405 //x2=85.22 //y2=0.18
cc_7450 ( N_noxref_22_c_11408_p N_GND_c_14316_n ) capacitor c=7.5371e-19 \
 //x=84.48 //y=2.265 //x2=85.22 //y2=0.18
cc_7451 ( N_noxref_22_M50_noxref_d N_GND_c_14316_n ) capacitor c=2.01013e-19 \
 //x=82.37 //y=1.085 //x2=85.22 //y2=0.18
cc_7452 ( N_noxref_22_c_11203_n N_GND_c_14322_n ) capacitor c=7.45235e-19 \
 //x=82.915 //y=1.825 //x2=83.57 //y2=0.175
cc_7453 ( N_noxref_22_c_11405_p N_GND_c_14871_n ) capacitor c=0.00114179f \
 //x=84.48 //y=2.265 //x2=84.765 //y2=0.715
cc_7454 ( N_noxref_22_c_11408_p N_GND_c_14871_n ) capacitor c=3.95714e-19 \
 //x=84.48 //y=2.265 //x2=84.765 //y2=0.715
cc_7455 ( N_noxref_22_c_11413_p N_GND_c_14871_n ) capacitor c=0.0125549f \
 //x=84.59 //y=1.09 //x2=84.765 //y2=0.715
cc_7456 ( N_noxref_22_c_11414_p N_GND_c_14871_n ) capacitor c=2.1838e-19 \
 //x=84.48 //y=2.265 //x2=84.765 //y2=0.715
cc_7457 ( N_noxref_22_c_11415_p N_GND_c_14875_n ) capacitor c=0.0134289f \
 //x=85.12 //y=1.09 //x2=85.255 //y2=0.715
cc_7458 ( N_noxref_22_c_11236_n N_GND_c_14338_n ) capacitor c=0.0202893f \
 //x=79.1 //y=1.405 //x2=77.08 //y2=0.175
cc_7459 ( N_noxref_22_M46_noxref_d N_GND_c_14338_n ) capacitor c=0.00128657f \
 //x=75.71 //y=1.085 //x2=77.08 //y2=0.175
cc_7460 ( N_noxref_22_c_11205_n N_GND_c_14342_n ) capacitor c=0.00135353f \
 //x=83 //y=4.095 //x2=80.41 //y2=0.175
cc_7461 ( N_noxref_22_c_11239_n N_GND_c_14342_n ) capacitor c=0.0183315f \
 //x=82.395 //y=1.405 //x2=80.41 //y2=0.175
cc_7462 ( N_noxref_22_M48_noxref_d N_GND_c_14342_n ) capacitor c=0.00129152f \
 //x=79.04 //y=1.085 //x2=80.41 //y2=0.175
cc_7463 ( N_noxref_22_c_11200_n N_GND_c_14343_n ) capacitor c=0.00248396f \
 //x=82.56 //y=1.74 //x2=83.74 //y2=0.175
cc_7464 ( N_noxref_22_c_11203_n N_GND_c_14343_n ) capacitor c=0.0274191f \
 //x=82.915 //y=1.825 //x2=83.74 //y2=0.175
cc_7465 ( N_noxref_22_c_11220_n N_GND_c_14343_n ) capacitor c=0.0103129f \
 //x=84.48 //y=4.095 //x2=83.74 //y2=0.175
cc_7466 ( N_noxref_22_c_11405_p N_GND_c_14343_n ) capacitor c=0.00682461f \
 //x=84.48 //y=2.265 //x2=83.74 //y2=0.175
cc_7467 ( N_noxref_22_c_11331_p N_GND_c_14343_n ) capacitor c=0.0035382f \
 //x=84.32 //y=4.255 //x2=83.74 //y2=0.175
cc_7468 ( N_noxref_22_c_11408_p N_GND_c_14343_n ) capacitor c=0.00733236f \
 //x=84.48 //y=2.265 //x2=83.74 //y2=0.175
cc_7469 ( N_noxref_22_c_11427_p N_GND_c_14343_n ) capacitor c=0.00427116f \
 //x=84.59 //y=2.1 //x2=83.74 //y2=0.175
cc_7470 ( N_noxref_22_c_11414_p N_GND_c_14343_n ) capacitor c=0.00786308f \
 //x=84.48 //y=2.265 //x2=83.74 //y2=0.175
cc_7471 ( N_noxref_22_M50_noxref_d N_GND_c_14343_n ) capacitor c=0.00165161f \
 //x=82.37 //y=1.085 //x2=83.74 //y2=0.175
cc_7472 ( N_noxref_22_c_11408_p N_GND_c_14890_n ) capacitor c=0.0022444f \
 //x=84.48 //y=2.265 //x2=85.34 //y2=0.175
cc_7473 ( N_noxref_22_c_11414_p N_GND_c_14890_n ) capacitor c=2.63786e-19 \
 //x=84.48 //y=2.265 //x2=85.34 //y2=0.175
cc_7474 ( N_noxref_22_c_11312_p N_GND_M51_noxref_s ) capacitor c=4.66358e-19 \
 //x=84.48 //y=4.415 //x2=84.235 //y2=0.55
cc_7475 ( N_noxref_22_c_11405_p N_GND_M51_noxref_s ) capacitor c=0.00297876f \
 //x=84.48 //y=2.265 //x2=84.235 //y2=0.55
cc_7476 ( N_noxref_22_c_11408_p N_GND_M51_noxref_s ) capacitor c=0.00651326f \
 //x=84.48 //y=2.265 //x2=84.235 //y2=0.55
cc_7477 ( N_noxref_22_c_11413_p N_GND_M51_noxref_s ) capacitor c=0.0301091f \
 //x=84.59 //y=1.09 //x2=84.235 //y2=0.55
cc_7478 ( N_noxref_22_c_11436_p N_GND_M51_noxref_s ) capacitor c=0.002132f \
 //x=84.59 //y=1.745 //x2=84.235 //y2=0.55
cc_7479 ( N_noxref_22_c_11427_p N_GND_M51_noxref_s ) capacitor c=0.00304786f \
 //x=84.59 //y=2.1 //x2=84.235 //y2=0.55
cc_7480 ( N_noxref_22_c_11438_p N_GND_M51_noxref_s ) capacitor c=0.00517463f \
 //x=84.965 //y=0.935 //x2=84.235 //y2=0.55
cc_7481 ( N_noxref_22_c_11415_p N_GND_M51_noxref_s ) capacitor c=0.0153553f \
 //x=85.12 //y=1.09 //x2=84.235 //y2=0.55
cc_7482 ( N_noxref_22_c_11440_p N_GND_M51_noxref_s ) capacitor c=0.00629878f \
 //x=85.12 //y=1.435 //x2=84.235 //y2=0.55
cc_7483 ( N_noxref_22_c_11414_p N_GND_M51_noxref_s ) capacitor c=0.00660555f \
 //x=84.48 //y=2.265 //x2=84.235 //y2=0.55
cc_7484 ( N_noxref_22_c_11205_n Q ) capacitor c=0.00353207f //x=83 //y=4.095 \
 //x2=85.22 //y2=2.4
cc_7485 ( N_noxref_22_c_11216_n Q ) capacitor c=0.00159336f //x=83 //y=5.305 \
 //x2=85.22 //y2=2.4
cc_7486 ( N_noxref_22_c_11220_n Q ) capacitor c=0.078466f //x=84.48 //y=4.095 \
 //x2=85.22 //y2=2.4
cc_7487 ( N_noxref_22_c_11312_p Q ) capacitor c=0.0149195f //x=84.48 //y=4.415 \
 //x2=85.22 //y2=2.4
cc_7488 ( N_noxref_22_c_11221_n Q ) capacitor c=0.0217291f //x=84.48 //y=4.76 \
 //x2=85.22 //y2=2.4
cc_7489 ( N_noxref_22_c_11330_p Q ) capacitor c=0.00459089f //x=84.48 //y=4.25 \
 //x2=85.22 //y2=2.4
cc_7490 ( N_noxref_22_c_11405_p Q ) capacitor c=0.00825076f //x=84.48 \
 //y=2.265 //x2=85.22 //y2=2.4
cc_7491 ( N_noxref_22_c_11344_p Q ) capacitor c=0.00699818f //x=84.48 \
 //y=4.255 //x2=85.22 //y2=2.4
cc_7492 ( N_noxref_22_c_11408_p Q ) capacitor c=0.0023016f //x=84.48 //y=2.265 \
 //x2=85.22 //y2=2.4
cc_7493 ( N_noxref_22_c_11314_p Q ) capacitor c=0.00250262f //x=84.48 //y=4.88 \
 //x2=85.22 //y2=2.4
cc_7494 ( N_noxref_22_c_11338_p Q ) capacitor c=4.08297e-19 //x=85 //y=4.97 \
 //x2=85.22 //y2=2.4
cc_7495 ( N_noxref_22_c_11335_p Q ) capacitor c=0.00124564f //x=84.71 //y=4.97 \
 //x2=85.22 //y2=2.4
cc_7496 ( N_noxref_22_c_11414_p Q ) capacitor c=0.00112403f //x=84.48 \
 //y=2.265 //x2=85.22 //y2=2.4
cc_7497 ( N_noxref_22_c_11190_n N_Q_c_15529_n ) capacitor c=0.00149649f \
 //x=82.56 //y=1.535 //x2=84.85 //y2=1.935
cc_7498 ( N_noxref_22_c_11200_n N_Q_c_15529_n ) capacitor c=0.00189939f \
 //x=82.56 //y=1.74 //x2=84.85 //y2=1.935
cc_7499 ( N_noxref_22_c_11203_n N_Q_c_15529_n ) capacitor c=0.00329389f \
 //x=82.915 //y=1.825 //x2=84.85 //y2=1.935
cc_7500 ( N_noxref_22_c_11237_n N_Q_c_15529_n ) capacitor c=0.00587899f \
 //x=82.555 //y=1.405 //x2=84.85 //y2=1.935
cc_7501 ( N_noxref_22_c_11459_p N_Q_c_15529_n ) capacitor c=0.0010801f \
 //x=84.59 //y=1.435 //x2=84.85 //y2=1.935
cc_7502 ( N_noxref_22_c_11436_p N_Q_c_15529_n ) capacitor c=0.00523499f \
 //x=84.59 //y=1.745 //x2=84.85 //y2=1.935
cc_7503 ( N_noxref_22_c_11427_p N_Q_c_15529_n ) capacitor c=0.00376062f \
 //x=84.59 //y=2.1 //x2=84.85 //y2=1.935
cc_7504 ( N_noxref_22_c_11462_p N_Q_c_15529_n ) capacitor c=0.00934105f \
 //x=84.965 //y=1.59 //x2=84.85 //y2=1.935
cc_7505 ( N_noxref_22_c_11440_p N_Q_c_15529_n ) capacitor c=0.00362207f \
 //x=85.12 //y=1.435 //x2=84.85 //y2=1.935
cc_7506 ( N_noxref_22_c_11202_n N_Q_c_15538_n ) capacitor c=0.00315048f \
 //x=82.915 //y=5.39 //x2=84.855 //y2=5.42
cc_7507 ( N_noxref_22_c_11230_n N_Q_c_15538_n ) capacitor c=5.82161e-19 \
 //x=82.517 //y=5.39 //x2=84.855 //y2=5.42
cc_7508 ( N_noxref_22_M154_noxref_g N_Q_c_15538_n ) capacitor c=0.00141266f \
 //x=84.635 //y=6.2 //x2=84.855 //y2=5.42
cc_7509 ( N_noxref_22_M155_noxref_g N_Q_c_15538_n ) capacitor c=0.00377331f \
 //x=85.075 //y=6.2 //x2=84.855 //y2=5.42
cc_7510 ( N_noxref_22_c_11462_p N_Q_c_15542_n ) capacitor c=0.00180253f \
 //x=84.965 //y=1.59 //x2=85.135 //y2=2.02
cc_7511 ( N_noxref_22_c_11205_n N_Q_c_15543_n ) capacitor c=0.00329389f //x=83 \
 //y=4.095 //x2=84.935 //y2=2.02
cc_7512 ( N_noxref_22_c_11414_p N_Q_c_15543_n ) capacitor c=0.00376062f \
 //x=84.48 //y=2.265 //x2=84.935 //y2=2.02
cc_7513 ( N_noxref_22_M155_noxref_g N_Q_c_15545_n ) capacitor c=0.00966342f \
 //x=85.075 //y=6.2 //x2=85.135 //y2=5.14
cc_7514 ( N_noxref_22_c_11216_n N_Q_c_15546_n ) capacitor c=0.00293539f //x=83 \
 //y=5.305 //x2=84.94 //y2=5.14
cc_7515 ( N_noxref_22_M154_noxref_g N_Q_c_15546_n ) capacitor c=0.00427521f \
 //x=84.635 //y=6.2 //x2=84.94 //y2=5.14
cc_7516 ( N_noxref_22_c_11338_p N_Q_c_15546_n ) capacitor c=0.00262283f //x=85 \
 //y=4.97 //x2=84.94 //y2=5.14
cc_7517 ( N_noxref_22_c_11190_n N_Q_c_15549_n ) capacitor c=0.00142298f \
 //x=82.56 //y=1.535 //x2=84.85 //y2=1.185
cc_7518 ( N_noxref_22_c_11237_n N_Q_c_15549_n ) capacitor c=0.00109769f \
 //x=82.555 //y=1.405 //x2=84.85 //y2=1.185
cc_7519 ( N_noxref_22_c_11413_p N_Q_c_15549_n ) capacitor c=0.0018223f \
 //x=84.59 //y=1.09 //x2=84.85 //y2=1.185
cc_7520 ( N_noxref_22_c_11459_p N_Q_c_15549_n ) capacitor c=0.00375161f \
 //x=84.59 //y=1.435 //x2=84.85 //y2=1.185
cc_7521 ( N_noxref_22_c_11438_p N_Q_c_15549_n ) capacitor c=5.57924e-19 \
 //x=84.965 //y=0.935 //x2=84.85 //y2=1.185
cc_7522 ( N_noxref_22_c_11462_p N_Q_c_15549_n ) capacitor c=5.75878e-19 \
 //x=84.965 //y=1.59 //x2=84.85 //y2=1.185
cc_7523 ( N_noxref_22_c_11415_p N_Q_c_15549_n ) capacitor c=0.00160969f \
 //x=85.12 //y=1.09 //x2=84.85 //y2=1.185
cc_7524 ( N_noxref_22_c_11440_p N_Q_c_15549_n ) capacitor c=0.00411132f \
 //x=85.12 //y=1.435 //x2=84.85 //y2=1.185
cc_7525 ( N_noxref_22_M154_noxref_g N_Q_c_15557_n ) capacitor c=0.0162066f \
 //x=84.635 //y=6.2 //x2=84.855 //y2=5.56
cc_7526 ( N_noxref_22_M155_noxref_g N_Q_c_15557_n ) capacitor c=0.0162066f \
 //x=85.075 //y=6.2 //x2=84.855 //y2=5.56
cc_7527 ( N_noxref_22_c_11338_p N_Q_c_15557_n ) capacitor c=0.00290963f //x=85 \
 //y=4.97 //x2=84.855 //y2=5.56
cc_7528 ( N_noxref_22_c_11413_p N_Q_M51_noxref_d ) capacitor c=0.00137914f \
 //x=84.59 //y=1.09 //x2=84.665 //y2=1.09
cc_7529 ( N_noxref_22_c_11459_p N_Q_M51_noxref_d ) capacitor c=0.0023891f \
 //x=84.59 //y=1.435 //x2=84.665 //y2=1.09
cc_7530 ( N_noxref_22_c_11438_p N_Q_M51_noxref_d ) capacitor c=0.0020782f \
 //x=84.965 //y=0.935 //x2=84.665 //y2=1.09
cc_7531 ( N_noxref_22_c_11462_p N_Q_M51_noxref_d ) capacitor c=0.00356097f \
 //x=84.965 //y=1.59 //x2=84.665 //y2=1.09
cc_7532 ( N_noxref_22_c_11415_p N_Q_M51_noxref_d ) capacitor c=0.00138452f \
 //x=85.12 //y=1.09 //x2=84.665 //y2=1.09
cc_7533 ( N_noxref_22_c_11440_p N_Q_M51_noxref_d ) capacitor c=0.00235934f \
 //x=85.12 //y=1.435 //x2=84.665 //y2=1.09
cc_7534 ( N_noxref_22_c_11222_n N_noxref_55_c_16735_n ) capacitor \
 c=0.00587436f //x=75.9 //y=1.36 //x2=76.3 //y2=0.71
cc_7535 ( N_noxref_22_c_11236_n N_noxref_55_c_16735_n ) capacitor \
 c=0.00185906f //x=79.1 //y=1.405 //x2=76.3 //y2=0.71
cc_7536 ( N_noxref_22_M46_noxref_d N_noxref_55_c_16735_n ) capacitor \
 c=0.0136817f //x=75.71 //y=1.085 //x2=76.3 //y2=0.71
cc_7537 ( N_noxref_22_c_11222_n N_noxref_55_M45_noxref_s ) capacitor \
 c=0.0123688f //x=75.9 //y=1.36 //x2=74.31 //y2=0.545
cc_7538 ( N_noxref_22_c_11236_n N_noxref_55_M45_noxref_s ) capacitor \
 c=0.00849636f //x=79.1 //y=1.405 //x2=74.31 //y2=0.545
cc_7539 ( N_noxref_22_M46_noxref_d N_noxref_55_M45_noxref_s ) capacitor \
 c=0.0446285f //x=75.71 //y=1.085 //x2=74.31 //y2=0.545
cc_7540 ( N_noxref_22_c_11236_n N_noxref_57_c_16805_n ) capacitor c=0.0121381f \
 //x=79.1 //y=1.405 //x2=78.66 //y2=1.76
cc_7541 ( N_noxref_22_c_11273_n N_noxref_57_c_16820_n ) capacitor c=0.0057298f \
 //x=79.23 //y=1.36 //x2=79.63 //y2=0.71
cc_7542 ( N_noxref_22_c_11236_n N_noxref_57_c_16820_n ) capacitor \
 c=0.00185906f //x=79.1 //y=1.405 //x2=79.63 //y2=0.71
cc_7543 ( N_noxref_22_c_11239_n N_noxref_57_c_16820_n ) capacitor \
 c=0.00515602f //x=82.395 //y=1.405 //x2=79.63 //y2=0.71
cc_7544 ( N_noxref_22_M48_noxref_d N_noxref_57_c_16820_n ) capacitor \
 c=0.0130616f //x=79.04 //y=1.085 //x2=79.63 //y2=0.71
cc_7545 ( N_noxref_22_c_11273_n N_noxref_57_M47_noxref_s ) capacitor \
 c=0.0103808f //x=79.23 //y=1.36 //x2=77.64 //y2=0.545
cc_7546 ( N_noxref_22_c_11236_n N_noxref_57_M47_noxref_s ) capacitor \
 c=0.0193569f //x=79.1 //y=1.405 //x2=77.64 //y2=0.545
cc_7547 ( N_noxref_22_c_11239_n N_noxref_57_M47_noxref_s ) capacitor \
 c=0.00742061f //x=82.395 //y=1.405 //x2=77.64 //y2=0.545
cc_7548 ( N_noxref_22_M48_noxref_d N_noxref_57_M47_noxref_s ) capacitor \
 c=0.0441243f //x=79.04 //y=1.085 //x2=77.64 //y2=0.545
cc_7549 ( N_noxref_22_c_11239_n N_noxref_58_c_16867_n ) capacitor c=0.0135245f \
 //x=82.395 //y=1.405 //x2=81.99 //y2=1.76
cc_7550 ( N_noxref_22_c_11204_n N_noxref_58_c_16868_n ) capacitor \
 c=0.00714695f //x=82.645 //y=1.825 //x2=82.075 //y2=1.675
cc_7551 ( N_noxref_22_c_11205_n N_noxref_58_c_16868_n ) capacitor \
 c=2.92748e-19 //x=83 //y=4.095 //x2=82.075 //y2=1.675
cc_7552 ( N_noxref_22_c_11190_n N_noxref_58_c_16872_n ) capacitor \
 c=0.00515582f //x=82.56 //y=1.535 //x2=82.96 //y2=0.71
cc_7553 ( N_noxref_22_c_11203_n N_noxref_58_c_16872_n ) capacitor \
 c=0.00332518f //x=82.915 //y=1.825 //x2=82.96 //y2=0.71
cc_7554 ( N_noxref_22_c_11237_n N_noxref_58_c_16872_n ) capacitor \
 c=0.00224828f //x=82.555 //y=1.405 //x2=82.96 //y2=0.71
cc_7555 ( N_noxref_22_c_11239_n N_noxref_58_c_16872_n ) capacitor \
 c=0.00185838f //x=82.395 //y=1.405 //x2=82.96 //y2=0.71
cc_7556 ( N_noxref_22_M50_noxref_d N_noxref_58_c_16872_n ) capacitor \
 c=0.0135038f //x=82.37 //y=1.085 //x2=82.96 //y2=0.71
cc_7557 ( N_noxref_22_c_11190_n N_noxref_58_M49_noxref_s ) capacitor \
 c=0.010254f //x=82.56 //y=1.535 //x2=80.97 //y2=0.545
cc_7558 ( N_noxref_22_c_11200_n N_noxref_58_M49_noxref_s ) capacitor \
 c=0.00775201f //x=82.56 //y=1.74 //x2=80.97 //y2=0.545
cc_7559 ( N_noxref_22_c_11203_n N_noxref_58_M49_noxref_s ) capacitor \
 c=0.00706721f //x=82.915 //y=1.825 //x2=80.97 //y2=0.545
cc_7560 ( N_noxref_22_c_11234_n N_noxref_58_M49_noxref_s ) capacitor \
 c=7.05604e-19 //x=83 //y=4.25 //x2=80.97 //y2=0.545
cc_7561 ( N_noxref_22_c_11237_n N_noxref_58_M49_noxref_s ) capacitor \
 c=0.0090031f //x=82.555 //y=1.405 //x2=80.97 //y2=0.545
cc_7562 ( N_noxref_22_c_11239_n N_noxref_58_M49_noxref_s ) capacitor \
 c=0.0219823f //x=82.395 //y=1.405 //x2=80.97 //y2=0.545
cc_7563 ( N_noxref_22_M50_noxref_d N_noxref_58_M49_noxref_s ) capacitor \
 c=0.0431094f //x=82.37 //y=1.085 //x2=80.97 //y2=0.545
cc_7564 ( N_VDD_c_12804_p N_noxref_33_c_13563_n ) capacitor c=4.78686e-19 \
 //x=75.335 //y=7.585 //x2=75.745 //y2=5.39
cc_7565 ( N_VDD_c_12121_n N_noxref_33_c_13563_n ) capacitor c=0.00476346f \
 //x=75.42 //y=7.035 //x2=75.745 //y2=5.39
cc_7566 ( N_VDD_c_12806_p N_noxref_33_c_13563_n ) capacitor c=5.98042e-19 \
 //x=76.215 //y=7.585 //x2=75.745 //y2=5.39
cc_7567 ( N_VDD_c_12139_n N_noxref_33_c_13563_n ) capacitor c=0.00734603f \
 //x=76.91 //y=7.585 //x2=75.745 //y2=5.39
cc_7568 ( N_VDD_M143_noxref_d N_noxref_33_c_13563_n ) capacitor c=0.00679741f \
 //x=75.275 //y=5.205 //x2=75.745 //y2=5.39
cc_7569 ( N_VDD_c_12806_p N_noxref_33_c_13570_n ) capacitor c=5.52065e-19 \
 //x=76.215 //y=7.585 //x2=77.745 //y2=5.39
cc_7570 ( N_VDD_c_12123_n N_noxref_33_c_13570_n ) capacitor c=0.0040485f \
 //x=76.3 //y=7.035 //x2=77.745 //y2=5.39
cc_7571 ( N_VDD_c_12764_n N_noxref_33_c_13570_n ) capacitor c=0.0140204f \
 //x=85.22 //y=7.58 //x2=77.745 //y2=5.39
cc_7572 ( N_VDD_c_12139_n N_noxref_33_c_13570_n ) capacitor c=0.00703326f \
 //x=76.91 //y=7.585 //x2=77.745 //y2=5.39
cc_7573 ( N_VDD_c_12649_n N_noxref_33_c_13570_n ) capacitor c=0.00273146f \
 //x=80.24 //y=7.585 //x2=77.745 //y2=5.39
cc_7574 ( N_VDD_c_12156_n N_noxref_33_c_13570_n ) capacitor c=0.039327f \
 //x=77.08 //y=7.585 //x2=77.745 //y2=5.39
cc_7575 ( N_VDD_M145_noxref_d N_noxref_33_c_13570_n ) capacitor c=0.0138307f \
 //x=76.155 //y=5.205 //x2=77.745 //y2=5.39
cc_7576 ( N_VDD_c_12156_n N_noxref_33_c_13571_n ) capacitor c=3.35418e-19 \
 //x=77.08 //y=7.585 //x2=75.975 //y2=5.39
cc_7577 ( N_VDD_M145_noxref_d N_noxref_33_c_13571_n ) capacitor c=6.02701e-19 \
 //x=76.155 //y=5.205 //x2=75.975 //y2=5.39
cc_7578 ( N_VDD_M142_noxref_s N_noxref_33_c_13594_n ) capacitor c=0.0552377f \
 //x=74.405 //y=5.205 //x2=74.982 //y2=5.39
cc_7579 ( N_VDD_c_12123_n N_noxref_33_c_13600_n ) capacitor c=0.00979658f \
 //x=76.3 //y=7.035 //x2=77.86 //y2=6.92
cc_7580 ( N_VDD_c_12124_n N_noxref_33_c_13600_n ) capacitor c=0.00197255f \
 //x=76.3 //y=7.41 //x2=77.86 //y2=6.92
cc_7581 ( N_VDD_c_12764_n N_noxref_33_c_13600_n ) capacitor c=0.172144f \
 //x=85.22 //y=7.58 //x2=77.86 //y2=6.92
cc_7582 ( N_VDD_c_12649_n N_noxref_33_c_13600_n ) capacitor c=0.0401324f \
 //x=80.24 //y=7.585 //x2=77.86 //y2=6.92
cc_7583 ( N_VDD_c_12156_n N_noxref_33_c_13600_n ) capacitor c=0.00739076f \
 //x=77.08 //y=7.585 //x2=77.86 //y2=6.92
cc_7584 ( N_VDD_c_12764_n N_noxref_33_c_13615_n ) capacitor c=0.0021469f \
 //x=85.22 //y=7.58 //x2=79.62 //y2=6.92
cc_7585 ( N_VDD_c_12649_n N_noxref_33_c_13615_n ) capacitor c=4.35699e-19 \
 //x=80.24 //y=7.585 //x2=79.62 //y2=6.92
cc_7586 ( N_VDD_c_12163_n N_noxref_33_c_13615_n ) capacitor c=0.00733935f \
 //x=80.41 //y=7.585 //x2=79.62 //y2=6.92
cc_7587 ( N_VDD_c_12628_n N_noxref_33_c_13602_n ) capacitor c=0.0041288f \
 //x=74.54 //y=7.035 //x2=74.98 //y2=5.56
cc_7588 ( N_VDD_c_12629_n N_noxref_33_c_13602_n ) capacitor c=0.00145923f \
 //x=74.54 //y=7.41 //x2=74.98 //y2=5.56
cc_7589 ( N_VDD_c_12804_p N_noxref_33_c_13602_n ) capacitor c=0.00233559f \
 //x=75.335 //y=7.585 //x2=74.98 //y2=5.56
cc_7590 ( N_VDD_c_12121_n N_noxref_33_c_13602_n ) capacitor c=0.00220869f \
 //x=75.42 //y=7.035 //x2=74.98 //y2=5.56
cc_7591 ( N_VDD_c_12122_n N_noxref_33_c_13602_n ) capacitor c=0.00130452f \
 //x=75.42 //y=7.41 //x2=74.98 //y2=5.56
cc_7592 ( N_VDD_c_12139_n N_noxref_33_c_13602_n ) capacitor c=0.0112616f \
 //x=76.91 //y=7.585 //x2=74.98 //y2=5.56
cc_7593 ( N_VDD_c_12155_n N_noxref_33_c_13602_n ) capacitor c=0.00724603f \
 //x=73.75 //y=7.585 //x2=74.98 //y2=5.56
cc_7594 ( N_VDD_c_12790_n N_noxref_33_c_13602_n ) capacitor c=2.28864e-19 \
 //x=85.22 //y=7.58 //x2=74.98 //y2=5.56
cc_7595 ( N_VDD_M142_noxref_s N_noxref_33_c_13602_n ) capacitor c=0.0897259f \
 //x=74.405 //y=5.205 //x2=74.98 //y2=5.56
cc_7596 ( N_VDD_M143_noxref_d N_noxref_33_c_13602_n ) capacitor c=0.0724825f \
 //x=75.275 //y=5.205 //x2=74.98 //y2=5.56
cc_7597 ( N_VDD_c_12121_n N_noxref_33_c_13575_n ) capacitor c=0.00230229f \
 //x=75.42 //y=7.035 //x2=75.86 //y2=5.39
cc_7598 ( N_VDD_c_12122_n N_noxref_33_c_13575_n ) capacitor c=0.00130452f \
 //x=75.42 //y=7.41 //x2=75.86 //y2=5.39
cc_7599 ( N_VDD_c_12806_p N_noxref_33_c_13575_n ) capacitor c=0.00233409f \
 //x=76.215 //y=7.585 //x2=75.86 //y2=5.39
cc_7600 ( N_VDD_c_12123_n N_noxref_33_c_13575_n ) capacitor c=0.00225444f \
 //x=76.3 //y=7.035 //x2=75.86 //y2=5.39
cc_7601 ( N_VDD_c_12124_n N_noxref_33_c_13575_n ) capacitor c=0.00130452f \
 //x=76.3 //y=7.41 //x2=75.86 //y2=5.39
cc_7602 ( N_VDD_c_12139_n N_noxref_33_c_13575_n ) capacitor c=0.0112507f \
 //x=76.91 //y=7.585 //x2=75.86 //y2=5.39
cc_7603 ( N_VDD_c_12155_n N_noxref_33_c_13575_n ) capacitor c=0.00105173f \
 //x=73.75 //y=7.585 //x2=75.86 //y2=5.39
cc_7604 ( N_VDD_c_12156_n N_noxref_33_c_13575_n ) capacitor c=0.00924237f \
 //x=77.08 //y=7.585 //x2=75.86 //y2=5.39
cc_7605 ( N_VDD_c_12790_n N_noxref_33_c_13575_n ) capacitor c=2.28864e-19 \
 //x=85.22 //y=7.58 //x2=75.86 //y2=5.39
cc_7606 ( N_VDD_M142_noxref_s N_noxref_33_c_13575_n ) capacitor c=0.00114869f \
 //x=74.405 //y=5.205 //x2=75.86 //y2=5.39
cc_7607 ( N_VDD_M143_noxref_d N_noxref_33_c_13575_n ) capacitor c=0.0724825f \
 //x=75.275 //y=5.205 //x2=75.86 //y2=5.39
cc_7608 ( N_VDD_M145_noxref_d N_noxref_33_c_13575_n ) capacitor c=0.0886704f \
 //x=76.155 //y=5.205 //x2=75.86 //y2=5.39
cc_7609 ( N_VDD_c_12764_n N_noxref_33_c_13606_n ) capacitor c=0.00204931f \
 //x=85.22 //y=7.58 //x2=77.86 //y2=5.39
cc_7610 ( N_VDD_c_12649_n N_noxref_33_c_13606_n ) capacitor c=0.00853641f \
 //x=80.24 //y=7.585 //x2=77.86 //y2=5.39
cc_7611 ( N_VDD_c_12156_n N_noxref_33_c_13606_n ) capacitor c=0.0602194f \
 //x=77.08 //y=7.585 //x2=77.86 //y2=5.39
cc_7612 ( N_VDD_c_12163_n N_noxref_33_c_13606_n ) capacitor c=6.42159e-19 \
 //x=80.41 //y=7.585 //x2=77.86 //y2=5.39
cc_7613 ( N_VDD_c_12790_n N_noxref_33_c_13606_n ) capacitor c=2.28864e-19 \
 //x=85.22 //y=7.58 //x2=77.86 //y2=5.39
cc_7614 ( N_VDD_M145_noxref_d N_noxref_33_c_13606_n ) capacitor c=0.00230512f \
 //x=76.155 //y=5.205 //x2=77.86 //y2=5.39
cc_7615 ( N_VDD_c_12628_n N_noxref_33_M142_noxref_d ) capacitor c=0.0391448f \
 //x=74.54 //y=7.035 //x2=74.835 //y2=5.205
cc_7616 ( N_VDD_c_12629_n N_noxref_33_M142_noxref_d ) capacitor c=0.00985747f \
 //x=74.54 //y=7.41 //x2=74.835 //y2=5.205
cc_7617 ( N_VDD_c_12804_p N_noxref_33_M142_noxref_d ) capacitor c=0.0238892f \
 //x=75.335 //y=7.585 //x2=74.835 //y2=5.205
cc_7618 ( N_VDD_c_12121_n N_noxref_33_M142_noxref_d ) capacitor c=0.0380657f \
 //x=75.42 //y=7.035 //x2=74.835 //y2=5.205
cc_7619 ( N_VDD_c_12122_n N_noxref_33_M142_noxref_d ) capacitor c=0.0100015f \
 //x=75.42 //y=7.41 //x2=74.835 //y2=5.205
cc_7620 ( N_VDD_c_12139_n N_noxref_33_M142_noxref_d ) capacitor c=0.00302682f \
 //x=76.91 //y=7.585 //x2=74.835 //y2=5.205
cc_7621 ( N_VDD_M142_noxref_s N_noxref_33_M142_noxref_d ) capacitor \
 c=0.00271779f //x=74.405 //y=5.205 //x2=74.835 //y2=5.205
cc_7622 ( N_VDD_M143_noxref_d N_noxref_33_M142_noxref_d ) capacitor \
 c=0.00360728f //x=75.275 //y=5.205 //x2=74.835 //y2=5.205
cc_7623 ( N_VDD_c_12121_n N_noxref_33_M144_noxref_d ) capacitor c=0.0379915f \
 //x=75.42 //y=7.035 //x2=75.715 //y2=5.205
cc_7624 ( N_VDD_c_12122_n N_noxref_33_M144_noxref_d ) capacitor c=0.0100015f \
 //x=75.42 //y=7.41 //x2=75.715 //y2=5.205
cc_7625 ( N_VDD_c_12806_p N_noxref_33_M144_noxref_d ) capacitor c=0.0230655f \
 //x=76.215 //y=7.585 //x2=75.715 //y2=5.205
cc_7626 ( N_VDD_c_12123_n N_noxref_33_M144_noxref_d ) capacitor c=0.0379915f \
 //x=76.3 //y=7.035 //x2=75.715 //y2=5.205
cc_7627 ( N_VDD_c_12124_n N_noxref_33_M144_noxref_d ) capacitor c=0.0100015f \
 //x=76.3 //y=7.41 //x2=75.715 //y2=5.205
cc_7628 ( N_VDD_c_12139_n N_noxref_33_M144_noxref_d ) capacitor c=0.00283306f \
 //x=76.91 //y=7.585 //x2=75.715 //y2=5.205
cc_7629 ( N_VDD_M143_noxref_d N_noxref_33_M144_noxref_d ) capacitor \
 c=0.00351276f //x=75.275 //y=5.205 //x2=75.715 //y2=5.205
cc_7630 ( N_VDD_M145_noxref_d N_noxref_33_M144_noxref_d ) capacitor \
 c=0.00355849f //x=76.155 //y=5.205 //x2=75.715 //y2=5.205
cc_7631 ( N_VDD_c_12764_n N_noxref_33_M147_noxref_d ) capacitor c=0.00206569f \
 //x=85.22 //y=7.58 //x2=78.595 //y2=5.205
cc_7632 ( N_VDD_c_12649_n N_noxref_33_M147_noxref_d ) capacitor c=0.00856914f \
 //x=80.24 //y=7.585 //x2=78.595 //y2=5.205
cc_7633 ( N_VDD_c_12790_n N_noxref_33_M147_noxref_d ) capacitor c=2.28864e-19 \
 //x=85.22 //y=7.58 //x2=78.595 //y2=5.205
cc_7634 ( N_VDD_c_12764_n N_noxref_33_M149_noxref_d ) capacitor c=0.00206569f \
 //x=85.22 //y=7.58 //x2=79.475 //y2=5.205
cc_7635 ( N_VDD_c_12649_n N_noxref_33_M149_noxref_d ) capacitor c=0.00856914f \
 //x=80.24 //y=7.585 //x2=79.475 //y2=5.205
cc_7636 ( N_VDD_c_12163_n N_noxref_33_M149_noxref_d ) capacitor c=0.0448255f \
 //x=80.41 //y=7.585 //x2=79.475 //y2=5.205
cc_7637 ( N_VDD_c_12790_n N_noxref_33_M149_noxref_d ) capacitor c=2.28864e-19 \
 //x=85.22 //y=7.58 //x2=79.475 //y2=5.205
cc_7638 ( N_VDD_c_12764_n N_noxref_34_c_13725_n ) capacitor c=0.0143613f \
 //x=85.22 //y=7.58 //x2=81.085 //y2=5.39
cc_7639 ( N_VDD_c_12649_n N_noxref_34_c_13725_n ) capacitor c=0.00336719f \
 //x=80.24 //y=7.585 //x2=81.085 //y2=5.39
cc_7640 ( N_VDD_c_12141_n N_noxref_34_c_13725_n ) capacitor c=0.00275849f \
 //x=83.57 //y=7.585 //x2=81.085 //y2=5.39
cc_7641 ( N_VDD_c_12163_n N_noxref_34_c_13725_n ) capacitor c=0.042287f \
 //x=80.41 //y=7.585 //x2=81.085 //y2=5.39
cc_7642 ( N_VDD_c_12163_n N_noxref_34_c_13726_n ) capacitor c=6.67754e-19 \
 //x=80.41 //y=7.585 //x2=79.295 //y2=5.39
cc_7643 ( N_VDD_c_12163_n N_noxref_34_c_13729_n ) capacitor c=0.00108821f \
 //x=80.41 //y=7.585 //x2=78.3 //y2=5.39
cc_7644 ( N_VDD_M142_noxref_s N_noxref_34_c_13729_n ) capacitor c=4.98377e-19 \
 //x=74.405 //y=5.205 //x2=78.3 //y2=5.39
cc_7645 ( N_VDD_c_12163_n N_noxref_34_c_13730_n ) capacitor c=0.00456697f \
 //x=80.41 //y=7.585 //x2=79.18 //y2=5.39
cc_7646 ( N_VDD_c_12764_n N_noxref_34_c_13768_n ) capacitor c=0.172244f \
 //x=85.22 //y=7.58 //x2=81.2 //y2=6.92
cc_7647 ( N_VDD_c_12141_n N_noxref_34_c_13768_n ) capacitor c=0.0392376f \
 //x=83.57 //y=7.585 //x2=81.2 //y2=6.92
cc_7648 ( N_VDD_c_12163_n N_noxref_34_c_13768_n ) capacitor c=0.00730382f \
 //x=80.41 //y=7.585 //x2=81.2 //y2=6.92
cc_7649 ( N_VDD_c_12764_n N_noxref_34_c_13732_n ) capacitor c=0.00215296f \
 //x=85.22 //y=7.58 //x2=82.96 //y2=6.92
cc_7650 ( N_VDD_c_12141_n N_noxref_34_c_13732_n ) capacitor c=4.60826e-19 \
 //x=83.57 //y=7.585 //x2=82.96 //y2=6.92
cc_7651 ( N_VDD_c_12167_n N_noxref_34_c_13732_n ) capacitor c=0.0114263f \
 //x=83.74 //y=7.585 //x2=82.96 //y2=6.92
cc_7652 ( N_VDD_c_12649_n N_noxref_34_c_13744_n ) capacitor c=0.00475693f \
 //x=80.24 //y=7.585 //x2=78.3 //y2=5.56
cc_7653 ( N_VDD_c_12156_n N_noxref_34_c_13744_n ) capacitor c=0.00539528f \
 //x=77.08 //y=7.585 //x2=78.3 //y2=5.56
cc_7654 ( N_VDD_c_12163_n N_noxref_34_c_13744_n ) capacitor c=0.00106566f \
 //x=80.41 //y=7.585 //x2=78.3 //y2=5.56
cc_7655 ( N_VDD_c_12764_n N_noxref_34_c_13733_n ) capacitor c=0.00204931f \
 //x=85.22 //y=7.58 //x2=81.2 //y2=5.39
cc_7656 ( N_VDD_c_12141_n N_noxref_34_c_13733_n ) capacitor c=0.00853641f \
 //x=83.57 //y=7.585 //x2=81.2 //y2=5.39
cc_7657 ( N_VDD_c_12163_n N_noxref_34_c_13733_n ) capacitor c=0.0592438f \
 //x=80.41 //y=7.585 //x2=81.2 //y2=5.39
cc_7658 ( N_VDD_c_12167_n N_noxref_34_c_13733_n ) capacitor c=0.00100394f \
 //x=83.74 //y=7.585 //x2=81.2 //y2=5.39
cc_7659 ( N_VDD_c_12790_n N_noxref_34_c_13733_n ) capacitor c=2.28864e-19 \
 //x=85.22 //y=7.58 //x2=81.2 //y2=5.39
cc_7660 ( N_VDD_c_12764_n N_noxref_34_M151_noxref_d ) capacitor c=0.00206569f \
 //x=85.22 //y=7.58 //x2=81.935 //y2=5.205
cc_7661 ( N_VDD_c_12141_n N_noxref_34_M151_noxref_d ) capacitor c=0.00856914f \
 //x=83.57 //y=7.585 //x2=81.935 //y2=5.205
cc_7662 ( N_VDD_c_12790_n N_noxref_34_M151_noxref_d ) capacitor c=2.28864e-19 \
 //x=85.22 //y=7.58 //x2=81.935 //y2=5.205
cc_7663 ( N_VDD_c_12764_n N_noxref_34_M153_noxref_d ) capacitor c=0.00206569f \
 //x=85.22 //y=7.58 //x2=82.815 //y2=5.205
cc_7664 ( N_VDD_c_12141_n N_noxref_34_M153_noxref_d ) capacitor c=0.00856914f \
 //x=83.57 //y=7.585 //x2=82.815 //y2=5.205
cc_7665 ( N_VDD_c_12167_n N_noxref_34_M153_noxref_d ) capacitor c=0.0443649f \
 //x=83.74 //y=7.585 //x2=82.815 //y2=5.205
cc_7666 ( N_VDD_c_12790_n N_noxref_34_M153_noxref_d ) capacitor c=2.28864e-19 \
 //x=85.22 //y=7.58 //x2=82.815 //y2=5.205
cc_7667 ( N_VDD_M154_noxref_s N_noxref_34_M153_noxref_d ) capacitor \
 c=0.00249451f //x=84.28 //y=5.2 //x2=82.815 //y2=5.205
cc_7668 ( N_VDD_M136_noxref_s N_GND_c_14620_n ) capacitor c=2.10777e-19 \
 //x=69.895 //y=5.2 //x2=70.015 //y2=1.145
cc_7669 ( N_VDD_c_11541_n N_GND_c_13898_n ) capacitor c=0.00989514f //x=1.23 \
 //y=7.58 //x2=1.23 //y2=0.18
cc_7670 ( N_VDD_c_11544_n N_GND_c_13902_n ) capacitor c=0.00653385f //x=3.82 \
 //y=7.585 //x2=3.82 //y2=0.175
cc_7671 ( N_VDD_c_11551_n N_GND_c_13914_n ) capacitor c=0.00648088f //x=8.63 \
 //y=7.585 //x2=8.63 //y2=0.175
cc_7672 ( N_VDD_c_11609_n N_GND_c_13958_n ) capacitor c=0.00648088f //x=13.44 \
 //y=7.585 //x2=13.44 //y2=0.175
cc_7673 ( N_VDD_c_11679_n N_GND_c_13971_n ) capacitor c=0.00648088f //x=16.77 \
 //y=7.585 //x2=16.77 //y2=0.175
cc_7674 ( N_VDD_c_11733_n N_GND_c_14041_n ) capacitor c=0.00648088f //x=20.1 \
 //y=7.585 //x2=20.1 //y2=0.175
cc_7675 ( N_VDD_c_11799_n N_GND_c_14078_n ) capacitor c=0.00906209f //x=24.91 \
 //y=7.585 //x2=24.91 //y2=0.175
cc_7676 ( N_VDD_c_11844_n N_GND_c_14120_n ) capacitor c=0.00650455f //x=28.24 \
 //y=7.585 //x2=28.24 //y2=0.175
cc_7677 ( N_VDD_c_11851_n N_GND_c_14132_n ) capacitor c=0.00648088f //x=33.05 \
 //y=7.585 //x2=33.05 //y2=0.175
cc_7678 ( N_VDD_c_11909_n N_GND_c_14176_n ) capacitor c=0.00648088f //x=37.86 \
 //y=7.585 //x2=37.86 //y2=0.175
cc_7679 ( N_VDD_c_11979_n N_GND_c_14189_n ) capacitor c=0.00648088f //x=41.19 \
 //y=7.585 //x2=41.19 //y2=0.175
cc_7680 ( N_VDD_c_12027_n N_GND_c_14261_n ) capacitor c=0.00648088f //x=44.52 \
 //y=7.585 //x2=44.52 //y2=0.175
cc_7681 ( N_VDD_c_12088_n N_GND_c_14304_n ) capacitor c=0.00906209f //x=49.33 \
 //y=7.585 //x2=49.33 //y2=0.175
cc_7682 ( N_VDD_c_12245_n N_GND_c_14332_n ) capacitor c=0.00650455f //x=52.66 \
 //y=7.585 //x2=52.66 //y2=0.175
cc_7683 ( N_VDD_c_12252_n N_GND_c_14333_n ) capacitor c=0.00648088f //x=57.47 \
 //y=7.585 //x2=57.47 //y2=0.175
cc_7684 ( N_VDD_c_12310_n N_GND_c_14334_n ) capacitor c=0.00648088f //x=62.28 \
 //y=7.585 //x2=62.28 //y2=0.175
cc_7685 ( N_VDD_c_12366_n N_GND_c_14335_n ) capacitor c=0.00648088f //x=65.61 \
 //y=7.585 //x2=65.61 //y2=0.175
cc_7686 ( N_VDD_c_12452_n N_GND_c_14336_n ) capacitor c=0.00897677f //x=68.94 \
 //y=7.585 //x2=68.94 //y2=0.175
cc_7687 ( N_VDD_c_12155_n N_GND_c_14337_n ) capacitor c=0.00906209f //x=73.75 \
 //y=7.585 //x2=73.75 //y2=0.175
cc_7688 ( N_VDD_c_12156_n N_GND_c_14338_n ) capacitor c=0.00656819f //x=77.08 \
 //y=7.585 //x2=77.08 //y2=0.175
cc_7689 ( N_VDD_c_12163_n N_GND_c_14342_n ) capacitor c=0.00684375f //x=80.41 \
 //y=7.585 //x2=80.41 //y2=0.175
cc_7690 ( N_VDD_c_12167_n N_GND_c_14343_n ) capacitor c=0.00655202f //x=83.74 \
 //y=7.585 //x2=83.74 //y2=0.175
cc_7691 ( N_VDD_c_12790_n N_GND_c_14890_n ) capacitor c=0.00989514f //x=85.22 \
 //y=7.58 //x2=85.34 //y2=0.175
cc_7692 ( N_VDD_c_12790_n Q ) capacitor c=0.0293824f //x=85.22 //y=7.58 \
 //x2=85.22 //y2=2.4
cc_7693 ( N_VDD_c_12764_n N_Q_c_15538_n ) capacitor c=0.00259721f //x=85.22 \
 //y=7.58 //x2=84.855 //y2=5.42
cc_7694 ( N_VDD_c_12773_n N_Q_c_15538_n ) capacitor c=0.00100699f //x=85.21 \
 //y=7.585 //x2=84.855 //y2=5.42
cc_7695 ( N_VDD_c_12790_n N_Q_c_15538_n ) capacitor c=0.00295945f //x=85.22 \
 //y=7.58 //x2=84.855 //y2=5.42
cc_7696 ( N_VDD_M154_noxref_s N_Q_c_15538_n ) capacitor c=0.0465774f //x=84.28 \
 //y=5.2 //x2=84.855 //y2=5.42
cc_7697 ( N_VDD_M155_noxref_d N_Q_c_15538_n ) capacitor c=0.0486749f //x=85.15 \
 //y=5.2 //x2=84.855 //y2=5.42
cc_7698 ( N_VDD_c_12764_n N_Q_c_15545_n ) capacitor c=0.00199795f //x=85.22 \
 //y=7.58 //x2=85.135 //y2=5.14
cc_7699 ( N_VDD_c_12773_n N_Q_c_15545_n ) capacitor c=0.00207379f //x=85.21 \
 //y=7.585 //x2=85.135 //y2=5.14
cc_7700 ( N_VDD_M155_noxref_d N_Q_c_15545_n ) capacitor c=0.0235609f //x=85.15 \
 //y=5.2 //x2=85.135 //y2=5.14
cc_7701 ( N_VDD_c_12167_n N_Q_c_15546_n ) capacitor c=0.00484013f //x=83.74 \
 //y=7.585 //x2=84.94 //y2=5.14
cc_7702 ( N_VDD_c_12764_n N_Q_c_15557_n ) capacitor c=0.00241566f //x=85.22 \
 //y=7.58 //x2=84.855 //y2=5.56
cc_7703 ( N_VDD_c_12773_n N_Q_c_15557_n ) capacitor c=0.0138017f //x=85.21 \
 //y=7.585 //x2=84.855 //y2=5.56
cc_7704 ( N_VDD_c_12167_n N_Q_c_15557_n ) capacitor c=0.00819514f //x=83.74 \
 //y=7.585 //x2=84.855 //y2=5.56
cc_7705 ( N_VDD_c_12790_n N_Q_c_15557_n ) capacitor c=0.00825846f //x=85.22 \
 //y=7.58 //x2=84.855 //y2=5.56
cc_7706 ( N_VDD_M154_noxref_s N_Q_c_15557_n ) capacitor c=0.0897898f //x=84.28 \
 //y=5.2 //x2=84.855 //y2=5.56
cc_7707 ( N_VDD_M155_noxref_d N_Q_c_15557_n ) capacitor c=0.0929254f //x=85.15 \
 //y=5.2 //x2=84.855 //y2=5.56
cc_7708 ( N_VDD_c_12649_n noxref_56 ) capacitor c=0.0048583f //x=80.24 \
 //y=7.585 //x2=79.035 //y2=5.205
cc_7709 ( N_VDD_c_12163_n noxref_56 ) capacitor c=0.00487712f //x=80.41 \
 //y=7.585 //x2=79.035 //y2=5.205
cc_7710 ( N_noxref_24_c_12950_n N_GND_c_13867_n ) capacitor c=0.00533679f \
 //x=6.835 //y=1.175 //x2=9.62 //y2=0.175
cc_7711 ( N_noxref_24_c_12992_p N_GND_c_13867_n ) capacitor c=0.00431259f \
 //x=6.92 //y=0.805 //x2=9.62 //y2=0.175
cc_7712 ( N_noxref_24_c_12951_n N_GND_c_13867_n ) capacitor c=0.0096072f \
 //x=7.805 //y=0.72 //x2=9.62 //y2=0.175
cc_7713 ( N_noxref_24_c_12994_p N_GND_c_13867_n ) capacitor c=0.00232964f \
 //x=7.89 //y=0.805 //x2=9.62 //y2=0.175
cc_7714 ( N_noxref_24_M3_noxref_d N_GND_c_13867_n ) capacitor c=0.0132354f \
 //x=5.68 //y=1.09 //x2=9.62 //y2=0.175
cc_7715 ( N_noxref_24_M3_noxref_d N_GND_c_13873_n ) capacitor c=0.0154456f \
 //x=5.68 //y=1.09 //x2=4.895 //y2=1.145
cc_7716 ( N_noxref_24_c_12950_n N_GND_c_13900_n ) capacitor c=0.00919902f \
 //x=6.835 //y=1.175 //x2=8.46 //y2=0.175
cc_7717 ( N_noxref_24_c_12992_p N_GND_c_13900_n ) capacitor c=0.0142396f \
 //x=6.92 //y=0.805 //x2=8.46 //y2=0.175
cc_7718 ( N_noxref_24_c_12951_n N_GND_c_13900_n ) capacitor c=0.0364875f \
 //x=7.805 //y=0.72 //x2=8.46 //y2=0.175
cc_7719 ( N_noxref_24_c_12994_p N_GND_c_13900_n ) capacitor c=0.013886f \
 //x=7.89 //y=0.805 //x2=8.46 //y2=0.175
cc_7720 ( N_noxref_24_M4_noxref_s N_GND_c_13902_n ) capacitor c=8.16352e-19 \
 //x=6.785 //y=0.555 //x2=3.82 //y2=0.175
cc_7721 ( N_noxref_24_c_12994_p N_GND_c_13914_n ) capacitor c=0.037873f \
 //x=7.89 //y=0.805 //x2=8.63 //y2=0.175
cc_7722 ( N_noxref_24_M4_noxref_s N_GND_c_13914_n ) capacitor c=0.0051897f \
 //x=6.785 //y=0.555 //x2=8.63 //y2=0.175
cc_7723 ( N_noxref_24_M3_noxref_d N_GND_M2_noxref_d ) capacitor c=3.12752e-19 \
 //x=5.68 //y=1.09 //x2=4.705 //y2=1.055
cc_7724 ( N_noxref_24_c_12992_p N_noxref_38_c_15686_n ) capacitor \
 c=2.15937e-19 //x=6.92 //y=0.805 //x2=5.38 //y2=0.805
cc_7725 ( N_noxref_24_c_12950_n N_noxref_38_c_15676_n ) capacitor c=0.0131134f \
 //x=6.835 //y=1.175 //x2=6.265 //y2=0.72
cc_7726 ( N_noxref_24_M3_noxref_d N_noxref_38_c_15676_n ) capacitor \
 c=0.0160925f //x=5.68 //y=1.09 //x2=6.265 //y2=0.72
cc_7727 ( N_noxref_24_c_12950_n N_noxref_38_c_15670_n ) capacitor \
 c=0.00947943f //x=6.835 //y=1.175 //x2=6.265 //y2=1.77
cc_7728 ( N_noxref_24_M3_noxref_d N_noxref_38_c_15670_n ) capacitor \
 c=0.0152665f //x=5.68 //y=1.09 //x2=6.265 //y2=1.77
cc_7729 ( N_noxref_24_c_12950_n N_noxref_38_M2_noxref_s ) capacitor \
 c=0.0225712f //x=6.835 //y=1.175 //x2=4.275 //y2=0.555
cc_7730 ( N_noxref_24_c_12992_p N_noxref_38_M2_noxref_s ) capacitor \
 c=0.0175461f //x=6.92 //y=0.805 //x2=4.275 //y2=0.555
cc_7731 ( N_noxref_24_c_12994_p N_noxref_38_M2_noxref_s ) capacitor \
 c=2.98576e-19 //x=7.89 //y=0.805 //x2=4.275 //y2=0.555
cc_7732 ( N_noxref_24_M3_noxref_d N_noxref_38_M2_noxref_s ) capacitor \
 c=0.0187674f //x=5.68 //y=1.09 //x2=4.275 //y2=0.555
cc_7733 ( N_noxref_24_M4_noxref_s N_noxref_38_M2_noxref_s ) capacitor \
 c=0.0210819f //x=6.785 //y=0.555 //x2=4.275 //y2=0.555
cc_7734 ( N_noxref_24_c_12994_p N_noxref_39_M5_noxref_s ) capacitor \
 c=0.00368328f //x=7.89 //y=0.805 //x2=9.085 //y2=0.555
cc_7735 ( N_noxref_24_M4_noxref_s N_noxref_39_M5_noxref_s ) capacitor \
 c=0.00125282f //x=6.785 //y=0.555 //x2=9.085 //y2=0.555
cc_7736 ( N_noxref_25_c_13041_n N_GND_c_13937_n ) capacitor c=0.00533679f \
 //x=11.645 //y=1.175 //x2=14.535 //y2=0.175
cc_7737 ( N_noxref_25_c_13061_p N_GND_c_13937_n ) capacitor c=0.0033879f \
 //x=11.73 //y=0.805 //x2=14.535 //y2=0.175
cc_7738 ( N_noxref_25_c_13017_n N_GND_c_13937_n ) capacitor c=0.0096072f \
 //x=12.615 //y=0.72 //x2=14.535 //y2=0.175
cc_7739 ( N_noxref_25_c_13063_p N_GND_c_13937_n ) capacitor c=0.00232964f \
 //x=12.7 //y=0.805 //x2=14.535 //y2=0.175
cc_7740 ( N_noxref_25_M6_noxref_d N_GND_c_13937_n ) capacitor c=0.0132509f \
 //x=10.49 //y=1.09 //x2=14.535 //y2=0.175
cc_7741 ( N_noxref_25_M6_noxref_d N_GND_c_13885_n ) capacitor c=0.0154456f \
 //x=10.49 //y=1.09 //x2=9.705 //y2=1.145
cc_7742 ( N_noxref_25_c_13041_n N_GND_c_13901_n ) capacitor c=0.0091517f \
 //x=11.645 //y=1.175 //x2=13.27 //y2=0.175
cc_7743 ( N_noxref_25_c_13061_p N_GND_c_13901_n ) capacitor c=0.0141638f \
 //x=11.73 //y=0.805 //x2=13.27 //y2=0.175
cc_7744 ( N_noxref_25_c_13017_n N_GND_c_13901_n ) capacitor c=0.0364778f \
 //x=12.615 //y=0.72 //x2=13.27 //y2=0.175
cc_7745 ( N_noxref_25_c_13063_p N_GND_c_13901_n ) capacitor c=0.013886f \
 //x=12.7 //y=0.805 //x2=13.27 //y2=0.175
cc_7746 ( N_noxref_25_M7_noxref_s N_GND_c_13914_n ) capacitor c=8.16352e-19 \
 //x=11.595 //y=0.555 //x2=8.63 //y2=0.175
cc_7747 ( N_noxref_25_c_13063_p N_GND_c_13958_n ) capacitor c=0.0374312f \
 //x=12.7 //y=0.805 //x2=13.44 //y2=0.175
cc_7748 ( N_noxref_25_M7_noxref_s N_GND_c_13958_n ) capacitor c=0.00519576f \
 //x=11.595 //y=0.555 //x2=13.44 //y2=0.175
cc_7749 ( N_noxref_25_M6_noxref_d N_GND_M5_noxref_d ) capacitor c=3.12752e-19 \
 //x=10.49 //y=1.09 //x2=9.515 //y2=1.055
cc_7750 ( N_noxref_25_c_13061_p N_noxref_39_c_15748_n ) capacitor \
 c=2.15937e-19 //x=11.73 //y=0.805 //x2=10.19 //y2=0.805
cc_7751 ( N_noxref_25_c_13041_n N_noxref_39_c_15735_n ) capacitor c=0.0130703f \
 //x=11.645 //y=1.175 //x2=11.075 //y2=0.72
cc_7752 ( N_noxref_25_M6_noxref_d N_noxref_39_c_15735_n ) capacitor \
 c=0.0160925f //x=10.49 //y=1.09 //x2=11.075 //y2=0.72
cc_7753 ( N_noxref_25_c_13041_n N_noxref_39_c_15733_n ) capacitor \
 c=0.00940787f //x=11.645 //y=1.175 //x2=11.075 //y2=1.77
cc_7754 ( N_noxref_25_M6_noxref_d N_noxref_39_c_15733_n ) capacitor \
 c=0.0151189f //x=10.49 //y=1.09 //x2=11.075 //y2=1.77
cc_7755 ( N_noxref_25_c_13041_n N_noxref_39_M5_noxref_s ) capacitor \
 c=0.0223986f //x=11.645 //y=1.175 //x2=9.085 //y2=0.555
cc_7756 ( N_noxref_25_c_13061_p N_noxref_39_M5_noxref_s ) capacitor \
 c=0.0175532f //x=11.73 //y=0.805 //x2=9.085 //y2=0.555
cc_7757 ( N_noxref_25_c_13063_p N_noxref_39_M5_noxref_s ) capacitor \
 c=2.98721e-19 //x=12.7 //y=0.805 //x2=9.085 //y2=0.555
cc_7758 ( N_noxref_25_M6_noxref_d N_noxref_39_M5_noxref_s ) capacitor \
 c=0.0187685f //x=10.49 //y=1.09 //x2=9.085 //y2=0.555
cc_7759 ( N_noxref_25_M7_noxref_s N_noxref_39_M5_noxref_s ) capacitor \
 c=0.021082f //x=11.595 //y=0.555 //x2=9.085 //y2=0.555
cc_7760 ( N_noxref_25_c_13063_p N_noxref_40_M8_noxref_s ) capacitor \
 c=0.00370912f //x=12.7 //y=0.805 //x2=14 //y2=0.545
cc_7761 ( N_noxref_25_M7_noxref_s N_noxref_40_M8_noxref_s ) capacitor \
 c=0.00101401f //x=11.595 //y=0.555 //x2=14 //y2=0.545
cc_7762 ( N_noxref_26_c_13098_n N_GND_c_14061_n ) capacitor c=0.00533679f \
 //x=23.115 //y=1.175 //x2=26.005 //y2=0.175
cc_7763 ( N_noxref_26_c_13130_p N_GND_c_14061_n ) capacitor c=0.00338834f \
 //x=23.2 //y=0.805 //x2=26.005 //y2=0.175
cc_7764 ( N_noxref_26_c_13087_n N_GND_c_14061_n ) capacitor c=0.00960852f \
 //x=24.085 //y=0.72 //x2=26.005 //y2=0.175
cc_7765 ( N_noxref_26_c_13132_p N_GND_c_14061_n ) capacitor c=0.00232964f \
 //x=24.17 //y=0.805 //x2=26.005 //y2=0.175
cc_7766 ( N_noxref_26_M13_noxref_d N_GND_c_14061_n ) capacitor c=0.0130869f \
 //x=21.96 //y=1.09 //x2=26.005 //y2=0.175
cc_7767 ( N_noxref_26_M13_noxref_d N_GND_c_14027_n ) capacitor c=0.0154456f \
 //x=21.96 //y=1.09 //x2=21.175 //y2=1.145
cc_7768 ( N_noxref_26_c_13098_n N_GND_c_14039_n ) capacitor c=0.0091517f \
 //x=23.115 //y=1.175 //x2=24.74 //y2=0.175
cc_7769 ( N_noxref_26_c_13130_p N_GND_c_14039_n ) capacitor c=0.0141638f \
 //x=23.2 //y=0.805 //x2=24.74 //y2=0.175
cc_7770 ( N_noxref_26_c_13087_n N_GND_c_14039_n ) capacitor c=0.0364778f \
 //x=24.085 //y=0.72 //x2=24.74 //y2=0.175
cc_7771 ( N_noxref_26_c_13132_p N_GND_c_14039_n ) capacitor c=0.013886f \
 //x=24.17 //y=0.805 //x2=24.74 //y2=0.175
cc_7772 ( N_noxref_26_M14_noxref_s N_GND_c_14041_n ) capacitor c=8.16352e-19 \
 //x=23.065 //y=0.555 //x2=20.1 //y2=0.175
cc_7773 ( N_noxref_26_c_13132_p N_GND_c_14078_n ) capacitor c=0.0374312f \
 //x=24.17 //y=0.805 //x2=24.91 //y2=0.175
cc_7774 ( N_noxref_26_M14_noxref_s N_GND_c_14078_n ) capacitor c=0.00519576f \
 //x=23.065 //y=0.555 //x2=24.91 //y2=0.175
cc_7775 ( N_noxref_26_M13_noxref_d N_GND_M12_noxref_d ) capacitor \
 c=3.12752e-19 //x=21.96 //y=1.09 //x2=20.985 //y2=1.055
cc_7776 ( N_noxref_26_c_13130_p N_noxref_42_c_15939_n ) capacitor \
 c=2.15937e-19 //x=23.2 //y=0.805 //x2=21.66 //y2=0.805
cc_7777 ( N_noxref_26_c_13098_n N_noxref_42_c_15926_n ) capacitor c=0.0130741f \
 //x=23.115 //y=1.175 //x2=22.545 //y2=0.72
cc_7778 ( N_noxref_26_M13_noxref_d N_noxref_42_c_15926_n ) capacitor \
 c=0.0160925f //x=21.96 //y=1.09 //x2=22.545 //y2=0.72
cc_7779 ( N_noxref_26_c_13098_n N_noxref_42_c_15928_n ) capacitor \
 c=0.00941725f //x=23.115 //y=1.175 //x2=22.545 //y2=1.77
cc_7780 ( N_noxref_26_M13_noxref_d N_noxref_42_c_15928_n ) capacitor \
 c=0.01508f //x=21.96 //y=1.09 //x2=22.545 //y2=1.77
cc_7781 ( N_noxref_26_c_13098_n N_noxref_42_M12_noxref_s ) capacitor \
 c=0.0223986f //x=23.115 //y=1.175 //x2=20.555 //y2=0.555
cc_7782 ( N_noxref_26_c_13130_p N_noxref_42_M12_noxref_s ) capacitor \
 c=0.0175532f //x=23.2 //y=0.805 //x2=20.555 //y2=0.555
cc_7783 ( N_noxref_26_c_13132_p N_noxref_42_M12_noxref_s ) capacitor \
 c=2.98721e-19 //x=24.17 //y=0.805 //x2=20.555 //y2=0.555
cc_7784 ( N_noxref_26_M13_noxref_d N_noxref_42_M12_noxref_s ) capacitor \
 c=0.0187674f //x=21.96 //y=1.09 //x2=20.555 //y2=0.555
cc_7785 ( N_noxref_26_M14_noxref_s N_noxref_42_M12_noxref_s ) capacitor \
 c=0.021082f //x=23.065 //y=0.555 //x2=20.555 //y2=0.555
cc_7786 ( N_noxref_26_c_13132_p N_noxref_43_M15_noxref_s ) capacitor \
 c=0.00370912f //x=24.17 //y=0.805 //x2=25.47 //y2=0.545
cc_7787 ( N_noxref_26_M14_noxref_s N_noxref_43_M15_noxref_s ) capacitor \
 c=0.00101401f //x=23.065 //y=0.555 //x2=25.47 //y2=0.545
cc_7788 ( N_noxref_27_c_13177_n N_GND_c_14198_n ) capacitor c=0.00533679f \
 //x=31.255 //y=1.175 //x2=34.04 //y2=0.175
cc_7789 ( N_noxref_27_c_13197_p N_GND_c_14198_n ) capacitor c=0.00431259f \
 //x=31.34 //y=0.805 //x2=34.04 //y2=0.175
cc_7790 ( N_noxref_27_c_13156_n N_GND_c_14198_n ) capacitor c=0.0096072f \
 //x=32.225 //y=0.72 //x2=34.04 //y2=0.175
cc_7791 ( N_noxref_27_c_13199_p N_GND_c_14198_n ) capacitor c=0.00232964f \
 //x=32.31 //y=0.805 //x2=34.04 //y2=0.175
cc_7792 ( N_noxref_27_M18_noxref_d N_GND_c_14198_n ) capacitor c=0.0130498f \
 //x=30.1 //y=1.09 //x2=34.04 //y2=0.175
cc_7793 ( N_noxref_27_M18_noxref_d N_GND_c_14093_n ) capacitor c=0.0154456f \
 //x=30.1 //y=1.09 //x2=29.315 //y2=1.145
cc_7794 ( N_noxref_27_c_13177_n N_GND_c_14116_n ) capacitor c=0.0091517f \
 //x=31.255 //y=1.175 //x2=32.88 //y2=0.175
cc_7795 ( N_noxref_27_c_13197_p N_GND_c_14116_n ) capacitor c=0.0141638f \
 //x=31.34 //y=0.805 //x2=32.88 //y2=0.175
cc_7796 ( N_noxref_27_c_13156_n N_GND_c_14116_n ) capacitor c=0.0364778f \
 //x=32.225 //y=0.72 //x2=32.88 //y2=0.175
cc_7797 ( N_noxref_27_c_13199_p N_GND_c_14116_n ) capacitor c=0.013886f \
 //x=32.31 //y=0.805 //x2=32.88 //y2=0.175
cc_7798 ( N_noxref_27_M19_noxref_s N_GND_c_14120_n ) capacitor c=8.16352e-19 \
 //x=31.205 //y=0.555 //x2=28.24 //y2=0.175
cc_7799 ( N_noxref_27_c_13199_p N_GND_c_14132_n ) capacitor c=0.037873f \
 //x=32.31 //y=0.805 //x2=33.05 //y2=0.175
cc_7800 ( N_noxref_27_M19_noxref_s N_GND_c_14132_n ) capacitor c=0.0051897f \
 //x=31.205 //y=0.555 //x2=33.05 //y2=0.175
cc_7801 ( N_noxref_27_M18_noxref_d N_GND_M17_noxref_d ) capacitor \
 c=3.12752e-19 //x=30.1 //y=1.09 //x2=29.125 //y2=1.055
cc_7802 ( N_noxref_27_c_13197_p N_noxref_44_c_16066_n ) capacitor \
 c=2.15937e-19 //x=31.34 //y=0.805 //x2=29.8 //y2=0.805
cc_7803 ( N_noxref_27_c_13177_n N_noxref_44_c_16050_n ) capacitor c=0.0130857f \
 //x=31.255 //y=1.175 //x2=30.685 //y2=0.72
cc_7804 ( N_noxref_27_M18_noxref_d N_noxref_44_c_16050_n ) capacitor \
 c=0.0160925f //x=30.1 //y=1.09 //x2=30.685 //y2=0.72
cc_7805 ( N_noxref_27_c_13177_n N_noxref_44_c_16052_n ) capacitor \
 c=0.00944538f //x=31.255 //y=1.175 //x2=30.685 //y2=1.77
cc_7806 ( N_noxref_27_M18_noxref_d N_noxref_44_c_16052_n ) capacitor \
 c=0.0152665f //x=30.1 //y=1.09 //x2=30.685 //y2=1.77
cc_7807 ( N_noxref_27_c_13177_n N_noxref_44_M17_noxref_s ) capacitor \
 c=0.0223986f //x=31.255 //y=1.175 //x2=28.695 //y2=0.555
cc_7808 ( N_noxref_27_c_13197_p N_noxref_44_M17_noxref_s ) capacitor \
 c=0.0175461f //x=31.34 //y=0.805 //x2=28.695 //y2=0.555
cc_7809 ( N_noxref_27_c_13199_p N_noxref_44_M17_noxref_s ) capacitor \
 c=2.98576e-19 //x=32.31 //y=0.805 //x2=28.695 //y2=0.555
cc_7810 ( N_noxref_27_M18_noxref_d N_noxref_44_M17_noxref_s ) capacitor \
 c=0.0187674f //x=30.1 //y=1.09 //x2=28.695 //y2=0.555
cc_7811 ( N_noxref_27_M19_noxref_s N_noxref_44_M17_noxref_s ) capacitor \
 c=0.0210819f //x=31.205 //y=0.555 //x2=28.695 //y2=0.555
cc_7812 ( N_noxref_27_c_13199_p N_noxref_45_M20_noxref_s ) capacitor \
 c=0.00368328f //x=32.31 //y=0.805 //x2=33.505 //y2=0.555
cc_7813 ( N_noxref_27_M19_noxref_s N_noxref_45_M20_noxref_s ) capacitor \
 c=0.00125282f //x=31.205 //y=0.555 //x2=33.505 //y2=0.555
cc_7814 ( N_noxref_28_c_13245_n N_GND_c_14155_n ) capacitor c=0.00533679f \
 //x=36.065 //y=1.175 //x2=38.955 //y2=0.175
cc_7815 ( N_noxref_28_c_13265_p N_GND_c_14155_n ) capacitor c=0.0033879f \
 //x=36.15 //y=0.805 //x2=38.955 //y2=0.175
cc_7816 ( N_noxref_28_c_13222_n N_GND_c_14155_n ) capacitor c=0.0096072f \
 //x=37.035 //y=0.72 //x2=38.955 //y2=0.175
cc_7817 ( N_noxref_28_c_13267_p N_GND_c_14155_n ) capacitor c=0.00232964f \
 //x=37.12 //y=0.805 //x2=38.955 //y2=0.175
cc_7818 ( N_noxref_28_M21_noxref_d N_GND_c_14155_n ) capacitor c=0.0130881f \
 //x=34.91 //y=1.09 //x2=38.955 //y2=0.175
cc_7819 ( N_noxref_28_M21_noxref_d N_GND_c_14104_n ) capacitor c=0.0154456f \
 //x=34.91 //y=1.09 //x2=34.125 //y2=1.145
cc_7820 ( N_noxref_28_c_13245_n N_GND_c_14117_n ) capacitor c=0.0091517f \
 //x=36.065 //y=1.175 //x2=37.69 //y2=0.175
cc_7821 ( N_noxref_28_c_13265_p N_GND_c_14117_n ) capacitor c=0.0141638f \
 //x=36.15 //y=0.805 //x2=37.69 //y2=0.175
cc_7822 ( N_noxref_28_c_13222_n N_GND_c_14117_n ) capacitor c=0.0364778f \
 //x=37.035 //y=0.72 //x2=37.69 //y2=0.175
cc_7823 ( N_noxref_28_c_13267_p N_GND_c_14117_n ) capacitor c=0.013886f \
 //x=37.12 //y=0.805 //x2=37.69 //y2=0.175
cc_7824 ( N_noxref_28_M22_noxref_s N_GND_c_14132_n ) capacitor c=8.16352e-19 \
 //x=36.015 //y=0.555 //x2=33.05 //y2=0.175
cc_7825 ( N_noxref_28_c_13267_p N_GND_c_14176_n ) capacitor c=0.0374312f \
 //x=37.12 //y=0.805 //x2=37.86 //y2=0.175
cc_7826 ( N_noxref_28_M22_noxref_s N_GND_c_14176_n ) capacitor c=0.00519576f \
 //x=36.015 //y=0.555 //x2=37.86 //y2=0.175
cc_7827 ( N_noxref_28_M21_noxref_d N_GND_M20_noxref_d ) capacitor \
 c=3.12752e-19 //x=34.91 //y=1.09 //x2=33.935 //y2=1.055
cc_7828 ( N_noxref_28_c_13265_p N_noxref_45_c_16129_n ) capacitor \
 c=2.15937e-19 //x=36.15 //y=0.805 //x2=34.61 //y2=0.805
cc_7829 ( N_noxref_28_c_13245_n N_noxref_45_c_16114_n ) capacitor c=0.0130703f \
 //x=36.065 //y=1.175 //x2=35.495 //y2=0.72
cc_7830 ( N_noxref_28_M21_noxref_d N_noxref_45_c_16114_n ) capacitor \
 c=0.0160925f //x=34.91 //y=1.09 //x2=35.495 //y2=0.72
cc_7831 ( N_noxref_28_c_13245_n N_noxref_45_c_16116_n ) capacitor \
 c=0.00940787f //x=36.065 //y=1.175 //x2=35.495 //y2=1.77
cc_7832 ( N_noxref_28_M21_noxref_d N_noxref_45_c_16116_n ) capacitor \
 c=0.0151189f //x=34.91 //y=1.09 //x2=35.495 //y2=1.77
cc_7833 ( N_noxref_28_c_13245_n N_noxref_45_M20_noxref_s ) capacitor \
 c=0.0223986f //x=36.065 //y=1.175 //x2=33.505 //y2=0.555
cc_7834 ( N_noxref_28_c_13265_p N_noxref_45_M20_noxref_s ) capacitor \
 c=0.0175532f //x=36.15 //y=0.805 //x2=33.505 //y2=0.555
cc_7835 ( N_noxref_28_c_13267_p N_noxref_45_M20_noxref_s ) capacitor \
 c=2.98721e-19 //x=37.12 //y=0.805 //x2=33.505 //y2=0.555
cc_7836 ( N_noxref_28_M21_noxref_d N_noxref_45_M20_noxref_s ) capacitor \
 c=0.0187685f //x=34.91 //y=1.09 //x2=33.505 //y2=0.555
cc_7837 ( N_noxref_28_M22_noxref_s N_noxref_45_M20_noxref_s ) capacitor \
 c=0.021082f //x=36.015 //y=0.555 //x2=33.505 //y2=0.555
cc_7838 ( N_noxref_28_c_13267_p N_noxref_46_M23_noxref_s ) capacitor \
 c=0.00370912f //x=37.12 //y=0.805 //x2=38.42 //y2=0.545
cc_7839 ( N_noxref_28_M22_noxref_s N_noxref_46_M23_noxref_s ) capacitor \
 c=0.00101401f //x=36.015 //y=0.555 //x2=38.42 //y2=0.545
cc_7840 ( N_noxref_29_c_13313_n N_GND_c_14287_n ) capacitor c=0.00533679f \
 //x=47.535 //y=1.175 //x2=50.425 //y2=0.175
cc_7841 ( N_noxref_29_c_13334_p N_GND_c_14287_n ) capacitor c=0.00338834f \
 //x=47.62 //y=0.805 //x2=50.425 //y2=0.175
cc_7842 ( N_noxref_29_c_13291_n N_GND_c_14287_n ) capacitor c=0.00960852f \
 //x=48.505 //y=0.72 //x2=50.425 //y2=0.175
cc_7843 ( N_noxref_29_c_13336_p N_GND_c_14287_n ) capacitor c=0.00232964f \
 //x=48.59 //y=0.805 //x2=50.425 //y2=0.175
cc_7844 ( N_noxref_29_M28_noxref_d N_GND_c_14287_n ) capacitor c=0.0130869f \
 //x=46.38 //y=1.09 //x2=50.425 //y2=0.175
cc_7845 ( N_noxref_29_M28_noxref_d N_GND_c_14245_n ) capacitor c=0.0154456f \
 //x=46.38 //y=1.09 //x2=45.595 //y2=1.145
cc_7846 ( N_noxref_29_c_13313_n N_GND_c_14258_n ) capacitor c=0.0091517f \
 //x=47.535 //y=1.175 //x2=49.16 //y2=0.175
cc_7847 ( N_noxref_29_c_13334_p N_GND_c_14258_n ) capacitor c=0.0141638f \
 //x=47.62 //y=0.805 //x2=49.16 //y2=0.175
cc_7848 ( N_noxref_29_c_13291_n N_GND_c_14258_n ) capacitor c=0.0364778f \
 //x=48.505 //y=0.72 //x2=49.16 //y2=0.175
cc_7849 ( N_noxref_29_c_13336_p N_GND_c_14258_n ) capacitor c=0.013886f \
 //x=48.59 //y=0.805 //x2=49.16 //y2=0.175
cc_7850 ( N_noxref_29_M29_noxref_s N_GND_c_14261_n ) capacitor c=8.16352e-19 \
 //x=47.485 //y=0.555 //x2=44.52 //y2=0.175
cc_7851 ( N_noxref_29_c_13336_p N_GND_c_14304_n ) capacitor c=0.0374312f \
 //x=48.59 //y=0.805 //x2=49.33 //y2=0.175
cc_7852 ( N_noxref_29_M29_noxref_s N_GND_c_14304_n ) capacitor c=0.00519576f \
 //x=47.485 //y=0.555 //x2=49.33 //y2=0.175
cc_7853 ( N_noxref_29_M28_noxref_d N_GND_M27_noxref_d ) capacitor \
 c=3.12752e-19 //x=46.38 //y=1.09 //x2=45.405 //y2=1.055
cc_7854 ( N_noxref_29_c_13334_p N_noxref_48_c_16319_n ) capacitor \
 c=2.15937e-19 //x=47.62 //y=0.805 //x2=46.08 //y2=0.805
cc_7855 ( N_noxref_29_c_13313_n N_noxref_48_c_16306_n ) capacitor c=0.0130741f \
 //x=47.535 //y=1.175 //x2=46.965 //y2=0.72
cc_7856 ( N_noxref_29_M28_noxref_d N_noxref_48_c_16306_n ) capacitor \
 c=0.0160925f //x=46.38 //y=1.09 //x2=46.965 //y2=0.72
cc_7857 ( N_noxref_29_c_13313_n N_noxref_48_c_16308_n ) capacitor \
 c=0.00941725f //x=47.535 //y=1.175 //x2=46.965 //y2=1.77
cc_7858 ( N_noxref_29_M28_noxref_d N_noxref_48_c_16308_n ) capacitor \
 c=0.01508f //x=46.38 //y=1.09 //x2=46.965 //y2=1.77
cc_7859 ( N_noxref_29_c_13313_n N_noxref_48_M27_noxref_s ) capacitor \
 c=0.0223986f //x=47.535 //y=1.175 //x2=44.975 //y2=0.555
cc_7860 ( N_noxref_29_c_13334_p N_noxref_48_M27_noxref_s ) capacitor \
 c=0.0175532f //x=47.62 //y=0.805 //x2=44.975 //y2=0.555
cc_7861 ( N_noxref_29_c_13336_p N_noxref_48_M27_noxref_s ) capacitor \
 c=2.98721e-19 //x=48.59 //y=0.805 //x2=44.975 //y2=0.555
cc_7862 ( N_noxref_29_M28_noxref_d N_noxref_48_M27_noxref_s ) capacitor \
 c=0.0187674f //x=46.38 //y=1.09 //x2=44.975 //y2=0.555
cc_7863 ( N_noxref_29_M29_noxref_s N_noxref_48_M27_noxref_s ) capacitor \
 c=0.021082f //x=47.485 //y=0.555 //x2=44.975 //y2=0.555
cc_7864 ( N_noxref_29_c_13336_p N_noxref_49_M30_noxref_s ) capacitor \
 c=0.00370912f //x=48.59 //y=0.805 //x2=49.89 //y2=0.545
cc_7865 ( N_noxref_29_M29_noxref_s N_noxref_49_M30_noxref_s ) capacitor \
 c=0.00101401f //x=47.485 //y=0.555 //x2=49.89 //y2=0.545
cc_7866 ( N_noxref_30_c_13360_n N_GND_c_14559_n ) capacitor c=0.00533679f \
 //x=55.675 //y=1.175 //x2=58.46 //y2=0.175
cc_7867 ( N_noxref_30_c_13401_p N_GND_c_14559_n ) capacitor c=0.00431259f \
 //x=55.76 //y=0.805 //x2=58.46 //y2=0.175
cc_7868 ( N_noxref_30_c_13375_n N_GND_c_14559_n ) capacitor c=0.0096072f \
 //x=56.645 //y=0.72 //x2=58.46 //y2=0.175
cc_7869 ( N_noxref_30_c_13403_p N_GND_c_14559_n ) capacitor c=0.00232964f \
 //x=56.73 //y=0.805 //x2=58.46 //y2=0.175
cc_7870 ( N_noxref_30_M33_noxref_d N_GND_c_14559_n ) capacitor c=0.0130498f \
 //x=54.52 //y=1.09 //x2=58.46 //y2=0.175
cc_7871 ( N_noxref_30_M33_noxref_d N_GND_c_14451_n ) capacitor c=0.0154456f \
 //x=54.52 //y=1.09 //x2=53.735 //y2=1.145
cc_7872 ( N_noxref_30_c_13360_n N_GND_c_14474_n ) capacitor c=0.0091517f \
 //x=55.675 //y=1.175 //x2=57.3 //y2=0.175
cc_7873 ( N_noxref_30_c_13401_p N_GND_c_14474_n ) capacitor c=0.0141638f \
 //x=55.76 //y=0.805 //x2=57.3 //y2=0.175
cc_7874 ( N_noxref_30_c_13375_n N_GND_c_14474_n ) capacitor c=0.0364778f \
 //x=56.645 //y=0.72 //x2=57.3 //y2=0.175
cc_7875 ( N_noxref_30_c_13403_p N_GND_c_14474_n ) capacitor c=0.013886f \
 //x=56.73 //y=0.805 //x2=57.3 //y2=0.175
cc_7876 ( N_noxref_30_M34_noxref_s N_GND_c_14332_n ) capacitor c=8.16352e-19 \
 //x=55.625 //y=0.555 //x2=52.66 //y2=0.175
cc_7877 ( N_noxref_30_c_13403_p N_GND_c_14333_n ) capacitor c=0.037873f \
 //x=56.73 //y=0.805 //x2=57.47 //y2=0.175
cc_7878 ( N_noxref_30_M34_noxref_s N_GND_c_14333_n ) capacitor c=0.0051897f \
 //x=55.625 //y=0.555 //x2=57.47 //y2=0.175
cc_7879 ( N_noxref_30_M33_noxref_d N_GND_M32_noxref_d ) capacitor \
 c=3.12752e-19 //x=54.52 //y=1.09 //x2=53.545 //y2=1.055
cc_7880 ( N_noxref_30_c_13401_p N_noxref_50_c_16446_n ) capacitor \
 c=2.15937e-19 //x=55.76 //y=0.805 //x2=54.22 //y2=0.805
cc_7881 ( N_noxref_30_c_13360_n N_noxref_50_c_16430_n ) capacitor c=0.0130857f \
 //x=55.675 //y=1.175 //x2=55.105 //y2=0.72
cc_7882 ( N_noxref_30_M33_noxref_d N_noxref_50_c_16430_n ) capacitor \
 c=0.0160925f //x=54.52 //y=1.09 //x2=55.105 //y2=0.72
cc_7883 ( N_noxref_30_c_13360_n N_noxref_50_c_16432_n ) capacitor \
 c=0.00944538f //x=55.675 //y=1.175 //x2=55.105 //y2=1.77
cc_7884 ( N_noxref_30_M33_noxref_d N_noxref_50_c_16432_n ) capacitor \
 c=0.0152665f //x=54.52 //y=1.09 //x2=55.105 //y2=1.77
cc_7885 ( N_noxref_30_c_13360_n N_noxref_50_M32_noxref_s ) capacitor \
 c=0.0223986f //x=55.675 //y=1.175 //x2=53.115 //y2=0.555
cc_7886 ( N_noxref_30_c_13401_p N_noxref_50_M32_noxref_s ) capacitor \
 c=0.0175461f //x=55.76 //y=0.805 //x2=53.115 //y2=0.555
cc_7887 ( N_noxref_30_c_13403_p N_noxref_50_M32_noxref_s ) capacitor \
 c=2.98576e-19 //x=56.73 //y=0.805 //x2=53.115 //y2=0.555
cc_7888 ( N_noxref_30_M33_noxref_d N_noxref_50_M32_noxref_s ) capacitor \
 c=0.0187674f //x=54.52 //y=1.09 //x2=53.115 //y2=0.555
cc_7889 ( N_noxref_30_M34_noxref_s N_noxref_50_M32_noxref_s ) capacitor \
 c=0.0210819f //x=55.625 //y=0.555 //x2=53.115 //y2=0.555
cc_7890 ( N_noxref_30_c_13403_p N_noxref_51_M35_noxref_s ) capacitor \
 c=0.00368328f //x=56.73 //y=0.805 //x2=57.925 //y2=0.555
cc_7891 ( N_noxref_30_M34_noxref_s N_noxref_51_M35_noxref_s ) capacitor \
 c=0.00125282f //x=55.625 //y=0.555 //x2=57.925 //y2=0.555
cc_7892 ( N_noxref_31_c_13438_n N_GND_c_14513_n ) capacitor c=0.00533679f \
 //x=60.485 //y=1.175 //x2=63.375 //y2=0.175
cc_7893 ( N_noxref_31_c_13469_p N_GND_c_14513_n ) capacitor c=0.0033879f \
 //x=60.57 //y=0.805 //x2=63.375 //y2=0.175
cc_7894 ( N_noxref_31_c_13426_n N_GND_c_14513_n ) capacitor c=0.0096072f \
 //x=61.455 //y=0.72 //x2=63.375 //y2=0.175
cc_7895 ( N_noxref_31_c_13471_p N_GND_c_14513_n ) capacitor c=0.00232964f \
 //x=61.54 //y=0.805 //x2=63.375 //y2=0.175
cc_7896 ( N_noxref_31_M36_noxref_d N_GND_c_14513_n ) capacitor c=0.0130881f \
 //x=59.33 //y=1.09 //x2=63.375 //y2=0.175
cc_7897 ( N_noxref_31_M36_noxref_d N_GND_c_14462_n ) capacitor c=0.0154456f \
 //x=59.33 //y=1.09 //x2=58.545 //y2=1.145
cc_7898 ( N_noxref_31_c_13438_n N_GND_c_14475_n ) capacitor c=0.0091517f \
 //x=60.485 //y=1.175 //x2=62.11 //y2=0.175
cc_7899 ( N_noxref_31_c_13469_p N_GND_c_14475_n ) capacitor c=0.0141638f \
 //x=60.57 //y=0.805 //x2=62.11 //y2=0.175
cc_7900 ( N_noxref_31_c_13426_n N_GND_c_14475_n ) capacitor c=0.0364778f \
 //x=61.455 //y=0.72 //x2=62.11 //y2=0.175
cc_7901 ( N_noxref_31_c_13471_p N_GND_c_14475_n ) capacitor c=0.013886f \
 //x=61.54 //y=0.805 //x2=62.11 //y2=0.175
cc_7902 ( N_noxref_31_M37_noxref_s N_GND_c_14333_n ) capacitor c=8.16352e-19 \
 //x=60.435 //y=0.555 //x2=57.47 //y2=0.175
cc_7903 ( N_noxref_31_c_13471_p N_GND_c_14334_n ) capacitor c=0.0374312f \
 //x=61.54 //y=0.805 //x2=62.28 //y2=0.175
cc_7904 ( N_noxref_31_M37_noxref_s N_GND_c_14334_n ) capacitor c=0.00519576f \
 //x=60.435 //y=0.555 //x2=62.28 //y2=0.175
cc_7905 ( N_noxref_31_M36_noxref_d N_GND_M35_noxref_d ) capacitor \
 c=3.12752e-19 //x=59.33 //y=1.09 //x2=58.355 //y2=1.055
cc_7906 ( N_noxref_31_c_13469_p N_noxref_51_c_16509_n ) capacitor \
 c=2.15937e-19 //x=60.57 //y=0.805 //x2=59.03 //y2=0.805
cc_7907 ( N_noxref_31_c_13438_n N_noxref_51_c_16494_n ) capacitor c=0.0130703f \
 //x=60.485 //y=1.175 //x2=59.915 //y2=0.72
cc_7908 ( N_noxref_31_M36_noxref_d N_noxref_51_c_16494_n ) capacitor \
 c=0.0160925f //x=59.33 //y=1.09 //x2=59.915 //y2=0.72
cc_7909 ( N_noxref_31_c_13438_n N_noxref_51_c_16496_n ) capacitor \
 c=0.00940787f //x=60.485 //y=1.175 //x2=59.915 //y2=1.77
cc_7910 ( N_noxref_31_M36_noxref_d N_noxref_51_c_16496_n ) capacitor \
 c=0.0151189f //x=59.33 //y=1.09 //x2=59.915 //y2=1.77
cc_7911 ( N_noxref_31_c_13438_n N_noxref_51_M35_noxref_s ) capacitor \
 c=0.0223986f //x=60.485 //y=1.175 //x2=57.925 //y2=0.555
cc_7912 ( N_noxref_31_c_13469_p N_noxref_51_M35_noxref_s ) capacitor \
 c=0.0175532f //x=60.57 //y=0.805 //x2=57.925 //y2=0.555
cc_7913 ( N_noxref_31_c_13471_p N_noxref_51_M35_noxref_s ) capacitor \
 c=2.98721e-19 //x=61.54 //y=0.805 //x2=57.925 //y2=0.555
cc_7914 ( N_noxref_31_M36_noxref_d N_noxref_51_M35_noxref_s ) capacitor \
 c=0.0187685f //x=59.33 //y=1.09 //x2=57.925 //y2=0.555
cc_7915 ( N_noxref_31_M37_noxref_s N_noxref_51_M35_noxref_s ) capacitor \
 c=0.021082f //x=60.435 //y=0.555 //x2=57.925 //y2=0.555
cc_7916 ( N_noxref_31_c_13471_p N_noxref_52_M38_noxref_s ) capacitor \
 c=0.00370912f //x=61.54 //y=0.805 //x2=62.84 //y2=0.545
cc_7917 ( N_noxref_31_M37_noxref_s N_noxref_52_M38_noxref_s ) capacitor \
 c=0.00101401f //x=60.435 //y=0.555 //x2=62.84 //y2=0.545
cc_7918 ( N_noxref_32_c_13494_n N_GND_c_14678_n ) capacitor c=0.00533679f \
 //x=71.955 //y=1.175 //x2=74.845 //y2=0.175
cc_7919 ( N_noxref_32_c_13538_p N_GND_c_14678_n ) capacitor c=0.00418576f \
 //x=72.04 //y=0.805 //x2=74.845 //y2=0.175
cc_7920 ( N_noxref_32_c_13495_n N_GND_c_14678_n ) capacitor c=0.00960852f \
 //x=72.925 //y=0.72 //x2=74.845 //y2=0.175
cc_7921 ( N_noxref_32_c_13540_p N_GND_c_14678_n ) capacitor c=0.00232964f \
 //x=73.01 //y=0.805 //x2=74.845 //y2=0.175
cc_7922 ( N_noxref_32_M43_noxref_d N_GND_c_14678_n ) capacitor c=0.0130869f \
 //x=70.8 //y=1.09 //x2=74.845 //y2=0.175
cc_7923 ( N_noxref_32_M43_noxref_d N_GND_c_14620_n ) capacitor c=0.0154456f \
 //x=70.8 //y=1.09 //x2=70.015 //y2=1.145
cc_7924 ( N_noxref_32_c_13494_n N_GND_c_14632_n ) capacitor c=0.0080792f \
 //x=71.955 //y=1.175 //x2=73.58 //y2=0.175
cc_7925 ( N_noxref_32_c_13538_p N_GND_c_14632_n ) capacitor c=0.0140604f \
 //x=72.04 //y=0.805 //x2=73.58 //y2=0.175
cc_7926 ( N_noxref_32_c_13495_n N_GND_c_14632_n ) capacitor c=0.0364637f \
 //x=72.925 //y=0.72 //x2=73.58 //y2=0.175
cc_7927 ( N_noxref_32_c_13540_p N_GND_c_14632_n ) capacitor c=0.013886f \
 //x=73.01 //y=0.805 //x2=73.58 //y2=0.175
cc_7928 ( N_noxref_32_M44_noxref_s N_GND_c_14336_n ) capacitor c=8.16352e-19 \
 //x=71.905 //y=0.555 //x2=68.94 //y2=0.175
cc_7929 ( N_noxref_32_c_13540_p N_GND_c_14337_n ) capacitor c=0.0374609f \
 //x=73.01 //y=0.805 //x2=73.75 //y2=0.175
cc_7930 ( N_noxref_32_M44_noxref_s N_GND_c_14337_n ) capacitor c=0.00519577f \
 //x=71.905 //y=0.555 //x2=73.75 //y2=0.175
cc_7931 ( N_noxref_32_M43_noxref_d N_GND_M42_noxref_d ) capacitor \
 c=3.12752e-19 //x=70.8 //y=1.09 //x2=69.825 //y2=1.055
cc_7932 ( N_noxref_32_c_13538_p N_noxref_54_c_16697_n ) capacitor \
 c=2.15937e-19 //x=72.04 //y=0.805 //x2=70.5 //y2=0.805
cc_7933 ( N_noxref_32_c_13494_n N_noxref_54_c_16686_n ) capacitor c=0.0131084f \
 //x=71.955 //y=1.175 //x2=71.385 //y2=0.72
cc_7934 ( N_noxref_32_M43_noxref_d N_noxref_54_c_16686_n ) capacitor \
 c=0.0160925f //x=70.8 //y=1.09 //x2=71.385 //y2=0.72
cc_7935 ( N_noxref_32_c_13494_n N_noxref_54_c_16670_n ) capacitor \
 c=0.00946019f //x=71.955 //y=1.175 //x2=71.385 //y2=1.77
cc_7936 ( N_noxref_32_M43_noxref_d N_noxref_54_c_16670_n ) capacitor \
 c=0.01508f //x=70.8 //y=1.09 //x2=71.385 //y2=1.77
cc_7937 ( N_noxref_32_c_13494_n N_noxref_54_M42_noxref_s ) capacitor \
 c=0.0226963f //x=71.955 //y=1.175 //x2=69.395 //y2=0.555
cc_7938 ( N_noxref_32_c_13538_p N_noxref_54_M42_noxref_s ) capacitor \
 c=0.0175532f //x=72.04 //y=0.805 //x2=69.395 //y2=0.555
cc_7939 ( N_noxref_32_c_13540_p N_noxref_54_M42_noxref_s ) capacitor \
 c=2.98721e-19 //x=73.01 //y=0.805 //x2=69.395 //y2=0.555
cc_7940 ( N_noxref_32_M43_noxref_d N_noxref_54_M42_noxref_s ) capacitor \
 c=0.0187674f //x=70.8 //y=1.09 //x2=69.395 //y2=0.555
cc_7941 ( N_noxref_32_M44_noxref_s N_noxref_54_M42_noxref_s ) capacitor \
 c=0.021082f //x=71.905 //y=0.555 //x2=69.395 //y2=0.555
cc_7942 ( N_noxref_32_c_13540_p N_noxref_55_M45_noxref_s ) capacitor \
 c=0.00369575f //x=73.01 //y=0.805 //x2=74.31 //y2=0.545
cc_7943 ( N_noxref_32_M44_noxref_s N_noxref_55_M45_noxref_s ) capacitor \
 c=0.00101401f //x=71.905 //y=0.555 //x2=74.31 //y2=0.545
cc_7944 ( N_noxref_33_c_13588_n N_noxref_34_c_13737_n ) capacitor \
 c=0.00321697f //x=78.62 //y=7.09 //x2=79.065 //y2=5.39
cc_7945 ( N_noxref_33_c_13612_n N_noxref_34_c_13737_n ) capacitor \
 c=0.00331901f //x=79.505 //y=7.09 //x2=79.065 //y2=5.39
cc_7946 ( N_noxref_33_c_13601_n N_noxref_34_c_13737_n ) capacitor c=0.0047685f \
 //x=78.737 //y=7.09 //x2=79.065 //y2=5.39
cc_7947 ( N_noxref_33_M147_noxref_d N_noxref_34_c_13737_n ) capacitor \
 c=0.00678641f //x=78.595 //y=5.205 //x2=79.065 //y2=5.39
cc_7948 ( N_noxref_33_c_13612_n N_noxref_34_c_13725_n ) capacitor \
 c=0.00331329f //x=79.505 //y=7.09 //x2=81.085 //y2=5.39
cc_7949 ( N_noxref_33_c_13615_n N_noxref_34_c_13725_n ) capacitor \
 c=0.00465918f //x=79.62 //y=6.92 //x2=81.085 //y2=5.39
cc_7950 ( N_noxref_33_M149_noxref_d N_noxref_34_c_13725_n ) capacitor \
 c=0.00491419f //x=79.475 //y=5.205 //x2=81.085 //y2=5.39
cc_7951 ( N_noxref_33_c_13570_n N_noxref_34_c_13726_n ) capacitor c=9.81e-19 \
 //x=77.745 //y=5.39 //x2=79.295 //y2=5.39
cc_7952 ( N_noxref_33_c_13612_n N_noxref_34_c_13726_n ) capacitor \
 c=0.00439275f //x=79.505 //y=7.09 //x2=79.295 //y2=5.39
cc_7953 ( N_noxref_33_c_13570_n N_noxref_34_c_13729_n ) capacitor c=0.033638f \
 //x=77.745 //y=5.39 //x2=78.3 //y2=5.39
cc_7954 ( N_noxref_33_c_13588_n N_noxref_34_c_13729_n ) capacitor c=0.0048075f \
 //x=78.62 //y=7.09 //x2=78.3 //y2=5.39
cc_7955 ( N_noxref_33_c_13594_n N_noxref_34_c_13729_n ) capacitor \
 c=0.00241473f //x=74.982 //y=5.39 //x2=78.3 //y2=5.39
cc_7956 ( N_noxref_33_c_13606_n N_noxref_34_c_13729_n ) capacitor c=0.0100239f \
 //x=77.86 //y=5.39 //x2=78.3 //y2=5.39
cc_7957 ( N_noxref_33_c_13570_n N_noxref_34_c_13730_n ) capacitor \
 c=5.61108e-19 //x=77.745 //y=5.39 //x2=79.18 //y2=5.39
cc_7958 ( N_noxref_33_c_13606_n N_noxref_34_c_13730_n ) capacitor \
 c=0.00225426f //x=77.86 //y=5.39 //x2=79.18 //y2=5.39
cc_7959 ( N_noxref_33_c_13601_n N_noxref_34_c_13768_n ) capacitor \
 c=2.01993e-19 //x=78.737 //y=7.09 //x2=81.2 //y2=6.92
cc_7960 ( N_noxref_33_c_13615_n N_noxref_34_c_13768_n ) capacitor c=0.0130503f \
 //x=79.62 //y=6.92 //x2=81.2 //y2=6.92
cc_7961 ( N_noxref_33_c_13615_n N_noxref_34_c_13731_n ) capacitor \
 c=2.01769e-19 //x=79.62 //y=6.92 //x2=82.08 //y2=7.09
cc_7962 ( N_noxref_33_c_13570_n N_noxref_34_c_13744_n ) capacitor \
 c=0.00238961f //x=77.745 //y=5.39 //x2=78.3 //y2=5.56
cc_7963 ( N_noxref_33_c_13588_n N_noxref_34_c_13744_n ) capacitor \
 c=0.00406191f //x=78.62 //y=7.09 //x2=78.3 //y2=5.56
cc_7964 ( N_noxref_33_c_13606_n N_noxref_34_c_13744_n ) capacitor c=0.0651197f \
 //x=77.86 //y=5.39 //x2=78.3 //y2=5.56
cc_7965 ( N_noxref_33_M147_noxref_d N_noxref_34_c_13744_n ) capacitor \
 c=0.0479141f //x=78.595 //y=5.205 //x2=78.3 //y2=5.56
cc_7966 ( N_noxref_33_M149_noxref_d N_noxref_34_c_13733_n ) capacitor \
 c=0.00143256f //x=79.475 //y=5.205 //x2=81.2 //y2=5.39
cc_7967 ( N_noxref_33_c_13594_n N_GND_c_14313_n ) capacitor c=0.00115718f \
 //x=74.982 //y=5.39 //x2=74.93 //y2=1.015
cc_7968 ( N_noxref_33_c_13570_n N_GND_c_14338_n ) capacitor c=0.00146427f \
 //x=77.745 //y=5.39 //x2=77.08 //y2=0.175
cc_7969 ( N_noxref_33_c_13612_n noxref_56 ) capacitor c=0.00419873f //x=79.505 \
 //y=7.09 //x2=79.035 //y2=5.205
cc_7970 ( N_noxref_33_M147_noxref_d noxref_56 ) capacitor c=0.0489565f \
 //x=78.595 //y=5.205 //x2=79.035 //y2=5.205
cc_7971 ( N_noxref_33_M149_noxref_d noxref_56 ) capacitor c=0.0489382f \
 //x=79.475 //y=5.205 //x2=79.035 //y2=5.205
cc_7972 ( N_noxref_33_c_13606_n N_noxref_57_c_16804_n ) capacitor \
 c=0.00111217f //x=77.86 //y=5.39 //x2=77.775 //y2=1.675
cc_7973 ( N_noxref_34_c_13729_n N_GND_c_14753_n ) capacitor c=2.10485e-19 \
 //x=78.3 //y=5.39 //x2=78.26 //y2=1.015
cc_7974 ( N_noxref_34_c_13725_n N_GND_c_14342_n ) capacitor c=0.00146427f \
 //x=81.085 //y=5.39 //x2=80.41 //y2=0.175
cc_7975 ( N_noxref_34_c_13730_n noxref_56 ) capacitor c=0.0218948f //x=79.18 \
 //y=5.39 //x2=79.035 //y2=5.205
cc_7976 ( N_noxref_34_c_13744_n noxref_56 ) capacitor c=0.00561178f //x=78.3 \
 //y=5.56 //x2=79.035 //y2=5.205
cc_7977 ( N_GND_c_14343_n N_Q_c_15529_n ) capacitor c=0.00272952f //x=83.74 \
 //y=0.175 //x2=84.85 //y2=1.935
cc_7978 ( N_GND_c_14890_n N_Q_c_15529_n ) capacitor c=0.00122336f //x=85.34 \
 //y=0.175 //x2=84.85 //y2=1.935
cc_7979 ( N_GND_M51_noxref_s N_Q_c_15529_n ) capacitor c=0.0325498f //x=84.235 \
 //y=0.55 //x2=84.85 //y2=1.935
cc_7980 ( N_GND_c_14316_n N_Q_c_15542_n ) capacitor c=0.00497604f //x=85.22 \
 //y=0.18 //x2=85.135 //y2=2.02
cc_7981 ( N_GND_c_14875_n N_Q_c_15542_n ) capacitor c=0.00321695f //x=85.255 \
 //y=0.715 //x2=85.135 //y2=2.02
cc_7982 ( N_GND_c_14890_n N_Q_c_15542_n ) capacitor c=0.030726f //x=85.34 \
 //y=0.175 //x2=85.135 //y2=2.02
cc_7983 ( N_GND_M51_noxref_s N_Q_c_15542_n ) capacitor c=0.00565821f \
 //x=84.235 //y=0.55 //x2=85.135 //y2=2.02
cc_7984 ( N_GND_c_14801_n N_Q_c_15549_n ) capacitor c=0.00306788f //x=81.59 \
 //y=1.02 //x2=84.85 //y2=1.185
cc_7985 ( N_GND_c_14316_n N_Q_c_15549_n ) capacitor c=0.00998676f //x=85.22 \
 //y=0.18 //x2=84.85 //y2=1.185
cc_7986 ( N_GND_c_14871_n N_Q_c_15549_n ) capacitor c=0.00124813f //x=84.765 \
 //y=0.715 //x2=84.85 //y2=1.185
cc_7987 ( N_GND_c_14875_n N_Q_c_15549_n ) capacitor c=0.00130539f //x=85.255 \
 //y=0.715 //x2=84.85 //y2=1.185
cc_7988 ( N_GND_M51_noxref_s N_Q_c_15549_n ) capacitor c=0.0161656f //x=84.235 \
 //y=0.55 //x2=84.85 //y2=1.185
cc_7989 ( N_GND_c_14316_n N_Q_M51_noxref_d ) capacitor c=0.00119455f //x=85.22 \
 //y=0.18 //x2=84.665 //y2=1.09
cc_7990 ( N_GND_M51_noxref_s N_Q_M51_noxref_d ) capacitor c=0.0377642f \
 //x=84.235 //y=0.55 //x2=84.665 //y2=1.09
cc_7991 ( N_GND_c_14346_n N_noxref_37_c_15619_n ) capacitor c=0.00267414f \
 //x=1.585 //y=0.175 //x2=2.07 //y2=1.76
cc_7992 ( N_GND_c_13858_n N_noxref_37_c_15619_n ) capacitor c=7.45647e-19 \
 //x=4.81 //y=0.175 //x2=2.07 //y2=1.76
cc_7993 ( N_GND_c_13871_n N_noxref_37_c_15619_n ) capacitor c=0.00375327f \
 //x=1.67 //y=1.135 //x2=2.07 //y2=1.76
cc_7994 ( N_GND_c_13896_n N_noxref_37_c_15619_n ) capacitor c=0.00375345f \
 //x=3.65 //y=0.175 //x2=2.07 //y2=1.76
cc_7995 ( N_GND_M0_noxref_d N_noxref_37_c_15619_n ) capacitor c=0.00578453f \
 //x=1.48 //y=1.045 //x2=2.07 //y2=1.76
cc_7996 ( N_GND_c_13858_n N_noxref_37_c_15638_n ) capacitor c=0.00645992f \
 //x=4.81 //y=0.175 //x2=2.155 //y2=0.795
cc_7997 ( N_GND_c_14359_n N_noxref_37_c_15638_n ) capacitor c=0.0119573f \
 //x=1.667 //y=1.005 //x2=2.155 //y2=0.795
cc_7998 ( N_GND_c_13896_n N_noxref_37_c_15638_n ) capacitor c=0.0146605f \
 //x=3.65 //y=0.175 //x2=2.155 //y2=0.795
cc_7999 ( N_GND_c_13898_n N_noxref_37_c_15638_n ) capacitor c=0.00283128f \
 //x=1.23 //y=0.18 //x2=2.155 //y2=0.795
cc_8000 ( N_GND_c_13902_n N_noxref_37_c_15638_n ) capacitor c=2.99181e-19 \
 //x=3.82 //y=0.175 //x2=2.155 //y2=0.795
cc_8001 ( N_GND_c_13898_n N_noxref_37_c_15596_n ) capacitor c=2.85935e-19 \
 //x=1.23 //y=0.18 //x2=2.155 //y2=1.675
cc_8002 ( N_GND_c_13858_n N_noxref_37_c_15597_n ) capacitor c=0.00974619f \
 //x=4.81 //y=0.175 //x2=3.04 //y2=0.71
cc_8003 ( N_GND_c_13896_n N_noxref_37_c_15597_n ) capacitor c=0.0374826f \
 //x=3.65 //y=0.175 //x2=3.04 //y2=0.71
cc_8004 ( N_GND_c_13858_n N_noxref_37_c_15646_n ) capacitor c=0.00245021f \
 //x=4.81 //y=0.175 //x2=3.125 //y2=0.795
cc_8005 ( N_GND_c_13896_n N_noxref_37_c_15646_n ) capacitor c=0.0145368f \
 //x=3.65 //y=0.175 //x2=3.125 //y2=0.795
cc_8006 ( N_GND_c_13902_n N_noxref_37_c_15646_n ) capacitor c=0.0396774f \
 //x=3.82 //y=0.175 //x2=3.125 //y2=0.795
cc_8007 ( N_GND_c_14346_n N_noxref_37_M0_noxref_s ) capacitor c=0.00724992f \
 //x=1.585 //y=0.175 //x2=1.05 //y2=0.545
cc_8008 ( N_GND_c_13871_n N_noxref_37_M0_noxref_s ) capacitor c=0.0113621f \
 //x=1.67 //y=1.135 //x2=1.05 //y2=0.545
cc_8009 ( N_GND_c_14359_n N_noxref_37_M0_noxref_s ) capacitor c=0.0170608f \
 //x=1.667 //y=1.005 //x2=1.05 //y2=0.545
cc_8010 ( N_GND_c_13896_n N_noxref_37_M0_noxref_s ) capacitor c=0.014661f \
 //x=3.65 //y=0.175 //x2=1.05 //y2=0.545
cc_8011 ( N_GND_c_13898_n N_noxref_37_M0_noxref_s ) capacitor c=0.0559891f \
 //x=1.23 //y=0.18 //x2=1.05 //y2=0.545
cc_8012 ( N_GND_c_13902_n N_noxref_37_M0_noxref_s ) capacitor c=0.00648062f \
 //x=3.82 //y=0.175 //x2=1.05 //y2=0.545
cc_8013 ( N_GND_M0_noxref_d N_noxref_37_M0_noxref_s ) capacitor c=0.0271276f \
 //x=1.48 //y=1.045 //x2=1.05 //y2=0.545
cc_8014 ( N_GND_c_13858_n N_noxref_38_c_15661_n ) capacitor c=0.0011329f \
 //x=4.81 //y=0.175 //x2=5.295 //y2=1.77
cc_8015 ( N_GND_c_13867_n N_noxref_38_c_15661_n ) capacitor c=6.52594e-19 \
 //x=9.62 //y=0.175 //x2=5.295 //y2=1.77
cc_8016 ( N_GND_c_13873_n N_noxref_38_c_15661_n ) capacitor c=0.00354861f \
 //x=4.895 //y=1.145 //x2=5.295 //y2=1.77
cc_8017 ( N_GND_c_13900_n N_noxref_38_c_15661_n ) capacitor c=0.00392315f \
 //x=8.46 //y=0.175 //x2=5.295 //y2=1.77
cc_8018 ( N_GND_M2_noxref_d N_noxref_38_c_15661_n ) capacitor c=0.00578031f \
 //x=4.705 //y=1.055 //x2=5.295 //y2=1.77
cc_8019 ( N_GND_c_13864_n N_noxref_38_c_15686_n ) capacitor c=0.0169052f \
 //x=4.895 //y=1.015 //x2=5.38 //y2=0.805
cc_8020 ( N_GND_c_13867_n N_noxref_38_c_15686_n ) capacitor c=0.00439789f \
 //x=9.62 //y=0.175 //x2=5.38 //y2=0.805
cc_8021 ( N_GND_c_13900_n N_noxref_38_c_15686_n ) capacitor c=0.0142396f \
 //x=8.46 //y=0.175 //x2=5.38 //y2=0.805
cc_8022 ( N_GND_c_13902_n N_noxref_38_c_15686_n ) capacitor c=0.00322442f \
 //x=3.82 //y=0.175 //x2=5.38 //y2=0.805
cc_8023 ( N_GND_c_13867_n N_noxref_38_c_15676_n ) capacitor c=0.0124077f \
 //x=9.62 //y=0.175 //x2=6.265 //y2=0.72
cc_8024 ( N_GND_c_13900_n N_noxref_38_c_15676_n ) capacitor c=0.0361782f \
 //x=8.46 //y=0.175 //x2=6.265 //y2=0.72
cc_8025 ( N_GND_c_13858_n N_noxref_38_M2_noxref_s ) capacitor c=0.00439789f \
 //x=4.81 //y=0.175 //x2=4.275 //y2=0.555
cc_8026 ( N_GND_c_13864_n N_noxref_38_M2_noxref_s ) capacitor c=0.0125586f \
 //x=4.895 //y=1.015 //x2=4.275 //y2=0.555
cc_8027 ( N_GND_c_13867_n N_noxref_38_M2_noxref_s ) capacitor c=0.0044479f \
 //x=9.62 //y=0.175 //x2=4.275 //y2=0.555
cc_8028 ( N_GND_c_13873_n N_noxref_38_M2_noxref_s ) capacitor c=0.00972044f \
 //x=4.895 //y=1.145 //x2=4.275 //y2=0.555
cc_8029 ( N_GND_c_13900_n N_noxref_38_M2_noxref_s ) capacitor c=0.0275237f \
 //x=8.46 //y=0.175 //x2=4.275 //y2=0.555
cc_8030 ( N_GND_c_13902_n N_noxref_38_M2_noxref_s ) capacitor c=0.0624873f \
 //x=3.82 //y=0.175 //x2=4.275 //y2=0.555
cc_8031 ( N_GND_c_13914_n N_noxref_38_M2_noxref_s ) capacitor c=0.00166413f \
 //x=8.63 //y=0.175 //x2=4.275 //y2=0.555
cc_8032 ( N_GND_M2_noxref_d N_noxref_38_M2_noxref_s ) capacitor c=0.0271316f \
 //x=4.705 //y=1.055 //x2=4.275 //y2=0.555
cc_8033 ( N_GND_c_13867_n N_noxref_39_c_15720_n ) capacitor c=0.0011329f \
 //x=9.62 //y=0.175 //x2=10.105 //y2=1.77
cc_8034 ( N_GND_c_13937_n N_noxref_39_c_15720_n ) capacitor c=7.40908e-19 \
 //x=14.535 //y=0.175 //x2=10.105 //y2=1.77
cc_8035 ( N_GND_c_13885_n N_noxref_39_c_15720_n ) capacitor c=0.00350567f \
 //x=9.705 //y=1.145 //x2=10.105 //y2=1.77
cc_8036 ( N_GND_c_13901_n N_noxref_39_c_15720_n ) capacitor c=0.00390822f \
 //x=13.27 //y=0.175 //x2=10.105 //y2=1.77
cc_8037 ( N_GND_M5_noxref_d N_noxref_39_c_15720_n ) capacitor c=0.00578031f \
 //x=9.515 //y=1.055 //x2=10.105 //y2=1.77
cc_8038 ( N_GND_c_13868_n N_noxref_39_c_15748_n ) capacitor c=0.0169052f \
 //x=9.705 //y=1.015 //x2=10.19 //y2=0.805
cc_8039 ( N_GND_c_13937_n N_noxref_39_c_15748_n ) capacitor c=0.00710913f \
 //x=14.535 //y=0.175 //x2=10.19 //y2=0.805
cc_8040 ( N_GND_c_13901_n N_noxref_39_c_15748_n ) capacitor c=0.0140604f \
 //x=13.27 //y=0.175 //x2=10.19 //y2=0.805
cc_8041 ( N_GND_c_13914_n N_noxref_39_c_15748_n ) capacitor c=0.00322478f \
 //x=8.63 //y=0.175 //x2=10.19 //y2=0.805
cc_8042 ( N_GND_c_13937_n N_noxref_39_c_15735_n ) capacitor c=0.0122813f \
 //x=14.535 //y=0.175 //x2=11.075 //y2=0.72
cc_8043 ( N_GND_c_13901_n N_noxref_39_c_15735_n ) capacitor c=0.0358801f \
 //x=13.27 //y=0.175 //x2=11.075 //y2=0.72
cc_8044 ( N_GND_c_13867_n N_noxref_39_M5_noxref_s ) capacitor c=0.00439789f \
 //x=9.62 //y=0.175 //x2=9.085 //y2=0.555
cc_8045 ( N_GND_c_13868_n N_noxref_39_M5_noxref_s ) capacitor c=0.0173062f \
 //x=9.705 //y=1.015 //x2=9.085 //y2=0.555
cc_8046 ( N_GND_c_13937_n N_noxref_39_M5_noxref_s ) capacitor c=0.0044479f \
 //x=14.535 //y=0.175 //x2=9.085 //y2=0.555
cc_8047 ( N_GND_c_13885_n N_noxref_39_M5_noxref_s ) capacitor c=0.00988958f \
 //x=9.705 //y=1.145 //x2=9.085 //y2=0.555
cc_8048 ( N_GND_c_13901_n N_noxref_39_M5_noxref_s ) capacitor c=0.0274451f \
 //x=13.27 //y=0.175 //x2=9.085 //y2=0.555
cc_8049 ( N_GND_c_13914_n N_noxref_39_M5_noxref_s ) capacitor c=0.0634633f \
 //x=8.63 //y=0.175 //x2=9.085 //y2=0.555
cc_8050 ( N_GND_c_13958_n N_noxref_39_M5_noxref_s ) capacitor c=0.00166451f \
 //x=13.44 //y=0.175 //x2=9.085 //y2=0.555
cc_8051 ( N_GND_M5_noxref_d N_noxref_39_M5_noxref_s ) capacitor c=0.0271316f \
 //x=9.515 //y=1.055 //x2=9.085 //y2=0.555
cc_8052 ( N_GND_c_13937_n N_noxref_40_c_15778_n ) capacitor c=9.58019e-19 \
 //x=14.535 //y=0.175 //x2=15.02 //y2=1.76
cc_8053 ( N_GND_c_14058_n N_noxref_40_c_15778_n ) capacitor c=7.45647e-19 \
 //x=17.865 //y=0.175 //x2=15.02 //y2=1.76
cc_8054 ( N_GND_c_13941_n N_noxref_40_c_15778_n ) capacitor c=0.00396941f \
 //x=14.62 //y=1.135 //x2=15.02 //y2=1.76
cc_8055 ( N_GND_c_13957_n N_noxref_40_c_15778_n ) capacitor c=0.00395774f \
 //x=16.6 //y=0.175 //x2=15.02 //y2=1.76
cc_8056 ( N_GND_M8_noxref_d N_noxref_40_c_15778_n ) capacitor c=0.00578453f \
 //x=14.43 //y=1.045 //x2=15.02 //y2=1.76
cc_8057 ( N_GND_c_14058_n N_noxref_40_c_15822_n ) capacitor c=0.0042561f \
 //x=17.865 //y=0.175 //x2=15.105 //y2=0.795
cc_8058 ( N_GND_c_13952_n N_noxref_40_c_15822_n ) capacitor c=0.0120153f \
 //x=14.617 //y=1.005 //x2=15.105 //y2=0.795
cc_8059 ( N_GND_c_13957_n N_noxref_40_c_15822_n ) capacitor c=0.0147548f \
 //x=16.6 //y=0.175 //x2=15.105 //y2=0.795
cc_8060 ( N_GND_c_13958_n N_noxref_40_c_15822_n ) capacitor c=0.00282583f \
 //x=13.44 //y=0.175 //x2=15.105 //y2=0.795
cc_8061 ( N_GND_c_13971_n N_noxref_40_c_15822_n ) capacitor c=2.99356e-19 \
 //x=16.77 //y=0.175 //x2=15.105 //y2=0.795
cc_8062 ( N_GND_c_13958_n N_noxref_40_c_15785_n ) capacitor c=2.8386e-19 \
 //x=13.44 //y=0.175 //x2=15.105 //y2=1.675
cc_8063 ( N_GND_c_14058_n N_noxref_40_c_15790_n ) capacitor c=0.00979428f \
 //x=17.865 //y=0.175 //x2=15.99 //y2=0.71
cc_8064 ( N_GND_c_13957_n N_noxref_40_c_15790_n ) capacitor c=0.0375602f \
 //x=16.6 //y=0.175 //x2=15.99 //y2=0.71
cc_8065 ( N_GND_c_14058_n N_noxref_40_c_15830_n ) capacitor c=0.00253402f \
 //x=17.865 //y=0.175 //x2=16.075 //y2=0.795
cc_8066 ( N_GND_c_13957_n N_noxref_40_c_15830_n ) capacitor c=0.0145307f \
 //x=16.6 //y=0.175 //x2=16.075 //y2=0.795
cc_8067 ( N_GND_c_13971_n N_noxref_40_c_15830_n ) capacitor c=0.0392026f \
 //x=16.77 //y=0.175 //x2=16.075 //y2=0.795
cc_8068 ( N_GND_c_13937_n N_noxref_40_M8_noxref_s ) capacitor c=0.0045077f \
 //x=14.535 //y=0.175 //x2=14 //y2=0.545
cc_8069 ( N_GND_c_13941_n N_noxref_40_M8_noxref_s ) capacitor c=0.0100997f \
 //x=14.62 //y=1.135 //x2=14 //y2=0.545
cc_8070 ( N_GND_c_13952_n N_noxref_40_M8_noxref_s ) capacitor c=0.0170652f \
 //x=14.617 //y=1.005 //x2=14 //y2=0.545
cc_8071 ( N_GND_c_13957_n N_noxref_40_M8_noxref_s ) capacitor c=0.0147643f \
 //x=16.6 //y=0.175 //x2=14 //y2=0.545
cc_8072 ( N_GND_c_13958_n N_noxref_40_M8_noxref_s ) capacitor c=0.0528206f \
 //x=13.44 //y=0.175 //x2=14 //y2=0.545
cc_8073 ( N_GND_c_13971_n N_noxref_40_M8_noxref_s ) capacitor c=0.0064811f \
 //x=16.77 //y=0.175 //x2=14 //y2=0.545
cc_8074 ( N_GND_M8_noxref_d N_noxref_40_M8_noxref_s ) capacitor c=0.0271276f \
 //x=14.43 //y=1.045 //x2=14 //y2=0.545
cc_8075 ( N_GND_c_14058_n N_noxref_41_c_15844_n ) capacitor c=9.98096e-19 \
 //x=17.865 //y=0.175 //x2=18.35 //y2=1.76
cc_8076 ( N_GND_c_14017_n N_noxref_41_c_15844_n ) capacitor c=7.45647e-19 \
 //x=21.09 //y=0.175 //x2=18.35 //y2=1.76
cc_8077 ( N_GND_c_13985_n N_noxref_41_c_15844_n ) capacitor c=0.00402812f \
 //x=17.95 //y=1.135 //x2=18.35 //y2=1.76
cc_8078 ( N_GND_c_13999_n N_noxref_41_c_15844_n ) capacitor c=0.00395774f \
 //x=19.93 //y=0.175 //x2=18.35 //y2=1.76
cc_8079 ( N_GND_M10_noxref_d N_noxref_41_c_15844_n ) capacitor c=0.00578453f \
 //x=17.76 //y=1.045 //x2=18.35 //y2=1.76
cc_8080 ( N_GND_c_14017_n N_noxref_41_c_15888_n ) capacitor c=0.00390888f \
 //x=21.09 //y=0.175 //x2=18.435 //y2=0.795
cc_8081 ( N_GND_c_13994_n N_noxref_41_c_15888_n ) capacitor c=0.0119573f \
 //x=17.947 //y=1.005 //x2=18.435 //y2=0.795
cc_8082 ( N_GND_c_13999_n N_noxref_41_c_15888_n ) capacitor c=0.0147548f \
 //x=19.93 //y=0.175 //x2=18.435 //y2=0.795
cc_8083 ( N_GND_c_13971_n N_noxref_41_c_15888_n ) capacitor c=0.00282552f \
 //x=16.77 //y=0.175 //x2=18.435 //y2=0.795
cc_8084 ( N_GND_c_14041_n N_noxref_41_c_15888_n ) capacitor c=2.99181e-19 \
 //x=20.1 //y=0.175 //x2=18.435 //y2=0.795
cc_8085 ( N_GND_c_13971_n N_noxref_41_c_15851_n ) capacitor c=2.8386e-19 \
 //x=16.77 //y=0.175 //x2=18.435 //y2=1.675
cc_8086 ( N_GND_c_14017_n N_noxref_41_c_15856_n ) capacitor c=0.00969879f \
 //x=21.09 //y=0.175 //x2=19.32 //y2=0.71
cc_8087 ( N_GND_c_13999_n N_noxref_41_c_15856_n ) capacitor c=0.0375602f \
 //x=19.93 //y=0.175 //x2=19.32 //y2=0.71
cc_8088 ( N_GND_c_14017_n N_noxref_41_c_15896_n ) capacitor c=0.00256023f \
 //x=21.09 //y=0.175 //x2=19.405 //y2=0.795
cc_8089 ( N_GND_c_13999_n N_noxref_41_c_15896_n ) capacitor c=0.0145307f \
 //x=19.93 //y=0.175 //x2=19.405 //y2=0.795
cc_8090 ( N_GND_c_14041_n N_noxref_41_c_15896_n ) capacitor c=0.0396774f \
 //x=20.1 //y=0.175 //x2=19.405 //y2=0.795
cc_8091 ( N_GND_c_14058_n N_noxref_41_M10_noxref_s ) capacitor c=0.0045077f \
 //x=17.865 //y=0.175 //x2=17.33 //y2=0.545
cc_8092 ( N_GND_c_13985_n N_noxref_41_M10_noxref_s ) capacitor c=0.00990843f \
 //x=17.95 //y=1.135 //x2=17.33 //y2=0.545
cc_8093 ( N_GND_c_13994_n N_noxref_41_M10_noxref_s ) capacitor c=0.0123717f \
 //x=17.947 //y=1.005 //x2=17.33 //y2=0.545
cc_8094 ( N_GND_c_13999_n N_noxref_41_M10_noxref_s ) capacitor c=0.0147643f \
 //x=19.93 //y=0.175 //x2=17.33 //y2=0.545
cc_8095 ( N_GND_c_13971_n N_noxref_41_M10_noxref_s ) capacitor c=0.0518718f \
 //x=16.77 //y=0.175 //x2=17.33 //y2=0.545
cc_8096 ( N_GND_c_14041_n N_noxref_41_M10_noxref_s ) capacitor c=0.00648063f \
 //x=20.1 //y=0.175 //x2=17.33 //y2=0.545
cc_8097 ( N_GND_M10_noxref_d N_noxref_41_M10_noxref_s ) capacitor c=0.0271276f \
 //x=17.76 //y=1.045 //x2=17.33 //y2=0.545
cc_8098 ( N_GND_c_14017_n N_noxref_42_c_15913_n ) capacitor c=0.0011329f \
 //x=21.09 //y=0.175 //x2=21.575 //y2=1.77
cc_8099 ( N_GND_c_14061_n N_noxref_42_c_15913_n ) capacitor c=7.40908e-19 \
 //x=26.005 //y=0.175 //x2=21.575 //y2=1.77
cc_8100 ( N_GND_c_14027_n N_noxref_42_c_15913_n ) capacitor c=0.00375743f \
 //x=21.175 //y=1.145 //x2=21.575 //y2=1.77
cc_8101 ( N_GND_c_14039_n N_noxref_42_c_15913_n ) capacitor c=0.00392232f \
 //x=24.74 //y=0.175 //x2=21.575 //y2=1.77
cc_8102 ( N_GND_M12_noxref_d N_noxref_42_c_15913_n ) capacitor c=0.00578031f \
 //x=20.985 //y=1.055 //x2=21.575 //y2=1.77
cc_8103 ( N_GND_c_14021_n N_noxref_42_c_15939_n ) capacitor c=0.0169052f \
 //x=21.175 //y=1.015 //x2=21.66 //y2=0.805
cc_8104 ( N_GND_c_14061_n N_noxref_42_c_15939_n ) capacitor c=0.00439789f \
 //x=26.005 //y=0.175 //x2=21.66 //y2=0.805
cc_8105 ( N_GND_c_14039_n N_noxref_42_c_15939_n ) capacitor c=0.0141638f \
 //x=24.74 //y=0.175 //x2=21.66 //y2=0.805
cc_8106 ( N_GND_c_14041_n N_noxref_42_c_15939_n ) capacitor c=0.00322442f \
 //x=20.1 //y=0.175 //x2=21.66 //y2=0.805
cc_8107 ( N_GND_c_14061_n N_noxref_42_c_15926_n ) capacitor c=0.0123748f \
 //x=26.005 //y=0.175 //x2=22.545 //y2=0.72
cc_8108 ( N_GND_c_14039_n N_noxref_42_c_15926_n ) capacitor c=0.0361346f \
 //x=24.74 //y=0.175 //x2=22.545 //y2=0.72
cc_8109 ( N_GND_c_14017_n N_noxref_42_M12_noxref_s ) capacitor c=0.00439789f \
 //x=21.09 //y=0.175 //x2=20.555 //y2=0.555
cc_8110 ( N_GND_c_14021_n N_noxref_42_M12_noxref_s ) capacitor c=0.0125586f \
 //x=21.175 //y=1.015 //x2=20.555 //y2=0.555
cc_8111 ( N_GND_c_14061_n N_noxref_42_M12_noxref_s ) capacitor c=0.0044479f \
 //x=26.005 //y=0.175 //x2=20.555 //y2=0.555
cc_8112 ( N_GND_c_14027_n N_noxref_42_M12_noxref_s ) capacitor c=0.00972044f \
 //x=21.175 //y=1.145 //x2=20.555 //y2=0.555
cc_8113 ( N_GND_c_14039_n N_noxref_42_M12_noxref_s ) capacitor c=0.0273693f \
 //x=24.74 //y=0.175 //x2=20.555 //y2=0.555
cc_8114 ( N_GND_c_14041_n N_noxref_42_M12_noxref_s ) capacitor c=0.0624873f \
 //x=20.1 //y=0.175 //x2=20.555 //y2=0.555
cc_8115 ( N_GND_c_14078_n N_noxref_42_M12_noxref_s ) capacitor c=0.00166451f \
 //x=24.91 //y=0.175 //x2=20.555 //y2=0.555
cc_8116 ( N_GND_M12_noxref_d N_noxref_42_M12_noxref_s ) capacitor c=0.0271316f \
 //x=20.985 //y=1.055 //x2=20.555 //y2=0.555
cc_8117 ( N_GND_c_14061_n N_noxref_43_c_15994_n ) capacitor c=0.0011359f \
 //x=26.005 //y=0.175 //x2=26.49 //y2=1.76
cc_8118 ( N_GND_c_14081_n N_noxref_43_c_15994_n ) capacitor c=7.45647e-19 \
 //x=29.23 //y=0.175 //x2=26.49 //y2=1.76
cc_8119 ( N_GND_c_14091_n N_noxref_43_c_15994_n ) capacitor c=0.00375089f \
 //x=26.09 //y=1.135 //x2=26.49 //y2=1.76
cc_8120 ( N_GND_c_14114_n N_noxref_43_c_15994_n ) capacitor c=0.00395774f \
 //x=28.07 //y=0.175 //x2=26.49 //y2=1.76
cc_8121 ( N_GND_M15_noxref_d N_noxref_43_c_15994_n ) capacitor c=0.00578453f \
 //x=25.9 //y=1.045 //x2=26.49 //y2=1.76
cc_8122 ( N_GND_c_14081_n N_noxref_43_c_16017_n ) capacitor c=0.00395967f \
 //x=29.23 //y=0.175 //x2=26.575 //y2=0.795
cc_8123 ( N_GND_c_14372_n N_noxref_43_c_16017_n ) capacitor c=0.0119573f \
 //x=26.087 //y=1.005 //x2=26.575 //y2=0.795
cc_8124 ( N_GND_c_14114_n N_noxref_43_c_16017_n ) capacitor c=0.0147548f \
 //x=28.07 //y=0.175 //x2=26.575 //y2=0.795
cc_8125 ( N_GND_c_14078_n N_noxref_43_c_16017_n ) capacitor c=0.00282583f \
 //x=24.91 //y=0.175 //x2=26.575 //y2=0.795
cc_8126 ( N_GND_c_14120_n N_noxref_43_c_16017_n ) capacitor c=2.99181e-19 \
 //x=28.24 //y=0.175 //x2=26.575 //y2=0.795
cc_8127 ( N_GND_c_14078_n N_noxref_43_c_15971_n ) capacitor c=2.8386e-19 \
 //x=24.91 //y=0.175 //x2=26.575 //y2=1.675
cc_8128 ( N_GND_c_14081_n N_noxref_43_c_15972_n ) capacitor c=0.00974619f \
 //x=29.23 //y=0.175 //x2=27.46 //y2=0.71
cc_8129 ( N_GND_c_14114_n N_noxref_43_c_15972_n ) capacitor c=0.0374826f \
 //x=28.07 //y=0.175 //x2=27.46 //y2=0.71
cc_8130 ( N_GND_c_14081_n N_noxref_43_c_16025_n ) capacitor c=0.00245021f \
 //x=29.23 //y=0.175 //x2=27.545 //y2=0.795
cc_8131 ( N_GND_c_14114_n N_noxref_43_c_16025_n ) capacitor c=0.0145298f \
 //x=28.07 //y=0.175 //x2=27.545 //y2=0.795
cc_8132 ( N_GND_c_14120_n N_noxref_43_c_16025_n ) capacitor c=0.0396774f \
 //x=28.24 //y=0.175 //x2=27.545 //y2=0.795
cc_8133 ( N_GND_c_14061_n N_noxref_43_M15_noxref_s ) capacitor c=0.0045077f \
 //x=26.005 //y=0.175 //x2=25.47 //y2=0.545
cc_8134 ( N_GND_c_14091_n N_noxref_43_M15_noxref_s ) capacitor c=0.0100945f \
 //x=26.09 //y=1.135 //x2=25.47 //y2=0.545
cc_8135 ( N_GND_c_14372_n N_noxref_43_M15_noxref_s ) capacitor c=0.0170608f \
 //x=26.087 //y=1.005 //x2=25.47 //y2=0.545
cc_8136 ( N_GND_c_14114_n N_noxref_43_M15_noxref_s ) capacitor c=0.0147643f \
 //x=28.07 //y=0.175 //x2=25.47 //y2=0.545
cc_8137 ( N_GND_c_14078_n N_noxref_43_M15_noxref_s ) capacitor c=0.0528206f \
 //x=24.91 //y=0.175 //x2=25.47 //y2=0.545
cc_8138 ( N_GND_c_14120_n N_noxref_43_M15_noxref_s ) capacitor c=0.00648063f \
 //x=28.24 //y=0.175 //x2=25.47 //y2=0.545
cc_8139 ( N_GND_M15_noxref_d N_noxref_43_M15_noxref_s ) capacitor c=0.0271276f \
 //x=25.9 //y=1.045 //x2=25.47 //y2=0.545
cc_8140 ( N_GND_c_14081_n N_noxref_44_c_16039_n ) capacitor c=0.0011329f \
 //x=29.23 //y=0.175 //x2=29.715 //y2=1.77
cc_8141 ( N_GND_c_14198_n N_noxref_44_c_16039_n ) capacitor c=6.52594e-19 \
 //x=34.04 //y=0.175 //x2=29.715 //y2=1.77
cc_8142 ( N_GND_c_14093_n N_noxref_44_c_16039_n ) capacitor c=0.00354861f \
 //x=29.315 //y=1.145 //x2=29.715 //y2=1.77
cc_8143 ( N_GND_c_14116_n N_noxref_44_c_16039_n ) capacitor c=0.00392232f \
 //x=32.88 //y=0.175 //x2=29.715 //y2=1.77
cc_8144 ( N_GND_M17_noxref_d N_noxref_44_c_16039_n ) capacitor c=0.00578031f \
 //x=29.125 //y=1.055 //x2=29.715 //y2=1.77
cc_8145 ( N_GND_c_14085_n N_noxref_44_c_16066_n ) capacitor c=0.0169052f \
 //x=29.315 //y=1.015 //x2=29.8 //y2=0.805
cc_8146 ( N_GND_c_14198_n N_noxref_44_c_16066_n ) capacitor c=0.00439789f \
 //x=34.04 //y=0.175 //x2=29.8 //y2=0.805
cc_8147 ( N_GND_c_14116_n N_noxref_44_c_16066_n ) capacitor c=0.0141638f \
 //x=32.88 //y=0.175 //x2=29.8 //y2=0.805
cc_8148 ( N_GND_c_14120_n N_noxref_44_c_16066_n ) capacitor c=0.00322442f \
 //x=28.24 //y=0.175 //x2=29.8 //y2=0.805
cc_8149 ( N_GND_c_14198_n N_noxref_44_c_16050_n ) capacitor c=0.0124077f \
 //x=34.04 //y=0.175 //x2=30.685 //y2=0.72
cc_8150 ( N_GND_c_14116_n N_noxref_44_c_16050_n ) capacitor c=0.0361346f \
 //x=32.88 //y=0.175 //x2=30.685 //y2=0.72
cc_8151 ( N_GND_c_14081_n N_noxref_44_M17_noxref_s ) capacitor c=0.00439789f \
 //x=29.23 //y=0.175 //x2=28.695 //y2=0.555
cc_8152 ( N_GND_c_14085_n N_noxref_44_M17_noxref_s ) capacitor c=0.0125586f \
 //x=29.315 //y=1.015 //x2=28.695 //y2=0.555
cc_8153 ( N_GND_c_14198_n N_noxref_44_M17_noxref_s ) capacitor c=0.0044479f \
 //x=34.04 //y=0.175 //x2=28.695 //y2=0.555
cc_8154 ( N_GND_c_14093_n N_noxref_44_M17_noxref_s ) capacitor c=0.00972044f \
 //x=29.315 //y=1.145 //x2=28.695 //y2=0.555
cc_8155 ( N_GND_c_14116_n N_noxref_44_M17_noxref_s ) capacitor c=0.0273693f \
 //x=32.88 //y=0.175 //x2=28.695 //y2=0.555
cc_8156 ( N_GND_c_14120_n N_noxref_44_M17_noxref_s ) capacitor c=0.0624873f \
 //x=28.24 //y=0.175 //x2=28.695 //y2=0.555
cc_8157 ( N_GND_c_14132_n N_noxref_44_M17_noxref_s ) capacitor c=0.00166413f \
 //x=33.05 //y=0.175 //x2=28.695 //y2=0.555
cc_8158 ( N_GND_M17_noxref_d N_noxref_44_M17_noxref_s ) capacitor c=0.0271316f \
 //x=29.125 //y=1.055 //x2=28.695 //y2=0.555
cc_8159 ( N_GND_c_14198_n N_noxref_45_c_16099_n ) capacitor c=0.0011329f \
 //x=34.04 //y=0.175 //x2=34.525 //y2=1.77
cc_8160 ( N_GND_c_14155_n N_noxref_45_c_16099_n ) capacitor c=7.40908e-19 \
 //x=38.955 //y=0.175 //x2=34.525 //y2=1.77
cc_8161 ( N_GND_c_14104_n N_noxref_45_c_16099_n ) capacitor c=0.00350567f \
 //x=34.125 //y=1.145 //x2=34.525 //y2=1.77
cc_8162 ( N_GND_c_14117_n N_noxref_45_c_16099_n ) capacitor c=0.00392232f \
 //x=37.69 //y=0.175 //x2=34.525 //y2=1.77
cc_8163 ( N_GND_M20_noxref_d N_noxref_45_c_16099_n ) capacitor c=0.00578031f \
 //x=33.935 //y=1.055 //x2=34.525 //y2=1.77
cc_8164 ( N_GND_c_14088_n N_noxref_45_c_16129_n ) capacitor c=0.0169052f \
 //x=34.125 //y=1.015 //x2=34.61 //y2=0.805
cc_8165 ( N_GND_c_14155_n N_noxref_45_c_16129_n ) capacitor c=0.00439789f \
 //x=38.955 //y=0.175 //x2=34.61 //y2=0.805
cc_8166 ( N_GND_c_14117_n N_noxref_45_c_16129_n ) capacitor c=0.0141638f \
 //x=37.69 //y=0.175 //x2=34.61 //y2=0.805
cc_8167 ( N_GND_c_14132_n N_noxref_45_c_16129_n ) capacitor c=0.00322478f \
 //x=33.05 //y=0.175 //x2=34.61 //y2=0.805
cc_8168 ( N_GND_c_14155_n N_noxref_45_c_16114_n ) capacitor c=0.0122813f \
 //x=38.955 //y=0.175 //x2=35.495 //y2=0.72
cc_8169 ( N_GND_c_14117_n N_noxref_45_c_16114_n ) capacitor c=0.0361346f \
 //x=37.69 //y=0.175 //x2=35.495 //y2=0.72
cc_8170 ( N_GND_c_14198_n N_noxref_45_M20_noxref_s ) capacitor c=0.00439789f \
 //x=34.04 //y=0.175 //x2=33.505 //y2=0.555
cc_8171 ( N_GND_c_14088_n N_noxref_45_M20_noxref_s ) capacitor c=0.0173062f \
 //x=34.125 //y=1.015 //x2=33.505 //y2=0.555
cc_8172 ( N_GND_c_14155_n N_noxref_45_M20_noxref_s ) capacitor c=0.0044479f \
 //x=38.955 //y=0.175 //x2=33.505 //y2=0.555
cc_8173 ( N_GND_c_14104_n N_noxref_45_M20_noxref_s ) capacitor c=0.00988958f \
 //x=34.125 //y=1.145 //x2=33.505 //y2=0.555
cc_8174 ( N_GND_c_14117_n N_noxref_45_M20_noxref_s ) capacitor c=0.0273693f \
 //x=37.69 //y=0.175 //x2=33.505 //y2=0.555
cc_8175 ( N_GND_c_14132_n N_noxref_45_M20_noxref_s ) capacitor c=0.0634633f \
 //x=33.05 //y=0.175 //x2=33.505 //y2=0.555
cc_8176 ( N_GND_c_14176_n N_noxref_45_M20_noxref_s ) capacitor c=0.00166451f \
 //x=37.86 //y=0.175 //x2=33.505 //y2=0.555
cc_8177 ( N_GND_M20_noxref_d N_noxref_45_M20_noxref_s ) capacitor c=0.0271316f \
 //x=33.935 //y=1.055 //x2=33.505 //y2=0.555
cc_8178 ( N_GND_c_14155_n N_noxref_46_c_16159_n ) capacitor c=9.58019e-19 \
 //x=38.955 //y=0.175 //x2=39.44 //y2=1.76
cc_8179 ( N_GND_c_14284_n N_noxref_46_c_16159_n ) capacitor c=7.45647e-19 \
 //x=42.285 //y=0.175 //x2=39.44 //y2=1.76
cc_8180 ( N_GND_c_14159_n N_noxref_46_c_16159_n ) capacitor c=0.00396941f \
 //x=39.04 //y=1.135 //x2=39.44 //y2=1.76
cc_8181 ( N_GND_c_14175_n N_noxref_46_c_16159_n ) capacitor c=0.00395774f \
 //x=41.02 //y=0.175 //x2=39.44 //y2=1.76
cc_8182 ( N_GND_M23_noxref_d N_noxref_46_c_16159_n ) capacitor c=0.00578453f \
 //x=38.85 //y=1.045 //x2=39.44 //y2=1.76
cc_8183 ( N_GND_c_14284_n N_noxref_46_c_16203_n ) capacitor c=0.0042561f \
 //x=42.285 //y=0.175 //x2=39.525 //y2=0.795
cc_8184 ( N_GND_c_14170_n N_noxref_46_c_16203_n ) capacitor c=0.0120153f \
 //x=39.037 //y=1.005 //x2=39.525 //y2=0.795
cc_8185 ( N_GND_c_14175_n N_noxref_46_c_16203_n ) capacitor c=0.0147548f \
 //x=41.02 //y=0.175 //x2=39.525 //y2=0.795
cc_8186 ( N_GND_c_14176_n N_noxref_46_c_16203_n ) capacitor c=0.00282583f \
 //x=37.86 //y=0.175 //x2=39.525 //y2=0.795
cc_8187 ( N_GND_c_14189_n N_noxref_46_c_16203_n ) capacitor c=2.99356e-19 \
 //x=41.19 //y=0.175 //x2=39.525 //y2=0.795
cc_8188 ( N_GND_c_14176_n N_noxref_46_c_16166_n ) capacitor c=2.8386e-19 \
 //x=37.86 //y=0.175 //x2=39.525 //y2=1.675
cc_8189 ( N_GND_c_14284_n N_noxref_46_c_16171_n ) capacitor c=0.00979428f \
 //x=42.285 //y=0.175 //x2=40.41 //y2=0.71
cc_8190 ( N_GND_c_14175_n N_noxref_46_c_16171_n ) capacitor c=0.0375602f \
 //x=41.02 //y=0.175 //x2=40.41 //y2=0.71
cc_8191 ( N_GND_c_14284_n N_noxref_46_c_16211_n ) capacitor c=0.00253402f \
 //x=42.285 //y=0.175 //x2=40.495 //y2=0.795
cc_8192 ( N_GND_c_14175_n N_noxref_46_c_16211_n ) capacitor c=0.0145307f \
 //x=41.02 //y=0.175 //x2=40.495 //y2=0.795
cc_8193 ( N_GND_c_14189_n N_noxref_46_c_16211_n ) capacitor c=0.0392026f \
 //x=41.19 //y=0.175 //x2=40.495 //y2=0.795
cc_8194 ( N_GND_c_14155_n N_noxref_46_M23_noxref_s ) capacitor c=0.0045077f \
 //x=38.955 //y=0.175 //x2=38.42 //y2=0.545
cc_8195 ( N_GND_c_14159_n N_noxref_46_M23_noxref_s ) capacitor c=0.0100997f \
 //x=39.04 //y=1.135 //x2=38.42 //y2=0.545
cc_8196 ( N_GND_c_14170_n N_noxref_46_M23_noxref_s ) capacitor c=0.0170652f \
 //x=39.037 //y=1.005 //x2=38.42 //y2=0.545
cc_8197 ( N_GND_c_14175_n N_noxref_46_M23_noxref_s ) capacitor c=0.0147643f \
 //x=41.02 //y=0.175 //x2=38.42 //y2=0.545
cc_8198 ( N_GND_c_14176_n N_noxref_46_M23_noxref_s ) capacitor c=0.0528206f \
 //x=37.86 //y=0.175 //x2=38.42 //y2=0.545
cc_8199 ( N_GND_c_14189_n N_noxref_46_M23_noxref_s ) capacitor c=0.0064811f \
 //x=41.19 //y=0.175 //x2=38.42 //y2=0.545
cc_8200 ( N_GND_M23_noxref_d N_noxref_46_M23_noxref_s ) capacitor c=0.0271276f \
 //x=38.85 //y=1.045 //x2=38.42 //y2=0.545
cc_8201 ( N_GND_c_14284_n N_noxref_47_c_16225_n ) capacitor c=9.98096e-19 \
 //x=42.285 //y=0.175 //x2=42.77 //y2=1.76
cc_8202 ( N_GND_c_14235_n N_noxref_47_c_16225_n ) capacitor c=7.45647e-19 \
 //x=45.51 //y=0.175 //x2=42.77 //y2=1.76
cc_8203 ( N_GND_c_14203_n N_noxref_47_c_16225_n ) capacitor c=0.00402812f \
 //x=42.37 //y=1.135 //x2=42.77 //y2=1.76
cc_8204 ( N_GND_c_14217_n N_noxref_47_c_16225_n ) capacitor c=0.00395774f \
 //x=44.35 //y=0.175 //x2=42.77 //y2=1.76
cc_8205 ( N_GND_M25_noxref_d N_noxref_47_c_16225_n ) capacitor c=0.00578453f \
 //x=42.18 //y=1.045 //x2=42.77 //y2=1.76
cc_8206 ( N_GND_c_14235_n N_noxref_47_c_16268_n ) capacitor c=0.00387846f \
 //x=45.51 //y=0.175 //x2=42.855 //y2=0.795
cc_8207 ( N_GND_c_14212_n N_noxref_47_c_16268_n ) capacitor c=0.0119573f \
 //x=42.367 //y=1.005 //x2=42.855 //y2=0.795
cc_8208 ( N_GND_c_14217_n N_noxref_47_c_16268_n ) capacitor c=0.0147548f \
 //x=44.35 //y=0.175 //x2=42.855 //y2=0.795
cc_8209 ( N_GND_c_14189_n N_noxref_47_c_16268_n ) capacitor c=0.00282552f \
 //x=41.19 //y=0.175 //x2=42.855 //y2=0.795
cc_8210 ( N_GND_c_14261_n N_noxref_47_c_16268_n ) capacitor c=2.99181e-19 \
 //x=44.52 //y=0.175 //x2=42.855 //y2=0.795
cc_8211 ( N_GND_c_14189_n N_noxref_47_c_16232_n ) capacitor c=2.8386e-19 \
 //x=41.19 //y=0.175 //x2=42.855 //y2=1.675
cc_8212 ( N_GND_c_14235_n N_noxref_47_c_16237_n ) capacitor c=0.00974783f \
 //x=45.51 //y=0.175 //x2=43.74 //y2=0.71
cc_8213 ( N_GND_c_14217_n N_noxref_47_c_16237_n ) capacitor c=0.0374826f \
 //x=44.35 //y=0.175 //x2=43.74 //y2=0.71
cc_8214 ( N_GND_c_14235_n N_noxref_47_c_16276_n ) capacitor c=0.00245151f \
 //x=45.51 //y=0.175 //x2=43.825 //y2=0.795
cc_8215 ( N_GND_c_14217_n N_noxref_47_c_16276_n ) capacitor c=0.0145307f \
 //x=44.35 //y=0.175 //x2=43.825 //y2=0.795
cc_8216 ( N_GND_c_14261_n N_noxref_47_c_16276_n ) capacitor c=0.0396774f \
 //x=44.52 //y=0.175 //x2=43.825 //y2=0.795
cc_8217 ( N_GND_c_14284_n N_noxref_47_M25_noxref_s ) capacitor c=0.0045077f \
 //x=42.285 //y=0.175 //x2=41.75 //y2=0.545
cc_8218 ( N_GND_c_14203_n N_noxref_47_M25_noxref_s ) capacitor c=0.00990843f \
 //x=42.37 //y=1.135 //x2=41.75 //y2=0.545
cc_8219 ( N_GND_c_14212_n N_noxref_47_M25_noxref_s ) capacitor c=0.0123717f \
 //x=42.367 //y=1.005 //x2=41.75 //y2=0.545
cc_8220 ( N_GND_c_14217_n N_noxref_47_M25_noxref_s ) capacitor c=0.0147643f \
 //x=44.35 //y=0.175 //x2=41.75 //y2=0.545
cc_8221 ( N_GND_c_14189_n N_noxref_47_M25_noxref_s ) capacitor c=0.0518718f \
 //x=41.19 //y=0.175 //x2=41.75 //y2=0.545
cc_8222 ( N_GND_c_14261_n N_noxref_47_M25_noxref_s ) capacitor c=0.00648063f \
 //x=44.52 //y=0.175 //x2=41.75 //y2=0.545
cc_8223 ( N_GND_M25_noxref_d N_noxref_47_M25_noxref_s ) capacitor c=0.0271276f \
 //x=42.18 //y=1.045 //x2=41.75 //y2=0.545
cc_8224 ( N_GND_c_14235_n N_noxref_48_c_16293_n ) capacitor c=0.0011329f \
 //x=45.51 //y=0.175 //x2=45.995 //y2=1.77
cc_8225 ( N_GND_c_14287_n N_noxref_48_c_16293_n ) capacitor c=7.40908e-19 \
 //x=50.425 //y=0.175 //x2=45.995 //y2=1.77
cc_8226 ( N_GND_c_14245_n N_noxref_48_c_16293_n ) capacitor c=0.00350793f \
 //x=45.595 //y=1.145 //x2=45.995 //y2=1.77
cc_8227 ( N_GND_c_14258_n N_noxref_48_c_16293_n ) capacitor c=0.00392232f \
 //x=49.16 //y=0.175 //x2=45.995 //y2=1.77
cc_8228 ( N_GND_M27_noxref_d N_noxref_48_c_16293_n ) capacitor c=0.00578031f \
 //x=45.405 //y=1.055 //x2=45.995 //y2=1.77
cc_8229 ( N_GND_c_14239_n N_noxref_48_c_16319_n ) capacitor c=0.0169052f \
 //x=45.595 //y=1.015 //x2=46.08 //y2=0.805
cc_8230 ( N_GND_c_14287_n N_noxref_48_c_16319_n ) capacitor c=0.00439789f \
 //x=50.425 //y=0.175 //x2=46.08 //y2=0.805
cc_8231 ( N_GND_c_14258_n N_noxref_48_c_16319_n ) capacitor c=0.0141638f \
 //x=49.16 //y=0.175 //x2=46.08 //y2=0.805
cc_8232 ( N_GND_c_14261_n N_noxref_48_c_16319_n ) capacitor c=0.00322442f \
 //x=44.52 //y=0.175 //x2=46.08 //y2=0.805
cc_8233 ( N_GND_c_14287_n N_noxref_48_c_16306_n ) capacitor c=0.0123748f \
 //x=50.425 //y=0.175 //x2=46.965 //y2=0.72
cc_8234 ( N_GND_c_14258_n N_noxref_48_c_16306_n ) capacitor c=0.0361346f \
 //x=49.16 //y=0.175 //x2=46.965 //y2=0.72
cc_8235 ( N_GND_c_14235_n N_noxref_48_M27_noxref_s ) capacitor c=0.00439789f \
 //x=45.51 //y=0.175 //x2=44.975 //y2=0.555
cc_8236 ( N_GND_c_14239_n N_noxref_48_M27_noxref_s ) capacitor c=0.0125586f \
 //x=45.595 //y=1.015 //x2=44.975 //y2=0.555
cc_8237 ( N_GND_c_14287_n N_noxref_48_M27_noxref_s ) capacitor c=0.0044479f \
 //x=50.425 //y=0.175 //x2=44.975 //y2=0.555
cc_8238 ( N_GND_c_14245_n N_noxref_48_M27_noxref_s ) capacitor c=0.00972044f \
 //x=45.595 //y=1.145 //x2=44.975 //y2=0.555
cc_8239 ( N_GND_c_14258_n N_noxref_48_M27_noxref_s ) capacitor c=0.0273693f \
 //x=49.16 //y=0.175 //x2=44.975 //y2=0.555
cc_8240 ( N_GND_c_14261_n N_noxref_48_M27_noxref_s ) capacitor c=0.0624873f \
 //x=44.52 //y=0.175 //x2=44.975 //y2=0.555
cc_8241 ( N_GND_c_14304_n N_noxref_48_M27_noxref_s ) capacitor c=0.00166451f \
 //x=49.33 //y=0.175 //x2=44.975 //y2=0.555
cc_8242 ( N_GND_M27_noxref_d N_noxref_48_M27_noxref_s ) capacitor c=0.0271316f \
 //x=45.405 //y=1.055 //x2=44.975 //y2=0.555
cc_8243 ( N_GND_c_14287_n N_noxref_49_c_16352_n ) capacitor c=9.69275e-19 \
 //x=50.425 //y=0.175 //x2=50.91 //y2=1.76
cc_8244 ( N_GND_c_14438_n N_noxref_49_c_16352_n ) capacitor c=7.45647e-19 \
 //x=53.65 //y=0.175 //x2=50.91 //y2=1.76
cc_8245 ( N_GND_c_14317_n N_noxref_49_c_16352_n ) capacitor c=0.00400223f \
 //x=50.51 //y=1.135 //x2=50.91 //y2=1.76
cc_8246 ( N_GND_c_14394_n N_noxref_49_c_16352_n ) capacitor c=0.00395774f \
 //x=52.49 //y=0.175 //x2=50.91 //y2=1.76
cc_8247 ( N_GND_M30_noxref_d N_noxref_49_c_16352_n ) capacitor c=0.00578453f \
 //x=50.32 //y=1.045 //x2=50.91 //y2=1.76
cc_8248 ( N_GND_c_14438_n N_noxref_49_c_16397_n ) capacitor c=0.00395967f \
 //x=53.65 //y=0.175 //x2=50.995 //y2=0.795
cc_8249 ( N_GND_c_14384_n N_noxref_49_c_16397_n ) capacitor c=0.0119573f \
 //x=50.507 //y=1.005 //x2=50.995 //y2=0.795
cc_8250 ( N_GND_c_14394_n N_noxref_49_c_16397_n ) capacitor c=0.0147548f \
 //x=52.49 //y=0.175 //x2=50.995 //y2=0.795
cc_8251 ( N_GND_c_14304_n N_noxref_49_c_16397_n ) capacitor c=0.00282583f \
 //x=49.33 //y=0.175 //x2=50.995 //y2=0.795
cc_8252 ( N_GND_c_14332_n N_noxref_49_c_16397_n ) capacitor c=2.99181e-19 \
 //x=52.66 //y=0.175 //x2=50.995 //y2=0.795
cc_8253 ( N_GND_c_14304_n N_noxref_49_c_16359_n ) capacitor c=2.8386e-19 \
 //x=49.33 //y=0.175 //x2=50.995 //y2=1.675
cc_8254 ( N_GND_c_14438_n N_noxref_49_c_16364_n ) capacitor c=0.00974619f \
 //x=53.65 //y=0.175 //x2=51.88 //y2=0.71
cc_8255 ( N_GND_c_14394_n N_noxref_49_c_16364_n ) capacitor c=0.0374826f \
 //x=52.49 //y=0.175 //x2=51.88 //y2=0.71
cc_8256 ( N_GND_c_14438_n N_noxref_49_c_16405_n ) capacitor c=0.00245021f \
 //x=53.65 //y=0.175 //x2=51.965 //y2=0.795
cc_8257 ( N_GND_c_14394_n N_noxref_49_c_16405_n ) capacitor c=0.0145298f \
 //x=52.49 //y=0.175 //x2=51.965 //y2=0.795
cc_8258 ( N_GND_c_14332_n N_noxref_49_c_16405_n ) capacitor c=0.0396774f \
 //x=52.66 //y=0.175 //x2=51.965 //y2=0.795
cc_8259 ( N_GND_c_14287_n N_noxref_49_M30_noxref_s ) capacitor c=0.0045077f \
 //x=50.425 //y=0.175 //x2=49.89 //y2=0.545
cc_8260 ( N_GND_c_14317_n N_noxref_49_M30_noxref_s ) capacitor c=0.0100945f \
 //x=50.51 //y=1.135 //x2=49.89 //y2=0.545
cc_8261 ( N_GND_c_14384_n N_noxref_49_M30_noxref_s ) capacitor c=0.0170608f \
 //x=50.507 //y=1.005 //x2=49.89 //y2=0.545
cc_8262 ( N_GND_c_14394_n N_noxref_49_M30_noxref_s ) capacitor c=0.0147643f \
 //x=52.49 //y=0.175 //x2=49.89 //y2=0.545
cc_8263 ( N_GND_c_14304_n N_noxref_49_M30_noxref_s ) capacitor c=0.0528206f \
 //x=49.33 //y=0.175 //x2=49.89 //y2=0.545
cc_8264 ( N_GND_c_14332_n N_noxref_49_M30_noxref_s ) capacitor c=0.00648063f \
 //x=52.66 //y=0.175 //x2=49.89 //y2=0.545
cc_8265 ( N_GND_M30_noxref_d N_noxref_49_M30_noxref_s ) capacitor c=0.0271276f \
 //x=50.32 //y=1.045 //x2=49.89 //y2=0.545
cc_8266 ( N_GND_c_14438_n N_noxref_50_c_16419_n ) capacitor c=0.0011329f \
 //x=53.65 //y=0.175 //x2=54.135 //y2=1.77
cc_8267 ( N_GND_c_14559_n N_noxref_50_c_16419_n ) capacitor c=6.52594e-19 \
 //x=58.46 //y=0.175 //x2=54.135 //y2=1.77
cc_8268 ( N_GND_c_14451_n N_noxref_50_c_16419_n ) capacitor c=0.00354861f \
 //x=53.735 //y=1.145 //x2=54.135 //y2=1.77
cc_8269 ( N_GND_c_14474_n N_noxref_50_c_16419_n ) capacitor c=0.00392232f \
 //x=57.3 //y=0.175 //x2=54.135 //y2=1.77
cc_8270 ( N_GND_M32_noxref_d N_noxref_50_c_16419_n ) capacitor c=0.00578031f \
 //x=53.545 //y=1.055 //x2=54.135 //y2=1.77
cc_8271 ( N_GND_c_14442_n N_noxref_50_c_16446_n ) capacitor c=0.0169052f \
 //x=53.735 //y=1.015 //x2=54.22 //y2=0.805
cc_8272 ( N_GND_c_14559_n N_noxref_50_c_16446_n ) capacitor c=0.00439789f \
 //x=58.46 //y=0.175 //x2=54.22 //y2=0.805
cc_8273 ( N_GND_c_14474_n N_noxref_50_c_16446_n ) capacitor c=0.0141638f \
 //x=57.3 //y=0.175 //x2=54.22 //y2=0.805
cc_8274 ( N_GND_c_14332_n N_noxref_50_c_16446_n ) capacitor c=0.00322442f \
 //x=52.66 //y=0.175 //x2=54.22 //y2=0.805
cc_8275 ( N_GND_c_14559_n N_noxref_50_c_16430_n ) capacitor c=0.0124077f \
 //x=58.46 //y=0.175 //x2=55.105 //y2=0.72
cc_8276 ( N_GND_c_14474_n N_noxref_50_c_16430_n ) capacitor c=0.0361346f \
 //x=57.3 //y=0.175 //x2=55.105 //y2=0.72
cc_8277 ( N_GND_c_14438_n N_noxref_50_M32_noxref_s ) capacitor c=0.00439789f \
 //x=53.65 //y=0.175 //x2=53.115 //y2=0.555
cc_8278 ( N_GND_c_14442_n N_noxref_50_M32_noxref_s ) capacitor c=0.0125586f \
 //x=53.735 //y=1.015 //x2=53.115 //y2=0.555
cc_8279 ( N_GND_c_14559_n N_noxref_50_M32_noxref_s ) capacitor c=0.0044479f \
 //x=58.46 //y=0.175 //x2=53.115 //y2=0.555
cc_8280 ( N_GND_c_14451_n N_noxref_50_M32_noxref_s ) capacitor c=0.00972044f \
 //x=53.735 //y=1.145 //x2=53.115 //y2=0.555
cc_8281 ( N_GND_c_14474_n N_noxref_50_M32_noxref_s ) capacitor c=0.0273693f \
 //x=57.3 //y=0.175 //x2=53.115 //y2=0.555
cc_8282 ( N_GND_c_14332_n N_noxref_50_M32_noxref_s ) capacitor c=0.0624873f \
 //x=52.66 //y=0.175 //x2=53.115 //y2=0.555
cc_8283 ( N_GND_c_14333_n N_noxref_50_M32_noxref_s ) capacitor c=0.00166413f \
 //x=57.47 //y=0.175 //x2=53.115 //y2=0.555
cc_8284 ( N_GND_M32_noxref_d N_noxref_50_M32_noxref_s ) capacitor c=0.0271316f \
 //x=53.545 //y=1.055 //x2=53.115 //y2=0.555
cc_8285 ( N_GND_c_14559_n N_noxref_51_c_16479_n ) capacitor c=0.0011329f \
 //x=58.46 //y=0.175 //x2=58.945 //y2=1.77
cc_8286 ( N_GND_c_14513_n N_noxref_51_c_16479_n ) capacitor c=7.40908e-19 \
 //x=63.375 //y=0.175 //x2=58.945 //y2=1.77
cc_8287 ( N_GND_c_14462_n N_noxref_51_c_16479_n ) capacitor c=0.00350567f \
 //x=58.545 //y=1.145 //x2=58.945 //y2=1.77
cc_8288 ( N_GND_c_14475_n N_noxref_51_c_16479_n ) capacitor c=0.00392232f \
 //x=62.11 //y=0.175 //x2=58.945 //y2=1.77
cc_8289 ( N_GND_M35_noxref_d N_noxref_51_c_16479_n ) capacitor c=0.00578031f \
 //x=58.355 //y=1.055 //x2=58.945 //y2=1.77
cc_8290 ( N_GND_c_14445_n N_noxref_51_c_16509_n ) capacitor c=0.0169052f \
 //x=58.545 //y=1.015 //x2=59.03 //y2=0.805
cc_8291 ( N_GND_c_14513_n N_noxref_51_c_16509_n ) capacitor c=0.00439789f \
 //x=63.375 //y=0.175 //x2=59.03 //y2=0.805
cc_8292 ( N_GND_c_14475_n N_noxref_51_c_16509_n ) capacitor c=0.0141638f \
 //x=62.11 //y=0.175 //x2=59.03 //y2=0.805
cc_8293 ( N_GND_c_14333_n N_noxref_51_c_16509_n ) capacitor c=0.00322478f \
 //x=57.47 //y=0.175 //x2=59.03 //y2=0.805
cc_8294 ( N_GND_c_14513_n N_noxref_51_c_16494_n ) capacitor c=0.0122813f \
 //x=63.375 //y=0.175 //x2=59.915 //y2=0.72
cc_8295 ( N_GND_c_14475_n N_noxref_51_c_16494_n ) capacitor c=0.0361346f \
 //x=62.11 //y=0.175 //x2=59.915 //y2=0.72
cc_8296 ( N_GND_c_14559_n N_noxref_51_M35_noxref_s ) capacitor c=0.00439789f \
 //x=58.46 //y=0.175 //x2=57.925 //y2=0.555
cc_8297 ( N_GND_c_14445_n N_noxref_51_M35_noxref_s ) capacitor c=0.0173062f \
 //x=58.545 //y=1.015 //x2=57.925 //y2=0.555
cc_8298 ( N_GND_c_14513_n N_noxref_51_M35_noxref_s ) capacitor c=0.0044479f \
 //x=63.375 //y=0.175 //x2=57.925 //y2=0.555
cc_8299 ( N_GND_c_14462_n N_noxref_51_M35_noxref_s ) capacitor c=0.00988958f \
 //x=58.545 //y=1.145 //x2=57.925 //y2=0.555
cc_8300 ( N_GND_c_14475_n N_noxref_51_M35_noxref_s ) capacitor c=0.0273693f \
 //x=62.11 //y=0.175 //x2=57.925 //y2=0.555
cc_8301 ( N_GND_c_14333_n N_noxref_51_M35_noxref_s ) capacitor c=0.0634633f \
 //x=57.47 //y=0.175 //x2=57.925 //y2=0.555
cc_8302 ( N_GND_c_14334_n N_noxref_51_M35_noxref_s ) capacitor c=0.00166451f \
 //x=62.28 //y=0.175 //x2=57.925 //y2=0.555
cc_8303 ( N_GND_M35_noxref_d N_noxref_51_M35_noxref_s ) capacitor c=0.0271316f \
 //x=58.355 //y=1.055 //x2=57.925 //y2=0.555
cc_8304 ( N_GND_c_14513_n N_noxref_52_c_16539_n ) capacitor c=9.58019e-19 \
 //x=63.375 //y=0.175 //x2=63.86 //y2=1.76
cc_8305 ( N_GND_c_14560_n N_noxref_52_c_16539_n ) capacitor c=7.45647e-19 \
 //x=66.705 //y=0.175 //x2=63.86 //y2=1.76
cc_8306 ( N_GND_c_14517_n N_noxref_52_c_16539_n ) capacitor c=0.00396941f \
 //x=63.46 //y=1.135 //x2=63.86 //y2=1.76
cc_8307 ( N_GND_c_14533_n N_noxref_52_c_16539_n ) capacitor c=0.00395774f \
 //x=65.44 //y=0.175 //x2=63.86 //y2=1.76
cc_8308 ( N_GND_M38_noxref_d N_noxref_52_c_16539_n ) capacitor c=0.00578453f \
 //x=63.27 //y=1.045 //x2=63.86 //y2=1.76
cc_8309 ( N_GND_c_14560_n N_noxref_52_c_16583_n ) capacitor c=0.0042561f \
 //x=66.705 //y=0.175 //x2=63.945 //y2=0.795
cc_8310 ( N_GND_c_14528_n N_noxref_52_c_16583_n ) capacitor c=0.0120153f \
 //x=63.457 //y=1.005 //x2=63.945 //y2=0.795
cc_8311 ( N_GND_c_14533_n N_noxref_52_c_16583_n ) capacitor c=0.0147548f \
 //x=65.44 //y=0.175 //x2=63.945 //y2=0.795
cc_8312 ( N_GND_c_14334_n N_noxref_52_c_16583_n ) capacitor c=0.00282583f \
 //x=62.28 //y=0.175 //x2=63.945 //y2=0.795
cc_8313 ( N_GND_c_14335_n N_noxref_52_c_16583_n ) capacitor c=2.99356e-19 \
 //x=65.61 //y=0.175 //x2=63.945 //y2=0.795
cc_8314 ( N_GND_c_14334_n N_noxref_52_c_16546_n ) capacitor c=2.8386e-19 \
 //x=62.28 //y=0.175 //x2=63.945 //y2=1.675
cc_8315 ( N_GND_c_14560_n N_noxref_52_c_16553_n ) capacitor c=0.00979428f \
 //x=66.705 //y=0.175 //x2=64.83 //y2=0.71
cc_8316 ( N_GND_c_14533_n N_noxref_52_c_16553_n ) capacitor c=0.0375602f \
 //x=65.44 //y=0.175 //x2=64.83 //y2=0.71
cc_8317 ( N_GND_c_14560_n N_noxref_52_c_16591_n ) capacitor c=0.00253402f \
 //x=66.705 //y=0.175 //x2=64.915 //y2=0.795
cc_8318 ( N_GND_c_14533_n N_noxref_52_c_16591_n ) capacitor c=0.0145307f \
 //x=65.44 //y=0.175 //x2=64.915 //y2=0.795
cc_8319 ( N_GND_c_14335_n N_noxref_52_c_16591_n ) capacitor c=0.0392026f \
 //x=65.61 //y=0.175 //x2=64.915 //y2=0.795
cc_8320 ( N_GND_c_14513_n N_noxref_52_M38_noxref_s ) capacitor c=0.0045077f \
 //x=63.375 //y=0.175 //x2=62.84 //y2=0.545
cc_8321 ( N_GND_c_14517_n N_noxref_52_M38_noxref_s ) capacitor c=0.0100997f \
 //x=63.46 //y=1.135 //x2=62.84 //y2=0.545
cc_8322 ( N_GND_c_14528_n N_noxref_52_M38_noxref_s ) capacitor c=0.0170652f \
 //x=63.457 //y=1.005 //x2=62.84 //y2=0.545
cc_8323 ( N_GND_c_14533_n N_noxref_52_M38_noxref_s ) capacitor c=0.0147643f \
 //x=65.44 //y=0.175 //x2=62.84 //y2=0.545
cc_8324 ( N_GND_c_14334_n N_noxref_52_M38_noxref_s ) capacitor c=0.0528206f \
 //x=62.28 //y=0.175 //x2=62.84 //y2=0.545
cc_8325 ( N_GND_c_14335_n N_noxref_52_M38_noxref_s ) capacitor c=0.0064811f \
 //x=65.61 //y=0.175 //x2=62.84 //y2=0.545
cc_8326 ( N_GND_M38_noxref_d N_noxref_52_M38_noxref_s ) capacitor c=0.0271276f \
 //x=63.27 //y=1.045 //x2=62.84 //y2=0.545
cc_8327 ( N_GND_c_14560_n N_noxref_53_c_16605_n ) capacitor c=9.98096e-19 \
 //x=66.705 //y=0.175 //x2=67.19 //y2=1.76
cc_8328 ( N_GND_c_14611_n N_noxref_53_c_16605_n ) capacitor c=7.45647e-19 \
 //x=69.93 //y=0.175 //x2=67.19 //y2=1.76
cc_8329 ( N_GND_c_14579_n N_noxref_53_c_16605_n ) capacitor c=0.00402812f \
 //x=66.79 //y=1.135 //x2=67.19 //y2=1.76
cc_8330 ( N_GND_c_14593_n N_noxref_53_c_16605_n ) capacitor c=0.00395774f \
 //x=68.77 //y=0.175 //x2=67.19 //y2=1.76
cc_8331 ( N_GND_M40_noxref_d N_noxref_53_c_16605_n ) capacitor c=0.00578453f \
 //x=66.6 //y=1.045 //x2=67.19 //y2=1.76
cc_8332 ( N_GND_c_14611_n N_noxref_53_c_16646_n ) capacitor c=0.0041386f \
 //x=69.93 //y=0.175 //x2=67.275 //y2=0.795
cc_8333 ( N_GND_c_14588_n N_noxref_53_c_16646_n ) capacitor c=0.0119573f \
 //x=66.787 //y=1.005 //x2=67.275 //y2=0.795
cc_8334 ( N_GND_c_14593_n N_noxref_53_c_16646_n ) capacitor c=0.0147548f \
 //x=68.77 //y=0.175 //x2=67.275 //y2=0.795
cc_8335 ( N_GND_c_14335_n N_noxref_53_c_16646_n ) capacitor c=0.00282552f \
 //x=65.61 //y=0.175 //x2=67.275 //y2=0.795
cc_8336 ( N_GND_c_14336_n N_noxref_53_c_16646_n ) capacitor c=2.99181e-19 \
 //x=68.94 //y=0.175 //x2=67.275 //y2=0.795
cc_8337 ( N_GND_c_14335_n N_noxref_53_c_16612_n ) capacitor c=2.8386e-19 \
 //x=65.61 //y=0.175 //x2=67.275 //y2=1.675
cc_8338 ( N_GND_c_14611_n N_noxref_53_c_16617_n ) capacitor c=0.00981886f \
 //x=69.93 //y=0.175 //x2=68.16 //y2=0.71
cc_8339 ( N_GND_c_14593_n N_noxref_53_c_16617_n ) capacitor c=0.0375602f \
 //x=68.77 //y=0.175 //x2=68.16 //y2=0.71
cc_8340 ( N_GND_c_14611_n N_noxref_53_c_16654_n ) capacitor c=0.00293309f \
 //x=69.93 //y=0.175 //x2=68.245 //y2=0.795
cc_8341 ( N_GND_c_14593_n N_noxref_53_c_16654_n ) capacitor c=0.0145307f \
 //x=68.77 //y=0.175 //x2=68.245 //y2=0.795
cc_8342 ( N_GND_c_14336_n N_noxref_53_c_16654_n ) capacitor c=0.0396774f \
 //x=68.94 //y=0.175 //x2=68.245 //y2=0.795
cc_8343 ( N_GND_c_14560_n N_noxref_53_M40_noxref_s ) capacitor c=0.0045077f \
 //x=66.705 //y=0.175 //x2=66.17 //y2=0.545
cc_8344 ( N_GND_c_14579_n N_noxref_53_M40_noxref_s ) capacitor c=0.00990843f \
 //x=66.79 //y=1.135 //x2=66.17 //y2=0.545
cc_8345 ( N_GND_c_14588_n N_noxref_53_M40_noxref_s ) capacitor c=0.0123717f \
 //x=66.787 //y=1.005 //x2=66.17 //y2=0.545
cc_8346 ( N_GND_c_14593_n N_noxref_53_M40_noxref_s ) capacitor c=0.0147643f \
 //x=68.77 //y=0.175 //x2=66.17 //y2=0.545
cc_8347 ( N_GND_c_14335_n N_noxref_53_M40_noxref_s ) capacitor c=0.0518718f \
 //x=65.61 //y=0.175 //x2=66.17 //y2=0.545
cc_8348 ( N_GND_c_14336_n N_noxref_53_M40_noxref_s ) capacitor c=0.00648063f \
 //x=68.94 //y=0.175 //x2=66.17 //y2=0.545
cc_8349 ( N_GND_M40_noxref_d N_noxref_53_M40_noxref_s ) capacitor c=0.0271276f \
 //x=66.6 //y=1.045 //x2=66.17 //y2=0.545
cc_8350 ( N_GND_c_14611_n N_noxref_54_c_16673_n ) capacitor c=0.0011329f \
 //x=69.93 //y=0.175 //x2=70.415 //y2=1.77
cc_8351 ( N_GND_c_14678_n N_noxref_54_c_16673_n ) capacitor c=7.40908e-19 \
 //x=74.845 //y=0.175 //x2=70.415 //y2=1.77
cc_8352 ( N_GND_c_14620_n N_noxref_54_c_16673_n ) capacitor c=0.00382071f \
 //x=70.015 //y=1.145 //x2=70.415 //y2=1.77
cc_8353 ( N_GND_c_14632_n N_noxref_54_c_16673_n ) capacitor c=0.00392232f \
 //x=73.58 //y=0.175 //x2=70.415 //y2=1.77
cc_8354 ( N_GND_M42_noxref_d N_noxref_54_c_16673_n ) capacitor c=0.00578031f \
 //x=69.825 //y=1.055 //x2=70.415 //y2=1.77
cc_8355 ( N_GND_c_14614_n N_noxref_54_c_16697_n ) capacitor c=0.0169052f \
 //x=70.015 //y=1.015 //x2=70.5 //y2=0.805
cc_8356 ( N_GND_c_14678_n N_noxref_54_c_16697_n ) capacitor c=0.00439789f \
 //x=74.845 //y=0.175 //x2=70.5 //y2=0.805
cc_8357 ( N_GND_c_14632_n N_noxref_54_c_16697_n ) capacitor c=0.0141638f \
 //x=73.58 //y=0.175 //x2=70.5 //y2=0.805
cc_8358 ( N_GND_c_14336_n N_noxref_54_c_16697_n ) capacitor c=0.00322442f \
 //x=68.94 //y=0.175 //x2=70.5 //y2=0.805
cc_8359 ( N_GND_c_14678_n N_noxref_54_c_16686_n ) capacitor c=0.0123748f \
 //x=74.845 //y=0.175 //x2=71.385 //y2=0.72
cc_8360 ( N_GND_c_14632_n N_noxref_54_c_16686_n ) capacitor c=0.0358997f \
 //x=73.58 //y=0.175 //x2=71.385 //y2=0.72
cc_8361 ( N_GND_c_14611_n N_noxref_54_M42_noxref_s ) capacitor c=0.00439789f \
 //x=69.93 //y=0.175 //x2=69.395 //y2=0.555
cc_8362 ( N_GND_c_14614_n N_noxref_54_M42_noxref_s ) capacitor c=0.0125586f \
 //x=70.015 //y=1.015 //x2=69.395 //y2=0.555
cc_8363 ( N_GND_c_14678_n N_noxref_54_M42_noxref_s ) capacitor c=0.00683407f \
 //x=74.845 //y=0.175 //x2=69.395 //y2=0.555
cc_8364 ( N_GND_c_14620_n N_noxref_54_M42_noxref_s ) capacitor c=0.00972044f \
 //x=70.015 //y=1.145 //x2=69.395 //y2=0.555
cc_8365 ( N_GND_c_14632_n N_noxref_54_M42_noxref_s ) capacitor c=0.027328f \
 //x=73.58 //y=0.175 //x2=69.395 //y2=0.555
cc_8366 ( N_GND_c_14336_n N_noxref_54_M42_noxref_s ) capacitor c=0.0624873f \
 //x=68.94 //y=0.175 //x2=69.395 //y2=0.555
cc_8367 ( N_GND_c_14337_n N_noxref_54_M42_noxref_s ) capacitor c=0.00166451f \
 //x=73.75 //y=0.175 //x2=69.395 //y2=0.555
cc_8368 ( N_GND_M42_noxref_d N_noxref_54_M42_noxref_s ) capacitor c=0.0271316f \
 //x=69.825 //y=1.055 //x2=69.395 //y2=0.555
cc_8369 ( N_GND_c_14678_n N_noxref_55_c_16730_n ) capacitor c=9.536e-19 \
 //x=74.845 //y=0.175 //x2=75.33 //y2=1.76
cc_8370 ( N_GND_c_14313_n N_noxref_55_c_16730_n ) capacitor c=0.0049241f \
 //x=74.93 //y=1.015 //x2=75.33 //y2=1.76
cc_8371 ( N_GND_c_14314_n N_noxref_55_c_16730_n ) capacitor c=7.45647e-19 \
 //x=78.175 //y=0.175 //x2=75.33 //y2=1.76
cc_8372 ( N_GND_c_14321_n N_noxref_55_c_16730_n ) capacitor c=0.00426366f \
 //x=76.91 //y=0.175 //x2=75.33 //y2=1.76
cc_8373 ( N_GND_M45_noxref_d N_noxref_55_c_16730_n ) capacitor c=0.00579662f \
 //x=74.74 //y=1.045 //x2=75.33 //y2=1.76
cc_8374 ( N_GND_c_14313_n N_noxref_55_c_16775_n ) capacitor c=0.0120153f \
 //x=74.93 //y=1.015 //x2=75.415 //y2=0.795
cc_8375 ( N_GND_c_14314_n N_noxref_55_c_16775_n ) capacitor c=0.00292448f \
 //x=78.175 //y=0.175 //x2=75.415 //y2=0.795
cc_8376 ( N_GND_c_14321_n N_noxref_55_c_16775_n ) capacitor c=0.0148539f \
 //x=76.91 //y=0.175 //x2=75.415 //y2=0.795
cc_8377 ( N_GND_c_14337_n N_noxref_55_c_16775_n ) capacitor c=0.00283186f \
 //x=73.75 //y=0.175 //x2=75.415 //y2=0.795
cc_8378 ( N_GND_c_14338_n N_noxref_55_c_16775_n ) capacitor c=2.99356e-19 \
 //x=77.08 //y=0.175 //x2=75.415 //y2=0.795
cc_8379 ( N_GND_c_14337_n N_noxref_55_c_16731_n ) capacitor c=2.89348e-19 \
 //x=73.75 //y=0.175 //x2=75.415 //y2=1.675
cc_8380 ( N_GND_c_14314_n N_noxref_55_c_16735_n ) capacitor c=0.0109409f \
 //x=78.175 //y=0.175 //x2=76.3 //y2=0.71
cc_8381 ( N_GND_c_14321_n N_noxref_55_c_16735_n ) capacitor c=0.0375489f \
 //x=76.91 //y=0.175 //x2=76.3 //y2=0.71
cc_8382 ( N_GND_c_14314_n N_noxref_55_c_16783_n ) capacitor c=0.0045077f \
 //x=78.175 //y=0.175 //x2=76.385 //y2=0.795
cc_8383 ( N_GND_c_14321_n N_noxref_55_c_16783_n ) capacitor c=0.0144994f \
 //x=76.91 //y=0.175 //x2=76.385 //y2=0.795
cc_8384 ( N_GND_c_14338_n N_noxref_55_c_16783_n ) capacitor c=0.0540895f \
 //x=77.08 //y=0.175 //x2=76.385 //y2=0.795
cc_8385 ( N_GND_c_14678_n N_noxref_55_M45_noxref_s ) capacitor c=0.00282008f \
 //x=74.845 //y=0.175 //x2=74.31 //y2=0.545
cc_8386 ( N_GND_c_14313_n N_noxref_55_M45_noxref_s ) capacitor c=0.0289797f \
 //x=74.93 //y=1.015 //x2=74.31 //y2=0.545
cc_8387 ( N_GND_c_14321_n N_noxref_55_M45_noxref_s ) capacitor c=0.014658f \
 //x=76.91 //y=0.175 //x2=74.31 //y2=0.545
cc_8388 ( N_GND_c_14337_n N_noxref_55_M45_noxref_s ) capacitor c=0.0536311f \
 //x=73.75 //y=0.175 //x2=74.31 //y2=0.545
cc_8389 ( N_GND_c_14338_n N_noxref_55_M45_noxref_s ) capacitor c=0.00250794f \
 //x=77.08 //y=0.175 //x2=74.31 //y2=0.545
cc_8390 ( N_GND_M45_noxref_d N_noxref_55_M45_noxref_s ) capacitor c=0.0271433f \
 //x=74.74 //y=1.045 //x2=74.31 //y2=0.545
cc_8391 ( N_GND_c_14314_n N_noxref_57_c_16805_n ) capacitor c=0.0010065f \
 //x=78.175 //y=0.175 //x2=78.66 //y2=1.76
cc_8392 ( N_GND_c_14753_n N_noxref_57_c_16805_n ) capacitor c=0.00375883f \
 //x=78.26 //y=1.015 //x2=78.66 //y2=1.76
cc_8393 ( N_GND_c_14798_n N_noxref_57_c_16805_n ) capacitor c=7.45647e-19 \
 //x=81.505 //y=0.175 //x2=78.66 //y2=1.76
cc_8394 ( N_GND_c_14765_n N_noxref_57_c_16805_n ) capacitor c=0.00358266f \
 //x=80.24 //y=0.175 //x2=78.66 //y2=1.76
cc_8395 ( N_GND_M47_noxref_d N_noxref_57_c_16805_n ) capacitor c=0.00750663f \
 //x=78.07 //y=1.045 //x2=78.66 //y2=1.76
cc_8396 ( N_GND_c_14753_n N_noxref_57_c_16846_n ) capacitor c=0.0120153f \
 //x=78.26 //y=1.015 //x2=78.745 //y2=0.795
cc_8397 ( N_GND_c_14798_n N_noxref_57_c_16846_n ) capacitor c=0.0045077f \
 //x=81.505 //y=0.175 //x2=78.745 //y2=0.795
cc_8398 ( N_GND_c_14765_n N_noxref_57_c_16846_n ) capacitor c=0.0144994f \
 //x=80.24 //y=0.175 //x2=78.745 //y2=0.795
cc_8399 ( N_GND_c_14338_n N_noxref_57_c_16846_n ) capacitor c=0.00226009f \
 //x=77.08 //y=0.175 //x2=78.745 //y2=0.795
cc_8400 ( N_GND_c_14342_n N_noxref_57_c_16846_n ) capacitor c=2.99356e-19 \
 //x=80.41 //y=0.175 //x2=78.745 //y2=0.795
cc_8401 ( N_GND_c_14338_n N_noxref_57_c_16812_n ) capacitor c=2.91423e-19 \
 //x=77.08 //y=0.175 //x2=78.745 //y2=1.675
cc_8402 ( N_GND_c_14798_n N_noxref_57_c_16820_n ) capacitor c=0.0114198f \
 //x=81.505 //y=0.175 //x2=79.63 //y2=0.71
cc_8403 ( N_GND_c_14765_n N_noxref_57_c_16820_n ) capacitor c=0.0374965f \
 //x=80.24 //y=0.175 //x2=79.63 //y2=0.71
cc_8404 ( N_GND_c_14798_n N_noxref_57_c_16854_n ) capacitor c=0.00251499f \
 //x=81.505 //y=0.175 //x2=79.715 //y2=0.795
cc_8405 ( N_GND_c_14765_n N_noxref_57_c_16854_n ) capacitor c=0.0144994f \
 //x=80.24 //y=0.175 //x2=79.715 //y2=0.795
cc_8406 ( N_GND_c_14342_n N_noxref_57_c_16854_n ) capacitor c=0.0528155f \
 //x=80.41 //y=0.175 //x2=79.715 //y2=0.795
cc_8407 ( N_GND_c_14314_n N_noxref_57_M47_noxref_s ) capacitor c=0.0045077f \
 //x=78.175 //y=0.175 //x2=77.64 //y2=0.545
cc_8408 ( N_GND_c_14753_n N_noxref_57_M47_noxref_s ) capacitor c=0.0251079f \
 //x=78.26 //y=1.015 //x2=77.64 //y2=0.545
cc_8409 ( N_GND_c_14765_n N_noxref_57_M47_noxref_s ) capacitor c=0.0144994f \
 //x=80.24 //y=0.175 //x2=77.64 //y2=0.545
cc_8410 ( N_GND_c_14338_n N_noxref_57_M47_noxref_s ) capacitor c=0.0536459f \
 //x=77.08 //y=0.175 //x2=77.64 //y2=0.545
cc_8411 ( N_GND_c_14342_n N_noxref_57_M47_noxref_s ) capacitor c=0.00291802f \
 //x=80.41 //y=0.175 //x2=77.64 //y2=0.545
cc_8412 ( N_GND_M47_noxref_d N_noxref_57_M47_noxref_s ) capacitor c=0.0296569f \
 //x=78.07 //y=1.045 //x2=77.64 //y2=0.545
cc_8413 ( N_GND_c_14798_n N_noxref_58_c_16867_n ) capacitor c=9.5216e-19 \
 //x=81.505 //y=0.175 //x2=81.99 //y2=1.76
cc_8414 ( N_GND_c_14801_n N_noxref_58_c_16867_n ) capacitor c=0.0048201f \
 //x=81.59 //y=1.02 //x2=81.99 //y2=1.76
cc_8415 ( N_GND_c_14316_n N_noxref_58_c_16867_n ) capacitor c=0.00204479f \
 //x=85.22 //y=0.18 //x2=81.99 //y2=1.76
cc_8416 ( N_GND_c_14322_n N_noxref_58_c_16867_n ) capacitor c=0.00357558f \
 //x=83.57 //y=0.175 //x2=81.99 //y2=1.76
cc_8417 ( N_GND_M49_noxref_d N_noxref_58_c_16867_n ) capacitor c=0.00579662f \
 //x=81.4 //y=1.045 //x2=81.99 //y2=1.76
cc_8418 ( N_GND_c_14801_n N_noxref_58_c_16915_n ) capacitor c=0.0167642f \
 //x=81.59 //y=1.02 //x2=82.075 //y2=0.795
cc_8419 ( N_GND_c_14316_n N_noxref_58_c_16915_n ) capacitor c=0.00310354f \
 //x=85.22 //y=0.18 //x2=82.075 //y2=0.795
cc_8420 ( N_GND_c_14322_n N_noxref_58_c_16915_n ) capacitor c=0.0144994f \
 //x=83.57 //y=0.175 //x2=82.075 //y2=0.795
cc_8421 ( N_GND_c_14342_n N_noxref_58_c_16915_n ) capacitor c=0.00225073f \
 //x=80.41 //y=0.175 //x2=82.075 //y2=0.795
cc_8422 ( N_GND_c_14343_n N_noxref_58_c_16915_n ) capacitor c=2.21767e-19 \
 //x=83.74 //y=0.175 //x2=82.075 //y2=0.795
cc_8423 ( N_GND_c_14342_n N_noxref_58_c_16868_n ) capacitor c=2.86225e-19 \
 //x=80.41 //y=0.175 //x2=82.075 //y2=1.675
cc_8424 ( N_GND_c_14316_n N_noxref_58_c_16872_n ) capacitor c=0.00939457f \
 //x=85.22 //y=0.18 //x2=82.96 //y2=0.71
cc_8425 ( N_GND_c_14322_n N_noxref_58_c_16872_n ) capacitor c=0.0375173f \
 //x=83.57 //y=0.175 //x2=82.96 //y2=0.71
cc_8426 ( N_GND_c_14316_n N_noxref_58_c_16923_n ) capacitor c=0.00326972f \
 //x=85.22 //y=0.18 //x2=83.045 //y2=0.795
cc_8427 ( N_GND_c_14322_n N_noxref_58_c_16923_n ) capacitor c=0.0144881f \
 //x=83.57 //y=0.175 //x2=83.045 //y2=0.795
cc_8428 ( N_GND_c_15507_p N_noxref_58_c_16923_n ) capacitor c=0.00211385f \
 //x=84.37 //y=0.63 //x2=83.045 //y2=0.795
cc_8429 ( N_GND_c_14343_n N_noxref_58_c_16923_n ) capacitor c=0.0406122f \
 //x=83.74 //y=0.175 //x2=83.045 //y2=0.795
cc_8430 ( N_GND_c_14798_n N_noxref_58_M49_noxref_s ) capacitor c=0.00251499f \
 //x=81.505 //y=0.175 //x2=80.97 //y2=0.545
cc_8431 ( N_GND_c_14801_n N_noxref_58_M49_noxref_s ) capacitor c=0.0250671f \
 //x=81.59 //y=1.02 //x2=80.97 //y2=0.545
cc_8432 ( N_GND_c_14322_n N_noxref_58_M49_noxref_s ) capacitor c=0.0144994f \
 //x=83.57 //y=0.175 //x2=80.97 //y2=0.545
cc_8433 ( N_GND_c_14342_n N_noxref_58_M49_noxref_s ) capacitor c=0.0528929f \
 //x=80.41 //y=0.175 //x2=80.97 //y2=0.545
cc_8434 ( N_GND_c_14343_n N_noxref_58_M49_noxref_s ) capacitor c=0.00580588f \
 //x=83.74 //y=0.175 //x2=80.97 //y2=0.545
cc_8435 ( N_GND_M49_noxref_d N_noxref_58_M49_noxref_s ) capacitor c=0.0272383f \
 //x=81.4 //y=1.045 //x2=80.97 //y2=0.545
cc_8436 ( N_GND_M51_noxref_s N_noxref_58_M49_noxref_s ) capacitor \
 c=0.00317066f //x=84.235 //y=0.55 //x2=80.97 //y2=0.545
cc_8437 ( N_noxref_37_c_15596_n N_noxref_38_c_15659_n ) capacitor \
 c=6.40432e-19 //x=2.155 //y=1.675 //x2=4.41 //y2=1.685
cc_8438 ( N_noxref_37_c_15646_n N_noxref_38_M2_noxref_s ) capacitor \
 c=0.00453771f //x=3.125 //y=0.795 //x2=4.275 //y2=0.555
cc_8439 ( N_noxref_37_M0_noxref_s N_noxref_38_M2_noxref_s ) capacitor \
 c=6.40432e-19 //x=1.05 //y=0.545 //x2=4.275 //y2=0.555
cc_8440 ( N_noxref_40_c_15785_n N_noxref_41_c_15843_n ) capacitor \
 c=5.34352e-19 //x=15.105 //y=1.675 //x2=17.465 //y2=1.675
cc_8441 ( N_noxref_40_c_15830_n N_noxref_41_M10_noxref_s ) capacitor \
 c=0.0045327f //x=16.075 //y=0.795 //x2=17.33 //y2=0.545
cc_8442 ( N_noxref_40_M8_noxref_s N_noxref_41_M10_noxref_s ) capacitor \
 c=5.34352e-19 //x=14 //y=0.545 //x2=17.33 //y2=0.545
cc_8443 ( N_noxref_41_c_15851_n N_noxref_42_c_15912_n ) capacitor \
 c=6.40432e-19 //x=18.435 //y=1.675 //x2=20.69 //y2=1.685
cc_8444 ( N_noxref_41_c_15896_n N_noxref_42_M12_noxref_s ) capacitor \
 c=0.00453771f //x=19.405 //y=0.795 //x2=20.555 //y2=0.555
cc_8445 ( N_noxref_41_M10_noxref_s N_noxref_42_M12_noxref_s ) capacitor \
 c=6.40432e-19 //x=17.33 //y=0.545 //x2=20.555 //y2=0.555
cc_8446 ( N_noxref_43_c_15971_n N_noxref_44_c_16038_n ) capacitor \
 c=6.40432e-19 //x=26.575 //y=1.675 //x2=28.83 //y2=1.685
cc_8447 ( N_noxref_43_c_16025_n N_noxref_44_M17_noxref_s ) capacitor \
 c=0.00453771f //x=27.545 //y=0.795 //x2=28.695 //y2=0.555
cc_8448 ( N_noxref_43_M15_noxref_s N_noxref_44_M17_noxref_s ) capacitor \
 c=6.40432e-19 //x=25.47 //y=0.545 //x2=28.695 //y2=0.555
cc_8449 ( N_noxref_46_c_16166_n N_noxref_47_c_16224_n ) capacitor \
 c=5.34352e-19 //x=39.525 //y=1.675 //x2=41.885 //y2=1.675
cc_8450 ( N_noxref_46_c_16211_n N_noxref_47_M25_noxref_s ) capacitor \
 c=0.0045327f //x=40.495 //y=0.795 //x2=41.75 //y2=0.545
cc_8451 ( N_noxref_46_M23_noxref_s N_noxref_47_M25_noxref_s ) capacitor \
 c=5.34352e-19 //x=38.42 //y=0.545 //x2=41.75 //y2=0.545
cc_8452 ( N_noxref_47_c_16232_n N_noxref_48_c_16292_n ) capacitor \
 c=6.40432e-19 //x=42.855 //y=1.675 //x2=45.11 //y2=1.685
cc_8453 ( N_noxref_47_c_16276_n N_noxref_48_M27_noxref_s ) capacitor \
 c=0.00453771f //x=43.825 //y=0.795 //x2=44.975 //y2=0.555
cc_8454 ( N_noxref_47_M25_noxref_s N_noxref_48_M27_noxref_s ) capacitor \
 c=6.40432e-19 //x=41.75 //y=0.545 //x2=44.975 //y2=0.555
cc_8455 ( N_noxref_49_c_16359_n N_noxref_50_c_16418_n ) capacitor \
 c=6.40432e-19 //x=50.995 //y=1.675 //x2=53.25 //y2=1.685
cc_8456 ( N_noxref_49_c_16405_n N_noxref_50_M32_noxref_s ) capacitor \
 c=0.00453771f //x=51.965 //y=0.795 //x2=53.115 //y2=0.555
cc_8457 ( N_noxref_49_M30_noxref_s N_noxref_50_M32_noxref_s ) capacitor \
 c=6.40432e-19 //x=49.89 //y=0.545 //x2=53.115 //y2=0.555
cc_8458 ( N_noxref_52_c_16546_n N_noxref_53_c_16604_n ) capacitor \
 c=5.34352e-19 //x=63.945 //y=1.675 //x2=66.305 //y2=1.675
cc_8459 ( N_noxref_52_c_16591_n N_noxref_53_M40_noxref_s ) capacitor \
 c=0.0045327f //x=64.915 //y=0.795 //x2=66.17 //y2=0.545
cc_8460 ( N_noxref_52_M38_noxref_s N_noxref_53_M40_noxref_s ) capacitor \
 c=5.34352e-19 //x=62.84 //y=0.545 //x2=66.17 //y2=0.545
cc_8461 ( N_noxref_53_c_16612_n N_noxref_54_c_16672_n ) capacitor \
 c=6.40432e-19 //x=67.275 //y=1.675 //x2=69.53 //y2=1.685
cc_8462 ( N_noxref_53_c_16654_n N_noxref_54_M42_noxref_s ) capacitor \
 c=0.00453771f //x=68.245 //y=0.795 //x2=69.395 //y2=0.555
cc_8463 ( N_noxref_53_M40_noxref_s N_noxref_54_M42_noxref_s ) capacitor \
 c=6.40432e-19 //x=66.17 //y=0.545 //x2=69.395 //y2=0.555
cc_8464 ( N_noxref_55_M45_noxref_s N_noxref_57_c_16804_n ) capacitor \
 c=0.00220044f //x=74.31 //y=0.545 //x2=77.775 //y2=1.675
cc_8465 ( N_noxref_55_c_16783_n N_noxref_57_M47_noxref_s ) capacitor \
 c=0.00220044f //x=76.385 //y=0.795 //x2=77.64 //y2=0.545
cc_8466 ( N_noxref_57_M47_noxref_s N_noxref_58_c_16880_n ) capacitor \
 c=0.00244935f //x=77.64 //y=0.545 //x2=81.105 //y2=1.675
cc_8467 ( N_noxref_57_c_16854_n N_noxref_58_M49_noxref_s ) capacitor \
 c=0.00244935f //x=79.715 //y=0.795 //x2=80.97 //y2=0.545
