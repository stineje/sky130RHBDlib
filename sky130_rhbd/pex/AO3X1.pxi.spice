// File: AO3X1.spi.AO3X1.pxi
// Created: Sun Mar 15 12:38:49 2026
//
simulator lang=spectre
x_PM_AO3X1\%noxref_1 ( N_noxref_1_c_43_p N_noxref_1_c_10_p N_noxref_1_c_30_p \
 N_noxref_1_c_17_p N_noxref_1_c_256_p N_noxref_1_c_25_p N_noxref_1_c_110_p \
 N_noxref_1_c_27_p N_noxref_1_c_26_p N_noxref_1_c_18_p N_noxref_1_c_28_p \
 N_noxref_1_c_45_p N_noxref_1_c_46_p N_noxref_1_c_47_p N_noxref_1_c_1_p \
 N_noxref_1_c_90_p N_noxref_1_c_31_p N_noxref_1_c_2_p N_noxref_1_c_71_p \
 N_noxref_1_c_72_p N_noxref_1_c_151_p N_noxref_1_c_20_p N_noxref_1_c_48_p \
 N_noxref_1_c_49_p N_noxref_1_c_29_p N_noxref_1_c_3_p N_noxref_1_M2_noxref_g \
 N_noxref_1_M9_noxref_g N_noxref_1_M10_noxref_g N_noxref_1_c_4_p \
 N_noxref_1_c_5_p N_noxref_1_c_12_p N_noxref_1_c_13_p N_noxref_1_c_6_p \
 N_noxref_1_c_7_p N_noxref_1_c_95_p N_noxref_1_c_8_p N_noxref_1_c_9_p \
 N_noxref_1_c_76_p N_noxref_1_M1_noxref_d N_noxref_1_M5_noxref_d \
 N_noxref_1_M7_noxref_d )  PM_AO3X1\%noxref_1
x_PM_AO3X1\%noxref_2 ( N_noxref_2_c_266_n N_noxref_2_c_275_n \
 N_noxref_2_c_281_n N_noxref_2_c_282_n N_noxref_2_c_339_p N_noxref_2_c_288_n \
 N_noxref_2_c_308_p N_noxref_2_c_340_p N_noxref_2_c_290_n N_noxref_2_c_341_p \
 N_noxref_2_c_292_n N_noxref_2_c_367_p N_noxref_2_c_330_p N_noxref_2_c_309_p \
 N_noxref_2_c_295_n N_noxref_2_c_296_n N_noxref_2_c_370_p N_noxref_2_c_344_p \
 N_noxref_2_c_297_n N_noxref_2_c_470_p N_noxref_2_c_320_p N_noxref_2_c_312_p \
 N_noxref_2_c_345_p N_noxref_2_c_310_p N_noxref_2_M4_noxref_g \
 N_noxref_2_M13_noxref_g N_noxref_2_M14_noxref_g N_noxref_2_c_360_p \
 N_noxref_2_c_479_p N_noxref_2_c_396_p N_noxref_2_c_374_p N_noxref_2_c_327_p \
 N_noxref_2_c_324_p N_noxref_2_c_398_p N_noxref_2_c_482_p N_noxref_2_c_362_p \
 N_noxref_2_c_400_p N_noxref_2_c_361_p N_noxref_2_M2_noxref_d \
 N_noxref_2_M3_noxref_d N_noxref_2_M11_noxref_d )  PM_AO3X1\%noxref_2
x_PM_AO3X1\%VDD ( VDD N_VDD_c_512_n N_VDD_c_519_n N_VDD_c_521_n N_VDD_c_565_n \
 N_VDD_c_523_n N_VDD_c_526_n N_VDD_c_531_n N_VDD_c_570_n N_VDD_c_533_n \
 N_VDD_c_536_n N_VDD_c_546_n N_VDD_c_547_n N_VDD_M5_noxref_s N_VDD_M6_noxref_d \
 N_VDD_M8_noxref_d N_VDD_M9_noxref_d N_VDD_M13_noxref_s N_VDD_M14_noxref_d )  \
 PM_AO3X1\%VDD
x_PM_AO3X1\%A ( A A A A A A A N_A_c_708_p N_A_c_686_n N_A_c_710_p N_A_c_688_n \
 N_A_M0_noxref_g N_A_M5_noxref_g N_A_M6_noxref_g N_A_c_711_p N_A_c_712_p \
 N_A_c_713_p N_A_c_726_p N_A_c_714_p N_A_c_715_p N_A_c_716_p N_A_c_717_p \
 N_A_c_695_n )  PM_AO3X1\%A
x_PM_AO3X1\%GND ( GND N_GND_c_887_n N_GND_c_782_n N_GND_c_788_n N_GND_c_897_n \
 N_GND_c_791_n N_GND_c_793_n N_GND_c_962_p N_GND_c_795_n N_GND_c_833_n \
 N_GND_c_837_n N_GND_c_838_n N_GND_c_843_n N_GND_c_801_n N_GND_c_845_n \
 N_GND_c_812_n N_GND_M0_noxref_d N_GND_M2_noxref_s N_GND_M4_noxref_s )  \
 PM_AO3X1\%GND
x_PM_AO3X1\%B ( B B B B B B B N_B_c_981_n N_B_c_983_n N_B_c_985_n N_B_c_986_n \
 N_B_M1_noxref_g N_B_M7_noxref_g N_B_M8_noxref_g N_B_c_994_n N_B_c_996_n \
 N_B_c_999_n N_B_c_1000_n N_B_c_1003_n N_B_c_1005_n N_B_c_1009_n N_B_c_1011_n \
 N_B_c_1015_n N_B_c_1016_n N_B_c_1018_n )  PM_AO3X1\%B
x_PM_AO3X1\%noxref_7 ( N_noxref_7_c_1081_n N_noxref_7_c_1104_n \
 N_noxref_7_c_1087_n N_noxref_7_c_1094_n N_noxref_7_c_1095_n \
 N_noxref_7_c_1111_n N_noxref_7_c_1096_n N_noxref_7_c_1100_n \
 N_noxref_7_M9_noxref_s N_noxref_7_M10_noxref_d N_noxref_7_M12_noxref_d )  \
 PM_AO3X1\%noxref_7
x_PM_AO3X1\%C ( C C C C C C C N_C_c_1184_n N_C_c_1187_n N_C_c_1190_n \
 N_C_c_1194_n N_C_M3_noxref_g N_C_M11_noxref_g N_C_M12_noxref_g N_C_c_1201_n \
 N_C_c_1203_n N_C_c_1206_n N_C_c_1247_n N_C_c_1250_n N_C_c_1208_n N_C_c_1209_n \
 N_C_c_1210_n N_C_c_1211_n N_C_c_1214_n N_C_c_1215_n )  PM_AO3X1\%C
x_PM_AO3X1\%Y ( Y Y Y Y Y Y Y N_Y_c_1308_n N_Y_c_1316_n N_Y_c_1320_n \
 N_Y_c_1321_n N_Y_c_1323_n N_Y_c_1324_n N_Y_c_1327_n N_Y_c_1335_n \
 N_Y_M4_noxref_d N_Y_M13_noxref_d )  PM_AO3X1\%Y
x_PM_AO3X1\%noxref_10 ( N_noxref_10_c_1386_n N_noxref_10_c_1387_n \
 N_noxref_10_c_1402_n N_noxref_10_c_1376_n N_noxref_10_c_1377_n \
 N_noxref_10_c_1412_n N_noxref_10_M0_noxref_s )  PM_AO3X1\%noxref_10
cc_1 ( N_noxref_1_c_1_p N_noxref_2_c_266_n ) capacitor c=0.00604284f //x=2.64 \
 //y=1.18 //x2=5 //y2=1.305
cc_2 ( N_noxref_1_c_2_p N_noxref_2_c_266_n ) capacitor c=0.00116632f //x=4.93 \
 //y=2.26 //x2=5 //y2=1.305
cc_3 ( N_noxref_1_c_3_p N_noxref_2_c_266_n ) capacitor c=7.02188e-19 //x=4.93 \
 //y=2.26 //x2=5 //y2=1.305
cc_4 ( N_noxref_1_c_4_p N_noxref_2_c_266_n ) capacitor c=6.06305e-19 //x=4.735 \
 //y=1.085 //x2=5 //y2=1.305
cc_5 ( N_noxref_1_c_5_p N_noxref_2_c_266_n ) capacitor c=0.00328491f //x=4.735 \
 //y=1.43 //x2=5 //y2=1.305
cc_6 ( N_noxref_1_c_6_p N_noxref_2_c_266_n ) capacitor c=5.29726e-19 //x=5.11 \
 //y=0.93 //x2=5 //y2=1.305
cc_7 ( N_noxref_1_c_7_p N_noxref_2_c_266_n ) capacitor c=6.14781e-19 //x=5.11 \
 //y=1.585 //x2=5 //y2=1.305
cc_8 ( N_noxref_1_c_8_p N_noxref_2_c_266_n ) capacitor c=5.57259e-19 //x=5.265 \
 //y=1.085 //x2=5 //y2=1.305
cc_9 ( N_noxref_1_c_9_p N_noxref_2_c_266_n ) capacitor c=0.00212774f //x=5.265 \
 //y=1.43 //x2=5 //y2=1.305
cc_10 ( N_noxref_1_c_10_p N_noxref_2_c_275_n ) capacitor c=0.00445584f \
 //x=2.64 //y=1.75 //x2=5 //y2=1.75
cc_11 ( N_noxref_1_c_5_p N_noxref_2_c_275_n ) capacitor c=0.00109347f \
 //x=4.735 //y=1.43 //x2=5 //y2=1.75
cc_12 ( N_noxref_1_c_12_p N_noxref_2_c_275_n ) capacitor c=0.00314841f \
 //x=4.735 //y=1.74 //x2=5 //y2=1.75
cc_13 ( N_noxref_1_c_13_p N_noxref_2_c_275_n ) capacitor c=0.00309965f \
 //x=4.735 //y=2.095 //x2=5 //y2=1.75
cc_14 ( N_noxref_1_c_7_p N_noxref_2_c_275_n ) capacitor c=0.00674367f //x=5.11 \
 //y=1.585 //x2=5 //y2=1.75
cc_15 ( N_noxref_1_c_9_p N_noxref_2_c_275_n ) capacitor c=0.00253555f \
 //x=5.265 //y=1.43 //x2=5 //y2=1.75
cc_16 ( N_noxref_1_c_9_p N_noxref_2_c_281_n ) capacitor c=7.25274e-19 \
 //x=5.265 //y=1.43 //x2=5.885 //y2=1.835
cc_17 ( N_noxref_1_c_17_p N_noxref_2_c_282_n ) capacitor c=0.00351497f \
 //x=2.995 //y=1.835 //x2=5.085 //y2=1.835
cc_18 ( N_noxref_1_c_18_p N_noxref_2_c_282_n ) capacitor c=0.00126129f \
 //x=4.93 //y=2.93 //x2=5.085 //y2=1.835
cc_19 ( N_noxref_1_c_2_p N_noxref_2_c_282_n ) capacitor c=0.016131f //x=4.93 \
 //y=2.26 //x2=5.085 //y2=1.835
cc_20 ( N_noxref_1_c_20_p N_noxref_2_c_282_n ) capacitor c=6.57311e-19 \
 //x=4.925 //y=2.77 //x2=5.085 //y2=1.835
cc_21 ( N_noxref_1_c_3_p N_noxref_2_c_282_n ) capacitor c=0.00293572f //x=4.93 \
 //y=2.26 //x2=5.085 //y2=1.835
cc_22 ( N_noxref_1_c_13_p N_noxref_2_c_282_n ) capacitor c=0.00107144f \
 //x=4.735 //y=2.095 //x2=5.085 //y2=1.835
cc_23 ( N_noxref_1_c_10_p N_noxref_2_c_288_n ) capacitor c=6.26629e-19 \
 //x=2.64 //y=1.75 //x2=5.97 //y2=1.75
cc_24 ( N_noxref_1_c_9_p N_noxref_2_c_288_n ) capacitor c=6.29838e-19 \
 //x=5.265 //y=1.43 //x2=5.97 //y2=1.75
cc_25 ( N_noxref_1_c_25_p N_noxref_2_c_290_n ) capacitor c=0.00204276f \
 //x=3.08 //y=2.61 //x2=6.41 //y2=2.61
cc_26 ( N_noxref_1_c_26_p N_noxref_2_c_290_n ) capacitor c=9.88422e-19 \
 //x=4.93 //y=2.61 //x2=6.41 //y2=2.61
cc_27 ( N_noxref_1_c_27_p N_noxref_2_c_292_n ) capacitor c=0.00293735f \
 //x=3.08 //y=5.295 //x2=6.41 //y2=5.305
cc_28 ( N_noxref_1_c_28_p N_noxref_2_c_292_n ) capacitor c=0.00558958f \
 //x=4.93 //y=4.765 //x2=6.41 //y2=5.305
cc_29 ( N_noxref_1_c_29_p N_noxref_2_c_292_n ) capacitor c=2.44646e-19 \
 //x=4.775 //y=4.885 //x2=6.41 //y2=5.305
cc_30 ( N_noxref_1_c_30_p N_noxref_2_c_295_n ) capacitor c=7.34073e-19 \
 //x=2.995 //y=5.38 //x2=5.925 //y2=5.39
cc_31 ( N_noxref_1_c_31_p N_noxref_2_c_296_n ) capacitor c=0.00250779f \
 //x=4.925 //y=2.77 //x2=6.405 //y2=2.77
cc_32 ( N_noxref_1_c_20_p N_noxref_2_c_297_n ) capacitor c=0.00540865f \
 //x=4.925 //y=2.77 //x2=6.565 //y2=2.77
cc_33 ( N_noxref_1_c_18_p N_noxref_2_M2_noxref_d ) capacitor c=3.24005e-19 \
 //x=4.93 //y=2.93 //x2=4.81 //y2=1.085
cc_34 ( N_noxref_1_c_2_p N_noxref_2_M2_noxref_d ) capacitor c=7.18966e-19 \
 //x=4.93 //y=2.26 //x2=4.81 //y2=1.085
cc_35 ( N_noxref_1_c_3_p N_noxref_2_M2_noxref_d ) capacitor c=0.00150225f \
 //x=4.93 //y=2.26 //x2=4.81 //y2=1.085
cc_36 ( N_noxref_1_c_4_p N_noxref_2_M2_noxref_d ) capacitor c=0.00124139f \
 //x=4.735 //y=1.085 //x2=4.81 //y2=1.085
cc_37 ( N_noxref_1_c_5_p N_noxref_2_M2_noxref_d ) capacitor c=0.00237422f \
 //x=4.735 //y=1.43 //x2=4.81 //y2=1.085
cc_38 ( N_noxref_1_c_13_p N_noxref_2_M2_noxref_d ) capacitor c=4.64713e-19 \
 //x=4.735 //y=2.095 //x2=4.81 //y2=1.085
cc_39 ( N_noxref_1_c_6_p N_noxref_2_M2_noxref_d ) capacitor c=0.00213893f \
 //x=5.11 //y=0.93 //x2=4.81 //y2=1.085
cc_40 ( N_noxref_1_c_7_p N_noxref_2_M2_noxref_d ) capacitor c=0.00345753f \
 //x=5.11 //y=1.585 //x2=4.81 //y2=1.085
cc_41 ( N_noxref_1_c_8_p N_noxref_2_M2_noxref_d ) capacitor c=0.00211919f \
 //x=5.265 //y=1.085 //x2=4.81 //y2=1.085
cc_42 ( N_noxref_1_c_9_p N_noxref_2_M2_noxref_d ) capacitor c=0.00237422f \
 //x=5.265 //y=1.43 //x2=4.81 //y2=1.085
cc_43 ( N_noxref_1_c_43_p N_VDD_c_512_n ) capacitor c=0.00648307f //x=2.485 \
 //y=5.38 //x2=4.965 //y2=7.585
cc_44 ( N_noxref_1_c_30_p N_VDD_c_512_n ) capacitor c=0.00488503f //x=2.995 \
 //y=5.38 //x2=4.965 //y2=7.585
cc_45 ( N_noxref_1_c_45_p N_VDD_c_512_n ) capacitor c=0.00368834f //x=1.72 \
 //y=5.56 //x2=4.965 //y2=7.585
cc_46 ( N_noxref_1_c_46_p N_VDD_c_512_n ) capacitor c=8.42709e-19 //x=2.6 \
 //y=5.38 //x2=4.965 //y2=7.585
cc_47 ( N_noxref_1_c_47_p N_VDD_c_512_n ) capacitor c=0.00285853f //x=2.6 \
 //y=5.56 //x2=4.965 //y2=7.585
cc_48 ( N_noxref_1_c_48_p N_VDD_c_512_n ) capacitor c=0.00224881f //x=1.72 \
 //y=5.56 //x2=4.965 //y2=7.585
cc_49 ( N_noxref_1_c_49_p N_VDD_c_512_n ) capacitor c=0.00224881f //x=2.6 \
 //y=5.56 //x2=4.965 //y2=7.585
cc_50 ( N_noxref_1_M9_noxref_g N_VDD_c_519_n ) capacitor c=0.00122608f \
 //x=4.83 //y=6.205 //x2=5.05 //y2=7.035
cc_51 ( N_noxref_1_M10_noxref_g N_VDD_c_519_n ) capacitor c=0.00122608f \
 //x=5.27 //y=6.205 //x2=5.05 //y2=7.035
cc_52 ( N_noxref_1_M9_noxref_g N_VDD_c_521_n ) capacitor c=0.00205385f \
 //x=4.83 //y=6.205 //x2=5.05 //y2=7.41
cc_53 ( N_noxref_1_M10_noxref_g N_VDD_c_521_n ) capacitor c=0.00294739f \
 //x=5.27 //y=6.205 //x2=5.05 //y2=7.41
cc_54 ( N_noxref_1_c_43_p N_VDD_c_523_n ) capacitor c=0.00213203f //x=2.485 \
 //y=5.38 //x2=2.075 //y2=7.585
cc_55 ( N_noxref_1_c_45_p N_VDD_c_523_n ) capacitor c=9.99055e-19 //x=1.72 \
 //y=5.56 //x2=2.075 //y2=7.585
cc_56 ( N_noxref_1_c_48_p N_VDD_c_523_n ) capacitor c=0.0136705f //x=1.72 \
 //y=5.56 //x2=2.075 //y2=7.585
cc_57 ( N_noxref_1_c_43_p N_VDD_c_526_n ) capacitor c=0.00184541f //x=2.485 \
 //y=5.38 //x2=2.955 //y2=7.585
cc_58 ( N_noxref_1_c_30_p N_VDD_c_526_n ) capacitor c=0.00213203f //x=2.995 \
 //y=5.38 //x2=2.955 //y2=7.585
cc_59 ( N_noxref_1_c_46_p N_VDD_c_526_n ) capacitor c=5.39459e-19 //x=2.6 \
 //y=5.38 //x2=2.955 //y2=7.585
cc_60 ( N_noxref_1_c_47_p N_VDD_c_526_n ) capacitor c=5.77976e-19 //x=2.6 \
 //y=5.56 //x2=2.955 //y2=7.585
cc_61 ( N_noxref_1_c_49_p N_VDD_c_526_n ) capacitor c=0.0136705f //x=2.6 \
 //y=5.56 //x2=2.955 //y2=7.585
cc_62 ( N_noxref_1_M9_noxref_g N_VDD_c_531_n ) capacitor c=0.00720181f \
 //x=4.83 //y=6.205 //x2=6.98 //y2=7.585
cc_63 ( N_noxref_1_M10_noxref_g N_VDD_c_531_n ) capacitor c=0.00760847f \
 //x=5.27 //y=6.205 //x2=6.98 //y2=7.585
cc_64 ( N_noxref_1_c_27_p N_VDD_c_533_n ) capacitor c=0.00197052f //x=3.08 \
 //y=5.295 //x2=1.23 //y2=7.58
cc_65 ( N_noxref_1_c_45_p N_VDD_c_533_n ) capacitor c=6.39392e-19 //x=1.72 \
 //y=5.56 //x2=1.23 //y2=7.58
cc_66 ( N_noxref_1_c_48_p N_VDD_c_533_n ) capacitor c=0.0064135f //x=1.72 \
 //y=5.56 //x2=1.23 //y2=7.58
cc_67 ( N_noxref_1_c_27_p N_VDD_c_536_n ) capacitor c=0.0305833f //x=3.08 \
 //y=5.295 //x2=3.82 //y2=7.585
cc_68 ( N_noxref_1_c_28_p N_VDD_c_536_n ) capacitor c=0.00722719f //x=4.93 \
 //y=4.765 //x2=3.82 //y2=7.585
cc_69 ( N_noxref_1_c_46_p N_VDD_c_536_n ) capacitor c=0.00240948f //x=2.6 \
 //y=5.38 //x2=3.82 //y2=7.585
cc_70 ( N_noxref_1_c_47_p N_VDD_c_536_n ) capacitor c=4.09141e-19 //x=2.6 \
 //y=5.56 //x2=3.82 //y2=7.585
cc_71 ( N_noxref_1_c_71_p N_VDD_c_536_n ) capacitor c=0.00344941f //x=4.775 \
 //y=4.885 //x2=3.82 //y2=7.585
cc_72 ( N_noxref_1_c_72_p N_VDD_c_536_n ) capacitor c=0.00259242f //x=4.765 \
 //y=2.77 //x2=3.82 //y2=7.585
cc_73 ( N_noxref_1_c_49_p N_VDD_c_536_n ) capacitor c=0.0101448f //x=2.6 \
 //y=5.56 //x2=3.82 //y2=7.585
cc_74 ( N_noxref_1_c_29_p N_VDD_c_536_n ) capacitor c=0.00643194f //x=4.775 \
 //y=4.885 //x2=3.82 //y2=7.585
cc_75 ( N_noxref_1_M9_noxref_g N_VDD_c_536_n ) capacitor c=0.00898416f \
 //x=4.83 //y=6.205 //x2=3.82 //y2=7.585
cc_76 ( N_noxref_1_c_76_p N_VDD_c_536_n ) capacitor c=0.00438848f //x=4.775 \
 //y=4.885 //x2=3.82 //y2=7.585
cc_77 ( N_noxref_1_c_29_p N_VDD_c_546_n ) capacitor c=3.49022e-19 //x=4.775 \
 //y=4.885 //x2=7.15 //y2=7.585
cc_78 ( N_noxref_1_c_48_p N_VDD_c_547_n ) capacitor c=0.00135089f //x=1.72 \
 //y=5.56 //x2=8.63 //y2=7.58
cc_79 ( N_noxref_1_c_49_p N_VDD_c_547_n ) capacitor c=0.00135089f //x=2.6 \
 //y=5.56 //x2=8.63 //y2=7.58
cc_80 ( N_noxref_1_c_45_p N_VDD_M5_noxref_s ) capacitor c=0.062494f //x=1.72 \
 //y=5.56 //x2=1.145 //y2=5.2
cc_81 ( N_noxref_1_c_46_p N_VDD_M5_noxref_s ) capacitor c=6.52457e-19 //x=2.6 \
 //y=5.38 //x2=1.145 //y2=5.2
cc_82 ( N_noxref_1_c_48_p N_VDD_M5_noxref_s ) capacitor c=0.0906034f //x=1.72 \
 //y=5.56 //x2=1.145 //y2=5.2
cc_83 ( N_noxref_1_c_43_p N_VDD_M6_noxref_d ) capacitor c=0.00810252f \
 //x=2.485 //y=5.38 //x2=2.015 //y2=5.2
cc_84 ( N_noxref_1_c_45_p N_VDD_M6_noxref_d ) capacitor c=0.0043528f //x=1.72 \
 //y=5.56 //x2=2.015 //y2=5.2
cc_85 ( N_noxref_1_c_47_p N_VDD_M6_noxref_d ) capacitor c=0.0043528f //x=2.6 \
 //y=5.56 //x2=2.015 //y2=5.2
cc_86 ( N_noxref_1_c_48_p N_VDD_M6_noxref_d ) capacitor c=0.0654258f //x=1.72 \
 //y=5.56 //x2=2.015 //y2=5.2
cc_87 ( N_noxref_1_c_49_p N_VDD_M6_noxref_d ) capacitor c=0.0653553f //x=2.6 \
 //y=5.56 //x2=2.015 //y2=5.2
cc_88 ( N_noxref_1_c_30_p N_VDD_M8_noxref_d ) capacitor c=0.0100502f //x=2.995 \
 //y=5.38 //x2=2.895 //y2=5.2
cc_89 ( N_noxref_1_c_47_p N_VDD_M8_noxref_d ) capacitor c=0.00979407f //x=2.6 \
 //y=5.56 //x2=2.895 //y2=5.2
cc_90 ( N_noxref_1_c_90_p N_VDD_M8_noxref_d ) capacitor c=6.87256e-19 //x=3.08 \
 //y=2.77 //x2=2.895 //y2=5.2
cc_91 ( N_noxref_1_c_49_p N_VDD_M8_noxref_d ) capacitor c=0.0651828f //x=2.6 \
 //y=5.56 //x2=2.895 //y2=5.2
cc_92 ( N_noxref_1_c_31_p N_VDD_M9_noxref_d ) capacitor c=3.55297e-19 \
 //x=4.925 //y=2.77 //x2=4.905 //y2=5.205
cc_93 ( N_noxref_1_M9_noxref_g N_VDD_M9_noxref_d ) capacitor c=0.0130453f \
 //x=4.83 //y=6.205 //x2=4.905 //y2=5.205
cc_94 ( N_noxref_1_M10_noxref_g N_VDD_M9_noxref_d ) capacitor c=0.0142727f \
 //x=5.27 //y=6.205 //x2=4.905 //y2=5.205
cc_95 ( N_noxref_1_c_95_p N_VDD_M9_noxref_d ) capacitor c=0.00241874f \
 //x=5.195 //y=4.975 //x2=4.905 //y2=5.205
cc_96 ( N_noxref_1_c_25_p A ) capacitor c=0.00102483f //x=3.08 //y=2.61 \
 //x2=1.6 //y2=2.4
cc_97 ( N_noxref_1_c_27_p A ) capacitor c=0.00451861f //x=3.08 //y=5.295 \
 //x2=1.6 //y2=2.4
cc_98 ( N_noxref_1_c_45_p N_A_c_686_n ) capacitor c=0.0118546f //x=1.72 \
 //y=5.56 //x2=1.6 //y2=4.88
cc_99 ( N_noxref_1_c_48_p N_A_c_686_n ) capacitor c=0.00165549f //x=1.72 \
 //y=5.56 //x2=1.6 //y2=4.88
cc_100 ( N_noxref_1_c_45_p N_A_c_688_n ) capacitor c=0.00277154f //x=1.72 \
 //y=5.56 //x2=1.6 //y2=4.88
cc_101 ( N_noxref_1_c_48_p N_A_c_688_n ) capacitor c=0.00377369f //x=1.72 \
 //y=5.56 //x2=1.6 //y2=4.88
cc_102 ( N_noxref_1_c_45_p N_A_M5_noxref_g ) capacitor c=0.0020878f //x=1.72 \
 //y=5.56 //x2=1.5 //y2=6.2
cc_103 ( N_noxref_1_c_48_p N_A_M5_noxref_g ) capacitor c=0.0158358f //x=1.72 \
 //y=5.56 //x2=1.5 //y2=6.2
cc_104 ( N_noxref_1_c_43_p N_A_M6_noxref_g ) capacitor c=0.0129249f //x=2.485 \
 //y=5.38 //x2=1.94 //y2=6.2
cc_105 ( N_noxref_1_c_45_p N_A_M6_noxref_g ) capacitor c=0.00192712f //x=1.72 \
 //y=5.56 //x2=1.94 //y2=6.2
cc_106 ( N_noxref_1_c_48_p N_A_M6_noxref_g ) capacitor c=0.0178987f //x=1.72 \
 //y=5.56 //x2=1.94 //y2=6.2
cc_107 ( N_noxref_1_c_45_p N_A_c_695_n ) capacitor c=0.00207241f //x=1.72 \
 //y=5.56 //x2=1.6 //y2=4.88
cc_108 ( N_noxref_1_c_48_p N_A_c_695_n ) capacitor c=0.0043218f //x=1.72 \
 //y=5.56 //x2=1.6 //y2=4.88
cc_109 ( N_noxref_1_c_17_p N_GND_c_782_n ) capacitor c=0.00654514f //x=2.995 \
 //y=1.835 //x2=8.63 //y2=0.18
cc_110 ( N_noxref_1_c_110_p N_GND_c_782_n ) capacitor c=5.98224e-19 //x=3.08 \
 //y=2.93 //x2=8.63 //y2=0.18
cc_111 ( N_noxref_1_c_18_p N_GND_c_782_n ) capacitor c=3.68425e-19 //x=4.93 \
 //y=2.93 //x2=8.63 //y2=0.18
cc_112 ( N_noxref_1_c_1_p N_GND_c_782_n ) capacitor c=0.00964814f //x=2.64 \
 //y=1.18 //x2=8.63 //y2=0.18
cc_113 ( N_noxref_1_c_2_p N_GND_c_782_n ) capacitor c=8.84449e-19 //x=4.93 \
 //y=2.26 //x2=8.63 //y2=0.18
cc_114 ( N_noxref_1_M1_noxref_d N_GND_c_782_n ) capacitor c=3.01769e-19 \
 //x=2.45 //y=1.085 //x2=8.63 //y2=0.18
cc_115 ( N_noxref_1_c_45_p N_GND_c_788_n ) capacitor c=8.63752e-19 //x=1.72 \
 //y=5.56 //x2=1.67 //y2=1.135
cc_116 ( N_noxref_1_c_1_p N_GND_c_788_n ) capacitor c=0.0141894f //x=2.64 \
 //y=1.18 //x2=1.67 //y2=1.135
cc_117 ( N_noxref_1_M1_noxref_d N_GND_c_788_n ) capacitor c=2.93544e-19 \
 //x=2.45 //y=1.085 //x2=1.67 //y2=1.135
cc_118 ( N_noxref_1_c_17_p N_GND_c_791_n ) capacitor c=7.75992e-19 //x=2.995 \
 //y=1.835 //x2=3.65 //y2=0.175
cc_119 ( N_noxref_1_c_110_p N_GND_c_791_n ) capacitor c=4.78337e-19 //x=3.08 \
 //y=2.93 //x2=3.65 //y2=0.175
cc_120 ( N_noxref_1_c_25_p N_GND_c_793_n ) capacitor c=0.00139243f //x=3.08 \
 //y=2.61 //x2=1.23 //y2=0.18
cc_121 ( N_noxref_1_c_90_p N_GND_c_793_n ) capacitor c=0.00133285f //x=3.08 \
 //y=2.77 //x2=1.23 //y2=0.18
cc_122 ( N_noxref_1_c_18_p N_GND_c_795_n ) capacitor c=9.53261e-19 //x=4.93 \
 //y=2.93 //x2=5.4 //y2=0.71
cc_123 ( N_noxref_1_c_2_p N_GND_c_795_n ) capacitor c=0.0010437f //x=4.93 \
 //y=2.26 //x2=5.4 //y2=0.71
cc_124 ( N_noxref_1_c_3_p N_GND_c_795_n ) capacitor c=6.77674e-19 //x=4.93 \
 //y=2.26 //x2=5.4 //y2=0.71
cc_125 ( N_noxref_1_c_4_p N_GND_c_795_n ) capacitor c=0.0211758f //x=4.735 \
 //y=1.085 //x2=5.4 //y2=0.71
cc_126 ( N_noxref_1_c_13_p N_GND_c_795_n ) capacitor c=2.1838e-19 //x=4.735 \
 //y=2.095 //x2=5.4 //y2=0.71
cc_127 ( N_noxref_1_c_8_p N_GND_c_795_n ) capacitor c=0.00805599f //x=5.265 \
 //y=1.085 //x2=5.4 //y2=0.71
cc_128 ( N_noxref_1_c_10_p N_GND_c_801_n ) capacitor c=0.00271975f //x=2.64 \
 //y=1.75 //x2=3.82 //y2=0.175
cc_129 ( N_noxref_1_c_17_p N_GND_c_801_n ) capacitor c=0.0215295f //x=2.995 \
 //y=1.835 //x2=3.82 //y2=0.175
cc_130 ( N_noxref_1_c_110_p N_GND_c_801_n ) capacitor c=0.00422283f //x=3.08 \
 //y=2.93 //x2=3.82 //y2=0.175
cc_131 ( N_noxref_1_c_26_p N_GND_c_801_n ) capacitor c=0.00329573f //x=4.93 \
 //y=2.61 //x2=3.82 //y2=0.175
cc_132 ( N_noxref_1_c_18_p N_GND_c_801_n ) capacitor c=0.00307096f //x=4.93 \
 //y=2.93 //x2=3.82 //y2=0.175
cc_133 ( N_noxref_1_c_90_p N_GND_c_801_n ) capacitor c=0.0101451f //x=3.08 \
 //y=2.77 //x2=3.82 //y2=0.175
cc_134 ( N_noxref_1_c_31_p N_GND_c_801_n ) capacitor c=0.00512549f //x=4.925 \
 //y=2.77 //x2=3.82 //y2=0.175
cc_135 ( N_noxref_1_c_2_p N_GND_c_801_n ) capacitor c=0.00446799f //x=4.93 \
 //y=2.26 //x2=3.82 //y2=0.175
cc_136 ( N_noxref_1_c_72_p N_GND_c_801_n ) capacitor c=0.0239533f //x=4.765 \
 //y=2.77 //x2=3.82 //y2=0.175
cc_137 ( N_noxref_1_c_3_p N_GND_c_801_n ) capacitor c=0.00369203f //x=4.93 \
 //y=2.26 //x2=3.82 //y2=0.175
cc_138 ( N_noxref_1_c_13_p N_GND_c_801_n ) capacitor c=0.0101725f //x=4.735 \
 //y=2.095 //x2=3.82 //y2=0.175
cc_139 ( N_noxref_1_c_1_p N_GND_c_812_n ) capacitor c=2.83275e-19 //x=2.64 \
 //y=1.18 //x2=8.75 //y2=0.175
cc_140 ( N_noxref_1_c_1_p N_GND_M0_noxref_d ) capacitor c=2.82748e-19 //x=2.64 \
 //y=1.18 //x2=1.48 //y2=1.045
cc_141 ( N_noxref_1_c_72_p N_GND_M2_noxref_s ) capacitor c=0.00355168f \
 //x=4.765 //y=2.77 //x2=4.38 //y2=0.545
cc_142 ( N_noxref_1_c_4_p N_GND_M2_noxref_s ) capacitor c=0.0329097f //x=4.735 \
 //y=1.085 //x2=4.38 //y2=0.545
cc_143 ( N_noxref_1_c_8_p N_GND_M2_noxref_s ) capacitor c=0.00605785f \
 //x=5.265 //y=1.085 //x2=4.38 //y2=0.545
cc_144 ( N_noxref_1_c_9_p N_GND_M2_noxref_s ) capacitor c=0.00120103f \
 //x=5.265 //y=1.43 //x2=4.38 //y2=0.545
cc_145 ( N_noxref_1_c_25_p B ) capacitor c=0.0092434f //x=3.08 //y=2.61 \
 //x2=2.34 //y2=2.4
cc_146 ( N_noxref_1_c_110_p B ) capacitor c=0.0148501f //x=3.08 //y=2.93 \
 //x2=2.34 //y2=2.4
cc_147 ( N_noxref_1_c_27_p B ) capacitor c=0.0835322f //x=3.08 //y=5.295 \
 //x2=2.34 //y2=2.4
cc_148 ( N_noxref_1_c_26_p B ) capacitor c=6.36091e-19 //x=4.93 //y=2.61 \
 //x2=2.34 //y2=2.4
cc_149 ( N_noxref_1_c_28_p B ) capacitor c=0.00287531f //x=4.93 //y=4.765 \
 //x2=2.34 //y2=2.4
cc_150 ( N_noxref_1_c_90_p B ) capacitor c=5.82756e-19 //x=3.08 //y=2.77 \
 //x2=2.34 //y2=2.4
cc_151 ( N_noxref_1_c_151_p B ) capacitor c=0.00687503f //x=3.24 //y=2.77 \
 //x2=2.34 //y2=2.4
cc_152 ( N_noxref_1_c_43_p N_B_c_981_n ) capacitor c=0.0228479f //x=2.485 \
 //y=5.38 //x2=2.34 //y2=4.735
cc_153 ( N_noxref_1_c_27_p N_B_c_981_n ) capacitor c=0.016905f //x=3.08 \
 //y=5.295 //x2=2.34 //y2=4.735
cc_154 ( N_noxref_1_c_43_p N_B_c_983_n ) capacitor c=2.77624e-19 //x=2.485 \
 //y=5.38 //x2=2.34 //y2=2.26
cc_155 ( N_noxref_1_c_25_p N_B_c_983_n ) capacitor c=0.015397f //x=3.08 \
 //y=2.61 //x2=2.34 //y2=2.26
cc_156 ( N_noxref_1_c_25_p N_B_c_985_n ) capacitor c=9.90728e-19 //x=3.08 \
 //y=2.61 //x2=2.34 //y2=2.26
cc_157 ( N_noxref_1_c_43_p N_B_c_986_n ) capacitor c=0.00469257f //x=2.485 \
 //y=5.38 //x2=2.37 //y2=4.88
cc_158 ( N_noxref_1_c_27_p N_B_c_986_n ) capacitor c=0.00342433f //x=3.08 \
 //y=5.295 //x2=2.37 //y2=4.88
cc_159 ( N_noxref_1_c_43_p N_B_M7_noxref_g ) capacitor c=0.00842859f //x=2.485 \
 //y=5.38 //x2=2.38 //y2=6.2
cc_160 ( N_noxref_1_c_46_p N_B_M7_noxref_g ) capacitor c=0.00192712f //x=2.6 \
 //y=5.38 //x2=2.38 //y2=6.2
cc_161 ( N_noxref_1_c_49_p N_B_M7_noxref_g ) capacitor c=0.0178987f //x=2.6 \
 //y=5.56 //x2=2.38 //y2=6.2
cc_162 ( N_noxref_1_c_30_p N_B_M8_noxref_g ) capacitor c=0.0115937f //x=2.995 \
 //y=5.38 //x2=2.82 //y2=6.2
cc_163 ( N_noxref_1_c_46_p N_B_M8_noxref_g ) capacitor c=0.00298276f //x=2.6 \
 //y=5.38 //x2=2.82 //y2=6.2
cc_164 ( N_noxref_1_c_49_p N_B_M8_noxref_g ) capacitor c=0.0178506f //x=2.6 \
 //y=5.56 //x2=2.82 //y2=6.2
cc_165 ( N_noxref_1_c_1_p N_B_c_994_n ) capacitor c=0.00120406f //x=2.64 \
 //y=1.18 //x2=2.375 //y2=1.085
cc_166 ( N_noxref_1_M1_noxref_d N_B_c_994_n ) capacitor c=0.00137165f //x=2.45 \
 //y=1.085 //x2=2.375 //y2=1.085
cc_167 ( N_noxref_1_c_10_p N_B_c_996_n ) capacitor c=0.00127432f //x=2.64 \
 //y=1.75 //x2=2.375 //y2=1.43
cc_168 ( N_noxref_1_c_1_p N_B_c_996_n ) capacitor c=0.00220847f //x=2.64 \
 //y=1.18 //x2=2.375 //y2=1.43
cc_169 ( N_noxref_1_M1_noxref_d N_B_c_996_n ) capacitor c=0.00237422f //x=2.45 \
 //y=1.085 //x2=2.375 //y2=1.43
cc_170 ( N_noxref_1_c_10_p N_B_c_999_n ) capacitor c=0.00454577f //x=2.64 \
 //y=1.75 //x2=2.375 //y2=1.74
cc_171 ( N_noxref_1_c_27_p N_B_c_1000_n ) capacitor c=0.00874009f //x=3.08 \
 //y=5.295 //x2=2.745 //y2=4.97
cc_172 ( N_noxref_1_c_46_p N_B_c_1000_n ) capacitor c=0.0020909f //x=2.6 \
 //y=5.38 //x2=2.745 //y2=4.97
cc_173 ( N_noxref_1_c_49_p N_B_c_1000_n ) capacitor c=0.00291714f //x=2.6 \
 //y=5.56 //x2=2.745 //y2=4.97
cc_174 ( N_noxref_1_c_1_p N_B_c_1003_n ) capacitor c=5.50523e-19 //x=2.64 \
 //y=1.18 //x2=2.75 //y2=0.93
cc_175 ( N_noxref_1_M1_noxref_d N_B_c_1003_n ) capacitor c=0.0020782f //x=2.45 \
 //y=1.085 //x2=2.75 //y2=0.93
cc_176 ( N_noxref_1_c_10_p N_B_c_1005_n ) capacitor c=0.00912818f //x=2.64 \
 //y=1.75 //x2=2.75 //y2=1.585
cc_177 ( N_noxref_1_c_17_p N_B_c_1005_n ) capacitor c=0.00194324f //x=2.995 \
 //y=1.835 //x2=2.75 //y2=1.585
cc_178 ( N_noxref_1_c_1_p N_B_c_1005_n ) capacitor c=5.67071e-19 //x=2.64 \
 //y=1.18 //x2=2.75 //y2=1.585
cc_179 ( N_noxref_1_M1_noxref_d N_B_c_1005_n ) capacitor c=0.00356097f \
 //x=2.45 //y=1.085 //x2=2.75 //y2=1.585
cc_180 ( N_noxref_1_c_1_p N_B_c_1009_n ) capacitor c=0.0010954f //x=2.64 \
 //y=1.18 //x2=2.905 //y2=1.085
cc_181 ( N_noxref_1_M1_noxref_d N_B_c_1009_n ) capacitor c=8.50095e-19 \
 //x=2.45 //y=1.085 //x2=2.905 //y2=1.085
cc_182 ( N_noxref_1_c_10_p N_B_c_1011_n ) capacitor c=0.00305472f //x=2.64 \
 //y=1.75 //x2=2.905 //y2=1.43
cc_183 ( N_noxref_1_c_17_p N_B_c_1011_n ) capacitor c=0.00323005f //x=2.995 \
 //y=1.835 //x2=2.905 //y2=1.43
cc_184 ( N_noxref_1_c_1_p N_B_c_1011_n ) capacitor c=0.00314842f //x=2.64 \
 //y=1.18 //x2=2.905 //y2=1.43
cc_185 ( N_noxref_1_M1_noxref_d N_B_c_1011_n ) capacitor c=0.00237422f \
 //x=2.45 //y=1.085 //x2=2.905 //y2=1.43
cc_186 ( N_noxref_1_c_25_p N_B_c_1015_n ) capacitor c=0.00285392f //x=3.08 \
 //y=2.61 //x2=2.34 //y2=2.26
cc_187 ( N_noxref_1_c_10_p N_B_c_1016_n ) capacitor c=0.00371023f //x=2.64 \
 //y=1.75 //x2=2.34 //y2=2.095
cc_188 ( N_noxref_1_c_25_p N_B_c_1016_n ) capacitor c=0.00341496f //x=3.08 \
 //y=2.61 //x2=2.34 //y2=2.095
cc_189 ( N_noxref_1_c_43_p N_B_c_1018_n ) capacitor c=9.8107e-19 //x=2.485 \
 //y=5.38 //x2=2.37 //y2=4.88
cc_190 ( N_noxref_1_c_27_p N_B_c_1018_n ) capacitor c=0.00142201f //x=3.08 \
 //y=5.295 //x2=2.37 //y2=4.88
cc_191 ( N_noxref_1_c_18_p N_noxref_7_c_1081_n ) capacitor c=4.99553e-19 \
 //x=4.93 //y=2.93 //x2=5.37 //y2=5.39
cc_192 ( N_noxref_1_c_71_p N_noxref_7_c_1081_n ) capacitor c=0.0078395f \
 //x=4.775 //y=4.885 //x2=5.37 //y2=5.39
cc_193 ( N_noxref_1_c_29_p N_noxref_7_c_1081_n ) capacitor c=0.00104675f \
 //x=4.775 //y=4.885 //x2=5.37 //y2=5.39
cc_194 ( N_noxref_1_M9_noxref_g N_noxref_7_c_1081_n ) capacitor c=0.00996264f \
 //x=4.83 //y=6.205 //x2=5.37 //y2=5.39
cc_195 ( N_noxref_1_M10_noxref_g N_noxref_7_c_1081_n ) capacitor c=0.00967241f \
 //x=5.27 //y=6.205 //x2=5.37 //y2=5.39
cc_196 ( N_noxref_1_c_95_p N_noxref_7_c_1081_n ) capacitor c=0.00189892f \
 //x=5.195 //y=4.975 //x2=5.37 //y2=5.39
cc_197 ( N_noxref_1_c_30_p N_noxref_7_c_1087_n ) capacitor c=0.00408808f \
 //x=2.995 //y=5.38 //x2=4.61 //y2=5.39
cc_198 ( N_noxref_1_c_46_p N_noxref_7_c_1087_n ) capacitor c=0.00518363f \
 //x=2.6 //y=5.38 //x2=4.61 //y2=5.39
cc_199 ( N_noxref_1_c_47_p N_noxref_7_c_1087_n ) capacitor c=3.28075e-19 \
 //x=2.6 //y=5.56 //x2=4.61 //y2=5.39
cc_200 ( N_noxref_1_c_71_p N_noxref_7_c_1087_n ) capacitor c=0.0243045f \
 //x=4.775 //y=4.885 //x2=4.61 //y2=5.39
cc_201 ( N_noxref_1_c_29_p N_noxref_7_c_1087_n ) capacitor c=0.00565356f \
 //x=4.775 //y=4.885 //x2=4.61 //y2=5.39
cc_202 ( N_noxref_1_M9_noxref_g N_noxref_7_c_1087_n ) capacitor c=0.00403872f \
 //x=4.83 //y=6.205 //x2=4.61 //y2=5.39
cc_203 ( N_noxref_1_c_76_p N_noxref_7_c_1087_n ) capacitor c=9.12041e-19 \
 //x=4.775 //y=4.885 //x2=4.61 //y2=5.39
cc_204 ( N_noxref_1_M10_noxref_g N_noxref_7_c_1094_n ) capacitor c=0.0018094f \
 //x=5.27 //y=6.205 //x2=5.49 //y2=5.39
cc_205 ( N_noxref_1_M10_noxref_g N_noxref_7_c_1095_n ) capacitor c=0.00180782f \
 //x=5.27 //y=6.205 //x2=5.49 //y2=6.92
cc_206 ( N_noxref_1_c_71_p N_noxref_7_c_1096_n ) capacitor c=0.00154424f \
 //x=4.775 //y=4.885 //x2=4.61 //y2=5.56
cc_207 ( N_noxref_1_c_29_p N_noxref_7_c_1096_n ) capacitor c=0.00126834f \
 //x=4.775 //y=4.885 //x2=4.61 //y2=5.56
cc_208 ( N_noxref_1_M9_noxref_g N_noxref_7_c_1096_n ) capacitor c=0.0483843f \
 //x=4.83 //y=6.205 //x2=4.61 //y2=5.56
cc_209 ( N_noxref_1_c_76_p N_noxref_7_c_1096_n ) capacitor c=0.00297041f \
 //x=4.775 //y=4.885 //x2=4.61 //y2=5.56
cc_210 ( N_noxref_1_M10_noxref_g N_noxref_7_c_1100_n ) capacitor c=0.0170175f \
 //x=5.27 //y=6.205 //x2=5.49 //y2=5.56
cc_211 ( N_noxref_1_M9_noxref_g N_noxref_7_M9_noxref_s ) capacitor \
 c=0.00378422f //x=4.83 //y=6.205 //x2=4.475 //y2=5.205
cc_212 ( N_noxref_1_c_25_p C ) capacitor c=6.64067e-19 //x=3.08 //y=2.61 \
 //x2=5.67 //y2=2.4
cc_213 ( N_noxref_1_c_27_p C ) capacitor c=0.00350333f //x=3.08 //y=5.295 \
 //x2=5.67 //y2=2.4
cc_214 ( N_noxref_1_c_26_p C ) capacitor c=0.00883287f //x=4.93 //y=2.61 \
 //x2=5.67 //y2=2.4
cc_215 ( N_noxref_1_c_18_p C ) capacitor c=0.0146933f //x=4.93 //y=2.93 \
 //x2=5.67 //y2=2.4
cc_216 ( N_noxref_1_c_28_p C ) capacitor c=0.0472911f //x=4.93 //y=4.765 \
 //x2=5.67 //y2=2.4
cc_217 ( N_noxref_1_c_31_p C ) capacitor c=5.52402e-19 //x=4.925 //y=2.77 \
 //x2=5.67 //y2=2.4
cc_218 ( N_noxref_1_c_20_p C ) capacitor c=0.00359337f //x=4.925 //y=2.77 \
 //x2=5.67 //y2=2.4
cc_219 ( N_noxref_1_c_3_p C ) capacitor c=2.61947e-19 //x=4.93 //y=2.26 \
 //x2=5.67 //y2=2.4
cc_220 ( N_noxref_1_c_2_p N_C_c_1184_n ) capacitor c=0.0217252f //x=4.93 \
 //y=2.26 //x2=5.67 //y2=2.26
cc_221 ( N_noxref_1_c_3_p N_C_c_1184_n ) capacitor c=5.41079e-19 //x=4.93 \
 //y=2.26 //x2=5.67 //y2=2.26
cc_222 ( N_noxref_1_c_13_p N_C_c_1184_n ) capacitor c=0.00178181f //x=4.735 \
 //y=2.095 //x2=5.67 //y2=2.26
cc_223 ( N_noxref_1_c_71_p N_C_c_1187_n ) capacitor c=0.0485099f //x=4.775 \
 //y=4.885 //x2=5.705 //y2=4.885
cc_224 ( N_noxref_1_c_29_p N_C_c_1187_n ) capacitor c=0.00105182f //x=4.775 \
 //y=4.885 //x2=5.705 //y2=4.885
cc_225 ( N_noxref_1_c_95_p N_C_c_1187_n ) capacitor c=0.00107587f //x=5.195 \
 //y=4.975 //x2=5.705 //y2=4.885
cc_226 ( N_noxref_1_c_26_p N_C_c_1190_n ) capacitor c=2.61947e-19 //x=4.93 \
 //y=2.61 //x2=5.67 //y2=2.26
cc_227 ( N_noxref_1_c_2_p N_C_c_1190_n ) capacitor c=5.24865e-19 //x=4.93 \
 //y=2.26 //x2=5.67 //y2=2.26
cc_228 ( N_noxref_1_c_3_p N_C_c_1190_n ) capacitor c=0.00445529f //x=4.93 \
 //y=2.26 //x2=5.67 //y2=2.26
cc_229 ( N_noxref_1_c_13_p N_C_c_1190_n ) capacitor c=0.00267961f //x=4.735 \
 //y=2.095 //x2=5.67 //y2=2.26
cc_230 ( N_noxref_1_c_71_p N_C_c_1194_n ) capacitor c=4.32488e-19 //x=4.775 \
 //y=4.885 //x2=5.705 //y2=4.885
cc_231 ( N_noxref_1_c_29_p N_C_c_1194_n ) capacitor c=0.00242589f //x=4.775 \
 //y=4.885 //x2=5.705 //y2=4.885
cc_232 ( N_noxref_1_c_95_p N_C_c_1194_n ) capacitor c=0.00116837f //x=5.195 \
 //y=4.975 //x2=5.705 //y2=4.885
cc_233 ( N_noxref_1_c_76_p N_C_c_1194_n ) capacitor c=0.00121814f //x=4.775 \
 //y=4.885 //x2=5.705 //y2=4.885
cc_234 ( N_noxref_1_M9_noxref_g N_C_M11_noxref_g ) capacitor c=0.0101077f \
 //x=4.83 //y=6.205 //x2=5.71 //y2=6.205
cc_235 ( N_noxref_1_M10_noxref_g N_C_M11_noxref_g ) capacitor c=0.109254f \
 //x=5.27 //y=6.205 //x2=5.71 //y2=6.205
cc_236 ( N_noxref_1_M10_noxref_g N_C_M12_noxref_g ) capacitor c=0.00945018f \
 //x=5.27 //y=6.205 //x2=6.15 //y2=6.205
cc_237 ( N_noxref_1_c_4_p N_C_c_1201_n ) capacitor c=0.00125788f //x=4.735 \
 //y=1.085 //x2=5.705 //y2=1.085
cc_238 ( N_noxref_1_c_8_p N_C_c_1201_n ) capacitor c=0.0126654f //x=5.265 \
 //y=1.085 //x2=5.705 //y2=1.085
cc_239 ( N_noxref_1_c_5_p N_C_c_1203_n ) capacitor c=0.00149727f //x=4.735 \
 //y=1.43 //x2=5.705 //y2=1.435
cc_240 ( N_noxref_1_c_12_p N_C_c_1203_n ) capacitor c=0.00111802f //x=4.735 \
 //y=1.74 //x2=5.705 //y2=1.435
cc_241 ( N_noxref_1_c_9_p N_C_c_1203_n ) capacitor c=0.0126654f //x=5.265 \
 //y=1.43 //x2=5.705 //y2=1.435
cc_242 ( N_noxref_1_c_12_p N_C_c_1206_n ) capacitor c=0.00116305f //x=4.735 \
 //y=1.74 //x2=5.705 //y2=1.74
cc_243 ( N_noxref_1_c_9_p N_C_c_1206_n ) capacitor c=0.00938322f //x=5.265 \
 //y=1.43 //x2=5.705 //y2=1.74
cc_244 ( N_noxref_1_c_9_p N_C_c_1208_n ) capacitor c=0.00131492f //x=5.265 \
 //y=1.43 //x2=6.08 //y2=1.585
cc_245 ( N_noxref_1_c_8_p N_C_c_1209_n ) capacitor c=0.00132934f //x=5.265 \
 //y=1.085 //x2=6.235 //y2=1.085
cc_246 ( N_noxref_1_c_9_p N_C_c_1210_n ) capacitor c=0.00151998f //x=5.265 \
 //y=1.43 //x2=6.235 //y2=1.435
cc_247 ( N_noxref_1_c_2_p N_C_c_1211_n ) capacitor c=0.00173144f //x=4.93 \
 //y=2.26 //x2=5.67 //y2=2.26
cc_248 ( N_noxref_1_c_3_p N_C_c_1211_n ) capacitor c=0.00266443f //x=4.93 \
 //y=2.26 //x2=5.67 //y2=2.26
cc_249 ( N_noxref_1_c_13_p N_C_c_1211_n ) capacitor c=0.0181449f //x=4.735 \
 //y=2.095 //x2=5.67 //y2=2.26
cc_250 ( N_noxref_1_c_13_p N_C_c_1214_n ) capacitor c=0.00636965f //x=4.735 \
 //y=2.095 //x2=5.67 //y2=2.095
cc_251 ( N_noxref_1_c_28_p N_C_c_1215_n ) capacitor c=0.00117265f //x=4.93 \
 //y=4.765 //x2=5.705 //y2=4.885
cc_252 ( N_noxref_1_c_71_p N_C_c_1215_n ) capacitor c=4.8456e-19 //x=4.775 \
 //y=4.885 //x2=5.705 //y2=4.885
cc_253 ( N_noxref_1_c_29_p N_C_c_1215_n ) capacitor c=0.00211373f //x=4.775 \
 //y=4.885 //x2=5.705 //y2=4.885
cc_254 ( N_noxref_1_c_95_p N_C_c_1215_n ) capacitor c=0.0203928f //x=5.195 \
 //y=4.975 //x2=5.705 //y2=4.885
cc_255 ( N_noxref_1_c_76_p N_C_c_1215_n ) capacitor c=0.00590438f //x=4.775 \
 //y=4.885 //x2=5.705 //y2=4.885
cc_256 ( N_noxref_1_c_256_p N_noxref_10_c_1376_n ) capacitor c=0.0103386f \
 //x=2.725 //y=1.835 //x2=2.155 //y2=1.675
cc_257 ( N_noxref_1_c_17_p N_noxref_10_c_1377_n ) capacitor c=0.00373013f \
 //x=2.995 //y=1.835 //x2=3.04 //y2=0.71
cc_258 ( N_noxref_1_c_1_p N_noxref_10_c_1377_n ) capacitor c=0.00367971f \
 //x=2.64 //y=1.18 //x2=3.04 //y2=0.71
cc_259 ( N_noxref_1_M1_noxref_d N_noxref_10_c_1377_n ) capacitor c=0.00910163f \
 //x=2.45 //y=1.085 //x2=3.04 //y2=0.71
cc_260 ( N_noxref_1_c_10_p N_noxref_10_M0_noxref_s ) capacitor c=0.0173667f \
 //x=2.64 //y=1.75 //x2=1.05 //y2=0.545
cc_261 ( N_noxref_1_c_17_p N_noxref_10_M0_noxref_s ) capacitor c=0.0055349f \
 //x=2.995 //y=1.835 //x2=1.05 //y2=0.545
cc_262 ( N_noxref_1_c_110_p N_noxref_10_M0_noxref_s ) capacitor c=7.86324e-19 \
 //x=3.08 //y=2.93 //x2=1.05 //y2=0.545
cc_263 ( N_noxref_1_c_1_p N_noxref_10_M0_noxref_s ) capacitor c=0.00907053f \
 //x=2.64 //y=1.18 //x2=1.05 //y2=0.545
cc_264 ( N_noxref_1_c_90_p N_noxref_10_M0_noxref_s ) capacitor c=0.00202552f \
 //x=3.08 //y=2.77 //x2=1.05 //y2=0.545
cc_265 ( N_noxref_1_M1_noxref_d N_noxref_10_M0_noxref_s ) capacitor \
 c=0.0275552f //x=2.45 //y=1.085 //x2=1.05 //y2=0.545
cc_266 ( N_noxref_2_c_308_p N_VDD_c_565_n ) capacitor c=2.90144e-19 //x=6.325 \
 //y=5.39 //x2=8.63 //y2=7.58
cc_267 ( N_noxref_2_c_309_p N_VDD_c_565_n ) capacitor c=5.73169e-19 //x=7.89 \
 //y=4.76 //x2=8.63 //y2=7.58
cc_268 ( N_noxref_2_c_310_p N_VDD_c_565_n ) capacitor c=3.40755e-19 //x=7.89 \
 //y=4.88 //x2=8.63 //y2=7.58
cc_269 ( N_noxref_2_c_308_p N_VDD_c_531_n ) capacitor c=0.00153182f //x=6.325 \
 //y=5.39 //x2=6.98 //y2=7.585
cc_270 ( N_noxref_2_c_312_p N_VDD_c_531_n ) capacitor c=0.00513429f //x=5.93 \
 //y=5.56 //x2=6.98 //y2=7.585
cc_271 ( N_noxref_2_c_309_p N_VDD_c_570_n ) capacitor c=5.48929e-19 //x=7.89 \
 //y=4.76 //x2=8.62 //y2=7.585
cc_272 ( N_noxref_2_M13_noxref_g N_VDD_c_570_n ) capacitor c=0.00753931f \
 //x=8.045 //y=6.2 //x2=8.62 //y2=7.585
cc_273 ( N_noxref_2_M14_noxref_g N_VDD_c_570_n ) capacitor c=0.00755544f \
 //x=8.485 //y=6.2 //x2=8.62 //y2=7.585
cc_274 ( N_noxref_2_c_292_n N_VDD_c_536_n ) capacitor c=0.00125992f //x=6.41 \
 //y=5.305 //x2=3.82 //y2=7.585
cc_275 ( N_noxref_2_c_292_n N_VDD_c_546_n ) capacitor c=0.0282523f //x=6.41 \
 //y=5.305 //x2=7.15 //y2=7.585
cc_276 ( N_noxref_2_c_309_p N_VDD_c_546_n ) capacitor c=0.0155837f //x=7.89 \
 //y=4.76 //x2=7.15 //y2=7.585
cc_277 ( N_noxref_2_c_295_n N_VDD_c_546_n ) capacitor c=0.00263628f //x=5.925 \
 //y=5.39 //x2=7.15 //y2=7.585
cc_278 ( N_noxref_2_c_320_p N_VDD_c_546_n ) capacitor c=0.00261569f //x=7.725 \
 //y=2.77 //x2=7.15 //y2=7.585
cc_279 ( N_noxref_2_c_312_p N_VDD_c_546_n ) capacitor c=0.00923008f //x=5.93 \
 //y=5.56 //x2=7.15 //y2=7.585
cc_280 ( N_noxref_2_c_310_p N_VDD_c_546_n ) capacitor c=0.0079528f //x=7.89 \
 //y=4.88 //x2=7.15 //y2=7.585
cc_281 ( N_noxref_2_M13_noxref_g N_VDD_c_546_n ) capacitor c=0.00770587f \
 //x=8.045 //y=6.2 //x2=7.15 //y2=7.585
cc_282 ( N_noxref_2_c_324_p N_VDD_c_546_n ) capacitor c=0.00799922f //x=8.12 \
 //y=4.97 //x2=7.15 //y2=7.585
cc_283 ( N_noxref_2_c_312_p N_VDD_c_547_n ) capacitor c=2.32853e-19 //x=5.93 \
 //y=5.56 //x2=8.63 //y2=7.58
cc_284 ( N_noxref_2_c_310_p N_VDD_c_547_n ) capacitor c=0.00241457f //x=7.89 \
 //y=4.88 //x2=8.63 //y2=7.58
cc_285 ( N_noxref_2_c_327_p N_VDD_c_547_n ) capacitor c=0.0196838f //x=8.41 \
 //y=4.97 //x2=8.63 //y2=7.58
cc_286 ( N_noxref_2_c_312_p N_VDD_M9_noxref_d ) capacitor c=0.00560369f \
 //x=5.93 //y=5.56 //x2=4.905 //y2=5.205
cc_287 ( N_noxref_2_c_308_p N_VDD_M13_noxref_s ) capacitor c=0.00336564f \
 //x=6.325 //y=5.39 //x2=7.69 //y2=5.2
cc_288 ( N_noxref_2_c_330_p N_VDD_M13_noxref_s ) capacitor c=8.66431e-19 \
 //x=7.89 //y=2.93 //x2=7.69 //y2=5.2
cc_289 ( N_noxref_2_c_309_p N_VDD_M13_noxref_s ) capacitor c=0.0211971f \
 //x=7.89 //y=4.76 //x2=7.69 //y2=5.2
cc_290 ( N_noxref_2_c_295_n N_VDD_M13_noxref_s ) capacitor c=0.00573134f \
 //x=5.925 //y=5.39 //x2=7.69 //y2=5.2
cc_291 ( N_noxref_2_c_310_p N_VDD_M13_noxref_s ) capacitor c=0.00914073f \
 //x=7.89 //y=4.88 //x2=7.69 //y2=5.2
cc_292 ( N_noxref_2_M13_noxref_g N_VDD_M13_noxref_s ) capacitor c=0.0573441f \
 //x=8.045 //y=6.2 //x2=7.69 //y2=5.2
cc_293 ( N_noxref_2_c_324_p N_VDD_M13_noxref_s ) capacitor c=0.00527347f \
 //x=8.12 //y=4.97 //x2=7.69 //y2=5.2
cc_294 ( N_noxref_2_M14_noxref_g N_VDD_M14_noxref_d ) capacitor c=0.0572684f \
 //x=8.485 //y=6.2 //x2=8.56 //y2=5.2
cc_295 ( N_noxref_2_c_266_n N_GND_c_782_n ) capacitor c=0.00996669f //x=5 \
 //y=1.305 //x2=8.63 //y2=0.18
cc_296 ( N_noxref_2_c_281_n N_GND_c_782_n ) capacitor c=0.00677962f //x=5.885 \
 //y=1.835 //x2=8.63 //y2=0.18
cc_297 ( N_noxref_2_c_339_p N_GND_c_782_n ) capacitor c=0.0106318f //x=5.97 \
 //y=1.3 //x2=8.63 //y2=0.18
cc_298 ( N_noxref_2_c_340_p N_GND_c_782_n ) capacitor c=0.00667105f //x=6.325 \
 //y=1.835 //x2=8.63 //y2=0.18
cc_299 ( N_noxref_2_c_341_p N_GND_c_782_n ) capacitor c=6.41798e-19 //x=6.41 \
 //y=2.93 //x2=8.63 //y2=0.18
cc_300 ( N_noxref_2_c_330_p N_GND_c_782_n ) capacitor c=5.78966e-19 //x=7.89 \
 //y=2.93 //x2=8.63 //y2=0.18
cc_301 ( N_noxref_2_c_296_n N_GND_c_782_n ) capacitor c=5.1261e-19 //x=6.405 \
 //y=2.77 //x2=8.63 //y2=0.18
cc_302 ( N_noxref_2_c_344_p N_GND_c_782_n ) capacitor c=0.00249122f //x=7.89 \
 //y=2.265 //x2=8.63 //y2=0.18
cc_303 ( N_noxref_2_c_345_p N_GND_c_782_n ) capacitor c=7.5371e-19 //x=7.89 \
 //y=2.265 //x2=8.63 //y2=0.18
cc_304 ( N_noxref_2_M2_noxref_d N_GND_c_782_n ) capacitor c=3.01769e-19 \
 //x=4.81 //y=1.085 //x2=8.63 //y2=0.18
cc_305 ( N_noxref_2_M3_noxref_d N_GND_c_782_n ) capacitor c=3.01769e-19 \
 //x=5.78 //y=1.085 //x2=8.63 //y2=0.18
cc_306 ( N_noxref_2_c_266_n N_GND_c_788_n ) capacitor c=4.59693e-19 //x=5 \
 //y=1.305 //x2=1.67 //y2=1.135
cc_307 ( N_noxref_2_c_266_n N_GND_c_795_n ) capacitor c=0.00372564f //x=5 \
 //y=1.305 //x2=5.4 //y2=0.71
cc_308 ( N_noxref_2_c_281_n N_GND_c_795_n ) capacitor c=0.00128856f //x=5.885 \
 //y=1.835 //x2=5.4 //y2=0.71
cc_309 ( N_noxref_2_M2_noxref_d N_GND_c_795_n ) capacitor c=0.0124264f \
 //x=4.81 //y=1.085 //x2=5.4 //y2=0.71
cc_310 ( N_noxref_2_c_281_n N_GND_c_833_n ) capacitor c=0.00105223f //x=5.885 \
 //y=1.835 //x2=6.37 //y2=0.71
cc_311 ( N_noxref_2_c_339_p N_GND_c_833_n ) capacitor c=0.00469733f //x=5.97 \
 //y=1.3 //x2=6.37 //y2=0.71
cc_312 ( N_noxref_2_c_340_p N_GND_c_833_n ) capacitor c=0.00353984f //x=6.325 \
 //y=1.835 //x2=6.37 //y2=0.71
cc_313 ( N_noxref_2_M3_noxref_d N_GND_c_833_n ) capacitor c=0.0122548f \
 //x=5.78 //y=1.085 //x2=6.37 //y2=0.71
cc_314 ( N_noxref_2_c_341_p N_GND_c_837_n ) capacitor c=2.81168e-19 //x=6.41 \
 //y=2.93 //x2=6.98 //y2=0.175
cc_315 ( N_noxref_2_c_330_p N_GND_c_838_n ) capacitor c=2.22497e-19 //x=7.89 \
 //y=2.93 //x2=8.175 //y2=0.715
cc_316 ( N_noxref_2_c_344_p N_GND_c_838_n ) capacitor c=0.00114179f //x=7.89 \
 //y=2.265 //x2=8.175 //y2=0.715
cc_317 ( N_noxref_2_c_345_p N_GND_c_838_n ) capacitor c=3.95714e-19 //x=7.89 \
 //y=2.265 //x2=8.175 //y2=0.715
cc_318 ( N_noxref_2_c_360_p N_GND_c_838_n ) capacitor c=0.0125444f //x=8 \
 //y=1.09 //x2=8.175 //y2=0.715
cc_319 ( N_noxref_2_c_361_p N_GND_c_838_n ) capacitor c=2.1838e-19 //x=7.89 \
 //y=2.265 //x2=8.175 //y2=0.715
cc_320 ( N_noxref_2_c_362_p N_GND_c_843_n ) capacitor c=0.0134289f //x=8.53 \
 //y=1.09 //x2=8.665 //y2=0.715
cc_321 ( N_noxref_2_c_290_n N_GND_c_801_n ) capacitor c=9.32616e-19 //x=6.41 \
 //y=2.61 //x2=3.82 //y2=0.175
cc_322 ( N_noxref_2_c_288_n N_GND_c_845_n ) capacitor c=0.00304019f //x=5.97 \
 //y=1.75 //x2=7.15 //y2=0.175
cc_323 ( N_noxref_2_c_340_p N_GND_c_845_n ) capacitor c=0.0204135f //x=6.325 \
 //y=1.835 //x2=7.15 //y2=0.175
cc_324 ( N_noxref_2_c_341_p N_GND_c_845_n ) capacitor c=0.00489833f //x=6.41 \
 //y=2.93 //x2=7.15 //y2=0.175
cc_325 ( N_noxref_2_c_367_p N_GND_c_845_n ) capacitor c=0.00387755f //x=7.89 \
 //y=2.61 //x2=7.15 //y2=0.175
cc_326 ( N_noxref_2_c_330_p N_GND_c_845_n ) capacitor c=0.00492136f //x=7.89 \
 //y=2.93 //x2=7.15 //y2=0.175
cc_327 ( N_noxref_2_c_296_n N_GND_c_845_n ) capacitor c=0.0100365f //x=6.405 \
 //y=2.77 //x2=7.15 //y2=0.175
cc_328 ( N_noxref_2_c_370_p N_GND_c_845_n ) capacitor c=0.0100352f //x=7.885 \
 //y=2.77 //x2=7.15 //y2=0.175
cc_329 ( N_noxref_2_c_344_p N_GND_c_845_n ) capacitor c=0.00682461f //x=7.89 \
 //y=2.265 //x2=7.15 //y2=0.175
cc_330 ( N_noxref_2_c_320_p N_GND_c_845_n ) capacitor c=0.02319f //x=7.725 \
 //y=2.77 //x2=7.15 //y2=0.175
cc_331 ( N_noxref_2_c_345_p N_GND_c_845_n ) capacitor c=0.00733236f //x=7.89 \
 //y=2.265 //x2=7.15 //y2=0.175
cc_332 ( N_noxref_2_c_374_p N_GND_c_845_n ) capacitor c=0.00425509f //x=8 \
 //y=2.1 //x2=7.15 //y2=0.175
cc_333 ( N_noxref_2_c_361_p N_GND_c_845_n ) capacitor c=0.00786308f //x=7.89 \
 //y=2.265 //x2=7.15 //y2=0.175
cc_334 ( N_noxref_2_c_266_n N_GND_c_812_n ) capacitor c=3.01913e-19 //x=5 \
 //y=1.305 //x2=8.75 //y2=0.175
cc_335 ( N_noxref_2_c_339_p N_GND_c_812_n ) capacitor c=3.01913e-19 //x=5.97 \
 //y=1.3 //x2=8.75 //y2=0.175
cc_336 ( N_noxref_2_c_370_p N_GND_c_812_n ) capacitor c=0.00313158f //x=7.885 \
 //y=2.77 //x2=8.75 //y2=0.175
cc_337 ( N_noxref_2_c_345_p N_GND_c_812_n ) capacitor c=0.0022444f //x=7.89 \
 //y=2.265 //x2=8.75 //y2=0.175
cc_338 ( N_noxref_2_c_361_p N_GND_c_812_n ) capacitor c=2.63786e-19 //x=7.89 \
 //y=2.265 //x2=8.75 //y2=0.175
cc_339 ( N_noxref_2_c_266_n N_GND_M2_noxref_s ) capacitor c=0.00926082f //x=5 \
 //y=1.305 //x2=4.38 //y2=0.545
cc_340 ( N_noxref_2_c_275_n N_GND_M2_noxref_s ) capacitor c=0.0225586f //x=5 \
 //y=1.75 //x2=4.38 //y2=0.545
cc_341 ( N_noxref_2_c_281_n N_GND_M2_noxref_s ) capacitor c=0.00857623f \
 //x=5.885 //y=1.835 //x2=4.38 //y2=0.545
cc_342 ( N_noxref_2_c_339_p N_GND_M2_noxref_s ) capacitor c=0.00943435f \
 //x=5.97 //y=1.3 //x2=4.38 //y2=0.545
cc_343 ( N_noxref_2_c_288_n N_GND_M2_noxref_s ) capacitor c=0.0106843f \
 //x=5.97 //y=1.75 //x2=4.38 //y2=0.545
cc_344 ( N_noxref_2_c_340_p N_GND_M2_noxref_s ) capacitor c=0.00607462f \
 //x=6.325 //y=1.835 //x2=4.38 //y2=0.545
cc_345 ( N_noxref_2_c_341_p N_GND_M2_noxref_s ) capacitor c=8.06338e-19 \
 //x=6.41 //y=2.93 //x2=4.38 //y2=0.545
cc_346 ( N_noxref_2_c_296_n N_GND_M2_noxref_s ) capacitor c=0.00206188f \
 //x=6.405 //y=2.77 //x2=4.38 //y2=0.545
cc_347 ( N_noxref_2_M2_noxref_d N_GND_M2_noxref_s ) capacitor c=0.0297221f \
 //x=4.81 //y=1.085 //x2=4.38 //y2=0.545
cc_348 ( N_noxref_2_M3_noxref_d N_GND_M2_noxref_s ) capacitor c=0.029747f \
 //x=5.78 //y=1.085 //x2=4.38 //y2=0.545
cc_349 ( N_noxref_2_c_330_p N_GND_M4_noxref_s ) capacitor c=0.00171622f \
 //x=7.89 //y=2.93 //x2=7.645 //y2=0.55
cc_350 ( N_noxref_2_c_344_p N_GND_M4_noxref_s ) capacitor c=0.00297876f \
 //x=7.89 //y=2.265 //x2=7.645 //y2=0.55
cc_351 ( N_noxref_2_c_320_p N_GND_M4_noxref_s ) capacitor c=5.04197e-19 \
 //x=7.725 //y=2.77 //x2=7.645 //y2=0.55
cc_352 ( N_noxref_2_c_345_p N_GND_M4_noxref_s ) capacitor c=0.00651326f \
 //x=7.89 //y=2.265 //x2=7.645 //y2=0.55
cc_353 ( N_noxref_2_c_360_p N_GND_M4_noxref_s ) capacitor c=0.030052f //x=8 \
 //y=1.09 //x2=7.645 //y2=0.55
cc_354 ( N_noxref_2_c_396_p N_GND_M4_noxref_s ) capacitor c=0.002132f //x=8 \
 //y=1.745 //x2=7.645 //y2=0.55
cc_355 ( N_noxref_2_c_374_p N_GND_M4_noxref_s ) capacitor c=0.00304786f //x=8 \
 //y=2.1 //x2=7.645 //y2=0.55
cc_356 ( N_noxref_2_c_398_p N_GND_M4_noxref_s ) capacitor c=0.00517463f \
 //x=8.375 //y=0.935 //x2=7.645 //y2=0.55
cc_357 ( N_noxref_2_c_362_p N_GND_M4_noxref_s ) capacitor c=0.0153553f \
 //x=8.53 //y=1.09 //x2=7.645 //y2=0.55
cc_358 ( N_noxref_2_c_400_p N_GND_M4_noxref_s ) capacitor c=0.00629878f \
 //x=8.53 //y=1.435 //x2=7.645 //y2=0.55
cc_359 ( N_noxref_2_c_361_p N_GND_M4_noxref_s ) capacitor c=0.00659834f \
 //x=7.89 //y=2.265 //x2=7.645 //y2=0.55
cc_360 ( N_noxref_2_c_266_n N_noxref_7_c_1081_n ) capacitor c=2.92511e-19 \
 //x=5 //y=1.305 //x2=5.37 //y2=5.39
cc_361 ( N_noxref_2_c_282_n N_noxref_7_c_1081_n ) capacitor c=0.00265497f \
 //x=5.085 //y=1.835 //x2=5.37 //y2=5.39
cc_362 ( N_noxref_2_c_308_p N_noxref_7_c_1104_n ) capacitor c=0.00301289f \
 //x=6.325 //y=5.39 //x2=6.24 //y2=7.09
cc_363 ( N_noxref_2_c_295_n N_noxref_7_c_1104_n ) capacitor c=0.00513934f \
 //x=5.925 //y=5.39 //x2=6.24 //y2=7.09
cc_364 ( N_noxref_2_c_312_p N_noxref_7_c_1104_n ) capacitor c=0.00406191f \
 //x=5.93 //y=5.56 //x2=6.24 //y2=7.09
cc_365 ( N_noxref_2_c_295_n N_noxref_7_c_1087_n ) capacitor c=5.08928e-19 \
 //x=5.925 //y=5.39 //x2=4.61 //y2=5.39
cc_366 ( N_noxref_2_c_281_n N_noxref_7_c_1094_n ) capacitor c=0.00291211f \
 //x=5.885 //y=1.835 //x2=5.49 //y2=5.39
cc_367 ( N_noxref_2_c_295_n N_noxref_7_c_1094_n ) capacitor c=0.0514662f \
 //x=5.925 //y=5.39 //x2=5.49 //y2=5.39
cc_368 ( N_noxref_2_c_312_p N_noxref_7_c_1094_n ) capacitor c=0.00398527f \
 //x=5.93 //y=5.56 //x2=5.49 //y2=5.39
cc_369 ( N_noxref_2_c_308_p N_noxref_7_c_1111_n ) capacitor c=0.0056963f \
 //x=6.325 //y=5.39 //x2=6.37 //y2=6.92
cc_370 ( N_noxref_2_c_295_n N_noxref_7_c_1100_n ) capacitor c=0.00275395f \
 //x=5.925 //y=5.39 //x2=5.49 //y2=5.56
cc_371 ( N_noxref_2_c_312_p N_noxref_7_c_1100_n ) capacitor c=0.0684172f \
 //x=5.93 //y=5.56 //x2=5.49 //y2=5.56
cc_372 ( N_noxref_2_c_308_p N_noxref_7_M12_noxref_d ) capacitor c=0.00855426f \
 //x=6.325 //y=5.39 //x2=6.225 //y2=5.205
cc_373 ( N_noxref_2_c_296_n N_noxref_7_M12_noxref_d ) capacitor c=6.7951e-19 \
 //x=6.405 //y=2.77 //x2=6.225 //y2=5.205
cc_374 ( N_noxref_2_c_312_p N_noxref_7_M12_noxref_d ) capacitor c=0.0478913f \
 //x=5.93 //y=5.56 //x2=6.225 //y2=5.205
cc_375 ( N_noxref_2_c_290_n C ) capacitor c=0.00885866f //x=6.41 //y=2.61 \
 //x2=5.67 //y2=2.4
cc_376 ( N_noxref_2_c_341_p C ) capacitor c=0.0150092f //x=6.41 //y=2.93 \
 //x2=5.67 //y2=2.4
cc_377 ( N_noxref_2_c_292_n C ) capacitor c=0.0837427f //x=6.41 //y=5.305 \
 //x2=5.67 //y2=2.4
cc_378 ( N_noxref_2_c_367_p C ) capacitor c=6.51793e-19 //x=7.89 //y=2.61 \
 //x2=5.67 //y2=2.4
cc_379 ( N_noxref_2_c_309_p C ) capacitor c=0.00309401f //x=7.89 //y=4.76 \
 //x2=5.67 //y2=2.4
cc_380 ( N_noxref_2_c_296_n C ) capacitor c=5.52402e-19 //x=6.405 //y=2.77 \
 //x2=5.67 //y2=2.4
cc_381 ( N_noxref_2_c_297_n C ) capacitor c=0.00361323f //x=6.565 //y=2.77 \
 //x2=5.67 //y2=2.4
cc_382 ( N_noxref_2_c_281_n N_C_c_1184_n ) capacitor c=0.0306211f //x=5.885 \
 //y=1.835 //x2=5.67 //y2=2.26
cc_383 ( N_noxref_2_c_290_n N_C_c_1184_n ) capacitor c=0.0160491f //x=6.41 \
 //y=2.61 //x2=5.67 //y2=2.26
cc_384 ( N_noxref_2_c_281_n N_C_c_1187_n ) capacitor c=4.30382e-19 //x=5.885 \
 //y=1.835 //x2=5.705 //y2=4.885
cc_385 ( N_noxref_2_c_292_n N_C_c_1187_n ) capacitor c=0.0175188f //x=6.41 \
 //y=5.305 //x2=5.705 //y2=4.885
cc_386 ( N_noxref_2_c_295_n N_C_c_1187_n ) capacitor c=0.00207961f //x=5.925 \
 //y=5.39 //x2=5.705 //y2=4.885
cc_387 ( N_noxref_2_c_281_n N_C_c_1190_n ) capacitor c=0.00491852f //x=5.885 \
 //y=1.835 //x2=5.67 //y2=2.26
cc_388 ( N_noxref_2_c_290_n N_C_c_1190_n ) capacitor c=0.00331564f //x=6.41 \
 //y=2.61 //x2=5.67 //y2=2.26
cc_389 ( N_noxref_2_c_292_n N_C_c_1194_n ) capacitor c=7.83796e-19 //x=6.41 \
 //y=5.305 //x2=5.705 //y2=4.885
cc_390 ( N_noxref_2_c_295_n N_C_M11_noxref_g ) capacitor c=0.00184899f \
 //x=5.925 //y=5.39 //x2=5.71 //y2=6.205
cc_391 ( N_noxref_2_c_312_p N_C_M11_noxref_g ) capacitor c=0.0120591f //x=5.93 \
 //y=5.56 //x2=5.71 //y2=6.205
cc_392 ( N_noxref_2_c_308_p N_C_M12_noxref_g ) capacitor c=0.0110031f \
 //x=6.325 //y=5.39 //x2=6.15 //y2=6.205
cc_393 ( N_noxref_2_c_295_n N_C_M12_noxref_g ) capacitor c=0.00272721f \
 //x=5.925 //y=5.39 //x2=6.15 //y2=6.205
cc_394 ( N_noxref_2_c_312_p N_C_M12_noxref_g ) capacitor c=0.0140704f //x=5.93 \
 //y=5.56 //x2=6.15 //y2=6.205
cc_395 ( N_noxref_2_c_339_p N_C_c_1201_n ) capacitor c=0.00112851f //x=5.97 \
 //y=1.3 //x2=5.705 //y2=1.085
cc_396 ( N_noxref_2_M3_noxref_d N_C_c_1201_n ) capacitor c=0.00218694f \
 //x=5.78 //y=1.085 //x2=5.705 //y2=1.085
cc_397 ( N_noxref_2_c_339_p N_C_c_1203_n ) capacitor c=0.0021447f //x=5.97 \
 //y=1.3 //x2=5.705 //y2=1.435
cc_398 ( N_noxref_2_c_288_n N_C_c_1203_n ) capacitor c=7.7986e-19 //x=5.97 \
 //y=1.75 //x2=5.705 //y2=1.435
cc_399 ( N_noxref_2_M3_noxref_d N_C_c_1203_n ) capacitor c=0.00237422f \
 //x=5.78 //y=1.085 //x2=5.705 //y2=1.435
cc_400 ( N_noxref_2_c_275_n N_C_c_1206_n ) capacitor c=0.00120307f //x=5 \
 //y=1.75 //x2=5.705 //y2=1.74
cc_401 ( N_noxref_2_c_288_n N_C_c_1206_n ) capacitor c=0.00364979f //x=5.97 \
 //y=1.75 //x2=5.705 //y2=1.74
cc_402 ( N_noxref_2_c_292_n N_C_c_1247_n ) capacitor c=0.00852293f //x=6.41 \
 //y=5.305 //x2=6.075 //y2=4.975
cc_403 ( N_noxref_2_c_295_n N_C_c_1247_n ) capacitor c=0.00213157f //x=5.925 \
 //y=5.39 //x2=6.075 //y2=4.975
cc_404 ( N_noxref_2_c_312_p N_C_c_1247_n ) capacitor c=0.00293135f //x=5.93 \
 //y=5.56 //x2=6.075 //y2=4.975
cc_405 ( N_noxref_2_c_339_p N_C_c_1250_n ) capacitor c=5.32053e-19 //x=5.97 \
 //y=1.3 //x2=6.08 //y2=0.93
cc_406 ( N_noxref_2_M3_noxref_d N_C_c_1250_n ) capacitor c=0.00213893f \
 //x=5.78 //y=1.085 //x2=6.08 //y2=0.93
cc_407 ( N_noxref_2_c_339_p N_C_c_1208_n ) capacitor c=5.60411e-19 //x=5.97 \
 //y=1.3 //x2=6.08 //y2=1.585
cc_408 ( N_noxref_2_c_288_n N_C_c_1208_n ) capacitor c=0.00954408f //x=5.97 \
 //y=1.75 //x2=6.08 //y2=1.585
cc_409 ( N_noxref_2_c_340_p N_C_c_1208_n ) capacitor c=0.00500113f //x=6.325 \
 //y=1.835 //x2=6.08 //y2=1.585
cc_410 ( N_noxref_2_M3_noxref_d N_C_c_1208_n ) capacitor c=0.00357974f \
 //x=5.78 //y=1.085 //x2=6.08 //y2=1.585
cc_411 ( N_noxref_2_c_339_p N_C_c_1209_n ) capacitor c=8.03404e-19 //x=5.97 \
 //y=1.3 //x2=6.235 //y2=1.085
cc_412 ( N_noxref_2_M3_noxref_d N_C_c_1209_n ) capacitor c=0.0012513f //x=5.78 \
 //y=1.085 //x2=6.235 //y2=1.085
cc_413 ( N_noxref_2_c_339_p N_C_c_1210_n ) capacitor c=0.00322382f //x=5.97 \
 //y=1.3 //x2=6.235 //y2=1.435
cc_414 ( N_noxref_2_c_288_n N_C_c_1210_n ) capacitor c=0.00115112f //x=5.97 \
 //y=1.75 //x2=6.235 //y2=1.435
cc_415 ( N_noxref_2_M3_noxref_d N_C_c_1210_n ) capacitor c=0.00237422f \
 //x=5.78 //y=1.085 //x2=6.235 //y2=1.435
cc_416 ( N_noxref_2_c_281_n N_C_c_1211_n ) capacitor c=0.00161541f //x=5.885 \
 //y=1.835 //x2=5.67 //y2=2.26
cc_417 ( N_noxref_2_c_290_n N_C_c_1211_n ) capacitor c=0.0028062f //x=6.41 \
 //y=2.61 //x2=5.67 //y2=2.26
cc_418 ( N_noxref_2_c_281_n N_C_c_1214_n ) capacitor c=0.00817459f //x=5.885 \
 //y=1.835 //x2=5.67 //y2=2.095
cc_419 ( N_noxref_2_c_290_n N_C_c_1214_n ) capacitor c=0.00311553f //x=6.41 \
 //y=2.61 //x2=5.67 //y2=2.095
cc_420 ( N_noxref_2_c_292_n N_C_c_1215_n ) capacitor c=0.00141757f //x=6.41 \
 //y=5.305 //x2=5.705 //y2=4.885
cc_421 ( N_noxref_2_c_290_n Y ) capacitor c=0.00111651f //x=6.41 //y=2.61 \
 //x2=8.63 //y2=2.4
cc_422 ( N_noxref_2_c_292_n Y ) capacitor c=0.00357715f //x=6.41 //y=5.305 \
 //x2=8.63 //y2=2.4
cc_423 ( N_noxref_2_c_367_p Y ) capacitor c=0.00781089f //x=7.89 //y=2.61 \
 //x2=8.63 //y2=2.4
cc_424 ( N_noxref_2_c_330_p Y ) capacitor c=0.0147607f //x=7.89 //y=2.93 \
 //x2=8.63 //y2=2.4
cc_425 ( N_noxref_2_c_309_p Y ) capacitor c=0.0932037f //x=7.89 //y=4.76 \
 //x2=8.63 //y2=2.4
cc_426 ( N_noxref_2_c_370_p Y ) capacitor c=0.00348226f //x=7.885 //y=2.77 \
 //x2=8.63 //y2=2.4
cc_427 ( N_noxref_2_c_344_p Y ) capacitor c=0.00825076f //x=7.89 //y=2.265 \
 //x2=8.63 //y2=2.4
cc_428 ( N_noxref_2_c_470_p Y ) capacitor c=0.00683712f //x=7.885 //y=2.77 \
 //x2=8.63 //y2=2.4
cc_429 ( N_noxref_2_c_345_p Y ) capacitor c=0.0023016f //x=7.89 //y=2.265 \
 //x2=8.63 //y2=2.4
cc_430 ( N_noxref_2_c_310_p Y ) capacitor c=0.00250262f //x=7.89 //y=4.88 \
 //x2=8.63 //y2=2.4
cc_431 ( N_noxref_2_c_327_p Y ) capacitor c=4.08297e-19 //x=8.41 //y=4.97 \
 //x2=8.63 //y2=2.4
cc_432 ( N_noxref_2_c_324_p Y ) capacitor c=0.00124564f //x=8.12 //y=4.97 \
 //x2=8.63 //y2=2.4
cc_433 ( N_noxref_2_c_361_p Y ) capacitor c=0.00112403f //x=7.89 //y=2.265 \
 //x2=8.63 //y2=2.4
cc_434 ( N_noxref_2_c_275_n N_Y_c_1308_n ) capacitor c=6.27081e-19 //x=5 \
 //y=1.75 //x2=8.26 //y2=1.935
cc_435 ( N_noxref_2_c_288_n N_Y_c_1308_n ) capacitor c=0.00448773f //x=5.97 \
 //y=1.75 //x2=8.26 //y2=1.935
cc_436 ( N_noxref_2_c_340_p N_Y_c_1308_n ) capacitor c=0.00321997f //x=6.325 \
 //y=1.835 //x2=8.26 //y2=1.935
cc_437 ( N_noxref_2_c_479_p N_Y_c_1308_n ) capacitor c=0.00108934f //x=8 \
 //y=1.435 //x2=8.26 //y2=1.935
cc_438 ( N_noxref_2_c_396_p N_Y_c_1308_n ) capacitor c=0.00524682f //x=8 \
 //y=1.745 //x2=8.26 //y2=1.935
cc_439 ( N_noxref_2_c_374_p N_Y_c_1308_n ) capacitor c=0.00376309f //x=8 \
 //y=2.1 //x2=8.26 //y2=1.935
cc_440 ( N_noxref_2_c_482_p N_Y_c_1308_n ) capacitor c=0.00934265f //x=8.375 \
 //y=1.59 //x2=8.26 //y2=1.935
cc_441 ( N_noxref_2_c_400_p N_Y_c_1308_n ) capacitor c=0.00362207f //x=8.53 \
 //y=1.435 //x2=8.26 //y2=1.935
cc_442 ( N_noxref_2_c_308_p N_Y_c_1316_n ) capacitor c=0.00310588f //x=6.325 \
 //y=5.39 //x2=8.265 //y2=5.42
cc_443 ( N_noxref_2_c_295_n N_Y_c_1316_n ) capacitor c=5.06627e-19 //x=5.925 \
 //y=5.39 //x2=8.265 //y2=5.42
cc_444 ( N_noxref_2_M13_noxref_g N_Y_c_1316_n ) capacitor c=0.00141266f \
 //x=8.045 //y=6.2 //x2=8.265 //y2=5.42
cc_445 ( N_noxref_2_M14_noxref_g N_Y_c_1316_n ) capacitor c=0.00377331f \
 //x=8.485 //y=6.2 //x2=8.265 //y2=5.42
cc_446 ( N_noxref_2_c_482_p N_Y_c_1320_n ) capacitor c=0.00180253f //x=8.375 \
 //y=1.59 //x2=8.545 //y2=2.02
cc_447 ( N_noxref_2_c_290_n N_Y_c_1321_n ) capacitor c=0.00321997f //x=6.41 \
 //y=2.61 //x2=8.345 //y2=2.02
cc_448 ( N_noxref_2_c_361_p N_Y_c_1321_n ) capacitor c=0.00376309f //x=7.89 \
 //y=2.265 //x2=8.345 //y2=2.02
cc_449 ( N_noxref_2_M14_noxref_g N_Y_c_1323_n ) capacitor c=0.00966342f \
 //x=8.485 //y=6.2 //x2=8.545 //y2=5.14
cc_450 ( N_noxref_2_c_292_n N_Y_c_1324_n ) capacitor c=0.0028971f //x=6.41 \
 //y=5.305 //x2=8.35 //y2=5.14
cc_451 ( N_noxref_2_M13_noxref_g N_Y_c_1324_n ) capacitor c=0.00427521f \
 //x=8.045 //y=6.2 //x2=8.35 //y2=5.14
cc_452 ( N_noxref_2_c_327_p N_Y_c_1324_n ) capacitor c=0.00262283f //x=8.41 \
 //y=4.97 //x2=8.35 //y2=5.14
cc_453 ( N_noxref_2_c_339_p N_Y_c_1327_n ) capacitor c=0.0059861f //x=5.97 \
 //y=1.3 //x2=8.26 //y2=1.185
cc_454 ( N_noxref_2_c_288_n N_Y_c_1327_n ) capacitor c=6.20316e-19 //x=5.97 \
 //y=1.75 //x2=8.26 //y2=1.185
cc_455 ( N_noxref_2_c_360_p N_Y_c_1327_n ) capacitor c=0.00175335f //x=8 \
 //y=1.09 //x2=8.26 //y2=1.185
cc_456 ( N_noxref_2_c_479_p N_Y_c_1327_n ) capacitor c=0.00353833f //x=8 \
 //y=1.435 //x2=8.26 //y2=1.185
cc_457 ( N_noxref_2_c_398_p N_Y_c_1327_n ) capacitor c=5.57924e-19 //x=8.375 \
 //y=0.935 //x2=8.26 //y2=1.185
cc_458 ( N_noxref_2_c_482_p N_Y_c_1327_n ) capacitor c=5.75878e-19 //x=8.375 \
 //y=1.59 //x2=8.26 //y2=1.185
cc_459 ( N_noxref_2_c_362_p N_Y_c_1327_n ) capacitor c=0.00160969f //x=8.53 \
 //y=1.09 //x2=8.26 //y2=1.185
cc_460 ( N_noxref_2_c_400_p N_Y_c_1327_n ) capacitor c=0.00411132f //x=8.53 \
 //y=1.435 //x2=8.26 //y2=1.185
cc_461 ( N_noxref_2_M13_noxref_g N_Y_c_1335_n ) capacitor c=0.0162066f \
 //x=8.045 //y=6.2 //x2=8.265 //y2=5.56
cc_462 ( N_noxref_2_M14_noxref_g N_Y_c_1335_n ) capacitor c=0.0162066f \
 //x=8.485 //y=6.2 //x2=8.265 //y2=5.56
cc_463 ( N_noxref_2_c_327_p N_Y_c_1335_n ) capacitor c=0.00290963f //x=8.41 \
 //y=4.97 //x2=8.265 //y2=5.56
cc_464 ( N_noxref_2_c_360_p N_Y_M4_noxref_d ) capacitor c=0.00137914f //x=8 \
 //y=1.09 //x2=8.075 //y2=1.09
cc_465 ( N_noxref_2_c_479_p N_Y_M4_noxref_d ) capacitor c=0.0023891f //x=8 \
 //y=1.435 //x2=8.075 //y2=1.09
cc_466 ( N_noxref_2_c_398_p N_Y_M4_noxref_d ) capacitor c=0.0020782f //x=8.375 \
 //y=0.935 //x2=8.075 //y2=1.09
cc_467 ( N_noxref_2_c_482_p N_Y_M4_noxref_d ) capacitor c=0.00356097f \
 //x=8.375 //y=1.59 //x2=8.075 //y2=1.09
cc_468 ( N_noxref_2_c_362_p N_Y_M4_noxref_d ) capacitor c=0.00138452f //x=8.53 \
 //y=1.09 //x2=8.075 //y2=1.09
cc_469 ( N_noxref_2_c_400_p N_Y_M4_noxref_d ) capacitor c=0.00235934f //x=8.53 \
 //y=1.435 //x2=8.075 //y2=1.09
cc_470 ( N_VDD_c_533_n A ) capacitor c=0.0104242f //x=1.23 //y=7.58 //x2=1.6 \
 //y2=2.4
cc_471 ( N_VDD_c_512_n N_A_c_686_n ) capacitor c=9.07241e-19 //x=4.965 \
 //y=7.585 //x2=1.6 //y2=4.88
cc_472 ( N_VDD_c_523_n N_A_c_686_n ) capacitor c=6.28113e-19 //x=2.075 \
 //y=7.585 //x2=1.6 //y2=4.88
cc_473 ( N_VDD_c_533_n N_A_c_686_n ) capacitor c=0.00867681f //x=1.23 //y=7.58 \
 //x2=1.6 //y2=4.88
cc_474 ( N_VDD_c_512_n N_A_c_688_n ) capacitor c=6.22888e-19 //x=4.965 \
 //y=7.585 //x2=1.6 //y2=4.88
cc_475 ( N_VDD_c_533_n N_A_c_688_n ) capacitor c=0.00370735f //x=1.23 //y=7.58 \
 //x2=1.6 //y2=4.88
cc_476 ( N_VDD_c_523_n N_A_M5_noxref_g ) capacitor c=0.00732618f //x=2.075 \
 //y=7.585 //x2=1.5 //y2=6.2
cc_477 ( N_VDD_M5_noxref_s N_A_M5_noxref_g ) capacitor c=0.0567929f //x=1.145 \
 //y=5.2 //x2=1.5 //y2=6.2
cc_478 ( N_VDD_c_523_n N_A_M6_noxref_g ) capacitor c=0.00755544f //x=2.075 \
 //y=7.585 //x2=1.94 //y2=6.2
cc_479 ( N_VDD_M6_noxref_d N_A_M6_noxref_g ) capacitor c=0.015318f //x=2.015 \
 //y=5.2 //x2=1.94 //y2=6.2
cc_480 ( N_VDD_c_533_n N_A_c_695_n ) capacitor c=0.0234764f //x=1.23 //y=7.58 \
 //x2=1.6 //y2=4.88
cc_481 ( N_VDD_c_533_n N_GND_c_793_n ) capacitor c=0.00989514f //x=1.23 \
 //y=7.58 //x2=1.23 //y2=0.18
cc_482 ( N_VDD_c_536_n N_GND_c_801_n ) capacitor c=0.00970423f //x=3.82 \
 //y=7.585 //x2=3.82 //y2=0.175
cc_483 ( N_VDD_c_546_n N_GND_c_845_n ) capacitor c=0.00970423f //x=7.15 \
 //y=7.585 //x2=7.15 //y2=0.175
cc_484 ( N_VDD_c_547_n N_GND_c_812_n ) capacitor c=0.00989514f //x=8.63 \
 //y=7.58 //x2=8.75 //y2=0.175
cc_485 ( N_VDD_c_536_n N_B_c_986_n ) capacitor c=0.00226427f //x=3.82 \
 //y=7.585 //x2=2.37 //y2=4.88
cc_486 ( N_VDD_c_526_n N_B_M7_noxref_g ) capacitor c=0.00697352f //x=2.955 \
 //y=7.585 //x2=2.38 //y2=6.2
cc_487 ( N_VDD_M6_noxref_d N_B_M7_noxref_g ) capacitor c=0.015318f //x=2.015 \
 //y=5.2 //x2=2.38 //y2=6.2
cc_488 ( N_VDD_c_526_n N_B_M8_noxref_g ) capacitor c=0.00755544f //x=2.955 \
 //y=7.585 //x2=2.82 //y2=6.2
cc_489 ( N_VDD_M8_noxref_d N_B_M8_noxref_g ) capacitor c=0.0430452f //x=2.895 \
 //y=5.2 //x2=2.82 //y2=6.2
cc_490 ( N_VDD_c_536_n N_B_c_1000_n ) capacitor c=0.0132232f //x=3.82 \
 //y=7.585 //x2=2.745 //y2=4.97
cc_491 ( N_VDD_c_536_n N_B_c_1018_n ) capacitor c=2.73429e-19 //x=3.82 \
 //y=7.585 //x2=2.37 //y2=4.88
cc_492 ( N_VDD_M6_noxref_d N_B_c_1018_n ) capacitor c=3.32552e-19 //x=2.015 \
 //y=5.2 //x2=2.37 //y2=4.88
cc_493 ( N_VDD_c_512_n N_noxref_7_c_1081_n ) capacitor c=0.00198753f //x=4.965 \
 //y=7.585 //x2=5.37 //y2=5.39
cc_494 ( N_VDD_c_519_n N_noxref_7_c_1081_n ) capacitor c=0.00495393f //x=5.05 \
 //y=7.035 //x2=5.37 //y2=5.39
cc_495 ( N_VDD_c_565_n N_noxref_7_c_1081_n ) capacitor c=0.00192799f //x=8.63 \
 //y=7.58 //x2=5.37 //y2=5.39
cc_496 ( N_VDD_c_531_n N_noxref_7_c_1081_n ) capacitor c=0.00433505f //x=6.98 \
 //y=7.585 //x2=5.37 //y2=5.39
cc_497 ( N_VDD_M9_noxref_d N_noxref_7_c_1081_n ) capacitor c=0.00655495f \
 //x=4.905 //y=5.205 //x2=5.37 //y2=5.39
cc_498 ( N_VDD_c_547_n N_noxref_7_c_1104_n ) capacitor c=0.00223057f //x=8.63 \
 //y=7.58 //x2=6.24 //y2=7.09
cc_499 ( N_VDD_c_536_n N_noxref_7_c_1087_n ) capacitor c=0.00766391f //x=3.82 \
 //y=7.585 //x2=4.61 //y2=5.39
cc_500 ( N_VDD_M5_noxref_s N_noxref_7_c_1087_n ) capacitor c=5.03296e-19 \
 //x=1.145 //y=5.2 //x2=4.61 //y2=5.39
cc_501 ( N_VDD_M13_noxref_s N_noxref_7_c_1094_n ) capacitor c=8.05316e-19 \
 //x=7.69 //y=5.2 //x2=5.49 //y2=5.39
cc_502 ( N_VDD_c_519_n N_noxref_7_c_1095_n ) capacitor c=0.0377581f //x=5.05 \
 //y=7.035 //x2=5.49 //y2=6.92
cc_503 ( N_VDD_c_521_n N_noxref_7_c_1095_n ) capacitor c=0.0104317f //x=5.05 \
 //y=7.41 //x2=5.49 //y2=6.92
cc_504 ( N_VDD_c_565_n N_noxref_7_c_1095_n ) capacitor c=0.0975191f //x=8.63 \
 //y=7.58 //x2=5.49 //y2=6.92
cc_505 ( N_VDD_c_531_n N_noxref_7_c_1095_n ) capacitor c=0.0204966f //x=6.98 \
 //y=7.585 //x2=5.49 //y2=6.92
cc_506 ( N_VDD_c_547_n N_noxref_7_c_1095_n ) capacitor c=0.00112916f //x=8.63 \
 //y=7.58 //x2=5.49 //y2=6.92
cc_507 ( N_VDD_M9_noxref_d N_noxref_7_c_1095_n ) capacitor c=0.00510287f \
 //x=4.905 //y=5.205 //x2=5.49 //y2=6.92
cc_508 ( N_VDD_c_519_n N_noxref_7_c_1111_n ) capacitor c=6.1128e-19 //x=5.05 \
 //y=7.035 //x2=6.37 //y2=6.92
cc_509 ( N_VDD_c_565_n N_noxref_7_c_1111_n ) capacitor c=0.00193184f //x=8.63 \
 //y=7.58 //x2=6.37 //y2=6.92
cc_510 ( N_VDD_c_531_n N_noxref_7_c_1111_n ) capacitor c=9.3761e-19 //x=6.98 \
 //y=7.585 //x2=6.37 //y2=6.92
cc_511 ( N_VDD_c_546_n N_noxref_7_c_1111_n ) capacitor c=0.0111101f //x=7.15 \
 //y=7.585 //x2=6.37 //y2=6.92
cc_512 ( N_VDD_c_547_n N_noxref_7_c_1111_n ) capacitor c=0.00112713f //x=8.63 \
 //y=7.58 //x2=6.37 //y2=6.92
cc_513 ( N_VDD_c_512_n N_noxref_7_c_1096_n ) capacitor c=0.00240365f //x=4.965 \
 //y=7.585 //x2=4.61 //y2=5.56
cc_514 ( N_VDD_c_519_n N_noxref_7_c_1096_n ) capacitor c=0.00220777f //x=5.05 \
 //y=7.035 //x2=4.61 //y2=5.56
cc_515 ( N_VDD_c_521_n N_noxref_7_c_1096_n ) capacitor c=0.00154298f //x=5.05 \
 //y=7.41 //x2=4.61 //y2=5.56
cc_516 ( N_VDD_c_531_n N_noxref_7_c_1096_n ) capacitor c=0.0126473f //x=6.98 \
 //y=7.585 //x2=4.61 //y2=5.56
cc_517 ( N_VDD_c_536_n N_noxref_7_c_1096_n ) capacitor c=0.0552885f //x=3.82 \
 //y=7.585 //x2=4.61 //y2=5.56
cc_518 ( N_VDD_c_547_n N_noxref_7_c_1096_n ) capacitor c=0.00161681f //x=8.63 \
 //y=7.58 //x2=4.61 //y2=5.56
cc_519 ( N_VDD_M8_noxref_d N_noxref_7_c_1096_n ) capacitor c=0.00271974f \
 //x=2.895 //y=5.2 //x2=4.61 //y2=5.56
cc_520 ( N_VDD_M9_noxref_d N_noxref_7_c_1096_n ) capacitor c=0.0736177f \
 //x=4.905 //y=5.205 //x2=4.61 //y2=5.56
cc_521 ( N_VDD_c_519_n N_noxref_7_c_1100_n ) capacitor c=0.00211426f //x=5.05 \
 //y=7.035 //x2=5.49 //y2=5.56
cc_522 ( N_VDD_c_521_n N_noxref_7_c_1100_n ) capacitor c=4.62894e-19 //x=5.05 \
 //y=7.41 //x2=5.49 //y2=5.56
cc_523 ( N_VDD_c_565_n N_noxref_7_c_1100_n ) capacitor c=0.00205411f //x=8.63 \
 //y=7.58 //x2=5.49 //y2=5.56
cc_524 ( N_VDD_c_531_n N_noxref_7_c_1100_n ) capacitor c=0.0085453f //x=6.98 \
 //y=7.585 //x2=5.49 //y2=5.56
cc_525 ( N_VDD_c_547_n N_noxref_7_c_1100_n ) capacitor c=0.00100828f //x=8.63 \
 //y=7.58 //x2=5.49 //y2=5.56
cc_526 ( N_VDD_M9_noxref_d N_noxref_7_c_1100_n ) capacitor c=0.0673333f \
 //x=4.905 //y=5.205 //x2=5.49 //y2=5.56
cc_527 ( N_VDD_c_512_n N_noxref_7_M9_noxref_s ) capacitor c=0.0245962f \
 //x=4.965 //y=7.585 //x2=4.475 //y2=5.205
cc_528 ( N_VDD_c_519_n N_noxref_7_M9_noxref_s ) capacitor c=0.0378001f \
 //x=5.05 //y=7.035 //x2=4.475 //y2=5.205
cc_529 ( N_VDD_c_521_n N_noxref_7_M9_noxref_s ) capacitor c=0.0124823f \
 //x=5.05 //y=7.41 //x2=4.475 //y2=5.205
cc_530 ( N_VDD_c_531_n N_noxref_7_M9_noxref_s ) capacitor c=0.00293047f \
 //x=6.98 //y=7.585 //x2=4.475 //y2=5.205
cc_531 ( N_VDD_c_536_n N_noxref_7_M9_noxref_s ) capacitor c=0.00933367f \
 //x=3.82 //y=7.585 //x2=4.475 //y2=5.205
cc_532 ( N_VDD_c_547_n N_noxref_7_M9_noxref_s ) capacitor c=0.00129282f \
 //x=8.63 //y=7.58 //x2=4.475 //y2=5.205
cc_533 ( N_VDD_M9_noxref_d N_noxref_7_M9_noxref_s ) capacitor c=0.00566597f \
 //x=4.905 //y=5.205 //x2=4.475 //y2=5.205
cc_534 ( N_VDD_c_565_n N_noxref_7_M12_noxref_d ) capacitor c=0.00206569f \
 //x=8.63 //y=7.58 //x2=6.225 //y2=5.205
cc_535 ( N_VDD_c_531_n N_noxref_7_M12_noxref_d ) capacitor c=0.00856914f \
 //x=6.98 //y=7.585 //x2=6.225 //y2=5.205
cc_536 ( N_VDD_c_546_n N_noxref_7_M12_noxref_d ) capacitor c=0.0444839f \
 //x=7.15 //y=7.585 //x2=6.225 //y2=5.205
cc_537 ( N_VDD_c_547_n N_noxref_7_M12_noxref_d ) capacitor c=0.00100487f \
 //x=8.63 //y=7.58 //x2=6.225 //y2=5.205
cc_538 ( N_VDD_M13_noxref_s N_noxref_7_M12_noxref_d ) capacitor c=0.00238698f \
 //x=7.69 //y=5.2 //x2=6.225 //y2=5.205
cc_539 ( N_VDD_c_546_n N_C_c_1194_n ) capacitor c=0.00231379f //x=7.15 \
 //y=7.585 //x2=5.705 //y2=4.885
cc_540 ( N_VDD_c_531_n N_C_M11_noxref_g ) capacitor c=0.00724816f //x=6.98 \
 //y=7.585 //x2=5.71 //y2=6.205
cc_541 ( N_VDD_c_531_n N_C_M12_noxref_g ) capacitor c=0.00782837f //x=6.98 \
 //y=7.585 //x2=6.15 //y2=6.205
cc_542 ( N_VDD_c_546_n N_C_c_1247_n ) capacitor c=0.016784f //x=7.15 //y=7.585 \
 //x2=6.075 //y2=4.975
cc_543 ( N_VDD_c_546_n N_C_c_1215_n ) capacitor c=2.75092e-19 //x=7.15 \
 //y=7.585 //x2=5.705 //y2=4.885
cc_544 ( N_VDD_c_547_n Y ) capacitor c=0.0297606f //x=8.63 //y=7.58 //x2=8.63 \
 //y2=2.4
cc_545 ( N_VDD_c_565_n N_Y_c_1316_n ) capacitor c=0.00259721f //x=8.63 \
 //y=7.58 //x2=8.265 //y2=5.42
cc_546 ( N_VDD_c_570_n N_Y_c_1316_n ) capacitor c=0.00100699f //x=8.62 \
 //y=7.585 //x2=8.265 //y2=5.42
cc_547 ( N_VDD_c_547_n N_Y_c_1316_n ) capacitor c=0.00295945f //x=8.63 \
 //y=7.58 //x2=8.265 //y2=5.42
cc_548 ( N_VDD_M13_noxref_s N_Y_c_1316_n ) capacitor c=0.0467655f //x=7.69 \
 //y=5.2 //x2=8.265 //y2=5.42
cc_549 ( N_VDD_M14_noxref_d N_Y_c_1316_n ) capacitor c=0.0486749f //x=8.56 \
 //y=5.2 //x2=8.265 //y2=5.42
cc_550 ( N_VDD_c_565_n N_Y_c_1323_n ) capacitor c=0.00199795f //x=8.63 \
 //y=7.58 //x2=8.545 //y2=5.14
cc_551 ( N_VDD_c_570_n N_Y_c_1323_n ) capacitor c=0.00207379f //x=8.62 \
 //y=7.585 //x2=8.545 //y2=5.14
cc_552 ( N_VDD_M14_noxref_d N_Y_c_1323_n ) capacitor c=0.0235609f //x=8.56 \
 //y=5.2 //x2=8.545 //y2=5.14
cc_553 ( N_VDD_c_546_n N_Y_c_1324_n ) capacitor c=0.00464635f //x=7.15 \
 //y=7.585 //x2=8.35 //y2=5.14
cc_554 ( N_VDD_c_565_n N_Y_c_1335_n ) capacitor c=0.00241566f //x=8.63 \
 //y=7.58 //x2=8.265 //y2=5.56
cc_555 ( N_VDD_c_570_n N_Y_c_1335_n ) capacitor c=0.0138017f //x=8.62 \
 //y=7.585 //x2=8.265 //y2=5.56
cc_556 ( N_VDD_c_546_n N_Y_c_1335_n ) capacitor c=0.00819834f //x=7.15 \
 //y=7.585 //x2=8.265 //y2=5.56
cc_557 ( N_VDD_c_547_n N_Y_c_1335_n ) capacitor c=0.0096096f //x=8.63 //y=7.58 \
 //x2=8.265 //y2=5.56
cc_558 ( N_VDD_M13_noxref_s N_Y_c_1335_n ) capacitor c=0.0898116f //x=7.69 \
 //y=5.2 //x2=8.265 //y2=5.56
cc_559 ( N_VDD_M14_noxref_d N_Y_c_1335_n ) capacitor c=0.0933215f //x=8.56 \
 //y=5.2 //x2=8.265 //y2=5.56
cc_560 ( N_A_c_708_p N_GND_c_887_n ) capacitor c=6.6172e-19 //x=1.6 //y=2.26 \
 //x2=1.585 //y2=0.175
cc_561 ( N_A_c_708_p N_GND_c_788_n ) capacitor c=0.00709624f //x=1.6 //y=2.26 \
 //x2=1.67 //y2=1.135
cc_562 ( N_A_c_710_p N_GND_c_788_n ) capacitor c=2.13705e-19 //x=1.6 //y=2.26 \
 //x2=1.67 //y2=1.135
cc_563 ( N_A_c_711_p N_GND_c_788_n ) capacitor c=0.00156094f //x=1.405 \
 //y=1.045 //x2=1.67 //y2=1.135
cc_564 ( N_A_c_712_p N_GND_c_788_n ) capacitor c=0.00413828f //x=1.405 \
 //y=1.39 //x2=1.67 //y2=1.135
cc_565 ( N_A_c_713_p N_GND_c_788_n ) capacitor c=4.2764e-19 //x=1.405 //y=1.7 \
 //x2=1.67 //y2=1.135
cc_566 ( N_A_c_714_p N_GND_c_788_n ) capacitor c=5.3458e-19 //x=1.78 //y=0.89 \
 //x2=1.67 //y2=1.135
cc_567 ( N_A_c_715_p N_GND_c_788_n ) capacitor c=6.38426e-19 //x=1.78 \
 //y=1.545 //x2=1.67 //y2=1.135
cc_568 ( N_A_c_716_p N_GND_c_788_n ) capacitor c=0.00156575f //x=1.935 \
 //y=1.045 //x2=1.67 //y2=1.135
cc_569 ( N_A_c_717_p N_GND_c_788_n ) capacitor c=0.00296337f //x=1.935 \
 //y=1.39 //x2=1.67 //y2=1.135
cc_570 ( N_A_c_711_p N_GND_c_897_n ) capacitor c=3.51399e-19 //x=1.405 \
 //y=1.045 //x2=1.667 //y2=1.005
cc_571 ( N_A_c_714_p N_GND_c_897_n ) capacitor c=0.00864609f //x=1.78 //y=0.89 \
 //x2=1.667 //y2=1.005
cc_572 ( N_A_c_716_p N_GND_c_897_n ) capacitor c=4.45447e-19 //x=1.935 \
 //y=1.045 //x2=1.667 //y2=1.005
cc_573 ( N_A_c_711_p N_GND_c_791_n ) capacitor c=0.00694725f //x=1.405 \
 //y=1.045 //x2=3.65 //y2=0.175
cc_574 ( A N_GND_c_793_n ) capacitor c=0.0113215f //x=1.6 //y=2.4 //x2=1.23 \
 //y2=0.18
cc_575 ( N_A_c_708_p N_GND_c_793_n ) capacitor c=0.0082376f //x=1.6 //y=2.26 \
 //x2=1.23 //y2=0.18
cc_576 ( N_A_c_710_p N_GND_c_793_n ) capacitor c=0.00369668f //x=1.6 //y=2.26 \
 //x2=1.23 //y2=0.18
cc_577 ( N_A_c_713_p N_GND_c_793_n ) capacitor c=0.0015404f //x=1.405 //y=1.7 \
 //x2=1.23 //y2=0.18
cc_578 ( N_A_c_726_p N_GND_c_793_n ) capacitor c=0.00950704f //x=1.405 \
 //y=2.095 //x2=1.23 //y2=0.18
cc_579 ( N_A_c_708_p N_GND_M0_noxref_d ) capacitor c=2.20438e-19 //x=1.6 \
 //y=2.26 //x2=1.48 //y2=1.045
cc_580 ( N_A_c_711_p N_GND_M0_noxref_d ) capacitor c=0.00192399f //x=1.405 \
 //y=1.045 //x2=1.48 //y2=1.045
cc_581 ( N_A_c_712_p N_GND_M0_noxref_d ) capacitor c=0.00210798f //x=1.405 \
 //y=1.39 //x2=1.48 //y2=1.045
cc_582 ( N_A_c_714_p N_GND_M0_noxref_d ) capacitor c=0.00472259f //x=1.78 \
 //y=0.89 //x2=1.48 //y2=1.045
cc_583 ( N_A_c_715_p N_GND_M0_noxref_d ) capacitor c=0.00166857f //x=1.78 \
 //y=1.545 //x2=1.48 //y2=1.045
cc_584 ( N_A_c_716_p N_GND_M0_noxref_d ) capacitor c=0.00230174f //x=1.935 \
 //y=1.045 //x2=1.48 //y2=1.045
cc_585 ( N_A_c_717_p N_GND_M0_noxref_d ) capacitor c=0.00210798f //x=1.935 \
 //y=1.39 //x2=1.48 //y2=1.045
cc_586 ( A B ) capacitor c=0.109381f //x=1.6 //y=2.4 //x2=2.34 //y2=2.4
cc_587 ( N_A_c_710_p B ) capacitor c=3.49899e-19 //x=1.6 //y=2.26 //x2=2.34 \
 //y2=2.4
cc_588 ( N_A_c_688_n B ) capacitor c=3.02466e-19 //x=1.6 //y=4.88 //x2=2.34 \
 //y2=2.4
cc_589 ( N_A_c_695_n B ) capacitor c=0.00108965f //x=1.6 //y=4.88 //x2=2.34 \
 //y2=2.4
cc_590 ( N_A_c_686_n N_B_c_981_n ) capacitor c=0.0172939f //x=1.6 //y=4.88 \
 //x2=2.34 //y2=4.735
cc_591 ( N_A_c_688_n N_B_c_981_n ) capacitor c=4.73677e-19 //x=1.6 //y=4.88 \
 //x2=2.34 //y2=4.735
cc_592 ( N_A_c_695_n N_B_c_981_n ) capacitor c=9.22067e-19 //x=1.6 //y=4.88 \
 //x2=2.34 //y2=4.735
cc_593 ( N_A_c_708_p N_B_c_983_n ) capacitor c=0.0205342f //x=1.6 //y=2.26 \
 //x2=2.34 //y2=2.26
cc_594 ( N_A_c_710_p N_B_c_983_n ) capacitor c=5.16867e-19 //x=1.6 //y=2.26 \
 //x2=2.34 //y2=2.26
cc_595 ( N_A_c_726_p N_B_c_983_n ) capacitor c=0.00167888f //x=1.405 //y=2.095 \
 //x2=2.34 //y2=2.26
cc_596 ( A N_B_c_985_n ) capacitor c=3.49899e-19 //x=1.6 //y=2.4 //x2=2.34 \
 //y2=2.26
cc_597 ( N_A_c_708_p N_B_c_985_n ) capacitor c=0.00370824f //x=1.6 //y=2.26 \
 //x2=2.34 //y2=2.26
cc_598 ( N_A_c_710_p N_B_c_985_n ) capacitor c=0.00445529f //x=1.6 //y=2.26 \
 //x2=2.34 //y2=2.26
cc_599 ( N_A_c_726_p N_B_c_985_n ) capacitor c=0.00267961f //x=1.405 //y=2.095 \
 //x2=2.34 //y2=2.26
cc_600 ( A N_B_c_986_n ) capacitor c=2.1563e-19 //x=1.6 //y=2.4 //x2=2.37 \
 //y2=4.88
cc_601 ( N_A_c_686_n N_B_c_986_n ) capacitor c=0.00389735f //x=1.6 //y=4.88 \
 //x2=2.37 //y2=4.88
cc_602 ( N_A_c_688_n N_B_c_986_n ) capacitor c=0.00397338f //x=1.6 //y=4.88 \
 //x2=2.37 //y2=4.88
cc_603 ( N_A_c_695_n N_B_c_986_n ) capacitor c=0.00283894f //x=1.6 //y=4.88 \
 //x2=2.37 //y2=4.88
cc_604 ( N_A_M5_noxref_g N_B_M7_noxref_g ) capacitor c=0.0104892f //x=1.5 \
 //y=6.2 //x2=2.38 //y2=6.2
cc_605 ( N_A_M6_noxref_g N_B_M7_noxref_g ) capacitor c=0.107636f //x=1.94 \
 //y=6.2 //x2=2.38 //y2=6.2
cc_606 ( N_A_M6_noxref_g N_B_M8_noxref_g ) capacitor c=0.0100341f //x=1.94 \
 //y=6.2 //x2=2.82 //y2=6.2
cc_607 ( N_A_c_711_p N_B_c_994_n ) capacitor c=4.86545e-19 //x=1.405 //y=1.045 \
 //x2=2.375 //y2=1.085
cc_608 ( N_A_c_712_p N_B_c_994_n ) capacitor c=0.00152405f //x=1.405 //y=1.39 \
 //x2=2.375 //y2=1.085
cc_609 ( N_A_c_716_p N_B_c_994_n ) capacitor c=0.0151475f //x=1.935 //y=1.045 \
 //x2=2.375 //y2=1.085
cc_610 ( N_A_c_713_p N_B_c_996_n ) capacitor c=0.00109982f //x=1.405 //y=1.7 \
 //x2=2.375 //y2=1.43
cc_611 ( N_A_c_717_p N_B_c_996_n ) capacitor c=0.0111064f //x=1.935 //y=1.39 \
 //x2=2.375 //y2=1.43
cc_612 ( N_A_c_713_p N_B_c_999_n ) capacitor c=9.58243e-19 //x=1.405 //y=1.7 \
 //x2=2.375 //y2=1.74
cc_613 ( N_A_c_726_p N_B_c_999_n ) capacitor c=0.00662747f //x=1.405 //y=2.095 \
 //x2=2.375 //y2=1.74
cc_614 ( N_A_c_717_p N_B_c_999_n ) capacitor c=0.00862358f //x=1.935 //y=1.39 \
 //x2=2.375 //y2=1.74
cc_615 ( N_A_c_716_p N_B_c_1009_n ) capacitor c=0.00127211f //x=1.935 \
 //y=1.045 //x2=2.905 //y2=1.085
cc_616 ( N_A_c_717_p N_B_c_1011_n ) capacitor c=0.00204774f //x=1.935 //y=1.39 \
 //x2=2.905 //y2=1.43
cc_617 ( N_A_c_708_p N_B_c_1015_n ) capacitor c=0.00167305f //x=1.6 //y=2.26 \
 //x2=2.34 //y2=2.26
cc_618 ( N_A_c_710_p N_B_c_1015_n ) capacitor c=0.00266443f //x=1.6 //y=2.26 \
 //x2=2.34 //y2=2.26
cc_619 ( N_A_c_726_p N_B_c_1015_n ) capacitor c=0.0181449f //x=1.405 //y=2.095 \
 //x2=2.34 //y2=2.26
cc_620 ( N_A_c_686_n N_B_c_1018_n ) capacitor c=0.00158715f //x=1.6 //y=4.88 \
 //x2=2.37 //y2=4.88
cc_621 ( N_A_c_688_n N_B_c_1018_n ) capacitor c=0.00237977f //x=1.6 //y=4.88 \
 //x2=2.37 //y2=4.88
cc_622 ( N_A_c_695_n N_B_c_1018_n ) capacitor c=0.0297875f //x=1.6 //y=4.88 \
 //x2=2.37 //y2=4.88
cc_623 ( N_A_c_726_p N_noxref_10_c_1386_n ) capacitor c=0.00262672f //x=1.405 \
 //y=2.095 //x2=1.185 //y2=1.675
cc_624 ( N_A_c_708_p N_noxref_10_c_1387_n ) capacitor c=0.00459552f //x=1.6 \
 //y=2.26 //x2=2.07 //y2=1.76
cc_625 ( N_A_c_710_p N_noxref_10_c_1387_n ) capacitor c=0.00763108f //x=1.6 \
 //y=2.26 //x2=2.07 //y2=1.76
cc_626 ( N_A_c_713_p N_noxref_10_c_1387_n ) capacitor c=0.00695869f //x=1.405 \
 //y=1.7 //x2=2.07 //y2=1.76
cc_627 ( N_A_c_726_p N_noxref_10_c_1387_n ) capacitor c=0.0194861f //x=1.405 \
 //y=2.095 //x2=2.07 //y2=1.76
cc_628 ( N_A_c_715_p N_noxref_10_c_1387_n ) capacitor c=0.00723574f //x=1.78 \
 //y=1.545 //x2=2.07 //y2=1.76
cc_629 ( N_A_c_717_p N_noxref_10_c_1387_n ) capacitor c=0.00339872f //x=1.935 \
 //y=1.39 //x2=2.07 //y2=1.76
cc_630 ( N_A_c_726_p N_noxref_10_c_1376_n ) capacitor c=6.71402e-19 //x=1.405 \
 //y=2.095 //x2=2.155 //y2=1.675
cc_631 ( N_A_c_711_p N_noxref_10_M0_noxref_s ) capacitor c=0.0294925f \
 //x=1.405 //y=1.045 //x2=1.05 //y2=0.545
cc_632 ( N_A_c_713_p N_noxref_10_M0_noxref_s ) capacitor c=3.48408e-19 \
 //x=1.405 //y=1.7 //x2=1.05 //y2=0.545
cc_633 ( N_A_c_716_p N_noxref_10_M0_noxref_s ) capacitor c=0.0125442f \
 //x=1.935 //y=1.045 //x2=1.05 //y2=0.545
cc_634 ( N_GND_c_782_n N_B_c_983_n ) capacitor c=0.00234561f //x=8.63 //y=0.18 \
 //x2=2.34 //y2=2.26
cc_635 ( N_GND_c_791_n N_B_c_983_n ) capacitor c=3.77328e-19 //x=3.65 \
 //y=0.175 //x2=2.34 //y2=2.26
cc_636 ( N_GND_c_801_n N_B_c_985_n ) capacitor c=0.00224736f //x=3.82 \
 //y=0.175 //x2=2.34 //y2=2.26
cc_637 ( N_GND_c_801_n N_B_c_1011_n ) capacitor c=0.00275184f //x=3.82 \
 //y=0.175 //x2=2.905 //y2=1.43
cc_638 ( N_GND_c_801_n N_B_c_1015_n ) capacitor c=2.63786e-19 //x=3.82 \
 //y=0.175 //x2=2.34 //y2=2.26
cc_639 ( N_GND_c_833_n N_C_c_1184_n ) capacitor c=6.61292e-19 //x=6.37 \
 //y=0.71 //x2=5.67 //y2=2.26
cc_640 ( N_GND_c_833_n N_C_c_1190_n ) capacitor c=8.64363e-19 //x=6.37 \
 //y=0.71 //x2=5.67 //y2=2.26
cc_641 ( N_GND_c_845_n N_C_c_1190_n ) capacitor c=0.00224736f //x=7.15 \
 //y=0.175 //x2=5.67 //y2=2.26
cc_642 ( N_GND_c_833_n N_C_c_1201_n ) capacitor c=0.0210318f //x=6.37 //y=0.71 \
 //x2=5.705 //y2=1.085
cc_643 ( N_GND_M2_noxref_s N_C_c_1201_n ) capacitor c=0.00720961f //x=4.38 \
 //y=0.545 //x2=5.705 //y2=1.085
cc_644 ( N_GND_c_845_n N_C_c_1208_n ) capacitor c=0.0028635f //x=7.15 \
 //y=0.175 //x2=6.08 //y2=1.585
cc_645 ( N_GND_M2_noxref_s N_C_c_1208_n ) capacitor c=0.00271091f //x=4.38 \
 //y=0.545 //x2=6.08 //y2=1.585
cc_646 ( N_GND_c_833_n N_C_c_1209_n ) capacitor c=0.00825432f //x=6.37 \
 //y=0.71 //x2=6.235 //y2=1.085
cc_647 ( N_GND_M2_noxref_s N_C_c_1209_n ) capacitor c=0.0151996f //x=4.38 \
 //y=0.545 //x2=6.235 //y2=1.085
cc_648 ( N_GND_c_833_n N_C_c_1211_n ) capacitor c=2.1838e-19 //x=6.37 //y=0.71 \
 //x2=5.67 //y2=2.26
cc_649 ( N_GND_c_845_n N_C_c_1211_n ) capacitor c=2.63786e-19 //x=7.15 \
 //y=0.175 //x2=5.67 //y2=2.26
cc_650 ( N_GND_M2_noxref_s N_C_c_1211_n ) capacitor c=0.00119136f //x=4.38 \
 //y=0.545 //x2=5.67 //y2=2.26
cc_651 ( N_GND_c_845_n N_Y_c_1308_n ) capacitor c=0.00344631f //x=7.15 \
 //y=0.175 //x2=8.26 //y2=1.935
cc_652 ( N_GND_c_812_n N_Y_c_1308_n ) capacitor c=0.00122336f //x=8.75 \
 //y=0.175 //x2=8.26 //y2=1.935
cc_653 ( N_GND_M4_noxref_s N_Y_c_1308_n ) capacitor c=0.0325324f //x=7.645 \
 //y=0.55 //x2=8.26 //y2=1.935
cc_654 ( N_GND_c_782_n N_Y_c_1320_n ) capacitor c=0.00497604f //x=8.63 \
 //y=0.18 //x2=8.545 //y2=2.02
cc_655 ( N_GND_c_843_n N_Y_c_1320_n ) capacitor c=0.00321695f //x=8.665 \
 //y=0.715 //x2=8.545 //y2=2.02
cc_656 ( N_GND_c_812_n N_Y_c_1320_n ) capacitor c=0.0298284f //x=8.75 \
 //y=0.175 //x2=8.545 //y2=2.02
cc_657 ( N_GND_M4_noxref_s N_Y_c_1320_n ) capacitor c=0.00565821f //x=7.645 \
 //y=0.55 //x2=8.545 //y2=2.02
cc_658 ( N_GND_c_782_n N_Y_c_1327_n ) capacitor c=0.00998676f //x=8.63 \
 //y=0.18 //x2=8.26 //y2=1.185
cc_659 ( N_GND_c_838_n N_Y_c_1327_n ) capacitor c=0.00124813f //x=8.175 \
 //y=0.715 //x2=8.26 //y2=1.185
cc_660 ( N_GND_c_843_n N_Y_c_1327_n ) capacitor c=0.00130539f //x=8.665 \
 //y=0.715 //x2=8.26 //y2=1.185
cc_661 ( N_GND_c_812_n N_Y_c_1327_n ) capacitor c=2.8029e-19 //x=8.75 \
 //y=0.175 //x2=8.26 //y2=1.185
cc_662 ( N_GND_M4_noxref_s N_Y_c_1327_n ) capacitor c=0.0156099f //x=7.645 \
 //y=0.55 //x2=8.26 //y2=1.185
cc_663 ( N_GND_c_782_n N_Y_M4_noxref_d ) capacitor c=0.00119455f //x=8.63 \
 //y=0.18 //x2=8.075 //y2=1.09
cc_664 ( N_GND_c_812_n N_Y_M4_noxref_d ) capacitor c=2.70835e-19 //x=8.75 \
 //y=0.175 //x2=8.075 //y2=1.09
cc_665 ( N_GND_M4_noxref_s N_Y_M4_noxref_d ) capacitor c=0.0377642f //x=7.645 \
 //y=0.55 //x2=8.075 //y2=1.09
cc_666 ( N_GND_c_887_n N_noxref_10_c_1387_n ) capacitor c=0.00275848f \
 //x=1.585 //y=0.175 //x2=2.07 //y2=1.76
cc_667 ( N_GND_c_782_n N_noxref_10_c_1387_n ) capacitor c=0.00203804f //x=8.63 \
 //y=0.18 //x2=2.07 //y2=1.76
cc_668 ( N_GND_c_788_n N_noxref_10_c_1387_n ) capacitor c=0.00407714f //x=1.67 \
 //y=1.135 //x2=2.07 //y2=1.76
cc_669 ( N_GND_c_791_n N_noxref_10_c_1387_n ) capacitor c=0.00369559f //x=3.65 \
 //y=0.175 //x2=2.07 //y2=1.76
cc_670 ( N_GND_M0_noxref_d N_noxref_10_c_1387_n ) capacitor c=0.00578453f \
 //x=1.48 //y=1.045 //x2=2.07 //y2=1.76
cc_671 ( N_GND_c_782_n N_noxref_10_c_1402_n ) capacitor c=0.0068323f //x=8.63 \
 //y=0.18 //x2=2.155 //y2=0.795
cc_672 ( N_GND_c_897_n N_noxref_10_c_1402_n ) capacitor c=0.0167642f //x=1.667 \
 //y=1.005 //x2=2.155 //y2=0.795
cc_673 ( N_GND_c_791_n N_noxref_10_c_1402_n ) capacitor c=0.0146605f //x=3.65 \
 //y=0.175 //x2=2.155 //y2=0.795
cc_674 ( N_GND_c_793_n N_noxref_10_c_1402_n ) capacitor c=0.00283128f //x=1.23 \
 //y=0.18 //x2=2.155 //y2=0.795
cc_675 ( N_GND_c_801_n N_noxref_10_c_1402_n ) capacitor c=2.21767e-19 //x=3.82 \
 //y=0.175 //x2=2.155 //y2=0.795
cc_676 ( N_GND_c_812_n N_noxref_10_c_1402_n ) capacitor c=0.00145873f //x=8.75 \
 //y=0.175 //x2=2.155 //y2=0.795
cc_677 ( N_GND_c_793_n N_noxref_10_c_1376_n ) capacitor c=2.85935e-19 //x=1.23 \
 //y=0.18 //x2=2.155 //y2=1.675
cc_678 ( N_GND_c_782_n N_noxref_10_c_1377_n ) capacitor c=0.0100399f //x=8.63 \
 //y=0.18 //x2=3.04 //y2=0.71
cc_679 ( N_GND_c_791_n N_noxref_10_c_1377_n ) capacitor c=0.0374826f //x=3.65 \
 //y=0.175 //x2=3.04 //y2=0.71
cc_680 ( N_GND_c_812_n N_noxref_10_c_1377_n ) capacitor c=0.00198956f //x=8.75 \
 //y=0.175 //x2=3.04 //y2=0.71
cc_681 ( N_GND_c_782_n N_noxref_10_c_1412_n ) capacitor c=0.00245021f //x=8.63 \
 //y=0.18 //x2=3.125 //y2=0.795
cc_682 ( N_GND_c_791_n N_noxref_10_c_1412_n ) capacitor c=0.0145368f //x=3.65 \
 //y=0.175 //x2=3.125 //y2=0.795
cc_683 ( N_GND_c_962_p N_noxref_10_c_1412_n ) capacitor c=0.0019997f //x=4.515 \
 //y=0.625 //x2=3.125 //y2=0.795
cc_684 ( N_GND_c_801_n N_noxref_10_c_1412_n ) capacitor c=0.0401922f //x=3.82 \
 //y=0.175 //x2=3.125 //y2=0.795
cc_685 ( N_GND_c_812_n N_noxref_10_c_1412_n ) capacitor c=0.00145015f //x=8.75 \
 //y=0.175 //x2=3.125 //y2=0.795
cc_686 ( N_GND_c_887_n N_noxref_10_M0_noxref_s ) capacitor c=0.00724992f \
 //x=1.585 //y=0.175 //x2=1.05 //y2=0.545
cc_687 ( N_GND_c_788_n N_noxref_10_M0_noxref_s ) capacitor c=0.0113988f \
 //x=1.67 //y=1.135 //x2=1.05 //y2=0.545
cc_688 ( N_GND_c_897_n N_noxref_10_M0_noxref_s ) capacitor c=0.0173062f \
 //x=1.667 //y=1.005 //x2=1.05 //y2=0.545
cc_689 ( N_GND_c_791_n N_noxref_10_M0_noxref_s ) capacitor c=0.014661f \
 //x=3.65 //y=0.175 //x2=1.05 //y2=0.545
cc_690 ( N_GND_c_793_n N_noxref_10_M0_noxref_s ) capacitor c=0.0559891f \
 //x=1.23 //y=0.18 //x2=1.05 //y2=0.545
cc_691 ( N_GND_c_801_n N_noxref_10_M0_noxref_s ) capacitor c=0.00642623f \
 //x=3.82 //y=0.175 //x2=1.05 //y2=0.545
cc_692 ( N_GND_c_812_n N_noxref_10_M0_noxref_s ) capacitor c=0.00145873f \
 //x=8.75 //y=0.175 //x2=1.05 //y2=0.545
cc_693 ( N_GND_M0_noxref_d N_noxref_10_M0_noxref_s ) capacitor c=0.0271276f \
 //x=1.48 //y=1.045 //x2=1.05 //y2=0.545
cc_694 ( N_GND_M2_noxref_s N_noxref_10_M0_noxref_s ) capacitor c=0.00298769f \
 //x=4.38 //y=0.545 //x2=1.05 //y2=0.545
cc_695 ( N_B_c_983_n N_noxref_10_c_1376_n ) capacitor c=7.471e-19 //x=2.34 \
 //y=2.26 //x2=2.155 //y2=1.675
cc_696 ( N_B_c_999_n N_noxref_10_c_1376_n ) capacitor c=0.00888238f //x=2.375 \
 //y=1.74 //x2=2.155 //y2=1.675
cc_697 ( N_B_c_1015_n N_noxref_10_c_1376_n ) capacitor c=0.00173073f //x=2.34 \
 //y=2.26 //x2=2.155 //y2=1.675
cc_698 ( N_B_c_983_n N_noxref_10_c_1377_n ) capacitor c=0.00141156f //x=2.34 \
 //y=2.26 //x2=3.04 //y2=0.71
cc_699 ( N_B_c_985_n N_noxref_10_c_1377_n ) capacitor c=8.82141e-19 //x=2.34 \
 //y=2.26 //x2=3.04 //y2=0.71
cc_700 ( N_B_c_994_n N_noxref_10_c_1377_n ) capacitor c=0.0199501f //x=2.375 \
 //y=1.085 //x2=3.04 //y2=0.71
cc_701 ( N_B_c_1009_n N_noxref_10_c_1377_n ) capacitor c=0.00825432f //x=2.905 \
 //y=1.085 //x2=3.04 //y2=0.71
cc_702 ( N_B_c_1015_n N_noxref_10_c_1377_n ) capacitor c=2.1838e-19 //x=2.34 \
 //y=2.26 //x2=3.04 //y2=0.71
cc_703 ( N_B_c_994_n N_noxref_10_M0_noxref_s ) capacitor c=0.00888238f \
 //x=2.375 //y=1.085 //x2=1.05 //y2=0.545
cc_704 ( N_B_c_1009_n N_noxref_10_M0_noxref_s ) capacitor c=0.015333f \
 //x=2.905 //y=1.085 //x2=1.05 //y2=0.545
cc_705 ( N_B_c_1011_n N_noxref_10_M0_noxref_s ) capacitor c=0.00248746f \
 //x=2.905 //y=1.43 //x2=1.05 //y2=0.545
cc_706 ( N_noxref_7_c_1094_n N_C_c_1184_n ) capacitor c=7.31659e-19 //x=5.49 \
 //y=5.39 //x2=5.67 //y2=2.26
cc_707 ( N_noxref_7_c_1104_n N_C_c_1187_n ) capacitor c=0.00213985f //x=6.24 \
 //y=7.09 //x2=5.705 //y2=4.885
cc_708 ( N_noxref_7_c_1094_n N_C_c_1187_n ) capacitor c=0.00262304f //x=5.49 \
 //y=5.39 //x2=5.705 //y2=4.885
cc_709 ( N_noxref_7_c_1104_n N_C_c_1194_n ) capacitor c=0.00233585f //x=6.24 \
 //y=7.09 //x2=5.705 //y2=4.885
cc_710 ( N_noxref_7_c_1104_n N_C_M11_noxref_g ) capacitor c=0.00777443f \
 //x=6.24 //y=7.09 //x2=5.71 //y2=6.205
cc_711 ( N_noxref_7_c_1094_n N_C_M11_noxref_g ) capacitor c=0.00176767f \
 //x=5.49 //y=5.39 //x2=5.71 //y2=6.205
cc_712 ( N_noxref_7_c_1095_n N_C_M11_noxref_g ) capacitor c=0.00186228f \
 //x=5.49 //y=6.92 //x2=5.71 //y2=6.205
cc_713 ( N_noxref_7_c_1100_n N_C_M11_noxref_g ) capacitor c=0.0170175f \
 //x=5.49 //y=5.56 //x2=5.71 //y2=6.205
cc_714 ( N_noxref_7_c_1104_n N_C_M12_noxref_g ) capacitor c=0.0093887f \
 //x=6.24 //y=7.09 //x2=6.15 //y2=6.205
cc_715 ( N_noxref_7_c_1111_n N_C_M12_noxref_g ) capacitor c=0.00410728f \
 //x=6.37 //y=6.92 //x2=6.15 //y2=6.205
cc_716 ( N_noxref_7_M12_noxref_d N_C_M12_noxref_g ) capacitor c=0.0365939f \
 //x=6.225 //y=5.205 //x2=6.15 //y2=6.205
cc_717 ( N_noxref_7_c_1094_n N_C_c_1215_n ) capacitor c=6.45633e-19 //x=5.49 \
 //y=5.39 //x2=5.705 //y2=4.885
cc_718 ( N_noxref_7_c_1094_n N_Y_c_1316_n ) capacitor c=3.69557e-19 //x=5.49 \
 //y=5.39 //x2=8.265 //y2=5.42
