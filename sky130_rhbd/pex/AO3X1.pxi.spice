// File: AO3X1.spi.AO3X1.pxi
// Created: Tue Apr 29 10:38:22 2025
//
simulator lang=spectre
x_PM_AO3X1\%GND ( GND N_GND_c_13_p N_GND_c_70_p N_GND_c_1_p N_GND_c_77_p \
 N_GND_c_96_p N_GND_c_5_p N_GND_c_21_p N_GND_c_35_p N_GND_c_38_p N_GND_c_27_p \
 N_GND_c_53_p N_GND_c_2_p N_GND_c_3_p N_GND_c_4_p N_GND_M0_noxref_d \
 N_GND_M2_noxref_s N_GND_M4_noxref_s )  PM_AO3X1\%GND
x_PM_AO3X1\%VDD ( VDD N_VDD_c_146_p N_VDD_c_128_p N_VDD_c_129_p N_VDD_c_140_p \
 N_VDD_c_143_p N_VDD_c_166_p N_VDD_c_123_n N_VDD_c_124_n N_VDD_c_125_n \
 N_VDD_c_126_n N_VDD_M5_noxref_s N_VDD_M6_noxref_d N_VDD_M8_noxref_d \
 N_VDD_M9_noxref_d N_VDD_M13_noxref_s N_VDD_M14_noxref_d )  PM_AO3X1\%VDD
x_PM_AO3X1\%noxref_3 ( N_noxref_3_c_225_n N_noxref_3_c_228_n \
 N_noxref_3_c_248_n N_noxref_3_c_251_n N_noxref_3_c_253_n N_noxref_3_c_229_n \
 N_noxref_3_c_324_p N_noxref_3_c_231_n N_noxref_3_c_233_n N_noxref_3_c_312_p \
 N_noxref_3_c_258_n N_noxref_3_M2_noxref_g N_noxref_3_M9_noxref_g \
 N_noxref_3_M10_noxref_g N_noxref_3_c_236_n N_noxref_3_c_286_p \
 N_noxref_3_c_287_p N_noxref_3_c_238_n N_noxref_3_c_240_n N_noxref_3_c_290_p \
 N_noxref_3_c_333_p N_noxref_3_c_241_n N_noxref_3_c_243_n N_noxref_3_c_265_n \
 N_noxref_3_M1_noxref_d N_noxref_3_M5_noxref_d N_noxref_3_M7_noxref_d )  \
 PM_AO3X1\%noxref_3
x_PM_AO3X1\%noxref_4 ( N_noxref_4_c_369_n N_noxref_4_c_373_n \
 N_noxref_4_c_375_n N_noxref_4_c_432_n N_noxref_4_c_412_n N_noxref_4_c_413_n \
 N_noxref_4_c_379_n N_noxref_4_c_384_n N_noxref_4_c_386_n \
 N_noxref_4_M4_noxref_g N_noxref_4_M13_noxref_g N_noxref_4_M14_noxref_g \
 N_noxref_4_c_391_n N_noxref_4_c_490_p N_noxref_4_c_491_p N_noxref_4_c_393_n \
 N_noxref_4_c_424_n N_noxref_4_c_425_n N_noxref_4_c_394_n N_noxref_4_c_482_p \
 N_noxref_4_c_395_n N_noxref_4_c_397_n N_noxref_4_c_398_n \
 N_noxref_4_M2_noxref_d N_noxref_4_M3_noxref_d N_noxref_4_M11_noxref_d )  \
 PM_AO3X1\%noxref_4
x_PM_AO3X1\%A ( A A A A A A A N_A_c_502_n N_A_M0_noxref_g N_A_M5_noxref_g \
 N_A_M6_noxref_g N_A_c_503_n N_A_c_505_n N_A_c_506_n N_A_c_507_n N_A_c_508_n \
 N_A_c_509_n N_A_c_510_n N_A_c_512_n N_A_c_519_n )  PM_AO3X1\%A
x_PM_AO3X1\%B ( B B B B B B B N_B_c_566_n N_B_c_557_n N_B_M1_noxref_g \
 N_B_M7_noxref_g N_B_M8_noxref_g N_B_c_575_n N_B_c_576_n N_B_c_577_n \
 N_B_c_578_n N_B_c_580_n N_B_c_581_n N_B_c_583_n N_B_c_584_n N_B_c_586_n \
 N_B_c_587_n N_B_c_589_n )  PM_AO3X1\%B
x_PM_AO3X1\%noxref_7 ( N_noxref_7_c_645_n N_noxref_7_c_621_n \
 N_noxref_7_c_625_n N_noxref_7_c_629_n N_noxref_7_c_630_n N_noxref_7_c_633_n \
 N_noxref_7_M0_noxref_s )  PM_AO3X1\%noxref_7
x_PM_AO3X1\%C ( C C C C C C C N_C_c_685_n N_C_c_672_n N_C_M3_noxref_g \
 N_C_M11_noxref_g N_C_M12_noxref_g N_C_c_674_n N_C_c_697_n N_C_c_700_n \
 N_C_c_724_n N_C_c_676_n N_C_c_677_n N_C_c_678_n N_C_c_704_n N_C_c_705_n \
 N_C_c_707_n N_C_c_708_n )  PM_AO3X1\%C
x_PM_AO3X1\%noxref_9 ( N_noxref_9_c_743_n N_noxref_9_c_747_n \
 N_noxref_9_c_748_n N_noxref_9_c_749_n N_noxref_9_M9_noxref_s \
 N_noxref_9_M10_noxref_d N_noxref_9_M12_noxref_d )  PM_AO3X1\%noxref_9
x_PM_AO3X1\%Y ( Y Y Y Y Y Y Y N_Y_c_787_n N_Y_c_810_n N_Y_c_797_n N_Y_c_799_n \
 N_Y_M4_noxref_d N_Y_M13_noxref_d )  PM_AO3X1\%Y
cc_1 ( N_GND_c_1_p N_VDD_c_123_n ) capacitor c=0.00989514f //x=1.23 //y=0.18 \
 //x2=1.23 //y2=7.58
cc_2 ( N_GND_c_2_p N_VDD_c_124_n ) capacitor c=0.00963367f //x=3.82 //y=0.175 \
 //x2=3.82 //y2=7.585
cc_3 ( N_GND_c_3_p N_VDD_c_125_n ) capacitor c=0.00963367f //x=7.15 //y=0.175 \
 //x2=7.15 //y2=7.585
cc_4 ( N_GND_c_4_p N_VDD_c_126_n ) capacitor c=0.00989514f //x=8.75 //y=0.175 \
 //x2=8.63 //y2=7.58
cc_5 ( N_GND_c_5_p N_noxref_3_c_225_n ) capacitor c=7.233e-19 //x=4.915 \
 //y=0.71 //x2=4.815 //y2=2.77
cc_6 ( N_GND_c_2_p N_noxref_3_c_225_n ) capacitor c=0.0435449f //x=3.82 \
 //y=0.175 //x2=4.815 //y2=2.77
cc_7 ( N_GND_M2_noxref_s N_noxref_3_c_225_n ) capacitor c=0.00494377f //x=4.38 \
 //y=0.545 //x2=4.815 //y2=2.77
cc_8 ( N_GND_c_2_p N_noxref_3_c_228_n ) capacitor c=0.00102529f //x=3.82 \
 //y=0.175 //x2=3.195 //y2=2.77
cc_9 ( N_GND_c_2_p N_noxref_3_c_229_n ) capacitor c=0.0431271f //x=3.82 \
 //y=0.175 //x2=2.995 //y2=1.835
cc_10 ( N_GND_M2_noxref_s N_noxref_3_c_229_n ) capacitor c=3.00901e-19 \
 //x=4.38 //y=0.545 //x2=2.995 //y2=1.835
cc_11 ( N_GND_c_1_p N_noxref_3_c_231_n ) capacitor c=0.00101801f //x=1.23 \
 //y=0.18 //x2=3.08 //y2=2.77
cc_12 ( N_GND_c_2_p N_noxref_3_c_231_n ) capacitor c=5.56859e-19 //x=3.82 \
 //y=0.175 //x2=3.08 //y2=2.77
cc_13 ( N_GND_c_13_p N_noxref_3_c_233_n ) capacitor c=6.77224e-19 //x=8.63 \
 //y=0.18 //x2=4.93 //y2=2.26
cc_14 ( N_GND_c_5_p N_noxref_3_c_233_n ) capacitor c=0.00133267f //x=4.915 \
 //y=0.71 //x2=4.93 //y2=2.26
cc_15 ( N_GND_c_2_p N_noxref_3_c_233_n ) capacitor c=0.0147015f //x=3.82 \
 //y=0.175 //x2=4.93 //y2=2.26
cc_16 ( N_GND_c_5_p N_noxref_3_c_236_n ) capacitor c=0.0122588f //x=4.915 \
 //y=0.71 //x2=4.735 //y2=1.085
cc_17 ( N_GND_M2_noxref_s N_noxref_3_c_236_n ) capacitor c=0.0318086f //x=4.38 \
 //y=0.545 //x2=4.735 //y2=1.085
cc_18 ( N_GND_c_5_p N_noxref_3_c_238_n ) capacitor c=2.1838e-19 //x=4.915 \
 //y=0.71 //x2=4.735 //y2=2.095
cc_19 ( N_GND_c_2_p N_noxref_3_c_238_n ) capacitor c=0.0131707f //x=3.82 \
 //y=0.175 //x2=4.735 //y2=2.095
cc_20 ( N_GND_M2_noxref_s N_noxref_3_c_240_n ) capacitor c=0.00476604f \
 //x=4.38 //y=0.545 //x2=5.11 //y2=0.93
cc_21 ( N_GND_c_21_p N_noxref_3_c_241_n ) capacitor c=0.0113306f //x=5.4 \
 //y=0.71 //x2=5.265 //y2=1.085
cc_22 ( N_GND_M2_noxref_s N_noxref_3_c_241_n ) capacitor c=0.00514143f \
 //x=4.38 //y=0.545 //x2=5.265 //y2=1.085
cc_23 ( N_GND_M2_noxref_s N_noxref_3_c_243_n ) capacitor c=8.33128e-19 \
 //x=4.38 //y=0.545 //x2=5.265 //y2=1.43
cc_24 ( N_GND_c_1_p N_noxref_3_M1_noxref_d ) capacitor c=8.58106e-19 //x=1.23 \
 //y=0.18 //x2=2.45 //y2=1.085
cc_25 ( N_GND_c_2_p N_noxref_3_M1_noxref_d ) capacitor c=0.00616547f //x=3.82 \
 //y=0.175 //x2=2.45 //y2=1.085
cc_26 ( N_GND_M0_noxref_d N_noxref_3_M1_noxref_d ) capacitor c=0.00143464f \
 //x=1.48 //y=1.045 //x2=2.45 //y2=1.085
cc_27 ( N_GND_c_27_p N_noxref_4_c_369_n ) capacitor c=2.8021e-19 //x=8.18 \
 //y=0.715 //x2=7.775 //y2=2.77
cc_28 ( N_GND_c_3_p N_noxref_4_c_369_n ) capacitor c=0.0424932f //x=7.15 \
 //y=0.175 //x2=7.775 //y2=2.77
cc_29 ( N_GND_M2_noxref_s N_noxref_4_c_369_n ) capacitor c=3.07352e-19 \
 //x=4.38 //y=0.545 //x2=7.775 //y2=2.77
cc_30 ( N_GND_M4_noxref_s N_noxref_4_c_369_n ) capacitor c=0.00380507f \
 //x=7.645 //y=0.55 //x2=7.775 //y2=2.77
cc_31 ( N_GND_c_3_p N_noxref_4_c_373_n ) capacitor c=9.11674e-19 //x=7.15 \
 //y=0.175 //x2=6.525 //y2=2.77
cc_32 ( N_GND_M2_noxref_s N_noxref_4_c_373_n ) capacitor c=0.00162167f \
 //x=4.38 //y=0.545 //x2=6.525 //y2=2.77
cc_33 ( N_GND_c_13_p N_noxref_4_c_375_n ) capacitor c=0.00359332f //x=8.63 \
 //y=0.18 //x2=5.885 //y2=1.835
cc_34 ( N_GND_c_21_p N_noxref_4_c_375_n ) capacitor c=0.00381844f //x=5.4 \
 //y=0.71 //x2=5.885 //y2=1.835
cc_35 ( N_GND_c_35_p N_noxref_4_c_375_n ) capacitor c=0.00323369f //x=5.885 \
 //y=0.71 //x2=5.885 //y2=1.835
cc_36 ( N_GND_M2_noxref_s N_noxref_4_c_375_n ) capacitor c=0.0173696f //x=4.38 \
 //y=0.545 //x2=5.885 //y2=1.835
cc_37 ( N_GND_c_13_p N_noxref_4_c_379_n ) capacitor c=0.00233035f //x=8.63 \
 //y=0.18 //x2=6.325 //y2=1.835
cc_38 ( N_GND_c_38_p N_noxref_4_c_379_n ) capacitor c=0.00479063f //x=6.37 \
 //y=0.71 //x2=6.325 //y2=1.835
cc_39 ( N_GND_c_3_p N_noxref_4_c_379_n ) capacitor c=0.0432715f //x=7.15 \
 //y=0.175 //x2=6.325 //y2=1.835
cc_40 ( N_GND_M2_noxref_s N_noxref_4_c_379_n ) capacitor c=0.0145664f //x=4.38 \
 //y=0.545 //x2=6.325 //y2=1.835
cc_41 ( N_GND_M4_noxref_s N_noxref_4_c_379_n ) capacitor c=3.53679e-19 \
 //x=7.645 //y=0.55 //x2=6.325 //y2=1.835
cc_42 ( N_GND_c_2_p N_noxref_4_c_384_n ) capacitor c=9.64732e-19 //x=3.82 \
 //y=0.175 //x2=6.41 //y2=2.77
cc_43 ( N_GND_c_3_p N_noxref_4_c_384_n ) capacitor c=5.56859e-19 //x=7.15 \
 //y=0.175 //x2=6.41 //y2=2.77
cc_44 ( N_GND_c_13_p N_noxref_4_c_386_n ) capacitor c=0.00203126f //x=8.63 \
 //y=0.18 //x2=7.89 //y2=2.265
cc_45 ( N_GND_c_27_p N_noxref_4_c_386_n ) capacitor c=7.79915e-19 //x=8.18 \
 //y=0.715 //x2=7.89 //y2=2.265
cc_46 ( N_GND_c_3_p N_noxref_4_c_386_n ) capacitor c=0.0264037f //x=7.15 \
 //y=0.175 //x2=7.89 //y2=2.265
cc_47 ( N_GND_c_4_p N_noxref_4_c_386_n ) capacitor c=0.00135052f //x=8.75 \
 //y=0.175 //x2=7.89 //y2=2.265
cc_48 ( N_GND_M4_noxref_s N_noxref_4_c_386_n ) capacitor c=0.0105404f \
 //x=7.645 //y=0.55 //x2=7.89 //y2=2.265
cc_49 ( N_GND_c_27_p N_noxref_4_c_391_n ) capacitor c=0.0121156f //x=8.18 \
 //y=0.715 //x2=8 //y2=1.09
cc_50 ( N_GND_M4_noxref_s N_noxref_4_c_391_n ) capacitor c=0.0317181f \
 //x=7.645 //y=0.55 //x2=8 //y2=1.09
cc_51 ( N_GND_c_3_p N_noxref_4_c_393_n ) capacitor c=0.00552709f //x=7.15 \
 //y=0.175 //x2=8 //y2=2.1
cc_52 ( N_GND_M4_noxref_s N_noxref_4_c_394_n ) capacitor c=0.00483567f \
 //x=7.645 //y=0.55 //x2=8.375 //y2=0.935
cc_53 ( N_GND_c_53_p N_noxref_4_c_395_n ) capacitor c=0.0118631f //x=8.665 \
 //y=0.715 //x2=8.53 //y2=1.09
cc_54 ( N_GND_M4_noxref_s N_noxref_4_c_395_n ) capacitor c=0.0143355f \
 //x=7.645 //y=0.55 //x2=8.53 //y2=1.09
cc_55 ( N_GND_M4_noxref_s N_noxref_4_c_397_n ) capacitor c=0.0074042f \
 //x=7.645 //y=0.55 //x2=8.53 //y2=1.435
cc_56 ( N_GND_c_27_p N_noxref_4_c_398_n ) capacitor c=2.1838e-19 //x=8.18 \
 //y=0.715 //x2=7.89 //y2=2.265
cc_57 ( N_GND_c_3_p N_noxref_4_c_398_n ) capacitor c=0.0108179f //x=7.15 \
 //y=0.175 //x2=7.89 //y2=2.265
cc_58 ( N_GND_M4_noxref_s N_noxref_4_c_398_n ) capacitor c=0.006523f //x=7.645 \
 //y=0.55 //x2=7.89 //y2=2.265
cc_59 ( N_GND_c_13_p N_noxref_4_M2_noxref_d ) capacitor c=0.00175671f //x=8.63 \
 //y=0.18 //x2=4.81 //y2=1.085
cc_60 ( N_GND_c_2_p N_noxref_4_M2_noxref_d ) capacitor c=0.00416273f //x=3.82 \
 //y=0.175 //x2=4.81 //y2=1.085
cc_61 ( N_GND_c_3_p N_noxref_4_M2_noxref_d ) capacitor c=2.57516e-19 //x=7.15 \
 //y=0.175 //x2=4.81 //y2=1.085
cc_62 ( N_GND_c_4_p N_noxref_4_M2_noxref_d ) capacitor c=2.31043e-19 //x=8.75 \
 //y=0.175 //x2=4.81 //y2=1.085
cc_63 ( N_GND_M2_noxref_s N_noxref_4_M2_noxref_d ) capacitor c=0.0769615f \
 //x=4.38 //y=0.545 //x2=4.81 //y2=1.085
cc_64 ( N_GND_c_13_p N_noxref_4_M3_noxref_d ) capacitor c=0.00195238f //x=8.63 \
 //y=0.18 //x2=5.78 //y2=1.085
cc_65 ( N_GND_c_3_p N_noxref_4_M3_noxref_d ) capacitor c=0.00609243f //x=7.15 \
 //y=0.175 //x2=5.78 //y2=1.085
cc_66 ( N_GND_c_4_p N_noxref_4_M3_noxref_d ) capacitor c=2.31043e-19 //x=8.75 \
 //y=0.175 //x2=5.78 //y2=1.085
cc_67 ( N_GND_M2_noxref_s N_noxref_4_M3_noxref_d ) capacitor c=0.061033f \
 //x=4.38 //y=0.545 //x2=5.78 //y2=1.085
cc_68 ( N_GND_M4_noxref_s N_noxref_4_M3_noxref_d ) capacitor c=2.04477e-19 \
 //x=7.645 //y=0.55 //x2=5.78 //y2=1.085
cc_69 ( N_GND_c_1_p N_A_c_502_n ) capacitor c=0.0180518f //x=1.23 //y=0.18 \
 //x2=1.6 //y2=2.26
cc_70 ( N_GND_c_70_p N_A_c_503_n ) capacitor c=0.00135783f //x=1.585 //y=0.175 \
 //x2=1.405 //y2=1.045
cc_71 ( N_GND_M0_noxref_d N_A_c_503_n ) capacitor c=0.00220047f //x=1.48 \
 //y=1.045 //x2=1.405 //y2=1.045
cc_72 ( N_GND_M0_noxref_d N_A_c_505_n ) capacitor c=0.00255985f //x=1.48 \
 //y=1.045 //x2=1.405 //y2=1.39
cc_73 ( N_GND_c_1_p N_A_c_506_n ) capacitor c=0.00264481f //x=1.23 //y=0.18 \
 //x2=1.405 //y2=1.7
cc_74 ( N_GND_c_1_p N_A_c_507_n ) capacitor c=0.0121947f //x=1.23 //y=0.18 \
 //x2=1.405 //y2=2.095
cc_75 ( N_GND_M0_noxref_d N_A_c_508_n ) capacitor c=0.0131374f //x=1.48 \
 //y=1.045 //x2=1.78 //y2=0.89
cc_76 ( N_GND_M0_noxref_d N_A_c_509_n ) capacitor c=0.00193146f //x=1.48 \
 //y=1.045 //x2=1.78 //y2=1.545
cc_77 ( N_GND_c_77_p N_A_c_510_n ) capacitor c=0.00131234f //x=3.65 //y=0.175 \
 //x2=1.935 //y2=1.045
cc_78 ( N_GND_M0_noxref_d N_A_c_510_n ) capacitor c=0.00257848f //x=1.48 \
 //y=1.045 //x2=1.935 //y2=1.045
cc_79 ( N_GND_M0_noxref_d N_A_c_512_n ) capacitor c=0.00255985f //x=1.48 \
 //y=1.045 //x2=1.935 //y2=1.39
cc_80 ( N_GND_c_1_p N_B_c_557_n ) capacitor c=9.2064e-19 //x=1.23 //y=0.18 \
 //x2=2.34 //y2=2.26
cc_81 ( N_GND_c_2_p N_B_c_557_n ) capacitor c=0.00110071f //x=3.82 //y=0.175 \
 //x2=2.34 //y2=2.26
cc_82 ( N_GND_c_13_p N_noxref_7_c_621_n ) capacitor c=0.00711001f //x=8.63 \
 //y=0.18 //x2=2.07 //y2=1.76
cc_83 ( N_GND_c_70_p N_noxref_7_c_621_n ) capacitor c=0.00111556f //x=1.585 \
 //y=0.175 //x2=2.07 //y2=1.76
cc_84 ( N_GND_c_77_p N_noxref_7_c_621_n ) capacitor c=0.00181083f //x=3.65 \
 //y=0.175 //x2=2.07 //y2=1.76
cc_85 ( N_GND_M0_noxref_d N_noxref_7_c_621_n ) capacitor c=0.00909955f \
 //x=1.48 //y=1.045 //x2=2.07 //y2=1.76
cc_86 ( N_GND_c_13_p N_noxref_7_c_625_n ) capacitor c=0.00724992f //x=8.63 \
 //y=0.18 //x2=2.155 //y2=0.795
cc_87 ( N_GND_c_77_p N_noxref_7_c_625_n ) capacitor c=0.014661f //x=3.65 \
 //y=0.175 //x2=2.155 //y2=0.795
cc_88 ( N_GND_c_4_p N_noxref_7_c_625_n ) capacitor c=0.00145873f //x=8.75 \
 //y=0.175 //x2=2.155 //y2=0.795
cc_89 ( N_GND_M0_noxref_d N_noxref_7_c_625_n ) capacitor c=0.033812f //x=1.48 \
 //y=1.045 //x2=2.155 //y2=0.795
cc_90 ( N_GND_c_1_p N_noxref_7_c_629_n ) capacitor c=2.91423e-19 //x=1.23 \
 //y=0.18 //x2=2.155 //y2=1.675
cc_91 ( N_GND_c_13_p N_noxref_7_c_630_n ) capacitor c=0.0199827f //x=8.63 \
 //y=0.18 //x2=3.04 //y2=0.71
cc_92 ( N_GND_c_77_p N_noxref_7_c_630_n ) capacitor c=0.0371502f //x=3.65 \
 //y=0.175 //x2=3.04 //y2=0.71
cc_93 ( N_GND_c_4_p N_noxref_7_c_630_n ) capacitor c=0.00198956f //x=8.75 \
 //y=0.175 //x2=3.04 //y2=0.71
cc_94 ( N_GND_c_13_p N_noxref_7_c_633_n ) capacitor c=0.00720883f //x=8.63 \
 //y=0.18 //x2=3.125 //y2=0.795
cc_95 ( N_GND_c_77_p N_noxref_7_c_633_n ) capacitor c=0.0144635f //x=3.65 \
 //y=0.175 //x2=3.125 //y2=0.795
cc_96 ( N_GND_c_96_p N_noxref_7_c_633_n ) capacitor c=9.02073e-19 //x=4.515 \
 //y=0.625 //x2=3.125 //y2=0.795
cc_97 ( N_GND_c_2_p N_noxref_7_c_633_n ) capacitor c=0.0431718f //x=3.82 \
 //y=0.175 //x2=3.125 //y2=0.795
cc_98 ( N_GND_c_4_p N_noxref_7_c_633_n ) capacitor c=0.00145015f //x=8.75 \
 //y=0.175 //x2=3.125 //y2=0.795
cc_99 ( N_GND_c_13_p N_noxref_7_M0_noxref_s ) capacitor c=0.00724992f //x=8.63 \
 //y=0.18 //x2=1.05 //y2=0.545
cc_100 ( N_GND_c_70_p N_noxref_7_M0_noxref_s ) capacitor c=0.014661f //x=1.585 \
 //y=0.175 //x2=1.05 //y2=0.545
cc_101 ( N_GND_c_1_p N_noxref_7_M0_noxref_s ) capacitor c=0.0594057f //x=1.23 \
 //y=0.18 //x2=1.05 //y2=0.545
cc_102 ( N_GND_c_2_p N_noxref_7_M0_noxref_s ) capacitor c=0.00198043f //x=3.82 \
 //y=0.175 //x2=1.05 //y2=0.545
cc_103 ( N_GND_c_4_p N_noxref_7_M0_noxref_s ) capacitor c=0.00145873f //x=8.75 \
 //y=0.175 //x2=1.05 //y2=0.545
cc_104 ( N_GND_M0_noxref_d N_noxref_7_M0_noxref_s ) capacitor c=0.0334197f \
 //x=1.48 //y=1.045 //x2=1.05 //y2=0.545
cc_105 ( N_GND_M2_noxref_s N_noxref_7_M0_noxref_s ) capacitor c=9.02073e-19 \
 //x=4.38 //y=0.545 //x2=1.05 //y2=0.545
cc_106 ( N_GND_c_2_p N_C_c_672_n ) capacitor c=0.00112835f //x=3.82 //y=0.175 \
 //x2=5.67 //y2=2.26
cc_107 ( N_GND_c_3_p N_C_c_672_n ) capacitor c=0.00110071f //x=7.15 //y=0.175 \
 //x2=5.67 //y2=2.26
cc_108 ( N_GND_c_35_p N_C_c_674_n ) capacitor c=0.0109831f //x=5.885 //y=0.71 \
 //x2=5.705 //y2=1.085
cc_109 ( N_GND_M2_noxref_s N_C_c_674_n ) capacitor c=0.00590563f //x=4.38 \
 //y=0.545 //x2=5.705 //y2=1.085
cc_110 ( N_GND_M2_noxref_s N_C_c_676_n ) capacitor c=0.00467042f //x=4.38 \
 //y=0.545 //x2=6.08 //y2=0.93
cc_111 ( N_GND_M2_noxref_s N_C_c_677_n ) capacitor c=0.00316186f //x=4.38 \
 //y=0.545 //x2=6.08 //y2=1.585
cc_112 ( N_GND_c_38_p N_C_c_678_n ) capacitor c=0.011235f //x=6.37 //y=0.71 \
 //x2=6.235 //y2=1.085
cc_113 ( N_GND_M2_noxref_s N_C_c_678_n ) capacitor c=0.0142835f //x=4.38 \
 //y=0.545 //x2=6.235 //y2=1.085
cc_114 ( N_GND_c_3_p Y ) capacitor c=9.57726e-19 //x=7.15 //y=0.175 //x2=8.63 \
 //y2=2.4
cc_115 ( N_GND_c_13_p N_Y_c_787_n ) capacitor c=0.00212303f //x=8.63 //y=0.18 \
 //x2=8.545 //y2=2.26
cc_116 ( N_GND_c_4_p N_Y_c_787_n ) capacitor c=0.029556f //x=8.75 //y=0.175 \
 //x2=8.545 //y2=2.26
cc_117 ( N_GND_M4_noxref_s N_Y_c_787_n ) capacitor c=0.0099963f //x=7.645 \
 //y=0.55 //x2=8.545 //y2=2.26
cc_118 ( N_GND_c_13_p N_Y_M4_noxref_d ) capacitor c=0.00194747f //x=8.63 \
 //y=0.18 //x2=8.075 //y2=1.09
cc_119 ( N_GND_c_27_p N_Y_M4_noxref_d ) capacitor c=0.014622f //x=8.18 \
 //y=0.715 //x2=8.075 //y2=1.09
cc_120 ( N_GND_c_3_p N_Y_M4_noxref_d ) capacitor c=0.00924905f //x=7.15 \
 //y=0.175 //x2=8.075 //y2=1.09
cc_121 ( N_GND_c_4_p N_Y_M4_noxref_d ) capacitor c=0.00973758f //x=8.75 \
 //y=0.175 //x2=8.075 //y2=1.09
cc_122 ( N_GND_M4_noxref_s N_Y_M4_noxref_d ) capacitor c=0.076995f //x=7.645 \
 //y=0.55 //x2=8.075 //y2=1.09
cc_123 ( N_VDD_c_124_n N_noxref_3_c_225_n ) capacitor c=0.00382819f //x=3.82 \
 //y=7.585 //x2=4.815 //y2=2.77
cc_124 ( N_VDD_c_128_p N_noxref_3_c_248_n ) capacitor c=5.7743e-19 //x=2.075 \
 //y=7.585 //x2=2.515 //y2=5.38
cc_125 ( N_VDD_c_129_p N_noxref_3_c_248_n ) capacitor c=5.7743e-19 //x=2.955 \
 //y=7.585 //x2=2.515 //y2=5.38
cc_126 ( N_VDD_M6_noxref_d N_noxref_3_c_248_n ) capacitor c=0.0132783f \
 //x=2.015 //y=5.2 //x2=2.515 //y2=5.38
cc_127 ( N_VDD_c_123_n N_noxref_3_c_251_n ) capacitor c=0.00989999f //x=1.23 \
 //y=7.58 //x2=1.805 //y2=5.38
cc_128 ( N_VDD_M5_noxref_s N_noxref_3_c_251_n ) capacitor c=0.087833f \
 //x=1.145 //y=5.2 //x2=1.805 //y2=5.38
cc_129 ( N_VDD_c_129_p N_noxref_3_c_253_n ) capacitor c=8.72934e-19 //x=2.955 \
 //y=7.585 //x2=2.995 //y2=5.38
cc_130 ( N_VDD_M8_noxref_d N_noxref_3_c_253_n ) capacitor c=0.0167847f \
 //x=2.895 //y=5.2 //x2=2.995 //y2=5.38
cc_131 ( N_VDD_c_123_n N_noxref_3_c_231_n ) capacitor c=0.00159771f //x=1.23 \
 //y=7.58 //x2=3.08 //y2=2.77
cc_132 ( N_VDD_c_124_n N_noxref_3_c_231_n ) capacitor c=0.0462672f //x=3.82 \
 //y=7.585 //x2=3.08 //y2=2.77
cc_133 ( N_VDD_c_124_n N_noxref_3_c_233_n ) capacitor c=0.0103855f //x=3.82 \
 //y=7.585 //x2=4.93 //y2=2.26
cc_134 ( N_VDD_c_124_n N_noxref_3_c_258_n ) capacitor c=0.00860173f //x=3.82 \
 //y=7.585 //x2=4.775 //y2=4.885
cc_135 ( N_VDD_M9_noxref_d N_noxref_3_c_258_n ) capacitor c=2.85066e-19 \
 //x=4.905 //y=5.205 //x2=4.775 //y2=4.885
cc_136 ( N_VDD_c_140_p N_noxref_3_M9_noxref_g ) capacitor c=0.00683851f \
 //x=4.965 //y=7.585 //x2=4.83 //y2=6.205
cc_137 ( N_VDD_c_124_n N_noxref_3_M9_noxref_g ) capacitor c=0.0105272f \
 //x=3.82 //y=7.585 //x2=4.83 //y2=6.205
cc_138 ( N_VDD_M9_noxref_d N_noxref_3_M9_noxref_g ) capacitor c=0.0156786f \
 //x=4.905 //y=5.205 //x2=4.83 //y2=6.205
cc_139 ( N_VDD_c_143_p N_noxref_3_M10_noxref_g ) capacitor c=0.0068279f \
 //x=6.98 //y=7.585 //x2=5.27 //y2=6.205
cc_140 ( N_VDD_M9_noxref_d N_noxref_3_M10_noxref_g ) capacitor c=0.0183011f \
 //x=4.905 //y=5.205 //x2=5.27 //y2=6.205
cc_141 ( N_VDD_c_124_n N_noxref_3_c_265_n ) capacitor c=0.00890932f //x=3.82 \
 //y=7.585 //x2=4.775 //y2=4.885
cc_142 ( N_VDD_c_146_p N_noxref_3_M5_noxref_d ) capacitor c=0.00720906f \
 //x=8.63 //y=7.58 //x2=1.575 //y2=5.2
cc_143 ( N_VDD_c_128_p N_noxref_3_M5_noxref_d ) capacitor c=0.0138506f \
 //x=2.075 //y=7.585 //x2=1.575 //y2=5.2
cc_144 ( N_VDD_c_124_n N_noxref_3_M5_noxref_d ) capacitor c=6.94454e-19 \
 //x=3.82 //y=7.585 //x2=1.575 //y2=5.2
cc_145 ( N_VDD_c_126_n N_noxref_3_M5_noxref_d ) capacitor c=0.00135231f \
 //x=8.63 //y=7.58 //x2=1.575 //y2=5.2
cc_146 ( N_VDD_M6_noxref_d N_noxref_3_M5_noxref_d ) capacitor c=0.0664752f \
 //x=2.015 //y=5.2 //x2=1.575 //y2=5.2
cc_147 ( N_VDD_c_146_p N_noxref_3_M7_noxref_d ) capacitor c=0.00720906f \
 //x=8.63 //y=7.58 //x2=2.455 //y2=5.2
cc_148 ( N_VDD_c_129_p N_noxref_3_M7_noxref_d ) capacitor c=0.0138783f \
 //x=2.955 //y=7.585 //x2=2.455 //y2=5.2
cc_149 ( N_VDD_c_124_n N_noxref_3_M7_noxref_d ) capacitor c=0.0120541f \
 //x=3.82 //y=7.585 //x2=2.455 //y2=5.2
cc_150 ( N_VDD_c_126_n N_noxref_3_M7_noxref_d ) capacitor c=0.00135231f \
 //x=8.63 //y=7.58 //x2=2.455 //y2=5.2
cc_151 ( N_VDD_M5_noxref_s N_noxref_3_M7_noxref_d ) capacitor c=0.00111971f \
 //x=1.145 //y=5.2 //x2=2.455 //y2=5.2
cc_152 ( N_VDD_M6_noxref_d N_noxref_3_M7_noxref_d ) capacitor c=0.0664752f \
 //x=2.015 //y=5.2 //x2=2.455 //y2=5.2
cc_153 ( N_VDD_M8_noxref_d N_noxref_3_M7_noxref_d ) capacitor c=0.0664752f \
 //x=2.895 //y=5.2 //x2=2.455 //y2=5.2
cc_154 ( N_VDD_c_125_n N_noxref_4_c_369_n ) capacitor c=0.00382819f //x=7.15 \
 //y=7.585 //x2=7.775 //y2=2.77
cc_155 ( N_VDD_c_143_p N_noxref_4_c_412_n ) capacitor c=9.662e-19 //x=6.98 \
 //y=7.585 //x2=6.325 //y2=5.39
cc_156 ( N_VDD_c_124_n N_noxref_4_c_413_n ) capacitor c=8.9933e-19 //x=3.82 \
 //y=7.585 //x2=6.015 //y2=5.39
cc_157 ( N_VDD_c_124_n N_noxref_4_c_384_n ) capacitor c=0.00155409f //x=3.82 \
 //y=7.585 //x2=6.41 //y2=2.77
cc_158 ( N_VDD_c_125_n N_noxref_4_c_384_n ) capacitor c=0.0462234f //x=7.15 \
 //y=7.585 //x2=6.41 //y2=2.77
cc_159 ( N_VDD_c_125_n N_noxref_4_c_386_n ) capacitor c=0.0272885f //x=7.15 \
 //y=7.585 //x2=7.89 //y2=2.265
cc_160 ( N_VDD_c_126_n N_noxref_4_c_386_n ) capacitor c=0.00144809f //x=8.63 \
 //y=7.58 //x2=7.89 //y2=2.265
cc_161 ( N_VDD_M13_noxref_s N_noxref_4_c_386_n ) capacitor c=0.00938354f \
 //x=7.69 //y=5.2 //x2=7.89 //y2=2.265
cc_162 ( N_VDD_c_166_p N_noxref_4_M13_noxref_g ) capacitor c=0.00753931f \
 //x=8.62 //y=7.585 //x2=8.045 //y2=6.2
cc_163 ( N_VDD_c_125_n N_noxref_4_M13_noxref_g ) capacitor c=0.0102569f \
 //x=7.15 //y=7.585 //x2=8.045 //y2=6.2
cc_164 ( N_VDD_M13_noxref_s N_noxref_4_M13_noxref_g ) capacitor c=0.0528676f \
 //x=7.69 //y=5.2 //x2=8.045 //y2=6.2
cc_165 ( N_VDD_c_166_p N_noxref_4_M14_noxref_g ) capacitor c=0.00702238f \
 //x=8.62 //y=7.585 //x2=8.485 //y2=6.2
cc_166 ( N_VDD_M14_noxref_d N_noxref_4_M14_noxref_g ) capacitor c=0.0528676f \
 //x=8.56 //y=5.2 //x2=8.485 //y2=6.2
cc_167 ( N_VDD_c_126_n N_noxref_4_c_424_n ) capacitor c=0.0287802f //x=8.63 \
 //y=7.58 //x2=8.41 //y2=4.97
cc_168 ( N_VDD_c_125_n N_noxref_4_c_425_n ) capacitor c=0.011132f //x=7.15 \
 //y=7.585 //x2=8.12 //y2=4.97
cc_169 ( N_VDD_M13_noxref_s N_noxref_4_c_425_n ) capacitor c=0.00665885f \
 //x=7.69 //y=5.2 //x2=8.12 //y2=4.97
cc_170 ( N_VDD_c_125_n N_noxref_4_M11_noxref_d ) capacitor c=0.00966019f \
 //x=7.15 //y=7.585 //x2=5.785 //y2=5.205
cc_171 ( N_VDD_M9_noxref_d N_noxref_4_M11_noxref_d ) capacitor c=0.00561178f \
 //x=4.905 //y=5.205 //x2=5.785 //y2=5.205
cc_172 ( N_VDD_M13_noxref_s N_noxref_4_M11_noxref_d ) capacitor c=4.94992e-19 \
 //x=7.69 //y=5.2 //x2=5.785 //y2=5.205
cc_173 ( N_VDD_c_128_p N_A_c_502_n ) capacitor c=3.98531e-19 //x=2.075 \
 //y=7.585 //x2=1.6 //y2=2.26
cc_174 ( N_VDD_c_123_n N_A_c_502_n ) capacitor c=0.016845f //x=1.23 //y=7.58 \
 //x2=1.6 //y2=2.26
cc_175 ( N_VDD_c_128_p N_A_M5_noxref_g ) capacitor c=0.00732332f //x=2.075 \
 //y=7.585 //x2=1.5 //y2=6.2
cc_176 ( N_VDD_M5_noxref_s N_A_M5_noxref_g ) capacitor c=0.054195f //x=1.145 \
 //y=5.2 //x2=1.5 //y2=6.2
cc_177 ( N_VDD_c_128_p N_A_M6_noxref_g ) capacitor c=0.00677553f //x=2.075 \
 //y=7.585 //x2=1.94 //y2=6.2
cc_178 ( N_VDD_M6_noxref_d N_A_M6_noxref_g ) capacitor c=0.015318f //x=2.015 \
 //y=5.2 //x2=1.94 //y2=6.2
cc_179 ( N_VDD_c_123_n N_A_c_519_n ) capacitor c=0.0292267f //x=1.23 //y=7.58 \
 //x2=1.6 //y2=4.88
cc_180 ( N_VDD_c_123_n N_B_c_557_n ) capacitor c=6.61004e-19 //x=1.23 //y=7.58 \
 //x2=2.34 //y2=2.26
cc_181 ( N_VDD_c_124_n N_B_c_557_n ) capacitor c=6.09526e-19 //x=3.82 \
 //y=7.585 //x2=2.34 //y2=2.26
cc_182 ( N_VDD_c_129_p N_B_M7_noxref_g ) capacitor c=0.00678607f //x=2.955 \
 //y=7.585 //x2=2.38 //y2=6.2
cc_183 ( N_VDD_M6_noxref_d N_B_M7_noxref_g ) capacitor c=0.015318f //x=2.015 \
 //y=5.2 //x2=2.38 //y2=6.2
cc_184 ( N_VDD_c_129_p N_B_M8_noxref_g ) capacitor c=0.00677553f //x=2.955 \
 //y=7.585 //x2=2.82 //y2=6.2
cc_185 ( N_VDD_c_124_n N_B_M8_noxref_g ) capacitor c=0.00954586f //x=3.82 \
 //y=7.585 //x2=2.82 //y2=6.2
cc_186 ( N_VDD_M8_noxref_d N_B_M8_noxref_g ) capacitor c=0.0430452f //x=2.895 \
 //y=5.2 //x2=2.82 //y2=6.2
cc_187 ( N_VDD_c_124_n N_C_c_672_n ) capacitor c=7.02327e-19 //x=3.82 \
 //y=7.585 //x2=5.67 //y2=2.26
cc_188 ( N_VDD_c_125_n N_C_c_672_n ) capacitor c=6.16704e-19 //x=7.15 \
 //y=7.585 //x2=5.67 //y2=2.26
cc_189 ( N_VDD_c_143_p N_C_M11_noxref_g ) capacitor c=0.00516984f //x=6.98 \
 //y=7.585 //x2=5.71 //y2=6.205
cc_190 ( N_VDD_c_143_p N_C_M12_noxref_g ) capacitor c=0.00515938f //x=6.98 \
 //y=7.585 //x2=6.15 //y2=6.205
cc_191 ( N_VDD_c_125_n N_C_M12_noxref_g ) capacitor c=0.0120232f //x=7.15 \
 //y=7.585 //x2=6.15 //y2=6.205
cc_192 ( N_VDD_c_140_p N_noxref_9_c_743_n ) capacitor c=5.82208e-19 //x=4.965 \
 //y=7.585 //x2=5.405 //y2=5.39
cc_193 ( N_VDD_c_143_p N_noxref_9_c_743_n ) capacitor c=5.82208e-19 //x=6.98 \
 //y=7.585 //x2=5.405 //y2=5.39
cc_194 ( N_VDD_c_125_n N_noxref_9_c_743_n ) capacitor c=0.00289291f //x=7.15 \
 //y=7.585 //x2=5.405 //y2=5.39
cc_195 ( N_VDD_M9_noxref_d N_noxref_9_c_743_n ) capacitor c=0.013244f \
 //x=4.905 //y=5.205 //x2=5.405 //y2=5.39
cc_196 ( N_VDD_c_124_n N_noxref_9_c_747_n ) capacitor c=0.0669114f //x=3.82 \
 //y=7.585 //x2=4.695 //y2=5.39
cc_197 ( N_VDD_c_126_n N_noxref_9_c_748_n ) capacitor c=0.00359933f //x=8.63 \
 //y=7.58 //x2=6.285 //y2=7.09
cc_198 ( N_VDD_c_146_p N_noxref_9_c_749_n ) capacitor c=0.0370795f //x=8.63 \
 //y=7.58 //x2=5.575 //y2=7.09
cc_199 ( N_VDD_c_143_p N_noxref_9_c_749_n ) capacitor c=0.0587731f //x=6.98 \
 //y=7.585 //x2=5.575 //y2=7.09
cc_200 ( N_VDD_c_126_n N_noxref_9_c_749_n ) capacitor c=0.00118659f //x=8.63 \
 //y=7.58 //x2=5.575 //y2=7.09
cc_201 ( N_VDD_c_146_p N_noxref_9_M9_noxref_s ) capacitor c=0.00727771f \
 //x=8.63 //y=7.58 //x2=4.475 //y2=5.205
cc_202 ( N_VDD_c_140_p N_noxref_9_M9_noxref_s ) capacitor c=0.0141529f \
 //x=4.965 //y=7.585 //x2=4.475 //y2=5.205
cc_203 ( N_VDD_c_126_n N_noxref_9_M9_noxref_s ) capacitor c=0.00138926f \
 //x=8.63 //y=7.58 //x2=4.475 //y2=5.205
cc_204 ( N_VDD_M8_noxref_d N_noxref_9_M9_noxref_s ) capacitor c=0.00196306f \
 //x=2.895 //y=5.2 //x2=4.475 //y2=5.205
cc_205 ( N_VDD_M9_noxref_d N_noxref_9_M9_noxref_s ) capacitor c=0.0667021f \
 //x=4.905 //y=5.205 //x2=4.475 //y2=5.205
cc_206 ( N_VDD_c_124_n N_noxref_9_M10_noxref_d ) capacitor c=8.88629e-19 \
 //x=3.82 //y=7.585 //x2=5.345 //y2=5.205
cc_207 ( N_VDD_M9_noxref_d N_noxref_9_M10_noxref_d ) capacitor c=0.0659925f \
 //x=4.905 //y=5.205 //x2=5.345 //y2=5.205
cc_208 ( N_VDD_c_125_n N_noxref_9_M12_noxref_d ) capacitor c=0.0520312f \
 //x=7.15 //y=7.585 //x2=6.225 //y2=5.205
cc_209 ( N_VDD_M9_noxref_d N_noxref_9_M12_noxref_d ) capacitor c=0.00107819f \
 //x=4.905 //y=5.205 //x2=6.225 //y2=5.205
cc_210 ( N_VDD_M13_noxref_s N_noxref_9_M12_noxref_d ) capacitor c=0.00226909f \
 //x=7.69 //y=5.2 //x2=6.225 //y2=5.205
cc_211 ( N_VDD_c_125_n Y ) capacitor c=4.80934e-19 //x=7.15 //y=7.585 \
 //x2=8.63 //y2=2.4
cc_212 ( N_VDD_c_126_n Y ) capacitor c=0.0232778f //x=8.63 //y=7.58 //x2=8.63 \
 //y2=2.4
cc_213 ( N_VDD_c_166_p N_Y_c_797_n ) capacitor c=8.94397e-19 //x=8.62 \
 //y=7.585 //x2=8.545 //y2=4.76
cc_214 ( N_VDD_M14_noxref_d N_Y_c_797_n ) capacitor c=0.00645128f //x=8.56 \
 //y=5.2 //x2=8.545 //y2=4.76
cc_215 ( N_VDD_c_125_n N_Y_c_799_n ) capacitor c=0.017572f //x=7.15 //y=7.585 \
 //x2=8.35 //y2=4.76
cc_216 ( N_VDD_c_146_p N_Y_M13_noxref_d ) capacitor c=0.00724309f //x=8.63 \
 //y=7.58 //x2=8.12 //y2=5.2
cc_217 ( N_VDD_c_166_p N_Y_M13_noxref_d ) capacitor c=0.0139426f //x=8.62 \
 //y=7.585 //x2=8.12 //y2=5.2
cc_218 ( N_VDD_c_126_n N_Y_M13_noxref_d ) capacitor c=0.0219131f //x=8.63 \
 //y=7.58 //x2=8.12 //y2=5.2
cc_219 ( N_VDD_M13_noxref_s N_Y_M13_noxref_d ) capacitor c=0.0843065f //x=7.69 \
 //y=5.2 //x2=8.12 //y2=5.2
cc_220 ( N_VDD_M14_noxref_d N_Y_M13_noxref_d ) capacitor c=0.0832641f //x=8.56 \
 //y=5.2 //x2=8.12 //y2=5.2
cc_221 ( N_noxref_3_c_225_n N_noxref_4_c_373_n ) capacitor c=0.0114841f \
 //x=4.815 //y=2.77 //x2=6.525 //y2=2.77
cc_222 ( N_noxref_3_c_243_n N_noxref_4_c_375_n ) capacitor c=0.00431513f \
 //x=5.265 //y=1.43 //x2=5.885 //y2=1.835
cc_223 ( N_noxref_3_c_225_n N_noxref_4_c_432_n ) capacitor c=0.0018301f \
 //x=4.815 //y=2.77 //x2=5.085 //y2=1.835
cc_224 ( N_noxref_3_c_233_n N_noxref_4_c_432_n ) capacitor c=0.0107041f \
 //x=4.93 //y=2.26 //x2=5.085 //y2=1.835
cc_225 ( N_noxref_3_c_238_n N_noxref_4_c_432_n ) capacitor c=0.00524371f \
 //x=4.735 //y=2.095 //x2=5.085 //y2=1.835
cc_226 ( N_noxref_3_c_231_n N_noxref_4_c_384_n ) capacitor c=3.55699e-19 \
 //x=3.08 //y=2.77 //x2=6.41 //y2=2.77
cc_227 ( N_noxref_3_c_233_n N_noxref_4_c_384_n ) capacitor c=0.00354085f \
 //x=4.93 //y=2.26 //x2=6.41 //y2=2.77
cc_228 ( N_noxref_3_c_236_n N_noxref_4_M2_noxref_d ) capacitor c=0.0013184f \
 //x=4.735 //y=1.085 //x2=4.81 //y2=1.085
cc_229 ( N_noxref_3_c_286_p N_noxref_4_M2_noxref_d ) capacitor c=0.0034598f \
 //x=4.735 //y=1.43 //x2=4.81 //y2=1.085
cc_230 ( N_noxref_3_c_287_p N_noxref_4_M2_noxref_d ) capacitor c=0.00300148f \
 //x=4.735 //y=1.74 //x2=4.81 //y2=1.085
cc_231 ( N_noxref_3_c_238_n N_noxref_4_M2_noxref_d ) capacitor c=0.00273686f \
 //x=4.735 //y=2.095 //x2=4.81 //y2=1.085
cc_232 ( N_noxref_3_c_240_n N_noxref_4_M2_noxref_d ) capacitor c=0.00241102f \
 //x=5.11 //y=0.93 //x2=4.81 //y2=1.085
cc_233 ( N_noxref_3_c_290_p N_noxref_4_M2_noxref_d ) capacitor c=0.0123304f \
 //x=5.11 //y=1.585 //x2=4.81 //y2=1.085
cc_234 ( N_noxref_3_c_241_n N_noxref_4_M2_noxref_d ) capacitor c=0.00219619f \
 //x=5.265 //y=1.085 //x2=4.81 //y2=1.085
cc_235 ( N_noxref_3_c_243_n N_noxref_4_M2_noxref_d ) capacitor c=0.00603828f \
 //x=5.265 //y=1.43 //x2=4.81 //y2=1.085
cc_236 ( N_noxref_3_c_251_n N_A_c_502_n ) capacitor c=0.0055959f //x=1.805 \
 //y=5.38 //x2=1.6 //y2=2.26
cc_237 ( N_noxref_3_c_231_n N_A_c_502_n ) capacitor c=0.00407922f //x=3.08 \
 //y=2.77 //x2=1.6 //y2=2.26
cc_238 ( N_noxref_3_c_251_n N_A_M5_noxref_g ) capacitor c=0.0177326f //x=1.805 \
 //y=5.38 //x2=1.5 //y2=6.2
cc_239 ( N_noxref_3_c_248_n N_A_M6_noxref_g ) capacitor c=0.0204115f //x=2.515 \
 //y=5.38 //x2=1.94 //y2=6.2
cc_240 ( N_noxref_3_M5_noxref_d N_A_M6_noxref_g ) capacitor c=0.0173476f \
 //x=1.575 //y=5.2 //x2=1.94 //y2=6.2
cc_241 ( N_noxref_3_c_251_n N_A_c_519_n ) capacitor c=0.00605692f //x=1.805 \
 //y=5.38 //x2=1.6 //y2=4.88
cc_242 ( N_noxref_3_c_248_n N_B_c_566_n ) capacitor c=0.0127867f //x=2.515 \
 //y=5.38 //x2=2.34 //y2=4.715
cc_243 ( N_noxref_3_c_231_n N_B_c_566_n ) capacitor c=0.0101284f //x=3.08 \
 //y=2.77 //x2=2.34 //y2=4.715
cc_244 ( N_noxref_3_c_228_n N_B_c_557_n ) capacitor c=0.00732168f //x=3.195 \
 //y=2.77 //x2=2.34 //y2=2.26
cc_245 ( N_noxref_3_c_231_n N_B_c_557_n ) capacitor c=0.0813981f //x=3.08 \
 //y=2.77 //x2=2.34 //y2=2.26
cc_246 ( N_noxref_3_c_233_n N_B_c_557_n ) capacitor c=9.8819e-19 //x=4.93 \
 //y=2.26 //x2=2.34 //y2=2.26
cc_247 ( N_noxref_3_c_248_n N_B_M7_noxref_g ) capacitor c=0.0166699f //x=2.515 \
 //y=5.38 //x2=2.38 //y2=6.2
cc_248 ( N_noxref_3_M7_noxref_d N_B_M7_noxref_g ) capacitor c=0.0173477f \
 //x=2.455 //y=5.2 //x2=2.38 //y2=6.2
cc_249 ( N_noxref_3_c_253_n N_B_M8_noxref_g ) capacitor c=0.0223814f //x=2.995 \
 //y=5.38 //x2=2.82 //y2=6.2
cc_250 ( N_noxref_3_M7_noxref_d N_B_M8_noxref_g ) capacitor c=0.0179769f \
 //x=2.455 //y=5.2 //x2=2.82 //y2=6.2
cc_251 ( N_noxref_3_M1_noxref_d N_B_c_575_n ) capacitor c=0.00217566f //x=2.45 \
 //y=1.085 //x2=2.375 //y2=1.085
cc_252 ( N_noxref_3_M1_noxref_d N_B_c_576_n ) capacitor c=0.0034598f //x=2.45 \
 //y=1.085 //x2=2.375 //y2=1.43
cc_253 ( N_noxref_3_M1_noxref_d N_B_c_577_n ) capacitor c=0.0065582f //x=2.45 \
 //y=1.085 //x2=2.375 //y2=1.74
cc_254 ( N_noxref_3_c_231_n N_B_c_578_n ) capacitor c=0.0142673f //x=3.08 \
 //y=2.77 //x2=2.745 //y2=4.97
cc_255 ( N_noxref_3_c_312_p N_B_c_578_n ) capacitor c=0.00421574f //x=2.6 \
 //y=5.38 //x2=2.745 //y2=4.97
cc_256 ( N_noxref_3_M1_noxref_d N_B_c_580_n ) capacitor c=0.00241102f //x=2.45 \
 //y=1.085 //x2=2.75 //y2=0.93
cc_257 ( N_noxref_3_c_229_n N_B_c_581_n ) capacitor c=0.00359704f //x=2.995 \
 //y=1.835 //x2=2.75 //y2=1.585
cc_258 ( N_noxref_3_M1_noxref_d N_B_c_581_n ) capacitor c=0.0138845f //x=2.45 \
 //y=1.085 //x2=2.75 //y2=1.585
cc_259 ( N_noxref_3_M1_noxref_d N_B_c_583_n ) capacitor c=0.00132245f //x=2.45 \
 //y=1.085 //x2=2.905 //y2=1.085
cc_260 ( N_noxref_3_c_229_n N_B_c_584_n ) capacitor c=0.00457401f //x=2.995 \
 //y=1.835 //x2=2.905 //y2=1.43
cc_261 ( N_noxref_3_M1_noxref_d N_B_c_584_n ) capacitor c=0.00566463f //x=2.45 \
 //y=1.085 //x2=2.905 //y2=1.43
cc_262 ( N_noxref_3_c_231_n N_B_c_586_n ) capacitor c=0.00877984f //x=3.08 \
 //y=2.77 //x2=2.34 //y2=2.26
cc_263 ( N_noxref_3_c_231_n N_B_c_587_n ) capacitor c=0.00306024f //x=3.08 \
 //y=2.77 //x2=2.34 //y2=2.095
cc_264 ( N_noxref_3_M1_noxref_d N_B_c_587_n ) capacitor c=0.00660593f //x=2.45 \
 //y=1.085 //x2=2.34 //y2=2.095
cc_265 ( N_noxref_3_c_248_n N_B_c_589_n ) capacitor c=0.00399417f //x=2.515 \
 //y=5.38 //x2=2.37 //y2=4.88
cc_266 ( N_noxref_3_c_231_n N_B_c_589_n ) capacitor c=0.00533692f //x=3.08 \
 //y=2.77 //x2=2.37 //y2=4.88
cc_267 ( N_noxref_3_c_324_p N_noxref_7_c_645_n ) capacitor c=3.15806e-19 \
 //x=2.725 //y=1.835 //x2=1.185 //y2=1.675
cc_268 ( N_noxref_3_c_324_p N_noxref_7_c_629_n ) capacitor c=0.0201674f \
 //x=2.725 //y=1.835 //x2=2.155 //y2=1.675
cc_269 ( N_noxref_3_c_229_n N_noxref_7_c_630_n ) capacitor c=0.00468333f \
 //x=2.995 //y=1.835 //x2=3.04 //y2=0.71
cc_270 ( N_noxref_3_M1_noxref_d N_noxref_7_c_630_n ) capacitor c=0.0118355f \
 //x=2.45 //y=1.085 //x2=3.04 //y2=0.71
cc_271 ( N_noxref_3_c_225_n N_noxref_7_M0_noxref_s ) capacitor c=3.03583e-19 \
 //x=4.815 //y=2.77 //x2=1.05 //y2=0.545
cc_272 ( N_noxref_3_c_228_n N_noxref_7_M0_noxref_s ) capacitor c=6.92363e-19 \
 //x=3.195 //y=2.77 //x2=1.05 //y2=0.545
cc_273 ( N_noxref_3_c_229_n N_noxref_7_M0_noxref_s ) capacitor c=0.0129465f \
 //x=2.995 //y=1.835 //x2=1.05 //y2=0.545
cc_274 ( N_noxref_3_M1_noxref_d N_noxref_7_M0_noxref_s ) capacitor \
 c=0.0437911f //x=2.45 //y=1.085 //x2=1.05 //y2=0.545
cc_275 ( N_noxref_3_c_258_n N_C_c_685_n ) capacitor c=0.0470738f //x=4.775 \
 //y=4.885 //x2=5.67 //y2=4.72
cc_276 ( N_noxref_3_c_333_p N_C_c_685_n ) capacitor c=0.00146509f //x=5.195 \
 //y=4.975 //x2=5.67 //y2=4.72
cc_277 ( N_noxref_3_c_265_n N_C_c_685_n ) capacitor c=0.00112871f //x=4.775 \
 //y=4.885 //x2=5.67 //y2=4.72
cc_278 ( N_noxref_3_c_225_n N_C_c_672_n ) capacitor c=0.00316948f //x=4.815 \
 //y=2.77 //x2=5.67 //y2=2.26
cc_279 ( N_noxref_3_c_231_n N_C_c_672_n ) capacitor c=9.8819e-19 //x=3.08 \
 //y=2.77 //x2=5.67 //y2=2.26
cc_280 ( N_noxref_3_c_233_n N_C_c_672_n ) capacitor c=0.0447305f //x=4.93 \
 //y=2.26 //x2=5.67 //y2=2.26
cc_281 ( N_noxref_3_c_238_n N_C_c_672_n ) capacitor c=0.00308814f //x=4.735 \
 //y=2.095 //x2=5.67 //y2=2.26
cc_282 ( N_noxref_3_M9_noxref_g N_C_M11_noxref_g ) capacitor c=0.0100243f \
 //x=4.83 //y=6.205 //x2=5.71 //y2=6.205
cc_283 ( N_noxref_3_M10_noxref_g N_C_M11_noxref_g ) capacitor c=0.107798f \
 //x=5.27 //y=6.205 //x2=5.71 //y2=6.205
cc_284 ( N_noxref_3_M10_noxref_g N_C_M12_noxref_g ) capacitor c=0.0094155f \
 //x=5.27 //y=6.205 //x2=6.15 //y2=6.205
cc_285 ( N_noxref_3_c_236_n N_C_c_674_n ) capacitor c=0.00125788f //x=4.735 \
 //y=1.085 //x2=5.705 //y2=1.085
cc_286 ( N_noxref_3_c_241_n N_C_c_674_n ) capacitor c=0.0126654f //x=5.265 \
 //y=1.085 //x2=5.705 //y2=1.085
cc_287 ( N_noxref_3_c_286_p N_C_c_697_n ) capacitor c=0.00148539f //x=4.735 \
 //y=1.43 //x2=5.705 //y2=1.435
cc_288 ( N_noxref_3_c_287_p N_C_c_697_n ) capacitor c=0.00105591f //x=4.735 \
 //y=1.74 //x2=5.705 //y2=1.435
cc_289 ( N_noxref_3_c_243_n N_C_c_697_n ) capacitor c=0.0126654f //x=5.265 \
 //y=1.43 //x2=5.705 //y2=1.435
cc_290 ( N_noxref_3_c_287_p N_C_c_700_n ) capacitor c=0.00109549f //x=4.735 \
 //y=1.74 //x2=5.705 //y2=1.74
cc_291 ( N_noxref_3_c_243_n N_C_c_700_n ) capacitor c=0.00886999f //x=5.265 \
 //y=1.43 //x2=5.705 //y2=1.74
cc_292 ( N_noxref_3_c_243_n N_C_c_677_n ) capacitor c=0.00123863f //x=5.265 \
 //y=1.43 //x2=6.08 //y2=1.585
cc_293 ( N_noxref_3_c_241_n N_C_c_678_n ) capacitor c=0.00132934f //x=5.265 \
 //y=1.085 //x2=6.235 //y2=1.085
cc_294 ( N_noxref_3_c_243_n N_C_c_704_n ) capacitor c=0.00150734f //x=5.265 \
 //y=1.43 //x2=6.235 //y2=1.435
cc_295 ( N_noxref_3_c_233_n N_C_c_705_n ) capacitor c=0.00307062f //x=4.93 \
 //y=2.26 //x2=5.67 //y2=2.26
cc_296 ( N_noxref_3_c_238_n N_C_c_705_n ) capacitor c=0.0179092f //x=4.735 \
 //y=2.095 //x2=5.67 //y2=2.26
cc_297 ( N_noxref_3_c_238_n N_C_c_707_n ) capacitor c=0.00577193f //x=4.735 \
 //y=2.095 //x2=5.67 //y2=2.095
cc_298 ( N_noxref_3_c_258_n N_C_c_708_n ) capacitor c=0.00336963f //x=4.775 \
 //y=4.885 //x2=5.705 //y2=4.885
cc_299 ( N_noxref_3_c_333_p N_C_c_708_n ) capacitor c=0.020271f //x=5.195 \
 //y=4.975 //x2=5.705 //y2=4.885
cc_300 ( N_noxref_3_c_265_n N_C_c_708_n ) capacitor c=0.00546725f //x=4.775 \
 //y=4.885 //x2=5.705 //y2=4.885
cc_301 ( N_noxref_3_c_258_n N_noxref_9_c_743_n ) capacitor c=0.00630079f \
 //x=4.775 //y=4.885 //x2=5.405 //y2=5.39
cc_302 ( N_noxref_3_M9_noxref_g N_noxref_9_c_743_n ) capacitor c=0.0182669f \
 //x=4.83 //y=6.205 //x2=5.405 //y2=5.39
cc_303 ( N_noxref_3_M10_noxref_g N_noxref_9_c_743_n ) capacitor c=0.0204082f \
 //x=5.27 //y=6.205 //x2=5.405 //y2=5.39
cc_304 ( N_noxref_3_c_333_p N_noxref_9_c_743_n ) capacitor c=0.00365818f \
 //x=5.195 //y=4.975 //x2=5.405 //y2=5.39
cc_305 ( N_noxref_3_c_265_n N_noxref_9_c_743_n ) capacitor c=0.0017421f \
 //x=4.775 //y=4.885 //x2=5.405 //y2=5.39
cc_306 ( N_noxref_3_c_253_n N_noxref_9_c_747_n ) capacitor c=2.87761e-19 \
 //x=2.995 //y=5.38 //x2=4.695 //y2=5.39
cc_307 ( N_noxref_3_c_258_n N_noxref_9_c_747_n ) capacitor c=0.0118415f \
 //x=4.775 //y=4.885 //x2=4.695 //y2=5.39
cc_308 ( N_noxref_3_c_265_n N_noxref_9_c_747_n ) capacitor c=0.00613395f \
 //x=4.775 //y=4.885 //x2=4.695 //y2=5.39
cc_309 ( N_noxref_3_M7_noxref_d N_noxref_9_c_747_n ) capacitor c=4.5543e-19 \
 //x=2.455 //y=5.2 //x2=4.695 //y2=5.39
cc_310 ( N_noxref_3_M9_noxref_g N_noxref_9_M9_noxref_s ) capacitor \
 c=0.0473218f //x=4.83 //y=6.205 //x2=4.475 //y2=5.205
cc_311 ( N_noxref_3_M10_noxref_g N_noxref_9_M10_noxref_d ) capacitor \
 c=0.0170604f //x=5.27 //y=6.205 //x2=5.345 //y2=5.205
cc_312 ( N_noxref_4_c_384_n N_C_c_685_n ) capacitor c=0.0102183f //x=6.41 \
 //y=2.77 //x2=5.67 //y2=4.72
cc_313 ( N_noxref_4_c_373_n N_C_c_672_n ) capacitor c=0.00316373f //x=6.525 \
 //y=2.77 //x2=5.67 //y2=2.26
cc_314 ( N_noxref_4_c_375_n N_C_c_672_n ) capacitor c=0.0162392f //x=5.885 \
 //y=1.835 //x2=5.67 //y2=2.26
cc_315 ( N_noxref_4_c_384_n N_C_c_672_n ) capacitor c=0.0822198f //x=6.41 \
 //y=2.77 //x2=5.67 //y2=2.26
cc_316 ( N_noxref_4_c_386_n N_C_c_672_n ) capacitor c=0.00108914f //x=7.89 \
 //y=2.265 //x2=5.67 //y2=2.26
cc_317 ( N_noxref_4_c_413_n N_C_M11_noxref_g ) capacitor c=0.0132788f \
 //x=6.015 //y=5.39 //x2=5.71 //y2=6.205
cc_318 ( N_noxref_4_c_412_n N_C_M12_noxref_g ) capacitor c=0.0217751f \
 //x=6.325 //y=5.39 //x2=6.15 //y2=6.205
cc_319 ( N_noxref_4_M11_noxref_d N_C_M12_noxref_g ) capacitor c=0.0136385f \
 //x=5.785 //y=5.205 //x2=6.15 //y2=6.205
cc_320 ( N_noxref_4_M3_noxref_d N_C_c_674_n ) capacitor c=0.00226395f //x=5.78 \
 //y=1.085 //x2=5.705 //y2=1.085
cc_321 ( N_noxref_4_M3_noxref_d N_C_c_697_n ) capacitor c=0.0035101f //x=5.78 \
 //y=1.085 //x2=5.705 //y2=1.435
cc_322 ( N_noxref_4_c_375_n N_C_c_700_n ) capacitor c=0.00218915f //x=5.885 \
 //y=1.835 //x2=5.705 //y2=1.74
cc_323 ( N_noxref_4_M2_noxref_d N_C_c_700_n ) capacitor c=0.00148728f //x=4.81 \
 //y=1.085 //x2=5.705 //y2=1.74
cc_324 ( N_noxref_4_M3_noxref_d N_C_c_700_n ) capacitor c=0.00546704f //x=5.78 \
 //y=1.085 //x2=5.705 //y2=1.74
cc_325 ( N_noxref_4_c_413_n N_C_c_724_n ) capacitor c=0.00417892f //x=6.015 \
 //y=5.39 //x2=6.075 //y2=4.975
cc_326 ( N_noxref_4_c_384_n N_C_c_724_n ) capacitor c=0.0144455f //x=6.41 \
 //y=2.77 //x2=6.075 //y2=4.975
cc_327 ( N_noxref_4_M3_noxref_d N_C_c_676_n ) capacitor c=0.00241102f //x=5.78 \
 //y=1.085 //x2=6.08 //y2=0.93
cc_328 ( N_noxref_4_c_379_n N_C_c_677_n ) capacitor c=0.00801563f //x=6.325 \
 //y=1.835 //x2=6.08 //y2=1.585
cc_329 ( N_noxref_4_M3_noxref_d N_C_c_677_n ) capacitor c=0.0158021f //x=5.78 \
 //y=1.085 //x2=6.08 //y2=1.585
cc_330 ( N_noxref_4_M3_noxref_d N_C_c_678_n ) capacitor c=0.00132831f //x=5.78 \
 //y=1.085 //x2=6.235 //y2=1.085
cc_331 ( N_noxref_4_M3_noxref_d N_C_c_704_n ) capacitor c=0.0035101f //x=5.78 \
 //y=1.085 //x2=6.235 //y2=1.435
cc_332 ( N_noxref_4_c_375_n N_C_c_705_n ) capacitor c=0.00633758f //x=5.885 \
 //y=1.835 //x2=5.67 //y2=2.26
cc_333 ( N_noxref_4_c_384_n N_C_c_705_n ) capacitor c=0.00877984f //x=6.41 \
 //y=2.77 //x2=5.67 //y2=2.26
cc_334 ( N_noxref_4_c_375_n N_C_c_707_n ) capacitor c=0.0189958f //x=5.885 \
 //y=1.835 //x2=5.67 //y2=2.095
cc_335 ( N_noxref_4_c_384_n N_C_c_707_n ) capacitor c=0.00306024f //x=6.41 \
 //y=2.77 //x2=5.67 //y2=2.095
cc_336 ( N_noxref_4_M3_noxref_d N_C_c_707_n ) capacitor c=3.4952e-19 //x=5.78 \
 //y=1.085 //x2=5.67 //y2=2.095
cc_337 ( N_noxref_4_c_384_n N_C_c_708_n ) capacitor c=0.00537091f //x=6.41 \
 //y=2.77 //x2=5.705 //y2=4.885
cc_338 ( N_noxref_4_c_413_n N_noxref_9_c_743_n ) capacitor c=0.0348754f \
 //x=6.015 //y=5.39 //x2=5.405 //y2=5.39
cc_339 ( N_noxref_4_c_412_n N_noxref_9_c_748_n ) capacitor c=0.00194034f \
 //x=6.325 //y=5.39 //x2=6.285 //y2=7.09
cc_340 ( N_noxref_4_M11_noxref_d N_noxref_9_c_748_n ) capacitor c=0.0118172f \
 //x=5.785 //y=5.205 //x2=6.285 //y2=7.09
cc_341 ( N_noxref_4_M11_noxref_d N_noxref_9_M9_noxref_s ) capacitor \
 c=0.00107541f //x=5.785 //y=5.205 //x2=4.475 //y2=5.205
cc_342 ( N_noxref_4_M11_noxref_d N_noxref_9_M10_noxref_d ) capacitor \
 c=0.0348754f //x=5.785 //y=5.205 //x2=5.345 //y2=5.205
cc_343 ( N_noxref_4_c_412_n N_noxref_9_M12_noxref_d ) capacitor c=0.0164221f \
 //x=6.325 //y=5.39 //x2=6.225 //y2=5.205
cc_344 ( N_noxref_4_M11_noxref_d N_noxref_9_M12_noxref_d ) capacitor \
 c=0.0458293f //x=5.785 //y=5.205 //x2=6.225 //y2=5.205
cc_345 ( N_noxref_4_c_369_n Y ) capacitor c=0.00730959f //x=7.775 //y=2.77 \
 //x2=8.63 //y2=2.4
cc_346 ( N_noxref_4_c_384_n Y ) capacitor c=0.00108914f //x=6.41 //y=2.77 \
 //x2=8.63 //y2=2.4
cc_347 ( N_noxref_4_c_386_n Y ) capacitor c=0.0712221f //x=7.89 //y=2.265 \
 //x2=8.63 //y2=2.4
cc_348 ( N_noxref_4_c_398_n Y ) capacitor c=8.49451e-19 //x=7.89 //y=2.265 \
 //x2=8.63 //y2=2.4
cc_349 ( N_noxref_4_c_482_p N_Y_c_787_n ) capacitor c=0.0023507f //x=8.375 \
 //y=1.59 //x2=8.545 //y2=2.26
cc_350 ( N_noxref_4_c_398_n N_Y_c_810_n ) capacitor c=0.0167852f //x=7.89 \
 //y=2.265 //x2=8.345 //y2=2.26
cc_351 ( N_noxref_4_c_424_n N_Y_c_797_n ) capacitor c=0.0107726f //x=8.41 \
 //y=4.97 //x2=8.545 //y2=4.76
cc_352 ( N_noxref_4_c_386_n N_Y_c_799_n ) capacitor c=0.0250878f //x=7.89 \
 //y=2.265 //x2=8.35 //y2=4.76
cc_353 ( N_noxref_4_c_425_n N_Y_c_799_n ) capacitor c=0.00962086f //x=8.12 \
 //y=4.97 //x2=8.35 //y2=4.76
cc_354 ( N_noxref_4_c_384_n N_Y_M4_noxref_d ) capacitor c=3.35192e-19 //x=6.41 \
 //y=2.77 //x2=8.075 //y2=1.09
cc_355 ( N_noxref_4_c_386_n N_Y_M4_noxref_d ) capacitor c=0.0175773f //x=7.89 \
 //y=2.265 //x2=8.075 //y2=1.09
cc_356 ( N_noxref_4_c_391_n N_Y_M4_noxref_d ) capacitor c=0.00218556f //x=8 \
 //y=1.09 //x2=8.075 //y2=1.09
cc_357 ( N_noxref_4_c_490_p N_Y_M4_noxref_d ) capacitor c=0.00347355f //x=8 \
 //y=1.435 //x2=8.075 //y2=1.09
cc_358 ( N_noxref_4_c_491_p N_Y_M4_noxref_d ) capacitor c=0.00742431f //x=8 \
 //y=1.745 //x2=8.075 //y2=1.09
cc_359 ( N_noxref_4_c_393_n N_Y_M4_noxref_d ) capacitor c=0.00957707f //x=8 \
 //y=2.1 //x2=8.075 //y2=1.09
cc_360 ( N_noxref_4_c_394_n N_Y_M4_noxref_d ) capacitor c=0.00220879f \
 //x=8.375 //y=0.935 //x2=8.075 //y2=1.09
cc_361 ( N_noxref_4_c_482_p N_Y_M4_noxref_d ) capacitor c=0.0138447f //x=8.375 \
 //y=1.59 //x2=8.075 //y2=1.09
cc_362 ( N_noxref_4_c_395_n N_Y_M4_noxref_d ) capacitor c=0.00218624f //x=8.53 \
 //y=1.09 //x2=8.075 //y2=1.09
cc_363 ( N_noxref_4_c_397_n N_Y_M4_noxref_d ) capacitor c=0.00601286f //x=8.53 \
 //y=1.435 //x2=8.075 //y2=1.09
cc_364 ( N_noxref_4_c_384_n N_Y_M13_noxref_d ) capacitor c=6.2839e-19 //x=6.41 \
 //y=2.77 //x2=8.12 //y2=5.2
cc_365 ( N_noxref_4_M13_noxref_g N_Y_M13_noxref_d ) capacitor c=0.0219309f \
 //x=8.045 //y=6.2 //x2=8.12 //y2=5.2
cc_366 ( N_noxref_4_M14_noxref_g N_Y_M13_noxref_d ) capacitor c=0.021902f \
 //x=8.485 //y=6.2 //x2=8.12 //y2=5.2
cc_367 ( N_noxref_4_c_424_n N_Y_M13_noxref_d ) capacitor c=0.0148755f //x=8.41 \
 //y=4.97 //x2=8.12 //y2=5.2
cc_368 ( N_noxref_4_c_425_n N_Y_M13_noxref_d ) capacitor c=0.00307344f \
 //x=8.12 //y=4.97 //x2=8.12 //y2=5.2
cc_369 ( N_A_c_502_n N_B_c_566_n ) capacitor c=0.00400249f //x=1.6 //y=2.26 \
 //x2=2.34 //y2=4.715
cc_370 ( N_A_c_519_n N_B_c_566_n ) capacitor c=0.00417994f //x=1.6 //y=4.88 \
 //x2=2.34 //y2=4.715
cc_371 ( N_A_c_502_n N_B_c_557_n ) capacitor c=0.0887263f //x=1.6 //y=2.26 \
 //x2=2.34 //y2=2.26
cc_372 ( N_A_c_507_n N_B_c_557_n ) capacitor c=0.00308814f //x=1.405 //y=2.095 \
 //x2=2.34 //y2=2.26
cc_373 ( N_A_M5_noxref_g N_B_M7_noxref_g ) capacitor c=0.0104611f //x=1.5 \
 //y=6.2 //x2=2.38 //y2=6.2
cc_374 ( N_A_M6_noxref_g N_B_M7_noxref_g ) capacitor c=0.106811f //x=1.94 \
 //y=6.2 //x2=2.38 //y2=6.2
cc_375 ( N_A_M6_noxref_g N_B_M8_noxref_g ) capacitor c=0.0100341f //x=1.94 \
 //y=6.2 //x2=2.82 //y2=6.2
cc_376 ( N_A_c_503_n N_B_c_575_n ) capacitor c=4.86506e-19 //x=1.405 //y=1.045 \
 //x2=2.375 //y2=1.085
cc_377 ( N_A_c_505_n N_B_c_575_n ) capacitor c=0.00152104f //x=1.405 //y=1.39 \
 //x2=2.375 //y2=1.085
cc_378 ( N_A_c_510_n N_B_c_575_n ) capacitor c=0.0151475f //x=1.935 //y=1.045 \
 //x2=2.375 //y2=1.085
cc_379 ( N_A_c_506_n N_B_c_576_n ) capacitor c=0.00109982f //x=1.405 //y=1.7 \
 //x2=2.375 //y2=1.43
cc_380 ( N_A_c_512_n N_B_c_576_n ) capacitor c=0.0111064f //x=1.935 //y=1.39 \
 //x2=2.375 //y2=1.43
cc_381 ( N_A_c_506_n N_B_c_577_n ) capacitor c=9.57794e-19 //x=1.405 //y=1.7 \
 //x2=2.375 //y2=1.74
cc_382 ( N_A_c_507_n N_B_c_577_n ) capacitor c=0.00662747f //x=1.405 //y=2.095 \
 //x2=2.375 //y2=1.74
cc_383 ( N_A_c_512_n N_B_c_577_n ) capacitor c=0.00862358f //x=1.935 //y=1.39 \
 //x2=2.375 //y2=1.74
cc_384 ( N_A_c_510_n N_B_c_583_n ) capacitor c=0.00124821f //x=1.935 //y=1.045 \
 //x2=2.905 //y2=1.085
cc_385 ( N_A_c_512_n N_B_c_584_n ) capacitor c=0.00200715f //x=1.935 //y=1.39 \
 //x2=2.905 //y2=1.43
cc_386 ( N_A_c_502_n N_B_c_586_n ) capacitor c=0.00307062f //x=1.6 //y=2.26 \
 //x2=2.34 //y2=2.26
cc_387 ( N_A_c_507_n N_B_c_586_n ) capacitor c=0.0179092f //x=1.405 //y=2.095 \
 //x2=2.34 //y2=2.26
cc_388 ( N_A_c_502_n N_B_c_589_n ) capacitor c=0.00344981f //x=1.6 //y=2.26 \
 //x2=2.37 //y2=4.88
cc_389 ( N_A_c_519_n N_B_c_589_n ) capacitor c=0.0293367f //x=1.6 //y=4.88 \
 //x2=2.37 //y2=4.88
cc_390 ( N_A_c_507_n N_noxref_7_c_645_n ) capacitor c=0.0034165f //x=1.405 \
 //y=2.095 //x2=1.185 //y2=1.675
cc_391 ( N_A_c_502_n N_noxref_7_c_621_n ) capacitor c=0.0118986f //x=1.6 \
 //y=2.26 //x2=2.07 //y2=1.76
cc_392 ( N_A_c_506_n N_noxref_7_c_621_n ) capacitor c=0.00703567f //x=1.405 \
 //y=1.7 //x2=2.07 //y2=1.76
cc_393 ( N_A_c_507_n N_noxref_7_c_621_n ) capacitor c=0.0216532f //x=1.405 \
 //y=2.095 //x2=2.07 //y2=1.76
cc_394 ( N_A_c_509_n N_noxref_7_c_621_n ) capacitor c=0.00780629f //x=1.78 \
 //y=1.545 //x2=2.07 //y2=1.76
cc_395 ( N_A_c_512_n N_noxref_7_c_621_n ) capacitor c=0.00339872f //x=1.935 \
 //y=1.39 //x2=2.07 //y2=1.76
cc_396 ( N_A_c_507_n N_noxref_7_c_629_n ) capacitor c=6.71402e-19 //x=1.405 \
 //y=2.095 //x2=2.155 //y2=1.675
cc_397 ( N_A_c_503_n N_noxref_7_M0_noxref_s ) capacitor c=0.0326577f //x=1.405 \
 //y=1.045 //x2=1.05 //y2=0.545
cc_398 ( N_A_c_506_n N_noxref_7_M0_noxref_s ) capacitor c=3.48408e-19 \
 //x=1.405 //y=1.7 //x2=1.05 //y2=0.545
cc_399 ( N_A_c_510_n N_noxref_7_M0_noxref_s ) capacitor c=0.0120759f //x=1.935 \
 //y=1.045 //x2=1.05 //y2=0.545
cc_400 ( N_B_c_577_n N_noxref_7_c_629_n ) capacitor c=0.00623646f //x=2.375 \
 //y=1.74 //x2=2.155 //y2=1.675
cc_401 ( N_B_c_586_n N_noxref_7_c_629_n ) capacitor c=0.00172768f //x=2.34 \
 //y=2.26 //x2=2.155 //y2=1.675
cc_402 ( N_B_c_557_n N_noxref_7_c_630_n ) capacitor c=0.00161845f //x=2.34 \
 //y=2.26 //x2=3.04 //y2=0.71
cc_403 ( N_B_c_575_n N_noxref_7_c_630_n ) capacitor c=0.0186143f //x=2.375 \
 //y=1.085 //x2=3.04 //y2=0.71
cc_404 ( N_B_c_583_n N_noxref_7_c_630_n ) capacitor c=0.00656458f //x=2.905 \
 //y=1.085 //x2=3.04 //y2=0.71
cc_405 ( N_B_c_586_n N_noxref_7_c_630_n ) capacitor c=2.1838e-19 //x=2.34 \
 //y=2.26 //x2=3.04 //y2=0.71
cc_406 ( N_B_c_575_n N_noxref_7_M0_noxref_s ) capacitor c=0.00623646f \
 //x=2.375 //y=1.085 //x2=1.05 //y2=0.545
cc_407 ( N_B_c_583_n N_noxref_7_M0_noxref_s ) capacitor c=0.0143002f //x=2.905 \
 //y=1.085 //x2=1.05 //y2=0.545
cc_408 ( N_B_c_584_n N_noxref_7_M0_noxref_s ) capacitor c=0.00290153f \
 //x=2.905 //y=1.43 //x2=1.05 //y2=0.545
cc_409 ( N_C_M11_noxref_g N_noxref_9_c_743_n ) capacitor c=0.0170604f //x=5.71 \
 //y=6.205 //x2=5.405 //y2=5.39
cc_410 ( N_C_c_708_n N_noxref_9_c_743_n ) capacitor c=2.3112e-19 //x=5.705 \
 //y=4.885 //x2=5.405 //y2=5.39
cc_411 ( N_C_c_685_n N_noxref_9_c_748_n ) capacitor c=0.00109004f //x=5.67 \
 //y=4.72 //x2=6.285 //y2=7.09
cc_412 ( N_C_M11_noxref_g N_noxref_9_c_748_n ) capacitor c=0.0148484f //x=5.71 \
 //y=6.205 //x2=6.285 //y2=7.09
cc_413 ( N_C_M12_noxref_g N_noxref_9_c_748_n ) capacitor c=0.0163196f //x=6.15 \
 //y=6.205 //x2=6.285 //y2=7.09
cc_414 ( N_C_M12_noxref_g N_noxref_9_M12_noxref_d ) capacitor c=0.0351101f \
 //x=6.15 //y=6.205 //x2=6.225 //y2=5.205
