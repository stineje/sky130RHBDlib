// File: aoa4x1_pcell.spi.pex
// Created: Sun Apr 12 08:39:10 2026
// Program "Calibre xRC"
// Version "v2023.2_27.15"
// Nominal Temperature: 30C
// Circuit Temperature: 30C
//
simulator lang=spectre
subckt PM_AOA4X1_PCELL\%noxref_1 ( 3 8 9 11 12 14 15 16 18 19 20 23 24 27 29 \
 34 38 40 44 51 53 54 57 65 82 87 95 96 97 98 99 100 101 105 107 110 112 113 \
 118 128 130 131 )
c264 ( 128 0 ) capacitor c=0.00878249f //x=1.96 //y=0.905
c265 ( 118 0 ) capacitor c=0.0426341f //x=4.285 //y=4.705
c266 ( 113 0 ) capacitor c=0.0337825f //x=4.775 //y=1.25
c267 ( 112 0 ) capacitor c=0.0183823f //x=4.775 //y=0.905
c268 ( 110 0 ) capacitor c=0.0350928f //x=4.705 //y=4.795
c269 ( 107 0 ) capacitor c=0.013578f //x=4.62 //y=1.405
c270 ( 105 0 ) capacitor c=0.0157803f //x=4.62 //y=0.75
c271 ( 101 0 ) capacitor c=0.0787231f //x=4.245 //y=1.915
c272 ( 100 0 ) capacitor c=0.0230165f //x=4.245 //y=1.56
c273 ( 99 0 ) capacitor c=0.0234348f //x=4.245 //y=1.25
c274 ( 98 0 ) capacitor c=0.019134f //x=4.245 //y=0.905
c275 ( 97 0 ) capacitor c=0.110994f //x=4.78 //y=6.025
c276 ( 96 0 ) capacitor c=0.154777f //x=4.34 //y=6.025
c277 ( 87 0 ) capacitor c=4.74639e-19 //x=4.44 //y=2.08
c278 ( 82 0 ) capacitor c=0.00705226f //x=4.285 //y=4.705
c279 ( 65 0 ) capacitor c=0.0325392f //x=2.11 //y=5.38
c280 ( 57 0 ) capacitor c=0.0291911f //x=1.23 //y=5.38
c281 ( 54 0 ) capacitor c=0.0774598f //x=4.275 //y=2.585
c282 ( 53 0 ) capacitor c=0.00528707f //x=4.435 //y=2.585
c283 ( 51 0 ) capacitor c=0.00557932f //x=2.75 //y=2.585
c284 ( 44 0 ) capacitor c=0.00772734f //x=4.285 //y=4.705
c285 ( 40 0 ) capacitor c=0.0063606f //x=4.44 //y=2.08
c286 ( 38 0 ) capacitor c=0.0141822f //x=4.44 //y=2.59
c287 ( 34 0 ) capacitor c=0.0148986f //x=2.59 //y=2.59
c288 ( 29 0 ) capacitor c=0.011771f //x=2.15 //y=1
c289 ( 27 0 ) capacitor c=6.70882e-19 //x=2.11 //y=5.38
c290 ( 24 0 ) capacitor c=0.0129472f //x=2.11 //y=5.2
c291 ( 23 0 ) capacitor c=0.0106213f //x=1.23 //y=5.38
c292 ( 20 0 ) capacitor c=0.0626275f //x=4.44 //y=4.585
c293 ( 19 0 ) capacitor c=0.0110376f //x=4.44 //y=2.745
c294 ( 18 0 ) capacitor c=0.00428329f //x=4.44 //y=2.425
c295 ( 16 0 ) capacitor c=0.0762425f //x=2.59 //y=5.115
c296 ( 15 0 ) capacitor c=0.0117766f //x=2.59 //y=2.745
c297 ( 14 0 ) capacitor c=0.0169876f //x=2.59 //y=2.425
c298 ( 12 0 ) capacitor c=0.00837358f //x=2.235 //y=1.655
c299 ( 11 0 ) capacitor c=0.0136795f //x=2.505 //y=1.655
c300 ( 9 0 ) capacitor c=0.0123394f //x=2.505 //y=5.2
c301 ( 8 0 ) capacitor c=0.012699f //x=2.15 //y=1.57
c302 ( 3 0 ) capacitor c=0.019362f //x=1.995 //y=5.2
r303 (  120 121 ) resistor r=32.4568 //w=0.214 //l=0.075 //layer=ply \
 //thickness=0.18 //x=4.285 //y=4.795 //x2=4.285 //y2=4.87
r304 (  118 120 ) resistor r=20.271 //w=0.214 //l=0.09 //layer=ply \
 //thickness=0.18 //x=4.285 //y=4.705 //x2=4.285 //y2=4.795
r305 (  113 127 ) resistor r=45.1352 //w=0.168 //l=0.173853 //layer=ply \
 //thickness=0.18 //x=4.775 //y=1.25 //x2=4.735 //y2=1.405
r306 (  112 126 ) resistor r=45.1352 //w=0.168 //l=0.173853 //layer=ply \
 //thickness=0.18 //x=4.775 //y=0.905 //x2=4.735 //y2=0.75
r307 (  112 113 ) resistor r=176.904 //w=0.094 //l=0.345 //layer=ply \
 //thickness=0.18 //x=4.775 //y=0.905 //x2=4.775 //y2=1.25
r308 (  111 120 ) resistor r=16.5046 //w=0.27 //l=0.135 //layer=ply \
 //thickness=0.18 //x=4.42 //y=4.795 //x2=4.285 //y2=4.795
r309 (  110 114 ) resistor r=26.9307 //w=0.15 //l=0.106066 //layer=ply \
 //thickness=0.18 //x=4.705 //y=4.795 //x2=4.78 //y2=4.87
r310 (  110 111 ) resistor r=146.138 //w=0.094 //l=0.285 //layer=ply \
 //thickness=0.18 //x=4.705 //y=4.795 //x2=4.42 //y2=4.795
r311 (  108 125 ) resistor r=10.701 //w=0.21 //l=0.115 //layer=ply \
 //thickness=0.18 //x=4.4 //y=1.405 //x2=4.285 //y2=1.405
r312 (  107 127 ) resistor r=5.52526 //w=0.168 //l=0.115 //layer=ply \
 //thickness=0.18 //x=4.62 //y=1.405 //x2=4.735 //y2=1.405
r313 (  106 124 ) resistor r=5.52526 //w=0.168 //l=0.115 //layer=ply \
 //thickness=0.18 //x=4.4 //y=0.75 //x2=4.285 //y2=0.75
r314 (  105 126 ) resistor r=5.52526 //w=0.168 //l=0.115 //layer=ply \
 //thickness=0.18 //x=4.62 //y=0.75 //x2=4.735 //y2=0.75
r315 (  105 106 ) resistor r=112.809 //w=0.094 //l=0.22 //layer=ply \
 //thickness=0.18 //x=4.62 //y=0.75 //x2=4.4 //y2=0.75
r316 (  101 123 ) resistor r=34.8111 //w=0.27 //l=0.264953 //layer=ply \
 //thickness=0.18 //x=4.245 //y=1.915 //x2=4.44 //y2=2.08
r317 (  100 125 ) resistor r=39.5823 //w=0.21 //l=0.173853 //layer=ply \
 //thickness=0.18 //x=4.245 //y=1.56 //x2=4.285 //y2=1.405
r318 (  100 101 ) resistor r=182.032 //w=0.094 //l=0.355 //layer=ply \
 //thickness=0.18 //x=4.245 //y=1.56 //x2=4.245 //y2=1.915
r319 (  99 125 ) resistor r=39.5823 //w=0.21 //l=0.173853 //layer=ply \
 //thickness=0.18 //x=4.245 //y=1.25 //x2=4.285 //y2=1.405
r320 (  98 124 ) resistor r=45.1352 //w=0.168 //l=0.173853 //layer=ply \
 //thickness=0.18 //x=4.245 //y=0.905 //x2=4.285 //y2=0.75
r321 (  98 99 ) resistor r=176.904 //w=0.094 //l=0.345 //layer=ply \
 //thickness=0.18 //x=4.245 //y=0.905 //x2=4.245 //y2=1.25
r322 (  97 114 ) resistor r=592.245 //w=0.094 //l=1.155 //layer=ply \
 //thickness=0.18 //x=4.78 //y=6.025 //x2=4.78 //y2=4.87
r323 (  96 121 ) resistor r=592.245 //w=0.094 //l=1.155 //layer=ply \
 //thickness=0.18 //x=4.34 //y=6.025 //x2=4.34 //y2=4.87
r324 (  95 107 ) resistor r=56.4043 //w=0.094 //l=0.11 //layer=ply \
 //thickness=0.18 //x=4.51 //y=1.405 //x2=4.62 //y2=1.405
r325 (  95 108 ) resistor r=56.4043 //w=0.094 //l=0.11 //layer=ply \
 //thickness=0.18 //x=4.51 //y=1.405 //x2=4.4 //y2=1.405
r326 (  87 123 ) resistor r=152 //w=0.17 //l=0.17 //layer=licon //count=1 \
 //x=4.44 //y=2.08 //x2=4.44 //y2=2.08
r327 (  82 118 ) resistor r=152 //w=0.17 //l=0.17 //layer=licon //count=1 \
 //x=4.285 //y=4.705 //x2=4.285 //y2=4.705
r328 (  65 131 ) resistor r=23.615 //w=0.187 //l=0.345 //layer=li \
 //thickness=0.1 //x=2.11 //y=5.38 //x2=2.11 //y2=5.725
r329 (  57 130 ) resistor r=23.615 //w=0.187 //l=0.345 //layer=li \
 //thickness=0.1 //x=1.23 //y=5.38 //x2=1.23 //y2=5.725
r330 (  53 54 ) resistor r=0.10734 //w=0.281 //l=0.16 //layer=m2 \
 //thickness=0.36 //x=4.435 //y=2.585 //x2=4.275 //y2=2.585
r331 (  51 54 ) resistor r=1.45515 //w=0.131 //l=1.525 //layer=m2 \
 //thickness=0.36 //x=2.75 //y=2.59 //x2=4.275 //y2=2.59
r332 (  49 51 ) resistor r=0.10734 //w=0.281 //l=0.16 //layer=m2 \
 //thickness=0.36 //x=2.59 //y=2.585 //x2=2.75 //y2=2.585
r333 (  44 82 ) resistor r=9.3 //w=0.17 //l=0.17 //layer=mcon //count=1 \
 //x=4.285 //y=4.705 //x2=4.285 //y2=4.705
r334 (  44 45 ) resistor r=0.0853524 //w=0.227 //l=0.155 //layer=m1 \
 //thickness=0.36 //x=4.285 //y=4.702 //x2=4.44 //y2=4.702
r335 (  40 87 ) resistor r=9.3 //w=0.17 //l=0.17 //layer=mcon //count=1 \
 //x=4.44 //y=2.08 //x2=4.44 //y2=2.08
r336 (  40 42 ) resistor r=0.0985786 //w=0.206 //l=0.135 //layer=m1 \
 //thickness=0.36 //x=4.437 //y=2.08 //x2=4.437 //y2=2.215
r337 (  36 53 ) resistor r=4.5 //w=0.15 //l=0.15 //layer=via1 //count=1 \
 //x=4.435 //y=2.585 //x2=4.435 //y2=2.585
r338 (  36 38 ) resistor r=0.00167112 //w=0.374 //l=0.005 //layer=m1 \
 //thickness=0.36 //x=4.385 //y=2.585 //x2=4.385 //y2=2.59
r339 (  32 49 ) resistor r=4.5 //w=0.15 //l=0.15 //layer=via1 //count=1 \
 //x=2.59 //y=2.585 //x2=2.59 //y2=2.585
r340 (  32 34 ) resistor r=0.00166223 //w=0.376 //l=0.005 //layer=m1 \
 //thickness=0.36 //x=2.642 //y=2.585 //x2=2.642 //y2=2.59
r341 (  29 128 ) resistor r=9.3 //w=0.17 //l=0.17 //layer=mcon //count=1 \
 //x=2.15 //y=1 //x2=2.15 //y2=1
r342 (  27 65 ) resistor r=9.3 //w=0.17 //l=0.17 //layer=mcon //count=1 \
 //x=2.11 //y=5.38 //x2=2.11 //y2=5.38
r343 (  24 27 ) resistor r=0.117801 //w=0.191 //l=0.18 //layer=m1 \
 //thickness=0.36 //x=2.11 //y=5.2 //x2=2.11 //y2=5.38
r344 (  23 57 ) resistor r=9.3 //w=0.17 //l=0.17 //layer=mcon //count=1 \
 //x=1.23 //y=5.38 //x2=1.23 //y2=5.38
r345 (  21 23 ) resistor r=0.10274 //w=0.219 //l=0.18 //layer=m1 \
 //thickness=0.36 //x=1.23 //y=5.2 //x2=1.23 //y2=5.38
r346 (  20 45 ) resistor r=0.0249239 //w=0.227 //l=0.117 //layer=m1 \
 //thickness=0.36 //x=4.44 //y=4.585 //x2=4.44 //y2=4.702
r347 (  19 38 ) resistor r=0.089409 //w=0.374 //l=0.180416 //layer=m1 \
 //thickness=0.36 //x=4.44 //y=2.745 //x2=4.385 //y2=2.59
r348 (  19 20 ) resistor r=1.75573 //w=0.131 //l=1.84 //layer=m1 \
 //thickness=0.36 //x=4.44 //y=2.745 //x2=4.44 //y2=4.585
r349 (  18 36 ) resistor r=0.0910802 //w=0.374 //l=0.185472 //layer=m1 \
 //thickness=0.36 //x=4.44 //y=2.425 //x2=4.385 //y2=2.585
r350 (  18 42 ) resistor r=0.200382 //w=0.131 //l=0.21 //layer=m1 \
 //thickness=0.36 //x=4.44 //y=2.425 //x2=4.44 //y2=2.215
r351 (  15 34 ) resistor r=0.0894971 //w=0.376 //l=0.179123 //layer=m1 \
 //thickness=0.36 //x=2.59 //y=2.745 //x2=2.642 //y2=2.59
r352 (  15 16 ) resistor r=2.26145 //w=0.131 //l=2.37 //layer=m1 \
 //thickness=0.36 //x=2.59 //y=2.745 //x2=2.59 //y2=5.115
r353 (  14 32 ) resistor r=0.0911593 //w=0.376 //l=0.184174 //layer=m1 \
 //thickness=0.36 //x=2.59 //y=2.425 //x2=2.642 //y2=2.585
r354 (  13 14 ) resistor r=0.653626 //w=0.131 //l=0.685 //layer=m1 \
 //thickness=0.36 //x=2.59 //y=1.74 //x2=2.59 //y2=2.425
r355 (  11 13 ) resistor r=0.0698411 //w=0.17 //l=0.120208 //layer=m1 \
 //thickness=0.36 //x=2.505 //y=1.655 //x2=2.59 //y2=1.74
r356 (  11 12 ) resistor r=0.257634 //w=0.131 //l=0.27 //layer=m1 \
 //thickness=0.36 //x=2.505 //y=1.655 //x2=2.235 //y2=1.655
r357 (  10 24 ) resistor r=0.0257089 //w=0.23 //l=0.115 //layer=m1 \
 //thickness=0.36 //x=2.225 //y=5.2 //x2=2.11 //y2=5.2
r358 (  9 16 ) resistor r=0.0698411 //w=0.17 //l=0.120208 //layer=m1 \
 //thickness=0.36 //x=2.505 //y=5.2 //x2=2.59 //y2=5.115
r359 (  9 10 ) resistor r=0.267176 //w=0.131 //l=0.28 //layer=m1 \
 //thickness=0.36 //x=2.505 //y=5.2 //x2=2.225 //y2=5.2
r360 (  8 12 ) resistor r=0.0698411 //w=0.17 //l=0.120208 //layer=m1 \
 //thickness=0.36 //x=2.15 //y=1.57 //x2=2.235 //y2=1.655
r361 (  7 29 ) resistor r=0.0913624 //w=0.191 //l=0.12 //layer=m1 \
 //thickness=0.36 //x=2.15 //y=1.12 //x2=2.15 //y2=1
r362 (  7 8 ) resistor r=0.429389 //w=0.131 //l=0.45 //layer=m1 \
 //thickness=0.36 //x=2.15 //y=1.12 //x2=2.15 //y2=1.57
r363 (  4 21 ) resistor r=0.0227762 //w=0.219 //l=0.115 //layer=m1 \
 //thickness=0.36 //x=1.345 //y=5.2 //x2=1.23 //y2=5.2
r364 (  3 24 ) resistor r=0.0257089 //w=0.23 //l=0.115 //layer=m1 \
 //thickness=0.36 //x=1.995 //y=5.2 //x2=2.11 //y2=5.2
r365 (  3 4 ) resistor r=0.620229 //w=0.131 //l=0.65 //layer=m1 \
 //thickness=0.36 //x=1.995 //y=5.2 //x2=1.345 //y2=5.2
ends PM_AOA4X1_PCELL\%noxref_1

subckt PM_AOA4X1_PCELL\%noxref_2 ( 1 2 3 4 5 6 7 9 12 13 14 16 17 22 30 34 36 \
 39 40 47 49 50 58 75 84 88 89 90 91 92 93 94 98 100 103 104 114 117 118 121 )
c270 ( 118 0 ) capacitor c=0.00901091f //x=5.29 //y=0.905
c271 ( 117 0 ) capacitor c=0.00876479f //x=4.32 //y=0.905
c272 ( 114 0 ) capacitor c=0.0682508f //x=7.77 //y=4.7
c273 ( 104 0 ) capacitor c=0.0318956f //x=8.105 //y=1.21
c274 ( 103 0 ) capacitor c=0.0186809f //x=8.105 //y=0.865
c275 ( 100 0 ) capacitor c=0.0141821f //x=7.95 //y=1.365
c276 ( 98 0 ) capacitor c=0.0158553f //x=7.95 //y=0.71
c277 ( 94 0 ) capacitor c=0.0815046f //x=7.575 //y=1.915
c278 ( 93 0 ) capacitor c=0.0229235f //x=7.575 //y=1.52
c279 ( 92 0 ) capacitor c=0.0234359f //x=7.575 //y=1.21
c280 ( 91 0 ) capacitor c=0.0198759f //x=7.575 //y=0.865
c281 ( 90 0 ) capacitor c=0.110369f //x=8.11 //y=6.02
c282 ( 89 0 ) capacitor c=0.154619f //x=7.67 //y=6.02
c283 ( 84 0 ) capacitor c=8.13451e-19 //x=7.77 //y=4.7
c284 ( 75 0 ) capacitor c=5.17312e-19 //x=7.77 //y=2.08
c285 ( 58 0 ) capacitor c=0.0245539f //x=5.44 //y=5.38
c286 ( 50 0 ) capacitor c=0.0772176f //x=7.6 //y=2.585
c287 ( 49 0 ) capacitor c=0.00407557f //x=7.76 //y=2.585
c288 ( 47 0 ) capacitor c=0.00547085f //x=6.075 //y=2.585
c289 ( 40 0 ) capacitor c=0.061867f //x=7.772 //y=4.56
c290 ( 39 0 ) capacitor c=0.00635496f //x=7.77 //y=4.7
c291 ( 36 0 ) capacitor c=0.00617935f //x=7.77 //y=2.08
c292 ( 34 0 ) capacitor c=0.0141213f //x=7.77 //y=2.59
c293 ( 30 0 ) capacitor c=0.0143422f //x=5.92 //y=2.59
c294 ( 22 0 ) capacitor c=0.0136691f //x=5.435 //y=5.21
c295 ( 21 0 ) capacitor c=0.00513603f //x=5.48 //y=1.655
c296 ( 17 0 ) capacitor c=0.0114695f //x=7.77 //y=2.745
c297 ( 16 0 ) capacitor c=0.0044026f //x=7.77 //y=2.425
c298 ( 14 0 ) capacitor c=0.0748422f //x=5.92 //y=5.125
c299 ( 13 0 ) capacitor c=0.0124328f //x=5.92 //y=2.745
c300 ( 12 0 ) capacitor c=0.0158617f //x=5.92 //y=2.425
c301 ( 9 0 ) capacitor c=0.0141638f //x=5.835 //y=1.655
c302 ( 7 0 ) capacitor c=0.0112568f //x=5.835 //y=5.21
c303 ( 6 0 ) capacitor c=0.00792854f //x=5.48 //y=1.57
c304 ( 5 0 ) capacitor c=0.00855942f //x=5.48 //y=1.12
c305 ( 4 0 ) capacitor c=0.00230949f //x=4.595 //y=1.655
c306 ( 3 0 ) capacitor c=0.0217217f //x=5.395 //y=1.655
c307 ( 2 0 ) capacitor c=0.00638036f //x=4.51 //y=1.57
c308 ( 1 0 ) capacitor c=0.00825276f //x=4.51 //y=1.125
r309 (  112 114 ) resistor r=20.6867 //w=0.233 //l=0.1 //layer=ply \
 //thickness=0.18 //x=7.67 //y=4.7 //x2=7.77 //y2=4.7
r310 (  105 114 ) resistor r=70.3348 //w=0.233 //l=0.414367 //layer=ply \
 //thickness=0.18 //x=8.11 //y=4.865 //x2=7.77 //y2=4.7
r311 (  104 116 ) resistor r=45.1352 //w=0.168 //l=0.173853 //layer=ply \
 //thickness=0.18 //x=8.105 //y=1.21 //x2=8.065 //y2=1.365
r312 (  103 115 ) resistor r=45.1352 //w=0.168 //l=0.173853 //layer=ply \
 //thickness=0.18 //x=8.105 //y=0.865 //x2=8.065 //y2=0.71
r313 (  103 104 ) resistor r=176.904 //w=0.094 //l=0.345 //layer=ply \
 //thickness=0.18 //x=8.105 //y=0.865 //x2=8.105 //y2=1.21
r314 (  101 111 ) resistor r=10.701 //w=0.21 //l=0.115 //layer=ply \
 //thickness=0.18 //x=7.73 //y=1.365 //x2=7.615 //y2=1.365
r315 (  100 116 ) resistor r=5.52526 //w=0.168 //l=0.115 //layer=ply \
 //thickness=0.18 //x=7.95 //y=1.365 //x2=8.065 //y2=1.365
r316 (  99 110 ) resistor r=5.52526 //w=0.168 //l=0.115 //layer=ply \
 //thickness=0.18 //x=7.73 //y=0.71 //x2=7.615 //y2=0.71
r317 (  98 115 ) resistor r=5.52526 //w=0.168 //l=0.115 //layer=ply \
 //thickness=0.18 //x=7.95 //y=0.71 //x2=8.065 //y2=0.71
r318 (  98 99 ) resistor r=112.809 //w=0.094 //l=0.22 //layer=ply \
 //thickness=0.18 //x=7.95 //y=0.71 //x2=7.73 //y2=0.71
r319 (  95 112 ) resistor r=13.0941 //w=0.233 //l=0.165 //layer=ply \
 //thickness=0.18 //x=7.67 //y=4.865 //x2=7.67 //y2=4.7
r320 (  94 109 ) resistor r=34.8111 //w=0.27 //l=0.264953 //layer=ply \
 //thickness=0.18 //x=7.575 //y=1.915 //x2=7.77 //y2=2.08
r321 (  93 111 ) resistor r=39.5823 //w=0.21 //l=0.173853 //layer=ply \
 //thickness=0.18 //x=7.575 //y=1.52 //x2=7.615 //y2=1.365
r322 (  93 94 ) resistor r=202.543 //w=0.094 //l=0.395 //layer=ply \
 //thickness=0.18 //x=7.575 //y=1.52 //x2=7.575 //y2=1.915
r323 (  92 111 ) resistor r=39.5823 //w=0.21 //l=0.173853 //layer=ply \
 //thickness=0.18 //x=7.575 //y=1.21 //x2=7.615 //y2=1.365
r324 (  91 110 ) resistor r=45.1352 //w=0.168 //l=0.173853 //layer=ply \
 //thickness=0.18 //x=7.575 //y=0.865 //x2=7.615 //y2=0.71
r325 (  91 92 ) resistor r=176.904 //w=0.094 //l=0.345 //layer=ply \
 //thickness=0.18 //x=7.575 //y=0.865 //x2=7.575 //y2=1.21
r326 (  90 105 ) resistor r=592.245 //w=0.094 //l=1.155 //layer=ply \
 //thickness=0.18 //x=8.11 //y=6.02 //x2=8.11 //y2=4.865
r327 (  89 95 ) resistor r=592.245 //w=0.094 //l=1.155 //layer=ply \
 //thickness=0.18 //x=7.67 //y=6.02 //x2=7.67 //y2=4.865
r328 (  88 100 ) resistor r=56.4043 //w=0.094 //l=0.11 //layer=ply \
 //thickness=0.18 //x=7.84 //y=1.365 //x2=7.95 //y2=1.365
r329 (  88 101 ) resistor r=56.4043 //w=0.094 //l=0.11 //layer=ply \
 //thickness=0.18 //x=7.84 //y=1.365 //x2=7.73 //y2=1.365
r330 (  84 114 ) resistor r=152 //w=0.17 //l=0.17 //layer=licon //count=1 \
 //x=7.77 //y=4.7 //x2=7.77 //y2=4.7
r331 (  75 109 ) resistor r=152 //w=0.17 //l=0.17 //layer=licon //count=1 \
 //x=7.77 //y=2.08 //x2=7.77 //y2=2.08
r332 (  58 121 ) resistor r=23.2727 //w=0.187 //l=0.34 //layer=li \
 //thickness=0.1 //x=5.44 //y=5.38 //x2=5.44 //y2=5.72
r333 (  49 50 ) resistor r=0.104807 //w=0.281 //l=0.16 //layer=m2 \
 //thickness=0.36 //x=7.76 //y=2.585 //x2=7.6 //y2=2.585
r334 (  47 50 ) resistor r=1.40165 //w=0.136 //l=1.525 //layer=m2 \
 //thickness=0.36 //x=6.075 //y=2.587 //x2=7.6 //y2=2.587
r335 (  45 47 ) resistor r=0.104807 //w=0.281 //l=0.16 //layer=m2 \
 //thickness=0.36 //x=5.915 //y=2.585 //x2=6.075 //y2=2.585
r336 (  39 84 ) resistor r=9.3 //w=0.17 //l=0.17 //layer=mcon //count=1 \
 //x=7.77 //y=4.7 //x2=7.77 //y2=4.7
r337 (  39 40 ) resistor r=0.103207 //w=0.196 //l=0.14 //layer=m1 \
 //thickness=0.36 //x=7.772 //y=4.7 //x2=7.772 //y2=4.56
r338 (  36 75 ) resistor r=9.3 //w=0.17 //l=0.17 //layer=mcon //count=1 \
 //x=7.77 //y=2.08 //x2=7.77 //y2=2.08
r339 (  32 49 ) resistor r=4.5 //w=0.15 //l=0.15 //layer=via1 //count=1 \
 //x=7.76 //y=2.585 //x2=7.76 //y2=2.585
r340 (  32 34 ) resistor r=0.00168464 //w=0.371 //l=0.005 //layer=m1 \
 //thickness=0.36 //x=7.712 //y=2.585 //x2=7.712 //y2=2.59
r341 (  28 45 ) resistor r=4.5 //w=0.15 //l=0.15 //layer=via1 //count=1 \
 //x=5.915 //y=2.585 //x2=5.915 //y2=2.585
r342 (  28 30 ) resistor r=0.00164908 //w=0.379 //l=0.005 //layer=m1 \
 //thickness=0.36 //x=5.97 //y=2.585 //x2=5.97 //y2=2.59
r343 (  26 118 ) resistor r=9.3 //w=0.17 //l=0.17 //layer=mcon //count=1 \
 //x=5.48 //y=1 //x2=5.48 //y2=1
r344 (  24 58 ) resistor r=9.3 //w=0.17 //l=0.17 //layer=mcon //count=1 \
 //x=5.44 //y=5.38 //x2=5.44 //y2=5.38
r345 (  22 24 ) resistor r=0.0974771 //w=0.218 //l=0.17 //layer=m1 \
 //thickness=0.36 //x=5.435 //y=5.21 //x2=5.435 //y2=5.38
r346 (  20 117 ) resistor r=9.3 //w=0.17 //l=0.17 //layer=mcon //count=1 \
 //x=4.51 //y=1 //x2=4.51 //y2=1
r347 (  17 34 ) resistor r=0.0892801 //w=0.371 //l=0.1817 //layer=m1 \
 //thickness=0.36 //x=7.77 //y=2.745 //x2=7.712 //y2=2.59
r348 (  17 40 ) resistor r=1.73187 //w=0.131 //l=1.815 //layer=m1 \
 //thickness=0.36 //x=7.77 //y=2.745 //x2=7.77 //y2=4.56
r349 (  16 32 ) resistor r=0.0909648 //w=0.371 //l=0.186762 //layer=m1 \
 //thickness=0.36 //x=7.77 //y=2.425 //x2=7.712 //y2=2.585
r350 (  15 36 ) resistor r=0.0933015 //w=0.201 //l=0.125 //layer=m1 \
 //thickness=0.36 //x=7.77 //y=2.205 //x2=7.77 //y2=2.08
r351 (  15 16 ) resistor r=0.209924 //w=0.131 //l=0.22 //layer=m1 \
 //thickness=0.36 //x=7.77 //y=2.205 //x2=7.77 //y2=2.425
r352 (  13 30 ) resistor r=0.0896323 //w=0.379 //l=0.178255 //layer=m1 \
 //thickness=0.36 //x=5.92 //y=2.745 //x2=5.97 //y2=2.59
r353 (  13 14 ) resistor r=2.27099 //w=0.131 //l=2.38 //layer=m1 \
 //thickness=0.36 //x=5.92 //y=2.745 //x2=5.92 //y2=5.125
r354 (  12 28 ) resistor r=0.0912814 //w=0.379 //l=0.183303 //layer=m1 \
 //thickness=0.36 //x=5.92 //y=2.425 //x2=5.97 //y2=2.585
r355 (  11 12 ) resistor r=0.653626 //w=0.131 //l=0.685 //layer=m1 \
 //thickness=0.36 //x=5.92 //y=1.74 //x2=5.92 //y2=2.425
r356 (  10 21 ) resistor r=0.0529306 //w=0.17 //l=0.085 //layer=m1 \
 //thickness=0.36 //x=5.565 //y=1.655 //x2=5.48 //y2=1.655
r357 (  9 11 ) resistor r=0.0698411 //w=0.17 //l=0.120208 //layer=m1 \
 //thickness=0.36 //x=5.835 //y=1.655 //x2=5.92 //y2=1.74
r358 (  9 10 ) resistor r=0.257634 //w=0.131 //l=0.27 //layer=m1 \
 //thickness=0.36 //x=5.835 //y=1.655 //x2=5.565 //y2=1.655
r359 (  8 22 ) resistor r=0.0225019 //w=0.218 //l=0.12 //layer=m1 \
 //thickness=0.36 //x=5.555 //y=5.21 //x2=5.435 //y2=5.21
r360 (  7 14 ) resistor r=0.0698411 //w=0.17 //l=0.120208 //layer=m1 \
 //thickness=0.36 //x=5.835 //y=5.21 //x2=5.92 //y2=5.125
r361 (  7 8 ) resistor r=0.267176 //w=0.131 //l=0.28 //layer=m1 \
 //thickness=0.36 //x=5.835 //y=5.21 //x2=5.555 //y2=5.21
r362 (  6 21 ) resistor r=0.0137558 //w=0.34 //l=0.085 //layer=m1 \
 //thickness=0.36 //x=5.48 //y=1.57 //x2=5.48 //y2=1.655
r363 (  5 26 ) resistor r=0.0728765 //w=0.25 //l=0.121491 //layer=m1 \
 //thickness=0.36 //x=5.48 //y=1.12 //x2=5.477 //y2=1
r364 (  5 6 ) resistor r=0.429389 //w=0.131 //l=0.45 //layer=m1 \
 //thickness=0.36 //x=5.48 //y=1.12 //x2=5.48 //y2=1.57
r365 (  3 21 ) resistor r=0.0529306 //w=0.17 //l=0.085 //layer=m1 \
 //thickness=0.36 //x=5.395 //y=1.655 //x2=5.48 //y2=1.655
r366 (  3 4 ) resistor r=0.763359 //w=0.131 //l=0.8 //layer=m1 \
 //thickness=0.36 //x=5.395 //y=1.655 //x2=4.595 //y2=1.655
r367 (  2 4 ) resistor r=0.0698411 //w=0.17 //l=0.120208 //layer=m1 \
 //thickness=0.36 //x=4.51 //y=1.57 //x2=4.595 //y2=1.655
r368 (  1 20 ) resistor r=0.0764279 //w=0.233 //l=0.126491 //layer=m1 \
 //thickness=0.36 //x=4.51 //y=1.125 //x2=4.507 //y2=1
r369 (  1 2 ) resistor r=0.424618 //w=0.131 //l=0.445 //layer=m1 \
 //thickness=0.36 //x=4.51 //y=1.125 //x2=4.51 //y2=1.57
ends PM_AOA4X1_PCELL\%noxref_2

subckt PM_AOA4X1_PCELL\%noxref_3 ( 3 8 9 11 12 14 15 16 18 19 20 23 24 27 29 \
 34 38 40 49 51 52 55 63 80 89 93 94 95 96 97 98 99 103 104 105 107 113 114 \
 116 124 126 127 )
c230 ( 124 0 ) capacitor c=0.00878249f //x=8.62 //y=0.905
c231 ( 116 0 ) capacitor c=0.0555093f //x=10.73 //y=2.085
c232 ( 114 0 ) capacitor c=0.0439576f //x=11.37 //y=1.255
c233 ( 113 0 ) capacitor c=0.0201087f //x=11.37 //y=0.91
c234 ( 107 0 ) capacitor c=0.0161986f //x=11.215 //y=1.41
c235 ( 105 0 ) capacitor c=0.0157807f //x=11.215 //y=0.755
c236 ( 104 0 ) capacitor c=0.0557689f //x=10.96 //y=4.79
c237 ( 103 0 ) capacitor c=0.0406047f //x=11.25 //y=4.79
c238 ( 99 0 ) capacitor c=0.0301471f //x=10.84 //y=1.92
c239 ( 98 0 ) capacitor c=0.0255349f //x=10.84 //y=1.565
c240 ( 97 0 ) capacitor c=0.0234346f //x=10.84 //y=1.255
c241 ( 96 0 ) capacitor c=0.02013f //x=10.84 //y=0.91
c242 ( 95 0 ) capacitor c=0.153839f //x=11.325 //y=6.02
c243 ( 94 0 ) capacitor c=0.15434f //x=10.885 //y=6.02
c244 ( 89 0 ) capacitor c=9.45276e-19 //x=10.73 //y=4.7
c245 ( 80 0 ) capacitor c=6.43121e-19 //x=10.73 //y=2.085
c246 ( 63 0 ) capacitor c=0.0325184f //x=8.77 //y=5.38
c247 ( 55 0 ) capacitor c=0.0290792f //x=7.89 //y=5.38
c248 ( 52 0 ) capacitor c=0.056805f //x=10.57 //y=2.585
c249 ( 51 0 ) capacitor c=0.0045193f //x=10.73 //y=2.585
c250 ( 49 0 ) capacitor c=0.00557932f //x=9.41 //y=2.585
c251 ( 40 0 ) capacitor c=0.0110657f //x=10.73 //y=2.085
c252 ( 38 0 ) capacitor c=0.0123916f //x=10.73 //y=2.59
c253 ( 34 0 ) capacitor c=0.0142381f //x=9.25 //y=2.59
c254 ( 29 0 ) capacitor c=0.0114007f //x=8.81 //y=1
c255 ( 27 0 ) capacitor c=8.73568e-19 //x=8.77 //y=5.38
c256 ( 24 0 ) capacitor c=0.0125762f //x=8.77 //y=5.2
c257 ( 23 0 ) capacitor c=0.0104542f //x=7.89 //y=5.38
c258 ( 20 0 ) capacitor c=0.0607743f //x=10.73 //y=4.58
c259 ( 19 0 ) capacitor c=0.0116251f //x=10.73 //y=2.745
c260 ( 18 0 ) capacitor c=0.00274252f //x=10.73 //y=2.425
c261 ( 16 0 ) capacitor c=0.0689735f //x=9.25 //y=5.115
c262 ( 15 0 ) capacitor c=0.011393f //x=9.25 //y=2.745
c263 ( 14 0 ) capacitor c=0.014907f //x=9.25 //y=2.425
c264 ( 12 0 ) capacitor c=0.0069619f //x=8.895 //y=1.655
c265 ( 11 0 ) capacitor c=0.0136462f //x=9.165 //y=1.655
c266 ( 9 0 ) capacitor c=0.0123258f //x=9.165 //y=5.2
c267 ( 8 0 ) capacitor c=0.00913132f //x=8.81 //y=1.57
c268 ( 3 0 ) capacitor c=0.019362f //x=8.655 //y=5.2
r269 (  116 117 ) resistor r=17.5563 //w=0.302 //l=0.11 //layer=ply \
 //thickness=0.18 //x=10.73 //y=2.085 //x2=10.84 //y2=2.085
r270 (  114 123 ) resistor r=45.1352 //w=0.168 //l=0.173853 //layer=ply \
 //thickness=0.18 //x=11.37 //y=1.255 //x2=11.33 //y2=1.41
r271 (  113 122 ) resistor r=45.1352 //w=0.168 //l=0.173853 //layer=ply \
 //thickness=0.18 //x=11.37 //y=0.91 //x2=11.33 //y2=0.755
r272 (  113 114 ) resistor r=176.904 //w=0.094 //l=0.345 //layer=ply \
 //thickness=0.18 //x=11.37 //y=0.91 //x2=11.37 //y2=1.255
r273 (  108 121 ) resistor r=10.701 //w=0.21 //l=0.115 //layer=ply \
 //thickness=0.18 //x=10.995 //y=1.41 //x2=10.88 //y2=1.41
r274 (  107 123 ) resistor r=5.52526 //w=0.168 //l=0.115 //layer=ply \
 //thickness=0.18 //x=11.215 //y=1.41 //x2=11.33 //y2=1.41
r275 (  106 120 ) resistor r=5.52526 //w=0.168 //l=0.115 //layer=ply \
 //thickness=0.18 //x=10.995 //y=0.755 //x2=10.88 //y2=0.755
r276 (  105 122 ) resistor r=5.52526 //w=0.168 //l=0.115 //layer=ply \
 //thickness=0.18 //x=11.215 //y=0.755 //x2=11.33 //y2=0.755
r277 (  105 106 ) resistor r=112.809 //w=0.094 //l=0.22 //layer=ply \
 //thickness=0.18 //x=11.215 //y=0.755 //x2=10.995 //y2=0.755
r278 (  103 110 ) resistor r=26.9307 //w=0.15 //l=0.106066 //layer=ply \
 //thickness=0.18 //x=11.25 //y=4.79 //x2=11.325 //y2=4.865
r279 (  103 104 ) resistor r=148.702 //w=0.094 //l=0.29 //layer=ply \
 //thickness=0.18 //x=11.25 //y=4.79 //x2=10.96 //y2=4.79
r280 (  100 104 ) resistor r=23.403 //w=0.284 //l=0.106066 //layer=ply \
 //thickness=0.18 //x=10.885 //y=4.865 //x2=10.96 //y2=4.79
r281 (  100 119 ) resistor r=26.3063 //w=0.284 //l=0.229783 //layer=ply \
 //thickness=0.18 //x=10.885 //y=4.865 //x2=10.73 //y2=4.7
r282 (  99 117 ) resistor r=19.1248 //w=0.302 //l=0.165 //layer=ply \
 //thickness=0.18 //x=10.84 //y=1.92 //x2=10.84 //y2=2.085
r283 (  98 121 ) resistor r=39.5823 //w=0.21 //l=0.173853 //layer=ply \
 //thickness=0.18 //x=10.84 //y=1.565 //x2=10.88 //y2=1.41
r284 (  98 99 ) resistor r=182.032 //w=0.094 //l=0.355 //layer=ply \
 //thickness=0.18 //x=10.84 //y=1.565 //x2=10.84 //y2=1.92
r285 (  97 121 ) resistor r=39.5823 //w=0.21 //l=0.173853 //layer=ply \
 //thickness=0.18 //x=10.84 //y=1.255 //x2=10.88 //y2=1.41
r286 (  96 120 ) resistor r=45.1352 //w=0.168 //l=0.173853 //layer=ply \
 //thickness=0.18 //x=10.84 //y=0.91 //x2=10.88 //y2=0.755
r287 (  96 97 ) resistor r=176.904 //w=0.094 //l=0.345 //layer=ply \
 //thickness=0.18 //x=10.84 //y=0.91 //x2=10.84 //y2=1.255
r288 (  95 110 ) resistor r=592.245 //w=0.094 //l=1.155 //layer=ply \
 //thickness=0.18 //x=11.325 //y=6.02 //x2=11.325 //y2=4.865
r289 (  94 100 ) resistor r=592.245 //w=0.094 //l=1.155 //layer=ply \
 //thickness=0.18 //x=10.885 //y=6.02 //x2=10.885 //y2=4.865
r290 (  93 107 ) resistor r=56.4043 //w=0.094 //l=0.11 //layer=ply \
 //thickness=0.18 //x=11.105 //y=1.41 //x2=11.215 //y2=1.41
r291 (  93 108 ) resistor r=56.4043 //w=0.094 //l=0.11 //layer=ply \
 //thickness=0.18 //x=11.105 //y=1.41 //x2=10.995 //y2=1.41
r292 (  89 119 ) resistor r=152 //w=0.17 //l=0.17 //layer=licon //count=1 \
 //x=10.73 //y=4.7 //x2=10.73 //y2=4.7
r293 (  80 116 ) resistor r=152 //w=0.17 //l=0.17 //layer=licon //count=1 \
 //x=10.73 //y=2.085 //x2=10.73 //y2=2.085
r294 (  63 127 ) resistor r=23.615 //w=0.187 //l=0.345 //layer=li \
 //thickness=0.1 //x=8.77 //y=5.38 //x2=8.77 //y2=5.725
r295 (  55 126 ) resistor r=23.615 //w=0.187 //l=0.345 //layer=li \
 //thickness=0.1 //x=7.89 //y=5.38 //x2=7.89 //y2=5.725
r296 (  51 52 ) resistor r=0.10734 //w=0.281 //l=0.16 //layer=m2 \
 //thickness=0.36 //x=10.73 //y=2.585 //x2=10.57 //y2=2.585
r297 (  49 52 ) resistor r=1.10687 //w=0.131 //l=1.16 //layer=m2 \
 //thickness=0.36 //x=9.41 //y=2.59 //x2=10.57 //y2=2.59
r298 (  47 49 ) resistor r=0.10734 //w=0.281 //l=0.16 //layer=m2 \
 //thickness=0.36 //x=9.25 //y=2.585 //x2=9.41 //y2=2.585
r299 (  43 89 ) resistor r=9.3 //w=0.17 //l=0.17 //layer=mcon //count=1 \
 //x=10.73 //y=4.7 //x2=10.73 //y2=4.7
r300 (  40 80 ) resistor r=9.3 //w=0.17 //l=0.17 //layer=mcon //count=1 \
 //x=10.73 //y=2.085 //x2=10.73 //y2=2.085
r301 (  36 51 ) resistor r=4.5 //w=0.15 //l=0.15 //layer=via1 //count=1 \
 //x=10.73 //y=2.585 //x2=10.73 //y2=2.585
r302 (  36 38 ) resistor r=0.00166223 //w=0.376 //l=0.005 //layer=m1 \
 //thickness=0.36 //x=10.677 //y=2.585 //x2=10.677 //y2=2.59
r303 (  32 47 ) resistor r=4.5 //w=0.15 //l=0.15 //layer=via1 //count=1 \
 //x=9.25 //y=2.585 //x2=9.25 //y2=2.585
r304 (  32 34 ) resistor r=0.00166223 //w=0.376 //l=0.005 //layer=m1 \
 //thickness=0.36 //x=9.302 //y=2.585 //x2=9.302 //y2=2.59
r305 (  29 124 ) resistor r=9.3 //w=0.17 //l=0.17 //layer=mcon //count=1 \
 //x=8.81 //y=1 //x2=8.81 //y2=1
r306 (  27 63 ) resistor r=9.3 //w=0.17 //l=0.17 //layer=mcon //count=1 \
 //x=8.77 //y=5.38 //x2=8.77 //y2=5.38
r307 (  24 27 ) resistor r=0.117801 //w=0.191 //l=0.18 //layer=m1 \
 //thickness=0.36 //x=8.77 //y=5.2 //x2=8.77 //y2=5.38
r308 (  23 55 ) resistor r=9.3 //w=0.17 //l=0.17 //layer=mcon //count=1 \
 //x=7.89 //y=5.38 //x2=7.89 //y2=5.38
r309 (  21 23 ) resistor r=0.10274 //w=0.219 //l=0.18 //layer=m1 \
 //thickness=0.36 //x=7.89 //y=5.2 //x2=7.89 //y2=5.38
r310 (  20 43 ) resistor r=0.0732479 //w=0.241 //l=0.122474 //layer=m1 \
 //thickness=0.36 //x=10.73 //y=4.58 //x2=10.735 //y2=4.7
r311 (  19 38 ) resistor r=0.0894971 //w=0.376 //l=0.179555 //layer=m1 \
 //thickness=0.36 //x=10.73 //y=2.745 //x2=10.677 //y2=2.59
r312 (  19 20 ) resistor r=1.75095 //w=0.131 //l=1.835 //layer=m1 \
 //thickness=0.36 //x=10.73 //y=2.745 //x2=10.73 //y2=4.58
r313 (  18 36 ) resistor r=0.0911593 //w=0.376 //l=0.184608 //layer=m1 \
 //thickness=0.36 //x=10.73 //y=2.425 //x2=10.677 //y2=2.585
r314 (  17 40 ) resistor r=0.116051 //w=0.211 //l=0.165 //layer=m1 \
 //thickness=0.36 //x=10.73 //y=2.25 //x2=10.73 //y2=2.085
r315 (  17 18 ) resistor r=0.166985 //w=0.131 //l=0.175 //layer=m1 \
 //thickness=0.36 //x=10.73 //y=2.25 //x2=10.73 //y2=2.425
r316 (  15 34 ) resistor r=0.0894971 //w=0.376 //l=0.179123 //layer=m1 \
 //thickness=0.36 //x=9.25 //y=2.745 //x2=9.302 //y2=2.59
r317 (  15 16 ) resistor r=2.26145 //w=0.131 //l=2.37 //layer=m1 \
 //thickness=0.36 //x=9.25 //y=2.745 //x2=9.25 //y2=5.115
r318 (  14 32 ) resistor r=0.0911593 //w=0.376 //l=0.184174 //layer=m1 \
 //thickness=0.36 //x=9.25 //y=2.425 //x2=9.302 //y2=2.585
r319 (  13 14 ) resistor r=0.653626 //w=0.131 //l=0.685 //layer=m1 \
 //thickness=0.36 //x=9.25 //y=1.74 //x2=9.25 //y2=2.425
r320 (  11 13 ) resistor r=0.0698411 //w=0.17 //l=0.120208 //layer=m1 \
 //thickness=0.36 //x=9.165 //y=1.655 //x2=9.25 //y2=1.74
r321 (  11 12 ) resistor r=0.257634 //w=0.131 //l=0.27 //layer=m1 \
 //thickness=0.36 //x=9.165 //y=1.655 //x2=8.895 //y2=1.655
r322 (  10 24 ) resistor r=0.0257089 //w=0.23 //l=0.115 //layer=m1 \
 //thickness=0.36 //x=8.885 //y=5.2 //x2=8.77 //y2=5.2
r323 (  9 16 ) resistor r=0.0698411 //w=0.17 //l=0.120208 //layer=m1 \
 //thickness=0.36 //x=9.165 //y=5.2 //x2=9.25 //y2=5.115
r324 (  9 10 ) resistor r=0.267176 //w=0.131 //l=0.28 //layer=m1 \
 //thickness=0.36 //x=9.165 //y=5.2 //x2=8.885 //y2=5.2
r325 (  8 12 ) resistor r=0.0698411 //w=0.17 //l=0.120208 //layer=m1 \
 //thickness=0.36 //x=8.81 //y=1.57 //x2=8.895 //y2=1.655
r326 (  7 29 ) resistor r=0.0913624 //w=0.191 //l=0.12 //layer=m1 \
 //thickness=0.36 //x=8.81 //y=1.12 //x2=8.81 //y2=1
r327 (  7 8 ) resistor r=0.429389 //w=0.131 //l=0.45 //layer=m1 \
 //thickness=0.36 //x=8.81 //y=1.12 //x2=8.81 //y2=1.57
r328 (  4 21 ) resistor r=0.0227762 //w=0.219 //l=0.115 //layer=m1 \
 //thickness=0.36 //x=8.005 //y=5.2 //x2=7.89 //y2=5.2
r329 (  3 24 ) resistor r=0.0257089 //w=0.23 //l=0.115 //layer=m1 \
 //thickness=0.36 //x=8.655 //y=5.2 //x2=8.77 //y2=5.2
r330 (  3 4 ) resistor r=0.620229 //w=0.131 //l=0.65 //layer=m1 \
 //thickness=0.36 //x=8.655 //y=5.2 //x2=8.005 //y2=5.2
ends PM_AOA4X1_PCELL\%noxref_3

subckt PM_AOA4X1_PCELL\%noxref_4 ( 1 11 12 25 50 58 74 101 111 133 148 151 152 \
 157 161 162 163 164 165 166 167 168 169 170 )
c234 ( 170 0 ) capacitor c=0.0633005f //x=11.4 //y=5.02
c235 ( 169 0 ) capacitor c=0.0583562f //x=10.53 //y=5.02
c236 ( 168 0 ) capacitor c=0.0398738f //x=9.065 //y=5.02
c237 ( 167 0 ) capacitor c=0.024747f //x=8.185 //y=5.02
c238 ( 166 0 ) capacitor c=0.0652533f //x=7.315 //y=5.02
c239 ( 165 0 ) capacitor c=0.0230094f //x=4.415 //y=5.025
c240 ( 164 0 ) capacitor c=0.0399063f //x=2.405 //y=5.02
c241 ( 163 0 ) capacitor c=0.0247431f //x=1.525 //y=5.02
c242 ( 162 0 ) capacitor c=0.0678024f //x=0.655 //y=5.02
c243 ( 161 0 ) capacitor c=0.24103f //x=11.47 //y=7.4
c244 ( 159 0 ) capacitor c=0.00591168f //x=10.73 //y=7.4
c245 ( 157 0 ) capacitor c=0.123307f //x=9.99 //y=7.4
c246 ( 156 0 ) capacitor c=0.00591168f //x=9.25 //y=7.4
c247 ( 154 0 ) capacitor c=0.00591168f //x=8.33 //y=7.4
c248 ( 153 0 ) capacitor c=0.00591168f //x=7.45 //y=7.4
c249 ( 152 0 ) capacitor c=0.130498f //x=6.66 //y=7.4
c250 ( 151 0 ) capacitor c=0.126437f //x=3.33 //y=7.4
c251 ( 150 0 ) capacitor c=0.00591168f //x=2.55 //y=7.4
c252 ( 149 0 ) capacitor c=0.00591168f //x=1.67 //y=7.4
c253 ( 148 0 ) capacitor c=0.253139f //x=0.74 //y=7.4
c254 ( 133 0 ) capacitor c=0.028723f //x=11.46 //y=7.4
c255 ( 123 0 ) capacitor c=0.0216067f //x=10.58 //y=7.4
c256 ( 119 0 ) capacitor c=0.0275781f //x=9.82 //y=7.4
c257 ( 111 0 ) capacitor c=0.0284687f //x=9.125 //y=7.4
c258 ( 101 0 ) capacitor c=0.0288404f //x=8.245 //y=7.4
c259 ( 89 0 ) capacitor c=0.0281468f //x=7.365 //y=7.4
c260 ( 74 0 ) capacitor c=0.137893f //x=6.49 //y=7.4
c261 ( 68 0 ) capacitor c=0.0275781f //x=3.16 //y=7.4
c262 ( 58 0 ) capacitor c=0.0284687f //x=2.465 //y=7.4
c263 ( 50 0 ) capacitor c=0.0288404f //x=1.585 //y=7.4
c264 ( 29 0 ) capacitor c=0.00498911f //x=4.56 //y=7.4
c265 ( 25 0 ) capacitor c=0.282858f //x=11.47 //y=7.4
c266 ( 12 0 ) capacitor c=0.00916089f //x=4.56 //y=7.23
c267 ( 11 0 ) capacitor c=0.00572492f //x=4.56 //y=6.855
c268 ( 1 0 ) capacitor c=0.17911f //x=4.475 //y=7.4
r269 (  135 161 ) resistor r=4.11603 //w=0.68 //l=0.17 //layer=li \
 //thickness=0.1 //x=11.545 //y=7.23 //x2=11.545 //y2=7.4
r270 (  135 170 ) resistor r=56.4706 //w=0.187 //l=0.825 //layer=li \
 //thickness=0.1 //x=11.545 //y=7.23 //x2=11.545 //y2=6.405
r271 (  134 159 ) resistor r=2.94794 //w=0.34 //l=0.085 //layer=li \
 //thickness=0.1 //x=10.75 //y=7.4 //x2=10.665 //y2=7.4
r272 (  133 161 ) resistor r=2.94794 //w=0.34 //l=0.085 //layer=li \
 //thickness=0.1 //x=11.46 //y=7.4 //x2=11.545 //y2=7.4
r273 (  133 134 ) resistor r=25.4566 //w=0.357 //l=0.71 //layer=li \
 //thickness=0.1 //x=11.46 //y=7.4 //x2=10.75 //y2=7.4
r274 (  125 159 ) resistor r=4.11603 //w=0.68 //l=0.17 //layer=li \
 //thickness=0.1 //x=10.665 //y=7.23 //x2=10.665 //y2=7.4
r275 (  125 169 ) resistor r=56.4706 //w=0.187 //l=0.825 //layer=li \
 //thickness=0.1 //x=10.665 //y=7.23 //x2=10.665 //y2=6.405
r276 (  124 157 ) resistor r=5.4201 //w=0.34 //l=0.17 //layer=li \
 //thickness=0.1 //x=10.16 //y=7.4 //x2=9.99 //y2=7.4
r277 (  123 159 ) resistor r=2.94794 //w=0.34 //l=0.085 //layer=li \
 //thickness=0.1 //x=10.58 //y=7.4 //x2=10.665 //y2=7.4
r278 (  123 124 ) resistor r=15.0588 //w=0.357 //l=0.42 //layer=li \
 //thickness=0.1 //x=10.58 //y=7.4 //x2=10.16 //y2=7.4
r279 (  120 156 ) resistor r=2.94794 //w=0.34 //l=0.085 //layer=li \
 //thickness=0.1 //x=9.295 //y=7.4 //x2=9.21 //y2=7.4
r280 (  119 157 ) resistor r=5.4201 //w=0.34 //l=0.17 //layer=li \
 //thickness=0.1 //x=9.82 //y=7.4 //x2=9.99 //y2=7.4
r281 (  119 120 ) resistor r=18.8235 //w=0.357 //l=0.525 //layer=li \
 //thickness=0.1 //x=9.82 //y=7.4 //x2=9.295 //y2=7.4
r282 (  113 156 ) resistor r=4.11603 //w=0.68 //l=0.17 //layer=li \
 //thickness=0.1 //x=9.21 //y=7.23 //x2=9.21 //y2=7.4
r283 (  113 168 ) resistor r=33.1979 //w=0.187 //l=0.485 //layer=li \
 //thickness=0.1 //x=9.21 //y=7.23 //x2=9.21 //y2=6.745
r284 (  112 154 ) resistor r=2.94794 //w=0.34 //l=0.085 //layer=li \
 //thickness=0.1 //x=8.415 //y=7.4 //x2=8.33 //y2=7.4
r285 (  111 156 ) resistor r=2.94794 //w=0.34 //l=0.085 //layer=li \
 //thickness=0.1 //x=9.125 //y=7.4 //x2=9.21 //y2=7.4
r286 (  111 112 ) resistor r=25.4566 //w=0.357 //l=0.71 //layer=li \
 //thickness=0.1 //x=9.125 //y=7.4 //x2=8.415 //y2=7.4
r287 (  105 154 ) resistor r=4.11603 //w=0.68 //l=0.17 //layer=li \
 //thickness=0.1 //x=8.33 //y=7.23 //x2=8.33 //y2=7.4
r288 (  105 167 ) resistor r=33.1979 //w=0.187 //l=0.485 //layer=li \
 //thickness=0.1 //x=8.33 //y=7.23 //x2=8.33 //y2=6.745
r289 (  102 153 ) resistor r=2.94794 //w=0.34 //l=0.085 //layer=li \
 //thickness=0.1 //x=7.535 //y=7.4 //x2=7.45 //y2=7.4
r290 (  102 104 ) resistor r=21.6919 //w=0.357 //l=0.605 //layer=li \
 //thickness=0.1 //x=7.535 //y=7.4 //x2=8.14 //y2=7.4
r291 (  101 154 ) resistor r=2.94794 //w=0.34 //l=0.085 //layer=li \
 //thickness=0.1 //x=8.245 //y=7.4 //x2=8.33 //y2=7.4
r292 (  101 104 ) resistor r=3.76471 //w=0.357 //l=0.105 //layer=li \
 //thickness=0.1 //x=8.245 //y=7.4 //x2=8.14 //y2=7.4
r293 (  93 153 ) resistor r=4.11603 //w=0.68 //l=0.17 //layer=li \
 //thickness=0.1 //x=7.45 //y=7.23 //x2=7.45 //y2=7.4
r294 (  93 166 ) resistor r=56.4706 //w=0.187 //l=0.825 //layer=li \
 //thickness=0.1 //x=7.45 //y=7.23 //x2=7.45 //y2=6.405
r295 (  90 152 ) resistor r=5.4201 //w=0.34 //l=0.17 //layer=li \
 //thickness=0.1 //x=6.83 //y=7.4 //x2=6.66 //y2=7.4
r296 (  90 92 ) resistor r=7.17087 //w=0.357 //l=0.2 //layer=li \
 //thickness=0.1 //x=6.83 //y=7.4 //x2=7.03 //y2=7.4
r297 (  89 153 ) resistor r=2.94794 //w=0.34 //l=0.085 //layer=li \
 //thickness=0.1 //x=7.365 //y=7.4 //x2=7.45 //y2=7.4
r298 (  89 92 ) resistor r=12.0112 //w=0.357 //l=0.335 //layer=li \
 //thickness=0.1 //x=7.365 //y=7.4 //x2=7.03 //y2=7.4
r299 (  77 79 ) resistor r=39.7983 //w=0.357 //l=1.11 //layer=li \
 //thickness=0.1 //x=4.44 //y=7.4 //x2=5.55 //y2=7.4
r300 (  75 151 ) resistor r=5.4201 //w=0.34 //l=0.17 //layer=li \
 //thickness=0.1 //x=3.5 //y=7.4 //x2=3.33 //y2=7.4
r301 (  75 77 ) resistor r=33.7031 //w=0.357 //l=0.94 //layer=li \
 //thickness=0.1 //x=3.5 //y=7.4 //x2=4.44 //y2=7.4
r302 (  74 152 ) resistor r=5.4201 //w=0.34 //l=0.17 //layer=li \
 //thickness=0.1 //x=6.49 //y=7.4 //x2=6.66 //y2=7.4
r303 (  74 79 ) resistor r=33.7031 //w=0.357 //l=0.94 //layer=li \
 //thickness=0.1 //x=6.49 //y=7.4 //x2=5.55 //y2=7.4
r304 (  69 150 ) resistor r=2.94794 //w=0.34 //l=0.085 //layer=li \
 //thickness=0.1 //x=2.635 //y=7.4 //x2=2.55 //y2=7.4
r305 (  69 71 ) resistor r=11.6527 //w=0.357 //l=0.325 //layer=li \
 //thickness=0.1 //x=2.635 //y=7.4 //x2=2.96 //y2=7.4
r306 (  68 151 ) resistor r=5.4201 //w=0.34 //l=0.17 //layer=li \
 //thickness=0.1 //x=3.16 //y=7.4 //x2=3.33 //y2=7.4
r307 (  68 71 ) resistor r=7.17087 //w=0.357 //l=0.2 //layer=li \
 //thickness=0.1 //x=3.16 //y=7.4 //x2=2.96 //y2=7.4
r308 (  62 150 ) resistor r=4.11603 //w=0.68 //l=0.17 //layer=li \
 //thickness=0.1 //x=2.55 //y=7.23 //x2=2.55 //y2=7.4
r309 (  62 164 ) resistor r=33.1979 //w=0.187 //l=0.485 //layer=li \
 //thickness=0.1 //x=2.55 //y=7.23 //x2=2.55 //y2=6.745
r310 (  59 149 ) resistor r=2.94794 //w=0.34 //l=0.085 //layer=li \
 //thickness=0.1 //x=1.755 //y=7.4 //x2=1.67 //y2=7.4
r311 (  59 61 ) resistor r=3.40616 //w=0.357 //l=0.095 //layer=li \
 //thickness=0.1 //x=1.755 //y=7.4 //x2=1.85 //y2=7.4
r312 (  58 150 ) resistor r=2.94794 //w=0.34 //l=0.085 //layer=li \
 //thickness=0.1 //x=2.465 //y=7.4 //x2=2.55 //y2=7.4
r313 (  58 61 ) resistor r=22.0504 //w=0.357 //l=0.615 //layer=li \
 //thickness=0.1 //x=2.465 //y=7.4 //x2=1.85 //y2=7.4
r314 (  52 149 ) resistor r=4.11603 //w=0.68 //l=0.17 //layer=li \
 //thickness=0.1 //x=1.67 //y=7.23 //x2=1.67 //y2=7.4
r315 (  52 163 ) resistor r=33.1979 //w=0.187 //l=0.485 //layer=li \
 //thickness=0.1 //x=1.67 //y=7.23 //x2=1.67 //y2=6.745
r316 (  51 148 ) resistor r=2.94794 //w=0.34 //l=0.085 //layer=li \
 //thickness=0.1 //x=0.875 //y=7.4 //x2=0.79 //y2=7.4
r317 (  50 149 ) resistor r=2.94794 //w=0.34 //l=0.085 //layer=li \
 //thickness=0.1 //x=1.585 //y=7.4 //x2=1.67 //y2=7.4
r318 (  50 51 ) resistor r=25.4566 //w=0.357 //l=0.71 //layer=li \
 //thickness=0.1 //x=1.585 //y=7.4 //x2=0.875 //y2=7.4
r319 (  42 148 ) resistor r=4.11603 //w=0.68 //l=0.17 //layer=li \
 //thickness=0.1 //x=0.79 //y=7.23 //x2=0.79 //y2=7.4
r320 (  42 162 ) resistor r=56.4706 //w=0.187 //l=0.825 //layer=li \
 //thickness=0.1 //x=0.79 //y=7.23 //x2=0.79 //y2=6.405
r321 (  31 165 ) resistor r=9.3 //w=0.17 //l=0.17 //layer=mcon //count=1 \
 //x=4.56 //y=6.74 //x2=4.56 //y2=6.74
r322 (  25 161 ) resistor r=4.65 //w=0.17 //l=0.34 //layer=mcon //count=2 \
 //x=11.47 //y=7.4 //x2=11.47 //y2=7.4
r323 (  23 159 ) resistor r=3.1 //w=0.17 //l=0.51 //layer=mcon //count=3 \
 //x=10.73 //y=7.4 //x2=10.73 //y2=7.4
r324 (  23 25 ) resistor r=0.307309 //w=0.301 //l=0.74 //layer=m1 \
 //thickness=0.36 //x=10.73 //y=7.4 //x2=11.47 //y2=7.4
r325 (  21 156 ) resistor r=3.1 //w=0.17 //l=0.51 //layer=mcon //count=3 \
 //x=9.25 //y=7.4 //x2=9.25 //y2=7.4
r326 (  21 23 ) resistor r=0.614618 //w=0.301 //l=1.48 //layer=m1 \
 //thickness=0.36 //x=9.25 //y=7.4 //x2=10.73 //y2=7.4
r327 (  19 104 ) resistor r=3.1 //w=0.17 //l=0.51 //layer=mcon //count=3 \
 //x=8.14 //y=7.4 //x2=8.14 //y2=7.4
r328 (  19 21 ) resistor r=0.460963 //w=0.301 //l=1.11 //layer=m1 \
 //thickness=0.36 //x=8.14 //y=7.4 //x2=9.25 //y2=7.4
r329 (  17 92 ) resistor r=3.1 //w=0.17 //l=0.51 //layer=mcon //count=3 \
 //x=7.03 //y=7.4 //x2=7.03 //y2=7.4
r330 (  17 19 ) resistor r=0.460963 //w=0.301 //l=1.11 //layer=m1 \
 //thickness=0.36 //x=7.03 //y=7.4 //x2=8.14 //y2=7.4
r331 (  15 79 ) resistor r=3.1 //w=0.17 //l=0.51 //layer=mcon //count=3 \
 //x=5.55 //y=7.4 //x2=5.55 //y2=7.4
r332 (  15 17 ) resistor r=0.614618 //w=0.301 //l=1.48 //layer=m1 \
 //thickness=0.36 //x=5.55 //y=7.4 //x2=7.03 //y2=7.4
r333 (  13 29 ) resistor r=0.0287885 //w=0.34 //l=0.085 //layer=m1 \
 //thickness=0.36 //x=4.645 //y=7.4 //x2=4.56 //y2=7.4
r334 (  13 15 ) resistor r=0.375831 //w=0.301 //l=0.905 //layer=m1 \
 //thickness=0.36 //x=4.645 //y=7.4 //x2=5.55 //y2=7.4
r335 (  12 29 ) resistor r=0.0401957 //w=0.68 //l=0.17 //layer=m1 \
 //thickness=0.36 //x=4.56 //y=7.23 //x2=4.56 //y2=7.4
r336 (  11 31 ) resistor r=0.0723371 //w=0.218 //l=0.115 //layer=m1 \
 //thickness=0.36 //x=4.56 //y=6.855 //x2=4.56 //y2=6.74
r337 (  11 12 ) resistor r=0.357824 //w=0.131 //l=0.375 //layer=m1 \
 //thickness=0.36 //x=4.56 //y=6.855 //x2=4.56 //y2=7.23
r338 (  10 77 ) resistor r=3.1 //w=0.17 //l=0.51 //layer=mcon //count=3 \
 //x=4.44 //y=7.4 //x2=4.44 //y2=7.4
r339 (  8 71 ) resistor r=3.1 //w=0.17 //l=0.51 //layer=mcon //count=3 \
 //x=2.96 //y=7.4 //x2=2.96 //y2=7.4
r340 (  8 10 ) resistor r=0.614618 //w=0.301 //l=1.48 //layer=m1 \
 //thickness=0.36 //x=2.96 //y=7.4 //x2=4.44 //y2=7.4
r341 (  6 61 ) resistor r=3.1 //w=0.17 //l=0.51 //layer=mcon //count=3 \
 //x=1.85 //y=7.4 //x2=1.85 //y2=7.4
r342 (  6 8 ) resistor r=0.460963 //w=0.301 //l=1.11 //layer=m1 \
 //thickness=0.36 //x=1.85 //y=7.4 //x2=2.96 //y2=7.4
r343 (  3 148 ) resistor r=3.1 //w=0.17 //l=0.51 //layer=mcon //count=3 \
 //x=0.74 //y=7.4 //x2=0.74 //y2=7.4
r344 (  3 6 ) resistor r=0.460963 //w=0.301 //l=1.11 //layer=m1 \
 //thickness=0.36 //x=0.74 //y=7.4 //x2=1.85 //y2=7.4
r345 (  1 29 ) resistor r=0.0287885 //w=0.34 //l=0.085 //layer=m1 \
 //thickness=0.36 //x=4.475 //y=7.4 //x2=4.56 //y2=7.4
r346 (  1 10 ) resistor r=0.0145349 //w=0.301 //l=0.035 //layer=m1 \
 //thickness=0.36 //x=4.475 //y=7.4 //x2=4.44 //y2=7.4
ends PM_AOA4X1_PCELL\%noxref_4

subckt PM_AOA4X1_PCELL\%noxref_5 ( 4 7 8 11 16 20 21 22 23 24 25 26 30 32 35 \
 36 46 )
c96 ( 46 0 ) capacitor c=0.0682508f //x=1.11 //y=4.7
c97 ( 36 0 ) capacitor c=0.0318956f //x=1.445 //y=1.21
c98 ( 35 0 ) capacitor c=0.0186809f //x=1.445 //y=0.865
c99 ( 32 0 ) capacitor c=0.0141821f //x=1.29 //y=1.365
c100 ( 30 0 ) capacitor c=0.0158553f //x=1.29 //y=0.71
c101 ( 26 0 ) capacitor c=0.088055f //x=0.915 //y=1.915
c102 ( 25 0 ) capacitor c=0.0229235f //x=0.915 //y=1.52
c103 ( 24 0 ) capacitor c=0.0234359f //x=0.915 //y=1.21
c104 ( 23 0 ) capacitor c=0.0198759f //x=0.915 //y=0.865
c105 ( 22 0 ) capacitor c=0.110369f //x=1.45 //y=6.02
c106 ( 21 0 ) capacitor c=0.154619f //x=1.01 //y=6.02
c107 ( 16 0 ) capacitor c=8.13451e-19 //x=1.11 //y=4.7
c108 ( 11 0 ) capacitor c=7.85889e-19 //x=1.11 //y=2.08
c109 ( 8 0 ) capacitor c=0.10646f //x=1.112 //y=4.56
c110 ( 7 0 ) capacitor c=0.0113945f //x=1.11 //y=4.7
c111 ( 4 0 ) capacitor c=0.0108617f //x=1.11 //y=2.08
r112 (  44 46 ) resistor r=20.6867 //w=0.233 //l=0.1 //layer=ply \
 //thickness=0.18 //x=1.01 //y=4.7 //x2=1.11 //y2=4.7
r113 (  37 46 ) resistor r=70.3348 //w=0.233 //l=0.414367 //layer=ply \
 //thickness=0.18 //x=1.45 //y=4.865 //x2=1.11 //y2=4.7
r114 (  36 48 ) resistor r=45.1352 //w=0.168 //l=0.173853 //layer=ply \
 //thickness=0.18 //x=1.445 //y=1.21 //x2=1.405 //y2=1.365
r115 (  35 47 ) resistor r=45.1352 //w=0.168 //l=0.173853 //layer=ply \
 //thickness=0.18 //x=1.445 //y=0.865 //x2=1.405 //y2=0.71
r116 (  35 36 ) resistor r=176.904 //w=0.094 //l=0.345 //layer=ply \
 //thickness=0.18 //x=1.445 //y=0.865 //x2=1.445 //y2=1.21
r117 (  33 43 ) resistor r=10.701 //w=0.21 //l=0.115 //layer=ply \
 //thickness=0.18 //x=1.07 //y=1.365 //x2=0.955 //y2=1.365
r118 (  32 48 ) resistor r=5.52526 //w=0.168 //l=0.115 //layer=ply \
 //thickness=0.18 //x=1.29 //y=1.365 //x2=1.405 //y2=1.365
r119 (  31 42 ) resistor r=5.52526 //w=0.168 //l=0.115 //layer=ply \
 //thickness=0.18 //x=1.07 //y=0.71 //x2=0.955 //y2=0.71
r120 (  30 47 ) resistor r=5.52526 //w=0.168 //l=0.115 //layer=ply \
 //thickness=0.18 //x=1.29 //y=0.71 //x2=1.405 //y2=0.71
r121 (  30 31 ) resistor r=112.809 //w=0.094 //l=0.22 //layer=ply \
 //thickness=0.18 //x=1.29 //y=0.71 //x2=1.07 //y2=0.71
r122 (  27 44 ) resistor r=13.0941 //w=0.233 //l=0.165 //layer=ply \
 //thickness=0.18 //x=1.01 //y=4.865 //x2=1.01 //y2=4.7
r123 (  26 41 ) resistor r=34.8111 //w=0.27 //l=0.264953 //layer=ply \
 //thickness=0.18 //x=0.915 //y=1.915 //x2=1.11 //y2=2.08
r124 (  25 43 ) resistor r=39.5823 //w=0.21 //l=0.173853 //layer=ply \
 //thickness=0.18 //x=0.915 //y=1.52 //x2=0.955 //y2=1.365
r125 (  25 26 ) resistor r=202.543 //w=0.094 //l=0.395 //layer=ply \
 //thickness=0.18 //x=0.915 //y=1.52 //x2=0.915 //y2=1.915
r126 (  24 43 ) resistor r=39.5823 //w=0.21 //l=0.173853 //layer=ply \
 //thickness=0.18 //x=0.915 //y=1.21 //x2=0.955 //y2=1.365
r127 (  23 42 ) resistor r=45.1352 //w=0.168 //l=0.173853 //layer=ply \
 //thickness=0.18 //x=0.915 //y=0.865 //x2=0.955 //y2=0.71
r128 (  23 24 ) resistor r=176.904 //w=0.094 //l=0.345 //layer=ply \
 //thickness=0.18 //x=0.915 //y=0.865 //x2=0.915 //y2=1.21
r129 (  22 37 ) resistor r=592.245 //w=0.094 //l=1.155 //layer=ply \
 //thickness=0.18 //x=1.45 //y=6.02 //x2=1.45 //y2=4.865
r130 (  21 27 ) resistor r=592.245 //w=0.094 //l=1.155 //layer=ply \
 //thickness=0.18 //x=1.01 //y=6.02 //x2=1.01 //y2=4.865
r131 (  20 32 ) resistor r=56.4043 //w=0.094 //l=0.11 //layer=ply \
 //thickness=0.18 //x=1.18 //y=1.365 //x2=1.29 //y2=1.365
r132 (  20 33 ) resistor r=56.4043 //w=0.094 //l=0.11 //layer=ply \
 //thickness=0.18 //x=1.18 //y=1.365 //x2=1.07 //y2=1.365
r133 (  16 46 ) resistor r=152 //w=0.17 //l=0.17 //layer=licon //count=1 \
 //x=1.11 //y=4.7 //x2=1.11 //y2=4.7
r134 (  11 41 ) resistor r=152 //w=0.17 //l=0.17 //layer=licon //count=1 \
 //x=1.11 //y=2.08 //x2=1.11 //y2=2.08
r135 (  7 16 ) resistor r=9.3 //w=0.17 //l=0.17 //layer=mcon //count=1 \
 //x=1.11 //y=4.7 //x2=1.11 //y2=4.7
r136 (  7 8 ) resistor r=0.103207 //w=0.196 //l=0.14 //layer=m1 \
 //thickness=0.36 //x=1.112 //y=4.7 //x2=1.112 //y2=4.56
r137 (  4 11 ) resistor r=9.3 //w=0.17 //l=0.17 //layer=mcon //count=1 \
 //x=1.11 //y=2.08 //x2=1.11 //y2=2.08
r138 (  1 4 ) resistor r=0.0933015 //w=0.201 //l=0.125 //layer=m1 \
 //thickness=0.36 //x=1.11 //y=2.205 //x2=1.11 //y2=2.08
r139 (  1 8 ) resistor r=2.24714 //w=0.131 //l=2.355 //layer=m1 \
 //thickness=0.36 //x=1.11 //y=2.205 //x2=1.11 //y2=4.56
ends PM_AOA4X1_PCELL\%noxref_5

subckt PM_AOA4X1_PCELL\%noxref_6 ( 2 4 10 15 19 20 21 22 23 24 29 31 33 39 40 \
 42 43 46 )
c104 ( 46 0 ) capacitor c=0.0393541f //x=1.88 //y=4.7
c105 ( 43 0 ) capacitor c=0.0284095f //x=1.85 //y=1.915
c106 ( 42 0 ) capacitor c=0.0476356f //x=1.85 //y=2.08
c107 ( 40 0 ) capacitor c=0.0439708f //x=2.415 //y=1.25
c108 ( 39 0 ) capacitor c=0.0192582f //x=2.415 //y=0.905
c109 ( 33 0 ) capacitor c=0.0162526f //x=2.26 //y=1.405
c110 ( 31 0 ) capacitor c=0.0157807f //x=2.26 //y=0.75
c111 ( 29 0 ) capacitor c=0.0372668f //x=2.255 //y=4.79
c112 ( 24 0 ) capacitor c=0.0210762f //x=1.885 //y=1.56
c113 ( 23 0 ) capacitor c=0.0168511f //x=1.885 //y=1.25
c114 ( 22 0 ) capacitor c=0.0175485f //x=1.885 //y=0.905
c115 ( 21 0 ) capacitor c=0.155269f //x=2.33 //y=6.02
c116 ( 20 0 ) capacitor c=0.110375f //x=1.89 //y=6.02
c117 ( 15 0 ) capacitor c=8.9038e-19 //x=1.88 //y=4.7
c118 ( 10 0 ) capacitor c=7.72439e-19 //x=1.85 //y=2.08
c119 ( 4 0 ) capacitor c=0.00687137f //x=1.85 //y=2.08
c120 ( 2 0 ) capacitor c=0.0640231f //x=1.85 //y=4.555
r121 (  48 49 ) resistor r=32.4568 //w=0.214 //l=0.075 //layer=ply \
 //thickness=0.18 //x=1.88 //y=4.79 //x2=1.88 //y2=4.865
r122 (  46 48 ) resistor r=20.271 //w=0.214 //l=0.09 //layer=ply \
 //thickness=0.18 //x=1.88 //y=4.7 //x2=1.88 //y2=4.79
r123 (  42 43 ) resistor r=52.7279 //w=0.214 //l=0.165 //layer=ply \
 //thickness=0.18 //x=1.85 //y=2.08 //x2=1.85 //y2=1.915
r124 (  40 53 ) resistor r=45.1352 //w=0.168 //l=0.173853 //layer=ply \
 //thickness=0.18 //x=2.415 //y=1.25 //x2=2.375 //y2=1.405
r125 (  39 52 ) resistor r=45.1352 //w=0.168 //l=0.173853 //layer=ply \
 //thickness=0.18 //x=2.415 //y=0.905 //x2=2.375 //y2=0.75
r126 (  39 40 ) resistor r=176.904 //w=0.094 //l=0.345 //layer=ply \
 //thickness=0.18 //x=2.415 //y=0.905 //x2=2.415 //y2=1.25
r127 (  34 51 ) resistor r=10.701 //w=0.21 //l=0.115 //layer=ply \
 //thickness=0.18 //x=2.04 //y=1.405 //x2=1.925 //y2=1.405
r128 (  33 53 ) resistor r=5.52526 //w=0.168 //l=0.115 //layer=ply \
 //thickness=0.18 //x=2.26 //y=1.405 //x2=2.375 //y2=1.405
r129 (  32 50 ) resistor r=5.52526 //w=0.168 //l=0.115 //layer=ply \
 //thickness=0.18 //x=2.04 //y=0.75 //x2=1.925 //y2=0.75
r130 (  31 52 ) resistor r=5.52526 //w=0.168 //l=0.115 //layer=ply \
 //thickness=0.18 //x=2.26 //y=0.75 //x2=2.375 //y2=0.75
r131 (  31 32 ) resistor r=112.809 //w=0.094 //l=0.22 //layer=ply \
 //thickness=0.18 //x=2.26 //y=0.75 //x2=2.04 //y2=0.75
r132 (  30 48 ) resistor r=16.5046 //w=0.27 //l=0.135 //layer=ply \
 //thickness=0.18 //x=2.015 //y=4.79 //x2=1.88 //y2=4.79
r133 (  29 36 ) resistor r=26.9307 //w=0.15 //l=0.106066 //layer=ply \
 //thickness=0.18 //x=2.255 //y=4.79 //x2=2.33 //y2=4.865
r134 (  29 30 ) resistor r=123.064 //w=0.094 //l=0.24 //layer=ply \
 //thickness=0.18 //x=2.255 //y=4.79 //x2=2.015 //y2=4.79
r135 (  24 51 ) resistor r=39.5823 //w=0.21 //l=0.173853 //layer=ply \
 //thickness=0.18 //x=1.885 //y=1.56 //x2=1.925 //y2=1.405
r136 (  24 43 ) resistor r=182.032 //w=0.094 //l=0.355 //layer=ply \
 //thickness=0.18 //x=1.885 //y=1.56 //x2=1.885 //y2=1.915
r137 (  23 51 ) resistor r=39.5823 //w=0.21 //l=0.173853 //layer=ply \
 //thickness=0.18 //x=1.885 //y=1.25 //x2=1.925 //y2=1.405
r138 (  22 50 ) resistor r=45.1352 //w=0.168 //l=0.173853 //layer=ply \
 //thickness=0.18 //x=1.885 //y=0.905 //x2=1.925 //y2=0.75
r139 (  22 23 ) resistor r=176.904 //w=0.094 //l=0.345 //layer=ply \
 //thickness=0.18 //x=1.885 //y=0.905 //x2=1.885 //y2=1.25
r140 (  21 36 ) resistor r=592.245 //w=0.094 //l=1.155 //layer=ply \
 //thickness=0.18 //x=2.33 //y=6.02 //x2=2.33 //y2=4.865
r141 (  20 49 ) resistor r=592.245 //w=0.094 //l=1.155 //layer=ply \
 //thickness=0.18 //x=1.89 //y=6.02 //x2=1.89 //y2=4.865
r142 (  19 33 ) resistor r=56.4043 //w=0.094 //l=0.11 //layer=ply \
 //thickness=0.18 //x=2.15 //y=1.405 //x2=2.26 //y2=1.405
r143 (  19 34 ) resistor r=56.4043 //w=0.094 //l=0.11 //layer=ply \
 //thickness=0.18 //x=2.15 //y=1.405 //x2=2.04 //y2=1.405
r144 (  15 46 ) resistor r=152 //w=0.17 //l=0.17 //layer=licon //count=1 \
 //x=1.88 //y=4.7 //x2=1.88 //y2=4.7
r145 (  10 42 ) resistor r=152 //w=0.17 //l=0.17 //layer=licon //count=1 \
 //x=1.85 //y=2.08 //x2=1.85 //y2=2.08
r146 (  8 15 ) resistor r=9.3 //w=0.17 //l=0.17 //layer=mcon //count=1 \
 //x=1.88 //y=4.7 //x2=1.88 //y2=4.7
r147 (  4 10 ) resistor r=9.3 //w=0.17 //l=0.17 //layer=mcon //count=1 \
 //x=1.85 //y=2.08 //x2=1.85 //y2=2.08
r148 (  4 6 ) resistor r=0.0936408 //w=0.196 //l=0.125 //layer=m1 \
 //thickness=0.36 //x=1.852 //y=2.08 //x2=1.852 //y2=2.205
r149 (  2 8 ) resistor r=0.0878548 //w=0.228 //l=0.159295 //layer=m1 \
 //thickness=0.36 //x=1.85 //y=4.555 //x2=1.88 //y2=4.7
r150 (  2 6 ) resistor r=2.24237 //w=0.131 //l=2.35 //layer=m1 \
 //thickness=0.36 //x=1.85 //y=4.555 //x2=1.85 //y2=2.205
ends PM_AOA4X1_PCELL\%noxref_6

subckt PM_AOA4X1_PCELL\%noxref_7 ( 1 3 5 10 14 17 20 30 46 47 48 )
c94 ( 48 0 ) capacitor c=0.0348842f //x=5.735 //y=5.025
c95 ( 46 0 ) capacitor c=0.0118024f //x=3.985 //y=5.025
c96 ( 30 0 ) capacitor c=0.0302598f //x=5 //y=5.38
c97 ( 20 0 ) capacitor c=0.045655f //x=4.12 //y=5.38
c98 ( 17 0 ) capacitor c=0.0164155f //x=5.88 //y=6.74
c99 ( 14 0 ) capacitor c=0.00604334f //x=5 //y=6.74
c100 ( 10 0 ) capacitor c=0.0112437f //x=5 //y=5.21
c101 ( 5 0 ) capacitor c=0.012947f //x=4.12 //y=5.21
c102 ( 3 0 ) capacitor c=0.00694548f //x=5.75 //y=6.91
c103 ( 1 0 ) capacitor c=0.0131356f //x=4.88 //y=5.21
r104 (  37 47 ) resistor r=23.2727 //w=0.187 //l=0.34 //layer=li \
 //thickness=0.1 //x=5 //y=6.74 //x2=5 //y2=6.4
r105 (  30 47 ) resistor r=23.2727 //w=0.187 //l=0.34 //layer=li \
 //thickness=0.1 //x=5 //y=5.38 //x2=5 //y2=5.72
r106 (  20 46 ) resistor r=23.2727 //w=0.187 //l=0.34 //layer=li \
 //thickness=0.1 //x=4.12 //y=5.38 //x2=4.12 //y2=5.72
r107 (  17 48 ) resistor r=9.3 //w=0.17 //l=0.17 //layer=mcon //count=1 \
 //x=5.88 //y=6.74 //x2=5.88 //y2=6.74
r108 (  17 18 ) resistor r=0.0932018 //w=0.228 //l=0.17 //layer=m1 \
 //thickness=0.36 //x=5.872 //y=6.74 //x2=5.872 //y2=6.91
r109 (  14 37 ) resistor r=9.3 //w=0.17 //l=0.17 //layer=mcon //count=1 //x=5 \
 //y=6.74 //x2=5 //y2=6.74
r110 (  14 15 ) resistor r=0.0992991 //w=0.214 //l=0.17 //layer=m1 \
 //thickness=0.36 //x=5 //y=6.74 //x2=5 //y2=6.91
r111 (  12 30 ) resistor r=9.3 //w=0.17 //l=0.17 //layer=mcon //count=1 //x=5 \
 //y=5.38 //x2=5 //y2=5.38
r112 (  10 12 ) resistor r=0.097032 //w=0.219 //l=0.17 //layer=m1 \
 //thickness=0.36 //x=5 //y=5.21 //x2=5 //y2=5.38
r113 (  7 20 ) resistor r=9.3 //w=0.17 //l=0.17 //layer=mcon //count=1 \
 //x=4.12 //y=5.38 //x2=4.12 //y2=5.38
r114 (  5 7 ) resistor r=0.0997653 //w=0.213 //l=0.17 //layer=m1 \
 //thickness=0.36 //x=4.12 //y=5.21 //x2=4.12 //y2=5.38
r115 (  4 15 ) resistor r=0.0213909 //w=0.214 //l=0.115 //layer=m1 \
 //thickness=0.36 //x=5.115 //y=6.91 //x2=5 //y2=6.91
r116 (  3 18 ) resistor r=0.0251868 //w=0.228 //l=0.122 //layer=m1 \
 //thickness=0.36 //x=5.75 //y=6.91 //x2=5.872 //y2=6.91
r117 (  3 4 ) resistor r=0.605916 //w=0.131 //l=0.635 //layer=m1 \
 //thickness=0.36 //x=5.75 //y=6.91 //x2=5.115 //y2=6.91
r118 (  2 5 ) resistor r=0.0211096 //w=0.213 //l=0.115 //layer=m1 \
 //thickness=0.36 //x=4.235 //y=5.21 //x2=4.12 //y2=5.21
r119 (  1 10 ) resistor r=0.0227762 //w=0.219 //l=0.12 //layer=m1 \
 //thickness=0.36 //x=4.88 //y=5.21 //x2=5 //y2=5.21
r120 (  1 2 ) resistor r=0.615458 //w=0.131 //l=0.645 //layer=m1 \
 //thickness=0.36 //x=4.88 //y=5.21 //x2=4.235 //y2=5.21
ends PM_AOA4X1_PCELL\%noxref_7

subckt PM_AOA4X1_PCELL\%noxref_8 ( 4 8 9 12 17 21 22 23 24 25 26 31 33 35 41 \
 42 44 45 48 )
c119 ( 48 0 ) capacitor c=0.0404287f //x=5.215 //y=4.705
c120 ( 45 0 ) capacitor c=0.0292709f //x=5.18 //y=1.915
c121 ( 44 0 ) capacitor c=0.0468503f //x=5.18 //y=2.08
c122 ( 42 0 ) capacitor c=0.0237765f //x=5.745 //y=1.255
c123 ( 41 0 ) capacitor c=0.0191782f //x=5.745 //y=0.905
c124 ( 35 0 ) capacitor c=0.035988f //x=5.59 //y=1.405
c125 ( 33 0 ) capacitor c=0.0157803f //x=5.59 //y=0.75
c126 ( 31 0 ) capacitor c=0.036638f //x=5.585 //y=4.795
c127 ( 26 0 ) capacitor c=0.0206674f //x=5.215 //y=1.56
c128 ( 25 0 ) capacitor c=0.0169638f //x=5.215 //y=1.255
c129 ( 24 0 ) capacitor c=0.0185462f //x=5.215 //y=0.905
c130 ( 23 0 ) capacitor c=0.155887f //x=5.66 //y=6.025
c131 ( 22 0 ) capacitor c=0.110534f //x=5.22 //y=6.025
c132 ( 17 0 ) capacitor c=0.00113117f //x=5.215 //y=4.705
c133 ( 12 0 ) capacitor c=9.45497e-19 //x=5.18 //y=2.08
c134 ( 9 0 ) capacitor c=0.0570424f //x=5.215 //y=4.56
c135 ( 8 0 ) capacitor c=0.0061903f //x=5.215 //y=4.705
c136 ( 4 0 ) capacitor c=0.00573992f //x=5.18 //y=2.08
r137 (  50 51 ) resistor r=32.4568 //w=0.214 //l=0.075 //layer=ply \
 //thickness=0.18 //x=5.215 //y=4.795 //x2=5.215 //y2=4.87
r138 (  48 50 ) resistor r=20.271 //w=0.214 //l=0.09 //layer=ply \
 //thickness=0.18 //x=5.215 //y=4.705 //x2=5.215 //y2=4.795
r139 (  44 45 ) resistor r=52.7279 //w=0.214 //l=0.165 //layer=ply \
 //thickness=0.18 //x=5.18 //y=2.08 //x2=5.18 //y2=1.915
r140 (  42 55 ) resistor r=4.95774 //w=0.164 //l=0.112 //layer=ply \
 //thickness=0.18 //x=5.745 //y=1.255 //x2=5.745 //y2=1.367
r141 (  41 54 ) resistor r=45.1352 //w=0.168 //l=0.173853 //layer=ply \
 //thickness=0.18 //x=5.745 //y=0.905 //x2=5.705 //y2=0.75
r142 (  41 42 ) resistor r=179.468 //w=0.094 //l=0.35 //layer=ply \
 //thickness=0.18 //x=5.745 //y=0.905 //x2=5.745 //y2=1.255
r143 (  36 53 ) resistor r=10.8103 //w=0.211 //l=0.115 //layer=ply \
 //thickness=0.18 //x=5.37 //y=1.405 //x2=5.255 //y2=1.405
r144 (  35 55 ) resistor r=45.9962 //w=0.164 //l=0.17296 //layer=ply \
 //thickness=0.18 //x=5.59 //y=1.405 //x2=5.745 //y2=1.367
r145 (  34 52 ) resistor r=5.52526 //w=0.168 //l=0.115 //layer=ply \
 //thickness=0.18 //x=5.37 //y=0.75 //x2=5.255 //y2=0.75
r146 (  33 54 ) resistor r=5.52526 //w=0.168 //l=0.115 //layer=ply \
 //thickness=0.18 //x=5.59 //y=0.75 //x2=5.705 //y2=0.75
r147 (  33 34 ) resistor r=112.809 //w=0.094 //l=0.22 //layer=ply \
 //thickness=0.18 //x=5.59 //y=0.75 //x2=5.37 //y2=0.75
r148 (  32 50 ) resistor r=16.5046 //w=0.27 //l=0.135 //layer=ply \
 //thickness=0.18 //x=5.35 //y=4.795 //x2=5.215 //y2=4.795
r149 (  31 38 ) resistor r=26.9307 //w=0.15 //l=0.106066 //layer=ply \
 //thickness=0.18 //x=5.585 //y=4.795 //x2=5.66 //y2=4.87
r150 (  31 32 ) resistor r=120.5 //w=0.094 //l=0.235 //layer=ply \
 //thickness=0.18 //x=5.585 //y=4.795 //x2=5.35 //y2=4.795
r151 (  26 53 ) resistor r=39.5036 //w=0.211 //l=0.173853 //layer=ply \
 //thickness=0.18 //x=5.215 //y=1.56 //x2=5.255 //y2=1.405
r152 (  26 45 ) resistor r=182.032 //w=0.094 //l=0.355 //layer=ply \
 //thickness=0.18 //x=5.215 //y=1.56 //x2=5.215 //y2=1.915
r153 (  25 53 ) resistor r=38.3614 //w=0.211 //l=0.168819 //layer=ply \
 //thickness=0.18 //x=5.215 //y=1.255 //x2=5.255 //y2=1.405
r154 (  24 52 ) resistor r=45.1352 //w=0.168 //l=0.173853 //layer=ply \
 //thickness=0.18 //x=5.215 //y=0.905 //x2=5.255 //y2=0.75
r155 (  24 25 ) resistor r=179.468 //w=0.094 //l=0.35 //layer=ply \
 //thickness=0.18 //x=5.215 //y=0.905 //x2=5.215 //y2=1.255
r156 (  23 38 ) resistor r=592.245 //w=0.094 //l=1.155 //layer=ply \
 //thickness=0.18 //x=5.66 //y=6.025 //x2=5.66 //y2=4.87
r157 (  22 51 ) resistor r=592.245 //w=0.094 //l=1.155 //layer=ply \
 //thickness=0.18 //x=5.22 //y=6.025 //x2=5.22 //y2=4.87
r158 (  21 35 ) resistor r=56.4043 //w=0.094 //l=0.11 //layer=ply \
 //thickness=0.18 //x=5.48 //y=1.405 //x2=5.59 //y2=1.405
r159 (  21 36 ) resistor r=56.4043 //w=0.094 //l=0.11 //layer=ply \
 //thickness=0.18 //x=5.48 //y=1.405 //x2=5.37 //y2=1.405
r160 (  17 48 ) resistor r=152 //w=0.17 //l=0.17 //layer=licon //count=1 \
 //x=5.215 //y=4.705 //x2=5.215 //y2=4.705
r161 (  12 44 ) resistor r=152 //w=0.17 //l=0.17 //layer=licon //count=1 \
 //x=5.18 //y=2.08 //x2=5.18 //y2=2.08
r162 (  8 17 ) resistor r=9.3 //w=0.17 //l=0.17 //layer=mcon //count=1 \
 //x=5.215 //y=4.705 //x2=5.215 //y2=4.705
r163 (  8 9 ) resistor r=0.105739 //w=0.201 //l=0.145 //layer=m1 \
 //thickness=0.36 //x=5.215 //y=4.705 //x2=5.215 //y2=4.56
r164 (  6 9 ) resistor r=2.2376 //w=0.131 //l=2.345 //layer=m1 \
 //thickness=0.36 //x=5.18 //y=2.215 //x2=5.18 //y2=4.56
r165 (  4 12 ) resistor r=9.3 //w=0.17 //l=0.17 //layer=mcon //count=1 \
 //x=5.18 //y=2.08 //x2=5.18 //y2=2.08
r166 (  4 6 ) resistor r=0.0977888 //w=0.216 //l=0.135 //layer=m1 \
 //thickness=0.36 //x=5.177 //y=2.08 //x2=5.177 //y2=2.215
ends PM_AOA4X1_PCELL\%noxref_8

subckt PM_AOA4X1_PCELL\%noxref_9 ( 1 7 29 32 33 37 38 43 46 61 70 84 89 94 98 \
 116 121 125 137 147 148 155 162 163 164 165 )
c275 ( 165 0 ) capacitor c=0.0650084f //x=10.485 //y=0.37
c276 ( 164 0 ) capacitor c=0.00843555f //x=7.65 //y=0.865
c277 ( 163 0 ) capacitor c=0.0736846f //x=3.89 //y=0.365
c278 ( 162 0 ) capacitor c=0.00843555f //x=0.99 //y=0.865
c279 ( 155 0 ) capacitor c=0.237754f //x=11.59 //y=0
c280 ( 148 0 ) capacitor c=0.107349f //x=9.99 //y=0
c281 ( 147 0 ) capacitor c=0.112269f //x=6.66 //y=0
c282 ( 144 0 ) capacitor c=0.00591168f //x=5.965 //y=0
c283 ( 141 0 ) capacitor c=0.00591168f //x=4.995 //y=0
c284 ( 138 0 ) capacitor c=0.00591168f //x=4.025 //y=0
c285 ( 137 0 ) capacitor c=0.112646f //x=3.33 //y=0
c286 ( 128 0 ) capacitor c=0.00585268f //x=11.59 //y=0.45
c287 ( 125 0 ) capacitor c=0.00625302f //x=11.505 //y=0.535
c288 ( 124 0 ) capacitor c=0.00479851f //x=11.1 //y=0.45
c289 ( 121 0 ) capacitor c=0.00633238f //x=11.015 //y=0.535
c290 ( 116 0 ) capacitor c=0.00586769f //x=10.62 //y=0.45
c291 ( 113 0 ) capacitor c=0.0189275f //x=10.535 //y=0
c292 ( 98 0 ) capacitor c=0.123925f //x=9.82 //y=0
c293 ( 94 0 ) capacitor c=0.0219529f //x=6.49 //y=0
c294 ( 89 0 ) capacitor c=0.00739123f //x=5.965 //y=0.445
c295 ( 84 0 ) capacitor c=0.0152893f //x=5.88 //y=0.53
c296 ( 80 0 ) capacitor c=0.0253251f //x=5.88 //y=0
c297 ( 75 0 ) capacitor c=0.00726869f //x=4.995 //y=0.445
c298 ( 70 0 ) capacitor c=0.0165507f //x=4.91 //y=0.53
c299 ( 66 0 ) capacitor c=0.025309f //x=4.91 //y=0
c300 ( 61 0 ) capacitor c=0.00739123f //x=4.025 //y=0.445
c301 ( 58 0 ) capacitor c=0.0227441f //x=3.94 //y=0
c302 ( 46 0 ) capacitor c=0.183052f //x=0.74 //y=0
c303 ( 43 0 ) capacitor c=0.123925f //x=3.16 //y=0
c304 ( 40 0 ) capacitor c=0.0050875f //x=7.84 //y=0
c305 ( 38 0 ) capacitor c=0.0278993f //x=7.837 //y=0.825
c306 ( 37 0 ) capacitor c=0.0139353f //x=7.84 //y=0.955
c307 ( 35 0 ) capacitor c=0.0050875f //x=1.18 //y=0
c308 ( 33 0 ) capacitor c=0.0278993f //x=1.177 //y=0.825
c309 ( 32 0 ) capacitor c=0.0168135f //x=1.18 //y=0.955
c310 ( 29 0 ) capacitor c=0.160586f //x=11.47 //y=0
c311 ( 7 0 ) capacitor c=0.220529f //x=7.755 //y=0
c312 ( 1 0 ) capacitor c=0.0587616f //x=1.095 //y=0
r313 (  154 155 ) resistor r=4.30252 //w=0.357 //l=0.12 //layer=li \
 //thickness=0.1 //x=11.47 //y=0 //x2=11.59 //y2=0
r314 (  152 154 ) resistor r=13.2661 //w=0.357 //l=0.37 //layer=li \
 //thickness=0.1 //x=11.1 //y=0 //x2=11.47 //y2=0
r315 (  151 152 ) resistor r=13.2661 //w=0.357 //l=0.37 //layer=li \
 //thickness=0.1 //x=10.73 //y=0 //x2=11.1 //y2=0
r316 (  149 151 ) resistor r=3.94398 //w=0.357 //l=0.11 //layer=li \
 //thickness=0.1 //x=10.62 //y=0 //x2=10.73 //y2=0
r317 (  129 165 ) resistor r=5.4201 //w=0.17 //l=0.085 //layer=li \
 //thickness=0.1 //x=11.59 //y=0.62 //x2=11.59 //y2=0.535
r318 (  129 165 ) resistor r=41.4118 //w=0.187 //l=0.605 //layer=li \
 //thickness=0.1 //x=11.59 //y=0.62 //x2=11.59 //y2=1.225
r319 (  128 165 ) resistor r=5.4201 //w=0.17 //l=0.085 //layer=li \
 //thickness=0.1 //x=11.59 //y=0.45 //x2=11.59 //y2=0.535
r320 (  127 155 ) resistor r=5.03728 //w=0.34 //l=0.17 //layer=li \
 //thickness=0.1 //x=11.59 //y=0.17 //x2=11.59 //y2=0
r321 (  127 128 ) resistor r=19.1658 //w=0.187 //l=0.28 //layer=li \
 //thickness=0.1 //x=11.59 //y=0.17 //x2=11.59 //y2=0.45
r322 (  126 165 ) resistor r=5.4201 //w=0.17 //l=0.085 //layer=li \
 //thickness=0.1 //x=11.185 //y=0.535 //x2=11.1 //y2=0.535
r323 (  125 165 ) resistor r=1.40859 //w=0.34 //l=0.085 //layer=li \
 //thickness=0.1 //x=11.505 //y=0.535 //x2=11.59 //y2=0.535
r324 (  125 126 ) resistor r=21.9037 //w=0.187 //l=0.32 //layer=li \
 //thickness=0.1 //x=11.505 //y=0.535 //x2=11.185 //y2=0.535
r325 (  124 165 ) resistor r=1.40859 //w=0.34 //l=0.085 //layer=li \
 //thickness=0.1 //x=11.1 //y=0.45 //x2=11.1 //y2=0.535
r326 (  123 152 ) resistor r=5.03728 //w=0.34 //l=0.17 //layer=li \
 //thickness=0.1 //x=11.1 //y=0.17 //x2=11.1 //y2=0
r327 (  123 124 ) resistor r=19.1658 //w=0.187 //l=0.28 //layer=li \
 //thickness=0.1 //x=11.1 //y=0.17 //x2=11.1 //y2=0.45
r328 (  122 165 ) resistor r=1.40859 //w=0.34 //l=0.085 //layer=li \
 //thickness=0.1 //x=10.705 //y=0.535 //x2=10.62 //y2=0.535
r329 (  121 165 ) resistor r=5.4201 //w=0.17 //l=0.085 //layer=li \
 //thickness=0.1 //x=11.015 //y=0.535 //x2=11.1 //y2=0.535
r330 (  121 122 ) resistor r=21.2193 //w=0.187 //l=0.31 //layer=li \
 //thickness=0.1 //x=11.015 //y=0.535 //x2=10.705 //y2=0.535
r331 (  117 165 ) resistor r=5.4201 //w=0.17 //l=0.085 //layer=li \
 //thickness=0.1 //x=10.62 //y=0.62 //x2=10.62 //y2=0.535
r332 (  117 165 ) resistor r=41.4118 //w=0.187 //l=0.605 //layer=li \
 //thickness=0.1 //x=10.62 //y=0.62 //x2=10.62 //y2=1.225
r333 (  116 165 ) resistor r=5.4201 //w=0.17 //l=0.085 //layer=li \
 //thickness=0.1 //x=10.62 //y=0.45 //x2=10.62 //y2=0.535
r334 (  115 149 ) resistor r=5.03728 //w=0.34 //l=0.17 //layer=li \
 //thickness=0.1 //x=10.62 //y=0.17 //x2=10.62 //y2=0
r335 (  115 116 ) resistor r=19.1658 //w=0.187 //l=0.28 //layer=li \
 //thickness=0.1 //x=10.62 //y=0.17 //x2=10.62 //y2=0.45
r336 (  114 148 ) resistor r=5.4201 //w=0.34 //l=0.17 //layer=li \
 //thickness=0.1 //x=10.16 //y=0 //x2=9.99 //y2=0
r337 (  113 149 ) resistor r=3.04762 //w=0.357 //l=0.085 //layer=li \
 //thickness=0.1 //x=10.535 //y=0 //x2=10.62 //y2=0
r338 (  113 114 ) resistor r=13.4454 //w=0.357 //l=0.375 //layer=li \
 //thickness=0.1 //x=10.535 //y=0 //x2=10.16 //y2=0
r339 (  103 105 ) resistor r=39.7983 //w=0.357 //l=1.11 //layer=li \
 //thickness=0.1 //x=8.14 //y=0 //x2=9.25 //y2=0
r340 (  101 103 ) resistor r=39.7983 //w=0.357 //l=1.11 //layer=li \
 //thickness=0.1 //x=7.03 //y=0 //x2=8.14 //y2=0
r341 (  99 147 ) resistor r=5.4201 //w=0.34 //l=0.17 //layer=li \
 //thickness=0.1 //x=6.83 //y=0 //x2=6.66 //y2=0
r342 (  99 101 ) resistor r=7.17087 //w=0.357 //l=0.2 //layer=li \
 //thickness=0.1 //x=6.83 //y=0 //x2=7.03 //y2=0
r343 (  98 148 ) resistor r=5.4201 //w=0.34 //l=0.17 //layer=li \
 //thickness=0.1 //x=9.82 //y=0 //x2=9.99 //y2=0
r344 (  98 105 ) resistor r=20.437 //w=0.357 //l=0.57 //layer=li \
 //thickness=0.1 //x=9.82 //y=0 //x2=9.25 //y2=0
r345 (  95 144 ) resistor r=2.94794 //w=0.34 //l=0.085 //layer=li \
 //thickness=0.1 //x=6.05 //y=0 //x2=5.965 //y2=0
r346 (  94 147 ) resistor r=5.4201 //w=0.34 //l=0.17 //layer=li \
 //thickness=0.1 //x=6.49 //y=0 //x2=6.66 //y2=0
r347 (  94 95 ) resistor r=15.7759 //w=0.357 //l=0.44 //layer=li \
 //thickness=0.1 //x=6.49 //y=0 //x2=6.05 //y2=0
r348 (  90 163 ) resistor r=5.4201 //w=0.17 //l=0.085 //layer=li \
 //thickness=0.1 //x=5.965 //y=0.615 //x2=5.965 //y2=0.53
r349 (  90 163 ) resistor r=18.139 //w=0.187 //l=0.265 //layer=li \
 //thickness=0.1 //x=5.965 //y=0.615 //x2=5.965 //y2=0.88
r350 (  89 163 ) resistor r=5.4201 //w=0.17 //l=0.085 //layer=li \
 //thickness=0.1 //x=5.965 //y=0.445 //x2=5.965 //y2=0.53
r351 (  88 144 ) resistor r=4.11603 //w=0.68 //l=0.17 //layer=li \
 //thickness=0.1 //x=5.965 //y=0.17 //x2=5.965 //y2=0
r352 (  88 89 ) resistor r=18.8235 //w=0.187 //l=0.275 //layer=li \
 //thickness=0.1 //x=5.965 //y=0.17 //x2=5.965 //y2=0.445
r353 (  85 163 ) resistor r=6.4 //w=0.17 //l=0.085 //layer=li //thickness=0.1 \
 //x=5.08 //y=0.53 //x2=4.995 //y2=0.53
r354 (  85 163 ) resistor r=27.3797 //w=0.187 //l=0.4 //layer=li \
 //thickness=0.1 //x=5.08 //y=0.53 //x2=5.48 //y2=0.53
r355 (  84 163 ) resistor r=1.40859 //w=0.34 //l=0.085 //layer=li \
 //thickness=0.1 //x=5.88 //y=0.53 //x2=5.965 //y2=0.53
r356 (  84 163 ) resistor r=27.3797 //w=0.187 //l=0.4 //layer=li \
 //thickness=0.1 //x=5.88 //y=0.53 //x2=5.48 //y2=0.53
r357 (  81 141 ) resistor r=2.94794 //w=0.34 //l=0.085 //layer=li \
 //thickness=0.1 //x=5.08 //y=0 //x2=4.995 //y2=0
r358 (  81 83 ) resistor r=16.8515 //w=0.357 //l=0.47 //layer=li \
 //thickness=0.1 //x=5.08 //y=0 //x2=5.55 //y2=0
r359 (  80 144 ) resistor r=2.94794 //w=0.34 //l=0.085 //layer=li \
 //thickness=0.1 //x=5.88 //y=0 //x2=5.965 //y2=0
r360 (  80 83 ) resistor r=11.8319 //w=0.357 //l=0.33 //layer=li \
 //thickness=0.1 //x=5.88 //y=0 //x2=5.55 //y2=0
r361 (  76 163 ) resistor r=6.4 //w=0.17 //l=0.085 //layer=li //thickness=0.1 \
 //x=4.995 //y=0.615 //x2=4.995 //y2=0.53
r362 (  76 163 ) resistor r=18.139 //w=0.187 //l=0.265 //layer=li \
 //thickness=0.1 //x=4.995 //y=0.615 //x2=4.995 //y2=0.88
r363 (  75 163 ) resistor r=6.4 //w=0.17 //l=0.085 //layer=li //thickness=0.1 \
 //x=4.995 //y=0.445 //x2=4.995 //y2=0.53
r364 (  74 141 ) resistor r=4.11603 //w=0.68 //l=0.17 //layer=li \
 //thickness=0.1 //x=4.995 //y=0.17 //x2=4.995 //y2=0
r365 (  74 75 ) resistor r=18.8235 //w=0.187 //l=0.275 //layer=li \
 //thickness=0.1 //x=4.995 //y=0.17 //x2=4.995 //y2=0.445
r366 (  71 163 ) resistor r=1.40859 //w=0.34 //l=0.085 //layer=li \
 //thickness=0.1 //x=4.11 //y=0.53 //x2=4.025 //y2=0.53
r367 (  71 163 ) resistor r=27.3797 //w=0.187 //l=0.4 //layer=li \
 //thickness=0.1 //x=4.11 //y=0.53 //x2=4.51 //y2=0.53
r368 (  70 163 ) resistor r=6.4 //w=0.17 //l=0.085 //layer=li //thickness=0.1 \
 //x=4.91 //y=0.53 //x2=4.995 //y2=0.53
r369 (  70 163 ) resistor r=27.3797 //w=0.187 //l=0.4 //layer=li \
 //thickness=0.1 //x=4.91 //y=0.53 //x2=4.51 //y2=0.53
r370 (  67 138 ) resistor r=2.94794 //w=0.34 //l=0.085 //layer=li \
 //thickness=0.1 //x=4.11 //y=0 //x2=4.025 //y2=0
r371 (  67 69 ) resistor r=11.8319 //w=0.357 //l=0.33 //layer=li \
 //thickness=0.1 //x=4.11 //y=0 //x2=4.44 //y2=0
r372 (  66 141 ) resistor r=2.94794 //w=0.34 //l=0.085 //layer=li \
 //thickness=0.1 //x=4.91 //y=0 //x2=4.995 //y2=0
r373 (  66 69 ) resistor r=16.8515 //w=0.357 //l=0.47 //layer=li \
 //thickness=0.1 //x=4.91 //y=0 //x2=4.44 //y2=0
r374 (  62 163 ) resistor r=5.4201 //w=0.17 //l=0.085 //layer=li \
 //thickness=0.1 //x=4.025 //y=0.615 //x2=4.025 //y2=0.53
r375 (  62 163 ) resistor r=41.4118 //w=0.187 //l=0.605 //layer=li \
 //thickness=0.1 //x=4.025 //y=0.615 //x2=4.025 //y2=1.22
r376 (  61 163 ) resistor r=5.4201 //w=0.17 //l=0.085 //layer=li \
 //thickness=0.1 //x=4.025 //y=0.445 //x2=4.025 //y2=0.53
r377 (  60 138 ) resistor r=4.11603 //w=0.68 //l=0.17 //layer=li \
 //thickness=0.1 //x=4.025 //y=0.17 //x2=4.025 //y2=0
r378 (  60 61 ) resistor r=18.8235 //w=0.187 //l=0.275 //layer=li \
 //thickness=0.1 //x=4.025 //y=0.17 //x2=4.025 //y2=0.445
r379 (  59 137 ) resistor r=5.4201 //w=0.34 //l=0.17 //layer=li \
 //thickness=0.1 //x=3.5 //y=0 //x2=3.33 //y2=0
r380 (  58 138 ) resistor r=2.94794 //w=0.34 //l=0.085 //layer=li \
 //thickness=0.1 //x=3.94 //y=0 //x2=4.025 //y2=0
r381 (  58 59 ) resistor r=15.7759 //w=0.357 //l=0.44 //layer=li \
 //thickness=0.1 //x=3.94 //y=0 //x2=3.5 //y2=0
r382 (  48 50 ) resistor r=39.7983 //w=0.357 //l=1.11 //layer=li \
 //thickness=0.1 //x=1.85 //y=0 //x2=2.96 //y2=0
r383 (  46 48 ) resistor r=39.7983 //w=0.357 //l=1.11 //layer=li \
 //thickness=0.1 //x=0.74 //y=0 //x2=1.85 //y2=0
r384 (  43 137 ) resistor r=5.4201 //w=0.34 //l=0.17 //layer=li \
 //thickness=0.1 //x=3.16 //y=0 //x2=3.33 //y2=0
r385 (  43 50 ) resistor r=7.17087 //w=0.357 //l=0.2 //layer=li \
 //thickness=0.1 //x=3.16 //y=0 //x2=2.96 //y2=0
r386 (  37 164 ) resistor r=9.3 //w=0.17 //l=0.17 //layer=mcon //count=1 \
 //x=7.84 //y=0.955 //x2=7.84 //y2=0.955
r387 (  37 38 ) resistor r=0.0939994 //w=0.226 //l=0.13 //layer=m1 \
 //thickness=0.36 //x=7.837 //y=0.955 //x2=7.837 //y2=0.825
r388 (  32 162 ) resistor r=9.3 //w=0.17 //l=0.17 //layer=mcon //count=1 \
 //x=1.18 //y=0.955 //x2=1.18 //y2=0.955
r389 (  32 33 ) resistor r=0.0939994 //w=0.226 //l=0.13 //layer=m1 \
 //thickness=0.36 //x=1.177 //y=0.955 //x2=1.177 //y2=0.825
r390 (  29 154 ) resistor r=4.65 //w=0.17 //l=0.34 //layer=mcon //count=2 \
 //x=11.47 //y=0 //x2=11.47 //y2=0
r391 (  27 151 ) resistor r=3.1 //w=0.17 //l=0.51 //layer=mcon //count=3 \
 //x=10.73 //y=0 //x2=10.73 //y2=0
r392 (  27 29 ) resistor r=0.307309 //w=0.301 //l=0.74 //layer=m1 \
 //thickness=0.36 //x=10.73 //y=0 //x2=11.47 //y2=0
r393 (  25 105 ) resistor r=3.1 //w=0.17 //l=0.51 //layer=mcon //count=3 \
 //x=9.25 //y=0 //x2=9.25 //y2=0
r394 (  25 27 ) resistor r=0.614618 //w=0.301 //l=1.48 //layer=m1 \
 //thickness=0.36 //x=9.25 //y=0 //x2=10.73 //y2=0
r395 (  23 103 ) resistor r=3.1 //w=0.17 //l=0.51 //layer=mcon //count=3 \
 //x=8.14 //y=0 //x2=8.14 //y2=0
r396 (  23 25 ) resistor r=0.460963 //w=0.301 //l=1.11 //layer=m1 \
 //thickness=0.36 //x=8.14 //y=0 //x2=9.25 //y2=0
r397 (  21 40 ) resistor r=0.0287885 //w=0.34 //l=0.085 //layer=m1 \
 //thickness=0.36 //x=7.925 //y=0 //x2=7.84 //y2=0
r398 (  21 23 ) resistor r=0.0892857 //w=0.301 //l=0.215 //layer=m1 \
 //thickness=0.36 //x=7.925 //y=0 //x2=8.14 //y2=0
r399 (  19 40 ) resistor r=0.0401957 //w=0.68 //l=0.17 //layer=m1 \
 //thickness=0.36 //x=7.84 //y=0.17 //x2=7.84 //y2=0
r400 (  19 38 ) resistor r=0.625 //w=0.131 //l=0.655 //layer=m1 \
 //thickness=0.36 //x=7.84 //y=0.17 //x2=7.84 //y2=0.825
r401 (  18 101 ) resistor r=3.1 //w=0.17 //l=0.51 //layer=mcon //count=3 \
 //x=7.03 //y=0 //x2=7.03 //y2=0
r402 (  16 83 ) resistor r=3.1 //w=0.17 //l=0.51 //layer=mcon //count=3 \
 //x=5.55 //y=0 //x2=5.55 //y2=0
r403 (  16 18 ) resistor r=0.614618 //w=0.301 //l=1.48 //layer=m1 \
 //thickness=0.36 //x=5.55 //y=0 //x2=7.03 //y2=0
r404 (  14 69 ) resistor r=3.1 //w=0.17 //l=0.51 //layer=mcon //count=3 \
 //x=4.44 //y=0 //x2=4.44 //y2=0
r405 (  14 16 ) resistor r=0.460963 //w=0.301 //l=1.11 //layer=m1 \
 //thickness=0.36 //x=4.44 //y=0 //x2=5.55 //y2=0
r406 (  12 50 ) resistor r=3.1 //w=0.17 //l=0.51 //layer=mcon //count=3 \
 //x=2.96 //y=0 //x2=2.96 //y2=0
r407 (  12 14 ) resistor r=0.614618 //w=0.301 //l=1.48 //layer=m1 \
 //thickness=0.36 //x=2.96 //y=0 //x2=4.44 //y2=0
r408 (  10 48 ) resistor r=3.1 //w=0.17 //l=0.51 //layer=mcon //count=3 \
 //x=1.85 //y=0 //x2=1.85 //y2=0
r409 (  10 12 ) resistor r=0.460963 //w=0.301 //l=1.11 //layer=m1 \
 //thickness=0.36 //x=1.85 //y=0 //x2=2.96 //y2=0
r410 (  8 35 ) resistor r=0.0287885 //w=0.34 //l=0.085 //layer=m1 \
 //thickness=0.36 //x=1.265 //y=0 //x2=1.18 //y2=0
r411 (  8 10 ) resistor r=0.24294 //w=0.301 //l=0.585 //layer=m1 \
 //thickness=0.36 //x=1.265 //y=0 //x2=1.85 //y2=0
r412 (  7 40 ) resistor r=0.0287885 //w=0.34 //l=0.085 //layer=m1 \
 //thickness=0.36 //x=7.755 //y=0 //x2=7.84 //y2=0
r413 (  7 18 ) resistor r=0.30108 //w=0.301 //l=0.725 //layer=m1 \
 //thickness=0.36 //x=7.755 //y=0 //x2=7.03 //y2=0
r414 (  5 35 ) resistor r=0.0401957 //w=0.68 //l=0.17 //layer=m1 \
 //thickness=0.36 //x=1.18 //y=0.17 //x2=1.18 //y2=0
r415 (  5 33 ) resistor r=0.625 //w=0.131 //l=0.655 //layer=m1 \
 //thickness=0.36 //x=1.18 //y=0.17 //x2=1.18 //y2=0.825
r416 (  3 46 ) resistor r=3.1 //w=0.17 //l=0.51 //layer=mcon //count=3 \
 //x=0.74 //y=0 //x2=0.74 //y2=0
r417 (  1 35 ) resistor r=0.0287885 //w=0.34 //l=0.085 //layer=m1 \
 //thickness=0.36 //x=1.095 //y=0 //x2=1.18 //y2=0
r418 (  1 3 ) resistor r=0.147425 //w=0.301 //l=0.355 //layer=m1 \
 //thickness=0.36 //x=1.095 //y=0 //x2=0.74 //y2=0
ends PM_AOA4X1_PCELL\%noxref_9

subckt PM_AOA4X1_PCELL\%noxref_10 ( 2 4 10 15 19 20 21 22 23 24 29 31 33 39 40 \
 42 43 46 )
c109 ( 46 0 ) capacitor c=0.0393541f //x=8.54 //y=4.7
c110 ( 43 0 ) capacitor c=0.0284095f //x=8.51 //y=1.915
c111 ( 42 0 ) capacitor c=0.0476356f //x=8.51 //y=2.08
c112 ( 40 0 ) capacitor c=0.0439708f //x=9.075 //y=1.25
c113 ( 39 0 ) capacitor c=0.0192582f //x=9.075 //y=0.905
c114 ( 33 0 ) capacitor c=0.0162526f //x=8.92 //y=1.405
c115 ( 31 0 ) capacitor c=0.0157807f //x=8.92 //y=0.75
c116 ( 29 0 ) capacitor c=0.0373491f //x=8.915 //y=4.79
c117 ( 24 0 ) capacitor c=0.0210762f //x=8.545 //y=1.56
c118 ( 23 0 ) capacitor c=0.0168511f //x=8.545 //y=1.25
c119 ( 22 0 ) capacitor c=0.0175485f //x=8.545 //y=0.905
c120 ( 21 0 ) capacitor c=0.155269f //x=8.99 //y=6.02
c121 ( 20 0 ) capacitor c=0.110375f //x=8.55 //y=6.02
c122 ( 15 0 ) capacitor c=8.9038e-19 //x=8.54 //y=4.7
c123 ( 10 0 ) capacitor c=7.72439e-19 //x=8.51 //y=2.08
c124 ( 4 0 ) capacitor c=0.00687137f //x=8.51 //y=2.08
c125 ( 2 0 ) capacitor c=0.06199f //x=8.51 //y=4.555
r126 (  48 49 ) resistor r=32.4568 //w=0.214 //l=0.075 //layer=ply \
 //thickness=0.18 //x=8.54 //y=4.79 //x2=8.54 //y2=4.865
r127 (  46 48 ) resistor r=20.271 //w=0.214 //l=0.09 //layer=ply \
 //thickness=0.18 //x=8.54 //y=4.7 //x2=8.54 //y2=4.79
r128 (  42 43 ) resistor r=52.7279 //w=0.214 //l=0.165 //layer=ply \
 //thickness=0.18 //x=8.51 //y=2.08 //x2=8.51 //y2=1.915
r129 (  40 53 ) resistor r=45.1352 //w=0.168 //l=0.173853 //layer=ply \
 //thickness=0.18 //x=9.075 //y=1.25 //x2=9.035 //y2=1.405
r130 (  39 52 ) resistor r=45.1352 //w=0.168 //l=0.173853 //layer=ply \
 //thickness=0.18 //x=9.075 //y=0.905 //x2=9.035 //y2=0.75
r131 (  39 40 ) resistor r=176.904 //w=0.094 //l=0.345 //layer=ply \
 //thickness=0.18 //x=9.075 //y=0.905 //x2=9.075 //y2=1.25
r132 (  34 51 ) resistor r=10.701 //w=0.21 //l=0.115 //layer=ply \
 //thickness=0.18 //x=8.7 //y=1.405 //x2=8.585 //y2=1.405
r133 (  33 53 ) resistor r=5.52526 //w=0.168 //l=0.115 //layer=ply \
 //thickness=0.18 //x=8.92 //y=1.405 //x2=9.035 //y2=1.405
r134 (  32 50 ) resistor r=5.52526 //w=0.168 //l=0.115 //layer=ply \
 //thickness=0.18 //x=8.7 //y=0.75 //x2=8.585 //y2=0.75
r135 (  31 52 ) resistor r=5.52526 //w=0.168 //l=0.115 //layer=ply \
 //thickness=0.18 //x=8.92 //y=0.75 //x2=9.035 //y2=0.75
r136 (  31 32 ) resistor r=112.809 //w=0.094 //l=0.22 //layer=ply \
 //thickness=0.18 //x=8.92 //y=0.75 //x2=8.7 //y2=0.75
r137 (  30 48 ) resistor r=16.5046 //w=0.27 //l=0.135 //layer=ply \
 //thickness=0.18 //x=8.675 //y=4.79 //x2=8.54 //y2=4.79
r138 (  29 36 ) resistor r=26.9307 //w=0.15 //l=0.106066 //layer=ply \
 //thickness=0.18 //x=8.915 //y=4.79 //x2=8.99 //y2=4.865
r139 (  29 30 ) resistor r=123.064 //w=0.094 //l=0.24 //layer=ply \
 //thickness=0.18 //x=8.915 //y=4.79 //x2=8.675 //y2=4.79
r140 (  24 51 ) resistor r=39.5823 //w=0.21 //l=0.173853 //layer=ply \
 //thickness=0.18 //x=8.545 //y=1.56 //x2=8.585 //y2=1.405
r141 (  24 43 ) resistor r=182.032 //w=0.094 //l=0.355 //layer=ply \
 //thickness=0.18 //x=8.545 //y=1.56 //x2=8.545 //y2=1.915
r142 (  23 51 ) resistor r=39.5823 //w=0.21 //l=0.173853 //layer=ply \
 //thickness=0.18 //x=8.545 //y=1.25 //x2=8.585 //y2=1.405
r143 (  22 50 ) resistor r=45.1352 //w=0.168 //l=0.173853 //layer=ply \
 //thickness=0.18 //x=8.545 //y=0.905 //x2=8.585 //y2=0.75
r144 (  22 23 ) resistor r=176.904 //w=0.094 //l=0.345 //layer=ply \
 //thickness=0.18 //x=8.545 //y=0.905 //x2=8.545 //y2=1.25
r145 (  21 36 ) resistor r=592.245 //w=0.094 //l=1.155 //layer=ply \
 //thickness=0.18 //x=8.99 //y=6.02 //x2=8.99 //y2=4.865
r146 (  20 49 ) resistor r=592.245 //w=0.094 //l=1.155 //layer=ply \
 //thickness=0.18 //x=8.55 //y=6.02 //x2=8.55 //y2=4.865
r147 (  19 33 ) resistor r=56.4043 //w=0.094 //l=0.11 //layer=ply \
 //thickness=0.18 //x=8.81 //y=1.405 //x2=8.92 //y2=1.405
r148 (  19 34 ) resistor r=56.4043 //w=0.094 //l=0.11 //layer=ply \
 //thickness=0.18 //x=8.81 //y=1.405 //x2=8.7 //y2=1.405
r149 (  15 46 ) resistor r=152 //w=0.17 //l=0.17 //layer=licon //count=1 \
 //x=8.54 //y=4.7 //x2=8.54 //y2=4.7
r150 (  10 42 ) resistor r=152 //w=0.17 //l=0.17 //layer=licon //count=1 \
 //x=8.51 //y=2.08 //x2=8.51 //y2=2.08
r151 (  8 15 ) resistor r=9.3 //w=0.17 //l=0.17 //layer=mcon //count=1 \
 //x=8.54 //y=4.7 //x2=8.54 //y2=4.7
r152 (  4 10 ) resistor r=9.3 //w=0.17 //l=0.17 //layer=mcon //count=1 \
 //x=8.51 //y=2.08 //x2=8.51 //y2=2.08
r153 (  4 6 ) resistor r=0.0936408 //w=0.196 //l=0.125 //layer=m1 \
 //thickness=0.36 //x=8.512 //y=2.08 //x2=8.512 //y2=2.205
r154 (  2 8 ) resistor r=0.0878548 //w=0.228 //l=0.159295 //layer=m1 \
 //thickness=0.36 //x=8.51 //y=4.555 //x2=8.54 //y2=4.7
r155 (  2 6 ) resistor r=2.24237 //w=0.131 //l=2.35 //layer=m1 \
 //thickness=0.36 //x=8.51 //y=4.555 //x2=8.51 //y2=2.205
ends PM_AOA4X1_PCELL\%noxref_10

subckt PM_AOA4X1_PCELL\%noxref_11 ( 2 4 5 6 7 8 10 12 22 29 31 )
c80 ( 29 0 ) capacitor c=0.00869746f //x=10.915 //y=0.91
c81 ( 22 0 ) capacitor c=0.0262395f //x=11.105 //y=5.38
c82 ( 12 0 ) capacitor c=0.0191378f //x=11.1 //y=1.005
c83 ( 10 0 ) capacitor c=0.117157f //x=11.47 //y=4.875
c84 ( 8 0 ) capacitor c=0.00557311f //x=11.19 //y=4.96
c85 ( 7 0 ) capacitor c=0.00944012f //x=11.385 //y=4.96
c86 ( 6 0 ) capacitor c=0.00724565f //x=11.185 //y=1.84
c87 ( 5 0 ) capacitor c=0.0145753f //x=11.385 //y=1.84
c88 ( 4 0 ) capacitor c=0.0118345f //x=11.105 //y=5.24
c89 ( 2 0 ) capacitor c=0.0170096f //x=11.1 //y=1.755
r90 (  22 31 ) resistor r=23.615 //w=0.187 //l=0.345 //layer=li \
 //thickness=0.1 //x=11.105 //y=5.38 //x2=11.105 //y2=5.725
r91 (  15 22 ) resistor r=9.3 //w=0.17 //l=0.17 //layer=mcon //count=1 \
 //x=11.105 //y=5.38 //x2=11.105 //y2=5.38
r92 (  12 29 ) resistor r=9.3 //w=0.17 //l=0.17 //layer=mcon //count=1 \
 //x=11.1 //y=1.005 //x2=11.1 //y2=1.005
r93 (  9 10 ) resistor r=2.81489 //w=0.131 //l=2.95 //layer=m1 \
 //thickness=0.36 //x=11.47 //y=1.925 //x2=11.47 //y2=4.875
r94 (  7 10 ) resistor r=0.0698411 //w=0.17 //l=0.120208 //layer=m1 \
 //thickness=0.36 //x=11.385 //y=4.96 //x2=11.47 //y2=4.875
r95 (  7 8 ) resistor r=0.186069 //w=0.131 //l=0.195 //layer=m1 \
 //thickness=0.36 //x=11.385 //y=4.96 //x2=11.19 //y2=4.96
r96 (  5 9 ) resistor r=0.0698411 //w=0.17 //l=0.120208 //layer=m1 \
 //thickness=0.36 //x=11.385 //y=1.84 //x2=11.47 //y2=1.925
r97 (  5 6 ) resistor r=0.19084 //w=0.131 //l=0.2 //layer=m1 //thickness=0.36 \
 //x=11.385 //y=1.84 //x2=11.185 //y2=1.84
r98 (  4 15 ) resistor r=0.086672 //w=0.218 //l=0.14 //layer=m1 \
 //thickness=0.36 //x=11.105 //y=5.24 //x2=11.105 //y2=5.38
r99 (  3 8 ) resistor r=0.0698411 //w=0.17 //l=0.120208 //layer=m1 \
 //thickness=0.36 //x=11.105 //y=5.045 //x2=11.19 //y2=4.96
r100 (  3 4 ) resistor r=0.186069 //w=0.131 //l=0.195 //layer=m1 \
 //thickness=0.36 //x=11.105 //y=5.045 //x2=11.105 //y2=5.24
r101 (  2 6 ) resistor r=0.0698411 //w=0.17 //l=0.120208 //layer=m1 \
 //thickness=0.36 //x=11.1 //y=1.755 //x2=11.185 //y2=1.84
r102 (  1 12 ) resistor r=0.105739 //w=0.201 //l=0.145 //layer=m1 \
 //thickness=0.36 //x=11.1 //y=1.15 //x2=11.1 //y2=1.005
r103 (  1 2 ) resistor r=0.57729 //w=0.131 //l=0.605 //layer=m1 \
 //thickness=0.36 //x=11.1 //y=1.15 //x2=11.1 //y2=1.755
ends PM_AOA4X1_PCELL\%noxref_11

subckt PM_AOA4X1_PCELL\%noxref_12 ( 1 5 9 10 13 17 29 )
c61 ( 29 0 ) capacitor c=0.0672366f //x=0.56 //y=0.365
c62 ( 17 0 ) capacitor c=0.00709791f //x=2.635 //y=0.615
c63 ( 13 0 ) capacitor c=0.0157877f //x=2.55 //y=0.53
c64 ( 10 0 ) capacitor c=0.00963509f //x=1.665 //y=1.495
c65 ( 9 0 ) capacitor c=0.00770028f //x=1.665 //y=0.615
c66 ( 5 0 ) capacitor c=0.0246013f //x=1.58 //y=1.58
c67 ( 1 0 ) capacitor c=0.0115037f //x=0.695 //y=1.495
r68 (  17 29 ) resistor r=3.57586 //w=0.17 //l=0.125 //layer=li \
 //thickness=0.1 //x=2.635 //y=0.615 //x2=2.635 //y2=0.49
r69 (  17 29 ) resistor r=18.139 //w=0.187 //l=0.265 //layer=li \
 //thickness=0.1 //x=2.635 //y=0.615 //x2=2.635 //y2=0.88
r70 (  14 29 ) resistor r=3.57586 //w=0.17 //l=0.103078 //layer=li \
 //thickness=0.1 //x=1.75 //y=0.53 //x2=1.665 //y2=0.49
r71 (  14 29 ) resistor r=27.3797 //w=0.187 //l=0.4 //layer=li //thickness=0.1 \
 //x=1.75 //y=0.53 //x2=2.15 //y2=0.53
r72 (  13 29 ) resistor r=3.57586 //w=0.17 //l=0.103078 //layer=li \
 //thickness=0.1 //x=2.55 //y=0.53 //x2=2.635 //y2=0.49
r73 (  13 29 ) resistor r=27.3797 //w=0.187 //l=0.4 //layer=li //thickness=0.1 \
 //x=2.55 //y=0.53 //x2=2.15 //y2=0.53
r74 (  10 29 ) resistor r=3.57586 //w=0.17 //l=0.125 //layer=li \
 //thickness=0.1 //x=1.665 //y=1.495 //x2=1.665 //y2=1.62
r75 (  10 29 ) resistor r=42.0963 //w=0.187 //l=0.615 //layer=li \
 //thickness=0.1 //x=1.665 //y=1.495 //x2=1.665 //y2=0.88
r76 (  9 29 ) resistor r=3.57586 //w=0.17 //l=0.125 //layer=li //thickness=0.1 \
 //x=1.665 //y=0.615 //x2=1.665 //y2=0.49
r77 (  9 29 ) resistor r=18.139 //w=0.187 //l=0.265 //layer=li //thickness=0.1 \
 //x=1.665 //y=0.615 //x2=1.665 //y2=0.88
r78 (  6 29 ) resistor r=3.57586 //w=0.17 //l=0.103078 //layer=li \
 //thickness=0.1 //x=0.78 //y=1.58 //x2=0.695 //y2=1.62
r79 (  6 29 ) resistor r=27.3797 //w=0.187 //l=0.4 //layer=li //thickness=0.1 \
 //x=0.78 //y=1.58 //x2=1.18 //y2=1.58
r80 (  5 29 ) resistor r=3.57586 //w=0.17 //l=0.103078 //layer=li \
 //thickness=0.1 //x=1.58 //y=1.58 //x2=1.665 //y2=1.62
r81 (  5 29 ) resistor r=27.3797 //w=0.187 //l=0.4 //layer=li //thickness=0.1 \
 //x=1.58 //y=1.58 //x2=1.18 //y2=1.58
r82 (  1 29 ) resistor r=3.57586 //w=0.17 //l=0.125 //layer=li //thickness=0.1 \
 //x=0.695 //y=1.495 //x2=0.695 //y2=1.62
r83 (  1 29 ) resistor r=42.0963 //w=0.187 //l=0.615 //layer=li \
 //thickness=0.1 //x=0.695 //y=1.495 //x2=0.695 //y2=0.88
ends PM_AOA4X1_PCELL\%noxref_12

subckt PM_AOA4X1_PCELL\%noxref_13 ( 1 5 9 10 13 17 29 )
c66 ( 29 0 ) capacitor c=0.0661664f //x=7.22 //y=0.365
c67 ( 17 0 ) capacitor c=0.00709791f //x=9.295 //y=0.615
c68 ( 13 0 ) capacitor c=0.0157877f //x=9.21 //y=0.53
c69 ( 10 0 ) capacitor c=0.00962197f //x=8.325 //y=1.495
c70 ( 9 0 ) capacitor c=0.00770028f //x=8.325 //y=0.615
c71 ( 5 0 ) capacitor c=0.0229059f //x=8.24 //y=1.58
c72 ( 1 0 ) capacitor c=0.00776684f //x=7.355 //y=1.495
r73 (  17 29 ) resistor r=3.57586 //w=0.17 //l=0.125 //layer=li \
 //thickness=0.1 //x=9.295 //y=0.615 //x2=9.295 //y2=0.49
r74 (  17 29 ) resistor r=18.139 //w=0.187 //l=0.265 //layer=li \
 //thickness=0.1 //x=9.295 //y=0.615 //x2=9.295 //y2=0.88
r75 (  14 29 ) resistor r=3.57586 //w=0.17 //l=0.103078 //layer=li \
 //thickness=0.1 //x=8.41 //y=0.53 //x2=8.325 //y2=0.49
r76 (  14 29 ) resistor r=27.3797 //w=0.187 //l=0.4 //layer=li //thickness=0.1 \
 //x=8.41 //y=0.53 //x2=8.81 //y2=0.53
r77 (  13 29 ) resistor r=3.57586 //w=0.17 //l=0.103078 //layer=li \
 //thickness=0.1 //x=9.21 //y=0.53 //x2=9.295 //y2=0.49
r78 (  13 29 ) resistor r=27.3797 //w=0.187 //l=0.4 //layer=li //thickness=0.1 \
 //x=9.21 //y=0.53 //x2=8.81 //y2=0.53
r79 (  10 29 ) resistor r=3.57586 //w=0.17 //l=0.125 //layer=li \
 //thickness=0.1 //x=8.325 //y=1.495 //x2=8.325 //y2=1.62
r80 (  10 29 ) resistor r=42.0963 //w=0.187 //l=0.615 //layer=li \
 //thickness=0.1 //x=8.325 //y=1.495 //x2=8.325 //y2=0.88
r81 (  9 29 ) resistor r=3.57586 //w=0.17 //l=0.125 //layer=li //thickness=0.1 \
 //x=8.325 //y=0.615 //x2=8.325 //y2=0.49
r82 (  9 29 ) resistor r=18.139 //w=0.187 //l=0.265 //layer=li //thickness=0.1 \
 //x=8.325 //y=0.615 //x2=8.325 //y2=0.88
r83 (  6 29 ) resistor r=3.57586 //w=0.17 //l=0.103078 //layer=li \
 //thickness=0.1 //x=7.44 //y=1.58 //x2=7.355 //y2=1.62
r84 (  6 29 ) resistor r=27.3797 //w=0.187 //l=0.4 //layer=li //thickness=0.1 \
 //x=7.44 //y=1.58 //x2=7.84 //y2=1.58
r85 (  5 29 ) resistor r=3.57586 //w=0.17 //l=0.103078 //layer=li \
 //thickness=0.1 //x=8.24 //y=1.58 //x2=8.325 //y2=1.62
r86 (  5 29 ) resistor r=27.3797 //w=0.187 //l=0.4 //layer=li //thickness=0.1 \
 //x=8.24 //y=1.58 //x2=7.84 //y2=1.58
r87 (  1 29 ) resistor r=3.57586 //w=0.17 //l=0.125 //layer=li //thickness=0.1 \
 //x=7.355 //y=1.495 //x2=7.355 //y2=1.62
r88 (  1 29 ) resistor r=42.0963 //w=0.187 //l=0.615 //layer=li \
 //thickness=0.1 //x=7.355 //y=1.495 //x2=7.355 //y2=0.88
ends PM_AOA4X1_PCELL\%noxref_13
