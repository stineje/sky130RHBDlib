// File: OR2X1.spi.pex
// Created: Tue Apr 29 10:44:03 2025
// Program "Calibre xRC"
// Version "v2023.2_27.15"
// Nominal Temperature: 30C
// Circuit Temperature: 30C
//
simulator lang=spectre
subckt PM_OR2X1\%GND ( 1 13 25 29 37 41 49 55 63 67 78 81 100 112 113 )
c74 ( 113 0 ) capacitor c=0.0600351f //x=4.315 //y=0.55
c75 ( 112 0 ) capacitor c=0.0737063f //x=1.05 //y=0.545
c76 ( 100 0 ) capacitor c=0.0993634f //x=3.82 //y=0.175
c77 ( 81 0 ) capacitor c=0.221616f //x=1.185 //y=0.175
c78 ( 78 0 ) capacitor c=0.217003f //x=5.67 //y=0.18
c79 ( 76 0 ) capacitor c=0.036681f //x=5.505 //y=0.175
c80 ( 70 0 ) capacitor c=0.00587411f //x=5.42 //y=0.63
c81 ( 67 0 ) capacitor c=0.00542565f //x=5.335 //y=0.715
c82 ( 66 0 ) capacitor c=0.00479856f //x=4.935 //y=0.63
c83 ( 63 0 ) capacitor c=0.0068422f //x=4.85 //y=0.715
c84 ( 58 0 ) capacitor c=0.00592191f //x=4.45 //y=0.63
c85 ( 55 0 ) capacitor c=0.0166308f //x=4.365 //y=0.175
c86 ( 50 0 ) capacitor c=0.0671134f //x=3.21 //y=0.175
c87 ( 49 0 ) capacitor c=0.0197476f //x=3.65 //y=0.175
c88 ( 44 0 ) capacitor c=0.00609805f //x=3.125 //y=0.625
c89 ( 41 0 ) capacitor c=0.00508472f //x=3.04 //y=0.71
c90 ( 40 0 ) capacitor c=0.00468234f //x=2.64 //y=0.625
c91 ( 37 0 ) capacitor c=0.00556167f //x=2.555 //y=0.71
c92 ( 32 0 ) capacitor c=0.00468234f //x=2.155 //y=0.625
c93 ( 29 0 ) capacitor c=0.00556167f //x=2.07 //y=0.71
c94 ( 28 0 ) capacitor c=0.00468234f //x=1.67 //y=0.625
c95 ( 25 0 ) capacitor c=0.00709098f //x=1.585 //y=0.71
c96 ( 20 0 ) capacitor c=0.00609805f //x=1.185 //y=0.625
c97 ( 13 0 ) capacitor c=0.260324f //x=5.67 //y=0.18
r98 (  104 105 ) resistor r=16.9155 //w=0.367 //l=0.485 //layer=li \
 //thickness=0.1 //x=4.935 //y=0.175 //x2=5.42 //y2=0.175
r99 (  103 104 ) resistor r=0.174387 //w=0.367 //l=0.005 //layer=li \
 //thickness=0.1 //x=4.93 //y=0.175 //x2=4.935 //y2=0.175
r100 (  101 103 ) resistor r=16.7411 //w=0.367 //l=0.48 //layer=li \
 //thickness=0.1 //x=4.45 //y=0.175 //x2=4.93 //y2=0.175
r101 (  88 89 ) resistor r=16.9155 //w=0.367 //l=0.485 //layer=li \
 //thickness=0.1 //x=2.64 //y=0.175 //x2=3.125 //y2=0.175
r102 (  87 88 ) resistor r=10.4632 //w=0.367 //l=0.3 //layer=li \
 //thickness=0.1 //x=2.34 //y=0.175 //x2=2.64 //y2=0.175
r103 (  85 87 ) resistor r=6.45232 //w=0.367 //l=0.185 //layer=li \
 //thickness=0.1 //x=2.155 //y=0.175 //x2=2.34 //y2=0.175
r104 (  84 85 ) resistor r=16.9155 //w=0.367 //l=0.485 //layer=li \
 //thickness=0.1 //x=1.67 //y=0.175 //x2=2.155 //y2=0.175
r105 (  83 84 ) resistor r=15.346 //w=0.367 //l=0.44 //layer=li \
 //thickness=0.1 //x=1.23 //y=0.175 //x2=1.67 //y2=0.175
r106 (  81 83 ) resistor r=1.56948 //w=0.367 //l=0.045 //layer=li \
 //thickness=0.1 //x=1.185 //y=0.175 //x2=1.23 //y2=0.175
r107 (  76 105 ) resistor r=2.96458 //w=0.367 //l=0.085 //layer=li \
 //thickness=0.1 //x=5.505 //y=0.175 //x2=5.42 //y2=0.175
r108 (  76 78 ) resistor r=5.75477 //w=0.367 //l=0.165 //layer=li \
 //thickness=0.1 //x=5.505 //y=0.175 //x2=5.67 //y2=0.175
r109 (  71 113 ) resistor r=5.4201 //w=0.17 //l=0.085 //layer=li \
 //thickness=0.1 //x=5.42 //y=0.8 //x2=5.42 //y2=0.715
r110 (  71 113 ) resistor r=41.4118 //w=0.187 //l=0.605 //layer=li \
 //thickness=0.1 //x=5.42 //y=0.8 //x2=5.42 //y2=1.405
r111 (  70 113 ) resistor r=5.4201 //w=0.17 //l=0.085 //layer=li \
 //thickness=0.1 //x=5.42 //y=0.63 //x2=5.42 //y2=0.715
r112 (  69 105 ) resistor r=5.21862 //w=0.35 //l=0.175 //layer=li \
 //thickness=0.1 //x=5.42 //y=0.35 //x2=5.42 //y2=0.175
r113 (  69 70 ) resistor r=19.1658 //w=0.187 //l=0.28 //layer=li \
 //thickness=0.1 //x=5.42 //y=0.35 //x2=5.42 //y2=0.63
r114 (  68 113 ) resistor r=5.4201 //w=0.17 //l=0.085 //layer=li \
 //thickness=0.1 //x=5.02 //y=0.715 //x2=4.935 //y2=0.715
r115 (  67 113 ) resistor r=1.40859 //w=0.34 //l=0.085 //layer=li \
 //thickness=0.1 //x=5.335 //y=0.715 //x2=5.42 //y2=0.715
r116 (  67 68 ) resistor r=21.5615 //w=0.187 //l=0.315 //layer=li \
 //thickness=0.1 //x=5.335 //y=0.715 //x2=5.02 //y2=0.715
r117 (  66 113 ) resistor r=1.40859 //w=0.34 //l=0.085 //layer=li \
 //thickness=0.1 //x=4.935 //y=0.63 //x2=4.935 //y2=0.715
r118 (  65 104 ) resistor r=5.21862 //w=0.35 //l=0.175 //layer=li \
 //thickness=0.1 //x=4.935 //y=0.35 //x2=4.935 //y2=0.175
r119 (  65 66 ) resistor r=19.1658 //w=0.187 //l=0.28 //layer=li \
 //thickness=0.1 //x=4.935 //y=0.35 //x2=4.935 //y2=0.63
r120 (  64 113 ) resistor r=1.40859 //w=0.34 //l=0.085 //layer=li \
 //thickness=0.1 //x=4.535 //y=0.715 //x2=4.45 //y2=0.715
r121 (  63 113 ) resistor r=5.4201 //w=0.17 //l=0.085 //layer=li \
 //thickness=0.1 //x=4.85 //y=0.715 //x2=4.935 //y2=0.715
r122 (  63 64 ) resistor r=21.5615 //w=0.187 //l=0.315 //layer=li \
 //thickness=0.1 //x=4.85 //y=0.715 //x2=4.535 //y2=0.715
r123 (  59 113 ) resistor r=5.4201 //w=0.17 //l=0.085 //layer=li \
 //thickness=0.1 //x=4.45 //y=0.8 //x2=4.45 //y2=0.715
r124 (  59 113 ) resistor r=41.4118 //w=0.187 //l=0.605 //layer=li \
 //thickness=0.1 //x=4.45 //y=0.8 //x2=4.45 //y2=1.405
r125 (  58 113 ) resistor r=5.4201 //w=0.17 //l=0.085 //layer=li \
 //thickness=0.1 //x=4.45 //y=0.63 //x2=4.45 //y2=0.715
r126 (  57 101 ) resistor r=5.21862 //w=0.35 //l=0.175 //layer=li \
 //thickness=0.1 //x=4.45 //y=0.35 //x2=4.45 //y2=0.175
r127 (  57 58 ) resistor r=19.1658 //w=0.187 //l=0.28 //layer=li \
 //thickness=0.1 //x=4.45 //y=0.35 //x2=4.45 //y2=0.63
r128 (  56 100 ) resistor r=5.29055 //w=0.35 //l=0.17 //layer=li \
 //thickness=0.1 //x=3.99 //y=0.175 //x2=3.82 //y2=0.175
r129 (  55 101 ) resistor r=2.96458 //w=0.367 //l=0.085 //layer=li \
 //thickness=0.1 //x=4.365 //y=0.175 //x2=4.45 //y2=0.175
r130 (  55 56 ) resistor r=13.079 //w=0.367 //l=0.375 //layer=li \
 //thickness=0.1 //x=4.365 //y=0.175 //x2=3.99 //y2=0.175
r131 (  50 89 ) resistor r=2.96458 //w=0.367 //l=0.085 //layer=li \
 //thickness=0.1 //x=3.21 //y=0.175 //x2=3.125 //y2=0.175
r132 (  50 52 ) resistor r=8.37057 //w=0.367 //l=0.24 //layer=li \
 //thickness=0.1 //x=3.21 //y=0.175 //x2=3.45 //y2=0.175
r133 (  49 100 ) resistor r=5.29055 //w=0.35 //l=0.17 //layer=li \
 //thickness=0.1 //x=3.65 //y=0.175 //x2=3.82 //y2=0.175
r134 (  49 52 ) resistor r=6.97548 //w=0.367 //l=0.2 //layer=li \
 //thickness=0.1 //x=3.65 //y=0.175 //x2=3.45 //y2=0.175
r135 (  45 112 ) resistor r=5.4201 //w=0.17 //l=0.085 //layer=li \
 //thickness=0.1 //x=3.125 //y=0.795 //x2=3.125 //y2=0.71
r136 (  45 112 ) resistor r=18.139 //w=0.187 //l=0.265 //layer=li \
 //thickness=0.1 //x=3.125 //y=0.795 //x2=3.125 //y2=1.06
r137 (  44 112 ) resistor r=5.4201 //w=0.17 //l=0.085 //layer=li \
 //thickness=0.1 //x=3.125 //y=0.625 //x2=3.125 //y2=0.71
r138 (  43 89 ) resistor r=5.21862 //w=0.35 //l=0.175 //layer=li \
 //thickness=0.1 //x=3.125 //y=0.35 //x2=3.125 //y2=0.175
r139 (  43 44 ) resistor r=18.8235 //w=0.187 //l=0.275 //layer=li \
 //thickness=0.1 //x=3.125 //y=0.35 //x2=3.125 //y2=0.625
r140 (  42 112 ) resistor r=5.4201 //w=0.17 //l=0.085 //layer=li \
 //thickness=0.1 //x=2.725 //y=0.71 //x2=2.64 //y2=0.71
r141 (  41 112 ) resistor r=1.40859 //w=0.34 //l=0.085 //layer=li \
 //thickness=0.1 //x=3.04 //y=0.71 //x2=3.125 //y2=0.71
r142 (  41 42 ) resistor r=21.5615 //w=0.187 //l=0.315 //layer=li \
 //thickness=0.1 //x=3.04 //y=0.71 //x2=2.725 //y2=0.71
r143 (  40 112 ) resistor r=1.40859 //w=0.34 //l=0.085 //layer=li \
 //thickness=0.1 //x=2.64 //y=0.625 //x2=2.64 //y2=0.71
r144 (  39 88 ) resistor r=5.21862 //w=0.35 //l=0.175 //layer=li \
 //thickness=0.1 //x=2.64 //y=0.35 //x2=2.64 //y2=0.175
r145 (  39 40 ) resistor r=18.8235 //w=0.187 //l=0.275 //layer=li \
 //thickness=0.1 //x=2.64 //y=0.35 //x2=2.64 //y2=0.625
r146 (  38 112 ) resistor r=6.4 //w=0.17 //l=0.085 //layer=li //thickness=0.1 \
 //x=2.24 //y=0.71 //x2=2.155 //y2=0.71
r147 (  37 112 ) resistor r=5.4201 //w=0.17 //l=0.085 //layer=li \
 //thickness=0.1 //x=2.555 //y=0.71 //x2=2.64 //y2=0.71
r148 (  37 38 ) resistor r=21.5615 //w=0.187 //l=0.315 //layer=li \
 //thickness=0.1 //x=2.555 //y=0.71 //x2=2.24 //y2=0.71
r149 (  33 112 ) resistor r=6.4 //w=0.17 //l=0.085 //layer=li //thickness=0.1 \
 //x=2.155 //y=0.795 //x2=2.155 //y2=0.71
r150 (  33 112 ) resistor r=18.139 //w=0.187 //l=0.265 //layer=li \
 //thickness=0.1 //x=2.155 //y=0.795 //x2=2.155 //y2=1.06
r151 (  32 112 ) resistor r=6.4 //w=0.17 //l=0.085 //layer=li //thickness=0.1 \
 //x=2.155 //y=0.625 //x2=2.155 //y2=0.71
r152 (  31 85 ) resistor r=5.21862 //w=0.35 //l=0.175 //layer=li \
 //thickness=0.1 //x=2.155 //y=0.35 //x2=2.155 //y2=0.175
r153 (  31 32 ) resistor r=18.8235 //w=0.187 //l=0.275 //layer=li \
 //thickness=0.1 //x=2.155 //y=0.35 //x2=2.155 //y2=0.625
r154 (  30 112 ) resistor r=5.4201 //w=0.17 //l=0.085 //layer=li \
 //thickness=0.1 //x=1.755 //y=0.71 //x2=1.67 //y2=0.71
r155 (  29 112 ) resistor r=6.4 //w=0.17 //l=0.085 //layer=li //thickness=0.1 \
 //x=2.07 //y=0.71 //x2=2.155 //y2=0.71
r156 (  29 30 ) resistor r=21.5615 //w=0.187 //l=0.315 //layer=li \
 //thickness=0.1 //x=2.07 //y=0.71 //x2=1.755 //y2=0.71
r157 (  28 112 ) resistor r=1.40859 //w=0.34 //l=0.085 //layer=li \
 //thickness=0.1 //x=1.67 //y=0.625 //x2=1.67 //y2=0.71
r158 (  27 84 ) resistor r=5.21862 //w=0.35 //l=0.175 //layer=li \
 //thickness=0.1 //x=1.67 //y=0.35 //x2=1.67 //y2=0.175
r159 (  27 28 ) resistor r=18.8235 //w=0.187 //l=0.275 //layer=li \
 //thickness=0.1 //x=1.67 //y=0.35 //x2=1.67 //y2=0.625
r160 (  26 112 ) resistor r=1.40859 //w=0.34 //l=0.085 //layer=li \
 //thickness=0.1 //x=1.27 //y=0.71 //x2=1.185 //y2=0.71
r161 (  25 112 ) resistor r=5.4201 //w=0.17 //l=0.085 //layer=li \
 //thickness=0.1 //x=1.585 //y=0.71 //x2=1.67 //y2=0.71
r162 (  25 26 ) resistor r=21.5615 //w=0.187 //l=0.315 //layer=li \
 //thickness=0.1 //x=1.585 //y=0.71 //x2=1.27 //y2=0.71
r163 (  21 112 ) resistor r=5.4201 //w=0.17 //l=0.085 //layer=li \
 //thickness=0.1 //x=1.185 //y=0.795 //x2=1.185 //y2=0.71
r164 (  21 112 ) resistor r=41.4118 //w=0.187 //l=0.605 //layer=li \
 //thickness=0.1 //x=1.185 //y=0.795 //x2=1.185 //y2=1.4
r165 (  20 112 ) resistor r=5.4201 //w=0.17 //l=0.085 //layer=li \
 //thickness=0.1 //x=1.185 //y=0.625 //x2=1.185 //y2=0.71
r166 (  19 81 ) resistor r=5.21862 //w=0.35 //l=0.175 //layer=li \
 //thickness=0.1 //x=1.185 //y=0.35 //x2=1.185 //y2=0.175
r167 (  19 20 ) resistor r=18.8235 //w=0.187 //l=0.275 //layer=li \
 //thickness=0.1 //x=1.185 //y=0.35 //x2=1.185 //y2=0.625
r168 (  13 78 ) resistor r=9.3 //w=0.17 //l=0.17 //layer=mcon //count=1 \
 //x=5.67 //y=0.18 //x2=5.67 //y2=0.18
r169 (  11 103 ) resistor r=3.1 //w=0.17 //l=0.51 //layer=mcon //count=3 \
 //x=4.93 //y=0.18 //x2=4.93 //y2=0.18
r170 (  11 13 ) resistor r=0.297428 //w=0.311 //l=0.74 //layer=m1 \
 //thickness=0.36 //x=4.93 //y=0.175 //x2=5.67 //y2=0.175
r171 (  9 52 ) resistor r=3.1 //w=0.17 //l=0.51 //layer=mcon //count=3 \
 //x=3.45 //y=0.18 //x2=3.45 //y2=0.18
r172 (  9 11 ) resistor r=0.594855 //w=0.311 //l=1.48 //layer=m1 \
 //thickness=0.36 //x=3.45 //y=0.175 //x2=4.93 //y2=0.175
r173 (  6 87 ) resistor r=3.1 //w=0.17 //l=0.51 //layer=mcon //count=3 \
 //x=2.34 //y=0.18 //x2=2.34 //y2=0.18
r174 (  3 83 ) resistor r=3.1 //w=0.17 //l=0.51 //layer=mcon //count=3 \
 //x=1.23 //y=0.18 //x2=1.23 //y2=0.18
r175 (  3 6 ) resistor r=0.446141 //w=0.311 //l=1.11 //layer=m1 \
 //thickness=0.36 //x=1.23 //y=0.175 //x2=2.34 //y2=0.175
r176 (  1 9 ) resistor r=0.0743569 //w=0.311 //l=0.185 //layer=m1 \
 //thickness=0.36 //x=3.265 //y=0.175 //x2=3.45 //y2=0.175
r177 (  1 6 ) resistor r=0.371785 //w=0.311 //l=0.925 //layer=m1 \
 //thickness=0.36 //x=3.265 //y=0.175 //x2=2.34 //y2=0.175
ends PM_OR2X1\%GND

subckt PM_OR2X1\%VDD ( 1 13 17 20 27 43 56 60 63 64 65 )
c72 ( 65 0 ) capacitor c=0.0451938f //x=5.23 //y=5.2
c73 ( 64 0 ) capacitor c=0.0423715f //x=4.36 //y=5.2
c74 ( 63 0 ) capacitor c=0.0256797f //x=1.575 //y=5.205
c75 ( 62 0 ) capacitor c=0.00597439f //x=5.375 //y=7.585
c76 ( 61 0 ) capacitor c=0.00597439f //x=4.495 //y=7.585
c77 ( 60 0 ) capacitor c=0.109902f //x=3.82 //y=7.585
c78 ( 59 0 ) capacitor c=0.00597439f //x=1.72 //y=7.585
c79 ( 56 0 ) capacitor c=0.247693f //x=5.67 //y=7.58
c80 ( 43 0 ) capacitor c=0.0289916f //x=5.29 //y=7.585
c81 ( 35 0 ) capacitor c=0.0217664f //x=4.41 //y=7.585
c82 ( 27 0 ) capacitor c=0.0785214f //x=3.65 //y=7.585
c83 ( 20 0 ) capacitor c=0.228778f //x=1.23 //y=7.58
c84 ( 17 0 ) capacitor c=0.046953f //x=1.635 //y=7.585
c85 ( 13 0 ) capacitor c=0.264572f //x=5.67 //y=7.58
r86 (  54 62 ) resistor r=2.87058 //w=0.35 //l=0.085 //layer=li \
 //thickness=0.1 //x=5.46 //y=7.585 //x2=5.375 //y2=7.585
r87 (  54 56 ) resistor r=7.32425 //w=0.367 //l=0.21 //layer=li \
 //thickness=0.1 //x=5.46 //y=7.585 //x2=5.67 //y2=7.585
r88 (  47 62 ) resistor r=4.23183 //w=0.7 //l=0.175 //layer=li //thickness=0.1 \
 //x=5.375 //y=7.41 //x2=5.375 //y2=7.585
r89 (  47 65 ) resistor r=56.4706 //w=0.187 //l=0.825 //layer=li \
 //thickness=0.1 //x=5.375 //y=7.41 //x2=5.375 //y2=6.585
r90 (  44 61 ) resistor r=2.87058 //w=0.35 //l=0.085 //layer=li \
 //thickness=0.1 //x=4.58 //y=7.585 //x2=4.495 //y2=7.585
r91 (  44 46 ) resistor r=12.2071 //w=0.367 //l=0.35 //layer=li \
 //thickness=0.1 //x=4.58 //y=7.585 //x2=4.93 //y2=7.585
r92 (  43 62 ) resistor r=2.87058 //w=0.35 //l=0.085 //layer=li \
 //thickness=0.1 //x=5.29 //y=7.585 //x2=5.375 //y2=7.585
r93 (  43 46 ) resistor r=12.5559 //w=0.367 //l=0.36 //layer=li \
 //thickness=0.1 //x=5.29 //y=7.585 //x2=4.93 //y2=7.585
r94 (  37 61 ) resistor r=4.23183 //w=0.7 //l=0.175 //layer=li //thickness=0.1 \
 //x=4.495 //y=7.41 //x2=4.495 //y2=7.585
r95 (  37 64 ) resistor r=56.4706 //w=0.187 //l=0.825 //layer=li \
 //thickness=0.1 //x=4.495 //y=7.41 //x2=4.495 //y2=6.585
r96 (  36 60 ) resistor r=5.29055 //w=0.35 //l=0.17 //layer=li //thickness=0.1 \
 //x=3.99 //y=7.585 //x2=3.82 //y2=7.585
r97 (  35 61 ) resistor r=2.87058 //w=0.35 //l=0.085 //layer=li \
 //thickness=0.1 //x=4.41 //y=7.585 //x2=4.495 //y2=7.585
r98 (  35 36 ) resistor r=14.6485 //w=0.367 //l=0.42 //layer=li \
 //thickness=0.1 //x=4.41 //y=7.585 //x2=3.99 //y2=7.585
r99 (  30 32 ) resistor r=38.7139 //w=0.367 //l=1.11 //layer=li \
 //thickness=0.1 //x=2.34 //y=7.585 //x2=3.45 //y2=7.585
r100 (  28 59 ) resistor r=2.87058 //w=0.35 //l=0.085 //layer=li \
 //thickness=0.1 //x=1.805 //y=7.585 //x2=1.72 //y2=7.585
r101 (  28 30 ) resistor r=18.6594 //w=0.367 //l=0.535 //layer=li \
 //thickness=0.1 //x=1.805 //y=7.585 //x2=2.34 //y2=7.585
r102 (  27 60 ) resistor r=5.29055 //w=0.35 //l=0.17 //layer=li \
 //thickness=0.1 //x=3.65 //y=7.585 //x2=3.82 //y2=7.585
r103 (  27 32 ) resistor r=6.97548 //w=0.367 //l=0.2 //layer=li \
 //thickness=0.1 //x=3.65 //y=7.585 //x2=3.45 //y2=7.585
r104 (  21 59 ) resistor r=4.23183 //w=0.7 //l=0.175 //layer=li \
 //thickness=0.1 //x=1.72 //y=7.41 //x2=1.72 //y2=7.585
r105 (  21 63 ) resistor r=33.5401 //w=0.187 //l=0.49 //layer=li \
 //thickness=0.1 //x=1.72 //y=7.41 //x2=1.72 //y2=6.92
r106 (  17 59 ) resistor r=2.87058 //w=0.35 //l=0.085 //layer=li \
 //thickness=0.1 //x=1.635 //y=7.585 //x2=1.72 //y2=7.585
r107 (  17 20 ) resistor r=14.1253 //w=0.367 //l=0.405 //layer=li \
 //thickness=0.1 //x=1.635 //y=7.585 //x2=1.23 //y2=7.585
r108 (  13 56 ) resistor r=9.3 //w=0.17 //l=0.17 //layer=mcon //count=1 \
 //x=5.67 //y=7.58 //x2=5.67 //y2=7.58
r109 (  11 46 ) resistor r=3.1 //w=0.17 //l=0.51 //layer=mcon //count=3 \
 //x=4.93 //y=7.58 //x2=4.93 //y2=7.58
r110 (  11 13 ) resistor r=0.297428 //w=0.311 //l=0.74 //layer=m1 \
 //thickness=0.36 //x=4.93 //y=7.585 //x2=5.67 //y2=7.585
r111 (  9 32 ) resistor r=3.1 //w=0.17 //l=0.51 //layer=mcon //count=3 \
 //x=3.45 //y=7.58 //x2=3.45 //y2=7.58
r112 (  9 11 ) resistor r=0.594855 //w=0.311 //l=1.48 //layer=m1 \
 //thickness=0.36 //x=3.45 //y=7.585 //x2=4.93 //y2=7.585
r113 (  6 30 ) resistor r=3.1 //w=0.17 //l=0.51 //layer=mcon //count=3 \
 //x=2.34 //y=7.58 //x2=2.34 //y2=7.58
r114 (  3 20 ) resistor r=3.1 //w=0.17 //l=0.51 //layer=mcon //count=3 \
 //x=1.23 //y=7.58 //x2=1.23 //y2=7.58
r115 (  3 6 ) resistor r=0.446141 //w=0.311 //l=1.11 //layer=m1 \
 //thickness=0.36 //x=1.23 //y=7.585 //x2=2.34 //y2=7.585
r116 (  1 9 ) resistor r=0.0743569 //w=0.311 //l=0.185 //layer=m1 \
 //thickness=0.36 //x=3.265 //y=7.585 //x2=3.45 //y2=7.585
r117 (  1 6 ) resistor r=0.371785 //w=0.311 //l=0.925 //layer=m1 \
 //thickness=0.36 //x=3.265 //y=7.585 //x2=2.34 //y2=7.585
ends PM_OR2X1\%VDD

subckt PM_OR2X1\%noxref_3 ( 1 2 11 12 23 24 25 30 32 40 41 42 43 44 45 46 50 \
 51 52 54 60 61 63 71 72 75 )
c136 ( 75 0 ) capacitor c=0.0159573f //x=2.455 //y=5.205
c137 ( 72 0 ) capacitor c=0.00905936f //x=2.45 //y=1.085
c138 ( 71 0 ) capacitor c=0.007684f //x=1.48 //y=1.085
c139 ( 63 0 ) capacitor c=0.0528806f //x=4.56 //y=2.265
c140 ( 61 0 ) capacitor c=0.0435629f //x=5.2 //y=1.435
c141 ( 60 0 ) capacitor c=0.0200386f //x=5.2 //y=1.09
c142 ( 54 0 ) capacitor c=0.0152946f //x=5.045 //y=1.59
c143 ( 52 0 ) capacitor c=0.0157804f //x=5.045 //y=0.935
c144 ( 51 0 ) capacitor c=0.0524991f //x=4.79 //y=4.97
c145 ( 50 0 ) capacitor c=0.0322983f //x=5.08 //y=4.97
c146 ( 46 0 ) capacitor c=0.0290017f //x=4.67 //y=2.1
c147 ( 45 0 ) capacitor c=0.0250027f //x=4.67 //y=1.745
c148 ( 44 0 ) capacitor c=0.0234316f //x=4.67 //y=1.435
c149 ( 43 0 ) capacitor c=0.0200596f //x=4.67 //y=1.09
c150 ( 42 0 ) capacitor c=0.154218f //x=5.155 //y=6.2
c151 ( 41 0 ) capacitor c=0.154243f //x=4.715 //y=6.2
c152 ( 39 0 ) capacitor c=0.00710337f //x=2.64 //y=1.835
c153 ( 32 0 ) capacitor c=0.0944547f //x=4.56 //y=2.265
c154 ( 30 0 ) capacitor c=0.112871f //x=3.08 //y=3.51
c155 ( 25 0 ) capacitor c=0.0162468f //x=2.995 //y=1.835
c156 ( 24 0 ) capacitor c=0.00499395f //x=2.685 //y=5.39
c157 ( 23 0 ) capacitor c=0.0155365f //x=2.995 //y=5.39
c158 ( 12 0 ) capacitor c=0.00277607f //x=1.755 //y=1.835
c159 ( 11 0 ) capacitor c=0.0280953f //x=2.555 //y=1.835
c160 ( 2 0 ) capacitor c=0.0155913f //x=3.195 //y=3.51
c161 ( 1 0 ) capacitor c=0.0801529f //x=4.445 //y=3.51
r162 (  63 64 ) resistor r=17.5563 //w=0.302 //l=0.11 //layer=ply \
 //thickness=0.18 //x=4.56 //y=2.265 //x2=4.67 //y2=2.265
r163 (  61 70 ) resistor r=45.1352 //w=0.168 //l=0.173853 //layer=ply \
 //thickness=0.18 //x=5.2 //y=1.435 //x2=5.16 //y2=1.59
r164 (  60 69 ) resistor r=45.1352 //w=0.168 //l=0.173853 //layer=ply \
 //thickness=0.18 //x=5.2 //y=1.09 //x2=5.16 //y2=0.935
r165 (  60 61 ) resistor r=176.904 //w=0.094 //l=0.345 //layer=ply \
 //thickness=0.18 //x=5.2 //y=1.09 //x2=5.2 //y2=1.435
r166 (  55 68 ) resistor r=10.701 //w=0.21 //l=0.115 //layer=ply \
 //thickness=0.18 //x=4.825 //y=1.59 //x2=4.71 //y2=1.59
r167 (  54 70 ) resistor r=5.52526 //w=0.168 //l=0.115 //layer=ply \
 //thickness=0.18 //x=5.045 //y=1.59 //x2=5.16 //y2=1.59
r168 (  53 67 ) resistor r=5.52526 //w=0.168 //l=0.115 //layer=ply \
 //thickness=0.18 //x=4.825 //y=0.935 //x2=4.71 //y2=0.935
r169 (  52 69 ) resistor r=5.52526 //w=0.168 //l=0.115 //layer=ply \
 //thickness=0.18 //x=5.045 //y=0.935 //x2=5.16 //y2=0.935
r170 (  52 53 ) resistor r=112.809 //w=0.094 //l=0.22 //layer=ply \
 //thickness=0.18 //x=5.045 //y=0.935 //x2=4.825 //y2=0.935
r171 (  50 57 ) resistor r=26.9307 //w=0.15 //l=0.106066 //layer=ply \
 //thickness=0.18 //x=5.08 //y=4.97 //x2=5.155 //y2=5.045
r172 (  50 51 ) resistor r=148.702 //w=0.094 //l=0.29 //layer=ply \
 //thickness=0.18 //x=5.08 //y=4.97 //x2=4.79 //y2=4.97
r173 (  47 51 ) resistor r=23.403 //w=0.284 //l=0.106066 //layer=ply \
 //thickness=0.18 //x=4.715 //y=5.045 //x2=4.79 //y2=4.97
r174 (  47 66 ) resistor r=26.3063 //w=0.284 //l=0.229783 //layer=ply \
 //thickness=0.18 //x=4.715 //y=5.045 //x2=4.56 //y2=4.88
r175 (  46 64 ) resistor r=19.1248 //w=0.302 //l=0.165 //layer=ply \
 //thickness=0.18 //x=4.67 //y=2.1 //x2=4.67 //y2=2.265
r176 (  45 68 ) resistor r=39.5823 //w=0.21 //l=0.173853 //layer=ply \
 //thickness=0.18 //x=4.67 //y=1.745 //x2=4.71 //y2=1.59
r177 (  45 46 ) resistor r=182.032 //w=0.094 //l=0.355 //layer=ply \
 //thickness=0.18 //x=4.67 //y=1.745 //x2=4.67 //y2=2.1
r178 (  44 68 ) resistor r=39.5823 //w=0.21 //l=0.173853 //layer=ply \
 //thickness=0.18 //x=4.67 //y=1.435 //x2=4.71 //y2=1.59
r179 (  43 67 ) resistor r=45.1352 //w=0.168 //l=0.173853 //layer=ply \
 //thickness=0.18 //x=4.67 //y=1.09 //x2=4.71 //y2=0.935
r180 (  43 44 ) resistor r=176.904 //w=0.094 //l=0.345 //layer=ply \
 //thickness=0.18 //x=4.67 //y=1.09 //x2=4.67 //y2=1.435
r181 (  42 57 ) resistor r=592.245 //w=0.094 //l=1.155 //layer=ply \
 //thickness=0.18 //x=5.155 //y=6.2 //x2=5.155 //y2=5.045
r182 (  41 47 ) resistor r=592.245 //w=0.094 //l=1.155 //layer=ply \
 //thickness=0.18 //x=4.715 //y=6.2 //x2=4.715 //y2=5.045
r183 (  40 54 ) resistor r=56.4043 //w=0.094 //l=0.11 //layer=ply \
 //thickness=0.18 //x=4.935 //y=1.59 //x2=5.045 //y2=1.59
r184 (  40 55 ) resistor r=56.4043 //w=0.094 //l=0.11 //layer=ply \
 //thickness=0.18 //x=4.935 //y=1.59 //x2=4.825 //y2=1.59
r185 (  37 66 ) resistor r=152 //w=0.17 //l=0.17 //layer=licon //count=1 \
 //x=4.56 //y=4.88 //x2=4.56 //y2=4.88
r186 (  35 37 ) resistor r=93.7754 //w=0.187 //l=1.37 //layer=li \
 //thickness=0.1 //x=4.56 //y=3.51 //x2=4.56 //y2=4.88
r187 (  32 63 ) resistor r=152 //w=0.17 //l=0.17 //layer=licon //count=1 \
 //x=4.56 //y=2.265 //x2=4.56 //y2=2.265
r188 (  32 35 ) resistor r=85.2193 //w=0.187 //l=1.245 //layer=li \
 //thickness=0.1 //x=4.56 //y=2.265 //x2=4.56 //y2=3.51
r189 (  28 30 ) resistor r=122.866 //w=0.187 //l=1.795 //layer=li \
 //thickness=0.1 //x=3.08 //y=5.305 //x2=3.08 //y2=3.51
r190 (  27 30 ) resistor r=108.834 //w=0.187 //l=1.59 //layer=li \
 //thickness=0.1 //x=3.08 //y=1.92 //x2=3.08 //y2=3.51
r191 (  26 39 ) resistor r=5.4201 //w=0.17 //l=0.085 //layer=li \
 //thickness=0.1 //x=2.725 //y=1.835 //x2=2.64 //y2=1.835
r192 (  25 27 ) resistor r=7.15173 //w=0.17 //l=0.120208 //layer=li \
 //thickness=0.1 //x=2.995 //y=1.835 //x2=3.08 //y2=1.92
r193 (  25 26 ) resistor r=18.4813 //w=0.187 //l=0.27 //layer=li \
 //thickness=0.1 //x=2.995 //y=1.835 //x2=2.725 //y2=1.835
r194 (  23 28 ) resistor r=7.15173 //w=0.17 //l=0.120208 //layer=li \
 //thickness=0.1 //x=2.995 //y=5.39 //x2=3.08 //y2=5.305
r195 (  23 24 ) resistor r=21.2193 //w=0.187 //l=0.31 //layer=li \
 //thickness=0.1 //x=2.995 //y=5.39 //x2=2.685 //y2=5.39
r196 (  19 39 ) resistor r=1.40859 //w=0.34 //l=0.085 //layer=li \
 //thickness=0.1 //x=2.64 //y=1.75 //x2=2.64 //y2=1.835
r197 (  19 72 ) resistor r=39.016 //w=0.187 //l=0.57 //layer=li \
 //thickness=0.1 //x=2.64 //y=1.75 //x2=2.64 //y2=1.18
r198 (  13 24 ) resistor r=7.15173 //w=0.17 //l=0.120208 //layer=li \
 //thickness=0.1 //x=2.6 //y=5.475 //x2=2.685 //y2=5.39
r199 (  13 75 ) resistor r=29.0909 //w=0.187 //l=0.425 //layer=li \
 //thickness=0.1 //x=2.6 //y=5.475 //x2=2.6 //y2=5.9
r200 (  11 39 ) resistor r=5.4201 //w=0.17 //l=0.085 //layer=li \
 //thickness=0.1 //x=2.555 //y=1.835 //x2=2.64 //y2=1.835
r201 (  11 12 ) resistor r=54.7594 //w=0.187 //l=0.8 //layer=li \
 //thickness=0.1 //x=2.555 //y=1.835 //x2=1.755 //y2=1.835
r202 (  7 12 ) resistor r=7.15173 //w=0.17 //l=0.120208 //layer=li \
 //thickness=0.1 //x=1.67 //y=1.75 //x2=1.755 //y2=1.835
r203 (  7 71 ) resistor r=39.016 //w=0.187 //l=0.57 //layer=li //thickness=0.1 \
 //x=1.67 //y=1.75 //x2=1.67 //y2=1.18
r204 (  6 35 ) resistor r=9.3 //w=0.17 //l=0.17 //layer=mcon //count=1 \
 //x=4.56 //y=3.51 //x2=4.56 //y2=3.51
r205 (  4 30 ) resistor r=9.3 //w=0.17 //l=0.17 //layer=mcon //count=1 \
 //x=3.08 //y=3.51 //x2=3.08 //y2=3.51
r206 (  2 4 ) resistor r=0.0717383 //w=0.224 //l=0.115 //layer=m1 \
 //thickness=0.36 //x=3.195 //y=3.51 //x2=3.08 //y2=3.51
r207 (  1 6 ) resistor r=0.0717383 //w=0.224 //l=0.115 //layer=m1 \
 //thickness=0.36 //x=4.445 //y=3.51 //x2=4.56 //y2=3.51
r208 (  1 2 ) resistor r=1.19275 //w=0.131 //l=1.25 //layer=m1 \
 //thickness=0.36 //x=4.445 //y=3.51 //x2=3.195 //y2=3.51
ends PM_OR2X1\%noxref_3

subckt PM_OR2X1\%A ( 1 2 3 4 5 6 7 10 20 22 23 24 25 26 27 28 32 34 37 39 40 \
 45 )
c66 ( 45 0 ) capacitor c=0.04214f //x=1.445 //y=4.885
c67 ( 40 0 ) capacitor c=0.0321911f //x=1.935 //y=1.43
c68 ( 39 0 ) capacitor c=0.0185201f //x=1.935 //y=1.085
c69 ( 37 0 ) capacitor c=0.0344254f //x=1.865 //y=4.975
c70 ( 34 0 ) capacitor c=0.0133656f //x=1.78 //y=1.585
c71 ( 32 0 ) capacitor c=0.0157804f //x=1.78 //y=0.93
c72 ( 28 0 ) capacitor c=0.0828832f //x=1.405 //y=2.095
c73 ( 27 0 ) capacitor c=0.022867f //x=1.405 //y=1.74
c74 ( 26 0 ) capacitor c=0.0234318f //x=1.405 //y=1.43
c75 ( 25 0 ) capacitor c=0.0192004f //x=1.405 //y=1.085
c76 ( 24 0 ) capacitor c=0.110795f //x=1.94 //y=6.205
c77 ( 23 0 ) capacitor c=0.153847f //x=1.5 //y=6.205
c78 ( 20 0 ) capacitor c=0.00993392f //x=1.445 //y=4.885
c79 ( 10 0 ) capacitor c=0.112424f //x=1.6 //y=2.26
r80 (  47 48 ) resistor r=32.4568 //w=0.214 //l=0.075 //layer=ply \
 //thickness=0.18 //x=1.445 //y=4.975 //x2=1.445 //y2=5.05
r81 (  45 47 ) resistor r=20.271 //w=0.214 //l=0.09 //layer=ply \
 //thickness=0.18 //x=1.445 //y=4.885 //x2=1.445 //y2=4.975
r82 (  40 54 ) resistor r=45.1352 //w=0.168 //l=0.173853 //layer=ply \
 //thickness=0.18 //x=1.935 //y=1.43 //x2=1.895 //y2=1.585
r83 (  39 53 ) resistor r=45.1352 //w=0.168 //l=0.173853 //layer=ply \
 //thickness=0.18 //x=1.935 //y=1.085 //x2=1.895 //y2=0.93
r84 (  39 40 ) resistor r=176.904 //w=0.094 //l=0.345 //layer=ply \
 //thickness=0.18 //x=1.935 //y=1.085 //x2=1.935 //y2=1.43
r85 (  38 47 ) resistor r=16.5046 //w=0.27 //l=0.135 //layer=ply \
 //thickness=0.18 //x=1.58 //y=4.975 //x2=1.445 //y2=4.975
r86 (  37 41 ) resistor r=26.9307 //w=0.15 //l=0.106066 //layer=ply \
 //thickness=0.18 //x=1.865 //y=4.975 //x2=1.94 //y2=5.05
r87 (  37 38 ) resistor r=146.138 //w=0.094 //l=0.285 //layer=ply \
 //thickness=0.18 //x=1.865 //y=4.975 //x2=1.58 //y2=4.975
r88 (  35 52 ) resistor r=10.701 //w=0.21 //l=0.115 //layer=ply \
 //thickness=0.18 //x=1.56 //y=1.585 //x2=1.445 //y2=1.585
r89 (  34 54 ) resistor r=5.52526 //w=0.168 //l=0.115 //layer=ply \
 //thickness=0.18 //x=1.78 //y=1.585 //x2=1.895 //y2=1.585
r90 (  33 51 ) resistor r=5.52526 //w=0.168 //l=0.115 //layer=ply \
 //thickness=0.18 //x=1.56 //y=0.93 //x2=1.445 //y2=0.93
r91 (  32 53 ) resistor r=5.52526 //w=0.168 //l=0.115 //layer=ply \
 //thickness=0.18 //x=1.78 //y=0.93 //x2=1.895 //y2=0.93
r92 (  32 33 ) resistor r=112.809 //w=0.094 //l=0.22 //layer=ply \
 //thickness=0.18 //x=1.78 //y=0.93 //x2=1.56 //y2=0.93
r93 (  28 50 ) resistor r=34.8111 //w=0.27 //l=0.264953 //layer=ply \
 //thickness=0.18 //x=1.405 //y=2.095 //x2=1.6 //y2=2.26
r94 (  27 52 ) resistor r=39.5823 //w=0.21 //l=0.173853 //layer=ply \
 //thickness=0.18 //x=1.405 //y=1.74 //x2=1.445 //y2=1.585
r95 (  27 28 ) resistor r=182.032 //w=0.094 //l=0.355 //layer=ply \
 //thickness=0.18 //x=1.405 //y=1.74 //x2=1.405 //y2=2.095
r96 (  26 52 ) resistor r=39.5823 //w=0.21 //l=0.173853 //layer=ply \
 //thickness=0.18 //x=1.405 //y=1.43 //x2=1.445 //y2=1.585
r97 (  25 51 ) resistor r=45.1352 //w=0.168 //l=0.173853 //layer=ply \
 //thickness=0.18 //x=1.405 //y=1.085 //x2=1.445 //y2=0.93
r98 (  25 26 ) resistor r=176.904 //w=0.094 //l=0.345 //layer=ply \
 //thickness=0.18 //x=1.405 //y=1.085 //x2=1.405 //y2=1.43
r99 (  24 41 ) resistor r=592.245 //w=0.094 //l=1.155 //layer=ply \
 //thickness=0.18 //x=1.94 //y=6.205 //x2=1.94 //y2=5.05
r100 (  23 48 ) resistor r=592.245 //w=0.094 //l=1.155 //layer=ply \
 //thickness=0.18 //x=1.5 //y=6.205 //x2=1.5 //y2=5.05
r101 (  22 34 ) resistor r=56.4043 //w=0.094 //l=0.11 //layer=ply \
 //thickness=0.18 //x=1.67 //y=1.585 //x2=1.78 //y2=1.585
r102 (  22 35 ) resistor r=56.4043 //w=0.094 //l=0.11 //layer=ply \
 //thickness=0.18 //x=1.67 //y=1.585 //x2=1.56 //y2=1.585
r103 (  20 45 ) resistor r=152 //w=0.17 //l=0.17 //layer=licon //count=1 \
 //x=1.445 //y=4.885 //x2=1.445 //y2=4.885
r104 (  20 21 ) resistor r=7.81102 //w=0.254 //l=0.155 //layer=li \
 //thickness=0.1 //x=1.445 //y=4.885 //x2=1.6 //y2=4.885
r105 (  10 50 ) resistor r=152 //w=0.17 //l=0.17 //layer=licon //count=1 \
 //x=1.6 //y=2.26 //x2=1.6 //y2=2.26
r106 (  8 21 ) resistor r=3.23951 //w=0.254 //l=0.165 //layer=li \
 //thickness=0.1 //x=1.6 //y=4.72 //x2=1.6 //y2=4.885
r107 (  7 8 ) resistor r=6.84492 //w=0.187 //l=0.1 //layer=li //thickness=0.1 \
 //x=1.6 //y=4.62 //x2=1.6 //y2=4.72
r108 (  6 7 ) resistor r=25.3262 //w=0.187 //l=0.37 //layer=li //thickness=0.1 \
 //x=1.6 //y=4.25 //x2=1.6 //y2=4.62
r109 (  5 6 ) resistor r=25.3262 //w=0.187 //l=0.37 //layer=li //thickness=0.1 \
 //x=1.6 //y=3.88 //x2=1.6 //y2=4.25
r110 (  4 5 ) resistor r=25.3262 //w=0.187 //l=0.37 //layer=li //thickness=0.1 \
 //x=1.6 //y=3.51 //x2=1.6 //y2=3.88
r111 (  3 4 ) resistor r=25.3262 //w=0.187 //l=0.37 //layer=li //thickness=0.1 \
 //x=1.6 //y=3.14 //x2=1.6 //y2=3.51
r112 (  2 3 ) resistor r=25.3262 //w=0.187 //l=0.37 //layer=li //thickness=0.1 \
 //x=1.6 //y=2.77 //x2=1.6 //y2=3.14
r113 (  1 2 ) resistor r=25.3262 //w=0.187 //l=0.37 //layer=li //thickness=0.1 \
 //x=1.6 //y=2.4 //x2=1.6 //y2=2.77
r114 (  1 10 ) resistor r=9.58289 //w=0.187 //l=0.14 //layer=li \
 //thickness=0.1 //x=1.6 //y=2.4 //x2=1.6 //y2=2.26
ends PM_OR2X1\%A

subckt PM_OR2X1\%B ( 1 2 3 4 5 6 7 8 10 21 22 23 24 25 26 31 33 35 41 42 44 45 \
 48 )
c69 ( 48 0 ) capacitor c=0.0369822f //x=2.375 //y=4.885
c70 ( 45 0 ) capacitor c=0.0279572f //x=2.34 //y=2.095
c71 ( 44 0 ) capacitor c=0.0422144f //x=2.34 //y=2.26
c72 ( 42 0 ) capacitor c=0.0237734f //x=2.905 //y=1.435
c73 ( 41 0 ) capacitor c=0.0191782f //x=2.905 //y=1.085
c74 ( 35 0 ) capacitor c=0.0346941f //x=2.75 //y=1.585
c75 ( 33 0 ) capacitor c=0.0157803f //x=2.75 //y=0.93
c76 ( 31 0 ) capacitor c=0.0360787f //x=2.745 //y=4.975
c77 ( 26 0 ) capacitor c=0.0199921f //x=2.375 //y=1.74
c78 ( 25 0 ) capacitor c=0.0169608f //x=2.375 //y=1.435
c79 ( 24 0 ) capacitor c=0.0185462f //x=2.375 //y=1.085
c80 ( 23 0 ) capacitor c=0.15325f //x=2.82 //y=6.205
c81 ( 22 0 ) capacitor c=0.110232f //x=2.38 //y=6.205
c82 ( 10 0 ) capacitor c=0.0809838f //x=2.34 //y=2.26
c83 ( 8 0 ) capacitor c=0.00521267f //x=2.34 //y=4.72
r84 (  50 51 ) resistor r=32.4568 //w=0.214 //l=0.075 //layer=ply \
 //thickness=0.18 //x=2.375 //y=4.975 //x2=2.375 //y2=5.05
r85 (  48 50 ) resistor r=20.271 //w=0.214 //l=0.09 //layer=ply \
 //thickness=0.18 //x=2.375 //y=4.885 //x2=2.375 //y2=4.975
r86 (  44 45 ) resistor r=52.7279 //w=0.214 //l=0.165 //layer=ply \
 //thickness=0.18 //x=2.34 //y=2.26 //x2=2.34 //y2=2.095
r87 (  42 55 ) resistor r=4.95774 //w=0.164 //l=0.112 //layer=ply \
 //thickness=0.18 //x=2.905 //y=1.435 //x2=2.905 //y2=1.547
r88 (  41 54 ) resistor r=45.1352 //w=0.168 //l=0.173853 //layer=ply \
 //thickness=0.18 //x=2.905 //y=1.085 //x2=2.865 //y2=0.93
r89 (  41 42 ) resistor r=179.468 //w=0.094 //l=0.35 //layer=ply \
 //thickness=0.18 //x=2.905 //y=1.085 //x2=2.905 //y2=1.435
r90 (  36 53 ) resistor r=10.8103 //w=0.211 //l=0.115 //layer=ply \
 //thickness=0.18 //x=2.53 //y=1.585 //x2=2.415 //y2=1.585
r91 (  35 55 ) resistor r=45.9962 //w=0.164 //l=0.17296 //layer=ply \
 //thickness=0.18 //x=2.75 //y=1.585 //x2=2.905 //y2=1.547
r92 (  34 52 ) resistor r=5.52526 //w=0.168 //l=0.115 //layer=ply \
 //thickness=0.18 //x=2.53 //y=0.93 //x2=2.415 //y2=0.93
r93 (  33 54 ) resistor r=5.52526 //w=0.168 //l=0.115 //layer=ply \
 //thickness=0.18 //x=2.75 //y=0.93 //x2=2.865 //y2=0.93
r94 (  33 34 ) resistor r=112.809 //w=0.094 //l=0.22 //layer=ply \
 //thickness=0.18 //x=2.75 //y=0.93 //x2=2.53 //y2=0.93
r95 (  32 50 ) resistor r=16.5046 //w=0.27 //l=0.135 //layer=ply \
 //thickness=0.18 //x=2.51 //y=4.975 //x2=2.375 //y2=4.975
r96 (  31 38 ) resistor r=26.9307 //w=0.15 //l=0.106066 //layer=ply \
 //thickness=0.18 //x=2.745 //y=4.975 //x2=2.82 //y2=5.05
r97 (  31 32 ) resistor r=120.5 //w=0.094 //l=0.235 //layer=ply \
 //thickness=0.18 //x=2.745 //y=4.975 //x2=2.51 //y2=4.975
r98 (  26 53 ) resistor r=39.5036 //w=0.211 //l=0.173853 //layer=ply \
 //thickness=0.18 //x=2.375 //y=1.74 //x2=2.415 //y2=1.585
r99 (  26 45 ) resistor r=182.032 //w=0.094 //l=0.355 //layer=ply \
 //thickness=0.18 //x=2.375 //y=1.74 //x2=2.375 //y2=2.095
r100 (  25 53 ) resistor r=38.3614 //w=0.211 //l=0.168819 //layer=ply \
 //thickness=0.18 //x=2.375 //y=1.435 //x2=2.415 //y2=1.585
r101 (  24 52 ) resistor r=45.1352 //w=0.168 //l=0.173853 //layer=ply \
 //thickness=0.18 //x=2.375 //y=1.085 //x2=2.415 //y2=0.93
r102 (  24 25 ) resistor r=179.468 //w=0.094 //l=0.35 //layer=ply \
 //thickness=0.18 //x=2.375 //y=1.085 //x2=2.375 //y2=1.435
r103 (  23 38 ) resistor r=592.245 //w=0.094 //l=1.155 //layer=ply \
 //thickness=0.18 //x=2.82 //y=6.205 //x2=2.82 //y2=5.05
r104 (  22 51 ) resistor r=592.245 //w=0.094 //l=1.155 //layer=ply \
 //thickness=0.18 //x=2.38 //y=6.205 //x2=2.38 //y2=5.05
r105 (  21 35 ) resistor r=56.4043 //w=0.094 //l=0.11 //layer=ply \
 //thickness=0.18 //x=2.64 //y=1.585 //x2=2.75 //y2=1.585
r106 (  21 36 ) resistor r=56.4043 //w=0.094 //l=0.11 //layer=ply \
 //thickness=0.18 //x=2.64 //y=1.585 //x2=2.53 //y2=1.585
r107 (  20 48 ) resistor r=152 //w=0.17 //l=0.17 //layer=licon //count=1 \
 //x=2.375 //y=4.885 //x2=2.375 //y2=4.885
r108 (  10 44 ) resistor r=152 //w=0.17 //l=0.17 //layer=licon //count=1 \
 //x=2.34 //y=2.26 //x2=2.34 //y2=2.26
r109 (  8 20 ) resistor r=11.332 //w=0.189 //l=0.173292 //layer=li \
 //thickness=0.1 //x=2.34 //y=4.72 //x2=2.357 //y2=4.885
r110 (  7 8 ) resistor r=6.84492 //w=0.187 //l=0.1 //layer=li //thickness=0.1 \
 //x=2.34 //y=4.62 //x2=2.34 //y2=4.72
r111 (  6 7 ) resistor r=25.3262 //w=0.187 //l=0.37 //layer=li //thickness=0.1 \
 //x=2.34 //y=4.25 //x2=2.34 //y2=4.62
r112 (  5 6 ) resistor r=25.3262 //w=0.187 //l=0.37 //layer=li //thickness=0.1 \
 //x=2.34 //y=3.88 //x2=2.34 //y2=4.25
r113 (  4 5 ) resistor r=25.3262 //w=0.187 //l=0.37 //layer=li //thickness=0.1 \
 //x=2.34 //y=3.51 //x2=2.34 //y2=3.88
r114 (  3 4 ) resistor r=25.3262 //w=0.187 //l=0.37 //layer=li //thickness=0.1 \
 //x=2.34 //y=3.14 //x2=2.34 //y2=3.51
r115 (  2 3 ) resistor r=25.3262 //w=0.187 //l=0.37 //layer=li //thickness=0.1 \
 //x=2.34 //y=2.77 //x2=2.34 //y2=3.14
r116 (  1 2 ) resistor r=25.3262 //w=0.187 //l=0.37 //layer=li //thickness=0.1 \
 //x=2.34 //y=2.4 //x2=2.34 //y2=2.77
r117 (  1 10 ) resistor r=9.58289 //w=0.187 //l=0.14 //layer=li \
 //thickness=0.1 //x=2.34 //y=2.4 //x2=2.34 //y2=2.26
ends PM_OR2X1\%B

subckt PM_OR2X1\%noxref_6 ( 7 8 15 16 23 24 25 )
c41 ( 25 0 ) capacitor c=0.030764f //x=2.895 //y=5.205
c42 ( 24 0 ) capacitor c=0.0185379f //x=2.015 //y=5.205
c43 ( 23 0 ) capacitor c=0.0409962f //x=1.145 //y=5.205
c44 ( 16 0 ) capacitor c=0.00193672f //x=2.245 //y=7.09
c45 ( 15 0 ) capacitor c=0.01354f //x=2.955 //y=7.09
c46 ( 8 0 ) capacitor c=0.00844339f //x=1.365 //y=5.39
c47 ( 7 0 ) capacitor c=0.0240359f //x=2.075 //y=5.39
r48 (  17 25 ) resistor r=5.81818 //w=0.187 //l=0.085 //layer=li \
 //thickness=0.1 //x=3.04 //y=7.005 //x2=3.04 //y2=6.92
r49 (  15 17 ) resistor r=7.15173 //w=0.17 //l=0.120208 //layer=li \
 //thickness=0.1 //x=2.955 //y=7.09 //x2=3.04 //y2=7.005
r50 (  15 16 ) resistor r=48.5989 //w=0.187 //l=0.71 //layer=li \
 //thickness=0.1 //x=2.955 //y=7.09 //x2=2.245 //y2=7.09
r51 (  10 16 ) resistor r=7.15173 //w=0.17 //l=0.120208 //layer=li \
 //thickness=0.1 //x=2.16 //y=7.005 //x2=2.245 //y2=7.09
r52 (  10 24 ) resistor r=29.0909 //w=0.187 //l=0.425 //layer=li \
 //thickness=0.1 //x=2.16 //y=7.005 //x2=2.16 //y2=6.58
r53 (  9 24 ) resistor r=29.0909 //w=0.187 //l=0.425 //layer=li \
 //thickness=0.1 //x=2.16 //y=5.475 //x2=2.16 //y2=5.9
r54 (  7 9 ) resistor r=7.15173 //w=0.17 //l=0.120208 //layer=li \
 //thickness=0.1 //x=2.075 //y=5.39 //x2=2.16 //y2=5.475
r55 (  7 8 ) resistor r=48.5989 //w=0.187 //l=0.71 //layer=li //thickness=0.1 \
 //x=2.075 //y=5.39 //x2=1.365 //y2=5.39
r56 (  1 8 ) resistor r=7.15173 //w=0.17 //l=0.120208 //layer=li \
 //thickness=0.1 //x=1.28 //y=5.475 //x2=1.365 //y2=5.39
r57 (  1 23 ) resistor r=29.0909 //w=0.187 //l=0.425 //layer=li \
 //thickness=0.1 //x=1.28 //y=5.475 //x2=1.28 //y2=5.9
ends PM_OR2X1\%noxref_6

subckt PM_OR2X1\%Y ( 1 2 3 4 5 6 7 18 19 20 21 31 33 )
c44 ( 33 0 ) capacitor c=0.028734f //x=4.79 //y=5.2
c45 ( 31 0 ) capacitor c=0.0173218f //x=4.745 //y=1.09
c46 ( 21 0 ) capacitor c=0.00575887f //x=5.02 //y=4.76
c47 ( 20 0 ) capacitor c=0.0136889f //x=5.215 //y=4.76
c48 ( 19 0 ) capacitor c=0.00636159f //x=5.015 //y=2.26
c49 ( 18 0 ) capacitor c=0.0140707f //x=5.215 //y=2.26
c50 ( 1 0 ) capacitor c=0.105613f //x=5.3 //y=2.4
r51 (  20 23 ) resistor r=7.15173 //w=0.17 //l=0.120208 //layer=li \
 //thickness=0.1 //x=5.215 //y=4.76 //x2=5.3 //y2=4.675
r52 (  20 21 ) resistor r=13.3476 //w=0.187 //l=0.195 //layer=li \
 //thickness=0.1 //x=5.215 //y=4.76 //x2=5.02 //y2=4.76
r53 (  18 22 ) resistor r=7.15173 //w=0.17 //l=0.120208 //layer=li \
 //thickness=0.1 //x=5.215 //y=2.26 //x2=5.3 //y2=2.345
r54 (  18 19 ) resistor r=13.6898 //w=0.187 //l=0.2 //layer=li //thickness=0.1 \
 //x=5.215 //y=2.26 //x2=5.015 //y2=2.26
r55 (  12 21 ) resistor r=7.15173 //w=0.17 //l=0.120208 //layer=li \
 //thickness=0.1 //x=4.935 //y=4.845 //x2=5.02 //y2=4.76
r56 (  12 33 ) resistor r=72.5562 //w=0.187 //l=1.06 //layer=li \
 //thickness=0.1 //x=4.935 //y=4.845 //x2=4.935 //y2=5.905
r57 (  8 19 ) resistor r=7.15173 //w=0.17 //l=0.120208 //layer=li \
 //thickness=0.1 //x=4.93 //y=2.175 //x2=5.015 //y2=2.26
r58 (  8 31 ) resistor r=67.7647 //w=0.187 //l=0.99 //layer=li //thickness=0.1 \
 //x=4.93 //y=2.175 //x2=4.93 //y2=1.185
r59 (  7 23 ) resistor r=3.76471 //w=0.187 //l=0.055 //layer=li \
 //thickness=0.1 //x=5.3 //y=4.62 //x2=5.3 //y2=4.675
r60 (  6 7 ) resistor r=25.3262 //w=0.187 //l=0.37 //layer=li //thickness=0.1 \
 //x=5.3 //y=4.25 //x2=5.3 //y2=4.62
r61 (  5 6 ) resistor r=25.3262 //w=0.187 //l=0.37 //layer=li //thickness=0.1 \
 //x=5.3 //y=3.88 //x2=5.3 //y2=4.25
r62 (  4 5 ) resistor r=25.3262 //w=0.187 //l=0.37 //layer=li //thickness=0.1 \
 //x=5.3 //y=3.51 //x2=5.3 //y2=3.88
r63 (  3 4 ) resistor r=25.3262 //w=0.187 //l=0.37 //layer=li //thickness=0.1 \
 //x=5.3 //y=3.14 //x2=5.3 //y2=3.51
r64 (  2 3 ) resistor r=25.3262 //w=0.187 //l=0.37 //layer=li //thickness=0.1 \
 //x=5.3 //y=2.77 //x2=5.3 //y2=3.14
r65 (  1 2 ) resistor r=25.3262 //w=0.187 //l=0.37 //layer=li //thickness=0.1 \
 //x=5.3 //y=2.4 //x2=5.3 //y2=2.77
r66 (  1 22 ) resistor r=3.76471 //w=0.187 //l=0.055 //layer=li \
 //thickness=0.1 //x=5.3 //y=2.4 //x2=5.3 //y2=2.345
ends PM_OR2X1\%Y
