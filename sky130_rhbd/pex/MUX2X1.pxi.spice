// File: MUX2X1.spi.MUX2X1.pxi
// Created: Sun Apr 12 08:34:17 2026
//
simulator lang=spectre
x_PM_MUX2X1\%S ( S S S S S S S S S S S S S N_S_c_20_p N_S_c_34_p N_S_c_21_p \
 N_S_c_22_p N_S_c_23_p N_S_c_35_p N_S_c_24_p N_S_c_25_p N_S_c_9_p N_S_c_27_p \
 N_S_c_36_p N_S_c_118_p N_S_c_70_p N_S_M0_noxref_g N_S_M1_noxref_g \
 N_S_M7_noxref_g N_S_M8_noxref_g N_S_M9_noxref_g N_S_M10_noxref_g N_S_c_40_p \
 N_S_c_1_p N_S_c_2_p N_S_c_3_p N_S_c_14_p N_S_c_38_p N_S_c_42_p N_S_c_4_p \
 N_S_c_44_p N_S_c_5_p N_S_c_137_p N_S_c_138_p N_S_c_140_p N_S_c_126_p \
 N_S_c_165_p N_S_c_166_p N_S_c_139_p N_S_c_141_p N_S_c_10_p N_S_c_73_p )  \
 PM_MUX2X1\%S
x_PM_MUX2X1\%noxref_2 ( N_noxref_2_c_223_n N_noxref_2_c_228_n \
 N_noxref_2_c_230_n N_noxref_2_c_231_n N_noxref_2_c_233_n N_noxref_2_c_234_n \
 N_noxref_2_c_237_n N_noxref_2_c_251_n N_noxref_2_c_254_n N_noxref_2_c_291_p \
 N_noxref_2_c_298_p N_noxref_2_c_261_n N_noxref_2_c_268_n N_noxref_2_c_326_p \
 N_noxref_2_c_292_p N_noxref_2_c_299_p N_noxref_2_c_300_p N_noxref_2_c_270_n \
 N_noxref_2_c_301_p N_noxref_2_c_273_n N_noxref_2_c_278_n N_noxref_2_c_384_p \
 N_noxref_2_c_322_p N_noxref_2_M3_noxref_g N_noxref_2_M13_noxref_g \
 N_noxref_2_M14_noxref_g N_noxref_2_c_403_p N_noxref_2_c_404_p \
 N_noxref_2_c_406_p N_noxref_2_c_392_p N_noxref_2_c_430_p N_noxref_2_c_431_p \
 N_noxref_2_c_405_p N_noxref_2_c_407_p N_noxref_2_c_325_p \
 N_noxref_2_M0_noxref_d N_noxref_2_M7_noxref_d )  PM_MUX2X1\%noxref_2
x_PM_MUX2X1\%noxref_3 ( N_noxref_3_c_479_n N_noxref_3_c_495_n \
 N_noxref_3_c_552_p N_noxref_3_c_526_p N_noxref_3_c_497_n N_noxref_3_c_480_n \
 N_noxref_3_c_501_n N_noxref_3_c_481_n N_noxref_3_c_529_p N_noxref_3_c_530_p \
 N_noxref_3_c_482_n N_noxref_3_c_513_n N_noxref_3_c_554_p N_noxref_3_c_514_n \
 N_noxref_3_c_488_n N_noxref_3_c_531_p N_noxref_3_c_532_p N_noxref_3_c_539_p \
 N_noxref_3_c_533_p N_noxref_3_c_515_n N_noxref_3_c_518_n N_noxref_3_c_525_p \
 N_noxref_3_c_535_p N_noxref_3_c_489_n N_noxref_3_c_490_n N_noxref_3_c_602_p \
 N_noxref_3_c_546_p N_noxref_3_c_550_p N_noxref_3_M5_noxref_g \
 N_noxref_3_M17_noxref_g N_noxref_3_M18_noxref_g N_noxref_3_c_578_p \
 N_noxref_3_c_579_p N_noxref_3_c_581_p N_noxref_3_c_560_p N_noxref_3_c_713_p \
 N_noxref_3_c_714_p N_noxref_3_c_580_p N_noxref_3_c_582_p N_noxref_3_c_551_p \
 N_noxref_3_M2_noxref_d N_noxref_3_M9_noxref_d N_noxref_3_M11_noxref_d )  \
 PM_MUX2X1\%noxref_3
x_PM_MUX2X1\%noxref_4 ( N_noxref_4_c_785_n N_noxref_4_c_802_n \
 N_noxref_4_c_873_p N_noxref_4_c_803_n N_noxref_4_c_804_n N_noxref_4_c_786_n \
 N_noxref_4_c_814_n N_noxref_4_c_787_n N_noxref_4_c_819_n N_noxref_4_c_825_n \
 N_noxref_4_c_826_n N_noxref_4_c_788_n N_noxref_4_c_876_p N_noxref_4_c_877_p \
 N_noxref_4_c_833_n N_noxref_4_c_795_n N_noxref_4_c_835_n N_noxref_4_c_836_n \
 N_noxref_4_c_839_n N_noxref_4_c_796_n N_noxref_4_c_845_n N_noxref_4_c_797_n \
 N_noxref_4_c_879_p N_noxref_4_c_846_n N_noxref_4_c_850_n \
 N_noxref_4_M6_noxref_g N_noxref_4_M19_noxref_g N_noxref_4_M20_noxref_g \
 N_noxref_4_c_856_n N_noxref_4_c_859_n N_noxref_4_c_861_n N_noxref_4_c_901_p \
 N_noxref_4_c_1025_p N_noxref_4_c_1008_p N_noxref_4_c_864_n N_noxref_4_c_865_n \
 N_noxref_4_c_866_n N_noxref_4_c_1010_p N_noxref_4_c_869_n \
 N_noxref_4_M4_noxref_d N_noxref_4_M13_noxref_d N_noxref_4_M15_noxref_d )  \
 PM_MUX2X1\%noxref_4
x_PM_MUX2X1\%VDD ( VDD N_VDD_c_1061_n N_VDD_c_1066_n N_VDD_c_1069_n \
 N_VDD_c_1145_n N_VDD_c_1101_n N_VDD_c_1196_n N_VDD_c_1150_n N_VDD_c_1201_n \
 N_VDD_c_1072_n N_VDD_c_1077_n N_VDD_c_1111_n N_VDD_c_1160_n N_VDD_c_1116_n \
 N_VDD_M7_noxref_s N_VDD_M8_noxref_d N_VDD_M9_noxref_s N_VDD_M10_noxref_d \
 N_VDD_M12_noxref_d N_VDD_M13_noxref_s N_VDD_M14_noxref_d N_VDD_M16_noxref_d \
 N_VDD_M17_noxref_s N_VDD_M18_noxref_d N_VDD_M20_noxref_d )  PM_MUX2X1\%VDD
x_PM_MUX2X1\%A0 ( A0 A0 A0 A0 A0 A0 N_A0_c_1298_n N_A0_c_1301_n N_A0_c_1304_n \
 N_A0_c_1308_n N_A0_M2_noxref_g N_A0_M11_noxref_g N_A0_M12_noxref_g \
 N_A0_c_1314_n N_A0_c_1317_n N_A0_c_1319_n N_A0_c_1361_n N_A0_c_1364_n \
 N_A0_c_1366_n N_A0_c_1322_n N_A0_c_1323_n N_A0_c_1324_n N_A0_c_1377_n \
 N_A0_c_1327_n )  PM_MUX2X1\%A0
x_PM_MUX2X1\%A1 ( A1 A1 A1 A1 A1 A1 N_A1_c_1413_n N_A1_c_1416_n N_A1_c_1419_n \
 N_A1_c_1423_n N_A1_M4_noxref_g N_A1_M15_noxref_g N_A1_M16_noxref_g \
 N_A1_c_1429_n N_A1_c_1432_n N_A1_c_1434_n N_A1_c_1475_n N_A1_c_1478_n \
 N_A1_c_1480_n N_A1_c_1437_n N_A1_c_1438_n N_A1_c_1439_n N_A1_c_1491_n \
 N_A1_c_1442_n )  PM_MUX2X1\%A1
x_PM_MUX2X1\%GND ( GND N_GND_c_1519_n N_GND_c_1621_n N_GND_c_1665_n \
 N_GND_c_1669_n N_GND_c_1524_n N_GND_c_1535_n N_GND_c_1581_n N_GND_c_1590_n \
 N_GND_c_1630_n N_GND_c_1640_n N_GND_c_1538_n N_GND_c_1543_n N_GND_c_1735_p \
 N_GND_c_1544_n N_GND_c_1597_n N_GND_c_1598_n N_GND_c_1545_n N_GND_c_1550_n \
 N_GND_c_1603_n N_GND_c_1651_n N_GND_M0_noxref_s N_GND_M1_noxref_d \
 N_GND_M3_noxref_d N_GND_M5_noxref_d )  PM_MUX2X1\%GND
x_PM_MUX2X1\%Y ( Y Y Y Y Y Y Y Y N_Y_c_1790_n N_Y_c_1821_n N_Y_c_1827_n \
 N_Y_c_1828_n N_Y_c_1830_n N_Y_c_1791_n N_Y_c_1835_n N_Y_c_1872_n N_Y_c_1838_n \
 N_Y_c_1797_n N_Y_c_1845_n N_Y_M6_noxref_d N_Y_M17_noxref_d N_Y_M19_noxref_d ) \
 PM_MUX2X1\%Y
x_PM_MUX2X1\%noxref_10 ( N_noxref_10_c_1907_n N_noxref_10_c_1909_n \
 N_noxref_10_c_1950_n N_noxref_10_c_1917_n N_noxref_10_c_1924_n \
 N_noxref_10_c_1960_n N_noxref_10_M1_noxref_s )  PM_MUX2X1\%noxref_10
x_PM_MUX2X1\%noxref_11 ( N_noxref_11_c_1976_n N_noxref_11_c_1977_n \
 N_noxref_11_c_2019_n N_noxref_11_c_1984_n N_noxref_11_c_1994_n \
 N_noxref_11_c_2029_n N_noxref_11_M3_noxref_s )  PM_MUX2X1\%noxref_11
x_PM_MUX2X1\%noxref_12 ( N_noxref_12_c_2047_n N_noxref_12_c_2049_n \
 N_noxref_12_c_2079_n N_noxref_12_c_2057_n N_noxref_12_c_2066_n \
 N_noxref_12_c_2086_n N_noxref_12_M5_noxref_s )  PM_MUX2X1\%noxref_12
cc_1 ( N_S_c_1_p N_noxref_2_c_223_n ) capacitor c=0.0012792f //x=1.34 \
 //y=1.435 //x2=1.6 //y2=1.935
cc_2 ( N_S_c_2_p N_noxref_2_c_223_n ) capacitor c=0.00561986f //x=1.34 \
 //y=1.745 //x2=1.6 //y2=1.935
cc_3 ( N_S_c_3_p N_noxref_2_c_223_n ) capacitor c=0.00440271f //x=1.34 //y=2.1 \
 //x2=1.6 //y2=1.935
cc_4 ( N_S_c_4_p N_noxref_2_c_223_n ) capacitor c=0.00953922f //x=1.715 \
 //y=1.59 //x2=1.6 //y2=1.935
cc_5 ( N_S_c_5_p N_noxref_2_c_223_n ) capacitor c=0.00344663f //x=1.87 \
 //y=1.435 //x2=1.6 //y2=1.935
cc_6 ( N_S_M7_noxref_g N_noxref_2_c_228_n ) capacitor c=0.00141266f //x=1.385 \
 //y=6.2 //x2=1.605 //y2=5.42
cc_7 ( N_S_M8_noxref_g N_noxref_2_c_228_n ) capacitor c=0.0035262f //x=1.825 \
 //y=6.2 //x2=1.605 //y2=5.42
cc_8 ( N_S_c_4_p N_noxref_2_c_230_n ) capacitor c=0.00180253f //x=1.715 \
 //y=1.59 //x2=1.885 //y2=2.02
cc_9 ( N_S_c_9_p N_noxref_2_c_231_n ) capacitor c=0.00946645f //x=3.66 \
 //y=3.12 //x2=1.685 //y2=2.02
cc_10 ( N_S_c_10_p N_noxref_2_c_231_n ) capacitor c=0.00440271f //x=1.23 \
 //y=2.265 //x2=1.685 //y2=2.02
cc_11 ( N_S_M8_noxref_g N_noxref_2_c_233_n ) capacitor c=0.00943784f //x=1.825 \
 //y=6.2 //x2=1.885 //y2=5.14
cc_12 ( N_S_c_9_p N_noxref_2_c_234_n ) capacitor c=0.00479539f //x=3.66 \
 //y=3.12 //x2=1.69 //y2=5.14
cc_13 ( N_S_M7_noxref_g N_noxref_2_c_234_n ) capacitor c=0.00534267f //x=1.385 \
 //y=6.2 //x2=1.69 //y2=5.14
cc_14 ( N_S_c_14_p N_noxref_2_c_234_n ) capacitor c=0.00262283f //x=1.75 \
 //y=4.97 //x2=1.69 //y2=5.14
cc_15 ( S N_noxref_2_c_237_n ) capacitor c=0.0243781f //x=1.23 //y=2.77 \
 //x2=1.97 //y2=3.37
cc_16 ( S N_noxref_2_c_237_n ) capacitor c=0.00307216f //x=1.23 //y=3.51 \
 //x2=1.97 //y2=3.37
cc_17 ( S N_noxref_2_c_237_n ) capacitor c=0.00929985f //x=3.82 //y=2.4 \
 //x2=1.97 //y2=3.37
cc_18 ( S N_noxref_2_c_237_n ) capacitor c=0.0014142f //x=3.82 //y=3.88 \
 //x2=1.97 //y2=3.37
cc_19 ( S N_noxref_2_c_237_n ) capacitor c=5.62253e-19 //x=1.23 //y=3.14 \
 //x2=1.97 //y2=3.37
cc_20 ( N_S_c_20_p N_noxref_2_c_237_n ) capacitor c=0.0176785f //x=1.23 \
 //y=3.3 //x2=1.97 //y2=3.37
cc_21 ( N_S_c_21_p N_noxref_2_c_237_n ) capacitor c=0.00254755f //x=3.82 \
 //y=3.28 //x2=1.97 //y2=3.37
cc_22 ( N_S_c_22_p N_noxref_2_c_237_n ) capacitor c=0.0181783f //x=1.23 \
 //y=2.265 //x2=1.97 //y2=3.37
cc_23 ( N_S_c_23_p N_noxref_2_c_237_n ) capacitor c=0.00457386f //x=3.82 \
 //y=2.26 //x2=1.97 //y2=3.37
cc_24 ( N_S_c_24_p N_noxref_2_c_237_n ) capacitor c=0.0032735f //x=1.39 \
 //y=3.14 //x2=1.97 //y2=3.37
cc_25 ( N_S_c_25_p N_noxref_2_c_237_n ) capacitor c=0.00160717f //x=3.82 \
 //y=3.12 //x2=1.97 //y2=3.37
cc_26 ( N_S_c_9_p N_noxref_2_c_237_n ) capacitor c=0.0277399f //x=3.66 \
 //y=3.12 //x2=1.97 //y2=3.37
cc_27 ( N_S_c_27_p N_noxref_2_c_237_n ) capacitor c=4.71798e-19 //x=1.23 \
 //y=2.265 //x2=1.97 //y2=3.37
cc_28 ( N_S_c_10_p N_noxref_2_c_237_n ) capacitor c=0.00275704f //x=1.23 \
 //y=2.265 //x2=1.97 //y2=3.37
cc_29 ( S N_noxref_2_c_251_n ) capacitor c=0.0151957f //x=1.23 //y=3.51 \
 //x2=1.97 //y2=3.69
cc_30 ( S N_noxref_2_c_251_n ) capacitor c=0.00254755f //x=3.82 //y=3.88 \
 //x2=1.97 //y2=3.69
cc_31 ( N_S_c_9_p N_noxref_2_c_251_n ) capacitor c=0.0069774f //x=3.66 \
 //y=3.12 //x2=1.97 //y2=3.69
cc_32 ( S N_noxref_2_c_254_n ) capacitor c=0.0495328f //x=1.23 //y=3.51 \
 //x2=1.97 //y2=5.055
cc_33 ( S N_noxref_2_c_254_n ) capacitor c=0.0192326f //x=3.82 //y=3.88 \
 //x2=1.97 //y2=5.055
cc_34 ( N_S_c_34_p N_noxref_2_c_254_n ) capacitor c=0.0169388f //x=1.23 \
 //y=4.76 //x2=1.97 //y2=5.055
cc_35 ( N_S_c_35_p N_noxref_2_c_254_n ) capacitor c=0.00476843f //x=3.82 \
 //y=4.88 //x2=1.97 //y2=5.055
cc_36 ( N_S_c_36_p N_noxref_2_c_254_n ) capacitor c=0.00160039f //x=1.23 \
 //y=4.88 //x2=1.97 //y2=5.055
cc_37 ( N_S_c_14_p N_noxref_2_c_254_n ) capacitor c=0.00208891f //x=1.75 \
 //y=4.97 //x2=1.97 //y2=5.055
cc_38 ( N_S_c_38_p N_noxref_2_c_254_n ) capacitor c=0.00140024f //x=1.46 \
 //y=4.97 //x2=1.97 //y2=5.055
cc_39 ( N_S_c_9_p N_noxref_2_c_261_n ) capacitor c=4.71823e-19 //x=3.66 \
 //y=3.12 //x2=1.6 //y2=1.185
cc_40 ( N_S_c_40_p N_noxref_2_c_261_n ) capacitor c=0.00187726f //x=1.34 \
 //y=1.09 //x2=1.6 //y2=1.185
cc_41 ( N_S_c_1_p N_noxref_2_c_261_n ) capacitor c=0.00414335f //x=1.34 \
 //y=1.435 //x2=1.6 //y2=1.185
cc_42 ( N_S_c_42_p N_noxref_2_c_261_n ) capacitor c=5.57924e-19 //x=1.715 \
 //y=0.935 //x2=1.6 //y2=1.185
cc_43 ( N_S_c_4_p N_noxref_2_c_261_n ) capacitor c=5.75878e-19 //x=1.715 \
 //y=1.59 //x2=1.6 //y2=1.185
cc_44 ( N_S_c_44_p N_noxref_2_c_261_n ) capacitor c=0.00148146f //x=1.87 \
 //y=1.09 //x2=1.6 //y2=1.185
cc_45 ( N_S_c_5_p N_noxref_2_c_261_n ) capacitor c=0.00356478f //x=1.87 \
 //y=1.435 //x2=1.6 //y2=1.185
cc_46 ( S N_noxref_2_c_268_n ) capacitor c=0.00560445f //x=1.23 //y=3.51 \
 //x2=1.97 //y2=3.51
cc_47 ( S N_noxref_2_c_268_n ) capacitor c=2.11402e-19 //x=3.82 //y=3.88 \
 //x2=1.97 //y2=3.51
cc_48 ( S N_noxref_2_c_270_n ) capacitor c=0.00700934f //x=1.23 //y=3.51 \
 //x2=2.13 //y2=3.53
cc_49 ( S N_noxref_2_c_270_n ) capacitor c=0.00160717f //x=3.82 //y=3.88 \
 //x2=2.13 //y2=3.53
cc_50 ( N_S_c_9_p N_noxref_2_c_270_n ) capacitor c=0.0369869f //x=3.66 \
 //y=3.12 //x2=2.13 //y2=3.53
cc_51 ( S N_noxref_2_c_273_n ) capacitor c=0.027735f //x=3.82 //y=3.88 \
 //x2=6.99 //y2=3.52
cc_52 ( N_S_c_21_p N_noxref_2_c_273_n ) capacitor c=0.00622005f //x=3.82 \
 //y=3.28 //x2=6.99 //y2=3.52
cc_53 ( N_S_c_35_p N_noxref_2_c_273_n ) capacitor c=0.00180599f //x=3.82 \
 //y=4.88 //x2=6.99 //y2=3.52
cc_54 ( N_S_c_25_p N_noxref_2_c_273_n ) capacitor c=0.0369869f //x=3.82 \
 //y=3.12 //x2=6.99 //y2=3.52
cc_55 ( N_S_c_9_p N_noxref_2_c_273_n ) capacitor c=0.145292f //x=3.66 //y=3.12 \
 //x2=6.99 //y2=3.52
cc_56 ( N_S_M7_noxref_g N_noxref_2_c_278_n ) capacitor c=0.0162066f //x=1.385 \
 //y=6.2 //x2=1.605 //y2=5.56
cc_57 ( N_S_M8_noxref_g N_noxref_2_c_278_n ) capacitor c=0.0162066f //x=1.825 \
 //y=6.2 //x2=1.605 //y2=5.56
cc_58 ( N_S_c_14_p N_noxref_2_c_278_n ) capacitor c=0.00290963f //x=1.75 \
 //y=4.97 //x2=1.605 //y2=5.56
cc_59 ( N_S_c_40_p N_noxref_2_M0_noxref_d ) capacitor c=0.00137914f //x=1.34 \
 //y=1.09 //x2=1.415 //y2=1.09
cc_60 ( N_S_c_1_p N_noxref_2_M0_noxref_d ) capacitor c=0.0023891f //x=1.34 \
 //y=1.435 //x2=1.415 //y2=1.09
cc_61 ( N_S_c_42_p N_noxref_2_M0_noxref_d ) capacitor c=0.0020782f //x=1.715 \
 //y=0.935 //x2=1.415 //y2=1.09
cc_62 ( N_S_c_4_p N_noxref_2_M0_noxref_d ) capacitor c=0.00356097f //x=1.715 \
 //y=1.59 //x2=1.415 //y2=1.09
cc_63 ( N_S_c_44_p N_noxref_2_M0_noxref_d ) capacitor c=0.00138452f //x=1.87 \
 //y=1.09 //x2=1.415 //y2=1.09
cc_64 ( N_S_c_5_p N_noxref_2_M0_noxref_d ) capacitor c=0.00235934f //x=1.87 \
 //y=1.435 //x2=1.415 //y2=1.09
cc_65 ( N_S_M10_noxref_g N_noxref_3_c_479_n ) capacitor c=0.0108476f //x=4.16 \
 //y=6.2 //x2=4.705 //y2=5.38
cc_66 ( S N_noxref_3_c_480_n ) capacitor c=0.00261412f //x=3.82 //y=2.4 \
 //x2=5.3 //y2=2.96
cc_67 ( S N_noxref_3_c_481_n ) capacitor c=0.00414685f //x=3.82 //y=3.88 \
 //x2=5.3 //y2=5.295
cc_68 ( N_S_c_21_p N_noxref_3_c_482_n ) capacitor c=5.01534e-19 //x=3.82 \
 //y=3.28 //x2=3.94 //y2=5.56
cc_69 ( N_S_c_35_p N_noxref_3_c_482_n ) capacitor c=0.0118323f //x=3.82 \
 //y=4.88 //x2=3.94 //y2=5.56
cc_70 ( N_S_c_70_p N_noxref_3_c_482_n ) capacitor c=0.00277154f //x=3.82 \
 //y=4.88 //x2=3.94 //y2=5.56
cc_71 ( N_S_M9_noxref_g N_noxref_3_c_482_n ) capacitor c=0.00203628f //x=3.72 \
 //y=6.2 //x2=3.94 //y2=5.56
cc_72 ( N_S_M10_noxref_g N_noxref_3_c_482_n ) capacitor c=0.00192712f //x=4.16 \
 //y=6.2 //x2=3.94 //y2=5.56
cc_73 ( N_S_c_73_p N_noxref_3_c_482_n ) capacitor c=0.00196913f //x=3.82 \
 //y=4.88 //x2=3.94 //y2=5.56
cc_74 ( S N_noxref_3_c_488_n ) capacitor c=0.00251935f //x=3.82 //y=3.14 \
 //x2=5.3 //y2=3.14
cc_75 ( N_S_c_25_p N_noxref_3_c_489_n ) capacitor c=0.00541921f //x=3.82 \
 //y=3.12 //x2=5.46 //y2=3.12
cc_76 ( N_S_c_35_p N_noxref_3_c_490_n ) capacitor c=0.00104426f //x=3.82 \
 //y=4.88 //x2=3.94 //y2=5.56
cc_77 ( N_S_c_70_p N_noxref_3_c_490_n ) capacitor c=0.00377369f //x=3.82 \
 //y=4.88 //x2=3.94 //y2=5.56
cc_78 ( N_S_M9_noxref_g N_noxref_3_c_490_n ) capacitor c=0.0158358f //x=3.72 \
 //y=6.2 //x2=3.94 //y2=5.56
cc_79 ( N_S_M10_noxref_g N_noxref_3_c_490_n ) capacitor c=0.0178987f //x=4.16 \
 //y=6.2 //x2=3.94 //y2=5.56
cc_80 ( N_S_c_73_p N_noxref_3_c_490_n ) capacitor c=0.0043218f //x=3.82 \
 //y=4.88 //x2=3.94 //y2=5.56
cc_81 ( N_S_c_20_p N_VDD_c_1061_n ) capacitor c=2.36727e-19 //x=1.23 //y=3.3 \
 //x2=11.96 //y2=7.58
cc_82 ( N_S_c_34_p N_VDD_c_1061_n ) capacitor c=5.73169e-19 //x=1.23 //y=4.76 \
 //x2=11.96 //y2=7.58
cc_83 ( N_S_c_35_p N_VDD_c_1061_n ) capacitor c=9.07241e-19 //x=3.82 //y=4.88 \
 //x2=11.96 //y2=7.58
cc_84 ( N_S_c_36_p N_VDD_c_1061_n ) capacitor c=3.40755e-19 //x=1.23 //y=4.88 \
 //x2=11.96 //y2=7.58
cc_85 ( N_S_c_70_p N_VDD_c_1061_n ) capacitor c=6.22888e-19 //x=3.82 //y=4.88 \
 //x2=11.96 //y2=7.58
cc_86 ( N_S_c_34_p N_VDD_c_1066_n ) capacitor c=5.48929e-19 //x=1.23 //y=4.76 \
 //x2=1.96 //y2=7.585
cc_87 ( N_S_M7_noxref_g N_VDD_c_1066_n ) capacitor c=0.00753931f //x=1.385 \
 //y=6.2 //x2=1.96 //y2=7.585
cc_88 ( N_S_M8_noxref_g N_VDD_c_1066_n ) capacitor c=0.00755544f //x=1.825 \
 //y=6.2 //x2=1.96 //y2=7.585
cc_89 ( N_S_c_35_p N_VDD_c_1069_n ) capacitor c=6.28113e-19 //x=3.82 //y=4.88 \
 //x2=4.295 //y2=7.585
cc_90 ( N_S_M9_noxref_g N_VDD_c_1069_n ) capacitor c=0.00732618f //x=3.72 \
 //y=6.2 //x2=4.295 //y2=7.585
cc_91 ( N_S_M10_noxref_g N_VDD_c_1069_n ) capacitor c=0.00755544f //x=4.16 \
 //y=6.2 //x2=4.295 //y2=7.585
cc_92 ( S N_VDD_c_1072_n ) capacitor c=0.0140262f //x=1.23 //y=3.51 //x2=1.23 \
 //y2=7.58
cc_93 ( N_S_c_34_p N_VDD_c_1072_n ) capacitor c=0.00869686f //x=1.23 //y=4.76 \
 //x2=1.23 //y2=7.58
cc_94 ( N_S_c_36_p N_VDD_c_1072_n ) capacitor c=0.00795821f //x=1.23 //y=4.88 \
 //x2=1.23 //y2=7.58
cc_95 ( N_S_M7_noxref_g N_VDD_c_1072_n ) capacitor c=0.0186157f //x=1.385 \
 //y=6.2 //x2=1.23 //y2=7.58
cc_96 ( N_S_c_38_p N_VDD_c_1072_n ) capacitor c=0.00799922f //x=1.46 //y=4.97 \
 //x2=1.23 //y2=7.58
cc_97 ( S N_VDD_c_1077_n ) capacitor c=0.00733791f //x=3.82 //y=3.88 //x2=2.71 \
 //y2=7.585
cc_98 ( N_S_c_35_p N_VDD_c_1077_n ) capacitor c=0.00447349f //x=3.82 //y=4.88 \
 //x2=2.71 //y2=7.585
cc_99 ( N_S_c_36_p N_VDD_c_1077_n ) capacitor c=0.00235165f //x=1.23 //y=4.88 \
 //x2=2.71 //y2=7.585
cc_100 ( N_S_c_70_p N_VDD_c_1077_n ) capacitor c=0.00370494f //x=3.82 //y=4.88 \
 //x2=2.71 //y2=7.585
cc_101 ( N_S_c_14_p N_VDD_c_1077_n ) capacitor c=0.00780996f //x=1.75 //y=4.97 \
 //x2=2.71 //y2=7.585
cc_102 ( N_S_c_38_p N_VDD_c_1077_n ) capacitor c=2.63786e-19 //x=1.46 //y=4.97 \
 //x2=2.71 //y2=7.585
cc_103 ( N_S_c_73_p N_VDD_c_1077_n ) capacitor c=0.0121704f //x=3.82 //y=4.88 \
 //x2=2.71 //y2=7.585
cc_104 ( N_S_c_20_p N_VDD_M7_noxref_s ) capacitor c=8.04718e-19 //x=1.23 \
 //y=3.3 //x2=1.03 //y2=5.2
cc_105 ( N_S_c_34_p N_VDD_M7_noxref_s ) capacitor c=0.0211971f //x=1.23 \
 //y=4.76 //x2=1.03 //y2=5.2
cc_106 ( N_S_c_36_p N_VDD_M7_noxref_s ) capacitor c=0.00914073f //x=1.23 \
 //y=4.88 //x2=1.03 //y2=5.2
cc_107 ( N_S_M7_noxref_g N_VDD_M7_noxref_s ) capacitor c=0.0573441f //x=1.385 \
 //y=6.2 //x2=1.03 //y2=5.2
cc_108 ( N_S_c_38_p N_VDD_M7_noxref_s ) capacitor c=0.00526119f //x=1.46 \
 //y=4.97 //x2=1.03 //y2=5.2
cc_109 ( N_S_M8_noxref_g N_VDD_M8_noxref_d ) capacitor c=0.0572684f //x=1.825 \
 //y=6.2 //x2=1.9 //y2=5.2
cc_110 ( N_S_c_21_p N_VDD_M9_noxref_s ) capacitor c=9.04186e-19 //x=3.82 \
 //y=3.28 //x2=3.365 //y2=5.2
cc_111 ( N_S_M9_noxref_g N_VDD_M9_noxref_s ) capacitor c=0.0567929f //x=3.72 \
 //y=6.2 //x2=3.365 //y2=5.2
cc_112 ( N_S_M10_noxref_g N_VDD_M10_noxref_d ) capacitor c=0.015318f //x=4.16 \
 //y=6.2 //x2=4.235 //y2=5.2
cc_113 ( S A0 ) capacitor c=0.0242931f //x=3.82 //y=2.4 //x2=4.56 //y2=2.4
cc_114 ( S A0 ) capacitor c=0.0632049f //x=3.82 //y=3.88 //x2=4.56 //y2=2.4
cc_115 ( S A0 ) capacitor c=6.92705e-19 //x=3.82 //y=3.14 //x2=4.56 //y2=2.4
cc_116 ( N_S_c_21_p A0 ) capacitor c=0.0151778f //x=3.82 //y=3.28 //x2=4.56 \
 //y2=2.4
cc_117 ( N_S_c_25_p A0 ) capacitor c=0.00360383f //x=3.82 //y=3.12 //x2=4.56 \
 //y2=2.4
cc_118 ( N_S_c_118_p A0 ) capacitor c=3.49899e-19 //x=3.82 //y=2.26 //x2=4.56 \
 //y2=2.4
cc_119 ( N_S_c_70_p A0 ) capacitor c=3.02466e-19 //x=3.82 //y=4.88 //x2=4.56 \
 //y2=2.4
cc_120 ( N_S_c_73_p A0 ) capacitor c=0.00108965f //x=3.82 //y=4.88 //x2=4.56 \
 //y2=2.4
cc_121 ( N_S_c_35_p N_A0_c_1298_n ) capacitor c=0.0172958f //x=3.82 //y=4.88 \
 //x2=4.56 //y2=4.735
cc_122 ( N_S_c_70_p N_A0_c_1298_n ) capacitor c=4.73677e-19 //x=3.82 //y=4.88 \
 //x2=4.56 //y2=4.735
cc_123 ( N_S_c_73_p N_A0_c_1298_n ) capacitor c=9.22067e-19 //x=3.82 //y=4.88 \
 //x2=4.56 //y2=4.735
cc_124 ( N_S_c_23_p N_A0_c_1301_n ) capacitor c=0.0205342f //x=3.82 //y=2.26 \
 //x2=4.56 //y2=2.26
cc_125 ( N_S_c_118_p N_A0_c_1301_n ) capacitor c=5.16867e-19 //x=3.82 //y=2.26 \
 //x2=4.56 //y2=2.26
cc_126 ( N_S_c_126_p N_A0_c_1301_n ) capacitor c=0.00167888f //x=3.625 \
 //y=2.095 //x2=4.56 //y2=2.26
cc_127 ( S N_A0_c_1304_n ) capacitor c=3.49899e-19 //x=3.82 //y=2.4 //x2=4.56 \
 //y2=2.26
cc_128 ( N_S_c_23_p N_A0_c_1304_n ) capacitor c=5.24723e-19 //x=3.82 //y=2.26 \
 //x2=4.56 //y2=2.26
cc_129 ( N_S_c_118_p N_A0_c_1304_n ) capacitor c=0.00525888f //x=3.82 //y=2.26 \
 //x2=4.56 //y2=2.26
cc_130 ( N_S_c_126_p N_A0_c_1304_n ) capacitor c=0.00190888f //x=3.625 \
 //y=2.095 //x2=4.56 //y2=2.26
cc_131 ( N_S_c_35_p N_A0_c_1308_n ) capacitor c=4.80626e-19 //x=3.82 //y=4.88 \
 //x2=4.59 //y2=4.88
cc_132 ( N_S_c_70_p N_A0_c_1308_n ) capacitor c=0.00397338f //x=3.82 //y=4.88 \
 //x2=4.59 //y2=4.88
cc_133 ( N_S_c_73_p N_A0_c_1308_n ) capacitor c=0.00283894f //x=3.82 //y=4.88 \
 //x2=4.59 //y2=4.88
cc_134 ( N_S_M9_noxref_g N_A0_M11_noxref_g ) capacitor c=0.0104892f //x=3.72 \
 //y=6.2 //x2=4.6 //y2=6.2
cc_135 ( N_S_M10_noxref_g N_A0_M11_noxref_g ) capacitor c=0.107636f //x=4.16 \
 //y=6.2 //x2=4.6 //y2=6.2
cc_136 ( N_S_M10_noxref_g N_A0_M12_noxref_g ) capacitor c=0.0100341f //x=4.16 \
 //y=6.2 //x2=5.04 //y2=6.2
cc_137 ( N_S_c_137_p N_A0_c_1314_n ) capacitor c=4.86545e-19 //x=3.625 \
 //y=1.045 //x2=4.595 //y2=1.085
cc_138 ( N_S_c_138_p N_A0_c_1314_n ) capacitor c=0.00152405f //x=3.625 \
 //y=1.39 //x2=4.595 //y2=1.085
cc_139 ( N_S_c_139_p N_A0_c_1314_n ) capacitor c=0.0151475f //x=4.155 \
 //y=1.045 //x2=4.595 //y2=1.085
cc_140 ( N_S_c_140_p N_A0_c_1317_n ) capacitor c=0.00109982f //x=3.625 //y=1.7 \
 //x2=4.595 //y2=1.43
cc_141 ( N_S_c_141_p N_A0_c_1317_n ) capacitor c=0.0111064f //x=4.155 //y=1.39 \
 //x2=4.595 //y2=1.43
cc_142 ( N_S_c_140_p N_A0_c_1319_n ) capacitor c=9.58243e-19 //x=3.625 //y=1.7 \
 //x2=4.595 //y2=1.74
cc_143 ( N_S_c_126_p N_A0_c_1319_n ) capacitor c=0.00662747f //x=3.625 \
 //y=2.095 //x2=4.595 //y2=1.74
cc_144 ( N_S_c_141_p N_A0_c_1319_n ) capacitor c=0.00862358f //x=4.155 \
 //y=1.39 //x2=4.595 //y2=1.74
cc_145 ( N_S_c_139_p N_A0_c_1322_n ) capacitor c=0.00127211f //x=4.155 \
 //y=1.045 //x2=5.125 //y2=1.085
cc_146 ( N_S_c_141_p N_A0_c_1323_n ) capacitor c=0.00204774f //x=4.155 \
 //y=1.39 //x2=5.125 //y2=1.43
cc_147 ( N_S_c_23_p N_A0_c_1324_n ) capacitor c=0.00167305f //x=3.82 //y=2.26 \
 //x2=4.56 //y2=2.26
cc_148 ( N_S_c_118_p N_A0_c_1324_n ) capacitor c=0.0018937f //x=3.82 //y=2.26 \
 //x2=4.56 //y2=2.26
cc_149 ( N_S_c_126_p N_A0_c_1324_n ) capacitor c=0.0181449f //x=3.625 \
 //y=2.095 //x2=4.56 //y2=2.26
cc_150 ( N_S_c_35_p N_A0_c_1327_n ) capacitor c=0.00158715f //x=3.82 //y=4.88 \
 //x2=4.59 //y2=4.88
cc_151 ( N_S_c_70_p N_A0_c_1327_n ) capacitor c=0.00237977f //x=3.82 //y=4.88 \
 //x2=4.59 //y2=4.88
cc_152 ( N_S_c_73_p N_A0_c_1327_n ) capacitor c=0.0297875f //x=3.82 //y=4.88 \
 //x2=4.59 //y2=4.88
cc_153 ( N_S_c_20_p N_GND_c_1519_n ) capacitor c=3.89238e-19 //x=1.23 //y=3.3 \
 //x2=3.805 //y2=0.175
cc_154 ( N_S_c_21_p N_GND_c_1519_n ) capacitor c=4.06367e-19 //x=3.82 //y=3.28 \
 //x2=3.805 //y2=0.175
cc_155 ( N_S_c_22_p N_GND_c_1519_n ) capacitor c=0.00249122f //x=1.23 \
 //y=2.265 //x2=3.805 //y2=0.175
cc_156 ( N_S_c_23_p N_GND_c_1519_n ) capacitor c=6.6172e-19 //x=3.82 //y=2.26 \
 //x2=3.805 //y2=0.175
cc_157 ( N_S_c_27_p N_GND_c_1519_n ) capacitor c=7.5371e-19 //x=1.23 //y=2.265 \
 //x2=3.805 //y2=0.175
cc_158 ( N_S_c_21_p N_GND_c_1524_n ) capacitor c=2.36762e-19 //x=3.82 //y=3.28 \
 //x2=3.89 //y2=1.135
cc_159 ( N_S_c_23_p N_GND_c_1524_n ) capacitor c=0.00678151f //x=3.82 //y=2.26 \
 //x2=3.89 //y2=1.135
cc_160 ( N_S_c_25_p N_GND_c_1524_n ) capacitor c=0.00257254f //x=3.82 //y=3.12 \
 //x2=3.89 //y2=1.135
cc_161 ( N_S_c_118_p N_GND_c_1524_n ) capacitor c=2.13705e-19 //x=3.82 \
 //y=2.26 //x2=3.89 //y2=1.135
cc_162 ( N_S_c_137_p N_GND_c_1524_n ) capacitor c=0.00154831f //x=3.625 \
 //y=1.045 //x2=3.89 //y2=1.135
cc_163 ( N_S_c_138_p N_GND_c_1524_n ) capacitor c=0.00354198f //x=3.625 \
 //y=1.39 //x2=3.89 //y2=1.135
cc_164 ( N_S_c_140_p N_GND_c_1524_n ) capacitor c=4.2764e-19 //x=3.625 //y=1.7 \
 //x2=3.89 //y2=1.135
cc_165 ( N_S_c_165_p N_GND_c_1524_n ) capacitor c=7.35788e-19 //x=4 //y=0.89 \
 //x2=3.89 //y2=1.135
cc_166 ( N_S_c_166_p N_GND_c_1524_n ) capacitor c=6.22762e-19 //x=4 //y=1.545 \
 //x2=3.89 //y2=1.135
cc_167 ( N_S_c_139_p N_GND_c_1524_n ) capacitor c=0.00171721f //x=4.155 \
 //y=1.045 //x2=3.89 //y2=1.135
cc_168 ( N_S_c_141_p N_GND_c_1524_n ) capacitor c=0.00296337f //x=4.155 \
 //y=1.39 //x2=3.89 //y2=1.135
cc_169 ( N_S_c_137_p N_GND_c_1535_n ) capacitor c=3.51399e-19 //x=3.625 \
 //y=1.045 //x2=3.887 //y2=1.005
cc_170 ( N_S_c_165_p N_GND_c_1535_n ) capacitor c=0.00852202f //x=4 //y=0.89 \
 //x2=3.887 //y2=1.005
cc_171 ( N_S_c_139_p N_GND_c_1535_n ) capacitor c=4.40641e-19 //x=4.155 \
 //y=1.045 //x2=3.887 //y2=1.005
cc_172 ( N_S_c_20_p N_GND_c_1538_n ) capacitor c=5.03187e-19 //x=1.23 //y=3.3 \
 //x2=1.515 //y2=0.715
cc_173 ( N_S_c_22_p N_GND_c_1538_n ) capacitor c=0.00114179f //x=1.23 \
 //y=2.265 //x2=1.515 //y2=0.715
cc_174 ( N_S_c_27_p N_GND_c_1538_n ) capacitor c=3.95714e-19 //x=1.23 \
 //y=2.265 //x2=1.515 //y2=0.715
cc_175 ( N_S_c_40_p N_GND_c_1538_n ) capacitor c=0.0126466f //x=1.34 //y=1.09 \
 //x2=1.515 //y2=0.715
cc_176 ( N_S_c_10_p N_GND_c_1538_n ) capacitor c=2.1838e-19 //x=1.23 //y=2.265 \
 //x2=1.515 //y2=0.715
cc_177 ( N_S_c_44_p N_GND_c_1543_n ) capacitor c=0.0132669f //x=1.87 //y=1.09 \
 //x2=2.005 //y2=0.715
cc_178 ( N_S_c_137_p N_GND_c_1544_n ) capacitor c=0.00690758f //x=3.625 \
 //y=1.045 //x2=5.87 //y2=0.175
cc_179 ( S N_GND_c_1545_n ) capacitor c=0.0146622f //x=1.23 //y=2.77 //x2=1.12 \
 //y2=0.175
cc_180 ( N_S_c_22_p N_GND_c_1545_n ) capacitor c=0.0100674f //x=1.23 //y=2.265 \
 //x2=1.12 //y2=0.175
cc_181 ( N_S_c_27_p N_GND_c_1545_n ) capacitor c=0.00789228f //x=1.23 \
 //y=2.265 //x2=1.12 //y2=0.175
cc_182 ( N_S_c_3_p N_GND_c_1545_n ) capacitor c=0.00552086f //x=1.34 //y=2.1 \
 //x2=1.12 //y2=0.175
cc_183 ( N_S_c_10_p N_GND_c_1545_n ) capacitor c=0.00687518f //x=1.23 \
 //y=2.265 //x2=1.12 //y2=0.175
cc_184 ( S N_GND_c_1550_n ) capacitor c=0.00829739f //x=3.82 //y=2.4 //x2=2.71 \
 //y2=0.175
cc_185 ( N_S_c_23_p N_GND_c_1550_n ) capacitor c=0.00427323f //x=3.82 //y=2.26 \
 //x2=2.71 //y2=0.175
cc_186 ( N_S_c_9_p N_GND_c_1550_n ) capacitor c=0.00725442f //x=3.66 //y=3.12 \
 //x2=2.71 //y2=0.175
cc_187 ( N_S_c_27_p N_GND_c_1550_n ) capacitor c=0.0022444f //x=1.23 //y=2.265 \
 //x2=2.71 //y2=0.175
cc_188 ( N_S_c_118_p N_GND_c_1550_n ) capacitor c=0.0038607f //x=3.82 //y=2.26 \
 //x2=2.71 //y2=0.175
cc_189 ( N_S_c_126_p N_GND_c_1550_n ) capacitor c=0.00887845f //x=3.625 \
 //y=2.095 //x2=2.71 //y2=0.175
cc_190 ( N_S_c_10_p N_GND_c_1550_n ) capacitor c=2.63786e-19 //x=1.23 \
 //y=2.265 //x2=2.71 //y2=0.175
cc_191 ( N_S_c_20_p N_GND_M0_noxref_s ) capacitor c=6.43535e-19 //x=1.23 \
 //y=3.3 //x2=0.985 //y2=0.55
cc_192 ( N_S_c_22_p N_GND_M0_noxref_s ) capacitor c=0.00297876f //x=1.23 \
 //y=2.265 //x2=0.985 //y2=0.55
cc_193 ( N_S_c_9_p N_GND_M0_noxref_s ) capacitor c=0.00184893f //x=3.66 \
 //y=3.12 //x2=0.985 //y2=0.55
cc_194 ( N_S_c_27_p N_GND_M0_noxref_s ) capacitor c=0.00651326f //x=1.23 \
 //y=2.265 //x2=0.985 //y2=0.55
cc_195 ( N_S_c_40_p N_GND_M0_noxref_s ) capacitor c=0.0300221f //x=1.34 \
 //y=1.09 //x2=0.985 //y2=0.55
cc_196 ( N_S_c_2_p N_GND_M0_noxref_s ) capacitor c=0.002132f //x=1.34 \
 //y=1.745 //x2=0.985 //y2=0.55
cc_197 ( N_S_c_3_p N_GND_M0_noxref_s ) capacitor c=0.00304786f //x=1.34 \
 //y=2.1 //x2=0.985 //y2=0.55
cc_198 ( N_S_c_42_p N_GND_M0_noxref_s ) capacitor c=0.00521375f //x=1.715 \
 //y=0.935 //x2=0.985 //y2=0.55
cc_199 ( N_S_c_44_p N_GND_M0_noxref_s ) capacitor c=0.0153553f //x=1.87 \
 //y=1.09 //x2=0.985 //y2=0.55
cc_200 ( N_S_c_5_p N_GND_M0_noxref_s ) capacitor c=0.00629878f //x=1.87 \
 //y=1.435 //x2=0.985 //y2=0.55
cc_201 ( N_S_c_10_p N_GND_M0_noxref_s ) capacitor c=0.0065996f //x=1.23 \
 //y=2.265 //x2=0.985 //y2=0.55
cc_202 ( N_S_c_23_p N_GND_M1_noxref_d ) capacitor c=2.20438e-19 //x=3.82 \
 //y=2.26 //x2=3.7 //y2=1.045
cc_203 ( N_S_c_137_p N_GND_M1_noxref_d ) capacitor c=0.00192399f //x=3.625 \
 //y=1.045 //x2=3.7 //y2=1.045
cc_204 ( N_S_c_138_p N_GND_M1_noxref_d ) capacitor c=0.00210798f //x=3.625 \
 //y=1.39 //x2=3.7 //y2=1.045
cc_205 ( N_S_c_165_p N_GND_M1_noxref_d ) capacitor c=0.00472259f //x=4 \
 //y=0.89 //x2=3.7 //y2=1.045
cc_206 ( N_S_c_166_p N_GND_M1_noxref_d ) capacitor c=0.00166857f //x=4 \
 //y=1.545 //x2=3.7 //y2=1.045
cc_207 ( N_S_c_139_p N_GND_M1_noxref_d ) capacitor c=0.00230174f //x=4.155 \
 //y=1.045 //x2=3.7 //y2=1.045
cc_208 ( N_S_c_141_p N_GND_M1_noxref_d ) capacitor c=0.00210798f //x=4.155 \
 //y=1.39 //x2=3.7 //y2=1.045
cc_209 ( N_S_c_9_p N_noxref_10_c_1907_n ) capacitor c=0.00317601f //x=3.66 \
 //y=3.12 //x2=3.405 //y2=1.675
cc_210 ( N_S_c_126_p N_noxref_10_c_1907_n ) capacitor c=0.00262672f //x=3.625 \
 //y=2.095 //x2=3.405 //y2=1.675
cc_211 ( N_S_c_21_p N_noxref_10_c_1909_n ) capacitor c=0.00444167f //x=3.82 \
 //y=3.28 //x2=4.29 //y2=1.76
cc_212 ( N_S_c_23_p N_noxref_10_c_1909_n ) capacitor c=0.00459552f //x=3.82 \
 //y=2.26 //x2=4.29 //y2=1.76
cc_213 ( N_S_c_9_p N_noxref_10_c_1909_n ) capacitor c=0.00118517f //x=3.66 \
 //y=3.12 //x2=4.29 //y2=1.76
cc_214 ( N_S_c_118_p N_noxref_10_c_1909_n ) capacitor c=0.00763108f //x=3.82 \
 //y=2.26 //x2=4.29 //y2=1.76
cc_215 ( N_S_c_140_p N_noxref_10_c_1909_n ) capacitor c=0.00695869f //x=3.625 \
 //y=1.7 //x2=4.29 //y2=1.76
cc_216 ( N_S_c_126_p N_noxref_10_c_1909_n ) capacitor c=0.0175635f //x=3.625 \
 //y=2.095 //x2=4.29 //y2=1.76
cc_217 ( N_S_c_166_p N_noxref_10_c_1909_n ) capacitor c=0.00723574f //x=4 \
 //y=1.545 //x2=4.29 //y2=1.76
cc_218 ( N_S_c_141_p N_noxref_10_c_1909_n ) capacitor c=0.00339872f //x=4.155 \
 //y=1.39 //x2=4.29 //y2=1.76
cc_219 ( N_S_c_126_p N_noxref_10_c_1917_n ) capacitor c=6.71402e-19 //x=3.625 \
 //y=2.095 //x2=4.375 //y2=1.675
cc_220 ( N_S_c_137_p N_noxref_10_M1_noxref_s ) capacitor c=0.0294925f \
 //x=3.625 //y=1.045 //x2=3.27 //y2=0.545
cc_221 ( N_S_c_140_p N_noxref_10_M1_noxref_s ) capacitor c=3.48408e-19 \
 //x=3.625 //y=1.7 //x2=3.27 //y2=0.545
cc_222 ( N_S_c_139_p N_noxref_10_M1_noxref_s ) capacitor c=0.0125442f \
 //x=4.155 //y=1.045 //x2=3.27 //y2=0.545
cc_223 ( N_noxref_2_c_223_n N_noxref_3_c_495_n ) capacitor c=0.00495291f \
 //x=1.6 //y=1.935 //x2=4.86 //y2=1.75
cc_224 ( N_noxref_2_c_261_n N_noxref_3_c_495_n ) capacitor c=4.16137e-19 \
 //x=1.6 //y=1.185 //x2=4.86 //y2=1.75
cc_225 ( N_noxref_2_c_273_n N_noxref_3_c_497_n ) capacitor c=0.00651645f \
 //x=6.99 //y=3.52 //x2=4.945 //y2=1.835
cc_226 ( N_noxref_2_c_230_n N_noxref_3_c_480_n ) capacitor c=0.00198397f \
 //x=1.885 //y=2.02 //x2=5.3 //y2=2.96
cc_227 ( N_noxref_2_c_291_p N_noxref_3_c_480_n ) capacitor c=0.00929985f \
 //x=7.15 //y=3.36 //x2=5.3 //y2=2.96
cc_228 ( N_noxref_2_c_292_p N_noxref_3_c_480_n ) capacitor c=0.00457386f \
 //x=7.15 //y=2.26 //x2=5.3 //y2=2.96
cc_229 ( N_noxref_2_c_291_p N_noxref_3_c_501_n ) capacitor c=0.00256905f \
 //x=7.15 //y=3.36 //x2=5.3 //y2=3.28
cc_230 ( N_noxref_2_c_273_n N_noxref_3_c_501_n ) capacitor c=0.00857174f \
 //x=6.99 //y=3.52 //x2=5.3 //y2=3.28
cc_231 ( N_noxref_2_c_228_n N_noxref_3_c_481_n ) capacitor c=6.68558e-19 \
 //x=1.605 //y=5.42 //x2=5.3 //y2=5.295
cc_232 ( N_noxref_2_c_254_n N_noxref_3_c_481_n ) capacitor c=0.00212579f \
 //x=1.97 //y=5.055 //x2=5.3 //y2=5.295
cc_233 ( N_noxref_2_c_291_p N_noxref_3_c_481_n ) capacitor c=0.00129137f \
 //x=7.15 //y=3.36 //x2=5.3 //y2=5.295
cc_234 ( N_noxref_2_c_298_p N_noxref_3_c_481_n ) capacitor c=0.00254639f \
 //x=7.15 //y=3.68 //x2=5.3 //y2=5.295
cc_235 ( N_noxref_2_c_299_p N_noxref_3_c_481_n ) capacitor c=0.00476843f \
 //x=7.15 //y=4.88 //x2=5.3 //y2=5.295
cc_236 ( N_noxref_2_c_300_p N_noxref_3_c_481_n ) capacitor c=0.0194346f \
 //x=7.152 //y=4.74 //x2=5.3 //y2=5.295
cc_237 ( N_noxref_2_c_301_p N_noxref_3_c_481_n ) capacitor c=0.00158959f \
 //x=7.15 //y=3.52 //x2=5.3 //y2=5.295
cc_238 ( N_noxref_2_c_273_n N_noxref_3_c_481_n ) capacitor c=0.0292806f \
 //x=6.99 //y=3.52 //x2=5.3 //y2=5.295
cc_239 ( N_noxref_2_c_228_n N_noxref_3_c_482_n ) capacitor c=6.32156e-19 \
 //x=1.605 //y=5.42 //x2=3.94 //y2=5.56
cc_240 ( N_noxref_2_c_273_n N_noxref_3_c_482_n ) capacitor c=0.0131021f \
 //x=6.99 //y=3.52 //x2=3.94 //y2=5.56
cc_241 ( N_noxref_2_c_273_n N_noxref_3_c_513_n ) capacitor c=0.00981136f \
 //x=6.99 //y=3.52 //x2=4.82 //y2=5.38
cc_242 ( N_noxref_2_c_261_n N_noxref_3_c_514_n ) capacitor c=6.80839e-19 \
 //x=1.6 //y=1.185 //x2=4.86 //y2=1.18
cc_243 ( N_noxref_2_c_291_p N_noxref_3_c_515_n ) capacitor c=3.24031e-19 \
 //x=7.15 //y=3.36 //x2=6.765 //y2=3.14
cc_244 ( N_noxref_2_c_298_p N_noxref_3_c_515_n ) capacitor c=0.00244307f \
 //x=7.15 //y=3.68 //x2=6.765 //y2=3.14
cc_245 ( N_noxref_2_c_273_n N_noxref_3_c_515_n ) capacitor c=0.144922f \
 //x=6.99 //y=3.52 //x2=6.765 //y2=3.14
cc_246 ( N_noxref_2_c_291_p N_noxref_3_c_518_n ) capacitor c=0.0268444f \
 //x=7.15 //y=3.36 //x2=7.365 //y2=3.13
cc_247 ( N_noxref_2_c_298_p N_noxref_3_c_518_n ) capacitor c=0.00472421f \
 //x=7.15 //y=3.68 //x2=7.365 //y2=3.13
cc_248 ( N_noxref_2_c_292_p N_noxref_3_c_518_n ) capacitor c=0.00245317f \
 //x=7.15 //y=2.26 //x2=7.365 //y2=3.13
cc_249 ( N_noxref_2_c_301_p N_noxref_3_c_518_n ) capacitor c=0.0369869f \
 //x=7.15 //y=3.52 //x2=7.365 //y2=3.13
cc_250 ( N_noxref_2_c_291_p N_noxref_3_c_489_n ) capacitor c=0.00150178f \
 //x=7.15 //y=3.36 //x2=5.46 //y2=3.12
cc_251 ( N_noxref_2_c_273_n N_noxref_3_c_489_n ) capacitor c=0.0369869f \
 //x=6.99 //y=3.52 //x2=5.46 //y2=3.12
cc_252 ( N_noxref_2_M14_noxref_g N_noxref_4_c_785_n ) capacitor c=0.0129249f \
 //x=7.49 //y=6.2 //x2=8.035 //y2=5.38
cc_253 ( N_noxref_2_c_291_p N_noxref_4_c_786_n ) capacitor c=0.00351945f \
 //x=7.15 //y=3.36 //x2=8.63 //y2=3.36
cc_254 ( N_noxref_2_c_300_p N_noxref_4_c_787_n ) capacitor c=0.00325019f \
 //x=7.152 //y=4.74 //x2=8.63 //y2=5.295
cc_255 ( N_noxref_2_c_298_p N_noxref_4_c_788_n ) capacitor c=6.41839e-19 \
 //x=7.15 //y=3.68 //x2=7.27 //y2=5.56
cc_256 ( N_noxref_2_c_299_p N_noxref_4_c_788_n ) capacitor c=0.01183f //x=7.15 \
 //y=4.88 //x2=7.27 //y2=5.56
cc_257 ( N_noxref_2_c_301_p N_noxref_4_c_788_n ) capacitor c=4.40123e-19 \
 //x=7.15 //y=3.52 //x2=7.27 //y2=5.56
cc_258 ( N_noxref_2_c_322_p N_noxref_4_c_788_n ) capacitor c=0.00277154f \
 //x=7.15 //y=4.88 //x2=7.27 //y2=5.56
cc_259 ( N_noxref_2_M13_noxref_g N_noxref_4_c_788_n ) capacitor c=0.00201806f \
 //x=7.05 //y=6.2 //x2=7.27 //y2=5.56
cc_260 ( N_noxref_2_M14_noxref_g N_noxref_4_c_788_n ) capacitor c=0.00192712f \
 //x=7.49 //y=6.2 //x2=7.27 //y2=5.56
cc_261 ( N_noxref_2_c_325_p N_noxref_4_c_788_n ) capacitor c=0.00192579f \
 //x=7.15 //y=4.88 //x2=7.27 //y2=5.56
cc_262 ( N_noxref_2_c_326_p N_noxref_4_c_795_n ) capacitor c=0.00251935f \
 //x=7.15 //y=3.51 //x2=8.63 //y2=3.51
cc_263 ( N_noxref_2_c_301_p N_noxref_4_c_796_n ) capacitor c=0.00541849f \
 //x=7.15 //y=3.52 //x2=8.79 //y2=3.52
cc_264 ( N_noxref_2_c_299_p N_noxref_4_c_797_n ) capacitor c=0.00104426f \
 //x=7.15 //y=4.88 //x2=7.27 //y2=5.56
cc_265 ( N_noxref_2_c_322_p N_noxref_4_c_797_n ) capacitor c=0.00377369f \
 //x=7.15 //y=4.88 //x2=7.27 //y2=5.56
cc_266 ( N_noxref_2_M13_noxref_g N_noxref_4_c_797_n ) capacitor c=0.0158358f \
 //x=7.05 //y=6.2 //x2=7.27 //y2=5.56
cc_267 ( N_noxref_2_M14_noxref_g N_noxref_4_c_797_n ) capacitor c=0.0178987f \
 //x=7.49 //y=6.2 //x2=7.27 //y2=5.56
cc_268 ( N_noxref_2_c_325_p N_noxref_4_c_797_n ) capacitor c=0.0043218f \
 //x=7.15 //y=4.88 //x2=7.27 //y2=5.56
cc_269 ( N_noxref_2_c_228_n N_VDD_c_1061_n ) capacitor c=0.00259718f //x=1.605 \
 //y=5.42 //x2=11.96 //y2=7.58
cc_270 ( N_noxref_2_c_233_n N_VDD_c_1061_n ) capacitor c=0.00266633f //x=1.885 \
 //y=5.14 //x2=11.96 //y2=7.58
cc_271 ( N_noxref_2_c_299_p N_VDD_c_1061_n ) capacitor c=9.07241e-19 //x=7.15 \
 //y=4.88 //x2=11.96 //y2=7.58
cc_272 ( N_noxref_2_c_278_n N_VDD_c_1061_n ) capacitor c=0.00241566f //x=1.605 \
 //y=5.56 //x2=11.96 //y2=7.58
cc_273 ( N_noxref_2_c_322_p N_VDD_c_1061_n ) capacitor c=6.22888e-19 //x=7.15 \
 //y=4.88 //x2=11.96 //y2=7.58
cc_274 ( N_noxref_2_c_228_n N_VDD_c_1066_n ) capacitor c=0.00100699f //x=1.605 \
 //y=5.42 //x2=1.96 //y2=7.585
cc_275 ( N_noxref_2_c_233_n N_VDD_c_1066_n ) capacitor c=0.00197507f //x=1.885 \
 //y=5.14 //x2=1.96 //y2=7.585
cc_276 ( N_noxref_2_c_278_n N_VDD_c_1066_n ) capacitor c=0.0138017f //x=1.605 \
 //y=5.56 //x2=1.96 //y2=7.585
cc_277 ( N_noxref_2_c_299_p N_VDD_c_1101_n ) capacitor c=6.28113e-19 //x=7.15 \
 //y=4.88 //x2=7.625 //y2=7.585
cc_278 ( N_noxref_2_M13_noxref_g N_VDD_c_1101_n ) capacitor c=0.00732618f \
 //x=7.05 //y=6.2 //x2=7.625 //y2=7.585
cc_279 ( N_noxref_2_M14_noxref_g N_VDD_c_1101_n ) capacitor c=0.00755544f \
 //x=7.49 //y=6.2 //x2=7.625 //y2=7.585
cc_280 ( N_noxref_2_c_234_n N_VDD_c_1072_n ) capacitor c=0.00685597f //x=1.69 \
 //y=5.14 //x2=1.23 //y2=7.58
cc_281 ( N_noxref_2_c_254_n N_VDD_c_1072_n ) capacitor c=2.43252e-19 //x=1.97 \
 //y=5.055 //x2=1.23 //y2=7.58
cc_282 ( N_noxref_2_c_278_n N_VDD_c_1072_n ) capacitor c=0.00823838f //x=1.605 \
 //y=5.56 //x2=1.23 //y2=7.58
cc_283 ( N_noxref_2_c_228_n N_VDD_c_1077_n ) capacitor c=0.00231872f //x=1.605 \
 //y=5.42 //x2=2.71 //y2=7.585
cc_284 ( N_noxref_2_c_254_n N_VDD_c_1077_n ) capacitor c=0.022346f //x=1.97 \
 //y=5.055 //x2=2.71 //y2=7.585
cc_285 ( N_noxref_2_c_273_n N_VDD_c_1077_n ) capacitor c=0.00501359f //x=6.99 \
 //y=3.52 //x2=2.71 //y2=7.585
cc_286 ( N_noxref_2_c_278_n N_VDD_c_1077_n ) capacitor c=0.00824867f //x=1.605 \
 //y=5.56 //x2=2.71 //y2=7.585
cc_287 ( N_noxref_2_c_299_p N_VDD_c_1111_n ) capacitor c=0.00447349f //x=7.15 \
 //y=4.88 //x2=6.04 //y2=7.585
cc_288 ( N_noxref_2_c_300_p N_VDD_c_1111_n ) capacitor c=0.00733791f //x=7.152 \
 //y=4.74 //x2=6.04 //y2=7.585
cc_289 ( N_noxref_2_c_273_n N_VDD_c_1111_n ) capacitor c=0.00501359f //x=6.99 \
 //y=3.52 //x2=6.04 //y2=7.585
cc_290 ( N_noxref_2_c_322_p N_VDD_c_1111_n ) capacitor c=0.00370494f //x=7.15 \
 //y=4.88 //x2=6.04 //y2=7.585
cc_291 ( N_noxref_2_c_325_p N_VDD_c_1111_n ) capacitor c=0.0129564f //x=7.15 \
 //y=4.88 //x2=6.04 //y2=7.585
cc_292 ( N_noxref_2_c_278_n N_VDD_c_1116_n ) capacitor c=0.00135089f //x=1.605 \
 //y=5.56 //x2=11.96 //y2=7.58
cc_293 ( N_noxref_2_c_228_n N_VDD_M7_noxref_s ) capacitor c=0.0480012f \
 //x=1.605 //y=5.42 //x2=1.03 //y2=5.2
cc_294 ( N_noxref_2_c_278_n N_VDD_M7_noxref_s ) capacitor c=0.0922749f \
 //x=1.605 //y=5.56 //x2=1.03 //y2=5.2
cc_295 ( N_noxref_2_c_228_n N_VDD_M8_noxref_d ) capacitor c=0.0474638f \
 //x=1.605 //y=5.42 //x2=1.9 //y2=5.2
cc_296 ( N_noxref_2_c_233_n N_VDD_M8_noxref_d ) capacitor c=0.0212582f \
 //x=1.885 //y=5.14 //x2=1.9 //y2=5.2
cc_297 ( N_noxref_2_c_251_n N_VDD_M8_noxref_d ) capacitor c=0.00236125f \
 //x=1.97 //y=3.69 //x2=1.9 //y2=5.2
cc_298 ( N_noxref_2_c_268_n N_VDD_M8_noxref_d ) capacitor c=3.07461e-19 \
 //x=1.97 //y=3.51 //x2=1.9 //y2=5.2
cc_299 ( N_noxref_2_c_270_n N_VDD_M8_noxref_d ) capacitor c=7.86037e-19 \
 //x=2.13 //y=3.53 //x2=1.9 //y2=5.2
cc_300 ( N_noxref_2_c_273_n N_VDD_M8_noxref_d ) capacitor c=3.76077e-19 \
 //x=6.99 //y=3.52 //x2=1.9 //y2=5.2
cc_301 ( N_noxref_2_c_278_n N_VDD_M8_noxref_d ) capacitor c=0.0911955f \
 //x=1.605 //y=5.56 //x2=1.9 //y2=5.2
cc_302 ( N_noxref_2_c_228_n N_VDD_M9_noxref_s ) capacitor c=0.00155698f \
 //x=1.605 //y=5.42 //x2=3.365 //y2=5.2
cc_303 ( N_noxref_2_c_273_n N_VDD_M9_noxref_s ) capacitor c=0.0037282f \
 //x=6.99 //y=3.52 //x2=3.365 //y2=5.2
cc_304 ( N_noxref_2_c_298_p N_VDD_M13_noxref_s ) capacitor c=0.0010689f \
 //x=7.15 //y=3.68 //x2=6.695 //y2=5.2
cc_305 ( N_noxref_2_c_273_n N_VDD_M13_noxref_s ) capacitor c=0.00359545f \
 //x=6.99 //y=3.52 //x2=6.695 //y2=5.2
cc_306 ( N_noxref_2_M13_noxref_g N_VDD_M13_noxref_s ) capacitor c=0.0567929f \
 //x=7.05 //y=6.2 //x2=6.695 //y2=5.2
cc_307 ( N_noxref_2_M14_noxref_g N_VDD_M14_noxref_d ) capacitor c=0.015318f \
 //x=7.49 //y=6.2 //x2=7.565 //y2=5.2
cc_308 ( N_noxref_2_c_237_n A0 ) capacitor c=0.00284096f //x=1.97 //y=3.37 \
 //x2=4.56 //y2=2.4
cc_309 ( N_noxref_2_c_254_n A0 ) capacitor c=0.00238388f //x=1.97 //y=5.055 \
 //x2=4.56 //y2=2.4
cc_310 ( N_noxref_2_c_291_p A0 ) capacitor c=0.00277806f //x=7.15 //y=3.36 \
 //x2=4.56 //y2=2.4
cc_311 ( N_noxref_2_c_300_p A0 ) capacitor c=0.00209698f //x=7.152 //y=4.74 \
 //x2=4.56 //y2=2.4
cc_312 ( N_noxref_2_c_273_n A0 ) capacitor c=0.0308183f //x=6.99 //y=3.52 \
 //x2=4.56 //y2=2.4
cc_313 ( N_noxref_2_c_273_n N_A0_c_1298_n ) capacitor c=0.00219107f //x=6.99 \
 //y=3.52 //x2=4.56 //y2=4.735
cc_314 ( N_noxref_2_c_273_n N_A0_c_1301_n ) capacitor c=0.00255328f //x=6.99 \
 //y=3.52 //x2=4.56 //y2=2.26
cc_315 ( N_noxref_2_c_291_p A1 ) capacitor c=0.0394956f //x=7.15 //y=3.36 \
 //x2=7.89 //y2=2.4
cc_316 ( N_noxref_2_c_298_p A1 ) capacitor c=0.0148747f //x=7.15 //y=3.68 \
 //x2=7.89 //y2=2.4
cc_317 ( N_noxref_2_c_326_p A1 ) capacitor c=6.02403e-19 //x=7.15 //y=3.51 \
 //x2=7.89 //y2=2.4
cc_318 ( N_noxref_2_c_300_p A1 ) capacitor c=0.0480316f //x=7.152 //y=4.74 \
 //x2=7.89 //y2=2.4
cc_319 ( N_noxref_2_c_301_p A1 ) capacitor c=0.00360246f //x=7.15 //y=3.52 \
 //x2=7.89 //y2=2.4
cc_320 ( N_noxref_2_c_384_p A1 ) capacitor c=3.49899e-19 //x=7.15 //y=2.26 \
 //x2=7.89 //y2=2.4
cc_321 ( N_noxref_2_c_322_p A1 ) capacitor c=3.02422e-19 //x=7.15 //y=4.88 \
 //x2=7.89 //y2=2.4
cc_322 ( N_noxref_2_c_325_p A1 ) capacitor c=0.00108965f //x=7.15 //y=4.88 \
 //x2=7.89 //y2=2.4
cc_323 ( N_noxref_2_c_299_p N_A1_c_1413_n ) capacitor c=0.0172958f //x=7.15 \
 //y=4.88 //x2=7.89 //y2=4.735
cc_324 ( N_noxref_2_c_322_p N_A1_c_1413_n ) capacitor c=4.73677e-19 //x=7.15 \
 //y=4.88 //x2=7.89 //y2=4.735
cc_325 ( N_noxref_2_c_325_p N_A1_c_1413_n ) capacitor c=9.22067e-19 //x=7.15 \
 //y=4.88 //x2=7.89 //y2=4.735
cc_326 ( N_noxref_2_c_292_p N_A1_c_1416_n ) capacitor c=0.0205342f //x=7.15 \
 //y=2.26 //x2=7.89 //y2=2.26
cc_327 ( N_noxref_2_c_384_p N_A1_c_1416_n ) capacitor c=5.16867e-19 //x=7.15 \
 //y=2.26 //x2=7.89 //y2=2.26
cc_328 ( N_noxref_2_c_392_p N_A1_c_1416_n ) capacitor c=0.00167888f //x=6.955 \
 //y=2.095 //x2=7.89 //y2=2.26
cc_329 ( N_noxref_2_c_291_p N_A1_c_1419_n ) capacitor c=3.49899e-19 //x=7.15 \
 //y=3.36 //x2=7.89 //y2=2.26
cc_330 ( N_noxref_2_c_292_p N_A1_c_1419_n ) capacitor c=5.24723e-19 //x=7.15 \
 //y=2.26 //x2=7.89 //y2=2.26
cc_331 ( N_noxref_2_c_384_p N_A1_c_1419_n ) capacitor c=0.00525888f //x=7.15 \
 //y=2.26 //x2=7.89 //y2=2.26
cc_332 ( N_noxref_2_c_392_p N_A1_c_1419_n ) capacitor c=0.00190888f //x=6.955 \
 //y=2.095 //x2=7.89 //y2=2.26
cc_333 ( N_noxref_2_c_299_p N_A1_c_1423_n ) capacitor c=4.80626e-19 //x=7.15 \
 //y=4.88 //x2=7.92 //y2=4.88
cc_334 ( N_noxref_2_c_322_p N_A1_c_1423_n ) capacitor c=0.00397338f //x=7.15 \
 //y=4.88 //x2=7.92 //y2=4.88
cc_335 ( N_noxref_2_c_325_p N_A1_c_1423_n ) capacitor c=0.00283894f //x=7.15 \
 //y=4.88 //x2=7.92 //y2=4.88
cc_336 ( N_noxref_2_M13_noxref_g N_A1_M15_noxref_g ) capacitor c=0.0104892f \
 //x=7.05 //y=6.2 //x2=7.93 //y2=6.2
cc_337 ( N_noxref_2_M14_noxref_g N_A1_M15_noxref_g ) capacitor c=0.107636f \
 //x=7.49 //y=6.2 //x2=7.93 //y2=6.2
cc_338 ( N_noxref_2_M14_noxref_g N_A1_M16_noxref_g ) capacitor c=0.0100341f \
 //x=7.49 //y=6.2 //x2=8.37 //y2=6.2
cc_339 ( N_noxref_2_c_403_p N_A1_c_1429_n ) capacitor c=4.86545e-19 //x=6.955 \
 //y=1.045 //x2=7.925 //y2=1.085
cc_340 ( N_noxref_2_c_404_p N_A1_c_1429_n ) capacitor c=0.00152405f //x=6.955 \
 //y=1.39 //x2=7.925 //y2=1.085
cc_341 ( N_noxref_2_c_405_p N_A1_c_1429_n ) capacitor c=0.0151475f //x=7.485 \
 //y=1.045 //x2=7.925 //y2=1.085
cc_342 ( N_noxref_2_c_406_p N_A1_c_1432_n ) capacitor c=0.00109982f //x=6.955 \
 //y=1.7 //x2=7.925 //y2=1.43
cc_343 ( N_noxref_2_c_407_p N_A1_c_1432_n ) capacitor c=0.0111064f //x=7.485 \
 //y=1.39 //x2=7.925 //y2=1.43
cc_344 ( N_noxref_2_c_406_p N_A1_c_1434_n ) capacitor c=9.58243e-19 //x=6.955 \
 //y=1.7 //x2=7.925 //y2=1.74
cc_345 ( N_noxref_2_c_392_p N_A1_c_1434_n ) capacitor c=0.00662747f //x=6.955 \
 //y=2.095 //x2=7.925 //y2=1.74
cc_346 ( N_noxref_2_c_407_p N_A1_c_1434_n ) capacitor c=0.00862358f //x=7.485 \
 //y=1.39 //x2=7.925 //y2=1.74
cc_347 ( N_noxref_2_c_405_p N_A1_c_1437_n ) capacitor c=0.00127211f //x=7.485 \
 //y=1.045 //x2=8.455 //y2=1.085
cc_348 ( N_noxref_2_c_407_p N_A1_c_1438_n ) capacitor c=0.00204774f //x=7.485 \
 //y=1.39 //x2=8.455 //y2=1.43
cc_349 ( N_noxref_2_c_292_p N_A1_c_1439_n ) capacitor c=0.00167305f //x=7.15 \
 //y=2.26 //x2=7.89 //y2=2.26
cc_350 ( N_noxref_2_c_384_p N_A1_c_1439_n ) capacitor c=0.0018937f //x=7.15 \
 //y=2.26 //x2=7.89 //y2=2.26
cc_351 ( N_noxref_2_c_392_p N_A1_c_1439_n ) capacitor c=0.0181449f //x=6.955 \
 //y=2.095 //x2=7.89 //y2=2.26
cc_352 ( N_noxref_2_c_299_p N_A1_c_1442_n ) capacitor c=0.00158715f //x=7.15 \
 //y=4.88 //x2=7.92 //y2=4.88
cc_353 ( N_noxref_2_c_322_p N_A1_c_1442_n ) capacitor c=0.00237977f //x=7.15 \
 //y=4.88 //x2=7.92 //y2=4.88
cc_354 ( N_noxref_2_c_325_p N_A1_c_1442_n ) capacitor c=0.0297875f //x=7.15 \
 //y=4.88 //x2=7.92 //y2=4.88
cc_355 ( N_noxref_2_c_230_n N_GND_c_1519_n ) capacitor c=0.00499608f //x=1.885 \
 //y=2.02 //x2=3.805 //y2=0.175
cc_356 ( N_noxref_2_c_251_n N_GND_c_1519_n ) capacitor c=5.20683e-19 //x=1.97 \
 //y=3.69 //x2=3.805 //y2=0.175
cc_357 ( N_noxref_2_c_261_n N_GND_c_1519_n ) capacitor c=0.00998676f //x=1.6 \
 //y=1.185 //x2=3.805 //y2=0.175
cc_358 ( N_noxref_2_c_268_n N_GND_c_1519_n ) capacitor c=2.38608e-19 //x=1.97 \
 //y=3.51 //x2=3.805 //y2=0.175
cc_359 ( N_noxref_2_M0_noxref_d N_GND_c_1519_n ) capacitor c=0.00119455f \
 //x=1.415 //y=1.09 //x2=3.805 //y2=0.175
cc_360 ( N_noxref_2_c_261_n N_GND_c_1524_n ) capacitor c=0.00524331f //x=1.6 \
 //y=1.185 //x2=3.89 //y2=1.135
cc_361 ( N_noxref_2_c_292_p N_GND_c_1581_n ) capacitor c=0.00681067f //x=7.15 \
 //y=2.26 //x2=7.22 //y2=1.135
cc_362 ( N_noxref_2_c_384_p N_GND_c_1581_n ) capacitor c=2.13705e-19 //x=7.15 \
 //y=2.26 //x2=7.22 //y2=1.135
cc_363 ( N_noxref_2_c_403_p N_GND_c_1581_n ) capacitor c=0.00171023f //x=6.955 \
 //y=1.045 //x2=7.22 //y2=1.135
cc_364 ( N_noxref_2_c_404_p N_GND_c_1581_n ) capacitor c=0.00357815f //x=6.955 \
 //y=1.39 //x2=7.22 //y2=1.135
cc_365 ( N_noxref_2_c_406_p N_GND_c_1581_n ) capacitor c=4.2764e-19 //x=6.955 \
 //y=1.7 //x2=7.22 //y2=1.135
cc_366 ( N_noxref_2_c_430_p N_GND_c_1581_n ) capacitor c=9.36995e-19 //x=7.33 \
 //y=0.89 //x2=7.22 //y2=1.135
cc_367 ( N_noxref_2_c_431_p N_GND_c_1581_n ) capacitor c=6.27576e-19 //x=7.33 \
 //y=1.545 //x2=7.22 //y2=1.135
cc_368 ( N_noxref_2_c_405_p N_GND_c_1581_n ) capacitor c=0.00171721f //x=7.485 \
 //y=1.045 //x2=7.22 //y2=1.135
cc_369 ( N_noxref_2_c_407_p N_GND_c_1581_n ) capacitor c=0.00296337f //x=7.485 \
 //y=1.39 //x2=7.22 //y2=1.135
cc_370 ( N_noxref_2_c_403_p N_GND_c_1590_n ) capacitor c=3.46594e-19 //x=6.955 \
 //y=1.045 //x2=7.217 //y2=1.005
cc_371 ( N_noxref_2_c_430_p N_GND_c_1590_n ) capacitor c=0.00839795f //x=7.33 \
 //y=0.89 //x2=7.217 //y2=1.005
cc_372 ( N_noxref_2_c_405_p N_GND_c_1590_n ) capacitor c=4.40641e-19 //x=7.485 \
 //y=1.045 //x2=7.217 //y2=1.005
cc_373 ( N_noxref_2_c_261_n N_GND_c_1538_n ) capacitor c=0.00127339f //x=1.6 \
 //y=1.185 //x2=1.515 //y2=0.715
cc_374 ( N_noxref_2_c_230_n N_GND_c_1543_n ) capacitor c=0.00315908f //x=1.885 \
 //y=2.02 //x2=2.005 //y2=0.715
cc_375 ( N_noxref_2_c_261_n N_GND_c_1543_n ) capacitor c=0.00130539f //x=1.6 \
 //y=1.185 //x2=2.005 //y2=0.715
cc_376 ( N_noxref_2_c_268_n N_GND_c_1543_n ) capacitor c=2.81376e-19 //x=1.97 \
 //y=3.51 //x2=2.005 //y2=0.715
cc_377 ( N_noxref_2_c_403_p N_GND_c_1597_n ) capacitor c=0.00688027f //x=6.955 \
 //y=1.045 //x2=9.2 //y2=0.175
cc_378 ( N_noxref_2_c_261_n N_GND_c_1598_n ) capacitor c=2.8029e-19 //x=1.6 \
 //y=1.185 //x2=11.96 //y2=0.18
cc_379 ( N_noxref_2_M0_noxref_d N_GND_c_1598_n ) capacitor c=2.70835e-19 \
 //x=1.415 //y=1.09 //x2=11.96 //y2=0.18
cc_380 ( N_noxref_2_c_223_n N_GND_c_1545_n ) capacitor c=0.00520602f //x=1.6 \
 //y=1.935 //x2=1.12 //y2=0.175
cc_381 ( N_noxref_2_c_237_n N_GND_c_1545_n ) capacitor c=2.14154e-19 //x=1.97 \
 //y=3.37 //x2=1.12 //y2=0.175
cc_382 ( N_noxref_2_c_230_n N_GND_c_1550_n ) capacitor c=0.0230294f //x=1.885 \
 //y=2.02 //x2=2.71 //y2=0.175
cc_383 ( N_noxref_2_c_291_p N_GND_c_1603_n ) capacitor c=0.00829739f //x=7.15 \
 //y=3.36 //x2=6.04 //y2=0.175
cc_384 ( N_noxref_2_c_292_p N_GND_c_1603_n ) capacitor c=0.00427323f //x=7.15 \
 //y=2.26 //x2=6.04 //y2=0.175
cc_385 ( N_noxref_2_c_384_p N_GND_c_1603_n ) capacitor c=0.00369427f //x=7.15 \
 //y=2.26 //x2=6.04 //y2=0.175
cc_386 ( N_noxref_2_c_406_p N_GND_c_1603_n ) capacitor c=0.0015404f //x=6.955 \
 //y=1.7 //x2=6.04 //y2=0.175
cc_387 ( N_noxref_2_c_392_p N_GND_c_1603_n ) capacitor c=0.00950704f //x=6.955 \
 //y=2.095 //x2=6.04 //y2=0.175
cc_388 ( N_noxref_2_c_223_n N_GND_M0_noxref_s ) capacitor c=0.0339428f //x=1.6 \
 //y=1.935 //x2=0.985 //y2=0.55
cc_389 ( N_noxref_2_c_230_n N_GND_M0_noxref_s ) capacitor c=0.00386445f \
 //x=1.885 //y=2.02 //x2=0.985 //y2=0.55
cc_390 ( N_noxref_2_c_251_n N_GND_M0_noxref_s ) capacitor c=0.00140579f \
 //x=1.97 //y=3.69 //x2=0.985 //y2=0.55
cc_391 ( N_noxref_2_c_261_n N_GND_M0_noxref_s ) capacitor c=0.0157322f //x=1.6 \
 //y=1.185 //x2=0.985 //y2=0.55
cc_392 ( N_noxref_2_c_268_n N_GND_M0_noxref_s ) capacitor c=7.90336e-19 \
 //x=1.97 //y=3.51 //x2=0.985 //y2=0.55
cc_393 ( N_noxref_2_M0_noxref_d N_GND_M0_noxref_s ) capacitor c=0.0377642f \
 //x=1.415 //y=1.09 //x2=0.985 //y2=0.55
cc_394 ( N_noxref_2_c_292_p N_GND_M3_noxref_d ) capacitor c=2.20438e-19 \
 //x=7.15 //y=2.26 //x2=7.03 //y2=1.045
cc_395 ( N_noxref_2_c_403_p N_GND_M3_noxref_d ) capacitor c=0.00192399f \
 //x=6.955 //y=1.045 //x2=7.03 //y2=1.045
cc_396 ( N_noxref_2_c_404_p N_GND_M3_noxref_d ) capacitor c=0.00210798f \
 //x=6.955 //y=1.39 //x2=7.03 //y2=1.045
cc_397 ( N_noxref_2_c_430_p N_GND_M3_noxref_d ) capacitor c=0.00472259f \
 //x=7.33 //y=0.89 //x2=7.03 //y2=1.045
cc_398 ( N_noxref_2_c_431_p N_GND_M3_noxref_d ) capacitor c=0.00166857f \
 //x=7.33 //y=1.545 //x2=7.03 //y2=1.045
cc_399 ( N_noxref_2_c_405_p N_GND_M3_noxref_d ) capacitor c=0.00230174f \
 //x=7.485 //y=1.045 //x2=7.03 //y2=1.045
cc_400 ( N_noxref_2_c_407_p N_GND_M3_noxref_d ) capacitor c=0.00210798f \
 //x=7.485 //y=1.39 //x2=7.03 //y2=1.045
cc_401 ( N_noxref_2_c_273_n N_noxref_10_c_1909_n ) capacitor c=0.00417624f \
 //x=6.99 //y=3.52 //x2=4.29 //y2=1.76
cc_402 ( N_noxref_2_c_273_n N_noxref_10_c_1917_n ) capacitor c=0.00225522f \
 //x=6.99 //y=3.52 //x2=4.375 //y2=1.675
cc_403 ( N_noxref_2_c_392_p N_noxref_11_c_1976_n ) capacitor c=0.00262672f \
 //x=6.955 //y=2.095 //x2=6.735 //y2=1.675
cc_404 ( N_noxref_2_c_298_p N_noxref_11_c_1977_n ) capacitor c=0.00405959f \
 //x=7.15 //y=3.68 //x2=7.62 //y2=1.76
cc_405 ( N_noxref_2_c_292_p N_noxref_11_c_1977_n ) capacitor c=0.00509504f \
 //x=7.15 //y=2.26 //x2=7.62 //y2=1.76
cc_406 ( N_noxref_2_c_384_p N_noxref_11_c_1977_n ) capacitor c=0.00763108f \
 //x=7.15 //y=2.26 //x2=7.62 //y2=1.76
cc_407 ( N_noxref_2_c_406_p N_noxref_11_c_1977_n ) capacitor c=0.00697076f \
 //x=6.955 //y=1.7 //x2=7.62 //y2=1.76
cc_408 ( N_noxref_2_c_392_p N_noxref_11_c_1977_n ) capacitor c=0.017926f \
 //x=6.955 //y=2.095 //x2=7.62 //y2=1.76
cc_409 ( N_noxref_2_c_431_p N_noxref_11_c_1977_n ) capacitor c=0.00723574f \
 //x=7.33 //y=1.545 //x2=7.62 //y2=1.76
cc_410 ( N_noxref_2_c_407_p N_noxref_11_c_1977_n ) capacitor c=0.00339872f \
 //x=7.485 //y=1.39 //x2=7.62 //y2=1.76
cc_411 ( N_noxref_2_c_392_p N_noxref_11_c_1984_n ) capacitor c=6.71402e-19 \
 //x=6.955 //y=2.095 //x2=7.705 //y2=1.675
cc_412 ( N_noxref_2_c_403_p N_noxref_11_M3_noxref_s ) capacitor c=0.0294925f \
 //x=6.955 //y=1.045 //x2=6.6 //y2=0.545
cc_413 ( N_noxref_2_c_406_p N_noxref_11_M3_noxref_s ) capacitor c=3.48408e-19 \
 //x=6.955 //y=1.7 //x2=6.6 //y2=0.545
cc_414 ( N_noxref_2_c_405_p N_noxref_11_M3_noxref_s ) capacitor c=0.0125442f \
 //x=7.485 //y=1.045 //x2=6.6 //y2=0.545
cc_415 ( N_noxref_3_c_495_n N_noxref_4_c_802_n ) capacitor c=0.00324213f \
 //x=4.86 //y=1.75 //x2=8.19 //y2=1.75
cc_416 ( N_noxref_3_c_525_p N_noxref_4_c_803_n ) capacitor c=0.00434482f \
 //x=8.245 //y=3.14 //x2=8.545 //y2=1.835
cc_417 ( N_noxref_3_c_526_p N_noxref_4_c_804_n ) capacitor c=0.00231467f \
 //x=5.215 //y=1.835 //x2=8.275 //y2=1.835
cc_418 ( N_noxref_3_c_525_p N_noxref_4_c_804_n ) capacitor c=0.00482943f \
 //x=8.245 //y=3.14 //x2=8.275 //y2=1.835
cc_419 ( N_noxref_3_c_480_n N_noxref_4_c_786_n ) capacitor c=0.00204244f \
 //x=5.3 //y=2.96 //x2=8.63 //y2=3.36
cc_420 ( N_noxref_3_c_529_p N_noxref_4_c_786_n ) capacitor c=0.00929985f \
 //x=10.48 //y=2.96 //x2=8.63 //y2=3.36
cc_421 ( N_noxref_3_c_530_p N_noxref_4_c_786_n ) capacitor c=0.00257908f \
 //x=10.48 //y=3.28 //x2=8.63 //y2=3.36
cc_422 ( N_noxref_3_c_531_p N_noxref_4_c_786_n ) capacitor c=2.11402e-19 \
 //x=10.48 //y=3.14 //x2=8.63 //y2=3.36
cc_423 ( N_noxref_3_c_532_p N_noxref_4_c_786_n ) capacitor c=0.00457386f \
 //x=10.48 //y=2.26 //x2=8.63 //y2=3.36
cc_424 ( N_noxref_3_c_533_p N_noxref_4_c_786_n ) capacitor c=0.00129144f \
 //x=10.482 //y=4.74 //x2=8.63 //y2=3.36
cc_425 ( N_noxref_3_c_525_p N_noxref_4_c_786_n ) capacitor c=2.15578e-19 \
 //x=8.245 //y=3.14 //x2=8.63 //y2=3.36
cc_426 ( N_noxref_3_c_535_p N_noxref_4_c_786_n ) capacitor c=0.030056f \
 //x=8.845 //y=3.13 //x2=8.63 //y2=3.36
cc_427 ( N_noxref_3_c_533_p N_noxref_4_c_814_n ) capacitor c=0.00254639f \
 //x=10.482 //y=4.74 //x2=8.63 //y2=3.68
cc_428 ( N_noxref_3_c_535_p N_noxref_4_c_814_n ) capacitor c=0.00802904f \
 //x=8.845 //y=3.13 //x2=8.63 //y2=3.68
cc_429 ( N_noxref_3_c_481_n N_noxref_4_c_787_n ) capacitor c=0.00281705f \
 //x=5.3 //y=5.295 //x2=8.63 //y2=5.295
cc_430 ( N_noxref_3_c_539_p N_noxref_4_c_787_n ) capacitor c=0.00476843f \
 //x=10.48 //y=4.88 //x2=8.63 //y2=5.295
cc_431 ( N_noxref_3_c_533_p N_noxref_4_c_787_n ) capacitor c=0.0194346f \
 //x=10.482 //y=4.74 //x2=8.63 //y2=5.295
cc_432 ( N_noxref_3_c_529_p N_noxref_4_c_819_n ) capacitor c=0.0242931f \
 //x=10.48 //y=2.96 //x2=11.22 //y2=3.35
cc_433 ( N_noxref_3_c_530_p N_noxref_4_c_819_n ) capacitor c=0.0148049f \
 //x=10.48 //y=3.28 //x2=11.22 //y2=3.35
cc_434 ( N_noxref_3_c_531_p N_noxref_4_c_819_n ) capacitor c=0.00103412f \
 //x=10.48 //y=3.14 //x2=11.22 //y2=3.35
cc_435 ( N_noxref_3_c_533_p N_noxref_4_c_819_n ) capacitor c=0.00302581f \
 //x=10.482 //y=4.74 //x2=11.22 //y2=3.35
cc_436 ( N_noxref_3_c_535_p N_noxref_4_c_819_n ) capacitor c=0.0069403f \
 //x=8.845 //y=3.13 //x2=11.22 //y2=3.35
cc_437 ( N_noxref_3_c_546_p N_noxref_4_c_819_n ) capacitor c=3.49899e-19 \
 //x=10.48 //y=2.26 //x2=11.22 //y2=3.35
cc_438 ( N_noxref_3_c_533_p N_noxref_4_c_825_n ) capacitor c=0.0173413f \
 //x=10.482 //y=4.74 //x2=11.22 //y2=3.67
cc_439 ( N_noxref_3_c_539_p N_noxref_4_c_826_n ) capacitor c=0.0172958f \
 //x=10.48 //y=4.88 //x2=11.22 //y2=4.735
cc_440 ( N_noxref_3_c_533_p N_noxref_4_c_826_n ) capacitor c=0.0484678f \
 //x=10.482 //y=4.74 //x2=11.22 //y2=4.735
cc_441 ( N_noxref_3_c_550_p N_noxref_4_c_826_n ) capacitor c=7.76099e-19 \
 //x=10.48 //y=4.88 //x2=11.22 //y2=4.735
cc_442 ( N_noxref_3_c_551_p N_noxref_4_c_826_n ) capacitor c=0.00201171f \
 //x=10.48 //y=4.88 //x2=11.22 //y2=4.735
cc_443 ( N_noxref_3_c_552_p N_noxref_4_c_788_n ) capacitor c=0.00114153f \
 //x=5.215 //y=5.38 //x2=7.27 //y2=5.56
cc_444 ( N_noxref_3_c_513_n N_noxref_4_c_788_n ) capacitor c=5.29822e-19 \
 //x=4.82 //y=5.38 //x2=7.27 //y2=5.56
cc_445 ( N_noxref_3_c_554_p N_noxref_4_c_788_n ) capacitor c=0.00147119f \
 //x=4.82 //y=5.56 //x2=7.27 //y2=5.56
cc_446 ( N_noxref_3_c_514_n N_noxref_4_c_833_n ) capacitor c=6.99317e-19 \
 //x=4.86 //y=1.18 //x2=8.19 //y2=1.18
cc_447 ( N_noxref_3_c_525_p N_noxref_4_c_833_n ) capacitor c=4.69652e-19 \
 //x=8.245 //y=3.14 //x2=8.19 //y2=1.18
cc_448 ( N_noxref_3_c_533_p N_noxref_4_c_835_n ) capacitor c=5.62253e-19 \
 //x=10.482 //y=4.74 //x2=11.22 //y2=3.51
cc_449 ( N_noxref_3_c_532_p N_noxref_4_c_836_n ) capacitor c=0.0205342f \
 //x=10.48 //y=2.26 //x2=11.22 //y2=2.26
cc_450 ( N_noxref_3_c_546_p N_noxref_4_c_836_n ) capacitor c=5.16867e-19 \
 //x=10.48 //y=2.26 //x2=11.22 //y2=2.26
cc_451 ( N_noxref_3_c_560_p N_noxref_4_c_836_n ) capacitor c=0.00167888f \
 //x=10.285 //y=2.095 //x2=11.22 //y2=2.26
cc_452 ( N_noxref_3_c_530_p N_noxref_4_c_839_n ) capacitor c=0.0060726f \
 //x=10.48 //y=3.28 //x2=11.06 //y2=3.51
cc_453 ( N_noxref_3_c_539_p N_noxref_4_c_839_n ) capacitor c=0.00180599f \
 //x=10.48 //y=4.88 //x2=11.06 //y2=3.51
cc_454 ( N_noxref_3_c_533_p N_noxref_4_c_839_n ) capacitor c=0.0266467f \
 //x=10.482 //y=4.74 //x2=11.06 //y2=3.51
cc_455 ( N_noxref_3_c_535_p N_noxref_4_c_839_n ) capacitor c=0.181163f \
 //x=8.845 //y=3.13 //x2=11.06 //y2=3.51
cc_456 ( N_noxref_3_c_533_p N_noxref_4_c_796_n ) capacitor c=0.00158959f \
 //x=10.482 //y=4.74 //x2=8.79 //y2=3.52
cc_457 ( N_noxref_3_c_535_p N_noxref_4_c_796_n ) capacitor c=0.0369869f \
 //x=8.845 //y=3.13 //x2=8.79 //y2=3.52
cc_458 ( N_noxref_3_c_533_p N_noxref_4_c_845_n ) capacitor c=0.0032735f \
 //x=10.482 //y=4.74 //x2=11.22 //y2=3.51
cc_459 ( N_noxref_3_c_529_p N_noxref_4_c_846_n ) capacitor c=3.49899e-19 \
 //x=10.48 //y=2.96 //x2=11.22 //y2=2.26
cc_460 ( N_noxref_3_c_532_p N_noxref_4_c_846_n ) capacitor c=5.24723e-19 \
 //x=10.48 //y=2.26 //x2=11.22 //y2=2.26
cc_461 ( N_noxref_3_c_546_p N_noxref_4_c_846_n ) capacitor c=0.00445529f \
 //x=10.48 //y=2.26 //x2=11.22 //y2=2.26
cc_462 ( N_noxref_3_c_560_p N_noxref_4_c_846_n ) capacitor c=0.00267961f \
 //x=10.285 //y=2.095 //x2=11.22 //y2=2.26
cc_463 ( N_noxref_3_c_539_p N_noxref_4_c_850_n ) capacitor c=4.80626e-19 \
 //x=10.48 //y=4.88 //x2=11.25 //y2=4.88
cc_464 ( N_noxref_3_c_550_p N_noxref_4_c_850_n ) capacitor c=0.00397338f \
 //x=10.48 //y=4.88 //x2=11.25 //y2=4.88
cc_465 ( N_noxref_3_c_551_p N_noxref_4_c_850_n ) capacitor c=0.00283894f \
 //x=10.48 //y=4.88 //x2=11.25 //y2=4.88
cc_466 ( N_noxref_3_M17_noxref_g N_noxref_4_M19_noxref_g ) capacitor \
 c=0.0104892f //x=10.38 //y=6.2 //x2=11.26 //y2=6.2
cc_467 ( N_noxref_3_M18_noxref_g N_noxref_4_M19_noxref_g ) capacitor \
 c=0.107636f //x=10.82 //y=6.2 //x2=11.26 //y2=6.2
cc_468 ( N_noxref_3_M18_noxref_g N_noxref_4_M20_noxref_g ) capacitor \
 c=0.0100341f //x=10.82 //y=6.2 //x2=11.7 //y2=6.2
cc_469 ( N_noxref_3_c_578_p N_noxref_4_c_856_n ) capacitor c=4.86545e-19 \
 //x=10.285 //y=1.045 //x2=11.255 //y2=1.085
cc_470 ( N_noxref_3_c_579_p N_noxref_4_c_856_n ) capacitor c=0.00152405f \
 //x=10.285 //y=1.39 //x2=11.255 //y2=1.085
cc_471 ( N_noxref_3_c_580_p N_noxref_4_c_856_n ) capacitor c=0.0151475f \
 //x=10.815 //y=1.045 //x2=11.255 //y2=1.085
cc_472 ( N_noxref_3_c_581_p N_noxref_4_c_859_n ) capacitor c=0.00109982f \
 //x=10.285 //y=1.7 //x2=11.255 //y2=1.43
cc_473 ( N_noxref_3_c_582_p N_noxref_4_c_859_n ) capacitor c=0.0111064f \
 //x=10.815 //y=1.39 //x2=11.255 //y2=1.43
cc_474 ( N_noxref_3_c_581_p N_noxref_4_c_861_n ) capacitor c=9.58243e-19 \
 //x=10.285 //y=1.7 //x2=11.255 //y2=1.74
cc_475 ( N_noxref_3_c_560_p N_noxref_4_c_861_n ) capacitor c=0.00662747f \
 //x=10.285 //y=2.095 //x2=11.255 //y2=1.74
cc_476 ( N_noxref_3_c_582_p N_noxref_4_c_861_n ) capacitor c=0.00862358f \
 //x=10.815 //y=1.39 //x2=11.255 //y2=1.74
cc_477 ( N_noxref_3_c_580_p N_noxref_4_c_864_n ) capacitor c=0.00127211f \
 //x=10.815 //y=1.045 //x2=11.785 //y2=1.085
cc_478 ( N_noxref_3_c_582_p N_noxref_4_c_865_n ) capacitor c=0.00204774f \
 //x=10.815 //y=1.39 //x2=11.785 //y2=1.43
cc_479 ( N_noxref_3_c_532_p N_noxref_4_c_866_n ) capacitor c=0.00167305f \
 //x=10.48 //y=2.26 //x2=11.22 //y2=2.26
cc_480 ( N_noxref_3_c_546_p N_noxref_4_c_866_n ) capacitor c=0.00266443f \
 //x=10.48 //y=2.26 //x2=11.22 //y2=2.26
cc_481 ( N_noxref_3_c_560_p N_noxref_4_c_866_n ) capacitor c=0.0181449f \
 //x=10.285 //y=2.095 //x2=11.22 //y2=2.26
cc_482 ( N_noxref_3_c_539_p N_noxref_4_c_869_n ) capacitor c=0.00158715f \
 //x=10.48 //y=4.88 //x2=11.25 //y2=4.88
cc_483 ( N_noxref_3_c_550_p N_noxref_4_c_869_n ) capacitor c=0.00237977f \
 //x=10.48 //y=4.88 //x2=11.25 //y2=4.88
cc_484 ( N_noxref_3_c_551_p N_noxref_4_c_869_n ) capacitor c=0.0297875f \
 //x=10.48 //y=4.88 //x2=11.25 //y2=4.88
cc_485 ( N_noxref_3_c_479_n N_VDD_c_1061_n ) capacitor c=0.00648307f //x=4.705 \
 //y=5.38 //x2=11.96 //y2=7.58
cc_486 ( N_noxref_3_c_552_p N_VDD_c_1061_n ) capacitor c=0.00492584f //x=5.215 \
 //y=5.38 //x2=11.96 //y2=7.58
cc_487 ( N_noxref_3_c_501_n N_VDD_c_1061_n ) capacitor c=4.17519e-19 //x=5.3 \
 //y=3.28 //x2=11.96 //y2=7.58
cc_488 ( N_noxref_3_c_482_n N_VDD_c_1061_n ) capacitor c=0.00368834f //x=3.94 \
 //y=5.56 //x2=11.96 //y2=7.58
cc_489 ( N_noxref_3_c_513_n N_VDD_c_1061_n ) capacitor c=8.42709e-19 //x=4.82 \
 //y=5.38 //x2=11.96 //y2=7.58
cc_490 ( N_noxref_3_c_554_p N_VDD_c_1061_n ) capacitor c=0.00285853f //x=4.82 \
 //y=5.56 //x2=11.96 //y2=7.58
cc_491 ( N_noxref_3_c_539_p N_VDD_c_1061_n ) capacitor c=9.07241e-19 //x=10.48 \
 //y=4.88 //x2=11.96 //y2=7.58
cc_492 ( N_noxref_3_c_490_n N_VDD_c_1061_n ) capacitor c=0.00224881f //x=3.94 \
 //y=5.56 //x2=11.96 //y2=7.58
cc_493 ( N_noxref_3_c_602_p N_VDD_c_1061_n ) capacitor c=0.00224881f //x=4.82 \
 //y=5.56 //x2=11.96 //y2=7.58
cc_494 ( N_noxref_3_c_550_p N_VDD_c_1061_n ) capacitor c=6.22888e-19 //x=10.48 \
 //y=4.88 //x2=11.96 //y2=7.58
cc_495 ( N_noxref_3_c_479_n N_VDD_c_1069_n ) capacitor c=0.00208087f //x=4.705 \
 //y=5.38 //x2=4.295 //y2=7.585
cc_496 ( N_noxref_3_c_482_n N_VDD_c_1069_n ) capacitor c=9.99055e-19 //x=3.94 \
 //y=5.56 //x2=4.295 //y2=7.585
cc_497 ( N_noxref_3_c_490_n N_VDD_c_1069_n ) capacitor c=0.0136705f //x=3.94 \
 //y=5.56 //x2=4.295 //y2=7.585
cc_498 ( N_noxref_3_c_479_n N_VDD_c_1145_n ) capacitor c=0.00180737f //x=4.705 \
 //y=5.38 //x2=5.175 //y2=7.585
cc_499 ( N_noxref_3_c_552_p N_VDD_c_1145_n ) capacitor c=0.00208087f //x=5.215 \
 //y=5.38 //x2=5.175 //y2=7.585
cc_500 ( N_noxref_3_c_513_n N_VDD_c_1145_n ) capacitor c=5.39459e-19 //x=4.82 \
 //y=5.38 //x2=5.175 //y2=7.585
cc_501 ( N_noxref_3_c_554_p N_VDD_c_1145_n ) capacitor c=5.77976e-19 //x=4.82 \
 //y=5.56 //x2=5.175 //y2=7.585
cc_502 ( N_noxref_3_c_602_p N_VDD_c_1145_n ) capacitor c=0.0136705f //x=4.82 \
 //y=5.56 //x2=5.175 //y2=7.585
cc_503 ( N_noxref_3_c_539_p N_VDD_c_1150_n ) capacitor c=6.28113e-19 //x=10.48 \
 //y=4.88 //x2=10.955 //y2=7.585
cc_504 ( N_noxref_3_M17_noxref_g N_VDD_c_1150_n ) capacitor c=0.00732618f \
 //x=10.38 //y=6.2 //x2=10.955 //y2=7.585
cc_505 ( N_noxref_3_M18_noxref_g N_VDD_c_1150_n ) capacitor c=0.00755544f \
 //x=10.82 //y=6.2 //x2=10.955 //y2=7.585
cc_506 ( N_noxref_3_c_481_n N_VDD_c_1077_n ) capacitor c=0.00133592f //x=5.3 \
 //y=5.295 //x2=2.71 //y2=7.585
cc_507 ( N_noxref_3_c_482_n N_VDD_c_1077_n ) capacitor c=5.11447e-19 //x=3.94 \
 //y=5.56 //x2=2.71 //y2=7.585
cc_508 ( N_noxref_3_c_490_n N_VDD_c_1077_n ) capacitor c=0.0064135f //x=3.94 \
 //y=5.56 //x2=2.71 //y2=7.585
cc_509 ( N_noxref_3_c_481_n N_VDD_c_1111_n ) capacitor c=0.0307343f //x=5.3 \
 //y=5.295 //x2=6.04 //y2=7.585
cc_510 ( N_noxref_3_c_513_n N_VDD_c_1111_n ) capacitor c=0.00240948f //x=4.82 \
 //y=5.38 //x2=6.04 //y2=7.585
cc_511 ( N_noxref_3_c_554_p N_VDD_c_1111_n ) capacitor c=4.09141e-19 //x=4.82 \
 //y=5.56 //x2=6.04 //y2=7.585
cc_512 ( N_noxref_3_c_602_p N_VDD_c_1111_n ) capacitor c=0.0101861f //x=4.82 \
 //y=5.56 //x2=6.04 //y2=7.585
cc_513 ( N_noxref_3_c_539_p N_VDD_c_1160_n ) capacitor c=0.00447349f //x=10.48 \
 //y=4.88 //x2=9.37 //y2=7.585
cc_514 ( N_noxref_3_c_533_p N_VDD_c_1160_n ) capacitor c=0.00733791f \
 //x=10.482 //y=4.74 //x2=9.37 //y2=7.585
cc_515 ( N_noxref_3_c_550_p N_VDD_c_1160_n ) capacitor c=0.00370494f //x=10.48 \
 //y=4.88 //x2=9.37 //y2=7.585
cc_516 ( N_noxref_3_c_551_p N_VDD_c_1160_n ) capacitor c=0.0129564f //x=10.48 \
 //y=4.88 //x2=9.37 //y2=7.585
cc_517 ( N_noxref_3_c_490_n N_VDD_c_1116_n ) capacitor c=0.00135089f //x=3.94 \
 //y=5.56 //x2=11.96 //y2=7.58
cc_518 ( N_noxref_3_c_602_p N_VDD_c_1116_n ) capacitor c=0.00135089f //x=4.82 \
 //y=5.56 //x2=11.96 //y2=7.58
cc_519 ( N_noxref_3_c_482_n N_VDD_M8_noxref_d ) capacitor c=0.00114029f \
 //x=3.94 //y=5.56 //x2=1.9 //y2=5.2
cc_520 ( N_noxref_3_c_482_n N_VDD_M9_noxref_s ) capacitor c=0.0604727f \
 //x=3.94 //y=5.56 //x2=3.365 //y2=5.2
cc_521 ( N_noxref_3_c_513_n N_VDD_M9_noxref_s ) capacitor c=6.52457e-19 \
 //x=4.82 //y=5.38 //x2=3.365 //y2=5.2
cc_522 ( N_noxref_3_c_490_n N_VDD_M9_noxref_s ) capacitor c=0.0887533f \
 //x=3.94 //y=5.56 //x2=3.365 //y2=5.2
cc_523 ( N_noxref_3_c_479_n N_VDD_M10_noxref_d ) capacitor c=0.00722911f \
 //x=4.705 //y=5.38 //x2=4.235 //y2=5.2
cc_524 ( N_noxref_3_c_482_n N_VDD_M10_noxref_d ) capacitor c=0.0043528f \
 //x=3.94 //y=5.56 //x2=4.235 //y2=5.2
cc_525 ( N_noxref_3_c_554_p N_VDD_M10_noxref_d ) capacitor c=0.0043528f \
 //x=4.82 //y=5.56 //x2=4.235 //y2=5.2
cc_526 ( N_noxref_3_c_490_n N_VDD_M10_noxref_d ) capacitor c=0.065554f \
 //x=3.94 //y=5.56 //x2=4.235 //y2=5.2
cc_527 ( N_noxref_3_c_602_p N_VDD_M10_noxref_d ) capacitor c=0.065554f \
 //x=4.82 //y=5.56 //x2=4.235 //y2=5.2
cc_528 ( N_noxref_3_c_552_p N_VDD_M12_noxref_d ) capacitor c=0.00961919f \
 //x=5.215 //y=5.38 //x2=5.115 //y2=5.2
cc_529 ( N_noxref_3_c_554_p N_VDD_M12_noxref_d ) capacitor c=0.00587834f \
 //x=4.82 //y=5.56 //x2=5.115 //y2=5.2
cc_530 ( N_noxref_3_c_488_n N_VDD_M12_noxref_d ) capacitor c=8.01916e-19 \
 //x=5.3 //y=3.14 //x2=5.115 //y2=5.2
cc_531 ( N_noxref_3_c_602_p N_VDD_M12_noxref_d ) capacitor c=0.065554f \
 //x=4.82 //y=5.56 //x2=5.115 //y2=5.2
cc_532 ( N_noxref_3_c_552_p N_VDD_M13_noxref_s ) capacitor c=0.00326953f \
 //x=5.215 //y=5.38 //x2=6.695 //y2=5.2
cc_533 ( N_noxref_3_c_513_n N_VDD_M13_noxref_s ) capacitor c=0.00515461f \
 //x=4.82 //y=5.38 //x2=6.695 //y2=5.2
cc_534 ( N_noxref_3_c_554_p N_VDD_M13_noxref_s ) capacitor c=3.28075e-19 \
 //x=4.82 //y=5.56 //x2=6.695 //y2=5.2
cc_535 ( N_noxref_3_c_530_p N_VDD_M17_noxref_s ) capacitor c=9.04186e-19 \
 //x=10.48 //y=3.28 //x2=10.025 //y2=5.2
cc_536 ( N_noxref_3_M17_noxref_g N_VDD_M17_noxref_s ) capacitor c=0.0567929f \
 //x=10.38 //y=6.2 //x2=10.025 //y2=5.2
cc_537 ( N_noxref_3_M18_noxref_g N_VDD_M18_noxref_d ) capacitor c=0.015318f \
 //x=10.82 //y=6.2 //x2=10.895 //y2=5.2
cc_538 ( N_noxref_3_c_480_n A0 ) capacitor c=0.024283f //x=5.3 //y=2.96 \
 //x2=4.56 //y2=2.4
cc_539 ( N_noxref_3_c_501_n A0 ) capacitor c=0.0151778f //x=5.3 //y=3.28 \
 //x2=4.56 //y2=2.4
cc_540 ( N_noxref_3_c_481_n A0 ) capacitor c=0.0628873f //x=5.3 //y=5.295 \
 //x2=4.56 //y2=2.4
cc_541 ( N_noxref_3_c_488_n A0 ) capacitor c=6.92705e-19 //x=5.3 //y=3.14 \
 //x2=4.56 //y2=2.4
cc_542 ( N_noxref_3_c_489_n A0 ) capacitor c=0.00360267f //x=5.46 //y=3.12 \
 //x2=4.56 //y2=2.4
cc_543 ( N_noxref_3_c_479_n N_A0_c_1298_n ) capacitor c=0.022731f //x=4.705 \
 //y=5.38 //x2=4.56 //y2=4.735
cc_544 ( N_noxref_3_c_481_n N_A0_c_1298_n ) capacitor c=0.016905f //x=5.3 \
 //y=5.295 //x2=4.56 //y2=4.735
cc_545 ( N_noxref_3_c_479_n N_A0_c_1301_n ) capacitor c=2.0313e-19 //x=4.705 \
 //y=5.38 //x2=4.56 //y2=2.26
cc_546 ( N_noxref_3_c_480_n N_A0_c_1301_n ) capacitor c=0.015397f //x=5.3 \
 //y=2.96 //x2=4.56 //y2=2.26
cc_547 ( N_noxref_3_c_480_n N_A0_c_1304_n ) capacitor c=9.90728e-19 //x=5.3 \
 //y=2.96 //x2=4.56 //y2=2.26
cc_548 ( N_noxref_3_c_479_n N_A0_c_1308_n ) capacitor c=0.00469257f //x=4.705 \
 //y=5.38 //x2=4.59 //y2=4.88
cc_549 ( N_noxref_3_c_481_n N_A0_c_1308_n ) capacitor c=7.76118e-19 //x=5.3 \
 //y=5.295 //x2=4.59 //y2=4.88
cc_550 ( N_noxref_3_c_479_n N_A0_M11_noxref_g ) capacitor c=0.00842859f \
 //x=4.705 //y=5.38 //x2=4.6 //y2=6.2
cc_551 ( N_noxref_3_c_513_n N_A0_M11_noxref_g ) capacitor c=0.00192712f \
 //x=4.82 //y=5.38 //x2=4.6 //y2=6.2
cc_552 ( N_noxref_3_c_602_p N_A0_M11_noxref_g ) capacitor c=0.0178987f \
 //x=4.82 //y=5.56 //x2=4.6 //y2=6.2
cc_553 ( N_noxref_3_c_552_p N_A0_M12_noxref_g ) capacitor c=0.0114149f \
 //x=5.215 //y=5.38 //x2=5.04 //y2=6.2
cc_554 ( N_noxref_3_c_513_n N_A0_M12_noxref_g ) capacitor c=0.00298276f \
 //x=4.82 //y=5.38 //x2=5.04 //y2=6.2
cc_555 ( N_noxref_3_c_602_p N_A0_M12_noxref_g ) capacitor c=0.0178506f \
 //x=4.82 //y=5.56 //x2=5.04 //y2=6.2
cc_556 ( N_noxref_3_c_514_n N_A0_c_1314_n ) capacitor c=0.00120406f //x=4.86 \
 //y=1.18 //x2=4.595 //y2=1.085
cc_557 ( N_noxref_3_M2_noxref_d N_A0_c_1314_n ) capacitor c=0.00137165f \
 //x=4.67 //y=1.085 //x2=4.595 //y2=1.085
cc_558 ( N_noxref_3_c_495_n N_A0_c_1317_n ) capacitor c=0.00118531f //x=4.86 \
 //y=1.75 //x2=4.595 //y2=1.43
cc_559 ( N_noxref_3_c_514_n N_A0_c_1317_n ) capacitor c=0.00218558f //x=4.86 \
 //y=1.18 //x2=4.595 //y2=1.43
cc_560 ( N_noxref_3_M2_noxref_d N_A0_c_1317_n ) capacitor c=0.00237422f \
 //x=4.67 //y=1.085 //x2=4.595 //y2=1.43
cc_561 ( N_noxref_3_c_495_n N_A0_c_1319_n ) capacitor c=0.00437687f //x=4.86 \
 //y=1.75 //x2=4.595 //y2=1.74
cc_562 ( N_noxref_3_c_481_n N_A0_c_1361_n ) capacitor c=0.0084741f //x=5.3 \
 //y=5.295 //x2=4.965 //y2=4.97
cc_563 ( N_noxref_3_c_513_n N_A0_c_1361_n ) capacitor c=0.0020909f //x=4.82 \
 //y=5.38 //x2=4.965 //y2=4.97
cc_564 ( N_noxref_3_c_602_p N_A0_c_1361_n ) capacitor c=0.00291714f //x=4.82 \
 //y=5.56 //x2=4.965 //y2=4.97
cc_565 ( N_noxref_3_c_514_n N_A0_c_1364_n ) capacitor c=5.50523e-19 //x=4.86 \
 //y=1.18 //x2=4.97 //y2=0.93
cc_566 ( N_noxref_3_M2_noxref_d N_A0_c_1364_n ) capacitor c=0.0020782f \
 //x=4.67 //y=1.085 //x2=4.97 //y2=0.93
cc_567 ( N_noxref_3_c_495_n N_A0_c_1366_n ) capacitor c=0.00916011f //x=4.86 \
 //y=1.75 //x2=4.97 //y2=1.585
cc_568 ( N_noxref_3_c_526_p N_A0_c_1366_n ) capacitor c=0.00194324f //x=5.215 \
 //y=1.835 //x2=4.97 //y2=1.585
cc_569 ( N_noxref_3_c_514_n N_A0_c_1366_n ) capacitor c=5.67071e-19 //x=4.86 \
 //y=1.18 //x2=4.97 //y2=1.585
cc_570 ( N_noxref_3_M2_noxref_d N_A0_c_1366_n ) capacitor c=0.00356097f \
 //x=4.67 //y=1.085 //x2=4.97 //y2=1.585
cc_571 ( N_noxref_3_c_514_n N_A0_c_1322_n ) capacitor c=0.00109205f //x=4.86 \
 //y=1.18 //x2=5.125 //y2=1.085
cc_572 ( N_noxref_3_M2_noxref_d N_A0_c_1322_n ) capacitor c=8.50095e-19 \
 //x=4.67 //y=1.085 //x2=5.125 //y2=1.085
cc_573 ( N_noxref_3_c_495_n N_A0_c_1323_n ) capacitor c=0.003249f //x=4.86 \
 //y=1.75 //x2=5.125 //y2=1.43
cc_574 ( N_noxref_3_c_526_p N_A0_c_1323_n ) capacitor c=0.00323005f //x=5.215 \
 //y=1.835 //x2=5.125 //y2=1.43
cc_575 ( N_noxref_3_c_514_n N_A0_c_1323_n ) capacitor c=0.00317092f //x=4.86 \
 //y=1.18 //x2=5.125 //y2=1.43
cc_576 ( N_noxref_3_M2_noxref_d N_A0_c_1323_n ) capacitor c=0.00237422f \
 //x=4.67 //y=1.085 //x2=5.125 //y2=1.43
cc_577 ( N_noxref_3_c_480_n N_A0_c_1324_n ) capacitor c=0.00281392f //x=5.3 \
 //y=2.96 //x2=4.56 //y2=2.26
cc_578 ( N_noxref_3_c_495_n N_A0_c_1377_n ) capacitor c=0.00348382f //x=4.86 \
 //y=1.75 //x2=4.56 //y2=2.095
cc_579 ( N_noxref_3_c_480_n N_A0_c_1377_n ) capacitor c=0.00309521f //x=5.3 \
 //y=2.96 //x2=4.56 //y2=2.095
cc_580 ( N_noxref_3_c_479_n N_A0_c_1327_n ) capacitor c=9.61466e-19 //x=4.705 \
 //y=5.38 //x2=4.59 //y2=4.88
cc_581 ( N_noxref_3_c_481_n N_A0_c_1327_n ) capacitor c=0.00142201f //x=5.3 \
 //y=5.295 //x2=4.59 //y2=4.88
cc_582 ( N_noxref_3_c_480_n A1 ) capacitor c=0.00174497f //x=5.3 //y=2.96 \
 //x2=7.89 //y2=2.4
cc_583 ( N_noxref_3_c_481_n A1 ) capacitor c=0.0034543f //x=5.3 //y=5.295 \
 //x2=7.89 //y2=2.4
cc_584 ( N_noxref_3_c_529_p A1 ) capacitor c=0.00170831f //x=10.48 //y=2.96 \
 //x2=7.89 //y2=2.4
cc_585 ( N_noxref_3_c_533_p A1 ) capacitor c=0.00315718f //x=10.482 //y=4.74 \
 //x2=7.89 //y2=2.4
cc_586 ( N_noxref_3_c_525_p A1 ) capacitor c=0.0307263f //x=8.245 //y=3.14 \
 //x2=7.89 //y2=2.4
cc_587 ( N_noxref_3_c_525_p N_A1_c_1413_n ) capacitor c=0.00188973f //x=8.245 \
 //y=3.14 //x2=7.89 //y2=4.735
cc_588 ( N_noxref_3_c_525_p N_A1_c_1416_n ) capacitor c=0.00314446f //x=8.245 \
 //y=3.14 //x2=7.89 //y2=2.26
cc_589 ( N_noxref_3_c_526_p N_GND_c_1621_n ) capacitor c=0.00654514f //x=5.215 \
 //y=1.835 //x2=7.135 //y2=0.175
cc_590 ( N_noxref_3_c_501_n N_GND_c_1621_n ) capacitor c=5.10607e-19 //x=5.3 \
 //y=3.28 //x2=7.135 //y2=0.175
cc_591 ( N_noxref_3_c_514_n N_GND_c_1621_n ) capacitor c=0.00964814f //x=4.86 \
 //y=1.18 //x2=7.135 //y2=0.175
cc_592 ( N_noxref_3_M2_noxref_d N_GND_c_1621_n ) capacitor c=3.01769e-19 \
 //x=4.67 //y=1.085 //x2=7.135 //y2=0.175
cc_593 ( N_noxref_3_c_482_n N_GND_c_1524_n ) capacitor c=7.06445e-19 //x=3.94 \
 //y=5.56 //x2=3.89 //y2=1.135
cc_594 ( N_noxref_3_c_514_n N_GND_c_1524_n ) capacitor c=0.0140149f //x=4.86 \
 //y=1.18 //x2=3.89 //y2=1.135
cc_595 ( N_noxref_3_M2_noxref_d N_GND_c_1524_n ) capacitor c=2.93544e-19 \
 //x=4.67 //y=1.085 //x2=3.89 //y2=1.135
cc_596 ( N_noxref_3_c_514_n N_GND_c_1581_n ) capacitor c=0.00549186f //x=4.86 \
 //y=1.18 //x2=7.22 //y2=1.135
cc_597 ( N_noxref_3_c_518_n N_GND_c_1581_n ) capacitor c=0.00326582f //x=7.365 \
 //y=3.13 //x2=7.22 //y2=1.135
cc_598 ( N_noxref_3_c_532_p N_GND_c_1630_n ) capacitor c=0.00678151f //x=10.48 \
 //y=2.26 //x2=10.55 //y2=1.135
cc_599 ( N_noxref_3_c_535_p N_GND_c_1630_n ) capacitor c=0.0025393f //x=8.845 \
 //y=3.13 //x2=10.55 //y2=1.135
cc_600 ( N_noxref_3_c_546_p N_GND_c_1630_n ) capacitor c=2.13705e-19 //x=10.48 \
 //y=2.26 //x2=10.55 //y2=1.135
cc_601 ( N_noxref_3_c_578_p N_GND_c_1630_n ) capacitor c=0.00171023f \
 //x=10.285 //y=1.045 //x2=10.55 //y2=1.135
cc_602 ( N_noxref_3_c_579_p N_GND_c_1630_n ) capacitor c=0.00357815f \
 //x=10.285 //y=1.39 //x2=10.55 //y2=1.135
cc_603 ( N_noxref_3_c_581_p N_GND_c_1630_n ) capacitor c=4.2764e-19 //x=10.285 \
 //y=1.7 //x2=10.55 //y2=1.135
cc_604 ( N_noxref_3_c_713_p N_GND_c_1630_n ) capacitor c=7.35788e-19 //x=10.66 \
 //y=0.89 //x2=10.55 //y2=1.135
cc_605 ( N_noxref_3_c_714_p N_GND_c_1630_n ) capacitor c=6.38426e-19 //x=10.66 \
 //y=1.545 //x2=10.55 //y2=1.135
cc_606 ( N_noxref_3_c_580_p N_GND_c_1630_n ) capacitor c=0.00158609f \
 //x=10.815 //y=1.045 //x2=10.55 //y2=1.135
cc_607 ( N_noxref_3_c_582_p N_GND_c_1630_n ) capacitor c=0.00296337f \
 //x=10.815 //y=1.39 //x2=10.55 //y2=1.135
cc_608 ( N_noxref_3_c_578_p N_GND_c_1640_n ) capacitor c=3.46594e-19 \
 //x=10.285 //y=1.045 //x2=10.547 //y2=1.005
cc_609 ( N_noxref_3_c_713_p N_GND_c_1640_n ) capacitor c=0.00852202f //x=10.66 \
 //y=0.89 //x2=10.547 //y2=1.005
cc_610 ( N_noxref_3_c_580_p N_GND_c_1640_n ) capacitor c=4.45447e-19 \
 //x=10.815 //y=1.045 //x2=10.547 //y2=1.005
cc_611 ( N_noxref_3_c_526_p N_GND_c_1544_n ) capacitor c=7.75992e-19 //x=5.215 \
 //y=1.835 //x2=5.87 //y2=0.175
cc_612 ( N_noxref_3_c_501_n N_GND_c_1544_n ) capacitor c=3.90092e-19 //x=5.3 \
 //y=3.28 //x2=5.87 //y2=0.175
cc_613 ( N_noxref_3_c_514_n N_GND_c_1598_n ) capacitor c=2.83275e-19 //x=4.86 \
 //y=1.18 //x2=11.96 //y2=0.18
cc_614 ( N_noxref_3_c_578_p N_GND_c_1598_n ) capacitor c=0.00691994f \
 //x=10.285 //y=1.045 //x2=11.96 //y2=0.18
cc_615 ( N_noxref_3_c_480_n N_GND_c_1550_n ) capacitor c=9.34543e-19 //x=5.3 \
 //y=2.96 //x2=2.71 //y2=0.175
cc_616 ( N_noxref_3_c_495_n N_GND_c_1603_n ) capacitor c=0.002973f //x=4.86 \
 //y=1.75 //x2=6.04 //y2=0.175
cc_617 ( N_noxref_3_c_526_p N_GND_c_1603_n ) capacitor c=0.0300121f //x=5.215 \
 //y=1.835 //x2=6.04 //y2=0.175
cc_618 ( N_noxref_3_c_515_n N_GND_c_1603_n ) capacitor c=0.00725442f //x=6.765 \
 //y=3.14 //x2=6.04 //y2=0.175
cc_619 ( N_noxref_3_c_529_p N_GND_c_1651_n ) capacitor c=0.00829739f //x=10.48 \
 //y=2.96 //x2=9.37 //y2=0.175
cc_620 ( N_noxref_3_c_532_p N_GND_c_1651_n ) capacitor c=0.00427323f //x=10.48 \
 //y=2.26 //x2=9.37 //y2=0.175
cc_621 ( N_noxref_3_c_535_p N_GND_c_1651_n ) capacitor c=0.00725442f //x=8.845 \
 //y=3.13 //x2=9.37 //y2=0.175
cc_622 ( N_noxref_3_c_546_p N_GND_c_1651_n ) capacitor c=0.0038607f //x=10.48 \
 //y=2.26 //x2=9.37 //y2=0.175
cc_623 ( N_noxref_3_c_581_p N_GND_c_1651_n ) capacitor c=0.0015404f //x=10.285 \
 //y=1.7 //x2=9.37 //y2=0.175
cc_624 ( N_noxref_3_c_560_p N_GND_c_1651_n ) capacitor c=0.00908419f \
 //x=10.285 //y=2.095 //x2=9.37 //y2=0.175
cc_625 ( N_noxref_3_c_514_n N_GND_M1_noxref_d ) capacitor c=2.82748e-19 \
 //x=4.86 //y=1.18 //x2=3.7 //y2=1.045
cc_626 ( N_noxref_3_c_532_p N_GND_M5_noxref_d ) capacitor c=2.20438e-19 \
 //x=10.48 //y=2.26 //x2=10.36 //y2=1.045
cc_627 ( N_noxref_3_c_578_p N_GND_M5_noxref_d ) capacitor c=0.00192399f \
 //x=10.285 //y=1.045 //x2=10.36 //y2=1.045
cc_628 ( N_noxref_3_c_579_p N_GND_M5_noxref_d ) capacitor c=0.00210798f \
 //x=10.285 //y=1.39 //x2=10.36 //y2=1.045
cc_629 ( N_noxref_3_c_713_p N_GND_M5_noxref_d ) capacitor c=0.00472259f \
 //x=10.66 //y=0.89 //x2=10.36 //y2=1.045
cc_630 ( N_noxref_3_c_714_p N_GND_M5_noxref_d ) capacitor c=0.00166857f \
 //x=10.66 //y=1.545 //x2=10.36 //y2=1.045
cc_631 ( N_noxref_3_c_580_p N_GND_M5_noxref_d ) capacitor c=0.00230174f \
 //x=10.815 //y=1.045 //x2=10.36 //y2=1.045
cc_632 ( N_noxref_3_c_582_p N_GND_M5_noxref_d ) capacitor c=0.00210798f \
 //x=10.815 //y=1.39 //x2=10.36 //y2=1.045
cc_633 ( N_noxref_3_c_529_p Y ) capacitor c=0.00261496f //x=10.48 //y=2.96 \
 //x2=11.96 //y2=2.4
cc_634 ( N_noxref_3_c_533_p Y ) capacitor c=0.00454526f //x=10.482 //y=4.74 \
 //x2=11.96 //y2=2.4
cc_635 ( N_noxref_3_M18_noxref_g N_Y_c_1790_n ) capacitor c=0.0108476f \
 //x=10.82 //y=6.2 //x2=11.365 //y2=5.38
cc_636 ( N_noxref_3_c_530_p N_Y_c_1791_n ) capacitor c=3.93756e-19 //x=10.48 \
 //y=3.28 //x2=10.6 //y2=5.56
cc_637 ( N_noxref_3_c_539_p N_Y_c_1791_n ) capacitor c=0.0118323f //x=10.48 \
 //y=4.88 //x2=10.6 //y2=5.56
cc_638 ( N_noxref_3_c_550_p N_Y_c_1791_n ) capacitor c=0.00277154f //x=10.48 \
 //y=4.88 //x2=10.6 //y2=5.56
cc_639 ( N_noxref_3_M17_noxref_g N_Y_c_1791_n ) capacitor c=0.00201806f \
 //x=10.38 //y=6.2 //x2=10.6 //y2=5.56
cc_640 ( N_noxref_3_M18_noxref_g N_Y_c_1791_n ) capacitor c=0.00192712f \
 //x=10.82 //y=6.2 //x2=10.6 //y2=5.56
cc_641 ( N_noxref_3_c_551_p N_Y_c_1791_n ) capacitor c=0.00199495f //x=10.48 \
 //y=4.88 //x2=10.6 //y2=5.56
cc_642 ( N_noxref_3_c_539_p N_Y_c_1797_n ) capacitor c=0.00104426f //x=10.48 \
 //y=4.88 //x2=10.6 //y2=5.56
cc_643 ( N_noxref_3_c_550_p N_Y_c_1797_n ) capacitor c=0.00377369f //x=10.48 \
 //y=4.88 //x2=10.6 //y2=5.56
cc_644 ( N_noxref_3_M17_noxref_g N_Y_c_1797_n ) capacitor c=0.0158358f \
 //x=10.38 //y=6.2 //x2=10.6 //y2=5.56
cc_645 ( N_noxref_3_M18_noxref_g N_Y_c_1797_n ) capacitor c=0.0178987f \
 //x=10.82 //y=6.2 //x2=10.6 //y2=5.56
cc_646 ( N_noxref_3_c_551_p N_Y_c_1797_n ) capacitor c=0.0043218f //x=10.48 \
 //y=4.88 //x2=10.6 //y2=5.56
cc_647 ( N_noxref_3_c_497_n N_noxref_10_c_1917_n ) capacitor c=0.00900974f \
 //x=4.945 //y=1.835 //x2=4.375 //y2=1.675
cc_648 ( N_noxref_3_c_526_p N_noxref_10_c_1924_n ) capacitor c=0.00373013f \
 //x=5.215 //y=1.835 //x2=5.26 //y2=0.71
cc_649 ( N_noxref_3_c_514_n N_noxref_10_c_1924_n ) capacitor c=0.00367971f \
 //x=4.86 //y=1.18 //x2=5.26 //y2=0.71
cc_650 ( N_noxref_3_M2_noxref_d N_noxref_10_c_1924_n ) capacitor c=0.00910163f \
 //x=4.67 //y=1.085 //x2=5.26 //y2=0.71
cc_651 ( N_noxref_3_c_495_n N_noxref_10_M1_noxref_s ) capacitor c=0.0161378f \
 //x=4.86 //y=1.75 //x2=3.27 //y2=0.545
cc_652 ( N_noxref_3_c_526_p N_noxref_10_M1_noxref_s ) capacitor c=0.00603051f \
 //x=5.215 //y=1.835 //x2=3.27 //y2=0.545
cc_653 ( N_noxref_3_c_501_n N_noxref_10_M1_noxref_s ) capacitor c=5.71487e-19 \
 //x=5.3 //y=3.28 //x2=3.27 //y2=0.545
cc_654 ( N_noxref_3_c_514_n N_noxref_10_M1_noxref_s ) capacitor c=0.00904877f \
 //x=4.86 //y=1.18 //x2=3.27 //y2=0.545
cc_655 ( N_noxref_3_c_488_n N_noxref_10_M1_noxref_s ) capacitor c=0.00140776f \
 //x=5.3 //y=3.14 //x2=3.27 //y2=0.545
cc_656 ( N_noxref_3_M2_noxref_d N_noxref_10_M1_noxref_s ) capacitor \
 c=0.0275552f //x=4.67 //y=1.085 //x2=3.27 //y2=0.545
cc_657 ( N_noxref_3_c_515_n N_noxref_11_c_1976_n ) capacitor c=0.0031675f \
 //x=6.765 //y=3.14 //x2=6.735 //y2=1.675
cc_658 ( N_noxref_3_c_515_n N_noxref_11_c_1977_n ) capacitor c=0.00691616f \
 //x=6.765 //y=3.14 //x2=7.62 //y2=1.76
cc_659 ( N_noxref_3_c_518_n N_noxref_11_c_1977_n ) capacitor c=0.00279672f \
 //x=7.365 //y=3.13 //x2=7.62 //y2=1.76
cc_660 ( N_noxref_3_c_525_p N_noxref_11_c_1984_n ) capacitor c=0.00273243f \
 //x=8.245 //y=3.14 //x2=7.705 //y2=1.675
cc_661 ( N_noxref_3_c_535_p N_noxref_11_M3_noxref_s ) capacitor c=5.85096e-19 \
 //x=8.845 //y=3.13 //x2=6.6 //y2=0.545
cc_662 ( N_noxref_3_c_535_p N_noxref_12_c_2047_n ) capacitor c=0.00317601f \
 //x=8.845 //y=3.13 //x2=10.065 //y2=1.675
cc_663 ( N_noxref_3_c_560_p N_noxref_12_c_2047_n ) capacitor c=0.00262672f \
 //x=10.285 //y=2.095 //x2=10.065 //y2=1.675
cc_664 ( N_noxref_3_c_530_p N_noxref_12_c_2049_n ) capacitor c=0.00447516f \
 //x=10.48 //y=3.28 //x2=10.95 //y2=1.76
cc_665 ( N_noxref_3_c_532_p N_noxref_12_c_2049_n ) capacitor c=0.00509504f \
 //x=10.48 //y=2.26 //x2=10.95 //y2=1.76
cc_666 ( N_noxref_3_c_535_p N_noxref_12_c_2049_n ) capacitor c=0.00118517f \
 //x=8.845 //y=3.13 //x2=10.95 //y2=1.76
cc_667 ( N_noxref_3_c_546_p N_noxref_12_c_2049_n ) capacitor c=0.00763108f \
 //x=10.48 //y=2.26 //x2=10.95 //y2=1.76
cc_668 ( N_noxref_3_c_581_p N_noxref_12_c_2049_n ) capacitor c=0.00697076f \
 //x=10.285 //y=1.7 //x2=10.95 //y2=1.76
cc_669 ( N_noxref_3_c_560_p N_noxref_12_c_2049_n ) capacitor c=0.0173953f \
 //x=10.285 //y=2.095 //x2=10.95 //y2=1.76
cc_670 ( N_noxref_3_c_714_p N_noxref_12_c_2049_n ) capacitor c=0.00723574f \
 //x=10.66 //y=1.545 //x2=10.95 //y2=1.76
cc_671 ( N_noxref_3_c_582_p N_noxref_12_c_2049_n ) capacitor c=0.00339872f \
 //x=10.815 //y=1.39 //x2=10.95 //y2=1.76
cc_672 ( N_noxref_3_c_560_p N_noxref_12_c_2057_n ) capacitor c=6.71402e-19 \
 //x=10.285 //y=2.095 //x2=11.035 //y2=1.675
cc_673 ( N_noxref_3_c_578_p N_noxref_12_M5_noxref_s ) capacitor c=0.0294925f \
 //x=10.285 //y=1.045 //x2=9.93 //y2=0.545
cc_674 ( N_noxref_3_c_581_p N_noxref_12_M5_noxref_s ) capacitor c=3.48408e-19 \
 //x=10.285 //y=1.7 //x2=9.93 //y2=0.545
cc_675 ( N_noxref_3_c_580_p N_noxref_12_M5_noxref_s ) capacitor c=0.0125442f \
 //x=10.815 //y=1.045 //x2=9.93 //y2=0.545
cc_676 ( N_noxref_4_c_785_n N_VDD_c_1061_n ) capacitor c=0.00648307f //x=8.035 \
 //y=5.38 //x2=11.96 //y2=7.58
cc_677 ( N_noxref_4_c_873_p N_VDD_c_1061_n ) capacitor c=0.00492584f //x=8.545 \
 //y=5.38 //x2=11.96 //y2=7.58
cc_678 ( N_noxref_4_c_814_n N_VDD_c_1061_n ) capacitor c=4.28603e-19 //x=8.63 \
 //y=3.68 //x2=11.96 //y2=7.58
cc_679 ( N_noxref_4_c_788_n N_VDD_c_1061_n ) capacitor c=0.00368834f //x=7.27 \
 //y=5.56 //x2=11.96 //y2=7.58
cc_680 ( N_noxref_4_c_876_p N_VDD_c_1061_n ) capacitor c=8.42709e-19 //x=8.15 \
 //y=5.38 //x2=11.96 //y2=7.58
cc_681 ( N_noxref_4_c_877_p N_VDD_c_1061_n ) capacitor c=0.00285853f //x=8.15 \
 //y=5.56 //x2=11.96 //y2=7.58
cc_682 ( N_noxref_4_c_797_n N_VDD_c_1061_n ) capacitor c=0.00224881f //x=7.27 \
 //y=5.56 //x2=11.96 //y2=7.58
cc_683 ( N_noxref_4_c_879_p N_VDD_c_1061_n ) capacitor c=0.00224881f //x=8.15 \
 //y=5.56 //x2=11.96 //y2=7.58
cc_684 ( N_noxref_4_c_785_n N_VDD_c_1101_n ) capacitor c=0.00213203f //x=8.035 \
 //y=5.38 //x2=7.625 //y2=7.585
cc_685 ( N_noxref_4_c_788_n N_VDD_c_1101_n ) capacitor c=9.99055e-19 //x=7.27 \
 //y=5.56 //x2=7.625 //y2=7.585
cc_686 ( N_noxref_4_c_797_n N_VDD_c_1101_n ) capacitor c=0.0136705f //x=7.27 \
 //y=5.56 //x2=7.625 //y2=7.585
cc_687 ( N_noxref_4_c_785_n N_VDD_c_1196_n ) capacitor c=0.00184541f //x=8.035 \
 //y=5.38 //x2=8.505 //y2=7.585
cc_688 ( N_noxref_4_c_873_p N_VDD_c_1196_n ) capacitor c=0.00213203f //x=8.545 \
 //y=5.38 //x2=8.505 //y2=7.585
cc_689 ( N_noxref_4_c_876_p N_VDD_c_1196_n ) capacitor c=5.39459e-19 //x=8.15 \
 //y=5.38 //x2=8.505 //y2=7.585
cc_690 ( N_noxref_4_c_877_p N_VDD_c_1196_n ) capacitor c=5.77976e-19 //x=8.15 \
 //y=5.56 //x2=8.505 //y2=7.585
cc_691 ( N_noxref_4_c_879_p N_VDD_c_1196_n ) capacitor c=0.0136705f //x=8.15 \
 //y=5.56 //x2=8.505 //y2=7.585
cc_692 ( N_noxref_4_M19_noxref_g N_VDD_c_1201_n ) capacitor c=0.00697352f \
 //x=11.26 //y=6.2 //x2=11.835 //y2=7.585
cc_693 ( N_noxref_4_M20_noxref_g N_VDD_c_1201_n ) capacitor c=0.00755544f \
 //x=11.7 //y=6.2 //x2=11.835 //y2=7.585
cc_694 ( N_noxref_4_c_787_n N_VDD_c_1111_n ) capacitor c=0.0013228f //x=8.63 \
 //y=5.295 //x2=6.04 //y2=7.585
cc_695 ( N_noxref_4_c_788_n N_VDD_c_1111_n ) capacitor c=4.91377e-19 //x=7.27 \
 //y=5.56 //x2=6.04 //y2=7.585
cc_696 ( N_noxref_4_c_797_n N_VDD_c_1111_n ) capacitor c=0.0064135f //x=7.27 \
 //y=5.56 //x2=6.04 //y2=7.585
cc_697 ( N_noxref_4_c_787_n N_VDD_c_1160_n ) capacitor c=0.0312058f //x=8.63 \
 //y=5.295 //x2=9.37 //y2=7.585
cc_698 ( N_noxref_4_c_876_p N_VDD_c_1160_n ) capacitor c=0.00240948f //x=8.15 \
 //y=5.38 //x2=9.37 //y2=7.585
cc_699 ( N_noxref_4_c_877_p N_VDD_c_1160_n ) capacitor c=4.09141e-19 //x=8.15 \
 //y=5.56 //x2=9.37 //y2=7.585
cc_700 ( N_noxref_4_c_839_n N_VDD_c_1160_n ) capacitor c=0.00501359f //x=11.06 \
 //y=3.51 //x2=9.37 //y2=7.585
cc_701 ( N_noxref_4_c_879_p N_VDD_c_1160_n ) capacitor c=0.0101861f //x=8.15 \
 //y=5.56 //x2=9.37 //y2=7.585
cc_702 ( N_noxref_4_c_797_n N_VDD_c_1116_n ) capacitor c=0.00135089f //x=7.27 \
 //y=5.56 //x2=11.96 //y2=7.58
cc_703 ( N_noxref_4_c_879_p N_VDD_c_1116_n ) capacitor c=0.00135089f //x=8.15 \
 //y=5.56 //x2=11.96 //y2=7.58
cc_704 ( N_noxref_4_c_850_n N_VDD_c_1116_n ) capacitor c=0.00226427f //x=11.25 \
 //y=4.88 //x2=11.96 //y2=7.58
cc_705 ( N_noxref_4_c_901_p N_VDD_c_1116_n ) capacitor c=0.0237963f //x=11.625 \
 //y=4.97 //x2=11.96 //y2=7.58
cc_706 ( N_noxref_4_c_869_n N_VDD_c_1116_n ) capacitor c=2.73429e-19 //x=11.25 \
 //y=4.88 //x2=11.96 //y2=7.58
cc_707 ( N_noxref_4_c_788_n N_VDD_M13_noxref_s ) capacitor c=0.0572211f \
 //x=7.27 //y=5.56 //x2=6.695 //y2=5.2
cc_708 ( N_noxref_4_c_876_p N_VDD_M13_noxref_s ) capacitor c=6.52457e-19 \
 //x=8.15 //y=5.38 //x2=6.695 //y2=5.2
cc_709 ( N_noxref_4_c_797_n N_VDD_M13_noxref_s ) capacitor c=0.0887533f \
 //x=7.27 //y=5.56 //x2=6.695 //y2=5.2
cc_710 ( N_noxref_4_c_785_n N_VDD_M14_noxref_d ) capacitor c=0.00810252f \
 //x=8.035 //y=5.38 //x2=7.565 //y2=5.2
cc_711 ( N_noxref_4_c_788_n N_VDD_M14_noxref_d ) capacitor c=0.0043528f \
 //x=7.27 //y=5.56 //x2=7.565 //y2=5.2
cc_712 ( N_noxref_4_c_877_p N_VDD_M14_noxref_d ) capacitor c=0.0043528f \
 //x=8.15 //y=5.56 //x2=7.565 //y2=5.2
cc_713 ( N_noxref_4_c_797_n N_VDD_M14_noxref_d ) capacitor c=0.065554f \
 //x=7.27 //y=5.56 //x2=7.565 //y2=5.2
cc_714 ( N_noxref_4_c_879_p N_VDD_M14_noxref_d ) capacitor c=0.065554f \
 //x=8.15 //y=5.56 //x2=7.565 //y2=5.2
cc_715 ( N_noxref_4_c_873_p N_VDD_M16_noxref_d ) capacitor c=0.00934027f \
 //x=8.545 //y=5.38 //x2=8.445 //y2=5.2
cc_716 ( N_noxref_4_c_877_p N_VDD_M16_noxref_d ) capacitor c=0.00587834f \
 //x=8.15 //y=5.56 //x2=8.445 //y2=5.2
cc_717 ( N_noxref_4_c_795_n N_VDD_M16_noxref_d ) capacitor c=9.65951e-19 \
 //x=8.63 //y=3.51 //x2=8.445 //y2=5.2
cc_718 ( N_noxref_4_c_879_p N_VDD_M16_noxref_d ) capacitor c=0.065554f \
 //x=8.15 //y=5.56 //x2=8.445 //y2=5.2
cc_719 ( N_noxref_4_c_873_p N_VDD_M17_noxref_s ) capacitor c=0.00326953f \
 //x=8.545 //y=5.38 //x2=10.025 //y2=5.2
cc_720 ( N_noxref_4_c_876_p N_VDD_M17_noxref_s ) capacitor c=0.00515461f \
 //x=8.15 //y=5.38 //x2=10.025 //y2=5.2
cc_721 ( N_noxref_4_c_877_p N_VDD_M17_noxref_s ) capacitor c=3.28075e-19 \
 //x=8.15 //y=5.56 //x2=10.025 //y2=5.2
cc_722 ( N_noxref_4_c_839_n N_VDD_M17_noxref_s ) capacitor c=0.0037282f \
 //x=11.06 //y=3.51 //x2=10.025 //y2=5.2
cc_723 ( N_noxref_4_M19_noxref_g N_VDD_M18_noxref_d ) capacitor c=0.015318f \
 //x=11.26 //y=6.2 //x2=10.895 //y2=5.2
cc_724 ( N_noxref_4_c_869_n N_VDD_M18_noxref_d ) capacitor c=3.32552e-19 \
 //x=11.25 //y=4.88 //x2=10.895 //y2=5.2
cc_725 ( N_noxref_4_M20_noxref_g N_VDD_M20_noxref_d ) capacitor c=0.0430452f \
 //x=11.7 //y=6.2 //x2=11.775 //y2=5.2
cc_726 ( N_noxref_4_c_786_n A1 ) capacitor c=0.0394854f //x=8.63 //y=3.36 \
 //x2=7.89 //y2=2.4
cc_727 ( N_noxref_4_c_814_n A1 ) capacitor c=0.0148747f //x=8.63 //y=3.68 \
 //x2=7.89 //y2=2.4
cc_728 ( N_noxref_4_c_787_n A1 ) capacitor c=0.0477134f //x=8.63 //y=5.295 \
 //x2=7.89 //y2=2.4
cc_729 ( N_noxref_4_c_795_n A1 ) capacitor c=6.02403e-19 //x=8.63 //y=3.51 \
 //x2=7.89 //y2=2.4
cc_730 ( N_noxref_4_c_796_n A1 ) capacitor c=0.00360383f //x=8.79 //y=3.52 \
 //x2=7.89 //y2=2.4
cc_731 ( N_noxref_4_c_785_n N_A1_c_1413_n ) capacitor c=0.0228479f //x=8.035 \
 //y=5.38 //x2=7.89 //y2=4.735
cc_732 ( N_noxref_4_c_787_n N_A1_c_1413_n ) capacitor c=0.016905f //x=8.63 \
 //y=5.295 //x2=7.89 //y2=4.735
cc_733 ( N_noxref_4_c_786_n N_A1_c_1416_n ) capacitor c=0.015397f //x=8.63 \
 //y=3.36 //x2=7.89 //y2=2.26
cc_734 ( N_noxref_4_c_786_n N_A1_c_1419_n ) capacitor c=9.90728e-19 //x=8.63 \
 //y=3.36 //x2=7.89 //y2=2.26
cc_735 ( N_noxref_4_c_785_n N_A1_c_1423_n ) capacitor c=0.00469257f //x=8.035 \
 //y=5.38 //x2=7.92 //y2=4.88
cc_736 ( N_noxref_4_c_787_n N_A1_c_1423_n ) capacitor c=7.76118e-19 //x=8.63 \
 //y=5.295 //x2=7.92 //y2=4.88
cc_737 ( N_noxref_4_c_785_n N_A1_M15_noxref_g ) capacitor c=0.00842859f \
 //x=8.035 //y=5.38 //x2=7.93 //y2=6.2
cc_738 ( N_noxref_4_c_876_p N_A1_M15_noxref_g ) capacitor c=0.00192712f \
 //x=8.15 //y=5.38 //x2=7.93 //y2=6.2
cc_739 ( N_noxref_4_c_879_p N_A1_M15_noxref_g ) capacitor c=0.0178987f \
 //x=8.15 //y=5.56 //x2=7.93 //y2=6.2
cc_740 ( N_noxref_4_c_873_p N_A1_M16_noxref_g ) capacitor c=0.0115937f \
 //x=8.545 //y=5.38 //x2=8.37 //y2=6.2
cc_741 ( N_noxref_4_c_876_p N_A1_M16_noxref_g ) capacitor c=0.00298276f \
 //x=8.15 //y=5.38 //x2=8.37 //y2=6.2
cc_742 ( N_noxref_4_c_879_p N_A1_M16_noxref_g ) capacitor c=0.0178506f \
 //x=8.15 //y=5.56 //x2=8.37 //y2=6.2
cc_743 ( N_noxref_4_c_833_n N_A1_c_1429_n ) capacitor c=0.00120406f //x=8.19 \
 //y=1.18 //x2=7.925 //y2=1.085
cc_744 ( N_noxref_4_M4_noxref_d N_A1_c_1429_n ) capacitor c=0.00137165f //x=8 \
 //y=1.085 //x2=7.925 //y2=1.085
cc_745 ( N_noxref_4_c_802_n N_A1_c_1432_n ) capacitor c=0.00119008f //x=8.19 \
 //y=1.75 //x2=7.925 //y2=1.43
cc_746 ( N_noxref_4_c_833_n N_A1_c_1432_n ) capacitor c=0.00218694f //x=8.19 \
 //y=1.18 //x2=7.925 //y2=1.43
cc_747 ( N_noxref_4_M4_noxref_d N_A1_c_1432_n ) capacitor c=0.00237422f //x=8 \
 //y=1.085 //x2=7.925 //y2=1.43
cc_748 ( N_noxref_4_c_802_n N_A1_c_1434_n ) capacitor c=0.00438634f //x=8.19 \
 //y=1.75 //x2=7.925 //y2=1.74
cc_749 ( N_noxref_4_c_787_n N_A1_c_1475_n ) capacitor c=0.00845606f //x=8.63 \
 //y=5.295 //x2=8.295 //y2=4.97
cc_750 ( N_noxref_4_c_876_p N_A1_c_1475_n ) capacitor c=0.0020909f //x=8.15 \
 //y=5.38 //x2=8.295 //y2=4.97
cc_751 ( N_noxref_4_c_879_p N_A1_c_1475_n ) capacitor c=0.00291714f //x=8.15 \
 //y=5.56 //x2=8.295 //y2=4.97
cc_752 ( N_noxref_4_c_833_n N_A1_c_1478_n ) capacitor c=5.50523e-19 //x=8.19 \
 //y=1.18 //x2=8.3 //y2=0.93
cc_753 ( N_noxref_4_M4_noxref_d N_A1_c_1478_n ) capacitor c=0.0020782f //x=8 \
 //y=1.085 //x2=8.3 //y2=0.93
cc_754 ( N_noxref_4_c_802_n N_A1_c_1480_n ) capacitor c=0.00916852f //x=8.19 \
 //y=1.75 //x2=8.3 //y2=1.585
cc_755 ( N_noxref_4_c_803_n N_A1_c_1480_n ) capacitor c=0.00194324f //x=8.545 \
 //y=1.835 //x2=8.3 //y2=1.585
cc_756 ( N_noxref_4_c_833_n N_A1_c_1480_n ) capacitor c=5.67071e-19 //x=8.19 \
 //y=1.18 //x2=8.3 //y2=1.585
cc_757 ( N_noxref_4_M4_noxref_d N_A1_c_1480_n ) capacitor c=0.00356097f //x=8 \
 //y=1.085 //x2=8.3 //y2=1.585
cc_758 ( N_noxref_4_c_833_n N_A1_c_1437_n ) capacitor c=0.00109205f //x=8.19 \
 //y=1.18 //x2=8.455 //y2=1.085
cc_759 ( N_noxref_4_M4_noxref_d N_A1_c_1437_n ) capacitor c=8.50095e-19 //x=8 \
 //y=1.085 //x2=8.455 //y2=1.085
cc_760 ( N_noxref_4_c_802_n N_A1_c_1438_n ) capacitor c=0.003249f //x=8.19 \
 //y=1.75 //x2=8.455 //y2=1.43
cc_761 ( N_noxref_4_c_803_n N_A1_c_1438_n ) capacitor c=0.00323005f //x=8.545 \
 //y=1.835 //x2=8.455 //y2=1.43
cc_762 ( N_noxref_4_c_833_n N_A1_c_1438_n ) capacitor c=0.00317092f //x=8.19 \
 //y=1.18 //x2=8.455 //y2=1.43
cc_763 ( N_noxref_4_M4_noxref_d N_A1_c_1438_n ) capacitor c=0.00237422f //x=8 \
 //y=1.085 //x2=8.455 //y2=1.43
cc_764 ( N_noxref_4_c_786_n N_A1_c_1439_n ) capacitor c=0.00281392f //x=8.63 \
 //y=3.36 //x2=7.89 //y2=2.26
cc_765 ( N_noxref_4_c_802_n N_A1_c_1491_n ) capacitor c=0.00341114f //x=8.19 \
 //y=1.75 //x2=7.89 //y2=2.095
cc_766 ( N_noxref_4_c_786_n N_A1_c_1491_n ) capacitor c=0.00309058f //x=8.63 \
 //y=3.36 //x2=7.89 //y2=2.095
cc_767 ( N_noxref_4_c_785_n N_A1_c_1442_n ) capacitor c=9.8107e-19 //x=8.035 \
 //y=5.38 //x2=7.92 //y2=4.88
cc_768 ( N_noxref_4_c_787_n N_A1_c_1442_n ) capacitor c=0.00142201f //x=8.63 \
 //y=5.295 //x2=7.92 //y2=4.88
cc_769 ( N_noxref_4_c_803_n N_GND_c_1665_n ) capacitor c=0.00654514f //x=8.545 \
 //y=1.835 //x2=10.465 //y2=0.175
cc_770 ( N_noxref_4_c_814_n N_GND_c_1665_n ) capacitor c=4.52005e-19 //x=8.63 \
 //y=3.68 //x2=10.465 //y2=0.175
cc_771 ( N_noxref_4_c_833_n N_GND_c_1665_n ) capacitor c=0.00951288f //x=8.19 \
 //y=1.18 //x2=10.465 //y2=0.175
cc_772 ( N_noxref_4_M4_noxref_d N_GND_c_1665_n ) capacitor c=3.01769e-19 //x=8 \
 //y=1.085 //x2=10.465 //y2=0.175
cc_773 ( N_noxref_4_c_825_n N_GND_c_1669_n ) capacitor c=3.37247e-19 //x=11.22 \
 //y=3.67 //x2=11.96 //y2=0.18
cc_774 ( N_noxref_4_c_836_n N_GND_c_1669_n ) capacitor c=0.00234561f //x=11.22 \
 //y=2.26 //x2=11.96 //y2=0.18
cc_775 ( N_noxref_4_c_788_n N_GND_c_1581_n ) capacitor c=6.97093e-19 //x=7.27 \
 //y=5.56 //x2=7.22 //y2=1.135
cc_776 ( N_noxref_4_c_833_n N_GND_c_1581_n ) capacitor c=0.0140087f //x=8.19 \
 //y=1.18 //x2=7.22 //y2=1.135
cc_777 ( N_noxref_4_M4_noxref_d N_GND_c_1581_n ) capacitor c=2.93544e-19 //x=8 \
 //y=1.085 //x2=7.22 //y2=1.135
cc_778 ( N_noxref_4_c_833_n N_GND_c_1630_n ) capacitor c=0.00549186f //x=8.19 \
 //y=1.18 //x2=10.55 //y2=1.135
cc_779 ( N_noxref_4_c_803_n N_GND_c_1597_n ) capacitor c=7.75992e-19 //x=8.545 \
 //y=1.835 //x2=9.2 //y2=0.175
cc_780 ( N_noxref_4_c_814_n N_GND_c_1597_n ) capacitor c=3.20879e-19 //x=8.63 \
 //y=3.68 //x2=9.2 //y2=0.175
cc_781 ( N_noxref_4_c_833_n N_GND_c_1598_n ) capacitor c=2.83275e-19 //x=8.19 \
 //y=1.18 //x2=11.96 //y2=0.18
cc_782 ( N_noxref_4_c_836_n N_GND_c_1598_n ) capacitor c=3.77328e-19 //x=11.22 \
 //y=2.26 //x2=11.96 //y2=0.18
cc_783 ( N_noxref_4_c_846_n N_GND_c_1598_n ) capacitor c=0.00224736f //x=11.22 \
 //y=2.26 //x2=11.96 //y2=0.18
cc_784 ( N_noxref_4_c_865_n N_GND_c_1598_n ) capacitor c=0.0028807f //x=11.785 \
 //y=1.43 //x2=11.96 //y2=0.18
cc_785 ( N_noxref_4_c_866_n N_GND_c_1598_n ) capacitor c=2.63786e-19 //x=11.22 \
 //y=2.26 //x2=11.96 //y2=0.18
cc_786 ( N_noxref_4_c_786_n N_GND_c_1603_n ) capacitor c=9.32616e-19 //x=8.63 \
 //y=3.36 //x2=6.04 //y2=0.175
cc_787 ( N_noxref_4_c_802_n N_GND_c_1651_n ) capacitor c=0.002973f //x=8.19 \
 //y=1.75 //x2=9.37 //y2=0.175
cc_788 ( N_noxref_4_c_803_n N_GND_c_1651_n ) capacitor c=0.0308456f //x=8.545 \
 //y=1.835 //x2=9.37 //y2=0.175
cc_789 ( N_noxref_4_c_833_n N_GND_M3_noxref_d ) capacitor c=2.82748e-19 \
 //x=8.19 //y=1.18 //x2=7.03 //y2=1.045
cc_790 ( N_noxref_4_c_787_n Y ) capacitor c=9.42509e-19 //x=8.63 //y=5.295 \
 //x2=11.96 //y2=2.4
cc_791 ( N_noxref_4_c_819_n Y ) capacitor c=0.0428994f //x=11.22 //y=3.35 \
 //x2=11.96 //y2=2.4
cc_792 ( N_noxref_4_c_825_n Y ) capacitor c=0.0149195f //x=11.22 //y=3.67 \
 //x2=11.96 //y2=2.4
cc_793 ( N_noxref_4_c_826_n Y ) capacitor c=0.0664964f //x=11.22 //y=4.735 \
 //x2=11.96 //y2=2.4
cc_794 ( N_noxref_4_c_835_n Y ) capacitor c=0.00539899f //x=11.22 //y=3.51 \
 //x2=11.96 //y2=2.4
cc_795 ( N_noxref_4_c_836_n Y ) capacitor c=0.015397f //x=11.22 //y=2.26 \
 //x2=11.96 //y2=2.4
cc_796 ( N_noxref_4_c_845_n Y ) capacitor c=0.00687201f //x=11.22 //y=3.51 \
 //x2=11.96 //y2=2.4
cc_797 ( N_noxref_4_c_846_n Y ) capacitor c=0.00440663f //x=11.22 //y=2.26 \
 //x2=11.96 //y2=2.4
cc_798 ( N_noxref_4_c_850_n Y ) capacitor c=0.00448306f //x=11.25 //y=4.88 \
 //x2=11.96 //y2=2.4
cc_799 ( N_noxref_4_c_901_p Y ) capacitor c=0.00461871f //x=11.625 //y=4.97 \
 //x2=11.96 //y2=2.4
cc_800 ( N_noxref_4_c_866_n Y ) capacitor c=0.00271446f //x=11.22 //y=2.26 \
 //x2=11.96 //y2=2.4
cc_801 ( N_noxref_4_c_869_n Y ) capacitor c=0.00142201f //x=11.25 //y=4.88 \
 //x2=11.96 //y2=2.4
cc_802 ( N_noxref_4_c_825_n N_Y_c_1790_n ) capacitor c=0.00225132f //x=11.22 \
 //y=3.67 //x2=11.365 //y2=5.38
cc_803 ( N_noxref_4_c_826_n N_Y_c_1790_n ) capacitor c=0.0226171f //x=11.22 \
 //y=4.735 //x2=11.365 //y2=5.38
cc_804 ( N_noxref_4_c_839_n N_Y_c_1790_n ) capacitor c=0.00104016f //x=11.06 \
 //y=3.51 //x2=11.365 //y2=5.38
cc_805 ( N_noxref_4_c_845_n N_Y_c_1790_n ) capacitor c=7.82777e-19 //x=11.22 \
 //y=3.51 //x2=11.365 //y2=5.38
cc_806 ( N_noxref_4_c_850_n N_Y_c_1790_n ) capacitor c=0.00469257f //x=11.25 \
 //y=4.88 //x2=11.365 //y2=5.38
cc_807 ( N_noxref_4_M19_noxref_g N_Y_c_1790_n ) capacitor c=0.00842859f \
 //x=11.26 //y=6.2 //x2=11.365 //y2=5.38
cc_808 ( N_noxref_4_c_869_n N_Y_c_1790_n ) capacitor c=9.10962e-19 //x=11.25 \
 //y=4.88 //x2=11.365 //y2=5.38
cc_809 ( N_noxref_4_c_802_n N_Y_c_1821_n ) capacitor c=0.00324213f //x=8.19 \
 //y=1.75 //x2=11.52 //y2=1.75
cc_810 ( N_noxref_4_c_859_n N_Y_c_1821_n ) capacitor c=0.00119008f //x=11.255 \
 //y=1.43 //x2=11.52 //y2=1.75
cc_811 ( N_noxref_4_c_861_n N_Y_c_1821_n ) capacitor c=0.00438634f //x=11.255 \
 //y=1.74 //x2=11.52 //y2=1.75
cc_812 ( N_noxref_4_c_1008_p N_Y_c_1821_n ) capacitor c=0.00929259f //x=11.63 \
 //y=1.585 //x2=11.52 //y2=1.75
cc_813 ( N_noxref_4_c_865_n N_Y_c_1821_n ) capacitor c=0.00341295f //x=11.785 \
 //y=1.43 //x2=11.52 //y2=1.75
cc_814 ( N_noxref_4_c_1010_p N_Y_c_1821_n ) capacitor c=0.00341114f //x=11.22 \
 //y=2.095 //x2=11.52 //y2=1.75
cc_815 ( N_noxref_4_M20_noxref_g N_Y_c_1827_n ) capacitor c=0.0115937f \
 //x=11.7 //y=6.2 //x2=11.875 //y2=5.38
cc_816 ( N_noxref_4_c_1008_p N_Y_c_1828_n ) capacitor c=0.00194324f //x=11.63 \
 //y=1.585 //x2=11.875 //y2=1.835
cc_817 ( N_noxref_4_c_865_n N_Y_c_1828_n ) capacitor c=0.00323005f //x=11.785 \
 //y=1.43 //x2=11.875 //y2=1.835
cc_818 ( N_noxref_4_c_803_n N_Y_c_1830_n ) capacitor c=0.00231467f //x=8.545 \
 //y=1.835 //x2=11.605 //y2=1.835
cc_819 ( N_noxref_4_c_873_p N_Y_c_1791_n ) capacitor c=0.00114153f //x=8.545 \
 //y=5.38 //x2=10.6 //y2=5.56
cc_820 ( N_noxref_4_c_876_p N_Y_c_1791_n ) capacitor c=5.29822e-19 //x=8.15 \
 //y=5.38 //x2=10.6 //y2=5.56
cc_821 ( N_noxref_4_c_877_p N_Y_c_1791_n ) capacitor c=0.00147119f //x=8.15 \
 //y=5.56 //x2=10.6 //y2=5.56
cc_822 ( N_noxref_4_c_839_n N_Y_c_1791_n ) capacitor c=0.0100578f //x=11.06 \
 //y=3.51 //x2=10.6 //y2=5.56
cc_823 ( N_noxref_4_M19_noxref_g N_Y_c_1835_n ) capacitor c=0.00192712f \
 //x=11.26 //y=6.2 //x2=11.48 //y2=5.38
cc_824 ( N_noxref_4_M20_noxref_g N_Y_c_1835_n ) capacitor c=0.00362563f \
 //x=11.7 //y=6.2 //x2=11.48 //y2=5.38
cc_825 ( N_noxref_4_c_901_p N_Y_c_1835_n ) capacitor c=0.0020909f //x=11.625 \
 //y=4.97 //x2=11.48 //y2=5.38
cc_826 ( N_noxref_4_c_833_n N_Y_c_1838_n ) capacitor c=6.99317e-19 //x=8.19 \
 //y=1.18 //x2=11.52 //y2=1.18
cc_827 ( N_noxref_4_c_856_n N_Y_c_1838_n ) capacitor c=0.00120406f //x=11.255 \
 //y=1.085 //x2=11.52 //y2=1.18
cc_828 ( N_noxref_4_c_859_n N_Y_c_1838_n ) capacitor c=0.00218694f //x=11.255 \
 //y=1.43 //x2=11.52 //y2=1.18
cc_829 ( N_noxref_4_c_1025_p N_Y_c_1838_n ) capacitor c=5.50523e-19 //x=11.63 \
 //y=0.93 //x2=11.52 //y2=1.18
cc_830 ( N_noxref_4_c_1008_p N_Y_c_1838_n ) capacitor c=5.67071e-19 //x=11.63 \
 //y=1.585 //x2=11.52 //y2=1.18
cc_831 ( N_noxref_4_c_864_n N_Y_c_1838_n ) capacitor c=0.00121175f //x=11.785 \
 //y=1.085 //x2=11.52 //y2=1.18
cc_832 ( N_noxref_4_c_865_n N_Y_c_1838_n ) capacitor c=0.00366282f //x=11.785 \
 //y=1.43 //x2=11.52 //y2=1.18
cc_833 ( N_noxref_4_M19_noxref_g N_Y_c_1845_n ) capacitor c=0.0178987f \
 //x=11.26 //y=6.2 //x2=11.48 //y2=5.56
cc_834 ( N_noxref_4_M20_noxref_g N_Y_c_1845_n ) capacitor c=0.0178506f \
 //x=11.7 //y=6.2 //x2=11.48 //y2=5.56
cc_835 ( N_noxref_4_c_901_p N_Y_c_1845_n ) capacitor c=0.00291714f //x=11.625 \
 //y=4.97 //x2=11.48 //y2=5.56
cc_836 ( N_noxref_4_c_856_n N_Y_M6_noxref_d ) capacitor c=0.00137165f \
 //x=11.255 //y=1.085 //x2=11.33 //y2=1.085
cc_837 ( N_noxref_4_c_859_n N_Y_M6_noxref_d ) capacitor c=0.00237422f \
 //x=11.255 //y=1.43 //x2=11.33 //y2=1.085
cc_838 ( N_noxref_4_c_1025_p N_Y_M6_noxref_d ) capacitor c=0.0020782f \
 //x=11.63 //y=0.93 //x2=11.33 //y2=1.085
cc_839 ( N_noxref_4_c_1008_p N_Y_M6_noxref_d ) capacitor c=0.00356097f \
 //x=11.63 //y=1.585 //x2=11.33 //y2=1.085
cc_840 ( N_noxref_4_c_864_n N_Y_M6_noxref_d ) capacitor c=8.50095e-19 \
 //x=11.785 //y=1.085 //x2=11.33 //y2=1.085
cc_841 ( N_noxref_4_c_865_n N_Y_M6_noxref_d ) capacitor c=0.00237422f \
 //x=11.785 //y=1.43 //x2=11.33 //y2=1.085
cc_842 ( N_noxref_4_c_804_n N_noxref_11_c_1984_n ) capacitor c=0.00911498f \
 //x=8.275 //y=1.835 //x2=7.705 //y2=1.675
cc_843 ( N_noxref_4_c_803_n N_noxref_11_c_1994_n ) capacitor c=0.00373013f \
 //x=8.545 //y=1.835 //x2=8.59 //y2=0.71
cc_844 ( N_noxref_4_c_833_n N_noxref_11_c_1994_n ) capacitor c=0.00367971f \
 //x=8.19 //y=1.18 //x2=8.59 //y2=0.71
cc_845 ( N_noxref_4_M4_noxref_d N_noxref_11_c_1994_n ) capacitor c=0.00910163f \
 //x=8 //y=1.085 //x2=8.59 //y2=0.71
cc_846 ( N_noxref_4_c_802_n N_noxref_11_M3_noxref_s ) capacitor c=0.0162484f \
 //x=8.19 //y=1.75 //x2=6.6 //y2=0.545
cc_847 ( N_noxref_4_c_803_n N_noxref_11_M3_noxref_s ) capacitor c=0.00640979f \
 //x=8.545 //y=1.835 //x2=6.6 //y2=0.545
cc_848 ( N_noxref_4_c_814_n N_noxref_11_M3_noxref_s ) capacitor c=4.13941e-19 \
 //x=8.63 //y=3.68 //x2=6.6 //y2=0.545
cc_849 ( N_noxref_4_c_833_n N_noxref_11_M3_noxref_s ) capacitor c=0.00905169f \
 //x=8.19 //y=1.18 //x2=6.6 //y2=0.545
cc_850 ( N_noxref_4_c_795_n N_noxref_11_M3_noxref_s ) capacitor c=0.0010514f \
 //x=8.63 //y=3.51 //x2=6.6 //y2=0.545
cc_851 ( N_noxref_4_M4_noxref_d N_noxref_11_M3_noxref_s ) capacitor \
 c=0.0275552f //x=8 //y=1.085 //x2=6.6 //y2=0.545
cc_852 ( N_noxref_4_c_839_n N_noxref_12_c_2049_n ) capacitor c=0.00436777f \
 //x=11.06 //y=3.51 //x2=10.95 //y2=1.76
cc_853 ( N_noxref_4_c_825_n N_noxref_12_c_2057_n ) capacitor c=0.00167766f \
 //x=11.22 //y=3.67 //x2=11.035 //y2=1.675
cc_854 ( N_noxref_4_c_836_n N_noxref_12_c_2057_n ) capacitor c=7.50092e-19 \
 //x=11.22 //y=2.26 //x2=11.035 //y2=1.675
cc_855 ( N_noxref_4_c_861_n N_noxref_12_c_2057_n ) capacitor c=0.00890678f \
 //x=11.255 //y=1.74 //x2=11.035 //y2=1.675
cc_856 ( N_noxref_4_c_866_n N_noxref_12_c_2057_n ) capacitor c=0.00175171f \
 //x=11.22 //y=2.26 //x2=11.035 //y2=1.675
cc_857 ( N_noxref_4_c_836_n N_noxref_12_c_2066_n ) capacitor c=0.001463f \
 //x=11.22 //y=2.26 //x2=11.92 //y2=0.71
cc_858 ( N_noxref_4_c_846_n N_noxref_12_c_2066_n ) capacitor c=8.82141e-19 \
 //x=11.22 //y=2.26 //x2=11.92 //y2=0.71
cc_859 ( N_noxref_4_c_856_n N_noxref_12_c_2066_n ) capacitor c=0.0200262f \
 //x=11.255 //y=1.085 //x2=11.92 //y2=0.71
cc_860 ( N_noxref_4_c_864_n N_noxref_12_c_2066_n ) capacitor c=0.00825432f \
 //x=11.785 //y=1.085 //x2=11.92 //y2=0.71
cc_861 ( N_noxref_4_c_866_n N_noxref_12_c_2066_n ) capacitor c=2.1838e-19 \
 //x=11.22 //y=2.26 //x2=11.92 //y2=0.71
cc_862 ( N_noxref_4_c_856_n N_noxref_12_M5_noxref_s ) capacitor c=0.00890678f \
 //x=11.255 //y=1.085 //x2=9.93 //y2=0.545
cc_863 ( N_noxref_4_c_864_n N_noxref_12_M5_noxref_s ) capacitor c=0.015333f \
 //x=11.785 //y=1.085 //x2=9.93 //y2=0.545
cc_864 ( N_noxref_4_c_865_n N_noxref_12_M5_noxref_s ) capacitor c=0.00248746f \
 //x=11.785 //y=1.43 //x2=9.93 //y2=0.545
cc_865 ( N_VDD_c_1111_n N_A0_c_1308_n ) capacitor c=0.00226427f //x=6.04 \
 //y=7.585 //x2=4.59 //y2=4.88
cc_866 ( N_VDD_c_1145_n N_A0_M11_noxref_g ) capacitor c=0.00697352f //x=5.175 \
 //y=7.585 //x2=4.6 //y2=6.2
cc_867 ( N_VDD_M10_noxref_d N_A0_M11_noxref_g ) capacitor c=0.015318f \
 //x=4.235 //y=5.2 //x2=4.6 //y2=6.2
cc_868 ( N_VDD_c_1145_n N_A0_M12_noxref_g ) capacitor c=0.00755544f //x=5.175 \
 //y=7.585 //x2=5.04 //y2=6.2
cc_869 ( N_VDD_M12_noxref_d N_A0_M12_noxref_g ) capacitor c=0.0430452f \
 //x=5.115 //y=5.2 //x2=5.04 //y2=6.2
cc_870 ( N_VDD_c_1111_n N_A0_c_1361_n ) capacitor c=0.0129149f //x=6.04 \
 //y=7.585 //x2=4.965 //y2=4.97
cc_871 ( N_VDD_c_1111_n N_A0_c_1327_n ) capacitor c=2.73429e-19 //x=6.04 \
 //y=7.585 //x2=4.59 //y2=4.88
cc_872 ( N_VDD_M10_noxref_d N_A0_c_1327_n ) capacitor c=3.32552e-19 //x=4.235 \
 //y=5.2 //x2=4.59 //y2=4.88
cc_873 ( N_VDD_c_1160_n N_A1_c_1423_n ) capacitor c=0.00226427f //x=9.37 \
 //y=7.585 //x2=7.92 //y2=4.88
cc_874 ( N_VDD_c_1196_n N_A1_M15_noxref_g ) capacitor c=0.00697352f //x=8.505 \
 //y=7.585 //x2=7.93 //y2=6.2
cc_875 ( N_VDD_M14_noxref_d N_A1_M15_noxref_g ) capacitor c=0.015318f \
 //x=7.565 //y=5.2 //x2=7.93 //y2=6.2
cc_876 ( N_VDD_c_1196_n N_A1_M16_noxref_g ) capacitor c=0.00755544f //x=8.505 \
 //y=7.585 //x2=8.37 //y2=6.2
cc_877 ( N_VDD_M16_noxref_d N_A1_M16_noxref_g ) capacitor c=0.0430452f \
 //x=8.445 //y=5.2 //x2=8.37 //y2=6.2
cc_878 ( N_VDD_c_1160_n N_A1_c_1475_n ) capacitor c=0.0129149f //x=9.37 \
 //y=7.585 //x2=8.295 //y2=4.97
cc_879 ( N_VDD_c_1160_n N_A1_c_1442_n ) capacitor c=2.73429e-19 //x=9.37 \
 //y=7.585 //x2=7.92 //y2=4.88
cc_880 ( N_VDD_M14_noxref_d N_A1_c_1442_n ) capacitor c=3.32552e-19 //x=7.565 \
 //y=5.2 //x2=7.92 //y2=4.88
cc_881 ( N_VDD_c_1116_n N_GND_c_1598_n ) capacitor c=0.00989514f //x=11.96 \
 //y=7.58 //x2=11.96 //y2=0.18
cc_882 ( N_VDD_c_1072_n N_GND_c_1545_n ) capacitor c=0.00989514f //x=1.23 \
 //y=7.58 //x2=1.12 //y2=0.175
cc_883 ( N_VDD_c_1077_n N_GND_c_1550_n ) capacitor c=0.00906209f //x=2.71 \
 //y=7.585 //x2=2.71 //y2=0.175
cc_884 ( N_VDD_c_1111_n N_GND_c_1603_n ) capacitor c=0.00906209f //x=6.04 \
 //y=7.585 //x2=6.04 //y2=0.175
cc_885 ( N_VDD_c_1160_n N_GND_c_1651_n ) capacitor c=0.00906209f //x=9.37 \
 //y=7.585 //x2=9.37 //y2=0.175
cc_886 ( N_VDD_c_1160_n Y ) capacitor c=6.93347e-19 //x=9.37 //y=7.585 \
 //x2=11.96 //y2=2.4
cc_887 ( N_VDD_c_1116_n Y ) capacitor c=0.0392011f //x=11.96 //y=7.58 \
 //x2=11.96 //y2=2.4
cc_888 ( N_VDD_c_1061_n N_Y_c_1790_n ) capacitor c=0.00648262f //x=11.96 \
 //y=7.58 //x2=11.365 //y2=5.38
cc_889 ( N_VDD_c_1150_n N_Y_c_1790_n ) capacitor c=0.00208087f //x=10.955 \
 //y=7.585 //x2=11.365 //y2=5.38
cc_890 ( N_VDD_c_1201_n N_Y_c_1790_n ) capacitor c=0.00180737f //x=11.835 \
 //y=7.585 //x2=11.365 //y2=5.38
cc_891 ( N_VDD_M18_noxref_d N_Y_c_1790_n ) capacitor c=0.00734094f //x=10.895 \
 //y=5.2 //x2=11.365 //y2=5.38
cc_892 ( N_VDD_c_1061_n N_Y_c_1827_n ) capacitor c=0.00488503f //x=11.96 \
 //y=7.58 //x2=11.875 //y2=5.38
cc_893 ( N_VDD_c_1201_n N_Y_c_1827_n ) capacitor c=0.00213203f //x=11.835 \
 //y=7.585 //x2=11.875 //y2=5.38
cc_894 ( N_VDD_M20_noxref_d N_Y_c_1827_n ) capacitor c=0.0125399f //x=11.775 \
 //y=5.2 //x2=11.875 //y2=5.38
cc_895 ( N_VDD_c_1061_n N_Y_c_1791_n ) capacitor c=0.00368834f //x=11.96 \
 //y=7.58 //x2=10.6 //y2=5.56
cc_896 ( N_VDD_c_1150_n N_Y_c_1791_n ) capacitor c=9.99055e-19 //x=10.955 \
 //y=7.585 //x2=10.6 //y2=5.56
cc_897 ( N_VDD_c_1160_n N_Y_c_1791_n ) capacitor c=4.91377e-19 //x=9.37 \
 //y=7.585 //x2=10.6 //y2=5.56
cc_898 ( N_VDD_M17_noxref_s N_Y_c_1791_n ) capacitor c=0.0577058f //x=10.025 \
 //y=5.2 //x2=10.6 //y2=5.56
cc_899 ( N_VDD_M18_noxref_d N_Y_c_1791_n ) capacitor c=0.0043528f //x=10.895 \
 //y=5.2 //x2=10.6 //y2=5.56
cc_900 ( N_VDD_c_1061_n N_Y_c_1835_n ) capacitor c=8.42623e-19 //x=11.96 \
 //y=7.58 //x2=11.48 //y2=5.38
cc_901 ( N_VDD_c_1201_n N_Y_c_1835_n ) capacitor c=5.10524e-19 //x=11.835 \
 //y=7.585 //x2=11.48 //y2=5.38
cc_902 ( N_VDD_c_1116_n N_Y_c_1835_n ) capacitor c=0.00379179f //x=11.96 \
 //y=7.58 //x2=11.48 //y2=5.38
cc_903 ( N_VDD_M17_noxref_s N_Y_c_1835_n ) capacitor c=6.52457e-19 //x=10.025 \
 //y=5.2 //x2=11.48 //y2=5.38
cc_904 ( N_VDD_c_1061_n N_Y_c_1872_n ) capacitor c=0.00285853f //x=11.96 \
 //y=7.58 //x2=11.48 //y2=5.56
cc_905 ( N_VDD_c_1201_n N_Y_c_1872_n ) capacitor c=5.77976e-19 //x=11.835 \
 //y=7.585 //x2=11.48 //y2=5.56
cc_906 ( N_VDD_c_1116_n N_Y_c_1872_n ) capacitor c=0.0016115f //x=11.96 \
 //y=7.58 //x2=11.48 //y2=5.56
cc_907 ( N_VDD_M18_noxref_d N_Y_c_1872_n ) capacitor c=0.0043528f //x=10.895 \
 //y=5.2 //x2=11.48 //y2=5.56
cc_908 ( N_VDD_M20_noxref_d N_Y_c_1872_n ) capacitor c=0.00979407f //x=11.775 \
 //y=5.2 //x2=11.48 //y2=5.56
cc_909 ( N_VDD_c_1061_n N_Y_c_1797_n ) capacitor c=0.00224881f //x=11.96 \
 //y=7.58 //x2=10.6 //y2=5.56
cc_910 ( N_VDD_c_1150_n N_Y_c_1797_n ) capacitor c=0.0136705f //x=10.955 \
 //y=7.585 //x2=10.6 //y2=5.56
cc_911 ( N_VDD_c_1160_n N_Y_c_1797_n ) capacitor c=0.0064135f //x=9.37 \
 //y=7.585 //x2=10.6 //y2=5.56
cc_912 ( N_VDD_c_1116_n N_Y_c_1797_n ) capacitor c=0.00135089f //x=11.96 \
 //y=7.58 //x2=10.6 //y2=5.56
cc_913 ( N_VDD_M17_noxref_s N_Y_c_1797_n ) capacitor c=0.0887533f //x=10.025 \
 //y=5.2 //x2=10.6 //y2=5.56
cc_914 ( N_VDD_M18_noxref_d N_Y_c_1797_n ) capacitor c=0.065554f //x=10.895 \
 //y=5.2 //x2=10.6 //y2=5.56
cc_915 ( N_VDD_c_1061_n N_Y_c_1845_n ) capacitor c=0.00224881f //x=11.96 \
 //y=7.58 //x2=11.48 //y2=5.56
cc_916 ( N_VDD_c_1201_n N_Y_c_1845_n ) capacitor c=0.0136705f //x=11.835 \
 //y=7.585 //x2=11.48 //y2=5.56
cc_917 ( N_VDD_c_1116_n N_Y_c_1845_n ) capacitor c=0.0115375f //x=11.96 \
 //y=7.58 //x2=11.48 //y2=5.56
cc_918 ( N_VDD_M18_noxref_d N_Y_c_1845_n ) capacitor c=0.065554f //x=10.895 \
 //y=5.2 //x2=11.48 //y2=5.56
cc_919 ( N_VDD_M20_noxref_d N_Y_c_1845_n ) capacitor c=0.065554f //x=11.775 \
 //y=5.2 //x2=11.48 //y2=5.56
cc_920 ( N_A0_c_1301_n N_GND_c_1621_n ) capacitor c=0.00234561f //x=4.56 \
 //y=2.26 //x2=7.135 //y2=0.175
cc_921 ( N_A0_c_1301_n N_GND_c_1544_n ) capacitor c=3.77328e-19 //x=4.56 \
 //y=2.26 //x2=5.87 //y2=0.175
cc_922 ( N_A0_c_1304_n N_GND_c_1603_n ) capacitor c=0.00224736f //x=4.56 \
 //y=2.26 //x2=6.04 //y2=0.175
cc_923 ( N_A0_c_1323_n N_GND_c_1603_n ) capacitor c=0.00275184f //x=5.125 \
 //y=1.43 //x2=6.04 //y2=0.175
cc_924 ( N_A0_c_1324_n N_GND_c_1603_n ) capacitor c=2.63786e-19 //x=4.56 \
 //y=2.26 //x2=6.04 //y2=0.175
cc_925 ( N_A0_c_1301_n N_noxref_10_c_1917_n ) capacitor c=7.50092e-19 //x=4.56 \
 //y=2.26 //x2=4.375 //y2=1.675
cc_926 ( N_A0_c_1319_n N_noxref_10_c_1917_n ) capacitor c=0.00888238f \
 //x=4.595 //y=1.74 //x2=4.375 //y2=1.675
cc_927 ( N_A0_c_1324_n N_noxref_10_c_1917_n ) capacitor c=0.00175171f //x=4.56 \
 //y=2.26 //x2=4.375 //y2=1.675
cc_928 ( N_A0_c_1301_n N_noxref_10_c_1924_n ) capacitor c=0.00141156f //x=4.56 \
 //y=2.26 //x2=5.26 //y2=0.71
cc_929 ( N_A0_c_1304_n N_noxref_10_c_1924_n ) capacitor c=8.82141e-19 //x=4.56 \
 //y=2.26 //x2=5.26 //y2=0.71
cc_930 ( N_A0_c_1314_n N_noxref_10_c_1924_n ) capacitor c=0.0199501f //x=4.595 \
 //y=1.085 //x2=5.26 //y2=0.71
cc_931 ( N_A0_c_1322_n N_noxref_10_c_1924_n ) capacitor c=0.00825432f \
 //x=5.125 //y=1.085 //x2=5.26 //y2=0.71
cc_932 ( N_A0_c_1324_n N_noxref_10_c_1924_n ) capacitor c=2.1838e-19 //x=4.56 \
 //y=2.26 //x2=5.26 //y2=0.71
cc_933 ( N_A0_c_1314_n N_noxref_10_M1_noxref_s ) capacitor c=0.00888238f \
 //x=4.595 //y=1.085 //x2=3.27 //y2=0.545
cc_934 ( N_A0_c_1322_n N_noxref_10_M1_noxref_s ) capacitor c=0.015333f \
 //x=5.125 //y=1.085 //x2=3.27 //y2=0.545
cc_935 ( N_A0_c_1323_n N_noxref_10_M1_noxref_s ) capacitor c=0.00248746f \
 //x=5.125 //y=1.43 //x2=3.27 //y2=0.545
cc_936 ( N_A1_c_1416_n N_GND_c_1665_n ) capacitor c=0.00234561f //x=7.89 \
 //y=2.26 //x2=10.465 //y2=0.175
cc_937 ( N_A1_c_1416_n N_GND_c_1597_n ) capacitor c=3.77328e-19 //x=7.89 \
 //y=2.26 //x2=9.2 //y2=0.175
cc_938 ( N_A1_c_1419_n N_GND_c_1651_n ) capacitor c=0.00224736f //x=7.89 \
 //y=2.26 //x2=9.37 //y2=0.175
cc_939 ( N_A1_c_1438_n N_GND_c_1651_n ) capacitor c=0.00275184f //x=8.455 \
 //y=1.43 //x2=9.37 //y2=0.175
cc_940 ( N_A1_c_1439_n N_GND_c_1651_n ) capacitor c=2.63786e-19 //x=7.89 \
 //y=2.26 //x2=9.37 //y2=0.175
cc_941 ( N_A1_c_1416_n N_noxref_11_c_1984_n ) capacitor c=7.50092e-19 //x=7.89 \
 //y=2.26 //x2=7.705 //y2=1.675
cc_942 ( N_A1_c_1434_n N_noxref_11_c_1984_n ) capacitor c=0.00888238f \
 //x=7.925 //y=1.74 //x2=7.705 //y2=1.675
cc_943 ( N_A1_c_1439_n N_noxref_11_c_1984_n ) capacitor c=0.00175171f //x=7.89 \
 //y=2.26 //x2=7.705 //y2=1.675
cc_944 ( N_A1_c_1416_n N_noxref_11_c_1994_n ) capacitor c=0.00141156f //x=7.89 \
 //y=2.26 //x2=8.59 //y2=0.71
cc_945 ( N_A1_c_1419_n N_noxref_11_c_1994_n ) capacitor c=8.82141e-19 //x=7.89 \
 //y=2.26 //x2=8.59 //y2=0.71
cc_946 ( N_A1_c_1429_n N_noxref_11_c_1994_n ) capacitor c=0.0199501f //x=7.925 \
 //y=1.085 //x2=8.59 //y2=0.71
cc_947 ( N_A1_c_1437_n N_noxref_11_c_1994_n ) capacitor c=0.00825432f \
 //x=8.455 //y=1.085 //x2=8.59 //y2=0.71
cc_948 ( N_A1_c_1439_n N_noxref_11_c_1994_n ) capacitor c=2.1838e-19 //x=7.89 \
 //y=2.26 //x2=8.59 //y2=0.71
cc_949 ( N_A1_c_1429_n N_noxref_11_M3_noxref_s ) capacitor c=0.00888238f \
 //x=7.925 //y=1.085 //x2=6.6 //y2=0.545
cc_950 ( N_A1_c_1437_n N_noxref_11_M3_noxref_s ) capacitor c=0.015333f \
 //x=8.455 //y=1.085 //x2=6.6 //y2=0.545
cc_951 ( N_A1_c_1438_n N_noxref_11_M3_noxref_s ) capacitor c=0.00248746f \
 //x=8.455 //y=1.43 //x2=6.6 //y2=0.545
cc_952 ( N_GND_c_1651_n Y ) capacitor c=3.54807e-19 //x=9.37 //y=0.175 \
 //x2=11.96 //y2=2.4
cc_953 ( N_GND_c_1598_n N_Y_c_1821_n ) capacitor c=0.00528499f //x=11.96 \
 //y=0.18 //x2=11.52 //y2=1.75
cc_954 ( N_GND_c_1669_n N_Y_c_1828_n ) capacitor c=0.00652597f //x=11.96 \
 //y=0.18 //x2=11.875 //y2=1.835
cc_955 ( N_GND_c_1598_n N_Y_c_1828_n ) capacitor c=0.0406516f //x=11.96 \
 //y=0.18 //x2=11.875 //y2=1.835
cc_956 ( N_GND_c_1630_n N_Y_c_1791_n ) capacitor c=8.02548e-19 //x=10.55 \
 //y=1.135 //x2=10.6 //y2=5.56
cc_957 ( N_GND_c_1669_n N_Y_c_1838_n ) capacitor c=0.00964814f //x=11.96 \
 //y=0.18 //x2=11.52 //y2=1.18
cc_958 ( N_GND_c_1630_n N_Y_c_1838_n ) capacitor c=0.0141824f //x=10.55 \
 //y=1.135 //x2=11.52 //y2=1.18
cc_959 ( N_GND_c_1598_n N_Y_c_1838_n ) capacitor c=2.83275e-19 //x=11.96 \
 //y=0.18 //x2=11.52 //y2=1.18
cc_960 ( N_GND_M5_noxref_d N_Y_c_1838_n ) capacitor c=2.82748e-19 //x=10.36 \
 //y=1.045 //x2=11.52 //y2=1.18
cc_961 ( N_GND_c_1669_n N_Y_M6_noxref_d ) capacitor c=3.01769e-19 //x=11.96 \
 //y=0.18 //x2=11.33 //y2=1.085
cc_962 ( N_GND_c_1630_n N_Y_M6_noxref_d ) capacitor c=2.93544e-19 //x=10.55 \
 //y=1.135 //x2=11.33 //y2=1.085
cc_963 ( N_GND_M0_noxref_s N_noxref_10_c_1907_n ) capacitor c=0.0029758f \
 //x=0.985 //y=0.55 //x2=3.405 //y2=1.675
cc_964 ( N_GND_c_1519_n N_noxref_10_c_1909_n ) capacitor c=0.00238305f \
 //x=3.805 //y=0.175 //x2=4.29 //y2=1.76
cc_965 ( N_GND_c_1621_n N_noxref_10_c_1909_n ) capacitor c=7.45647e-19 \
 //x=7.135 //y=0.175 //x2=4.29 //y2=1.76
cc_966 ( N_GND_c_1524_n N_noxref_10_c_1909_n ) capacitor c=0.00396001f \
 //x=3.89 //y=1.135 //x2=4.29 //y2=1.76
cc_967 ( N_GND_c_1544_n N_noxref_10_c_1909_n ) capacitor c=0.00375345f \
 //x=5.87 //y=0.175 //x2=4.29 //y2=1.76
cc_968 ( N_GND_M1_noxref_d N_noxref_10_c_1909_n ) capacitor c=0.00578453f \
 //x=3.7 //y=1.045 //x2=4.29 //y2=1.76
cc_969 ( N_GND_c_1621_n N_noxref_10_c_1950_n ) capacitor c=0.0068323f \
 //x=7.135 //y=0.175 //x2=4.375 //y2=0.795
cc_970 ( N_GND_c_1535_n N_noxref_10_c_1950_n ) capacitor c=0.0120153f \
 //x=3.887 //y=1.005 //x2=4.375 //y2=0.795
cc_971 ( N_GND_c_1544_n N_noxref_10_c_1950_n ) capacitor c=0.0146605f //x=5.87 \
 //y=0.175 //x2=4.375 //y2=0.795
cc_972 ( N_GND_c_1598_n N_noxref_10_c_1950_n ) capacitor c=0.00145873f \
 //x=11.96 //y=0.18 //x2=4.375 //y2=0.795
cc_973 ( N_GND_c_1550_n N_noxref_10_c_1950_n ) capacitor c=0.00282499f \
 //x=2.71 //y=0.175 //x2=4.375 //y2=0.795
cc_974 ( N_GND_c_1603_n N_noxref_10_c_1950_n ) capacitor c=2.99356e-19 \
 //x=6.04 //y=0.175 //x2=4.375 //y2=0.795
cc_975 ( N_GND_c_1550_n N_noxref_10_c_1917_n ) capacitor c=2.84609e-19 \
 //x=2.71 //y=0.175 //x2=4.375 //y2=1.675
cc_976 ( N_GND_c_1621_n N_noxref_10_c_1924_n ) capacitor c=0.0100395f \
 //x=7.135 //y=0.175 //x2=5.26 //y2=0.71
cc_977 ( N_GND_c_1544_n N_noxref_10_c_1924_n ) capacitor c=0.0374812f //x=5.87 \
 //y=0.175 //x2=5.26 //y2=0.71
cc_978 ( N_GND_c_1598_n N_noxref_10_c_1924_n ) capacitor c=0.00199095f \
 //x=11.96 //y=0.18 //x2=5.26 //y2=0.71
cc_979 ( N_GND_c_1621_n N_noxref_10_c_1960_n ) capacitor c=0.00247935f \
 //x=7.135 //y=0.175 //x2=5.345 //y2=0.795
cc_980 ( N_GND_c_1544_n N_noxref_10_c_1960_n ) capacitor c=0.0145578f //x=5.87 \
 //y=0.175 //x2=5.345 //y2=0.795
cc_981 ( N_GND_c_1598_n N_noxref_10_c_1960_n ) capacitor c=0.00145015f \
 //x=11.96 //y=0.18 //x2=5.345 //y2=0.795
cc_982 ( N_GND_c_1603_n N_noxref_10_c_1960_n ) capacitor c=0.0392026f //x=6.04 \
 //y=0.175 //x2=5.345 //y2=0.795
cc_983 ( N_GND_c_1519_n N_noxref_10_M1_noxref_s ) capacitor c=0.00724992f \
 //x=3.805 //y=0.175 //x2=3.27 //y2=0.545
cc_984 ( N_GND_c_1524_n N_noxref_10_M1_noxref_s ) capacitor c=0.00996107f \
 //x=3.89 //y=1.135 //x2=3.27 //y2=0.545
cc_985 ( N_GND_c_1535_n N_noxref_10_M1_noxref_s ) capacitor c=0.0170652f \
 //x=3.887 //y=1.005 //x2=3.27 //y2=0.545
cc_986 ( N_GND_c_1735_p N_noxref_10_M1_noxref_s ) capacitor c=0.0029758f \
 //x=2.09 //y=0.63 //x2=3.27 //y2=0.545
cc_987 ( N_GND_c_1544_n N_noxref_10_M1_noxref_s ) capacitor c=0.014661f \
 //x=5.87 //y=0.175 //x2=3.27 //y2=0.545
cc_988 ( N_GND_c_1598_n N_noxref_10_M1_noxref_s ) capacitor c=0.00145873f \
 //x=11.96 //y=0.18 //x2=3.27 //y2=0.545
cc_989 ( N_GND_c_1550_n N_noxref_10_M1_noxref_s ) capacitor c=0.0528146f \
 //x=2.71 //y=0.175 //x2=3.27 //y2=0.545
cc_990 ( N_GND_c_1603_n N_noxref_10_M1_noxref_s ) capacitor c=0.0064811f \
 //x=6.04 //y=0.175 //x2=3.27 //y2=0.545
cc_991 ( N_GND_M1_noxref_d N_noxref_10_M1_noxref_s ) capacitor c=0.0271276f \
 //x=3.7 //y=1.045 //x2=3.27 //y2=0.545
cc_992 ( N_GND_c_1621_n N_noxref_11_c_1977_n ) capacitor c=9.79596e-19 \
 //x=7.135 //y=0.175 //x2=7.62 //y2=1.76
cc_993 ( N_GND_c_1665_n N_noxref_11_c_1977_n ) capacitor c=7.45647e-19 \
 //x=10.465 //y=0.175 //x2=7.62 //y2=1.76
cc_994 ( N_GND_c_1581_n N_noxref_11_c_1977_n ) capacitor c=0.00398718f \
 //x=7.22 //y=1.135 //x2=7.62 //y2=1.76
cc_995 ( N_GND_c_1597_n N_noxref_11_c_1977_n ) capacitor c=0.00392838f //x=9.2 \
 //y=0.175 //x2=7.62 //y2=1.76
cc_996 ( N_GND_M3_noxref_d N_noxref_11_c_1977_n ) capacitor c=0.00578453f \
 //x=7.03 //y=1.045 //x2=7.62 //y2=1.76
cc_997 ( N_GND_c_1665_n N_noxref_11_c_2019_n ) capacitor c=0.0068323f \
 //x=10.465 //y=0.175 //x2=7.705 //y2=0.795
cc_998 ( N_GND_c_1590_n N_noxref_11_c_2019_n ) capacitor c=0.0120153f \
 //x=7.217 //y=1.005 //x2=7.705 //y2=0.795
cc_999 ( N_GND_c_1597_n N_noxref_11_c_2019_n ) capacitor c=0.0146605f //x=9.2 \
 //y=0.175 //x2=7.705 //y2=0.795
cc_1000 ( N_GND_c_1598_n N_noxref_11_c_2019_n ) capacitor c=0.00145873f \
 //x=11.96 //y=0.18 //x2=7.705 //y2=0.795
cc_1001 ( N_GND_c_1603_n N_noxref_11_c_2019_n ) capacitor c=0.00282552f \
 //x=6.04 //y=0.175 //x2=7.705 //y2=0.795
cc_1002 ( N_GND_c_1651_n N_noxref_11_c_2019_n ) capacitor c=2.99356e-19 \
 //x=9.37 //y=0.175 //x2=7.705 //y2=0.795
cc_1003 ( N_GND_c_1603_n N_noxref_11_c_1984_n ) capacitor c=2.8386e-19 \
 //x=6.04 //y=0.175 //x2=7.705 //y2=1.675
cc_1004 ( N_GND_c_1665_n N_noxref_11_c_1994_n ) capacitor c=0.0100533f \
 //x=10.465 //y=0.175 //x2=8.59 //y2=0.71
cc_1005 ( N_GND_c_1597_n N_noxref_11_c_1994_n ) capacitor c=0.0374802f //x=9.2 \
 //y=0.175 //x2=8.59 //y2=0.71
cc_1006 ( N_GND_c_1598_n N_noxref_11_c_1994_n ) capacitor c=0.00199095f \
 //x=11.96 //y=0.18 //x2=8.59 //y2=0.71
cc_1007 ( N_GND_c_1665_n N_noxref_11_c_2029_n ) capacitor c=0.00250977f \
 //x=10.465 //y=0.175 //x2=8.675 //y2=0.795
cc_1008 ( N_GND_c_1597_n N_noxref_11_c_2029_n ) capacitor c=0.0145789f //x=9.2 \
 //y=0.175 //x2=8.675 //y2=0.795
cc_1009 ( N_GND_c_1598_n N_noxref_11_c_2029_n ) capacitor c=0.00145015f \
 //x=11.96 //y=0.18 //x2=8.675 //y2=0.795
cc_1010 ( N_GND_c_1651_n N_noxref_11_c_2029_n ) capacitor c=0.0392026f \
 //x=9.37 //y=0.175 //x2=8.675 //y2=0.795
cc_1011 ( N_GND_c_1621_n N_noxref_11_M3_noxref_s ) capacitor c=0.00724992f \
 //x=7.135 //y=0.175 //x2=6.6 //y2=0.545
cc_1012 ( N_GND_c_1581_n N_noxref_11_M3_noxref_s ) capacitor c=0.0099136f \
 //x=7.22 //y=1.135 //x2=6.6 //y2=0.545
cc_1013 ( N_GND_c_1590_n N_noxref_11_M3_noxref_s ) capacitor c=0.0123761f \
 //x=7.217 //y=1.005 //x2=6.6 //y2=0.545
cc_1014 ( N_GND_c_1597_n N_noxref_11_M3_noxref_s ) capacitor c=0.014661f \
 //x=9.2 //y=0.175 //x2=6.6 //y2=0.545
cc_1015 ( N_GND_c_1598_n N_noxref_11_M3_noxref_s ) capacitor c=0.00145873f \
 //x=11.96 //y=0.18 //x2=6.6 //y2=0.545
cc_1016 ( N_GND_c_1603_n N_noxref_11_M3_noxref_s ) capacitor c=0.0518718f \
 //x=6.04 //y=0.175 //x2=6.6 //y2=0.545
cc_1017 ( N_GND_c_1651_n N_noxref_11_M3_noxref_s ) capacitor c=0.0064811f \
 //x=9.37 //y=0.175 //x2=6.6 //y2=0.545
cc_1018 ( N_GND_M3_noxref_d N_noxref_11_M3_noxref_s ) capacitor c=0.0271276f \
 //x=7.03 //y=1.045 //x2=6.6 //y2=0.545
cc_1019 ( N_GND_c_1665_n N_noxref_12_c_2049_n ) capacitor c=9.69275e-19 \
 //x=10.465 //y=0.175 //x2=10.95 //y2=1.76
cc_1020 ( N_GND_c_1669_n N_noxref_12_c_2049_n ) capacitor c=0.00200937f \
 //x=11.96 //y=0.18 //x2=10.95 //y2=1.76
cc_1021 ( N_GND_c_1630_n N_noxref_12_c_2049_n ) capacitor c=0.00400069f \
 //x=10.55 //y=1.135 //x2=10.95 //y2=1.76
cc_1022 ( N_GND_c_1598_n N_noxref_12_c_2049_n ) capacitor c=0.00387051f \
 //x=11.96 //y=0.18 //x2=10.95 //y2=1.76
cc_1023 ( N_GND_M5_noxref_d N_noxref_12_c_2049_n ) capacitor c=0.00578453f \
 //x=10.36 //y=1.045 //x2=10.95 //y2=1.76
cc_1024 ( N_GND_c_1669_n N_noxref_12_c_2079_n ) capacitor c=0.0030184f \
 //x=11.96 //y=0.18 //x2=11.035 //y2=0.795
cc_1025 ( N_GND_c_1640_n N_noxref_12_c_2079_n ) capacitor c=0.0167642f \
 //x=10.547 //y=1.005 //x2=11.035 //y2=0.795
cc_1026 ( N_GND_c_1598_n N_noxref_12_c_2079_n ) capacitor c=0.0165992f \
 //x=11.96 //y=0.18 //x2=11.035 //y2=0.795
cc_1027 ( N_GND_c_1651_n N_noxref_12_c_2079_n ) capacitor c=0.00282552f \
 //x=9.37 //y=0.175 //x2=11.035 //y2=0.795
cc_1028 ( N_GND_c_1651_n N_noxref_12_c_2057_n ) capacitor c=2.84067e-19 \
 //x=9.37 //y=0.175 //x2=11.035 //y2=1.675
cc_1029 ( N_GND_c_1669_n N_noxref_12_c_2066_n ) capacitor c=0.00990412f \
 //x=11.96 //y=0.18 //x2=11.92 //y2=0.71
cc_1030 ( N_GND_c_1598_n N_noxref_12_c_2066_n ) capacitor c=0.0395512f \
 //x=11.96 //y=0.18 //x2=11.92 //y2=0.71
cc_1031 ( N_GND_c_1669_n N_noxref_12_c_2086_n ) capacitor c=0.00364623f \
 //x=11.96 //y=0.18 //x2=12.005 //y2=0.795
cc_1032 ( N_GND_c_1598_n N_noxref_12_c_2086_n ) capacitor c=0.0582236f \
 //x=11.96 //y=0.18 //x2=12.005 //y2=0.795
cc_1033 ( N_GND_c_1665_n N_noxref_12_M5_noxref_s ) capacitor c=0.00724992f \
 //x=10.465 //y=0.175 //x2=9.93 //y2=0.545
cc_1034 ( N_GND_c_1630_n N_noxref_12_M5_noxref_s ) capacitor c=0.0100024f \
 //x=10.55 //y=1.135 //x2=9.93 //y2=0.545
cc_1035 ( N_GND_c_1640_n N_noxref_12_M5_noxref_s ) capacitor c=0.012617f \
 //x=10.547 //y=1.005 //x2=9.93 //y2=0.545
cc_1036 ( N_GND_c_1598_n N_noxref_12_M5_noxref_s ) capacitor c=0.0227624f \
 //x=11.96 //y=0.18 //x2=9.93 //y2=0.545
cc_1037 ( N_GND_c_1651_n N_noxref_12_M5_noxref_s ) capacitor c=0.0518734f \
 //x=9.37 //y=0.175 //x2=9.93 //y2=0.545
cc_1038 ( N_GND_M5_noxref_d N_noxref_12_M5_noxref_s ) capacitor c=0.0271276f \
 //x=10.36 //y=1.045 //x2=9.93 //y2=0.545
cc_1039 ( N_Y_c_1830_n N_noxref_12_c_2057_n ) capacitor c=0.00911498f \
 //x=11.605 //y=1.835 //x2=11.035 //y2=1.675
cc_1040 ( N_Y_c_1828_n N_noxref_12_c_2066_n ) capacitor c=0.00361884f \
 //x=11.875 //y=1.835 //x2=11.92 //y2=0.71
cc_1041 ( N_Y_c_1838_n N_noxref_12_c_2066_n ) capacitor c=0.00367971f \
 //x=11.52 //y=1.18 //x2=11.92 //y2=0.71
cc_1042 ( N_Y_M6_noxref_d N_noxref_12_c_2066_n ) capacitor c=0.00910163f \
 //x=11.33 //y=1.085 //x2=11.92 //y2=0.71
cc_1043 ( N_Y_c_1821_n N_noxref_12_M5_noxref_s ) capacitor c=0.0175047f \
 //x=11.52 //y=1.75 //x2=9.93 //y2=0.545
cc_1044 ( N_Y_c_1828_n N_noxref_12_M5_noxref_s ) capacitor c=0.0078077f \
 //x=11.875 //y=1.835 //x2=9.93 //y2=0.545
cc_1045 ( N_Y_c_1838_n N_noxref_12_M5_noxref_s ) capacitor c=0.0104658f \
 //x=11.52 //y=1.18 //x2=9.93 //y2=0.545
cc_1046 ( N_Y_M6_noxref_d N_noxref_12_M5_noxref_s ) capacitor c=0.0275552f \
 //x=11.33 //y=1.085 //x2=9.93 //y2=0.545
cc_1047 ( N_noxref_10_c_1917_n N_noxref_11_c_1976_n ) capacitor c=5.34352e-19 \
 //x=4.375 //y=1.675 //x2=6.735 //y2=1.675
cc_1048 ( N_noxref_10_c_1960_n N_noxref_11_M3_noxref_s ) capacitor \
 c=0.0045327f //x=5.345 //y=0.795 //x2=6.6 //y2=0.545
cc_1049 ( N_noxref_10_M1_noxref_s N_noxref_11_M3_noxref_s ) capacitor \
 c=5.34352e-19 //x=3.27 //y=0.545 //x2=6.6 //y2=0.545
cc_1050 ( N_noxref_11_c_1984_n N_noxref_12_c_2047_n ) capacitor c=5.34352e-19 \
 //x=7.705 //y=1.675 //x2=10.065 //y2=1.675
cc_1051 ( N_noxref_11_c_2029_n N_noxref_12_M5_noxref_s ) capacitor \
 c=0.0045327f //x=8.675 //y=0.795 //x2=9.93 //y2=0.545
cc_1052 ( N_noxref_11_M3_noxref_s N_noxref_12_M5_noxref_s ) capacitor \
 c=5.34352e-19 //x=6.6 //y=0.545 //x2=9.93 //y2=0.545
