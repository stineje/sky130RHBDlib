// File: HA.spi
// Created: Thu Jan 22 07:06:25 2026
// Program "Calibre xRC"
// Version "v2023.2_27.15"
//
simulator lang=spectre
include "/import/yukari1/lrburle/sky130RHBDlib/sky130_rhbd/pex/HA.pex.spice"
subckt HA (  A SUM B VDD COUT GND )
//
// GND	GND
// COUT	COUT
// VDD	VDD
// B	B
// SUM	SUM
// A	A
M0_noxref ( N_GND_M0_noxref_d N_A_M0_noxref_g N_noxref_12_M0_noxref_s \
 noxref_193 ) NMOS l=0.163119 w=2.35104 m=1
M1_noxref ( N_noxref_1_M1_noxref_d N_B_M1_noxref_g N_noxref_12_M0_noxref_s \
 noxref_193 ) NMOS l=0.163346 w=2.31104 m=1
M2_noxref ( N_COUT_M2_noxref_d N_noxref_1_M2_noxref_g N_GND_M2_noxref_s \
 noxref_193 ) NMOS l=0.163346 w=2.31104 m=1
M3_noxref ( N_noxref_3_M3_noxref_d N_A_M3_noxref_g N_GND_M3_noxref_s \
 noxref_193 ) NMOS l=0.163346 w=2.31104 m=1
M4_noxref ( N_GND_M4_noxref_d N_A_M4_noxref_g N_noxref_13_M4_noxref_s \
 noxref_193 ) NMOS l=0.163119 w=2.35104 m=1
M5_noxref ( N_SUM_M5_noxref_d N_B_M5_noxref_g N_noxref_13_M4_noxref_s \
 noxref_193 ) NMOS l=0.163346 w=2.31104 m=1
M6_noxref ( N_GND_M6_noxref_d N_noxref_5_M6_noxref_g N_noxref_14_M6_noxref_s \
 noxref_193 ) NMOS l=0.163119 w=2.35104 m=1
M7_noxref ( N_SUM_M7_noxref_d N_noxref_3_M7_noxref_g N_noxref_14_M6_noxref_s \
 noxref_193 ) NMOS l=0.163346 w=2.31104 m=1
M8_noxref ( N_noxref_5_M8_noxref_d N_B_M8_noxref_g N_GND_M8_noxref_s \
 noxref_193 ) NMOS l=0.163346 w=2.31104 m=1
M9_noxref ( N_noxref_1_M9_noxref_d N_A_M9_noxref_g N_VDD_M9_noxref_s \
 noxref_191 ) PMOS l=0.15 w=2 ad=0.57 as=0.57 pd=2.57 ps=2.57 nrd=0 nrs=0 m=1
M10_noxref ( N_VDD_M10_noxref_d N_A_M10_noxref_g N_noxref_1_M9_noxref_d \
 noxref_191 ) PMOS l=0.15 w=2 ad=0.58 as=0.58 pd=2.58 ps=2.58 nrd=0 nrs=0 m=1
M11_noxref ( N_noxref_1_M11_noxref_d N_B_M11_noxref_g N_VDD_M10_noxref_d \
 noxref_191 ) PMOS l=0.15 w=2 ad=0.58 as=0.58 pd=2.58 ps=2.58 nrd=0 nrs=0 m=1
M12_noxref ( N_VDD_M12_noxref_d N_B_M12_noxref_g N_noxref_1_M11_noxref_d \
 noxref_191 ) PMOS l=0.15 w=2 ad=0.56 as=0.56 pd=2.56 ps=2.56 nrd=0 nrs=0 m=1
M13_noxref ( N_COUT_M13_noxref_d N_noxref_1_M13_noxref_g N_VDD_M13_noxref_s \
 noxref_191 ) PMOS l=0.15 w=2 ad=0.57 as=0.57 pd=2.57 ps=2.57 nrd=0 nrs=0 m=1
M14_noxref ( N_VDD_M14_noxref_d N_noxref_1_M14_noxref_g N_COUT_M13_noxref_d \
 noxref_191 ) PMOS l=0.15 w=2 ad=0.56 as=0.56 pd=2.56 ps=2.56 nrd=0 nrs=0 m=1
M15_noxref ( N_noxref_3_M15_noxref_d N_A_M15_noxref_g N_VDD_M15_noxref_s \
 noxref_191 ) PMOS l=0.15 w=2 ad=0.57 as=0.57 pd=2.57 ps=2.57 nrd=0 nrs=0 m=1
M16_noxref ( N_VDD_M16_noxref_d N_A_M16_noxref_g N_noxref_3_M15_noxref_d \
 noxref_191 ) PMOS l=0.15 w=2 ad=0.56 as=0.56 pd=2.56 ps=2.56 nrd=0 nrs=0 m=1
M17_noxref ( N_VDD_M17_noxref_d N_A_M17_noxref_g N_noxref_9_M17_noxref_s \
 noxref_191 ) PMOS l=0.15 w=2 ad=0.57 as=0.57 pd=2.57 ps=2.57 nrd=0 nrs=0 m=1
M18_noxref ( N_noxref_9_M18_noxref_d N_A_M18_noxref_g N_VDD_M17_noxref_d \
 noxref_191 ) PMOS l=0.15 w=2 ad=0.58 as=0.58 pd=2.58 ps=2.58 nrd=0 nrs=0 m=1
M19_noxref ( N_SUM_M19_noxref_d N_noxref_5_M19_noxref_g \
 N_noxref_9_M18_noxref_d noxref_191 ) PMOS l=0.15 w=2 ad=0.58 as=0.58 pd=2.58 \
 ps=2.58 nrd=0 nrs=0 m=1
M20_noxref ( N_noxref_9_M20_noxref_d N_noxref_5_M20_noxref_g \
 N_SUM_M19_noxref_d noxref_191 ) PMOS l=0.15 w=2 ad=0.56 as=0.56 pd=2.56 \
 ps=2.56 nrd=0 nrs=0 m=1
M21_noxref ( N_VDD_M21_noxref_d N_B_M21_noxref_g N_noxref_10_M21_noxref_s \
 noxref_191 ) PMOS l=0.15 w=2 ad=0.57 as=0.57 pd=2.57 ps=2.57 nrd=0 nrs=0 m=1
M22_noxref ( N_noxref_10_M22_noxref_d N_B_M22_noxref_g N_VDD_M21_noxref_d \
 noxref_191 ) PMOS l=0.15 w=2 ad=0.58 as=0.58 pd=2.58 ps=2.58 nrd=0 nrs=0 m=1
M23_noxref ( N_SUM_M23_noxref_d N_noxref_3_M23_noxref_g \
 N_noxref_10_M22_noxref_d noxref_191 ) PMOS l=0.15 w=2 ad=0.58 as=0.58 pd=2.58 \
 ps=2.58 nrd=0 nrs=0 m=1
M24_noxref ( N_noxref_10_M24_noxref_d N_noxref_3_M24_noxref_g \
 N_SUM_M23_noxref_d noxref_191 ) PMOS l=0.15 w=2 ad=0.56 as=0.56 pd=2.56 \
 ps=2.56 nrd=0 nrs=0 m=1
M25_noxref ( N_noxref_5_M25_noxref_d N_B_M25_noxref_g N_VDD_M25_noxref_s \
 noxref_191 ) PMOS l=0.15 w=2 ad=0.56 as=0.56 pd=2.56 ps=2.56 nrd=0 nrs=0 m=1
M26_noxref ( N_VDD_M26_noxref_d N_B_M26_noxref_g N_noxref_5_M25_noxref_d \
 noxref_191 ) PMOS l=0.15 w=2 ad=0.57 as=0.57 pd=2.57 ps=2.57 nrd=0 nrs=0 m=1
//
include "/import/yukari1/lrburle/sky130RHBDlib/sky130_rhbd/pex/HA.pxi.spice"
//
ends HA
//
//
