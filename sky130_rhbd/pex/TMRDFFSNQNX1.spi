// File: TMRDFFSNQNX1.spi
// Created: Sun Mar 15 12:45:50 2026
// Program "Calibre xRC"
// Version "v2023.2_27.15"
//
simulator lang=spectre
include "/import/yukari1/lrburle/sky130RHBDlib/calibre/sky130_rhbd_output/spice/TMRDFFSNQNX1.pex.spice"
subckt TMRDFFSNQNX1 (  D CLK SN QN VDD GND )
//
// GND	GND
// VDD	VDD
// QN	QN
// SN	SN
// CLK	CLK
// D	D
M0_noxref ( N_GND_M0_noxref_d N_D_M0_noxref_g N_noxref_36_M0_noxref_s \
 noxref_776 ) NMOS l=0.163119 w=2.35104 m=1
M1_noxref ( N_noxref_1_M1_noxref_d N_noxref_3_M1_noxref_g \
 N_noxref_36_M0_noxref_s noxref_776 ) NMOS l=0.163346 w=2.31104 m=1
M2_noxref ( N_GND_M2_noxref_d N_noxref_1_M2_noxref_g N_noxref_37_M2_noxref_s \
 noxref_776 ) NMOS l=0.163119 w=2.35104 m=1
M3_noxref ( N_noxref_24_M3_noxref_d N_CLK_M3_noxref_g N_noxref_37_M2_noxref_s \
 noxref_776 ) NMOS l=0.160516 w=2.29447 m=1
M4_noxref ( N_noxref_3_M4_noxref_d N_noxref_4_M4_noxref_g \
 N_noxref_24_M4_noxref_s noxref_776 ) NMOS l=0.163346 w=2.31104 m=1
M5_noxref ( N_GND_M5_noxref_d N_noxref_1_M5_noxref_g N_noxref_38_M5_noxref_s \
 noxref_776 ) NMOS l=0.163119 w=2.35104 m=1
M6_noxref ( N_noxref_25_M6_noxref_d N_SN_M6_noxref_g N_noxref_38_M5_noxref_s \
 noxref_776 ) NMOS l=0.160516 w=2.29447 m=1
M7_noxref ( N_noxref_2_M7_noxref_d N_noxref_4_M7_noxref_g \
 N_noxref_25_M7_noxref_s noxref_776 ) NMOS l=0.163346 w=2.31104 m=1
M8_noxref ( N_GND_M8_noxref_d N_noxref_2_M8_noxref_g N_noxref_39_M8_noxref_s \
 noxref_776 ) NMOS l=0.163119 w=2.35104 m=1
M9_noxref ( N_noxref_4_M9_noxref_d N_CLK_M9_noxref_g N_noxref_39_M8_noxref_s \
 noxref_776 ) NMOS l=0.163346 w=2.31104 m=1
M10_noxref ( N_GND_M10_noxref_d N_noxref_3_M10_noxref_g \
 N_noxref_40_M10_noxref_s noxref_776 ) NMOS l=0.163119 w=2.35104 m=1
M11_noxref ( N_noxref_21_M11_noxref_d N_noxref_5_M11_noxref_g \
 N_noxref_40_M10_noxref_s noxref_776 ) NMOS l=0.163346 w=2.31104 m=1
M12_noxref ( N_GND_M12_noxref_d N_noxref_21_M12_noxref_g \
 N_noxref_41_M12_noxref_s noxref_776 ) NMOS l=0.163119 w=2.35104 m=1
M13_noxref ( N_noxref_26_M13_noxref_d N_SN_M13_noxref_g \
 N_noxref_41_M12_noxref_s noxref_776 ) NMOS l=0.160516 w=2.29447 m=1
M14_noxref ( N_noxref_5_M14_noxref_d N_noxref_4_M14_noxref_g \
 N_noxref_26_M14_noxref_s noxref_776 ) NMOS l=0.163346 w=2.31104 m=1
M15_noxref ( N_GND_M15_noxref_d N_D_M15_noxref_g N_noxref_42_M15_noxref_s \
 noxref_776 ) NMOS l=0.163119 w=2.35104 m=1
M16_noxref ( N_noxref_6_M16_noxref_d N_noxref_8_M16_noxref_g \
 N_noxref_42_M15_noxref_s noxref_776 ) NMOS l=0.163346 w=2.31104 m=1
M17_noxref ( N_GND_M17_noxref_d N_noxref_6_M17_noxref_g \
 N_noxref_43_M17_noxref_s noxref_776 ) NMOS l=0.163119 w=2.35104 m=1
M18_noxref ( N_noxref_27_M18_noxref_d N_CLK_M18_noxref_g \
 N_noxref_43_M17_noxref_s noxref_776 ) NMOS l=0.160516 w=2.29447 m=1
M19_noxref ( N_noxref_8_M19_noxref_d N_noxref_9_M19_noxref_g \
 N_noxref_27_M19_noxref_s noxref_776 ) NMOS l=0.163346 w=2.31104 m=1
M20_noxref ( N_GND_M20_noxref_d N_noxref_6_M20_noxref_g \
 N_noxref_44_M20_noxref_s noxref_776 ) NMOS l=0.163119 w=2.35104 m=1
M21_noxref ( N_noxref_28_M21_noxref_d N_SN_M21_noxref_g \
 N_noxref_44_M20_noxref_s noxref_776 ) NMOS l=0.160516 w=2.29447 m=1
M22_noxref ( N_noxref_7_M22_noxref_d N_noxref_9_M22_noxref_g \
 N_noxref_28_M22_noxref_s noxref_776 ) NMOS l=0.163346 w=2.31104 m=1
M23_noxref ( N_GND_M23_noxref_d N_noxref_7_M23_noxref_g \
 N_noxref_45_M23_noxref_s noxref_776 ) NMOS l=0.163119 w=2.35104 m=1
M24_noxref ( N_noxref_9_M24_noxref_d N_CLK_M24_noxref_g \
 N_noxref_45_M23_noxref_s noxref_776 ) NMOS l=0.163346 w=2.31104 m=1
M25_noxref ( N_GND_M25_noxref_d N_noxref_8_M25_noxref_g \
 N_noxref_46_M25_noxref_s noxref_776 ) NMOS l=0.163119 w=2.35104 m=1
M26_noxref ( N_noxref_19_M26_noxref_d N_noxref_10_M26_noxref_g \
 N_noxref_46_M25_noxref_s noxref_776 ) NMOS l=0.163346 w=2.31104 m=1
M27_noxref ( N_GND_M27_noxref_d N_noxref_19_M27_noxref_g \
 N_noxref_47_M27_noxref_s noxref_776 ) NMOS l=0.163119 w=2.35104 m=1
M28_noxref ( N_noxref_29_M28_noxref_d N_SN_M28_noxref_g \
 N_noxref_47_M27_noxref_s noxref_776 ) NMOS l=0.160516 w=2.29447 m=1
M29_noxref ( N_noxref_10_M29_noxref_d N_noxref_9_M29_noxref_g \
 N_noxref_29_M29_noxref_s noxref_776 ) NMOS l=0.163346 w=2.31104 m=1
M30_noxref ( N_GND_M30_noxref_d N_D_M30_noxref_g N_noxref_48_M30_noxref_s \
 noxref_776 ) NMOS l=0.163119 w=2.35104 m=1
M31_noxref ( N_noxref_12_M31_noxref_d N_noxref_15_M31_noxref_g \
 N_noxref_48_M30_noxref_s noxref_776 ) NMOS l=0.163346 w=2.31104 m=1
M32_noxref ( N_GND_M32_noxref_d N_noxref_12_M32_noxref_g \
 N_noxref_49_M32_noxref_s noxref_776 ) NMOS l=0.163119 w=2.35104 m=1
M33_noxref ( N_noxref_30_M33_noxref_d N_CLK_M33_noxref_g \
 N_noxref_49_M32_noxref_s noxref_776 ) NMOS l=0.160516 w=2.29447 m=1
M34_noxref ( N_noxref_15_M34_noxref_d N_noxref_17_M34_noxref_g \
 N_noxref_30_M34_noxref_s noxref_776 ) NMOS l=0.163346 w=2.31104 m=1
M35_noxref ( N_GND_M35_noxref_d N_noxref_12_M35_noxref_g \
 N_noxref_50_M35_noxref_s noxref_776 ) NMOS l=0.163119 w=2.35104 m=1
M36_noxref ( N_noxref_31_M36_noxref_d N_SN_M36_noxref_g \
 N_noxref_50_M35_noxref_s noxref_776 ) NMOS l=0.160516 w=2.29447 m=1
M37_noxref ( N_noxref_13_M37_noxref_d N_noxref_17_M37_noxref_g \
 N_noxref_31_M37_noxref_s noxref_776 ) NMOS l=0.163346 w=2.31104 m=1
M38_noxref ( N_GND_M38_noxref_d N_noxref_13_M38_noxref_g \
 N_noxref_51_M38_noxref_s noxref_776 ) NMOS l=0.163119 w=2.35104 m=1
M39_noxref ( N_noxref_17_M39_noxref_d N_CLK_M39_noxref_g \
 N_noxref_51_M38_noxref_s noxref_776 ) NMOS l=0.163346 w=2.31104 m=1
M40_noxref ( N_GND_M40_noxref_d N_noxref_15_M40_noxref_g \
 N_noxref_52_M40_noxref_s noxref_776 ) NMOS l=0.163119 w=2.35104 m=1
M41_noxref ( N_noxref_20_M41_noxref_d N_noxref_18_M41_noxref_g \
 N_noxref_52_M40_noxref_s noxref_776 ) NMOS l=0.163346 w=2.31104 m=1
M42_noxref ( N_GND_M42_noxref_d N_noxref_20_M42_noxref_g \
 N_noxref_53_M42_noxref_s noxref_776 ) NMOS l=0.163119 w=2.35104 m=1
M43_noxref ( N_noxref_32_M43_noxref_d N_SN_M43_noxref_g \
 N_noxref_53_M42_noxref_s noxref_776 ) NMOS l=0.160516 w=2.29447 m=1
M44_noxref ( N_noxref_18_M44_noxref_d N_noxref_17_M44_noxref_g \
 N_noxref_32_M44_noxref_s noxref_776 ) NMOS l=0.163346 w=2.31104 m=1
M45_noxref ( N_GND_M45_noxref_d N_noxref_20_M45_noxref_g \
 N_noxref_54_M45_noxref_s noxref_776 ) NMOS l=0.163119 w=2.35104 m=1
M46_noxref ( N_QN_M46_noxref_d N_noxref_19_M46_noxref_g \
 N_noxref_54_M45_noxref_s noxref_776 ) NMOS l=0.163346 w=2.31104 m=1
M47_noxref ( N_GND_M47_noxref_d N_noxref_20_M47_noxref_g \
 N_noxref_56_M47_noxref_s noxref_776 ) NMOS l=0.163119 w=2.35104 m=1
M48_noxref ( N_QN_M48_noxref_d N_noxref_21_M48_noxref_g \
 N_noxref_56_M47_noxref_s noxref_776 ) NMOS l=0.163346 w=2.31104 m=1
M49_noxref ( N_GND_M49_noxref_d N_noxref_21_M49_noxref_g \
 N_noxref_57_M49_noxref_s noxref_776 ) NMOS l=0.163119 w=2.35104 m=1
M50_noxref ( N_QN_M50_noxref_d N_noxref_19_M50_noxref_g \
 N_noxref_57_M49_noxref_s noxref_776 ) NMOS l=0.163129 w=2.31397 m=1
M51_noxref ( N_noxref_1_M51_noxref_d N_D_M51_noxref_g N_VDD_M51_noxref_s \
 noxref_774 ) PMOS l=0.15 w=2 ad=0.57 as=0.57 pd=2.57 ps=2.57 nrd=0 nrs=0 m=1
M52_noxref ( N_VDD_M52_noxref_d N_D_M52_noxref_g N_noxref_1_M51_noxref_d \
 noxref_774 ) PMOS l=0.15 w=2 ad=0.58 as=0.58 pd=2.58 ps=2.58 nrd=0 nrs=0 m=1
M53_noxref ( N_noxref_1_M53_noxref_d N_noxref_3_M53_noxref_g \
 N_VDD_M52_noxref_d noxref_774 ) PMOS l=0.15 w=2 ad=0.58 as=0.58 pd=2.58 \
 ps=2.58 nrd=0 nrs=0 m=1
M54_noxref ( N_VDD_M54_noxref_d N_noxref_3_M54_noxref_g \
 N_noxref_1_M53_noxref_d noxref_774 ) PMOS l=0.15 w=2 ad=0.56 as=0.56 pd=2.56 \
 ps=2.56 nrd=0 nrs=0 m=1
M55_noxref ( N_noxref_3_M55_noxref_d N_noxref_1_M55_noxref_g \
 N_VDD_M55_noxref_s noxref_774 ) PMOS l=0.15 w=2 ad=0.57 as=0.57 pd=2.57 \
 ps=2.57 nrd=0 nrs=0 m=1
M56_noxref ( N_VDD_M56_noxref_d N_noxref_1_M56_noxref_g \
 N_noxref_3_M55_noxref_d noxref_774 ) PMOS l=0.15 w=2 ad=0.58 as=0.58 pd=2.58 \
 ps=2.58 nrd=0 nrs=0 m=1
M57_noxref ( N_noxref_3_M57_noxref_d N_CLK_M57_noxref_g N_VDD_M56_noxref_d \
 noxref_774 ) PMOS l=0.15 w=2 ad=0.58 as=0.58 pd=2.58 ps=2.58 nrd=0 nrs=0 m=1
M58_noxref ( N_VDD_M58_noxref_d N_CLK_M58_noxref_g N_noxref_3_M57_noxref_d \
 noxref_774 ) PMOS l=0.15 w=2 ad=0.58 as=0.58 pd=2.58 ps=2.58 nrd=0 nrs=0 m=1
M59_noxref ( N_noxref_3_M59_noxref_d N_noxref_4_M59_noxref_g \
 N_VDD_M58_noxref_d noxref_774 ) PMOS l=0.15 w=2 ad=0.58 as=0.58 pd=2.58 \
 ps=2.58 nrd=0 nrs=0 m=1
M60_noxref ( N_VDD_M60_noxref_d N_noxref_4_M60_noxref_g \
 N_noxref_3_M59_noxref_d noxref_774 ) PMOS l=0.15 w=2 ad=0.56 as=0.56 pd=2.56 \
 ps=2.56 nrd=0 nrs=0 m=1
M61_noxref ( N_noxref_2_M61_noxref_d N_noxref_1_M61_noxref_g \
 N_VDD_M61_noxref_s noxref_774 ) PMOS l=0.15 w=2 ad=0.57 as=0.57 pd=2.57 \
 ps=2.57 nrd=0 nrs=0 m=1
M62_noxref ( N_VDD_M62_noxref_d N_noxref_1_M62_noxref_g \
 N_noxref_2_M61_noxref_d noxref_774 ) PMOS l=0.15 w=2 ad=0.58 as=0.58 pd=2.58 \
 ps=2.58 nrd=0 nrs=0 m=1
M63_noxref ( N_noxref_2_M63_noxref_d N_SN_M63_noxref_g N_VDD_M62_noxref_d \
 noxref_774 ) PMOS l=0.15 w=2 ad=0.58 as=0.58 pd=2.58 ps=2.58 nrd=0 nrs=0 m=1
M64_noxref ( N_VDD_M64_noxref_d N_SN_M64_noxref_g N_noxref_2_M63_noxref_d \
 noxref_774 ) PMOS l=0.15 w=2 ad=0.58 as=0.58 pd=2.58 ps=2.58 nrd=0 nrs=0 m=1
M65_noxref ( N_noxref_2_M65_noxref_d N_noxref_4_M65_noxref_g \
 N_VDD_M64_noxref_d noxref_774 ) PMOS l=0.15 w=2 ad=0.58 as=0.58 pd=2.58 \
 ps=2.58 nrd=0 nrs=0 m=1
M66_noxref ( N_VDD_M66_noxref_d N_noxref_4_M66_noxref_g \
 N_noxref_2_M65_noxref_d noxref_774 ) PMOS l=0.15 w=2 ad=0.56 as=0.56 pd=2.56 \
 ps=2.56 nrd=0 nrs=0 m=1
M67_noxref ( N_noxref_4_M67_noxref_d N_noxref_2_M67_noxref_g \
 N_VDD_M67_noxref_s noxref_774 ) PMOS l=0.15 w=2 ad=0.57 as=0.57 pd=2.57 \
 ps=2.57 nrd=0 nrs=0 m=1
M68_noxref ( N_VDD_M68_noxref_d N_noxref_2_M68_noxref_g \
 N_noxref_4_M67_noxref_d noxref_774 ) PMOS l=0.15 w=2 ad=0.58 as=0.58 pd=2.58 \
 ps=2.58 nrd=0 nrs=0 m=1
M69_noxref ( N_noxref_4_M69_noxref_d N_CLK_M69_noxref_g N_VDD_M68_noxref_d \
 noxref_774 ) PMOS l=0.15 w=2 ad=0.58 as=0.58 pd=2.58 ps=2.58 nrd=0 nrs=0 m=1
M70_noxref ( N_VDD_M70_noxref_d N_CLK_M70_noxref_g N_noxref_4_M69_noxref_d \
 noxref_774 ) PMOS l=0.15 w=2 ad=0.56 as=0.56 pd=2.56 ps=2.56 nrd=0 nrs=0 m=1
M71_noxref ( N_noxref_21_M71_noxref_d N_noxref_3_M71_noxref_g \
 N_VDD_M71_noxref_s noxref_774 ) PMOS l=0.15 w=2 ad=0.57 as=0.57 pd=2.57 \
 ps=2.57 nrd=0 nrs=0 m=1
M72_noxref ( N_VDD_M72_noxref_d N_noxref_3_M72_noxref_g \
 N_noxref_21_M71_noxref_d noxref_774 ) PMOS l=0.15 w=2 ad=0.58 as=0.58 pd=2.58 \
 ps=2.58 nrd=0 nrs=0 m=1
M73_noxref ( N_noxref_21_M73_noxref_d N_noxref_5_M73_noxref_g \
 N_VDD_M72_noxref_d noxref_774 ) PMOS l=0.15 w=2 ad=0.58 as=0.58 pd=2.58 \
 ps=2.58 nrd=0 nrs=0 m=1
M74_noxref ( N_VDD_M74_noxref_d N_noxref_5_M74_noxref_g \
 N_noxref_21_M73_noxref_d noxref_774 ) PMOS l=0.15 w=2 ad=0.56 as=0.56 pd=2.56 \
 ps=2.56 nrd=0 nrs=0 m=1
M75_noxref ( N_noxref_5_M75_noxref_d N_noxref_21_M75_noxref_g \
 N_VDD_M75_noxref_s noxref_774 ) PMOS l=0.15 w=2 ad=0.57 as=0.57 pd=2.57 \
 ps=2.57 nrd=0 nrs=0 m=1
M76_noxref ( N_VDD_M76_noxref_d N_noxref_21_M76_noxref_g \
 N_noxref_5_M75_noxref_d noxref_774 ) PMOS l=0.15 w=2 ad=0.58 as=0.58 pd=2.58 \
 ps=2.58 nrd=0 nrs=0 m=1
M77_noxref ( N_noxref_5_M77_noxref_d N_SN_M77_noxref_g N_VDD_M76_noxref_d \
 noxref_774 ) PMOS l=0.15 w=2 ad=0.58 as=0.58 pd=2.58 ps=2.58 nrd=0 nrs=0 m=1
M78_noxref ( N_VDD_M78_noxref_d N_SN_M78_noxref_g N_noxref_5_M77_noxref_d \
 noxref_774 ) PMOS l=0.15 w=2 ad=0.58 as=0.58 pd=2.58 ps=2.58 nrd=0 nrs=0 m=1
M79_noxref ( N_noxref_5_M79_noxref_d N_noxref_4_M79_noxref_g \
 N_VDD_M78_noxref_d noxref_774 ) PMOS l=0.15 w=2 ad=0.58 as=0.58 pd=2.58 \
 ps=2.58 nrd=0 nrs=0 m=1
M80_noxref ( N_VDD_M80_noxref_d N_noxref_4_M80_noxref_g \
 N_noxref_5_M79_noxref_d noxref_774 ) PMOS l=0.15 w=2 ad=0.56 as=0.56 pd=2.56 \
 ps=2.56 nrd=0 nrs=0 m=1
M81_noxref ( N_noxref_6_M81_noxref_d N_D_M81_noxref_g N_VDD_M81_noxref_s \
 noxref_774 ) PMOS l=0.15 w=2 ad=0.57 as=0.57 pd=2.57 ps=2.57 nrd=0 nrs=0 m=1
M82_noxref ( N_VDD_M82_noxref_d N_D_M82_noxref_g N_noxref_6_M81_noxref_d \
 noxref_774 ) PMOS l=0.15 w=2 ad=0.58 as=0.58 pd=2.58 ps=2.58 nrd=0 nrs=0 m=1
M83_noxref ( N_noxref_6_M83_noxref_d N_noxref_8_M83_noxref_g \
 N_VDD_M82_noxref_d noxref_774 ) PMOS l=0.15 w=2 ad=0.58 as=0.58 pd=2.58 \
 ps=2.58 nrd=0 nrs=0 m=1
M84_noxref ( N_VDD_M84_noxref_d N_noxref_8_M84_noxref_g \
 N_noxref_6_M83_noxref_d noxref_774 ) PMOS l=0.15 w=2 ad=0.56 as=0.56 pd=2.56 \
 ps=2.56 nrd=0 nrs=0 m=1
M85_noxref ( N_noxref_8_M85_noxref_d N_noxref_6_M85_noxref_g \
 N_VDD_M85_noxref_s noxref_774 ) PMOS l=0.15 w=2 ad=0.57 as=0.57 pd=2.57 \
 ps=2.57 nrd=0 nrs=0 m=1
M86_noxref ( N_VDD_M86_noxref_d N_noxref_6_M86_noxref_g \
 N_noxref_8_M85_noxref_d noxref_774 ) PMOS l=0.15 w=2 ad=0.58 as=0.58 pd=2.58 \
 ps=2.58 nrd=0 nrs=0 m=1
M87_noxref ( N_noxref_8_M87_noxref_d N_CLK_M87_noxref_g N_VDD_M86_noxref_d \
 noxref_774 ) PMOS l=0.15 w=2 ad=0.58 as=0.58 pd=2.58 ps=2.58 nrd=0 nrs=0 m=1
M88_noxref ( N_VDD_M88_noxref_d N_CLK_M88_noxref_g N_noxref_8_M87_noxref_d \
 noxref_774 ) PMOS l=0.15 w=2 ad=0.58 as=0.58 pd=2.58 ps=2.58 nrd=0 nrs=0 m=1
M89_noxref ( N_noxref_8_M89_noxref_d N_noxref_9_M89_noxref_g \
 N_VDD_M88_noxref_d noxref_774 ) PMOS l=0.15 w=2 ad=0.58 as=0.58 pd=2.58 \
 ps=2.58 nrd=0 nrs=0 m=1
M90_noxref ( N_VDD_M90_noxref_d N_noxref_9_M90_noxref_g \
 N_noxref_8_M89_noxref_d noxref_774 ) PMOS l=0.15 w=2 ad=0.56 as=0.56 pd=2.56 \
 ps=2.56 nrd=0 nrs=0 m=1
M91_noxref ( N_noxref_7_M91_noxref_d N_noxref_6_M91_noxref_g \
 N_VDD_M91_noxref_s noxref_774 ) PMOS l=0.15 w=2 ad=0.57 as=0.57 pd=2.57 \
 ps=2.57 nrd=0 nrs=0 m=1
M92_noxref ( N_VDD_M92_noxref_d N_noxref_6_M92_noxref_g \
 N_noxref_7_M91_noxref_d noxref_774 ) PMOS l=0.15 w=2 ad=0.58 as=0.58 pd=2.58 \
 ps=2.58 nrd=0 nrs=0 m=1
M93_noxref ( N_noxref_7_M93_noxref_d N_SN_M93_noxref_g N_VDD_M92_noxref_d \
 noxref_774 ) PMOS l=0.15 w=2 ad=0.58 as=0.58 pd=2.58 ps=2.58 nrd=0 nrs=0 m=1
M94_noxref ( N_VDD_M94_noxref_d N_SN_M94_noxref_g N_noxref_7_M93_noxref_d \
 noxref_774 ) PMOS l=0.15 w=2 ad=0.58 as=0.58 pd=2.58 ps=2.58 nrd=0 nrs=0 m=1
M95_noxref ( N_noxref_7_M95_noxref_d N_noxref_9_M95_noxref_g \
 N_VDD_M94_noxref_d noxref_774 ) PMOS l=0.15 w=2 ad=0.58 as=0.58 pd=2.58 \
 ps=2.58 nrd=0 nrs=0 m=1
M96_noxref ( N_VDD_M96_noxref_d N_noxref_9_M96_noxref_g \
 N_noxref_7_M95_noxref_d noxref_774 ) PMOS l=0.15 w=2 ad=0.56 as=0.56 pd=2.56 \
 ps=2.56 nrd=0 nrs=0 m=1
M97_noxref ( N_noxref_9_M97_noxref_d N_noxref_7_M97_noxref_g \
 N_VDD_M97_noxref_s noxref_774 ) PMOS l=0.15 w=2 ad=0.57 as=0.57 pd=2.57 \
 ps=2.57 nrd=0 nrs=0 m=1
M98_noxref ( N_VDD_M98_noxref_d N_noxref_7_M98_noxref_g \
 N_noxref_9_M97_noxref_d noxref_774 ) PMOS l=0.15 w=2 ad=0.58 as=0.58 pd=2.58 \
 ps=2.58 nrd=0 nrs=0 m=1
M99_noxref ( N_noxref_9_M99_noxref_d N_CLK_M99_noxref_g N_VDD_M98_noxref_d \
 noxref_774 ) PMOS l=0.15 w=2 ad=0.58 as=0.58 pd=2.58 ps=2.58 nrd=0 nrs=0 m=1
M100_noxref ( N_VDD_M100_noxref_d N_CLK_M100_noxref_g N_noxref_9_M99_noxref_d \
 noxref_774 ) PMOS l=0.15 w=2 ad=0.56 as=0.56 pd=2.56 ps=2.56 nrd=0 nrs=0 m=1
M101_noxref ( N_noxref_19_M101_noxref_d N_noxref_8_M101_noxref_g \
 N_VDD_M101_noxref_s noxref_774 ) PMOS l=0.15 w=2 ad=0.57 as=0.57 pd=2.57 \
 ps=2.57 nrd=0 nrs=0 m=1
M102_noxref ( N_VDD_M102_noxref_d N_noxref_8_M102_noxref_g \
 N_noxref_19_M101_noxref_d noxref_774 ) PMOS l=0.15 w=2 ad=0.58 as=0.58 \
 pd=2.58 ps=2.58 nrd=0 nrs=0 m=1
M103_noxref ( N_noxref_19_M103_noxref_d N_noxref_10_M103_noxref_g \
 N_VDD_M102_noxref_d noxref_774 ) PMOS l=0.15 w=2 ad=0.58 as=0.58 pd=2.58 \
 ps=2.58 nrd=0 nrs=0 m=1
M104_noxref ( N_VDD_M104_noxref_d N_noxref_10_M104_noxref_g \
 N_noxref_19_M103_noxref_d noxref_774 ) PMOS l=0.15 w=2 ad=0.56 as=0.56 \
 pd=2.56 ps=2.56 nrd=0 nrs=0 m=1
M105_noxref ( N_noxref_10_M105_noxref_d N_noxref_19_M105_noxref_g \
 N_VDD_M105_noxref_s noxref_774 ) PMOS l=0.15 w=2 ad=0.57 as=0.57 pd=2.57 \
 ps=2.57 nrd=0 nrs=0 m=1
M106_noxref ( N_VDD_M106_noxref_d N_noxref_19_M106_noxref_g \
 N_noxref_10_M105_noxref_d noxref_774 ) PMOS l=0.15 w=2 ad=0.58 as=0.58 \
 pd=2.58 ps=2.58 nrd=0 nrs=0 m=1
M107_noxref ( N_noxref_10_M107_noxref_d N_SN_M107_noxref_g N_VDD_M106_noxref_d \
 noxref_774 ) PMOS l=0.15 w=2 ad=0.58 as=0.58 pd=2.58 ps=2.58 nrd=0 nrs=0 m=1
M108_noxref ( N_VDD_M108_noxref_d N_SN_M108_noxref_g N_noxref_10_M107_noxref_d \
 noxref_774 ) PMOS l=0.15 w=2 ad=0.58 as=0.58 pd=2.58 ps=2.58 nrd=0 nrs=0 m=1
M109_noxref ( N_noxref_10_M109_noxref_d N_noxref_9_M109_noxref_g \
 N_VDD_M108_noxref_d noxref_774 ) PMOS l=0.15 w=2 ad=0.58 as=0.58 pd=2.58 \
 ps=2.58 nrd=0 nrs=0 m=1
M110_noxref ( N_VDD_M110_noxref_d N_noxref_9_M110_noxref_g \
 N_noxref_10_M109_noxref_d noxref_774 ) PMOS l=0.15 w=2 ad=0.56 as=0.56 \
 pd=2.56 ps=2.56 nrd=0 nrs=0 m=1
M111_noxref ( N_noxref_12_M111_noxref_d N_D_M111_noxref_g N_VDD_M111_noxref_s \
 noxref_774 ) PMOS l=0.15 w=2 ad=0.57 as=0.57 pd=2.57 ps=2.57 nrd=0 nrs=0 m=1
M112_noxref ( N_VDD_M112_noxref_d N_D_M112_noxref_g N_noxref_12_M111_noxref_d \
 noxref_774 ) PMOS l=0.15 w=2 ad=0.58 as=0.58 pd=2.58 ps=2.58 nrd=0 nrs=0 m=1
M113_noxref ( N_noxref_12_M113_noxref_d N_noxref_15_M113_noxref_g \
 N_VDD_M112_noxref_d noxref_774 ) PMOS l=0.15 w=2 ad=0.58 as=0.58 pd=2.58 \
 ps=2.58 nrd=0 nrs=0 m=1
M114_noxref ( N_VDD_M114_noxref_d N_noxref_15_M114_noxref_g \
 N_noxref_12_M113_noxref_d noxref_774 ) PMOS l=0.15 w=2 ad=0.56 as=0.56 \
 pd=2.56 ps=2.56 nrd=0 nrs=0 m=1
M115_noxref ( N_noxref_15_M115_noxref_d N_noxref_12_M115_noxref_g \
 N_VDD_M115_noxref_s noxref_774 ) PMOS l=0.15 w=2 ad=0.57 as=0.57 pd=2.57 \
 ps=2.57 nrd=0 nrs=0 m=1
M116_noxref ( N_VDD_M116_noxref_d N_noxref_12_M116_noxref_g \
 N_noxref_15_M115_noxref_d noxref_774 ) PMOS l=0.15 w=2 ad=0.58 as=0.58 \
 pd=2.58 ps=2.58 nrd=0 nrs=0 m=1
M117_noxref ( N_noxref_15_M117_noxref_d N_CLK_M117_noxref_g \
 N_VDD_M116_noxref_d noxref_774 ) PMOS l=0.15 w=2 ad=0.58 as=0.58 pd=2.58 \
 ps=2.58 nrd=0 nrs=0 m=1
M118_noxref ( N_VDD_M118_noxref_d N_CLK_M118_noxref_g \
 N_noxref_15_M117_noxref_d noxref_774 ) PMOS l=0.15 w=2 ad=0.58 as=0.58 \
 pd=2.58 ps=2.58 nrd=0 nrs=0 m=1
M119_noxref ( N_noxref_15_M119_noxref_d N_noxref_17_M119_noxref_g \
 N_VDD_M118_noxref_d noxref_774 ) PMOS l=0.15 w=2 ad=0.58 as=0.58 pd=2.58 \
 ps=2.58 nrd=0 nrs=0 m=1
M120_noxref ( N_VDD_M120_noxref_d N_noxref_17_M120_noxref_g \
 N_noxref_15_M119_noxref_d noxref_774 ) PMOS l=0.15 w=2 ad=0.56 as=0.56 \
 pd=2.56 ps=2.56 nrd=0 nrs=0 m=1
M121_noxref ( N_noxref_13_M121_noxref_d N_noxref_12_M121_noxref_g \
 N_VDD_M121_noxref_s noxref_774 ) PMOS l=0.15 w=2 ad=0.57 as=0.57 pd=2.57 \
 ps=2.57 nrd=0 nrs=0 m=1
M122_noxref ( N_VDD_M122_noxref_d N_noxref_12_M122_noxref_g \
 N_noxref_13_M121_noxref_d noxref_774 ) PMOS l=0.15 w=2 ad=0.58 as=0.58 \
 pd=2.58 ps=2.58 nrd=0 nrs=0 m=1
M123_noxref ( N_noxref_13_M123_noxref_d N_SN_M123_noxref_g N_VDD_M122_noxref_d \
 noxref_774 ) PMOS l=0.15 w=2 ad=0.58 as=0.58 pd=2.58 ps=2.58 nrd=0 nrs=0 m=1
M124_noxref ( N_VDD_M124_noxref_d N_SN_M124_noxref_g N_noxref_13_M123_noxref_d \
 noxref_774 ) PMOS l=0.15 w=2 ad=0.58 as=0.58 pd=2.58 ps=2.58 nrd=0 nrs=0 m=1
M125_noxref ( N_noxref_13_M125_noxref_d N_noxref_17_M125_noxref_g \
 N_VDD_M124_noxref_d noxref_774 ) PMOS l=0.15 w=2 ad=0.58 as=0.58 pd=2.58 \
 ps=2.58 nrd=0 nrs=0 m=1
M126_noxref ( N_VDD_M126_noxref_d N_noxref_17_M126_noxref_g \
 N_noxref_13_M125_noxref_d noxref_774 ) PMOS l=0.15 w=2 ad=0.56 as=0.56 \
 pd=2.56 ps=2.56 nrd=0 nrs=0 m=1
M127_noxref ( N_noxref_17_M127_noxref_d N_noxref_13_M127_noxref_g \
 N_VDD_M127_noxref_s noxref_774 ) PMOS l=0.15 w=2 ad=0.57 as=0.57 pd=2.57 \
 ps=2.57 nrd=0 nrs=0 m=1
M128_noxref ( N_VDD_M128_noxref_d N_noxref_13_M128_noxref_g \
 N_noxref_17_M127_noxref_d noxref_774 ) PMOS l=0.15 w=2 ad=0.58 as=0.58 \
 pd=2.58 ps=2.58 nrd=0 nrs=0 m=1
M129_noxref ( N_noxref_17_M129_noxref_d N_CLK_M129_noxref_g \
 N_VDD_M128_noxref_d noxref_774 ) PMOS l=0.15 w=2 ad=0.58 as=0.58 pd=2.58 \
 ps=2.58 nrd=0 nrs=0 m=1
M130_noxref ( N_VDD_M130_noxref_d N_CLK_M130_noxref_g \
 N_noxref_17_M129_noxref_d noxref_774 ) PMOS l=0.15 w=2 ad=0.56 as=0.56 \
 pd=2.56 ps=2.56 nrd=0 nrs=0 m=1
M131_noxref ( N_noxref_20_M131_noxref_d N_noxref_15_M131_noxref_g \
 N_VDD_M131_noxref_s noxref_774 ) PMOS l=0.15 w=2 ad=0.57 as=0.57 pd=2.57 \
 ps=2.57 nrd=0 nrs=0 m=1
M132_noxref ( N_VDD_M132_noxref_d N_noxref_15_M132_noxref_g \
 N_noxref_20_M131_noxref_d noxref_774 ) PMOS l=0.15 w=2 ad=0.58 as=0.58 \
 pd=2.58 ps=2.58 nrd=0 nrs=0 m=1
M133_noxref ( N_noxref_20_M133_noxref_d N_noxref_18_M133_noxref_g \
 N_VDD_M132_noxref_d noxref_774 ) PMOS l=0.15 w=2 ad=0.58 as=0.58 pd=2.58 \
 ps=2.58 nrd=0 nrs=0 m=1
M134_noxref ( N_VDD_M134_noxref_d N_noxref_18_M134_noxref_g \
 N_noxref_20_M133_noxref_d noxref_774 ) PMOS l=0.15 w=2 ad=0.56 as=0.56 \
 pd=2.56 ps=2.56 nrd=0 nrs=0 m=1
M135_noxref ( N_noxref_18_M135_noxref_d N_noxref_20_M135_noxref_g \
 N_VDD_M135_noxref_s noxref_774 ) PMOS l=0.15 w=2 ad=0.57 as=0.57 pd=2.57 \
 ps=2.57 nrd=0 nrs=0 m=1
M136_noxref ( N_VDD_M136_noxref_d N_noxref_20_M136_noxref_g \
 N_noxref_18_M135_noxref_d noxref_774 ) PMOS l=0.15 w=2 ad=0.58 as=0.58 \
 pd=2.58 ps=2.58 nrd=0 nrs=0 m=1
M137_noxref ( N_noxref_18_M137_noxref_d N_SN_M137_noxref_g N_VDD_M136_noxref_d \
 noxref_774 ) PMOS l=0.15 w=2 ad=0.58 as=0.58 pd=2.58 ps=2.58 nrd=0 nrs=0 m=1
M138_noxref ( N_VDD_M138_noxref_d N_SN_M138_noxref_g N_noxref_18_M137_noxref_d \
 noxref_774 ) PMOS l=0.15 w=2 ad=0.58 as=0.58 pd=2.58 ps=2.58 nrd=0 nrs=0 m=1
M139_noxref ( N_noxref_18_M139_noxref_d N_noxref_17_M139_noxref_g \
 N_VDD_M138_noxref_d noxref_774 ) PMOS l=0.15 w=2 ad=0.58 as=0.58 pd=2.58 \
 ps=2.58 nrd=0 nrs=0 m=1
M140_noxref ( N_VDD_M140_noxref_d N_noxref_17_M140_noxref_g \
 N_noxref_18_M139_noxref_d noxref_774 ) PMOS l=0.15 w=2 ad=0.56 as=0.56 \
 pd=2.56 ps=2.56 nrd=0 nrs=0 m=1
M141_noxref ( N_noxref_33_M141_noxref_d N_noxref_20_M141_noxref_g \
 N_VDD_M141_noxref_s noxref_774 ) PMOS l=0.15 w=2 ad=0.57 as=0.57 pd=2.57 \
 ps=2.57 nrd=0 nrs=0 m=1
M142_noxref ( N_VDD_M142_noxref_d N_noxref_20_M142_noxref_g \
 N_noxref_33_M141_noxref_d noxref_774 ) PMOS l=0.15 w=2 ad=0.58 as=0.58 \
 pd=2.58 ps=2.58 nrd=0 nrs=0 m=1
M143_noxref ( N_noxref_33_M143_noxref_d N_noxref_19_M143_noxref_g \
 N_VDD_M142_noxref_d noxref_774 ) PMOS l=0.15 w=2 ad=0.58 as=0.58 pd=2.58 \
 ps=2.58 nrd=0 nrs=0 m=1
M144_noxref ( N_VDD_M144_noxref_d N_noxref_19_M144_noxref_g \
 N_noxref_33_M143_noxref_d noxref_774 ) PMOS l=0.15 w=2 ad=0.56 as=0.56 \
 pd=2.56 ps=2.56 nrd=0 nrs=0 m=1
M145_noxref ( N_noxref_34_M145_noxref_d N_noxref_20_M145_noxref_g \
 N_noxref_33_M145_noxref_s noxref_774 ) PMOS l=0.15 w=2 ad=0.56 as=0.56 \
 pd=2.56 ps=2.56 nrd=0 nrs=0 m=1
M146_noxref ( N_noxref_33_M146_noxref_d N_noxref_20_M146_noxref_g \
 N_noxref_34_M145_noxref_d noxref_774 ) PMOS l=0.15 w=2 ad=0.58 as=0.58 \
 pd=2.58 ps=2.58 nrd=0 nrs=0 m=1
M147_noxref ( noxref_55 N_noxref_21_M147_noxref_g N_noxref_33_M146_noxref_d \
 noxref_774 ) PMOS l=0.15 w=2 ad=0.58 as=0.58 pd=2.58 ps=2.58 nrd=0 nrs=0 m=1
M148_noxref ( N_noxref_33_M148_noxref_d N_noxref_21_M148_noxref_g noxref_55 \
 noxref_774 ) PMOS l=0.15 w=2 ad=0.57 as=0.57 pd=2.57 ps=2.57 nrd=0 nrs=0 m=1
M149_noxref ( N_QN_M149_noxref_d N_noxref_21_M149_noxref_g \
 N_noxref_34_M149_noxref_s noxref_774 ) PMOS l=0.15 w=2 ad=0.57 as=0.57 \
 pd=2.57 ps=2.57 nrd=0 nrs=0 m=1
M150_noxref ( N_noxref_34_M150_noxref_d N_noxref_21_M150_noxref_g \
 N_QN_M149_noxref_d noxref_774 ) PMOS l=0.15 w=2 ad=0.58 as=0.58 pd=2.58 \
 ps=2.58 nrd=0 nrs=0 m=1
M151_noxref ( N_QN_M151_noxref_d N_noxref_19_M151_noxref_g \
 N_noxref_34_M150_noxref_d noxref_774 ) PMOS l=0.15 w=2 ad=0.58 as=0.58 \
 pd=2.58 ps=2.58 nrd=0 nrs=0 m=1
M152_noxref ( N_noxref_34_M152_noxref_d N_noxref_19_M152_noxref_g \
 N_QN_M151_noxref_d noxref_774 ) PMOS l=0.15 w=2 ad=0.56 as=0.56 pd=2.56 \
 ps=2.56 nrd=0 nrs=0 m=1
c_16498 ( noxref_55 0 ) capacitor c=0.0143171f //x=79.035 //y=5.205
//
include "/import/yukari1/lrburle/sky130RHBDlib/calibre/sky130_rhbd_output/spice/TMRDFFSNQNX1.pxi.spice"
//
ends TMRDFFSNQNX1
//
//
