// File: TMRDFFRNQNX1.spi.TMRDFFRNQNX1.pxi
// Created: Sun Mar 15 12:45:23 2026
//
simulator lang=spectre
x_PM_TMRDFFRNQNX1\%noxref_1 ( N_noxref_1_c_52_p N_noxref_1_c_53_p \
 N_noxref_1_c_24_p N_noxref_1_c_30_p N_noxref_1_c_102_p N_noxref_1_c_195_p \
 N_noxref_1_c_8_p N_noxref_1_c_9_p N_noxref_1_c_16_p N_noxref_1_c_2_p \
 N_noxref_1_c_3_p N_noxref_1_c_46_p N_noxref_1_c_116_p N_noxref_1_c_80_p \
 N_noxref_1_c_6_p N_noxref_1_c_5_p N_noxref_1_c_10_p N_noxref_1_c_56_p \
 N_noxref_1_c_26_p N_noxref_1_c_176_p N_noxref_1_c_251_p N_noxref_1_c_246_p \
 N_noxref_1_c_17_p N_noxref_1_c_131_p N_noxref_1_c_11_p N_noxref_1_c_7_p \
 N_noxref_1_c_47_p N_noxref_1_c_57_p N_noxref_1_c_58_p N_noxref_1_c_69_p \
 N_noxref_1_c_67_p N_noxref_1_c_82_p N_noxref_1_c_71_p N_noxref_1_c_18_p \
 N_noxref_1_c_59_p N_noxref_1_c_32_p N_noxref_1_c_101_p N_noxref_1_c_178_p \
 N_noxref_1_c_255_p N_noxref_1_c_123_p N_noxref_1_c_12_p \
 N_noxref_1_M2_noxref_g N_noxref_1_M6_noxref_g N_noxref_1_M58_noxref_g \
 N_noxref_1_M59_noxref_g N_noxref_1_M66_noxref_g N_noxref_1_M67_noxref_g \
 N_noxref_1_c_35_p N_noxref_1_c_36_p N_noxref_1_c_42_p N_noxref_1_c_37_p \
 N_noxref_1_c_38_p N_noxref_1_c_39_p N_noxref_1_c_40_p N_noxref_1_c_155_p \
 N_noxref_1_c_156_p N_noxref_1_c_158_p N_noxref_1_c_133_p N_noxref_1_c_394_p \
 N_noxref_1_c_395_p N_noxref_1_c_157_p N_noxref_1_c_159_p N_noxref_1_c_60_p \
 N_noxref_1_c_45_p N_noxref_1_c_66_p N_noxref_1_c_15_p N_noxref_1_M5_noxref_d \
 N_noxref_1_M60_noxref_d N_noxref_1_M62_noxref_d N_noxref_1_M64_noxref_d )  \
 PM_TMRDFFRNQNX1\%noxref_1
x_PM_TMRDFFRNQNX1\%noxref_2 ( N_noxref_2_c_440_n N_noxref_2_c_441_n \
 N_noxref_2_c_510_p N_noxref_2_c_488_p N_noxref_2_c_442_n N_noxref_2_c_443_n \
 N_noxref_2_c_463_p N_noxref_2_c_445_n N_noxref_2_c_554_p N_noxref_2_c_478_p \
 N_noxref_2_c_469_p N_noxref_2_c_470_p N_noxref_2_c_447_n N_noxref_2_c_493_p \
 N_noxref_2_c_609_p N_noxref_2_c_455_n N_noxref_2_c_456_n N_noxref_2_c_551_p \
 N_noxref_2_c_457_n N_noxref_2_c_471_p N_noxref_2_c_468_p N_noxref_2_c_458_n \
 N_noxref_2_c_509_p N_noxref_2_c_553_p N_noxref_2_c_558_p \
 N_noxref_2_M8_noxref_g N_noxref_2_M70_noxref_g N_noxref_2_M71_noxref_g \
 N_noxref_2_c_578_p N_noxref_2_c_579_p N_noxref_2_c_581_p N_noxref_2_c_556_p \
 N_noxref_2_c_659_p N_noxref_2_c_672_p N_noxref_2_c_580_p N_noxref_2_c_582_p \
 N_noxref_2_c_496_p N_noxref_2_c_560_p N_noxref_2_M7_noxref_d \
 N_noxref_2_M66_noxref_d N_noxref_2_M68_noxref_d )  PM_TMRDFFRNQNX1\%noxref_2
x_PM_TMRDFFRNQNX1\%noxref_3 ( N_noxref_3_c_872_p N_noxref_3_c_717_n \
 N_noxref_3_c_719_n N_noxref_3_c_722_n N_noxref_3_c_727_n N_noxref_3_c_734_n \
 N_noxref_3_c_739_n N_noxref_3_c_743_n N_noxref_3_c_745_n N_noxref_3_c_755_n \
 N_noxref_3_c_757_n N_noxref_3_c_760_n N_noxref_3_c_761_n N_noxref_3_c_765_n \
 N_noxref_3_c_766_n N_noxref_3_c_822_p N_noxref_3_c_823_p N_noxref_3_c_824_p \
 N_noxref_3_c_825_p N_noxref_3_c_838_p N_noxref_3_c_941_p N_noxref_3_c_767_n \
 N_noxref_3_c_770_n N_noxref_3_c_882_p N_noxref_3_c_983_p N_noxref_3_c_771_n \
 N_noxref_3_c_773_n N_noxref_3_c_776_n N_noxref_3_c_780_n N_noxref_3_c_784_n \
 N_noxref_3_c_806_n N_noxref_3_c_809_n N_noxref_3_c_812_n N_noxref_3_c_816_n \
 N_noxref_3_c_826_p N_noxref_3_c_827_p N_noxref_3_c_786_n N_noxref_3_c_871_p \
 N_noxref_3_c_942_p N_noxref_3_c_788_n N_noxref_3_c_887_p N_noxref_3_c_884_p \
 N_noxref_3_c_988_p N_noxref_3_c_985_p N_noxref_3_M3_noxref_g \
 N_noxref_3_M11_noxref_g N_noxref_3_M60_noxref_g N_noxref_3_M61_noxref_g \
 N_noxref_3_M76_noxref_g N_noxref_3_M77_noxref_g N_noxref_3_c_921_p \
 N_noxref_3_c_922_p N_noxref_3_c_924_p N_noxref_3_c_888_p N_noxref_3_c_1116_p \
 N_noxref_3_c_1129_p N_noxref_3_c_923_p N_noxref_3_c_925_p N_noxref_3_c_798_n \
 N_noxref_3_c_896_p N_noxref_3_c_1016_p N_noxref_3_c_1017_p \
 N_noxref_3_c_1019_p N_noxref_3_c_989_p N_noxref_3_c_1119_p \
 N_noxref_3_c_1139_p N_noxref_3_c_1018_p N_noxref_3_c_1020_p \
 N_noxref_3_c_835_p N_noxref_3_c_993_p N_noxref_3_M2_noxref_d \
 N_noxref_3_M54_noxref_d N_noxref_3_M56_noxref_d N_noxref_3_M58_noxref_d )  \
 PM_TMRDFFRNQNX1\%noxref_3
x_PM_TMRDFFRNQNX1\%noxref_4 ( N_noxref_4_c_1403_p N_noxref_4_c_1196_n \
 N_noxref_4_c_1394_p N_noxref_4_c_1198_n N_noxref_4_c_1199_n \
 N_noxref_4_c_1207_n N_noxref_4_c_1208_n N_noxref_4_c_1266_n \
 N_noxref_4_c_1475_p N_noxref_4_c_1547_p N_noxref_4_c_1431_p \
 N_noxref_4_c_1508_p N_noxref_4_c_1267_n N_noxref_4_c_1568_p \
 N_noxref_4_c_1268_n N_noxref_4_c_1322_n N_noxref_4_c_1328_n \
 N_noxref_4_c_1331_n N_noxref_4_c_1332_n N_noxref_4_c_1555_p \
 N_noxref_4_c_1640_p N_noxref_4_c_1438_p N_noxref_4_c_1523_p \
 N_noxref_4_c_1610_p N_noxref_4_c_1619_p N_noxref_4_c_1524_p \
 N_noxref_4_c_1384_p N_noxref_4_c_1439_p N_noxref_4_c_1440_p \
 N_noxref_4_c_1385_p N_noxref_4_c_1441_p N_noxref_4_c_1377_p \
 N_noxref_4_c_1442_p N_noxref_4_c_1378_p N_noxref_4_c_1396_p \
 N_noxref_4_c_1213_n N_noxref_4_c_1214_n N_noxref_4_c_1271_n \
 N_noxref_4_c_1413_p N_noxref_4_c_1510_p N_noxref_4_c_1500_p \
 N_noxref_4_c_1333_n N_noxref_4_c_1445_p N_noxref_4_c_1599_p \
 N_noxref_4_c_1600_p N_noxref_4_c_1813_p N_noxref_4_c_1528_p \
 N_noxref_4_c_1446_p N_noxref_4_c_1447_p N_noxref_4_c_1379_p \
 N_noxref_4_c_1529_p N_noxref_4_c_1217_n N_noxref_4_c_1221_n \
 N_noxref_4_c_1222_n N_noxref_4_c_1223_n N_noxref_4_c_1276_n \
 N_noxref_4_c_1224_n N_noxref_4_c_1361_n N_noxref_4_c_1363_n \
 N_noxref_4_c_1366_n N_noxref_4_c_1398_p N_noxref_4_c_1391_p \
 N_noxref_4_c_1451_p N_noxref_4_c_1380_p N_noxref_4_c_1392_p \
 N_noxref_4_c_1399_p N_noxref_4_c_1409_p N_noxref_4_c_1228_n \
 N_noxref_4_c_1232_n N_noxref_4_c_1283_n N_noxref_4_c_1415_p \
 N_noxref_4_c_1514_p N_noxref_4_c_1367_n N_noxref_4_c_1518_p \
 N_noxref_4_c_1603_p N_noxref_4_c_1531_p N_noxref_4_c_1644_p \
 N_noxref_4_c_1624_p N_noxref_4_c_1606_p N_noxref_4_M0_noxref_g \
 N_noxref_4_M7_noxref_g N_noxref_4_M14_noxref_g N_noxref_4_M15_noxref_g \
 N_noxref_4_M54_noxref_g N_noxref_4_M55_noxref_g N_noxref_4_M68_noxref_g \
 N_noxref_4_M69_noxref_g N_noxref_4_M82_noxref_g N_noxref_4_M83_noxref_g \
 N_noxref_4_M84_noxref_g N_noxref_4_M85_noxref_g N_noxref_4_c_1478_p \
 N_noxref_4_c_1479_p N_noxref_4_c_1481_p N_noxref_4_c_1406_p \
 N_noxref_4_c_1893_p N_noxref_4_c_1911_p N_noxref_4_c_1480_p \
 N_noxref_4_c_1482_p N_noxref_4_c_1375_n N_noxref_4_c_1411_p \
 N_noxref_4_c_1238_n N_noxref_4_c_1241_n N_noxref_4_c_1243_n \
 N_noxref_4_c_1298_n N_noxref_4_c_1301_n N_noxref_4_c_1303_n \
 N_noxref_4_c_1246_n N_noxref_4_c_1247_n N_noxref_4_c_1919_p \
 N_noxref_4_c_1920_p N_noxref_4_c_1921_p N_noxref_4_c_1532_p \
 N_noxref_4_c_1922_p N_noxref_4_c_1923_p N_noxref_4_c_1924_p \
 N_noxref_4_c_1925_p N_noxref_4_c_1652_p N_noxref_4_c_1611_p \
 N_noxref_4_c_1612_p N_noxref_4_c_1637_p N_noxref_4_c_1654_p \
 N_noxref_4_c_1613_p N_noxref_4_c_1656_p N_noxref_4_c_1614_p \
 N_noxref_4_c_1248_n N_noxref_4_c_1314_n N_noxref_4_c_1251_n \
 N_noxref_4_c_1647_p N_noxref_4_c_1533_p N_noxref_4_c_1615_p \
 N_noxref_4_c_1456_p N_noxref_4_M10_noxref_d N_noxref_4_M13_noxref_d \
 N_noxref_4_M70_noxref_d N_noxref_4_M72_noxref_d N_noxref_4_M74_noxref_d \
 N_noxref_4_M76_noxref_d N_noxref_4_M78_noxref_d N_noxref_4_M80_noxref_d )  \
 PM_TMRDFFRNQNX1\%noxref_4
x_PM_TMRDFFRNQNX1\%noxref_5 ( N_noxref_5_c_2069_p N_noxref_5_c_2070_p \
 N_noxref_5_c_2043_p N_noxref_5_c_2049_p N_noxref_5_c_2118_p \
 N_noxref_5_c_2211_p N_noxref_5_c_2027_p N_noxref_5_c_2028_p \
 N_noxref_5_c_2035_p N_noxref_5_c_2021_p N_noxref_5_c_2022_p \
 N_noxref_5_c_2065_p N_noxref_5_c_2132_p N_noxref_5_c_2096_p \
 N_noxref_5_c_2025_p N_noxref_5_c_2024_p N_noxref_5_c_2029_p \
 N_noxref_5_c_2073_p N_noxref_5_c_2045_p N_noxref_5_c_2189_p \
 N_noxref_5_c_2259_p N_noxref_5_c_2266_p N_noxref_5_c_2036_p \
 N_noxref_5_c_2147_p N_noxref_5_c_2030_p N_noxref_5_c_2026_p \
 N_noxref_5_c_2152_p N_noxref_5_c_2074_p N_noxref_5_c_2075_p \
 N_noxref_5_c_2085_p N_noxref_5_c_2086_p N_noxref_5_c_2098_p \
 N_noxref_5_c_2087_p N_noxref_5_c_2037_p N_noxref_5_c_2076_p \
 N_noxref_5_c_2051_p N_noxref_5_c_2117_p N_noxref_5_c_2190_p \
 N_noxref_5_c_2269_p N_noxref_5_c_2139_p N_noxref_5_c_2031_p \
 N_noxref_5_M18_noxref_g N_noxref_5_M22_noxref_g N_noxref_5_M90_noxref_g \
 N_noxref_5_M91_noxref_g N_noxref_5_M98_noxref_g N_noxref_5_M99_noxref_g \
 N_noxref_5_c_2054_p N_noxref_5_c_2055_p N_noxref_5_c_2061_p \
 N_noxref_5_c_2056_p N_noxref_5_c_2057_p N_noxref_5_c_2058_p \
 N_noxref_5_c_2059_p N_noxref_5_c_2171_p N_noxref_5_c_2172_p \
 N_noxref_5_c_2174_p N_noxref_5_c_2149_p N_noxref_5_c_2427_p \
 N_noxref_5_c_2428_p N_noxref_5_c_2173_p N_noxref_5_c_2175_p \
 N_noxref_5_c_2077_p N_noxref_5_c_2064_p N_noxref_5_c_2083_p \
 N_noxref_5_c_2034_p N_noxref_5_M21_noxref_d N_noxref_5_M92_noxref_d \
 N_noxref_5_M94_noxref_d N_noxref_5_M96_noxref_d )  PM_TMRDFFRNQNX1\%noxref_5
x_PM_TMRDFFRNQNX1\%noxref_6 ( N_noxref_6_c_2467_n N_noxref_6_c_2468_n \
 N_noxref_6_c_2537_p N_noxref_6_c_2515_p N_noxref_6_c_2469_n \
 N_noxref_6_c_2470_n N_noxref_6_c_2490_p N_noxref_6_c_2472_n \
 N_noxref_6_c_2577_p N_noxref_6_c_2505_p N_noxref_6_c_2496_p \
 N_noxref_6_c_2497_p N_noxref_6_c_2474_n N_noxref_6_c_2520_p \
 N_noxref_6_c_2642_p N_noxref_6_c_2482_n N_noxref_6_c_2483_n \
 N_noxref_6_c_2574_p N_noxref_6_c_2484_n N_noxref_6_c_2498_p \
 N_noxref_6_c_2495_p N_noxref_6_c_2485_n N_noxref_6_c_2536_p \
 N_noxref_6_c_2576_p N_noxref_6_c_2581_p N_noxref_6_M24_noxref_g \
 N_noxref_6_M102_noxref_g N_noxref_6_M103_noxref_g N_noxref_6_c_2601_p \
 N_noxref_6_c_2602_p N_noxref_6_c_2604_p N_noxref_6_c_2579_p \
 N_noxref_6_c_2692_p N_noxref_6_c_2705_p N_noxref_6_c_2603_p \
 N_noxref_6_c_2605_p N_noxref_6_c_2523_p N_noxref_6_c_2583_p \
 N_noxref_6_M23_noxref_d N_noxref_6_M98_noxref_d N_noxref_6_M100_noxref_d )  \
 PM_TMRDFFRNQNX1\%noxref_6
x_PM_TMRDFFRNQNX1\%noxref_7 ( N_noxref_7_c_2900_p N_noxref_7_c_2749_n \
 N_noxref_7_c_2751_n N_noxref_7_c_2754_n N_noxref_7_c_2759_n \
 N_noxref_7_c_2766_n N_noxref_7_c_2771_n N_noxref_7_c_2774_n \
 N_noxref_7_c_2775_n N_noxref_7_c_2785_n N_noxref_7_c_2787_n \
 N_noxref_7_c_2905_p N_noxref_7_c_2790_n N_noxref_7_c_2794_n \
 N_noxref_7_c_2795_n N_noxref_7_c_2859_p N_noxref_7_c_2860_p \
 N_noxref_7_c_2861_p N_noxref_7_c_2862_p N_noxref_7_c_2898_p \
 N_noxref_7_c_2963_p N_noxref_7_c_2796_n N_noxref_7_c_2799_n \
 N_noxref_7_c_2917_p N_noxref_7_c_2851_p N_noxref_7_c_2800_n \
 N_noxref_7_c_2802_n N_noxref_7_c_2805_n N_noxref_7_c_2809_n \
 N_noxref_7_c_2813_n N_noxref_7_c_2835_n N_noxref_7_c_2838_n \
 N_noxref_7_c_2841_n N_noxref_7_c_2845_n N_noxref_7_c_2863_p \
 N_noxref_7_c_2864_p N_noxref_7_c_2815_n N_noxref_7_c_2899_p \
 N_noxref_7_c_2964_p N_noxref_7_c_2817_n N_noxref_7_c_2906_p \
 N_noxref_7_c_2919_p N_noxref_7_c_3010_p N_noxref_7_c_3004_p \
 N_noxref_7_M19_noxref_g N_noxref_7_M27_noxref_g N_noxref_7_M92_noxref_g \
 N_noxref_7_M93_noxref_g N_noxref_7_M108_noxref_g N_noxref_7_M109_noxref_g \
 N_noxref_7_c_2943_p N_noxref_7_c_2944_p N_noxref_7_c_2946_p \
 N_noxref_7_c_2907_p N_noxref_7_c_3159_p N_noxref_7_c_3172_p \
 N_noxref_7_c_2945_p N_noxref_7_c_2947_p N_noxref_7_c_2827_n \
 N_noxref_7_c_2921_p N_noxref_7_c_3039_p N_noxref_7_c_3040_p \
 N_noxref_7_c_3042_p N_noxref_7_c_3011_p N_noxref_7_c_3162_p \
 N_noxref_7_c_3182_p N_noxref_7_c_3041_p N_noxref_7_c_3043_p \
 N_noxref_7_c_2850_p N_noxref_7_c_3015_p N_noxref_7_M18_noxref_d \
 N_noxref_7_M86_noxref_d N_noxref_7_M88_noxref_d N_noxref_7_M90_noxref_d )  \
 PM_TMRDFFRNQNX1\%noxref_7
x_PM_TMRDFFRNQNX1\%noxref_8 ( N_noxref_8_c_3238_n N_noxref_8_c_3326_p \
 N_noxref_8_c_3357_p N_noxref_8_c_3301_p N_noxref_8_c_3314_p \
 N_noxref_8_c_3350_p N_noxref_8_c_3351_p N_noxref_8_c_3248_p \
 N_noxref_8_c_3249_p N_noxref_8_c_3266_p N_noxref_8_c_3257_p \
 N_noxref_8_c_3250_p N_noxref_8_c_3251_p N_noxref_8_c_3239_n \
 N_noxref_8_c_3304_p N_noxref_8_c_3344_p N_noxref_8_c_3242_n \
 N_noxref_8_c_3252_p N_noxref_8_c_3263_p N_noxref_8_c_3258_p \
 N_noxref_8_c_3253_p N_noxref_8_c_3270_p N_noxref_8_c_3254_p \
 N_noxref_8_c_3272_p N_noxref_8_c_3243_n N_noxref_8_c_3313_p \
 N_noxref_8_c_3348_p N_noxref_8_c_3255_p N_noxref_8_c_3260_p \
 N_noxref_8_M30_noxref_g N_noxref_8_M114_noxref_g N_noxref_8_M115_noxref_g \
 N_noxref_8_c_3283_p N_noxref_8_c_3284_p N_noxref_8_c_3286_p \
 N_noxref_8_c_3265_p N_noxref_8_c_3496_p N_noxref_8_c_3497_p \
 N_noxref_8_c_3285_p N_noxref_8_c_3287_p N_noxref_8_c_3261_p \
 N_noxref_8_M29_noxref_d N_noxref_8_M108_noxref_d N_noxref_8_M110_noxref_d \
 N_noxref_8_M112_noxref_d )  PM_TMRDFFRNQNX1\%noxref_8
x_PM_TMRDFFRNQNX1\%noxref_9 ( N_noxref_9_c_3777_p N_noxref_9_c_3531_n \
 N_noxref_9_c_3768_p N_noxref_9_c_3532_n N_noxref_9_c_3538_n \
 N_noxref_9_c_3546_n N_noxref_9_c_3547_n N_noxref_9_c_3605_n \
 N_noxref_9_c_3842_p N_noxref_9_c_3707_n N_noxref_9_c_3708_n \
 N_noxref_9_c_3872_p N_noxref_9_c_3606_n N_noxref_9_c_3709_n \
 N_noxref_9_c_3607_n N_noxref_9_c_3661_n N_noxref_9_c_3667_n \
 N_noxref_9_c_3670_n N_noxref_9_c_3710_n N_noxref_9_c_3717_n \
 N_noxref_9_c_3718_n N_noxref_9_c_3533_n N_noxref_9_c_3552_n \
 N_noxref_9_c_3553_n N_noxref_9_c_3610_n N_noxref_9_c_3786_p \
 N_noxref_9_c_3874_p N_noxref_9_c_3865_p N_noxref_9_c_3723_n \
 N_noxref_9_c_3724_n N_noxref_9_c_3556_n N_noxref_9_c_3560_n \
 N_noxref_9_c_3561_n N_noxref_9_c_3562_n N_noxref_9_c_3615_n \
 N_noxref_9_c_3563_n N_noxref_9_c_3695_n N_noxref_9_c_3697_n \
 N_noxref_9_c_3534_n N_noxref_9_c_3773_p N_noxref_9_c_3782_p \
 N_noxref_9_c_3567_n N_noxref_9_c_3571_n N_noxref_9_c_3622_n \
 N_noxref_9_c_3788_p N_noxref_9_c_3878_p N_noxref_9_c_3734_n \
 N_noxref_9_c_3738_n N_noxref_9_M16_noxref_g N_noxref_9_M23_noxref_g \
 N_noxref_9_M31_noxref_g N_noxref_9_M86_noxref_g N_noxref_9_M87_noxref_g \
 N_noxref_9_M100_noxref_g N_noxref_9_M101_noxref_g N_noxref_9_M116_noxref_g \
 N_noxref_9_M117_noxref_g N_noxref_9_c_3845_p N_noxref_9_c_3846_p \
 N_noxref_9_c_3848_p N_noxref_9_c_3779_p N_noxref_9_c_4107_p \
 N_noxref_9_c_4121_p N_noxref_9_c_3847_p N_noxref_9_c_3849_p \
 N_noxref_9_c_3705_n N_noxref_9_c_3784_p N_noxref_9_c_3577_n \
 N_noxref_9_c_3580_n N_noxref_9_c_3582_n N_noxref_9_c_3637_n \
 N_noxref_9_c_3640_n N_noxref_9_c_3642_n N_noxref_9_c_3585_n \
 N_noxref_9_c_3586_n N_noxref_9_c_3744_n N_noxref_9_c_3747_n \
 N_noxref_9_c_3749_n N_noxref_9_c_3959_p N_noxref_9_c_3966_p \
 N_noxref_9_c_3941_p N_noxref_9_c_3752_n N_noxref_9_c_3753_n \
 N_noxref_9_c_3587_n N_noxref_9_c_3653_n N_noxref_9_c_3590_n \
 N_noxref_9_c_3754_n N_noxref_9_c_3943_p N_noxref_9_c_3757_n \
 N_noxref_9_M26_noxref_d N_noxref_9_M102_noxref_d N_noxref_9_M104_noxref_d \
 N_noxref_9_M106_noxref_d )  PM_TMRDFFRNQNX1\%noxref_9
x_PM_TMRDFFRNQNX1\%D ( D D N_D_c_4231_n N_D_c_4188_n N_D_c_4189_n N_D_c_4193_n \
 N_D_c_4326_n N_D_c_4293_n N_D_c_4294_n N_D_c_4297_n N_D_c_4403_p N_D_c_4399_p \
 N_D_c_4407_p N_D_c_4398_p N_D_c_4343_n N_D_c_4409_p N_D_c_4303_n N_D_c_4196_n \
 N_D_c_4197_n N_D_c_4352_n N_D_c_4411_p N_D_c_4255_n N_D_c_4204_n N_D_c_4353_n \
 N_D_c_4312_n N_D_c_4404_p N_D_c_4415_p N_D_M4_noxref_g N_D_M20_noxref_g \
 N_D_M36_noxref_g N_D_M62_noxref_g N_D_M63_noxref_g N_D_M94_noxref_g \
 N_D_M95_noxref_g N_D_M126_noxref_g N_D_M127_noxref_g N_D_c_4266_n \
 N_D_c_4269_n N_D_c_4662_p N_D_c_4663_p N_D_c_4271_n N_D_c_4272_n N_D_c_4273_n \
 N_D_c_4274_n N_D_c_4212_n N_D_c_4364_n N_D_c_4367_n N_D_c_4679_p N_D_c_4680_p \
 N_D_c_4369_n N_D_c_4370_n N_D_c_4371_n N_D_c_4372_n N_D_c_4320_n N_D_c_4429_p \
 N_D_c_4431_p N_D_c_4695_p N_D_c_4696_p N_D_c_4436_p N_D_c_4438_p N_D_c_4439_p \
 N_D_c_4405_p N_D_c_4575_p N_D_c_4214_n N_D_c_4322_n N_D_c_4416_p )  \
 PM_TMRDFFRNQNX1\%D
x_PM_TMRDFFRNQNX1\%CLK ( CLK CLK CLK CLK CLK CLK CLK CLK CLK CLK CLK CLK CLK \
 CLK CLK CLK N_CLK_c_4769_n N_CLK_c_4812_n N_CLK_c_4998_n N_CLK_c_5040_n \
 N_CLK_c_5307_p N_CLK_c_5293_p N_CLK_c_5256_p N_CLK_c_4772_n N_CLK_c_4815_n \
 N_CLK_c_5001_n N_CLK_c_5043_n N_CLK_c_5230_p N_CLK_c_5298_p N_CLK_c_4775_n \
 N_CLK_c_4821_n N_CLK_c_4868_n N_CLK_c_4822_n N_CLK_c_4875_n N_CLK_c_4950_n \
 N_CLK_c_5146_n N_CLK_c_5149_n N_CLK_c_5047_n N_CLK_c_5004_n N_CLK_c_5098_n \
 N_CLK_c_5050_n N_CLK_c_5105_n N_CLK_c_5180_n N_CLK_c_5388_p N_CLK_c_5389_p \
 N_CLK_c_5253_p N_CLK_c_5229_n N_CLK_c_4783_n N_CLK_c_4784_n N_CLK_c_4788_n \
 N_CLK_c_4825_n N_CLK_c_4829_n N_CLK_c_5012_n N_CLK_c_5016_n N_CLK_c_5053_n \
 N_CLK_c_5057_n N_CLK_c_5308_p N_CLK_c_5232_p N_CLK_c_5295_p N_CLK_c_5300_p \
 N_CLK_M1_noxref_g N_CLK_M9_noxref_g N_CLK_M17_noxref_g N_CLK_M25_noxref_g \
 N_CLK_M33_noxref_g N_CLK_M41_noxref_g N_CLK_M56_noxref_g N_CLK_M57_noxref_g \
 N_CLK_M72_noxref_g N_CLK_M73_noxref_g N_CLK_M88_noxref_g N_CLK_M89_noxref_g \
 N_CLK_M104_noxref_g N_CLK_M105_noxref_g N_CLK_M120_noxref_g \
 N_CLK_M121_noxref_g N_CLK_M136_noxref_g N_CLK_M137_noxref_g N_CLK_c_4974_n \
 N_CLK_c_4977_n N_CLK_c_5651_p N_CLK_c_5652_p N_CLK_c_4794_n N_CLK_c_4795_n \
 N_CLK_c_4796_n N_CLK_c_4797_n N_CLK_c_4801_n N_CLK_c_4836_n N_CLK_c_4839_n \
 N_CLK_c_5666_p N_CLK_c_5667_p N_CLK_c_4841_n N_CLK_c_4842_n N_CLK_c_4843_n \
 N_CLK_c_4844_n N_CLK_c_4985_n N_CLK_c_5202_n N_CLK_c_5205_n N_CLK_c_5681_p \
 N_CLK_c_5682_p N_CLK_c_5022_n N_CLK_c_5023_n N_CLK_c_5024_n N_CLK_c_5025_n \
 N_CLK_c_5029_n N_CLK_c_5064_n N_CLK_c_5067_n N_CLK_c_5696_p N_CLK_c_5697_p \
 N_CLK_c_5069_n N_CLK_c_5070_n N_CLK_c_5071_n N_CLK_c_5072_n N_CLK_c_5213_n \
 N_CLK_c_5442_p N_CLK_c_5444_p N_CLK_c_5711_p N_CLK_c_5712_p N_CLK_c_5449_p \
 N_CLK_c_5451_p N_CLK_c_5452_p N_CLK_c_5309_p N_CLK_c_5247_p N_CLK_c_5540_p \
 N_CLK_c_5542_p N_CLK_c_5726_p N_CLK_c_5727_p N_CLK_c_5358_p N_CLK_c_5359_p \
 N_CLK_c_5360_p N_CLK_c_5296_p N_CLK_c_5380_p N_CLK_c_4802_n N_CLK_c_4847_n \
 N_CLK_c_5030_n N_CLK_c_5075_n N_CLK_c_5234_p N_CLK_c_5301_p )  \
 PM_TMRDFFRNQNX1\%CLK
x_PM_TMRDFFRNQNX1\%noxref_12 ( N_noxref_12_c_5847_n N_noxref_12_c_5852_n \
 N_noxref_12_c_6034_p N_noxref_12_c_5853_n N_noxref_12_c_5900_p \
 N_noxref_12_c_5996_p N_noxref_12_c_6017_p N_noxref_12_c_5901_p \
 N_noxref_12_c_5800_n N_noxref_12_c_5956_p N_noxref_12_c_5803_n \
 N_noxref_12_c_5804_n N_noxref_12_c_5807_n N_noxref_12_c_5814_n \
 N_noxref_12_c_5815_n N_noxref_12_c_5892_p N_noxref_12_c_5880_p \
 N_noxref_12_c_5881_p N_noxref_12_c_5882_p N_noxref_12_c_5858_n \
 N_noxref_12_c_5859_n N_noxref_12_c_6012_p N_noxref_12_c_6013_p \
 N_noxref_12_c_5818_n N_noxref_12_c_5883_p N_noxref_12_c_5865_n \
 N_noxref_12_c_5866_n N_noxref_12_c_5819_n N_noxref_12_c_5868_n \
 N_noxref_12_c_5869_n N_noxref_12_c_5870_n N_noxref_12_c_5871_n \
 N_noxref_12_c_5872_n N_noxref_12_c_5873_n N_noxref_12_c_5875_n \
 N_noxref_12_c_5884_p N_noxref_12_c_5958_p N_noxref_12_c_5990_p \
 N_noxref_12_c_5876_n N_noxref_12_c_6015_p N_noxref_12_c_5820_n \
 N_noxref_12_c_5824_n N_noxref_12_c_5894_p N_noxref_12_c_5885_p \
 N_noxref_12_M35_noxref_g N_noxref_12_M43_noxref_g N_noxref_12_M124_noxref_g \
 N_noxref_12_M125_noxref_g N_noxref_12_M140_noxref_g N_noxref_12_M141_noxref_g \
 N_noxref_12_c_5830_n N_noxref_12_c_5831_n N_noxref_12_c_5832_n \
 N_noxref_12_c_5833_n N_noxref_12_c_6212_p N_noxref_12_c_6225_p \
 N_noxref_12_c_5836_n N_noxref_12_c_5838_n N_noxref_12_c_5841_n \
 N_noxref_12_c_5844_n N_noxref_12_c_5923_p N_noxref_12_c_5924_p \
 N_noxref_12_c_5926_p N_noxref_12_c_5895_p N_noxref_12_c_6215_p \
 N_noxref_12_c_6235_p N_noxref_12_c_5925_p N_noxref_12_c_5927_p \
 N_noxref_12_c_5898_p N_noxref_12_c_5899_p N_noxref_12_M34_noxref_d \
 N_noxref_12_M118_noxref_d N_noxref_12_M120_noxref_d N_noxref_12_M122_noxref_d \
 )  PM_TMRDFFRNQNX1\%noxref_12
x_PM_TMRDFFRNQNX1\%RN ( RN RN RN RN RN RN RN RN RN RN N_RN_c_6301_n \
 N_RN_c_6429_n N_RN_c_6432_n N_RN_c_6372_n N_RN_c_6376_n N_RN_c_6506_n \
 N_RN_c_6509_n N_RN_c_6667_n N_RN_c_6670_n N_RN_c_6587_n N_RN_c_6591_n \
 N_RN_c_6760_n N_RN_c_6764_n N_RN_c_6884_n N_RN_c_6888_n N_RN_c_6985_n \
 N_RN_c_6989_n N_RN_c_6380_n N_RN_c_6771_n N_RN_c_6386_n N_RN_c_6523_n \
 N_RN_c_6602_n N_RN_c_6783_n N_RN_c_6606_n N_RN_c_6791_n N_RN_c_6305_n \
 N_RN_c_6308_n N_RN_c_6391_n N_RN_c_6525_n N_RN_c_6686_n N_RN_c_6911_n \
 N_RN_c_6915_n N_RN_c_7000_n N_RN_c_7002_n N_RN_c_6315_n N_RN_c_6316_n \
 N_RN_c_6460_n N_RN_c_6461_n N_RN_c_6392_n N_RN_c_6395_n N_RN_c_6531_n \
 N_RN_c_6532_n N_RN_c_6688_n N_RN_c_6689_n N_RN_c_6608_n N_RN_c_6611_n \
 N_RN_c_6809_n N_RN_c_6812_n N_RN_c_6928_n N_RN_c_6931_n N_RN_c_7006_n \
 N_RN_c_7009_n N_RN_M5_noxref_g N_RN_M10_noxref_g N_RN_M12_noxref_g \
 N_RN_M21_noxref_g N_RN_M26_noxref_g N_RN_M28_noxref_g N_RN_M37_noxref_g \
 N_RN_M42_noxref_g N_RN_M44_noxref_g N_RN_M64_noxref_g N_RN_M65_noxref_g \
 N_RN_M74_noxref_g N_RN_M75_noxref_g N_RN_M78_noxref_g N_RN_M79_noxref_g \
 N_RN_M96_noxref_g N_RN_M97_noxref_g N_RN_M106_noxref_g N_RN_M107_noxref_g \
 N_RN_M110_noxref_g N_RN_M111_noxref_g N_RN_M128_noxref_g N_RN_M129_noxref_g \
 N_RN_M138_noxref_g N_RN_M139_noxref_g N_RN_M142_noxref_g N_RN_M143_noxref_g \
 N_RN_c_6326_n N_RN_c_6328_n N_RN_c_6331_n N_RN_c_6332_n N_RN_c_6334_n \
 N_RN_c_6338_n N_RN_c_6340_n N_RN_c_6479_n N_RN_c_6481_n N_RN_c_6484_n \
 N_RN_c_6485_n N_RN_c_6487_n N_RN_c_6491_n N_RN_c_6493_n N_RN_c_6402_n \
 N_RN_c_6405_n N_RN_c_7428_p N_RN_c_7429_p N_RN_c_6407_n N_RN_c_6408_n \
 N_RN_c_6409_n N_RN_c_6410_n N_RN_c_6497_n N_RN_c_6542_n N_RN_c_6544_n \
 N_RN_c_6547_n N_RN_c_6548_n N_RN_c_6550_n N_RN_c_6554_n N_RN_c_6556_n \
 N_RN_c_6699_n N_RN_c_6701_n N_RN_c_6704_n N_RN_c_6705_n N_RN_c_6707_n \
 N_RN_c_6711_n N_RN_c_6713_n N_RN_c_6618_n N_RN_c_6621_n N_RN_c_7480_p \
 N_RN_c_7481_p N_RN_c_6623_n N_RN_c_6624_n N_RN_c_6625_n N_RN_c_6626_n \
 N_RN_c_6654_n N_RN_c_6830_n N_RN_c_6831_n N_RN_c_6832_n N_RN_c_7138_p \
 N_RN_c_7139_p N_RN_c_7140_p N_RN_c_7141_p N_RN_c_6949_n N_RN_c_6950_n \
 N_RN_c_6951_n N_RN_c_7045_p N_RN_c_7046_p N_RN_c_7047_p N_RN_c_7048_p \
 N_RN_c_7016_n N_RN_c_7019_n N_RN_c_7530_p N_RN_c_7531_p N_RN_c_7021_n \
 N_RN_c_7022_n N_RN_c_7023_n N_RN_c_7024_n N_RN_c_7088_p N_RN_c_6344_n \
 N_RN_c_6345_n N_RN_c_6347_n N_RN_c_6499_n N_RN_c_6500_n N_RN_c_6502_n \
 N_RN_c_6413_n N_RN_c_6560_n N_RN_c_6561_n N_RN_c_6563_n N_RN_c_6717_n \
 N_RN_c_6718_n N_RN_c_6720_n N_RN_c_6629_n N_RN_c_6847_n N_RN_c_6849_n \
 N_RN_c_6850_n N_RN_c_6966_n N_RN_c_6968_n N_RN_c_6969_n N_RN_c_7027_n )  \
 PM_TMRDFFRNQNX1\%RN
x_PM_TMRDFFRNQNX1\%noxref_14 ( N_noxref_14_c_7733_n N_noxref_14_c_7727_n \
 N_noxref_14_c_7738_n N_noxref_14_c_7728_n N_noxref_14_c_7812_n \
 N_noxref_14_c_7747_n N_noxref_14_c_7749_n N_noxref_14_c_7751_n \
 N_noxref_14_c_7756_n N_noxref_14_c_7874_n N_noxref_14_c_7876_n \
 N_noxref_14_c_7880_n N_noxref_14_c_7888_n N_noxref_14_c_7893_n \
 N_noxref_14_c_7895_n N_noxref_14_c_7757_n N_noxref_14_c_7822_n \
 N_noxref_14_c_7758_n N_noxref_14_c_7826_n N_noxref_14_c_7914_n \
 N_noxref_14_c_8172_p N_noxref_14_c_8120_p N_noxref_14_c_8107_p \
 N_noxref_14_c_8142_p N_noxref_14_c_8151_p N_noxref_14_c_8108_p \
 N_noxref_14_c_7915_n N_noxref_14_c_8127_p N_noxref_14_c_7916_n \
 N_noxref_14_c_8050_p N_noxref_14_c_8174_p N_noxref_14_c_8005_p \
 N_noxref_14_c_8134_p N_noxref_14_c_8135_p N_noxref_14_c_7729_n \
 N_noxref_14_c_7994_p N_noxref_14_c_7917_n N_noxref_14_c_7760_n \
 N_noxref_14_c_7761_n N_noxref_14_c_7918_n N_noxref_14_c_7922_n \
 N_noxref_14_c_7827_n N_noxref_14_c_7923_n N_noxref_14_c_8129_p \
 N_noxref_14_c_8130_p N_noxref_14_c_8349_p N_noxref_14_c_8112_p \
 N_noxref_14_c_8175_p N_noxref_14_c_8131_p N_noxref_14_c_8166_p \
 N_noxref_14_c_8113_p N_noxref_14_c_7767_n N_noxref_14_c_7771_n \
 N_noxref_14_c_7772_n N_noxref_14_c_7840_n N_noxref_14_c_7773_n \
 N_noxref_14_c_7732_n N_noxref_14_c_7854_n N_noxref_14_c_7856_n \
 N_noxref_14_c_7859_n N_noxref_14_c_7730_n N_noxref_14_c_8053_p \
 N_noxref_14_c_8176_p N_noxref_14_c_8136_p N_noxref_14_c_8054_p \
 N_noxref_14_c_7779_n N_noxref_14_c_7783_n N_noxref_14_c_7968_p \
 N_noxref_14_c_7972_p N_noxref_14_c_8073_p N_noxref_14_c_7786_n \
 N_noxref_14_c_7934_n N_noxref_14_c_7860_n N_noxref_14_c_7939_n \
 N_noxref_14_c_8133_p N_noxref_14_c_8454_p N_noxref_14_c_8178_p \
 N_noxref_14_c_8156_p N_noxref_14_c_8138_p N_noxref_14_M32_noxref_g \
 N_noxref_14_M39_noxref_g N_noxref_14_M46_noxref_g N_noxref_14_M47_noxref_g \
 N_noxref_14_M118_noxref_g N_noxref_14_M119_noxref_g N_noxref_14_M132_noxref_g \
 N_noxref_14_M133_noxref_g N_noxref_14_M146_noxref_g N_noxref_14_M147_noxref_g \
 N_noxref_14_M148_noxref_g N_noxref_14_M149_noxref_g N_noxref_14_c_7793_n \
 N_noxref_14_c_7794_n N_noxref_14_c_7795_n N_noxref_14_c_7796_n \
 N_noxref_14_c_8429_p N_noxref_14_c_8448_p N_noxref_14_c_7799_n \
 N_noxref_14_c_7801_n N_noxref_14_c_7804_n N_noxref_14_c_7807_n \
 N_noxref_14_c_8023_p N_noxref_14_c_7975_p N_noxref_14_c_7976_p \
 N_noxref_14_c_7999_p N_noxref_14_c_8025_p N_noxref_14_c_7977_p \
 N_noxref_14_c_8027_p N_noxref_14_c_7978_p N_noxref_14_c_8455_p \
 N_noxref_14_c_8456_p N_noxref_14_c_8457_p N_noxref_14_c_8487_p \
 N_noxref_14_c_8458_p N_noxref_14_c_8459_p N_noxref_14_c_8460_p \
 N_noxref_14_c_8461_p N_noxref_14_c_8186_p N_noxref_14_c_8143_p \
 N_noxref_14_c_8144_p N_noxref_14_c_8160_p N_noxref_14_c_8188_p \
 N_noxref_14_c_8145_p N_noxref_14_c_8190_p N_noxref_14_c_8146_p \
 N_noxref_14_c_7944_n N_noxref_14_c_7979_p N_noxref_14_c_7811_n \
 N_noxref_14_c_8181_p N_noxref_14_c_8157_p N_noxref_14_c_8147_p \
 N_noxref_14_c_8141_p N_noxref_14_M42_noxref_d N_noxref_14_M45_noxref_d \
 N_noxref_14_M134_noxref_d N_noxref_14_M136_noxref_d N_noxref_14_M138_noxref_d \
 N_noxref_14_M140_noxref_d N_noxref_14_M142_noxref_d N_noxref_14_M144_noxref_d \
 )  PM_TMRDFFRNQNX1\%noxref_14
x_PM_TMRDFFRNQNX1\%noxref_15 ( N_noxref_15_c_8554_n N_noxref_15_c_8552_n \
 N_noxref_15_c_8557_n N_noxref_15_c_8553_n N_noxref_15_c_8571_n \
 N_noxref_15_c_8572_n N_noxref_15_c_8653_n N_noxref_15_c_8654_n \
 N_noxref_15_c_8573_n N_noxref_15_c_8574_n N_noxref_15_c_8661_n \
 N_noxref_15_c_8576_n N_noxref_15_c_8738_n N_noxref_15_c_8698_n \
 N_noxref_15_c_8743_n N_noxref_15_c_8744_n N_noxref_15_c_8699_n \
 N_noxref_15_c_8704_n N_noxref_15_c_8963_n N_noxref_15_c_8748_n \
 N_noxref_15_c_8968_n N_noxref_15_c_8976_n N_noxref_15_c_8981_n \
 N_noxref_15_c_8855_n N_noxref_15_c_8705_n N_noxref_15_c_8856_n \
 N_noxref_15_c_8708_n N_noxref_15_c_8995_n N_noxref_15_c_8860_n \
 N_noxref_15_c_8750_n N_noxref_15_c_9090_n N_noxref_15_c_9095_n \
 N_noxref_15_c_9096_n N_noxref_15_c_8997_n N_noxref_15_c_8751_n \
 N_noxref_15_c_8862_n N_noxref_15_c_8752_n N_noxref_15_c_8754_n \
 N_noxref_15_c_8757_n N_noxref_15_c_8759_n N_noxref_15_c_8760_n \
 N_noxref_15_c_9277_p N_noxref_15_c_9120_n N_noxref_15_c_9272_p \
 N_noxref_15_c_9121_n N_noxref_15_c_9216_p N_noxref_15_c_9217_p \
 N_noxref_15_c_8578_n N_noxref_15_c_8579_n N_noxref_15_c_8670_n \
 N_noxref_15_c_9414_p N_noxref_15_c_8587_n N_noxref_15_c_8679_n \
 N_noxref_15_c_8767_n N_noxref_15_c_8768_n N_noxref_15_c_8709_n \
 N_noxref_15_c_9005_n N_noxref_15_c_9009_n N_noxref_15_c_9122_n \
 N_noxref_15_c_9010_n N_noxref_15_c_8770_n N_noxref_15_c_8771_n \
 N_noxref_15_c_8772_n N_noxref_15_c_8773_n N_noxref_15_c_9420_p \
 N_noxref_15_c_9012_n N_noxref_15_c_9144_n N_noxref_15_c_8774_n \
 N_noxref_15_c_9331_p N_noxref_15_c_9321_p N_noxref_15_c_9222_p \
 N_noxref_15_c_8588_n N_noxref_15_c_8589_n N_noxref_15_c_8593_n \
 N_noxref_15_c_8596_n N_noxref_15_c_8718_n N_noxref_15_c_8599_n \
 N_noxref_15_c_8720_n N_noxref_15_c_8721_n N_noxref_15_c_8722_n \
 N_noxref_15_c_8886_n N_noxref_15_c_8889_n N_noxref_15_c_8723_n \
 N_noxref_15_c_8893_n N_noxref_15_c_8894_n N_noxref_15_c_8896_n \
 N_noxref_15_c_8785_n N_noxref_15_c_9023_n N_noxref_15_c_9164_n \
 N_noxref_15_c_9322_p N_noxref_15_c_8600_n N_noxref_15_c_8905_n \
 N_noxref_15_c_8907_n N_noxref_15_c_9223_p N_noxref_15_c_9283_p \
 N_noxref_15_c_8601_n N_noxref_15_c_8602_n N_noxref_15_c_8606_n \
 N_noxref_15_c_8687_n N_noxref_15_c_8786_n N_noxref_15_c_8790_n \
 N_noxref_15_c_8913_n N_noxref_15_c_8725_n N_noxref_15_c_9035_n \
 N_noxref_15_c_9040_n N_noxref_15_c_9178_n N_noxref_15_c_9428_p \
 N_noxref_15_c_9181_n N_noxref_15_c_8793_n N_noxref_15_c_8797_n \
 N_noxref_15_c_9325_p N_noxref_15_c_9344_p N_noxref_15_c_9218_p \
 N_noxref_15_c_9224_p N_noxref_15_M29_noxref_g N_noxref_15_M34_noxref_g \
 N_noxref_15_M38_noxref_g N_noxref_15_M40_noxref_g N_noxref_15_M48_noxref_g \
 N_noxref_15_M50_noxref_g N_noxref_15_M112_noxref_g N_noxref_15_M113_noxref_g \
 N_noxref_15_M122_noxref_g N_noxref_15_M123_noxref_g N_noxref_15_M130_noxref_g \
 N_noxref_15_M131_noxref_g N_noxref_15_M134_noxref_g N_noxref_15_M135_noxref_g \
 N_noxref_15_M150_noxref_g N_noxref_15_M151_noxref_g N_noxref_15_M154_noxref_g \
 N_noxref_15_M155_noxref_g N_noxref_15_c_8617_n N_noxref_15_c_8619_n \
 N_noxref_15_c_8622_n N_noxref_15_c_8623_n N_noxref_15_c_8625_n \
 N_noxref_15_c_8629_n N_noxref_15_c_8631_n N_noxref_15_c_8806_n \
 N_noxref_15_c_8807_n N_noxref_15_c_8808_n N_noxref_15_c_8928_n \
 N_noxref_15_c_8930_n N_noxref_15_c_8934_n N_noxref_15_c_8936_n \
 N_noxref_15_c_9192_n N_noxref_15_c_9193_n N_noxref_15_c_9194_n \
 N_noxref_15_c_9048_n N_noxref_15_c_9701_p N_noxref_15_c_9702_p \
 N_noxref_15_c_9200_n N_noxref_15_c_9202_n N_noxref_15_c_8809_n \
 N_noxref_15_c_8810_n N_noxref_15_c_8811_n N_noxref_15_c_8812_n \
 N_noxref_15_c_9669_p N_noxref_15_c_9717_p N_noxref_15_c_8815_n \
 N_noxref_15_c_8817_n N_noxref_15_c_8820_n N_noxref_15_c_8823_n \
 N_noxref_15_c_9377_p N_noxref_15_c_9378_p N_noxref_15_c_9380_p \
 N_noxref_15_c_9383_p N_noxref_15_c_9676_p N_noxref_15_c_9677_p \
 N_noxref_15_c_9345_p N_noxref_15_c_9346_p N_noxref_15_c_9379_p \
 N_noxref_15_c_9381_p N_noxref_15_c_9296_p N_noxref_15_c_9297_p \
 N_noxref_15_c_9299_p N_noxref_15_c_9289_p N_noxref_15_c_9685_p \
 N_noxref_15_c_9686_p N_noxref_15_c_9298_p N_noxref_15_c_9300_p \
 N_noxref_15_c_8635_n N_noxref_15_c_8636_n N_noxref_15_c_8638_n \
 N_noxref_15_c_8826_n N_noxref_15_c_8829_n N_noxref_15_c_8830_n \
 N_noxref_15_c_9207_n N_noxref_15_c_9326_p N_noxref_15_c_9225_p \
 N_noxref_15_M31_noxref_d N_noxref_15_M37_noxref_d N_noxref_15_M39_noxref_d \
 N_noxref_15_M114_noxref_d N_noxref_15_M116_noxref_d N_noxref_15_M124_noxref_d \
 N_noxref_15_M126_noxref_d N_noxref_15_M128_noxref_d N_noxref_15_M130_noxref_d \
 N_noxref_15_M132_noxref_d )  PM_TMRDFFRNQNX1\%noxref_15
x_PM_TMRDFFRNQNX1\%noxref_16 ( N_noxref_16_c_9871_n N_noxref_16_c_9868_n \
 N_noxref_16_c_9874_n N_noxref_16_c_9869_n N_noxref_16_c_9890_n \
 N_noxref_16_c_9896_n N_noxref_16_c_9902_n N_noxref_16_c_9903_n \
 N_noxref_16_c_9905_n N_noxref_16_c_9906_n N_noxref_16_c_9913_n \
 N_noxref_16_c_9914_n N_noxref_16_c_10242_n N_noxref_16_c_10245_n \
 N_noxref_16_c_10246_n N_noxref_16_c_10247_n N_noxref_16_c_10346_p \
 N_noxref_16_c_10252_n N_noxref_16_c_9925_n N_noxref_16_c_9926_n \
 N_noxref_16_c_9934_n N_noxref_16_c_10451_p N_noxref_16_c_9937_n \
 N_noxref_16_c_9944_n N_noxref_16_c_10253_n N_noxref_16_c_9945_n \
 N_noxref_16_c_10009_n N_noxref_16_c_9956_n N_noxref_16_c_10014_n \
 N_noxref_16_c_10018_n N_noxref_16_c_10022_n N_noxref_16_c_10025_n \
 N_noxref_16_c_10028_n N_noxref_16_c_10029_n N_noxref_16_c_10033_n \
 N_noxref_16_c_10036_n N_noxref_16_c_10055_n N_noxref_16_c_10102_n \
 N_noxref_16_c_10103_n N_noxref_16_c_10107_n N_noxref_16_c_10139_n \
 N_noxref_16_c_10140_n N_noxref_16_c_10141_n N_noxref_16_c_10142_n \
 N_noxref_16_c_10143_n N_noxref_16_c_10144_n N_noxref_16_c_10145_n \
 N_noxref_16_c_10131_n N_noxref_16_c_10132_n N_noxref_16_c_10303_n \
 N_noxref_16_c_9957_n N_noxref_16_c_10310_n N_noxref_16_c_10347_p \
 N_noxref_16_c_10376_p N_noxref_16_c_9959_n N_noxref_16_c_9960_n \
 N_noxref_16_c_9964_n N_noxref_16_c_9970_n N_noxref_16_c_10312_n \
 N_noxref_16_c_10316_n N_noxref_16_c_10348_p N_noxref_16_c_10358_p \
 N_noxref_16_M13_noxref_g N_noxref_16_M51_noxref_g N_noxref_16_M52_noxref_g \
 N_noxref_16_M80_noxref_g N_noxref_16_M81_noxref_g N_noxref_16_M156_noxref_g \
 N_noxref_16_M157_noxref_g N_noxref_16_M158_noxref_g N_noxref_16_M159_noxref_g \
 N_noxref_16_c_9979_n N_noxref_16_c_9981_n N_noxref_16_c_9984_n \
 N_noxref_16_c_9985_n N_noxref_16_c_9987_n N_noxref_16_c_9991_n \
 N_noxref_16_c_9993_n N_noxref_16_c_10322_n N_noxref_16_c_10325_n \
 N_noxref_16_c_10546_p N_noxref_16_c_10327_n N_noxref_16_c_10413_p \
 N_noxref_16_c_10414_p N_noxref_16_c_10329_n N_noxref_16_c_10331_n \
 N_noxref_16_c_10332_n N_noxref_16_c_10333_n N_noxref_16_c_10334_n \
 N_noxref_16_c_10387_p N_noxref_16_c_10388_p N_noxref_16_c_10390_p \
 N_noxref_16_c_10393_p N_noxref_16_c_10563_p N_noxref_16_c_10564_p \
 N_noxref_16_c_10359_p N_noxref_16_c_10360_p N_noxref_16_c_10389_p \
 N_noxref_16_c_10391_p N_noxref_16_c_9997_n N_noxref_16_c_9998_n \
 N_noxref_16_c_10000_n N_noxref_16_c_10349_p N_noxref_16_M15_noxref_d \
 N_noxref_16_M82_noxref_d N_noxref_16_M84_noxref_d )  PM_TMRDFFRNQNX1\%noxref_16
x_PM_TMRDFFRNQNX1\%noxref_17 ( N_noxref_17_c_10673_n N_noxref_17_c_10669_n \
 N_noxref_17_c_10680_n N_noxref_17_c_10670_n N_noxref_17_c_10726_n \
 N_noxref_17_c_10734_n N_noxref_17_c_10740_n N_noxref_17_c_10741_n \
 N_noxref_17_c_10743_n N_noxref_17_c_10744_n N_noxref_17_c_10751_n \
 N_noxref_17_c_10753_n N_noxref_17_c_10864_n N_noxref_17_c_10868_n \
 N_noxref_17_c_10875_n N_noxref_17_c_10878_n N_noxref_17_c_10945_n \
 N_noxref_17_c_10949_n N_noxref_17_c_10954_n N_noxref_17_c_10955_n \
 N_noxref_17_c_10671_n N_noxref_17_c_10764_n N_noxref_17_c_10774_n \
 N_noxref_17_c_11078_p N_noxref_17_c_10777_n N_noxref_17_c_10784_n \
 N_noxref_17_c_10889_n N_noxref_17_c_10961_n N_noxref_17_c_10785_n \
 N_noxref_17_c_10795_n N_noxref_17_c_10891_n N_noxref_17_c_10798_n \
 N_noxref_17_c_10900_n N_noxref_17_c_10672_n N_noxref_17_c_10966_n \
 N_noxref_17_c_10904_n N_noxref_17_c_10687_n N_noxref_17_c_10690_n \
 N_noxref_17_c_10806_n N_noxref_17_c_10812_n N_noxref_17_c_10908_n \
 N_noxref_17_c_10912_n N_noxref_17_c_10976_n N_noxref_17_c_10979_n \
 N_noxref_17_M45_noxref_g N_noxref_17_M49_noxref_g N_noxref_17_M53_noxref_g \
 N_noxref_17_M144_noxref_g N_noxref_17_M145_noxref_g N_noxref_17_M152_noxref_g \
 N_noxref_17_M153_noxref_g N_noxref_17_M160_noxref_g N_noxref_17_M161_noxref_g \
 N_noxref_17_c_10697_n N_noxref_17_c_10698_n N_noxref_17_c_10699_n \
 N_noxref_17_c_10827_n N_noxref_17_c_10829_n N_noxref_17_c_10833_n \
 N_noxref_17_c_10835_n N_noxref_17_c_10918_n N_noxref_17_c_10921_n \
 N_noxref_17_c_10923_n N_noxref_17_c_11119_p N_noxref_17_c_11042_p \
 N_noxref_17_c_11043_p N_noxref_17_c_10926_n N_noxref_17_c_10927_n \
 N_noxref_17_c_10986_n N_noxref_17_c_10989_n N_noxref_17_c_10991_n \
 N_noxref_17_c_11012_p N_noxref_17_c_11027_p N_noxref_17_c_10994_n \
 N_noxref_17_c_10995_n N_noxref_17_c_10996_n N_noxref_17_c_10700_n \
 N_noxref_17_c_10703_n N_noxref_17_c_10704_n N_noxref_17_c_10928_n \
 N_noxref_17_c_11237_p N_noxref_17_c_10931_n N_noxref_17_c_10997_n \
 N_noxref_17_c_11036_p N_noxref_17_c_11000_n N_noxref_17_M47_noxref_d \
 N_noxref_17_M146_noxref_d N_noxref_17_M148_noxref_d )  \
 PM_TMRDFFRNQNX1\%noxref_17
x_PM_TMRDFFRNQNX1\%QN ( QN QN QN QN QN QN QN QN N_QN_c_11258_n N_QN_c_11315_n \
 N_QN_c_11325_n N_QN_c_11327_n N_QN_c_11328_n N_QN_c_11329_n N_QN_c_11259_n \
 N_QN_c_11260_n N_QN_c_11268_n N_QN_c_11340_n N_QN_c_11271_n N_QN_c_11251_n \
 N_QN_c_11274_n N_QN_c_11345_n N_QN_c_11275_n N_QN_c_11287_n N_QN_c_11350_n \
 N_QN_M49_noxref_d N_QN_M51_noxref_d N_QN_M53_noxref_d N_QN_M158_noxref_d \
 N_QN_M160_noxref_d )  PM_TMRDFFRNQNX1\%QN
x_PM_TMRDFFRNQNX1\%VDD ( VDD N_VDD_c_11464_n N_VDD_c_12457_n N_VDD_c_12458_n \
 N_VDD_c_12743_p N_VDD_c_12459_n N_VDD_c_12460_n N_VDD_c_12745_p \
 N_VDD_c_12674_n N_VDD_c_12675_n N_VDD_c_12735_n N_VDD_c_11585_n \
 N_VDD_c_11587_n N_VDD_c_11590_n N_VDD_c_11477_n N_VDD_c_11598_n \
 N_VDD_c_11479_n N_VDD_c_11482_n N_VDD_c_11486_n N_VDD_c_11490_n \
 N_VDD_c_11491_n N_VDD_c_11535_n N_VDD_c_11540_n N_VDD_c_11677_n \
 N_VDD_c_11681_n N_VDD_c_11685_n N_VDD_c_11601_n N_VDD_c_11689_n \
 N_VDD_c_11693_n N_VDD_c_11697_n N_VDD_c_11699_n N_VDD_c_11702_n \
 N_VDD_c_11904_n N_VDD_c_11907_n N_VDD_c_11796_n N_VDD_c_11915_n \
 N_VDD_c_11798_n N_VDD_c_11801_n N_VDD_c_11805_n N_VDD_c_11809_n \
 N_VDD_c_11810_n N_VDD_c_11854_n N_VDD_c_11859_n N_VDD_c_12031_n \
 N_VDD_c_12035_n N_VDD_c_12039_n N_VDD_c_11918_n N_VDD_c_11974_n \
 N_VDD_c_11978_n N_VDD_c_11982_n N_VDD_c_11983_n N_VDD_c_12040_n \
 N_VDD_c_12177_n N_VDD_c_12117_n N_VDD_c_12184_n N_VDD_c_12188_n \
 N_VDD_c_12189_n N_VDD_c_12101_n N_VDD_c_12243_n N_VDD_c_12484_n \
 N_VDD_c_12485_n N_VDD_c_12308_n N_VDD_c_12310_n N_VDD_c_12119_n \
 N_VDD_c_12245_n N_VDD_c_12321_n N_VDD_c_12191_n N_VDD_c_12247_n \
 N_VDD_c_12329_n N_VDD_c_12333_n N_VDD_c_12335_n N_VDD_c_12338_n \
 N_VDD_c_12498_n N_VDD_c_12501_n N_VDD_c_12628_n N_VDD_c_11494_n \
 N_VDD_c_11498_n N_VDD_c_11545_n N_VDD_c_11609_n N_VDD_c_11723_n \
 N_VDD_c_11735_n N_VDD_c_11813_n N_VDD_c_11817_n N_VDD_c_11864_n \
 N_VDD_c_11928_n N_VDD_c_11988_n N_VDD_c_12066_n N_VDD_c_12135_n \
 N_VDD_c_12136_n N_VDD_c_12137_n N_VDD_c_12201_n N_VDD_c_12364_n \
 N_VDD_c_12376_n N_VDD_c_12540_n N_VDD_c_12546_n N_VDD_M54_noxref_s \
 N_VDD_M55_noxref_d N_VDD_M57_noxref_d N_VDD_M59_noxref_d N_VDD_M60_noxref_s \
 N_VDD_M61_noxref_d N_VDD_M63_noxref_d N_VDD_M65_noxref_d N_VDD_M66_noxref_s \
 N_VDD_M67_noxref_d N_VDD_M69_noxref_d N_VDD_M70_noxref_s N_VDD_M71_noxref_d \
 N_VDD_M73_noxref_d N_VDD_M75_noxref_d N_VDD_M76_noxref_s N_VDD_M77_noxref_d \
 N_VDD_M79_noxref_d N_VDD_M81_noxref_d N_VDD_M82_noxref_s N_VDD_M83_noxref_d \
 N_VDD_M85_noxref_d N_VDD_M86_noxref_s N_VDD_M87_noxref_d N_VDD_M89_noxref_d \
 N_VDD_M91_noxref_d N_VDD_M92_noxref_s N_VDD_M93_noxref_d N_VDD_M95_noxref_d \
 N_VDD_M97_noxref_d N_VDD_M98_noxref_s N_VDD_M99_noxref_d N_VDD_M101_noxref_d \
 N_VDD_M102_noxref_s N_VDD_M103_noxref_d N_VDD_M105_noxref_d \
 N_VDD_M107_noxref_d N_VDD_M108_noxref_s N_VDD_M109_noxref_d \
 N_VDD_M111_noxref_d N_VDD_M113_noxref_d N_VDD_M114_noxref_s \
 N_VDD_M115_noxref_d N_VDD_M117_noxref_d N_VDD_M118_noxref_s \
 N_VDD_M119_noxref_d N_VDD_M121_noxref_d N_VDD_M123_noxref_d \
 N_VDD_M124_noxref_s N_VDD_M125_noxref_d N_VDD_M127_noxref_d \
 N_VDD_M129_noxref_d N_VDD_M130_noxref_s N_VDD_M131_noxref_d \
 N_VDD_M133_noxref_d N_VDD_M134_noxref_s N_VDD_M135_noxref_d \
 N_VDD_M137_noxref_d N_VDD_M139_noxref_d N_VDD_M140_noxref_s \
 N_VDD_M141_noxref_d N_VDD_M143_noxref_d N_VDD_M145_noxref_d \
 N_VDD_M146_noxref_s N_VDD_M147_noxref_d N_VDD_M149_noxref_d \
 N_VDD_M150_noxref_s N_VDD_M151_noxref_d N_VDD_M153_noxref_d )  \
 PM_TMRDFFRNQNX1\%VDD
x_PM_TMRDFFRNQNX1\%noxref_20 ( N_noxref_20_c_12882_n N_noxref_20_c_12898_p \
 N_noxref_20_c_12860_n N_noxref_20_c_12900_p N_noxref_20_c_12865_n \
 N_noxref_20_M1_noxref_d N_noxref_20_M2_noxref_s )  PM_TMRDFFRNQNX1\%noxref_20
x_PM_TMRDFFRNQNX1\%noxref_21 ( N_noxref_21_c_12936_n N_noxref_21_c_12967_p \
 N_noxref_21_c_12923_n N_noxref_21_c_12969_p N_noxref_21_c_12926_n \
 N_noxref_21_M4_noxref_d N_noxref_21_M5_noxref_s )  PM_TMRDFFRNQNX1\%noxref_21
x_PM_TMRDFFRNQNX1\%noxref_22 ( N_noxref_22_c_13004_n N_noxref_22_c_13034_p \
 N_noxref_22_c_12993_n N_noxref_22_c_13036_p N_noxref_22_c_12996_n \
 N_noxref_22_M9_noxref_d N_noxref_22_M10_noxref_s )  PM_TMRDFFRNQNX1\%noxref_22
x_PM_TMRDFFRNQNX1\%noxref_23 ( N_noxref_23_c_13071_n N_noxref_23_c_13103_p \
 N_noxref_23_c_13059_n N_noxref_23_c_13105_p N_noxref_23_c_13062_n \
 N_noxref_23_M12_noxref_d N_noxref_23_M13_noxref_s )  PM_TMRDFFRNQNX1\%noxref_23
x_PM_TMRDFFRNQNX1\%noxref_24 ( N_noxref_24_c_13149_n N_noxref_24_c_13170_p \
 N_noxref_24_c_13128_n N_noxref_24_c_13172_p N_noxref_24_c_13133_n \
 N_noxref_24_M17_noxref_d N_noxref_24_M18_noxref_s )  PM_TMRDFFRNQNX1\%noxref_24
x_PM_TMRDFFRNQNX1\%noxref_25 ( N_noxref_25_c_13207_n N_noxref_25_c_13238_p \
 N_noxref_25_c_13195_n N_noxref_25_c_13240_p N_noxref_25_c_13198_n \
 N_noxref_25_M20_noxref_d N_noxref_25_M21_noxref_s )  PM_TMRDFFRNQNX1\%noxref_25
x_PM_TMRDFFRNQNX1\%noxref_26 ( N_noxref_26_c_13275_n N_noxref_26_c_13305_p \
 N_noxref_26_c_13264_n N_noxref_26_c_13307_p N_noxref_26_c_13267_n \
 N_noxref_26_M25_noxref_d N_noxref_26_M26_noxref_s )  PM_TMRDFFRNQNX1\%noxref_26
x_PM_TMRDFFRNQNX1\%noxref_27 ( N_noxref_27_c_13342_n N_noxref_27_c_13373_p \
 N_noxref_27_c_13330_n N_noxref_27_c_13375_p N_noxref_27_c_13333_n \
 N_noxref_27_M28_noxref_d N_noxref_27_M29_noxref_s )  PM_TMRDFFRNQNX1\%noxref_27
x_PM_TMRDFFRNQNX1\%noxref_28 ( N_noxref_28_c_13398_n N_noxref_28_c_13440_p \
 N_noxref_28_c_13413_n N_noxref_28_c_13442_p N_noxref_28_c_13416_n \
 N_noxref_28_M33_noxref_d N_noxref_28_M34_noxref_s )  PM_TMRDFFRNQNX1\%noxref_28
x_PM_TMRDFFRNQNX1\%noxref_29 ( N_noxref_29_c_13465_n N_noxref_29_c_13508_p \
 N_noxref_29_c_13483_n N_noxref_29_c_13510_p N_noxref_29_c_13488_n \
 N_noxref_29_M36_noxref_d N_noxref_29_M37_noxref_s )  PM_TMRDFFRNQNX1\%noxref_29
x_PM_TMRDFFRNQNX1\%noxref_30 ( N_noxref_30_c_13533_n N_noxref_30_c_13575_p \
 N_noxref_30_c_13549_n N_noxref_30_c_13577_p N_noxref_30_c_13554_n \
 N_noxref_30_M41_noxref_d N_noxref_30_M42_noxref_s )  PM_TMRDFFRNQNX1\%noxref_30
x_PM_TMRDFFRNQNX1\%noxref_31 ( N_noxref_31_c_13600_n N_noxref_31_c_13643_p \
 N_noxref_31_c_13617_n N_noxref_31_c_13645_p N_noxref_31_c_13620_n \
 N_noxref_31_M44_noxref_d N_noxref_31_M45_noxref_s )  PM_TMRDFFRNQNX1\%noxref_31
x_PM_TMRDFFRNQNX1\%noxref_32 ( N_noxref_32_c_13668_n N_noxref_32_c_13670_n \
 N_noxref_32_c_13673_n N_noxref_32_c_13674_n N_noxref_32_c_13696_n \
 N_noxref_32_c_13680_n N_noxref_32_c_13684_n N_noxref_32_c_13685_n \
 N_noxref_32_c_13699_n N_noxref_32_c_13686_n N_noxref_32_c_13689_n \
 N_noxref_32_c_13690_n N_noxref_32_M150_noxref_d N_noxref_32_M152_noxref_d \
 N_noxref_32_M154_noxref_s N_noxref_32_M155_noxref_d N_noxref_32_M157_noxref_d \
 )  PM_TMRDFFRNQNX1\%noxref_32
x_PM_TMRDFFRNQNX1\%noxref_33 ( N_noxref_33_c_13828_n N_noxref_33_c_13841_n \
 N_noxref_33_c_13852_n N_noxref_33_c_13854_n N_noxref_33_c_13868_n \
 N_noxref_33_c_13829_n N_noxref_33_c_13856_n N_noxref_33_c_13857_n \
 N_noxref_33_c_13872_n N_noxref_33_c_13835_n N_noxref_33_c_13858_n \
 N_noxref_33_c_13861_n N_noxref_33_M154_noxref_d N_noxref_33_M156_noxref_d \
 N_noxref_33_M158_noxref_s N_noxref_33_M159_noxref_d N_noxref_33_M161_noxref_d \
 )  PM_TMRDFFRNQNX1\%noxref_33
x_PM_TMRDFFRNQNX1\%GND ( GND N_GND_c_15106_p N_GND_c_14094_n N_GND_c_13951_n \
 N_GND_c_14037_n N_GND_c_13952_n N_GND_c_13992_n N_GND_c_13996_n \
 N_GND_c_14098_n N_GND_c_14040_n N_GND_c_14101_n N_GND_c_14105_n \
 N_GND_c_14343_n N_GND_c_14171_n N_GND_c_14254_n N_GND_c_14172_n \
 N_GND_c_14210_n N_GND_c_14214_n N_GND_c_14347_n N_GND_c_14257_n \
 N_GND_c_14310_n N_GND_c_14350_n N_GND_c_14567_n N_GND_c_14416_n \
 N_GND_c_14422_n N_GND_c_14392_n N_GND_c_14511_n N_GND_c_14656_n \
 N_GND_c_14417_n N_GND_c_14425_n N_GND_c_14516_n N_GND_c_14578_n \
 N_GND_c_14661_n N_GND_c_14853_n N_GND_c_14668_n N_GND_c_14788_n \
 N_GND_c_14791_n N_GND_c_14854_n N_GND_c_14106_n N_GND_c_13956_n \
 N_GND_c_13957_n N_GND_c_13967_n N_GND_c_14002_n N_GND_c_14054_n \
 N_GND_c_14117_n N_GND_c_14128_n N_GND_c_14351_n N_GND_c_14260_n \
 N_GND_c_14176_n N_GND_c_14186_n N_GND_c_14220_n N_GND_c_14271_n \
 N_GND_c_14314_n N_GND_c_14324_n N_GND_c_14529_n N_GND_c_14428_n \
 N_GND_c_14531_n N_GND_c_14694_n N_GND_c_14532_n N_GND_c_14439_n \
 N_GND_c_14591_n N_GND_c_14601_n N_GND_c_13970_n N_GND_c_14132_n \
 N_GND_c_13971_n N_GND_c_13973_n N_GND_c_14015_n N_GND_c_14066_n \
 N_GND_c_14140_n N_GND_c_14189_n N_GND_c_14190_n N_GND_c_14192_n \
 N_GND_c_14233_n N_GND_c_14283_n N_GND_c_14328_n N_GND_c_14449_n \
 N_GND_c_14450_n N_GND_c_14605_n N_GND_c_14606_n N_GND_c_14451_n \
 N_GND_c_14608_n N_GND_c_14717_n N_GND_c_14719_n N_GND_c_14806_n \
 N_GND_c_13974_n N_GND_c_13977_n N_GND_c_14017_n N_GND_c_14074_n \
 N_GND_c_14147_n N_GND_c_14154_n N_GND_c_14193_n N_GND_c_14196_n \
 N_GND_c_14235_n N_GND_c_14291_n N_GND_c_14329_n N_GND_c_14376_n \
 N_GND_c_14409_n N_GND_c_14411_n N_GND_c_14562_n N_GND_c_14459_n \
 N_GND_c_14620_n N_GND_c_14627_n N_GND_c_14750_n N_GND_c_14831_n \
 N_GND_M0_noxref_d N_GND_M3_noxref_d N_GND_M6_noxref_d N_GND_M8_noxref_d \
 N_GND_M11_noxref_d N_GND_M14_noxref_d N_GND_M16_noxref_d N_GND_M19_noxref_d \
 N_GND_M22_noxref_d N_GND_M24_noxref_d N_GND_M27_noxref_d N_GND_M30_noxref_d \
 N_GND_M32_noxref_d N_GND_M35_noxref_d N_GND_M38_noxref_d N_GND_M40_noxref_d \
 N_GND_M43_noxref_d N_GND_M46_noxref_d N_GND_M48_noxref_d N_GND_M50_noxref_d \
 N_GND_M52_noxref_d )  PM_TMRDFFRNQNX1\%GND
x_PM_TMRDFFRNQNX1\%noxref_35 ( N_noxref_35_c_15535_n N_noxref_35_c_15536_n \
 N_noxref_35_c_15560_n N_noxref_35_c_15550_n N_noxref_35_c_15544_n \
 N_noxref_35_M0_noxref_s )  PM_TMRDFFRNQNX1\%noxref_35
x_PM_TMRDFFRNQNX1\%noxref_36 ( N_noxref_36_c_15589_n N_noxref_36_c_15590_n \
 N_noxref_36_c_15620_n N_noxref_36_c_15606_n N_noxref_36_c_15592_n \
 N_noxref_36_M3_noxref_s )  PM_TMRDFFRNQNX1\%noxref_36
x_PM_TMRDFFRNQNX1\%noxref_37 ( N_noxref_37_c_15649_n N_noxref_37_c_15650_n \
 N_noxref_37_c_15695_n N_noxref_37_c_15657_n N_noxref_37_c_15662_n \
 N_noxref_37_c_15703_n N_noxref_37_M6_noxref_s )  PM_TMRDFFRNQNX1\%noxref_37
x_PM_TMRDFFRNQNX1\%noxref_38 ( N_noxref_38_c_15716_n N_noxref_38_c_15717_n \
 N_noxref_38_c_15742_n N_noxref_38_c_15728_n N_noxref_38_c_15730_n \
 N_noxref_38_M8_noxref_s )  PM_TMRDFFRNQNX1\%noxref_38
x_PM_TMRDFFRNQNX1\%noxref_39 ( N_noxref_39_c_15774_n N_noxref_39_c_15775_n \
 N_noxref_39_c_15803_n N_noxref_39_c_15788_n N_noxref_39_c_15790_n \
 N_noxref_39_M11_noxref_s )  PM_TMRDFFRNQNX1\%noxref_39
x_PM_TMRDFFRNQNX1\%noxref_40 ( N_noxref_40_c_15832_n N_noxref_40_c_15833_n \
 N_noxref_40_c_15878_n N_noxref_40_c_15840_n N_noxref_40_c_15845_n \
 N_noxref_40_c_15886_n N_noxref_40_M14_noxref_s )  PM_TMRDFFRNQNX1\%noxref_40
x_PM_TMRDFFRNQNX1\%noxref_41 ( N_noxref_41_c_15899_n N_noxref_41_c_15900_n \
 N_noxref_41_c_15925_n N_noxref_41_c_15911_n N_noxref_41_c_15913_n \
 N_noxref_41_M16_noxref_s )  PM_TMRDFFRNQNX1\%noxref_41
x_PM_TMRDFFRNQNX1\%noxref_42 ( N_noxref_42_c_15957_n N_noxref_42_c_15958_n \
 N_noxref_42_c_15988_n N_noxref_42_c_15969_n N_noxref_42_c_15971_n \
 N_noxref_42_M19_noxref_s )  PM_TMRDFFRNQNX1\%noxref_42
x_PM_TMRDFFRNQNX1\%noxref_43 ( N_noxref_43_c_16017_n N_noxref_43_c_16018_n \
 N_noxref_43_c_16063_n N_noxref_43_c_16025_n N_noxref_43_c_16030_n \
 N_noxref_43_c_16071_n N_noxref_43_M22_noxref_s )  PM_TMRDFFRNQNX1\%noxref_43
x_PM_TMRDFFRNQNX1\%noxref_44 ( N_noxref_44_c_16084_n N_noxref_44_c_16085_n \
 N_noxref_44_c_16110_n N_noxref_44_c_16096_n N_noxref_44_c_16098_n \
 N_noxref_44_M24_noxref_s )  PM_TMRDFFRNQNX1\%noxref_44
x_PM_TMRDFFRNQNX1\%noxref_45 ( N_noxref_45_c_16142_n N_noxref_45_c_16143_n \
 N_noxref_45_c_16171_n N_noxref_45_c_16156_n N_noxref_45_c_16158_n \
 N_noxref_45_M27_noxref_s )  PM_TMRDFFRNQNX1\%noxref_45
x_PM_TMRDFFRNQNX1\%noxref_46 ( N_noxref_46_c_16200_n N_noxref_46_c_16201_n \
 N_noxref_46_c_16246_n N_noxref_46_c_16208_n N_noxref_46_c_16216_n \
 N_noxref_46_c_16254_n N_noxref_46_M30_noxref_s )  PM_TMRDFFRNQNX1\%noxref_46
x_PM_TMRDFFRNQNX1\%noxref_47 ( N_noxref_47_c_16277_n N_noxref_47_c_16278_n \
 N_noxref_47_c_16293_n N_noxref_47_c_16267_n N_noxref_47_c_16269_n \
 N_noxref_47_M32_noxref_s )  PM_TMRDFFRNQNX1\%noxref_47
x_PM_TMRDFFRNQNX1\%noxref_48 ( N_noxref_48_c_16336_n N_noxref_48_c_16337_n \
 N_noxref_48_c_16356_n N_noxref_48_c_16325_n N_noxref_48_c_16327_n \
 N_noxref_48_M35_noxref_s )  PM_TMRDFFRNQNX1\%noxref_48
x_PM_TMRDFFRNQNX1\%noxref_49 ( N_noxref_49_c_16385_n N_noxref_49_c_16386_n \
 N_noxref_49_c_16431_n N_noxref_49_c_16387_n N_noxref_49_c_16388_n \
 N_noxref_49_c_16439_n N_noxref_49_M38_noxref_s )  PM_TMRDFFRNQNX1\%noxref_49
x_PM_TMRDFFRNQNX1\%noxref_50 ( N_noxref_50_c_16462_n N_noxref_50_c_16463_n \
 N_noxref_50_c_16478_n N_noxref_50_c_16452_n N_noxref_50_c_16454_n \
 N_noxref_50_M40_noxref_s )  PM_TMRDFFRNQNX1\%noxref_50
x_PM_TMRDFFRNQNX1\%noxref_51 ( N_noxref_51_c_16510_n N_noxref_51_c_16511_n \
 N_noxref_51_c_16539_n N_noxref_51_c_16524_n N_noxref_51_c_16526_n \
 N_noxref_51_M43_noxref_s )  PM_TMRDFFRNQNX1\%noxref_51
x_PM_TMRDFFRNQNX1\%noxref_52 ( N_noxref_52_c_16568_n N_noxref_52_c_16569_n \
 N_noxref_52_c_16614_n N_noxref_52_c_16576_n N_noxref_52_c_16581_n \
 N_noxref_52_c_16622_n N_noxref_52_M46_noxref_s )  PM_TMRDFFRNQNX1\%noxref_52
x_PM_TMRDFFRNQNX1\%noxref_53 ( N_noxref_53_c_16635_n N_noxref_53_c_16639_n \
 N_noxref_53_c_16682_n N_noxref_53_c_16648_n N_noxref_53_c_16655_n \
 N_noxref_53_c_16690_n N_noxref_53_M48_noxref_s )  PM_TMRDFFRNQNX1\%noxref_53
x_PM_TMRDFFRNQNX1\%noxref_54 ( N_noxref_54_c_16704_n N_noxref_54_c_16705_n \
 N_noxref_54_c_16746_n N_noxref_54_c_16712_n N_noxref_54_c_16720_n \
 N_noxref_54_c_16754_n N_noxref_54_M50_noxref_s )  PM_TMRDFFRNQNX1\%noxref_54
x_PM_TMRDFFRNQNX1\%noxref_55 ( N_noxref_55_c_16767_n N_noxref_55_c_16771_n \
 N_noxref_55_c_16813_n N_noxref_55_c_16778_n N_noxref_55_c_16787_n \
 N_noxref_55_c_16820_n N_noxref_55_M52_noxref_s )  PM_TMRDFFRNQNX1\%noxref_55
cc_1 ( N_noxref_1_M67_noxref_g N_noxref_2_c_440_n ) capacitor c=0.00889217f \
 //x=11.56 //y=6.2 //x2=12.105 //y2=5.38
cc_2 ( N_noxref_1_c_2_p N_noxref_2_c_441_n ) capacitor c=0.00326079f //x=8.885 \
 //y=1.76 //x2=12.26 //y2=1.75
cc_3 ( N_noxref_1_c_3_p N_noxref_2_c_442_n ) capacitor c=0.00218808f //x=9.285 \
 //y=1.845 //x2=12.345 //y2=1.835
cc_4 ( N_noxref_1_c_3_p N_noxref_2_c_443_n ) capacitor c=0.00203766f //x=9.285 \
 //y=1.845 //x2=12.7 //y2=3.355
cc_5 ( N_noxref_1_c_5_p N_noxref_2_c_443_n ) capacitor c=0.001997f //x=11.22 \
 //y=3.35 //x2=12.7 //y2=3.355
cc_6 ( N_noxref_1_c_6_p N_noxref_2_c_445_n ) capacitor c=0.0028534f //x=9.37 \
 //y=5.25 //x2=12.7 //y2=5.295
cc_7 ( N_noxref_1_c_7_p N_noxref_2_c_445_n ) capacitor c=0.00196578f \
 //x=11.222 //y=4.74 //x2=12.7 //y2=5.295
cc_8 ( N_noxref_1_c_8_p N_noxref_2_c_447_n ) capacitor c=5.58535e-19 //x=8.59 \
 //y=5.56 //x2=11.34 //y2=5.56
cc_9 ( N_noxref_1_c_9_p N_noxref_2_c_447_n ) capacitor c=0.00104762f //x=9.285 \
 //y=5.335 //x2=11.34 //y2=5.56
cc_10 ( N_noxref_1_c_10_p N_noxref_2_c_447_n ) capacitor c=6.37679e-19 \
 //x=11.22 //y=3.67 //x2=11.34 //y2=5.56
cc_11 ( N_noxref_1_c_11_p N_noxref_2_c_447_n ) capacitor c=0.0117744f \
 //x=11.22 //y=4.88 //x2=11.34 //y2=5.56
cc_12 ( N_noxref_1_c_12_p N_noxref_2_c_447_n ) capacitor c=0.00277154f \
 //x=11.22 //y=4.88 //x2=11.34 //y2=5.56
cc_13 ( N_noxref_1_M66_noxref_g N_noxref_2_c_447_n ) capacitor c=0.00201806f \
 //x=11.12 //y=6.2 //x2=11.34 //y2=5.56
cc_14 ( N_noxref_1_M67_noxref_g N_noxref_2_c_447_n ) capacitor c=0.00192712f \
 //x=11.56 //y=6.2 //x2=11.34 //y2=5.56
cc_15 ( N_noxref_1_c_15_p N_noxref_2_c_447_n ) capacitor c=0.00192702f \
 //x=11.22 //y=4.88 //x2=11.34 //y2=5.56
cc_16 ( N_noxref_1_c_16_p N_noxref_2_c_455_n ) capacitor c=6.5615e-19 \
 //x=8.885 //y=1.305 //x2=12.26 //y2=1.18
cc_17 ( N_noxref_1_c_17_p N_noxref_2_c_456_n ) capacitor c=0.00251357f \
 //x=11.22 //y=3.51 //x2=12.7 //y2=3.51
cc_18 ( N_noxref_1_c_18_p N_noxref_2_c_457_n ) capacitor c=0.00529185f \
 //x=11.22 //y=3.51 //x2=12.86 //y2=3.515
cc_19 ( N_noxref_1_c_11_p N_noxref_2_c_458_n ) capacitor c=0.00104426f \
 //x=11.22 //y=4.88 //x2=11.34 //y2=5.56
cc_20 ( N_noxref_1_c_12_p N_noxref_2_c_458_n ) capacitor c=0.00377369f \
 //x=11.22 //y=4.88 //x2=11.34 //y2=5.56
cc_21 ( N_noxref_1_M66_noxref_g N_noxref_2_c_458_n ) capacitor c=0.0158358f \
 //x=11.12 //y=6.2 //x2=11.34 //y2=5.56
cc_22 ( N_noxref_1_M67_noxref_g N_noxref_2_c_458_n ) capacitor c=0.0178987f \
 //x=11.56 //y=6.2 //x2=11.34 //y2=5.56
cc_23 ( N_noxref_1_c_15_p N_noxref_2_c_458_n ) capacitor c=0.0043218f \
 //x=11.22 //y=4.88 //x2=11.34 //y2=5.56
cc_24 ( N_noxref_1_c_24_p N_noxref_3_c_717_n ) capacitor c=7.46501e-19 \
 //x=3.82 //y=3.67 //x2=3.665 //y2=5.335
cc_25 ( N_noxref_1_M58_noxref_g N_noxref_3_c_717_n ) capacitor c=0.00955829f \
 //x=3.56 //y=6.2 //x2=3.665 //y2=5.335
cc_26 ( N_noxref_1_c_26_p N_noxref_3_c_719_n ) capacitor c=6.09703e-19 \
 //x=6.832 //y=5.335 //x2=3.78 //y2=5.56
cc_27 ( N_noxref_1_M58_noxref_g N_noxref_3_c_719_n ) capacitor c=0.00226521f \
 //x=3.56 //y=6.2 //x2=3.78 //y2=5.56
cc_28 ( N_noxref_1_M59_noxref_g N_noxref_3_c_719_n ) capacitor c=0.00381703f \
 //x=4 //y=6.2 //x2=3.78 //y2=5.56
cc_29 ( N_noxref_1_c_24_p N_noxref_3_c_722_n ) capacitor c=0.00109666f \
 //x=3.82 //y=3.67 //x2=4.475 //y2=5.335
cc_30 ( N_noxref_1_c_30_p N_noxref_3_c_722_n ) capacitor c=0.00228791f \
 //x=3.82 //y=4.75 //x2=4.475 //y2=5.335
cc_31 ( N_noxref_1_c_26_p N_noxref_3_c_722_n ) capacitor c=0.00306432f \
 //x=6.832 //y=5.335 //x2=4.475 //y2=5.335
cc_32 ( N_noxref_1_c_32_p N_noxref_3_c_722_n ) capacitor c=0.00130631f \
 //x=3.82 //y=4.88 //x2=4.475 //y2=5.335
cc_33 ( N_noxref_1_M59_noxref_g N_noxref_3_c_722_n ) capacitor c=0.0110526f \
 //x=4 //y=6.2 //x2=4.475 //y2=5.335
cc_34 ( N_noxref_1_c_24_p N_noxref_3_c_727_n ) capacitor c=2.40405e-19 \
 //x=3.82 //y=3.67 //x2=4.075 //y2=1.305
cc_35 ( N_noxref_1_c_35_p N_noxref_3_c_727_n ) capacitor c=4.64015e-19 \
 //x=3.81 //y=1.095 //x2=4.075 //y2=1.305
cc_36 ( N_noxref_1_c_36_p N_noxref_3_c_727_n ) capacitor c=0.0026012f //x=3.81 \
 //y=1.44 //x2=4.075 //y2=1.305
cc_37 ( N_noxref_1_c_37_p N_noxref_3_c_727_n ) capacitor c=5.29969e-19 \
 //x=4.185 //y=0.94 //x2=4.075 //y2=1.305
cc_38 ( N_noxref_1_c_38_p N_noxref_3_c_727_n ) capacitor c=5.01408e-19 \
 //x=4.185 //y=1.595 //x2=4.075 //y2=1.305
cc_39 ( N_noxref_1_c_39_p N_noxref_3_c_727_n ) capacitor c=5.24634e-19 \
 //x=4.34 //y=1.095 //x2=4.075 //y2=1.305
cc_40 ( N_noxref_1_c_40_p N_noxref_3_c_727_n ) capacitor c=0.00307978f \
 //x=4.34 //y=1.44 //x2=4.075 //y2=1.305
cc_41 ( N_noxref_1_c_36_p N_noxref_3_c_734_n ) capacitor c=0.00127432f \
 //x=3.81 //y=1.44 //x2=4.075 //y2=1.76
cc_42 ( N_noxref_1_c_42_p N_noxref_3_c_734_n ) capacitor c=0.00429966f \
 //x=3.81 //y=1.75 //x2=4.075 //y2=1.76
cc_43 ( N_noxref_1_c_38_p N_noxref_3_c_734_n ) capacitor c=0.00942306f \
 //x=4.185 //y=1.595 //x2=4.075 //y2=1.76
cc_44 ( N_noxref_1_c_40_p N_noxref_3_c_734_n ) capacitor c=0.00363411f \
 //x=4.34 //y=1.44 //x2=4.075 //y2=1.76
cc_45 ( N_noxref_1_c_45_p N_noxref_3_c_734_n ) capacitor c=0.00372124f \
 //x=3.82 //y=2.095 //x2=4.075 //y2=1.76
cc_46 ( N_noxref_1_c_46_p N_noxref_3_c_739_n ) capacitor c=0.00163399f \
 //x=8.97 //y=1.845 //x2=4.475 //y2=1.845
cc_47 ( N_noxref_1_c_47_p N_noxref_3_c_739_n ) capacitor c=0.0033552f //x=4.18 \
 //y=3.51 //x2=4.475 //y2=1.845
cc_48 ( N_noxref_1_c_38_p N_noxref_3_c_739_n ) capacitor c=0.00194716f \
 //x=4.185 //y=1.595 //x2=4.475 //y2=1.845
cc_49 ( N_noxref_1_c_40_p N_noxref_3_c_739_n ) capacitor c=0.00323576f \
 //x=4.34 //y=1.44 //x2=4.475 //y2=1.845
cc_50 ( N_noxref_1_c_24_p N_noxref_3_c_743_n ) capacitor c=0.00112398f \
 //x=3.82 //y=3.67 //x2=4.16 //y2=1.845
cc_51 ( N_noxref_1_c_47_p N_noxref_3_c_743_n ) capacitor c=0.00430279f \
 //x=4.18 //y=3.51 //x2=4.16 //y2=1.845
cc_52 ( N_noxref_1_c_52_p N_noxref_3_c_745_n ) capacitor c=0.0154269f //x=3.82 \
 //y=2.375 //x2=4.56 //y2=3.725
cc_53 ( N_noxref_1_c_53_p N_noxref_3_c_745_n ) capacitor c=0.0445642f //x=3.82 \
 //y=3.35 //x2=4.56 //y2=3.725
cc_54 ( N_noxref_1_c_24_p N_noxref_3_c_745_n ) capacitor c=0.0173072f //x=3.82 \
 //y=3.67 //x2=4.56 //y2=3.725
cc_55 ( N_noxref_1_c_30_p N_noxref_3_c_745_n ) capacitor c=0.00244924f \
 //x=3.82 //y=4.75 //x2=4.56 //y2=3.725
cc_56 ( N_noxref_1_c_56_p N_noxref_3_c_745_n ) capacitor c=6.78671e-19 \
 //x=3.82 //y=3.51 //x2=4.56 //y2=3.725
cc_57 ( N_noxref_1_c_57_p N_noxref_3_c_745_n ) capacitor c=0.0030925f //x=3.98 \
 //y=3.51 //x2=4.56 //y2=3.725
cc_58 ( N_noxref_1_c_58_p N_noxref_3_c_745_n ) capacitor c=0.027698f //x=4.78 \
 //y=3.5 //x2=4.56 //y2=3.725
cc_59 ( N_noxref_1_c_59_p N_noxref_3_c_745_n ) capacitor c=0.00163444f \
 //x=3.82 //y=2.26 //x2=4.56 //y2=3.725
cc_60 ( N_noxref_1_c_60_p N_noxref_3_c_745_n ) capacitor c=0.0025845f //x=3.82 \
 //y=2.26 //x2=4.56 //y2=3.725
cc_61 ( N_noxref_1_c_45_p N_noxref_3_c_745_n ) capacitor c=0.00282067f \
 //x=3.82 //y=2.095 //x2=4.56 //y2=3.725
cc_62 ( N_noxref_1_c_30_p N_noxref_3_c_755_n ) capacitor c=0.0146933f //x=3.82 \
 //y=4.75 //x2=4.56 //y2=4.045
cc_63 ( N_noxref_1_c_58_p N_noxref_3_c_755_n ) capacitor c=0.00895951f \
 //x=4.78 //y=3.5 //x2=4.56 //y2=4.045
cc_64 ( N_noxref_1_c_30_p N_noxref_3_c_757_n ) capacitor c=0.0414151f //x=3.82 \
 //y=4.75 //x2=4.56 //y2=5.25
cc_65 ( N_noxref_1_c_32_p N_noxref_3_c_757_n ) capacitor c=0.00131258f \
 //x=3.82 //y=4.88 //x2=4.56 //y2=5.25
cc_66 ( N_noxref_1_c_66_p N_noxref_3_c_757_n ) capacitor c=0.00739875f \
 //x=3.82 //y=4.88 //x2=4.56 //y2=5.25
cc_67 ( N_noxref_1_c_67_p N_noxref_3_c_760_n ) capacitor c=0.00179329f \
 //x=6.63 //y=3.495 //x2=6.41 //y2=2.375
cc_68 ( N_noxref_1_c_53_p N_noxref_3_c_761_n ) capacitor c=0.00210705f \
 //x=3.82 //y=3.35 //x2=6.41 //y2=3.72
cc_69 ( N_noxref_1_c_69_p N_noxref_3_c_761_n ) capacitor c=4.94863e-19 \
 //x=6.03 //y=3.51 //x2=6.41 //y2=3.72
cc_70 ( N_noxref_1_c_67_p N_noxref_3_c_761_n ) capacitor c=0.0286424f //x=6.63 \
 //y=3.495 //x2=6.41 //y2=3.72
cc_71 ( N_noxref_1_c_71_p N_noxref_3_c_761_n ) capacitor c=3.74737e-19 \
 //x=9.535 //y=3.51 //x2=6.41 //y2=3.72
cc_72 ( N_noxref_1_c_67_p N_noxref_3_c_765_n ) capacitor c=0.00797853f \
 //x=6.63 //y=3.495 //x2=6.41 //y2=4.04
cc_73 ( N_noxref_1_c_30_p N_noxref_3_c_766_n ) capacitor c=8.5348e-19 //x=3.82 \
 //y=4.75 //x2=6.41 //y2=4.755
cc_74 ( N_noxref_1_c_30_p N_noxref_3_c_767_n ) capacitor c=0.0228808f //x=3.82 \
 //y=4.75 //x2=3.78 //y2=5.335
cc_75 ( N_noxref_1_c_32_p N_noxref_3_c_767_n ) capacitor c=0.00346456f \
 //x=3.82 //y=4.88 //x2=3.78 //y2=5.335
cc_76 ( N_noxref_1_c_66_p N_noxref_3_c_767_n ) capacitor c=0.00203307f \
 //x=3.82 //y=4.88 //x2=3.78 //y2=5.335
cc_77 ( N_noxref_1_c_30_p N_noxref_3_c_770_n ) capacitor c=6.15181e-19 \
 //x=3.82 //y=4.75 //x2=4.56 //y2=3.88
cc_78 ( N_noxref_1_c_58_p N_noxref_3_c_771_n ) capacitor c=0.133263f //x=4.78 \
 //y=3.5 //x2=6.255 //y2=3.88
cc_79 ( N_noxref_1_c_69_p N_noxref_3_c_771_n ) capacitor c=0.0126826f //x=6.03 \
 //y=3.51 //x2=6.255 //y2=3.88
cc_80 ( N_noxref_1_c_80_p N_noxref_3_c_773_n ) capacitor c=0.00771097f \
 //x=9.37 //y=3.67 //x2=9.59 //y2=3.895
cc_81 ( N_noxref_1_c_6_p N_noxref_3_c_773_n ) capacitor c=0.0226453f //x=9.37 \
 //y=5.25 //x2=9.59 //y2=3.895
cc_82 ( N_noxref_1_c_82_p N_noxref_3_c_773_n ) capacitor c=0.127201f //x=11.06 \
 //y=3.51 //x2=9.59 //y2=3.895
cc_83 ( N_noxref_1_c_80_p N_noxref_3_c_776_n ) capacitor c=0.00128047f \
 //x=9.37 //y=3.67 //x2=9.245 //y2=3.895
cc_84 ( N_noxref_1_c_6_p N_noxref_3_c_776_n ) capacitor c=3.14797e-19 //x=9.37 \
 //y=5.25 //x2=9.245 //y2=3.895
cc_85 ( N_noxref_1_c_67_p N_noxref_3_c_776_n ) capacitor c=0.0477348f //x=6.63 \
 //y=3.495 //x2=9.245 //y2=3.895
cc_86 ( N_noxref_1_c_71_p N_noxref_3_c_776_n ) capacitor c=0.252113f //x=9.535 \
 //y=3.51 //x2=9.245 //y2=3.895
cc_87 ( N_noxref_1_c_10_p N_noxref_3_c_780_n ) capacitor c=0.00339401f \
 //x=11.22 //y=3.67 //x2=10.835 //y2=3.88
cc_88 ( N_noxref_1_c_7_p N_noxref_3_c_780_n ) capacitor c=5.02752e-19 \
 //x=11.222 //y=4.74 //x2=10.835 //y2=3.88
cc_89 ( N_noxref_1_c_82_p N_noxref_3_c_780_n ) capacitor c=0.0107648f \
 //x=11.06 //y=3.51 //x2=10.835 //y2=3.88
cc_90 ( N_noxref_1_c_18_p N_noxref_3_c_780_n ) capacitor c=0.0358254f \
 //x=11.22 //y=3.51 //x2=10.835 //y2=3.88
cc_91 ( N_noxref_1_c_10_p N_noxref_3_c_784_n ) capacitor c=0.00260425f \
 //x=11.22 //y=3.67 //x2=11.435 //y2=3.895
cc_92 ( N_noxref_1_c_7_p N_noxref_3_c_784_n ) capacitor c=0.0229559f \
 //x=11.222 //y=4.74 //x2=11.435 //y2=3.895
cc_93 ( N_noxref_1_c_30_p N_noxref_3_c_786_n ) capacitor c=0.00683433f \
 //x=3.82 //y=4.75 //x2=4.725 //y2=3.885
cc_94 ( N_noxref_1_c_58_p N_noxref_3_c_786_n ) capacitor c=0.0365231f //x=4.78 \
 //y=3.5 //x2=4.725 //y2=3.885
cc_95 ( N_noxref_1_c_30_p N_noxref_3_c_788_n ) capacitor c=0.00217653f \
 //x=3.82 //y=4.75 //x2=3.78 //y2=5.56
cc_96 ( N_noxref_1_c_32_p N_noxref_3_c_788_n ) capacitor c=0.00624059f \
 //x=3.82 //y=4.88 //x2=3.78 //y2=5.56
cc_97 ( N_noxref_1_M58_noxref_g N_noxref_3_c_788_n ) capacitor c=0.0178885f \
 //x=3.56 //y=6.2 //x2=3.78 //y2=5.56
cc_98 ( N_noxref_1_M59_noxref_g N_noxref_3_c_788_n ) capacitor c=0.0188608f \
 //x=4 //y=6.2 //x2=3.78 //y2=5.56
cc_99 ( N_noxref_1_c_66_p N_noxref_3_c_788_n ) capacitor c=0.00375636f \
 //x=3.82 //y=4.88 //x2=3.78 //y2=5.56
cc_100 ( N_noxref_1_c_26_p N_noxref_3_M60_noxref_g ) capacitor c=0.00461408f \
 //x=6.832 //y=5.335 //x2=6.61 //y2=6.2
cc_101 ( N_noxref_1_c_101_p N_noxref_3_M60_noxref_g ) capacitor c=0.0162284f \
 //x=6.83 //y=5.56 //x2=6.61 //y2=6.2
cc_102 ( N_noxref_1_c_102_p N_noxref_3_M61_noxref_g ) capacitor c=0.00893512f \
 //x=7.59 //y=5.335 //x2=7.05 //y2=6.2
cc_103 ( N_noxref_1_c_26_p N_noxref_3_M61_noxref_g ) capacitor c=0.00229208f \
 //x=6.832 //y=5.335 //x2=7.05 //y2=6.2
cc_104 ( N_noxref_1_c_101_p N_noxref_3_M61_noxref_g ) capacitor c=0.0179041f \
 //x=6.83 //y=5.56 //x2=7.05 //y2=6.2
cc_105 ( N_noxref_1_c_26_p N_noxref_3_c_798_n ) capacitor c=0.00171885f \
 //x=6.832 //y=5.335 //x2=6.975 //y2=4.97
cc_106 ( N_noxref_1_c_101_p N_noxref_3_c_798_n ) capacitor c=0.00291477f \
 //x=6.83 //y=5.56 //x2=6.975 //y2=4.97
cc_107 ( N_noxref_1_c_35_p N_noxref_3_M2_noxref_d ) capacitor c=0.00137165f \
 //x=3.81 //y=1.095 //x2=3.885 //y2=1.095
cc_108 ( N_noxref_1_c_36_p N_noxref_3_M2_noxref_d ) capacitor c=0.00237422f \
 //x=3.81 //y=1.44 //x2=3.885 //y2=1.095
cc_109 ( N_noxref_1_c_37_p N_noxref_3_M2_noxref_d ) capacitor c=0.0020782f \
 //x=4.185 //y=0.94 //x2=3.885 //y2=1.095
cc_110 ( N_noxref_1_c_38_p N_noxref_3_M2_noxref_d ) capacitor c=0.00356097f \
 //x=4.185 //y=1.595 //x2=3.885 //y2=1.095
cc_111 ( N_noxref_1_c_39_p N_noxref_3_M2_noxref_d ) capacitor c=0.00139206f \
 //x=4.34 //y=1.095 //x2=3.885 //y2=1.095
cc_112 ( N_noxref_1_c_40_p N_noxref_3_M2_noxref_d ) capacitor c=0.00237422f \
 //x=4.34 //y=1.44 //x2=3.885 //y2=1.095
cc_113 ( N_noxref_1_c_53_p N_noxref_4_c_1196_n ) capacitor c=0.00142312f \
 //x=3.82 //y=3.35 //x2=1.6 //y2=4.1
cc_114 ( N_noxref_1_c_30_p N_noxref_4_c_1196_n ) capacitor c=8.0808e-19 \
 //x=3.82 //y=4.75 //x2=1.6 //y2=4.1
cc_115 ( N_noxref_1_c_30_p N_noxref_4_c_1198_n ) capacitor c=5.44383e-19 \
 //x=3.82 //y=4.75 //x2=1.6 //y2=4.755
cc_116 ( N_noxref_1_c_116_p N_noxref_4_c_1199_n ) capacitor c=0.00131559f \
 //x=9.37 //y=3.35 //x2=11.96 //y2=4.09
cc_117 ( N_noxref_1_c_6_p N_noxref_4_c_1199_n ) capacitor c=3.24787e-19 \
 //x=9.37 //y=5.25 //x2=11.96 //y2=4.09
cc_118 ( N_noxref_1_c_5_p N_noxref_4_c_1199_n ) capacitor c=0.0396214f \
 //x=11.22 //y=3.35 //x2=11.96 //y2=4.09
cc_119 ( N_noxref_1_c_10_p N_noxref_4_c_1199_n ) capacitor c=0.0148501f \
 //x=11.22 //y=3.67 //x2=11.96 //y2=4.09
cc_120 ( N_noxref_1_c_17_p N_noxref_4_c_1199_n ) capacitor c=5.52402e-19 \
 //x=11.22 //y=3.51 //x2=11.96 //y2=4.09
cc_121 ( N_noxref_1_c_7_p N_noxref_4_c_1199_n ) capacitor c=0.0167029f \
 //x=11.222 //y=4.74 //x2=11.96 //y2=4.09
cc_122 ( N_noxref_1_c_18_p N_noxref_4_c_1199_n ) capacitor c=0.00365413f \
 //x=11.22 //y=3.51 //x2=11.96 //y2=4.09
cc_123 ( N_noxref_1_c_123_p N_noxref_4_c_1199_n ) capacitor c=3.30333e-19 \
 //x=11.22 //y=2.26 //x2=11.96 //y2=4.09
cc_124 ( N_noxref_1_c_7_p N_noxref_4_c_1207_n ) capacitor c=0.0172847f \
 //x=11.222 //y=4.74 //x2=11.96 //y2=4.41
cc_125 ( N_noxref_1_c_6_p N_noxref_4_c_1208_n ) capacitor c=7.59756e-19 \
 //x=9.37 //y=5.25 //x2=11.96 //y2=4.735
cc_126 ( N_noxref_1_c_11_p N_noxref_4_c_1208_n ) capacitor c=0.0172939f \
 //x=11.22 //y=4.88 //x2=11.96 //y2=4.735
cc_127 ( N_noxref_1_c_7_p N_noxref_4_c_1208_n ) capacitor c=0.0117609f \
 //x=11.222 //y=4.74 //x2=11.96 //y2=4.735
cc_128 ( N_noxref_1_c_12_p N_noxref_4_c_1208_n ) capacitor c=7.51041e-19 \
 //x=11.22 //y=4.88 //x2=11.96 //y2=4.735
cc_129 ( N_noxref_1_c_15_p N_noxref_4_c_1208_n ) capacitor c=0.00200732f \
 //x=11.22 //y=4.88 //x2=11.96 //y2=4.735
cc_130 ( N_noxref_1_c_7_p N_noxref_4_c_1213_n ) capacitor c=6.16997e-19 \
 //x=11.222 //y=4.74 //x2=11.96 //y2=4.25
cc_131 ( N_noxref_1_c_131_p N_noxref_4_c_1214_n ) capacitor c=0.0179797f \
 //x=11.22 //y=2.26 //x2=11.96 //y2=2.26
cc_132 ( N_noxref_1_c_123_p N_noxref_4_c_1214_n ) capacitor c=5.16867e-19 \
 //x=11.22 //y=2.26 //x2=11.96 //y2=2.26
cc_133 ( N_noxref_1_c_133_p N_noxref_4_c_1214_n ) capacitor c=0.00161745f \
 //x=11.025 //y=2.095 //x2=11.96 //y2=2.26
cc_134 ( N_noxref_1_c_24_p N_noxref_4_c_1217_n ) capacitor c=0.0032242f \
 //x=3.82 //y=3.67 //x2=4.175 //y2=4.25
cc_135 ( N_noxref_1_c_30_p N_noxref_4_c_1217_n ) capacitor c=0.024687f \
 //x=3.82 //y=4.75 //x2=4.175 //y2=4.25
cc_136 ( N_noxref_1_c_47_p N_noxref_4_c_1217_n ) capacitor c=0.0164241f \
 //x=4.18 //y=3.51 //x2=4.175 //y2=4.25
cc_137 ( N_noxref_1_c_57_p N_noxref_4_c_1217_n ) capacitor c=0.0160572f \
 //x=3.98 //y=3.51 //x2=4.175 //y2=4.25
cc_138 ( N_noxref_1_c_58_p N_noxref_4_c_1221_n ) capacitor c=0.0087977f \
 //x=4.78 //y=3.5 //x2=4.815 //y2=4.27
cc_139 ( N_noxref_1_c_69_p N_noxref_4_c_1222_n ) capacitor c=0.00556214f \
 //x=6.03 //y=3.51 //x2=6.03 //y2=4.25
cc_140 ( N_noxref_1_c_67_p N_noxref_4_c_1223_n ) capacitor c=0.00123933f \
 //x=6.63 //y=3.495 //x2=6.63 //y2=4.265
cc_141 ( N_noxref_1_c_6_p N_noxref_4_c_1224_n ) capacitor c=0.0232184f \
 //x=9.37 //y=5.25 //x2=12.125 //y2=4.25
cc_142 ( N_noxref_1_c_7_p N_noxref_4_c_1224_n ) capacitor c=0.0253737f \
 //x=11.222 //y=4.74 //x2=12.125 //y2=4.25
cc_143 ( N_noxref_1_c_82_p N_noxref_4_c_1224_n ) capacitor c=0.0104445f \
 //x=11.06 //y=3.51 //x2=12.125 //y2=4.25
cc_144 ( N_noxref_1_c_71_p N_noxref_4_c_1224_n ) capacitor c=0.0225638f \
 //x=9.535 //y=3.51 //x2=12.125 //y2=4.25
cc_145 ( N_noxref_1_c_5_p N_noxref_4_c_1228_n ) capacitor c=3.30333e-19 \
 //x=11.22 //y=3.35 //x2=11.96 //y2=2.26
cc_146 ( N_noxref_1_c_131_p N_noxref_4_c_1228_n ) capacitor c=5.24723e-19 \
 //x=11.22 //y=2.26 //x2=11.96 //y2=2.26
cc_147 ( N_noxref_1_c_123_p N_noxref_4_c_1228_n ) capacitor c=0.00525888f \
 //x=11.22 //y=2.26 //x2=11.96 //y2=2.26
cc_148 ( N_noxref_1_c_133_p N_noxref_4_c_1228_n ) capacitor c=0.00190888f \
 //x=11.025 //y=2.095 //x2=11.96 //y2=2.26
cc_149 ( N_noxref_1_c_11_p N_noxref_4_c_1232_n ) capacitor c=4.80626e-19 \
 //x=11.22 //y=4.88 //x2=11.99 //y2=4.88
cc_150 ( N_noxref_1_c_12_p N_noxref_4_c_1232_n ) capacitor c=0.00397338f \
 //x=11.22 //y=4.88 //x2=11.99 //y2=4.88
cc_151 ( N_noxref_1_c_15_p N_noxref_4_c_1232_n ) capacitor c=0.00283894f \
 //x=11.22 //y=4.88 //x2=11.99 //y2=4.88
cc_152 ( N_noxref_1_M66_noxref_g N_noxref_4_M68_noxref_g ) capacitor \
 c=0.0104892f //x=11.12 //y=6.2 //x2=12 //y2=6.2
cc_153 ( N_noxref_1_M67_noxref_g N_noxref_4_M68_noxref_g ) capacitor \
 c=0.107636f //x=11.56 //y=6.2 //x2=12 //y2=6.2
cc_154 ( N_noxref_1_M67_noxref_g N_noxref_4_M69_noxref_g ) capacitor \
 c=0.0100341f //x=11.56 //y=6.2 //x2=12.44 //y2=6.2
cc_155 ( N_noxref_1_c_155_p N_noxref_4_c_1238_n ) capacitor c=4.86545e-19 \
 //x=11.025 //y=1.045 //x2=11.995 //y2=1.085
cc_156 ( N_noxref_1_c_156_p N_noxref_4_c_1238_n ) capacitor c=0.00152405f \
 //x=11.025 //y=1.39 //x2=11.995 //y2=1.085
cc_157 ( N_noxref_1_c_157_p N_noxref_4_c_1238_n ) capacitor c=0.0151475f \
 //x=11.555 //y=1.045 //x2=11.995 //y2=1.085
cc_158 ( N_noxref_1_c_158_p N_noxref_4_c_1241_n ) capacitor c=0.00109982f \
 //x=11.025 //y=1.7 //x2=11.995 //y2=1.43
cc_159 ( N_noxref_1_c_159_p N_noxref_4_c_1241_n ) capacitor c=0.0111064f \
 //x=11.555 //y=1.39 //x2=11.995 //y2=1.43
cc_160 ( N_noxref_1_c_158_p N_noxref_4_c_1243_n ) capacitor c=9.58243e-19 \
 //x=11.025 //y=1.7 //x2=11.995 //y2=1.74
cc_161 ( N_noxref_1_c_133_p N_noxref_4_c_1243_n ) capacitor c=0.00662747f \
 //x=11.025 //y=2.095 //x2=11.995 //y2=1.74
cc_162 ( N_noxref_1_c_159_p N_noxref_4_c_1243_n ) capacitor c=0.00862358f \
 //x=11.555 //y=1.39 //x2=11.995 //y2=1.74
cc_163 ( N_noxref_1_c_157_p N_noxref_4_c_1246_n ) capacitor c=0.00127211f \
 //x=11.555 //y=1.045 //x2=12.525 //y2=1.085
cc_164 ( N_noxref_1_c_159_p N_noxref_4_c_1247_n ) capacitor c=0.00204774f \
 //x=11.555 //y=1.39 //x2=12.525 //y2=1.43
cc_165 ( N_noxref_1_c_131_p N_noxref_4_c_1248_n ) capacitor c=0.00161167f \
 //x=11.22 //y=2.26 //x2=11.96 //y2=2.26
cc_166 ( N_noxref_1_c_123_p N_noxref_4_c_1248_n ) capacitor c=0.0018937f \
 //x=11.22 //y=2.26 //x2=11.96 //y2=2.26
cc_167 ( N_noxref_1_c_133_p N_noxref_4_c_1248_n ) capacitor c=0.0181449f \
 //x=11.025 //y=2.095 //x2=11.96 //y2=2.26
cc_168 ( N_noxref_1_c_11_p N_noxref_4_c_1251_n ) capacitor c=0.00158715f \
 //x=11.22 //y=4.88 //x2=11.99 //y2=4.88
cc_169 ( N_noxref_1_c_12_p N_noxref_4_c_1251_n ) capacitor c=0.00237977f \
 //x=11.22 //y=4.88 //x2=11.99 //y2=4.88
cc_170 ( N_noxref_1_c_15_p N_noxref_4_c_1251_n ) capacitor c=0.0297875f \
 //x=11.22 //y=4.88 //x2=11.99 //y2=4.88
cc_171 ( N_noxref_1_c_116_p D ) capacitor c=5.32179e-19 //x=9.37 //y=3.35 \
 //x2=7.52 //y2=3.14
cc_172 ( N_noxref_1_c_6_p D ) capacitor c=0.00135693f //x=9.37 //y=5.25 \
 //x2=7.52 //y2=3.14
cc_173 ( N_noxref_1_c_71_p D ) capacitor c=0.0260815f //x=9.535 //y=3.51 \
 //x2=7.52 //y2=3.14
cc_174 ( N_noxref_1_c_116_p N_D_c_4188_n ) capacitor c=4.35995e-19 //x=9.37 \
 //y=3.35 //x2=7.52 //y2=2.62
cc_175 ( N_noxref_1_c_102_p N_D_c_4189_n ) capacitor c=4.4244e-19 //x=7.59 \
 //y=5.335 //x2=7.52 //y2=2.94
cc_176 ( N_noxref_1_c_176_p N_D_c_4189_n ) capacitor c=0.00123151f //x=7.71 \
 //y=5.335 //x2=7.52 //y2=2.94
cc_177 ( N_noxref_1_c_71_p N_D_c_4189_n ) capacitor c=0.00354873f //x=9.535 \
 //y=3.51 //x2=7.52 //y2=2.94
cc_178 ( N_noxref_1_c_178_p N_D_c_4189_n ) capacitor c=3.89319e-19 //x=7.71 \
 //y=5.56 //x2=7.52 //y2=2.94
cc_179 ( N_noxref_1_c_102_p N_D_c_4193_n ) capacitor c=0.0213631f //x=7.59 \
 //y=5.335 //x2=7.52 //y2=4.765
cc_180 ( N_noxref_1_c_176_p N_D_c_4193_n ) capacitor c=0.00239361f //x=7.71 \
 //y=5.335 //x2=7.52 //y2=4.765
cc_181 ( N_noxref_1_c_178_p N_D_c_4193_n ) capacitor c=6.21282e-19 //x=7.71 \
 //y=5.56 //x2=7.52 //y2=4.765
cc_182 ( N_noxref_1_c_71_p N_D_c_4196_n ) capacitor c=0.0163271f //x=9.535 \
 //y=3.51 //x2=7.675 //y2=2.78
cc_183 ( N_noxref_1_c_116_p N_D_c_4197_n ) capacitor c=0.0255647f //x=9.37 \
 //y=3.35 //x2=33.26 //y2=2.755
cc_184 ( N_noxref_1_c_80_p N_D_c_4197_n ) capacitor c=0.00501777f //x=9.37 \
 //y=3.67 //x2=33.26 //y2=2.755
cc_185 ( N_noxref_1_c_5_p N_D_c_4197_n ) capacitor c=0.0255504f //x=11.22 \
 //y=3.35 //x2=33.26 //y2=2.755
cc_186 ( N_noxref_1_c_10_p N_D_c_4197_n ) capacitor c=0.00401541f //x=11.22 \
 //y=3.67 //x2=33.26 //y2=2.755
cc_187 ( N_noxref_1_c_82_p N_D_c_4197_n ) capacitor c=0.0689712f //x=11.06 \
 //y=3.51 //x2=33.26 //y2=2.755
cc_188 ( N_noxref_1_c_71_p N_D_c_4197_n ) capacitor c=0.0810691f //x=9.535 \
 //y=3.51 //x2=33.26 //y2=2.755
cc_189 ( N_noxref_1_c_18_p N_D_c_4197_n ) capacitor c=0.0156866f //x=11.22 \
 //y=3.51 //x2=33.26 //y2=2.755
cc_190 ( N_noxref_1_c_102_p N_D_c_4204_n ) capacitor c=0.00492634f //x=7.59 \
 //y=5.335 //x2=7.52 //y2=4.88
cc_191 ( N_noxref_1_c_176_p N_D_c_4204_n ) capacitor c=0.00132214f //x=7.71 \
 //y=5.335 //x2=7.52 //y2=4.88
cc_192 ( N_noxref_1_c_102_p N_D_M62_noxref_g ) capacitor c=0.00858241f \
 //x=7.59 //y=5.335 //x2=7.49 //y2=6.2
cc_193 ( N_noxref_1_c_176_p N_D_M62_noxref_g ) capacitor c=0.00229818f \
 //x=7.71 //y=5.335 //x2=7.49 //y2=6.2
cc_194 ( N_noxref_1_c_178_p N_D_M62_noxref_g ) capacitor c=0.0179041f //x=7.71 \
 //y=5.56 //x2=7.49 //y2=6.2
cc_195 ( N_noxref_1_c_195_p N_D_M63_noxref_g ) capacitor c=0.00955829f \
 //x=8.475 //y=5.335 //x2=7.93 //y2=6.2
cc_196 ( N_noxref_1_c_176_p N_D_M63_noxref_g ) capacitor c=0.00230699f \
 //x=7.71 //y=5.335 //x2=7.93 //y2=6.2
cc_197 ( N_noxref_1_c_178_p N_D_M63_noxref_g ) capacitor c=0.0179041f //x=7.71 \
 //y=5.56 //x2=7.93 //y2=6.2
cc_198 ( N_noxref_1_c_176_p N_D_c_4212_n ) capacitor c=0.00209217f //x=7.71 \
 //y=5.335 //x2=7.855 //y2=4.97
cc_199 ( N_noxref_1_c_178_p N_D_c_4212_n ) capacitor c=0.00290085f //x=7.71 \
 //y=5.56 //x2=7.855 //y2=4.97
cc_200 ( N_noxref_1_c_102_p N_D_c_4214_n ) capacitor c=6.02148e-19 //x=7.59 \
 //y=5.335 //x2=7.52 //y2=4.88
cc_201 ( N_noxref_1_c_53_p CLK ) capacitor c=0.029075f //x=3.82 //y=3.35 \
 //x2=2.71 //y2=2.77
cc_202 ( N_noxref_1_c_24_p CLK ) capacitor c=0.00775314f //x=3.82 //y=3.67 \
 //x2=2.71 //y2=2.77
cc_203 ( N_noxref_1_c_30_p CLK ) capacitor c=0.0245236f //x=3.82 //y=4.75 \
 //x2=2.71 //y2=2.77
cc_204 ( N_noxref_1_c_56_p CLK ) capacitor c=3.35971e-19 //x=3.82 //y=3.51 \
 //x2=2.71 //y2=2.77
cc_205 ( N_noxref_1_c_57_p CLK ) capacitor c=0.00508753f //x=3.98 //y=3.51 \
 //x2=2.71 //y2=2.77
cc_206 ( N_noxref_1_c_59_p CLK ) capacitor c=4.16726e-19 //x=3.82 //y=2.26 \
 //x2=2.71 //y2=2.77
cc_207 ( N_noxref_1_c_52_p N_CLK_c_4769_n ) capacitor c=0.0116288f //x=3.82 \
 //y=2.375 //x2=2.71 //y2=2.375
cc_208 ( N_noxref_1_c_59_p N_CLK_c_4769_n ) capacitor c=5.42289e-19 //x=3.82 \
 //y=2.26 //x2=2.71 //y2=2.375
cc_209 ( N_noxref_1_c_60_p N_CLK_c_4769_n ) capacitor c=0.00139071f //x=3.82 \
 //y=2.26 //x2=2.71 //y2=2.375
cc_210 ( N_noxref_1_c_30_p N_CLK_c_4772_n ) capacitor c=0.0082089f //x=3.82 \
 //y=4.75 //x2=2.705 //y2=4.835
cc_211 ( N_noxref_1_c_32_p N_CLK_c_4772_n ) capacitor c=7.52809e-19 //x=3.82 \
 //y=4.88 //x2=2.705 //y2=4.835
cc_212 ( N_noxref_1_c_66_p N_CLK_c_4772_n ) capacitor c=0.0013272f //x=3.82 \
 //y=4.88 //x2=2.705 //y2=4.835
cc_213 ( N_noxref_1_c_30_p N_CLK_c_4775_n ) capacitor c=0.0290574f //x=3.82 \
 //y=4.75 //x2=11.58 //y2=4.62
cc_214 ( N_noxref_1_c_9_p N_CLK_c_4775_n ) capacitor c=0.0221996f //x=9.285 \
 //y=5.335 //x2=11.58 //y2=4.62
cc_215 ( N_noxref_1_c_6_p N_CLK_c_4775_n ) capacitor c=0.0300479f //x=9.37 \
 //y=5.25 //x2=11.58 //y2=4.62
cc_216 ( N_noxref_1_c_26_p N_CLK_c_4775_n ) capacitor c=0.029717f //x=6.832 \
 //y=5.335 //x2=11.58 //y2=4.62
cc_217 ( N_noxref_1_c_176_p N_CLK_c_4775_n ) capacitor c=0.0398444f //x=7.71 \
 //y=5.335 //x2=11.58 //y2=4.62
cc_218 ( N_noxref_1_c_11_p N_CLK_c_4775_n ) capacitor c=0.00404699f //x=11.22 \
 //y=4.88 //x2=11.58 //y2=4.62
cc_219 ( N_noxref_1_c_7_p N_CLK_c_4775_n ) capacitor c=0.0269932f //x=11.222 \
 //y=4.74 //x2=11.58 //y2=4.62
cc_220 ( N_noxref_1_c_47_p N_CLK_c_4775_n ) capacitor c=0.0021303f //x=4.18 \
 //y=3.51 //x2=11.58 //y2=4.62
cc_221 ( N_noxref_1_c_30_p N_CLK_c_4783_n ) capacitor c=0.00655852f //x=3.82 \
 //y=4.75 //x2=2.705 //y2=4.62
cc_222 ( N_noxref_1_c_52_p N_CLK_c_4784_n ) capacitor c=5.39999e-19 //x=3.82 \
 //y=2.375 //x2=2.71 //y2=2.26
cc_223 ( N_noxref_1_c_53_p N_CLK_c_4784_n ) capacitor c=4.16726e-19 //x=3.82 \
 //y=3.35 //x2=2.71 //y2=2.26
cc_224 ( N_noxref_1_c_59_p N_CLK_c_4784_n ) capacitor c=0.00125213f //x=3.82 \
 //y=2.26 //x2=2.71 //y2=2.26
cc_225 ( N_noxref_1_c_60_p N_CLK_c_4784_n ) capacitor c=0.00204868f //x=3.82 \
 //y=2.26 //x2=2.71 //y2=2.26
cc_226 ( N_noxref_1_c_30_p N_CLK_c_4788_n ) capacitor c=4.56604e-19 //x=3.82 \
 //y=4.75 //x2=2.71 //y2=4.88
cc_227 ( N_noxref_1_c_32_p N_CLK_c_4788_n ) capacitor c=0.00113671f //x=3.82 \
 //y=4.88 //x2=2.71 //y2=4.88
cc_228 ( N_noxref_1_c_66_p N_CLK_c_4788_n ) capacitor c=0.00186974f //x=3.82 \
 //y=4.88 //x2=2.71 //y2=4.88
cc_229 ( N_noxref_1_M58_noxref_g N_CLK_M56_noxref_g ) capacitor c=0.0101598f \
 //x=3.56 //y=6.2 //x2=2.68 //y2=6.2
cc_230 ( N_noxref_1_M58_noxref_g N_CLK_M57_noxref_g ) capacitor c=0.0607518f \
 //x=3.56 //y=6.2 //x2=3.12 //y2=6.2
cc_231 ( N_noxref_1_M59_noxref_g N_CLK_M57_noxref_g ) capacitor c=0.0101598f \
 //x=4 //y=6.2 //x2=3.12 //y2=6.2
cc_232 ( N_noxref_1_c_35_p N_CLK_c_4794_n ) capacitor c=0.00456962f //x=3.81 \
 //y=1.095 //x2=2.8 //y2=1.09
cc_233 ( N_noxref_1_c_36_p N_CLK_c_4795_n ) capacitor c=0.00438372f //x=3.81 \
 //y=1.44 //x2=2.8 //y2=1.4
cc_234 ( N_noxref_1_c_42_p N_CLK_c_4796_n ) capacitor c=0.00438372f //x=3.81 \
 //y=1.75 //x2=2.8 //y2=1.63
cc_235 ( N_noxref_1_c_52_p N_CLK_c_4797_n ) capacitor c=0.00141236f //x=3.82 \
 //y=2.375 //x2=2.8 //y2=2.095
cc_236 ( N_noxref_1_c_59_p N_CLK_c_4797_n ) capacitor c=0.00209664f //x=3.82 \
 //y=2.26 //x2=2.8 //y2=2.095
cc_237 ( N_noxref_1_c_60_p N_CLK_c_4797_n ) capacitor c=0.00933826f //x=3.82 \
 //y=2.26 //x2=2.8 //y2=2.095
cc_238 ( N_noxref_1_c_45_p N_CLK_c_4797_n ) capacitor c=0.00438372f //x=3.82 \
 //y=2.095 //x2=2.8 //y2=2.095
cc_239 ( N_noxref_1_c_66_p N_CLK_c_4801_n ) capacitor c=0.0616777f //x=3.82 \
 //y=4.88 //x2=3.045 //y2=4.97
cc_240 ( N_noxref_1_c_32_p N_CLK_c_4802_n ) capacitor c=9.77556e-19 //x=3.82 \
 //y=4.88 //x2=2.71 //y2=4.88
cc_241 ( N_noxref_1_c_66_p N_CLK_c_4802_n ) capacitor c=0.0042693f //x=3.82 \
 //y=4.88 //x2=2.71 //y2=4.88
cc_242 ( N_noxref_1_c_116_p RN ) capacitor c=0.0376631f //x=9.37 //y=3.35 \
 //x2=8.63 //y2=3.14
cc_243 ( N_noxref_1_c_80_p RN ) capacitor c=0.0144538f //x=9.37 //y=3.67 \
 //x2=8.63 //y2=3.14
cc_244 ( N_noxref_1_c_6_p RN ) capacitor c=0.0411806f //x=9.37 //y=5.25 \
 //x2=8.63 //y2=3.14
cc_245 ( N_noxref_1_c_5_p RN ) capacitor c=0.00131626f //x=11.22 //y=3.35 \
 //x2=8.63 //y2=3.14
cc_246 ( N_noxref_1_c_246_p RN ) capacitor c=6.03895e-19 //x=9.37 //y=3.51 \
 //x2=8.63 //y2=3.14
cc_247 ( N_noxref_1_c_7_p RN ) capacitor c=0.00123473f //x=11.222 //y=4.74 \
 //x2=8.63 //y2=3.14
cc_248 ( N_noxref_1_c_71_p RN ) capacitor c=0.0275423f //x=9.535 //y=3.51 \
 //x2=8.63 //y2=3.14
cc_249 ( N_noxref_1_c_16_p RN ) capacitor c=5.60322e-19 //x=8.885 //y=1.305 \
 //x2=8.63 //y2=2.4
cc_250 ( N_noxref_1_c_116_p RN ) capacitor c=0.0170216f //x=9.37 //y=3.35 \
 //x2=8.63 //y2=2.4
cc_251 ( N_noxref_1_c_251_p RN ) capacitor c=4.27678e-19 //x=8.59 //y=5.335 \
 //x2=8.63 //y2=2.4
cc_252 ( N_noxref_1_c_9_p N_RN_c_6301_n ) capacitor c=0.00228791f //x=9.285 \
 //y=5.335 //x2=8.63 //y2=4.75
cc_253 ( N_noxref_1_c_6_p N_RN_c_6301_n ) capacitor c=0.0152702f //x=9.37 \
 //y=5.25 //x2=8.63 //y2=4.75
cc_254 ( N_noxref_1_c_251_p N_RN_c_6301_n ) capacitor c=0.0223028f //x=8.59 \
 //y=5.335 //x2=8.63 //y2=4.75
cc_255 ( N_noxref_1_c_255_p N_RN_c_6301_n ) capacitor c=0.00266858f //x=8.59 \
 //y=5.56 //x2=8.63 //y2=4.75
cc_256 ( N_noxref_1_c_16_p N_RN_c_6305_n ) capacitor c=4.13793e-19 //x=8.885 \
 //y=1.305 //x2=8.635 //y2=2.305
cc_257 ( N_noxref_1_c_116_p N_RN_c_6305_n ) capacitor c=0.00372846f //x=9.37 \
 //y=3.35 //x2=8.635 //y2=2.305
cc_258 ( N_noxref_1_c_71_p N_RN_c_6305_n ) capacitor c=0.0026061f //x=9.535 \
 //y=3.51 //x2=8.635 //y2=2.305
cc_259 ( N_noxref_1_c_46_p N_RN_c_6308_n ) capacitor c=0.0215425f //x=8.97 \
 //y=1.845 //x2=16.615 //y2=2.315
cc_260 ( N_noxref_1_c_116_p N_RN_c_6308_n ) capacitor c=0.0275062f //x=9.37 \
 //y=3.35 //x2=16.615 //y2=2.315
cc_261 ( N_noxref_1_c_5_p N_RN_c_6308_n ) capacitor c=0.0126785f //x=11.22 \
 //y=3.35 //x2=16.615 //y2=2.315
cc_262 ( N_noxref_1_c_131_p N_RN_c_6308_n ) capacitor c=0.0177708f //x=11.22 \
 //y=2.26 //x2=16.615 //y2=2.315
cc_263 ( N_noxref_1_c_82_p N_RN_c_6308_n ) capacitor c=0.0055647f //x=11.06 \
 //y=3.51 //x2=16.615 //y2=2.315
cc_264 ( N_noxref_1_c_123_p N_RN_c_6308_n ) capacitor c=2.20453e-19 //x=11.22 \
 //y=2.26 //x2=16.615 //y2=2.315
cc_265 ( N_noxref_1_c_133_p N_RN_c_6308_n ) capacitor c=3.61358e-19 //x=11.025 \
 //y=2.095 //x2=16.615 //y2=2.315
cc_266 ( N_noxref_1_c_116_p N_RN_c_6315_n ) capacitor c=0.00115564f //x=9.37 \
 //y=3.35 //x2=8.63 //y2=2.26
cc_267 ( N_noxref_1_c_9_p N_RN_c_6316_n ) capacitor c=0.00130631f //x=9.285 \
 //y=5.335 //x2=8.63 //y2=4.88
cc_268 ( N_noxref_1_c_6_p N_RN_c_6316_n ) capacitor c=0.00131258f //x=9.37 \
 //y=5.25 //x2=8.63 //y2=4.88
cc_269 ( N_noxref_1_c_251_p N_RN_c_6316_n ) capacitor c=0.00346017f //x=8.59 \
 //y=5.335 //x2=8.63 //y2=4.88
cc_270 ( N_noxref_1_c_255_p N_RN_c_6316_n ) capacitor c=0.00624059f //x=8.59 \
 //y=5.56 //x2=8.63 //y2=4.88
cc_271 ( N_noxref_1_c_195_p N_RN_M64_noxref_g ) capacitor c=0.00955829f \
 //x=8.475 //y=5.335 //x2=8.37 //y2=6.2
cc_272 ( N_noxref_1_c_8_p N_RN_M64_noxref_g ) capacitor c=0.00226521f //x=8.59 \
 //y=5.56 //x2=8.37 //y2=6.2
cc_273 ( N_noxref_1_c_255_p N_RN_M64_noxref_g ) capacitor c=0.0178885f \
 //x=8.59 //y=5.56 //x2=8.37 //y2=6.2
cc_274 ( N_noxref_1_c_8_p N_RN_M65_noxref_g ) capacitor c=0.00368945f //x=8.59 \
 //y=5.56 //x2=8.81 //y2=6.2
cc_275 ( N_noxref_1_c_9_p N_RN_M65_noxref_g ) capacitor c=0.0108612f //x=9.285 \
 //y=5.335 //x2=8.81 //y2=6.2
cc_276 ( N_noxref_1_c_255_p N_RN_M65_noxref_g ) capacitor c=0.0188608f \
 //x=8.59 //y=5.56 //x2=8.81 //y2=6.2
cc_277 ( N_noxref_1_c_16_p N_RN_c_6326_n ) capacitor c=4.64015e-19 //x=8.885 \
 //y=1.305 //x2=8.62 //y2=1.095
cc_278 ( N_noxref_1_M5_noxref_d N_RN_c_6326_n ) capacitor c=0.00137165f \
 //x=8.695 //y=1.095 //x2=8.62 //y2=1.095
cc_279 ( N_noxref_1_c_16_p N_RN_c_6328_n ) capacitor c=0.0026012f //x=8.885 \
 //y=1.305 //x2=8.62 //y2=1.44
cc_280 ( N_noxref_1_c_2_p N_RN_c_6328_n ) capacitor c=0.00127432f //x=8.885 \
 //y=1.76 //x2=8.62 //y2=1.44
cc_281 ( N_noxref_1_M5_noxref_d N_RN_c_6328_n ) capacitor c=0.00237422f \
 //x=8.695 //y=1.095 //x2=8.62 //y2=1.44
cc_282 ( N_noxref_1_c_2_p N_RN_c_6331_n ) capacitor c=0.00441386f //x=8.885 \
 //y=1.76 //x2=8.62 //y2=1.75
cc_283 ( N_noxref_1_c_16_p N_RN_c_6332_n ) capacitor c=5.29969e-19 //x=8.885 \
 //y=1.305 //x2=8.995 //y2=0.94
cc_284 ( N_noxref_1_M5_noxref_d N_RN_c_6332_n ) capacitor c=0.0020782f \
 //x=8.695 //y=1.095 //x2=8.995 //y2=0.94
cc_285 ( N_noxref_1_c_16_p N_RN_c_6334_n ) capacitor c=4.32061e-19 //x=8.885 \
 //y=1.305 //x2=8.995 //y2=1.595
cc_286 ( N_noxref_1_c_2_p N_RN_c_6334_n ) capacitor c=0.00930387f //x=8.885 \
 //y=1.76 //x2=8.995 //y2=1.595
cc_287 ( N_noxref_1_c_3_p N_RN_c_6334_n ) capacitor c=0.00194716f //x=9.285 \
 //y=1.845 //x2=8.995 //y2=1.595
cc_288 ( N_noxref_1_M5_noxref_d N_RN_c_6334_n ) capacitor c=0.00356097f \
 //x=8.695 //y=1.095 //x2=8.995 //y2=1.595
cc_289 ( N_noxref_1_c_16_p N_RN_c_6338_n ) capacitor c=5.28622e-19 //x=8.885 \
 //y=1.305 //x2=9.15 //y2=1.095
cc_290 ( N_noxref_1_M5_noxref_d N_RN_c_6338_n ) capacitor c=0.00139206f \
 //x=8.695 //y=1.095 //x2=9.15 //y2=1.095
cc_291 ( N_noxref_1_c_16_p N_RN_c_6340_n ) capacitor c=0.00312156f //x=8.885 \
 //y=1.305 //x2=9.15 //y2=1.44
cc_292 ( N_noxref_1_c_2_p N_RN_c_6340_n ) capacitor c=0.00347599f //x=8.885 \
 //y=1.76 //x2=9.15 //y2=1.44
cc_293 ( N_noxref_1_c_3_p N_RN_c_6340_n ) capacitor c=0.00323576f //x=9.285 \
 //y=1.845 //x2=9.15 //y2=1.44
cc_294 ( N_noxref_1_M5_noxref_d N_RN_c_6340_n ) capacitor c=0.00237422f \
 //x=8.695 //y=1.095 //x2=9.15 //y2=1.44
cc_295 ( N_noxref_1_c_116_p N_RN_c_6344_n ) capacitor c=3.96703e-19 //x=9.37 \
 //y=3.35 //x2=8.63 //y2=2.26
cc_296 ( N_noxref_1_c_2_p N_RN_c_6345_n ) capacitor c=0.0036273f //x=8.885 \
 //y=1.76 //x2=8.63 //y2=2.095
cc_297 ( N_noxref_1_c_116_p N_RN_c_6345_n ) capacitor c=0.00282067f //x=9.37 \
 //y=3.35 //x2=8.63 //y2=2.095
cc_298 ( N_noxref_1_c_6_p N_RN_c_6347_n ) capacitor c=0.00739875f //x=9.37 \
 //y=5.25 //x2=8.63 //y2=4.88
cc_299 ( N_noxref_1_c_251_p N_RN_c_6347_n ) capacitor c=0.00203307f //x=8.59 \
 //y=5.335 //x2=8.63 //y2=4.88
cc_300 ( N_noxref_1_c_255_p N_RN_c_6347_n ) capacitor c=0.00375636f //x=8.59 \
 //y=5.56 //x2=8.63 //y2=4.88
cc_301 ( N_noxref_1_c_102_p N_VDD_c_11464_n ) capacitor c=0.00621363f //x=7.59 \
 //y=5.335 //x2=78.895 //y2=7.585
cc_302 ( N_noxref_1_c_195_p N_VDD_c_11464_n ) capacitor c=0.00627192f \
 //x=8.475 //y=5.335 //x2=78.895 //y2=7.585
cc_303 ( N_noxref_1_c_8_p N_VDD_c_11464_n ) capacitor c=0.00256036f //x=8.59 \
 //y=5.56 //x2=78.895 //y2=7.585
cc_304 ( N_noxref_1_c_9_p N_VDD_c_11464_n ) capacitor c=0.00829251f //x=9.285 \
 //y=5.335 //x2=78.895 //y2=7.585
cc_305 ( N_noxref_1_c_80_p N_VDD_c_11464_n ) capacitor c=4.58912e-19 //x=9.37 \
 //y=3.67 //x2=78.895 //y2=7.585
cc_306 ( N_noxref_1_c_10_p N_VDD_c_11464_n ) capacitor c=2.00241e-19 //x=11.22 \
 //y=3.67 //x2=78.895 //y2=7.585
cc_307 ( N_noxref_1_c_26_p N_VDD_c_11464_n ) capacitor c=0.00261804f //x=6.832 \
 //y=5.335 //x2=78.895 //y2=7.585
cc_308 ( N_noxref_1_c_176_p N_VDD_c_11464_n ) capacitor c=0.00270108f //x=7.71 \
 //y=5.335 //x2=78.895 //y2=7.585
cc_309 ( N_noxref_1_c_11_p N_VDD_c_11464_n ) capacitor c=9.07241e-19 //x=11.22 \
 //y=4.88 //x2=78.895 //y2=7.585
cc_310 ( N_noxref_1_c_101_p N_VDD_c_11464_n ) capacitor c=0.0024232f //x=6.83 \
 //y=5.56 //x2=78.895 //y2=7.585
cc_311 ( N_noxref_1_c_178_p N_VDD_c_11464_n ) capacitor c=0.0024232f //x=7.71 \
 //y=5.56 //x2=78.895 //y2=7.585
cc_312 ( N_noxref_1_c_255_p N_VDD_c_11464_n ) capacitor c=0.0024232f //x=8.59 \
 //y=5.56 //x2=78.895 //y2=7.585
cc_313 ( N_noxref_1_c_12_p N_VDD_c_11464_n ) capacitor c=6.22888e-19 //x=11.22 \
 //y=4.88 //x2=78.895 //y2=7.585
cc_314 ( N_noxref_1_M58_noxref_g N_VDD_c_11477_n ) capacitor c=0.00755544f \
 //x=3.56 //y=6.2 //x2=4.135 //y2=7.585
cc_315 ( N_noxref_1_M59_noxref_g N_VDD_c_11477_n ) capacitor c=0.00755754f \
 //x=4 //y=6.2 //x2=4.135 //y2=7.585
cc_316 ( N_noxref_1_c_102_p N_VDD_c_11479_n ) capacitor c=0.00202922f //x=7.59 \
 //y=5.335 //x2=7.185 //y2=7.585
cc_317 ( N_noxref_1_c_26_p N_VDD_c_11479_n ) capacitor c=9.3757e-19 //x=6.832 \
 //y=5.335 //x2=7.185 //y2=7.585
cc_318 ( N_noxref_1_c_101_p N_VDD_c_11479_n ) capacitor c=0.0138074f //x=6.83 \
 //y=5.56 //x2=7.185 //y2=7.585
cc_319 ( N_noxref_1_c_102_p N_VDD_c_11482_n ) capacitor c=0.0017708f //x=7.59 \
 //y=5.335 //x2=8.065 //y2=7.585
cc_320 ( N_noxref_1_c_195_p N_VDD_c_11482_n ) capacitor c=0.00202922f \
 //x=8.475 //y=5.335 //x2=8.065 //y2=7.585
cc_321 ( N_noxref_1_c_176_p N_VDD_c_11482_n ) capacitor c=9.4822e-19 //x=7.71 \
 //y=5.335 //x2=8.065 //y2=7.585
cc_322 ( N_noxref_1_c_178_p N_VDD_c_11482_n ) capacitor c=0.0138074f //x=7.71 \
 //y=5.56 //x2=8.065 //y2=7.585
cc_323 ( N_noxref_1_c_195_p N_VDD_c_11486_n ) capacitor c=0.00205906f \
 //x=8.475 //y=5.335 //x2=8.945 //y2=7.585
cc_324 ( N_noxref_1_c_8_p N_VDD_c_11486_n ) capacitor c=8.49654e-19 //x=8.59 \
 //y=5.56 //x2=8.945 //y2=7.585
cc_325 ( N_noxref_1_c_9_p N_VDD_c_11486_n ) capacitor c=0.00204238f //x=9.285 \
 //y=5.335 //x2=8.945 //y2=7.585
cc_326 ( N_noxref_1_c_255_p N_VDD_c_11486_n ) capacitor c=0.0138074f //x=8.59 \
 //y=5.56 //x2=8.945 //y2=7.585
cc_327 ( N_noxref_1_c_9_p N_VDD_c_11490_n ) capacitor c=0.00183742f //x=9.285 \
 //y=5.335 //x2=9.94 //y2=7.585
cc_328 ( N_noxref_1_c_11_p N_VDD_c_11491_n ) capacitor c=6.28113e-19 //x=11.22 \
 //y=4.88 //x2=11.695 //y2=7.585
cc_329 ( N_noxref_1_M66_noxref_g N_VDD_c_11491_n ) capacitor c=0.00732618f \
 //x=11.12 //y=6.2 //x2=11.695 //y2=7.585
cc_330 ( N_noxref_1_M67_noxref_g N_VDD_c_11491_n ) capacitor c=0.00755544f \
 //x=11.56 //y=6.2 //x2=11.695 //y2=7.585
cc_331 ( N_noxref_1_c_26_p N_VDD_c_11494_n ) capacitor c=0.0022955f //x=6.832 \
 //y=5.335 //x2=5.3 //y2=7.585
cc_332 ( N_noxref_1_c_32_p N_VDD_c_11494_n ) capacitor c=0.00224736f //x=3.82 \
 //y=4.88 //x2=5.3 //y2=7.585
cc_333 ( N_noxref_1_c_101_p N_VDD_c_11494_n ) capacitor c=0.00509469f //x=6.83 \
 //y=5.56 //x2=5.3 //y2=7.585
cc_334 ( N_noxref_1_c_66_p N_VDD_c_11494_n ) capacitor c=2.63786e-19 //x=3.82 \
 //y=4.88 //x2=5.3 //y2=7.585
cc_335 ( N_noxref_1_c_8_p N_VDD_c_11498_n ) capacitor c=0.00269779f //x=8.59 \
 //y=5.56 //x2=10.11 //y2=7.585
cc_336 ( N_noxref_1_c_6_p N_VDD_c_11498_n ) capacitor c=0.0312736f //x=9.37 \
 //y=5.25 //x2=10.11 //y2=7.585
cc_337 ( N_noxref_1_c_11_p N_VDD_c_11498_n ) capacitor c=0.00447349f //x=11.22 \
 //y=4.88 //x2=10.11 //y2=7.585
cc_338 ( N_noxref_1_c_7_p N_VDD_c_11498_n ) capacitor c=0.00564116f //x=11.222 \
 //y=4.74 //x2=10.11 //y2=7.585
cc_339 ( N_noxref_1_c_255_p N_VDD_c_11498_n ) capacitor c=0.00776541f //x=8.59 \
 //y=5.56 //x2=10.11 //y2=7.585
cc_340 ( N_noxref_1_c_12_p N_VDD_c_11498_n ) capacitor c=0.00370494f //x=11.22 \
 //y=4.88 //x2=10.11 //y2=7.585
cc_341 ( N_noxref_1_c_15_p N_VDD_c_11498_n ) capacitor c=0.0129564f //x=11.22 \
 //y=4.88 //x2=10.11 //y2=7.585
cc_342 ( N_noxref_1_M58_noxref_g N_VDD_M57_noxref_d ) capacitor c=0.015318f \
 //x=3.56 //y=6.2 //x2=3.195 //y2=5.2
cc_343 ( N_noxref_1_M59_noxref_g N_VDD_M59_noxref_d ) capacitor c=0.0394719f \
 //x=4 //y=6.2 //x2=4.075 //y2=5.2
cc_344 ( N_noxref_1_c_26_p N_VDD_M60_noxref_s ) capacitor c=0.0441176f \
 //x=6.832 //y=5.335 //x2=6.255 //y2=5.2
cc_345 ( N_noxref_1_c_176_p N_VDD_M60_noxref_s ) capacitor c=7.80122e-19 \
 //x=7.71 //y=5.335 //x2=6.255 //y2=5.2
cc_346 ( N_noxref_1_c_101_p N_VDD_M60_noxref_s ) capacitor c=0.09305f //x=6.83 \
 //y=5.56 //x2=6.255 //y2=5.2
cc_347 ( N_noxref_1_c_102_p N_VDD_M61_noxref_d ) capacitor c=0.00700141f \
 //x=7.59 //y=5.335 //x2=7.125 //y2=5.2
cc_348 ( N_noxref_1_c_101_p N_VDD_M61_noxref_d ) capacitor c=0.0674491f \
 //x=6.83 //y=5.56 //x2=7.125 //y2=5.2
cc_349 ( N_noxref_1_c_178_p N_VDD_M61_noxref_d ) capacitor c=0.0674762f \
 //x=7.71 //y=5.56 //x2=7.125 //y2=5.2
cc_350 ( N_noxref_1_c_195_p N_VDD_M63_noxref_d ) capacitor c=0.00700141f \
 //x=8.475 //y=5.335 //x2=8.005 //y2=5.2
cc_351 ( N_noxref_1_c_178_p N_VDD_M63_noxref_d ) capacitor c=0.067493f \
 //x=7.71 //y=5.56 //x2=8.005 //y2=5.2
cc_352 ( N_noxref_1_c_255_p N_VDD_M63_noxref_d ) capacitor c=0.0674288f \
 //x=8.59 //y=5.56 //x2=8.005 //y2=5.2
cc_353 ( N_noxref_1_c_9_p N_VDD_M65_noxref_d ) capacitor c=0.00700141f \
 //x=9.285 //y=5.335 //x2=8.885 //y2=5.2
cc_354 ( N_noxref_1_c_255_p N_VDD_M65_noxref_d ) capacitor c=0.0673824f \
 //x=8.59 //y=5.56 //x2=8.885 //y2=5.2
cc_355 ( N_noxref_1_c_8_p N_VDD_M66_noxref_s ) capacitor c=0.00536022f \
 //x=8.59 //y=5.56 //x2=10.765 //y2=5.2
cc_356 ( N_noxref_1_c_9_p N_VDD_M66_noxref_s ) capacitor c=0.00211796f \
 //x=9.285 //y=5.335 //x2=10.765 //y2=5.2
cc_357 ( N_noxref_1_c_10_p N_VDD_M66_noxref_s ) capacitor c=0.00111275f \
 //x=11.22 //y=3.67 //x2=10.765 //y2=5.2
cc_358 ( N_noxref_1_M66_noxref_g N_VDD_M66_noxref_s ) capacitor c=0.0567929f \
 //x=11.12 //y=6.2 //x2=10.765 //y2=5.2
cc_359 ( N_noxref_1_M67_noxref_g N_VDD_M67_noxref_d ) capacitor c=0.015318f \
 //x=11.56 //y=6.2 //x2=11.635 //y2=5.2
cc_360 ( N_noxref_1_c_52_p N_noxref_20_c_12860_n ) capacitor c=0.00177186f \
 //x=3.82 //y=2.375 //x2=4.475 //y2=0.72
cc_361 ( N_noxref_1_c_59_p N_noxref_20_c_12860_n ) capacitor c=0.00117306f \
 //x=3.82 //y=2.26 //x2=4.475 //y2=0.72
cc_362 ( N_noxref_1_c_35_p N_noxref_20_c_12860_n ) capacitor c=0.0206349f \
 //x=3.81 //y=1.095 //x2=4.475 //y2=0.72
cc_363 ( N_noxref_1_c_39_p N_noxref_20_c_12860_n ) capacitor c=0.00825432f \
 //x=4.34 //y=1.095 //x2=4.475 //y2=0.72
cc_364 ( N_noxref_1_c_60_p N_noxref_20_c_12860_n ) capacitor c=2.20712e-19 \
 //x=3.82 //y=2.26 //x2=4.475 //y2=0.72
cc_365 ( N_noxref_1_c_36_p N_noxref_20_c_12865_n ) capacitor c=0.0071177f \
 //x=3.81 //y=1.44 //x2=3.59 //y2=1.175
cc_366 ( N_noxref_1_c_35_p N_noxref_20_M2_noxref_s ) capacitor c=0.0071177f \
 //x=3.81 //y=1.095 //x2=3.455 //y2=0.555
cc_367 ( N_noxref_1_c_42_p N_noxref_20_M2_noxref_s ) capacitor c=0.0071177f \
 //x=3.81 //y=1.75 //x2=3.455 //y2=0.555
cc_368 ( N_noxref_1_c_39_p N_noxref_20_M2_noxref_s ) capacitor c=0.015333f \
 //x=4.34 //y=1.095 //x2=3.455 //y2=0.555
cc_369 ( N_noxref_1_c_40_p N_noxref_20_M2_noxref_s ) capacitor c=0.00248746f \
 //x=4.34 //y=1.44 //x2=3.455 //y2=0.555
cc_370 ( N_noxref_1_c_16_p N_noxref_21_c_12923_n ) capacitor c=0.0036878f \
 //x=8.885 //y=1.305 //x2=9.285 //y2=0.72
cc_371 ( N_noxref_1_c_3_p N_noxref_21_c_12923_n ) capacitor c=0.00399931f \
 //x=9.285 //y=1.845 //x2=9.285 //y2=0.72
cc_372 ( N_noxref_1_M5_noxref_d N_noxref_21_c_12923_n ) capacitor \
 c=0.00910163f //x=8.695 //y=1.095 //x2=9.285 //y2=0.72
cc_373 ( N_noxref_1_M5_noxref_d N_noxref_21_c_12926_n ) capacitor \
 c=0.00120711f //x=8.695 //y=1.095 //x2=8.4 //y2=1.175
cc_374 ( N_noxref_1_c_102_p N_noxref_21_M4_noxref_d ) capacitor c=0.0013469f \
 //x=7.59 //y=5.335 //x2=7.16 //y2=1.09
cc_375 ( N_noxref_1_c_16_p N_noxref_21_M4_noxref_d ) capacitor c=0.00802836f \
 //x=8.885 //y=1.305 //x2=7.16 //y2=1.09
cc_376 ( N_noxref_1_c_71_p N_noxref_21_M4_noxref_d ) capacitor c=0.00333505f \
 //x=9.535 //y=3.51 //x2=7.16 //y2=1.09
cc_377 ( N_noxref_1_c_16_p N_noxref_21_M5_noxref_s ) capacitor c=0.00993092f \
 //x=8.885 //y=1.305 //x2=8.265 //y2=0.555
cc_378 ( N_noxref_1_c_2_p N_noxref_21_M5_noxref_s ) capacitor c=0.0270624f \
 //x=8.885 //y=1.76 //x2=8.265 //y2=0.555
cc_379 ( N_noxref_1_c_3_p N_noxref_21_M5_noxref_s ) capacitor c=0.00871957f \
 //x=9.285 //y=1.845 //x2=8.265 //y2=0.555
cc_380 ( N_noxref_1_c_246_p N_noxref_21_M5_noxref_s ) capacitor c=0.0016218f \
 //x=9.37 //y=3.51 //x2=8.265 //y2=0.555
cc_381 ( N_noxref_1_M5_noxref_d N_noxref_21_M5_noxref_s ) capacitor \
 c=0.0279003f //x=8.695 //y=1.095 //x2=8.265 //y2=0.555
cc_382 ( N_noxref_1_c_52_p N_GND_c_13951_n ) capacitor c=0.0021992f //x=3.82 \
 //y=2.375 //x2=6.29 //y2=0.175
cc_383 ( N_noxref_1_c_16_p N_GND_c_13952_n ) capacitor c=0.00883621f //x=8.885 \
 //y=1.305 //x2=11.205 //y2=0.175
cc_384 ( N_noxref_1_c_3_p N_GND_c_13952_n ) capacitor c=0.00662992f //x=9.285 \
 //y=1.845 //x2=11.205 //y2=0.175
cc_385 ( N_noxref_1_c_80_p N_GND_c_13952_n ) capacitor c=2.94824e-19 //x=9.37 \
 //y=3.67 //x2=11.205 //y2=0.175
cc_386 ( N_noxref_1_M5_noxref_d N_GND_c_13952_n ) capacitor c=2.9462e-19 \
 //x=8.695 //y=1.095 //x2=11.205 //y2=0.175
cc_387 ( N_noxref_1_c_67_p N_GND_c_13956_n ) capacitor c=0.00246332f //x=6.63 \
 //y=3.495 //x2=6.375 //y2=1.145
cc_388 ( N_noxref_1_c_16_p N_GND_c_13957_n ) capacitor c=0.00488628f //x=8.885 \
 //y=1.305 //x2=11.29 //y2=1.135
cc_389 ( N_noxref_1_c_131_p N_GND_c_13957_n ) capacitor c=0.00645051f \
 //x=11.22 //y=2.26 //x2=11.29 //y2=1.135
cc_390 ( N_noxref_1_c_123_p N_GND_c_13957_n ) capacitor c=2.13705e-19 \
 //x=11.22 //y=2.26 //x2=11.29 //y2=1.135
cc_391 ( N_noxref_1_c_155_p N_GND_c_13957_n ) capacitor c=0.00176535f \
 //x=11.025 //y=1.045 //x2=11.29 //y2=1.135
cc_392 ( N_noxref_1_c_156_p N_GND_c_13957_n ) capacitor c=0.0036005f \
 //x=11.025 //y=1.39 //x2=11.29 //y2=1.135
cc_393 ( N_noxref_1_c_158_p N_GND_c_13957_n ) capacitor c=4.2764e-19 \
 //x=11.025 //y=1.7 //x2=11.29 //y2=1.135
cc_394 ( N_noxref_1_c_394_p N_GND_c_13957_n ) capacitor c=9.36995e-19 //x=11.4 \
 //y=0.89 //x2=11.29 //y2=1.135
cc_395 ( N_noxref_1_c_395_p N_GND_c_13957_n ) capacitor c=6.27472e-19 //x=11.4 \
 //y=1.545 //x2=11.29 //y2=1.135
cc_396 ( N_noxref_1_c_157_p N_GND_c_13957_n ) capacitor c=0.00171483f \
 //x=11.555 //y=1.045 //x2=11.29 //y2=1.135
cc_397 ( N_noxref_1_c_159_p N_GND_c_13957_n ) capacitor c=0.00296337f \
 //x=11.555 //y=1.39 //x2=11.29 //y2=1.135
cc_398 ( N_noxref_1_c_155_p N_GND_c_13967_n ) capacitor c=3.51399e-19 \
 //x=11.025 //y=1.045 //x2=11.287 //y2=1.005
cc_399 ( N_noxref_1_c_394_p N_GND_c_13967_n ) capacitor c=0.00850983f //x=11.4 \
 //y=0.89 //x2=11.287 //y2=1.005
cc_400 ( N_noxref_1_c_157_p N_GND_c_13967_n ) capacitor c=4.40196e-19 \
 //x=11.555 //y=1.045 //x2=11.287 //y2=1.005
cc_401 ( N_noxref_1_c_52_p N_GND_c_13970_n ) capacitor c=2.016e-19 //x=3.82 \
 //y=2.375 //x2=5.13 //y2=0.175
cc_402 ( N_noxref_1_c_3_p N_GND_c_13971_n ) capacitor c=6.86343e-19 //x=9.285 \
 //y=1.845 //x2=9.94 //y2=0.175
cc_403 ( N_noxref_1_c_80_p N_GND_c_13971_n ) capacitor c=4.02711e-19 //x=9.37 \
 //y=3.67 //x2=9.94 //y2=0.175
cc_404 ( N_noxref_1_c_155_p N_GND_c_13973_n ) capacitor c=0.00688027f \
 //x=11.025 //y=1.045 //x2=13.27 //y2=0.175
cc_405 ( N_noxref_1_c_69_p N_GND_c_13974_n ) capacitor c=0.00560367f //x=6.03 \
 //y=3.51 //x2=5.3 //y2=0.175
cc_406 ( N_noxref_1_c_59_p N_GND_c_13974_n ) capacitor c=0.00246191f //x=3.82 \
 //y=2.26 //x2=5.3 //y2=0.175
cc_407 ( N_noxref_1_c_40_p N_GND_c_13974_n ) capacitor c=0.00262688f //x=4.34 \
 //y=1.44 //x2=5.3 //y2=0.175
cc_408 ( N_noxref_1_c_2_p N_GND_c_13977_n ) capacitor c=0.00285697f //x=8.885 \
 //y=1.76 //x2=10.11 //y2=0.175
cc_409 ( N_noxref_1_c_3_p N_GND_c_13977_n ) capacitor c=0.0289308f //x=9.285 \
 //y=1.845 //x2=10.11 //y2=0.175
cc_410 ( N_noxref_1_c_5_p N_GND_c_13977_n ) capacitor c=0.00670922f //x=11.22 \
 //y=3.35 //x2=10.11 //y2=0.175
cc_411 ( N_noxref_1_c_131_p N_GND_c_13977_n ) capacitor c=0.00386815f \
 //x=11.22 //y=2.26 //x2=10.11 //y2=0.175
cc_412 ( N_noxref_1_c_82_p N_GND_c_13977_n ) capacitor c=0.00341388f //x=11.06 \
 //y=3.51 //x2=10.11 //y2=0.175
cc_413 ( N_noxref_1_c_123_p N_GND_c_13977_n ) capacitor c=0.00371068f \
 //x=11.22 //y=2.26 //x2=10.11 //y2=0.175
cc_414 ( N_noxref_1_c_158_p N_GND_c_13977_n ) capacitor c=0.0015404f \
 //x=11.025 //y=1.7 //x2=10.11 //y2=0.175
cc_415 ( N_noxref_1_c_133_p N_GND_c_13977_n ) capacitor c=0.0093907f \
 //x=11.025 //y=2.095 //x2=10.11 //y2=0.175
cc_416 ( N_noxref_1_c_131_p N_GND_M6_noxref_d ) capacitor c=2.20438e-19 \
 //x=11.22 //y=2.26 //x2=11.1 //y2=1.045
cc_417 ( N_noxref_1_c_155_p N_GND_M6_noxref_d ) capacitor c=0.00192399f \
 //x=11.025 //y=1.045 //x2=11.1 //y2=1.045
cc_418 ( N_noxref_1_c_156_p N_GND_M6_noxref_d ) capacitor c=0.00210798f \
 //x=11.025 //y=1.39 //x2=11.1 //y2=1.045
cc_419 ( N_noxref_1_c_394_p N_GND_M6_noxref_d ) capacitor c=0.00472259f \
 //x=11.4 //y=0.89 //x2=11.1 //y2=1.045
cc_420 ( N_noxref_1_c_395_p N_GND_M6_noxref_d ) capacitor c=0.00166857f \
 //x=11.4 //y=1.545 //x2=11.1 //y2=1.045
cc_421 ( N_noxref_1_c_157_p N_GND_M6_noxref_d ) capacitor c=0.00230174f \
 //x=11.555 //y=1.045 //x2=11.1 //y2=1.045
cc_422 ( N_noxref_1_c_159_p N_GND_M6_noxref_d ) capacitor c=0.00210798f \
 //x=11.555 //y=1.39 //x2=11.1 //y2=1.045
cc_423 ( N_noxref_1_c_69_p N_noxref_36_c_15589_n ) capacitor c=0.00270802f \
 //x=6.03 //y=3.51 //x2=5.89 //y2=1.685
cc_424 ( N_noxref_1_c_69_p N_noxref_36_c_15590_n ) capacitor c=0.00776697f \
 //x=6.03 //y=3.51 //x2=6.775 //y2=1.77
cc_425 ( N_noxref_1_c_71_p N_noxref_36_c_15590_n ) capacitor c=8.84534e-19 \
 //x=9.535 //y=3.51 //x2=6.775 //y2=1.77
cc_426 ( N_noxref_1_c_71_p N_noxref_36_c_15592_n ) capacitor c=0.00562506f \
 //x=9.535 //y=3.51 //x2=7.745 //y2=1.77
cc_427 ( N_noxref_1_c_71_p N_noxref_36_M3_noxref_s ) capacitor c=0.0026208f \
 //x=9.535 //y=3.51 //x2=5.755 //y2=0.555
cc_428 ( N_noxref_1_c_133_p N_noxref_37_c_15649_n ) capacitor c=0.00262672f \
 //x=11.025 //y=2.095 //x2=10.805 //y2=1.675
cc_429 ( N_noxref_1_c_10_p N_noxref_37_c_15650_n ) capacitor c=0.00406558f \
 //x=11.22 //y=3.67 //x2=11.69 //y2=1.76
cc_430 ( N_noxref_1_c_131_p N_noxref_37_c_15650_n ) capacitor c=0.00509504f \
 //x=11.22 //y=2.26 //x2=11.69 //y2=1.76
cc_431 ( N_noxref_1_c_123_p N_noxref_37_c_15650_n ) capacitor c=0.00763108f \
 //x=11.22 //y=2.26 //x2=11.69 //y2=1.76
cc_432 ( N_noxref_1_c_158_p N_noxref_37_c_15650_n ) capacitor c=0.00697076f \
 //x=11.025 //y=1.7 //x2=11.69 //y2=1.76
cc_433 ( N_noxref_1_c_133_p N_noxref_37_c_15650_n ) capacitor c=0.0170561f \
 //x=11.025 //y=2.095 //x2=11.69 //y2=1.76
cc_434 ( N_noxref_1_c_395_p N_noxref_37_c_15650_n ) capacitor c=0.00723574f \
 //x=11.4 //y=1.545 //x2=11.69 //y2=1.76
cc_435 ( N_noxref_1_c_159_p N_noxref_37_c_15650_n ) capacitor c=0.00339872f \
 //x=11.555 //y=1.39 //x2=11.69 //y2=1.76
cc_436 ( N_noxref_1_c_133_p N_noxref_37_c_15657_n ) capacitor c=6.71402e-19 \
 //x=11.025 //y=2.095 //x2=11.775 //y2=1.675
cc_437 ( N_noxref_1_c_155_p N_noxref_37_M6_noxref_s ) capacitor c=0.0295366f \
 //x=11.025 //y=1.045 //x2=10.67 //y2=0.545
cc_438 ( N_noxref_1_c_158_p N_noxref_37_M6_noxref_s ) capacitor c=3.48408e-19 \
 //x=11.025 //y=1.7 //x2=10.67 //y2=0.545
cc_439 ( N_noxref_1_c_157_p N_noxref_37_M6_noxref_s ) capacitor c=0.0125442f \
 //x=11.555 //y=1.045 //x2=10.67 //y2=0.545
cc_440 ( N_noxref_2_c_463_p N_noxref_3_c_806_n ) capacitor c=0.0013819f \
 //x=12.7 //y=3.675 //x2=12.18 //y2=3.865
cc_441 ( N_noxref_2_c_445_n N_noxref_3_c_806_n ) capacitor c=0.00113794f \
 //x=12.7 //y=5.295 //x2=12.18 //y2=3.865
cc_442 ( N_noxref_2_c_457_n N_noxref_3_c_806_n ) capacitor c=0.0358254f \
 //x=12.86 //y=3.515 //x2=12.18 //y2=3.865
cc_443 ( N_noxref_2_c_463_p N_noxref_3_c_809_n ) capacitor c=0.00694169f \
 //x=12.7 //y=3.675 //x2=12.915 //y2=3.9
cc_444 ( N_noxref_2_c_445_n N_noxref_3_c_809_n ) capacitor c=0.022395f \
 //x=12.7 //y=5.295 //x2=12.915 //y2=3.9
cc_445 ( N_noxref_2_c_468_p N_noxref_3_c_809_n ) capacitor c=0.128042f \
 //x=14.395 //y=3.515 //x2=12.915 //y2=3.9
cc_446 ( N_noxref_2_c_469_p N_noxref_3_c_812_n ) capacitor c=0.00342064f \
 //x=14.55 //y=3.675 //x2=14.17 //y2=3.88
cc_447 ( N_noxref_2_c_470_p N_noxref_3_c_812_n ) capacitor c=6.75872e-19 \
 //x=14.55 //y=4.755 //x2=14.17 //y2=3.88
cc_448 ( N_noxref_2_c_471_p N_noxref_3_c_812_n ) capacitor c=0.0358254f \
 //x=14.555 //y=3.515 //x2=14.17 //y2=3.88
cc_449 ( N_noxref_2_c_468_p N_noxref_3_c_812_n ) capacitor c=0.0106805f \
 //x=14.395 //y=3.515 //x2=14.17 //y2=3.88
cc_450 ( N_noxref_2_c_469_p N_noxref_3_c_816_n ) capacitor c=0.00292429f \
 //x=14.55 //y=3.675 //x2=14.77 //y2=3.9
cc_451 ( N_noxref_2_c_470_p N_noxref_3_c_816_n ) capacitor c=0.023831f \
 //x=14.55 //y=4.755 //x2=14.77 //y2=3.9
cc_452 ( N_noxref_2_c_443_n N_noxref_4_c_1199_n ) capacitor c=0.0400117f \
 //x=12.7 //y=3.355 //x2=11.96 //y2=4.09
cc_453 ( N_noxref_2_c_463_p N_noxref_4_c_1199_n ) capacitor c=0.0148501f \
 //x=12.7 //y=3.675 //x2=11.96 //y2=4.09
cc_454 ( N_noxref_2_c_445_n N_noxref_4_c_1199_n ) capacitor c=0.0164753f \
 //x=12.7 //y=5.295 //x2=11.96 //y2=4.09
cc_455 ( N_noxref_2_c_478_p N_noxref_4_c_1199_n ) capacitor c=0.00132815f \
 //x=14.55 //y=3.355 //x2=11.96 //y2=4.09
cc_456 ( N_noxref_2_c_470_p N_noxref_4_c_1199_n ) capacitor c=3.22894e-19 \
 //x=14.55 //y=4.755 //x2=11.96 //y2=4.09
cc_457 ( N_noxref_2_c_456_n N_noxref_4_c_1199_n ) capacitor c=5.57251e-19 \
 //x=12.7 //y=3.51 //x2=11.96 //y2=4.09
cc_458 ( N_noxref_2_c_457_n N_noxref_4_c_1199_n ) capacitor c=0.00365657f \
 //x=12.86 //y=3.515 //x2=11.96 //y2=4.09
cc_459 ( N_noxref_2_c_440_n N_noxref_4_c_1207_n ) capacitor c=0.00424065f \
 //x=12.105 //y=5.38 //x2=11.96 //y2=4.41
cc_460 ( N_noxref_2_c_445_n N_noxref_4_c_1207_n ) capacitor c=0.0147977f \
 //x=12.7 //y=5.295 //x2=11.96 //y2=4.41
cc_461 ( N_noxref_2_c_440_n N_noxref_4_c_1208_n ) capacitor c=0.0215376f \
 //x=12.105 //y=5.38 //x2=11.96 //y2=4.735
cc_462 ( N_noxref_2_c_445_n N_noxref_4_c_1208_n ) capacitor c=0.0284267f \
 //x=12.7 //y=5.295 //x2=11.96 //y2=4.735
cc_463 ( N_noxref_2_c_470_p N_noxref_4_c_1208_n ) capacitor c=4.6204e-19 \
 //x=14.55 //y=4.755 //x2=11.96 //y2=4.735
cc_464 ( N_noxref_2_M71_noxref_g N_noxref_4_c_1266_n ) capacitor c=0.00893512f \
 //x=15.19 //y=6.2 //x2=15.73 //y2=5.335
cc_465 ( N_noxref_2_c_488_p N_noxref_4_c_1267_n ) capacitor c=8.29536e-19 \
 //x=12.615 //y=1.835 //x2=17.025 //y2=1.76
cc_466 ( N_noxref_2_c_443_n N_noxref_4_c_1268_n ) capacitor c=8.29536e-19 \
 //x=12.7 //y=3.355 //x2=17.11 //y2=1.845
cc_467 ( N_noxref_2_c_445_n N_noxref_4_c_1213_n ) capacitor c=6.15063e-19 \
 //x=12.7 //y=5.295 //x2=11.96 //y2=4.25
cc_468 ( N_noxref_2_c_443_n N_noxref_4_c_1214_n ) capacitor c=0.0138368f \
 //x=12.7 //y=3.355 //x2=11.96 //y2=2.26
cc_469 ( N_noxref_2_c_445_n N_noxref_4_c_1271_n ) capacitor c=0.00261914f \
 //x=12.7 //y=5.295 //x2=14.972 //y2=5.335
cc_470 ( N_noxref_2_c_493_p N_noxref_4_c_1271_n ) capacitor c=5.0812e-19 \
 //x=12.22 //y=5.38 //x2=14.972 //y2=5.335
cc_471 ( N_noxref_2_M70_noxref_g N_noxref_4_c_1271_n ) capacitor c=0.00461408f \
 //x=14.75 //y=6.2 //x2=14.972 //y2=5.335
cc_472 ( N_noxref_2_M71_noxref_g N_noxref_4_c_1271_n ) capacitor c=0.00229208f \
 //x=15.19 //y=6.2 //x2=14.972 //y2=5.335
cc_473 ( N_noxref_2_c_496_p N_noxref_4_c_1271_n ) capacitor c=0.00171885f \
 //x=15.115 //y=4.97 //x2=14.972 //y2=5.335
cc_474 ( N_noxref_2_c_445_n N_noxref_4_c_1276_n ) capacitor c=0.022727f \
 //x=12.7 //y=5.295 //x2=17.355 //y2=4.25
cc_475 ( N_noxref_2_c_470_p N_noxref_4_c_1276_n ) capacitor c=0.0246035f \
 //x=14.55 //y=4.755 //x2=17.355 //y2=4.25
cc_476 ( N_noxref_2_c_468_p N_noxref_4_c_1276_n ) capacitor c=0.0103367f \
 //x=14.395 //y=3.515 //x2=17.355 //y2=4.25
cc_477 ( N_noxref_2_c_445_n N_noxref_4_c_1224_n ) capacitor c=0.00328982f \
 //x=12.7 //y=5.295 //x2=12.125 //y2=4.25
cc_478 ( N_noxref_2_c_443_n N_noxref_4_c_1228_n ) capacitor c=9.26054e-19 \
 //x=12.7 //y=3.355 //x2=11.96 //y2=2.26
cc_479 ( N_noxref_2_c_440_n N_noxref_4_c_1232_n ) capacitor c=0.00469257f \
 //x=12.105 //y=5.38 //x2=11.99 //y2=4.88
cc_480 ( N_noxref_2_c_445_n N_noxref_4_c_1232_n ) capacitor c=7.76118e-19 \
 //x=12.7 //y=5.295 //x2=11.99 //y2=4.88
cc_481 ( N_noxref_2_M70_noxref_g N_noxref_4_c_1283_n ) capacitor c=0.0162284f \
 //x=14.75 //y=6.2 //x2=14.97 //y2=5.56
cc_482 ( N_noxref_2_M71_noxref_g N_noxref_4_c_1283_n ) capacitor c=0.0179041f \
 //x=15.19 //y=6.2 //x2=14.97 //y2=5.56
cc_483 ( N_noxref_2_c_496_p N_noxref_4_c_1283_n ) capacitor c=0.00291477f \
 //x=15.115 //y=4.97 //x2=14.97 //y2=5.56
cc_484 ( N_noxref_2_c_440_n N_noxref_4_M68_noxref_g ) capacitor c=0.00842859f \
 //x=12.105 //y=5.38 //x2=12 //y2=6.2
cc_485 ( N_noxref_2_c_493_p N_noxref_4_M68_noxref_g ) capacitor c=0.00192712f \
 //x=12.22 //y=5.38 //x2=12 //y2=6.2
cc_486 ( N_noxref_2_c_509_p N_noxref_4_M68_noxref_g ) capacitor c=0.0178987f \
 //x=12.22 //y=5.56 //x2=12 //y2=6.2
cc_487 ( N_noxref_2_c_510_p N_noxref_4_M69_noxref_g ) capacitor c=0.0106088f \
 //x=12.615 //y=5.38 //x2=12.44 //y2=6.2
cc_488 ( N_noxref_2_c_493_p N_noxref_4_M69_noxref_g ) capacitor c=0.00312463f \
 //x=12.22 //y=5.38 //x2=12.44 //y2=6.2
cc_489 ( N_noxref_2_c_509_p N_noxref_4_M69_noxref_g ) capacitor c=0.0178506f \
 //x=12.22 //y=5.56 //x2=12.44 //y2=6.2
cc_490 ( N_noxref_2_c_455_n N_noxref_4_c_1238_n ) capacitor c=0.00120406f \
 //x=12.26 //y=1.18 //x2=11.995 //y2=1.085
cc_491 ( N_noxref_2_M7_noxref_d N_noxref_4_c_1238_n ) capacitor c=0.00137165f \
 //x=12.07 //y=1.085 //x2=11.995 //y2=1.085
cc_492 ( N_noxref_2_c_441_n N_noxref_4_c_1241_n ) capacitor c=0.00119302f \
 //x=12.26 //y=1.75 //x2=11.995 //y2=1.43
cc_493 ( N_noxref_2_c_455_n N_noxref_4_c_1241_n ) capacitor c=0.00218772f \
 //x=12.26 //y=1.18 //x2=11.995 //y2=1.43
cc_494 ( N_noxref_2_M7_noxref_d N_noxref_4_c_1241_n ) capacitor c=0.00237422f \
 //x=12.07 //y=1.085 //x2=11.995 //y2=1.43
cc_495 ( N_noxref_2_c_441_n N_noxref_4_c_1243_n ) capacitor c=0.00439215f \
 //x=12.26 //y=1.75 //x2=11.995 //y2=1.74
cc_496 ( N_noxref_2_c_445_n N_noxref_4_c_1298_n ) capacitor c=0.00845606f \
 //x=12.7 //y=5.295 //x2=12.365 //y2=4.97
cc_497 ( N_noxref_2_c_493_p N_noxref_4_c_1298_n ) capacitor c=0.0020909f \
 //x=12.22 //y=5.38 //x2=12.365 //y2=4.97
cc_498 ( N_noxref_2_c_509_p N_noxref_4_c_1298_n ) capacitor c=0.00291714f \
 //x=12.22 //y=5.56 //x2=12.365 //y2=4.97
cc_499 ( N_noxref_2_c_455_n N_noxref_4_c_1301_n ) capacitor c=5.50523e-19 \
 //x=12.26 //y=1.18 //x2=12.37 //y2=0.93
cc_500 ( N_noxref_2_M7_noxref_d N_noxref_4_c_1301_n ) capacitor c=0.0020782f \
 //x=12.07 //y=1.085 //x2=12.37 //y2=0.93
cc_501 ( N_noxref_2_c_441_n N_noxref_4_c_1303_n ) capacitor c=0.00929773f \
 //x=12.26 //y=1.75 //x2=12.37 //y2=1.585
cc_502 ( N_noxref_2_c_488_p N_noxref_4_c_1303_n ) capacitor c=0.00194324f \
 //x=12.615 //y=1.835 //x2=12.37 //y2=1.585
cc_503 ( N_noxref_2_c_455_n N_noxref_4_c_1303_n ) capacitor c=5.67071e-19 \
 //x=12.26 //y=1.18 //x2=12.37 //y2=1.585
cc_504 ( N_noxref_2_M7_noxref_d N_noxref_4_c_1303_n ) capacitor c=0.00356097f \
 //x=12.07 //y=1.085 //x2=12.37 //y2=1.585
cc_505 ( N_noxref_2_c_455_n N_noxref_4_c_1246_n ) capacitor c=0.00108157f \
 //x=12.26 //y=1.18 //x2=12.525 //y2=1.085
cc_506 ( N_noxref_2_M7_noxref_d N_noxref_4_c_1246_n ) capacitor c=8.50095e-19 \
 //x=12.07 //y=1.085 //x2=12.525 //y2=1.085
cc_507 ( N_noxref_2_c_441_n N_noxref_4_c_1247_n ) capacitor c=0.00341295f \
 //x=12.26 //y=1.75 //x2=12.525 //y2=1.43
cc_508 ( N_noxref_2_c_488_p N_noxref_4_c_1247_n ) capacitor c=0.00323005f \
 //x=12.615 //y=1.835 //x2=12.525 //y2=1.43
cc_509 ( N_noxref_2_c_455_n N_noxref_4_c_1247_n ) capacitor c=0.00312028f \
 //x=12.26 //y=1.18 //x2=12.525 //y2=1.43
cc_510 ( N_noxref_2_M7_noxref_d N_noxref_4_c_1247_n ) capacitor c=0.00237422f \
 //x=12.07 //y=1.085 //x2=12.525 //y2=1.43
cc_511 ( N_noxref_2_c_443_n N_noxref_4_c_1248_n ) capacitor c=0.00268898f \
 //x=12.7 //y=3.355 //x2=11.96 //y2=2.26
cc_512 ( N_noxref_2_c_441_n N_noxref_4_c_1314_n ) capacitor c=0.00341688f \
 //x=12.26 //y=1.75 //x2=11.96 //y2=2.095
cc_513 ( N_noxref_2_c_443_n N_noxref_4_c_1314_n ) capacitor c=0.00309058f \
 //x=12.7 //y=3.355 //x2=11.96 //y2=2.095
cc_514 ( N_noxref_2_c_440_n N_noxref_4_c_1251_n ) capacitor c=8.42507e-19 \
 //x=12.105 //y=5.38 //x2=11.99 //y2=4.88
cc_515 ( N_noxref_2_c_445_n N_noxref_4_c_1251_n ) capacitor c=0.00142201f \
 //x=12.7 //y=5.295 //x2=11.99 //y2=4.88
cc_516 ( N_noxref_2_c_443_n N_D_c_4197_n ) capacitor c=0.0255954f //x=12.7 \
 //y=3.355 //x2=33.26 //y2=2.755
cc_517 ( N_noxref_2_c_463_p N_D_c_4197_n ) capacitor c=0.00463064f //x=12.7 \
 //y=3.675 //x2=33.26 //y2=2.755
cc_518 ( N_noxref_2_c_478_p N_D_c_4197_n ) capacitor c=0.0270252f //x=14.55 \
 //y=3.355 //x2=33.26 //y2=2.755
cc_519 ( N_noxref_2_c_469_p N_D_c_4197_n ) capacitor c=0.00465071f //x=14.55 \
 //y=3.675 //x2=33.26 //y2=2.755
cc_520 ( N_noxref_2_c_457_n N_D_c_4197_n ) capacitor c=0.0154975f //x=12.86 \
 //y=3.515 //x2=33.26 //y2=2.755
cc_521 ( N_noxref_2_c_471_p N_D_c_4197_n ) capacitor c=0.015523f //x=14.555 \
 //y=3.515 //x2=33.26 //y2=2.755
cc_522 ( N_noxref_2_c_468_p N_D_c_4197_n ) capacitor c=0.0690402f //x=14.395 \
 //y=3.515 //x2=33.26 //y2=2.755
cc_523 ( N_noxref_2_c_443_n CLK ) capacitor c=9.36553e-19 //x=12.7 //y=3.355 \
 //x2=15.66 //y2=3.14
cc_524 ( N_noxref_2_c_445_n CLK ) capacitor c=7.56903e-19 //x=12.7 //y=5.295 \
 //x2=15.66 //y2=3.14
cc_525 ( N_noxref_2_c_478_p CLK ) capacitor c=0.0256396f //x=14.55 //y=3.355 \
 //x2=15.66 //y2=3.14
cc_526 ( N_noxref_2_c_469_p CLK ) capacitor c=0.00781344f //x=14.55 //y=3.675 \
 //x2=15.66 //y2=3.14
cc_527 ( N_noxref_2_c_470_p CLK ) capacitor c=0.0204064f //x=14.55 //y=4.755 \
 //x2=15.66 //y2=3.14
cc_528 ( N_noxref_2_c_551_p CLK ) capacitor c=2.98349e-19 //x=14.55 //y=3.51 \
 //x2=15.66 //y2=3.14
cc_529 ( N_noxref_2_c_471_p CLK ) capacitor c=0.00510347f //x=14.555 //y=3.515 \
 //x2=15.66 //y2=3.14
cc_530 ( N_noxref_2_c_553_p CLK ) capacitor c=3.9149e-19 //x=14.55 //y=2.26 \
 //x2=15.66 //y2=3.14
cc_531 ( N_noxref_2_c_554_p N_CLK_c_4812_n ) capacitor c=0.00894339f //x=14.55 \
 //y=2.375 //x2=15.66 //y2=2.375
cc_532 ( N_noxref_2_c_553_p N_CLK_c_4812_n ) capacitor c=5.40058e-19 //x=14.55 \
 //y=2.26 //x2=15.66 //y2=2.375
cc_533 ( N_noxref_2_c_556_p N_CLK_c_4812_n ) capacitor c=0.00142893f //x=14.25 \
 //y=2.095 //x2=15.66 //y2=2.375
cc_534 ( N_noxref_2_c_470_p N_CLK_c_4815_n ) capacitor c=0.0128897f //x=14.55 \
 //y=4.755 //x2=15.655 //y2=4.695
cc_535 ( N_noxref_2_c_558_p N_CLK_c_4815_n ) capacitor c=8.3916e-19 //x=14.55 \
 //y=4.88 //x2=15.655 //y2=4.695
cc_536 ( N_noxref_2_c_496_p N_CLK_c_4815_n ) capacitor c=7.66769e-19 \
 //x=15.115 //y=4.97 //x2=15.655 //y2=4.695
cc_537 ( N_noxref_2_c_560_p N_CLK_c_4815_n ) capacitor c=9.07197e-19 \
 //x=14.825 //y=4.97 //x2=15.655 //y2=4.695
cc_538 ( N_noxref_2_c_440_n N_CLK_c_4775_n ) capacitor c=0.00653719f \
 //x=12.105 //y=5.38 //x2=11.58 //y2=4.62
cc_539 ( N_noxref_2_c_447_n N_CLK_c_4775_n ) capacitor c=0.0154492f //x=11.34 \
 //y=5.56 //x2=11.58 //y2=4.62
cc_540 ( N_noxref_2_c_493_p N_CLK_c_4821_n ) capacitor c=0.00643612f //x=12.22 \
 //y=5.38 //x2=12.18 //y2=4.635
cc_541 ( N_noxref_2_c_445_n N_CLK_c_4822_n ) capacitor c=0.0290879f //x=12.7 \
 //y=5.295 //x2=17.385 //y2=4.64
cc_542 ( N_noxref_2_c_470_p N_CLK_c_4822_n ) capacitor c=0.0355055f //x=14.55 \
 //y=4.755 //x2=17.385 //y2=4.64
cc_543 ( N_noxref_2_c_493_p N_CLK_c_4822_n ) capacitor c=0.0151127f //x=12.22 \
 //y=5.38 //x2=17.385 //y2=4.64
cc_544 ( N_noxref_2_c_554_p N_CLK_c_4825_n ) capacitor c=5.39999e-19 //x=14.55 \
 //y=2.375 //x2=15.66 //y2=2.26
cc_545 ( N_noxref_2_c_478_p N_CLK_c_4825_n ) capacitor c=3.9149e-19 //x=14.55 \
 //y=3.355 //x2=15.66 //y2=2.26
cc_546 ( N_noxref_2_c_553_p N_CLK_c_4825_n ) capacitor c=0.00125213f //x=14.55 \
 //y=2.26 //x2=15.66 //y2=2.26
cc_547 ( N_noxref_2_c_556_p N_CLK_c_4825_n ) capacitor c=0.00214573f //x=14.25 \
 //y=2.095 //x2=15.66 //y2=2.26
cc_548 ( N_noxref_2_c_470_p N_CLK_c_4829_n ) capacitor c=5.64453e-19 //x=14.55 \
 //y=4.755 //x2=15.66 //y2=4.88
cc_549 ( N_noxref_2_c_558_p N_CLK_c_4829_n ) capacitor c=0.00113666f //x=14.55 \
 //y=4.88 //x2=15.66 //y2=4.88
cc_550 ( N_noxref_2_c_496_p N_CLK_c_4829_n ) capacitor c=0.00116563f \
 //x=15.115 //y=4.97 //x2=15.66 //y2=4.88
cc_551 ( N_noxref_2_c_560_p N_CLK_c_4829_n ) capacitor c=0.0012974f //x=14.825 \
 //y=4.97 //x2=15.66 //y2=4.88
cc_552 ( N_noxref_2_M70_noxref_g N_CLK_M72_noxref_g ) capacitor c=0.0106276f \
 //x=14.75 //y=6.2 //x2=15.63 //y2=6.2
cc_553 ( N_noxref_2_M71_noxref_g N_CLK_M72_noxref_g ) capacitor c=0.107144f \
 //x=15.19 //y=6.2 //x2=15.63 //y2=6.2
cc_554 ( N_noxref_2_M71_noxref_g N_CLK_M73_noxref_g ) capacitor c=0.0101598f \
 //x=15.19 //y=6.2 //x2=16.07 //y2=6.2
cc_555 ( N_noxref_2_c_578_p N_CLK_c_4836_n ) capacitor c=5.72528e-19 //x=14.25 \
 //y=1.055 //x2=15.225 //y2=1.09
cc_556 ( N_noxref_2_c_579_p N_CLK_c_4836_n ) capacitor c=0.00150277f //x=14.25 \
 //y=1.4 //x2=15.225 //y2=1.09
cc_557 ( N_noxref_2_c_580_p N_CLK_c_4836_n ) capacitor c=0.0160123f //x=14.78 \
 //y=1.055 //x2=15.225 //y2=1.09
cc_558 ( N_noxref_2_c_581_p N_CLK_c_4839_n ) capacitor c=0.00111227f //x=14.25 \
 //y=1.71 //x2=15.225 //y2=1.4
cc_559 ( N_noxref_2_c_582_p N_CLK_c_4839_n ) capacitor c=0.0124075f //x=14.78 \
 //y=1.4 //x2=15.225 //y2=1.4
cc_560 ( N_noxref_2_c_580_p N_CLK_c_4841_n ) capacitor c=9.19165e-19 //x=14.78 \
 //y=1.055 //x2=15.75 //y2=1.09
cc_561 ( N_noxref_2_c_582_p N_CLK_c_4842_n ) capacitor c=0.0010154f //x=14.78 \
 //y=1.4 //x2=15.75 //y2=1.4
cc_562 ( N_noxref_2_c_582_p N_CLK_c_4843_n ) capacitor c=9.23422e-19 //x=14.78 \
 //y=1.4 //x2=15.75 //y2=1.63
cc_563 ( N_noxref_2_c_554_p N_CLK_c_4844_n ) capacitor c=0.00136403f //x=14.55 \
 //y=2.375 //x2=15.75 //y2=2.095
cc_564 ( N_noxref_2_c_553_p N_CLK_c_4844_n ) capacitor c=0.0020754f //x=14.55 \
 //y=2.26 //x2=15.75 //y2=2.095
cc_565 ( N_noxref_2_c_556_p N_CLK_c_4844_n ) capacitor c=0.00964411f //x=14.25 \
 //y=2.095 //x2=15.75 //y2=2.095
cc_566 ( N_noxref_2_c_470_p N_CLK_c_4847_n ) capacitor c=5.7788e-19 //x=14.55 \
 //y=4.755 //x2=15.66 //y2=4.88
cc_567 ( N_noxref_2_c_558_p N_CLK_c_4847_n ) capacitor c=0.0013104f //x=14.55 \
 //y=4.88 //x2=15.66 //y2=4.88
cc_568 ( N_noxref_2_c_496_p N_CLK_c_4847_n ) capacitor c=0.0171374f //x=15.115 \
 //y=4.97 //x2=15.66 //y2=4.88
cc_569 ( N_noxref_2_c_560_p N_CLK_c_4847_n ) capacitor c=0.00419533f \
 //x=14.825 //y=4.97 //x2=15.66 //y2=4.88
cc_570 ( N_noxref_2_c_478_p RN ) capacitor c=9.4168e-19 //x=14.55 //y=3.355 \
 //x2=16.77 //y2=3.14
cc_571 ( N_noxref_2_c_470_p RN ) capacitor c=9.86735e-19 //x=14.55 //y=4.755 \
 //x2=16.77 //y2=3.14
cc_572 ( N_noxref_2_c_442_n N_RN_c_6308_n ) capacitor c=0.0193939f //x=12.345 \
 //y=1.835 //x2=16.615 //y2=2.315
cc_573 ( N_noxref_2_c_443_n N_RN_c_6308_n ) capacitor c=0.0281849f //x=12.7 \
 //y=3.355 //x2=16.615 //y2=2.315
cc_574 ( N_noxref_2_c_554_p N_RN_c_6308_n ) capacitor c=0.016619f //x=14.55 \
 //y=2.375 //x2=16.615 //y2=2.315
cc_575 ( N_noxref_2_c_478_p N_RN_c_6308_n ) capacitor c=0.0143826f //x=14.55 \
 //y=3.355 //x2=16.615 //y2=2.315
cc_576 ( N_noxref_2_c_455_n N_RN_c_6308_n ) capacitor c=7.09092e-19 //x=12.26 \
 //y=1.18 //x2=16.615 //y2=2.315
cc_577 ( N_noxref_2_c_468_p N_RN_c_6308_n ) capacitor c=0.00578595f //x=14.395 \
 //y=3.515 //x2=16.615 //y2=2.315
cc_578 ( N_noxref_2_c_553_p N_RN_c_6308_n ) capacitor c=5.18204e-19 //x=14.55 \
 //y=2.26 //x2=16.615 //y2=2.315
cc_579 ( N_noxref_2_c_556_p N_RN_c_6308_n ) capacitor c=3.41298e-19 //x=14.25 \
 //y=2.095 //x2=16.615 //y2=2.315
cc_580 ( N_noxref_2_c_440_n N_VDD_c_11464_n ) capacitor c=0.00648267f \
 //x=12.105 //y=5.38 //x2=78.895 //y2=7.585
cc_581 ( N_noxref_2_c_510_p N_VDD_c_11464_n ) capacitor c=0.00492584f \
 //x=12.615 //y=5.38 //x2=78.895 //y2=7.585
cc_582 ( N_noxref_2_c_463_p N_VDD_c_11464_n ) capacitor c=4.58709e-19 //x=12.7 \
 //y=3.675 //x2=78.895 //y2=7.585
cc_583 ( N_noxref_2_c_469_p N_VDD_c_11464_n ) capacitor c=3.99241e-19 \
 //x=14.55 //y=3.675 //x2=78.895 //y2=7.585
cc_584 ( N_noxref_2_c_447_n N_VDD_c_11464_n ) capacitor c=0.00368834f \
 //x=11.34 //y=5.56 //x2=78.895 //y2=7.585
cc_585 ( N_noxref_2_c_493_p N_VDD_c_11464_n ) capacitor c=8.42594e-19 \
 //x=12.22 //y=5.38 //x2=78.895 //y2=7.585
cc_586 ( N_noxref_2_c_609_p N_VDD_c_11464_n ) capacitor c=0.00285853f \
 //x=12.22 //y=5.56 //x2=78.895 //y2=7.585
cc_587 ( N_noxref_2_c_458_n N_VDD_c_11464_n ) capacitor c=0.00224881f \
 //x=11.34 //y=5.56 //x2=78.895 //y2=7.585
cc_588 ( N_noxref_2_c_509_p N_VDD_c_11464_n ) capacitor c=0.00224881f \
 //x=12.22 //y=5.56 //x2=78.895 //y2=7.585
cc_589 ( N_noxref_2_c_440_n N_VDD_c_11491_n ) capacitor c=0.00208087f \
 //x=12.105 //y=5.38 //x2=11.695 //y2=7.585
cc_590 ( N_noxref_2_c_447_n N_VDD_c_11491_n ) capacitor c=9.41185e-19 \
 //x=11.34 //y=5.56 //x2=11.695 //y2=7.585
cc_591 ( N_noxref_2_c_458_n N_VDD_c_11491_n ) capacitor c=0.0136705f //x=11.34 \
 //y=5.56 //x2=11.695 //y2=7.585
cc_592 ( N_noxref_2_c_440_n N_VDD_c_11535_n ) capacitor c=0.00180737f \
 //x=12.105 //y=5.38 //x2=12.575 //y2=7.585
cc_593 ( N_noxref_2_c_510_p N_VDD_c_11535_n ) capacitor c=0.00208087f \
 //x=12.615 //y=5.38 //x2=12.575 //y2=7.585
cc_594 ( N_noxref_2_c_493_p N_VDD_c_11535_n ) capacitor c=4.23719e-19 \
 //x=12.22 //y=5.38 //x2=12.575 //y2=7.585
cc_595 ( N_noxref_2_c_609_p N_VDD_c_11535_n ) capacitor c=5.77976e-19 \
 //x=12.22 //y=5.56 //x2=12.575 //y2=7.585
cc_596 ( N_noxref_2_c_509_p N_VDD_c_11535_n ) capacitor c=0.0136705f //x=12.22 \
 //y=5.56 //x2=12.575 //y2=7.585
cc_597 ( N_noxref_2_M70_noxref_g N_VDD_c_11540_n ) capacitor c=0.00755614f \
 //x=14.75 //y=6.2 //x2=15.325 //y2=7.585
cc_598 ( N_noxref_2_M71_noxref_g N_VDD_c_11540_n ) capacitor c=0.00755544f \
 //x=15.19 //y=6.2 //x2=15.325 //y2=7.585
cc_599 ( N_noxref_2_c_445_n N_VDD_c_11498_n ) capacitor c=0.0013228f //x=12.7 \
 //y=5.295 //x2=10.11 //y2=7.585
cc_600 ( N_noxref_2_c_447_n N_VDD_c_11498_n ) capacitor c=4.91377e-19 \
 //x=11.34 //y=5.56 //x2=10.11 //y2=7.585
cc_601 ( N_noxref_2_c_458_n N_VDD_c_11498_n ) capacitor c=0.0064135f //x=11.34 \
 //y=5.56 //x2=10.11 //y2=7.585
cc_602 ( N_noxref_2_c_445_n N_VDD_c_11545_n ) capacitor c=0.0294123f //x=12.7 \
 //y=5.295 //x2=13.44 //y2=7.585
cc_603 ( N_noxref_2_c_470_p N_VDD_c_11545_n ) capacitor c=0.0119111f //x=14.55 \
 //y=4.755 //x2=13.44 //y2=7.585
cc_604 ( N_noxref_2_c_493_p N_VDD_c_11545_n ) capacitor c=0.0025639f //x=12.22 \
 //y=5.38 //x2=13.44 //y2=7.585
cc_605 ( N_noxref_2_c_609_p N_VDD_c_11545_n ) capacitor c=4.19141e-19 \
 //x=12.22 //y=5.56 //x2=13.44 //y2=7.585
cc_606 ( N_noxref_2_c_509_p N_VDD_c_11545_n ) capacitor c=0.0101861f //x=12.22 \
 //y=5.56 //x2=13.44 //y2=7.585
cc_607 ( N_noxref_2_c_558_p N_VDD_c_11545_n ) capacitor c=0.00370784f \
 //x=14.55 //y=4.88 //x2=13.44 //y2=7.585
cc_608 ( N_noxref_2_c_560_p N_VDD_c_11545_n ) capacitor c=0.00590568f \
 //x=14.825 //y=4.97 //x2=13.44 //y2=7.585
cc_609 ( N_noxref_2_c_447_n N_VDD_M66_noxref_s ) capacitor c=0.0611368f \
 //x=11.34 //y=5.56 //x2=10.765 //y2=5.2
cc_610 ( N_noxref_2_c_493_p N_VDD_M66_noxref_s ) capacitor c=6.52457e-19 \
 //x=12.22 //y=5.38 //x2=10.765 //y2=5.2
cc_611 ( N_noxref_2_c_458_n N_VDD_M66_noxref_s ) capacitor c=0.0887533f \
 //x=11.34 //y=5.56 //x2=10.765 //y2=5.2
cc_612 ( N_noxref_2_c_440_n N_VDD_M67_noxref_d ) capacitor c=0.00734094f \
 //x=12.105 //y=5.38 //x2=11.635 //y2=5.2
cc_613 ( N_noxref_2_c_447_n N_VDD_M67_noxref_d ) capacitor c=0.0043528f \
 //x=11.34 //y=5.56 //x2=11.635 //y2=5.2
cc_614 ( N_noxref_2_c_609_p N_VDD_M67_noxref_d ) capacitor c=0.0043528f \
 //x=12.22 //y=5.56 //x2=11.635 //y2=5.2
cc_615 ( N_noxref_2_c_458_n N_VDD_M67_noxref_d ) capacitor c=0.065554f \
 //x=11.34 //y=5.56 //x2=11.635 //y2=5.2
cc_616 ( N_noxref_2_c_509_p N_VDD_M67_noxref_d ) capacitor c=0.065554f \
 //x=12.22 //y=5.56 //x2=11.635 //y2=5.2
cc_617 ( N_noxref_2_c_510_p N_VDD_M69_noxref_d ) capacitor c=0.00934027f \
 //x=12.615 //y=5.38 //x2=12.515 //y2=5.2
cc_618 ( N_noxref_2_c_609_p N_VDD_M69_noxref_d ) capacitor c=0.00955781f \
 //x=12.22 //y=5.56 //x2=12.515 //y2=5.2
cc_619 ( N_noxref_2_c_456_n N_VDD_M69_noxref_d ) capacitor c=9.65951e-19 \
 //x=12.7 //y=3.51 //x2=12.515 //y2=5.2
cc_620 ( N_noxref_2_c_509_p N_VDD_M69_noxref_d ) capacitor c=0.065554f \
 //x=12.22 //y=5.56 //x2=12.515 //y2=5.2
cc_621 ( N_noxref_2_c_510_p N_VDD_M70_noxref_s ) capacitor c=0.00220019f \
 //x=12.615 //y=5.38 //x2=14.395 //y2=5.2
cc_622 ( N_noxref_2_c_469_p N_VDD_M70_noxref_s ) capacitor c=6.02115e-19 \
 //x=14.55 //y=3.675 //x2=14.395 //y2=5.2
cc_623 ( N_noxref_2_c_470_p N_VDD_M70_noxref_s ) capacitor c=0.0217981f \
 //x=14.55 //y=4.755 //x2=14.395 //y2=5.2
cc_624 ( N_noxref_2_c_493_p N_VDD_M70_noxref_s ) capacitor c=0.00371125f \
 //x=12.22 //y=5.38 //x2=14.395 //y2=5.2
cc_625 ( N_noxref_2_c_609_p N_VDD_M70_noxref_s ) capacitor c=9.52042e-19 \
 //x=12.22 //y=5.56 //x2=14.395 //y2=5.2
cc_626 ( N_noxref_2_c_558_p N_VDD_M70_noxref_s ) capacitor c=0.00983846f \
 //x=14.55 //y=4.88 //x2=14.395 //y2=5.2
cc_627 ( N_noxref_2_M70_noxref_g N_VDD_M70_noxref_s ) capacitor c=0.053419f \
 //x=14.75 //y=6.2 //x2=14.395 //y2=5.2
cc_628 ( N_noxref_2_c_560_p N_VDD_M70_noxref_s ) capacitor c=0.0060625f \
 //x=14.825 //y=4.97 //x2=14.395 //y2=5.2
cc_629 ( N_noxref_2_M71_noxref_g N_VDD_M71_noxref_d ) capacitor c=0.015318f \
 //x=15.19 //y=6.2 //x2=15.265 //y2=5.2
cc_630 ( N_noxref_2_c_455_n N_noxref_22_M9_noxref_d ) capacitor c=3.39394e-19 \
 //x=12.26 //y=1.18 //x2=15.3 //y2=1.09
cc_631 ( N_noxref_2_c_488_p N_GND_c_13992_n ) capacitor c=0.00608539f \
 //x=12.615 //y=1.835 //x2=14.43 //y2=0.175
cc_632 ( N_noxref_2_c_463_p N_GND_c_13992_n ) capacitor c=2.7199e-19 //x=12.7 \
 //y=3.675 //x2=14.43 //y2=0.175
cc_633 ( N_noxref_2_c_455_n N_GND_c_13992_n ) capacitor c=0.00928865f \
 //x=12.26 //y=1.18 //x2=14.43 //y2=0.175
cc_634 ( N_noxref_2_M7_noxref_d N_GND_c_13992_n ) capacitor c=3.01769e-19 \
 //x=12.07 //y=1.085 //x2=14.43 //y2=0.175
cc_635 ( N_noxref_2_c_578_p N_GND_c_13996_n ) capacitor c=3.92414e-19 \
 //x=14.25 //y=1.055 //x2=14.515 //y2=1.015
cc_636 ( N_noxref_2_c_659_p N_GND_c_13996_n ) capacitor c=0.0085115f \
 //x=14.625 //y=0.9 //x2=14.515 //y2=1.015
cc_637 ( N_noxref_2_c_580_p N_GND_c_13996_n ) capacitor c=4.45447e-19 \
 //x=14.78 //y=1.055 //x2=14.515 //y2=1.015
cc_638 ( N_noxref_2_c_447_n N_GND_c_13957_n ) capacitor c=6.80717e-19 \
 //x=11.34 //y=5.56 //x2=11.29 //y2=1.135
cc_639 ( N_noxref_2_c_455_n N_GND_c_13957_n ) capacitor c=0.0140211f //x=12.26 \
 //y=1.18 //x2=11.29 //y2=1.135
cc_640 ( N_noxref_2_M7_noxref_d N_GND_c_13957_n ) capacitor c=2.93544e-19 \
 //x=12.07 //y=1.085 //x2=11.29 //y2=1.135
cc_641 ( N_noxref_2_c_554_p N_GND_c_14002_n ) capacitor c=0.00772482f \
 //x=14.55 //y=2.375 //x2=14.515 //y2=1.145
cc_642 ( N_noxref_2_c_469_p N_GND_c_14002_n ) capacitor c=7.58937e-19 \
 //x=14.55 //y=3.675 //x2=14.515 //y2=1.145
cc_643 ( N_noxref_2_c_455_n N_GND_c_14002_n ) capacitor c=0.00606355f \
 //x=12.26 //y=1.18 //x2=14.515 //y2=1.145
cc_644 ( N_noxref_2_c_553_p N_GND_c_14002_n ) capacitor c=2.22883e-19 \
 //x=14.55 //y=2.26 //x2=14.515 //y2=1.145
cc_645 ( N_noxref_2_c_578_p N_GND_c_14002_n ) capacitor c=0.0015128f //x=14.25 \
 //y=1.055 //x2=14.515 //y2=1.145
cc_646 ( N_noxref_2_c_579_p N_GND_c_14002_n ) capacitor c=0.00350108f \
 //x=14.25 //y=1.4 //x2=14.515 //y2=1.145
cc_647 ( N_noxref_2_c_581_p N_GND_c_14002_n ) capacitor c=4.28277e-19 \
 //x=14.25 //y=1.71 //x2=14.515 //y2=1.145
cc_648 ( N_noxref_2_c_659_p N_GND_c_14002_n ) capacitor c=9.36995e-19 \
 //x=14.625 //y=0.9 //x2=14.515 //y2=1.145
cc_649 ( N_noxref_2_c_672_p N_GND_c_14002_n ) capacitor c=5.79535e-19 \
 //x=14.625 //y=1.555 //x2=14.515 //y2=1.145
cc_650 ( N_noxref_2_c_580_p N_GND_c_14002_n ) capacitor c=0.0017438f //x=14.78 \
 //y=1.055 //x2=14.515 //y2=1.145
cc_651 ( N_noxref_2_c_582_p N_GND_c_14002_n ) capacitor c=0.00276804f \
 //x=14.78 //y=1.4 //x2=14.515 //y2=1.145
cc_652 ( N_noxref_2_c_488_p N_GND_c_13973_n ) capacitor c=7.75992e-19 \
 //x=12.615 //y=1.835 //x2=13.27 //y2=0.175
cc_653 ( N_noxref_2_c_463_p N_GND_c_13973_n ) capacitor c=3.21092e-19 //x=12.7 \
 //y=3.675 //x2=13.27 //y2=0.175
cc_654 ( N_noxref_2_c_578_p N_GND_c_14015_n ) capacitor c=0.00677932f \
 //x=14.25 //y=1.055 //x2=18.08 //y2=0.175
cc_655 ( N_noxref_2_c_443_n N_GND_c_13977_n ) capacitor c=9.32616e-19 //x=12.7 \
 //y=3.355 //x2=10.11 //y2=0.175
cc_656 ( N_noxref_2_c_441_n N_GND_c_14017_n ) capacitor c=0.00460657f \
 //x=12.26 //y=1.75 //x2=13.44 //y2=0.175
cc_657 ( N_noxref_2_c_488_p N_GND_c_14017_n ) capacitor c=0.0287655f \
 //x=12.615 //y=1.835 //x2=13.44 //y2=0.175
cc_658 ( N_noxref_2_c_554_p N_GND_c_14017_n ) capacitor c=0.00380125f \
 //x=14.55 //y=2.375 //x2=13.44 //y2=0.175
cc_659 ( N_noxref_2_c_478_p N_GND_c_14017_n ) capacitor c=0.00881103f \
 //x=14.55 //y=3.355 //x2=13.44 //y2=0.175
cc_660 ( N_noxref_2_c_468_p N_GND_c_14017_n ) capacitor c=0.00341388f \
 //x=14.395 //y=3.515 //x2=13.44 //y2=0.175
cc_661 ( N_noxref_2_c_553_p N_GND_c_14017_n ) capacitor c=0.00379568f \
 //x=14.55 //y=2.26 //x2=13.44 //y2=0.175
cc_662 ( N_noxref_2_c_581_p N_GND_c_14017_n ) capacitor c=0.00170145f \
 //x=14.25 //y=1.71 //x2=13.44 //y2=0.175
cc_663 ( N_noxref_2_c_556_p N_GND_c_14017_n ) capacitor c=0.0102191f //x=14.25 \
 //y=2.095 //x2=13.44 //y2=0.175
cc_664 ( N_noxref_2_c_455_n N_GND_M6_noxref_d ) capacitor c=2.82748e-19 \
 //x=12.26 //y=1.18 //x2=11.1 //y2=1.045
cc_665 ( N_noxref_2_c_554_p N_GND_M8_noxref_d ) capacitor c=4.4417e-19 \
 //x=14.55 //y=2.375 //x2=14.325 //y2=1.055
cc_666 ( N_noxref_2_c_578_p N_GND_M8_noxref_d ) capacitor c=0.00184354f \
 //x=14.25 //y=1.055 //x2=14.325 //y2=1.055
cc_667 ( N_noxref_2_c_579_p N_GND_M8_noxref_d ) capacitor c=0.00210798f \
 //x=14.25 //y=1.4 //x2=14.325 //y2=1.055
cc_668 ( N_noxref_2_c_659_p N_GND_M8_noxref_d ) capacitor c=0.00474029f \
 //x=14.625 //y=0.9 //x2=14.325 //y2=1.055
cc_669 ( N_noxref_2_c_672_p N_GND_M8_noxref_d ) capacitor c=0.00166857f \
 //x=14.625 //y=1.555 //x2=14.325 //y2=1.055
cc_670 ( N_noxref_2_c_580_p N_GND_M8_noxref_d ) capacitor c=0.00230174f \
 //x=14.78 //y=1.055 //x2=14.325 //y2=1.055
cc_671 ( N_noxref_2_c_582_p N_GND_M8_noxref_d ) capacitor c=0.00210798f \
 //x=14.78 //y=1.4 //x2=14.325 //y2=1.055
cc_672 ( N_noxref_2_c_442_n N_noxref_37_c_15657_n ) capacitor c=0.00911405f \
 //x=12.345 //y=1.835 //x2=11.775 //y2=1.675
cc_673 ( N_noxref_2_c_488_p N_noxref_37_c_15662_n ) capacitor c=0.00399245f \
 //x=12.615 //y=1.835 //x2=12.66 //y2=0.71
cc_674 ( N_noxref_2_c_455_n N_noxref_37_c_15662_n ) capacitor c=0.003751f \
 //x=12.26 //y=1.18 //x2=12.66 //y2=0.71
cc_675 ( N_noxref_2_M7_noxref_d N_noxref_37_c_15662_n ) capacitor \
 c=0.00910163f //x=12.07 //y=1.085 //x2=12.66 //y2=0.71
cc_676 ( N_noxref_2_c_441_n N_noxref_37_M6_noxref_s ) capacitor c=0.0175063f \
 //x=12.26 //y=1.75 //x2=10.67 //y2=0.545
cc_677 ( N_noxref_2_c_488_p N_noxref_37_M6_noxref_s ) capacitor c=0.00640979f \
 //x=12.615 //y=1.835 //x2=10.67 //y2=0.545
cc_678 ( N_noxref_2_c_463_p N_noxref_37_M6_noxref_s ) capacitor c=4.15501e-19 \
 //x=12.7 //y=3.675 //x2=10.67 //y2=0.545
cc_679 ( N_noxref_2_c_455_n N_noxref_37_M6_noxref_s ) capacitor c=0.0089443f \
 //x=12.26 //y=1.18 //x2=10.67 //y2=0.545
cc_680 ( N_noxref_2_c_456_n N_noxref_37_M6_noxref_s ) capacitor c=0.0010514f \
 //x=12.7 //y=3.51 //x2=10.67 //y2=0.545
cc_681 ( N_noxref_2_M7_noxref_d N_noxref_37_M6_noxref_s ) capacitor \
 c=0.0275552f //x=12.07 //y=1.085 //x2=10.67 //y2=0.545
cc_682 ( N_noxref_2_c_556_p N_noxref_38_c_15716_n ) capacitor c=0.00262672f \
 //x=14.25 //y=2.095 //x2=14.03 //y2=1.685
cc_683 ( N_noxref_2_c_554_p N_noxref_38_c_15717_n ) capacitor c=0.00428451f \
 //x=14.55 //y=2.375 //x2=14.915 //y2=1.77
cc_684 ( N_noxref_2_c_469_p N_noxref_38_c_15717_n ) capacitor c=0.00270049f \
 //x=14.55 //y=3.675 //x2=14.915 //y2=1.77
cc_685 ( N_noxref_2_c_553_p N_noxref_38_c_15717_n ) capacitor c=0.0104666f \
 //x=14.55 //y=2.26 //x2=14.915 //y2=1.77
cc_686 ( N_noxref_2_c_581_p N_noxref_38_c_15717_n ) capacitor c=0.00705077f \
 //x=14.25 //y=1.71 //x2=14.915 //y2=1.77
cc_687 ( N_noxref_2_c_556_p N_noxref_38_c_15717_n ) capacitor c=0.020708f \
 //x=14.25 //y=2.095 //x2=14.915 //y2=1.77
cc_688 ( N_noxref_2_c_672_p N_noxref_38_c_15717_n ) capacitor c=0.00588627f \
 //x=14.625 //y=1.555 //x2=14.915 //y2=1.77
cc_689 ( N_noxref_2_c_582_p N_noxref_38_c_15717_n ) capacitor c=0.00698822f \
 //x=14.78 //y=1.4 //x2=14.915 //y2=1.77
cc_690 ( N_noxref_2_c_578_p N_noxref_38_M8_noxref_s ) capacitor c=0.0295256f \
 //x=14.25 //y=1.055 //x2=13.895 //y2=0.555
cc_691 ( N_noxref_2_c_581_p N_noxref_38_M8_noxref_s ) capacitor c=7.99997e-19 \
 //x=14.25 //y=1.71 //x2=13.895 //y2=0.555
cc_692 ( N_noxref_2_c_556_p N_noxref_38_M8_noxref_s ) capacitor c=0.00122123f \
 //x=14.25 //y=2.095 //x2=13.895 //y2=0.555
cc_693 ( N_noxref_2_c_580_p N_noxref_38_M8_noxref_s ) capacitor c=0.0125924f \
 //x=14.78 //y=1.055 //x2=13.895 //y2=0.555
cc_694 ( N_noxref_3_c_784_n N_noxref_4_c_1199_n ) capacitor c=6.09845e-19 \
 //x=11.435 //y=3.895 //x2=11.96 //y2=4.09
cc_695 ( N_noxref_3_c_806_n N_noxref_4_c_1199_n ) capacitor c=0.0245809f \
 //x=12.18 //y=3.865 //x2=11.96 //y2=4.09
cc_696 ( N_noxref_3_c_784_n N_noxref_4_c_1207_n ) capacitor c=0.00217342f \
 //x=11.435 //y=3.895 //x2=11.96 //y2=4.41
cc_697 ( N_noxref_3_c_806_n N_noxref_4_c_1207_n ) capacitor c=0.00450608f \
 //x=12.18 //y=3.865 //x2=11.96 //y2=4.41
cc_698 ( N_noxref_3_c_822_p N_noxref_4_c_1322_n ) capacitor c=0.00324093f \
 //x=19.36 //y=2.375 //x2=17.51 //y2=4.095
cc_699 ( N_noxref_3_c_823_p N_noxref_4_c_1322_n ) capacitor c=0.0212704f \
 //x=19.36 //y=3.72 //x2=17.51 //y2=4.095
cc_700 ( N_noxref_3_c_824_p N_noxref_4_c_1322_n ) capacitor c=0.00257738f \
 //x=19.36 //y=4.04 //x2=17.51 //y2=4.095
cc_701 ( N_noxref_3_c_825_p N_noxref_4_c_1322_n ) capacitor c=9.84588e-19 \
 //x=19.36 //y=4.755 //x2=17.51 //y2=4.095
cc_702 ( N_noxref_3_c_826_p N_noxref_4_c_1322_n ) capacitor c=2.09913e-19 \
 //x=17.13 //y=3.88 //x2=17.51 //y2=4.095
cc_703 ( N_noxref_3_c_827_p N_noxref_4_c_1322_n ) capacitor c=0.0283254f \
 //x=17.73 //y=3.87 //x2=17.51 //y2=4.095
cc_704 ( N_noxref_3_c_825_p N_noxref_4_c_1328_n ) capacitor c=0.00237452f \
 //x=19.36 //y=4.755 //x2=17.51 //y2=4.415
cc_705 ( N_noxref_3_c_826_p N_noxref_4_c_1328_n ) capacitor c=0.0018855f \
 //x=17.13 //y=3.88 //x2=17.51 //y2=4.415
cc_706 ( N_noxref_3_c_827_p N_noxref_4_c_1328_n ) capacitor c=0.00583578f \
 //x=17.73 //y=3.87 //x2=17.51 //y2=4.415
cc_707 ( N_noxref_3_c_825_p N_noxref_4_c_1331_n ) capacitor c=0.0075763f \
 //x=19.36 //y=4.755 //x2=17.51 //y2=5.25
cc_708 ( N_noxref_3_M77_noxref_g N_noxref_4_c_1332_n ) capacitor c=0.00893512f \
 //x=20 //y=6.2 //x2=20.54 //y2=5.335
cc_709 ( N_noxref_3_M76_noxref_g N_noxref_4_c_1333_n ) capacitor c=0.00461408f \
 //x=19.56 //y=6.2 //x2=19.782 //y2=5.335
cc_710 ( N_noxref_3_M77_noxref_g N_noxref_4_c_1333_n ) capacitor c=0.00229208f \
 //x=20 //y=6.2 //x2=19.782 //y2=5.335
cc_711 ( N_noxref_3_c_835_p N_noxref_4_c_1333_n ) capacitor c=0.00171885f \
 //x=19.925 //y=4.97 //x2=19.782 //y2=5.335
cc_712 ( N_noxref_3_c_755_n N_noxref_4_c_1217_n ) capacitor c=0.00118691f \
 //x=4.56 //y=4.045 //x2=4.175 //y2=4.25
cc_713 ( N_noxref_3_c_757_n N_noxref_4_c_1217_n ) capacitor c=4.26819e-19 \
 //x=4.56 //y=5.25 //x2=4.175 //y2=4.25
cc_714 ( N_noxref_3_c_838_p N_noxref_4_c_1217_n ) capacitor c=0.0224292f \
 //x=2.022 //y=5.335 //x2=4.175 //y2=4.25
cc_715 ( N_noxref_3_c_786_n N_noxref_4_c_1217_n ) capacitor c=0.0358254f \
 //x=4.725 //y=3.885 //x2=4.175 //y2=4.25
cc_716 ( N_noxref_3_c_755_n N_noxref_4_c_1221_n ) capacitor c=0.00757286f \
 //x=4.56 //y=4.045 //x2=4.815 //y2=4.27
cc_717 ( N_noxref_3_c_757_n N_noxref_4_c_1221_n ) capacitor c=0.0225812f \
 //x=4.56 //y=5.25 //x2=4.815 //y2=4.27
cc_718 ( N_noxref_3_c_771_n N_noxref_4_c_1221_n ) capacitor c=0.127594f \
 //x=6.255 //y=3.88 //x2=4.815 //y2=4.27
cc_719 ( N_noxref_3_c_765_n N_noxref_4_c_1222_n ) capacitor c=0.00118033f \
 //x=6.41 //y=4.04 //x2=6.03 //y2=4.25
cc_720 ( N_noxref_3_c_766_n N_noxref_4_c_1222_n ) capacitor c=5.06484e-19 \
 //x=6.41 //y=4.755 //x2=6.03 //y2=4.25
cc_721 ( N_noxref_3_c_771_n N_noxref_4_c_1222_n ) capacitor c=0.0121043f \
 //x=6.255 //y=3.88 //x2=6.03 //y2=4.25
cc_722 ( N_noxref_3_c_776_n N_noxref_4_c_1222_n ) capacitor c=0.0358254f \
 //x=9.245 //y=3.895 //x2=6.03 //y2=4.25
cc_723 ( N_noxref_3_c_765_n N_noxref_4_c_1223_n ) capacitor c=0.00475287f \
 //x=6.41 //y=4.04 //x2=6.63 //y2=4.265
cc_724 ( N_noxref_3_c_766_n N_noxref_4_c_1223_n ) capacitor c=0.0235427f \
 //x=6.41 //y=4.755 //x2=6.63 //y2=4.265
cc_725 ( N_noxref_3_c_776_n N_noxref_4_c_1223_n ) capacitor c=0.0109313f \
 //x=9.245 //y=3.895 //x2=6.63 //y2=4.265
cc_726 ( N_noxref_3_c_806_n N_noxref_4_c_1276_n ) capacitor c=0.0811722f \
 //x=12.18 //y=3.865 //x2=17.355 //y2=4.25
cc_727 ( N_noxref_3_c_809_n N_noxref_4_c_1276_n ) capacitor c=0.112087f \
 //x=12.915 //y=3.9 //x2=17.355 //y2=4.25
cc_728 ( N_noxref_3_c_812_n N_noxref_4_c_1276_n ) capacitor c=0.0584235f \
 //x=14.17 //y=3.88 //x2=17.355 //y2=4.25
cc_729 ( N_noxref_3_c_816_n N_noxref_4_c_1276_n ) capacitor c=0.200781f \
 //x=14.77 //y=3.9 //x2=17.355 //y2=4.25
cc_730 ( N_noxref_3_c_826_p N_noxref_4_c_1276_n ) capacitor c=0.0107886f \
 //x=17.13 //y=3.88 //x2=17.355 //y2=4.25
cc_731 ( N_noxref_3_c_766_n N_noxref_4_c_1224_n ) capacitor c=3.74821e-19 \
 //x=6.41 //y=4.755 //x2=12.125 //y2=4.25
cc_732 ( N_noxref_3_c_773_n N_noxref_4_c_1224_n ) capacitor c=0.11095f \
 //x=9.59 //y=3.895 //x2=12.125 //y2=4.25
cc_733 ( N_noxref_3_c_776_n N_noxref_4_c_1224_n ) capacitor c=0.258108f \
 //x=9.245 //y=3.895 //x2=12.125 //y2=4.25
cc_734 ( N_noxref_3_c_780_n N_noxref_4_c_1224_n ) capacitor c=0.0563855f \
 //x=10.835 //y=3.88 //x2=12.125 //y2=4.25
cc_735 ( N_noxref_3_c_784_n N_noxref_4_c_1224_n ) capacitor c=0.0231836f \
 //x=11.435 //y=3.895 //x2=12.125 //y2=4.25
cc_736 ( N_noxref_3_c_806_n N_noxref_4_c_1224_n ) capacitor c=0.0358686f \
 //x=12.18 //y=3.865 //x2=12.125 //y2=4.25
cc_737 ( N_noxref_3_c_824_p N_noxref_4_c_1361_n ) capacitor c=0.00248957f \
 //x=19.36 //y=4.04 //x2=19.565 //y2=4.265
cc_738 ( N_noxref_3_c_825_p N_noxref_4_c_1361_n ) capacitor c=0.0234196f \
 //x=19.36 //y=4.755 //x2=19.565 //y2=4.265
cc_739 ( N_noxref_3_c_824_p N_noxref_4_c_1363_n ) capacitor c=0.00335139f \
 //x=19.36 //y=4.04 //x2=19.22 //y2=4.265
cc_740 ( N_noxref_3_c_825_p N_noxref_4_c_1363_n ) capacitor c=0.00195984f \
 //x=19.36 //y=4.755 //x2=19.22 //y2=4.265
cc_741 ( N_noxref_3_c_827_p N_noxref_4_c_1363_n ) capacitor c=0.205653f \
 //x=17.73 //y=3.87 //x2=19.22 //y2=4.265
cc_742 ( N_noxref_3_c_825_p N_noxref_4_c_1366_n ) capacitor c=3.8472e-19 \
 //x=19.36 //y=4.755 //x2=22.475 //y2=4.25
cc_743 ( N_noxref_3_M76_noxref_g N_noxref_4_c_1367_n ) capacitor c=0.0162284f \
 //x=19.56 //y=6.2 //x2=19.78 //y2=5.56
cc_744 ( N_noxref_3_M77_noxref_g N_noxref_4_c_1367_n ) capacitor c=0.0179041f \
 //x=20 //y=6.2 //x2=19.78 //y2=5.56
cc_745 ( N_noxref_3_c_835_p N_noxref_4_c_1367_n ) capacitor c=0.00291477f \
 //x=19.925 //y=4.97 //x2=19.78 //y2=5.56
cc_746 ( N_noxref_3_c_838_p N_noxref_4_M54_noxref_g ) capacitor c=0.00501342f \
 //x=2.022 //y=5.335 //x2=1.8 //y2=6.2
cc_747 ( N_noxref_3_c_871_p N_noxref_4_M54_noxref_g ) capacitor c=0.0162284f \
 //x=2.02 //y=5.56 //x2=1.8 //y2=6.2
cc_748 ( N_noxref_3_c_872_p N_noxref_4_M55_noxref_g ) capacitor c=0.00973141f \
 //x=2.78 //y=5.335 //x2=2.24 //y2=6.2
cc_749 ( N_noxref_3_c_838_p N_noxref_4_M55_noxref_g ) capacitor c=0.00229208f \
 //x=2.022 //y=5.335 //x2=2.24 //y2=6.2
cc_750 ( N_noxref_3_c_871_p N_noxref_4_M55_noxref_g ) capacitor c=0.0179041f \
 //x=2.02 //y=5.56 //x2=2.24 //y2=6.2
cc_751 ( N_noxref_3_c_838_p N_noxref_4_c_1375_n ) capacitor c=0.00171885f \
 //x=2.022 //y=5.335 //x2=2.165 //y2=4.97
cc_752 ( N_noxref_3_c_871_p N_noxref_4_c_1375_n ) capacitor c=0.00291477f \
 //x=2.02 //y=5.56 //x2=2.165 //y2=4.97
cc_753 ( N_noxref_3_c_745_n D ) capacitor c=4.25944e-19 //x=4.56 //y=3.725 \
 //x2=7.52 //y2=3.14
cc_754 ( N_noxref_3_c_757_n D ) capacitor c=6.66489e-19 //x=4.56 //y=5.25 \
 //x2=7.52 //y2=3.14
cc_755 ( N_noxref_3_c_761_n D ) capacitor c=0.0218434f //x=6.41 //y=3.72 \
 //x2=7.52 //y2=3.14
cc_756 ( N_noxref_3_c_765_n D ) capacitor c=0.00774769f //x=6.41 //y=4.04 \
 //x2=7.52 //y2=3.14
cc_757 ( N_noxref_3_c_766_n D ) capacitor c=0.015882f //x=6.41 //y=4.755 \
 //x2=7.52 //y2=3.14
cc_758 ( N_noxref_3_c_882_p D ) capacitor c=2.90818e-19 //x=6.41 //y=3.88 \
 //x2=7.52 //y2=3.14
cc_759 ( N_noxref_3_c_776_n D ) capacitor c=0.0253585f //x=9.245 //y=3.895 \
 //x2=7.52 //y2=3.14
cc_760 ( N_noxref_3_c_884_p D ) capacitor c=3.36194e-19 //x=6.41 //y=4.88 \
 //x2=7.52 //y2=3.14
cc_761 ( N_noxref_3_c_761_n D ) capacitor c=3.02012e-19 //x=6.41 //y=3.72 \
 //x2=7.52 //y2=2.77
cc_762 ( N_noxref_3_c_760_n N_D_c_4231_n ) capacitor c=0.0109668f //x=6.41 \
 //y=2.375 //x2=7.52 //y2=2.375
cc_763 ( N_noxref_3_c_887_p N_D_c_4231_n ) capacitor c=5.40058e-19 //x=6.41 \
 //y=2.26 //x2=7.52 //y2=2.375
cc_764 ( N_noxref_3_c_888_p N_D_c_4231_n ) capacitor c=0.00147006f //x=6.11 \
 //y=2.095 //x2=7.52 //y2=2.375
cc_765 ( N_noxref_3_c_745_n N_D_c_4188_n ) capacitor c=5.30445e-19 //x=4.56 \
 //y=3.725 //x2=7.52 //y2=2.62
cc_766 ( N_noxref_3_c_761_n N_D_c_4188_n ) capacitor c=0.00651604f //x=6.41 \
 //y=3.72 //x2=7.52 //y2=2.62
cc_767 ( N_noxref_3_c_887_p N_D_c_4188_n ) capacitor c=4.16726e-19 //x=6.41 \
 //y=2.26 //x2=7.52 //y2=2.62
cc_768 ( N_noxref_3_c_761_n N_D_c_4189_n ) capacitor c=0.00781632f //x=6.41 \
 //y=3.72 //x2=7.52 //y2=2.94
cc_769 ( N_noxref_3_c_766_n N_D_c_4193_n ) capacitor c=0.0110307f //x=6.41 \
 //y=4.755 //x2=7.52 //y2=4.765
cc_770 ( N_noxref_3_c_884_p N_D_c_4193_n ) capacitor c=2.89813e-19 //x=6.41 \
 //y=4.88 //x2=7.52 //y2=4.765
cc_771 ( N_noxref_3_c_798_n N_D_c_4193_n ) capacitor c=7.66769e-19 //x=6.975 \
 //y=4.97 //x2=7.52 //y2=4.765
cc_772 ( N_noxref_3_c_896_p N_D_c_4193_n ) capacitor c=7.54501e-19 //x=6.685 \
 //y=4.97 //x2=7.52 //y2=4.765
cc_773 ( N_noxref_3_c_761_n N_D_c_4196_n ) capacitor c=0.00512577f //x=6.41 \
 //y=3.72 //x2=7.675 //y2=2.78
cc_774 ( N_noxref_3_c_823_p N_D_c_4197_n ) capacitor c=0.0287243f //x=19.36 \
 //y=3.72 //x2=33.26 //y2=2.755
cc_775 ( N_noxref_3_c_824_p N_D_c_4197_n ) capacitor c=0.00324821f //x=19.36 \
 //y=4.04 //x2=33.26 //y2=2.755
cc_776 ( N_noxref_3_c_773_n N_D_c_4197_n ) capacitor c=0.00533676f //x=9.59 \
 //y=3.895 //x2=33.26 //y2=2.755
cc_777 ( N_noxref_3_c_776_n N_D_c_4197_n ) capacitor c=0.0111559f //x=9.245 \
 //y=3.895 //x2=33.26 //y2=2.755
cc_778 ( N_noxref_3_c_780_n N_D_c_4197_n ) capacitor c=0.00643617f //x=10.835 \
 //y=3.88 //x2=33.26 //y2=2.755
cc_779 ( N_noxref_3_c_784_n N_D_c_4197_n ) capacitor c=0.0223994f //x=11.435 \
 //y=3.895 //x2=33.26 //y2=2.755
cc_780 ( N_noxref_3_c_806_n N_D_c_4197_n ) capacitor c=0.0105862f //x=12.18 \
 //y=3.865 //x2=33.26 //y2=2.755
cc_781 ( N_noxref_3_c_809_n N_D_c_4197_n ) capacitor c=0.00567398f //x=12.915 \
 //y=3.9 //x2=33.26 //y2=2.755
cc_782 ( N_noxref_3_c_812_n N_D_c_4197_n ) capacitor c=0.00641151f //x=14.17 \
 //y=3.88 //x2=33.26 //y2=2.755
cc_783 ( N_noxref_3_c_816_n N_D_c_4197_n ) capacitor c=0.0653352f //x=14.77 \
 //y=3.9 //x2=33.26 //y2=2.755
cc_784 ( N_noxref_3_c_826_p N_D_c_4197_n ) capacitor c=0.0181445f //x=17.13 \
 //y=3.88 //x2=33.26 //y2=2.755
cc_785 ( N_noxref_3_c_827_p N_D_c_4197_n ) capacitor c=0.0512789f //x=17.73 \
 //y=3.87 //x2=33.26 //y2=2.755
cc_786 ( N_noxref_3_c_760_n N_D_c_4255_n ) capacitor c=5.39999e-19 //x=6.41 \
 //y=2.375 //x2=7.52 //y2=2.26
cc_787 ( N_noxref_3_c_761_n N_D_c_4255_n ) capacitor c=4.16726e-19 //x=6.41 \
 //y=3.72 //x2=7.52 //y2=2.26
cc_788 ( N_noxref_3_c_887_p N_D_c_4255_n ) capacitor c=0.00125213f //x=6.41 \
 //y=2.26 //x2=7.52 //y2=2.26
cc_789 ( N_noxref_3_c_888_p N_D_c_4255_n ) capacitor c=0.00214573f //x=6.11 \
 //y=2.095 //x2=7.52 //y2=2.26
cc_790 ( N_noxref_3_c_766_n N_D_c_4204_n ) capacitor c=0.00103399f //x=6.41 \
 //y=4.755 //x2=7.52 //y2=4.88
cc_791 ( N_noxref_3_c_884_p N_D_c_4204_n ) capacitor c=0.00113984f //x=6.41 \
 //y=4.88 //x2=7.52 //y2=4.88
cc_792 ( N_noxref_3_c_798_n N_D_c_4204_n ) capacitor c=0.00116563f //x=6.975 \
 //y=4.97 //x2=7.52 //y2=4.88
cc_793 ( N_noxref_3_c_896_p N_D_c_4204_n ) capacitor c=0.00129812f //x=6.685 \
 //y=4.97 //x2=7.52 //y2=4.88
cc_794 ( N_noxref_3_M60_noxref_g N_D_M62_noxref_g ) capacitor c=0.0106276f \
 //x=6.61 //y=6.2 //x2=7.49 //y2=6.2
cc_795 ( N_noxref_3_M61_noxref_g N_D_M62_noxref_g ) capacitor c=0.107144f \
 //x=7.05 //y=6.2 //x2=7.49 //y2=6.2
cc_796 ( N_noxref_3_M61_noxref_g N_D_M63_noxref_g ) capacitor c=0.0101598f \
 //x=7.05 //y=6.2 //x2=7.93 //y2=6.2
cc_797 ( N_noxref_3_c_921_p N_D_c_4266_n ) capacitor c=5.72528e-19 //x=6.11 \
 //y=1.055 //x2=7.085 //y2=1.09
cc_798 ( N_noxref_3_c_922_p N_D_c_4266_n ) capacitor c=0.00150277f //x=6.11 \
 //y=1.4 //x2=7.085 //y2=1.09
cc_799 ( N_noxref_3_c_923_p N_D_c_4266_n ) capacitor c=0.0160123f //x=6.64 \
 //y=1.055 //x2=7.085 //y2=1.09
cc_800 ( N_noxref_3_c_924_p N_D_c_4269_n ) capacitor c=0.00111227f //x=6.11 \
 //y=1.71 //x2=7.085 //y2=1.4
cc_801 ( N_noxref_3_c_925_p N_D_c_4269_n ) capacitor c=0.0124075f //x=6.64 \
 //y=1.4 //x2=7.085 //y2=1.4
cc_802 ( N_noxref_3_c_923_p N_D_c_4271_n ) capacitor c=9.19165e-19 //x=6.64 \
 //y=1.055 //x2=7.61 //y2=1.09
cc_803 ( N_noxref_3_c_925_p N_D_c_4272_n ) capacitor c=0.0010154f //x=6.64 \
 //y=1.4 //x2=7.61 //y2=1.4
cc_804 ( N_noxref_3_c_925_p N_D_c_4273_n ) capacitor c=9.23422e-19 //x=6.64 \
 //y=1.4 //x2=7.61 //y2=1.63
cc_805 ( N_noxref_3_c_760_n N_D_c_4274_n ) capacitor c=0.00140534f //x=6.41 \
 //y=2.375 //x2=7.61 //y2=2.095
cc_806 ( N_noxref_3_c_887_p N_D_c_4274_n ) capacitor c=0.0020754f //x=6.41 \
 //y=2.26 //x2=7.61 //y2=2.095
cc_807 ( N_noxref_3_c_888_p N_D_c_4274_n ) capacitor c=0.00964411f //x=6.11 \
 //y=2.095 //x2=7.61 //y2=2.095
cc_808 ( N_noxref_3_c_766_n N_D_c_4214_n ) capacitor c=0.00116212f //x=6.41 \
 //y=4.755 //x2=7.52 //y2=4.88
cc_809 ( N_noxref_3_c_884_p N_D_c_4214_n ) capacitor c=0.00155973f //x=6.41 \
 //y=4.88 //x2=7.52 //y2=4.88
cc_810 ( N_noxref_3_c_798_n N_D_c_4214_n ) capacitor c=0.0171374f //x=6.975 \
 //y=4.97 //x2=7.52 //y2=4.88
cc_811 ( N_noxref_3_c_896_p N_D_c_4214_n ) capacitor c=0.00484466f //x=6.685 \
 //y=4.97 //x2=7.52 //y2=4.88
cc_812 ( N_noxref_3_c_745_n CLK ) capacitor c=0.00286279f //x=4.56 //y=3.725 \
 //x2=2.71 //y2=2.77
cc_813 ( N_noxref_3_c_757_n CLK ) capacitor c=9.29639e-19 //x=4.56 //y=5.25 \
 //x2=2.71 //y2=2.77
cc_814 ( N_noxref_3_c_816_n CLK ) capacitor c=6.63302e-19 //x=14.77 //y=3.9 \
 //x2=15.66 //y2=3.14
cc_815 ( N_noxref_3_c_826_p CLK ) capacitor c=0.0278143f //x=17.13 //y=3.88 \
 //x2=15.66 //y2=3.14
cc_816 ( N_noxref_3_c_872_p N_CLK_c_4772_n ) capacitor c=0.0234972f //x=2.78 \
 //y=5.335 //x2=2.705 //y2=4.835
cc_817 ( N_noxref_3_c_941_p N_CLK_c_4772_n ) capacitor c=0.00512107f //x=2.9 \
 //y=5.335 //x2=2.705 //y2=4.835
cc_818 ( N_noxref_3_c_942_p N_CLK_c_4772_n ) capacitor c=0.00134045f //x=2.9 \
 //y=5.56 //x2=2.705 //y2=4.835
cc_819 ( N_noxref_3_c_722_n N_CLK_c_4775_n ) capacitor c=0.0206181f //x=4.475 \
 //y=5.335 //x2=11.58 //y2=4.62
cc_820 ( N_noxref_3_c_757_n N_CLK_c_4775_n ) capacitor c=0.0298618f //x=4.56 \
 //y=5.25 //x2=11.58 //y2=4.62
cc_821 ( N_noxref_3_c_766_n N_CLK_c_4775_n ) capacitor c=0.0317543f //x=6.41 \
 //y=4.755 //x2=11.58 //y2=4.62
cc_822 ( N_noxref_3_c_941_p N_CLK_c_4775_n ) capacitor c=0.0383042f //x=2.9 \
 //y=5.335 //x2=11.58 //y2=4.62
cc_823 ( N_noxref_3_c_771_n N_CLK_c_4775_n ) capacitor c=0.00757951f //x=6.255 \
 //y=3.88 //x2=11.58 //y2=4.62
cc_824 ( N_noxref_3_c_773_n N_CLK_c_4775_n ) capacitor c=0.00651789f //x=9.59 \
 //y=3.895 //x2=11.58 //y2=4.62
cc_825 ( N_noxref_3_c_776_n N_CLK_c_4775_n ) capacitor c=0.0204153f //x=9.245 \
 //y=3.895 //x2=11.58 //y2=4.62
cc_826 ( N_noxref_3_c_780_n N_CLK_c_4775_n ) capacitor c=0.00369971f \
 //x=10.835 //y=3.88 //x2=11.58 //y2=4.62
cc_827 ( N_noxref_3_c_784_n N_CLK_c_4775_n ) capacitor c=0.00294922f \
 //x=11.435 //y=3.895 //x2=11.58 //y2=4.62
cc_828 ( N_noxref_3_c_806_n N_CLK_c_4821_n ) capacitor c=0.00185346f //x=12.18 \
 //y=3.865 //x2=12.18 //y2=4.635
cc_829 ( N_noxref_3_c_825_p N_CLK_c_4868_n ) capacitor c=4.17734e-19 //x=19.36 \
 //y=4.755 //x2=17.73 //y2=4.64
cc_830 ( N_noxref_3_c_827_p N_CLK_c_4868_n ) capacitor c=0.00848127f //x=17.73 \
 //y=3.87 //x2=17.73 //y2=4.64
cc_831 ( N_noxref_3_c_806_n N_CLK_c_4822_n ) capacitor c=0.00442067f //x=12.18 \
 //y=3.865 //x2=17.385 //y2=4.64
cc_832 ( N_noxref_3_c_809_n N_CLK_c_4822_n ) capacitor c=0.00621235f \
 //x=12.915 //y=3.9 //x2=17.385 //y2=4.64
cc_833 ( N_noxref_3_c_812_n N_CLK_c_4822_n ) capacitor c=0.00307733f //x=14.17 \
 //y=3.88 //x2=17.385 //y2=4.64
cc_834 ( N_noxref_3_c_816_n N_CLK_c_4822_n ) capacitor c=0.0152567f //x=14.77 \
 //y=3.9 //x2=17.385 //y2=4.64
cc_835 ( N_noxref_3_c_826_p N_CLK_c_4822_n ) capacitor c=0.00167251f //x=17.13 \
 //y=3.88 //x2=17.385 //y2=4.64
cc_836 ( N_noxref_3_c_825_p N_CLK_c_4875_n ) capacitor c=0.031668f //x=19.36 \
 //y=4.755 //x2=24.515 //y2=4.62
cc_837 ( N_noxref_3_c_872_p N_CLK_c_4783_n ) capacitor c=0.00243571f //x=2.78 \
 //y=5.335 //x2=2.705 //y2=4.62
cc_838 ( N_noxref_3_c_941_p N_CLK_c_4783_n ) capacitor c=0.00207204f //x=2.9 \
 //y=5.335 //x2=2.705 //y2=4.62
cc_839 ( N_noxref_3_c_872_p N_CLK_c_4788_n ) capacitor c=0.00492634f //x=2.78 \
 //y=5.335 //x2=2.71 //y2=4.88
cc_840 ( N_noxref_3_c_941_p N_CLK_c_4788_n ) capacitor c=0.00132214f //x=2.9 \
 //y=5.335 //x2=2.71 //y2=4.88
cc_841 ( N_noxref_3_c_872_p N_CLK_M56_noxref_g ) capacitor c=0.00858222f \
 //x=2.78 //y=5.335 //x2=2.68 //y2=6.2
cc_842 ( N_noxref_3_c_941_p N_CLK_M56_noxref_g ) capacitor c=0.00229818f \
 //x=2.9 //y=5.335 //x2=2.68 //y2=6.2
cc_843 ( N_noxref_3_c_942_p N_CLK_M56_noxref_g ) capacitor c=0.0179041f \
 //x=2.9 //y=5.56 //x2=2.68 //y2=6.2
cc_844 ( N_noxref_3_c_717_n N_CLK_M57_noxref_g ) capacitor c=0.00955829f \
 //x=3.665 //y=5.335 //x2=3.12 //y2=6.2
cc_845 ( N_noxref_3_c_941_p N_CLK_M57_noxref_g ) capacitor c=0.00230699f \
 //x=2.9 //y=5.335 //x2=3.12 //y2=6.2
cc_846 ( N_noxref_3_c_942_p N_CLK_M57_noxref_g ) capacitor c=0.0179041f \
 //x=2.9 //y=5.56 //x2=3.12 //y2=6.2
cc_847 ( N_noxref_3_c_941_p N_CLK_c_4801_n ) capacitor c=0.00170733f //x=2.9 \
 //y=5.335 //x2=3.045 //y2=4.97
cc_848 ( N_noxref_3_c_942_p N_CLK_c_4801_n ) capacitor c=0.00293647f //x=2.9 \
 //y=5.56 //x2=3.045 //y2=4.97
cc_849 ( N_noxref_3_c_872_p N_CLK_c_4802_n ) capacitor c=3.54644e-19 //x=2.78 \
 //y=5.335 //x2=2.71 //y2=4.88
cc_850 ( N_noxref_3_c_761_n RN ) capacitor c=0.00184992f //x=6.41 //y=3.72 \
 //x2=8.63 //y2=3.14
cc_851 ( N_noxref_3_c_766_n RN ) capacitor c=5.77971e-19 //x=6.41 //y=4.755 \
 //x2=8.63 //y2=3.14
cc_852 ( N_noxref_3_c_776_n RN ) capacitor c=0.0223923f //x=9.245 //y=3.895 \
 //x2=8.63 //y2=3.14
cc_853 ( N_noxref_3_c_823_p RN ) capacitor c=0.00169519f //x=19.36 //y=3.72 \
 //x2=16.77 //y2=3.14
cc_854 ( N_noxref_3_c_825_p RN ) capacitor c=0.00103263f //x=19.36 //y=4.755 \
 //x2=16.77 //y2=3.14
cc_855 ( N_noxref_3_c_826_p RN ) capacitor c=0.0265616f //x=17.13 //y=3.88 \
 //x2=16.77 //y2=3.14
cc_856 ( N_noxref_3_c_823_p RN ) capacitor c=0.0348726f //x=19.36 //y=3.72 \
 //x2=20.47 //y2=3.14
cc_857 ( N_noxref_3_c_824_p RN ) capacitor c=0.00763467f //x=19.36 //y=4.04 \
 //x2=20.47 //y2=3.14
cc_858 ( N_noxref_3_c_825_p RN ) capacitor c=0.015275f //x=19.36 //y=4.755 \
 //x2=20.47 //y2=3.14
cc_859 ( N_noxref_3_c_983_p RN ) capacitor c=3.35971e-19 //x=19.35 //y=3.88 \
 //x2=20.47 //y2=3.14
cc_860 ( N_noxref_3_c_827_p RN ) capacitor c=0.00504644f //x=17.73 //y=3.87 \
 //x2=20.47 //y2=3.14
cc_861 ( N_noxref_3_c_985_p RN ) capacitor c=3.36194e-19 //x=19.36 //y=4.88 \
 //x2=20.47 //y2=3.14
cc_862 ( N_noxref_3_c_822_p N_RN_c_6372_n ) capacitor c=0.00799025f //x=19.36 \
 //y=2.375 //x2=20.47 //y2=2.515
cc_863 ( N_noxref_3_c_823_p N_RN_c_6372_n ) capacitor c=0.00291253f //x=19.36 \
 //y=3.72 //x2=20.47 //y2=2.515
cc_864 ( N_noxref_3_c_988_p N_RN_c_6372_n ) capacitor c=0.00120311f //x=19.36 \
 //y=2.26 //x2=20.47 //y2=2.515
cc_865 ( N_noxref_3_c_989_p N_RN_c_6372_n ) capacitor c=0.00159215f //x=19.06 \
 //y=2.095 //x2=20.47 //y2=2.515
cc_866 ( N_noxref_3_c_825_p N_RN_c_6376_n ) capacitor c=0.0110307f //x=19.36 \
 //y=4.755 //x2=20.47 //y2=4.765
cc_867 ( N_noxref_3_c_985_p N_RN_c_6376_n ) capacitor c=2.89813e-19 //x=19.36 \
 //y=4.88 //x2=20.47 //y2=4.765
cc_868 ( N_noxref_3_c_835_p N_RN_c_6376_n ) capacitor c=7.66769e-19 //x=19.925 \
 //y=4.97 //x2=20.47 //y2=4.765
cc_869 ( N_noxref_3_c_993_p N_RN_c_6376_n ) capacitor c=7.54501e-19 //x=19.635 \
 //y=4.97 //x2=20.47 //y2=4.765
cc_870 ( N_noxref_3_c_822_p N_RN_c_6380_n ) capacitor c=0.0168121f //x=19.36 \
 //y=2.375 //x2=20.265 //y2=2.4
cc_871 ( N_noxref_3_c_823_p N_RN_c_6380_n ) capacitor c=0.0141438f //x=19.36 \
 //y=3.72 //x2=20.265 //y2=2.4
cc_872 ( N_noxref_3_c_826_p N_RN_c_6380_n ) capacitor c=0.00223018f //x=17.13 \
 //y=3.88 //x2=20.265 //y2=2.4
cc_873 ( N_noxref_3_c_827_p N_RN_c_6380_n ) capacitor c=0.00425954f //x=17.73 \
 //y=3.87 //x2=20.265 //y2=2.4
cc_874 ( N_noxref_3_c_988_p N_RN_c_6380_n ) capacitor c=2.54369e-19 //x=19.36 \
 //y=2.26 //x2=20.265 //y2=2.4
cc_875 ( N_noxref_3_c_989_p N_RN_c_6380_n ) capacitor c=3.41298e-19 //x=19.06 \
 //y=2.095 //x2=20.265 //y2=2.4
cc_876 ( N_noxref_3_c_822_p N_RN_c_6386_n ) capacitor c=0.00279365f //x=19.36 \
 //y=2.375 //x2=33.205 //y2=2.37
cc_877 ( N_noxref_3_c_823_p N_RN_c_6386_n ) capacitor c=5.00559e-19 //x=19.36 \
 //y=3.72 //x2=33.205 //y2=2.37
cc_878 ( N_noxref_3_c_784_n N_RN_c_6308_n ) capacitor c=0.0033974f //x=11.435 \
 //y=3.895 //x2=16.615 //y2=2.315
cc_879 ( N_noxref_3_c_806_n N_RN_c_6308_n ) capacitor c=0.00114426f //x=12.18 \
 //y=3.865 //x2=16.615 //y2=2.315
cc_880 ( N_noxref_3_c_816_n N_RN_c_6308_n ) capacitor c=0.00467983f //x=14.77 \
 //y=3.9 //x2=16.615 //y2=2.315
cc_881 ( N_noxref_3_c_826_p N_RN_c_6391_n ) capacitor c=0.00409965f //x=17.13 \
 //y=3.88 //x2=16.935 //y2=2.315
cc_882 ( N_noxref_3_c_822_p N_RN_c_6392_n ) capacitor c=5.39999e-19 //x=19.36 \
 //y=2.375 //x2=20.47 //y2=2.26
cc_883 ( N_noxref_3_c_988_p N_RN_c_6392_n ) capacitor c=0.00124896f //x=19.36 \
 //y=2.26 //x2=20.47 //y2=2.26
cc_884 ( N_noxref_3_c_989_p N_RN_c_6392_n ) capacitor c=0.00214501f //x=19.06 \
 //y=2.095 //x2=20.47 //y2=2.26
cc_885 ( N_noxref_3_c_825_p N_RN_c_6395_n ) capacitor c=0.00103399f //x=19.36 \
 //y=4.755 //x2=20.47 //y2=4.88
cc_886 ( N_noxref_3_c_985_p N_RN_c_6395_n ) capacitor c=0.00113984f //x=19.36 \
 //y=4.88 //x2=20.47 //y2=4.88
cc_887 ( N_noxref_3_c_835_p N_RN_c_6395_n ) capacitor c=0.00116563f //x=19.925 \
 //y=4.97 //x2=20.47 //y2=4.88
cc_888 ( N_noxref_3_c_993_p N_RN_c_6395_n ) capacitor c=0.00129812f //x=19.635 \
 //y=4.97 //x2=20.47 //y2=4.88
cc_889 ( N_noxref_3_M76_noxref_g N_RN_M78_noxref_g ) capacitor c=0.0106276f \
 //x=19.56 //y=6.2 //x2=20.44 //y2=6.2
cc_890 ( N_noxref_3_M77_noxref_g N_RN_M78_noxref_g ) capacitor c=0.107144f \
 //x=20 //y=6.2 //x2=20.44 //y2=6.2
cc_891 ( N_noxref_3_M77_noxref_g N_RN_M79_noxref_g ) capacitor c=0.0101598f \
 //x=20 //y=6.2 //x2=20.88 //y2=6.2
cc_892 ( N_noxref_3_c_1016_p N_RN_c_6402_n ) capacitor c=5.72528e-19 //x=19.06 \
 //y=1.055 //x2=20.035 //y2=1.09
cc_893 ( N_noxref_3_c_1017_p N_RN_c_6402_n ) capacitor c=0.00150277f //x=19.06 \
 //y=1.4 //x2=20.035 //y2=1.09
cc_894 ( N_noxref_3_c_1018_p N_RN_c_6402_n ) capacitor c=0.0160123f //x=19.59 \
 //y=1.055 //x2=20.035 //y2=1.09
cc_895 ( N_noxref_3_c_1019_p N_RN_c_6405_n ) capacitor c=0.00111227f //x=19.06 \
 //y=1.71 //x2=20.035 //y2=1.4
cc_896 ( N_noxref_3_c_1020_p N_RN_c_6405_n ) capacitor c=0.0124075f //x=19.59 \
 //y=1.4 //x2=20.035 //y2=1.4
cc_897 ( N_noxref_3_c_1018_p N_RN_c_6407_n ) capacitor c=9.19165e-19 //x=19.59 \
 //y=1.055 //x2=20.56 //y2=1.09
cc_898 ( N_noxref_3_c_1020_p N_RN_c_6408_n ) capacitor c=0.0010154f //x=19.59 \
 //y=1.4 //x2=20.56 //y2=1.4
cc_899 ( N_noxref_3_c_1020_p N_RN_c_6409_n ) capacitor c=9.23422e-19 //x=19.59 \
 //y=1.4 //x2=20.56 //y2=1.63
cc_900 ( N_noxref_3_c_822_p N_RN_c_6410_n ) capacitor c=3.54695e-19 //x=19.36 \
 //y=2.375 //x2=20.56 //y2=2.095
cc_901 ( N_noxref_3_c_988_p N_RN_c_6410_n ) capacitor c=0.00166305f //x=19.36 \
 //y=2.26 //x2=20.56 //y2=2.095
cc_902 ( N_noxref_3_c_989_p N_RN_c_6410_n ) capacitor c=0.00868554f //x=19.06 \
 //y=2.095 //x2=20.56 //y2=2.095
cc_903 ( N_noxref_3_c_825_p N_RN_c_6413_n ) capacitor c=0.00116212f //x=19.36 \
 //y=4.755 //x2=20.47 //y2=4.88
cc_904 ( N_noxref_3_c_985_p N_RN_c_6413_n ) capacitor c=0.00155973f //x=19.36 \
 //y=4.88 //x2=20.47 //y2=4.88
cc_905 ( N_noxref_3_c_835_p N_RN_c_6413_n ) capacitor c=0.0171374f //x=19.925 \
 //y=4.97 //x2=20.47 //y2=4.88
cc_906 ( N_noxref_3_c_993_p N_RN_c_6413_n ) capacitor c=0.00484466f //x=19.635 \
 //y=4.97 //x2=20.47 //y2=4.88
cc_907 ( N_noxref_3_c_823_p N_noxref_16_c_9868_n ) capacitor c=6.58395e-19 \
 //x=19.36 //y=3.72 //x2=21.58 //y2=2.995
cc_908 ( N_noxref_3_c_823_p N_noxref_16_c_9869_n ) capacitor c=3.70403e-19 \
 //x=19.36 //y=3.72 //x2=21.58 //y2=4.75
cc_909 ( N_noxref_3_c_825_p N_noxref_16_c_9869_n ) capacitor c=7.55038e-19 \
 //x=19.36 //y=4.755 //x2=21.58 //y2=4.75
cc_910 ( N_noxref_3_c_872_p N_VDD_c_11464_n ) capacitor c=0.00599866f //x=2.78 \
 //y=5.335 //x2=78.895 //y2=7.585
cc_911 ( N_noxref_3_c_717_n N_VDD_c_11464_n ) capacitor c=0.00627191f \
 //x=3.665 //y=5.335 //x2=78.895 //y2=7.585
cc_912 ( N_noxref_3_c_719_n N_VDD_c_11464_n ) capacitor c=0.00256019f //x=3.78 \
 //y=5.56 //x2=78.895 //y2=7.585
cc_913 ( N_noxref_3_c_722_n N_VDD_c_11464_n ) capacitor c=0.00829248f \
 //x=4.475 //y=5.335 //x2=78.895 //y2=7.585
cc_914 ( N_noxref_3_c_755_n N_VDD_c_11464_n ) capacitor c=5.1373e-19 //x=4.56 \
 //y=4.045 //x2=78.895 //y2=7.585
cc_915 ( N_noxref_3_c_765_n N_VDD_c_11464_n ) capacitor c=3.34593e-19 //x=6.41 \
 //y=4.04 //x2=78.895 //y2=7.585
cc_916 ( N_noxref_3_c_824_p N_VDD_c_11464_n ) capacitor c=4.0659e-19 //x=19.36 \
 //y=4.04 //x2=78.895 //y2=7.585
cc_917 ( N_noxref_3_c_838_p N_VDD_c_11464_n ) capacitor c=0.00261804f \
 //x=2.022 //y=5.335 //x2=78.895 //y2=7.585
cc_918 ( N_noxref_3_c_941_p N_VDD_c_11464_n ) capacitor c=0.00262723f //x=2.9 \
 //y=5.335 //x2=78.895 //y2=7.585
cc_919 ( N_noxref_3_c_871_p N_VDD_c_11464_n ) capacitor c=0.0024232f //x=2.02 \
 //y=5.56 //x2=78.895 //y2=7.585
cc_920 ( N_noxref_3_c_942_p N_VDD_c_11464_n ) capacitor c=0.0024232f //x=2.9 \
 //y=5.56 //x2=78.895 //y2=7.585
cc_921 ( N_noxref_3_c_788_n N_VDD_c_11464_n ) capacitor c=0.0024232f //x=3.78 \
 //y=5.56 //x2=78.895 //y2=7.585
cc_922 ( N_noxref_3_c_838_p N_VDD_c_11585_n ) capacitor c=0.00331944f \
 //x=2.022 //y=5.335 //x2=1.23 //y2=7.58
cc_923 ( N_noxref_3_c_871_p N_VDD_c_11585_n ) capacitor c=0.00509469f //x=2.02 \
 //y=5.56 //x2=1.23 //y2=7.58
cc_924 ( N_noxref_3_c_872_p N_VDD_c_11587_n ) capacitor c=0.00202922f //x=2.78 \
 //y=5.335 //x2=2.375 //y2=7.585
cc_925 ( N_noxref_3_c_838_p N_VDD_c_11587_n ) capacitor c=9.3757e-19 //x=2.022 \
 //y=5.335 //x2=2.375 //y2=7.585
cc_926 ( N_noxref_3_c_871_p N_VDD_c_11587_n ) capacitor c=0.0138074f //x=2.02 \
 //y=5.56 //x2=2.375 //y2=7.585
cc_927 ( N_noxref_3_c_872_p N_VDD_c_11590_n ) capacitor c=0.0017708f //x=2.78 \
 //y=5.335 //x2=3.255 //y2=7.585
cc_928 ( N_noxref_3_c_717_n N_VDD_c_11590_n ) capacitor c=0.00202922f \
 //x=3.665 //y=5.335 //x2=3.255 //y2=7.585
cc_929 ( N_noxref_3_c_941_p N_VDD_c_11590_n ) capacitor c=9.4822e-19 //x=2.9 \
 //y=5.335 //x2=3.255 //y2=7.585
cc_930 ( N_noxref_3_c_942_p N_VDD_c_11590_n ) capacitor c=0.0138074f //x=2.9 \
 //y=5.56 //x2=3.255 //y2=7.585
cc_931 ( N_noxref_3_c_717_n N_VDD_c_11477_n ) capacitor c=0.00205906f \
 //x=3.665 //y=5.335 //x2=4.135 //y2=7.585
cc_932 ( N_noxref_3_c_719_n N_VDD_c_11477_n ) capacitor c=8.49654e-19 //x=3.78 \
 //y=5.56 //x2=4.135 //y2=7.585
cc_933 ( N_noxref_3_c_722_n N_VDD_c_11477_n ) capacitor c=0.00204238f \
 //x=4.475 //y=5.335 //x2=4.135 //y2=7.585
cc_934 ( N_noxref_3_c_788_n N_VDD_c_11477_n ) capacitor c=0.0138074f //x=3.78 \
 //y=5.56 //x2=4.135 //y2=7.585
cc_935 ( N_noxref_3_c_722_n N_VDD_c_11598_n ) capacitor c=0.00183742f \
 //x=4.475 //y=5.335 //x2=5.13 //y2=7.585
cc_936 ( N_noxref_3_M60_noxref_g N_VDD_c_11479_n ) capacitor c=0.00755614f \
 //x=6.61 //y=6.2 //x2=7.185 //y2=7.585
cc_937 ( N_noxref_3_M61_noxref_g N_VDD_c_11479_n ) capacitor c=0.00755544f \
 //x=7.05 //y=6.2 //x2=7.185 //y2=7.585
cc_938 ( N_noxref_3_M76_noxref_g N_VDD_c_11601_n ) capacitor c=0.00755614f \
 //x=19.56 //y=6.2 //x2=20.135 //y2=7.585
cc_939 ( N_noxref_3_M77_noxref_g N_VDD_c_11601_n ) capacitor c=0.00755544f \
 //x=20 //y=6.2 //x2=20.135 //y2=7.585
cc_940 ( N_noxref_3_c_719_n N_VDD_c_11494_n ) capacitor c=0.00282782f //x=3.78 \
 //y=5.56 //x2=5.3 //y2=7.585
cc_941 ( N_noxref_3_c_757_n N_VDD_c_11494_n ) capacitor c=0.0325571f //x=4.56 \
 //y=5.25 //x2=5.3 //y2=7.585
cc_942 ( N_noxref_3_c_766_n N_VDD_c_11494_n ) capacitor c=0.0118976f //x=6.41 \
 //y=4.755 //x2=5.3 //y2=7.585
cc_943 ( N_noxref_3_c_788_n N_VDD_c_11494_n ) capacitor c=0.00777981f //x=3.78 \
 //y=5.56 //x2=5.3 //y2=7.585
cc_944 ( N_noxref_3_c_884_p N_VDD_c_11494_n ) capacitor c=0.00370784f //x=6.41 \
 //y=4.88 //x2=5.3 //y2=7.585
cc_945 ( N_noxref_3_c_896_p N_VDD_c_11494_n ) capacitor c=0.00590568f \
 //x=6.685 //y=4.97 //x2=5.3 //y2=7.585
cc_946 ( N_noxref_3_c_825_p N_VDD_c_11609_n ) capacitor c=0.0116306f //x=19.36 \
 //y=4.755 //x2=18.25 //y2=7.585
cc_947 ( N_noxref_3_c_985_p N_VDD_c_11609_n ) capacitor c=0.00370784f \
 //x=19.36 //y=4.88 //x2=18.25 //y2=7.585
cc_948 ( N_noxref_3_c_993_p N_VDD_c_11609_n ) capacitor c=0.00590568f \
 //x=19.635 //y=4.97 //x2=18.25 //y2=7.585
cc_949 ( N_noxref_3_c_838_p N_VDD_M54_noxref_s ) capacitor c=0.0453361f \
 //x=2.022 //y=5.335 //x2=1.445 //y2=5.2
cc_950 ( N_noxref_3_c_941_p N_VDD_M54_noxref_s ) capacitor c=7.80122e-19 \
 //x=2.9 //y=5.335 //x2=1.445 //y2=5.2
cc_951 ( N_noxref_3_c_871_p N_VDD_M54_noxref_s ) capacitor c=0.09305f //x=2.02 \
 //y=5.56 //x2=1.445 //y2=5.2
cc_952 ( N_noxref_3_c_872_p N_VDD_M55_noxref_d ) capacitor c=0.00700141f \
 //x=2.78 //y=5.335 //x2=2.315 //y2=5.2
cc_953 ( N_noxref_3_c_871_p N_VDD_M55_noxref_d ) capacitor c=0.0674491f \
 //x=2.02 //y=5.56 //x2=2.315 //y2=5.2
cc_954 ( N_noxref_3_c_942_p N_VDD_M55_noxref_d ) capacitor c=0.0674762f \
 //x=2.9 //y=5.56 //x2=2.315 //y2=5.2
cc_955 ( N_noxref_3_c_717_n N_VDD_M57_noxref_d ) capacitor c=0.00700141f \
 //x=3.665 //y=5.335 //x2=3.195 //y2=5.2
cc_956 ( N_noxref_3_c_942_p N_VDD_M57_noxref_d ) capacitor c=0.067493f //x=2.9 \
 //y=5.56 //x2=3.195 //y2=5.2
cc_957 ( N_noxref_3_c_788_n N_VDD_M57_noxref_d ) capacitor c=0.0674979f \
 //x=3.78 //y=5.56 //x2=3.195 //y2=5.2
cc_958 ( N_noxref_3_c_722_n N_VDD_M59_noxref_d ) capacitor c=0.00700141f \
 //x=4.475 //y=5.335 //x2=4.075 //y2=5.2
cc_959 ( N_noxref_3_c_788_n N_VDD_M59_noxref_d ) capacitor c=0.0675002f \
 //x=3.78 //y=5.56 //x2=4.075 //y2=5.2
cc_960 ( N_noxref_3_c_719_n N_VDD_M60_noxref_s ) capacitor c=0.00492616f \
 //x=3.78 //y=5.56 //x2=6.255 //y2=5.2
cc_961 ( N_noxref_3_c_722_n N_VDD_M60_noxref_s ) capacitor c=9.42705e-19 \
 //x=4.475 //y=5.335 //x2=6.255 //y2=5.2
cc_962 ( N_noxref_3_c_765_n N_VDD_M60_noxref_s ) capacitor c=7.08613e-19 \
 //x=6.41 //y=4.04 //x2=6.255 //y2=5.2
cc_963 ( N_noxref_3_c_766_n N_VDD_M60_noxref_s ) capacitor c=0.0217981f \
 //x=6.41 //y=4.755 //x2=6.255 //y2=5.2
cc_964 ( N_noxref_3_c_941_p N_VDD_M60_noxref_s ) capacitor c=2.11884e-19 \
 //x=2.9 //y=5.335 //x2=6.255 //y2=5.2
cc_965 ( N_noxref_3_c_884_p N_VDD_M60_noxref_s ) capacitor c=0.00983846f \
 //x=6.41 //y=4.88 //x2=6.255 //y2=5.2
cc_966 ( N_noxref_3_M60_noxref_g N_VDD_M60_noxref_s ) capacitor c=0.053419f \
 //x=6.61 //y=6.2 //x2=6.255 //y2=5.2
cc_967 ( N_noxref_3_c_896_p N_VDD_M60_noxref_s ) capacitor c=0.00604424f \
 //x=6.685 //y=4.97 //x2=6.255 //y2=5.2
cc_968 ( N_noxref_3_M61_noxref_g N_VDD_M61_noxref_d ) capacitor c=0.015318f \
 //x=7.05 //y=6.2 //x2=7.125 //y2=5.2
cc_969 ( N_noxref_3_c_824_p N_VDD_M76_noxref_s ) capacitor c=7.08613e-19 \
 //x=19.36 //y=4.04 //x2=19.205 //y2=5.2
cc_970 ( N_noxref_3_c_825_p N_VDD_M76_noxref_s ) capacitor c=0.0217981f \
 //x=19.36 //y=4.755 //x2=19.205 //y2=5.2
cc_971 ( N_noxref_3_c_985_p N_VDD_M76_noxref_s ) capacitor c=0.00983846f \
 //x=19.36 //y=4.88 //x2=19.205 //y2=5.2
cc_972 ( N_noxref_3_M76_noxref_g N_VDD_M76_noxref_s ) capacitor c=0.053419f \
 //x=19.56 //y=6.2 //x2=19.205 //y2=5.2
cc_973 ( N_noxref_3_c_993_p N_VDD_M76_noxref_s ) capacitor c=0.00604424f \
 //x=19.635 //y=4.97 //x2=19.205 //y2=5.2
cc_974 ( N_noxref_3_M77_noxref_g N_VDD_M77_noxref_d ) capacitor c=0.015318f \
 //x=20 //y=6.2 //x2=20.075 //y2=5.2
cc_975 ( N_noxref_3_c_727_n N_noxref_20_c_12860_n ) capacitor c=0.0036878f \
 //x=4.075 //y=1.305 //x2=4.475 //y2=0.72
cc_976 ( N_noxref_3_c_739_n N_noxref_20_c_12860_n ) capacitor c=0.00365967f \
 //x=4.475 //y=1.845 //x2=4.475 //y2=0.72
cc_977 ( N_noxref_3_M2_noxref_d N_noxref_20_c_12860_n ) capacitor \
 c=0.00949319f //x=3.885 //y=1.095 //x2=4.475 //y2=0.72
cc_978 ( N_noxref_3_M2_noxref_d N_noxref_20_c_12865_n ) capacitor \
 c=0.00120711f //x=3.885 //y=1.095 //x2=3.59 //y2=1.175
cc_979 ( N_noxref_3_c_872_p N_noxref_20_M1_noxref_d ) capacitor c=0.00159405f \
 //x=2.78 //y=5.335 //x2=2.35 //y2=1.09
cc_980 ( N_noxref_3_c_727_n N_noxref_20_M1_noxref_d ) capacitor c=0.00802417f \
 //x=4.075 //y=1.305 //x2=2.35 //y2=1.09
cc_981 ( N_noxref_3_c_727_n N_noxref_20_M2_noxref_s ) capacitor c=0.0098487f \
 //x=4.075 //y=1.305 //x2=3.455 //y2=0.555
cc_982 ( N_noxref_3_c_734_n N_noxref_20_M2_noxref_s ) capacitor c=0.028602f \
 //x=4.075 //y=1.76 //x2=3.455 //y2=0.555
cc_983 ( N_noxref_3_c_739_n N_noxref_20_M2_noxref_s ) capacitor c=0.00911719f \
 //x=4.475 //y=1.845 //x2=3.455 //y2=0.555
cc_984 ( N_noxref_3_c_770_n N_noxref_20_M2_noxref_s ) capacitor c=0.00129723f \
 //x=4.56 //y=3.88 //x2=3.455 //y2=0.555
cc_985 ( N_noxref_3_M2_noxref_d N_noxref_20_M2_noxref_s ) capacitor \
 c=0.0279003f //x=3.885 //y=1.095 //x2=3.455 //y2=0.555
cc_986 ( N_noxref_3_c_727_n N_noxref_21_M4_noxref_d ) capacitor c=3.20746e-19 \
 //x=4.075 //y=1.305 //x2=7.16 //y2=1.09
cc_987 ( N_noxref_3_c_727_n N_GND_c_13951_n ) capacitor c=0.00901861f \
 //x=4.075 //y=1.305 //x2=6.29 //y2=0.175
cc_988 ( N_noxref_3_c_739_n N_GND_c_13951_n ) capacitor c=0.00713708f \
 //x=4.475 //y=1.845 //x2=6.29 //y2=0.175
cc_989 ( N_noxref_3_c_755_n N_GND_c_13951_n ) capacitor c=5.12818e-19 //x=4.56 \
 //y=4.045 //x2=6.29 //y2=0.175
cc_990 ( N_noxref_3_M2_noxref_d N_GND_c_13951_n ) capacitor c=2.9462e-19 \
 //x=3.885 //y=1.095 //x2=6.29 //y2=0.175
cc_991 ( N_noxref_3_c_921_p N_GND_c_14037_n ) capacitor c=3.97665e-19 //x=6.11 \
 //y=1.055 //x2=6.375 //y2=1.015
cc_992 ( N_noxref_3_c_1116_p N_GND_c_14037_n ) capacitor c=0.00864776f \
 //x=6.485 //y=0.9 //x2=6.375 //y2=1.015
cc_993 ( N_noxref_3_c_923_p N_GND_c_14037_n ) capacitor c=4.45447e-19 //x=6.64 \
 //y=1.055 //x2=6.375 //y2=1.015
cc_994 ( N_noxref_3_c_1016_p N_GND_c_14040_n ) capacitor c=3.97665e-19 \
 //x=19.06 //y=1.055 //x2=19.325 //y2=1.015
cc_995 ( N_noxref_3_c_1119_p N_GND_c_14040_n ) capacitor c=0.00864776f \
 //x=19.435 //y=0.9 //x2=19.325 //y2=1.015
cc_996 ( N_noxref_3_c_1018_p N_GND_c_14040_n ) capacitor c=4.45447e-19 \
 //x=19.59 //y=1.055 //x2=19.325 //y2=1.015
cc_997 ( N_noxref_3_c_727_n N_GND_c_13956_n ) capacitor c=0.00543195f \
 //x=4.075 //y=1.305 //x2=6.375 //y2=1.145
cc_998 ( N_noxref_3_c_760_n N_GND_c_13956_n ) capacitor c=0.00828177f //x=6.41 \
 //y=2.375 //x2=6.375 //y2=1.145
cc_999 ( N_noxref_3_c_765_n N_GND_c_13956_n ) capacitor c=5.4002e-19 //x=6.41 \
 //y=4.04 //x2=6.375 //y2=1.145
cc_1000 ( N_noxref_3_c_887_p N_GND_c_13956_n ) capacitor c=2.22883e-19 \
 //x=6.41 //y=2.26 //x2=6.375 //y2=1.145
cc_1001 ( N_noxref_3_c_921_p N_GND_c_13956_n ) capacitor c=0.00156339f \
 //x=6.11 //y=1.055 //x2=6.375 //y2=1.145
cc_1002 ( N_noxref_3_c_922_p N_GND_c_13956_n ) capacitor c=0.00352472f \
 //x=6.11 //y=1.4 //x2=6.375 //y2=1.145
cc_1003 ( N_noxref_3_c_924_p N_GND_c_13956_n ) capacitor c=4.63388e-19 \
 //x=6.11 //y=1.71 //x2=6.375 //y2=1.145
cc_1004 ( N_noxref_3_c_1116_p N_GND_c_13956_n ) capacitor c=9.36995e-19 \
 //x=6.485 //y=0.9 //x2=6.375 //y2=1.145
cc_1005 ( N_noxref_3_c_1129_p N_GND_c_13956_n ) capacitor c=5.96388e-19 \
 //x=6.485 //y=1.555 //x2=6.375 //y2=1.145
cc_1006 ( N_noxref_3_c_923_p N_GND_c_13956_n ) capacitor c=0.0017438f //x=6.64 \
 //y=1.055 //x2=6.375 //y2=1.145
cc_1007 ( N_noxref_3_c_925_p N_GND_c_13956_n ) capacitor c=0.00276804f \
 //x=6.64 //y=1.4 //x2=6.375 //y2=1.145
cc_1008 ( N_noxref_3_c_822_p N_GND_c_14054_n ) capacitor c=0.00772482f \
 //x=19.36 //y=2.375 //x2=19.325 //y2=1.145
cc_1009 ( N_noxref_3_c_824_p N_GND_c_14054_n ) capacitor c=6.6735e-19 \
 //x=19.36 //y=4.04 //x2=19.325 //y2=1.145
cc_1010 ( N_noxref_3_c_988_p N_GND_c_14054_n ) capacitor c=2.22883e-19 \
 //x=19.36 //y=2.26 //x2=19.325 //y2=1.145
cc_1011 ( N_noxref_3_c_1016_p N_GND_c_14054_n ) capacitor c=0.00156339f \
 //x=19.06 //y=1.055 //x2=19.325 //y2=1.145
cc_1012 ( N_noxref_3_c_1017_p N_GND_c_14054_n ) capacitor c=0.00352472f \
 //x=19.06 //y=1.4 //x2=19.325 //y2=1.145
cc_1013 ( N_noxref_3_c_1019_p N_GND_c_14054_n ) capacitor c=4.40631e-19 \
 //x=19.06 //y=1.71 //x2=19.325 //y2=1.145
cc_1014 ( N_noxref_3_c_1119_p N_GND_c_14054_n ) capacitor c=9.36995e-19 \
 //x=19.435 //y=0.9 //x2=19.325 //y2=1.145
cc_1015 ( N_noxref_3_c_1139_p N_GND_c_14054_n ) capacitor c=5.96388e-19 \
 //x=19.435 //y=1.555 //x2=19.325 //y2=1.145
cc_1016 ( N_noxref_3_c_1018_p N_GND_c_14054_n ) capacitor c=0.0017438f \
 //x=19.59 //y=1.055 //x2=19.325 //y2=1.145
cc_1017 ( N_noxref_3_c_1020_p N_GND_c_14054_n ) capacitor c=0.00276804f \
 //x=19.59 //y=1.4 //x2=19.325 //y2=1.145
cc_1018 ( N_noxref_3_c_739_n N_GND_c_13970_n ) capacitor c=6.86343e-19 \
 //x=4.475 //y=1.845 //x2=5.13 //y2=0.175
cc_1019 ( N_noxref_3_c_921_p N_GND_c_13971_n ) capacitor c=0.00677766f \
 //x=6.11 //y=1.055 //x2=9.94 //y2=0.175
cc_1020 ( N_noxref_3_c_1016_p N_GND_c_14066_n ) capacitor c=0.00677766f \
 //x=19.06 //y=1.055 //x2=22.89 //y2=0.175
cc_1021 ( N_noxref_3_c_734_n N_GND_c_13974_n ) capacitor c=0.0045138f \
 //x=4.075 //y=1.76 //x2=5.3 //y2=0.175
cc_1022 ( N_noxref_3_c_739_n N_GND_c_13974_n ) capacitor c=0.0335382f \
 //x=4.475 //y=1.845 //x2=5.3 //y2=0.175
cc_1023 ( N_noxref_3_c_760_n N_GND_c_13974_n ) capacitor c=0.00457512f \
 //x=6.41 //y=2.375 //x2=5.3 //y2=0.175
cc_1024 ( N_noxref_3_c_761_n N_GND_c_13974_n ) capacitor c=0.00886231f \
 //x=6.41 //y=3.72 //x2=5.3 //y2=0.175
cc_1025 ( N_noxref_3_c_887_p N_GND_c_13974_n ) capacitor c=0.00394651f \
 //x=6.41 //y=2.26 //x2=5.3 //y2=0.175
cc_1026 ( N_noxref_3_c_924_p N_GND_c_13974_n ) capacitor c=0.00170145f \
 //x=6.11 //y=1.71 //x2=5.3 //y2=0.175
cc_1027 ( N_noxref_3_c_888_p N_GND_c_13974_n ) capacitor c=0.0103608f //x=6.11 \
 //y=2.095 //x2=5.3 //y2=0.175
cc_1028 ( N_noxref_3_c_822_p N_GND_c_14074_n ) capacitor c=0.00380125f \
 //x=19.36 //y=2.375 //x2=18.25 //y2=0.175
cc_1029 ( N_noxref_3_c_823_p N_GND_c_14074_n ) capacitor c=0.00870608f \
 //x=19.36 //y=3.72 //x2=18.25 //y2=0.175
cc_1030 ( N_noxref_3_c_827_p N_GND_c_14074_n ) capacitor c=0.00276652f \
 //x=17.73 //y=3.87 //x2=18.25 //y2=0.175
cc_1031 ( N_noxref_3_c_988_p N_GND_c_14074_n ) capacitor c=0.0039621f \
 //x=19.36 //y=2.26 //x2=18.25 //y2=0.175
cc_1032 ( N_noxref_3_c_1019_p N_GND_c_14074_n ) capacitor c=0.00170145f \
 //x=19.06 //y=1.71 //x2=18.25 //y2=0.175
cc_1033 ( N_noxref_3_c_989_p N_GND_c_14074_n ) capacitor c=0.0102191f \
 //x=19.06 //y=2.095 //x2=18.25 //y2=0.175
cc_1034 ( N_noxref_3_c_760_n N_GND_M3_noxref_d ) capacitor c=4.4417e-19 \
 //x=6.41 //y=2.375 //x2=6.185 //y2=1.055
cc_1035 ( N_noxref_3_c_921_p N_GND_M3_noxref_d ) capacitor c=0.00184354f \
 //x=6.11 //y=1.055 //x2=6.185 //y2=1.055
cc_1036 ( N_noxref_3_c_922_p N_GND_M3_noxref_d ) capacitor c=0.00210798f \
 //x=6.11 //y=1.4 //x2=6.185 //y2=1.055
cc_1037 ( N_noxref_3_c_1116_p N_GND_M3_noxref_d ) capacitor c=0.00474029f \
 //x=6.485 //y=0.9 //x2=6.185 //y2=1.055
cc_1038 ( N_noxref_3_c_1129_p N_GND_M3_noxref_d ) capacitor c=0.00166857f \
 //x=6.485 //y=1.555 //x2=6.185 //y2=1.055
cc_1039 ( N_noxref_3_c_923_p N_GND_M3_noxref_d ) capacitor c=0.00230174f \
 //x=6.64 //y=1.055 //x2=6.185 //y2=1.055
cc_1040 ( N_noxref_3_c_925_p N_GND_M3_noxref_d ) capacitor c=0.00210798f \
 //x=6.64 //y=1.4 //x2=6.185 //y2=1.055
cc_1041 ( N_noxref_3_c_822_p N_GND_M11_noxref_d ) capacitor c=4.4417e-19 \
 //x=19.36 //y=2.375 //x2=19.135 //y2=1.055
cc_1042 ( N_noxref_3_c_1016_p N_GND_M11_noxref_d ) capacitor c=0.00184354f \
 //x=19.06 //y=1.055 //x2=19.135 //y2=1.055
cc_1043 ( N_noxref_3_c_1017_p N_GND_M11_noxref_d ) capacitor c=0.00210798f \
 //x=19.06 //y=1.4 //x2=19.135 //y2=1.055
cc_1044 ( N_noxref_3_c_1119_p N_GND_M11_noxref_d ) capacitor c=0.00474029f \
 //x=19.435 //y=0.9 //x2=19.135 //y2=1.055
cc_1045 ( N_noxref_3_c_1139_p N_GND_M11_noxref_d ) capacitor c=0.00166857f \
 //x=19.435 //y=1.555 //x2=19.135 //y2=1.055
cc_1046 ( N_noxref_3_c_1018_p N_GND_M11_noxref_d ) capacitor c=0.00230174f \
 //x=19.59 //y=1.055 //x2=19.135 //y2=1.055
cc_1047 ( N_noxref_3_c_1020_p N_GND_M11_noxref_d ) capacitor c=0.00210798f \
 //x=19.59 //y=1.4 //x2=19.135 //y2=1.055
cc_1048 ( N_noxref_3_c_888_p N_noxref_36_c_15589_n ) capacitor c=0.00262672f \
 //x=6.11 //y=2.095 //x2=5.89 //y2=1.685
cc_1049 ( N_noxref_3_c_760_n N_noxref_36_c_15590_n ) capacitor c=0.00428451f \
 //x=6.41 //y=2.375 //x2=6.775 //y2=1.77
cc_1050 ( N_noxref_3_c_765_n N_noxref_36_c_15590_n ) capacitor c=0.00144481f \
 //x=6.41 //y=4.04 //x2=6.775 //y2=1.77
cc_1051 ( N_noxref_3_c_887_p N_noxref_36_c_15590_n ) capacitor c=0.0104666f \
 //x=6.41 //y=2.26 //x2=6.775 //y2=1.77
cc_1052 ( N_noxref_3_c_924_p N_noxref_36_c_15590_n ) capacitor c=0.00705077f \
 //x=6.11 //y=1.71 //x2=6.775 //y2=1.77
cc_1053 ( N_noxref_3_c_888_p N_noxref_36_c_15590_n ) capacitor c=0.0219597f \
 //x=6.11 //y=2.095 //x2=6.775 //y2=1.77
cc_1054 ( N_noxref_3_c_1129_p N_noxref_36_c_15590_n ) capacitor c=0.00588627f \
 //x=6.485 //y=1.555 //x2=6.775 //y2=1.77
cc_1055 ( N_noxref_3_c_925_p N_noxref_36_c_15590_n ) capacitor c=0.00698822f \
 //x=6.64 //y=1.4 //x2=6.775 //y2=1.77
cc_1056 ( N_noxref_3_c_921_p N_noxref_36_M3_noxref_s ) capacitor c=0.0295256f \
 //x=6.11 //y=1.055 //x2=5.755 //y2=0.555
cc_1057 ( N_noxref_3_c_924_p N_noxref_36_M3_noxref_s ) capacitor c=7.99997e-19 \
 //x=6.11 //y=1.71 //x2=5.755 //y2=0.555
cc_1058 ( N_noxref_3_c_888_p N_noxref_36_M3_noxref_s ) capacitor c=0.00122123f \
 //x=6.11 //y=2.095 //x2=5.755 //y2=0.555
cc_1059 ( N_noxref_3_c_923_p N_noxref_36_M3_noxref_s ) capacitor c=0.0125924f \
 //x=6.64 //y=1.055 //x2=5.755 //y2=0.555
cc_1060 ( N_noxref_3_c_989_p N_noxref_39_c_15774_n ) capacitor c=0.00262672f \
 //x=19.06 //y=2.095 //x2=18.84 //y2=1.685
cc_1061 ( N_noxref_3_c_822_p N_noxref_39_c_15775_n ) capacitor c=0.00428451f \
 //x=19.36 //y=2.375 //x2=19.725 //y2=1.77
cc_1062 ( N_noxref_3_c_824_p N_noxref_39_c_15775_n ) capacitor c=0.00205403f \
 //x=19.36 //y=4.04 //x2=19.725 //y2=1.77
cc_1063 ( N_noxref_3_c_988_p N_noxref_39_c_15775_n ) capacitor c=0.0104666f \
 //x=19.36 //y=2.26 //x2=19.725 //y2=1.77
cc_1064 ( N_noxref_3_c_1019_p N_noxref_39_c_15775_n ) capacitor c=0.00705077f \
 //x=19.06 //y=1.71 //x2=19.725 //y2=1.77
cc_1065 ( N_noxref_3_c_989_p N_noxref_39_c_15775_n ) capacitor c=0.020708f \
 //x=19.06 //y=2.095 //x2=19.725 //y2=1.77
cc_1066 ( N_noxref_3_c_1139_p N_noxref_39_c_15775_n ) capacitor c=0.00588627f \
 //x=19.435 //y=1.555 //x2=19.725 //y2=1.77
cc_1067 ( N_noxref_3_c_1020_p N_noxref_39_c_15775_n ) capacitor c=0.00698822f \
 //x=19.59 //y=1.4 //x2=19.725 //y2=1.77
cc_1068 ( N_noxref_3_c_1016_p N_noxref_39_M11_noxref_s ) capacitor \
 c=0.0295256f //x=19.06 //y=1.055 //x2=18.705 //y2=0.555
cc_1069 ( N_noxref_3_c_1019_p N_noxref_39_M11_noxref_s ) capacitor \
 c=7.99997e-19 //x=19.06 //y=1.71 //x2=18.705 //y2=0.555
cc_1070 ( N_noxref_3_c_989_p N_noxref_39_M11_noxref_s ) capacitor \
 c=0.00122123f //x=19.06 //y=2.095 //x2=18.705 //y2=0.555
cc_1071 ( N_noxref_3_c_1018_p N_noxref_39_M11_noxref_s ) capacitor \
 c=0.0125924f //x=19.59 //y=1.055 //x2=18.705 //y2=0.555
cc_1072 ( N_noxref_4_c_1377_p N_noxref_9_c_3531_n ) capacitor c=0.00227577f \
 //x=24.91 //y=4.095 //x2=27.5 //y2=4.1
cc_1073 ( N_noxref_4_c_1378_p N_noxref_9_c_3532_n ) capacitor c=4.60155e-19 \
 //x=24.91 //y=4.735 //x2=27.5 //y2=4.755
cc_1074 ( N_noxref_4_c_1379_p N_noxref_9_c_3533_n ) capacitor c=3.5728e-19 \
 //x=24.91 //y=4.25 //x2=27.5 //y2=4.25
cc_1075 ( N_noxref_4_c_1380_p N_noxref_9_c_3534_n ) capacitor c=0.00179992f \
 //x=24.9 //y=4.255 //x2=27.66 //y2=4.26
cc_1076 ( N_noxref_4_c_1224_n D ) capacitor c=0.0239233f //x=12.125 //y=4.25 \
 //x2=7.52 //y2=3.14
cc_1077 ( N_noxref_4_c_1199_n N_D_c_4197_n ) capacitor c=0.0248433f //x=11.96 \
 //y=4.09 //x2=33.26 //y2=2.755
cc_1078 ( N_noxref_4_c_1322_n N_D_c_4197_n ) capacitor c=0.0275401f //x=17.51 \
 //y=4.095 //x2=33.26 //y2=2.755
cc_1079 ( N_noxref_4_c_1384_p N_D_c_4197_n ) capacitor c=0.0233645f //x=22.32 \
 //y=4.075 //x2=33.26 //y2=2.755
cc_1080 ( N_noxref_4_c_1385_p N_D_c_4197_n ) capacitor c=0.0233546f //x=24.17 \
 //y=4.075 //x2=33.26 //y2=2.755
cc_1081 ( N_noxref_4_c_1377_p N_D_c_4197_n ) capacitor c=0.0206273f //x=24.91 \
 //y=4.095 //x2=33.26 //y2=2.755
cc_1082 ( N_noxref_4_c_1276_n N_D_c_4197_n ) capacitor c=0.0163473f //x=17.355 \
 //y=4.25 //x2=33.26 //y2=2.755
cc_1083 ( N_noxref_4_c_1224_n N_D_c_4197_n ) capacitor c=0.00201308f \
 //x=12.125 //y=4.25 //x2=33.26 //y2=2.755
cc_1084 ( N_noxref_4_c_1363_n N_D_c_4197_n ) capacitor c=0.0108644f //x=19.22 \
 //y=4.265 //x2=33.26 //y2=2.755
cc_1085 ( N_noxref_4_c_1366_n N_D_c_4197_n ) capacitor c=0.0422318f //x=22.475 \
 //y=4.25 //x2=33.26 //y2=2.755
cc_1086 ( N_noxref_4_c_1391_p N_D_c_4197_n ) capacitor c=0.00491792f //x=24.02 \
 //y=4.235 //x2=33.26 //y2=2.755
cc_1087 ( N_noxref_4_c_1392_p N_D_c_4197_n ) capacitor c=0.0017585f //x=24.74 \
 //y=4.255 //x2=33.26 //y2=2.755
cc_1088 ( N_noxref_4_c_1196_n CLK ) capacitor c=0.0544022f //x=1.6 //y=4.1 \
 //x2=2.71 //y2=2.77
cc_1089 ( N_noxref_4_c_1394_p CLK ) capacitor c=0.00795617f //x=1.6 //y=4.42 \
 //x2=2.71 //y2=2.77
cc_1090 ( N_noxref_4_c_1198_n CLK ) capacitor c=0.00593778f //x=1.6 //y=4.755 \
 //x2=2.71 //y2=2.77
cc_1091 ( N_noxref_4_c_1396_p CLK ) capacitor c=4.22577e-19 //x=1.6 //y=4.25 \
 //x2=2.71 //y2=2.77
cc_1092 ( N_noxref_4_c_1217_n CLK ) capacitor c=0.0286023f //x=4.175 //y=4.25 \
 //x2=2.71 //y2=2.77
cc_1093 ( N_noxref_4_c_1398_p CLK ) capacitor c=0.00242466f //x=1.76 //y=4.26 \
 //x2=2.71 //y2=2.77
cc_1094 ( N_noxref_4_c_1399_p CLK ) capacitor c=4.16726e-19 //x=1.6 //y=2.26 \
 //x2=2.71 //y2=2.77
cc_1095 ( N_noxref_4_c_1322_n CLK ) capacitor c=0.00253693f //x=17.51 \
 //y=4.095 //x2=15.66 //y2=3.14
cc_1096 ( N_noxref_4_c_1331_n CLK ) capacitor c=2.99109e-19 //x=17.51 //y=5.25 \
 //x2=15.66 //y2=3.14
cc_1097 ( N_noxref_4_c_1276_n CLK ) capacitor c=0.023508f //x=17.355 //y=4.25 \
 //x2=15.66 //y2=3.14
cc_1098 ( N_noxref_4_c_1403_p N_CLK_c_4769_n ) capacitor c=0.0115546f //x=1.6 \
 //y=2.375 //x2=2.71 //y2=2.375
cc_1099 ( N_noxref_4_c_1217_n N_CLK_c_4769_n ) capacitor c=0.00160969f \
 //x=4.175 //y=4.25 //x2=2.71 //y2=2.375
cc_1100 ( N_noxref_4_c_1399_p N_CLK_c_4769_n ) capacitor c=5.40058e-19 //x=1.6 \
 //y=2.26 //x2=2.71 //y2=2.375
cc_1101 ( N_noxref_4_c_1406_p N_CLK_c_4769_n ) capacitor c=0.00147006f //x=1.3 \
 //y=2.095 //x2=2.71 //y2=2.375
cc_1102 ( N_noxref_4_c_1198_n N_CLK_c_4772_n ) capacitor c=0.00911997f //x=1.6 \
 //y=4.755 //x2=2.705 //y2=4.835
cc_1103 ( N_noxref_4_c_1217_n N_CLK_c_4772_n ) capacitor c=0.00269476f \
 //x=4.175 //y=4.25 //x2=2.705 //y2=4.835
cc_1104 ( N_noxref_4_c_1409_p N_CLK_c_4772_n ) capacitor c=6.32742e-19 //x=1.6 \
 //y=4.88 //x2=2.705 //y2=4.835
cc_1105 ( N_noxref_4_c_1375_n N_CLK_c_4772_n ) capacitor c=7.15803e-19 \
 //x=2.165 //y=4.97 //x2=2.705 //y2=4.835
cc_1106 ( N_noxref_4_c_1411_p N_CLK_c_4772_n ) capacitor c=8.67242e-19 \
 //x=1.875 //y=4.97 //x2=2.705 //y2=4.835
cc_1107 ( N_noxref_4_c_1266_n N_CLK_c_4815_n ) capacitor c=0.0234494f \
 //x=15.73 //y=5.335 //x2=15.655 //y2=4.695
cc_1108 ( N_noxref_4_c_1413_p N_CLK_c_4815_n ) capacitor c=0.00463905f \
 //x=15.85 //y=5.335 //x2=15.655 //y2=4.695
cc_1109 ( N_noxref_4_c_1276_n N_CLK_c_4815_n ) capacitor c=0.00375947f \
 //x=17.355 //y=4.25 //x2=15.655 //y2=4.695
cc_1110 ( N_noxref_4_c_1415_p N_CLK_c_4815_n ) capacitor c=0.00169377f \
 //x=15.85 //y=5.56 //x2=15.655 //y2=4.695
cc_1111 ( N_noxref_4_c_1207_n N_CLK_c_4775_n ) capacitor c=0.00261296f \
 //x=11.96 //y=4.41 //x2=11.58 //y2=4.62
cc_1112 ( N_noxref_4_c_1208_n N_CLK_c_4775_n ) capacitor c=3.14882e-19 \
 //x=11.96 //y=4.735 //x2=11.58 //y2=4.62
cc_1113 ( N_noxref_4_c_1217_n N_CLK_c_4775_n ) capacitor c=0.064437f //x=4.175 \
 //y=4.25 //x2=11.58 //y2=4.62
cc_1114 ( N_noxref_4_c_1221_n N_CLK_c_4775_n ) capacitor c=0.113902f //x=4.815 \
 //y=4.27 //x2=11.58 //y2=4.62
cc_1115 ( N_noxref_4_c_1222_n N_CLK_c_4775_n ) capacitor c=0.0602971f //x=6.03 \
 //y=4.25 //x2=11.58 //y2=4.62
cc_1116 ( N_noxref_4_c_1224_n N_CLK_c_4775_n ) capacitor c=0.496301f \
 //x=12.125 //y=4.25 //x2=11.58 //y2=4.62
cc_1117 ( N_noxref_4_c_1207_n N_CLK_c_4821_n ) capacitor c=0.00232919f \
 //x=11.96 //y=4.41 //x2=12.18 //y2=4.635
cc_1118 ( N_noxref_4_c_1208_n N_CLK_c_4821_n ) capacitor c=0.0262394f \
 //x=11.96 //y=4.735 //x2=12.18 //y2=4.635
cc_1119 ( N_noxref_4_c_1276_n N_CLK_c_4821_n ) capacitor c=0.0123783f \
 //x=17.355 //y=4.25 //x2=12.18 //y2=4.635
cc_1120 ( N_noxref_4_c_1251_n N_CLK_c_4821_n ) capacitor c=7.56668e-19 \
 //x=11.99 //y=4.88 //x2=12.18 //y2=4.635
cc_1121 ( N_noxref_4_c_1328_n N_CLK_c_4868_n ) capacitor c=0.00431212f \
 //x=17.51 //y=4.415 //x2=17.73 //y2=4.64
cc_1122 ( N_noxref_4_c_1331_n N_CLK_c_4868_n ) capacitor c=0.0293846f \
 //x=17.51 //y=5.25 //x2=17.73 //y2=4.64
cc_1123 ( N_noxref_4_c_1363_n N_CLK_c_4868_n ) capacitor c=0.13123f //x=19.22 \
 //y=4.265 //x2=17.73 //y2=4.64
cc_1124 ( N_noxref_4_c_1208_n N_CLK_c_4822_n ) capacitor c=3.09272e-19 \
 //x=11.96 //y=4.735 //x2=17.385 //y2=4.64
cc_1125 ( N_noxref_4_c_1266_n N_CLK_c_4822_n ) capacitor c=0.00121614f \
 //x=15.73 //y=5.335 //x2=17.385 //y2=4.64
cc_1126 ( N_noxref_4_c_1431_p N_CLK_c_4822_n ) capacitor c=0.0203211f \
 //x=17.425 //y=5.335 //x2=17.385 //y2=4.64
cc_1127 ( N_noxref_4_c_1328_n N_CLK_c_4822_n ) capacitor c=0.00255844f \
 //x=17.51 //y=4.415 //x2=17.385 //y2=4.64
cc_1128 ( N_noxref_4_c_1331_n N_CLK_c_4822_n ) capacitor c=4.1983e-19 \
 //x=17.51 //y=5.25 //x2=17.385 //y2=4.64
cc_1129 ( N_noxref_4_c_1271_n N_CLK_c_4822_n ) capacitor c=0.0278748f \
 //x=14.972 //y=5.335 //x2=17.385 //y2=4.64
cc_1130 ( N_noxref_4_c_1413_p N_CLK_c_4822_n ) capacitor c=0.039567f //x=15.85 \
 //y=5.335 //x2=17.385 //y2=4.64
cc_1131 ( N_noxref_4_c_1276_n N_CLK_c_4822_n ) capacitor c=0.463741f \
 //x=17.355 //y=4.25 //x2=17.385 //y2=4.64
cc_1132 ( N_noxref_4_c_1363_n N_CLK_c_4822_n ) capacitor c=0.0364799f \
 //x=19.22 //y=4.265 //x2=17.385 //y2=4.64
cc_1133 ( N_noxref_4_c_1438_p N_CLK_c_4875_n ) capacitor c=0.0205724f \
 //x=22.235 //y=5.335 //x2=24.515 //y2=4.62
cc_1134 ( N_noxref_4_c_1439_p N_CLK_c_4875_n ) capacitor c=0.00877199f \
 //x=22.32 //y=4.395 //x2=24.515 //y2=4.62
cc_1135 ( N_noxref_4_c_1440_p N_CLK_c_4875_n ) capacitor c=0.0294637f \
 //x=22.32 //y=5.25 //x2=24.515 //y2=4.62
cc_1136 ( N_noxref_4_c_1441_p N_CLK_c_4875_n ) capacitor c=0.00677089f \
 //x=24.17 //y=4.395 //x2=24.515 //y2=4.62
cc_1137 ( N_noxref_4_c_1442_p N_CLK_c_4875_n ) capacitor c=0.0026189f \
 //x=24.91 //y=4.415 //x2=24.515 //y2=4.62
cc_1138 ( N_noxref_4_c_1378_p N_CLK_c_4875_n ) capacitor c=4.08711e-19 \
 //x=24.91 //y=4.735 //x2=24.515 //y2=4.62
cc_1139 ( N_noxref_4_c_1333_n N_CLK_c_4875_n ) capacitor c=0.0297912f \
 //x=19.782 //y=5.335 //x2=24.515 //y2=4.62
cc_1140 ( N_noxref_4_c_1445_p N_CLK_c_4875_n ) capacitor c=0.0400278f \
 //x=20.66 //y=5.335 //x2=24.515 //y2=4.62
cc_1141 ( N_noxref_4_c_1446_p N_CLK_c_4875_n ) capacitor c=0.00281289f \
 //x=24.17 //y=4.88 //x2=24.515 //y2=4.62
cc_1142 ( N_noxref_4_c_1447_p N_CLK_c_4875_n ) capacitor c=0.0265489f \
 //x=24.172 //y=4.74 //x2=24.515 //y2=4.62
cc_1143 ( N_noxref_4_c_1363_n N_CLK_c_4875_n ) capacitor c=0.0603296f \
 //x=19.22 //y=4.265 //x2=24.515 //y2=4.62
cc_1144 ( N_noxref_4_c_1366_n N_CLK_c_4875_n ) capacitor c=0.261182f \
 //x=22.475 //y=4.25 //x2=24.515 //y2=4.62
cc_1145 ( N_noxref_4_c_1391_p N_CLK_c_4875_n ) capacitor c=0.141126f //x=24.02 \
 //y=4.235 //x2=24.515 //y2=4.62
cc_1146 ( N_noxref_4_c_1451_p N_CLK_c_4875_n ) capacitor c=0.036523f //x=24.34 \
 //y=4.235 //x2=24.515 //y2=4.62
cc_1147 ( N_noxref_4_c_1380_p N_CLK_c_4875_n ) capacitor c=0.0364798f //x=24.9 \
 //y=4.255 //x2=24.515 //y2=4.62
cc_1148 ( N_noxref_4_c_1392_p N_CLK_c_4875_n ) capacitor c=0.0375979f \
 //x=24.74 //y=4.255 //x2=24.515 //y2=4.62
cc_1149 ( N_noxref_4_c_1442_p N_CLK_c_4950_n ) capacitor c=0.00209198f \
 //x=24.91 //y=4.415 //x2=25.115 //y2=4.64
cc_1150 ( N_noxref_4_c_1378_p N_CLK_c_4950_n ) capacitor c=0.0265578f \
 //x=24.91 //y=4.735 //x2=25.115 //y2=4.64
cc_1151 ( N_noxref_4_c_1456_p N_CLK_c_4950_n ) capacitor c=7.54771e-19 \
 //x=24.94 //y=4.88 //x2=25.115 //y2=4.64
cc_1152 ( N_noxref_4_c_1198_n N_CLK_c_4783_n ) capacitor c=0.00912377f //x=1.6 \
 //y=4.755 //x2=2.705 //y2=4.62
cc_1153 ( N_noxref_4_c_1217_n N_CLK_c_4783_n ) capacitor c=0.155603f //x=4.175 \
 //y=4.25 //x2=2.705 //y2=4.62
cc_1154 ( N_noxref_4_c_1403_p N_CLK_c_4784_n ) capacitor c=0.00375644f //x=1.6 \
 //y=2.375 //x2=2.71 //y2=2.26
cc_1155 ( N_noxref_4_c_1196_n N_CLK_c_4784_n ) capacitor c=4.16726e-19 //x=1.6 \
 //y=4.1 //x2=2.71 //y2=2.26
cc_1156 ( N_noxref_4_c_1399_p N_CLK_c_4784_n ) capacitor c=0.00125213f //x=1.6 \
 //y=2.26 //x2=2.71 //y2=2.26
cc_1157 ( N_noxref_4_c_1406_p N_CLK_c_4784_n ) capacitor c=0.00214573f //x=1.3 \
 //y=2.095 //x2=2.71 //y2=2.26
cc_1158 ( N_noxref_4_c_1198_n N_CLK_c_4788_n ) capacitor c=0.00402042f //x=1.6 \
 //y=4.755 //x2=2.71 //y2=4.88
cc_1159 ( N_noxref_4_c_1409_p N_CLK_c_4788_n ) capacitor c=0.00113666f //x=1.6 \
 //y=4.88 //x2=2.71 //y2=4.88
cc_1160 ( N_noxref_4_c_1375_n N_CLK_c_4788_n ) capacitor c=0.00116563f \
 //x=2.165 //y=4.97 //x2=2.71 //y2=4.88
cc_1161 ( N_noxref_4_c_1411_p N_CLK_c_4788_n ) capacitor c=0.0012974f \
 //x=1.875 //y=4.97 //x2=2.71 //y2=4.88
cc_1162 ( N_noxref_4_c_1266_n N_CLK_c_4829_n ) capacitor c=0.00492634f \
 //x=15.73 //y=5.335 //x2=15.66 //y2=4.88
cc_1163 ( N_noxref_4_c_1413_p N_CLK_c_4829_n ) capacitor c=0.00132214f \
 //x=15.85 //y=5.335 //x2=15.66 //y2=4.88
cc_1164 ( N_noxref_4_M54_noxref_g N_CLK_M56_noxref_g ) capacitor c=0.0106276f \
 //x=1.8 //y=6.2 //x2=2.68 //y2=6.2
cc_1165 ( N_noxref_4_M55_noxref_g N_CLK_M56_noxref_g ) capacitor c=0.107144f \
 //x=2.24 //y=6.2 //x2=2.68 //y2=6.2
cc_1166 ( N_noxref_4_M55_noxref_g N_CLK_M57_noxref_g ) capacitor c=0.0101598f \
 //x=2.24 //y=6.2 //x2=3.12 //y2=6.2
cc_1167 ( N_noxref_4_c_1266_n N_CLK_M72_noxref_g ) capacitor c=0.00858239f \
 //x=15.73 //y=5.335 //x2=15.63 //y2=6.2
cc_1168 ( N_noxref_4_c_1413_p N_CLK_M72_noxref_g ) capacitor c=0.00229818f \
 //x=15.85 //y=5.335 //x2=15.63 //y2=6.2
cc_1169 ( N_noxref_4_c_1415_p N_CLK_M72_noxref_g ) capacitor c=0.0179041f \
 //x=15.85 //y=5.56 //x2=15.63 //y2=6.2
cc_1170 ( N_noxref_4_c_1475_p N_CLK_M73_noxref_g ) capacitor c=0.00955829f \
 //x=16.615 //y=5.335 //x2=16.07 //y2=6.2
cc_1171 ( N_noxref_4_c_1413_p N_CLK_M73_noxref_g ) capacitor c=0.00230699f \
 //x=15.85 //y=5.335 //x2=16.07 //y2=6.2
cc_1172 ( N_noxref_4_c_1415_p N_CLK_M73_noxref_g ) capacitor c=0.0179041f \
 //x=15.85 //y=5.56 //x2=16.07 //y2=6.2
cc_1173 ( N_noxref_4_c_1478_p N_CLK_c_4974_n ) capacitor c=5.72528e-19 //x=1.3 \
 //y=1.055 //x2=2.275 //y2=1.09
cc_1174 ( N_noxref_4_c_1479_p N_CLK_c_4974_n ) capacitor c=0.00150277f //x=1.3 \
 //y=1.4 //x2=2.275 //y2=1.09
cc_1175 ( N_noxref_4_c_1480_p N_CLK_c_4974_n ) capacitor c=0.0160123f //x=1.83 \
 //y=1.055 //x2=2.275 //y2=1.09
cc_1176 ( N_noxref_4_c_1481_p N_CLK_c_4977_n ) capacitor c=0.00111227f //x=1.3 \
 //y=1.71 //x2=2.275 //y2=1.4
cc_1177 ( N_noxref_4_c_1482_p N_CLK_c_4977_n ) capacitor c=0.0124075f //x=1.83 \
 //y=1.4 //x2=2.275 //y2=1.4
cc_1178 ( N_noxref_4_c_1480_p N_CLK_c_4794_n ) capacitor c=9.19165e-19 \
 //x=1.83 //y=1.055 //x2=2.8 //y2=1.09
cc_1179 ( N_noxref_4_c_1482_p N_CLK_c_4795_n ) capacitor c=0.0010154f //x=1.83 \
 //y=1.4 //x2=2.8 //y2=1.4
cc_1180 ( N_noxref_4_c_1482_p N_CLK_c_4796_n ) capacitor c=9.23422e-19 \
 //x=1.83 //y=1.4 //x2=2.8 //y2=1.63
cc_1181 ( N_noxref_4_c_1403_p N_CLK_c_4797_n ) capacitor c=0.00140534f //x=1.6 \
 //y=2.375 //x2=2.8 //y2=2.095
cc_1182 ( N_noxref_4_c_1399_p N_CLK_c_4797_n ) capacitor c=0.0020754f //x=1.6 \
 //y=2.26 //x2=2.8 //y2=2.095
cc_1183 ( N_noxref_4_c_1406_p N_CLK_c_4797_n ) capacitor c=0.00964411f //x=1.3 \
 //y=2.095 //x2=2.8 //y2=2.095
cc_1184 ( N_noxref_4_c_1413_p N_CLK_c_4985_n ) capacitor c=0.0017286f \
 //x=15.85 //y=5.335 //x2=15.995 //y2=4.97
cc_1185 ( N_noxref_4_c_1415_p N_CLK_c_4985_n ) capacitor c=0.00293647f \
 //x=15.85 //y=5.56 //x2=15.995 //y2=4.97
cc_1186 ( N_noxref_4_c_1198_n N_CLK_c_4802_n ) capacitor c=0.00107711f //x=1.6 \
 //y=4.755 //x2=2.71 //y2=4.88
cc_1187 ( N_noxref_4_c_1409_p N_CLK_c_4802_n ) capacitor c=0.00123917f //x=1.6 \
 //y=4.88 //x2=2.71 //y2=4.88
cc_1188 ( N_noxref_4_c_1375_n N_CLK_c_4802_n ) capacitor c=0.0169508f \
 //x=2.165 //y=4.97 //x2=2.71 //y2=4.88
cc_1189 ( N_noxref_4_c_1411_p N_CLK_c_4802_n ) capacitor c=0.00406071f \
 //x=1.875 //y=4.97 //x2=2.71 //y2=4.88
cc_1190 ( N_noxref_4_c_1266_n N_CLK_c_4847_n ) capacitor c=3.77911e-19 \
 //x=15.73 //y=5.335 //x2=15.66 //y2=4.88
cc_1191 ( N_noxref_4_c_1224_n RN ) capacitor c=0.0220634f //x=12.125 //y=4.25 \
 //x2=8.63 //y2=3.14
cc_1192 ( N_noxref_4_c_1322_n RN ) capacitor c=0.0695067f //x=17.51 //y=4.095 \
 //x2=16.77 //y2=3.14
cc_1193 ( N_noxref_4_c_1328_n RN ) capacitor c=0.0172847f //x=17.51 //y=4.415 \
 //x2=16.77 //y2=3.14
cc_1194 ( N_noxref_4_c_1331_n RN ) capacitor c=0.0121545f //x=17.51 //y=5.25 \
 //x2=16.77 //y2=3.14
cc_1195 ( N_noxref_4_c_1500_p RN ) capacitor c=6.89957e-19 //x=17.51 //y=4.25 \
 //x2=16.77 //y2=3.14
cc_1196 ( N_noxref_4_c_1276_n RN ) capacitor c=0.0209751f //x=17.355 //y=4.25 \
 //x2=16.77 //y2=3.14
cc_1197 ( N_noxref_4_c_1363_n RN ) capacitor c=0.00325739f //x=19.22 //y=4.265 \
 //x2=16.77 //y2=3.14
cc_1198 ( N_noxref_4_c_1322_n RN ) capacitor c=0.00179698f //x=17.51 //y=4.095 \
 //x2=20.47 //y2=3.14
cc_1199 ( N_noxref_4_c_1331_n RN ) capacitor c=3.82204e-19 //x=17.51 //y=5.25 \
 //x2=20.47 //y2=3.14
cc_1200 ( N_noxref_4_c_1384_p RN ) capacitor c=0.00311616f //x=22.32 //y=4.075 \
 //x2=20.47 //y2=3.14
cc_1201 ( N_noxref_4_c_1440_p RN ) capacitor c=4.809e-19 //x=22.32 //y=5.25 \
 //x2=20.47 //y2=3.14
cc_1202 ( N_noxref_4_c_1366_n RN ) capacitor c=0.0291747f //x=22.475 //y=4.25 \
 //x2=20.47 //y2=3.14
cc_1203 ( N_noxref_4_c_1508_p N_RN_c_6429_n ) capacitor c=5.60322e-19 \
 //x=17.025 //y=1.305 //x2=16.77 //y2=2.465
cc_1204 ( N_noxref_4_c_1322_n N_RN_c_6429_n ) capacitor c=0.0170216f //x=17.51 \
 //y=4.095 //x2=16.77 //y2=2.465
cc_1205 ( N_noxref_4_c_1510_p N_RN_c_6429_n ) capacitor c=4.27678e-19 \
 //x=16.73 //y=5.335 //x2=16.77 //y2=2.465
cc_1206 ( N_noxref_4_c_1431_p N_RN_c_6432_n ) capacitor c=0.00228791f \
 //x=17.425 //y=5.335 //x2=16.77 //y2=4.75
cc_1207 ( N_noxref_4_c_1331_n N_RN_c_6432_n ) capacitor c=0.0151931f //x=17.51 \
 //y=5.25 //x2=16.77 //y2=4.75
cc_1208 ( N_noxref_4_c_1510_p N_RN_c_6432_n ) capacitor c=0.022916f //x=16.73 \
 //y=5.335 //x2=16.77 //y2=4.75
cc_1209 ( N_noxref_4_c_1514_p N_RN_c_6432_n ) capacitor c=0.00266858f \
 //x=16.73 //y=5.56 //x2=16.77 //y2=4.75
cc_1210 ( N_noxref_4_c_1332_n N_RN_c_6372_n ) capacitor c=6.01844e-19 \
 //x=20.54 //y=5.335 //x2=20.47 //y2=2.515
cc_1211 ( N_noxref_4_c_1332_n N_RN_c_6376_n ) capacitor c=0.0212668f //x=20.54 \
 //y=5.335 //x2=20.47 //y2=4.765
cc_1212 ( N_noxref_4_c_1445_p N_RN_c_6376_n ) capacitor c=0.00239361f \
 //x=20.66 //y=5.335 //x2=20.47 //y2=4.765
cc_1213 ( N_noxref_4_c_1518_p N_RN_c_6376_n ) capacitor c=7.85344e-19 \
 //x=20.66 //y=5.56 //x2=20.47 //y2=4.765
cc_1214 ( N_noxref_4_c_1268_n N_RN_c_6380_n ) capacitor c=0.021696f //x=17.11 \
 //y=1.845 //x2=20.265 //y2=2.4
cc_1215 ( N_noxref_4_c_1322_n N_RN_c_6380_n ) capacitor c=0.027451f //x=17.51 \
 //y=4.095 //x2=20.265 //y2=2.4
cc_1216 ( N_noxref_4_c_1361_n N_RN_c_6380_n ) capacitor c=5.23559e-19 \
 //x=19.565 //y=4.265 //x2=20.265 //y2=2.4
cc_1217 ( N_noxref_4_c_1366_n N_RN_c_6380_n ) capacitor c=0.00231139f \
 //x=22.475 //y=4.25 //x2=20.265 //y2=2.4
cc_1218 ( N_noxref_4_c_1523_p N_RN_c_6386_n ) capacitor c=6.59681e-19 \
 //x=21.835 //y=1.305 //x2=33.205 //y2=2.37
cc_1219 ( N_noxref_4_c_1524_p N_RN_c_6386_n ) capacitor c=0.0209906f //x=21.92 \
 //y=1.845 //x2=33.205 //y2=2.37
cc_1220 ( N_noxref_4_c_1384_p N_RN_c_6386_n ) capacitor c=0.0278451f //x=22.32 \
 //y=4.075 //x2=33.205 //y2=2.37
cc_1221 ( N_noxref_4_c_1385_p N_RN_c_6386_n ) capacitor c=0.0127016f //x=24.17 \
 //y=4.075 //x2=33.205 //y2=2.37
cc_1222 ( N_noxref_4_c_1377_p N_RN_c_6386_n ) capacitor c=0.0113738f //x=24.91 \
 //y=4.095 //x2=33.205 //y2=2.37
cc_1223 ( N_noxref_4_c_1528_p N_RN_c_6386_n ) capacitor c=0.0184063f //x=24.17 \
 //y=2.26 //x2=33.205 //y2=2.37
cc_1224 ( N_noxref_4_c_1529_p N_RN_c_6386_n ) capacitor c=0.0170089f //x=24.91 \
 //y=2.26 //x2=33.205 //y2=2.37
cc_1225 ( N_noxref_4_c_1366_n N_RN_c_6386_n ) capacitor c=0.00272015f \
 //x=22.475 //y=4.25 //x2=33.205 //y2=2.37
cc_1226 ( N_noxref_4_c_1531_p N_RN_c_6386_n ) capacitor c=2.20453e-19 \
 //x=24.17 //y=2.26 //x2=33.205 //y2=2.37
cc_1227 ( N_noxref_4_c_1532_p N_RN_c_6386_n ) capacitor c=3.61358e-19 \
 //x=23.975 //y=2.095 //x2=33.205 //y2=2.37
cc_1228 ( N_noxref_4_c_1533_p N_RN_c_6386_n ) capacitor c=2.98635e-19 \
 //x=24.91 //y=2.26 //x2=33.205 //y2=2.37
cc_1229 ( N_noxref_4_c_1199_n N_RN_c_6308_n ) capacitor c=0.0113611f //x=11.96 \
 //y=4.09 //x2=16.615 //y2=2.315
cc_1230 ( N_noxref_4_c_1214_n N_RN_c_6308_n ) capacitor c=0.0170024f //x=11.96 \
 //y=2.26 //x2=16.615 //y2=2.315
cc_1231 ( N_noxref_4_c_1248_n N_RN_c_6308_n ) capacitor c=2.98635e-19 \
 //x=11.96 //y=2.26 //x2=16.615 //y2=2.315
cc_1232 ( N_noxref_4_c_1508_p N_RN_c_6391_n ) capacitor c=4.13793e-19 \
 //x=17.025 //y=1.305 //x2=16.935 //y2=2.315
cc_1233 ( N_noxref_4_c_1322_n N_RN_c_6391_n ) capacitor c=0.00372846f \
 //x=17.51 //y=4.095 //x2=16.935 //y2=2.315
cc_1234 ( N_noxref_4_c_1322_n N_RN_c_6460_n ) capacitor c=0.00115564f \
 //x=17.51 //y=4.095 //x2=16.77 //y2=2.26
cc_1235 ( N_noxref_4_c_1431_p N_RN_c_6461_n ) capacitor c=0.00130631f \
 //x=17.425 //y=5.335 //x2=16.77 //y2=4.88
cc_1236 ( N_noxref_4_c_1331_n N_RN_c_6461_n ) capacitor c=0.00129641f \
 //x=17.51 //y=5.25 //x2=16.77 //y2=4.88
cc_1237 ( N_noxref_4_c_1510_p N_RN_c_6461_n ) capacitor c=0.00346017f \
 //x=16.73 //y=5.335 //x2=16.77 //y2=4.88
cc_1238 ( N_noxref_4_c_1514_p N_RN_c_6461_n ) capacitor c=0.00624059f \
 //x=16.73 //y=5.56 //x2=16.77 //y2=4.88
cc_1239 ( N_noxref_4_c_1332_n N_RN_c_6395_n ) capacitor c=0.00492634f \
 //x=20.54 //y=5.335 //x2=20.47 //y2=4.88
cc_1240 ( N_noxref_4_c_1445_p N_RN_c_6395_n ) capacitor c=0.00132214f \
 //x=20.66 //y=5.335 //x2=20.47 //y2=4.88
cc_1241 ( N_noxref_4_c_1475_p N_RN_M74_noxref_g ) capacitor c=0.00955829f \
 //x=16.615 //y=5.335 //x2=16.51 //y2=6.2
cc_1242 ( N_noxref_4_c_1547_p N_RN_M74_noxref_g ) capacitor c=0.00226521f \
 //x=16.73 //y=5.56 //x2=16.51 //y2=6.2
cc_1243 ( N_noxref_4_c_1514_p N_RN_M74_noxref_g ) capacitor c=0.0178885f \
 //x=16.73 //y=5.56 //x2=16.51 //y2=6.2
cc_1244 ( N_noxref_4_c_1547_p N_RN_M75_noxref_g ) capacitor c=0.00381703f \
 //x=16.73 //y=5.56 //x2=16.95 //y2=6.2
cc_1245 ( N_noxref_4_c_1431_p N_RN_M75_noxref_g ) capacitor c=0.0108612f \
 //x=17.425 //y=5.335 //x2=16.95 //y2=6.2
cc_1246 ( N_noxref_4_c_1514_p N_RN_M75_noxref_g ) capacitor c=0.0188608f \
 //x=16.73 //y=5.56 //x2=16.95 //y2=6.2
cc_1247 ( N_noxref_4_c_1332_n N_RN_M78_noxref_g ) capacitor c=0.00858241f \
 //x=20.54 //y=5.335 //x2=20.44 //y2=6.2
cc_1248 ( N_noxref_4_c_1445_p N_RN_M78_noxref_g ) capacitor c=0.00229818f \
 //x=20.66 //y=5.335 //x2=20.44 //y2=6.2
cc_1249 ( N_noxref_4_c_1518_p N_RN_M78_noxref_g ) capacitor c=0.0179041f \
 //x=20.66 //y=5.56 //x2=20.44 //y2=6.2
cc_1250 ( N_noxref_4_c_1555_p N_RN_M79_noxref_g ) capacitor c=0.00955829f \
 //x=21.425 //y=5.335 //x2=20.88 //y2=6.2
cc_1251 ( N_noxref_4_c_1445_p N_RN_M79_noxref_g ) capacitor c=0.00230699f \
 //x=20.66 //y=5.335 //x2=20.88 //y2=6.2
cc_1252 ( N_noxref_4_c_1518_p N_RN_M79_noxref_g ) capacitor c=0.0179041f \
 //x=20.66 //y=5.56 //x2=20.88 //y2=6.2
cc_1253 ( N_noxref_4_c_1508_p N_RN_c_6479_n ) capacitor c=4.64015e-19 \
 //x=17.025 //y=1.305 //x2=16.76 //y2=1.095
cc_1254 ( N_noxref_4_M10_noxref_d N_RN_c_6479_n ) capacitor c=0.00137165f \
 //x=16.835 //y=1.095 //x2=16.76 //y2=1.095
cc_1255 ( N_noxref_4_c_1508_p N_RN_c_6481_n ) capacitor c=0.0026012f \
 //x=17.025 //y=1.305 //x2=16.76 //y2=1.44
cc_1256 ( N_noxref_4_c_1267_n N_RN_c_6481_n ) capacitor c=0.00127432f \
 //x=17.025 //y=1.76 //x2=16.76 //y2=1.44
cc_1257 ( N_noxref_4_M10_noxref_d N_RN_c_6481_n ) capacitor c=0.00237422f \
 //x=16.835 //y=1.095 //x2=16.76 //y2=1.44
cc_1258 ( N_noxref_4_c_1267_n N_RN_c_6484_n ) capacitor c=0.00441386f \
 //x=17.025 //y=1.76 //x2=16.76 //y2=1.75
cc_1259 ( N_noxref_4_c_1508_p N_RN_c_6485_n ) capacitor c=5.29969e-19 \
 //x=17.025 //y=1.305 //x2=17.135 //y2=0.94
cc_1260 ( N_noxref_4_M10_noxref_d N_RN_c_6485_n ) capacitor c=0.0020782f \
 //x=16.835 //y=1.095 //x2=17.135 //y2=0.94
cc_1261 ( N_noxref_4_c_1508_p N_RN_c_6487_n ) capacitor c=4.32061e-19 \
 //x=17.025 //y=1.305 //x2=17.135 //y2=1.595
cc_1262 ( N_noxref_4_c_1267_n N_RN_c_6487_n ) capacitor c=0.00942306f \
 //x=17.025 //y=1.76 //x2=17.135 //y2=1.595
cc_1263 ( N_noxref_4_c_1568_p N_RN_c_6487_n ) capacitor c=0.00194716f \
 //x=17.425 //y=1.845 //x2=17.135 //y2=1.595
cc_1264 ( N_noxref_4_M10_noxref_d N_RN_c_6487_n ) capacitor c=0.00356097f \
 //x=16.835 //y=1.095 //x2=17.135 //y2=1.595
cc_1265 ( N_noxref_4_c_1508_p N_RN_c_6491_n ) capacitor c=5.24634e-19 \
 //x=17.025 //y=1.305 //x2=17.29 //y2=1.095
cc_1266 ( N_noxref_4_M10_noxref_d N_RN_c_6491_n ) capacitor c=0.00139206f \
 //x=16.835 //y=1.095 //x2=17.29 //y2=1.095
cc_1267 ( N_noxref_4_c_1508_p N_RN_c_6493_n ) capacitor c=0.00307978f \
 //x=17.025 //y=1.305 //x2=17.29 //y2=1.44
cc_1268 ( N_noxref_4_c_1267_n N_RN_c_6493_n ) capacitor c=0.00363411f \
 //x=17.025 //y=1.76 //x2=17.29 //y2=1.44
cc_1269 ( N_noxref_4_c_1568_p N_RN_c_6493_n ) capacitor c=0.00323576f \
 //x=17.425 //y=1.845 //x2=17.29 //y2=1.44
cc_1270 ( N_noxref_4_M10_noxref_d N_RN_c_6493_n ) capacitor c=0.00237422f \
 //x=16.835 //y=1.095 //x2=17.29 //y2=1.44
cc_1271 ( N_noxref_4_c_1445_p N_RN_c_6497_n ) capacitor c=0.00171075f \
 //x=20.66 //y=5.335 //x2=20.805 //y2=4.97
cc_1272 ( N_noxref_4_c_1518_p N_RN_c_6497_n ) capacitor c=0.00290085f \
 //x=20.66 //y=5.56 //x2=20.805 //y2=4.97
cc_1273 ( N_noxref_4_c_1322_n N_RN_c_6499_n ) capacitor c=3.96703e-19 \
 //x=17.51 //y=4.095 //x2=16.77 //y2=2.26
cc_1274 ( N_noxref_4_c_1267_n N_RN_c_6500_n ) capacitor c=0.00362297f \
 //x=17.025 //y=1.76 //x2=16.77 //y2=2.095
cc_1275 ( N_noxref_4_c_1322_n N_RN_c_6500_n ) capacitor c=0.00282067f \
 //x=17.51 //y=4.095 //x2=16.77 //y2=2.095
cc_1276 ( N_noxref_4_c_1331_n N_RN_c_6502_n ) capacitor c=0.007387f //x=17.51 \
 //y=5.25 //x2=16.77 //y2=4.88
cc_1277 ( N_noxref_4_c_1510_p N_RN_c_6502_n ) capacitor c=0.00203307f \
 //x=16.73 //y=5.335 //x2=16.77 //y2=4.88
cc_1278 ( N_noxref_4_c_1514_p N_RN_c_6502_n ) capacitor c=0.00375636f \
 //x=16.73 //y=5.56 //x2=16.77 //y2=4.88
cc_1279 ( N_noxref_4_c_1332_n N_RN_c_6413_n ) capacitor c=6.15714e-19 \
 //x=20.54 //y=5.335 //x2=20.47 //y2=4.88
cc_1280 ( N_noxref_4_c_1384_p N_noxref_16_c_9871_n ) capacitor c=0.0139216f \
 //x=22.32 //y=4.075 //x2=21.58 //y2=2.375
cc_1281 ( N_noxref_4_c_1384_p N_noxref_16_c_9868_n ) capacitor c=0.0235265f \
 //x=22.32 //y=4.075 //x2=21.58 //y2=2.995
cc_1282 ( N_noxref_4_c_1385_p N_noxref_16_c_9868_n ) capacitor c=9.46702e-19 \
 //x=24.17 //y=4.075 //x2=21.58 //y2=2.995
cc_1283 ( N_noxref_4_c_1555_p N_noxref_16_c_9874_n ) capacitor c=6.79605e-19 \
 //x=21.425 //y=5.335 //x2=21.58 //y2=3.315
cc_1284 ( N_noxref_4_c_1438_p N_noxref_16_c_9874_n ) capacitor c=7.87384e-19 \
 //x=22.235 //y=5.335 //x2=21.58 //y2=3.315
cc_1285 ( N_noxref_4_c_1523_p N_noxref_16_c_9874_n ) capacitor c=2.759e-19 \
 //x=21.835 //y=1.305 //x2=21.58 //y2=3.315
cc_1286 ( N_noxref_4_c_1524_p N_noxref_16_c_9874_n ) capacitor c=0.00146296f \
 //x=21.92 //y=1.845 //x2=21.58 //y2=3.315
cc_1287 ( N_noxref_4_c_1384_p N_noxref_16_c_9874_n ) capacitor c=0.0175485f \
 //x=22.32 //y=4.075 //x2=21.58 //y2=3.315
cc_1288 ( N_noxref_4_c_1366_n N_noxref_16_c_9874_n ) capacitor c=0.00258844f \
 //x=22.475 //y=4.25 //x2=21.58 //y2=3.315
cc_1289 ( N_noxref_4_c_1438_p N_noxref_16_c_9869_n ) capacitor c=0.00228791f \
 //x=22.235 //y=5.335 //x2=21.58 //y2=4.75
cc_1290 ( N_noxref_4_c_1384_p N_noxref_16_c_9869_n ) capacitor c=0.0354118f \
 //x=22.32 //y=4.075 //x2=21.58 //y2=4.75
cc_1291 ( N_noxref_4_c_1439_p N_noxref_16_c_9869_n ) capacitor c=0.0150714f \
 //x=22.32 //y=4.395 //x2=21.58 //y2=4.75
cc_1292 ( N_noxref_4_c_1440_p N_noxref_16_c_9869_n ) capacitor c=0.0284109f \
 //x=22.32 //y=5.25 //x2=21.58 //y2=4.75
cc_1293 ( N_noxref_4_c_1385_p N_noxref_16_c_9869_n ) capacitor c=7.7565e-19 \
 //x=24.17 //y=4.075 //x2=21.58 //y2=4.75
cc_1294 ( N_noxref_4_c_1599_p N_noxref_16_c_9869_n ) capacitor c=0.0221596f \
 //x=21.54 //y=5.335 //x2=21.58 //y2=4.75
cc_1295 ( N_noxref_4_c_1600_p N_noxref_16_c_9869_n ) capacitor c=7.6985e-19 \
 //x=22.32 //y=4.25 //x2=21.58 //y2=4.75
cc_1296 ( N_noxref_4_c_1447_p N_noxref_16_c_9869_n ) capacitor c=4.984e-19 \
 //x=24.172 //y=4.74 //x2=21.58 //y2=4.75
cc_1297 ( N_noxref_4_c_1366_n N_noxref_16_c_9869_n ) capacitor c=0.0288437f \
 //x=22.475 //y=4.25 //x2=21.58 //y2=4.75
cc_1298 ( N_noxref_4_c_1603_p N_noxref_16_c_9869_n ) capacitor c=0.00217653f \
 //x=21.54 //y=5.56 //x2=21.58 //y2=4.75
cc_1299 ( N_noxref_4_c_1442_p N_noxref_16_c_9890_n ) capacitor c=0.00393667f \
 //x=24.91 //y=4.415 //x2=25.055 //y2=5.38
cc_1300 ( N_noxref_4_c_1378_p N_noxref_16_c_9890_n ) capacitor c=0.0215252f \
 //x=24.91 //y=4.735 //x2=25.055 //y2=5.38
cc_1301 ( N_noxref_4_c_1606_p N_noxref_16_c_9890_n ) capacitor c=0.00469257f \
 //x=24.94 //y=4.88 //x2=25.055 //y2=5.38
cc_1302 ( N_noxref_4_M83_noxref_g N_noxref_16_c_9890_n ) capacitor \
 c=0.00888329f //x=24.51 //y=6.2 //x2=25.055 //y2=5.38
cc_1303 ( N_noxref_4_M84_noxref_g N_noxref_16_c_9890_n ) capacitor \
 c=0.00842859f //x=24.95 //y=6.2 //x2=25.055 //y2=5.38
cc_1304 ( N_noxref_4_c_1456_p N_noxref_16_c_9890_n ) capacitor c=8.41897e-19 \
 //x=24.94 //y=4.88 //x2=25.055 //y2=5.38
cc_1305 ( N_noxref_4_c_1610_p N_noxref_16_c_9896_n ) capacitor c=0.00326079f \
 //x=21.835 //y=1.76 //x2=25.21 //y2=1.75
cc_1306 ( N_noxref_4_c_1611_p N_noxref_16_c_9896_n ) capacitor c=0.00119302f \
 //x=24.945 //y=1.43 //x2=25.21 //y2=1.75
cc_1307 ( N_noxref_4_c_1612_p N_noxref_16_c_9896_n ) capacitor c=0.00439215f \
 //x=24.945 //y=1.74 //x2=25.21 //y2=1.75
cc_1308 ( N_noxref_4_c_1613_p N_noxref_16_c_9896_n ) capacitor c=0.00929773f \
 //x=25.32 //y=1.585 //x2=25.21 //y2=1.75
cc_1309 ( N_noxref_4_c_1614_p N_noxref_16_c_9896_n ) capacitor c=0.00341295f \
 //x=25.475 //y=1.43 //x2=25.21 //y2=1.75
cc_1310 ( N_noxref_4_c_1615_p N_noxref_16_c_9896_n ) capacitor c=0.00341688f \
 //x=24.91 //y=2.095 //x2=25.21 //y2=1.75
cc_1311 ( N_noxref_4_M85_noxref_g N_noxref_16_c_9902_n ) capacitor \
 c=0.0107457f //x=25.39 //y=6.2 //x2=25.565 //y2=5.38
cc_1312 ( N_noxref_4_c_1613_p N_noxref_16_c_9903_n ) capacitor c=0.00194324f \
 //x=25.32 //y=1.585 //x2=25.565 //y2=1.835
cc_1313 ( N_noxref_4_c_1614_p N_noxref_16_c_9903_n ) capacitor c=0.00323005f \
 //x=25.475 //y=1.43 //x2=25.565 //y2=1.835
cc_1314 ( N_noxref_4_c_1619_p N_noxref_16_c_9905_n ) capacitor c=0.00218808f \
 //x=22.235 //y=1.845 //x2=25.295 //y2=1.835
cc_1315 ( N_noxref_4_c_1619_p N_noxref_16_c_9906_n ) capacitor c=0.00203766f \
 //x=22.235 //y=1.845 //x2=25.65 //y2=2.995
cc_1316 ( N_noxref_4_c_1385_p N_noxref_16_c_9906_n ) capacitor c=0.00142418f \
 //x=24.17 //y=4.075 //x2=25.65 //y2=2.995
cc_1317 ( N_noxref_4_c_1377_p N_noxref_16_c_9906_n ) capacitor c=0.0227107f \
 //x=24.91 //y=4.095 //x2=25.65 //y2=2.995
cc_1318 ( N_noxref_4_c_1529_p N_noxref_16_c_9906_n ) capacitor c=0.0138368f \
 //x=24.91 //y=2.26 //x2=25.65 //y2=2.995
cc_1319 ( N_noxref_4_c_1624_p N_noxref_16_c_9906_n ) capacitor c=9.26054e-19 \
 //x=24.91 //y=2.26 //x2=25.65 //y2=2.995
cc_1320 ( N_noxref_4_c_1533_p N_noxref_16_c_9906_n ) capacitor c=0.00268898f \
 //x=24.91 //y=2.26 //x2=25.65 //y2=2.995
cc_1321 ( N_noxref_4_c_1615_p N_noxref_16_c_9906_n ) capacitor c=0.00309058f \
 //x=24.91 //y=2.095 //x2=25.65 //y2=2.995
cc_1322 ( N_noxref_4_c_1377_p N_noxref_16_c_9913_n ) capacitor c=0.01761f \
 //x=24.91 //y=4.095 //x2=25.65 //y2=3.315
cc_1323 ( N_noxref_4_c_1440_p N_noxref_16_c_9914_n ) capacitor c=0.0028534f \
 //x=22.32 //y=5.25 //x2=25.65 //y2=5.295
cc_1324 ( N_noxref_4_c_1385_p N_noxref_16_c_9914_n ) capacitor c=0.00127779f \
 //x=24.17 //y=4.075 //x2=25.65 //y2=5.295
cc_1325 ( N_noxref_4_c_1377_p N_noxref_16_c_9914_n ) capacitor c=0.0371095f \
 //x=24.91 //y=4.095 //x2=25.65 //y2=5.295
cc_1326 ( N_noxref_4_c_1442_p N_noxref_16_c_9914_n ) capacitor c=0.0145387f \
 //x=24.91 //y=4.415 //x2=25.65 //y2=5.295
cc_1327 ( N_noxref_4_c_1378_p N_noxref_16_c_9914_n ) capacitor c=0.0281783f \
 //x=24.91 //y=4.735 //x2=25.65 //y2=5.295
cc_1328 ( N_noxref_4_c_1447_p N_noxref_16_c_9914_n ) capacitor c=7.58275e-19 \
 //x=24.172 //y=4.74 //x2=25.65 //y2=5.295
cc_1329 ( N_noxref_4_c_1379_p N_noxref_16_c_9914_n ) capacitor c=5.68333e-19 \
 //x=24.91 //y=4.25 //x2=25.65 //y2=5.295
cc_1330 ( N_noxref_4_c_1380_p N_noxref_16_c_9914_n ) capacitor c=0.00410789f \
 //x=24.9 //y=4.255 //x2=25.65 //y2=5.295
cc_1331 ( N_noxref_4_c_1606_p N_noxref_16_c_9914_n ) capacitor c=7.76118e-19 \
 //x=24.94 //y=4.88 //x2=25.65 //y2=5.295
cc_1332 ( N_noxref_4_c_1637_p N_noxref_16_c_9914_n ) capacitor c=0.00845606f \
 //x=25.315 //y=4.97 //x2=25.65 //y2=5.295
cc_1333 ( N_noxref_4_c_1456_p N_noxref_16_c_9914_n ) capacitor c=0.00142201f \
 //x=24.94 //y=4.88 //x2=25.65 //y2=5.295
cc_1334 ( N_noxref_4_c_1384_p N_noxref_16_c_9925_n ) capacitor c=9.19401e-19 \
 //x=22.32 //y=4.075 //x2=21.58 //y2=3.14
cc_1335 ( N_noxref_4_c_1640_p N_noxref_16_c_9926_n ) capacitor c=5.58535e-19 \
 //x=21.54 //y=5.56 //x2=24.29 //y2=5.56
cc_1336 ( N_noxref_4_c_1438_p N_noxref_16_c_9926_n ) capacitor c=0.00104762f \
 //x=22.235 //y=5.335 //x2=24.29 //y2=5.56
cc_1337 ( N_noxref_4_c_1441_p N_noxref_16_c_9926_n ) capacitor c=0.0014477f \
 //x=24.17 //y=4.395 //x2=24.29 //y2=5.56
cc_1338 ( N_noxref_4_c_1446_p N_noxref_16_c_9926_n ) capacitor c=0.0117744f \
 //x=24.17 //y=4.88 //x2=24.29 //y2=5.56
cc_1339 ( N_noxref_4_c_1644_p N_noxref_16_c_9926_n ) capacitor c=0.00277154f \
 //x=24.17 //y=4.88 //x2=24.29 //y2=5.56
cc_1340 ( N_noxref_4_M82_noxref_g N_noxref_16_c_9926_n ) capacitor \
 c=0.00201806f //x=24.07 //y=6.2 //x2=24.29 //y2=5.56
cc_1341 ( N_noxref_4_M83_noxref_g N_noxref_16_c_9926_n ) capacitor \
 c=0.00192712f //x=24.51 //y=6.2 //x2=24.29 //y2=5.56
cc_1342 ( N_noxref_4_c_1647_p N_noxref_16_c_9926_n ) capacitor c=0.00200032f \
 //x=24.17 //y=4.88 //x2=24.29 //y2=5.56
cc_1343 ( N_noxref_4_M84_noxref_g N_noxref_16_c_9934_n ) capacitor \
 c=0.00192712f //x=24.95 //y=6.2 //x2=25.17 //y2=5.38
cc_1344 ( N_noxref_4_M85_noxref_g N_noxref_16_c_9934_n ) capacitor \
 c=0.00312463f //x=25.39 //y=6.2 //x2=25.17 //y2=5.38
cc_1345 ( N_noxref_4_c_1637_p N_noxref_16_c_9934_n ) capacitor c=0.0020909f \
 //x=25.315 //y=4.97 //x2=25.17 //y2=5.38
cc_1346 ( N_noxref_4_c_1523_p N_noxref_16_c_9937_n ) capacitor c=6.5615e-19 \
 //x=21.835 //y=1.305 //x2=25.21 //y2=1.18
cc_1347 ( N_noxref_4_c_1652_p N_noxref_16_c_9937_n ) capacitor c=0.00120406f \
 //x=24.945 //y=1.085 //x2=25.21 //y2=1.18
cc_1348 ( N_noxref_4_c_1611_p N_noxref_16_c_9937_n ) capacitor c=0.00218772f \
 //x=24.945 //y=1.43 //x2=25.21 //y2=1.18
cc_1349 ( N_noxref_4_c_1654_p N_noxref_16_c_9937_n ) capacitor c=5.50523e-19 \
 //x=25.32 //y=0.93 //x2=25.21 //y2=1.18
cc_1350 ( N_noxref_4_c_1613_p N_noxref_16_c_9937_n ) capacitor c=5.67071e-19 \
 //x=25.32 //y=1.585 //x2=25.21 //y2=1.18
cc_1351 ( N_noxref_4_c_1656_p N_noxref_16_c_9937_n ) capacitor c=0.00108157f \
 //x=25.475 //y=1.085 //x2=25.21 //y2=1.18
cc_1352 ( N_noxref_4_c_1614_p N_noxref_16_c_9937_n ) capacitor c=0.00312028f \
 //x=25.475 //y=1.43 //x2=25.21 //y2=1.18
cc_1353 ( N_noxref_4_c_1377_p N_noxref_16_c_9944_n ) capacitor c=9.19401e-19 \
 //x=24.91 //y=4.095 //x2=25.65 //y2=3.14
cc_1354 ( N_noxref_4_c_1384_p N_noxref_16_c_9945_n ) capacitor c=0.026213f \
 //x=22.32 //y=4.075 //x2=25.49 //y2=3.14
cc_1355 ( N_noxref_4_c_1439_p N_noxref_16_c_9945_n ) capacitor c=0.00370971f \
 //x=22.32 //y=4.395 //x2=25.49 //y2=3.14
cc_1356 ( N_noxref_4_c_1385_p N_noxref_16_c_9945_n ) capacitor c=0.027299f \
 //x=24.17 //y=4.075 //x2=25.49 //y2=3.14
cc_1357 ( N_noxref_4_c_1441_p N_noxref_16_c_9945_n ) capacitor c=0.00320311f \
 //x=24.17 //y=4.395 //x2=25.49 //y2=3.14
cc_1358 ( N_noxref_4_c_1377_p N_noxref_16_c_9945_n ) capacitor c=0.0235575f \
 //x=24.91 //y=4.095 //x2=25.49 //y2=3.14
cc_1359 ( N_noxref_4_c_1442_p N_noxref_16_c_9945_n ) capacitor c=0.00264841f \
 //x=24.91 //y=4.415 //x2=25.49 //y2=3.14
cc_1360 ( N_noxref_4_c_1366_n N_noxref_16_c_9945_n ) capacitor c=0.0197094f \
 //x=22.475 //y=4.25 //x2=25.49 //y2=3.14
cc_1361 ( N_noxref_4_c_1391_p N_noxref_16_c_9945_n ) capacitor c=0.0473284f \
 //x=24.02 //y=4.235 //x2=25.49 //y2=3.14
cc_1362 ( N_noxref_4_c_1451_p N_noxref_16_c_9945_n ) capacitor c=0.00831879f \
 //x=24.34 //y=4.235 //x2=25.49 //y2=3.14
cc_1363 ( N_noxref_4_c_1380_p N_noxref_16_c_9945_n ) capacitor c=0.00806378f \
 //x=24.9 //y=4.255 //x2=25.49 //y2=3.14
cc_1364 ( N_noxref_4_c_1392_p N_noxref_16_c_9945_n ) capacitor c=0.0109367f \
 //x=24.74 //y=4.255 //x2=25.49 //y2=3.14
cc_1365 ( N_noxref_4_c_1377_p N_noxref_16_c_9956_n ) capacitor c=0.00336755f \
 //x=24.91 //y=4.095 //x2=29.505 //y2=3.125
cc_1366 ( N_noxref_4_c_1384_p N_noxref_16_c_9957_n ) capacitor c=0.00335074f \
 //x=22.32 //y=4.075 //x2=21.735 //y2=3.155
cc_1367 ( N_noxref_4_c_1366_n N_noxref_16_c_9957_n ) capacitor c=0.00831872f \
 //x=22.475 //y=4.25 //x2=21.735 //y2=3.155
cc_1368 ( N_noxref_4_c_1384_p N_noxref_16_c_9959_n ) capacitor c=0.0015536f \
 //x=22.32 //y=4.075 //x2=21.58 //y2=2.26
cc_1369 ( N_noxref_4_c_1438_p N_noxref_16_c_9960_n ) capacitor c=0.00130631f \
 //x=22.235 //y=5.335 //x2=21.58 //y2=4.88
cc_1370 ( N_noxref_4_c_1440_p N_noxref_16_c_9960_n ) capacitor c=0.00131258f \
 //x=22.32 //y=5.25 //x2=21.58 //y2=4.88
cc_1371 ( N_noxref_4_c_1599_p N_noxref_16_c_9960_n ) capacitor c=0.00346456f \
 //x=21.54 //y=5.335 //x2=21.58 //y2=4.88
cc_1372 ( N_noxref_4_c_1603_p N_noxref_16_c_9960_n ) capacitor c=0.00624059f \
 //x=21.54 //y=5.56 //x2=21.58 //y2=4.88
cc_1373 ( N_noxref_4_c_1441_p N_noxref_16_c_9964_n ) capacitor c=5.50989e-19 \
 //x=24.17 //y=4.395 //x2=24.29 //y2=5.56
cc_1374 ( N_noxref_4_c_1446_p N_noxref_16_c_9964_n ) capacitor c=0.00104426f \
 //x=24.17 //y=4.88 //x2=24.29 //y2=5.56
cc_1375 ( N_noxref_4_c_1644_p N_noxref_16_c_9964_n ) capacitor c=0.00377369f \
 //x=24.17 //y=4.88 //x2=24.29 //y2=5.56
cc_1376 ( N_noxref_4_M82_noxref_g N_noxref_16_c_9964_n ) capacitor \
 c=0.0158358f //x=24.07 //y=6.2 //x2=24.29 //y2=5.56
cc_1377 ( N_noxref_4_M83_noxref_g N_noxref_16_c_9964_n ) capacitor \
 c=0.0178987f //x=24.51 //y=6.2 //x2=24.29 //y2=5.56
cc_1378 ( N_noxref_4_c_1647_p N_noxref_16_c_9964_n ) capacitor c=0.00321302f \
 //x=24.17 //y=4.88 //x2=24.29 //y2=5.56
cc_1379 ( N_noxref_4_M84_noxref_g N_noxref_16_c_9970_n ) capacitor \
 c=0.0178987f //x=24.95 //y=6.2 //x2=25.17 //y2=5.56
cc_1380 ( N_noxref_4_M85_noxref_g N_noxref_16_c_9970_n ) capacitor \
 c=0.0178506f //x=25.39 //y=6.2 //x2=25.17 //y2=5.56
cc_1381 ( N_noxref_4_c_1637_p N_noxref_16_c_9970_n ) capacitor c=0.00291714f \
 //x=25.315 //y=4.97 //x2=25.17 //y2=5.56
cc_1382 ( N_noxref_4_c_1555_p N_noxref_16_M80_noxref_g ) capacitor \
 c=0.00955829f //x=21.425 //y=5.335 //x2=21.32 //y2=6.2
cc_1383 ( N_noxref_4_c_1640_p N_noxref_16_M80_noxref_g ) capacitor \
 c=0.00226521f //x=21.54 //y=5.56 //x2=21.32 //y2=6.2
cc_1384 ( N_noxref_4_c_1603_p N_noxref_16_M80_noxref_g ) capacitor \
 c=0.0178885f //x=21.54 //y=5.56 //x2=21.32 //y2=6.2
cc_1385 ( N_noxref_4_c_1640_p N_noxref_16_M81_noxref_g ) capacitor \
 c=0.00368945f //x=21.54 //y=5.56 //x2=21.76 //y2=6.2
cc_1386 ( N_noxref_4_c_1438_p N_noxref_16_M81_noxref_g ) capacitor c=0.011061f \
 //x=22.235 //y=5.335 //x2=21.76 //y2=6.2
cc_1387 ( N_noxref_4_c_1603_p N_noxref_16_M81_noxref_g ) capacitor \
 c=0.0188608f //x=21.54 //y=5.56 //x2=21.76 //y2=6.2
cc_1388 ( N_noxref_4_c_1523_p N_noxref_16_c_9979_n ) capacitor c=4.64015e-19 \
 //x=21.835 //y=1.305 //x2=21.57 //y2=1.095
cc_1389 ( N_noxref_4_M13_noxref_d N_noxref_16_c_9979_n ) capacitor \
 c=0.00137165f //x=21.645 //y=1.095 //x2=21.57 //y2=1.095
cc_1390 ( N_noxref_4_c_1523_p N_noxref_16_c_9981_n ) capacitor c=0.0026012f \
 //x=21.835 //y=1.305 //x2=21.57 //y2=1.44
cc_1391 ( N_noxref_4_c_1610_p N_noxref_16_c_9981_n ) capacitor c=0.00127432f \
 //x=21.835 //y=1.76 //x2=21.57 //y2=1.44
cc_1392 ( N_noxref_4_M13_noxref_d N_noxref_16_c_9981_n ) capacitor \
 c=0.00237422f //x=21.645 //y=1.095 //x2=21.57 //y2=1.44
cc_1393 ( N_noxref_4_c_1610_p N_noxref_16_c_9984_n ) capacitor c=0.00429966f \
 //x=21.835 //y=1.76 //x2=21.57 //y2=1.75
cc_1394 ( N_noxref_4_c_1523_p N_noxref_16_c_9985_n ) capacitor c=5.29969e-19 \
 //x=21.835 //y=1.305 //x2=21.945 //y2=0.94
cc_1395 ( N_noxref_4_M13_noxref_d N_noxref_16_c_9985_n ) capacitor \
 c=0.0020782f //x=21.645 //y=1.095 //x2=21.945 //y2=0.94
cc_1396 ( N_noxref_4_c_1523_p N_noxref_16_c_9987_n ) capacitor c=4.81291e-19 \
 //x=21.835 //y=1.305 //x2=21.945 //y2=1.595
cc_1397 ( N_noxref_4_c_1610_p N_noxref_16_c_9987_n ) capacitor c=0.00930387f \
 //x=21.835 //y=1.76 //x2=21.945 //y2=1.595
cc_1398 ( N_noxref_4_c_1619_p N_noxref_16_c_9987_n ) capacitor c=0.00194716f \
 //x=22.235 //y=1.845 //x2=21.945 //y2=1.595
cc_1399 ( N_noxref_4_M13_noxref_d N_noxref_16_c_9987_n ) capacitor \
 c=0.00356097f //x=21.645 //y=1.095 //x2=21.945 //y2=1.595
cc_1400 ( N_noxref_4_c_1523_p N_noxref_16_c_9991_n ) capacitor c=5.28622e-19 \
 //x=21.835 //y=1.305 //x2=22.1 //y2=1.095
cc_1401 ( N_noxref_4_M13_noxref_d N_noxref_16_c_9991_n ) capacitor \
 c=0.00139206f //x=21.645 //y=1.095 //x2=22.1 //y2=1.095
cc_1402 ( N_noxref_4_c_1523_p N_noxref_16_c_9993_n ) capacitor c=0.00312156f \
 //x=21.835 //y=1.305 //x2=22.1 //y2=1.44
cc_1403 ( N_noxref_4_c_1610_p N_noxref_16_c_9993_n ) capacitor c=0.00347599f \
 //x=21.835 //y=1.76 //x2=22.1 //y2=1.44
cc_1404 ( N_noxref_4_c_1619_p N_noxref_16_c_9993_n ) capacitor c=0.00323576f \
 //x=22.235 //y=1.845 //x2=22.1 //y2=1.44
cc_1405 ( N_noxref_4_M13_noxref_d N_noxref_16_c_9993_n ) capacitor \
 c=0.00237422f //x=21.645 //y=1.095 //x2=22.1 //y2=1.44
cc_1406 ( N_noxref_4_c_1384_p N_noxref_16_c_9997_n ) capacitor c=0.0024584f \
 //x=22.32 //y=4.075 //x2=21.58 //y2=2.26
cc_1407 ( N_noxref_4_c_1610_p N_noxref_16_c_9998_n ) capacitor c=0.0036273f \
 //x=21.835 //y=1.76 //x2=21.58 //y2=2.095
cc_1408 ( N_noxref_4_c_1384_p N_noxref_16_c_9998_n ) capacitor c=0.00282067f \
 //x=22.32 //y=4.075 //x2=21.58 //y2=2.095
cc_1409 ( N_noxref_4_c_1440_p N_noxref_16_c_10000_n ) capacitor c=0.00739875f \
 //x=22.32 //y=5.25 //x2=21.58 //y2=4.88
cc_1410 ( N_noxref_4_c_1599_p N_noxref_16_c_10000_n ) capacitor c=0.00203307f \
 //x=21.54 //y=5.335 //x2=21.58 //y2=4.88
cc_1411 ( N_noxref_4_c_1603_p N_noxref_16_c_10000_n ) capacitor c=0.00375636f \
 //x=21.54 //y=5.56 //x2=21.58 //y2=4.88
cc_1412 ( N_noxref_4_c_1652_p N_noxref_16_M15_noxref_d ) capacitor \
 c=0.00137165f //x=24.945 //y=1.085 //x2=25.02 //y2=1.085
cc_1413 ( N_noxref_4_c_1611_p N_noxref_16_M15_noxref_d ) capacitor \
 c=0.00237422f //x=24.945 //y=1.43 //x2=25.02 //y2=1.085
cc_1414 ( N_noxref_4_c_1654_p N_noxref_16_M15_noxref_d ) capacitor \
 c=0.0020782f //x=25.32 //y=0.93 //x2=25.02 //y2=1.085
cc_1415 ( N_noxref_4_c_1613_p N_noxref_16_M15_noxref_d ) capacitor \
 c=0.00356097f //x=25.32 //y=1.585 //x2=25.02 //y2=1.085
cc_1416 ( N_noxref_4_c_1656_p N_noxref_16_M15_noxref_d ) capacitor \
 c=8.50095e-19 //x=25.475 //y=1.085 //x2=25.02 //y2=1.085
cc_1417 ( N_noxref_4_c_1614_p N_noxref_16_M15_noxref_d ) capacitor \
 c=0.00237422f //x=25.475 //y=1.43 //x2=25.02 //y2=1.085
cc_1418 ( N_noxref_4_c_1394_p N_VDD_c_11464_n ) capacitor c=3.8494e-19 //x=1.6 \
 //y=4.42 //x2=78.895 //y2=7.585
cc_1419 ( N_noxref_4_c_1266_n N_VDD_c_11464_n ) capacitor c=0.00621352f \
 //x=15.73 //y=5.335 //x2=78.895 //y2=7.585
cc_1420 ( N_noxref_4_c_1475_p N_VDD_c_11464_n ) capacitor c=0.00627192f \
 //x=16.615 //y=5.335 //x2=78.895 //y2=7.585
cc_1421 ( N_noxref_4_c_1547_p N_VDD_c_11464_n ) capacitor c=0.00256036f \
 //x=16.73 //y=5.56 //x2=78.895 //y2=7.585
cc_1422 ( N_noxref_4_c_1431_p N_VDD_c_11464_n ) capacitor c=0.00829214f \
 //x=17.425 //y=5.335 //x2=78.895 //y2=7.585
cc_1423 ( N_noxref_4_c_1328_n N_VDD_c_11464_n ) capacitor c=2.29405e-19 \
 //x=17.51 //y=4.415 //x2=78.895 //y2=7.585
cc_1424 ( N_noxref_4_c_1332_n N_VDD_c_11464_n ) capacitor c=0.00621363f \
 //x=20.54 //y=5.335 //x2=78.895 //y2=7.585
cc_1425 ( N_noxref_4_c_1555_p N_VDD_c_11464_n ) capacitor c=0.0062719f \
 //x=21.425 //y=5.335 //x2=78.895 //y2=7.585
cc_1426 ( N_noxref_4_c_1640_p N_VDD_c_11464_n ) capacitor c=0.00256019f \
 //x=21.54 //y=5.56 //x2=78.895 //y2=7.585
cc_1427 ( N_noxref_4_c_1438_p N_VDD_c_11464_n ) capacitor c=0.00829234f \
 //x=22.235 //y=5.335 //x2=78.895 //y2=7.585
cc_1428 ( N_noxref_4_c_1439_p N_VDD_c_11464_n ) capacitor c=4.98016e-19 \
 //x=22.32 //y=4.395 //x2=78.895 //y2=7.585
cc_1429 ( N_noxref_4_c_1441_p N_VDD_c_11464_n ) capacitor c=2.33493e-19 \
 //x=24.17 //y=4.395 //x2=78.895 //y2=7.585
cc_1430 ( N_noxref_4_c_1271_n N_VDD_c_11464_n ) capacitor c=0.00261804f \
 //x=14.972 //y=5.335 //x2=78.895 //y2=7.585
cc_1431 ( N_noxref_4_c_1413_p N_VDD_c_11464_n ) capacitor c=0.00270108f \
 //x=15.85 //y=5.335 //x2=78.895 //y2=7.585
cc_1432 ( N_noxref_4_c_1500_p N_VDD_c_11464_n ) capacitor c=3.94104e-19 \
 //x=17.51 //y=4.25 //x2=78.895 //y2=7.585
cc_1433 ( N_noxref_4_c_1333_n N_VDD_c_11464_n ) capacitor c=0.00261804f \
 //x=19.782 //y=5.335 //x2=78.895 //y2=7.585
cc_1434 ( N_noxref_4_c_1445_p N_VDD_c_11464_n ) capacitor c=0.00270108f \
 //x=20.66 //y=5.335 //x2=78.895 //y2=7.585
cc_1435 ( N_noxref_4_c_1600_p N_VDD_c_11464_n ) capacitor c=3.94104e-19 \
 //x=22.32 //y=4.25 //x2=78.895 //y2=7.585
cc_1436 ( N_noxref_4_c_1446_p N_VDD_c_11464_n ) capacitor c=9.07241e-19 \
 //x=24.17 //y=4.88 //x2=78.895 //y2=7.585
cc_1437 ( N_noxref_4_c_1283_n N_VDD_c_11464_n ) capacitor c=0.0024232f \
 //x=14.97 //y=5.56 //x2=78.895 //y2=7.585
cc_1438 ( N_noxref_4_c_1415_p N_VDD_c_11464_n ) capacitor c=0.0024232f \
 //x=15.85 //y=5.56 //x2=78.895 //y2=7.585
cc_1439 ( N_noxref_4_c_1514_p N_VDD_c_11464_n ) capacitor c=0.0024232f \
 //x=16.73 //y=5.56 //x2=78.895 //y2=7.585
cc_1440 ( N_noxref_4_c_1367_n N_VDD_c_11464_n ) capacitor c=0.0024232f \
 //x=19.78 //y=5.56 //x2=78.895 //y2=7.585
cc_1441 ( N_noxref_4_c_1518_p N_VDD_c_11464_n ) capacitor c=0.0024232f \
 //x=20.66 //y=5.56 //x2=78.895 //y2=7.585
cc_1442 ( N_noxref_4_c_1603_p N_VDD_c_11464_n ) capacitor c=0.0024232f \
 //x=21.54 //y=5.56 //x2=78.895 //y2=7.585
cc_1443 ( N_noxref_4_c_1644_p N_VDD_c_11464_n ) capacitor c=6.22888e-19 \
 //x=24.17 //y=4.88 //x2=78.895 //y2=7.585
cc_1444 ( N_noxref_4_c_1394_p N_VDD_c_11585_n ) capacitor c=0.001923f //x=1.6 \
 //y=4.42 //x2=1.23 //y2=7.58
cc_1445 ( N_noxref_4_c_1198_n N_VDD_c_11585_n ) capacitor c=0.0157044f //x=1.6 \
 //y=4.755 //x2=1.23 //y2=7.58
cc_1446 ( N_noxref_4_c_1396_p N_VDD_c_11585_n ) capacitor c=0.00229603f \
 //x=1.6 //y=4.25 //x2=1.23 //y2=7.58
cc_1447 ( N_noxref_4_c_1409_p N_VDD_c_11585_n ) capacitor c=0.00371026f \
 //x=1.6 //y=4.88 //x2=1.23 //y2=7.58
cc_1448 ( N_noxref_4_c_1411_p N_VDD_c_11585_n ) capacitor c=0.00594885f \
 //x=1.875 //y=4.97 //x2=1.23 //y2=7.58
cc_1449 ( N_noxref_4_c_1394_p N_VDD_c_11587_n ) capacitor c=3.24038e-19 \
 //x=1.6 //y=4.42 //x2=2.375 //y2=7.585
cc_1450 ( N_noxref_4_M54_noxref_g N_VDD_c_11587_n ) capacitor c=0.00755614f \
 //x=1.8 //y=6.2 //x2=2.375 //y2=7.585
cc_1451 ( N_noxref_4_M55_noxref_g N_VDD_c_11587_n ) capacitor c=0.00755544f \
 //x=2.24 //y=6.2 //x2=2.375 //y2=7.585
cc_1452 ( N_noxref_4_M68_noxref_g N_VDD_c_11535_n ) capacitor c=0.00697352f \
 //x=12 //y=6.2 //x2=12.575 //y2=7.585
cc_1453 ( N_noxref_4_M69_noxref_g N_VDD_c_11535_n ) capacitor c=0.00755544f \
 //x=12.44 //y=6.2 //x2=12.575 //y2=7.585
cc_1454 ( N_noxref_4_c_1266_n N_VDD_c_11540_n ) capacitor c=0.00202922f \
 //x=15.73 //y=5.335 //x2=15.325 //y2=7.585
cc_1455 ( N_noxref_4_c_1271_n N_VDD_c_11540_n ) capacitor c=9.3757e-19 \
 //x=14.972 //y=5.335 //x2=15.325 //y2=7.585
cc_1456 ( N_noxref_4_c_1283_n N_VDD_c_11540_n ) capacitor c=0.0138074f \
 //x=14.97 //y=5.56 //x2=15.325 //y2=7.585
cc_1457 ( N_noxref_4_c_1266_n N_VDD_c_11677_n ) capacitor c=0.0017708f \
 //x=15.73 //y=5.335 //x2=16.205 //y2=7.585
cc_1458 ( N_noxref_4_c_1475_p N_VDD_c_11677_n ) capacitor c=0.00202922f \
 //x=16.615 //y=5.335 //x2=16.205 //y2=7.585
cc_1459 ( N_noxref_4_c_1413_p N_VDD_c_11677_n ) capacitor c=9.4822e-19 \
 //x=15.85 //y=5.335 //x2=16.205 //y2=7.585
cc_1460 ( N_noxref_4_c_1415_p N_VDD_c_11677_n ) capacitor c=0.0138074f \
 //x=15.85 //y=5.56 //x2=16.205 //y2=7.585
cc_1461 ( N_noxref_4_c_1475_p N_VDD_c_11681_n ) capacitor c=0.00205906f \
 //x=16.615 //y=5.335 //x2=17.085 //y2=7.585
cc_1462 ( N_noxref_4_c_1547_p N_VDD_c_11681_n ) capacitor c=8.49654e-19 \
 //x=16.73 //y=5.56 //x2=17.085 //y2=7.585
cc_1463 ( N_noxref_4_c_1431_p N_VDD_c_11681_n ) capacitor c=0.00204238f \
 //x=17.425 //y=5.335 //x2=17.085 //y2=7.585
cc_1464 ( N_noxref_4_c_1514_p N_VDD_c_11681_n ) capacitor c=0.0138074f \
 //x=16.73 //y=5.56 //x2=17.085 //y2=7.585
cc_1465 ( N_noxref_4_c_1431_p N_VDD_c_11685_n ) capacitor c=0.00157252f \
 //x=17.425 //y=5.335 //x2=18.08 //y2=7.585
cc_1466 ( N_noxref_4_c_1332_n N_VDD_c_11601_n ) capacitor c=0.00202922f \
 //x=20.54 //y=5.335 //x2=20.135 //y2=7.585
cc_1467 ( N_noxref_4_c_1333_n N_VDD_c_11601_n ) capacitor c=9.3757e-19 \
 //x=19.782 //y=5.335 //x2=20.135 //y2=7.585
cc_1468 ( N_noxref_4_c_1367_n N_VDD_c_11601_n ) capacitor c=0.0138074f \
 //x=19.78 //y=5.56 //x2=20.135 //y2=7.585
cc_1469 ( N_noxref_4_c_1332_n N_VDD_c_11689_n ) capacitor c=0.0017708f \
 //x=20.54 //y=5.335 //x2=21.015 //y2=7.585
cc_1470 ( N_noxref_4_c_1555_p N_VDD_c_11689_n ) capacitor c=0.00202922f \
 //x=21.425 //y=5.335 //x2=21.015 //y2=7.585
cc_1471 ( N_noxref_4_c_1445_p N_VDD_c_11689_n ) capacitor c=9.4822e-19 \
 //x=20.66 //y=5.335 //x2=21.015 //y2=7.585
cc_1472 ( N_noxref_4_c_1518_p N_VDD_c_11689_n ) capacitor c=0.0138074f \
 //x=20.66 //y=5.56 //x2=21.015 //y2=7.585
cc_1473 ( N_noxref_4_c_1555_p N_VDD_c_11693_n ) capacitor c=0.00205906f \
 //x=21.425 //y=5.335 //x2=21.895 //y2=7.585
cc_1474 ( N_noxref_4_c_1640_p N_VDD_c_11693_n ) capacitor c=8.49654e-19 \
 //x=21.54 //y=5.56 //x2=21.895 //y2=7.585
cc_1475 ( N_noxref_4_c_1438_p N_VDD_c_11693_n ) capacitor c=0.00204238f \
 //x=22.235 //y=5.335 //x2=21.895 //y2=7.585
cc_1476 ( N_noxref_4_c_1603_p N_VDD_c_11693_n ) capacitor c=0.0138074f \
 //x=21.54 //y=5.56 //x2=21.895 //y2=7.585
cc_1477 ( N_noxref_4_c_1438_p N_VDD_c_11697_n ) capacitor c=0.00157252f \
 //x=22.235 //y=5.335 //x2=22.89 //y2=7.585
cc_1478 ( N_noxref_4_c_1439_p N_VDD_c_11697_n ) capacitor c=4.01167e-19 \
 //x=22.32 //y=4.395 //x2=22.89 //y2=7.585
cc_1479 ( N_noxref_4_c_1446_p N_VDD_c_11699_n ) capacitor c=6.28113e-19 \
 //x=24.17 //y=4.88 //x2=24.645 //y2=7.585
cc_1480 ( N_noxref_4_M82_noxref_g N_VDD_c_11699_n ) capacitor c=0.00732618f \
 //x=24.07 //y=6.2 //x2=24.645 //y2=7.585
cc_1481 ( N_noxref_4_M83_noxref_g N_VDD_c_11699_n ) capacitor c=0.00755544f \
 //x=24.51 //y=6.2 //x2=24.645 //y2=7.585
cc_1482 ( N_noxref_4_M84_noxref_g N_VDD_c_11702_n ) capacitor c=0.00697352f \
 //x=24.95 //y=6.2 //x2=25.525 //y2=7.585
cc_1483 ( N_noxref_4_M85_noxref_g N_VDD_c_11702_n ) capacitor c=0.00755544f \
 //x=25.39 //y=6.2 //x2=25.525 //y2=7.585
cc_1484 ( N_noxref_4_c_1221_n N_VDD_c_11494_n ) capacitor c=5.71665e-19 \
 //x=4.815 //y=4.27 //x2=5.3 //y2=7.585
cc_1485 ( N_noxref_4_c_1222_n N_VDD_c_11494_n ) capacitor c=0.00910495f \
 //x=6.03 //y=4.25 //x2=5.3 //y2=7.585
cc_1486 ( N_noxref_4_c_1213_n N_VDD_c_11498_n ) capacitor c=8.4651e-19 \
 //x=11.96 //y=4.25 //x2=10.11 //y2=7.585
cc_1487 ( N_noxref_4_c_1224_n N_VDD_c_11498_n ) capacitor c=0.00875046f \
 //x=12.125 //y=4.25 //x2=10.11 //y2=7.585
cc_1488 ( N_noxref_4_c_1213_n N_VDD_c_11545_n ) capacitor c=0.00133334f \
 //x=11.96 //y=4.25 //x2=13.44 //y2=7.585
cc_1489 ( N_noxref_4_c_1271_n N_VDD_c_11545_n ) capacitor c=0.0022955f \
 //x=14.972 //y=5.335 //x2=13.44 //y2=7.585
cc_1490 ( N_noxref_4_c_1276_n N_VDD_c_11545_n ) capacitor c=0.00867114f \
 //x=17.355 //y=4.25 //x2=13.44 //y2=7.585
cc_1491 ( N_noxref_4_c_1232_n N_VDD_c_11545_n ) capacitor c=0.00226427f \
 //x=11.99 //y=4.88 //x2=13.44 //y2=7.585
cc_1492 ( N_noxref_4_c_1283_n N_VDD_c_11545_n ) capacitor c=0.00508013f \
 //x=14.97 //y=5.56 //x2=13.44 //y2=7.585
cc_1493 ( N_noxref_4_c_1298_n N_VDD_c_11545_n ) capacitor c=0.0129149f \
 //x=12.365 //y=4.97 //x2=13.44 //y2=7.585
cc_1494 ( N_noxref_4_c_1251_n N_VDD_c_11545_n ) capacitor c=2.73429e-19 \
 //x=11.99 //y=4.88 //x2=13.44 //y2=7.585
cc_1495 ( N_noxref_4_c_1547_p N_VDD_c_11609_n ) capacitor c=0.00282782f \
 //x=16.73 //y=5.56 //x2=18.25 //y2=7.585
cc_1496 ( N_noxref_4_c_1328_n N_VDD_c_11609_n ) capacitor c=0.00175322f \
 //x=17.51 //y=4.415 //x2=18.25 //y2=7.585
cc_1497 ( N_noxref_4_c_1331_n N_VDD_c_11609_n ) capacitor c=0.0292825f \
 //x=17.51 //y=5.25 //x2=18.25 //y2=7.585
cc_1498 ( N_noxref_4_c_1500_p N_VDD_c_11609_n ) capacitor c=0.00507985f \
 //x=17.51 //y=4.25 //x2=18.25 //y2=7.585
cc_1499 ( N_noxref_4_c_1333_n N_VDD_c_11609_n ) capacitor c=0.0022955f \
 //x=19.782 //y=5.335 //x2=18.25 //y2=7.585
cc_1500 ( N_noxref_4_c_1363_n N_VDD_c_11609_n ) capacitor c=0.00867386f \
 //x=19.22 //y=4.265 //x2=18.25 //y2=7.585
cc_1501 ( N_noxref_4_c_1514_p N_VDD_c_11609_n ) capacitor c=0.00777981f \
 //x=16.73 //y=5.56 //x2=18.25 //y2=7.585
cc_1502 ( N_noxref_4_c_1367_n N_VDD_c_11609_n ) capacitor c=0.00509469f \
 //x=19.78 //y=5.56 //x2=18.25 //y2=7.585
cc_1503 ( N_noxref_4_c_1640_p N_VDD_c_11723_n ) capacitor c=0.00269779f \
 //x=21.54 //y=5.56 //x2=23.06 //y2=7.585
cc_1504 ( N_noxref_4_c_1439_p N_VDD_c_11723_n ) capacitor c=0.00151466f \
 //x=22.32 //y=4.395 //x2=23.06 //y2=7.585
cc_1505 ( N_noxref_4_c_1440_p N_VDD_c_11723_n ) capacitor c=0.028134f \
 //x=22.32 //y=5.25 //x2=23.06 //y2=7.585
cc_1506 ( N_noxref_4_c_1441_p N_VDD_c_11723_n ) capacitor c=0.00106588f \
 //x=24.17 //y=4.395 //x2=23.06 //y2=7.585
cc_1507 ( N_noxref_4_c_1600_p N_VDD_c_11723_n ) capacitor c=0.0050463f \
 //x=22.32 //y=4.25 //x2=23.06 //y2=7.585
cc_1508 ( N_noxref_4_c_1813_p N_VDD_c_11723_n ) capacitor c=0.00245889f \
 //x=24.17 //y=4.25 //x2=23.06 //y2=7.585
cc_1509 ( N_noxref_4_c_1446_p N_VDD_c_11723_n ) capacitor c=0.00447349f \
 //x=24.17 //y=4.88 //x2=23.06 //y2=7.585
cc_1510 ( N_noxref_4_c_1447_p N_VDD_c_11723_n ) capacitor c=0.00428131f \
 //x=24.172 //y=4.74 //x2=23.06 //y2=7.585
cc_1511 ( N_noxref_4_c_1391_p N_VDD_c_11723_n ) capacitor c=0.00792529f \
 //x=24.02 //y=4.235 //x2=23.06 //y2=7.585
cc_1512 ( N_noxref_4_c_1603_p N_VDD_c_11723_n ) capacitor c=0.00776541f \
 //x=21.54 //y=5.56 //x2=23.06 //y2=7.585
cc_1513 ( N_noxref_4_c_1644_p N_VDD_c_11723_n ) capacitor c=0.00370494f \
 //x=24.17 //y=4.88 //x2=23.06 //y2=7.585
cc_1514 ( N_noxref_4_c_1647_p N_VDD_c_11723_n ) capacitor c=0.0129564f \
 //x=24.17 //y=4.88 //x2=23.06 //y2=7.585
cc_1515 ( N_noxref_4_c_1379_p N_VDD_c_11735_n ) capacitor c=0.00143727f \
 //x=24.91 //y=4.25 //x2=26.39 //y2=7.585
cc_1516 ( N_noxref_4_c_1606_p N_VDD_c_11735_n ) capacitor c=0.00226427f \
 //x=24.94 //y=4.88 //x2=26.39 //y2=7.585
cc_1517 ( N_noxref_4_c_1637_p N_VDD_c_11735_n ) capacitor c=0.0129149f \
 //x=25.315 //y=4.97 //x2=26.39 //y2=7.585
cc_1518 ( N_noxref_4_c_1456_p N_VDD_c_11735_n ) capacitor c=2.73429e-19 \
 //x=24.94 //y=4.88 //x2=26.39 //y2=7.585
cc_1519 ( N_noxref_4_c_1394_p N_VDD_M54_noxref_s ) capacitor c=9.65642e-19 \
 //x=1.6 //y=4.42 //x2=1.445 //y2=5.2
cc_1520 ( N_noxref_4_c_1198_n N_VDD_M54_noxref_s ) capacitor c=0.0223496f \
 //x=1.6 //y=4.755 //x2=1.445 //y2=5.2
cc_1521 ( N_noxref_4_c_1398_p N_VDD_M54_noxref_s ) capacitor c=4.28833e-19 \
 //x=1.76 //y=4.26 //x2=1.445 //y2=5.2
cc_1522 ( N_noxref_4_c_1409_p N_VDD_M54_noxref_s ) capacitor c=0.00911317f \
 //x=1.6 //y=4.88 //x2=1.445 //y2=5.2
cc_1523 ( N_noxref_4_M54_noxref_g N_VDD_M54_noxref_s ) capacitor c=0.053419f \
 //x=1.8 //y=6.2 //x2=1.445 //y2=5.2
cc_1524 ( N_noxref_4_c_1411_p N_VDD_M54_noxref_s ) capacitor c=0.00597604f \
 //x=1.875 //y=4.97 //x2=1.445 //y2=5.2
cc_1525 ( N_noxref_4_M55_noxref_g N_VDD_M55_noxref_d ) capacitor c=0.015318f \
 //x=2.24 //y=6.2 //x2=2.315 //y2=5.2
cc_1526 ( N_noxref_4_c_1271_n N_VDD_M66_noxref_s ) capacitor c=4.22189e-19 \
 //x=14.972 //y=5.335 //x2=10.765 //y2=5.2
cc_1527 ( N_noxref_4_M68_noxref_g N_VDD_M67_noxref_d ) capacitor c=0.015318f \
 //x=12 //y=6.2 //x2=11.635 //y2=5.2
cc_1528 ( N_noxref_4_c_1251_n N_VDD_M67_noxref_d ) capacitor c=3.50465e-19 \
 //x=11.99 //y=4.88 //x2=11.635 //y2=5.2
cc_1529 ( N_noxref_4_M69_noxref_g N_VDD_M69_noxref_d ) capacitor c=0.0430452f \
 //x=12.44 //y=6.2 //x2=12.515 //y2=5.2
cc_1530 ( N_noxref_4_c_1271_n N_VDD_M70_noxref_s ) capacitor c=0.0442713f \
 //x=14.972 //y=5.335 //x2=14.395 //y2=5.2
cc_1531 ( N_noxref_4_c_1413_p N_VDD_M70_noxref_s ) capacitor c=7.80122e-19 \
 //x=15.85 //y=5.335 //x2=14.395 //y2=5.2
cc_1532 ( N_noxref_4_c_1283_n N_VDD_M70_noxref_s ) capacitor c=0.0908457f \
 //x=14.97 //y=5.56 //x2=14.395 //y2=5.2
cc_1533 ( N_noxref_4_c_1266_n N_VDD_M71_noxref_d ) capacitor c=0.00700141f \
 //x=15.73 //y=5.335 //x2=15.265 //y2=5.2
cc_1534 ( N_noxref_4_c_1283_n N_VDD_M71_noxref_d ) capacitor c=0.0673792f \
 //x=14.97 //y=5.56 //x2=15.265 //y2=5.2
cc_1535 ( N_noxref_4_c_1415_p N_VDD_M71_noxref_d ) capacitor c=0.0674762f \
 //x=15.85 //y=5.56 //x2=15.265 //y2=5.2
cc_1536 ( N_noxref_4_c_1475_p N_VDD_M73_noxref_d ) capacitor c=0.00700141f \
 //x=16.615 //y=5.335 //x2=16.145 //y2=5.2
cc_1537 ( N_noxref_4_c_1415_p N_VDD_M73_noxref_d ) capacitor c=0.067493f \
 //x=15.85 //y=5.56 //x2=16.145 //y2=5.2
cc_1538 ( N_noxref_4_c_1514_p N_VDD_M73_noxref_d ) capacitor c=0.0674979f \
 //x=16.73 //y=5.56 //x2=16.145 //y2=5.2
cc_1539 ( N_noxref_4_c_1431_p N_VDD_M75_noxref_d ) capacitor c=0.00700141f \
 //x=17.425 //y=5.335 //x2=17.025 //y2=5.2
cc_1540 ( N_noxref_4_c_1514_p N_VDD_M75_noxref_d ) capacitor c=0.0675002f \
 //x=16.73 //y=5.56 //x2=17.025 //y2=5.2
cc_1541 ( N_noxref_4_c_1547_p N_VDD_M76_noxref_s ) capacitor c=0.00492616f \
 //x=16.73 //y=5.56 //x2=19.205 //y2=5.2
cc_1542 ( N_noxref_4_c_1431_p N_VDD_M76_noxref_s ) capacitor c=9.42705e-19 \
 //x=17.425 //y=5.335 //x2=19.205 //y2=5.2
cc_1543 ( N_noxref_4_c_1413_p N_VDD_M76_noxref_s ) capacitor c=2.11884e-19 \
 //x=15.85 //y=5.335 //x2=19.205 //y2=5.2
cc_1544 ( N_noxref_4_c_1333_n N_VDD_M76_noxref_s ) capacitor c=0.0441176f \
 //x=19.782 //y=5.335 //x2=19.205 //y2=5.2
cc_1545 ( N_noxref_4_c_1445_p N_VDD_M76_noxref_s ) capacitor c=7.80122e-19 \
 //x=20.66 //y=5.335 //x2=19.205 //y2=5.2
cc_1546 ( N_noxref_4_c_1367_n N_VDD_M76_noxref_s ) capacitor c=0.09305f \
 //x=19.78 //y=5.56 //x2=19.205 //y2=5.2
cc_1547 ( N_noxref_4_c_1332_n N_VDD_M77_noxref_d ) capacitor c=0.00700141f \
 //x=20.54 //y=5.335 //x2=20.075 //y2=5.2
cc_1548 ( N_noxref_4_c_1367_n N_VDD_M77_noxref_d ) capacitor c=0.0674491f \
 //x=19.78 //y=5.56 //x2=20.075 //y2=5.2
cc_1549 ( N_noxref_4_c_1518_p N_VDD_M77_noxref_d ) capacitor c=0.0674762f \
 //x=20.66 //y=5.56 //x2=20.075 //y2=5.2
cc_1550 ( N_noxref_4_c_1555_p N_VDD_M79_noxref_d ) capacitor c=0.00700141f \
 //x=21.425 //y=5.335 //x2=20.955 //y2=5.2
cc_1551 ( N_noxref_4_c_1518_p N_VDD_M79_noxref_d ) capacitor c=0.067493f \
 //x=20.66 //y=5.56 //x2=20.955 //y2=5.2
cc_1552 ( N_noxref_4_c_1603_p N_VDD_M79_noxref_d ) capacitor c=0.0674288f \
 //x=21.54 //y=5.56 //x2=20.955 //y2=5.2
cc_1553 ( N_noxref_4_c_1438_p N_VDD_M81_noxref_d ) capacitor c=0.00700141f \
 //x=22.235 //y=5.335 //x2=21.835 //y2=5.2
cc_1554 ( N_noxref_4_c_1603_p N_VDD_M81_noxref_d ) capacitor c=0.0673824f \
 //x=21.54 //y=5.56 //x2=21.835 //y2=5.2
cc_1555 ( N_noxref_4_c_1640_p N_VDD_M82_noxref_s ) capacitor c=0.00536022f \
 //x=21.54 //y=5.56 //x2=23.715 //y2=5.2
cc_1556 ( N_noxref_4_c_1438_p N_VDD_M82_noxref_s ) capacitor c=0.00211796f \
 //x=22.235 //y=5.335 //x2=23.715 //y2=5.2
cc_1557 ( N_noxref_4_c_1441_p N_VDD_M82_noxref_s ) capacitor c=0.00231437f \
 //x=24.17 //y=4.395 //x2=23.715 //y2=5.2
cc_1558 ( N_noxref_4_M82_noxref_g N_VDD_M82_noxref_s ) capacitor c=0.0567929f \
 //x=24.07 //y=6.2 //x2=23.715 //y2=5.2
cc_1559 ( N_noxref_4_M83_noxref_g N_VDD_M83_noxref_d ) capacitor c=0.015318f \
 //x=24.51 //y=6.2 //x2=24.585 //y2=5.2
cc_1560 ( N_noxref_4_M84_noxref_g N_VDD_M83_noxref_d ) capacitor c=0.015318f \
 //x=24.95 //y=6.2 //x2=24.585 //y2=5.2
cc_1561 ( N_noxref_4_c_1456_p N_VDD_M83_noxref_d ) capacitor c=3.50465e-19 \
 //x=24.94 //y=4.88 //x2=24.585 //y2=5.2
cc_1562 ( N_noxref_4_M85_noxref_g N_VDD_M85_noxref_d ) capacitor c=0.0430452f \
 //x=25.39 //y=6.2 //x2=25.465 //y2=5.2
cc_1563 ( N_noxref_4_c_1217_n N_noxref_20_M2_noxref_s ) capacitor \
 c=0.00164236f //x=4.175 //y=4.25 //x2=3.455 //y2=0.555
cc_1564 ( N_noxref_4_c_1508_p N_noxref_22_c_12993_n ) capacitor c=0.0036878f \
 //x=17.025 //y=1.305 //x2=17.425 //y2=0.72
cc_1565 ( N_noxref_4_c_1568_p N_noxref_22_c_12993_n ) capacitor c=0.00399931f \
 //x=17.425 //y=1.845 //x2=17.425 //y2=0.72
cc_1566 ( N_noxref_4_M10_noxref_d N_noxref_22_c_12993_n ) capacitor \
 c=0.00910163f //x=16.835 //y=1.095 //x2=17.425 //y2=0.72
cc_1567 ( N_noxref_4_M10_noxref_d N_noxref_22_c_12996_n ) capacitor \
 c=0.00120711f //x=16.835 //y=1.095 //x2=16.54 //y2=1.175
cc_1568 ( N_noxref_4_c_1266_n N_noxref_22_M9_noxref_d ) capacitor \
 c=0.00143783f //x=15.73 //y=5.335 //x2=15.3 //y2=1.09
cc_1569 ( N_noxref_4_c_1508_p N_noxref_22_M9_noxref_d ) capacitor \
 c=0.00802417f //x=17.025 //y=1.305 //x2=15.3 //y2=1.09
cc_1570 ( N_noxref_4_c_1508_p N_noxref_22_M10_noxref_s ) capacitor \
 c=0.0098487f //x=17.025 //y=1.305 //x2=16.405 //y2=0.555
cc_1571 ( N_noxref_4_c_1267_n N_noxref_22_M10_noxref_s ) capacitor \
 c=0.0283111f //x=17.025 //y=1.76 //x2=16.405 //y2=0.555
cc_1572 ( N_noxref_4_c_1568_p N_noxref_22_M10_noxref_s ) capacitor \
 c=0.00942148f //x=17.425 //y=1.845 //x2=16.405 //y2=0.555
cc_1573 ( N_noxref_4_c_1500_p N_noxref_22_M10_noxref_s ) capacitor \
 c=0.00108527f //x=17.51 //y=4.25 //x2=16.405 //y2=0.555
cc_1574 ( N_noxref_4_M10_noxref_d N_noxref_22_M10_noxref_s ) capacitor \
 c=0.0279003f //x=16.835 //y=1.095 //x2=16.405 //y2=0.555
cc_1575 ( N_noxref_4_c_1523_p N_noxref_23_c_13059_n ) capacitor c=0.0036878f \
 //x=21.835 //y=1.305 //x2=22.235 //y2=0.72
cc_1576 ( N_noxref_4_c_1619_p N_noxref_23_c_13059_n ) capacitor c=0.00399931f \
 //x=22.235 //y=1.845 //x2=22.235 //y2=0.72
cc_1577 ( N_noxref_4_M13_noxref_d N_noxref_23_c_13059_n ) capacitor \
 c=0.00910163f //x=21.645 //y=1.095 //x2=22.235 //y2=0.72
cc_1578 ( N_noxref_4_M13_noxref_d N_noxref_23_c_13062_n ) capacitor \
 c=0.00120711f //x=21.645 //y=1.095 //x2=21.35 //y2=1.175
cc_1579 ( N_noxref_4_c_1508_p N_noxref_23_M12_noxref_d ) capacitor \
 c=3.20746e-19 //x=17.025 //y=1.305 //x2=20.11 //y2=1.09
cc_1580 ( N_noxref_4_c_1332_n N_noxref_23_M12_noxref_d ) capacitor \
 c=0.00112133f //x=20.54 //y=5.335 //x2=20.11 //y2=1.09
cc_1581 ( N_noxref_4_c_1523_p N_noxref_23_M12_noxref_d ) capacitor \
 c=0.00802836f //x=21.835 //y=1.305 //x2=20.11 //y2=1.09
cc_1582 ( N_noxref_4_c_1523_p N_noxref_23_M13_noxref_s ) capacitor \
 c=0.00993092f //x=21.835 //y=1.305 //x2=21.215 //y2=0.555
cc_1583 ( N_noxref_4_c_1610_p N_noxref_23_M13_noxref_s ) capacitor \
 c=0.0270624f //x=21.835 //y=1.76 //x2=21.215 //y2=0.555
cc_1584 ( N_noxref_4_c_1619_p N_noxref_23_M13_noxref_s ) capacitor \
 c=0.00942148f //x=22.235 //y=1.845 //x2=21.215 //y2=0.555
cc_1585 ( N_noxref_4_c_1600_p N_noxref_23_M13_noxref_s ) capacitor \
 c=0.00108527f //x=22.32 //y=4.25 //x2=21.215 //y2=0.555
cc_1586 ( N_noxref_4_M13_noxref_d N_noxref_23_M13_noxref_s ) capacitor \
 c=0.0279003f //x=21.645 //y=1.095 //x2=21.215 //y2=0.555
cc_1587 ( N_noxref_4_c_1478_p N_GND_c_14094_n ) capacitor c=3.97665e-19 \
 //x=1.3 //y=1.055 //x2=1.565 //y2=1.015
cc_1588 ( N_noxref_4_c_1893_p N_GND_c_14094_n ) capacitor c=0.00864776f \
 //x=1.675 //y=0.9 //x2=1.565 //y2=1.015
cc_1589 ( N_noxref_4_c_1480_p N_GND_c_14094_n ) capacitor c=4.45447e-19 \
 //x=1.83 //y=1.055 //x2=1.565 //y2=1.015
cc_1590 ( N_noxref_4_c_1214_n N_GND_c_13992_n ) capacitor c=0.00210951f \
 //x=11.96 //y=2.26 //x2=14.43 //y2=0.175
cc_1591 ( N_noxref_4_c_1508_p N_GND_c_14098_n ) capacitor c=0.00878061f \
 //x=17.025 //y=1.305 //x2=19.24 //y2=0.175
cc_1592 ( N_noxref_4_c_1568_p N_GND_c_14098_n ) capacitor c=0.00662992f \
 //x=17.425 //y=1.845 //x2=19.24 //y2=0.175
cc_1593 ( N_noxref_4_M10_noxref_d N_GND_c_14098_n ) capacitor c=2.9462e-19 \
 //x=16.835 //y=1.095 //x2=19.24 //y2=0.175
cc_1594 ( N_noxref_4_c_1523_p N_GND_c_14101_n ) capacitor c=0.00884249f \
 //x=21.835 //y=1.305 //x2=24.155 //y2=0.175
cc_1595 ( N_noxref_4_c_1619_p N_GND_c_14101_n ) capacitor c=0.00662992f \
 //x=22.235 //y=1.845 //x2=24.155 //y2=0.175
cc_1596 ( N_noxref_4_c_1439_p N_GND_c_14101_n ) capacitor c=2.70234e-19 \
 //x=22.32 //y=4.395 //x2=24.155 //y2=0.175
cc_1597 ( N_noxref_4_M13_noxref_d N_GND_c_14101_n ) capacitor c=2.9462e-19 \
 //x=21.645 //y=1.095 //x2=24.155 //y2=0.175
cc_1598 ( N_noxref_4_c_1529_p N_GND_c_14105_n ) capacitor c=0.00210951f \
 //x=24.91 //y=2.26 //x2=27.38 //y2=0.175
cc_1599 ( N_noxref_4_c_1403_p N_GND_c_14106_n ) capacitor c=0.00849742f \
 //x=1.6 //y=2.375 //x2=1.565 //y2=1.145
cc_1600 ( N_noxref_4_c_1394_p N_GND_c_14106_n ) capacitor c=5.61357e-19 \
 //x=1.6 //y=4.42 //x2=1.565 //y2=1.145
cc_1601 ( N_noxref_4_c_1399_p N_GND_c_14106_n ) capacitor c=2.22883e-19 \
 //x=1.6 //y=2.26 //x2=1.565 //y2=1.145
cc_1602 ( N_noxref_4_c_1478_p N_GND_c_14106_n ) capacitor c=0.00142616f \
 //x=1.3 //y=1.055 //x2=1.565 //y2=1.145
cc_1603 ( N_noxref_4_c_1479_p N_GND_c_14106_n ) capacitor c=0.00411286f \
 //x=1.3 //y=1.4 //x2=1.565 //y2=1.145
cc_1604 ( N_noxref_4_c_1481_p N_GND_c_14106_n ) capacitor c=4.60246e-19 \
 //x=1.3 //y=1.71 //x2=1.565 //y2=1.145
cc_1605 ( N_noxref_4_c_1893_p N_GND_c_14106_n ) capacitor c=7.3749e-19 \
 //x=1.675 //y=0.9 //x2=1.565 //y2=1.145
cc_1606 ( N_noxref_4_c_1911_p N_GND_c_14106_n ) capacitor c=6.09813e-19 \
 //x=1.675 //y=1.555 //x2=1.565 //y2=1.145
cc_1607 ( N_noxref_4_c_1480_p N_GND_c_14106_n ) capacitor c=0.0017438f \
 //x=1.83 //y=1.055 //x2=1.565 //y2=1.145
cc_1608 ( N_noxref_4_c_1482_p N_GND_c_14106_n ) capacitor c=0.00276804f \
 //x=1.83 //y=1.4 //x2=1.565 //y2=1.145
cc_1609 ( N_noxref_4_c_1508_p N_GND_c_14054_n ) capacitor c=0.00543195f \
 //x=17.025 //y=1.305 //x2=19.325 //y2=1.145
cc_1610 ( N_noxref_4_c_1523_p N_GND_c_14117_n ) capacitor c=0.00488628f \
 //x=21.835 //y=1.305 //x2=24.24 //y2=1.135
cc_1611 ( N_noxref_4_c_1441_p N_GND_c_14117_n ) capacitor c=2.2902e-19 \
 //x=24.17 //y=4.395 //x2=24.24 //y2=1.135
cc_1612 ( N_noxref_4_c_1528_p N_GND_c_14117_n ) capacitor c=0.00645051f \
 //x=24.17 //y=2.26 //x2=24.24 //y2=1.135
cc_1613 ( N_noxref_4_c_1531_p N_GND_c_14117_n ) capacitor c=2.13705e-19 \
 //x=24.17 //y=2.26 //x2=24.24 //y2=1.135
cc_1614 ( N_noxref_4_c_1919_p N_GND_c_14117_n ) capacitor c=0.00176535f \
 //x=23.975 //y=1.045 //x2=24.24 //y2=1.135
cc_1615 ( N_noxref_4_c_1920_p N_GND_c_14117_n ) capacitor c=0.0036005f \
 //x=23.975 //y=1.39 //x2=24.24 //y2=1.135
cc_1616 ( N_noxref_4_c_1921_p N_GND_c_14117_n ) capacitor c=4.2764e-19 \
 //x=23.975 //y=1.7 //x2=24.24 //y2=1.135
cc_1617 ( N_noxref_4_c_1922_p N_GND_c_14117_n ) capacitor c=9.36995e-19 \
 //x=24.35 //y=0.89 //x2=24.24 //y2=1.135
cc_1618 ( N_noxref_4_c_1923_p N_GND_c_14117_n ) capacitor c=6.23294e-19 \
 //x=24.35 //y=1.545 //x2=24.24 //y2=1.135
cc_1619 ( N_noxref_4_c_1924_p N_GND_c_14117_n ) capacitor c=0.00171483f \
 //x=24.505 //y=1.045 //x2=24.24 //y2=1.135
cc_1620 ( N_noxref_4_c_1925_p N_GND_c_14117_n ) capacitor c=0.00296337f \
 //x=24.505 //y=1.39 //x2=24.24 //y2=1.135
cc_1621 ( N_noxref_4_c_1919_p N_GND_c_14128_n ) capacitor c=3.51399e-19 \
 //x=23.975 //y=1.045 //x2=24.237 //y2=1.005
cc_1622 ( N_noxref_4_c_1922_p N_GND_c_14128_n ) capacitor c=0.00850983f \
 //x=24.35 //y=0.89 //x2=24.237 //y2=1.005
cc_1623 ( N_noxref_4_c_1924_p N_GND_c_14128_n ) capacitor c=4.40196e-19 \
 //x=24.505 //y=1.045 //x2=24.237 //y2=1.005
cc_1624 ( N_noxref_4_c_1478_p N_GND_c_13970_n ) capacitor c=0.00680635f \
 //x=1.3 //y=1.055 //x2=5.13 //y2=0.175
cc_1625 ( N_noxref_4_c_1403_p N_GND_c_14132_n ) capacitor c=0.00779049f \
 //x=1.6 //y=2.375 //x2=1.23 //y2=0.18
cc_1626 ( N_noxref_4_c_1196_n N_GND_c_14132_n ) capacitor c=0.0126319f //x=1.6 \
 //y=4.1 //x2=1.23 //y2=0.18
cc_1627 ( N_noxref_4_c_1399_p N_GND_c_14132_n ) capacitor c=0.00394776f \
 //x=1.6 //y=2.26 //x2=1.23 //y2=0.18
cc_1628 ( N_noxref_4_c_1481_p N_GND_c_14132_n ) capacitor c=0.00295461f \
 //x=1.3 //y=1.71 //x2=1.23 //y2=0.18
cc_1629 ( N_noxref_4_c_1406_p N_GND_c_14132_n ) capacitor c=0.0112432f //x=1.3 \
 //y=2.095 //x2=1.23 //y2=0.18
cc_1630 ( N_noxref_4_c_1214_n N_GND_c_13973_n ) capacitor c=3.77328e-19 \
 //x=11.96 //y=2.26 //x2=13.27 //y2=0.175
cc_1631 ( N_noxref_4_c_1568_p N_GND_c_14015_n ) capacitor c=6.86343e-19 \
 //x=17.425 //y=1.845 //x2=18.08 //y2=0.175
cc_1632 ( N_noxref_4_c_1619_p N_GND_c_14066_n ) capacitor c=6.86343e-19 \
 //x=22.235 //y=1.845 //x2=22.89 //y2=0.175
cc_1633 ( N_noxref_4_c_1529_p N_GND_c_14140_n ) capacitor c=3.77328e-19 \
 //x=24.91 //y=2.26 //x2=26.22 //y2=0.175
cc_1634 ( N_noxref_4_c_1919_p N_GND_c_14140_n ) capacitor c=0.00688027f \
 //x=23.975 //y=1.045 //x2=26.22 //y2=0.175
cc_1635 ( N_noxref_4_c_1228_n N_GND_c_14017_n ) capacitor c=0.00207214f \
 //x=11.96 //y=2.26 //x2=13.44 //y2=0.175
cc_1636 ( N_noxref_4_c_1247_n N_GND_c_14017_n ) capacitor c=0.00275184f \
 //x=12.525 //y=1.43 //x2=13.44 //y2=0.175
cc_1637 ( N_noxref_4_c_1248_n N_GND_c_14017_n ) capacitor c=2.63786e-19 \
 //x=11.96 //y=2.26 //x2=13.44 //y2=0.175
cc_1638 ( N_noxref_4_c_1267_n N_GND_c_14074_n ) capacitor c=0.0045138f \
 //x=17.025 //y=1.76 //x2=18.25 //y2=0.175
cc_1639 ( N_noxref_4_c_1568_p N_GND_c_14074_n ) capacitor c=0.0312195f \
 //x=17.425 //y=1.845 //x2=18.25 //y2=0.175
cc_1640 ( N_noxref_4_c_1610_p N_GND_c_14147_n ) capacitor c=0.00285697f \
 //x=21.835 //y=1.76 //x2=23.06 //y2=0.175
cc_1641 ( N_noxref_4_c_1619_p N_GND_c_14147_n ) capacitor c=0.0302549f \
 //x=22.235 //y=1.845 //x2=23.06 //y2=0.175
cc_1642 ( N_noxref_4_c_1385_p N_GND_c_14147_n ) capacitor c=0.00670922f \
 //x=24.17 //y=4.075 //x2=23.06 //y2=0.175
cc_1643 ( N_noxref_4_c_1528_p N_GND_c_14147_n ) capacitor c=0.00351582f \
 //x=24.17 //y=2.26 //x2=23.06 //y2=0.175
cc_1644 ( N_noxref_4_c_1531_p N_GND_c_14147_n ) capacitor c=0.00354425f \
 //x=24.17 //y=2.26 //x2=23.06 //y2=0.175
cc_1645 ( N_noxref_4_c_1921_p N_GND_c_14147_n ) capacitor c=0.0015404f \
 //x=23.975 //y=1.7 //x2=23.06 //y2=0.175
cc_1646 ( N_noxref_4_c_1532_p N_GND_c_14147_n ) capacitor c=0.0093907f \
 //x=23.975 //y=2.095 //x2=23.06 //y2=0.175
cc_1647 ( N_noxref_4_c_1624_p N_GND_c_14154_n ) capacitor c=0.00207214f \
 //x=24.91 //y=2.26 //x2=26.39 //y2=0.175
cc_1648 ( N_noxref_4_c_1614_p N_GND_c_14154_n ) capacitor c=0.00275184f \
 //x=25.475 //y=1.43 //x2=26.39 //y2=0.175
cc_1649 ( N_noxref_4_c_1533_p N_GND_c_14154_n ) capacitor c=2.63786e-19 \
 //x=24.91 //y=2.26 //x2=26.39 //y2=0.175
cc_1650 ( N_noxref_4_c_1403_p N_GND_M0_noxref_d ) capacitor c=4.4417e-19 \
 //x=1.6 //y=2.375 //x2=1.375 //y2=1.055
cc_1651 ( N_noxref_4_c_1478_p N_GND_M0_noxref_d ) capacitor c=0.00184354f \
 //x=1.3 //y=1.055 //x2=1.375 //y2=1.055
cc_1652 ( N_noxref_4_c_1479_p N_GND_M0_noxref_d ) capacitor c=0.00210798f \
 //x=1.3 //y=1.4 //x2=1.375 //y2=1.055
cc_1653 ( N_noxref_4_c_1893_p N_GND_M0_noxref_d ) capacitor c=0.00474029f \
 //x=1.675 //y=0.9 //x2=1.375 //y2=1.055
cc_1654 ( N_noxref_4_c_1911_p N_GND_M0_noxref_d ) capacitor c=0.00166857f \
 //x=1.675 //y=1.555 //x2=1.375 //y2=1.055
cc_1655 ( N_noxref_4_c_1480_p N_GND_M0_noxref_d ) capacitor c=0.00230174f \
 //x=1.83 //y=1.055 //x2=1.375 //y2=1.055
cc_1656 ( N_noxref_4_c_1482_p N_GND_M0_noxref_d ) capacitor c=0.00210798f \
 //x=1.83 //y=1.4 //x2=1.375 //y2=1.055
cc_1657 ( N_noxref_4_c_1528_p N_GND_M14_noxref_d ) capacitor c=2.20438e-19 \
 //x=24.17 //y=2.26 //x2=24.05 //y2=1.045
cc_1658 ( N_noxref_4_c_1919_p N_GND_M14_noxref_d ) capacitor c=0.00192399f \
 //x=23.975 //y=1.045 //x2=24.05 //y2=1.045
cc_1659 ( N_noxref_4_c_1920_p N_GND_M14_noxref_d ) capacitor c=0.00210798f \
 //x=23.975 //y=1.39 //x2=24.05 //y2=1.045
cc_1660 ( N_noxref_4_c_1922_p N_GND_M14_noxref_d ) capacitor c=0.00472259f \
 //x=24.35 //y=0.89 //x2=24.05 //y2=1.045
cc_1661 ( N_noxref_4_c_1923_p N_GND_M14_noxref_d ) capacitor c=0.00166857f \
 //x=24.35 //y=1.545 //x2=24.05 //y2=1.045
cc_1662 ( N_noxref_4_c_1924_p N_GND_M14_noxref_d ) capacitor c=0.00230174f \
 //x=24.505 //y=1.045 //x2=24.05 //y2=1.045
cc_1663 ( N_noxref_4_c_1925_p N_GND_M14_noxref_d ) capacitor c=0.00210798f \
 //x=24.505 //y=1.39 //x2=24.05 //y2=1.045
cc_1664 ( N_noxref_4_c_1406_p N_noxref_35_c_15535_n ) capacitor c=0.00267608f \
 //x=1.3 //y=2.095 //x2=1.08 //y2=1.685
cc_1665 ( N_noxref_4_c_1403_p N_noxref_35_c_15536_n ) capacitor c=0.00428451f \
 //x=1.6 //y=2.375 //x2=1.965 //y2=1.77
cc_1666 ( N_noxref_4_c_1394_p N_noxref_35_c_15536_n ) capacitor c=0.00112138f \
 //x=1.6 //y=4.42 //x2=1.965 //y2=1.77
cc_1667 ( N_noxref_4_c_1217_n N_noxref_35_c_15536_n ) capacitor c=0.00135436f \
 //x=4.175 //y=4.25 //x2=1.965 //y2=1.77
cc_1668 ( N_noxref_4_c_1399_p N_noxref_35_c_15536_n ) capacitor c=0.0104666f \
 //x=1.6 //y=2.26 //x2=1.965 //y2=1.77
cc_1669 ( N_noxref_4_c_1481_p N_noxref_35_c_15536_n ) capacitor c=0.00703864f \
 //x=1.3 //y=1.71 //x2=1.965 //y2=1.77
cc_1670 ( N_noxref_4_c_1406_p N_noxref_35_c_15536_n ) capacitor c=0.0232409f \
 //x=1.3 //y=2.095 //x2=1.965 //y2=1.77
cc_1671 ( N_noxref_4_c_1911_p N_noxref_35_c_15536_n ) capacitor c=0.00588627f \
 //x=1.675 //y=1.555 //x2=1.965 //y2=1.77
cc_1672 ( N_noxref_4_c_1482_p N_noxref_35_c_15536_n ) capacitor c=0.00698822f \
 //x=1.83 //y=1.4 //x2=1.965 //y2=1.77
cc_1673 ( N_noxref_4_c_1217_n N_noxref_35_c_15544_n ) capacitor c=0.00574427f \
 //x=4.175 //y=4.25 //x2=2.935 //y2=1.77
cc_1674 ( N_noxref_4_c_1217_n N_noxref_35_M0_noxref_s ) capacitor \
 c=0.00351966f //x=4.175 //y=4.25 //x2=0.945 //y2=0.555
cc_1675 ( N_noxref_4_c_1478_p N_noxref_35_M0_noxref_s ) capacitor c=0.0295256f \
 //x=1.3 //y=1.055 //x2=0.945 //y2=0.555
cc_1676 ( N_noxref_4_c_1481_p N_noxref_35_M0_noxref_s ) capacitor \
 c=7.99997e-19 //x=1.3 //y=1.71 //x2=0.945 //y2=0.555
cc_1677 ( N_noxref_4_c_1406_p N_noxref_35_M0_noxref_s ) capacitor \
 c=0.00122123f //x=1.3 //y=2.095 //x2=0.945 //y2=0.555
cc_1678 ( N_noxref_4_c_1480_p N_noxref_35_M0_noxref_s ) capacitor c=0.0125924f \
 //x=1.83 //y=1.055 //x2=0.945 //y2=0.555
cc_1679 ( N_noxref_4_c_1207_n N_noxref_37_c_15657_n ) capacitor c=9.49001e-19 \
 //x=11.96 //y=4.41 //x2=11.775 //y2=1.675
cc_1680 ( N_noxref_4_c_1214_n N_noxref_37_c_15657_n ) capacitor c=7.50092e-19 \
 //x=11.96 //y=2.26 //x2=11.775 //y2=1.675
cc_1681 ( N_noxref_4_c_1243_n N_noxref_37_c_15657_n ) capacitor c=0.00888238f \
 //x=11.995 //y=1.74 //x2=11.775 //y2=1.675
cc_1682 ( N_noxref_4_c_1248_n N_noxref_37_c_15657_n ) capacitor c=0.00175171f \
 //x=11.96 //y=2.26 //x2=11.775 //y2=1.675
cc_1683 ( N_noxref_4_c_1214_n N_noxref_37_c_15662_n ) capacitor c=0.001463f \
 //x=11.96 //y=2.26 //x2=12.66 //y2=0.71
cc_1684 ( N_noxref_4_c_1228_n N_noxref_37_c_15662_n ) capacitor c=8.82141e-19 \
 //x=11.96 //y=2.26 //x2=12.66 //y2=0.71
cc_1685 ( N_noxref_4_c_1238_n N_noxref_37_c_15662_n ) capacitor c=0.0200738f \
 //x=11.995 //y=1.085 //x2=12.66 //y2=0.71
cc_1686 ( N_noxref_4_c_1246_n N_noxref_37_c_15662_n ) capacitor c=0.00825432f \
 //x=12.525 //y=1.085 //x2=12.66 //y2=0.71
cc_1687 ( N_noxref_4_c_1248_n N_noxref_37_c_15662_n ) capacitor c=2.1838e-19 \
 //x=11.96 //y=2.26 //x2=12.66 //y2=0.71
cc_1688 ( N_noxref_4_c_1238_n N_noxref_37_M6_noxref_s ) capacitor \
 c=0.00888238f //x=11.995 //y=1.085 //x2=10.67 //y2=0.545
cc_1689 ( N_noxref_4_c_1246_n N_noxref_37_M6_noxref_s ) capacitor c=0.015333f \
 //x=12.525 //y=1.085 //x2=10.67 //y2=0.545
cc_1690 ( N_noxref_4_c_1247_n N_noxref_37_M6_noxref_s ) capacitor \
 c=0.00248746f //x=12.525 //y=1.43 //x2=10.67 //y2=0.545
cc_1691 ( N_noxref_4_c_1532_p N_noxref_40_c_15832_n ) capacitor c=0.00262672f \
 //x=23.975 //y=2.095 //x2=23.755 //y2=1.675
cc_1692 ( N_noxref_4_c_1441_p N_noxref_40_c_15833_n ) capacitor c=0.00336352f \
 //x=24.17 //y=4.395 //x2=24.64 //y2=1.76
cc_1693 ( N_noxref_4_c_1528_p N_noxref_40_c_15833_n ) capacitor c=0.00509504f \
 //x=24.17 //y=2.26 //x2=24.64 //y2=1.76
cc_1694 ( N_noxref_4_c_1531_p N_noxref_40_c_15833_n ) capacitor c=0.00763108f \
 //x=24.17 //y=2.26 //x2=24.64 //y2=1.76
cc_1695 ( N_noxref_4_c_1921_p N_noxref_40_c_15833_n ) capacitor c=0.00697076f \
 //x=23.975 //y=1.7 //x2=24.64 //y2=1.76
cc_1696 ( N_noxref_4_c_1532_p N_noxref_40_c_15833_n ) capacitor c=0.0170561f \
 //x=23.975 //y=2.095 //x2=24.64 //y2=1.76
cc_1697 ( N_noxref_4_c_1923_p N_noxref_40_c_15833_n ) capacitor c=0.00723574f \
 //x=24.35 //y=1.545 //x2=24.64 //y2=1.76
cc_1698 ( N_noxref_4_c_1925_p N_noxref_40_c_15833_n ) capacitor c=0.00339872f \
 //x=24.505 //y=1.39 //x2=24.64 //y2=1.76
cc_1699 ( N_noxref_4_c_1442_p N_noxref_40_c_15840_n ) capacitor c=9.6454e-19 \
 //x=24.91 //y=4.415 //x2=24.725 //y2=1.675
cc_1700 ( N_noxref_4_c_1529_p N_noxref_40_c_15840_n ) capacitor c=7.50092e-19 \
 //x=24.91 //y=2.26 //x2=24.725 //y2=1.675
cc_1701 ( N_noxref_4_c_1532_p N_noxref_40_c_15840_n ) capacitor c=6.71402e-19 \
 //x=23.975 //y=2.095 //x2=24.725 //y2=1.675
cc_1702 ( N_noxref_4_c_1612_p N_noxref_40_c_15840_n ) capacitor c=0.00888238f \
 //x=24.945 //y=1.74 //x2=24.725 //y2=1.675
cc_1703 ( N_noxref_4_c_1533_p N_noxref_40_c_15840_n ) capacitor c=0.00175171f \
 //x=24.91 //y=2.26 //x2=24.725 //y2=1.675
cc_1704 ( N_noxref_4_c_1529_p N_noxref_40_c_15845_n ) capacitor c=0.001463f \
 //x=24.91 //y=2.26 //x2=25.61 //y2=0.71
cc_1705 ( N_noxref_4_c_1624_p N_noxref_40_c_15845_n ) capacitor c=8.82141e-19 \
 //x=24.91 //y=2.26 //x2=25.61 //y2=0.71
cc_1706 ( N_noxref_4_c_1652_p N_noxref_40_c_15845_n ) capacitor c=0.0200738f \
 //x=24.945 //y=1.085 //x2=25.61 //y2=0.71
cc_1707 ( N_noxref_4_c_1656_p N_noxref_40_c_15845_n ) capacitor c=0.00825432f \
 //x=25.475 //y=1.085 //x2=25.61 //y2=0.71
cc_1708 ( N_noxref_4_c_1533_p N_noxref_40_c_15845_n ) capacitor c=2.1838e-19 \
 //x=24.91 //y=2.26 //x2=25.61 //y2=0.71
cc_1709 ( N_noxref_4_c_1919_p N_noxref_40_M14_noxref_s ) capacitor \
 c=0.0295366f //x=23.975 //y=1.045 //x2=23.62 //y2=0.545
cc_1710 ( N_noxref_4_c_1921_p N_noxref_40_M14_noxref_s ) capacitor \
 c=3.48408e-19 //x=23.975 //y=1.7 //x2=23.62 //y2=0.545
cc_1711 ( N_noxref_4_c_1924_p N_noxref_40_M14_noxref_s ) capacitor \
 c=0.0125442f //x=24.505 //y=1.045 //x2=23.62 //y2=0.545
cc_1712 ( N_noxref_4_c_1652_p N_noxref_40_M14_noxref_s ) capacitor \
 c=0.00888238f //x=24.945 //y=1.085 //x2=23.62 //y2=0.545
cc_1713 ( N_noxref_4_c_1656_p N_noxref_40_M14_noxref_s ) capacitor c=0.015333f \
 //x=25.475 //y=1.085 //x2=23.62 //y2=0.545
cc_1714 ( N_noxref_4_c_1614_p N_noxref_40_M14_noxref_s ) capacitor \
 c=0.00248746f //x=25.475 //y=1.43 //x2=23.62 //y2=0.545
cc_1715 ( N_noxref_5_M99_noxref_g N_noxref_6_c_2467_n ) capacitor \
 c=0.00889217f //x=37.46 //y=6.2 //x2=38.005 //y2=5.38
cc_1716 ( N_noxref_5_c_2021_p N_noxref_6_c_2468_n ) capacitor c=0.00326079f \
 //x=34.785 //y=1.76 //x2=38.16 //y2=1.75
cc_1717 ( N_noxref_5_c_2022_p N_noxref_6_c_2469_n ) capacitor c=0.00218808f \
 //x=35.185 //y=1.845 //x2=38.245 //y2=1.835
cc_1718 ( N_noxref_5_c_2022_p N_noxref_6_c_2470_n ) capacitor c=0.00203766f \
 //x=35.185 //y=1.845 //x2=38.6 //y2=3.355
cc_1719 ( N_noxref_5_c_2024_p N_noxref_6_c_2470_n ) capacitor c=0.00175142f \
 //x=37.12 //y=3.35 //x2=38.6 //y2=3.355
cc_1720 ( N_noxref_5_c_2025_p N_noxref_6_c_2472_n ) capacitor c=0.0028534f \
 //x=35.27 //y=5.25 //x2=38.6 //y2=5.295
cc_1721 ( N_noxref_5_c_2026_p N_noxref_6_c_2472_n ) capacitor c=0.00196578f \
 //x=37.122 //y=4.74 //x2=38.6 //y2=5.295
cc_1722 ( N_noxref_5_c_2027_p N_noxref_6_c_2474_n ) capacitor c=5.58535e-19 \
 //x=34.49 //y=5.56 //x2=37.24 //y2=5.56
cc_1723 ( N_noxref_5_c_2028_p N_noxref_6_c_2474_n ) capacitor c=0.00104762f \
 //x=35.185 //y=5.335 //x2=37.24 //y2=5.56
cc_1724 ( N_noxref_5_c_2029_p N_noxref_6_c_2474_n ) capacitor c=6.37679e-19 \
 //x=37.12 //y=3.67 //x2=37.24 //y2=5.56
cc_1725 ( N_noxref_5_c_2030_p N_noxref_6_c_2474_n ) capacitor c=0.0117744f \
 //x=37.12 //y=4.88 //x2=37.24 //y2=5.56
cc_1726 ( N_noxref_5_c_2031_p N_noxref_6_c_2474_n ) capacitor c=0.00277154f \
 //x=37.12 //y=4.88 //x2=37.24 //y2=5.56
cc_1727 ( N_noxref_5_M98_noxref_g N_noxref_6_c_2474_n ) capacitor \
 c=0.00201806f //x=37.02 //y=6.2 //x2=37.24 //y2=5.56
cc_1728 ( N_noxref_5_M99_noxref_g N_noxref_6_c_2474_n ) capacitor \
 c=0.00192712f //x=37.46 //y=6.2 //x2=37.24 //y2=5.56
cc_1729 ( N_noxref_5_c_2034_p N_noxref_6_c_2474_n ) capacitor c=0.00192702f \
 //x=37.12 //y=4.88 //x2=37.24 //y2=5.56
cc_1730 ( N_noxref_5_c_2035_p N_noxref_6_c_2482_n ) capacitor c=6.5615e-19 \
 //x=34.785 //y=1.305 //x2=38.16 //y2=1.18
cc_1731 ( N_noxref_5_c_2036_p N_noxref_6_c_2483_n ) capacitor c=0.00251357f \
 //x=37.12 //y=3.51 //x2=38.6 //y2=3.51
cc_1732 ( N_noxref_5_c_2037_p N_noxref_6_c_2484_n ) capacitor c=0.00529185f \
 //x=37.12 //y=3.51 //x2=38.76 //y2=3.515
cc_1733 ( N_noxref_5_c_2030_p N_noxref_6_c_2485_n ) capacitor c=0.00104426f \
 //x=37.12 //y=4.88 //x2=37.24 //y2=5.56
cc_1734 ( N_noxref_5_c_2031_p N_noxref_6_c_2485_n ) capacitor c=0.00377369f \
 //x=37.12 //y=4.88 //x2=37.24 //y2=5.56
cc_1735 ( N_noxref_5_M98_noxref_g N_noxref_6_c_2485_n ) capacitor c=0.0158358f \
 //x=37.02 //y=6.2 //x2=37.24 //y2=5.56
cc_1736 ( N_noxref_5_M99_noxref_g N_noxref_6_c_2485_n ) capacitor c=0.0178987f \
 //x=37.46 //y=6.2 //x2=37.24 //y2=5.56
cc_1737 ( N_noxref_5_c_2034_p N_noxref_6_c_2485_n ) capacitor c=0.0043218f \
 //x=37.12 //y=4.88 //x2=37.24 //y2=5.56
cc_1738 ( N_noxref_5_c_2043_p N_noxref_7_c_2749_n ) capacitor c=7.46501e-19 \
 //x=29.72 //y=3.67 //x2=29.565 //y2=5.335
cc_1739 ( N_noxref_5_M90_noxref_g N_noxref_7_c_2749_n ) capacitor \
 c=0.00955829f //x=29.46 //y=6.2 //x2=29.565 //y2=5.335
cc_1740 ( N_noxref_5_c_2045_p N_noxref_7_c_2751_n ) capacitor c=6.09703e-19 \
 //x=32.732 //y=5.335 //x2=29.68 //y2=5.56
cc_1741 ( N_noxref_5_M90_noxref_g N_noxref_7_c_2751_n ) capacitor \
 c=0.00226521f //x=29.46 //y=6.2 //x2=29.68 //y2=5.56
cc_1742 ( N_noxref_5_M91_noxref_g N_noxref_7_c_2751_n ) capacitor \
 c=0.00381703f //x=29.9 //y=6.2 //x2=29.68 //y2=5.56
cc_1743 ( N_noxref_5_c_2043_p N_noxref_7_c_2754_n ) capacitor c=0.00109666f \
 //x=29.72 //y=3.67 //x2=30.375 //y2=5.335
cc_1744 ( N_noxref_5_c_2049_p N_noxref_7_c_2754_n ) capacitor c=0.00228791f \
 //x=29.72 //y=4.75 //x2=30.375 //y2=5.335
cc_1745 ( N_noxref_5_c_2045_p N_noxref_7_c_2754_n ) capacitor c=0.00306432f \
 //x=32.732 //y=5.335 //x2=30.375 //y2=5.335
cc_1746 ( N_noxref_5_c_2051_p N_noxref_7_c_2754_n ) capacitor c=0.00130631f \
 //x=29.72 //y=4.88 //x2=30.375 //y2=5.335
cc_1747 ( N_noxref_5_M91_noxref_g N_noxref_7_c_2754_n ) capacitor c=0.0110526f \
 //x=29.9 //y=6.2 //x2=30.375 //y2=5.335
cc_1748 ( N_noxref_5_c_2043_p N_noxref_7_c_2759_n ) capacitor c=2.29817e-19 \
 //x=29.72 //y=3.67 //x2=29.975 //y2=1.305
cc_1749 ( N_noxref_5_c_2054_p N_noxref_7_c_2759_n ) capacitor c=4.64015e-19 \
 //x=29.71 //y=1.095 //x2=29.975 //y2=1.305
cc_1750 ( N_noxref_5_c_2055_p N_noxref_7_c_2759_n ) capacitor c=0.0026012f \
 //x=29.71 //y=1.44 //x2=29.975 //y2=1.305
cc_1751 ( N_noxref_5_c_2056_p N_noxref_7_c_2759_n ) capacitor c=5.29969e-19 \
 //x=30.085 //y=0.94 //x2=29.975 //y2=1.305
cc_1752 ( N_noxref_5_c_2057_p N_noxref_7_c_2759_n ) capacitor c=5.01408e-19 \
 //x=30.085 //y=1.595 //x2=29.975 //y2=1.305
cc_1753 ( N_noxref_5_c_2058_p N_noxref_7_c_2759_n ) capacitor c=5.24634e-19 \
 //x=30.24 //y=1.095 //x2=29.975 //y2=1.305
cc_1754 ( N_noxref_5_c_2059_p N_noxref_7_c_2759_n ) capacitor c=0.00307978f \
 //x=30.24 //y=1.44 //x2=29.975 //y2=1.305
cc_1755 ( N_noxref_5_c_2055_p N_noxref_7_c_2766_n ) capacitor c=0.00127432f \
 //x=29.71 //y=1.44 //x2=29.975 //y2=1.76
cc_1756 ( N_noxref_5_c_2061_p N_noxref_7_c_2766_n ) capacitor c=0.00429966f \
 //x=29.71 //y=1.75 //x2=29.975 //y2=1.76
cc_1757 ( N_noxref_5_c_2057_p N_noxref_7_c_2766_n ) capacitor c=0.00942306f \
 //x=30.085 //y=1.595 //x2=29.975 //y2=1.76
cc_1758 ( N_noxref_5_c_2059_p N_noxref_7_c_2766_n ) capacitor c=0.00363411f \
 //x=30.24 //y=1.44 //x2=29.975 //y2=1.76
cc_1759 ( N_noxref_5_c_2064_p N_noxref_7_c_2766_n ) capacitor c=0.00362297f \
 //x=29.72 //y=2.095 //x2=29.975 //y2=1.76
cc_1760 ( N_noxref_5_c_2065_p N_noxref_7_c_2771_n ) capacitor c=0.00163399f \
 //x=34.87 //y=1.845 //x2=30.375 //y2=1.845
cc_1761 ( N_noxref_5_c_2057_p N_noxref_7_c_2771_n ) capacitor c=0.00194716f \
 //x=30.085 //y=1.595 //x2=30.375 //y2=1.845
cc_1762 ( N_noxref_5_c_2059_p N_noxref_7_c_2771_n ) capacitor c=0.00323576f \
 //x=30.24 //y=1.44 //x2=30.375 //y2=1.845
cc_1763 ( N_noxref_5_c_2043_p N_noxref_7_c_2774_n ) capacitor c=0.00103023f \
 //x=29.72 //y=3.67 //x2=30.06 //y2=1.845
cc_1764 ( N_noxref_5_c_2069_p N_noxref_7_c_2775_n ) capacitor c=0.0140058f \
 //x=29.72 //y=2.375 //x2=30.46 //y2=3.725
cc_1765 ( N_noxref_5_c_2070_p N_noxref_7_c_2775_n ) capacitor c=0.0376974f \
 //x=29.72 //y=3.35 //x2=30.46 //y2=3.725
cc_1766 ( N_noxref_5_c_2043_p N_noxref_7_c_2775_n ) capacitor c=0.0173072f \
 //x=29.72 //y=3.67 //x2=30.46 //y2=3.725
cc_1767 ( N_noxref_5_c_2049_p N_noxref_7_c_2775_n ) capacitor c=0.00244924f \
 //x=29.72 //y=4.75 //x2=30.46 //y2=3.725
cc_1768 ( N_noxref_5_c_2073_p N_noxref_7_c_2775_n ) capacitor c=6.78671e-19 \
 //x=29.72 //y=3.51 //x2=30.46 //y2=3.725
cc_1769 ( N_noxref_5_c_2074_p N_noxref_7_c_2775_n ) capacitor c=0.0030925f \
 //x=29.88 //y=3.51 //x2=30.46 //y2=3.725
cc_1770 ( N_noxref_5_c_2075_p N_noxref_7_c_2775_n ) capacitor c=0.0216482f \
 //x=30.68 //y=3.5 //x2=30.46 //y2=3.725
cc_1771 ( N_noxref_5_c_2076_p N_noxref_7_c_2775_n ) capacitor c=0.0015536f \
 //x=29.72 //y=2.26 //x2=30.46 //y2=3.725
cc_1772 ( N_noxref_5_c_2077_p N_noxref_7_c_2775_n ) capacitor c=0.0024584f \
 //x=29.72 //y=2.26 //x2=30.46 //y2=3.725
cc_1773 ( N_noxref_5_c_2064_p N_noxref_7_c_2775_n ) capacitor c=0.00282067f \
 //x=29.72 //y=2.095 //x2=30.46 //y2=3.725
cc_1774 ( N_noxref_5_c_2049_p N_noxref_7_c_2785_n ) capacitor c=0.0146933f \
 //x=29.72 //y=4.75 //x2=30.46 //y2=4.045
cc_1775 ( N_noxref_5_c_2075_p N_noxref_7_c_2785_n ) capacitor c=0.00895951f \
 //x=30.68 //y=3.5 //x2=30.46 //y2=4.045
cc_1776 ( N_noxref_5_c_2049_p N_noxref_7_c_2787_n ) capacitor c=0.0414151f \
 //x=29.72 //y=4.75 //x2=30.46 //y2=5.25
cc_1777 ( N_noxref_5_c_2051_p N_noxref_7_c_2787_n ) capacitor c=0.00131258f \
 //x=29.72 //y=4.88 //x2=30.46 //y2=5.25
cc_1778 ( N_noxref_5_c_2083_p N_noxref_7_c_2787_n ) capacitor c=0.00739875f \
 //x=29.72 //y=4.88 //x2=30.46 //y2=5.25
cc_1779 ( N_noxref_5_c_2070_p N_noxref_7_c_2790_n ) capacitor c=0.00116776f \
 //x=29.72 //y=3.35 //x2=32.31 //y2=3.72
cc_1780 ( N_noxref_5_c_2085_p N_noxref_7_c_2790_n ) capacitor c=4.94863e-19 \
 //x=31.93 //y=3.51 //x2=32.31 //y2=3.72
cc_1781 ( N_noxref_5_c_2086_p N_noxref_7_c_2790_n ) capacitor c=0.023561f \
 //x=32.53 //y=3.495 //x2=32.31 //y2=3.72
cc_1782 ( N_noxref_5_c_2087_p N_noxref_7_c_2790_n ) capacitor c=3.74737e-19 \
 //x=35.435 //y=3.51 //x2=32.31 //y2=3.72
cc_1783 ( N_noxref_5_c_2086_p N_noxref_7_c_2794_n ) capacitor c=0.00797853f \
 //x=32.53 //y=3.495 //x2=32.31 //y2=4.04
cc_1784 ( N_noxref_5_c_2049_p N_noxref_7_c_2795_n ) capacitor c=8.5348e-19 \
 //x=29.72 //y=4.75 //x2=32.31 //y2=4.755
cc_1785 ( N_noxref_5_c_2049_p N_noxref_7_c_2796_n ) capacitor c=0.0228808f \
 //x=29.72 //y=4.75 //x2=29.68 //y2=5.335
cc_1786 ( N_noxref_5_c_2051_p N_noxref_7_c_2796_n ) capacitor c=0.00346456f \
 //x=29.72 //y=4.88 //x2=29.68 //y2=5.335
cc_1787 ( N_noxref_5_c_2083_p N_noxref_7_c_2796_n ) capacitor c=0.00203307f \
 //x=29.72 //y=4.88 //x2=29.68 //y2=5.335
cc_1788 ( N_noxref_5_c_2049_p N_noxref_7_c_2799_n ) capacitor c=6.15181e-19 \
 //x=29.72 //y=4.75 //x2=30.46 //y2=3.88
cc_1789 ( N_noxref_5_c_2075_p N_noxref_7_c_2800_n ) capacitor c=0.128059f \
 //x=30.68 //y=3.5 //x2=32.155 //y2=3.88
cc_1790 ( N_noxref_5_c_2085_p N_noxref_7_c_2800_n ) capacitor c=0.0120328f \
 //x=31.93 //y=3.51 //x2=32.155 //y2=3.88
cc_1791 ( N_noxref_5_c_2096_p N_noxref_7_c_2802_n ) capacitor c=0.00771097f \
 //x=35.27 //y=3.67 //x2=35.49 //y2=3.895
cc_1792 ( N_noxref_5_c_2025_p N_noxref_7_c_2802_n ) capacitor c=0.0226453f \
 //x=35.27 //y=5.25 //x2=35.49 //y2=3.895
cc_1793 ( N_noxref_5_c_2098_p N_noxref_7_c_2802_n ) capacitor c=0.127201f \
 //x=36.96 //y=3.51 //x2=35.49 //y2=3.895
cc_1794 ( N_noxref_5_c_2096_p N_noxref_7_c_2805_n ) capacitor c=0.00128047f \
 //x=35.27 //y=3.67 //x2=35.145 //y2=3.895
cc_1795 ( N_noxref_5_c_2025_p N_noxref_7_c_2805_n ) capacitor c=3.14797e-19 \
 //x=35.27 //y=5.25 //x2=35.145 //y2=3.895
cc_1796 ( N_noxref_5_c_2086_p N_noxref_7_c_2805_n ) capacitor c=0.0467915f \
 //x=32.53 //y=3.495 //x2=35.145 //y2=3.895
cc_1797 ( N_noxref_5_c_2087_p N_noxref_7_c_2805_n ) capacitor c=0.249049f \
 //x=35.435 //y=3.51 //x2=35.145 //y2=3.895
cc_1798 ( N_noxref_5_c_2029_p N_noxref_7_c_2809_n ) capacitor c=0.00339401f \
 //x=37.12 //y=3.67 //x2=36.735 //y2=3.88
cc_1799 ( N_noxref_5_c_2026_p N_noxref_7_c_2809_n ) capacitor c=5.02752e-19 \
 //x=37.122 //y=4.74 //x2=36.735 //y2=3.88
cc_1800 ( N_noxref_5_c_2098_p N_noxref_7_c_2809_n ) capacitor c=0.0107648f \
 //x=36.96 //y=3.51 //x2=36.735 //y2=3.88
cc_1801 ( N_noxref_5_c_2037_p N_noxref_7_c_2809_n ) capacitor c=0.0358254f \
 //x=37.12 //y=3.51 //x2=36.735 //y2=3.88
cc_1802 ( N_noxref_5_c_2029_p N_noxref_7_c_2813_n ) capacitor c=0.00260425f \
 //x=37.12 //y=3.67 //x2=37.335 //y2=3.895
cc_1803 ( N_noxref_5_c_2026_p N_noxref_7_c_2813_n ) capacitor c=0.0229559f \
 //x=37.122 //y=4.74 //x2=37.335 //y2=3.895
cc_1804 ( N_noxref_5_c_2049_p N_noxref_7_c_2815_n ) capacitor c=0.00683433f \
 //x=29.72 //y=4.75 //x2=30.625 //y2=3.885
cc_1805 ( N_noxref_5_c_2075_p N_noxref_7_c_2815_n ) capacitor c=0.0358686f \
 //x=30.68 //y=3.5 //x2=30.625 //y2=3.885
cc_1806 ( N_noxref_5_c_2049_p N_noxref_7_c_2817_n ) capacitor c=0.00217653f \
 //x=29.72 //y=4.75 //x2=29.68 //y2=5.56
cc_1807 ( N_noxref_5_c_2051_p N_noxref_7_c_2817_n ) capacitor c=0.00624059f \
 //x=29.72 //y=4.88 //x2=29.68 //y2=5.56
cc_1808 ( N_noxref_5_M90_noxref_g N_noxref_7_c_2817_n ) capacitor c=0.0178885f \
 //x=29.46 //y=6.2 //x2=29.68 //y2=5.56
cc_1809 ( N_noxref_5_M91_noxref_g N_noxref_7_c_2817_n ) capacitor c=0.0188608f \
 //x=29.9 //y=6.2 //x2=29.68 //y2=5.56
cc_1810 ( N_noxref_5_c_2083_p N_noxref_7_c_2817_n ) capacitor c=0.00375636f \
 //x=29.72 //y=4.88 //x2=29.68 //y2=5.56
cc_1811 ( N_noxref_5_c_2045_p N_noxref_7_M92_noxref_g ) capacitor \
 c=0.00461408f //x=32.732 //y=5.335 //x2=32.51 //y2=6.2
cc_1812 ( N_noxref_5_c_2117_p N_noxref_7_M92_noxref_g ) capacitor c=0.0162284f \
 //x=32.73 //y=5.56 //x2=32.51 //y2=6.2
cc_1813 ( N_noxref_5_c_2118_p N_noxref_7_M93_noxref_g ) capacitor \
 c=0.00893512f //x=33.49 //y=5.335 //x2=32.95 //y2=6.2
cc_1814 ( N_noxref_5_c_2045_p N_noxref_7_M93_noxref_g ) capacitor \
 c=0.00229208f //x=32.732 //y=5.335 //x2=32.95 //y2=6.2
cc_1815 ( N_noxref_5_c_2117_p N_noxref_7_M93_noxref_g ) capacitor c=0.0179041f \
 //x=32.73 //y=5.56 //x2=32.95 //y2=6.2
cc_1816 ( N_noxref_5_c_2045_p N_noxref_7_c_2827_n ) capacitor c=0.00171885f \
 //x=32.732 //y=5.335 //x2=32.875 //y2=4.97
cc_1817 ( N_noxref_5_c_2117_p N_noxref_7_c_2827_n ) capacitor c=0.00291477f \
 //x=32.73 //y=5.56 //x2=32.875 //y2=4.97
cc_1818 ( N_noxref_5_c_2054_p N_noxref_7_M18_noxref_d ) capacitor \
 c=0.00137165f //x=29.71 //y=1.095 //x2=29.785 //y2=1.095
cc_1819 ( N_noxref_5_c_2055_p N_noxref_7_M18_noxref_d ) capacitor \
 c=0.00237422f //x=29.71 //y=1.44 //x2=29.785 //y2=1.095
cc_1820 ( N_noxref_5_c_2056_p N_noxref_7_M18_noxref_d ) capacitor c=0.0020782f \
 //x=30.085 //y=0.94 //x2=29.785 //y2=1.095
cc_1821 ( N_noxref_5_c_2057_p N_noxref_7_M18_noxref_d ) capacitor \
 c=0.00356097f //x=30.085 //y=1.595 //x2=29.785 //y2=1.095
cc_1822 ( N_noxref_5_c_2058_p N_noxref_7_M18_noxref_d ) capacitor \
 c=0.00139206f //x=30.24 //y=1.095 //x2=29.785 //y2=1.095
cc_1823 ( N_noxref_5_c_2059_p N_noxref_7_M18_noxref_d ) capacitor \
 c=0.00237422f //x=30.24 //y=1.44 //x2=29.785 //y2=1.095
cc_1824 ( N_noxref_5_c_2070_p N_noxref_9_c_3531_n ) capacitor c=8.11351e-19 \
 //x=29.72 //y=3.35 //x2=27.5 //y2=4.1
cc_1825 ( N_noxref_5_c_2049_p N_noxref_9_c_3531_n ) capacitor c=8.0808e-19 \
 //x=29.72 //y=4.75 //x2=27.5 //y2=4.1
cc_1826 ( N_noxref_5_c_2049_p N_noxref_9_c_3532_n ) capacitor c=2.96131e-19 \
 //x=29.72 //y=4.75 //x2=27.5 //y2=4.755
cc_1827 ( N_noxref_5_c_2132_p N_noxref_9_c_3538_n ) capacitor c=0.00117238f \
 //x=35.27 //y=3.35 //x2=37.86 //y2=4.09
cc_1828 ( N_noxref_5_c_2025_p N_noxref_9_c_3538_n ) capacitor c=3.24787e-19 \
 //x=35.27 //y=5.25 //x2=37.86 //y2=4.09
cc_1829 ( N_noxref_5_c_2024_p N_noxref_9_c_3538_n ) capacitor c=0.0365764f \
 //x=37.12 //y=3.35 //x2=37.86 //y2=4.09
cc_1830 ( N_noxref_5_c_2029_p N_noxref_9_c_3538_n ) capacitor c=0.0148501f \
 //x=37.12 //y=3.67 //x2=37.86 //y2=4.09
cc_1831 ( N_noxref_5_c_2036_p N_noxref_9_c_3538_n ) capacitor c=5.52402e-19 \
 //x=37.12 //y=3.51 //x2=37.86 //y2=4.09
cc_1832 ( N_noxref_5_c_2026_p N_noxref_9_c_3538_n ) capacitor c=0.0167029f \
 //x=37.122 //y=4.74 //x2=37.86 //y2=4.09
cc_1833 ( N_noxref_5_c_2037_p N_noxref_9_c_3538_n ) capacitor c=0.00365413f \
 //x=37.12 //y=3.51 //x2=37.86 //y2=4.09
cc_1834 ( N_noxref_5_c_2139_p N_noxref_9_c_3538_n ) capacitor c=3.30333e-19 \
 //x=37.12 //y=2.26 //x2=37.86 //y2=4.09
cc_1835 ( N_noxref_5_c_2026_p N_noxref_9_c_3546_n ) capacitor c=0.0172847f \
 //x=37.122 //y=4.74 //x2=37.86 //y2=4.41
cc_1836 ( N_noxref_5_c_2025_p N_noxref_9_c_3547_n ) capacitor c=7.59756e-19 \
 //x=35.27 //y=5.25 //x2=37.86 //y2=4.735
cc_1837 ( N_noxref_5_c_2030_p N_noxref_9_c_3547_n ) capacitor c=0.0172939f \
 //x=37.12 //y=4.88 //x2=37.86 //y2=4.735
cc_1838 ( N_noxref_5_c_2026_p N_noxref_9_c_3547_n ) capacitor c=0.0117609f \
 //x=37.122 //y=4.74 //x2=37.86 //y2=4.735
cc_1839 ( N_noxref_5_c_2031_p N_noxref_9_c_3547_n ) capacitor c=7.51041e-19 \
 //x=37.12 //y=4.88 //x2=37.86 //y2=4.735
cc_1840 ( N_noxref_5_c_2034_p N_noxref_9_c_3547_n ) capacitor c=0.00200732f \
 //x=37.12 //y=4.88 //x2=37.86 //y2=4.735
cc_1841 ( N_noxref_5_c_2026_p N_noxref_9_c_3552_n ) capacitor c=6.16997e-19 \
 //x=37.122 //y=4.74 //x2=37.86 //y2=4.25
cc_1842 ( N_noxref_5_c_2147_p N_noxref_9_c_3553_n ) capacitor c=0.0179797f \
 //x=37.12 //y=2.26 //x2=37.86 //y2=2.26
cc_1843 ( N_noxref_5_c_2139_p N_noxref_9_c_3553_n ) capacitor c=5.16867e-19 \
 //x=37.12 //y=2.26 //x2=37.86 //y2=2.26
cc_1844 ( N_noxref_5_c_2149_p N_noxref_9_c_3553_n ) capacitor c=0.00161745f \
 //x=36.925 //y=2.095 //x2=37.86 //y2=2.26
cc_1845 ( N_noxref_5_c_2043_p N_noxref_9_c_3556_n ) capacitor c=0.0032242f \
 //x=29.72 //y=3.67 //x2=30.075 //y2=4.25
cc_1846 ( N_noxref_5_c_2049_p N_noxref_9_c_3556_n ) capacitor c=0.024687f \
 //x=29.72 //y=4.75 //x2=30.075 //y2=4.25
cc_1847 ( N_noxref_5_c_2152_p N_noxref_9_c_3556_n ) capacitor c=0.0156063f \
 //x=30.08 //y=3.51 //x2=30.075 //y2=4.25
cc_1848 ( N_noxref_5_c_2074_p N_noxref_9_c_3556_n ) capacitor c=0.0156808f \
 //x=29.88 //y=3.51 //x2=30.075 //y2=4.25
cc_1849 ( N_noxref_5_c_2075_p N_noxref_9_c_3560_n ) capacitor c=0.00863702f \
 //x=30.68 //y=3.5 //x2=30.715 //y2=4.27
cc_1850 ( N_noxref_5_c_2085_p N_noxref_9_c_3561_n ) capacitor c=0.00556214f \
 //x=31.93 //y=3.51 //x2=31.93 //y2=4.25
cc_1851 ( N_noxref_5_c_2086_p N_noxref_9_c_3562_n ) capacitor c=0.00123933f \
 //x=32.53 //y=3.495 //x2=32.53 //y2=4.265
cc_1852 ( N_noxref_5_c_2025_p N_noxref_9_c_3563_n ) capacitor c=0.0232184f \
 //x=35.27 //y=5.25 //x2=38.025 //y2=4.25
cc_1853 ( N_noxref_5_c_2026_p N_noxref_9_c_3563_n ) capacitor c=0.0253737f \
 //x=37.122 //y=4.74 //x2=38.025 //y2=4.25
cc_1854 ( N_noxref_5_c_2098_p N_noxref_9_c_3563_n ) capacitor c=0.0104445f \
 //x=36.96 //y=3.51 //x2=38.025 //y2=4.25
cc_1855 ( N_noxref_5_c_2087_p N_noxref_9_c_3563_n ) capacitor c=0.0225657f \
 //x=35.435 //y=3.51 //x2=38.025 //y2=4.25
cc_1856 ( N_noxref_5_c_2024_p N_noxref_9_c_3567_n ) capacitor c=3.30333e-19 \
 //x=37.12 //y=3.35 //x2=37.86 //y2=2.26
cc_1857 ( N_noxref_5_c_2147_p N_noxref_9_c_3567_n ) capacitor c=5.24723e-19 \
 //x=37.12 //y=2.26 //x2=37.86 //y2=2.26
cc_1858 ( N_noxref_5_c_2139_p N_noxref_9_c_3567_n ) capacitor c=0.00525888f \
 //x=37.12 //y=2.26 //x2=37.86 //y2=2.26
cc_1859 ( N_noxref_5_c_2149_p N_noxref_9_c_3567_n ) capacitor c=0.00190888f \
 //x=36.925 //y=2.095 //x2=37.86 //y2=2.26
cc_1860 ( N_noxref_5_c_2030_p N_noxref_9_c_3571_n ) capacitor c=4.80626e-19 \
 //x=37.12 //y=4.88 //x2=37.89 //y2=4.88
cc_1861 ( N_noxref_5_c_2031_p N_noxref_9_c_3571_n ) capacitor c=0.00397338f \
 //x=37.12 //y=4.88 //x2=37.89 //y2=4.88
cc_1862 ( N_noxref_5_c_2034_p N_noxref_9_c_3571_n ) capacitor c=0.00283894f \
 //x=37.12 //y=4.88 //x2=37.89 //y2=4.88
cc_1863 ( N_noxref_5_M98_noxref_g N_noxref_9_M100_noxref_g ) capacitor \
 c=0.0104892f //x=37.02 //y=6.2 //x2=37.9 //y2=6.2
cc_1864 ( N_noxref_5_M99_noxref_g N_noxref_9_M100_noxref_g ) capacitor \
 c=0.107636f //x=37.46 //y=6.2 //x2=37.9 //y2=6.2
cc_1865 ( N_noxref_5_M99_noxref_g N_noxref_9_M101_noxref_g ) capacitor \
 c=0.0100341f //x=37.46 //y=6.2 //x2=38.34 //y2=6.2
cc_1866 ( N_noxref_5_c_2171_p N_noxref_9_c_3577_n ) capacitor c=4.86545e-19 \
 //x=36.925 //y=1.045 //x2=37.895 //y2=1.085
cc_1867 ( N_noxref_5_c_2172_p N_noxref_9_c_3577_n ) capacitor c=0.00152405f \
 //x=36.925 //y=1.39 //x2=37.895 //y2=1.085
cc_1868 ( N_noxref_5_c_2173_p N_noxref_9_c_3577_n ) capacitor c=0.0151475f \
 //x=37.455 //y=1.045 //x2=37.895 //y2=1.085
cc_1869 ( N_noxref_5_c_2174_p N_noxref_9_c_3580_n ) capacitor c=0.00109982f \
 //x=36.925 //y=1.7 //x2=37.895 //y2=1.43
cc_1870 ( N_noxref_5_c_2175_p N_noxref_9_c_3580_n ) capacitor c=0.0111064f \
 //x=37.455 //y=1.39 //x2=37.895 //y2=1.43
cc_1871 ( N_noxref_5_c_2174_p N_noxref_9_c_3582_n ) capacitor c=9.58243e-19 \
 //x=36.925 //y=1.7 //x2=37.895 //y2=1.74
cc_1872 ( N_noxref_5_c_2149_p N_noxref_9_c_3582_n ) capacitor c=0.00662747f \
 //x=36.925 //y=2.095 //x2=37.895 //y2=1.74
cc_1873 ( N_noxref_5_c_2175_p N_noxref_9_c_3582_n ) capacitor c=0.00862358f \
 //x=37.455 //y=1.39 //x2=37.895 //y2=1.74
cc_1874 ( N_noxref_5_c_2173_p N_noxref_9_c_3585_n ) capacitor c=0.00127211f \
 //x=37.455 //y=1.045 //x2=38.425 //y2=1.085
cc_1875 ( N_noxref_5_c_2175_p N_noxref_9_c_3586_n ) capacitor c=0.00204774f \
 //x=37.455 //y=1.39 //x2=38.425 //y2=1.43
cc_1876 ( N_noxref_5_c_2147_p N_noxref_9_c_3587_n ) capacitor c=0.00161167f \
 //x=37.12 //y=2.26 //x2=37.86 //y2=2.26
cc_1877 ( N_noxref_5_c_2139_p N_noxref_9_c_3587_n ) capacitor c=0.0018937f \
 //x=37.12 //y=2.26 //x2=37.86 //y2=2.26
cc_1878 ( N_noxref_5_c_2149_p N_noxref_9_c_3587_n ) capacitor c=0.0181449f \
 //x=36.925 //y=2.095 //x2=37.86 //y2=2.26
cc_1879 ( N_noxref_5_c_2030_p N_noxref_9_c_3590_n ) capacitor c=0.00158715f \
 //x=37.12 //y=4.88 //x2=37.89 //y2=4.88
cc_1880 ( N_noxref_5_c_2031_p N_noxref_9_c_3590_n ) capacitor c=0.00237977f \
 //x=37.12 //y=4.88 //x2=37.89 //y2=4.88
cc_1881 ( N_noxref_5_c_2034_p N_noxref_9_c_3590_n ) capacitor c=0.0297875f \
 //x=37.12 //y=4.88 //x2=37.89 //y2=4.88
cc_1882 ( N_noxref_5_c_2132_p N_D_c_4293_n ) capacitor c=3.17935e-19 //x=35.27 \
 //y=3.35 //x2=33.42 //y2=2.595
cc_1883 ( N_noxref_5_c_2118_p N_D_c_4294_n ) capacitor c=3.92616e-19 //x=33.49 \
 //y=5.335 //x2=33.42 //y2=2.915
cc_1884 ( N_noxref_5_c_2189_p N_D_c_4294_n ) capacitor c=0.00123114f //x=33.61 \
 //y=5.335 //x2=33.42 //y2=2.915
cc_1885 ( N_noxref_5_c_2190_p N_D_c_4294_n ) capacitor c=3.88405e-19 //x=33.61 \
 //y=5.56 //x2=33.42 //y2=2.915
cc_1886 ( N_noxref_5_c_2118_p N_D_c_4297_n ) capacitor c=0.0213631f //x=33.49 \
 //y=5.335 //x2=33.42 //y2=4.765
cc_1887 ( N_noxref_5_c_2132_p N_D_c_4297_n ) capacitor c=4.06588e-19 //x=35.27 \
 //y=3.35 //x2=33.42 //y2=4.765
cc_1888 ( N_noxref_5_c_2025_p N_D_c_4297_n ) capacitor c=0.00135693f //x=35.27 \
 //y=5.25 //x2=33.42 //y2=4.765
cc_1889 ( N_noxref_5_c_2189_p N_D_c_4297_n ) capacitor c=0.00239361f //x=33.61 \
 //y=5.335 //x2=33.42 //y2=4.765
cc_1890 ( N_noxref_5_c_2087_p N_D_c_4297_n ) capacitor c=0.0239331f //x=35.435 \
 //y=3.51 //x2=33.42 //y2=4.765
cc_1891 ( N_noxref_5_c_2190_p N_D_c_4297_n ) capacitor c=6.21282e-19 //x=33.61 \
 //y=5.56 //x2=33.42 //y2=4.765
cc_1892 ( N_noxref_5_c_2132_p N_D_c_4303_n ) capacitor c=0.0232171f //x=35.27 \
 //y=3.35 //x2=59.16 //y2=2.77
cc_1893 ( N_noxref_5_c_2024_p N_D_c_4303_n ) capacitor c=0.0232027f //x=37.12 \
 //y=3.35 //x2=59.16 //y2=2.77
cc_1894 ( N_noxref_5_c_2098_p N_D_c_4303_n ) capacitor c=0.00820225f //x=36.96 \
 //y=3.51 //x2=59.16 //y2=2.77
cc_1895 ( N_noxref_5_c_2087_p N_D_c_4303_n ) capacitor c=0.0136363f //x=35.435 \
 //y=3.51 //x2=59.16 //y2=2.77
cc_1896 ( N_noxref_5_c_2070_p N_D_c_4197_n ) capacitor c=0.02192f //x=29.72 \
 //y=3.35 //x2=33.26 //y2=2.755
cc_1897 ( N_noxref_5_c_2152_p N_D_c_4197_n ) capacitor c=0.00611767f //x=30.08 \
 //y=3.51 //x2=33.26 //y2=2.755
cc_1898 ( N_noxref_5_c_2075_p N_D_c_4197_n ) capacitor c=0.00703957f //x=30.68 \
 //y=3.5 //x2=33.26 //y2=2.755
cc_1899 ( N_noxref_5_c_2085_p N_D_c_4197_n ) capacitor c=0.00396666f //x=31.93 \
 //y=3.51 //x2=33.26 //y2=2.755
cc_1900 ( N_noxref_5_c_2087_p N_D_c_4197_n ) capacitor c=0.00665158f \
 //x=35.435 //y=3.51 //x2=33.26 //y2=2.755
cc_1901 ( N_noxref_5_c_2118_p N_D_c_4312_n ) capacitor c=0.00492634f //x=33.49 \
 //y=5.335 //x2=33.42 //y2=4.88
cc_1902 ( N_noxref_5_c_2189_p N_D_c_4312_n ) capacitor c=0.00132214f //x=33.61 \
 //y=5.335 //x2=33.42 //y2=4.88
cc_1903 ( N_noxref_5_c_2118_p N_D_M94_noxref_g ) capacitor c=0.00858241f \
 //x=33.49 //y=5.335 //x2=33.39 //y2=6.2
cc_1904 ( N_noxref_5_c_2189_p N_D_M94_noxref_g ) capacitor c=0.00229818f \
 //x=33.61 //y=5.335 //x2=33.39 //y2=6.2
cc_1905 ( N_noxref_5_c_2190_p N_D_M94_noxref_g ) capacitor c=0.0179041f \
 //x=33.61 //y=5.56 //x2=33.39 //y2=6.2
cc_1906 ( N_noxref_5_c_2211_p N_D_M95_noxref_g ) capacitor c=0.00955829f \
 //x=34.375 //y=5.335 //x2=33.83 //y2=6.2
cc_1907 ( N_noxref_5_c_2189_p N_D_M95_noxref_g ) capacitor c=0.00230699f \
 //x=33.61 //y=5.335 //x2=33.83 //y2=6.2
cc_1908 ( N_noxref_5_c_2190_p N_D_M95_noxref_g ) capacitor c=0.0179041f \
 //x=33.61 //y=5.56 //x2=33.83 //y2=6.2
cc_1909 ( N_noxref_5_c_2189_p N_D_c_4320_n ) capacitor c=0.00209256f //x=33.61 \
 //y=5.335 //x2=33.755 //y2=4.97
cc_1910 ( N_noxref_5_c_2190_p N_D_c_4320_n ) capacitor c=0.00290085f //x=33.61 \
 //y=5.56 //x2=33.755 //y2=4.97
cc_1911 ( N_noxref_5_c_2118_p N_D_c_4322_n ) capacitor c=6.03064e-19 //x=33.49 \
 //y=5.335 //x2=33.42 //y2=4.88
cc_1912 ( N_noxref_5_c_2070_p CLK ) capacitor c=0.0212411f //x=29.72 //y=3.35 \
 //x2=28.61 //y2=3.51
cc_1913 ( N_noxref_5_c_2043_p CLK ) capacitor c=0.00775314f //x=29.72 //y=3.67 \
 //x2=28.61 //y2=3.51
cc_1914 ( N_noxref_5_c_2049_p CLK ) capacitor c=0.0245158f //x=29.72 //y=4.75 \
 //x2=28.61 //y2=3.51
cc_1915 ( N_noxref_5_c_2073_p CLK ) capacitor c=3.35971e-19 //x=29.72 //y=3.51 \
 //x2=28.61 //y2=3.51
cc_1916 ( N_noxref_5_c_2074_p CLK ) capacitor c=0.00508753f //x=29.88 //y=3.51 \
 //x2=28.61 //y2=3.51
cc_1917 ( N_noxref_5_c_2076_p CLK ) capacitor c=3.9149e-19 //x=29.72 //y=2.26 \
 //x2=28.61 //y2=3.51
cc_1918 ( N_noxref_5_c_2069_p N_CLK_c_4998_n ) capacitor c=0.00939109f \
 //x=29.72 //y=2.375 //x2=28.61 //y2=2.375
cc_1919 ( N_noxref_5_c_2076_p N_CLK_c_4998_n ) capacitor c=5.42289e-19 \
 //x=29.72 //y=2.26 //x2=28.61 //y2=2.375
cc_1920 ( N_noxref_5_c_2077_p N_CLK_c_4998_n ) capacitor c=0.00134951f \
 //x=29.72 //y=2.26 //x2=28.61 //y2=2.375
cc_1921 ( N_noxref_5_c_2049_p N_CLK_c_5001_n ) capacitor c=0.0082089f \
 //x=29.72 //y=4.75 //x2=28.605 //y2=4.835
cc_1922 ( N_noxref_5_c_2051_p N_CLK_c_5001_n ) capacitor c=7.52809e-19 \
 //x=29.72 //y=4.88 //x2=28.605 //y2=4.835
cc_1923 ( N_noxref_5_c_2083_p N_CLK_c_5001_n ) capacitor c=0.0013272f \
 //x=29.72 //y=4.88 //x2=28.605 //y2=4.835
cc_1924 ( N_noxref_5_c_2049_p N_CLK_c_5004_n ) capacitor c=0.0356159f \
 //x=29.72 //y=4.75 //x2=37.735 //y2=4.635
cc_1925 ( N_noxref_5_c_2028_p N_CLK_c_5004_n ) capacitor c=0.0221996f \
 //x=35.185 //y=5.335 //x2=37.735 //y2=4.635
cc_1926 ( N_noxref_5_c_2025_p N_CLK_c_5004_n ) capacitor c=0.0300479f \
 //x=35.27 //y=5.25 //x2=37.735 //y2=4.635
cc_1927 ( N_noxref_5_c_2045_p N_CLK_c_5004_n ) capacitor c=0.0297339f \
 //x=32.732 //y=5.335 //x2=37.735 //y2=4.635
cc_1928 ( N_noxref_5_c_2189_p N_CLK_c_5004_n ) capacitor c=0.039888f //x=33.61 \
 //y=5.335 //x2=37.735 //y2=4.635
cc_1929 ( N_noxref_5_c_2030_p N_CLK_c_5004_n ) capacitor c=0.00404699f \
 //x=37.12 //y=4.88 //x2=37.735 //y2=4.635
cc_1930 ( N_noxref_5_c_2026_p N_CLK_c_5004_n ) capacitor c=0.0269932f \
 //x=37.122 //y=4.74 //x2=37.735 //y2=4.635
cc_1931 ( N_noxref_5_c_2152_p N_CLK_c_5004_n ) capacitor c=0.0021303f \
 //x=30.08 //y=3.51 //x2=37.735 //y2=4.635
cc_1932 ( N_noxref_5_c_2069_p N_CLK_c_5012_n ) capacitor c=5.39999e-19 \
 //x=29.72 //y=2.375 //x2=28.61 //y2=2.26
cc_1933 ( N_noxref_5_c_2070_p N_CLK_c_5012_n ) capacitor c=3.9149e-19 \
 //x=29.72 //y=3.35 //x2=28.61 //y2=2.26
cc_1934 ( N_noxref_5_c_2076_p N_CLK_c_5012_n ) capacitor c=0.00125213f \
 //x=29.72 //y=2.26 //x2=28.61 //y2=2.26
cc_1935 ( N_noxref_5_c_2077_p N_CLK_c_5012_n ) capacitor c=0.00204868f \
 //x=29.72 //y=2.26 //x2=28.61 //y2=2.26
cc_1936 ( N_noxref_5_c_2049_p N_CLK_c_5016_n ) capacitor c=4.56604e-19 \
 //x=29.72 //y=4.75 //x2=28.61 //y2=4.88
cc_1937 ( N_noxref_5_c_2051_p N_CLK_c_5016_n ) capacitor c=0.00113671f \
 //x=29.72 //y=4.88 //x2=28.61 //y2=4.88
cc_1938 ( N_noxref_5_c_2083_p N_CLK_c_5016_n ) capacitor c=0.00186974f \
 //x=29.72 //y=4.88 //x2=28.61 //y2=4.88
cc_1939 ( N_noxref_5_M90_noxref_g N_CLK_M88_noxref_g ) capacitor c=0.0101598f \
 //x=29.46 //y=6.2 //x2=28.58 //y2=6.2
cc_1940 ( N_noxref_5_M90_noxref_g N_CLK_M89_noxref_g ) capacitor c=0.0607518f \
 //x=29.46 //y=6.2 //x2=29.02 //y2=6.2
cc_1941 ( N_noxref_5_M91_noxref_g N_CLK_M89_noxref_g ) capacitor c=0.0101598f \
 //x=29.9 //y=6.2 //x2=29.02 //y2=6.2
cc_1942 ( N_noxref_5_c_2054_p N_CLK_c_5022_n ) capacitor c=0.00456962f \
 //x=29.71 //y=1.095 //x2=28.7 //y2=1.09
cc_1943 ( N_noxref_5_c_2055_p N_CLK_c_5023_n ) capacitor c=0.00438372f \
 //x=29.71 //y=1.44 //x2=28.7 //y2=1.4
cc_1944 ( N_noxref_5_c_2061_p N_CLK_c_5024_n ) capacitor c=0.00438372f \
 //x=29.71 //y=1.75 //x2=28.7 //y2=1.63
cc_1945 ( N_noxref_5_c_2069_p N_CLK_c_5025_n ) capacitor c=0.00137098f \
 //x=29.72 //y=2.375 //x2=28.7 //y2=2.095
cc_1946 ( N_noxref_5_c_2076_p N_CLK_c_5025_n ) capacitor c=0.00209664f \
 //x=29.72 //y=2.26 //x2=28.7 //y2=2.095
cc_1947 ( N_noxref_5_c_2077_p N_CLK_c_5025_n ) capacitor c=0.00933826f \
 //x=29.72 //y=2.26 //x2=28.7 //y2=2.095
cc_1948 ( N_noxref_5_c_2064_p N_CLK_c_5025_n ) capacitor c=0.00438372f \
 //x=29.72 //y=2.095 //x2=28.7 //y2=2.095
cc_1949 ( N_noxref_5_c_2083_p N_CLK_c_5029_n ) capacitor c=0.0616777f \
 //x=29.72 //y=4.88 //x2=28.945 //y2=4.97
cc_1950 ( N_noxref_5_c_2051_p N_CLK_c_5030_n ) capacitor c=9.77556e-19 \
 //x=29.72 //y=4.88 //x2=28.61 //y2=4.88
cc_1951 ( N_noxref_5_c_2083_p N_CLK_c_5030_n ) capacitor c=0.0042693f \
 //x=29.72 //y=4.88 //x2=28.61 //y2=4.88
cc_1952 ( N_noxref_5_c_2035_p N_RN_c_6506_n ) capacitor c=5.60322e-19 \
 //x=34.785 //y=1.305 //x2=34.53 //y2=2.465
cc_1953 ( N_noxref_5_c_2132_p N_RN_c_6506_n ) capacitor c=0.0170216f //x=35.27 \
 //y=3.35 //x2=34.53 //y2=2.465
cc_1954 ( N_noxref_5_c_2259_p N_RN_c_6506_n ) capacitor c=4.27678e-19 \
 //x=34.49 //y=5.335 //x2=34.53 //y2=2.465
cc_1955 ( N_noxref_5_c_2028_p N_RN_c_6509_n ) capacitor c=0.00228791f \
 //x=35.185 //y=5.335 //x2=34.53 //y2=4.75
cc_1956 ( N_noxref_5_c_2132_p N_RN_c_6509_n ) capacitor c=0.0346044f //x=35.27 \
 //y=3.35 //x2=34.53 //y2=4.75
cc_1957 ( N_noxref_5_c_2096_p N_RN_c_6509_n ) capacitor c=0.0144538f //x=35.27 \
 //y=3.67 //x2=34.53 //y2=4.75
cc_1958 ( N_noxref_5_c_2025_p N_RN_c_6509_n ) capacitor c=0.0564508f //x=35.27 \
 //y=5.25 //x2=34.53 //y2=4.75
cc_1959 ( N_noxref_5_c_2024_p N_RN_c_6509_n ) capacitor c=0.00117306f \
 //x=37.12 //y=3.35 //x2=34.53 //y2=4.75
cc_1960 ( N_noxref_5_c_2259_p N_RN_c_6509_n ) capacitor c=0.0223028f //x=34.49 \
 //y=5.335 //x2=34.53 //y2=4.75
cc_1961 ( N_noxref_5_c_2266_p N_RN_c_6509_n ) capacitor c=6.03895e-19 \
 //x=35.27 //y=3.51 //x2=34.53 //y2=4.75
cc_1962 ( N_noxref_5_c_2026_p N_RN_c_6509_n ) capacitor c=0.00123473f \
 //x=37.122 //y=4.74 //x2=34.53 //y2=4.75
cc_1963 ( N_noxref_5_c_2087_p N_RN_c_6509_n ) capacitor c=0.0249153f \
 //x=35.435 //y=3.51 //x2=34.53 //y2=4.75
cc_1964 ( N_noxref_5_c_2269_p N_RN_c_6509_n ) capacitor c=0.00266858f \
 //x=34.49 //y=5.56 //x2=34.53 //y2=4.75
cc_1965 ( N_noxref_5_c_2069_p N_RN_c_6386_n ) capacitor c=0.0157528f //x=29.72 \
 //y=2.375 //x2=33.205 //y2=2.37
cc_1966 ( N_noxref_5_c_2070_p N_RN_c_6386_n ) capacitor c=0.0129611f //x=29.72 \
 //y=3.35 //x2=33.205 //y2=2.37
cc_1967 ( N_noxref_5_c_2076_p N_RN_c_6386_n ) capacitor c=2.63835e-19 \
 //x=29.72 //y=2.26 //x2=33.205 //y2=2.37
cc_1968 ( N_noxref_5_c_2077_p N_RN_c_6386_n ) capacitor c=3.41298e-19 \
 //x=29.72 //y=2.26 //x2=33.205 //y2=2.37
cc_1969 ( N_noxref_5_c_2035_p N_RN_c_6523_n ) capacitor c=4.13793e-19 \
 //x=34.785 //y=1.305 //x2=34.695 //y2=2.4
cc_1970 ( N_noxref_5_c_2132_p N_RN_c_6523_n ) capacitor c=0.00372846f \
 //x=35.27 //y=3.35 //x2=34.695 //y2=2.4
cc_1971 ( N_noxref_5_c_2065_p N_RN_c_6525_n ) capacitor c=0.0215425f //x=34.87 \
 //y=1.845 //x2=42.515 //y2=2.315
cc_1972 ( N_noxref_5_c_2132_p N_RN_c_6525_n ) capacitor c=0.0275062f //x=35.27 \
 //y=3.35 //x2=42.515 //y2=2.315
cc_1973 ( N_noxref_5_c_2024_p N_RN_c_6525_n ) capacitor c=0.0126748f //x=37.12 \
 //y=3.35 //x2=42.515 //y2=2.315
cc_1974 ( N_noxref_5_c_2147_p N_RN_c_6525_n ) capacitor c=0.0177708f //x=37.12 \
 //y=2.26 //x2=42.515 //y2=2.315
cc_1975 ( N_noxref_5_c_2139_p N_RN_c_6525_n ) capacitor c=2.20453e-19 \
 //x=37.12 //y=2.26 //x2=42.515 //y2=2.315
cc_1976 ( N_noxref_5_c_2149_p N_RN_c_6525_n ) capacitor c=3.61358e-19 \
 //x=36.925 //y=2.095 //x2=42.515 //y2=2.315
cc_1977 ( N_noxref_5_c_2132_p N_RN_c_6531_n ) capacitor c=0.00115564f \
 //x=35.27 //y=3.35 //x2=34.53 //y2=2.26
cc_1978 ( N_noxref_5_c_2028_p N_RN_c_6532_n ) capacitor c=0.00130631f \
 //x=35.185 //y=5.335 //x2=34.53 //y2=4.88
cc_1979 ( N_noxref_5_c_2025_p N_RN_c_6532_n ) capacitor c=0.00131258f \
 //x=35.27 //y=5.25 //x2=34.53 //y2=4.88
cc_1980 ( N_noxref_5_c_2259_p N_RN_c_6532_n ) capacitor c=0.00346017f \
 //x=34.49 //y=5.335 //x2=34.53 //y2=4.88
cc_1981 ( N_noxref_5_c_2269_p N_RN_c_6532_n ) capacitor c=0.00624059f \
 //x=34.49 //y=5.56 //x2=34.53 //y2=4.88
cc_1982 ( N_noxref_5_c_2211_p N_RN_M96_noxref_g ) capacitor c=0.00955829f \
 //x=34.375 //y=5.335 //x2=34.27 //y2=6.2
cc_1983 ( N_noxref_5_c_2027_p N_RN_M96_noxref_g ) capacitor c=0.00226521f \
 //x=34.49 //y=5.56 //x2=34.27 //y2=6.2
cc_1984 ( N_noxref_5_c_2269_p N_RN_M96_noxref_g ) capacitor c=0.0178885f \
 //x=34.49 //y=5.56 //x2=34.27 //y2=6.2
cc_1985 ( N_noxref_5_c_2027_p N_RN_M97_noxref_g ) capacitor c=0.00368945f \
 //x=34.49 //y=5.56 //x2=34.71 //y2=6.2
cc_1986 ( N_noxref_5_c_2028_p N_RN_M97_noxref_g ) capacitor c=0.0108612f \
 //x=35.185 //y=5.335 //x2=34.71 //y2=6.2
cc_1987 ( N_noxref_5_c_2269_p N_RN_M97_noxref_g ) capacitor c=0.0188608f \
 //x=34.49 //y=5.56 //x2=34.71 //y2=6.2
cc_1988 ( N_noxref_5_c_2035_p N_RN_c_6542_n ) capacitor c=4.64015e-19 \
 //x=34.785 //y=1.305 //x2=34.52 //y2=1.095
cc_1989 ( N_noxref_5_M21_noxref_d N_RN_c_6542_n ) capacitor c=0.00137165f \
 //x=34.595 //y=1.095 //x2=34.52 //y2=1.095
cc_1990 ( N_noxref_5_c_2035_p N_RN_c_6544_n ) capacitor c=0.0026012f \
 //x=34.785 //y=1.305 //x2=34.52 //y2=1.44
cc_1991 ( N_noxref_5_c_2021_p N_RN_c_6544_n ) capacitor c=0.00127432f \
 //x=34.785 //y=1.76 //x2=34.52 //y2=1.44
cc_1992 ( N_noxref_5_M21_noxref_d N_RN_c_6544_n ) capacitor c=0.00237422f \
 //x=34.595 //y=1.095 //x2=34.52 //y2=1.44
cc_1993 ( N_noxref_5_c_2021_p N_RN_c_6547_n ) capacitor c=0.00441386f \
 //x=34.785 //y=1.76 //x2=34.52 //y2=1.75
cc_1994 ( N_noxref_5_c_2035_p N_RN_c_6548_n ) capacitor c=5.29969e-19 \
 //x=34.785 //y=1.305 //x2=34.895 //y2=0.94
cc_1995 ( N_noxref_5_M21_noxref_d N_RN_c_6548_n ) capacitor c=0.0020782f \
 //x=34.595 //y=1.095 //x2=34.895 //y2=0.94
cc_1996 ( N_noxref_5_c_2035_p N_RN_c_6550_n ) capacitor c=4.32061e-19 \
 //x=34.785 //y=1.305 //x2=34.895 //y2=1.595
cc_1997 ( N_noxref_5_c_2021_p N_RN_c_6550_n ) capacitor c=0.00930387f \
 //x=34.785 //y=1.76 //x2=34.895 //y2=1.595
cc_1998 ( N_noxref_5_c_2022_p N_RN_c_6550_n ) capacitor c=0.00194716f \
 //x=35.185 //y=1.845 //x2=34.895 //y2=1.595
cc_1999 ( N_noxref_5_M21_noxref_d N_RN_c_6550_n ) capacitor c=0.00356097f \
 //x=34.595 //y=1.095 //x2=34.895 //y2=1.595
cc_2000 ( N_noxref_5_c_2035_p N_RN_c_6554_n ) capacitor c=5.28622e-19 \
 //x=34.785 //y=1.305 //x2=35.05 //y2=1.095
cc_2001 ( N_noxref_5_M21_noxref_d N_RN_c_6554_n ) capacitor c=0.00139206f \
 //x=34.595 //y=1.095 //x2=35.05 //y2=1.095
cc_2002 ( N_noxref_5_c_2035_p N_RN_c_6556_n ) capacitor c=0.00312156f \
 //x=34.785 //y=1.305 //x2=35.05 //y2=1.44
cc_2003 ( N_noxref_5_c_2021_p N_RN_c_6556_n ) capacitor c=0.00347599f \
 //x=34.785 //y=1.76 //x2=35.05 //y2=1.44
cc_2004 ( N_noxref_5_c_2022_p N_RN_c_6556_n ) capacitor c=0.00323576f \
 //x=35.185 //y=1.845 //x2=35.05 //y2=1.44
cc_2005 ( N_noxref_5_M21_noxref_d N_RN_c_6556_n ) capacitor c=0.00237422f \
 //x=34.595 //y=1.095 //x2=35.05 //y2=1.44
cc_2006 ( N_noxref_5_c_2132_p N_RN_c_6560_n ) capacitor c=3.96703e-19 \
 //x=35.27 //y=3.35 //x2=34.53 //y2=2.26
cc_2007 ( N_noxref_5_c_2021_p N_RN_c_6561_n ) capacitor c=0.0036273f \
 //x=34.785 //y=1.76 //x2=34.53 //y2=2.095
cc_2008 ( N_noxref_5_c_2132_p N_RN_c_6561_n ) capacitor c=0.00282067f \
 //x=35.27 //y=3.35 //x2=34.53 //y2=2.095
cc_2009 ( N_noxref_5_c_2025_p N_RN_c_6563_n ) capacitor c=0.00739875f \
 //x=35.27 //y=5.25 //x2=34.53 //y2=4.88
cc_2010 ( N_noxref_5_c_2259_p N_RN_c_6563_n ) capacitor c=0.00203307f \
 //x=34.49 //y=5.335 //x2=34.53 //y2=4.88
cc_2011 ( N_noxref_5_c_2269_p N_RN_c_6563_n ) capacitor c=0.00375636f \
 //x=34.49 //y=5.56 //x2=34.53 //y2=4.88
cc_2012 ( N_noxref_5_c_2070_p N_noxref_16_c_10009_n ) capacitor c=0.0216243f \
 //x=29.72 //y=3.35 //x2=29.935 //y2=3.125
cc_2013 ( N_noxref_5_c_2043_p N_noxref_16_c_10009_n ) capacitor c=0.00580966f \
 //x=29.72 //y=3.67 //x2=29.935 //y2=3.125
cc_2014 ( N_noxref_5_c_2152_p N_noxref_16_c_10009_n ) capacitor c=0.0540452f \
 //x=30.08 //y=3.51 //x2=29.935 //y2=3.125
cc_2015 ( N_noxref_5_c_2074_p N_noxref_16_c_10009_n ) capacitor c=0.0358686f \
 //x=29.88 //y=3.51 //x2=29.935 //y2=3.125
cc_2016 ( N_noxref_5_c_2070_p N_noxref_16_c_9956_n ) capacitor c=3.78085e-19 \
 //x=29.72 //y=3.35 //x2=29.505 //y2=3.125
cc_2017 ( N_noxref_5_c_2132_p N_noxref_16_c_10014_n ) capacitor c=3.14871e-19 \
 //x=35.27 //y=3.35 //x2=34.89 //y2=3.14
cc_2018 ( N_noxref_5_c_2075_p N_noxref_16_c_10014_n ) capacitor c=0.139818f \
 //x=30.68 //y=3.5 //x2=34.89 //y2=3.14
cc_2019 ( N_noxref_5_c_2085_p N_noxref_16_c_10014_n ) capacitor c=0.056967f \
 //x=31.93 //y=3.51 //x2=34.89 //y2=3.14
cc_2020 ( N_noxref_5_c_2087_p N_noxref_16_c_10014_n ) capacitor c=0.214575f \
 //x=35.435 //y=3.51 //x2=34.89 //y2=3.14
cc_2021 ( N_noxref_5_c_2132_p N_noxref_16_c_10018_n ) capacitor c=0.0226523f \
 //x=35.27 //y=3.35 //x2=35.49 //y2=3.125
cc_2022 ( N_noxref_5_c_2096_p N_noxref_16_c_10018_n ) capacitor c=0.00872737f \
 //x=35.27 //y=3.67 //x2=35.49 //y2=3.125
cc_2023 ( N_noxref_5_c_2098_p N_noxref_16_c_10018_n ) capacitor c=0.127185f \
 //x=36.96 //y=3.51 //x2=35.49 //y2=3.125
cc_2024 ( N_noxref_5_c_2087_p N_noxref_16_c_10018_n ) capacitor c=0.0358686f \
 //x=35.435 //y=3.51 //x2=35.49 //y2=3.125
cc_2025 ( N_noxref_5_c_2024_p N_noxref_16_c_10022_n ) capacitor c=5.02752e-19 \
 //x=37.12 //y=3.35 //x2=36.735 //y2=3.14
cc_2026 ( N_noxref_5_c_2029_p N_noxref_16_c_10022_n ) capacitor c=0.00241791f \
 //x=37.12 //y=3.67 //x2=36.735 //y2=3.14
cc_2027 ( N_noxref_5_c_2098_p N_noxref_16_c_10022_n ) capacitor c=0.0107308f \
 //x=36.96 //y=3.51 //x2=36.735 //y2=3.14
cc_2028 ( N_noxref_5_c_2024_p N_noxref_16_c_10025_n ) capacitor c=0.0224661f \
 //x=37.12 //y=3.35 //x2=37.335 //y2=3.125
cc_2029 ( N_noxref_5_c_2029_p N_noxref_16_c_10025_n ) capacitor c=0.00481227f \
 //x=37.12 //y=3.67 //x2=37.335 //y2=3.125
cc_2030 ( N_noxref_5_c_2037_p N_noxref_16_c_10025_n ) capacitor c=0.0358686f \
 //x=37.12 //y=3.51 //x2=37.335 //y2=3.125
cc_2031 ( N_noxref_5_c_2118_p N_VDD_c_11464_n ) capacitor c=0.00621363f \
 //x=33.49 //y=5.335 //x2=78.895 //y2=7.585
cc_2032 ( N_noxref_5_c_2211_p N_VDD_c_11464_n ) capacitor c=0.00627192f \
 //x=34.375 //y=5.335 //x2=78.895 //y2=7.585
cc_2033 ( N_noxref_5_c_2027_p N_VDD_c_11464_n ) capacitor c=0.00256036f \
 //x=34.49 //y=5.56 //x2=78.895 //y2=7.585
cc_2034 ( N_noxref_5_c_2028_p N_VDD_c_11464_n ) capacitor c=0.00829251f \
 //x=35.185 //y=5.335 //x2=78.895 //y2=7.585
cc_2035 ( N_noxref_5_c_2096_p N_VDD_c_11464_n ) capacitor c=4.58912e-19 \
 //x=35.27 //y=3.67 //x2=78.895 //y2=7.585
cc_2036 ( N_noxref_5_c_2029_p N_VDD_c_11464_n ) capacitor c=2.00241e-19 \
 //x=37.12 //y=3.67 //x2=78.895 //y2=7.585
cc_2037 ( N_noxref_5_c_2045_p N_VDD_c_11464_n ) capacitor c=0.00261804f \
 //x=32.732 //y=5.335 //x2=78.895 //y2=7.585
cc_2038 ( N_noxref_5_c_2189_p N_VDD_c_11464_n ) capacitor c=0.00270108f \
 //x=33.61 //y=5.335 //x2=78.895 //y2=7.585
cc_2039 ( N_noxref_5_c_2030_p N_VDD_c_11464_n ) capacitor c=9.07241e-19 \
 //x=37.12 //y=4.88 //x2=78.895 //y2=7.585
cc_2040 ( N_noxref_5_c_2117_p N_VDD_c_11464_n ) capacitor c=0.0024232f \
 //x=32.73 //y=5.56 //x2=78.895 //y2=7.585
cc_2041 ( N_noxref_5_c_2190_p N_VDD_c_11464_n ) capacitor c=0.0024232f \
 //x=33.61 //y=5.56 //x2=78.895 //y2=7.585
cc_2042 ( N_noxref_5_c_2269_p N_VDD_c_11464_n ) capacitor c=0.0024232f \
 //x=34.49 //y=5.56 //x2=78.895 //y2=7.585
cc_2043 ( N_noxref_5_c_2031_p N_VDD_c_11464_n ) capacitor c=6.22888e-19 \
 //x=37.12 //y=4.88 //x2=78.895 //y2=7.585
cc_2044 ( N_noxref_5_M90_noxref_g N_VDD_c_11796_n ) capacitor c=0.00755544f \
 //x=29.46 //y=6.2 //x2=30.035 //y2=7.585
cc_2045 ( N_noxref_5_M91_noxref_g N_VDD_c_11796_n ) capacitor c=0.00755754f \
 //x=29.9 //y=6.2 //x2=30.035 //y2=7.585
cc_2046 ( N_noxref_5_c_2118_p N_VDD_c_11798_n ) capacitor c=0.00202922f \
 //x=33.49 //y=5.335 //x2=33.085 //y2=7.585
cc_2047 ( N_noxref_5_c_2045_p N_VDD_c_11798_n ) capacitor c=9.3757e-19 \
 //x=32.732 //y=5.335 //x2=33.085 //y2=7.585
cc_2048 ( N_noxref_5_c_2117_p N_VDD_c_11798_n ) capacitor c=0.0138074f \
 //x=32.73 //y=5.56 //x2=33.085 //y2=7.585
cc_2049 ( N_noxref_5_c_2118_p N_VDD_c_11801_n ) capacitor c=0.0017708f \
 //x=33.49 //y=5.335 //x2=33.965 //y2=7.585
cc_2050 ( N_noxref_5_c_2211_p N_VDD_c_11801_n ) capacitor c=0.00202922f \
 //x=34.375 //y=5.335 //x2=33.965 //y2=7.585
cc_2051 ( N_noxref_5_c_2189_p N_VDD_c_11801_n ) capacitor c=9.4822e-19 \
 //x=33.61 //y=5.335 //x2=33.965 //y2=7.585
cc_2052 ( N_noxref_5_c_2190_p N_VDD_c_11801_n ) capacitor c=0.0138074f \
 //x=33.61 //y=5.56 //x2=33.965 //y2=7.585
cc_2053 ( N_noxref_5_c_2211_p N_VDD_c_11805_n ) capacitor c=0.00205906f \
 //x=34.375 //y=5.335 //x2=34.845 //y2=7.585
cc_2054 ( N_noxref_5_c_2027_p N_VDD_c_11805_n ) capacitor c=8.49654e-19 \
 //x=34.49 //y=5.56 //x2=34.845 //y2=7.585
cc_2055 ( N_noxref_5_c_2028_p N_VDD_c_11805_n ) capacitor c=0.00204238f \
 //x=35.185 //y=5.335 //x2=34.845 //y2=7.585
cc_2056 ( N_noxref_5_c_2269_p N_VDD_c_11805_n ) capacitor c=0.0138074f \
 //x=34.49 //y=5.56 //x2=34.845 //y2=7.585
cc_2057 ( N_noxref_5_c_2028_p N_VDD_c_11809_n ) capacitor c=0.00183742f \
 //x=35.185 //y=5.335 //x2=35.84 //y2=7.585
cc_2058 ( N_noxref_5_c_2030_p N_VDD_c_11810_n ) capacitor c=6.28113e-19 \
 //x=37.12 //y=4.88 //x2=37.595 //y2=7.585
cc_2059 ( N_noxref_5_M98_noxref_g N_VDD_c_11810_n ) capacitor c=0.00732618f \
 //x=37.02 //y=6.2 //x2=37.595 //y2=7.585
cc_2060 ( N_noxref_5_M99_noxref_g N_VDD_c_11810_n ) capacitor c=0.00755544f \
 //x=37.46 //y=6.2 //x2=37.595 //y2=7.585
cc_2061 ( N_noxref_5_c_2045_p N_VDD_c_11813_n ) capacitor c=0.0022955f \
 //x=32.732 //y=5.335 //x2=31.2 //y2=7.585
cc_2062 ( N_noxref_5_c_2051_p N_VDD_c_11813_n ) capacitor c=0.00224736f \
 //x=29.72 //y=4.88 //x2=31.2 //y2=7.585
cc_2063 ( N_noxref_5_c_2117_p N_VDD_c_11813_n ) capacitor c=0.00509469f \
 //x=32.73 //y=5.56 //x2=31.2 //y2=7.585
cc_2064 ( N_noxref_5_c_2083_p N_VDD_c_11813_n ) capacitor c=2.63786e-19 \
 //x=29.72 //y=4.88 //x2=31.2 //y2=7.585
cc_2065 ( N_noxref_5_c_2027_p N_VDD_c_11817_n ) capacitor c=0.00269779f \
 //x=34.49 //y=5.56 //x2=36.01 //y2=7.585
cc_2066 ( N_noxref_5_c_2025_p N_VDD_c_11817_n ) capacitor c=0.0312736f \
 //x=35.27 //y=5.25 //x2=36.01 //y2=7.585
cc_2067 ( N_noxref_5_c_2030_p N_VDD_c_11817_n ) capacitor c=0.00447349f \
 //x=37.12 //y=4.88 //x2=36.01 //y2=7.585
cc_2068 ( N_noxref_5_c_2026_p N_VDD_c_11817_n ) capacitor c=0.00564116f \
 //x=37.122 //y=4.74 //x2=36.01 //y2=7.585
cc_2069 ( N_noxref_5_c_2269_p N_VDD_c_11817_n ) capacitor c=0.00776541f \
 //x=34.49 //y=5.56 //x2=36.01 //y2=7.585
cc_2070 ( N_noxref_5_c_2031_p N_VDD_c_11817_n ) capacitor c=0.00370494f \
 //x=37.12 //y=4.88 //x2=36.01 //y2=7.585
cc_2071 ( N_noxref_5_c_2034_p N_VDD_c_11817_n ) capacitor c=0.0129564f \
 //x=37.12 //y=4.88 //x2=36.01 //y2=7.585
cc_2072 ( N_noxref_5_M90_noxref_g N_VDD_M89_noxref_d ) capacitor c=0.015318f \
 //x=29.46 //y=6.2 //x2=29.095 //y2=5.2
cc_2073 ( N_noxref_5_M91_noxref_g N_VDD_M91_noxref_d ) capacitor c=0.0394719f \
 //x=29.9 //y=6.2 //x2=29.975 //y2=5.2
cc_2074 ( N_noxref_5_c_2045_p N_VDD_M92_noxref_s ) capacitor c=0.0441176f \
 //x=32.732 //y=5.335 //x2=32.155 //y2=5.2
cc_2075 ( N_noxref_5_c_2189_p N_VDD_M92_noxref_s ) capacitor c=7.80122e-19 \
 //x=33.61 //y=5.335 //x2=32.155 //y2=5.2
cc_2076 ( N_noxref_5_c_2117_p N_VDD_M92_noxref_s ) capacitor c=0.09305f \
 //x=32.73 //y=5.56 //x2=32.155 //y2=5.2
cc_2077 ( N_noxref_5_c_2118_p N_VDD_M93_noxref_d ) capacitor c=0.00700141f \
 //x=33.49 //y=5.335 //x2=33.025 //y2=5.2
cc_2078 ( N_noxref_5_c_2117_p N_VDD_M93_noxref_d ) capacitor c=0.0674491f \
 //x=32.73 //y=5.56 //x2=33.025 //y2=5.2
cc_2079 ( N_noxref_5_c_2190_p N_VDD_M93_noxref_d ) capacitor c=0.0674762f \
 //x=33.61 //y=5.56 //x2=33.025 //y2=5.2
cc_2080 ( N_noxref_5_c_2211_p N_VDD_M95_noxref_d ) capacitor c=0.00700141f \
 //x=34.375 //y=5.335 //x2=33.905 //y2=5.2
cc_2081 ( N_noxref_5_c_2190_p N_VDD_M95_noxref_d ) capacitor c=0.067493f \
 //x=33.61 //y=5.56 //x2=33.905 //y2=5.2
cc_2082 ( N_noxref_5_c_2269_p N_VDD_M95_noxref_d ) capacitor c=0.0674288f \
 //x=34.49 //y=5.56 //x2=33.905 //y2=5.2
cc_2083 ( N_noxref_5_c_2028_p N_VDD_M97_noxref_d ) capacitor c=0.00700141f \
 //x=35.185 //y=5.335 //x2=34.785 //y2=5.2
cc_2084 ( N_noxref_5_c_2269_p N_VDD_M97_noxref_d ) capacitor c=0.0673824f \
 //x=34.49 //y=5.56 //x2=34.785 //y2=5.2
cc_2085 ( N_noxref_5_c_2027_p N_VDD_M98_noxref_s ) capacitor c=0.00536022f \
 //x=34.49 //y=5.56 //x2=36.665 //y2=5.2
cc_2086 ( N_noxref_5_c_2028_p N_VDD_M98_noxref_s ) capacitor c=0.00211796f \
 //x=35.185 //y=5.335 //x2=36.665 //y2=5.2
cc_2087 ( N_noxref_5_c_2029_p N_VDD_M98_noxref_s ) capacitor c=0.00111275f \
 //x=37.12 //y=3.67 //x2=36.665 //y2=5.2
cc_2088 ( N_noxref_5_M98_noxref_g N_VDD_M98_noxref_s ) capacitor c=0.0567929f \
 //x=37.02 //y=6.2 //x2=36.665 //y2=5.2
cc_2089 ( N_noxref_5_M99_noxref_g N_VDD_M99_noxref_d ) capacitor c=0.015318f \
 //x=37.46 //y=6.2 //x2=37.535 //y2=5.2
cc_2090 ( N_noxref_5_c_2069_p N_noxref_24_c_13128_n ) capacitor c=0.00177186f \
 //x=29.72 //y=2.375 //x2=30.375 //y2=0.72
cc_2091 ( N_noxref_5_c_2076_p N_noxref_24_c_13128_n ) capacitor c=0.00117306f \
 //x=29.72 //y=2.26 //x2=30.375 //y2=0.72
cc_2092 ( N_noxref_5_c_2054_p N_noxref_24_c_13128_n ) capacitor c=0.0206349f \
 //x=29.71 //y=1.095 //x2=30.375 //y2=0.72
cc_2093 ( N_noxref_5_c_2058_p N_noxref_24_c_13128_n ) capacitor c=0.00825432f \
 //x=30.24 //y=1.095 //x2=30.375 //y2=0.72
cc_2094 ( N_noxref_5_c_2077_p N_noxref_24_c_13128_n ) capacitor c=2.20712e-19 \
 //x=29.72 //y=2.26 //x2=30.375 //y2=0.72
cc_2095 ( N_noxref_5_c_2055_p N_noxref_24_c_13133_n ) capacitor c=0.0071177f \
 //x=29.71 //y=1.44 //x2=29.49 //y2=1.175
cc_2096 ( N_noxref_5_c_2054_p N_noxref_24_M18_noxref_s ) capacitor \
 c=0.0071177f //x=29.71 //y=1.095 //x2=29.355 //y2=0.555
cc_2097 ( N_noxref_5_c_2061_p N_noxref_24_M18_noxref_s ) capacitor \
 c=0.0071177f //x=29.71 //y=1.75 //x2=29.355 //y2=0.555
cc_2098 ( N_noxref_5_c_2058_p N_noxref_24_M18_noxref_s ) capacitor c=0.015333f \
 //x=30.24 //y=1.095 //x2=29.355 //y2=0.555
cc_2099 ( N_noxref_5_c_2059_p N_noxref_24_M18_noxref_s ) capacitor \
 c=0.00248746f //x=30.24 //y=1.44 //x2=29.355 //y2=0.555
cc_2100 ( N_noxref_5_c_2035_p N_noxref_25_c_13195_n ) capacitor c=0.0036878f \
 //x=34.785 //y=1.305 //x2=35.185 //y2=0.72
cc_2101 ( N_noxref_5_c_2022_p N_noxref_25_c_13195_n ) capacitor c=0.00399931f \
 //x=35.185 //y=1.845 //x2=35.185 //y2=0.72
cc_2102 ( N_noxref_5_M21_noxref_d N_noxref_25_c_13195_n ) capacitor \
 c=0.00910163f //x=34.595 //y=1.095 //x2=35.185 //y2=0.72
cc_2103 ( N_noxref_5_M21_noxref_d N_noxref_25_c_13198_n ) capacitor \
 c=0.00120711f //x=34.595 //y=1.095 //x2=34.3 //y2=1.175
cc_2104 ( N_noxref_5_c_2118_p N_noxref_25_M20_noxref_d ) capacitor \
 c=0.0013203f //x=33.49 //y=5.335 //x2=33.06 //y2=1.09
cc_2105 ( N_noxref_5_c_2035_p N_noxref_25_M20_noxref_d ) capacitor \
 c=0.00802836f //x=34.785 //y=1.305 //x2=33.06 //y2=1.09
cc_2106 ( N_noxref_5_c_2035_p N_noxref_25_M21_noxref_s ) capacitor \
 c=0.00993092f //x=34.785 //y=1.305 //x2=34.165 //y2=0.555
cc_2107 ( N_noxref_5_c_2021_p N_noxref_25_M21_noxref_s ) capacitor \
 c=0.0270624f //x=34.785 //y=1.76 //x2=34.165 //y2=0.555
cc_2108 ( N_noxref_5_c_2022_p N_noxref_25_M21_noxref_s ) capacitor \
 c=0.00871957f //x=35.185 //y=1.845 //x2=34.165 //y2=0.555
cc_2109 ( N_noxref_5_c_2266_p N_noxref_25_M21_noxref_s ) capacitor \
 c=0.0016218f //x=35.27 //y=3.51 //x2=34.165 //y2=0.555
cc_2110 ( N_noxref_5_M21_noxref_d N_noxref_25_M21_noxref_s ) capacitor \
 c=0.0279003f //x=34.595 //y=1.095 //x2=34.165 //y2=0.555
cc_2111 ( N_noxref_5_c_2069_p N_GND_c_14171_n ) capacitor c=0.00196498f \
 //x=29.72 //y=2.375 //x2=32.19 //y2=0.175
cc_2112 ( N_noxref_5_c_2035_p N_GND_c_14172_n ) capacitor c=0.00883621f \
 //x=34.785 //y=1.305 //x2=37.105 //y2=0.175
cc_2113 ( N_noxref_5_c_2022_p N_GND_c_14172_n ) capacitor c=0.00662992f \
 //x=35.185 //y=1.845 //x2=37.105 //y2=0.175
cc_2114 ( N_noxref_5_c_2096_p N_GND_c_14172_n ) capacitor c=2.94824e-19 \
 //x=35.27 //y=3.67 //x2=37.105 //y2=0.175
cc_2115 ( N_noxref_5_M21_noxref_d N_GND_c_14172_n ) capacitor c=2.9462e-19 \
 //x=34.595 //y=1.095 //x2=37.105 //y2=0.175
cc_2116 ( N_noxref_5_c_2035_p N_GND_c_14176_n ) capacitor c=0.00488628f \
 //x=34.785 //y=1.305 //x2=37.19 //y2=1.135
cc_2117 ( N_noxref_5_c_2147_p N_GND_c_14176_n ) capacitor c=0.00645051f \
 //x=37.12 //y=2.26 //x2=37.19 //y2=1.135
cc_2118 ( N_noxref_5_c_2139_p N_GND_c_14176_n ) capacitor c=2.13705e-19 \
 //x=37.12 //y=2.26 //x2=37.19 //y2=1.135
cc_2119 ( N_noxref_5_c_2171_p N_GND_c_14176_n ) capacitor c=0.00176535f \
 //x=36.925 //y=1.045 //x2=37.19 //y2=1.135
cc_2120 ( N_noxref_5_c_2172_p N_GND_c_14176_n ) capacitor c=0.0036005f \
 //x=36.925 //y=1.39 //x2=37.19 //y2=1.135
cc_2121 ( N_noxref_5_c_2174_p N_GND_c_14176_n ) capacitor c=4.2764e-19 \
 //x=36.925 //y=1.7 //x2=37.19 //y2=1.135
cc_2122 ( N_noxref_5_c_2427_p N_GND_c_14176_n ) capacitor c=9.36995e-19 \
 //x=37.3 //y=0.89 //x2=37.19 //y2=1.135
cc_2123 ( N_noxref_5_c_2428_p N_GND_c_14176_n ) capacitor c=6.27472e-19 \
 //x=37.3 //y=1.545 //x2=37.19 //y2=1.135
cc_2124 ( N_noxref_5_c_2173_p N_GND_c_14176_n ) capacitor c=0.00171483f \
 //x=37.455 //y=1.045 //x2=37.19 //y2=1.135
cc_2125 ( N_noxref_5_c_2175_p N_GND_c_14176_n ) capacitor c=0.00296337f \
 //x=37.455 //y=1.39 //x2=37.19 //y2=1.135
cc_2126 ( N_noxref_5_c_2171_p N_GND_c_14186_n ) capacitor c=3.51399e-19 \
 //x=36.925 //y=1.045 //x2=37.187 //y2=1.005
cc_2127 ( N_noxref_5_c_2427_p N_GND_c_14186_n ) capacitor c=0.00850983f \
 //x=37.3 //y=0.89 //x2=37.187 //y2=1.005
cc_2128 ( N_noxref_5_c_2173_p N_GND_c_14186_n ) capacitor c=4.40196e-19 \
 //x=37.455 //y=1.045 //x2=37.187 //y2=1.005
cc_2129 ( N_noxref_5_c_2069_p N_GND_c_14189_n ) capacitor c=2.016e-19 \
 //x=29.72 //y=2.375 //x2=31.03 //y2=0.175
cc_2130 ( N_noxref_5_c_2022_p N_GND_c_14190_n ) capacitor c=6.86343e-19 \
 //x=35.185 //y=1.845 //x2=35.84 //y2=0.175
cc_2131 ( N_noxref_5_c_2096_p N_GND_c_14190_n ) capacitor c=4.02711e-19 \
 //x=35.27 //y=3.67 //x2=35.84 //y2=0.175
cc_2132 ( N_noxref_5_c_2171_p N_GND_c_14192_n ) capacitor c=0.00688027f \
 //x=36.925 //y=1.045 //x2=39.17 //y2=0.175
cc_2133 ( N_noxref_5_c_2076_p N_GND_c_14193_n ) capacitor c=0.00222376f \
 //x=29.72 //y=2.26 //x2=31.2 //y2=0.175
cc_2134 ( N_noxref_5_c_2059_p N_GND_c_14193_n ) capacitor c=0.00262688f \
 //x=30.24 //y=1.44 //x2=31.2 //y2=0.175
cc_2135 ( N_noxref_5_c_2077_p N_GND_c_14193_n ) capacitor c=2.63786e-19 \
 //x=29.72 //y=2.26 //x2=31.2 //y2=0.175
cc_2136 ( N_noxref_5_c_2021_p N_GND_c_14196_n ) capacitor c=0.00285697f \
 //x=34.785 //y=1.76 //x2=36.01 //y2=0.175
cc_2137 ( N_noxref_5_c_2022_p N_GND_c_14196_n ) capacitor c=0.0288813f \
 //x=35.185 //y=1.845 //x2=36.01 //y2=0.175
cc_2138 ( N_noxref_5_c_2024_p N_GND_c_14196_n ) capacitor c=0.00670922f \
 //x=37.12 //y=3.35 //x2=36.01 //y2=0.175
cc_2139 ( N_noxref_5_c_2147_p N_GND_c_14196_n ) capacitor c=0.00386815f \
 //x=37.12 //y=2.26 //x2=36.01 //y2=0.175
cc_2140 ( N_noxref_5_c_2139_p N_GND_c_14196_n ) capacitor c=0.00354425f \
 //x=37.12 //y=2.26 //x2=36.01 //y2=0.175
cc_2141 ( N_noxref_5_c_2174_p N_GND_c_14196_n ) capacitor c=0.0015404f \
 //x=36.925 //y=1.7 //x2=36.01 //y2=0.175
cc_2142 ( N_noxref_5_c_2149_p N_GND_c_14196_n ) capacitor c=0.0093907f \
 //x=36.925 //y=2.095 //x2=36.01 //y2=0.175
cc_2143 ( N_noxref_5_c_2147_p N_GND_M22_noxref_d ) capacitor c=2.20438e-19 \
 //x=37.12 //y=2.26 //x2=37 //y2=1.045
cc_2144 ( N_noxref_5_c_2171_p N_GND_M22_noxref_d ) capacitor c=0.00192399f \
 //x=36.925 //y=1.045 //x2=37 //y2=1.045
cc_2145 ( N_noxref_5_c_2172_p N_GND_M22_noxref_d ) capacitor c=0.00210798f \
 //x=36.925 //y=1.39 //x2=37 //y2=1.045
cc_2146 ( N_noxref_5_c_2427_p N_GND_M22_noxref_d ) capacitor c=0.00472259f \
 //x=37.3 //y=0.89 //x2=37 //y2=1.045
cc_2147 ( N_noxref_5_c_2428_p N_GND_M22_noxref_d ) capacitor c=0.00166857f \
 //x=37.3 //y=1.545 //x2=37 //y2=1.045
cc_2148 ( N_noxref_5_c_2173_p N_GND_M22_noxref_d ) capacitor c=0.00230174f \
 //x=37.455 //y=1.045 //x2=37 //y2=1.045
cc_2149 ( N_noxref_5_c_2175_p N_GND_M22_noxref_d ) capacitor c=0.00210798f \
 //x=37.455 //y=1.39 //x2=37 //y2=1.045
cc_2150 ( N_noxref_5_c_2149_p N_noxref_43_c_16017_n ) capacitor c=0.00262672f \
 //x=36.925 //y=2.095 //x2=36.705 //y2=1.675
cc_2151 ( N_noxref_5_c_2029_p N_noxref_43_c_16018_n ) capacitor c=0.00406558f \
 //x=37.12 //y=3.67 //x2=37.59 //y2=1.76
cc_2152 ( N_noxref_5_c_2147_p N_noxref_43_c_16018_n ) capacitor c=0.00509504f \
 //x=37.12 //y=2.26 //x2=37.59 //y2=1.76
cc_2153 ( N_noxref_5_c_2139_p N_noxref_43_c_16018_n ) capacitor c=0.00763108f \
 //x=37.12 //y=2.26 //x2=37.59 //y2=1.76
cc_2154 ( N_noxref_5_c_2174_p N_noxref_43_c_16018_n ) capacitor c=0.00697076f \
 //x=36.925 //y=1.7 //x2=37.59 //y2=1.76
cc_2155 ( N_noxref_5_c_2149_p N_noxref_43_c_16018_n ) capacitor c=0.0170561f \
 //x=36.925 //y=2.095 //x2=37.59 //y2=1.76
cc_2156 ( N_noxref_5_c_2428_p N_noxref_43_c_16018_n ) capacitor c=0.00723574f \
 //x=37.3 //y=1.545 //x2=37.59 //y2=1.76
cc_2157 ( N_noxref_5_c_2175_p N_noxref_43_c_16018_n ) capacitor c=0.00339872f \
 //x=37.455 //y=1.39 //x2=37.59 //y2=1.76
cc_2158 ( N_noxref_5_c_2149_p N_noxref_43_c_16025_n ) capacitor c=6.71402e-19 \
 //x=36.925 //y=2.095 //x2=37.675 //y2=1.675
cc_2159 ( N_noxref_5_c_2171_p N_noxref_43_M22_noxref_s ) capacitor \
 c=0.0295366f //x=36.925 //y=1.045 //x2=36.57 //y2=0.545
cc_2160 ( N_noxref_5_c_2174_p N_noxref_43_M22_noxref_s ) capacitor \
 c=3.48408e-19 //x=36.925 //y=1.7 //x2=36.57 //y2=0.545
cc_2161 ( N_noxref_5_c_2173_p N_noxref_43_M22_noxref_s ) capacitor \
 c=0.0125442f //x=37.455 //y=1.045 //x2=36.57 //y2=0.545
cc_2162 ( N_noxref_6_c_2490_p N_noxref_7_c_2835_n ) capacitor c=0.0013819f \
 //x=38.6 //y=3.675 //x2=38.08 //y2=3.865
cc_2163 ( N_noxref_6_c_2472_n N_noxref_7_c_2835_n ) capacitor c=0.00113794f \
 //x=38.6 //y=5.295 //x2=38.08 //y2=3.865
cc_2164 ( N_noxref_6_c_2484_n N_noxref_7_c_2835_n ) capacitor c=0.0358254f \
 //x=38.76 //y=3.515 //x2=38.08 //y2=3.865
cc_2165 ( N_noxref_6_c_2490_p N_noxref_7_c_2838_n ) capacitor c=0.00694169f \
 //x=38.6 //y=3.675 //x2=38.815 //y2=3.9
cc_2166 ( N_noxref_6_c_2472_n N_noxref_7_c_2838_n ) capacitor c=0.022395f \
 //x=38.6 //y=5.295 //x2=38.815 //y2=3.9
cc_2167 ( N_noxref_6_c_2495_p N_noxref_7_c_2838_n ) capacitor c=0.128042f \
 //x=40.295 //y=3.515 //x2=38.815 //y2=3.9
cc_2168 ( N_noxref_6_c_2496_p N_noxref_7_c_2841_n ) capacitor c=0.00342064f \
 //x=40.45 //y=3.675 //x2=40.07 //y2=3.88
cc_2169 ( N_noxref_6_c_2497_p N_noxref_7_c_2841_n ) capacitor c=6.75872e-19 \
 //x=40.45 //y=4.755 //x2=40.07 //y2=3.88
cc_2170 ( N_noxref_6_c_2498_p N_noxref_7_c_2841_n ) capacitor c=0.0358254f \
 //x=40.455 //y=3.515 //x2=40.07 //y2=3.88
cc_2171 ( N_noxref_6_c_2495_p N_noxref_7_c_2841_n ) capacitor c=0.0106805f \
 //x=40.295 //y=3.515 //x2=40.07 //y2=3.88
cc_2172 ( N_noxref_6_c_2496_p N_noxref_7_c_2845_n ) capacitor c=0.00292429f \
 //x=40.45 //y=3.675 //x2=40.67 //y2=3.9
cc_2173 ( N_noxref_6_c_2497_p N_noxref_7_c_2845_n ) capacitor c=0.023831f \
 //x=40.45 //y=4.755 //x2=40.67 //y2=3.9
cc_2174 ( N_noxref_6_c_2470_n N_noxref_9_c_3538_n ) capacitor c=0.0370052f \
 //x=38.6 //y=3.355 //x2=37.86 //y2=4.09
cc_2175 ( N_noxref_6_c_2490_p N_noxref_9_c_3538_n ) capacitor c=0.0148501f \
 //x=38.6 //y=3.675 //x2=37.86 //y2=4.09
cc_2176 ( N_noxref_6_c_2472_n N_noxref_9_c_3538_n ) capacitor c=0.0164753f \
 //x=38.6 //y=5.295 //x2=37.86 //y2=4.09
cc_2177 ( N_noxref_6_c_2505_p N_noxref_9_c_3538_n ) capacitor c=0.00117474f \
 //x=40.45 //y=3.355 //x2=37.86 //y2=4.09
cc_2178 ( N_noxref_6_c_2497_p N_noxref_9_c_3538_n ) capacitor c=3.22894e-19 \
 //x=40.45 //y=4.755 //x2=37.86 //y2=4.09
cc_2179 ( N_noxref_6_c_2483_n N_noxref_9_c_3538_n ) capacitor c=5.57251e-19 \
 //x=38.6 //y=3.51 //x2=37.86 //y2=4.09
cc_2180 ( N_noxref_6_c_2484_n N_noxref_9_c_3538_n ) capacitor c=0.00365657f \
 //x=38.76 //y=3.515 //x2=37.86 //y2=4.09
cc_2181 ( N_noxref_6_c_2467_n N_noxref_9_c_3546_n ) capacitor c=0.00424065f \
 //x=38.005 //y=5.38 //x2=37.86 //y2=4.41
cc_2182 ( N_noxref_6_c_2472_n N_noxref_9_c_3546_n ) capacitor c=0.0147977f \
 //x=38.6 //y=5.295 //x2=37.86 //y2=4.41
cc_2183 ( N_noxref_6_c_2467_n N_noxref_9_c_3547_n ) capacitor c=0.0215376f \
 //x=38.005 //y=5.38 //x2=37.86 //y2=4.735
cc_2184 ( N_noxref_6_c_2472_n N_noxref_9_c_3547_n ) capacitor c=0.0284267f \
 //x=38.6 //y=5.295 //x2=37.86 //y2=4.735
cc_2185 ( N_noxref_6_c_2497_p N_noxref_9_c_3547_n ) capacitor c=4.6204e-19 \
 //x=40.45 //y=4.755 //x2=37.86 //y2=4.735
cc_2186 ( N_noxref_6_M103_noxref_g N_noxref_9_c_3605_n ) capacitor \
 c=0.00893512f //x=41.09 //y=6.2 //x2=41.63 //y2=5.335
cc_2187 ( N_noxref_6_c_2515_p N_noxref_9_c_3606_n ) capacitor c=8.29536e-19 \
 //x=38.515 //y=1.835 //x2=42.925 //y2=1.76
cc_2188 ( N_noxref_6_c_2470_n N_noxref_9_c_3607_n ) capacitor c=8.29536e-19 \
 //x=38.6 //y=3.355 //x2=43.01 //y2=1.845
cc_2189 ( N_noxref_6_c_2472_n N_noxref_9_c_3552_n ) capacitor c=6.15063e-19 \
 //x=38.6 //y=5.295 //x2=37.86 //y2=4.25
cc_2190 ( N_noxref_6_c_2470_n N_noxref_9_c_3553_n ) capacitor c=0.0138368f \
 //x=38.6 //y=3.355 //x2=37.86 //y2=2.26
cc_2191 ( N_noxref_6_c_2472_n N_noxref_9_c_3610_n ) capacitor c=0.00261914f \
 //x=38.6 //y=5.295 //x2=40.872 //y2=5.335
cc_2192 ( N_noxref_6_c_2520_p N_noxref_9_c_3610_n ) capacitor c=5.0812e-19 \
 //x=38.12 //y=5.38 //x2=40.872 //y2=5.335
cc_2193 ( N_noxref_6_M102_noxref_g N_noxref_9_c_3610_n ) capacitor \
 c=0.00461408f //x=40.65 //y=6.2 //x2=40.872 //y2=5.335
cc_2194 ( N_noxref_6_M103_noxref_g N_noxref_9_c_3610_n ) capacitor \
 c=0.00229208f //x=41.09 //y=6.2 //x2=40.872 //y2=5.335
cc_2195 ( N_noxref_6_c_2523_p N_noxref_9_c_3610_n ) capacitor c=0.00171885f \
 //x=41.015 //y=4.97 //x2=40.872 //y2=5.335
cc_2196 ( N_noxref_6_c_2472_n N_noxref_9_c_3615_n ) capacitor c=0.022727f \
 //x=38.6 //y=5.295 //x2=43.255 //y2=4.25
cc_2197 ( N_noxref_6_c_2497_p N_noxref_9_c_3615_n ) capacitor c=0.0246035f \
 //x=40.45 //y=4.755 //x2=43.255 //y2=4.25
cc_2198 ( N_noxref_6_c_2495_p N_noxref_9_c_3615_n ) capacitor c=0.0103367f \
 //x=40.295 //y=3.515 //x2=43.255 //y2=4.25
cc_2199 ( N_noxref_6_c_2472_n N_noxref_9_c_3563_n ) capacitor c=0.00328982f \
 //x=38.6 //y=5.295 //x2=38.025 //y2=4.25
cc_2200 ( N_noxref_6_c_2470_n N_noxref_9_c_3567_n ) capacitor c=9.26054e-19 \
 //x=38.6 //y=3.355 //x2=37.86 //y2=2.26
cc_2201 ( N_noxref_6_c_2467_n N_noxref_9_c_3571_n ) capacitor c=0.00469257f \
 //x=38.005 //y=5.38 //x2=37.89 //y2=4.88
cc_2202 ( N_noxref_6_c_2472_n N_noxref_9_c_3571_n ) capacitor c=7.76118e-19 \
 //x=38.6 //y=5.295 //x2=37.89 //y2=4.88
cc_2203 ( N_noxref_6_M102_noxref_g N_noxref_9_c_3622_n ) capacitor \
 c=0.0162284f //x=40.65 //y=6.2 //x2=40.87 //y2=5.56
cc_2204 ( N_noxref_6_M103_noxref_g N_noxref_9_c_3622_n ) capacitor \
 c=0.0179041f //x=41.09 //y=6.2 //x2=40.87 //y2=5.56
cc_2205 ( N_noxref_6_c_2523_p N_noxref_9_c_3622_n ) capacitor c=0.00291477f \
 //x=41.015 //y=4.97 //x2=40.87 //y2=5.56
cc_2206 ( N_noxref_6_c_2467_n N_noxref_9_M100_noxref_g ) capacitor \
 c=0.00842859f //x=38.005 //y=5.38 //x2=37.9 //y2=6.2
cc_2207 ( N_noxref_6_c_2520_p N_noxref_9_M100_noxref_g ) capacitor \
 c=0.00192712f //x=38.12 //y=5.38 //x2=37.9 //y2=6.2
cc_2208 ( N_noxref_6_c_2536_p N_noxref_9_M100_noxref_g ) capacitor \
 c=0.0178987f //x=38.12 //y=5.56 //x2=37.9 //y2=6.2
cc_2209 ( N_noxref_6_c_2537_p N_noxref_9_M101_noxref_g ) capacitor \
 c=0.0106088f //x=38.515 //y=5.38 //x2=38.34 //y2=6.2
cc_2210 ( N_noxref_6_c_2520_p N_noxref_9_M101_noxref_g ) capacitor \
 c=0.00312463f //x=38.12 //y=5.38 //x2=38.34 //y2=6.2
cc_2211 ( N_noxref_6_c_2536_p N_noxref_9_M101_noxref_g ) capacitor \
 c=0.0178506f //x=38.12 //y=5.56 //x2=38.34 //y2=6.2
cc_2212 ( N_noxref_6_c_2482_n N_noxref_9_c_3577_n ) capacitor c=0.00120406f \
 //x=38.16 //y=1.18 //x2=37.895 //y2=1.085
cc_2213 ( N_noxref_6_M23_noxref_d N_noxref_9_c_3577_n ) capacitor \
 c=0.00137165f //x=37.97 //y=1.085 //x2=37.895 //y2=1.085
cc_2214 ( N_noxref_6_c_2468_n N_noxref_9_c_3580_n ) capacitor c=0.00119302f \
 //x=38.16 //y=1.75 //x2=37.895 //y2=1.43
cc_2215 ( N_noxref_6_c_2482_n N_noxref_9_c_3580_n ) capacitor c=0.00218772f \
 //x=38.16 //y=1.18 //x2=37.895 //y2=1.43
cc_2216 ( N_noxref_6_M23_noxref_d N_noxref_9_c_3580_n ) capacitor \
 c=0.00237422f //x=37.97 //y=1.085 //x2=37.895 //y2=1.43
cc_2217 ( N_noxref_6_c_2468_n N_noxref_9_c_3582_n ) capacitor c=0.00439215f \
 //x=38.16 //y=1.75 //x2=37.895 //y2=1.74
cc_2218 ( N_noxref_6_c_2472_n N_noxref_9_c_3637_n ) capacitor c=0.00845606f \
 //x=38.6 //y=5.295 //x2=38.265 //y2=4.97
cc_2219 ( N_noxref_6_c_2520_p N_noxref_9_c_3637_n ) capacitor c=0.0020909f \
 //x=38.12 //y=5.38 //x2=38.265 //y2=4.97
cc_2220 ( N_noxref_6_c_2536_p N_noxref_9_c_3637_n ) capacitor c=0.00291714f \
 //x=38.12 //y=5.56 //x2=38.265 //y2=4.97
cc_2221 ( N_noxref_6_c_2482_n N_noxref_9_c_3640_n ) capacitor c=5.50523e-19 \
 //x=38.16 //y=1.18 //x2=38.27 //y2=0.93
cc_2222 ( N_noxref_6_M23_noxref_d N_noxref_9_c_3640_n ) capacitor c=0.0020782f \
 //x=37.97 //y=1.085 //x2=38.27 //y2=0.93
cc_2223 ( N_noxref_6_c_2468_n N_noxref_9_c_3642_n ) capacitor c=0.00929773f \
 //x=38.16 //y=1.75 //x2=38.27 //y2=1.585
cc_2224 ( N_noxref_6_c_2515_p N_noxref_9_c_3642_n ) capacitor c=0.00194324f \
 //x=38.515 //y=1.835 //x2=38.27 //y2=1.585
cc_2225 ( N_noxref_6_c_2482_n N_noxref_9_c_3642_n ) capacitor c=5.67071e-19 \
 //x=38.16 //y=1.18 //x2=38.27 //y2=1.585
cc_2226 ( N_noxref_6_M23_noxref_d N_noxref_9_c_3642_n ) capacitor \
 c=0.00356097f //x=37.97 //y=1.085 //x2=38.27 //y2=1.585
cc_2227 ( N_noxref_6_c_2482_n N_noxref_9_c_3585_n ) capacitor c=0.00108157f \
 //x=38.16 //y=1.18 //x2=38.425 //y2=1.085
cc_2228 ( N_noxref_6_M23_noxref_d N_noxref_9_c_3585_n ) capacitor \
 c=8.50095e-19 //x=37.97 //y=1.085 //x2=38.425 //y2=1.085
cc_2229 ( N_noxref_6_c_2468_n N_noxref_9_c_3586_n ) capacitor c=0.00341295f \
 //x=38.16 //y=1.75 //x2=38.425 //y2=1.43
cc_2230 ( N_noxref_6_c_2515_p N_noxref_9_c_3586_n ) capacitor c=0.00323005f \
 //x=38.515 //y=1.835 //x2=38.425 //y2=1.43
cc_2231 ( N_noxref_6_c_2482_n N_noxref_9_c_3586_n ) capacitor c=0.00312028f \
 //x=38.16 //y=1.18 //x2=38.425 //y2=1.43
cc_2232 ( N_noxref_6_M23_noxref_d N_noxref_9_c_3586_n ) capacitor \
 c=0.00237422f //x=37.97 //y=1.085 //x2=38.425 //y2=1.43
cc_2233 ( N_noxref_6_c_2470_n N_noxref_9_c_3587_n ) capacitor c=0.00268898f \
 //x=38.6 //y=3.355 //x2=37.86 //y2=2.26
cc_2234 ( N_noxref_6_c_2468_n N_noxref_9_c_3653_n ) capacitor c=0.00341688f \
 //x=38.16 //y=1.75 //x2=37.86 //y2=2.095
cc_2235 ( N_noxref_6_c_2470_n N_noxref_9_c_3653_n ) capacitor c=0.00309058f \
 //x=38.6 //y=3.355 //x2=37.86 //y2=2.095
cc_2236 ( N_noxref_6_c_2467_n N_noxref_9_c_3590_n ) capacitor c=8.42507e-19 \
 //x=38.005 //y=5.38 //x2=37.89 //y2=4.88
cc_2237 ( N_noxref_6_c_2472_n N_noxref_9_c_3590_n ) capacitor c=0.00142201f \
 //x=38.6 //y=5.295 //x2=37.89 //y2=4.88
cc_2238 ( N_noxref_6_c_2470_n N_D_c_4303_n ) capacitor c=0.0232638f //x=38.6 \
 //y=3.355 //x2=59.16 //y2=2.77
cc_2239 ( N_noxref_6_c_2505_p N_D_c_4303_n ) capacitor c=0.0246937f //x=40.45 \
 //y=3.355 //x2=59.16 //y2=2.77
cc_2240 ( N_noxref_6_c_2495_p N_D_c_4303_n ) capacitor c=0.00852827f \
 //x=40.295 //y=3.515 //x2=59.16 //y2=2.77
cc_2241 ( N_noxref_6_c_2470_n CLK ) capacitor c=8.46095e-19 //x=38.6 //y=3.355 \
 //x2=41.56 //y2=3.51
cc_2242 ( N_noxref_6_c_2472_n CLK ) capacitor c=7.56903e-19 //x=38.6 //y=5.295 \
 //x2=41.56 //y2=3.51
cc_2243 ( N_noxref_6_c_2505_p CLK ) capacitor c=0.0220451f //x=40.45 //y=3.355 \
 //x2=41.56 //y2=3.51
cc_2244 ( N_noxref_6_c_2496_p CLK ) capacitor c=0.00781344f //x=40.45 \
 //y=3.675 //x2=41.56 //y2=3.51
cc_2245 ( N_noxref_6_c_2497_p CLK ) capacitor c=0.0204064f //x=40.45 //y=4.755 \
 //x2=41.56 //y2=3.51
cc_2246 ( N_noxref_6_c_2574_p CLK ) capacitor c=2.98349e-19 //x=40.45 //y=3.51 \
 //x2=41.56 //y2=3.51
cc_2247 ( N_noxref_6_c_2498_p CLK ) capacitor c=0.00510347f //x=40.455 \
 //y=3.515 //x2=41.56 //y2=3.51
cc_2248 ( N_noxref_6_c_2576_p CLK ) capacitor c=3.9149e-19 //x=40.45 //y=2.26 \
 //x2=41.56 //y2=3.51
cc_2249 ( N_noxref_6_c_2577_p N_CLK_c_5040_n ) capacitor c=0.00894339f \
 //x=40.45 //y=2.375 //x2=41.56 //y2=2.375
cc_2250 ( N_noxref_6_c_2576_p N_CLK_c_5040_n ) capacitor c=5.40058e-19 \
 //x=40.45 //y=2.26 //x2=41.56 //y2=2.375
cc_2251 ( N_noxref_6_c_2579_p N_CLK_c_5040_n ) capacitor c=0.00142893f \
 //x=40.15 //y=2.095 //x2=41.56 //y2=2.375
cc_2252 ( N_noxref_6_c_2497_p N_CLK_c_5043_n ) capacitor c=0.0128897f \
 //x=40.45 //y=4.755 //x2=41.555 //y2=4.695
cc_2253 ( N_noxref_6_c_2581_p N_CLK_c_5043_n ) capacitor c=8.3916e-19 \
 //x=40.45 //y=4.88 //x2=41.555 //y2=4.695
cc_2254 ( N_noxref_6_c_2523_p N_CLK_c_5043_n ) capacitor c=7.66769e-19 \
 //x=41.015 //y=4.97 //x2=41.555 //y2=4.695
cc_2255 ( N_noxref_6_c_2583_p N_CLK_c_5043_n ) capacitor c=9.07197e-19 \
 //x=40.725 //y=4.97 //x2=41.555 //y2=4.695
cc_2256 ( N_noxref_6_c_2520_p N_CLK_c_5047_n ) capacitor c=0.00643612f \
 //x=38.12 //y=5.38 //x2=38.08 //y2=4.635
cc_2257 ( N_noxref_6_c_2467_n N_CLK_c_5004_n ) capacitor c=0.00653719f \
 //x=38.005 //y=5.38 //x2=37.735 //y2=4.635
cc_2258 ( N_noxref_6_c_2474_n N_CLK_c_5004_n ) capacitor c=0.0154694f \
 //x=37.24 //y=5.56 //x2=37.735 //y2=4.635
cc_2259 ( N_noxref_6_c_2472_n N_CLK_c_5050_n ) capacitor c=0.0290879f //x=38.6 \
 //y=5.295 //x2=43.285 //y2=4.64
cc_2260 ( N_noxref_6_c_2497_p N_CLK_c_5050_n ) capacitor c=0.0355055f \
 //x=40.45 //y=4.755 //x2=43.285 //y2=4.64
cc_2261 ( N_noxref_6_c_2520_p N_CLK_c_5050_n ) capacitor c=0.0151127f \
 //x=38.12 //y=5.38 //x2=43.285 //y2=4.64
cc_2262 ( N_noxref_6_c_2577_p N_CLK_c_5053_n ) capacitor c=5.39999e-19 \
 //x=40.45 //y=2.375 //x2=41.56 //y2=2.26
cc_2263 ( N_noxref_6_c_2505_p N_CLK_c_5053_n ) capacitor c=3.9149e-19 \
 //x=40.45 //y=3.355 //x2=41.56 //y2=2.26
cc_2264 ( N_noxref_6_c_2576_p N_CLK_c_5053_n ) capacitor c=0.00125213f \
 //x=40.45 //y=2.26 //x2=41.56 //y2=2.26
cc_2265 ( N_noxref_6_c_2579_p N_CLK_c_5053_n ) capacitor c=0.00214573f \
 //x=40.15 //y=2.095 //x2=41.56 //y2=2.26
cc_2266 ( N_noxref_6_c_2497_p N_CLK_c_5057_n ) capacitor c=5.64453e-19 \
 //x=40.45 //y=4.755 //x2=41.56 //y2=4.88
cc_2267 ( N_noxref_6_c_2581_p N_CLK_c_5057_n ) capacitor c=0.00113666f \
 //x=40.45 //y=4.88 //x2=41.56 //y2=4.88
cc_2268 ( N_noxref_6_c_2523_p N_CLK_c_5057_n ) capacitor c=0.00116563f \
 //x=41.015 //y=4.97 //x2=41.56 //y2=4.88
cc_2269 ( N_noxref_6_c_2583_p N_CLK_c_5057_n ) capacitor c=0.0012974f \
 //x=40.725 //y=4.97 //x2=41.56 //y2=4.88
cc_2270 ( N_noxref_6_M102_noxref_g N_CLK_M104_noxref_g ) capacitor \
 c=0.0106276f //x=40.65 //y=6.2 //x2=41.53 //y2=6.2
cc_2271 ( N_noxref_6_M103_noxref_g N_CLK_M104_noxref_g ) capacitor c=0.107144f \
 //x=41.09 //y=6.2 //x2=41.53 //y2=6.2
cc_2272 ( N_noxref_6_M103_noxref_g N_CLK_M105_noxref_g ) capacitor \
 c=0.0101598f //x=41.09 //y=6.2 //x2=41.97 //y2=6.2
cc_2273 ( N_noxref_6_c_2601_p N_CLK_c_5064_n ) capacitor c=5.72528e-19 \
 //x=40.15 //y=1.055 //x2=41.125 //y2=1.09
cc_2274 ( N_noxref_6_c_2602_p N_CLK_c_5064_n ) capacitor c=0.00150277f \
 //x=40.15 //y=1.4 //x2=41.125 //y2=1.09
cc_2275 ( N_noxref_6_c_2603_p N_CLK_c_5064_n ) capacitor c=0.0160123f \
 //x=40.68 //y=1.055 //x2=41.125 //y2=1.09
cc_2276 ( N_noxref_6_c_2604_p N_CLK_c_5067_n ) capacitor c=0.00111227f \
 //x=40.15 //y=1.71 //x2=41.125 //y2=1.4
cc_2277 ( N_noxref_6_c_2605_p N_CLK_c_5067_n ) capacitor c=0.0124075f \
 //x=40.68 //y=1.4 //x2=41.125 //y2=1.4
cc_2278 ( N_noxref_6_c_2603_p N_CLK_c_5069_n ) capacitor c=9.19165e-19 \
 //x=40.68 //y=1.055 //x2=41.65 //y2=1.09
cc_2279 ( N_noxref_6_c_2605_p N_CLK_c_5070_n ) capacitor c=0.0010154f \
 //x=40.68 //y=1.4 //x2=41.65 //y2=1.4
cc_2280 ( N_noxref_6_c_2605_p N_CLK_c_5071_n ) capacitor c=9.23422e-19 \
 //x=40.68 //y=1.4 //x2=41.65 //y2=1.63
cc_2281 ( N_noxref_6_c_2577_p N_CLK_c_5072_n ) capacitor c=0.00136403f \
 //x=40.45 //y=2.375 //x2=41.65 //y2=2.095
cc_2282 ( N_noxref_6_c_2576_p N_CLK_c_5072_n ) capacitor c=0.0020754f \
 //x=40.45 //y=2.26 //x2=41.65 //y2=2.095
cc_2283 ( N_noxref_6_c_2579_p N_CLK_c_5072_n ) capacitor c=0.00964411f \
 //x=40.15 //y=2.095 //x2=41.65 //y2=2.095
cc_2284 ( N_noxref_6_c_2497_p N_CLK_c_5075_n ) capacitor c=5.7788e-19 \
 //x=40.45 //y=4.755 //x2=41.56 //y2=4.88
cc_2285 ( N_noxref_6_c_2581_p N_CLK_c_5075_n ) capacitor c=0.0013104f \
 //x=40.45 //y=4.88 //x2=41.56 //y2=4.88
cc_2286 ( N_noxref_6_c_2523_p N_CLK_c_5075_n ) capacitor c=0.0171374f \
 //x=41.015 //y=4.97 //x2=41.56 //y2=4.88
cc_2287 ( N_noxref_6_c_2583_p N_CLK_c_5075_n ) capacitor c=0.00419533f \
 //x=40.725 //y=4.97 //x2=41.56 //y2=4.88
cc_2288 ( N_noxref_6_c_2505_p RN ) capacitor c=8.08998e-19 //x=40.45 //y=3.355 \
 //x2=42.67 //y2=3.51
cc_2289 ( N_noxref_6_c_2497_p RN ) capacitor c=9.86735e-19 //x=40.45 //y=4.755 \
 //x2=42.67 //y2=3.51
cc_2290 ( N_noxref_6_c_2469_n N_RN_c_6525_n ) capacitor c=0.0193939f \
 //x=38.245 //y=1.835 //x2=42.515 //y2=2.315
cc_2291 ( N_noxref_6_c_2470_n N_RN_c_6525_n ) capacitor c=0.0281849f //x=38.6 \
 //y=3.355 //x2=42.515 //y2=2.315
cc_2292 ( N_noxref_6_c_2577_p N_RN_c_6525_n ) capacitor c=0.016619f //x=40.45 \
 //y=2.375 //x2=42.515 //y2=2.315
cc_2293 ( N_noxref_6_c_2505_p N_RN_c_6525_n ) capacitor c=0.0143826f //x=40.45 \
 //y=3.355 //x2=42.515 //y2=2.315
cc_2294 ( N_noxref_6_c_2482_n N_RN_c_6525_n ) capacitor c=7.09092e-19 \
 //x=38.16 //y=1.18 //x2=42.515 //y2=2.315
cc_2295 ( N_noxref_6_c_2576_p N_RN_c_6525_n ) capacitor c=5.18204e-19 \
 //x=40.45 //y=2.26 //x2=42.515 //y2=2.315
cc_2296 ( N_noxref_6_c_2579_p N_RN_c_6525_n ) capacitor c=3.41298e-19 \
 //x=40.15 //y=2.095 //x2=42.515 //y2=2.315
cc_2297 ( N_noxref_6_c_2470_n N_noxref_16_c_10028_n ) capacitor c=2.13613e-19 \
 //x=38.6 //y=3.355 //x2=38.21 //y2=3.14
cc_2298 ( N_noxref_6_c_2470_n N_noxref_16_c_10029_n ) capacitor c=0.0227003f \
 //x=38.6 //y=3.355 //x2=38.81 //y2=3.13
cc_2299 ( N_noxref_6_c_2490_p N_noxref_16_c_10029_n ) capacitor c=0.00811103f \
 //x=38.6 //y=3.675 //x2=38.81 //y2=3.13
cc_2300 ( N_noxref_6_c_2484_n N_noxref_16_c_10029_n ) capacitor c=0.0358686f \
 //x=38.76 //y=3.515 //x2=38.81 //y2=3.13
cc_2301 ( N_noxref_6_c_2495_p N_noxref_16_c_10029_n ) capacitor c=0.128361f \
 //x=40.295 //y=3.515 //x2=38.81 //y2=3.13
cc_2302 ( N_noxref_6_c_2505_p N_noxref_16_c_10033_n ) capacitor c=3.3797e-19 \
 //x=40.45 //y=3.355 //x2=40.07 //y2=3.14
cc_2303 ( N_noxref_6_c_2496_p N_noxref_16_c_10033_n ) capacitor c=0.00346018f \
 //x=40.45 //y=3.675 //x2=40.07 //y2=3.14
cc_2304 ( N_noxref_6_c_2495_p N_noxref_16_c_10033_n ) capacitor c=0.0108861f \
 //x=40.295 //y=3.515 //x2=40.07 //y2=3.14
cc_2305 ( N_noxref_6_c_2505_p N_noxref_16_c_10036_n ) capacitor c=0.0240253f \
 //x=40.45 //y=3.355 //x2=40.67 //y2=3.13
cc_2306 ( N_noxref_6_c_2496_p N_noxref_16_c_10036_n ) capacitor c=0.00505868f \
 //x=40.45 //y=3.675 //x2=40.67 //y2=3.13
cc_2307 ( N_noxref_6_c_2498_p N_noxref_16_c_10036_n ) capacitor c=0.0358686f \
 //x=40.455 //y=3.515 //x2=40.67 //y2=3.13
cc_2308 ( N_noxref_6_c_2467_n N_VDD_c_11464_n ) capacitor c=0.00648267f \
 //x=38.005 //y=5.38 //x2=78.895 //y2=7.585
cc_2309 ( N_noxref_6_c_2537_p N_VDD_c_11464_n ) capacitor c=0.00492584f \
 //x=38.515 //y=5.38 //x2=78.895 //y2=7.585
cc_2310 ( N_noxref_6_c_2490_p N_VDD_c_11464_n ) capacitor c=4.58709e-19 \
 //x=38.6 //y=3.675 //x2=78.895 //y2=7.585
cc_2311 ( N_noxref_6_c_2496_p N_VDD_c_11464_n ) capacitor c=3.99241e-19 \
 //x=40.45 //y=3.675 //x2=78.895 //y2=7.585
cc_2312 ( N_noxref_6_c_2474_n N_VDD_c_11464_n ) capacitor c=0.00368834f \
 //x=37.24 //y=5.56 //x2=78.895 //y2=7.585
cc_2313 ( N_noxref_6_c_2520_p N_VDD_c_11464_n ) capacitor c=8.42594e-19 \
 //x=38.12 //y=5.38 //x2=78.895 //y2=7.585
cc_2314 ( N_noxref_6_c_2642_p N_VDD_c_11464_n ) capacitor c=0.00285853f \
 //x=38.12 //y=5.56 //x2=78.895 //y2=7.585
cc_2315 ( N_noxref_6_c_2485_n N_VDD_c_11464_n ) capacitor c=0.00224881f \
 //x=37.24 //y=5.56 //x2=78.895 //y2=7.585
cc_2316 ( N_noxref_6_c_2536_p N_VDD_c_11464_n ) capacitor c=0.00224881f \
 //x=38.12 //y=5.56 //x2=78.895 //y2=7.585
cc_2317 ( N_noxref_6_c_2467_n N_VDD_c_11810_n ) capacitor c=0.00208087f \
 //x=38.005 //y=5.38 //x2=37.595 //y2=7.585
cc_2318 ( N_noxref_6_c_2474_n N_VDD_c_11810_n ) capacitor c=9.41185e-19 \
 //x=37.24 //y=5.56 //x2=37.595 //y2=7.585
cc_2319 ( N_noxref_6_c_2485_n N_VDD_c_11810_n ) capacitor c=0.0136705f \
 //x=37.24 //y=5.56 //x2=37.595 //y2=7.585
cc_2320 ( N_noxref_6_c_2467_n N_VDD_c_11854_n ) capacitor c=0.00180737f \
 //x=38.005 //y=5.38 //x2=38.475 //y2=7.585
cc_2321 ( N_noxref_6_c_2537_p N_VDD_c_11854_n ) capacitor c=0.00208087f \
 //x=38.515 //y=5.38 //x2=38.475 //y2=7.585
cc_2322 ( N_noxref_6_c_2520_p N_VDD_c_11854_n ) capacitor c=4.23719e-19 \
 //x=38.12 //y=5.38 //x2=38.475 //y2=7.585
cc_2323 ( N_noxref_6_c_2642_p N_VDD_c_11854_n ) capacitor c=5.77976e-19 \
 //x=38.12 //y=5.56 //x2=38.475 //y2=7.585
cc_2324 ( N_noxref_6_c_2536_p N_VDD_c_11854_n ) capacitor c=0.0136705f \
 //x=38.12 //y=5.56 //x2=38.475 //y2=7.585
cc_2325 ( N_noxref_6_M102_noxref_g N_VDD_c_11859_n ) capacitor c=0.00755614f \
 //x=40.65 //y=6.2 //x2=41.225 //y2=7.585
cc_2326 ( N_noxref_6_M103_noxref_g N_VDD_c_11859_n ) capacitor c=0.00755544f \
 //x=41.09 //y=6.2 //x2=41.225 //y2=7.585
cc_2327 ( N_noxref_6_c_2472_n N_VDD_c_11817_n ) capacitor c=0.0013228f \
 //x=38.6 //y=5.295 //x2=36.01 //y2=7.585
cc_2328 ( N_noxref_6_c_2474_n N_VDD_c_11817_n ) capacitor c=4.91377e-19 \
 //x=37.24 //y=5.56 //x2=36.01 //y2=7.585
cc_2329 ( N_noxref_6_c_2485_n N_VDD_c_11817_n ) capacitor c=0.0064135f \
 //x=37.24 //y=5.56 //x2=36.01 //y2=7.585
cc_2330 ( N_noxref_6_c_2472_n N_VDD_c_11864_n ) capacitor c=0.0294123f \
 //x=38.6 //y=5.295 //x2=39.34 //y2=7.585
cc_2331 ( N_noxref_6_c_2497_p N_VDD_c_11864_n ) capacitor c=0.0119111f \
 //x=40.45 //y=4.755 //x2=39.34 //y2=7.585
cc_2332 ( N_noxref_6_c_2520_p N_VDD_c_11864_n ) capacitor c=0.0025639f \
 //x=38.12 //y=5.38 //x2=39.34 //y2=7.585
cc_2333 ( N_noxref_6_c_2642_p N_VDD_c_11864_n ) capacitor c=4.19141e-19 \
 //x=38.12 //y=5.56 //x2=39.34 //y2=7.585
cc_2334 ( N_noxref_6_c_2536_p N_VDD_c_11864_n ) capacitor c=0.0101861f \
 //x=38.12 //y=5.56 //x2=39.34 //y2=7.585
cc_2335 ( N_noxref_6_c_2581_p N_VDD_c_11864_n ) capacitor c=0.00370784f \
 //x=40.45 //y=4.88 //x2=39.34 //y2=7.585
cc_2336 ( N_noxref_6_c_2583_p N_VDD_c_11864_n ) capacitor c=0.00590568f \
 //x=40.725 //y=4.97 //x2=39.34 //y2=7.585
cc_2337 ( N_noxref_6_c_2474_n N_VDD_M98_noxref_s ) capacitor c=0.0611368f \
 //x=37.24 //y=5.56 //x2=36.665 //y2=5.2
cc_2338 ( N_noxref_6_c_2520_p N_VDD_M98_noxref_s ) capacitor c=6.52457e-19 \
 //x=38.12 //y=5.38 //x2=36.665 //y2=5.2
cc_2339 ( N_noxref_6_c_2485_n N_VDD_M98_noxref_s ) capacitor c=0.0887533f \
 //x=37.24 //y=5.56 //x2=36.665 //y2=5.2
cc_2340 ( N_noxref_6_c_2467_n N_VDD_M99_noxref_d ) capacitor c=0.00734094f \
 //x=38.005 //y=5.38 //x2=37.535 //y2=5.2
cc_2341 ( N_noxref_6_c_2474_n N_VDD_M99_noxref_d ) capacitor c=0.0043528f \
 //x=37.24 //y=5.56 //x2=37.535 //y2=5.2
cc_2342 ( N_noxref_6_c_2642_p N_VDD_M99_noxref_d ) capacitor c=0.0043528f \
 //x=38.12 //y=5.56 //x2=37.535 //y2=5.2
cc_2343 ( N_noxref_6_c_2485_n N_VDD_M99_noxref_d ) capacitor c=0.065554f \
 //x=37.24 //y=5.56 //x2=37.535 //y2=5.2
cc_2344 ( N_noxref_6_c_2536_p N_VDD_M99_noxref_d ) capacitor c=0.065554f \
 //x=38.12 //y=5.56 //x2=37.535 //y2=5.2
cc_2345 ( N_noxref_6_c_2537_p N_VDD_M101_noxref_d ) capacitor c=0.00934027f \
 //x=38.515 //y=5.38 //x2=38.415 //y2=5.2
cc_2346 ( N_noxref_6_c_2642_p N_VDD_M101_noxref_d ) capacitor c=0.00955781f \
 //x=38.12 //y=5.56 //x2=38.415 //y2=5.2
cc_2347 ( N_noxref_6_c_2483_n N_VDD_M101_noxref_d ) capacitor c=9.65951e-19 \
 //x=38.6 //y=3.51 //x2=38.415 //y2=5.2
cc_2348 ( N_noxref_6_c_2536_p N_VDD_M101_noxref_d ) capacitor c=0.065554f \
 //x=38.12 //y=5.56 //x2=38.415 //y2=5.2
cc_2349 ( N_noxref_6_c_2537_p N_VDD_M102_noxref_s ) capacitor c=0.00220019f \
 //x=38.515 //y=5.38 //x2=40.295 //y2=5.2
cc_2350 ( N_noxref_6_c_2496_p N_VDD_M102_noxref_s ) capacitor c=6.02115e-19 \
 //x=40.45 //y=3.675 //x2=40.295 //y2=5.2
cc_2351 ( N_noxref_6_c_2497_p N_VDD_M102_noxref_s ) capacitor c=0.0217981f \
 //x=40.45 //y=4.755 //x2=40.295 //y2=5.2
cc_2352 ( N_noxref_6_c_2520_p N_VDD_M102_noxref_s ) capacitor c=0.00371125f \
 //x=38.12 //y=5.38 //x2=40.295 //y2=5.2
cc_2353 ( N_noxref_6_c_2642_p N_VDD_M102_noxref_s ) capacitor c=9.52042e-19 \
 //x=38.12 //y=5.56 //x2=40.295 //y2=5.2
cc_2354 ( N_noxref_6_c_2581_p N_VDD_M102_noxref_s ) capacitor c=0.00983846f \
 //x=40.45 //y=4.88 //x2=40.295 //y2=5.2
cc_2355 ( N_noxref_6_M102_noxref_g N_VDD_M102_noxref_s ) capacitor c=0.053419f \
 //x=40.65 //y=6.2 //x2=40.295 //y2=5.2
cc_2356 ( N_noxref_6_c_2583_p N_VDD_M102_noxref_s ) capacitor c=0.0060625f \
 //x=40.725 //y=4.97 //x2=40.295 //y2=5.2
cc_2357 ( N_noxref_6_M103_noxref_g N_VDD_M103_noxref_d ) capacitor c=0.015318f \
 //x=41.09 //y=6.2 //x2=41.165 //y2=5.2
cc_2358 ( N_noxref_6_c_2482_n N_noxref_26_M25_noxref_d ) capacitor \
 c=3.39394e-19 //x=38.16 //y=1.18 //x2=41.2 //y2=1.09
cc_2359 ( N_noxref_6_c_2515_p N_GND_c_14210_n ) capacitor c=0.00608539f \
 //x=38.515 //y=1.835 //x2=40.33 //y2=0.175
cc_2360 ( N_noxref_6_c_2490_p N_GND_c_14210_n ) capacitor c=2.7199e-19 \
 //x=38.6 //y=3.675 //x2=40.33 //y2=0.175
cc_2361 ( N_noxref_6_c_2482_n N_GND_c_14210_n ) capacitor c=0.00928865f \
 //x=38.16 //y=1.18 //x2=40.33 //y2=0.175
cc_2362 ( N_noxref_6_M23_noxref_d N_GND_c_14210_n ) capacitor c=3.01769e-19 \
 //x=37.97 //y=1.085 //x2=40.33 //y2=0.175
cc_2363 ( N_noxref_6_c_2601_p N_GND_c_14214_n ) capacitor c=3.92414e-19 \
 //x=40.15 //y=1.055 //x2=40.415 //y2=1.015
cc_2364 ( N_noxref_6_c_2692_p N_GND_c_14214_n ) capacitor c=0.0085115f \
 //x=40.525 //y=0.9 //x2=40.415 //y2=1.015
cc_2365 ( N_noxref_6_c_2603_p N_GND_c_14214_n ) capacitor c=4.45447e-19 \
 //x=40.68 //y=1.055 //x2=40.415 //y2=1.015
cc_2366 ( N_noxref_6_c_2474_n N_GND_c_14176_n ) capacitor c=6.80717e-19 \
 //x=37.24 //y=5.56 //x2=37.19 //y2=1.135
cc_2367 ( N_noxref_6_c_2482_n N_GND_c_14176_n ) capacitor c=0.0140211f \
 //x=38.16 //y=1.18 //x2=37.19 //y2=1.135
cc_2368 ( N_noxref_6_M23_noxref_d N_GND_c_14176_n ) capacitor c=2.93544e-19 \
 //x=37.97 //y=1.085 //x2=37.19 //y2=1.135
cc_2369 ( N_noxref_6_c_2577_p N_GND_c_14220_n ) capacitor c=0.00772482f \
 //x=40.45 //y=2.375 //x2=40.415 //y2=1.145
cc_2370 ( N_noxref_6_c_2496_p N_GND_c_14220_n ) capacitor c=7.58937e-19 \
 //x=40.45 //y=3.675 //x2=40.415 //y2=1.145
cc_2371 ( N_noxref_6_c_2482_n N_GND_c_14220_n ) capacitor c=0.00606355f \
 //x=38.16 //y=1.18 //x2=40.415 //y2=1.145
cc_2372 ( N_noxref_6_c_2576_p N_GND_c_14220_n ) capacitor c=2.22883e-19 \
 //x=40.45 //y=2.26 //x2=40.415 //y2=1.145
cc_2373 ( N_noxref_6_c_2601_p N_GND_c_14220_n ) capacitor c=0.0015128f \
 //x=40.15 //y=1.055 //x2=40.415 //y2=1.145
cc_2374 ( N_noxref_6_c_2602_p N_GND_c_14220_n ) capacitor c=0.00350108f \
 //x=40.15 //y=1.4 //x2=40.415 //y2=1.145
cc_2375 ( N_noxref_6_c_2604_p N_GND_c_14220_n ) capacitor c=4.28277e-19 \
 //x=40.15 //y=1.71 //x2=40.415 //y2=1.145
cc_2376 ( N_noxref_6_c_2692_p N_GND_c_14220_n ) capacitor c=9.36995e-19 \
 //x=40.525 //y=0.9 //x2=40.415 //y2=1.145
cc_2377 ( N_noxref_6_c_2705_p N_GND_c_14220_n ) capacitor c=5.79535e-19 \
 //x=40.525 //y=1.555 //x2=40.415 //y2=1.145
cc_2378 ( N_noxref_6_c_2603_p N_GND_c_14220_n ) capacitor c=0.0017438f \
 //x=40.68 //y=1.055 //x2=40.415 //y2=1.145
cc_2379 ( N_noxref_6_c_2605_p N_GND_c_14220_n ) capacitor c=0.00276804f \
 //x=40.68 //y=1.4 //x2=40.415 //y2=1.145
cc_2380 ( N_noxref_6_c_2515_p N_GND_c_14192_n ) capacitor c=7.75992e-19 \
 //x=38.515 //y=1.835 //x2=39.17 //y2=0.175
cc_2381 ( N_noxref_6_c_2490_p N_GND_c_14192_n ) capacitor c=3.21092e-19 \
 //x=38.6 //y=3.675 //x2=39.17 //y2=0.175
cc_2382 ( N_noxref_6_c_2601_p N_GND_c_14233_n ) capacitor c=0.00677932f \
 //x=40.15 //y=1.055 //x2=43.98 //y2=0.175
cc_2383 ( N_noxref_6_c_2470_n N_GND_c_14196_n ) capacitor c=9.32616e-19 \
 //x=38.6 //y=3.355 //x2=36.01 //y2=0.175
cc_2384 ( N_noxref_6_c_2468_n N_GND_c_14235_n ) capacitor c=0.00460657f \
 //x=38.16 //y=1.75 //x2=39.34 //y2=0.175
cc_2385 ( N_noxref_6_c_2515_p N_GND_c_14235_n ) capacitor c=0.0287655f \
 //x=38.515 //y=1.835 //x2=39.34 //y2=0.175
cc_2386 ( N_noxref_6_c_2577_p N_GND_c_14235_n ) capacitor c=0.00380125f \
 //x=40.45 //y=2.375 //x2=39.34 //y2=0.175
cc_2387 ( N_noxref_6_c_2505_p N_GND_c_14235_n ) capacitor c=0.00881103f \
 //x=40.45 //y=3.355 //x2=39.34 //y2=0.175
cc_2388 ( N_noxref_6_c_2576_p N_GND_c_14235_n ) capacitor c=0.00396211f \
 //x=40.45 //y=2.26 //x2=39.34 //y2=0.175
cc_2389 ( N_noxref_6_c_2604_p N_GND_c_14235_n ) capacitor c=0.00170145f \
 //x=40.15 //y=1.71 //x2=39.34 //y2=0.175
cc_2390 ( N_noxref_6_c_2579_p N_GND_c_14235_n ) capacitor c=0.0102191f \
 //x=40.15 //y=2.095 //x2=39.34 //y2=0.175
cc_2391 ( N_noxref_6_c_2482_n N_GND_M22_noxref_d ) capacitor c=2.82748e-19 \
 //x=38.16 //y=1.18 //x2=37 //y2=1.045
cc_2392 ( N_noxref_6_c_2577_p N_GND_M24_noxref_d ) capacitor c=4.4417e-19 \
 //x=40.45 //y=2.375 //x2=40.225 //y2=1.055
cc_2393 ( N_noxref_6_c_2601_p N_GND_M24_noxref_d ) capacitor c=0.00184354f \
 //x=40.15 //y=1.055 //x2=40.225 //y2=1.055
cc_2394 ( N_noxref_6_c_2602_p N_GND_M24_noxref_d ) capacitor c=0.00210798f \
 //x=40.15 //y=1.4 //x2=40.225 //y2=1.055
cc_2395 ( N_noxref_6_c_2692_p N_GND_M24_noxref_d ) capacitor c=0.00474029f \
 //x=40.525 //y=0.9 //x2=40.225 //y2=1.055
cc_2396 ( N_noxref_6_c_2705_p N_GND_M24_noxref_d ) capacitor c=0.00166857f \
 //x=40.525 //y=1.555 //x2=40.225 //y2=1.055
cc_2397 ( N_noxref_6_c_2603_p N_GND_M24_noxref_d ) capacitor c=0.00230174f \
 //x=40.68 //y=1.055 //x2=40.225 //y2=1.055
cc_2398 ( N_noxref_6_c_2605_p N_GND_M24_noxref_d ) capacitor c=0.00210798f \
 //x=40.68 //y=1.4 //x2=40.225 //y2=1.055
cc_2399 ( N_noxref_6_c_2469_n N_noxref_43_c_16025_n ) capacitor c=0.00911405f \
 //x=38.245 //y=1.835 //x2=37.675 //y2=1.675
cc_2400 ( N_noxref_6_c_2515_p N_noxref_43_c_16030_n ) capacitor c=0.00399245f \
 //x=38.515 //y=1.835 //x2=38.56 //y2=0.71
cc_2401 ( N_noxref_6_c_2482_n N_noxref_43_c_16030_n ) capacitor c=0.003751f \
 //x=38.16 //y=1.18 //x2=38.56 //y2=0.71
cc_2402 ( N_noxref_6_M23_noxref_d N_noxref_43_c_16030_n ) capacitor \
 c=0.00910163f //x=37.97 //y=1.085 //x2=38.56 //y2=0.71
cc_2403 ( N_noxref_6_c_2468_n N_noxref_43_M22_noxref_s ) capacitor \
 c=0.0175063f //x=38.16 //y=1.75 //x2=36.57 //y2=0.545
cc_2404 ( N_noxref_6_c_2515_p N_noxref_43_M22_noxref_s ) capacitor \
 c=0.00640979f //x=38.515 //y=1.835 //x2=36.57 //y2=0.545
cc_2405 ( N_noxref_6_c_2490_p N_noxref_43_M22_noxref_s ) capacitor \
 c=4.15501e-19 //x=38.6 //y=3.675 //x2=36.57 //y2=0.545
cc_2406 ( N_noxref_6_c_2482_n N_noxref_43_M22_noxref_s ) capacitor \
 c=0.0089443f //x=38.16 //y=1.18 //x2=36.57 //y2=0.545
cc_2407 ( N_noxref_6_c_2483_n N_noxref_43_M22_noxref_s ) capacitor \
 c=0.0010514f //x=38.6 //y=3.51 //x2=36.57 //y2=0.545
cc_2408 ( N_noxref_6_M23_noxref_d N_noxref_43_M22_noxref_s ) capacitor \
 c=0.0275552f //x=37.97 //y=1.085 //x2=36.57 //y2=0.545
cc_2409 ( N_noxref_6_c_2579_p N_noxref_44_c_16084_n ) capacitor c=0.00262672f \
 //x=40.15 //y=2.095 //x2=39.93 //y2=1.685
cc_2410 ( N_noxref_6_c_2577_p N_noxref_44_c_16085_n ) capacitor c=0.00428451f \
 //x=40.45 //y=2.375 //x2=40.815 //y2=1.77
cc_2411 ( N_noxref_6_c_2496_p N_noxref_44_c_16085_n ) capacitor c=0.00270049f \
 //x=40.45 //y=3.675 //x2=40.815 //y2=1.77
cc_2412 ( N_noxref_6_c_2576_p N_noxref_44_c_16085_n ) capacitor c=0.0104666f \
 //x=40.45 //y=2.26 //x2=40.815 //y2=1.77
cc_2413 ( N_noxref_6_c_2604_p N_noxref_44_c_16085_n ) capacitor c=0.00705077f \
 //x=40.15 //y=1.71 //x2=40.815 //y2=1.77
cc_2414 ( N_noxref_6_c_2579_p N_noxref_44_c_16085_n ) capacitor c=0.020708f \
 //x=40.15 //y=2.095 //x2=40.815 //y2=1.77
cc_2415 ( N_noxref_6_c_2705_p N_noxref_44_c_16085_n ) capacitor c=0.00588627f \
 //x=40.525 //y=1.555 //x2=40.815 //y2=1.77
cc_2416 ( N_noxref_6_c_2605_p N_noxref_44_c_16085_n ) capacitor c=0.00698822f \
 //x=40.68 //y=1.4 //x2=40.815 //y2=1.77
cc_2417 ( N_noxref_6_c_2601_p N_noxref_44_M24_noxref_s ) capacitor \
 c=0.0295256f //x=40.15 //y=1.055 //x2=39.795 //y2=0.555
cc_2418 ( N_noxref_6_c_2604_p N_noxref_44_M24_noxref_s ) capacitor \
 c=7.99997e-19 //x=40.15 //y=1.71 //x2=39.795 //y2=0.555
cc_2419 ( N_noxref_6_c_2579_p N_noxref_44_M24_noxref_s ) capacitor \
 c=0.00122123f //x=40.15 //y=2.095 //x2=39.795 //y2=0.555
cc_2420 ( N_noxref_6_c_2603_p N_noxref_44_M24_noxref_s ) capacitor \
 c=0.0125924f //x=40.68 //y=1.055 //x2=39.795 //y2=0.555
cc_2421 ( N_noxref_7_M109_noxref_g N_noxref_8_c_3238_n ) capacitor \
 c=0.00893512f //x=45.9 //y=6.2 //x2=46.44 //y2=5.335
cc_2422 ( N_noxref_7_M108_noxref_g N_noxref_8_c_3239_n ) capacitor \
 c=0.00461408f //x=45.46 //y=6.2 //x2=45.682 //y2=5.335
cc_2423 ( N_noxref_7_M109_noxref_g N_noxref_8_c_3239_n ) capacitor \
 c=0.00229208f //x=45.9 //y=6.2 //x2=45.682 //y2=5.335
cc_2424 ( N_noxref_7_c_2850_p N_noxref_8_c_3239_n ) capacitor c=0.00171885f \
 //x=45.825 //y=4.97 //x2=45.682 //y2=5.335
cc_2425 ( N_noxref_7_c_2851_p N_noxref_8_c_3242_n ) capacitor c=4.2549e-19 \
 //x=45.25 //y=3.88 //x2=48.22 //y2=3.88
cc_2426 ( N_noxref_7_M108_noxref_g N_noxref_8_c_3243_n ) capacitor \
 c=0.0162284f //x=45.46 //y=6.2 //x2=45.68 //y2=5.56
cc_2427 ( N_noxref_7_M109_noxref_g N_noxref_8_c_3243_n ) capacitor \
 c=0.0179041f //x=45.9 //y=6.2 //x2=45.68 //y2=5.56
cc_2428 ( N_noxref_7_c_2850_p N_noxref_8_c_3243_n ) capacitor c=0.00291477f \
 //x=45.825 //y=4.97 //x2=45.68 //y2=5.56
cc_2429 ( N_noxref_7_c_2813_n N_noxref_9_c_3538_n ) capacitor c=6.09845e-19 \
 //x=37.335 //y=3.895 //x2=37.86 //y2=4.09
cc_2430 ( N_noxref_7_c_2835_n N_noxref_9_c_3538_n ) capacitor c=0.0229366f \
 //x=38.08 //y=3.865 //x2=37.86 //y2=4.09
cc_2431 ( N_noxref_7_c_2813_n N_noxref_9_c_3546_n ) capacitor c=0.00217342f \
 //x=37.335 //y=3.895 //x2=37.86 //y2=4.41
cc_2432 ( N_noxref_7_c_2835_n N_noxref_9_c_3546_n ) capacitor c=0.00450608f \
 //x=38.08 //y=3.865 //x2=37.86 //y2=4.41
cc_2433 ( N_noxref_7_c_2859_p N_noxref_9_c_3661_n ) capacitor c=0.00324093f \
 //x=45.26 //y=2.375 //x2=43.41 //y2=4.095
cc_2434 ( N_noxref_7_c_2860_p N_noxref_9_c_3661_n ) capacitor c=0.0183684f \
 //x=45.26 //y=3.72 //x2=43.41 //y2=4.095
cc_2435 ( N_noxref_7_c_2861_p N_noxref_9_c_3661_n ) capacitor c=0.00257738f \
 //x=45.26 //y=4.04 //x2=43.41 //y2=4.095
cc_2436 ( N_noxref_7_c_2862_p N_noxref_9_c_3661_n ) capacitor c=9.84588e-19 \
 //x=45.26 //y=4.755 //x2=43.41 //y2=4.095
cc_2437 ( N_noxref_7_c_2863_p N_noxref_9_c_3661_n ) capacitor c=2.09913e-19 \
 //x=43.03 //y=3.88 //x2=43.41 //y2=4.095
cc_2438 ( N_noxref_7_c_2864_p N_noxref_9_c_3661_n ) capacitor c=0.0266893f \
 //x=43.63 //y=3.87 //x2=43.41 //y2=4.095
cc_2439 ( N_noxref_7_c_2862_p N_noxref_9_c_3667_n ) capacitor c=0.00237452f \
 //x=45.26 //y=4.755 //x2=43.41 //y2=4.415
cc_2440 ( N_noxref_7_c_2863_p N_noxref_9_c_3667_n ) capacitor c=0.0018855f \
 //x=43.03 //y=3.88 //x2=43.41 //y2=4.415
cc_2441 ( N_noxref_7_c_2864_p N_noxref_9_c_3667_n ) capacitor c=0.00583578f \
 //x=43.63 //y=3.87 //x2=43.41 //y2=4.415
cc_2442 ( N_noxref_7_c_2862_p N_noxref_9_c_3670_n ) capacitor c=0.0075763f \
 //x=45.26 //y=4.755 //x2=43.41 //y2=5.25
cc_2443 ( N_noxref_7_c_2785_n N_noxref_9_c_3556_n ) capacitor c=0.00118691f \
 //x=30.46 //y=4.045 //x2=30.075 //y2=4.25
cc_2444 ( N_noxref_7_c_2787_n N_noxref_9_c_3556_n ) capacitor c=4.26819e-19 \
 //x=30.46 //y=5.25 //x2=30.075 //y2=4.25
cc_2445 ( N_noxref_7_c_2815_n N_noxref_9_c_3556_n ) capacitor c=0.0358254f \
 //x=30.625 //y=3.885 //x2=30.075 //y2=4.25
cc_2446 ( N_noxref_7_c_2785_n N_noxref_9_c_3560_n ) capacitor c=0.00757286f \
 //x=30.46 //y=4.045 //x2=30.715 //y2=4.27
cc_2447 ( N_noxref_7_c_2787_n N_noxref_9_c_3560_n ) capacitor c=0.0225812f \
 //x=30.46 //y=5.25 //x2=30.715 //y2=4.27
cc_2448 ( N_noxref_7_c_2800_n N_noxref_9_c_3560_n ) capacitor c=0.127594f \
 //x=32.155 //y=3.88 //x2=30.715 //y2=4.27
cc_2449 ( N_noxref_7_c_2794_n N_noxref_9_c_3561_n ) capacitor c=0.00118033f \
 //x=32.31 //y=4.04 //x2=31.93 //y2=4.25
cc_2450 ( N_noxref_7_c_2795_n N_noxref_9_c_3561_n ) capacitor c=5.06484e-19 \
 //x=32.31 //y=4.755 //x2=31.93 //y2=4.25
cc_2451 ( N_noxref_7_c_2800_n N_noxref_9_c_3561_n ) capacitor c=0.0121043f \
 //x=32.155 //y=3.88 //x2=31.93 //y2=4.25
cc_2452 ( N_noxref_7_c_2805_n N_noxref_9_c_3561_n ) capacitor c=0.0358254f \
 //x=35.145 //y=3.895 //x2=31.93 //y2=4.25
cc_2453 ( N_noxref_7_c_2794_n N_noxref_9_c_3562_n ) capacitor c=0.00475287f \
 //x=32.31 //y=4.04 //x2=32.53 //y2=4.265
cc_2454 ( N_noxref_7_c_2795_n N_noxref_9_c_3562_n ) capacitor c=0.0235427f \
 //x=32.31 //y=4.755 //x2=32.53 //y2=4.265
cc_2455 ( N_noxref_7_c_2805_n N_noxref_9_c_3562_n ) capacitor c=0.0109313f \
 //x=35.145 //y=3.895 //x2=32.53 //y2=4.265
cc_2456 ( N_noxref_7_c_2835_n N_noxref_9_c_3615_n ) capacitor c=0.0811722f \
 //x=38.08 //y=3.865 //x2=43.255 //y2=4.25
cc_2457 ( N_noxref_7_c_2838_n N_noxref_9_c_3615_n ) capacitor c=0.112087f \
 //x=38.815 //y=3.9 //x2=43.255 //y2=4.25
cc_2458 ( N_noxref_7_c_2841_n N_noxref_9_c_3615_n ) capacitor c=0.0584235f \
 //x=40.07 //y=3.88 //x2=43.255 //y2=4.25
cc_2459 ( N_noxref_7_c_2845_n N_noxref_9_c_3615_n ) capacitor c=0.200781f \
 //x=40.67 //y=3.9 //x2=43.255 //y2=4.25
cc_2460 ( N_noxref_7_c_2863_p N_noxref_9_c_3615_n ) capacitor c=0.0107886f \
 //x=43.03 //y=3.88 //x2=43.255 //y2=4.25
cc_2461 ( N_noxref_7_c_2795_n N_noxref_9_c_3563_n ) capacitor c=3.74821e-19 \
 //x=32.31 //y=4.755 //x2=38.025 //y2=4.25
cc_2462 ( N_noxref_7_c_2802_n N_noxref_9_c_3563_n ) capacitor c=0.11095f \
 //x=35.49 //y=3.895 //x2=38.025 //y2=4.25
cc_2463 ( N_noxref_7_c_2805_n N_noxref_9_c_3563_n ) capacitor c=0.258124f \
 //x=35.145 //y=3.895 //x2=38.025 //y2=4.25
cc_2464 ( N_noxref_7_c_2809_n N_noxref_9_c_3563_n ) capacitor c=0.0563855f \
 //x=36.735 //y=3.88 //x2=38.025 //y2=4.25
cc_2465 ( N_noxref_7_c_2813_n N_noxref_9_c_3563_n ) capacitor c=0.0231836f \
 //x=37.335 //y=3.895 //x2=38.025 //y2=4.25
cc_2466 ( N_noxref_7_c_2835_n N_noxref_9_c_3563_n ) capacitor c=0.0358686f \
 //x=38.08 //y=3.865 //x2=38.025 //y2=4.25
cc_2467 ( N_noxref_7_c_2861_p N_noxref_9_c_3695_n ) capacitor c=0.00248957f \
 //x=45.26 //y=4.04 //x2=45.465 //y2=4.265
cc_2468 ( N_noxref_7_c_2862_p N_noxref_9_c_3695_n ) capacitor c=0.0238043f \
 //x=45.26 //y=4.755 //x2=45.465 //y2=4.265
cc_2469 ( N_noxref_7_c_2861_p N_noxref_9_c_3697_n ) capacitor c=0.00335139f \
 //x=45.26 //y=4.04 //x2=45.12 //y2=4.265
cc_2470 ( N_noxref_7_c_2862_p N_noxref_9_c_3697_n ) capacitor c=0.00195984f \
 //x=45.26 //y=4.755 //x2=45.12 //y2=4.265
cc_2471 ( N_noxref_7_c_2864_p N_noxref_9_c_3697_n ) capacitor c=0.205653f \
 //x=43.63 //y=3.87 //x2=45.12 //y2=4.265
cc_2472 ( N_noxref_7_c_2898_p N_noxref_9_M86_noxref_g ) capacitor \
 c=0.00461408f //x=27.922 //y=5.335 //x2=27.7 //y2=6.2
cc_2473 ( N_noxref_7_c_2899_p N_noxref_9_M86_noxref_g ) capacitor c=0.0162284f \
 //x=27.92 //y=5.56 //x2=27.7 //y2=6.2
cc_2474 ( N_noxref_7_c_2900_p N_noxref_9_M87_noxref_g ) capacitor \
 c=0.00893512f //x=28.68 //y=5.335 //x2=28.14 //y2=6.2
cc_2475 ( N_noxref_7_c_2898_p N_noxref_9_M87_noxref_g ) capacitor \
 c=0.00229208f //x=27.922 //y=5.335 //x2=28.14 //y2=6.2
cc_2476 ( N_noxref_7_c_2899_p N_noxref_9_M87_noxref_g ) capacitor c=0.0179041f \
 //x=27.92 //y=5.56 //x2=28.14 //y2=6.2
cc_2477 ( N_noxref_7_c_2898_p N_noxref_9_c_3705_n ) capacitor c=0.00171885f \
 //x=27.922 //y=5.335 //x2=28.065 //y2=4.97
cc_2478 ( N_noxref_7_c_2899_p N_noxref_9_c_3705_n ) capacitor c=0.00291477f \
 //x=27.92 //y=5.56 //x2=28.065 //y2=4.97
cc_2479 ( N_noxref_7_c_2905_p N_D_c_4326_n ) capacitor c=0.00851314f //x=32.31 \
 //y=2.375 //x2=33.42 //y2=2.375
cc_2480 ( N_noxref_7_c_2906_p N_D_c_4326_n ) capacitor c=5.40058e-19 //x=32.31 \
 //y=2.26 //x2=33.42 //y2=2.375
cc_2481 ( N_noxref_7_c_2907_p N_D_c_4326_n ) capacitor c=0.00140836f //x=32.01 \
 //y=2.095 //x2=33.42 //y2=2.375
cc_2482 ( N_noxref_7_c_2775_n N_D_c_4293_n ) capacitor c=3.26708e-19 //x=30.46 \
 //y=3.725 //x2=33.42 //y2=2.595
cc_2483 ( N_noxref_7_c_2790_n N_D_c_4293_n ) capacitor c=0.00449316f //x=32.31 \
 //y=3.72 //x2=33.42 //y2=2.595
cc_2484 ( N_noxref_7_c_2906_p N_D_c_4293_n ) capacitor c=3.9149e-19 //x=32.31 \
 //y=2.26 //x2=33.42 //y2=2.595
cc_2485 ( N_noxref_7_c_2790_n N_D_c_4294_n ) capacitor c=0.00679084f //x=32.31 \
 //y=3.72 //x2=33.42 //y2=2.915
cc_2486 ( N_noxref_7_c_2775_n N_D_c_4297_n ) capacitor c=3.42189e-19 //x=30.46 \
 //y=3.725 //x2=33.42 //y2=4.765
cc_2487 ( N_noxref_7_c_2787_n N_D_c_4297_n ) capacitor c=6.66489e-19 //x=30.46 \
 //y=5.25 //x2=33.42 //y2=4.765
cc_2488 ( N_noxref_7_c_2790_n N_D_c_4297_n ) capacitor c=0.0189693f //x=32.31 \
 //y=3.72 //x2=33.42 //y2=4.765
cc_2489 ( N_noxref_7_c_2794_n N_D_c_4297_n ) capacitor c=0.00774769f //x=32.31 \
 //y=4.04 //x2=33.42 //y2=4.765
cc_2490 ( N_noxref_7_c_2795_n N_D_c_4297_n ) capacitor c=0.0269128f //x=32.31 \
 //y=4.755 //x2=33.42 //y2=4.765
cc_2491 ( N_noxref_7_c_2917_p N_D_c_4297_n ) capacitor c=2.90818e-19 //x=32.31 \
 //y=3.88 //x2=33.42 //y2=4.765
cc_2492 ( N_noxref_7_c_2805_n N_D_c_4297_n ) capacitor c=0.0253585f //x=35.145 \
 //y=3.895 //x2=33.42 //y2=4.765
cc_2493 ( N_noxref_7_c_2919_p N_D_c_4297_n ) capacitor c=6.26008e-19 //x=32.31 \
 //y=4.88 //x2=33.42 //y2=4.765
cc_2494 ( N_noxref_7_c_2827_n N_D_c_4297_n ) capacitor c=7.66769e-19 \
 //x=32.875 //y=4.97 //x2=33.42 //y2=4.765
cc_2495 ( N_noxref_7_c_2921_p N_D_c_4297_n ) capacitor c=7.54501e-19 \
 //x=32.585 //y=4.97 //x2=33.42 //y2=4.765
cc_2496 ( N_noxref_7_c_2790_n N_D_c_4343_n ) capacitor c=5.01652e-19 //x=32.31 \
 //y=3.72 //x2=33.42 //y2=2.77
cc_2497 ( N_noxref_7_c_2860_p N_D_c_4303_n ) capacitor c=0.0247303f //x=45.26 \
 //y=3.72 //x2=59.16 //y2=2.77
cc_2498 ( N_noxref_7_c_2813_n N_D_c_4303_n ) capacitor c=0.00413888f \
 //x=37.335 //y=3.895 //x2=59.16 //y2=2.77
cc_2499 ( N_noxref_7_c_2835_n N_D_c_4303_n ) capacitor c=0.0013802f //x=38.08 \
 //y=3.865 //x2=59.16 //y2=2.77
cc_2500 ( N_noxref_7_c_2845_n N_D_c_4303_n ) capacitor c=0.0157048f //x=40.67 \
 //y=3.9 //x2=59.16 //y2=2.77
cc_2501 ( N_noxref_7_c_2863_p N_D_c_4303_n ) capacitor c=0.00257285f //x=43.03 \
 //y=3.88 //x2=59.16 //y2=2.77
cc_2502 ( N_noxref_7_c_2864_p N_D_c_4303_n ) capacitor c=0.00507174f //x=43.63 \
 //y=3.87 //x2=59.16 //y2=2.77
cc_2503 ( N_noxref_7_c_2775_n N_D_c_4197_n ) capacitor c=0.0233619f //x=30.46 \
 //y=3.725 //x2=33.26 //y2=2.755
cc_2504 ( N_noxref_7_c_2790_n N_D_c_4197_n ) capacitor c=0.0245653f //x=32.31 \
 //y=3.72 //x2=33.26 //y2=2.755
cc_2505 ( N_noxref_7_c_2790_n N_D_c_4352_n ) capacitor c=0.00242466f //x=32.31 \
 //y=3.72 //x2=33.58 //y2=2.755
cc_2506 ( N_noxref_7_c_2905_p N_D_c_4353_n ) capacitor c=5.39999e-19 //x=32.31 \
 //y=2.375 //x2=33.42 //y2=2.26
cc_2507 ( N_noxref_7_c_2790_n N_D_c_4353_n ) capacitor c=3.9149e-19 //x=32.31 \
 //y=3.72 //x2=33.42 //y2=2.26
cc_2508 ( N_noxref_7_c_2906_p N_D_c_4353_n ) capacitor c=0.00125213f //x=32.31 \
 //y=2.26 //x2=33.42 //y2=2.26
cc_2509 ( N_noxref_7_c_2907_p N_D_c_4353_n ) capacitor c=0.00214573f //x=32.01 \
 //y=2.095 //x2=33.42 //y2=2.26
cc_2510 ( N_noxref_7_c_2795_n N_D_c_4312_n ) capacitor c=0.00103399f //x=32.31 \
 //y=4.755 //x2=33.42 //y2=4.88
cc_2511 ( N_noxref_7_c_2919_p N_D_c_4312_n ) capacitor c=0.00113984f //x=32.31 \
 //y=4.88 //x2=33.42 //y2=4.88
cc_2512 ( N_noxref_7_c_2827_n N_D_c_4312_n ) capacitor c=0.00116563f \
 //x=32.875 //y=4.97 //x2=33.42 //y2=4.88
cc_2513 ( N_noxref_7_c_2921_p N_D_c_4312_n ) capacitor c=0.00129812f \
 //x=32.585 //y=4.97 //x2=33.42 //y2=4.88
cc_2514 ( N_noxref_7_M92_noxref_g N_D_M94_noxref_g ) capacitor c=0.0106276f \
 //x=32.51 //y=6.2 //x2=33.39 //y2=6.2
cc_2515 ( N_noxref_7_M93_noxref_g N_D_M94_noxref_g ) capacitor c=0.107144f \
 //x=32.95 //y=6.2 //x2=33.39 //y2=6.2
cc_2516 ( N_noxref_7_M93_noxref_g N_D_M95_noxref_g ) capacitor c=0.0101598f \
 //x=32.95 //y=6.2 //x2=33.83 //y2=6.2
cc_2517 ( N_noxref_7_c_2943_p N_D_c_4364_n ) capacitor c=5.72528e-19 //x=32.01 \
 //y=1.055 //x2=32.985 //y2=1.09
cc_2518 ( N_noxref_7_c_2944_p N_D_c_4364_n ) capacitor c=0.00150277f //x=32.01 \
 //y=1.4 //x2=32.985 //y2=1.09
cc_2519 ( N_noxref_7_c_2945_p N_D_c_4364_n ) capacitor c=0.0160123f //x=32.54 \
 //y=1.055 //x2=32.985 //y2=1.09
cc_2520 ( N_noxref_7_c_2946_p N_D_c_4367_n ) capacitor c=0.00111227f //x=32.01 \
 //y=1.71 //x2=32.985 //y2=1.4
cc_2521 ( N_noxref_7_c_2947_p N_D_c_4367_n ) capacitor c=0.0124075f //x=32.54 \
 //y=1.4 //x2=32.985 //y2=1.4
cc_2522 ( N_noxref_7_c_2945_p N_D_c_4369_n ) capacitor c=9.19165e-19 //x=32.54 \
 //y=1.055 //x2=33.51 //y2=1.09
cc_2523 ( N_noxref_7_c_2947_p N_D_c_4370_n ) capacitor c=0.0010154f //x=32.54 \
 //y=1.4 //x2=33.51 //y2=1.4
cc_2524 ( N_noxref_7_c_2947_p N_D_c_4371_n ) capacitor c=9.23422e-19 //x=32.54 \
 //y=1.4 //x2=33.51 //y2=1.63
cc_2525 ( N_noxref_7_c_2905_p N_D_c_4372_n ) capacitor c=0.00136403f //x=32.31 \
 //y=2.375 //x2=33.51 //y2=2.095
cc_2526 ( N_noxref_7_c_2906_p N_D_c_4372_n ) capacitor c=0.0020754f //x=32.31 \
 //y=2.26 //x2=33.51 //y2=2.095
cc_2527 ( N_noxref_7_c_2907_p N_D_c_4372_n ) capacitor c=0.00964411f //x=32.01 \
 //y=2.095 //x2=33.51 //y2=2.095
cc_2528 ( N_noxref_7_c_2795_n N_D_c_4322_n ) capacitor c=0.00116212f //x=32.31 \
 //y=4.755 //x2=33.42 //y2=4.88
cc_2529 ( N_noxref_7_c_2919_p N_D_c_4322_n ) capacitor c=0.00155973f //x=32.31 \
 //y=4.88 //x2=33.42 //y2=4.88
cc_2530 ( N_noxref_7_c_2827_n N_D_c_4322_n ) capacitor c=0.0171374f //x=32.875 \
 //y=4.97 //x2=33.42 //y2=4.88
cc_2531 ( N_noxref_7_c_2921_p N_D_c_4322_n ) capacitor c=0.00484466f \
 //x=32.585 //y=4.97 //x2=33.42 //y2=4.88
cc_2532 ( N_noxref_7_c_2775_n CLK ) capacitor c=0.00198162f //x=30.46 \
 //y=3.725 //x2=28.61 //y2=3.51
cc_2533 ( N_noxref_7_c_2787_n CLK ) capacitor c=9.21998e-19 //x=30.46 //y=5.25 \
 //x2=28.61 //y2=3.51
cc_2534 ( N_noxref_7_c_2845_n CLK ) capacitor c=6.63302e-19 //x=40.67 //y=3.9 \
 //x2=41.56 //y2=3.51
cc_2535 ( N_noxref_7_c_2863_p CLK ) capacitor c=0.026203f //x=43.03 //y=3.88 \
 //x2=41.56 //y2=3.51
cc_2536 ( N_noxref_7_c_2900_p N_CLK_c_5001_n ) capacitor c=0.0236366f \
 //x=28.68 //y=5.335 //x2=28.605 //y2=4.835
cc_2537 ( N_noxref_7_c_2963_p N_CLK_c_5001_n ) capacitor c=0.00512107f \
 //x=28.8 //y=5.335 //x2=28.605 //y2=4.835
cc_2538 ( N_noxref_7_c_2964_p N_CLK_c_5001_n ) capacitor c=0.00134045f \
 //x=28.8 //y=5.56 //x2=28.605 //y2=4.835
cc_2539 ( N_noxref_7_c_2835_n N_CLK_c_5047_n ) capacitor c=0.00185346f \
 //x=38.08 //y=3.865 //x2=38.08 //y2=4.635
cc_2540 ( N_noxref_7_c_2900_p N_CLK_c_5004_n ) capacitor c=0.00242901f \
 //x=28.68 //y=5.335 //x2=37.735 //y2=4.635
cc_2541 ( N_noxref_7_c_2754_n N_CLK_c_5004_n ) capacitor c=0.0206181f \
 //x=30.375 //y=5.335 //x2=37.735 //y2=4.635
cc_2542 ( N_noxref_7_c_2787_n N_CLK_c_5004_n ) capacitor c=0.0298618f \
 //x=30.46 //y=5.25 //x2=37.735 //y2=4.635
cc_2543 ( N_noxref_7_c_2795_n N_CLK_c_5004_n ) capacitor c=0.0317543f \
 //x=32.31 //y=4.755 //x2=37.735 //y2=4.635
cc_2544 ( N_noxref_7_c_2898_p N_CLK_c_5004_n ) capacitor c=0.0278748f \
 //x=27.922 //y=5.335 //x2=37.735 //y2=4.635
cc_2545 ( N_noxref_7_c_2963_p N_CLK_c_5004_n ) capacitor c=0.0403966f //x=28.8 \
 //y=5.335 //x2=37.735 //y2=4.635
cc_2546 ( N_noxref_7_c_2800_n N_CLK_c_5004_n ) capacitor c=0.00757951f \
 //x=32.155 //y=3.88 //x2=37.735 //y2=4.635
cc_2547 ( N_noxref_7_c_2802_n N_CLK_c_5004_n ) capacitor c=0.00651789f \
 //x=35.49 //y=3.895 //x2=37.735 //y2=4.635
cc_2548 ( N_noxref_7_c_2805_n N_CLK_c_5004_n ) capacitor c=0.0204024f \
 //x=35.145 //y=3.895 //x2=37.735 //y2=4.635
cc_2549 ( N_noxref_7_c_2809_n N_CLK_c_5004_n ) capacitor c=0.00369971f \
 //x=36.735 //y=3.88 //x2=37.735 //y2=4.635
cc_2550 ( N_noxref_7_c_2813_n N_CLK_c_5004_n ) capacitor c=0.00295169f \
 //x=37.335 //y=3.895 //x2=37.735 //y2=4.635
cc_2551 ( N_noxref_7_c_2862_p N_CLK_c_5098_n ) capacitor c=4.17734e-19 \
 //x=45.26 //y=4.755 //x2=43.63 //y2=4.64
cc_2552 ( N_noxref_7_c_2864_p N_CLK_c_5098_n ) capacitor c=0.00848127f \
 //x=43.63 //y=3.87 //x2=43.63 //y2=4.64
cc_2553 ( N_noxref_7_c_2835_n N_CLK_c_5050_n ) capacitor c=0.00442067f \
 //x=38.08 //y=3.865 //x2=43.285 //y2=4.64
cc_2554 ( N_noxref_7_c_2838_n N_CLK_c_5050_n ) capacitor c=0.00621235f \
 //x=38.815 //y=3.9 //x2=43.285 //y2=4.64
cc_2555 ( N_noxref_7_c_2841_n N_CLK_c_5050_n ) capacitor c=0.00307733f \
 //x=40.07 //y=3.88 //x2=43.285 //y2=4.64
cc_2556 ( N_noxref_7_c_2845_n N_CLK_c_5050_n ) capacitor c=0.0152567f \
 //x=40.67 //y=3.9 //x2=43.285 //y2=4.64
cc_2557 ( N_noxref_7_c_2863_p N_CLK_c_5050_n ) capacitor c=0.00167251f \
 //x=43.03 //y=3.88 //x2=43.285 //y2=4.64
cc_2558 ( N_noxref_7_c_2862_p N_CLK_c_5105_n ) capacitor c=0.031668f //x=45.26 \
 //y=4.755 //x2=50.415 //y2=4.62
cc_2559 ( N_noxref_7_c_2900_p N_CLK_c_5016_n ) capacitor c=0.00492634f \
 //x=28.68 //y=5.335 //x2=28.61 //y2=4.88
cc_2560 ( N_noxref_7_c_2963_p N_CLK_c_5016_n ) capacitor c=0.00132214f \
 //x=28.8 //y=5.335 //x2=28.61 //y2=4.88
cc_2561 ( N_noxref_7_c_2900_p N_CLK_M88_noxref_g ) capacitor c=0.00858222f \
 //x=28.68 //y=5.335 //x2=28.58 //y2=6.2
cc_2562 ( N_noxref_7_c_2963_p N_CLK_M88_noxref_g ) capacitor c=0.00229818f \
 //x=28.8 //y=5.335 //x2=28.58 //y2=6.2
cc_2563 ( N_noxref_7_c_2964_p N_CLK_M88_noxref_g ) capacitor c=0.0179041f \
 //x=28.8 //y=5.56 //x2=28.58 //y2=6.2
cc_2564 ( N_noxref_7_c_2749_n N_CLK_M89_noxref_g ) capacitor c=0.00955829f \
 //x=29.565 //y=5.335 //x2=29.02 //y2=6.2
cc_2565 ( N_noxref_7_c_2963_p N_CLK_M89_noxref_g ) capacitor c=0.00230699f \
 //x=28.8 //y=5.335 //x2=29.02 //y2=6.2
cc_2566 ( N_noxref_7_c_2964_p N_CLK_M89_noxref_g ) capacitor c=0.0179041f \
 //x=28.8 //y=5.56 //x2=29.02 //y2=6.2
cc_2567 ( N_noxref_7_c_2963_p N_CLK_c_5029_n ) capacitor c=0.00170733f \
 //x=28.8 //y=5.335 //x2=28.945 //y2=4.97
cc_2568 ( N_noxref_7_c_2964_p N_CLK_c_5029_n ) capacitor c=0.00293647f \
 //x=28.8 //y=5.56 //x2=28.945 //y2=4.97
cc_2569 ( N_noxref_7_c_2900_p N_CLK_c_5030_n ) capacitor c=3.54644e-19 \
 //x=28.68 //y=5.335 //x2=28.61 //y2=4.88
cc_2570 ( N_noxref_7_c_2860_p RN ) capacitor c=0.00152146f //x=45.26 //y=3.72 \
 //x2=42.67 //y2=3.51
cc_2571 ( N_noxref_7_c_2862_p RN ) capacitor c=0.00103263f //x=45.26 //y=4.755 \
 //x2=42.67 //y2=3.51
cc_2572 ( N_noxref_7_c_2863_p RN ) capacitor c=0.0249503f //x=43.03 //y=3.88 \
 //x2=42.67 //y2=3.51
cc_2573 ( N_noxref_7_c_2860_p RN ) capacitor c=0.0313679f //x=45.26 //y=3.72 \
 //x2=46.37 //y2=3.51
cc_2574 ( N_noxref_7_c_2861_p RN ) capacitor c=0.00763467f //x=45.26 //y=4.04 \
 //x2=46.37 //y2=3.51
cc_2575 ( N_noxref_7_c_2862_p RN ) capacitor c=0.0156666f //x=45.26 //y=4.755 \
 //x2=46.37 //y2=3.51
cc_2576 ( N_noxref_7_c_2851_p RN ) capacitor c=2.64774e-19 //x=45.25 //y=3.88 \
 //x2=46.37 //y2=3.51
cc_2577 ( N_noxref_7_c_2864_p RN ) capacitor c=0.00504644f //x=43.63 //y=3.87 \
 //x2=46.37 //y2=3.51
cc_2578 ( N_noxref_7_c_3004_p RN ) capacitor c=3.36194e-19 //x=45.26 //y=4.88 \
 //x2=46.37 //y2=3.51
cc_2579 ( N_noxref_7_c_2790_n N_RN_c_6509_n ) capacitor c=0.00139213f \
 //x=32.31 //y=3.72 //x2=34.53 //y2=4.75
cc_2580 ( N_noxref_7_c_2795_n N_RN_c_6509_n ) capacitor c=5.77971e-19 \
 //x=32.31 //y=4.755 //x2=34.53 //y2=4.75
cc_2581 ( N_noxref_7_c_2805_n N_RN_c_6509_n ) capacitor c=0.0223923f \
 //x=35.145 //y=3.895 //x2=34.53 //y2=4.75
cc_2582 ( N_noxref_7_c_2859_p N_RN_c_6587_n ) capacitor c=0.00799025f \
 //x=45.26 //y=2.375 //x2=46.37 //y2=2.515
cc_2583 ( N_noxref_7_c_2860_p N_RN_c_6587_n ) capacitor c=0.00291253f \
 //x=45.26 //y=3.72 //x2=46.37 //y2=2.515
cc_2584 ( N_noxref_7_c_3010_p N_RN_c_6587_n ) capacitor c=0.00120311f \
 //x=45.26 //y=2.26 //x2=46.37 //y2=2.515
cc_2585 ( N_noxref_7_c_3011_p N_RN_c_6587_n ) capacitor c=0.00159215f \
 //x=44.96 //y=2.095 //x2=46.37 //y2=2.515
cc_2586 ( N_noxref_7_c_2862_p N_RN_c_6591_n ) capacitor c=0.0110307f //x=45.26 \
 //y=4.755 //x2=46.37 //y2=4.765
cc_2587 ( N_noxref_7_c_3004_p N_RN_c_6591_n ) capacitor c=2.89813e-19 \
 //x=45.26 //y=4.88 //x2=46.37 //y2=4.765
cc_2588 ( N_noxref_7_c_2850_p N_RN_c_6591_n ) capacitor c=7.66769e-19 \
 //x=45.825 //y=4.97 //x2=46.37 //y2=4.765
cc_2589 ( N_noxref_7_c_3015_p N_RN_c_6591_n ) capacitor c=7.54501e-19 \
 //x=45.535 //y=4.97 //x2=46.37 //y2=4.765
cc_2590 ( N_noxref_7_c_2759_n N_RN_c_6386_n ) capacitor c=6.8859e-19 \
 //x=29.975 //y=1.305 //x2=33.205 //y2=2.37
cc_2591 ( N_noxref_7_c_2774_n N_RN_c_6386_n ) capacitor c=0.021157f //x=30.06 \
 //y=1.845 //x2=33.205 //y2=2.37
cc_2592 ( N_noxref_7_c_2775_n N_RN_c_6386_n ) capacitor c=0.027837f //x=30.46 \
 //y=3.725 //x2=33.205 //y2=2.37
cc_2593 ( N_noxref_7_c_2905_p N_RN_c_6386_n ) capacitor c=0.0179786f //x=32.31 \
 //y=2.375 //x2=33.205 //y2=2.37
cc_2594 ( N_noxref_7_c_2790_n N_RN_c_6386_n ) capacitor c=0.0144128f //x=32.31 \
 //y=3.72 //x2=33.205 //y2=2.37
cc_2595 ( N_noxref_7_c_2906_p N_RN_c_6386_n ) capacitor c=5.18204e-19 \
 //x=32.31 //y=2.26 //x2=33.205 //y2=2.37
cc_2596 ( N_noxref_7_c_2907_p N_RN_c_6386_n ) capacitor c=3.41298e-19 \
 //x=32.01 //y=2.095 //x2=33.205 //y2=2.37
cc_2597 ( N_noxref_7_c_2859_p N_RN_c_6602_n ) capacitor c=0.0168121f //x=45.26 \
 //y=2.375 //x2=46.165 //y2=2.4
cc_2598 ( N_noxref_7_c_2860_p N_RN_c_6602_n ) capacitor c=0.0141438f //x=45.26 \
 //y=3.72 //x2=46.165 //y2=2.4
cc_2599 ( N_noxref_7_c_3010_p N_RN_c_6602_n ) capacitor c=2.54369e-19 \
 //x=45.26 //y=2.26 //x2=46.165 //y2=2.4
cc_2600 ( N_noxref_7_c_3011_p N_RN_c_6602_n ) capacitor c=3.41298e-19 \
 //x=44.96 //y=2.095 //x2=46.165 //y2=2.4
cc_2601 ( N_noxref_7_c_2859_p N_RN_c_6606_n ) capacitor c=0.00279365f \
 //x=45.26 //y=2.375 //x2=59.105 //y2=2.385
cc_2602 ( N_noxref_7_c_2860_p N_RN_c_6606_n ) capacitor c=5.00559e-19 \
 //x=45.26 //y=3.72 //x2=59.105 //y2=2.385
cc_2603 ( N_noxref_7_c_2859_p N_RN_c_6608_n ) capacitor c=5.39999e-19 \
 //x=45.26 //y=2.375 //x2=46.37 //y2=2.26
cc_2604 ( N_noxref_7_c_3010_p N_RN_c_6608_n ) capacitor c=0.00124896f \
 //x=45.26 //y=2.26 //x2=46.37 //y2=2.26
cc_2605 ( N_noxref_7_c_3011_p N_RN_c_6608_n ) capacitor c=0.00214501f \
 //x=44.96 //y=2.095 //x2=46.37 //y2=2.26
cc_2606 ( N_noxref_7_c_2862_p N_RN_c_6611_n ) capacitor c=0.00103399f \
 //x=45.26 //y=4.755 //x2=46.37 //y2=4.88
cc_2607 ( N_noxref_7_c_3004_p N_RN_c_6611_n ) capacitor c=0.00113984f \
 //x=45.26 //y=4.88 //x2=46.37 //y2=4.88
cc_2608 ( N_noxref_7_c_2850_p N_RN_c_6611_n ) capacitor c=0.00116563f \
 //x=45.825 //y=4.97 //x2=46.37 //y2=4.88
cc_2609 ( N_noxref_7_c_3015_p N_RN_c_6611_n ) capacitor c=0.00129812f \
 //x=45.535 //y=4.97 //x2=46.37 //y2=4.88
cc_2610 ( N_noxref_7_M108_noxref_g N_RN_M110_noxref_g ) capacitor c=0.0106276f \
 //x=45.46 //y=6.2 //x2=46.34 //y2=6.2
cc_2611 ( N_noxref_7_M109_noxref_g N_RN_M110_noxref_g ) capacitor c=0.107144f \
 //x=45.9 //y=6.2 //x2=46.34 //y2=6.2
cc_2612 ( N_noxref_7_M109_noxref_g N_RN_M111_noxref_g ) capacitor c=0.0101598f \
 //x=45.9 //y=6.2 //x2=46.78 //y2=6.2
cc_2613 ( N_noxref_7_c_3039_p N_RN_c_6618_n ) capacitor c=5.72528e-19 \
 //x=44.96 //y=1.055 //x2=45.935 //y2=1.09
cc_2614 ( N_noxref_7_c_3040_p N_RN_c_6618_n ) capacitor c=0.00150277f \
 //x=44.96 //y=1.4 //x2=45.935 //y2=1.09
cc_2615 ( N_noxref_7_c_3041_p N_RN_c_6618_n ) capacitor c=0.0160123f //x=45.49 \
 //y=1.055 //x2=45.935 //y2=1.09
cc_2616 ( N_noxref_7_c_3042_p N_RN_c_6621_n ) capacitor c=0.00111227f \
 //x=44.96 //y=1.71 //x2=45.935 //y2=1.4
cc_2617 ( N_noxref_7_c_3043_p N_RN_c_6621_n ) capacitor c=0.0124075f //x=45.49 \
 //y=1.4 //x2=45.935 //y2=1.4
cc_2618 ( N_noxref_7_c_3041_p N_RN_c_6623_n ) capacitor c=9.19165e-19 \
 //x=45.49 //y=1.055 //x2=46.46 //y2=1.09
cc_2619 ( N_noxref_7_c_3043_p N_RN_c_6624_n ) capacitor c=0.0010154f //x=45.49 \
 //y=1.4 //x2=46.46 //y2=1.4
cc_2620 ( N_noxref_7_c_3043_p N_RN_c_6625_n ) capacitor c=9.23422e-19 \
 //x=45.49 //y=1.4 //x2=46.46 //y2=1.63
cc_2621 ( N_noxref_7_c_2859_p N_RN_c_6626_n ) capacitor c=3.54695e-19 \
 //x=45.26 //y=2.375 //x2=46.46 //y2=2.095
cc_2622 ( N_noxref_7_c_3010_p N_RN_c_6626_n ) capacitor c=0.00166305f \
 //x=45.26 //y=2.26 //x2=46.46 //y2=2.095
cc_2623 ( N_noxref_7_c_3011_p N_RN_c_6626_n ) capacitor c=0.00868554f \
 //x=44.96 //y=2.095 //x2=46.46 //y2=2.095
cc_2624 ( N_noxref_7_c_2862_p N_RN_c_6629_n ) capacitor c=0.00116212f \
 //x=45.26 //y=4.755 //x2=46.37 //y2=4.88
cc_2625 ( N_noxref_7_c_3004_p N_RN_c_6629_n ) capacitor c=0.00155973f \
 //x=45.26 //y=4.88 //x2=46.37 //y2=4.88
cc_2626 ( N_noxref_7_c_2850_p N_RN_c_6629_n ) capacitor c=0.0171374f \
 //x=45.825 //y=4.97 //x2=46.37 //y2=4.88
cc_2627 ( N_noxref_7_c_3015_p N_RN_c_6629_n ) capacitor c=0.00484466f \
 //x=45.535 //y=4.97 //x2=46.37 //y2=4.88
cc_2628 ( N_noxref_7_c_2860_p N_noxref_15_c_8552_n ) capacitor c=8.39657e-19 \
 //x=45.26 //y=3.72 //x2=47.48 //y2=3.365
cc_2629 ( N_noxref_7_c_2862_p N_noxref_15_c_8553_n ) capacitor c=5.77938e-19 \
 //x=45.26 //y=4.755 //x2=47.48 //y2=4.75
cc_2630 ( N_noxref_7_c_2766_n N_noxref_16_c_9903_n ) capacitor c=8.29536e-19 \
 //x=29.975 //y=1.76 //x2=25.565 //y2=1.835
cc_2631 ( N_noxref_7_c_2774_n N_noxref_16_c_9906_n ) capacitor c=8.29536e-19 \
 //x=30.06 //y=1.845 //x2=25.65 //y2=2.995
cc_2632 ( N_noxref_7_c_2898_p N_noxref_16_c_9914_n ) capacitor c=0.00261914f \
 //x=27.922 //y=5.335 //x2=25.65 //y2=5.295
cc_2633 ( N_noxref_7_c_2898_p N_noxref_16_c_9934_n ) capacitor c=5.0812e-19 \
 //x=27.922 //y=5.335 //x2=25.17 //y2=5.38
cc_2634 ( N_noxref_7_c_2775_n N_noxref_16_c_10009_n ) capacitor c=7.06471e-19 \
 //x=30.46 //y=3.725 //x2=29.935 //y2=3.125
cc_2635 ( N_noxref_7_c_2775_n N_noxref_16_c_10014_n ) capacitor c=0.0230457f \
 //x=30.46 //y=3.725 //x2=34.89 //y2=3.14
cc_2636 ( N_noxref_7_c_2790_n N_noxref_16_c_10014_n ) capacitor c=0.0246505f \
 //x=32.31 //y=3.72 //x2=34.89 //y2=3.14
cc_2637 ( N_noxref_7_c_2800_n N_noxref_16_c_10014_n ) capacitor c=0.0105804f \
 //x=32.155 //y=3.88 //x2=34.89 //y2=3.14
cc_2638 ( N_noxref_7_c_2805_n N_noxref_16_c_10014_n ) capacitor c=0.0226821f \
 //x=35.145 //y=3.895 //x2=34.89 //y2=3.14
cc_2639 ( N_noxref_7_c_2802_n N_noxref_16_c_10018_n ) capacitor c=0.0064155f \
 //x=35.49 //y=3.895 //x2=35.49 //y2=3.125
cc_2640 ( N_noxref_7_c_2809_n N_noxref_16_c_10022_n ) capacitor c=0.00868468f \
 //x=36.735 //y=3.88 //x2=36.735 //y2=3.14
cc_2641 ( N_noxref_7_c_2813_n N_noxref_16_c_10025_n ) capacitor c=0.0253228f \
 //x=37.335 //y=3.895 //x2=37.335 //y2=3.125
cc_2642 ( N_noxref_7_c_2835_n N_noxref_16_c_10028_n ) capacitor c=0.0247449f \
 //x=38.08 //y=3.865 //x2=38.21 //y2=3.14
cc_2643 ( N_noxref_7_c_2838_n N_noxref_16_c_10029_n ) capacitor c=0.00859283f \
 //x=38.815 //y=3.9 //x2=38.81 //y2=3.13
cc_2644 ( N_noxref_7_c_2841_n N_noxref_16_c_10033_n ) capacitor c=0.00879477f \
 //x=40.07 //y=3.88 //x2=40.07 //y2=3.14
cc_2645 ( N_noxref_7_c_2845_n N_noxref_16_c_10036_n ) capacitor c=0.0543931f \
 //x=40.67 //y=3.9 //x2=40.67 //y2=3.13
cc_2646 ( N_noxref_7_c_2860_p N_noxref_16_c_10055_n ) capacitor c=0.0269417f \
 //x=45.26 //y=3.72 //x2=55.235 //y2=3.14
cc_2647 ( N_noxref_7_c_2861_p N_noxref_16_c_10055_n ) capacitor c=0.00441923f \
 //x=45.26 //y=4.04 //x2=55.235 //y2=3.14
cc_2648 ( N_noxref_7_c_2863_p N_noxref_16_c_10055_n ) capacitor c=0.0778759f \
 //x=43.03 //y=3.88 //x2=55.235 //y2=3.14
cc_2649 ( N_noxref_7_c_2864_p N_noxref_16_c_10055_n ) capacitor c=0.0777753f \
 //x=43.63 //y=3.87 //x2=55.235 //y2=3.14
cc_2650 ( N_noxref_7_c_2900_p N_VDD_c_11464_n ) capacitor c=0.00599866f \
 //x=28.68 //y=5.335 //x2=78.895 //y2=7.585
cc_2651 ( N_noxref_7_c_2749_n N_VDD_c_11464_n ) capacitor c=0.00627191f \
 //x=29.565 //y=5.335 //x2=78.895 //y2=7.585
cc_2652 ( N_noxref_7_c_2751_n N_VDD_c_11464_n ) capacitor c=0.00256019f \
 //x=29.68 //y=5.56 //x2=78.895 //y2=7.585
cc_2653 ( N_noxref_7_c_2754_n N_VDD_c_11464_n ) capacitor c=0.00829248f \
 //x=30.375 //y=5.335 //x2=78.895 //y2=7.585
cc_2654 ( N_noxref_7_c_2785_n N_VDD_c_11464_n ) capacitor c=5.1373e-19 \
 //x=30.46 //y=4.045 //x2=78.895 //y2=7.585
cc_2655 ( N_noxref_7_c_2794_n N_VDD_c_11464_n ) capacitor c=3.34593e-19 \
 //x=32.31 //y=4.04 //x2=78.895 //y2=7.585
cc_2656 ( N_noxref_7_c_2861_p N_VDD_c_11464_n ) capacitor c=4.0659e-19 \
 //x=45.26 //y=4.04 //x2=78.895 //y2=7.585
cc_2657 ( N_noxref_7_c_2898_p N_VDD_c_11464_n ) capacitor c=0.00261804f \
 //x=27.922 //y=5.335 //x2=78.895 //y2=7.585
cc_2658 ( N_noxref_7_c_2963_p N_VDD_c_11464_n ) capacitor c=0.00262723f \
 //x=28.8 //y=5.335 //x2=78.895 //y2=7.585
cc_2659 ( N_noxref_7_c_2899_p N_VDD_c_11464_n ) capacitor c=0.0024232f \
 //x=27.92 //y=5.56 //x2=78.895 //y2=7.585
cc_2660 ( N_noxref_7_c_2964_p N_VDD_c_11464_n ) capacitor c=0.0024232f \
 //x=28.8 //y=5.56 //x2=78.895 //y2=7.585
cc_2661 ( N_noxref_7_c_2817_n N_VDD_c_11464_n ) capacitor c=0.0024232f \
 //x=29.68 //y=5.56 //x2=78.895 //y2=7.585
cc_2662 ( N_noxref_7_c_2900_p N_VDD_c_11904_n ) capacitor c=0.00202922f \
 //x=28.68 //y=5.335 //x2=28.275 //y2=7.585
cc_2663 ( N_noxref_7_c_2898_p N_VDD_c_11904_n ) capacitor c=9.3757e-19 \
 //x=27.922 //y=5.335 //x2=28.275 //y2=7.585
cc_2664 ( N_noxref_7_c_2899_p N_VDD_c_11904_n ) capacitor c=0.0138074f \
 //x=27.92 //y=5.56 //x2=28.275 //y2=7.585
cc_2665 ( N_noxref_7_c_2900_p N_VDD_c_11907_n ) capacitor c=0.0017708f \
 //x=28.68 //y=5.335 //x2=29.155 //y2=7.585
cc_2666 ( N_noxref_7_c_2749_n N_VDD_c_11907_n ) capacitor c=0.00202922f \
 //x=29.565 //y=5.335 //x2=29.155 //y2=7.585
cc_2667 ( N_noxref_7_c_2963_p N_VDD_c_11907_n ) capacitor c=9.4822e-19 \
 //x=28.8 //y=5.335 //x2=29.155 //y2=7.585
cc_2668 ( N_noxref_7_c_2964_p N_VDD_c_11907_n ) capacitor c=0.0138074f \
 //x=28.8 //y=5.56 //x2=29.155 //y2=7.585
cc_2669 ( N_noxref_7_c_2749_n N_VDD_c_11796_n ) capacitor c=0.00205906f \
 //x=29.565 //y=5.335 //x2=30.035 //y2=7.585
cc_2670 ( N_noxref_7_c_2751_n N_VDD_c_11796_n ) capacitor c=8.49654e-19 \
 //x=29.68 //y=5.56 //x2=30.035 //y2=7.585
cc_2671 ( N_noxref_7_c_2754_n N_VDD_c_11796_n ) capacitor c=0.00204238f \
 //x=30.375 //y=5.335 //x2=30.035 //y2=7.585
cc_2672 ( N_noxref_7_c_2817_n N_VDD_c_11796_n ) capacitor c=0.0138074f \
 //x=29.68 //y=5.56 //x2=30.035 //y2=7.585
cc_2673 ( N_noxref_7_c_2754_n N_VDD_c_11915_n ) capacitor c=0.00183742f \
 //x=30.375 //y=5.335 //x2=31.03 //y2=7.585
cc_2674 ( N_noxref_7_M92_noxref_g N_VDD_c_11798_n ) capacitor c=0.00755614f \
 //x=32.51 //y=6.2 //x2=33.085 //y2=7.585
cc_2675 ( N_noxref_7_M93_noxref_g N_VDD_c_11798_n ) capacitor c=0.00755544f \
 //x=32.95 //y=6.2 //x2=33.085 //y2=7.585
cc_2676 ( N_noxref_7_M108_noxref_g N_VDD_c_11918_n ) capacitor c=0.00755614f \
 //x=45.46 //y=6.2 //x2=46.035 //y2=7.585
cc_2677 ( N_noxref_7_M109_noxref_g N_VDD_c_11918_n ) capacitor c=0.00755544f \
 //x=45.9 //y=6.2 //x2=46.035 //y2=7.585
cc_2678 ( N_noxref_7_c_2898_p N_VDD_c_11735_n ) capacitor c=0.0022955f \
 //x=27.922 //y=5.335 //x2=26.39 //y2=7.585
cc_2679 ( N_noxref_7_c_2899_p N_VDD_c_11735_n ) capacitor c=0.00508013f \
 //x=27.92 //y=5.56 //x2=26.39 //y2=7.585
cc_2680 ( N_noxref_7_c_2751_n N_VDD_c_11813_n ) capacitor c=0.00282782f \
 //x=29.68 //y=5.56 //x2=31.2 //y2=7.585
cc_2681 ( N_noxref_7_c_2787_n N_VDD_c_11813_n ) capacitor c=0.0325571f \
 //x=30.46 //y=5.25 //x2=31.2 //y2=7.585
cc_2682 ( N_noxref_7_c_2795_n N_VDD_c_11813_n ) capacitor c=0.0118976f \
 //x=32.31 //y=4.755 //x2=31.2 //y2=7.585
cc_2683 ( N_noxref_7_c_2817_n N_VDD_c_11813_n ) capacitor c=0.00777981f \
 //x=29.68 //y=5.56 //x2=31.2 //y2=7.585
cc_2684 ( N_noxref_7_c_2919_p N_VDD_c_11813_n ) capacitor c=0.00370784f \
 //x=32.31 //y=4.88 //x2=31.2 //y2=7.585
cc_2685 ( N_noxref_7_c_2921_p N_VDD_c_11813_n ) capacitor c=0.00590568f \
 //x=32.585 //y=4.97 //x2=31.2 //y2=7.585
cc_2686 ( N_noxref_7_c_2862_p N_VDD_c_11928_n ) capacitor c=0.0116306f \
 //x=45.26 //y=4.755 //x2=44.15 //y2=7.585
cc_2687 ( N_noxref_7_c_3004_p N_VDD_c_11928_n ) capacitor c=0.00370784f \
 //x=45.26 //y=4.88 //x2=44.15 //y2=7.585
cc_2688 ( N_noxref_7_c_3015_p N_VDD_c_11928_n ) capacitor c=0.00590568f \
 //x=45.535 //y=4.97 //x2=44.15 //y2=7.585
cc_2689 ( N_noxref_7_c_2898_p N_VDD_M82_noxref_s ) capacitor c=4.22189e-19 \
 //x=27.922 //y=5.335 //x2=23.715 //y2=5.2
cc_2690 ( N_noxref_7_c_2898_p N_VDD_M86_noxref_s ) capacitor c=0.0442713f \
 //x=27.922 //y=5.335 //x2=27.345 //y2=5.2
cc_2691 ( N_noxref_7_c_2963_p N_VDD_M86_noxref_s ) capacitor c=7.80122e-19 \
 //x=28.8 //y=5.335 //x2=27.345 //y2=5.2
cc_2692 ( N_noxref_7_c_2899_p N_VDD_M86_noxref_s ) capacitor c=0.0908457f \
 //x=27.92 //y=5.56 //x2=27.345 //y2=5.2
cc_2693 ( N_noxref_7_c_2900_p N_VDD_M87_noxref_d ) capacitor c=0.00700141f \
 //x=28.68 //y=5.335 //x2=28.215 //y2=5.2
cc_2694 ( N_noxref_7_c_2899_p N_VDD_M87_noxref_d ) capacitor c=0.0673792f \
 //x=27.92 //y=5.56 //x2=28.215 //y2=5.2
cc_2695 ( N_noxref_7_c_2964_p N_VDD_M87_noxref_d ) capacitor c=0.0674762f \
 //x=28.8 //y=5.56 //x2=28.215 //y2=5.2
cc_2696 ( N_noxref_7_c_2749_n N_VDD_M89_noxref_d ) capacitor c=0.00700141f \
 //x=29.565 //y=5.335 //x2=29.095 //y2=5.2
cc_2697 ( N_noxref_7_c_2964_p N_VDD_M89_noxref_d ) capacitor c=0.067493f \
 //x=28.8 //y=5.56 //x2=29.095 //y2=5.2
cc_2698 ( N_noxref_7_c_2817_n N_VDD_M89_noxref_d ) capacitor c=0.0674979f \
 //x=29.68 //y=5.56 //x2=29.095 //y2=5.2
cc_2699 ( N_noxref_7_c_2754_n N_VDD_M91_noxref_d ) capacitor c=0.00700141f \
 //x=30.375 //y=5.335 //x2=29.975 //y2=5.2
cc_2700 ( N_noxref_7_c_2817_n N_VDD_M91_noxref_d ) capacitor c=0.0675002f \
 //x=29.68 //y=5.56 //x2=29.975 //y2=5.2
cc_2701 ( N_noxref_7_c_2751_n N_VDD_M92_noxref_s ) capacitor c=0.00492616f \
 //x=29.68 //y=5.56 //x2=32.155 //y2=5.2
cc_2702 ( N_noxref_7_c_2754_n N_VDD_M92_noxref_s ) capacitor c=9.42705e-19 \
 //x=30.375 //y=5.335 //x2=32.155 //y2=5.2
cc_2703 ( N_noxref_7_c_2794_n N_VDD_M92_noxref_s ) capacitor c=7.08613e-19 \
 //x=32.31 //y=4.04 //x2=32.155 //y2=5.2
cc_2704 ( N_noxref_7_c_2795_n N_VDD_M92_noxref_s ) capacitor c=0.0217981f \
 //x=32.31 //y=4.755 //x2=32.155 //y2=5.2
cc_2705 ( N_noxref_7_c_2963_p N_VDD_M92_noxref_s ) capacitor c=2.11884e-19 \
 //x=28.8 //y=5.335 //x2=32.155 //y2=5.2
cc_2706 ( N_noxref_7_c_2919_p N_VDD_M92_noxref_s ) capacitor c=0.00983846f \
 //x=32.31 //y=4.88 //x2=32.155 //y2=5.2
cc_2707 ( N_noxref_7_M92_noxref_g N_VDD_M92_noxref_s ) capacitor c=0.053419f \
 //x=32.51 //y=6.2 //x2=32.155 //y2=5.2
cc_2708 ( N_noxref_7_c_2921_p N_VDD_M92_noxref_s ) capacitor c=0.00604424f \
 //x=32.585 //y=4.97 //x2=32.155 //y2=5.2
cc_2709 ( N_noxref_7_M93_noxref_g N_VDD_M93_noxref_d ) capacitor c=0.015318f \
 //x=32.95 //y=6.2 //x2=33.025 //y2=5.2
cc_2710 ( N_noxref_7_c_2861_p N_VDD_M108_noxref_s ) capacitor c=7.08613e-19 \
 //x=45.26 //y=4.04 //x2=45.105 //y2=5.2
cc_2711 ( N_noxref_7_c_2862_p N_VDD_M108_noxref_s ) capacitor c=0.0217981f \
 //x=45.26 //y=4.755 //x2=45.105 //y2=5.2
cc_2712 ( N_noxref_7_c_3004_p N_VDD_M108_noxref_s ) capacitor c=0.00983846f \
 //x=45.26 //y=4.88 //x2=45.105 //y2=5.2
cc_2713 ( N_noxref_7_M108_noxref_g N_VDD_M108_noxref_s ) capacitor c=0.053419f \
 //x=45.46 //y=6.2 //x2=45.105 //y2=5.2
cc_2714 ( N_noxref_7_c_3015_p N_VDD_M108_noxref_s ) capacitor c=0.00604424f \
 //x=45.535 //y=4.97 //x2=45.105 //y2=5.2
cc_2715 ( N_noxref_7_M109_noxref_g N_VDD_M109_noxref_d ) capacitor c=0.015318f \
 //x=45.9 //y=6.2 //x2=45.975 //y2=5.2
cc_2716 ( N_noxref_7_c_2759_n N_noxref_24_c_13128_n ) capacitor c=0.0036878f \
 //x=29.975 //y=1.305 //x2=30.375 //y2=0.72
cc_2717 ( N_noxref_7_c_2771_n N_noxref_24_c_13128_n ) capacitor c=0.00399931f \
 //x=30.375 //y=1.845 //x2=30.375 //y2=0.72
cc_2718 ( N_noxref_7_M18_noxref_d N_noxref_24_c_13128_n ) capacitor \
 c=0.00910163f //x=29.785 //y=1.095 //x2=30.375 //y2=0.72
cc_2719 ( N_noxref_7_M18_noxref_d N_noxref_24_c_13133_n ) capacitor \
 c=0.00120711f //x=29.785 //y=1.095 //x2=29.49 //y2=1.175
cc_2720 ( N_noxref_7_c_2900_p N_noxref_24_M17_noxref_d ) capacitor \
 c=0.0014854f //x=28.68 //y=5.335 //x2=28.25 //y2=1.09
cc_2721 ( N_noxref_7_c_2759_n N_noxref_24_M17_noxref_d ) capacitor \
 c=0.00802417f //x=29.975 //y=1.305 //x2=28.25 //y2=1.09
cc_2722 ( N_noxref_7_c_2759_n N_noxref_24_M18_noxref_s ) capacitor \
 c=0.0098487f //x=29.975 //y=1.305 //x2=29.355 //y2=0.555
cc_2723 ( N_noxref_7_c_2766_n N_noxref_24_M18_noxref_s ) capacitor \
 c=0.0283111f //x=29.975 //y=1.76 //x2=29.355 //y2=0.555
cc_2724 ( N_noxref_7_c_2771_n N_noxref_24_M18_noxref_s ) capacitor \
 c=0.00911719f //x=30.375 //y=1.845 //x2=29.355 //y2=0.555
cc_2725 ( N_noxref_7_c_2799_n N_noxref_24_M18_noxref_s ) capacitor \
 c=0.00129723f //x=30.46 //y=3.88 //x2=29.355 //y2=0.555
cc_2726 ( N_noxref_7_M18_noxref_d N_noxref_24_M18_noxref_s ) capacitor \
 c=0.0279003f //x=29.785 //y=1.095 //x2=29.355 //y2=0.555
cc_2727 ( N_noxref_7_c_2759_n N_noxref_25_M20_noxref_d ) capacitor \
 c=3.20746e-19 //x=29.975 //y=1.305 //x2=33.06 //y2=1.09
cc_2728 ( N_noxref_7_c_2759_n N_GND_c_14171_n ) capacitor c=0.00884249f \
 //x=29.975 //y=1.305 //x2=32.19 //y2=0.175
cc_2729 ( N_noxref_7_c_2771_n N_GND_c_14171_n ) capacitor c=0.00662992f \
 //x=30.375 //y=1.845 //x2=32.19 //y2=0.175
cc_2730 ( N_noxref_7_c_2785_n N_GND_c_14171_n ) capacitor c=3.10289e-19 \
 //x=30.46 //y=4.045 //x2=32.19 //y2=0.175
cc_2731 ( N_noxref_7_M18_noxref_d N_GND_c_14171_n ) capacitor c=2.9462e-19 \
 //x=29.785 //y=1.095 //x2=32.19 //y2=0.175
cc_2732 ( N_noxref_7_c_2943_p N_GND_c_14254_n ) capacitor c=3.97665e-19 \
 //x=32.01 //y=1.055 //x2=32.275 //y2=1.015
cc_2733 ( N_noxref_7_c_3159_p N_GND_c_14254_n ) capacitor c=0.00864776f \
 //x=32.385 //y=0.9 //x2=32.275 //y2=1.015
cc_2734 ( N_noxref_7_c_2945_p N_GND_c_14254_n ) capacitor c=4.45447e-19 \
 //x=32.54 //y=1.055 //x2=32.275 //y2=1.015
cc_2735 ( N_noxref_7_c_3039_p N_GND_c_14257_n ) capacitor c=3.97665e-19 \
 //x=44.96 //y=1.055 //x2=45.225 //y2=1.015
cc_2736 ( N_noxref_7_c_3162_p N_GND_c_14257_n ) capacitor c=0.00864776f \
 //x=45.335 //y=0.9 //x2=45.225 //y2=1.015
cc_2737 ( N_noxref_7_c_3041_p N_GND_c_14257_n ) capacitor c=4.45447e-19 \
 //x=45.49 //y=1.055 //x2=45.225 //y2=1.015
cc_2738 ( N_noxref_7_c_2759_n N_GND_c_14260_n ) capacitor c=0.00543195f \
 //x=29.975 //y=1.305 //x2=32.275 //y2=1.145
cc_2739 ( N_noxref_7_c_2905_p N_GND_c_14260_n ) capacitor c=0.00772482f \
 //x=32.31 //y=2.375 //x2=32.275 //y2=1.145
cc_2740 ( N_noxref_7_c_2794_n N_GND_c_14260_n ) capacitor c=5.12587e-19 \
 //x=32.31 //y=4.04 //x2=32.275 //y2=1.145
cc_2741 ( N_noxref_7_c_2906_p N_GND_c_14260_n ) capacitor c=2.22883e-19 \
 //x=32.31 //y=2.26 //x2=32.275 //y2=1.145
cc_2742 ( N_noxref_7_c_2943_p N_GND_c_14260_n ) capacitor c=0.00156339f \
 //x=32.01 //y=1.055 //x2=32.275 //y2=1.145
cc_2743 ( N_noxref_7_c_2944_p N_GND_c_14260_n ) capacitor c=0.00352472f \
 //x=32.01 //y=1.4 //x2=32.275 //y2=1.145
cc_2744 ( N_noxref_7_c_2946_p N_GND_c_14260_n ) capacitor c=4.63388e-19 \
 //x=32.01 //y=1.71 //x2=32.275 //y2=1.145
cc_2745 ( N_noxref_7_c_3159_p N_GND_c_14260_n ) capacitor c=9.36995e-19 \
 //x=32.385 //y=0.9 //x2=32.275 //y2=1.145
cc_2746 ( N_noxref_7_c_3172_p N_GND_c_14260_n ) capacitor c=5.96388e-19 \
 //x=32.385 //y=1.555 //x2=32.275 //y2=1.145
cc_2747 ( N_noxref_7_c_2945_p N_GND_c_14260_n ) capacitor c=0.0017438f \
 //x=32.54 //y=1.055 //x2=32.275 //y2=1.145
cc_2748 ( N_noxref_7_c_2947_p N_GND_c_14260_n ) capacitor c=0.00276804f \
 //x=32.54 //y=1.4 //x2=32.275 //y2=1.145
cc_2749 ( N_noxref_7_c_2859_p N_GND_c_14271_n ) capacitor c=0.00772482f \
 //x=45.26 //y=2.375 //x2=45.225 //y2=1.145
cc_2750 ( N_noxref_7_c_2861_p N_GND_c_14271_n ) capacitor c=6.6735e-19 \
 //x=45.26 //y=4.04 //x2=45.225 //y2=1.145
cc_2751 ( N_noxref_7_c_3010_p N_GND_c_14271_n ) capacitor c=2.22883e-19 \
 //x=45.26 //y=2.26 //x2=45.225 //y2=1.145
cc_2752 ( N_noxref_7_c_3039_p N_GND_c_14271_n ) capacitor c=0.00156339f \
 //x=44.96 //y=1.055 //x2=45.225 //y2=1.145
cc_2753 ( N_noxref_7_c_3040_p N_GND_c_14271_n ) capacitor c=0.00352472f \
 //x=44.96 //y=1.4 //x2=45.225 //y2=1.145
cc_2754 ( N_noxref_7_c_3042_p N_GND_c_14271_n ) capacitor c=4.40631e-19 \
 //x=44.96 //y=1.71 //x2=45.225 //y2=1.145
cc_2755 ( N_noxref_7_c_3162_p N_GND_c_14271_n ) capacitor c=9.36995e-19 \
 //x=45.335 //y=0.9 //x2=45.225 //y2=1.145
cc_2756 ( N_noxref_7_c_3182_p N_GND_c_14271_n ) capacitor c=5.96388e-19 \
 //x=45.335 //y=1.555 //x2=45.225 //y2=1.145
cc_2757 ( N_noxref_7_c_3041_p N_GND_c_14271_n ) capacitor c=0.0017438f \
 //x=45.49 //y=1.055 //x2=45.225 //y2=1.145
cc_2758 ( N_noxref_7_c_3043_p N_GND_c_14271_n ) capacitor c=0.00276804f \
 //x=45.49 //y=1.4 //x2=45.225 //y2=1.145
cc_2759 ( N_noxref_7_c_2771_n N_GND_c_14189_n ) capacitor c=6.86343e-19 \
 //x=30.375 //y=1.845 //x2=31.03 //y2=0.175
cc_2760 ( N_noxref_7_c_2943_p N_GND_c_14190_n ) capacitor c=0.00677766f \
 //x=32.01 //y=1.055 //x2=35.84 //y2=0.175
cc_2761 ( N_noxref_7_c_3039_p N_GND_c_14283_n ) capacitor c=0.00677766f \
 //x=44.96 //y=1.055 //x2=48.79 //y2=0.175
cc_2762 ( N_noxref_7_c_2766_n N_GND_c_14193_n ) capacitor c=0.0045138f \
 //x=29.975 //y=1.76 //x2=31.2 //y2=0.175
cc_2763 ( N_noxref_7_c_2771_n N_GND_c_14193_n ) capacitor c=0.030601f \
 //x=30.375 //y=1.845 //x2=31.2 //y2=0.175
cc_2764 ( N_noxref_7_c_2905_p N_GND_c_14193_n ) capacitor c=0.00380125f \
 //x=32.31 //y=2.375 //x2=31.2 //y2=0.175
cc_2765 ( N_noxref_7_c_2790_n N_GND_c_14193_n ) capacitor c=0.00731521f \
 //x=32.31 //y=3.72 //x2=31.2 //y2=0.175
cc_2766 ( N_noxref_7_c_2906_p N_GND_c_14193_n ) capacitor c=0.00379567f \
 //x=32.31 //y=2.26 //x2=31.2 //y2=0.175
cc_2767 ( N_noxref_7_c_2946_p N_GND_c_14193_n ) capacitor c=0.00170145f \
 //x=32.01 //y=1.71 //x2=31.2 //y2=0.175
cc_2768 ( N_noxref_7_c_2907_p N_GND_c_14193_n ) capacitor c=0.0102191f \
 //x=32.01 //y=2.095 //x2=31.2 //y2=0.175
cc_2769 ( N_noxref_7_c_2859_p N_GND_c_14291_n ) capacitor c=0.00380125f \
 //x=45.26 //y=2.375 //x2=44.15 //y2=0.175
cc_2770 ( N_noxref_7_c_2860_p N_GND_c_14291_n ) capacitor c=0.00870608f \
 //x=45.26 //y=3.72 //x2=44.15 //y2=0.175
cc_2771 ( N_noxref_7_c_3010_p N_GND_c_14291_n ) capacitor c=0.00379567f \
 //x=45.26 //y=2.26 //x2=44.15 //y2=0.175
cc_2772 ( N_noxref_7_c_3042_p N_GND_c_14291_n ) capacitor c=0.00170145f \
 //x=44.96 //y=1.71 //x2=44.15 //y2=0.175
cc_2773 ( N_noxref_7_c_3011_p N_GND_c_14291_n ) capacitor c=0.0102191f \
 //x=44.96 //y=2.095 //x2=44.15 //y2=0.175
cc_2774 ( N_noxref_7_c_2905_p N_GND_M19_noxref_d ) capacitor c=4.4417e-19 \
 //x=32.31 //y=2.375 //x2=32.085 //y2=1.055
cc_2775 ( N_noxref_7_c_2943_p N_GND_M19_noxref_d ) capacitor c=0.00184354f \
 //x=32.01 //y=1.055 //x2=32.085 //y2=1.055
cc_2776 ( N_noxref_7_c_2944_p N_GND_M19_noxref_d ) capacitor c=0.00210798f \
 //x=32.01 //y=1.4 //x2=32.085 //y2=1.055
cc_2777 ( N_noxref_7_c_3159_p N_GND_M19_noxref_d ) capacitor c=0.00474029f \
 //x=32.385 //y=0.9 //x2=32.085 //y2=1.055
cc_2778 ( N_noxref_7_c_3172_p N_GND_M19_noxref_d ) capacitor c=0.00166857f \
 //x=32.385 //y=1.555 //x2=32.085 //y2=1.055
cc_2779 ( N_noxref_7_c_2945_p N_GND_M19_noxref_d ) capacitor c=0.00230174f \
 //x=32.54 //y=1.055 //x2=32.085 //y2=1.055
cc_2780 ( N_noxref_7_c_2947_p N_GND_M19_noxref_d ) capacitor c=0.00210798f \
 //x=32.54 //y=1.4 //x2=32.085 //y2=1.055
cc_2781 ( N_noxref_7_c_2859_p N_GND_M27_noxref_d ) capacitor c=4.4417e-19 \
 //x=45.26 //y=2.375 //x2=45.035 //y2=1.055
cc_2782 ( N_noxref_7_c_3039_p N_GND_M27_noxref_d ) capacitor c=0.00184354f \
 //x=44.96 //y=1.055 //x2=45.035 //y2=1.055
cc_2783 ( N_noxref_7_c_3040_p N_GND_M27_noxref_d ) capacitor c=0.00210798f \
 //x=44.96 //y=1.4 //x2=45.035 //y2=1.055
cc_2784 ( N_noxref_7_c_3162_p N_GND_M27_noxref_d ) capacitor c=0.00474029f \
 //x=45.335 //y=0.9 //x2=45.035 //y2=1.055
cc_2785 ( N_noxref_7_c_3182_p N_GND_M27_noxref_d ) capacitor c=0.00166857f \
 //x=45.335 //y=1.555 //x2=45.035 //y2=1.055
cc_2786 ( N_noxref_7_c_3041_p N_GND_M27_noxref_d ) capacitor c=0.00230174f \
 //x=45.49 //y=1.055 //x2=45.035 //y2=1.055
cc_2787 ( N_noxref_7_c_3043_p N_GND_M27_noxref_d ) capacitor c=0.00210798f \
 //x=45.49 //y=1.4 //x2=45.035 //y2=1.055
cc_2788 ( N_noxref_7_c_2907_p N_noxref_42_c_15957_n ) capacitor c=0.00262672f \
 //x=32.01 //y=2.095 //x2=31.79 //y2=1.685
cc_2789 ( N_noxref_7_c_2905_p N_noxref_42_c_15958_n ) capacitor c=0.00428451f \
 //x=32.31 //y=2.375 //x2=32.675 //y2=1.77
cc_2790 ( N_noxref_7_c_2794_n N_noxref_42_c_15958_n ) capacitor c=0.00142431f \
 //x=32.31 //y=4.04 //x2=32.675 //y2=1.77
cc_2791 ( N_noxref_7_c_2906_p N_noxref_42_c_15958_n ) capacitor c=0.0104666f \
 //x=32.31 //y=2.26 //x2=32.675 //y2=1.77
cc_2792 ( N_noxref_7_c_2946_p N_noxref_42_c_15958_n ) capacitor c=0.00705077f \
 //x=32.01 //y=1.71 //x2=32.675 //y2=1.77
cc_2793 ( N_noxref_7_c_2907_p N_noxref_42_c_15958_n ) capacitor c=0.020708f \
 //x=32.01 //y=2.095 //x2=32.675 //y2=1.77
cc_2794 ( N_noxref_7_c_3172_p N_noxref_42_c_15958_n ) capacitor c=0.00588627f \
 //x=32.385 //y=1.555 //x2=32.675 //y2=1.77
cc_2795 ( N_noxref_7_c_2947_p N_noxref_42_c_15958_n ) capacitor c=0.00698822f \
 //x=32.54 //y=1.4 //x2=32.675 //y2=1.77
cc_2796 ( N_noxref_7_c_2943_p N_noxref_42_M19_noxref_s ) capacitor \
 c=0.0295256f //x=32.01 //y=1.055 //x2=31.655 //y2=0.555
cc_2797 ( N_noxref_7_c_2946_p N_noxref_42_M19_noxref_s ) capacitor \
 c=7.99997e-19 //x=32.01 //y=1.71 //x2=31.655 //y2=0.555
cc_2798 ( N_noxref_7_c_2907_p N_noxref_42_M19_noxref_s ) capacitor \
 c=0.00122123f //x=32.01 //y=2.095 //x2=31.655 //y2=0.555
cc_2799 ( N_noxref_7_c_2945_p N_noxref_42_M19_noxref_s ) capacitor \
 c=0.0125924f //x=32.54 //y=1.055 //x2=31.655 //y2=0.555
cc_2800 ( N_noxref_7_c_3011_p N_noxref_45_c_16142_n ) capacitor c=0.00262672f \
 //x=44.96 //y=2.095 //x2=44.74 //y2=1.685
cc_2801 ( N_noxref_7_c_2859_p N_noxref_45_c_16143_n ) capacitor c=0.00428451f \
 //x=45.26 //y=2.375 //x2=45.625 //y2=1.77
cc_2802 ( N_noxref_7_c_2861_p N_noxref_45_c_16143_n ) capacitor c=0.00205403f \
 //x=45.26 //y=4.04 //x2=45.625 //y2=1.77
cc_2803 ( N_noxref_7_c_3010_p N_noxref_45_c_16143_n ) capacitor c=0.0104666f \
 //x=45.26 //y=2.26 //x2=45.625 //y2=1.77
cc_2804 ( N_noxref_7_c_3042_p N_noxref_45_c_16143_n ) capacitor c=0.00705077f \
 //x=44.96 //y=1.71 //x2=45.625 //y2=1.77
cc_2805 ( N_noxref_7_c_3011_p N_noxref_45_c_16143_n ) capacitor c=0.020708f \
 //x=44.96 //y=2.095 //x2=45.625 //y2=1.77
cc_2806 ( N_noxref_7_c_3182_p N_noxref_45_c_16143_n ) capacitor c=0.00588627f \
 //x=45.335 //y=1.555 //x2=45.625 //y2=1.77
cc_2807 ( N_noxref_7_c_3043_p N_noxref_45_c_16143_n ) capacitor c=0.00698822f \
 //x=45.49 //y=1.4 //x2=45.625 //y2=1.77
cc_2808 ( N_noxref_7_c_3039_p N_noxref_45_M27_noxref_s ) capacitor \
 c=0.0295256f //x=44.96 //y=1.055 //x2=44.605 //y2=0.555
cc_2809 ( N_noxref_7_c_3042_p N_noxref_45_M27_noxref_s ) capacitor \
 c=7.99997e-19 //x=44.96 //y=1.71 //x2=44.605 //y2=0.555
cc_2810 ( N_noxref_7_c_3011_p N_noxref_45_M27_noxref_s ) capacitor \
 c=0.00122123f //x=44.96 //y=2.095 //x2=44.605 //y2=0.555
cc_2811 ( N_noxref_7_c_3041_p N_noxref_45_M27_noxref_s ) capacitor \
 c=0.0125924f //x=45.49 //y=1.055 //x2=44.605 //y2=0.555
cc_2812 ( N_noxref_8_c_3239_n N_noxref_9_c_3707_n ) capacitor c=6.09703e-19 \
 //x=45.682 //y=5.335 //x2=42.63 //y2=5.56
cc_2813 ( N_noxref_8_c_3239_n N_noxref_9_c_3708_n ) capacitor c=0.00306432f \
 //x=45.682 //y=5.335 //x2=43.325 //y2=5.335
cc_2814 ( N_noxref_8_c_3248_p N_noxref_9_c_3709_n ) capacitor c=0.00163399f \
 //x=47.82 //y=1.845 //x2=43.325 //y2=1.845
cc_2815 ( N_noxref_8_c_3249_p N_noxref_9_c_3710_n ) capacitor c=0.00171715f \
 //x=48.22 //y=3.705 //x2=50.81 //y2=4.095
cc_2816 ( N_noxref_8_c_3250_p N_noxref_9_c_3710_n ) capacitor c=0.0496125f \
 //x=50.07 //y=3.705 //x2=50.81 //y2=4.095
cc_2817 ( N_noxref_8_c_3251_p N_noxref_9_c_3710_n ) capacitor c=0.0146405f \
 //x=50.07 //y=4.025 //x2=50.81 //y2=4.095
cc_2818 ( N_noxref_8_c_3252_p N_noxref_9_c_3710_n ) capacitor c=7.6985e-19 \
 //x=50.07 //y=3.88 //x2=50.81 //y2=4.095
cc_2819 ( N_noxref_8_c_3253_p N_noxref_9_c_3710_n ) capacitor c=0.00302581f \
 //x=50.072 //y=4.74 //x2=50.81 //y2=4.095
cc_2820 ( N_noxref_8_c_3254_p N_noxref_9_c_3710_n ) capacitor c=0.0067743f \
 //x=50.055 //y=3.865 //x2=50.81 //y2=4.095
cc_2821 ( N_noxref_8_c_3255_p N_noxref_9_c_3710_n ) capacitor c=3.30333e-19 \
 //x=50.07 //y=2.26 //x2=50.81 //y2=4.095
cc_2822 ( N_noxref_8_c_3253_p N_noxref_9_c_3717_n ) capacitor c=0.0174568f \
 //x=50.072 //y=4.74 //x2=50.81 //y2=4.415
cc_2823 ( N_noxref_8_c_3257_p N_noxref_9_c_3718_n ) capacitor c=7.63063e-19 \
 //x=48.22 //y=5.25 //x2=50.81 //y2=4.735
cc_2824 ( N_noxref_8_c_3258_p N_noxref_9_c_3718_n ) capacitor c=0.0172939f \
 //x=50.07 //y=4.88 //x2=50.81 //y2=4.735
cc_2825 ( N_noxref_8_c_3253_p N_noxref_9_c_3718_n ) capacitor c=0.0114844f \
 //x=50.072 //y=4.74 //x2=50.81 //y2=4.735
cc_2826 ( N_noxref_8_c_3260_p N_noxref_9_c_3718_n ) capacitor c=7.25939e-19 \
 //x=50.07 //y=4.88 //x2=50.81 //y2=4.735
cc_2827 ( N_noxref_8_c_3261_p N_noxref_9_c_3718_n ) capacitor c=0.00200292f \
 //x=50.07 //y=4.88 //x2=50.81 //y2=4.735
cc_2828 ( N_noxref_8_c_3253_p N_noxref_9_c_3723_n ) capacitor c=6.15181e-19 \
 //x=50.072 //y=4.74 //x2=50.81 //y2=4.25
cc_2829 ( N_noxref_8_c_3263_p N_noxref_9_c_3724_n ) capacitor c=0.0179797f \
 //x=50.07 //y=2.26 //x2=50.81 //y2=2.26
cc_2830 ( N_noxref_8_c_3255_p N_noxref_9_c_3724_n ) capacitor c=5.16867e-19 \
 //x=50.07 //y=2.26 //x2=50.81 //y2=2.26
cc_2831 ( N_noxref_8_c_3265_p N_noxref_9_c_3724_n ) capacitor c=0.00161745f \
 //x=49.875 //y=2.095 //x2=50.81 //y2=2.26
cc_2832 ( N_noxref_8_c_3266_p N_noxref_9_c_3695_n ) capacitor c=0.00896029f \
 //x=48.22 //y=4.025 //x2=45.465 //y2=4.265
cc_2833 ( N_noxref_8_c_3257_p N_noxref_9_c_3695_n ) capacitor c=0.0227809f \
 //x=48.22 //y=5.25 //x2=45.465 //y2=4.265
cc_2834 ( N_noxref_8_c_3251_p N_noxref_9_c_3695_n ) capacitor c=0.00556515f \
 //x=50.07 //y=4.025 //x2=45.465 //y2=4.265
cc_2835 ( N_noxref_8_c_3253_p N_noxref_9_c_3695_n ) capacitor c=0.0249851f \
 //x=50.072 //y=4.74 //x2=45.465 //y2=4.265
cc_2836 ( N_noxref_8_c_3270_p N_noxref_9_c_3695_n ) capacitor c=0.0358686f \
 //x=48.38 //y=3.865 //x2=45.465 //y2=4.265
cc_2837 ( N_noxref_8_c_3254_p N_noxref_9_c_3695_n ) capacitor c=0.0358686f \
 //x=50.055 //y=3.865 //x2=45.465 //y2=4.265
cc_2838 ( N_noxref_8_c_3272_p N_noxref_9_c_3695_n ) capacitor c=0.132799f \
 //x=49.895 //y=3.865 //x2=45.465 //y2=4.265
cc_2839 ( N_noxref_8_c_3250_p N_noxref_9_c_3734_n ) capacitor c=3.30333e-19 \
 //x=50.07 //y=3.705 //x2=50.81 //y2=2.26
cc_2840 ( N_noxref_8_c_3263_p N_noxref_9_c_3734_n ) capacitor c=5.24723e-19 \
 //x=50.07 //y=2.26 //x2=50.81 //y2=2.26
cc_2841 ( N_noxref_8_c_3255_p N_noxref_9_c_3734_n ) capacitor c=0.00445529f \
 //x=50.07 //y=2.26 //x2=50.81 //y2=2.26
cc_2842 ( N_noxref_8_c_3265_p N_noxref_9_c_3734_n ) capacitor c=0.00267961f \
 //x=49.875 //y=2.095 //x2=50.81 //y2=2.26
cc_2843 ( N_noxref_8_c_3258_p N_noxref_9_c_3738_n ) capacitor c=4.80626e-19 \
 //x=50.07 //y=4.88 //x2=50.84 //y2=4.88
cc_2844 ( N_noxref_8_c_3260_p N_noxref_9_c_3738_n ) capacitor c=0.00397338f \
 //x=50.07 //y=4.88 //x2=50.84 //y2=4.88
cc_2845 ( N_noxref_8_c_3261_p N_noxref_9_c_3738_n ) capacitor c=0.00283894f \
 //x=50.07 //y=4.88 //x2=50.84 //y2=4.88
cc_2846 ( N_noxref_8_M114_noxref_g N_noxref_9_M116_noxref_g ) capacitor \
 c=0.0104892f //x=49.97 //y=6.2 //x2=50.85 //y2=6.2
cc_2847 ( N_noxref_8_M115_noxref_g N_noxref_9_M116_noxref_g ) capacitor \
 c=0.107636f //x=50.41 //y=6.2 //x2=50.85 //y2=6.2
cc_2848 ( N_noxref_8_M115_noxref_g N_noxref_9_M117_noxref_g ) capacitor \
 c=0.0100341f //x=50.41 //y=6.2 //x2=51.29 //y2=6.2
cc_2849 ( N_noxref_8_c_3283_p N_noxref_9_c_3744_n ) capacitor c=4.86545e-19 \
 //x=49.875 //y=1.045 //x2=50.845 //y2=1.085
cc_2850 ( N_noxref_8_c_3284_p N_noxref_9_c_3744_n ) capacitor c=0.00152405f \
 //x=49.875 //y=1.39 //x2=50.845 //y2=1.085
cc_2851 ( N_noxref_8_c_3285_p N_noxref_9_c_3744_n ) capacitor c=0.0151475f \
 //x=50.405 //y=1.045 //x2=50.845 //y2=1.085
cc_2852 ( N_noxref_8_c_3286_p N_noxref_9_c_3747_n ) capacitor c=0.00109982f \
 //x=49.875 //y=1.7 //x2=50.845 //y2=1.43
cc_2853 ( N_noxref_8_c_3287_p N_noxref_9_c_3747_n ) capacitor c=0.0111064f \
 //x=50.405 //y=1.39 //x2=50.845 //y2=1.43
cc_2854 ( N_noxref_8_c_3286_p N_noxref_9_c_3749_n ) capacitor c=9.58243e-19 \
 //x=49.875 //y=1.7 //x2=50.845 //y2=1.74
cc_2855 ( N_noxref_8_c_3265_p N_noxref_9_c_3749_n ) capacitor c=0.00662747f \
 //x=49.875 //y=2.095 //x2=50.845 //y2=1.74
cc_2856 ( N_noxref_8_c_3287_p N_noxref_9_c_3749_n ) capacitor c=0.00862358f \
 //x=50.405 //y=1.39 //x2=50.845 //y2=1.74
cc_2857 ( N_noxref_8_c_3285_p N_noxref_9_c_3752_n ) capacitor c=0.00127211f \
 //x=50.405 //y=1.045 //x2=51.375 //y2=1.085
cc_2858 ( N_noxref_8_c_3287_p N_noxref_9_c_3753_n ) capacitor c=0.00204774f \
 //x=50.405 //y=1.39 //x2=51.375 //y2=1.43
cc_2859 ( N_noxref_8_c_3263_p N_noxref_9_c_3754_n ) capacitor c=0.00161167f \
 //x=50.07 //y=2.26 //x2=50.81 //y2=2.26
cc_2860 ( N_noxref_8_c_3255_p N_noxref_9_c_3754_n ) capacitor c=0.00266443f \
 //x=50.07 //y=2.26 //x2=50.81 //y2=2.26
cc_2861 ( N_noxref_8_c_3265_p N_noxref_9_c_3754_n ) capacitor c=0.0181449f \
 //x=49.875 //y=2.095 //x2=50.81 //y2=2.26
cc_2862 ( N_noxref_8_c_3258_p N_noxref_9_c_3757_n ) capacitor c=0.00158715f \
 //x=50.07 //y=4.88 //x2=50.84 //y2=4.88
cc_2863 ( N_noxref_8_c_3260_p N_noxref_9_c_3757_n ) capacitor c=0.00237977f \
 //x=50.07 //y=4.88 //x2=50.84 //y2=4.88
cc_2864 ( N_noxref_8_c_3261_p N_noxref_9_c_3757_n ) capacitor c=0.0297875f \
 //x=50.07 //y=4.88 //x2=50.84 //y2=4.88
cc_2865 ( N_noxref_8_c_3249_p N_D_c_4303_n ) capacitor c=0.0233619f //x=48.22 \
 //y=3.705 //x2=59.16 //y2=2.77
cc_2866 ( N_noxref_8_c_3250_p N_D_c_4303_n ) capacitor c=0.0233476f //x=50.07 \
 //y=3.705 //x2=59.16 //y2=2.77
cc_2867 ( N_noxref_8_c_3301_p N_CLK_c_5105_n ) capacitor c=0.0205861f \
 //x=48.135 //y=5.335 //x2=50.415 //y2=4.62
cc_2868 ( N_noxref_8_c_3257_p N_CLK_c_5105_n ) capacitor c=0.0300392f \
 //x=48.22 //y=5.25 //x2=50.415 //y2=4.62
cc_2869 ( N_noxref_8_c_3239_n N_CLK_c_5105_n ) capacitor c=0.0297912f \
 //x=45.682 //y=5.335 //x2=50.415 //y2=4.62
cc_2870 ( N_noxref_8_c_3304_p N_CLK_c_5105_n ) capacitor c=0.03994f //x=46.56 \
 //y=5.335 //x2=50.415 //y2=4.62
cc_2871 ( N_noxref_8_c_3258_p N_CLK_c_5105_n ) capacitor c=0.00357426f \
 //x=50.07 //y=4.88 //x2=50.415 //y2=4.62
cc_2872 ( N_noxref_8_c_3253_p N_CLK_c_5105_n ) capacitor c=0.0271206f \
 //x=50.072 //y=4.74 //x2=50.415 //y2=4.62
cc_2873 ( N_noxref_8_c_3272_p N_CLK_c_5105_n ) capacitor c=0.00792515f \
 //x=49.895 //y=3.865 //x2=50.415 //y2=4.62
cc_2874 ( N_noxref_8_c_3249_p RN ) capacitor c=0.00186323f //x=48.22 //y=3.705 \
 //x2=46.37 //y2=3.51
cc_2875 ( N_noxref_8_c_3257_p RN ) capacitor c=8.37342e-19 //x=48.22 //y=5.25 \
 //x2=46.37 //y2=3.51
cc_2876 ( N_noxref_8_c_3238_n N_RN_c_6587_n ) capacitor c=6.01844e-19 \
 //x=46.44 //y=5.335 //x2=46.37 //y2=2.515
cc_2877 ( N_noxref_8_c_3238_n N_RN_c_6591_n ) capacitor c=0.0213631f //x=46.44 \
 //y=5.335 //x2=46.37 //y2=4.765
cc_2878 ( N_noxref_8_c_3304_p N_RN_c_6591_n ) capacitor c=0.00239361f \
 //x=46.56 //y=5.335 //x2=46.37 //y2=4.765
cc_2879 ( N_noxref_8_c_3313_p N_RN_c_6591_n ) capacitor c=7.85344e-19 \
 //x=46.56 //y=5.56 //x2=46.37 //y2=4.765
cc_2880 ( N_noxref_8_c_3314_p N_RN_c_6606_n ) capacitor c=6.89366e-19 \
 //x=47.735 //y=1.305 //x2=59.105 //y2=2.385
cc_2881 ( N_noxref_8_c_3248_p N_RN_c_6606_n ) capacitor c=0.0211352f //x=47.82 \
 //y=1.845 //x2=59.105 //y2=2.385
cc_2882 ( N_noxref_8_c_3249_p N_RN_c_6606_n ) capacitor c=0.0278445f //x=48.22 \
 //y=3.705 //x2=59.105 //y2=2.385
cc_2883 ( N_noxref_8_c_3250_p N_RN_c_6606_n ) capacitor c=0.0126883f //x=50.07 \
 //y=3.705 //x2=59.105 //y2=2.385
cc_2884 ( N_noxref_8_c_3263_p N_RN_c_6606_n ) capacitor c=0.0181311f //x=50.07 \
 //y=2.26 //x2=59.105 //y2=2.385
cc_2885 ( N_noxref_8_c_3255_p N_RN_c_6606_n ) capacitor c=2.20453e-19 \
 //x=50.07 //y=2.26 //x2=59.105 //y2=2.385
cc_2886 ( N_noxref_8_c_3265_p N_RN_c_6606_n ) capacitor c=3.61358e-19 \
 //x=49.875 //y=2.095 //x2=59.105 //y2=2.385
cc_2887 ( N_noxref_8_c_3238_n N_RN_c_6611_n ) capacitor c=0.00492634f \
 //x=46.44 //y=5.335 //x2=46.37 //y2=4.88
cc_2888 ( N_noxref_8_c_3304_p N_RN_c_6611_n ) capacitor c=0.00132214f \
 //x=46.56 //y=5.335 //x2=46.37 //y2=4.88
cc_2889 ( N_noxref_8_c_3238_n N_RN_M110_noxref_g ) capacitor c=0.00858241f \
 //x=46.44 //y=5.335 //x2=46.34 //y2=6.2
cc_2890 ( N_noxref_8_c_3304_p N_RN_M110_noxref_g ) capacitor c=0.00229818f \
 //x=46.56 //y=5.335 //x2=46.34 //y2=6.2
cc_2891 ( N_noxref_8_c_3313_p N_RN_M110_noxref_g ) capacitor c=0.0179041f \
 //x=46.56 //y=5.56 //x2=46.34 //y2=6.2
cc_2892 ( N_noxref_8_c_3326_p N_RN_M111_noxref_g ) capacitor c=0.00955829f \
 //x=47.325 //y=5.335 //x2=46.78 //y2=6.2
cc_2893 ( N_noxref_8_c_3304_p N_RN_M111_noxref_g ) capacitor c=0.00230699f \
 //x=46.56 //y=5.335 //x2=46.78 //y2=6.2
cc_2894 ( N_noxref_8_c_3313_p N_RN_M111_noxref_g ) capacitor c=0.0179041f \
 //x=46.56 //y=5.56 //x2=46.78 //y2=6.2
cc_2895 ( N_noxref_8_c_3304_p N_RN_c_6654_n ) capacitor c=0.00171075f \
 //x=46.56 //y=5.335 //x2=46.705 //y2=4.97
cc_2896 ( N_noxref_8_c_3313_p N_RN_c_6654_n ) capacitor c=0.00290085f \
 //x=46.56 //y=5.56 //x2=46.705 //y2=4.97
cc_2897 ( N_noxref_8_c_3238_n N_RN_c_6629_n ) capacitor c=6.15714e-19 \
 //x=46.44 //y=5.335 //x2=46.37 //y2=4.88
cc_2898 ( N_noxref_8_c_3249_p N_noxref_15_c_8554_n ) capacitor c=0.0139216f \
 //x=48.22 //y=3.705 //x2=47.48 //y2=2.375
cc_2899 ( N_noxref_8_c_3249_p N_noxref_15_c_8552_n ) capacitor c=0.0383476f \
 //x=48.22 //y=3.705 //x2=47.48 //y2=3.365
cc_2900 ( N_noxref_8_c_3250_p N_noxref_15_c_8552_n ) capacitor c=0.00115109f \
 //x=50.07 //y=3.705 //x2=47.48 //y2=3.365
cc_2901 ( N_noxref_8_c_3326_p N_noxref_15_c_8557_n ) capacitor c=7.52866e-19 \
 //x=47.325 //y=5.335 //x2=47.48 //y2=3.685
cc_2902 ( N_noxref_8_c_3301_p N_noxref_15_c_8557_n ) capacitor c=0.0011019f \
 //x=48.135 //y=5.335 //x2=47.48 //y2=3.685
cc_2903 ( N_noxref_8_c_3314_p N_noxref_15_c_8557_n ) capacitor c=2.28699e-19 \
 //x=47.735 //y=1.305 //x2=47.48 //y2=3.685
cc_2904 ( N_noxref_8_c_3248_p N_noxref_15_c_8557_n ) capacitor c=0.00103023f \
 //x=47.82 //y=1.845 //x2=47.48 //y2=3.685
cc_2905 ( N_noxref_8_c_3249_p N_noxref_15_c_8557_n ) capacitor c=0.0174706f \
 //x=48.22 //y=3.705 //x2=47.48 //y2=3.685
cc_2906 ( N_noxref_8_c_3301_p N_noxref_15_c_8553_n ) capacitor c=0.00228791f \
 //x=48.135 //y=5.335 //x2=47.48 //y2=4.75
cc_2907 ( N_noxref_8_c_3249_p N_noxref_15_c_8553_n ) capacitor c=9.08473e-19 \
 //x=48.22 //y=3.705 //x2=47.48 //y2=4.75
cc_2908 ( N_noxref_8_c_3266_p N_noxref_15_c_8553_n ) capacitor c=0.0151188f \
 //x=48.22 //y=4.025 //x2=47.48 //y2=4.75
cc_2909 ( N_noxref_8_c_3257_p N_noxref_15_c_8553_n ) capacitor c=0.0427666f \
 //x=48.22 //y=5.25 //x2=47.48 //y2=4.75
cc_2910 ( N_noxref_8_c_3344_p N_noxref_15_c_8553_n ) capacitor c=0.0228808f \
 //x=47.44 //y=5.335 //x2=47.48 //y2=4.75
cc_2911 ( N_noxref_8_c_3242_n N_noxref_15_c_8553_n ) capacitor c=6.77171e-19 \
 //x=48.22 //y=3.88 //x2=47.48 //y2=4.75
cc_2912 ( N_noxref_8_c_3253_p N_noxref_15_c_8553_n ) capacitor c=0.0010355f \
 //x=50.072 //y=4.74 //x2=47.48 //y2=4.75
cc_2913 ( N_noxref_8_c_3270_p N_noxref_15_c_8553_n ) capacitor c=0.00687508f \
 //x=48.38 //y=3.865 //x2=47.48 //y2=4.75
cc_2914 ( N_noxref_8_c_3348_p N_noxref_15_c_8553_n ) capacitor c=0.00217653f \
 //x=47.44 //y=5.56 //x2=47.48 //y2=4.75
cc_2915 ( N_noxref_8_M115_noxref_g N_noxref_15_c_8571_n ) capacitor \
 c=0.00889217f //x=50.41 //y=6.2 //x2=50.955 //y2=5.38
cc_2916 ( N_noxref_8_c_3350_p N_noxref_15_c_8572_n ) capacitor c=0.00326079f \
 //x=47.735 //y=1.76 //x2=51.11 //y2=1.75
cc_2917 ( N_noxref_8_c_3351_p N_noxref_15_c_8573_n ) capacitor c=0.00218808f \
 //x=48.135 //y=1.845 //x2=51.195 //y2=1.835
cc_2918 ( N_noxref_8_c_3351_p N_noxref_15_c_8574_n ) capacitor c=0.00203766f \
 //x=48.135 //y=1.845 //x2=51.55 //y2=3.37
cc_2919 ( N_noxref_8_c_3250_p N_noxref_15_c_8574_n ) capacitor c=0.00177341f \
 //x=50.07 //y=3.705 //x2=51.55 //y2=3.37
cc_2920 ( N_noxref_8_c_3257_p N_noxref_15_c_8576_n ) capacitor c=0.0028534f \
 //x=48.22 //y=5.25 //x2=51.55 //y2=5.295
cc_2921 ( N_noxref_8_c_3253_p N_noxref_15_c_8576_n ) capacitor c=0.00197847f \
 //x=50.072 //y=4.74 //x2=51.55 //y2=5.295
cc_2922 ( N_noxref_8_c_3249_p N_noxref_15_c_8578_n ) capacitor c=9.19401e-19 \
 //x=48.22 //y=3.705 //x2=47.48 //y2=3.51
cc_2923 ( N_noxref_8_c_3357_p N_noxref_15_c_8579_n ) capacitor c=5.58535e-19 \
 //x=47.44 //y=5.56 //x2=50.19 //y2=5.56
cc_2924 ( N_noxref_8_c_3301_p N_noxref_15_c_8579_n ) capacitor c=0.00104762f \
 //x=48.135 //y=5.335 //x2=50.19 //y2=5.56
cc_2925 ( N_noxref_8_c_3251_p N_noxref_15_c_8579_n ) capacitor c=5.31286e-19 \
 //x=50.07 //y=4.025 //x2=50.19 //y2=5.56
cc_2926 ( N_noxref_8_c_3258_p N_noxref_15_c_8579_n ) capacitor c=0.0117744f \
 //x=50.07 //y=4.88 //x2=50.19 //y2=5.56
cc_2927 ( N_noxref_8_c_3260_p N_noxref_15_c_8579_n ) capacitor c=0.00277154f \
 //x=50.07 //y=4.88 //x2=50.19 //y2=5.56
cc_2928 ( N_noxref_8_M114_noxref_g N_noxref_15_c_8579_n ) capacitor \
 c=0.00201806f //x=49.97 //y=6.2 //x2=50.19 //y2=5.56
cc_2929 ( N_noxref_8_M115_noxref_g N_noxref_15_c_8579_n ) capacitor \
 c=0.00192712f //x=50.41 //y=6.2 //x2=50.19 //y2=5.56
cc_2930 ( N_noxref_8_c_3261_p N_noxref_15_c_8579_n ) capacitor c=0.00195072f \
 //x=50.07 //y=4.88 //x2=50.19 //y2=5.56
cc_2931 ( N_noxref_8_c_3314_p N_noxref_15_c_8587_n ) capacitor c=6.5615e-19 \
 //x=47.735 //y=1.305 //x2=51.11 //y2=1.18
cc_2932 ( N_noxref_8_c_3249_p N_noxref_15_c_8588_n ) capacitor c=5.51486e-19 \
 //x=48.22 //y=3.705 //x2=47.835 //y2=3.51
cc_2933 ( N_noxref_8_c_3249_p N_noxref_15_c_8589_n ) capacitor c=0.0215864f \
 //x=48.22 //y=3.705 //x2=48.435 //y2=3.48
cc_2934 ( N_noxref_8_c_3266_p N_noxref_15_c_8589_n ) capacitor c=0.00890774f \
 //x=48.22 //y=4.025 //x2=48.435 //y2=3.48
cc_2935 ( N_noxref_8_c_3270_p N_noxref_15_c_8589_n ) capacitor c=0.0358686f \
 //x=48.38 //y=3.865 //x2=48.435 //y2=3.48
cc_2936 ( N_noxref_8_c_3272_p N_noxref_15_c_8589_n ) capacitor c=0.12589f \
 //x=49.895 //y=3.865 //x2=48.435 //y2=3.48
cc_2937 ( N_noxref_8_c_3250_p N_noxref_15_c_8593_n ) capacitor c=9.81479e-19 \
 //x=50.07 //y=3.705 //x2=49.67 //y2=3.51
cc_2938 ( N_noxref_8_c_3251_p N_noxref_15_c_8593_n ) capacitor c=0.00191284f \
 //x=50.07 //y=4.025 //x2=49.67 //y2=3.51
cc_2939 ( N_noxref_8_c_3272_p N_noxref_15_c_8593_n ) capacitor c=0.0104912f \
 //x=49.895 //y=3.865 //x2=49.67 //y2=3.51
cc_2940 ( N_noxref_8_c_3250_p N_noxref_15_c_8596_n ) capacitor c=0.0215234f \
 //x=50.07 //y=3.705 //x2=50.27 //y2=3.48
cc_2941 ( N_noxref_8_c_3251_p N_noxref_15_c_8596_n ) capacitor c=0.00524359f \
 //x=50.07 //y=4.025 //x2=50.27 //y2=3.48
cc_2942 ( N_noxref_8_c_3254_p N_noxref_15_c_8596_n ) capacitor c=0.0358686f \
 //x=50.055 //y=3.865 //x2=50.27 //y2=3.48
cc_2943 ( N_noxref_8_c_3250_p N_noxref_15_c_8599_n ) capacitor c=6.41217e-19 \
 //x=50.07 //y=3.705 //x2=51.71 //y2=3.51
cc_2944 ( N_noxref_8_c_3249_p N_noxref_15_c_8600_n ) capacitor c=0.00295804f \
 //x=48.22 //y=3.705 //x2=47.64 //y2=3.525
cc_2945 ( N_noxref_8_c_3249_p N_noxref_15_c_8601_n ) capacitor c=0.0015536f \
 //x=48.22 //y=3.705 //x2=47.48 //y2=2.26
cc_2946 ( N_noxref_8_c_3301_p N_noxref_15_c_8602_n ) capacitor c=0.00130631f \
 //x=48.135 //y=5.335 //x2=47.48 //y2=4.88
cc_2947 ( N_noxref_8_c_3257_p N_noxref_15_c_8602_n ) capacitor c=0.00131258f \
 //x=48.22 //y=5.25 //x2=47.48 //y2=4.88
cc_2948 ( N_noxref_8_c_3344_p N_noxref_15_c_8602_n ) capacitor c=0.00346456f \
 //x=47.44 //y=5.335 //x2=47.48 //y2=4.88
cc_2949 ( N_noxref_8_c_3348_p N_noxref_15_c_8602_n ) capacitor c=0.00624059f \
 //x=47.44 //y=5.56 //x2=47.48 //y2=4.88
cc_2950 ( N_noxref_8_c_3258_p N_noxref_15_c_8606_n ) capacitor c=0.00104426f \
 //x=50.07 //y=4.88 //x2=50.19 //y2=5.56
cc_2951 ( N_noxref_8_c_3260_p N_noxref_15_c_8606_n ) capacitor c=0.00377369f \
 //x=50.07 //y=4.88 //x2=50.19 //y2=5.56
cc_2952 ( N_noxref_8_M114_noxref_g N_noxref_15_c_8606_n ) capacitor \
 c=0.0158358f //x=49.97 //y=6.2 //x2=50.19 //y2=5.56
cc_2953 ( N_noxref_8_M115_noxref_g N_noxref_15_c_8606_n ) capacitor \
 c=0.0178987f //x=50.41 //y=6.2 //x2=50.19 //y2=5.56
cc_2954 ( N_noxref_8_c_3261_p N_noxref_15_c_8606_n ) capacitor c=0.0043218f \
 //x=50.07 //y=4.88 //x2=50.19 //y2=5.56
cc_2955 ( N_noxref_8_c_3326_p N_noxref_15_M112_noxref_g ) capacitor \
 c=0.00955829f //x=47.325 //y=5.335 //x2=47.22 //y2=6.2
cc_2956 ( N_noxref_8_c_3357_p N_noxref_15_M112_noxref_g ) capacitor \
 c=0.00226521f //x=47.44 //y=5.56 //x2=47.22 //y2=6.2
cc_2957 ( N_noxref_8_c_3348_p N_noxref_15_M112_noxref_g ) capacitor \
 c=0.0178885f //x=47.44 //y=5.56 //x2=47.22 //y2=6.2
cc_2958 ( N_noxref_8_c_3357_p N_noxref_15_M113_noxref_g ) capacitor \
 c=0.00368945f //x=47.44 //y=5.56 //x2=47.66 //y2=6.2
cc_2959 ( N_noxref_8_c_3301_p N_noxref_15_M113_noxref_g ) capacitor \
 c=0.011052f //x=48.135 //y=5.335 //x2=47.66 //y2=6.2
cc_2960 ( N_noxref_8_c_3348_p N_noxref_15_M113_noxref_g ) capacitor \
 c=0.0188608f //x=47.44 //y=5.56 //x2=47.66 //y2=6.2
cc_2961 ( N_noxref_8_c_3314_p N_noxref_15_c_8617_n ) capacitor c=4.64015e-19 \
 //x=47.735 //y=1.305 //x2=47.47 //y2=1.095
cc_2962 ( N_noxref_8_M29_noxref_d N_noxref_15_c_8617_n ) capacitor \
 c=0.00137165f //x=47.545 //y=1.095 //x2=47.47 //y2=1.095
cc_2963 ( N_noxref_8_c_3314_p N_noxref_15_c_8619_n ) capacitor c=0.0026012f \
 //x=47.735 //y=1.305 //x2=47.47 //y2=1.44
cc_2964 ( N_noxref_8_c_3350_p N_noxref_15_c_8619_n ) capacitor c=0.00127432f \
 //x=47.735 //y=1.76 //x2=47.47 //y2=1.44
cc_2965 ( N_noxref_8_M29_noxref_d N_noxref_15_c_8619_n ) capacitor \
 c=0.00237422f //x=47.545 //y=1.095 //x2=47.47 //y2=1.44
cc_2966 ( N_noxref_8_c_3350_p N_noxref_15_c_8622_n ) capacitor c=0.00429966f \
 //x=47.735 //y=1.76 //x2=47.47 //y2=1.75
cc_2967 ( N_noxref_8_c_3314_p N_noxref_15_c_8623_n ) capacitor c=5.29969e-19 \
 //x=47.735 //y=1.305 //x2=47.845 //y2=0.94
cc_2968 ( N_noxref_8_M29_noxref_d N_noxref_15_c_8623_n ) capacitor \
 c=0.0020782f //x=47.545 //y=1.095 //x2=47.845 //y2=0.94
cc_2969 ( N_noxref_8_c_3314_p N_noxref_15_c_8625_n ) capacitor c=5.01873e-19 \
 //x=47.735 //y=1.305 //x2=47.845 //y2=1.595
cc_2970 ( N_noxref_8_c_3350_p N_noxref_15_c_8625_n ) capacitor c=0.00930387f \
 //x=47.735 //y=1.76 //x2=47.845 //y2=1.595
cc_2971 ( N_noxref_8_c_3351_p N_noxref_15_c_8625_n ) capacitor c=0.00194716f \
 //x=48.135 //y=1.845 //x2=47.845 //y2=1.595
cc_2972 ( N_noxref_8_M29_noxref_d N_noxref_15_c_8625_n ) capacitor \
 c=0.00356097f //x=47.545 //y=1.095 //x2=47.845 //y2=1.595
cc_2973 ( N_noxref_8_c_3314_p N_noxref_15_c_8629_n ) capacitor c=5.28622e-19 \
 //x=47.735 //y=1.305 //x2=48 //y2=1.095
cc_2974 ( N_noxref_8_M29_noxref_d N_noxref_15_c_8629_n ) capacitor \
 c=0.00139206f //x=47.545 //y=1.095 //x2=48 //y2=1.095
cc_2975 ( N_noxref_8_c_3314_p N_noxref_15_c_8631_n ) capacitor c=0.00312156f \
 //x=47.735 //y=1.305 //x2=48 //y2=1.44
cc_2976 ( N_noxref_8_c_3350_p N_noxref_15_c_8631_n ) capacitor c=0.00347599f \
 //x=47.735 //y=1.76 //x2=48 //y2=1.44
cc_2977 ( N_noxref_8_c_3351_p N_noxref_15_c_8631_n ) capacitor c=0.00323576f \
 //x=48.135 //y=1.845 //x2=48 //y2=1.44
cc_2978 ( N_noxref_8_M29_noxref_d N_noxref_15_c_8631_n ) capacitor \
 c=0.00237422f //x=47.545 //y=1.095 //x2=48 //y2=1.44
cc_2979 ( N_noxref_8_c_3249_p N_noxref_15_c_8635_n ) capacitor c=0.0024584f \
 //x=48.22 //y=3.705 //x2=47.48 //y2=2.26
cc_2980 ( N_noxref_8_c_3350_p N_noxref_15_c_8636_n ) capacitor c=0.0036273f \
 //x=47.735 //y=1.76 //x2=47.48 //y2=2.095
cc_2981 ( N_noxref_8_c_3249_p N_noxref_15_c_8636_n ) capacitor c=0.00282067f \
 //x=48.22 //y=3.705 //x2=47.48 //y2=2.095
cc_2982 ( N_noxref_8_c_3257_p N_noxref_15_c_8638_n ) capacitor c=0.00739875f \
 //x=48.22 //y=5.25 //x2=47.48 //y2=4.88
cc_2983 ( N_noxref_8_c_3344_p N_noxref_15_c_8638_n ) capacitor c=0.00203307f \
 //x=47.44 //y=5.335 //x2=47.48 //y2=4.88
cc_2984 ( N_noxref_8_c_3348_p N_noxref_15_c_8638_n ) capacitor c=0.00375636f \
 //x=47.44 //y=5.56 //x2=47.48 //y2=4.88
cc_2985 ( N_noxref_8_c_3249_p N_noxref_16_c_10055_n ) capacitor c=0.0230772f \
 //x=48.22 //y=3.705 //x2=55.235 //y2=3.14
cc_2986 ( N_noxref_8_c_3250_p N_noxref_16_c_10055_n ) capacitor c=0.0230705f \
 //x=50.07 //y=3.705 //x2=55.235 //y2=3.14
cc_2987 ( N_noxref_8_c_3272_p N_noxref_16_c_10055_n ) capacitor c=0.010423f \
 //x=49.895 //y=3.865 //x2=55.235 //y2=3.14
cc_2988 ( N_noxref_8_c_3238_n N_VDD_c_11464_n ) capacitor c=0.00621363f \
 //x=46.44 //y=5.335 //x2=78.895 //y2=7.585
cc_2989 ( N_noxref_8_c_3326_p N_VDD_c_11464_n ) capacitor c=0.00627191f \
 //x=47.325 //y=5.335 //x2=78.895 //y2=7.585
cc_2990 ( N_noxref_8_c_3357_p N_VDD_c_11464_n ) capacitor c=0.00256019f \
 //x=47.44 //y=5.56 //x2=78.895 //y2=7.585
cc_2991 ( N_noxref_8_c_3301_p N_VDD_c_11464_n ) capacitor c=0.00829247f \
 //x=48.135 //y=5.335 //x2=78.895 //y2=7.585
cc_2992 ( N_noxref_8_c_3266_p N_VDD_c_11464_n ) capacitor c=5.11349e-19 \
 //x=48.22 //y=4.025 //x2=78.895 //y2=7.585
cc_2993 ( N_noxref_8_c_3251_p N_VDD_c_11464_n ) capacitor c=2.12705e-19 \
 //x=50.07 //y=4.025 //x2=78.895 //y2=7.585
cc_2994 ( N_noxref_8_c_3239_n N_VDD_c_11464_n ) capacitor c=0.00261804f \
 //x=45.682 //y=5.335 //x2=78.895 //y2=7.585
cc_2995 ( N_noxref_8_c_3304_p N_VDD_c_11464_n ) capacitor c=0.00270108f \
 //x=46.56 //y=5.335 //x2=78.895 //y2=7.585
cc_2996 ( N_noxref_8_c_3258_p N_VDD_c_11464_n ) capacitor c=9.07241e-19 \
 //x=50.07 //y=4.88 //x2=78.895 //y2=7.585
cc_2997 ( N_noxref_8_c_3243_n N_VDD_c_11464_n ) capacitor c=0.0024232f \
 //x=45.68 //y=5.56 //x2=78.895 //y2=7.585
cc_2998 ( N_noxref_8_c_3313_p N_VDD_c_11464_n ) capacitor c=0.0024232f \
 //x=46.56 //y=5.56 //x2=78.895 //y2=7.585
cc_2999 ( N_noxref_8_c_3348_p N_VDD_c_11464_n ) capacitor c=0.0024232f \
 //x=47.44 //y=5.56 //x2=78.895 //y2=7.585
cc_3000 ( N_noxref_8_c_3260_p N_VDD_c_11464_n ) capacitor c=6.22888e-19 \
 //x=50.07 //y=4.88 //x2=78.895 //y2=7.585
cc_3001 ( N_noxref_8_c_3238_n N_VDD_c_11918_n ) capacitor c=0.00202922f \
 //x=46.44 //y=5.335 //x2=46.035 //y2=7.585
cc_3002 ( N_noxref_8_c_3239_n N_VDD_c_11918_n ) capacitor c=9.3757e-19 \
 //x=45.682 //y=5.335 //x2=46.035 //y2=7.585
cc_3003 ( N_noxref_8_c_3243_n N_VDD_c_11918_n ) capacitor c=0.0138074f \
 //x=45.68 //y=5.56 //x2=46.035 //y2=7.585
cc_3004 ( N_noxref_8_c_3238_n N_VDD_c_11974_n ) capacitor c=0.0017708f \
 //x=46.44 //y=5.335 //x2=46.915 //y2=7.585
cc_3005 ( N_noxref_8_c_3326_p N_VDD_c_11974_n ) capacitor c=0.00202922f \
 //x=47.325 //y=5.335 //x2=46.915 //y2=7.585
cc_3006 ( N_noxref_8_c_3304_p N_VDD_c_11974_n ) capacitor c=9.4822e-19 \
 //x=46.56 //y=5.335 //x2=46.915 //y2=7.585
cc_3007 ( N_noxref_8_c_3313_p N_VDD_c_11974_n ) capacitor c=0.0138074f \
 //x=46.56 //y=5.56 //x2=46.915 //y2=7.585
cc_3008 ( N_noxref_8_c_3326_p N_VDD_c_11978_n ) capacitor c=0.00205906f \
 //x=47.325 //y=5.335 //x2=47.795 //y2=7.585
cc_3009 ( N_noxref_8_c_3357_p N_VDD_c_11978_n ) capacitor c=8.49654e-19 \
 //x=47.44 //y=5.56 //x2=47.795 //y2=7.585
cc_3010 ( N_noxref_8_c_3301_p N_VDD_c_11978_n ) capacitor c=0.00204238f \
 //x=48.135 //y=5.335 //x2=47.795 //y2=7.585
cc_3011 ( N_noxref_8_c_3348_p N_VDD_c_11978_n ) capacitor c=0.0138074f \
 //x=47.44 //y=5.56 //x2=47.795 //y2=7.585
cc_3012 ( N_noxref_8_c_3301_p N_VDD_c_11982_n ) capacitor c=0.00183742f \
 //x=48.135 //y=5.335 //x2=48.79 //y2=7.585
cc_3013 ( N_noxref_8_c_3258_p N_VDD_c_11983_n ) capacitor c=6.28113e-19 \
 //x=50.07 //y=4.88 //x2=50.545 //y2=7.585
cc_3014 ( N_noxref_8_M114_noxref_g N_VDD_c_11983_n ) capacitor c=0.00732618f \
 //x=49.97 //y=6.2 //x2=50.545 //y2=7.585
cc_3015 ( N_noxref_8_M115_noxref_g N_VDD_c_11983_n ) capacitor c=0.00755544f \
 //x=50.41 //y=6.2 //x2=50.545 //y2=7.585
cc_3016 ( N_noxref_8_c_3239_n N_VDD_c_11928_n ) capacitor c=0.0022955f \
 //x=45.682 //y=5.335 //x2=44.15 //y2=7.585
cc_3017 ( N_noxref_8_c_3243_n N_VDD_c_11928_n ) capacitor c=0.00509469f \
 //x=45.68 //y=5.56 //x2=44.15 //y2=7.585
cc_3018 ( N_noxref_8_c_3357_p N_VDD_c_11988_n ) capacitor c=0.00269779f \
 //x=47.44 //y=5.56 //x2=48.96 //y2=7.585
cc_3019 ( N_noxref_8_c_3257_p N_VDD_c_11988_n ) capacitor c=0.0312736f \
 //x=48.22 //y=5.25 //x2=48.96 //y2=7.585
cc_3020 ( N_noxref_8_c_3258_p N_VDD_c_11988_n ) capacitor c=0.00447349f \
 //x=50.07 //y=4.88 //x2=48.96 //y2=7.585
cc_3021 ( N_noxref_8_c_3253_p N_VDD_c_11988_n ) capacitor c=0.00564116f \
 //x=50.072 //y=4.74 //x2=48.96 //y2=7.585
cc_3022 ( N_noxref_8_c_3348_p N_VDD_c_11988_n ) capacitor c=0.00776541f \
 //x=47.44 //y=5.56 //x2=48.96 //y2=7.585
cc_3023 ( N_noxref_8_c_3260_p N_VDD_c_11988_n ) capacitor c=0.00370494f \
 //x=50.07 //y=4.88 //x2=48.96 //y2=7.585
cc_3024 ( N_noxref_8_c_3261_p N_VDD_c_11988_n ) capacitor c=0.0129564f \
 //x=50.07 //y=4.88 //x2=48.96 //y2=7.585
cc_3025 ( N_noxref_8_c_3239_n N_VDD_M108_noxref_s ) capacitor c=0.0441176f \
 //x=45.682 //y=5.335 //x2=45.105 //y2=5.2
cc_3026 ( N_noxref_8_c_3304_p N_VDD_M108_noxref_s ) capacitor c=7.80122e-19 \
 //x=46.56 //y=5.335 //x2=45.105 //y2=5.2
cc_3027 ( N_noxref_8_c_3243_n N_VDD_M108_noxref_s ) capacitor c=0.09305f \
 //x=45.68 //y=5.56 //x2=45.105 //y2=5.2
cc_3028 ( N_noxref_8_c_3238_n N_VDD_M109_noxref_d ) capacitor c=0.00700141f \
 //x=46.44 //y=5.335 //x2=45.975 //y2=5.2
cc_3029 ( N_noxref_8_c_3243_n N_VDD_M109_noxref_d ) capacitor c=0.0674491f \
 //x=45.68 //y=5.56 //x2=45.975 //y2=5.2
cc_3030 ( N_noxref_8_c_3313_p N_VDD_M109_noxref_d ) capacitor c=0.0674762f \
 //x=46.56 //y=5.56 //x2=45.975 //y2=5.2
cc_3031 ( N_noxref_8_c_3326_p N_VDD_M111_noxref_d ) capacitor c=0.00700141f \
 //x=47.325 //y=5.335 //x2=46.855 //y2=5.2
cc_3032 ( N_noxref_8_c_3313_p N_VDD_M111_noxref_d ) capacitor c=0.067493f \
 //x=46.56 //y=5.56 //x2=46.855 //y2=5.2
cc_3033 ( N_noxref_8_c_3348_p N_VDD_M111_noxref_d ) capacitor c=0.0674288f \
 //x=47.44 //y=5.56 //x2=46.855 //y2=5.2
cc_3034 ( N_noxref_8_c_3301_p N_VDD_M113_noxref_d ) capacitor c=0.00700141f \
 //x=48.135 //y=5.335 //x2=47.735 //y2=5.2
cc_3035 ( N_noxref_8_c_3348_p N_VDD_M113_noxref_d ) capacitor c=0.0673824f \
 //x=47.44 //y=5.56 //x2=47.735 //y2=5.2
cc_3036 ( N_noxref_8_c_3357_p N_VDD_M114_noxref_s ) capacitor c=0.00536022f \
 //x=47.44 //y=5.56 //x2=49.615 //y2=5.2
cc_3037 ( N_noxref_8_c_3301_p N_VDD_M114_noxref_s ) capacitor c=0.00211796f \
 //x=48.135 //y=5.335 //x2=49.615 //y2=5.2
cc_3038 ( N_noxref_8_c_3251_p N_VDD_M114_noxref_s ) capacitor c=0.00143516f \
 //x=50.07 //y=4.025 //x2=49.615 //y2=5.2
cc_3039 ( N_noxref_8_M114_noxref_g N_VDD_M114_noxref_s ) capacitor \
 c=0.0567929f //x=49.97 //y=6.2 //x2=49.615 //y2=5.2
cc_3040 ( N_noxref_8_M115_noxref_g N_VDD_M115_noxref_d ) capacitor c=0.015318f \
 //x=50.41 //y=6.2 //x2=50.485 //y2=5.2
cc_3041 ( N_noxref_8_c_3314_p N_noxref_27_c_13330_n ) capacitor c=0.0036878f \
 //x=47.735 //y=1.305 //x2=48.135 //y2=0.72
cc_3042 ( N_noxref_8_c_3351_p N_noxref_27_c_13330_n ) capacitor c=0.00399931f \
 //x=48.135 //y=1.845 //x2=48.135 //y2=0.72
cc_3043 ( N_noxref_8_M29_noxref_d N_noxref_27_c_13330_n ) capacitor \
 c=0.00910163f //x=47.545 //y=1.095 //x2=48.135 //y2=0.72
cc_3044 ( N_noxref_8_M29_noxref_d N_noxref_27_c_13333_n ) capacitor \
 c=0.00120711f //x=47.545 //y=1.095 //x2=47.25 //y2=1.175
cc_3045 ( N_noxref_8_c_3238_n N_noxref_27_M28_noxref_d ) capacitor \
 c=0.00112133f //x=46.44 //y=5.335 //x2=46.01 //y2=1.09
cc_3046 ( N_noxref_8_c_3314_p N_noxref_27_M28_noxref_d ) capacitor \
 c=0.00802836f //x=47.735 //y=1.305 //x2=46.01 //y2=1.09
cc_3047 ( N_noxref_8_c_3314_p N_noxref_27_M29_noxref_s ) capacitor \
 c=0.00993092f //x=47.735 //y=1.305 //x2=47.115 //y2=0.555
cc_3048 ( N_noxref_8_c_3350_p N_noxref_27_M29_noxref_s ) capacitor \
 c=0.0270624f //x=47.735 //y=1.76 //x2=47.115 //y2=0.555
cc_3049 ( N_noxref_8_c_3351_p N_noxref_27_M29_noxref_s ) capacitor \
 c=0.00911719f //x=48.135 //y=1.845 //x2=47.115 //y2=0.555
cc_3050 ( N_noxref_8_c_3242_n N_noxref_27_M29_noxref_s ) capacitor \
 c=0.00129723f //x=48.22 //y=3.88 //x2=47.115 //y2=0.555
cc_3051 ( N_noxref_8_M29_noxref_d N_noxref_27_M29_noxref_s ) capacitor \
 c=0.0279003f //x=47.545 //y=1.095 //x2=47.115 //y2=0.555
cc_3052 ( N_noxref_8_c_3314_p N_GND_c_14310_n ) capacitor c=0.00884249f \
 //x=47.735 //y=1.305 //x2=50.055 //y2=0.175
cc_3053 ( N_noxref_8_c_3351_p N_GND_c_14310_n ) capacitor c=0.00662992f \
 //x=48.135 //y=1.845 //x2=50.055 //y2=0.175
cc_3054 ( N_noxref_8_c_3266_p N_GND_c_14310_n ) capacitor c=3.11577e-19 \
 //x=48.22 //y=4.025 //x2=50.055 //y2=0.175
cc_3055 ( N_noxref_8_M29_noxref_d N_GND_c_14310_n ) capacitor c=2.9462e-19 \
 //x=47.545 //y=1.095 //x2=50.055 //y2=0.175
cc_3056 ( N_noxref_8_c_3314_p N_GND_c_14314_n ) capacitor c=0.00488628f \
 //x=47.735 //y=1.305 //x2=50.14 //y2=1.135
cc_3057 ( N_noxref_8_c_3263_p N_GND_c_14314_n ) capacitor c=0.00645051f \
 //x=50.07 //y=2.26 //x2=50.14 //y2=1.135
cc_3058 ( N_noxref_8_c_3255_p N_GND_c_14314_n ) capacitor c=2.13705e-19 \
 //x=50.07 //y=2.26 //x2=50.14 //y2=1.135
cc_3059 ( N_noxref_8_c_3283_p N_GND_c_14314_n ) capacitor c=0.00176535f \
 //x=49.875 //y=1.045 //x2=50.14 //y2=1.135
cc_3060 ( N_noxref_8_c_3284_p N_GND_c_14314_n ) capacitor c=0.0036005f \
 //x=49.875 //y=1.39 //x2=50.14 //y2=1.135
cc_3061 ( N_noxref_8_c_3286_p N_GND_c_14314_n ) capacitor c=4.2764e-19 \
 //x=49.875 //y=1.7 //x2=50.14 //y2=1.135
cc_3062 ( N_noxref_8_c_3496_p N_GND_c_14314_n ) capacitor c=9.36995e-19 \
 //x=50.25 //y=0.89 //x2=50.14 //y2=1.135
cc_3063 ( N_noxref_8_c_3497_p N_GND_c_14314_n ) capacitor c=6.38426e-19 \
 //x=50.25 //y=1.545 //x2=50.14 //y2=1.135
cc_3064 ( N_noxref_8_c_3285_p N_GND_c_14314_n ) capacitor c=0.00171483f \
 //x=50.405 //y=1.045 //x2=50.14 //y2=1.135
cc_3065 ( N_noxref_8_c_3287_p N_GND_c_14314_n ) capacitor c=0.00296337f \
 //x=50.405 //y=1.39 //x2=50.14 //y2=1.135
cc_3066 ( N_noxref_8_c_3283_p N_GND_c_14324_n ) capacitor c=3.51399e-19 \
 //x=49.875 //y=1.045 //x2=50.137 //y2=1.005
cc_3067 ( N_noxref_8_c_3496_p N_GND_c_14324_n ) capacitor c=0.00850983f \
 //x=50.25 //y=0.89 //x2=50.137 //y2=1.005
cc_3068 ( N_noxref_8_c_3285_p N_GND_c_14324_n ) capacitor c=4.40196e-19 \
 //x=50.405 //y=1.045 //x2=50.137 //y2=1.005
cc_3069 ( N_noxref_8_c_3351_p N_GND_c_14283_n ) capacitor c=6.86343e-19 \
 //x=48.135 //y=1.845 //x2=48.79 //y2=0.175
cc_3070 ( N_noxref_8_c_3283_p N_GND_c_14328_n ) capacitor c=0.00688027f \
 //x=49.875 //y=1.045 //x2=52.12 //y2=0.175
cc_3071 ( N_noxref_8_c_3350_p N_GND_c_14329_n ) capacitor c=0.00285697f \
 //x=47.735 //y=1.76 //x2=48.96 //y2=0.175
cc_3072 ( N_noxref_8_c_3351_p N_GND_c_14329_n ) capacitor c=0.0302549f \
 //x=48.135 //y=1.845 //x2=48.96 //y2=0.175
cc_3073 ( N_noxref_8_c_3250_p N_GND_c_14329_n ) capacitor c=0.00670922f \
 //x=50.07 //y=3.705 //x2=48.96 //y2=0.175
cc_3074 ( N_noxref_8_c_3263_p N_GND_c_14329_n ) capacitor c=0.00351582f \
 //x=50.07 //y=2.26 //x2=48.96 //y2=0.175
cc_3075 ( N_noxref_8_c_3255_p N_GND_c_14329_n ) capacitor c=0.00354425f \
 //x=50.07 //y=2.26 //x2=48.96 //y2=0.175
cc_3076 ( N_noxref_8_c_3286_p N_GND_c_14329_n ) capacitor c=0.0015404f \
 //x=49.875 //y=1.7 //x2=48.96 //y2=0.175
cc_3077 ( N_noxref_8_c_3265_p N_GND_c_14329_n ) capacitor c=0.0093907f \
 //x=49.875 //y=2.095 //x2=48.96 //y2=0.175
cc_3078 ( N_noxref_8_c_3263_p N_GND_M30_noxref_d ) capacitor c=2.20438e-19 \
 //x=50.07 //y=2.26 //x2=49.95 //y2=1.045
cc_3079 ( N_noxref_8_c_3283_p N_GND_M30_noxref_d ) capacitor c=0.00192399f \
 //x=49.875 //y=1.045 //x2=49.95 //y2=1.045
cc_3080 ( N_noxref_8_c_3284_p N_GND_M30_noxref_d ) capacitor c=0.00210798f \
 //x=49.875 //y=1.39 //x2=49.95 //y2=1.045
cc_3081 ( N_noxref_8_c_3496_p N_GND_M30_noxref_d ) capacitor c=0.00472259f \
 //x=50.25 //y=0.89 //x2=49.95 //y2=1.045
cc_3082 ( N_noxref_8_c_3497_p N_GND_M30_noxref_d ) capacitor c=0.00166857f \
 //x=50.25 //y=1.545 //x2=49.95 //y2=1.045
cc_3083 ( N_noxref_8_c_3285_p N_GND_M30_noxref_d ) capacitor c=0.00230174f \
 //x=50.405 //y=1.045 //x2=49.95 //y2=1.045
cc_3084 ( N_noxref_8_c_3287_p N_GND_M30_noxref_d ) capacitor c=0.00210798f \
 //x=50.405 //y=1.39 //x2=49.95 //y2=1.045
cc_3085 ( N_noxref_8_c_3265_p N_noxref_46_c_16200_n ) capacitor c=0.00262672f \
 //x=49.875 //y=2.095 //x2=49.655 //y2=1.675
cc_3086 ( N_noxref_8_c_3251_p N_noxref_46_c_16201_n ) capacitor c=0.00355415f \
 //x=50.07 //y=4.025 //x2=50.54 //y2=1.76
cc_3087 ( N_noxref_8_c_3263_p N_noxref_46_c_16201_n ) capacitor c=0.00509504f \
 //x=50.07 //y=2.26 //x2=50.54 //y2=1.76
cc_3088 ( N_noxref_8_c_3255_p N_noxref_46_c_16201_n ) capacitor c=0.00763108f \
 //x=50.07 //y=2.26 //x2=50.54 //y2=1.76
cc_3089 ( N_noxref_8_c_3286_p N_noxref_46_c_16201_n ) capacitor c=0.00697076f \
 //x=49.875 //y=1.7 //x2=50.54 //y2=1.76
cc_3090 ( N_noxref_8_c_3265_p N_noxref_46_c_16201_n ) capacitor c=0.0170561f \
 //x=49.875 //y=2.095 //x2=50.54 //y2=1.76
cc_3091 ( N_noxref_8_c_3497_p N_noxref_46_c_16201_n ) capacitor c=0.00723574f \
 //x=50.25 //y=1.545 //x2=50.54 //y2=1.76
cc_3092 ( N_noxref_8_c_3287_p N_noxref_46_c_16201_n ) capacitor c=0.00339872f \
 //x=50.405 //y=1.39 //x2=50.54 //y2=1.76
cc_3093 ( N_noxref_8_c_3265_p N_noxref_46_c_16208_n ) capacitor c=6.71402e-19 \
 //x=49.875 //y=2.095 //x2=50.625 //y2=1.675
cc_3094 ( N_noxref_8_c_3283_p N_noxref_46_M30_noxref_s ) capacitor \
 c=0.0295366f //x=49.875 //y=1.045 //x2=49.52 //y2=0.545
cc_3095 ( N_noxref_8_c_3286_p N_noxref_46_M30_noxref_s ) capacitor \
 c=3.48408e-19 //x=49.875 //y=1.7 //x2=49.52 //y2=0.545
cc_3096 ( N_noxref_8_c_3285_p N_noxref_46_M30_noxref_s ) capacitor \
 c=0.0125442f //x=50.405 //y=1.045 //x2=49.52 //y2=0.545
cc_3097 ( N_noxref_9_c_3563_n N_D_c_4297_n ) capacitor c=0.0239233f //x=38.025 \
 //y=4.25 //x2=33.42 //y2=4.765
cc_3098 ( N_noxref_9_c_3538_n N_D_c_4303_n ) capacitor c=0.0206228f //x=37.86 \
 //y=4.09 //x2=59.16 //y2=2.77
cc_3099 ( N_noxref_9_c_3661_n N_D_c_4303_n ) capacitor c=0.0233026f //x=43.41 \
 //y=4.095 //x2=59.16 //y2=2.77
cc_3100 ( N_noxref_9_c_3710_n N_D_c_4303_n ) capacitor c=0.0206228f //x=50.81 \
 //y=4.095 //x2=59.16 //y2=2.77
cc_3101 ( N_noxref_9_c_3695_n N_D_c_4303_n ) capacitor c=0.0110962f //x=45.465 \
 //y=4.265 //x2=59.16 //y2=2.77
cc_3102 ( N_noxref_9_c_3531_n N_D_c_4197_n ) capacitor c=0.0247328f //x=27.5 \
 //y=4.1 //x2=33.26 //y2=2.755
cc_3103 ( N_noxref_9_c_3556_n N_D_c_4197_n ) capacitor c=0.011167f //x=30.075 \
 //y=4.25 //x2=33.26 //y2=2.755
cc_3104 ( N_noxref_9_c_3531_n CLK ) capacitor c=0.0444893f //x=27.5 //y=4.1 \
 //x2=28.61 //y2=3.51
cc_3105 ( N_noxref_9_c_3768_p CLK ) capacitor c=0.00772839f //x=27.5 //y=4.42 \
 //x2=28.61 //y2=3.51
cc_3106 ( N_noxref_9_c_3532_n CLK ) capacitor c=0.00539f //x=27.5 //y=4.755 \
 //x2=28.61 //y2=3.51
cc_3107 ( N_noxref_9_c_3533_n CLK ) capacitor c=4.22577e-19 //x=27.5 //y=4.25 \
 //x2=28.61 //y2=3.51
cc_3108 ( N_noxref_9_c_3556_n CLK ) capacitor c=0.0271902f //x=30.075 //y=4.25 \
 //x2=28.61 //y2=3.51
cc_3109 ( N_noxref_9_c_3534_n CLK ) capacitor c=0.00242466f //x=27.66 //y=4.26 \
 //x2=28.61 //y2=3.51
cc_3110 ( N_noxref_9_c_3773_p CLK ) capacitor c=3.9149e-19 //x=27.5 //y=2.26 \
 //x2=28.61 //y2=3.51
cc_3111 ( N_noxref_9_c_3661_n CLK ) capacitor c=0.00231684f //x=43.41 \
 //y=4.095 //x2=41.56 //y2=3.51
cc_3112 ( N_noxref_9_c_3670_n CLK ) capacitor c=2.99109e-19 //x=43.41 //y=5.25 \
 //x2=41.56 //y2=3.51
cc_3113 ( N_noxref_9_c_3615_n CLK ) capacitor c=0.023508f //x=43.255 //y=4.25 \
 //x2=41.56 //y2=3.51
cc_3114 ( N_noxref_9_c_3777_p N_CLK_c_4998_n ) capacitor c=0.00932261f \
 //x=27.5 //y=2.375 //x2=28.61 //y2=2.375
cc_3115 ( N_noxref_9_c_3773_p N_CLK_c_4998_n ) capacitor c=5.40058e-19 \
 //x=27.5 //y=2.26 //x2=28.61 //y2=2.375
cc_3116 ( N_noxref_9_c_3779_p N_CLK_c_4998_n ) capacitor c=0.00142893f \
 //x=27.2 //y=2.095 //x2=28.61 //y2=2.375
cc_3117 ( N_noxref_9_c_3532_n N_CLK_c_5001_n ) capacitor c=0.00880319f \
 //x=27.5 //y=4.755 //x2=28.605 //y2=4.835
cc_3118 ( N_noxref_9_c_3556_n N_CLK_c_5001_n ) capacitor c=4.73489e-19 \
 //x=30.075 //y=4.25 //x2=28.605 //y2=4.835
cc_3119 ( N_noxref_9_c_3782_p N_CLK_c_5001_n ) capacitor c=6.32742e-19 \
 //x=27.5 //y=4.88 //x2=28.605 //y2=4.835
cc_3120 ( N_noxref_9_c_3705_n N_CLK_c_5001_n ) capacitor c=7.15803e-19 \
 //x=28.065 //y=4.97 //x2=28.605 //y2=4.835
cc_3121 ( N_noxref_9_c_3784_p N_CLK_c_5001_n ) capacitor c=8.67242e-19 \
 //x=27.775 //y=4.97 //x2=28.605 //y2=4.835
cc_3122 ( N_noxref_9_c_3605_n N_CLK_c_5043_n ) capacitor c=0.0234494f \
 //x=41.63 //y=5.335 //x2=41.555 //y2=4.695
cc_3123 ( N_noxref_9_c_3786_p N_CLK_c_5043_n ) capacitor c=0.00463905f \
 //x=41.75 //y=5.335 //x2=41.555 //y2=4.695
cc_3124 ( N_noxref_9_c_3615_n N_CLK_c_5043_n ) capacitor c=0.00375947f \
 //x=43.255 //y=4.25 //x2=41.555 //y2=4.695
cc_3125 ( N_noxref_9_c_3788_p N_CLK_c_5043_n ) capacitor c=0.00169377f \
 //x=41.75 //y=5.56 //x2=41.555 //y2=4.695
cc_3126 ( N_noxref_9_c_3768_p N_CLK_c_5146_n ) capacitor c=0.00138888f \
 //x=27.5 //y=4.42 //x2=27.115 //y2=4.62
cc_3127 ( N_noxref_9_c_3532_n N_CLK_c_5146_n ) capacitor c=8.46751e-19 \
 //x=27.5 //y=4.755 //x2=27.115 //y2=4.62
cc_3128 ( N_noxref_9_c_3534_n N_CLK_c_5146_n ) capacitor c=0.0364798f \
 //x=27.66 //y=4.26 //x2=27.115 //y2=4.62
cc_3129 ( N_noxref_9_c_3768_p N_CLK_c_5149_n ) capacitor c=0.0064995f //x=27.5 \
 //y=4.42 //x2=27.715 //y2=4.645
cc_3130 ( N_noxref_9_c_3532_n N_CLK_c_5149_n ) capacitor c=0.03052f //x=27.5 \
 //y=4.755 //x2=27.715 //y2=4.645
cc_3131 ( N_noxref_9_c_3556_n N_CLK_c_5149_n ) capacitor c=0.0108554f \
 //x=30.075 //y=4.25 //x2=27.715 //y2=4.645
cc_3132 ( N_noxref_9_c_3784_p N_CLK_c_5149_n ) capacitor c=0.00105879f \
 //x=27.775 //y=4.97 //x2=27.715 //y2=4.645
cc_3133 ( N_noxref_9_c_3546_n N_CLK_c_5047_n ) capacitor c=0.00232919f \
 //x=37.86 //y=4.41 //x2=38.08 //y2=4.635
cc_3134 ( N_noxref_9_c_3547_n N_CLK_c_5047_n ) capacitor c=0.0262394f \
 //x=37.86 //y=4.735 //x2=38.08 //y2=4.635
cc_3135 ( N_noxref_9_c_3615_n N_CLK_c_5047_n ) capacitor c=0.0123783f \
 //x=43.255 //y=4.25 //x2=38.08 //y2=4.635
cc_3136 ( N_noxref_9_c_3590_n N_CLK_c_5047_n ) capacitor c=7.56668e-19 \
 //x=37.89 //y=4.88 //x2=38.08 //y2=4.635
cc_3137 ( N_noxref_9_c_3532_n N_CLK_c_5004_n ) capacitor c=0.00694109f \
 //x=27.5 //y=4.755 //x2=37.735 //y2=4.635
cc_3138 ( N_noxref_9_c_3546_n N_CLK_c_5004_n ) capacitor c=0.00261296f \
 //x=37.86 //y=4.41 //x2=37.735 //y2=4.635
cc_3139 ( N_noxref_9_c_3547_n N_CLK_c_5004_n ) capacitor c=3.14882e-19 \
 //x=37.86 //y=4.735 //x2=37.735 //y2=4.635
cc_3140 ( N_noxref_9_c_3556_n N_CLK_c_5004_n ) capacitor c=0.279277f \
 //x=30.075 //y=4.25 //x2=37.735 //y2=4.635
cc_3141 ( N_noxref_9_c_3560_n N_CLK_c_5004_n ) capacitor c=0.113902f \
 //x=30.715 //y=4.27 //x2=37.735 //y2=4.635
cc_3142 ( N_noxref_9_c_3561_n N_CLK_c_5004_n ) capacitor c=0.0602971f \
 //x=31.93 //y=4.25 //x2=37.735 //y2=4.635
cc_3143 ( N_noxref_9_c_3563_n N_CLK_c_5004_n ) capacitor c=0.496368f \
 //x=38.025 //y=4.25 //x2=37.735 //y2=4.635
cc_3144 ( N_noxref_9_c_3667_n N_CLK_c_5098_n ) capacitor c=0.00431212f \
 //x=43.41 //y=4.415 //x2=43.63 //y2=4.64
cc_3145 ( N_noxref_9_c_3670_n N_CLK_c_5098_n ) capacitor c=0.0293846f \
 //x=43.41 //y=5.25 //x2=43.63 //y2=4.64
cc_3146 ( N_noxref_9_c_3697_n N_CLK_c_5098_n ) capacitor c=0.13123f //x=45.12 \
 //y=4.265 //x2=43.63 //y2=4.64
cc_3147 ( N_noxref_9_c_3547_n N_CLK_c_5050_n ) capacitor c=3.09272e-19 \
 //x=37.86 //y=4.735 //x2=43.285 //y2=4.64
cc_3148 ( N_noxref_9_c_3605_n N_CLK_c_5050_n ) capacitor c=0.00121614f \
 //x=41.63 //y=5.335 //x2=43.285 //y2=4.64
cc_3149 ( N_noxref_9_c_3708_n N_CLK_c_5050_n ) capacitor c=0.0203211f \
 //x=43.325 //y=5.335 //x2=43.285 //y2=4.64
cc_3150 ( N_noxref_9_c_3667_n N_CLK_c_5050_n ) capacitor c=0.00255844f \
 //x=43.41 //y=4.415 //x2=43.285 //y2=4.64
cc_3151 ( N_noxref_9_c_3670_n N_CLK_c_5050_n ) capacitor c=4.1983e-19 \
 //x=43.41 //y=5.25 //x2=43.285 //y2=4.64
cc_3152 ( N_noxref_9_c_3610_n N_CLK_c_5050_n ) capacitor c=0.0278748f \
 //x=40.872 //y=5.335 //x2=43.285 //y2=4.64
cc_3153 ( N_noxref_9_c_3786_p N_CLK_c_5050_n ) capacitor c=0.039567f //x=41.75 \
 //y=5.335 //x2=43.285 //y2=4.64
cc_3154 ( N_noxref_9_c_3615_n N_CLK_c_5050_n ) capacitor c=0.463741f \
 //x=43.255 //y=4.25 //x2=43.285 //y2=4.64
cc_3155 ( N_noxref_9_c_3697_n N_CLK_c_5050_n ) capacitor c=0.0364799f \
 //x=45.12 //y=4.265 //x2=43.285 //y2=4.64
cc_3156 ( N_noxref_9_c_3717_n N_CLK_c_5105_n ) capacitor c=0.00262858f \
 //x=50.81 //y=4.415 //x2=50.415 //y2=4.62
cc_3157 ( N_noxref_9_c_3718_n N_CLK_c_5105_n ) capacitor c=4.08711e-19 \
 //x=50.81 //y=4.735 //x2=50.415 //y2=4.62
cc_3158 ( N_noxref_9_c_3695_n N_CLK_c_5105_n ) capacitor c=0.495277f \
 //x=45.465 //y=4.265 //x2=50.415 //y2=4.62
cc_3159 ( N_noxref_9_c_3697_n N_CLK_c_5105_n ) capacitor c=0.0603296f \
 //x=45.12 //y=4.265 //x2=50.415 //y2=4.62
cc_3160 ( N_noxref_9_c_3717_n N_CLK_c_5180_n ) capacitor c=0.00209198f \
 //x=50.81 //y=4.415 //x2=51.015 //y2=4.64
cc_3161 ( N_noxref_9_c_3718_n N_CLK_c_5180_n ) capacitor c=0.0265538f \
 //x=50.81 //y=4.735 //x2=51.015 //y2=4.64
cc_3162 ( N_noxref_9_c_3757_n N_CLK_c_5180_n ) capacitor c=7.54771e-19 \
 //x=50.84 //y=4.88 //x2=51.015 //y2=4.64
cc_3163 ( N_noxref_9_c_3777_p N_CLK_c_5012_n ) capacitor c=5.39999e-19 \
 //x=27.5 //y=2.375 //x2=28.61 //y2=2.26
cc_3164 ( N_noxref_9_c_3531_n N_CLK_c_5012_n ) capacitor c=3.9149e-19 //x=27.5 \
 //y=4.1 //x2=28.61 //y2=2.26
cc_3165 ( N_noxref_9_c_3773_p N_CLK_c_5012_n ) capacitor c=0.00125213f \
 //x=27.5 //y=2.26 //x2=28.61 //y2=2.26
cc_3166 ( N_noxref_9_c_3779_p N_CLK_c_5012_n ) capacitor c=0.00214573f \
 //x=27.2 //y=2.095 //x2=28.61 //y2=2.26
cc_3167 ( N_noxref_9_c_3532_n N_CLK_c_5016_n ) capacitor c=5.64453e-19 \
 //x=27.5 //y=4.755 //x2=28.61 //y2=4.88
cc_3168 ( N_noxref_9_c_3782_p N_CLK_c_5016_n ) capacitor c=0.00113666f \
 //x=27.5 //y=4.88 //x2=28.61 //y2=4.88
cc_3169 ( N_noxref_9_c_3705_n N_CLK_c_5016_n ) capacitor c=0.00116563f \
 //x=28.065 //y=4.97 //x2=28.61 //y2=4.88
cc_3170 ( N_noxref_9_c_3784_p N_CLK_c_5016_n ) capacitor c=0.0012974f \
 //x=27.775 //y=4.97 //x2=28.61 //y2=4.88
cc_3171 ( N_noxref_9_c_3605_n N_CLK_c_5057_n ) capacitor c=0.00492634f \
 //x=41.63 //y=5.335 //x2=41.56 //y2=4.88
cc_3172 ( N_noxref_9_c_3786_p N_CLK_c_5057_n ) capacitor c=0.00132214f \
 //x=41.75 //y=5.335 //x2=41.56 //y2=4.88
cc_3173 ( N_noxref_9_M86_noxref_g N_CLK_M88_noxref_g ) capacitor c=0.0106276f \
 //x=27.7 //y=6.2 //x2=28.58 //y2=6.2
cc_3174 ( N_noxref_9_M87_noxref_g N_CLK_M88_noxref_g ) capacitor c=0.107144f \
 //x=28.14 //y=6.2 //x2=28.58 //y2=6.2
cc_3175 ( N_noxref_9_M87_noxref_g N_CLK_M89_noxref_g ) capacitor c=0.0101598f \
 //x=28.14 //y=6.2 //x2=29.02 //y2=6.2
cc_3176 ( N_noxref_9_c_3605_n N_CLK_M104_noxref_g ) capacitor c=0.00858239f \
 //x=41.63 //y=5.335 //x2=41.53 //y2=6.2
cc_3177 ( N_noxref_9_c_3786_p N_CLK_M104_noxref_g ) capacitor c=0.00229818f \
 //x=41.75 //y=5.335 //x2=41.53 //y2=6.2
cc_3178 ( N_noxref_9_c_3788_p N_CLK_M104_noxref_g ) capacitor c=0.0179041f \
 //x=41.75 //y=5.56 //x2=41.53 //y2=6.2
cc_3179 ( N_noxref_9_c_3842_p N_CLK_M105_noxref_g ) capacitor c=0.00955829f \
 //x=42.515 //y=5.335 //x2=41.97 //y2=6.2
cc_3180 ( N_noxref_9_c_3786_p N_CLK_M105_noxref_g ) capacitor c=0.00230699f \
 //x=41.75 //y=5.335 //x2=41.97 //y2=6.2
cc_3181 ( N_noxref_9_c_3788_p N_CLK_M105_noxref_g ) capacitor c=0.0179041f \
 //x=41.75 //y=5.56 //x2=41.97 //y2=6.2
cc_3182 ( N_noxref_9_c_3845_p N_CLK_c_5202_n ) capacitor c=5.72528e-19 \
 //x=27.2 //y=1.055 //x2=28.175 //y2=1.09
cc_3183 ( N_noxref_9_c_3846_p N_CLK_c_5202_n ) capacitor c=0.00150277f \
 //x=27.2 //y=1.4 //x2=28.175 //y2=1.09
cc_3184 ( N_noxref_9_c_3847_p N_CLK_c_5202_n ) capacitor c=0.0160123f \
 //x=27.73 //y=1.055 //x2=28.175 //y2=1.09
cc_3185 ( N_noxref_9_c_3848_p N_CLK_c_5205_n ) capacitor c=0.00111227f \
 //x=27.2 //y=1.71 //x2=28.175 //y2=1.4
cc_3186 ( N_noxref_9_c_3849_p N_CLK_c_5205_n ) capacitor c=0.0124075f \
 //x=27.73 //y=1.4 //x2=28.175 //y2=1.4
cc_3187 ( N_noxref_9_c_3847_p N_CLK_c_5022_n ) capacitor c=9.19165e-19 \
 //x=27.73 //y=1.055 //x2=28.7 //y2=1.09
cc_3188 ( N_noxref_9_c_3849_p N_CLK_c_5023_n ) capacitor c=0.0010154f \
 //x=27.73 //y=1.4 //x2=28.7 //y2=1.4
cc_3189 ( N_noxref_9_c_3849_p N_CLK_c_5024_n ) capacitor c=9.23422e-19 \
 //x=27.73 //y=1.4 //x2=28.7 //y2=1.63
cc_3190 ( N_noxref_9_c_3777_p N_CLK_c_5025_n ) capacitor c=0.00136403f \
 //x=27.5 //y=2.375 //x2=28.7 //y2=2.095
cc_3191 ( N_noxref_9_c_3773_p N_CLK_c_5025_n ) capacitor c=0.0020754f //x=27.5 \
 //y=2.26 //x2=28.7 //y2=2.095
cc_3192 ( N_noxref_9_c_3779_p N_CLK_c_5025_n ) capacitor c=0.00964411f \
 //x=27.2 //y=2.095 //x2=28.7 //y2=2.095
cc_3193 ( N_noxref_9_c_3786_p N_CLK_c_5213_n ) capacitor c=0.0017286f \
 //x=41.75 //y=5.335 //x2=41.895 //y2=4.97
cc_3194 ( N_noxref_9_c_3788_p N_CLK_c_5213_n ) capacitor c=0.00293647f \
 //x=41.75 //y=5.56 //x2=41.895 //y2=4.97
cc_3195 ( N_noxref_9_c_3782_p N_CLK_c_5030_n ) capacitor c=0.00123917f \
 //x=27.5 //y=4.88 //x2=28.61 //y2=4.88
cc_3196 ( N_noxref_9_c_3705_n N_CLK_c_5030_n ) capacitor c=0.0169508f \
 //x=28.065 //y=4.97 //x2=28.61 //y2=4.88
cc_3197 ( N_noxref_9_c_3784_p N_CLK_c_5030_n ) capacitor c=0.00406071f \
 //x=27.775 //y=4.97 //x2=28.61 //y2=4.88
cc_3198 ( N_noxref_9_c_3605_n N_CLK_c_5075_n ) capacitor c=3.77911e-19 \
 //x=41.63 //y=5.335 //x2=41.56 //y2=4.88
cc_3199 ( N_noxref_9_c_3661_n RN ) capacitor c=0.0666364f //x=43.41 //y=4.095 \
 //x2=42.67 //y2=3.51
cc_3200 ( N_noxref_9_c_3667_n RN ) capacitor c=0.0172847f //x=43.41 //y=4.415 \
 //x2=42.67 //y2=3.51
cc_3201 ( N_noxref_9_c_3670_n RN ) capacitor c=0.0121545f //x=43.41 //y=5.25 \
 //x2=42.67 //y2=3.51
cc_3202 ( N_noxref_9_c_3865_p RN ) capacitor c=6.89957e-19 //x=43.41 //y=4.25 \
 //x2=42.67 //y2=3.51
cc_3203 ( N_noxref_9_c_3615_n RN ) capacitor c=0.0209751f //x=43.255 //y=4.25 \
 //x2=42.67 //y2=3.51
cc_3204 ( N_noxref_9_c_3697_n RN ) capacitor c=0.00325739f //x=45.12 //y=4.265 \
 //x2=42.67 //y2=3.51
cc_3205 ( N_noxref_9_c_3661_n RN ) capacitor c=0.00168915f //x=43.41 //y=4.095 \
 //x2=46.37 //y2=3.51
cc_3206 ( N_noxref_9_c_3670_n RN ) capacitor c=3.82204e-19 //x=43.41 //y=5.25 \
 //x2=46.37 //y2=3.51
cc_3207 ( N_noxref_9_c_3695_n RN ) capacitor c=0.0281978f //x=45.465 //y=4.265 \
 //x2=46.37 //y2=3.51
cc_3208 ( N_noxref_9_c_3563_n N_RN_c_6509_n ) capacitor c=0.0220634f \
 //x=38.025 //y=4.25 //x2=34.53 //y2=4.75
cc_3209 ( N_noxref_9_c_3872_p N_RN_c_6667_n ) capacitor c=5.60322e-19 \
 //x=42.925 //y=1.305 //x2=42.67 //y2=2.465
cc_3210 ( N_noxref_9_c_3661_n N_RN_c_6667_n ) capacitor c=0.0170216f //x=43.41 \
 //y=4.095 //x2=42.67 //y2=2.465
cc_3211 ( N_noxref_9_c_3874_p N_RN_c_6667_n ) capacitor c=4.27678e-19 \
 //x=42.63 //y=5.335 //x2=42.67 //y2=2.465
cc_3212 ( N_noxref_9_c_3708_n N_RN_c_6670_n ) capacitor c=0.00228791f \
 //x=43.325 //y=5.335 //x2=42.67 //y2=4.75
cc_3213 ( N_noxref_9_c_3670_n N_RN_c_6670_n ) capacitor c=0.0151931f //x=43.41 \
 //y=5.25 //x2=42.67 //y2=4.75
cc_3214 ( N_noxref_9_c_3874_p N_RN_c_6670_n ) capacitor c=0.0223028f //x=42.63 \
 //y=5.335 //x2=42.67 //y2=4.75
cc_3215 ( N_noxref_9_c_3878_p N_RN_c_6670_n ) capacitor c=0.00266858f \
 //x=42.63 //y=5.56 //x2=42.67 //y2=4.75
cc_3216 ( N_noxref_9_c_3777_p N_RN_c_6386_n ) capacitor c=0.017138f //x=27.5 \
 //y=2.375 //x2=33.205 //y2=2.37
cc_3217 ( N_noxref_9_c_3531_n N_RN_c_6386_n ) capacitor c=0.0143423f //x=27.5 \
 //y=4.1 //x2=33.205 //y2=2.37
cc_3218 ( N_noxref_9_c_3773_p N_RN_c_6386_n ) capacitor c=5.18204e-19 //x=27.5 \
 //y=2.26 //x2=33.205 //y2=2.37
cc_3219 ( N_noxref_9_c_3779_p N_RN_c_6386_n ) capacitor c=3.41298e-19 //x=27.2 \
 //y=2.095 //x2=33.205 //y2=2.37
cc_3220 ( N_noxref_9_c_3607_n N_RN_c_6602_n ) capacitor c=0.021696f //x=43.01 \
 //y=1.845 //x2=46.165 //y2=2.4
cc_3221 ( N_noxref_9_c_3661_n N_RN_c_6602_n ) capacitor c=0.027451f //x=43.41 \
 //y=4.095 //x2=46.165 //y2=2.4
cc_3222 ( N_noxref_9_c_3710_n N_RN_c_6606_n ) capacitor c=0.0113611f //x=50.81 \
 //y=4.095 //x2=59.105 //y2=2.385
cc_3223 ( N_noxref_9_c_3724_n N_RN_c_6606_n ) capacitor c=0.0170052f //x=50.81 \
 //y=2.26 //x2=59.105 //y2=2.385
cc_3224 ( N_noxref_9_c_3754_n N_RN_c_6606_n ) capacitor c=2.98635e-19 \
 //x=50.81 //y=2.26 //x2=59.105 //y2=2.385
cc_3225 ( N_noxref_9_c_3538_n N_RN_c_6525_n ) capacitor c=0.0113611f //x=37.86 \
 //y=4.09 //x2=42.515 //y2=2.315
cc_3226 ( N_noxref_9_c_3553_n N_RN_c_6525_n ) capacitor c=0.0170024f //x=37.86 \
 //y=2.26 //x2=42.515 //y2=2.315
cc_3227 ( N_noxref_9_c_3587_n N_RN_c_6525_n ) capacitor c=2.98635e-19 \
 //x=37.86 //y=2.26 //x2=42.515 //y2=2.315
cc_3228 ( N_noxref_9_c_3872_p N_RN_c_6686_n ) capacitor c=4.13793e-19 \
 //x=42.925 //y=1.305 //x2=42.835 //y2=2.315
cc_3229 ( N_noxref_9_c_3661_n N_RN_c_6686_n ) capacitor c=0.00372846f \
 //x=43.41 //y=4.095 //x2=42.835 //y2=2.315
cc_3230 ( N_noxref_9_c_3661_n N_RN_c_6688_n ) capacitor c=0.00115564f \
 //x=43.41 //y=4.095 //x2=42.67 //y2=2.26
cc_3231 ( N_noxref_9_c_3708_n N_RN_c_6689_n ) capacitor c=0.00130631f \
 //x=43.325 //y=5.335 //x2=42.67 //y2=4.88
cc_3232 ( N_noxref_9_c_3670_n N_RN_c_6689_n ) capacitor c=0.00129641f \
 //x=43.41 //y=5.25 //x2=42.67 //y2=4.88
cc_3233 ( N_noxref_9_c_3874_p N_RN_c_6689_n ) capacitor c=0.00346017f \
 //x=42.63 //y=5.335 //x2=42.67 //y2=4.88
cc_3234 ( N_noxref_9_c_3878_p N_RN_c_6689_n ) capacitor c=0.00624059f \
 //x=42.63 //y=5.56 //x2=42.67 //y2=4.88
cc_3235 ( N_noxref_9_c_3842_p N_RN_M106_noxref_g ) capacitor c=0.00955829f \
 //x=42.515 //y=5.335 //x2=42.41 //y2=6.2
cc_3236 ( N_noxref_9_c_3707_n N_RN_M106_noxref_g ) capacitor c=0.00226521f \
 //x=42.63 //y=5.56 //x2=42.41 //y2=6.2
cc_3237 ( N_noxref_9_c_3878_p N_RN_M106_noxref_g ) capacitor c=0.0178885f \
 //x=42.63 //y=5.56 //x2=42.41 //y2=6.2
cc_3238 ( N_noxref_9_c_3707_n N_RN_M107_noxref_g ) capacitor c=0.00381703f \
 //x=42.63 //y=5.56 //x2=42.85 //y2=6.2
cc_3239 ( N_noxref_9_c_3708_n N_RN_M107_noxref_g ) capacitor c=0.0108612f \
 //x=43.325 //y=5.335 //x2=42.85 //y2=6.2
cc_3240 ( N_noxref_9_c_3878_p N_RN_M107_noxref_g ) capacitor c=0.0188608f \
 //x=42.63 //y=5.56 //x2=42.85 //y2=6.2
cc_3241 ( N_noxref_9_c_3872_p N_RN_c_6699_n ) capacitor c=4.64015e-19 \
 //x=42.925 //y=1.305 //x2=42.66 //y2=1.095
cc_3242 ( N_noxref_9_M26_noxref_d N_RN_c_6699_n ) capacitor c=0.00137165f \
 //x=42.735 //y=1.095 //x2=42.66 //y2=1.095
cc_3243 ( N_noxref_9_c_3872_p N_RN_c_6701_n ) capacitor c=0.0026012f \
 //x=42.925 //y=1.305 //x2=42.66 //y2=1.44
cc_3244 ( N_noxref_9_c_3606_n N_RN_c_6701_n ) capacitor c=0.00127432f \
 //x=42.925 //y=1.76 //x2=42.66 //y2=1.44
cc_3245 ( N_noxref_9_M26_noxref_d N_RN_c_6701_n ) capacitor c=0.00237422f \
 //x=42.735 //y=1.095 //x2=42.66 //y2=1.44
cc_3246 ( N_noxref_9_c_3606_n N_RN_c_6704_n ) capacitor c=0.00441386f \
 //x=42.925 //y=1.76 //x2=42.66 //y2=1.75
cc_3247 ( N_noxref_9_c_3872_p N_RN_c_6705_n ) capacitor c=5.29969e-19 \
 //x=42.925 //y=1.305 //x2=43.035 //y2=0.94
cc_3248 ( N_noxref_9_M26_noxref_d N_RN_c_6705_n ) capacitor c=0.0020782f \
 //x=42.735 //y=1.095 //x2=43.035 //y2=0.94
cc_3249 ( N_noxref_9_c_3872_p N_RN_c_6707_n ) capacitor c=4.32061e-19 \
 //x=42.925 //y=1.305 //x2=43.035 //y2=1.595
cc_3250 ( N_noxref_9_c_3606_n N_RN_c_6707_n ) capacitor c=0.00942306f \
 //x=42.925 //y=1.76 //x2=43.035 //y2=1.595
cc_3251 ( N_noxref_9_c_3709_n N_RN_c_6707_n ) capacitor c=0.00194716f \
 //x=43.325 //y=1.845 //x2=43.035 //y2=1.595
cc_3252 ( N_noxref_9_M26_noxref_d N_RN_c_6707_n ) capacitor c=0.00356097f \
 //x=42.735 //y=1.095 //x2=43.035 //y2=1.595
cc_3253 ( N_noxref_9_c_3872_p N_RN_c_6711_n ) capacitor c=5.24634e-19 \
 //x=42.925 //y=1.305 //x2=43.19 //y2=1.095
cc_3254 ( N_noxref_9_M26_noxref_d N_RN_c_6711_n ) capacitor c=0.00139206f \
 //x=42.735 //y=1.095 //x2=43.19 //y2=1.095
cc_3255 ( N_noxref_9_c_3872_p N_RN_c_6713_n ) capacitor c=0.00307978f \
 //x=42.925 //y=1.305 //x2=43.19 //y2=1.44
cc_3256 ( N_noxref_9_c_3606_n N_RN_c_6713_n ) capacitor c=0.00363411f \
 //x=42.925 //y=1.76 //x2=43.19 //y2=1.44
cc_3257 ( N_noxref_9_c_3709_n N_RN_c_6713_n ) capacitor c=0.00323576f \
 //x=43.325 //y=1.845 //x2=43.19 //y2=1.44
cc_3258 ( N_noxref_9_M26_noxref_d N_RN_c_6713_n ) capacitor c=0.00237422f \
 //x=42.735 //y=1.095 //x2=43.19 //y2=1.44
cc_3259 ( N_noxref_9_c_3661_n N_RN_c_6717_n ) capacitor c=3.96703e-19 \
 //x=43.41 //y=4.095 //x2=42.67 //y2=2.26
cc_3260 ( N_noxref_9_c_3606_n N_RN_c_6718_n ) capacitor c=0.00362297f \
 //x=42.925 //y=1.76 //x2=42.67 //y2=2.095
cc_3261 ( N_noxref_9_c_3661_n N_RN_c_6718_n ) capacitor c=0.00282067f \
 //x=43.41 //y=4.095 //x2=42.67 //y2=2.095
cc_3262 ( N_noxref_9_c_3670_n N_RN_c_6720_n ) capacitor c=0.007387f //x=43.41 \
 //y=5.25 //x2=42.67 //y2=4.88
cc_3263 ( N_noxref_9_c_3874_p N_RN_c_6720_n ) capacitor c=0.00203307f \
 //x=42.63 //y=5.335 //x2=42.67 //y2=4.88
cc_3264 ( N_noxref_9_c_3878_p N_RN_c_6720_n ) capacitor c=0.00375636f \
 //x=42.63 //y=5.56 //x2=42.67 //y2=4.88
cc_3265 ( N_noxref_9_c_3710_n N_noxref_14_c_7727_n ) capacitor c=0.00238091f \
 //x=50.81 //y=4.095 //x2=53.4 //y2=4.1
cc_3266 ( N_noxref_9_c_3718_n N_noxref_14_c_7728_n ) capacitor c=4.60155e-19 \
 //x=50.81 //y=4.735 //x2=53.4 //y2=4.755
cc_3267 ( N_noxref_9_c_3723_n N_noxref_14_c_7729_n ) capacitor c=3.5728e-19 \
 //x=50.81 //y=4.25 //x2=53.4 //y2=4.25
cc_3268 ( N_noxref_9_c_3695_n N_noxref_14_c_7730_n ) capacitor c=0.00179992f \
 //x=45.465 //y=4.265 //x2=53.56 //y2=4.26
cc_3269 ( N_noxref_9_c_3695_n N_noxref_15_c_8557_n ) capacitor c=0.00325326f \
 //x=45.465 //y=4.265 //x2=47.48 //y2=3.685
cc_3270 ( N_noxref_9_c_3695_n N_noxref_15_c_8553_n ) capacitor c=0.0241709f \
 //x=45.465 //y=4.265 //x2=47.48 //y2=4.75
cc_3271 ( N_noxref_9_c_3717_n N_noxref_15_c_8571_n ) capacitor c=0.00394271f \
 //x=50.81 //y=4.415 //x2=50.955 //y2=5.38
cc_3272 ( N_noxref_9_c_3718_n N_noxref_15_c_8571_n ) capacitor c=0.0215252f \
 //x=50.81 //y=4.735 //x2=50.955 //y2=5.38
cc_3273 ( N_noxref_9_c_3738_n N_noxref_15_c_8571_n ) capacitor c=0.00469257f \
 //x=50.84 //y=4.88 //x2=50.955 //y2=5.38
cc_3274 ( N_noxref_9_M116_noxref_g N_noxref_15_c_8571_n ) capacitor \
 c=0.00842859f //x=50.85 //y=6.2 //x2=50.955 //y2=5.38
cc_3275 ( N_noxref_9_c_3757_n N_noxref_15_c_8571_n ) capacitor c=8.41897e-19 \
 //x=50.84 //y=4.88 //x2=50.955 //y2=5.38
cc_3276 ( N_noxref_9_c_3747_n N_noxref_15_c_8572_n ) capacitor c=0.00119302f \
 //x=50.845 //y=1.43 //x2=51.11 //y2=1.75
cc_3277 ( N_noxref_9_c_3749_n N_noxref_15_c_8572_n ) capacitor c=0.00439215f \
 //x=50.845 //y=1.74 //x2=51.11 //y2=1.75
cc_3278 ( N_noxref_9_c_3941_p N_noxref_15_c_8572_n ) capacitor c=0.00929773f \
 //x=51.22 //y=1.585 //x2=51.11 //y2=1.75
cc_3279 ( N_noxref_9_c_3753_n N_noxref_15_c_8572_n ) capacitor c=0.00341295f \
 //x=51.375 //y=1.43 //x2=51.11 //y2=1.75
cc_3280 ( N_noxref_9_c_3943_p N_noxref_15_c_8572_n ) capacitor c=0.00341688f \
 //x=50.81 //y=2.095 //x2=51.11 //y2=1.75
cc_3281 ( N_noxref_9_M117_noxref_g N_noxref_15_c_8653_n ) capacitor \
 c=0.0107429f //x=51.29 //y=6.2 //x2=51.465 //y2=5.38
cc_3282 ( N_noxref_9_c_3941_p N_noxref_15_c_8654_n ) capacitor c=0.00194324f \
 //x=51.22 //y=1.585 //x2=51.465 //y2=1.835
cc_3283 ( N_noxref_9_c_3753_n N_noxref_15_c_8654_n ) capacitor c=0.00323005f \
 //x=51.375 //y=1.43 //x2=51.465 //y2=1.835
cc_3284 ( N_noxref_9_c_3710_n N_noxref_15_c_8574_n ) capacitor c=0.0377235f \
 //x=50.81 //y=4.095 //x2=51.55 //y2=3.37
cc_3285 ( N_noxref_9_c_3724_n N_noxref_15_c_8574_n ) capacitor c=0.0138368f \
 //x=50.81 //y=2.26 //x2=51.55 //y2=3.37
cc_3286 ( N_noxref_9_c_3734_n N_noxref_15_c_8574_n ) capacitor c=9.26054e-19 \
 //x=50.81 //y=2.26 //x2=51.55 //y2=3.37
cc_3287 ( N_noxref_9_c_3754_n N_noxref_15_c_8574_n ) capacitor c=0.00268898f \
 //x=50.81 //y=2.26 //x2=51.55 //y2=3.37
cc_3288 ( N_noxref_9_c_3943_p N_noxref_15_c_8574_n ) capacitor c=0.00309058f \
 //x=50.81 //y=2.095 //x2=51.55 //y2=3.37
cc_3289 ( N_noxref_9_c_3710_n N_noxref_15_c_8661_n ) capacitor c=0.0176571f \
 //x=50.81 //y=4.095 //x2=51.55 //y2=3.69
cc_3290 ( N_noxref_9_c_3710_n N_noxref_15_c_8576_n ) capacitor c=0.0178243f \
 //x=50.81 //y=4.095 //x2=51.55 //y2=5.295
cc_3291 ( N_noxref_9_c_3717_n N_noxref_15_c_8576_n ) capacitor c=0.0145387f \
 //x=50.81 //y=4.415 //x2=51.55 //y2=5.295
cc_3292 ( N_noxref_9_c_3718_n N_noxref_15_c_8576_n ) capacitor c=0.0281783f \
 //x=50.81 //y=4.735 //x2=51.55 //y2=5.295
cc_3293 ( N_noxref_9_c_3723_n N_noxref_15_c_8576_n ) capacitor c=5.68333e-19 \
 //x=50.81 //y=4.25 //x2=51.55 //y2=5.295
cc_3294 ( N_noxref_9_c_3695_n N_noxref_15_c_8576_n ) capacitor c=0.00410789f \
 //x=45.465 //y=4.265 //x2=51.55 //y2=5.295
cc_3295 ( N_noxref_9_c_3738_n N_noxref_15_c_8576_n ) capacitor c=7.76118e-19 \
 //x=50.84 //y=4.88 //x2=51.55 //y2=5.295
cc_3296 ( N_noxref_9_c_3959_p N_noxref_15_c_8576_n ) capacitor c=0.00845606f \
 //x=51.215 //y=4.97 //x2=51.55 //y2=5.295
cc_3297 ( N_noxref_9_c_3757_n N_noxref_15_c_8576_n ) capacitor c=0.00142201f \
 //x=50.84 //y=4.88 //x2=51.55 //y2=5.295
cc_3298 ( N_noxref_9_M116_noxref_g N_noxref_15_c_8670_n ) capacitor \
 c=0.00192712f //x=50.85 //y=6.2 //x2=51.07 //y2=5.38
cc_3299 ( N_noxref_9_M117_noxref_g N_noxref_15_c_8670_n ) capacitor \
 c=0.00312463f //x=51.29 //y=6.2 //x2=51.07 //y2=5.38
cc_3300 ( N_noxref_9_c_3959_p N_noxref_15_c_8670_n ) capacitor c=0.0020909f \
 //x=51.215 //y=4.97 //x2=51.07 //y2=5.38
cc_3301 ( N_noxref_9_c_3744_n N_noxref_15_c_8587_n ) capacitor c=0.00120406f \
 //x=50.845 //y=1.085 //x2=51.11 //y2=1.18
cc_3302 ( N_noxref_9_c_3747_n N_noxref_15_c_8587_n ) capacitor c=0.00218772f \
 //x=50.845 //y=1.43 //x2=51.11 //y2=1.18
cc_3303 ( N_noxref_9_c_3966_p N_noxref_15_c_8587_n ) capacitor c=5.50523e-19 \
 //x=51.22 //y=0.93 //x2=51.11 //y2=1.18
cc_3304 ( N_noxref_9_c_3941_p N_noxref_15_c_8587_n ) capacitor c=5.67071e-19 \
 //x=51.22 //y=1.585 //x2=51.11 //y2=1.18
cc_3305 ( N_noxref_9_c_3752_n N_noxref_15_c_8587_n ) capacitor c=0.00108157f \
 //x=51.375 //y=1.085 //x2=51.11 //y2=1.18
cc_3306 ( N_noxref_9_c_3753_n N_noxref_15_c_8587_n ) capacitor c=0.00312028f \
 //x=51.375 //y=1.43 //x2=51.11 //y2=1.18
cc_3307 ( N_noxref_9_c_3710_n N_noxref_15_c_8679_n ) capacitor c=0.00103412f \
 //x=50.81 //y=4.095 //x2=51.55 //y2=3.51
cc_3308 ( N_noxref_9_c_3695_n N_noxref_15_c_8588_n ) capacitor c=0.0195986f \
 //x=45.465 //y=4.265 //x2=47.835 //y2=3.51
cc_3309 ( N_noxref_9_c_3695_n N_noxref_15_c_8589_n ) capacitor c=0.00872679f \
 //x=45.465 //y=4.265 //x2=48.435 //y2=3.48
cc_3310 ( N_noxref_9_c_3695_n N_noxref_15_c_8593_n ) capacitor c=0.00854864f \
 //x=45.465 //y=4.265 //x2=49.67 //y2=3.51
cc_3311 ( N_noxref_9_c_3710_n N_noxref_15_c_8599_n ) capacitor c=0.0252893f \
 //x=50.81 //y=4.095 //x2=51.71 //y2=3.51
cc_3312 ( N_noxref_9_c_3717_n N_noxref_15_c_8599_n ) capacitor c=0.00355392f \
 //x=50.81 //y=4.415 //x2=51.71 //y2=3.51
cc_3313 ( N_noxref_9_c_3695_n N_noxref_15_c_8599_n ) capacitor c=0.0270544f \
 //x=45.465 //y=4.265 //x2=51.71 //y2=3.51
cc_3314 ( N_noxref_9_c_3695_n N_noxref_15_c_8600_n ) capacitor c=0.0161728f \
 //x=45.465 //y=4.265 //x2=47.64 //y2=3.525
cc_3315 ( N_noxref_9_M116_noxref_g N_noxref_15_c_8687_n ) capacitor \
 c=0.0178987f //x=50.85 //y=6.2 //x2=51.07 //y2=5.56
cc_3316 ( N_noxref_9_M117_noxref_g N_noxref_15_c_8687_n ) capacitor \
 c=0.0178506f //x=51.29 //y=6.2 //x2=51.07 //y2=5.56
cc_3317 ( N_noxref_9_c_3959_p N_noxref_15_c_8687_n ) capacitor c=0.00291714f \
 //x=51.215 //y=4.97 //x2=51.07 //y2=5.56
cc_3318 ( N_noxref_9_c_3744_n N_noxref_15_M31_noxref_d ) capacitor \
 c=0.00137165f //x=50.845 //y=1.085 //x2=50.92 //y2=1.085
cc_3319 ( N_noxref_9_c_3747_n N_noxref_15_M31_noxref_d ) capacitor \
 c=0.00237422f //x=50.845 //y=1.43 //x2=50.92 //y2=1.085
cc_3320 ( N_noxref_9_c_3966_p N_noxref_15_M31_noxref_d ) capacitor \
 c=0.0020782f //x=51.22 //y=0.93 //x2=50.92 //y2=1.085
cc_3321 ( N_noxref_9_c_3941_p N_noxref_15_M31_noxref_d ) capacitor \
 c=0.00356097f //x=51.22 //y=1.585 //x2=50.92 //y2=1.085
cc_3322 ( N_noxref_9_c_3752_n N_noxref_15_M31_noxref_d ) capacitor \
 c=8.50095e-19 //x=51.375 //y=1.085 //x2=50.92 //y2=1.085
cc_3323 ( N_noxref_9_c_3753_n N_noxref_15_M31_noxref_d ) capacitor \
 c=0.00237422f //x=51.375 //y=1.43 //x2=50.92 //y2=1.085
cc_3324 ( N_noxref_9_c_3777_p N_noxref_16_c_9906_n ) capacitor c=0.00357748f \
 //x=27.5 //y=2.375 //x2=25.65 //y2=2.995
cc_3325 ( N_noxref_9_c_3531_n N_noxref_16_c_9906_n ) capacitor c=0.00650352f \
 //x=27.5 //y=4.1 //x2=25.65 //y2=2.995
cc_3326 ( N_noxref_9_c_3531_n N_noxref_16_c_9913_n ) capacitor c=0.00239869f \
 //x=27.5 //y=4.1 //x2=25.65 //y2=3.315
cc_3327 ( N_noxref_9_c_3531_n N_noxref_16_c_9914_n ) capacitor c=0.0157233f \
 //x=27.5 //y=4.1 //x2=25.65 //y2=5.295
cc_3328 ( N_noxref_9_c_3768_p N_noxref_16_c_9914_n ) capacitor c=0.00352705f \
 //x=27.5 //y=4.42 //x2=25.65 //y2=5.295
cc_3329 ( N_noxref_9_c_3532_n N_noxref_16_c_9914_n ) capacitor c=0.00754567f \
 //x=27.5 //y=4.755 //x2=25.65 //y2=5.295
cc_3330 ( N_noxref_9_c_3534_n N_noxref_16_c_9914_n ) capacitor c=0.00219376f \
 //x=27.66 //y=4.26 //x2=25.65 //y2=5.295
cc_3331 ( N_noxref_9_c_3556_n N_noxref_16_c_10009_n ) capacitor c=0.00221297f \
 //x=30.075 //y=4.25 //x2=29.935 //y2=3.125
cc_3332 ( N_noxref_9_c_3531_n N_noxref_16_c_9956_n ) capacitor c=0.0303002f \
 //x=27.5 //y=4.1 //x2=29.505 //y2=3.125
cc_3333 ( N_noxref_9_c_3768_p N_noxref_16_c_9956_n ) capacitor c=0.00327574f \
 //x=27.5 //y=4.42 //x2=29.505 //y2=3.125
cc_3334 ( N_noxref_9_c_3556_n N_noxref_16_c_9956_n ) capacitor c=0.0554955f \
 //x=30.075 //y=4.25 //x2=29.505 //y2=3.125
cc_3335 ( N_noxref_9_c_3534_n N_noxref_16_c_9956_n ) capacitor c=0.00800638f \
 //x=27.66 //y=4.26 //x2=29.505 //y2=3.125
cc_3336 ( N_noxref_9_c_3538_n N_noxref_16_c_10025_n ) capacitor c=3.74563e-19 \
 //x=37.86 //y=4.09 //x2=37.335 //y2=3.125
cc_3337 ( N_noxref_9_c_3563_n N_noxref_16_c_10025_n ) capacitor c=0.00273952f \
 //x=38.025 //y=4.25 //x2=37.335 //y2=3.125
cc_3338 ( N_noxref_9_c_3538_n N_noxref_16_c_10028_n ) capacitor c=0.023034f \
 //x=37.86 //y=4.09 //x2=38.21 //y2=3.14
cc_3339 ( N_noxref_9_c_3615_n N_noxref_16_c_10028_n ) capacitor c=0.00309476f \
 //x=43.255 //y=4.25 //x2=38.21 //y2=3.14
cc_3340 ( N_noxref_9_c_3615_n N_noxref_16_c_10036_n ) capacitor c=0.0160193f \
 //x=43.255 //y=4.25 //x2=40.67 //y2=3.13
cc_3341 ( N_noxref_9_c_3661_n N_noxref_16_c_10055_n ) capacitor c=0.0259012f \
 //x=43.41 //y=4.095 //x2=55.235 //y2=3.14
cc_3342 ( N_noxref_9_c_3710_n N_noxref_16_c_10055_n ) capacitor c=0.0206289f \
 //x=50.81 //y=4.095 //x2=55.235 //y2=3.14
cc_3343 ( N_noxref_9_c_3695_n N_noxref_16_c_10055_n ) capacitor c=0.0577768f \
 //x=45.465 //y=4.265 //x2=55.235 //y2=3.14
cc_3344 ( N_noxref_9_c_3697_n N_noxref_16_c_10055_n ) capacitor c=0.0133642f \
 //x=45.12 //y=4.265 //x2=55.235 //y2=3.14
cc_3345 ( N_noxref_9_c_3768_p N_VDD_c_11464_n ) capacitor c=3.90015e-19 \
 //x=27.5 //y=4.42 //x2=78.895 //y2=7.585
cc_3346 ( N_noxref_9_c_3605_n N_VDD_c_11464_n ) capacitor c=0.00621352f \
 //x=41.63 //y=5.335 //x2=78.895 //y2=7.585
cc_3347 ( N_noxref_9_c_3842_p N_VDD_c_11464_n ) capacitor c=0.00627192f \
 //x=42.515 //y=5.335 //x2=78.895 //y2=7.585
cc_3348 ( N_noxref_9_c_3707_n N_VDD_c_11464_n ) capacitor c=0.00256036f \
 //x=42.63 //y=5.56 //x2=78.895 //y2=7.585
cc_3349 ( N_noxref_9_c_3708_n N_VDD_c_11464_n ) capacitor c=0.00829214f \
 //x=43.325 //y=5.335 //x2=78.895 //y2=7.585
cc_3350 ( N_noxref_9_c_3667_n N_VDD_c_11464_n ) capacitor c=2.29405e-19 \
 //x=43.41 //y=4.415 //x2=78.895 //y2=7.585
cc_3351 ( N_noxref_9_c_3610_n N_VDD_c_11464_n ) capacitor c=0.00261804f \
 //x=40.872 //y=5.335 //x2=78.895 //y2=7.585
cc_3352 ( N_noxref_9_c_3786_p N_VDD_c_11464_n ) capacitor c=0.00270108f \
 //x=41.75 //y=5.335 //x2=78.895 //y2=7.585
cc_3353 ( N_noxref_9_c_3865_p N_VDD_c_11464_n ) capacitor c=3.94104e-19 \
 //x=43.41 //y=4.25 //x2=78.895 //y2=7.585
cc_3354 ( N_noxref_9_c_3622_n N_VDD_c_11464_n ) capacitor c=0.0024232f \
 //x=40.87 //y=5.56 //x2=78.895 //y2=7.585
cc_3355 ( N_noxref_9_c_3788_p N_VDD_c_11464_n ) capacitor c=0.0024232f \
 //x=41.75 //y=5.56 //x2=78.895 //y2=7.585
cc_3356 ( N_noxref_9_c_3878_p N_VDD_c_11464_n ) capacitor c=0.0024232f \
 //x=42.63 //y=5.56 //x2=78.895 //y2=7.585
cc_3357 ( N_noxref_9_c_3768_p N_VDD_c_11904_n ) capacitor c=3.24038e-19 \
 //x=27.5 //y=4.42 //x2=28.275 //y2=7.585
cc_3358 ( N_noxref_9_M86_noxref_g N_VDD_c_11904_n ) capacitor c=0.00755614f \
 //x=27.7 //y=6.2 //x2=28.275 //y2=7.585
cc_3359 ( N_noxref_9_M87_noxref_g N_VDD_c_11904_n ) capacitor c=0.00755544f \
 //x=28.14 //y=6.2 //x2=28.275 //y2=7.585
cc_3360 ( N_noxref_9_M100_noxref_g N_VDD_c_11854_n ) capacitor c=0.00697352f \
 //x=37.9 //y=6.2 //x2=38.475 //y2=7.585
cc_3361 ( N_noxref_9_M101_noxref_g N_VDD_c_11854_n ) capacitor c=0.00755544f \
 //x=38.34 //y=6.2 //x2=38.475 //y2=7.585
cc_3362 ( N_noxref_9_c_3605_n N_VDD_c_11859_n ) capacitor c=0.00202922f \
 //x=41.63 //y=5.335 //x2=41.225 //y2=7.585
cc_3363 ( N_noxref_9_c_3610_n N_VDD_c_11859_n ) capacitor c=9.3757e-19 \
 //x=40.872 //y=5.335 //x2=41.225 //y2=7.585
cc_3364 ( N_noxref_9_c_3622_n N_VDD_c_11859_n ) capacitor c=0.0138074f \
 //x=40.87 //y=5.56 //x2=41.225 //y2=7.585
cc_3365 ( N_noxref_9_c_3605_n N_VDD_c_12031_n ) capacitor c=0.0017708f \
 //x=41.63 //y=5.335 //x2=42.105 //y2=7.585
cc_3366 ( N_noxref_9_c_3842_p N_VDD_c_12031_n ) capacitor c=0.00202922f \
 //x=42.515 //y=5.335 //x2=42.105 //y2=7.585
cc_3367 ( N_noxref_9_c_3786_p N_VDD_c_12031_n ) capacitor c=9.4822e-19 \
 //x=41.75 //y=5.335 //x2=42.105 //y2=7.585
cc_3368 ( N_noxref_9_c_3788_p N_VDD_c_12031_n ) capacitor c=0.0138074f \
 //x=41.75 //y=5.56 //x2=42.105 //y2=7.585
cc_3369 ( N_noxref_9_c_3842_p N_VDD_c_12035_n ) capacitor c=0.00205906f \
 //x=42.515 //y=5.335 //x2=42.985 //y2=7.585
cc_3370 ( N_noxref_9_c_3707_n N_VDD_c_12035_n ) capacitor c=8.49654e-19 \
 //x=42.63 //y=5.56 //x2=42.985 //y2=7.585
cc_3371 ( N_noxref_9_c_3708_n N_VDD_c_12035_n ) capacitor c=0.00204238f \
 //x=43.325 //y=5.335 //x2=42.985 //y2=7.585
cc_3372 ( N_noxref_9_c_3878_p N_VDD_c_12035_n ) capacitor c=0.0138074f \
 //x=42.63 //y=5.56 //x2=42.985 //y2=7.585
cc_3373 ( N_noxref_9_c_3708_n N_VDD_c_12039_n ) capacitor c=0.00157252f \
 //x=43.325 //y=5.335 //x2=43.98 //y2=7.585
cc_3374 ( N_noxref_9_M116_noxref_g N_VDD_c_12040_n ) capacitor c=0.00697352f \
 //x=50.85 //y=6.2 //x2=51.425 //y2=7.585
cc_3375 ( N_noxref_9_M117_noxref_g N_VDD_c_12040_n ) capacitor c=0.00755544f \
 //x=51.29 //y=6.2 //x2=51.425 //y2=7.585
cc_3376 ( N_noxref_9_c_3768_p N_VDD_c_11735_n ) capacitor c=0.0012857f \
 //x=27.5 //y=4.42 //x2=26.39 //y2=7.585
cc_3377 ( N_noxref_9_c_3532_n N_VDD_c_11735_n ) capacitor c=0.00995973f \
 //x=27.5 //y=4.755 //x2=26.39 //y2=7.585
cc_3378 ( N_noxref_9_c_3533_n N_VDD_c_11735_n ) capacitor c=0.00268604f \
 //x=27.5 //y=4.25 //x2=26.39 //y2=7.585
cc_3379 ( N_noxref_9_c_3782_p N_VDD_c_11735_n ) capacitor c=0.00370784f \
 //x=27.5 //y=4.88 //x2=26.39 //y2=7.585
cc_3380 ( N_noxref_9_c_3784_p N_VDD_c_11735_n ) capacitor c=0.00590568f \
 //x=27.775 //y=4.97 //x2=26.39 //y2=7.585
cc_3381 ( N_noxref_9_c_3560_n N_VDD_c_11813_n ) capacitor c=5.71665e-19 \
 //x=30.715 //y=4.27 //x2=31.2 //y2=7.585
cc_3382 ( N_noxref_9_c_3561_n N_VDD_c_11813_n ) capacitor c=0.00910495f \
 //x=31.93 //y=4.25 //x2=31.2 //y2=7.585
cc_3383 ( N_noxref_9_c_3552_n N_VDD_c_11817_n ) capacitor c=8.4651e-19 \
 //x=37.86 //y=4.25 //x2=36.01 //y2=7.585
cc_3384 ( N_noxref_9_c_3563_n N_VDD_c_11817_n ) capacitor c=0.00875046f \
 //x=38.025 //y=4.25 //x2=36.01 //y2=7.585
cc_3385 ( N_noxref_9_c_3552_n N_VDD_c_11864_n ) capacitor c=0.00133334f \
 //x=37.86 //y=4.25 //x2=39.34 //y2=7.585
cc_3386 ( N_noxref_9_c_3610_n N_VDD_c_11864_n ) capacitor c=0.0022955f \
 //x=40.872 //y=5.335 //x2=39.34 //y2=7.585
cc_3387 ( N_noxref_9_c_3615_n N_VDD_c_11864_n ) capacitor c=0.00867114f \
 //x=43.255 //y=4.25 //x2=39.34 //y2=7.585
cc_3388 ( N_noxref_9_c_3571_n N_VDD_c_11864_n ) capacitor c=0.00226427f \
 //x=37.89 //y=4.88 //x2=39.34 //y2=7.585
cc_3389 ( N_noxref_9_c_3622_n N_VDD_c_11864_n ) capacitor c=0.00508013f \
 //x=40.87 //y=5.56 //x2=39.34 //y2=7.585
cc_3390 ( N_noxref_9_c_3637_n N_VDD_c_11864_n ) capacitor c=0.0129149f \
 //x=38.265 //y=4.97 //x2=39.34 //y2=7.585
cc_3391 ( N_noxref_9_c_3590_n N_VDD_c_11864_n ) capacitor c=2.73429e-19 \
 //x=37.89 //y=4.88 //x2=39.34 //y2=7.585
cc_3392 ( N_noxref_9_c_3707_n N_VDD_c_11928_n ) capacitor c=0.00282782f \
 //x=42.63 //y=5.56 //x2=44.15 //y2=7.585
cc_3393 ( N_noxref_9_c_3667_n N_VDD_c_11928_n ) capacitor c=0.00175322f \
 //x=43.41 //y=4.415 //x2=44.15 //y2=7.585
cc_3394 ( N_noxref_9_c_3670_n N_VDD_c_11928_n ) capacitor c=0.0292825f \
 //x=43.41 //y=5.25 //x2=44.15 //y2=7.585
cc_3395 ( N_noxref_9_c_3865_p N_VDD_c_11928_n ) capacitor c=0.00507985f \
 //x=43.41 //y=4.25 //x2=44.15 //y2=7.585
cc_3396 ( N_noxref_9_c_3697_n N_VDD_c_11928_n ) capacitor c=0.00867386f \
 //x=45.12 //y=4.265 //x2=44.15 //y2=7.585
cc_3397 ( N_noxref_9_c_3878_p N_VDD_c_11928_n ) capacitor c=0.00777981f \
 //x=42.63 //y=5.56 //x2=44.15 //y2=7.585
cc_3398 ( N_noxref_9_c_3723_n N_VDD_c_11988_n ) capacitor c=8.50173e-19 \
 //x=50.81 //y=4.25 //x2=48.96 //y2=7.585
cc_3399 ( N_noxref_9_c_3695_n N_VDD_c_11988_n ) capacitor c=0.00867144f \
 //x=45.465 //y=4.265 //x2=48.96 //y2=7.585
cc_3400 ( N_noxref_9_c_3723_n N_VDD_c_12066_n ) capacitor c=0.00143727f \
 //x=50.81 //y=4.25 //x2=52.29 //y2=7.585
cc_3401 ( N_noxref_9_c_3738_n N_VDD_c_12066_n ) capacitor c=0.00226427f \
 //x=50.84 //y=4.88 //x2=52.29 //y2=7.585
cc_3402 ( N_noxref_9_c_3959_p N_VDD_c_12066_n ) capacitor c=0.0129149f \
 //x=51.215 //y=4.97 //x2=52.29 //y2=7.585
cc_3403 ( N_noxref_9_c_3757_n N_VDD_c_12066_n ) capacitor c=2.73429e-19 \
 //x=50.84 //y=4.88 //x2=52.29 //y2=7.585
cc_3404 ( N_noxref_9_c_3768_p N_VDD_M86_noxref_s ) capacitor c=9.69442e-19 \
 //x=27.5 //y=4.42 //x2=27.345 //y2=5.2
cc_3405 ( N_noxref_9_c_3532_n N_VDD_M86_noxref_s ) capacitor c=0.0217321f \
 //x=27.5 //y=4.755 //x2=27.345 //y2=5.2
cc_3406 ( N_noxref_9_c_3782_p N_VDD_M86_noxref_s ) capacitor c=0.00983846f \
 //x=27.5 //y=4.88 //x2=27.345 //y2=5.2
cc_3407 ( N_noxref_9_M86_noxref_g N_VDD_M86_noxref_s ) capacitor c=0.053419f \
 //x=27.7 //y=6.2 //x2=27.345 //y2=5.2
cc_3408 ( N_noxref_9_c_3784_p N_VDD_M86_noxref_s ) capacitor c=0.0047643f \
 //x=27.775 //y=4.97 //x2=27.345 //y2=5.2
cc_3409 ( N_noxref_9_M87_noxref_g N_VDD_M87_noxref_d ) capacitor c=0.015318f \
 //x=28.14 //y=6.2 //x2=28.215 //y2=5.2
cc_3410 ( N_noxref_9_c_3610_n N_VDD_M98_noxref_s ) capacitor c=4.22189e-19 \
 //x=40.872 //y=5.335 //x2=36.665 //y2=5.2
cc_3411 ( N_noxref_9_M100_noxref_g N_VDD_M99_noxref_d ) capacitor c=0.015318f \
 //x=37.9 //y=6.2 //x2=37.535 //y2=5.2
cc_3412 ( N_noxref_9_c_3590_n N_VDD_M99_noxref_d ) capacitor c=3.50465e-19 \
 //x=37.89 //y=4.88 //x2=37.535 //y2=5.2
cc_3413 ( N_noxref_9_M101_noxref_g N_VDD_M101_noxref_d ) capacitor \
 c=0.0430452f //x=38.34 //y=6.2 //x2=38.415 //y2=5.2
cc_3414 ( N_noxref_9_c_3610_n N_VDD_M102_noxref_s ) capacitor c=0.0442713f \
 //x=40.872 //y=5.335 //x2=40.295 //y2=5.2
cc_3415 ( N_noxref_9_c_3786_p N_VDD_M102_noxref_s ) capacitor c=7.80122e-19 \
 //x=41.75 //y=5.335 //x2=40.295 //y2=5.2
cc_3416 ( N_noxref_9_c_3622_n N_VDD_M102_noxref_s ) capacitor c=0.0908457f \
 //x=40.87 //y=5.56 //x2=40.295 //y2=5.2
cc_3417 ( N_noxref_9_c_3605_n N_VDD_M103_noxref_d ) capacitor c=0.00700141f \
 //x=41.63 //y=5.335 //x2=41.165 //y2=5.2
cc_3418 ( N_noxref_9_c_3622_n N_VDD_M103_noxref_d ) capacitor c=0.0673792f \
 //x=40.87 //y=5.56 //x2=41.165 //y2=5.2
cc_3419 ( N_noxref_9_c_3788_p N_VDD_M103_noxref_d ) capacitor c=0.0674762f \
 //x=41.75 //y=5.56 //x2=41.165 //y2=5.2
cc_3420 ( N_noxref_9_c_3842_p N_VDD_M105_noxref_d ) capacitor c=0.00700141f \
 //x=42.515 //y=5.335 //x2=42.045 //y2=5.2
cc_3421 ( N_noxref_9_c_3788_p N_VDD_M105_noxref_d ) capacitor c=0.067493f \
 //x=41.75 //y=5.56 //x2=42.045 //y2=5.2
cc_3422 ( N_noxref_9_c_3878_p N_VDD_M105_noxref_d ) capacitor c=0.0674979f \
 //x=42.63 //y=5.56 //x2=42.045 //y2=5.2
cc_3423 ( N_noxref_9_c_3708_n N_VDD_M107_noxref_d ) capacitor c=0.00700141f \
 //x=43.325 //y=5.335 //x2=42.925 //y2=5.2
cc_3424 ( N_noxref_9_c_3878_p N_VDD_M107_noxref_d ) capacitor c=0.0675002f \
 //x=42.63 //y=5.56 //x2=42.925 //y2=5.2
cc_3425 ( N_noxref_9_c_3707_n N_VDD_M108_noxref_s ) capacitor c=0.00492616f \
 //x=42.63 //y=5.56 //x2=45.105 //y2=5.2
cc_3426 ( N_noxref_9_c_3708_n N_VDD_M108_noxref_s ) capacitor c=9.42705e-19 \
 //x=43.325 //y=5.335 //x2=45.105 //y2=5.2
cc_3427 ( N_noxref_9_c_3786_p N_VDD_M108_noxref_s ) capacitor c=2.11884e-19 \
 //x=41.75 //y=5.335 //x2=45.105 //y2=5.2
cc_3428 ( N_noxref_9_M116_noxref_g N_VDD_M115_noxref_d ) capacitor c=0.015318f \
 //x=50.85 //y=6.2 //x2=50.485 //y2=5.2
cc_3429 ( N_noxref_9_c_3757_n N_VDD_M115_noxref_d ) capacitor c=3.50465e-19 \
 //x=50.84 //y=4.88 //x2=50.485 //y2=5.2
cc_3430 ( N_noxref_9_M117_noxref_g N_VDD_M117_noxref_d ) capacitor \
 c=0.0430452f //x=51.29 //y=6.2 //x2=51.365 //y2=5.2
cc_3431 ( N_noxref_9_c_3872_p N_noxref_26_c_13264_n ) capacitor c=0.0036878f \
 //x=42.925 //y=1.305 //x2=43.325 //y2=0.72
cc_3432 ( N_noxref_9_c_3709_n N_noxref_26_c_13264_n ) capacitor c=0.00399931f \
 //x=43.325 //y=1.845 //x2=43.325 //y2=0.72
cc_3433 ( N_noxref_9_M26_noxref_d N_noxref_26_c_13264_n ) capacitor \
 c=0.00910163f //x=42.735 //y=1.095 //x2=43.325 //y2=0.72
cc_3434 ( N_noxref_9_M26_noxref_d N_noxref_26_c_13267_n ) capacitor \
 c=0.00120711f //x=42.735 //y=1.095 //x2=42.44 //y2=1.175
cc_3435 ( N_noxref_9_c_3605_n N_noxref_26_M25_noxref_d ) capacitor \
 c=0.00143783f //x=41.63 //y=5.335 //x2=41.2 //y2=1.09
cc_3436 ( N_noxref_9_c_3872_p N_noxref_26_M25_noxref_d ) capacitor \
 c=0.00802417f //x=42.925 //y=1.305 //x2=41.2 //y2=1.09
cc_3437 ( N_noxref_9_c_3872_p N_noxref_26_M26_noxref_s ) capacitor \
 c=0.0098487f //x=42.925 //y=1.305 //x2=42.305 //y2=0.555
cc_3438 ( N_noxref_9_c_3606_n N_noxref_26_M26_noxref_s ) capacitor \
 c=0.0283111f //x=42.925 //y=1.76 //x2=42.305 //y2=0.555
cc_3439 ( N_noxref_9_c_3709_n N_noxref_26_M26_noxref_s ) capacitor \
 c=0.00942148f //x=43.325 //y=1.845 //x2=42.305 //y2=0.555
cc_3440 ( N_noxref_9_c_3865_p N_noxref_26_M26_noxref_s ) capacitor \
 c=0.00108527f //x=43.41 //y=4.25 //x2=42.305 //y2=0.555
cc_3441 ( N_noxref_9_M26_noxref_d N_noxref_26_M26_noxref_s ) capacitor \
 c=0.0279003f //x=42.735 //y=1.095 //x2=42.305 //y2=0.555
cc_3442 ( N_noxref_9_c_3872_p N_noxref_27_M28_noxref_d ) capacitor \
 c=3.20746e-19 //x=42.925 //y=1.305 //x2=46.01 //y2=1.09
cc_3443 ( N_noxref_9_c_3845_p N_GND_c_14343_n ) capacitor c=3.92414e-19 \
 //x=27.2 //y=1.055 //x2=27.465 //y2=1.015
cc_3444 ( N_noxref_9_c_4107_p N_GND_c_14343_n ) capacitor c=0.0085115f \
 //x=27.575 //y=0.9 //x2=27.465 //y2=1.015
cc_3445 ( N_noxref_9_c_3847_p N_GND_c_14343_n ) capacitor c=4.45447e-19 \
 //x=27.73 //y=1.055 //x2=27.465 //y2=1.015
cc_3446 ( N_noxref_9_c_3553_n N_GND_c_14210_n ) capacitor c=0.00210951f \
 //x=37.86 //y=2.26 //x2=40.33 //y2=0.175
cc_3447 ( N_noxref_9_c_3872_p N_GND_c_14347_n ) capacitor c=0.00883621f \
 //x=42.925 //y=1.305 //x2=45.14 //y2=0.175
cc_3448 ( N_noxref_9_c_3709_n N_GND_c_14347_n ) capacitor c=0.00662992f \
 //x=43.325 //y=1.845 //x2=45.14 //y2=0.175
cc_3449 ( N_noxref_9_M26_noxref_d N_GND_c_14347_n ) capacitor c=2.9462e-19 \
 //x=42.735 //y=1.095 //x2=45.14 //y2=0.175
cc_3450 ( N_noxref_9_c_3724_n N_GND_c_14350_n ) capacitor c=0.00210951f \
 //x=50.81 //y=2.26 //x2=53.28 //y2=0.175
cc_3451 ( N_noxref_9_c_3777_p N_GND_c_14351_n ) capacitor c=0.00772482f \
 //x=27.5 //y=2.375 //x2=27.465 //y2=1.145
cc_3452 ( N_noxref_9_c_3768_p N_GND_c_14351_n ) capacitor c=5.20125e-19 \
 //x=27.5 //y=4.42 //x2=27.465 //y2=1.145
cc_3453 ( N_noxref_9_c_3773_p N_GND_c_14351_n ) capacitor c=2.22883e-19 \
 //x=27.5 //y=2.26 //x2=27.465 //y2=1.145
cc_3454 ( N_noxref_9_c_3845_p N_GND_c_14351_n ) capacitor c=0.0015128f \
 //x=27.2 //y=1.055 //x2=27.465 //y2=1.145
cc_3455 ( N_noxref_9_c_3846_p N_GND_c_14351_n ) capacitor c=0.00350108f \
 //x=27.2 //y=1.4 //x2=27.465 //y2=1.145
cc_3456 ( N_noxref_9_c_3848_p N_GND_c_14351_n ) capacitor c=4.60246e-19 \
 //x=27.2 //y=1.71 //x2=27.465 //y2=1.145
cc_3457 ( N_noxref_9_c_4107_p N_GND_c_14351_n ) capacitor c=9.36995e-19 \
 //x=27.575 //y=0.9 //x2=27.465 //y2=1.145
cc_3458 ( N_noxref_9_c_4121_p N_GND_c_14351_n ) capacitor c=6.09813e-19 \
 //x=27.575 //y=1.555 //x2=27.465 //y2=1.145
cc_3459 ( N_noxref_9_c_3847_p N_GND_c_14351_n ) capacitor c=0.0017438f \
 //x=27.73 //y=1.055 //x2=27.465 //y2=1.145
cc_3460 ( N_noxref_9_c_3849_p N_GND_c_14351_n ) capacitor c=0.00276804f \
 //x=27.73 //y=1.4 //x2=27.465 //y2=1.145
cc_3461 ( N_noxref_9_c_3872_p N_GND_c_14271_n ) capacitor c=0.00543195f \
 //x=42.925 //y=1.305 //x2=45.225 //y2=1.145
cc_3462 ( N_noxref_9_c_3845_p N_GND_c_14189_n ) capacitor c=0.00677766f \
 //x=27.2 //y=1.055 //x2=31.03 //y2=0.175
cc_3463 ( N_noxref_9_c_3553_n N_GND_c_14192_n ) capacitor c=3.77328e-19 \
 //x=37.86 //y=2.26 //x2=39.17 //y2=0.175
cc_3464 ( N_noxref_9_c_3709_n N_GND_c_14233_n ) capacitor c=6.86343e-19 \
 //x=43.325 //y=1.845 //x2=43.98 //y2=0.175
cc_3465 ( N_noxref_9_c_3724_n N_GND_c_14328_n ) capacitor c=3.77328e-19 \
 //x=50.81 //y=2.26 //x2=52.12 //y2=0.175
cc_3466 ( N_noxref_9_c_3777_p N_GND_c_14154_n ) capacitor c=0.00343139f \
 //x=27.5 //y=2.375 //x2=26.39 //y2=0.175
cc_3467 ( N_noxref_9_c_3531_n N_GND_c_14154_n ) capacitor c=0.00881103f \
 //x=27.5 //y=4.1 //x2=26.39 //y2=0.175
cc_3468 ( N_noxref_9_c_3773_p N_GND_c_14154_n ) capacitor c=0.00396211f \
 //x=27.5 //y=2.26 //x2=26.39 //y2=0.175
cc_3469 ( N_noxref_9_c_3848_p N_GND_c_14154_n ) capacitor c=0.00170145f \
 //x=27.2 //y=1.71 //x2=26.39 //y2=0.175
cc_3470 ( N_noxref_9_c_3779_p N_GND_c_14154_n ) capacitor c=0.0102191f \
 //x=27.2 //y=2.095 //x2=26.39 //y2=0.175
cc_3471 ( N_noxref_9_c_3567_n N_GND_c_14235_n ) capacitor c=0.00207214f \
 //x=37.86 //y=2.26 //x2=39.34 //y2=0.175
cc_3472 ( N_noxref_9_c_3586_n N_GND_c_14235_n ) capacitor c=0.00275184f \
 //x=38.425 //y=1.43 //x2=39.34 //y2=0.175
cc_3473 ( N_noxref_9_c_3587_n N_GND_c_14235_n ) capacitor c=2.63786e-19 \
 //x=37.86 //y=2.26 //x2=39.34 //y2=0.175
cc_3474 ( N_noxref_9_c_3606_n N_GND_c_14291_n ) capacitor c=0.0045138f \
 //x=42.925 //y=1.76 //x2=44.15 //y2=0.175
cc_3475 ( N_noxref_9_c_3709_n N_GND_c_14291_n ) capacitor c=0.0312195f \
 //x=43.325 //y=1.845 //x2=44.15 //y2=0.175
cc_3476 ( N_noxref_9_c_3734_n N_GND_c_14376_n ) capacitor c=0.00200922f \
 //x=50.81 //y=2.26 //x2=52.29 //y2=0.175
cc_3477 ( N_noxref_9_c_3753_n N_GND_c_14376_n ) capacitor c=0.00275184f \
 //x=51.375 //y=1.43 //x2=52.29 //y2=0.175
cc_3478 ( N_noxref_9_c_3754_n N_GND_c_14376_n ) capacitor c=2.63786e-19 \
 //x=50.81 //y=2.26 //x2=52.29 //y2=0.175
cc_3479 ( N_noxref_9_c_3777_p N_GND_M16_noxref_d ) capacitor c=4.4417e-19 \
 //x=27.5 //y=2.375 //x2=27.275 //y2=1.055
cc_3480 ( N_noxref_9_c_3845_p N_GND_M16_noxref_d ) capacitor c=0.00184354f \
 //x=27.2 //y=1.055 //x2=27.275 //y2=1.055
cc_3481 ( N_noxref_9_c_3846_p N_GND_M16_noxref_d ) capacitor c=0.00210798f \
 //x=27.2 //y=1.4 //x2=27.275 //y2=1.055
cc_3482 ( N_noxref_9_c_4107_p N_GND_M16_noxref_d ) capacitor c=0.00474029f \
 //x=27.575 //y=0.9 //x2=27.275 //y2=1.055
cc_3483 ( N_noxref_9_c_4121_p N_GND_M16_noxref_d ) capacitor c=0.00166857f \
 //x=27.575 //y=1.555 //x2=27.275 //y2=1.055
cc_3484 ( N_noxref_9_c_3847_p N_GND_M16_noxref_d ) capacitor c=0.00230174f \
 //x=27.73 //y=1.055 //x2=27.275 //y2=1.055
cc_3485 ( N_noxref_9_c_3849_p N_GND_M16_noxref_d ) capacitor c=0.00210798f \
 //x=27.73 //y=1.4 //x2=27.275 //y2=1.055
cc_3486 ( N_noxref_9_c_3779_p N_noxref_41_c_15899_n ) capacitor c=0.00262672f \
 //x=27.2 //y=2.095 //x2=26.98 //y2=1.685
cc_3487 ( N_noxref_9_c_3777_p N_noxref_41_c_15900_n ) capacitor c=0.00428451f \
 //x=27.5 //y=2.375 //x2=27.865 //y2=1.77
cc_3488 ( N_noxref_9_c_3768_p N_noxref_41_c_15900_n ) capacitor c=0.00110122f \
 //x=27.5 //y=4.42 //x2=27.865 //y2=1.77
cc_3489 ( N_noxref_9_c_3773_p N_noxref_41_c_15900_n ) capacitor c=0.0104666f \
 //x=27.5 //y=2.26 //x2=27.865 //y2=1.77
cc_3490 ( N_noxref_9_c_3848_p N_noxref_41_c_15900_n ) capacitor c=0.00705077f \
 //x=27.2 //y=1.71 //x2=27.865 //y2=1.77
cc_3491 ( N_noxref_9_c_3779_p N_noxref_41_c_15900_n ) capacitor c=0.020708f \
 //x=27.2 //y=2.095 //x2=27.865 //y2=1.77
cc_3492 ( N_noxref_9_c_4121_p N_noxref_41_c_15900_n ) capacitor c=0.00588627f \
 //x=27.575 //y=1.555 //x2=27.865 //y2=1.77
cc_3493 ( N_noxref_9_c_3849_p N_noxref_41_c_15900_n ) capacitor c=0.00698822f \
 //x=27.73 //y=1.4 //x2=27.865 //y2=1.77
cc_3494 ( N_noxref_9_c_3845_p N_noxref_41_M16_noxref_s ) capacitor \
 c=0.0295256f //x=27.2 //y=1.055 //x2=26.845 //y2=0.555
cc_3495 ( N_noxref_9_c_3848_p N_noxref_41_M16_noxref_s ) capacitor \
 c=7.99997e-19 //x=27.2 //y=1.71 //x2=26.845 //y2=0.555
cc_3496 ( N_noxref_9_c_3779_p N_noxref_41_M16_noxref_s ) capacitor \
 c=0.00122123f //x=27.2 //y=2.095 //x2=26.845 //y2=0.555
cc_3497 ( N_noxref_9_c_3847_p N_noxref_41_M16_noxref_s ) capacitor \
 c=0.0125924f //x=27.73 //y=1.055 //x2=26.845 //y2=0.555
cc_3498 ( N_noxref_9_c_3546_n N_noxref_43_c_16025_n ) capacitor c=9.49001e-19 \
 //x=37.86 //y=4.41 //x2=37.675 //y2=1.675
cc_3499 ( N_noxref_9_c_3553_n N_noxref_43_c_16025_n ) capacitor c=7.50092e-19 \
 //x=37.86 //y=2.26 //x2=37.675 //y2=1.675
cc_3500 ( N_noxref_9_c_3582_n N_noxref_43_c_16025_n ) capacitor c=0.00888238f \
 //x=37.895 //y=1.74 //x2=37.675 //y2=1.675
cc_3501 ( N_noxref_9_c_3587_n N_noxref_43_c_16025_n ) capacitor c=0.00175171f \
 //x=37.86 //y=2.26 //x2=37.675 //y2=1.675
cc_3502 ( N_noxref_9_c_3553_n N_noxref_43_c_16030_n ) capacitor c=0.001463f \
 //x=37.86 //y=2.26 //x2=38.56 //y2=0.71
cc_3503 ( N_noxref_9_c_3567_n N_noxref_43_c_16030_n ) capacitor c=8.82141e-19 \
 //x=37.86 //y=2.26 //x2=38.56 //y2=0.71
cc_3504 ( N_noxref_9_c_3577_n N_noxref_43_c_16030_n ) capacitor c=0.0200738f \
 //x=37.895 //y=1.085 //x2=38.56 //y2=0.71
cc_3505 ( N_noxref_9_c_3585_n N_noxref_43_c_16030_n ) capacitor c=0.00825432f \
 //x=38.425 //y=1.085 //x2=38.56 //y2=0.71
cc_3506 ( N_noxref_9_c_3587_n N_noxref_43_c_16030_n ) capacitor c=2.1838e-19 \
 //x=37.86 //y=2.26 //x2=38.56 //y2=0.71
cc_3507 ( N_noxref_9_c_3577_n N_noxref_43_M22_noxref_s ) capacitor \
 c=0.00888238f //x=37.895 //y=1.085 //x2=36.57 //y2=0.545
cc_3508 ( N_noxref_9_c_3585_n N_noxref_43_M22_noxref_s ) capacitor c=0.015333f \
 //x=38.425 //y=1.085 //x2=36.57 //y2=0.545
cc_3509 ( N_noxref_9_c_3586_n N_noxref_43_M22_noxref_s ) capacitor \
 c=0.00248746f //x=38.425 //y=1.43 //x2=36.57 //y2=0.545
cc_3510 ( N_noxref_9_c_3717_n N_noxref_46_c_16208_n ) capacitor c=9.65024e-19 \
 //x=50.81 //y=4.415 //x2=50.625 //y2=1.675
cc_3511 ( N_noxref_9_c_3724_n N_noxref_46_c_16208_n ) capacitor c=7.50092e-19 \
 //x=50.81 //y=2.26 //x2=50.625 //y2=1.675
cc_3512 ( N_noxref_9_c_3749_n N_noxref_46_c_16208_n ) capacitor c=0.00888238f \
 //x=50.845 //y=1.74 //x2=50.625 //y2=1.675
cc_3513 ( N_noxref_9_c_3754_n N_noxref_46_c_16208_n ) capacitor c=0.00175171f \
 //x=50.81 //y=2.26 //x2=50.625 //y2=1.675
cc_3514 ( N_noxref_9_c_3724_n N_noxref_46_c_16216_n ) capacitor c=0.001463f \
 //x=50.81 //y=2.26 //x2=51.51 //y2=0.71
cc_3515 ( N_noxref_9_c_3734_n N_noxref_46_c_16216_n ) capacitor c=8.82141e-19 \
 //x=50.81 //y=2.26 //x2=51.51 //y2=0.71
cc_3516 ( N_noxref_9_c_3744_n N_noxref_46_c_16216_n ) capacitor c=0.0200738f \
 //x=50.845 //y=1.085 //x2=51.51 //y2=0.71
cc_3517 ( N_noxref_9_c_3752_n N_noxref_46_c_16216_n ) capacitor c=0.00825432f \
 //x=51.375 //y=1.085 //x2=51.51 //y2=0.71
cc_3518 ( N_noxref_9_c_3754_n N_noxref_46_c_16216_n ) capacitor c=2.1838e-19 \
 //x=50.81 //y=2.26 //x2=51.51 //y2=0.71
cc_3519 ( N_noxref_9_c_3744_n N_noxref_46_M30_noxref_s ) capacitor \
 c=0.00888238f //x=50.845 //y=1.085 //x2=49.52 //y2=0.545
cc_3520 ( N_noxref_9_c_3752_n N_noxref_46_M30_noxref_s ) capacitor c=0.015333f \
 //x=51.375 //y=1.085 //x2=49.52 //y2=0.545
cc_3521 ( N_noxref_9_c_3753_n N_noxref_46_M30_noxref_s ) capacitor \
 c=0.00248746f //x=51.375 //y=1.43 //x2=49.52 //y2=0.545
cc_3522 ( N_D_c_4197_n CLK ) capacitor c=0.0277903f //x=33.26 //y=2.755 \
 //x2=15.66 //y2=3.14
cc_3523 ( N_D_c_4197_n CLK ) capacitor c=0.0235128f //x=33.26 //y=2.755 \
 //x2=28.61 //y2=3.51
cc_3524 ( N_D_c_4303_n CLK ) capacitor c=0.0235128f //x=59.16 //y=2.77 \
 //x2=41.56 //y2=3.51
cc_3525 ( N_D_c_4303_n CLK ) capacitor c=0.0235128f //x=59.16 //y=2.77 \
 //x2=54.51 //y2=3.88
cc_3526 ( D N_CLK_c_4775_n ) capacitor c=0.0268256f //x=7.52 //y=3.14 \
 //x2=11.58 //y2=4.62
cc_3527 ( N_D_c_4193_n N_CLK_c_4775_n ) capacitor c=0.00415302f //x=7.52 \
 //y=4.765 //x2=11.58 //y2=4.62
cc_3528 ( N_D_c_4197_n N_CLK_c_4875_n ) capacitor c=0.00677614f //x=33.26 \
 //y=2.755 //x2=24.515 //y2=4.62
cc_3529 ( N_D_c_4197_n N_CLK_c_4950_n ) capacitor c=0.00534322f //x=33.26 \
 //y=2.755 //x2=25.115 //y2=4.64
cc_3530 ( N_D_c_4197_n N_CLK_c_5146_n ) capacitor c=3.84576e-19 //x=33.26 \
 //y=2.755 //x2=27.115 //y2=4.62
cc_3531 ( N_D_c_4297_n N_CLK_c_5004_n ) capacitor c=0.0309907f //x=33.42 \
 //y=4.765 //x2=37.735 //y2=4.635
cc_3532 ( N_D_c_4398_p N_CLK_c_5229_n ) capacitor c=0.0309835f //x=59.32 \
 //y=4.765 //x2=63.635 //y2=4.635
cc_3533 ( N_D_c_4399_p N_noxref_12_c_5800_n ) capacitor c=3.38245e-19 \
 //x=59.32 //y=2.61 //x2=56.36 //y2=3.725
cc_3534 ( N_D_c_4398_p N_noxref_12_c_5800_n ) capacitor c=3.41169e-19 \
 //x=59.32 //y=4.765 //x2=56.36 //y2=3.725
cc_3535 ( N_D_c_4303_n N_noxref_12_c_5800_n ) capacitor c=0.0233619f //x=59.16 \
 //y=2.77 //x2=56.36 //y2=3.725
cc_3536 ( N_D_c_4398_p N_noxref_12_c_5803_n ) capacitor c=6.66489e-19 \
 //x=59.32 //y=4.765 //x2=56.36 //y2=5.25
cc_3537 ( N_D_c_4403_p N_noxref_12_c_5804_n ) capacitor c=0.00872827f \
 //x=59.32 //y=2.375 //x2=58.21 //y2=2.375
cc_3538 ( N_D_c_4404_p N_noxref_12_c_5804_n ) capacitor c=5.39999e-19 \
 //x=59.32 //y=2.26 //x2=58.21 //y2=2.375
cc_3539 ( N_D_c_4405_p N_noxref_12_c_5804_n ) capacitor c=0.00136403f \
 //x=59.41 //y=2.095 //x2=58.21 //y2=2.375
cc_3540 ( N_D_c_4399_p N_noxref_12_c_5807_n ) capacitor c=0.00483736f \
 //x=59.32 //y=2.61 //x2=58.21 //y2=3.72
cc_3541 ( N_D_c_4407_p N_noxref_12_c_5807_n ) capacitor c=0.00671686f \
 //x=59.32 //y=2.93 //x2=58.21 //y2=3.72
cc_3542 ( N_D_c_4398_p N_noxref_12_c_5807_n ) capacitor c=0.0184924f //x=59.32 \
 //y=4.765 //x2=58.21 //y2=3.72
cc_3543 ( N_D_c_4409_p N_noxref_12_c_5807_n ) capacitor c=2.98299e-19 \
 //x=59.32 //y=2.77 //x2=58.21 //y2=3.72
cc_3544 ( N_D_c_4303_n N_noxref_12_c_5807_n ) capacitor c=0.0245653f //x=59.16 \
 //y=2.77 //x2=58.21 //y2=3.72
cc_3545 ( N_D_c_4411_p N_noxref_12_c_5807_n ) capacitor c=0.00242466f \
 //x=59.32 //y=2.77 //x2=58.21 //y2=3.72
cc_3546 ( N_D_c_4404_p N_noxref_12_c_5807_n ) capacitor c=3.9149e-19 //x=59.32 \
 //y=2.26 //x2=58.21 //y2=3.72
cc_3547 ( N_D_c_4398_p N_noxref_12_c_5814_n ) capacitor c=0.00774769f \
 //x=59.32 //y=4.765 //x2=58.21 //y2=4.04
cc_3548 ( N_D_c_4398_p N_noxref_12_c_5815_n ) capacitor c=0.0269128f //x=59.32 \
 //y=4.765 //x2=58.21 //y2=4.755
cc_3549 ( N_D_c_4415_p N_noxref_12_c_5815_n ) capacitor c=0.00103399f \
 //x=59.32 //y=4.88 //x2=58.21 //y2=4.755
cc_3550 ( N_D_c_4416_p N_noxref_12_c_5815_n ) capacitor c=0.00116212f \
 //x=59.32 //y=4.88 //x2=58.21 //y2=4.755
cc_3551 ( N_D_c_4398_p N_noxref_12_c_5818_n ) capacitor c=2.90818e-19 \
 //x=59.32 //y=4.765 //x2=58.21 //y2=3.88
cc_3552 ( N_D_c_4398_p N_noxref_12_c_5819_n ) capacitor c=0.0253585f //x=59.32 \
 //y=4.765 //x2=61.045 //y2=3.895
cc_3553 ( N_D_c_4403_p N_noxref_12_c_5820_n ) capacitor c=5.40058e-19 \
 //x=59.32 //y=2.375 //x2=58.21 //y2=2.26
cc_3554 ( N_D_c_4399_p N_noxref_12_c_5820_n ) capacitor c=3.9149e-19 //x=59.32 \
 //y=2.61 //x2=58.21 //y2=2.26
cc_3555 ( N_D_c_4404_p N_noxref_12_c_5820_n ) capacitor c=0.00125213f \
 //x=59.32 //y=2.26 //x2=58.21 //y2=2.26
cc_3556 ( N_D_c_4405_p N_noxref_12_c_5820_n ) capacitor c=0.0020754f //x=59.41 \
 //y=2.095 //x2=58.21 //y2=2.26
cc_3557 ( N_D_c_4398_p N_noxref_12_c_5824_n ) capacitor c=6.26008e-19 \
 //x=59.32 //y=4.765 //x2=58.21 //y2=4.88
cc_3558 ( N_D_c_4415_p N_noxref_12_c_5824_n ) capacitor c=0.00113984f \
 //x=59.32 //y=4.88 //x2=58.21 //y2=4.88
cc_3559 ( N_D_c_4416_p N_noxref_12_c_5824_n ) capacitor c=0.00155973f \
 //x=59.32 //y=4.88 //x2=58.21 //y2=4.88
cc_3560 ( N_D_M126_noxref_g N_noxref_12_M124_noxref_g ) capacitor c=0.0106276f \
 //x=59.29 //y=6.2 //x2=58.41 //y2=6.2
cc_3561 ( N_D_M126_noxref_g N_noxref_12_M125_noxref_g ) capacitor c=0.107144f \
 //x=59.29 //y=6.2 //x2=58.85 //y2=6.2
cc_3562 ( N_D_M127_noxref_g N_noxref_12_M125_noxref_g ) capacitor c=0.0101598f \
 //x=59.73 //y=6.2 //x2=58.85 //y2=6.2
cc_3563 ( N_D_c_4429_p N_noxref_12_c_5830_n ) capacitor c=5.72528e-19 \
 //x=58.885 //y=1.09 //x2=57.91 //y2=1.055
cc_3564 ( N_D_c_4429_p N_noxref_12_c_5831_n ) capacitor c=0.00150277f \
 //x=58.885 //y=1.09 //x2=57.91 //y2=1.4
cc_3565 ( N_D_c_4431_p N_noxref_12_c_5832_n ) capacitor c=0.00111227f \
 //x=58.885 //y=1.4 //x2=57.91 //y2=1.71
cc_3566 ( N_D_c_4403_p N_noxref_12_c_5833_n ) capacitor c=0.00141865f \
 //x=59.32 //y=2.375 //x2=57.91 //y2=2.095
cc_3567 ( N_D_c_4404_p N_noxref_12_c_5833_n ) capacitor c=0.00214573f \
 //x=59.32 //y=2.26 //x2=57.91 //y2=2.095
cc_3568 ( N_D_c_4405_p N_noxref_12_c_5833_n ) capacitor c=0.00964411f \
 //x=59.41 //y=2.095 //x2=57.91 //y2=2.095
cc_3569 ( N_D_c_4429_p N_noxref_12_c_5836_n ) capacitor c=0.0160123f \
 //x=58.885 //y=1.09 //x2=58.44 //y2=1.055
cc_3570 ( N_D_c_4436_p N_noxref_12_c_5836_n ) capacitor c=9.19165e-19 \
 //x=59.41 //y=1.09 //x2=58.44 //y2=1.055
cc_3571 ( N_D_c_4431_p N_noxref_12_c_5838_n ) capacitor c=0.0124075f \
 //x=58.885 //y=1.4 //x2=58.44 //y2=1.4
cc_3572 ( N_D_c_4438_p N_noxref_12_c_5838_n ) capacitor c=0.0010154f //x=59.41 \
 //y=1.4 //x2=58.44 //y2=1.4
cc_3573 ( N_D_c_4439_p N_noxref_12_c_5838_n ) capacitor c=9.23422e-19 \
 //x=59.41 //y=1.63 //x2=58.44 //y2=1.4
cc_3574 ( N_D_c_4398_p N_noxref_12_c_5841_n ) capacitor c=7.66769e-19 \
 //x=59.32 //y=4.765 //x2=58.775 //y2=4.97
cc_3575 ( N_D_c_4415_p N_noxref_12_c_5841_n ) capacitor c=0.00116563f \
 //x=59.32 //y=4.88 //x2=58.775 //y2=4.97
cc_3576 ( N_D_c_4416_p N_noxref_12_c_5841_n ) capacitor c=0.0171374f //x=59.32 \
 //y=4.88 //x2=58.775 //y2=4.97
cc_3577 ( N_D_c_4398_p N_noxref_12_c_5844_n ) capacitor c=7.54501e-19 \
 //x=59.32 //y=4.765 //x2=58.485 //y2=4.97
cc_3578 ( N_D_c_4415_p N_noxref_12_c_5844_n ) capacitor c=0.00129812f \
 //x=59.32 //y=4.88 //x2=58.485 //y2=4.97
cc_3579 ( N_D_c_4416_p N_noxref_12_c_5844_n ) capacitor c=0.00484466f \
 //x=59.32 //y=4.88 //x2=58.485 //y2=4.97
cc_3580 ( D RN ) capacitor c=0.0434201f //x=7.52 //y=3.14 //x2=8.63 //y2=3.14
cc_3581 ( D RN ) capacitor c=3.05467e-19 //x=7.52 //y=2.77 //x2=8.63 //y2=3.14
cc_3582 ( N_D_c_4188_n RN ) capacitor c=0.00405447f //x=7.52 //y=2.62 \
 //x2=8.63 //y2=3.14
cc_3583 ( N_D_c_4189_n RN ) capacitor c=0.00770767f //x=7.52 //y=2.94 \
 //x2=8.63 //y2=3.14
cc_3584 ( N_D_c_4196_n RN ) capacitor c=0.00244268f //x=7.675 //y=2.78 \
 //x2=8.63 //y2=3.14
cc_3585 ( N_D_c_4197_n RN ) capacitor c=0.0240796f //x=33.26 //y=2.755 \
 //x2=8.63 //y2=3.14
cc_3586 ( N_D_c_4204_n RN ) capacitor c=2.8902e-19 //x=7.52 //y=4.88 //x2=8.63 \
 //y2=3.14
cc_3587 ( N_D_c_4197_n RN ) capacitor c=0.0262882f //x=33.26 //y=2.755 \
 //x2=16.77 //y2=3.14
cc_3588 ( N_D_c_4197_n RN ) capacitor c=0.0284894f //x=33.26 //y=2.755 \
 //x2=20.47 //y2=3.14
cc_3589 ( N_D_c_4303_n RN ) capacitor c=0.0220107f //x=59.16 //y=2.77 \
 //x2=42.67 //y2=3.51
cc_3590 ( N_D_c_4303_n RN ) capacitor c=0.0232345f //x=59.16 //y=2.77 \
 //x2=46.37 //y2=3.51
cc_3591 ( N_D_c_4231_n RN ) capacitor c=0.007145f //x=7.52 //y=2.375 //x2=8.63 \
 //y2=2.4
cc_3592 ( N_D_c_4188_n RN ) capacitor c=0.0020306f //x=7.52 //y=2.62 //x2=8.63 \
 //y2=2.4
cc_3593 ( N_D_c_4197_n RN ) capacitor c=0.00172274f //x=33.26 //y=2.755 \
 //x2=8.63 //y2=2.4
cc_3594 ( N_D_c_4255_n RN ) capacitor c=9.53526e-19 //x=7.52 //y=2.26 \
 //x2=8.63 //y2=2.4
cc_3595 ( N_D_c_4274_n RN ) capacitor c=0.00135583f //x=7.61 //y=2.095 \
 //x2=8.63 //y2=2.4
cc_3596 ( D N_RN_c_6301_n ) capacitor c=6.3306e-19 //x=7.52 //y=3.14 //x2=8.63 \
 //y2=4.75
cc_3597 ( N_D_c_4193_n N_RN_c_6301_n ) capacitor c=0.0107551f //x=7.52 \
 //y=4.765 //x2=8.63 //y2=4.75
cc_3598 ( N_D_c_4204_n N_RN_c_6301_n ) capacitor c=6.63375e-19 //x=7.52 \
 //y=4.88 //x2=8.63 //y2=4.75
cc_3599 ( N_D_c_4214_n N_RN_c_6301_n ) capacitor c=8.42568e-19 //x=7.52 \
 //y=4.88 //x2=8.63 //y2=4.75
cc_3600 ( N_D_c_4197_n N_RN_c_6429_n ) capacitor c=8.29898e-19 //x=33.26 \
 //y=2.755 //x2=16.77 //y2=2.465
cc_3601 ( N_D_c_4197_n N_RN_c_6372_n ) capacitor c=0.00399105f //x=33.26 \
 //y=2.755 //x2=20.47 //y2=2.515
cc_3602 ( N_D_c_4326_n N_RN_c_6506_n ) capacitor c=0.00656577f //x=33.42 \
 //y=2.375 //x2=34.53 //y2=2.465
cc_3603 ( N_D_c_4293_n N_RN_c_6506_n ) capacitor c=0.00163468f //x=33.42 \
 //y=2.595 //x2=34.53 //y2=2.465
cc_3604 ( N_D_c_4303_n N_RN_c_6506_n ) capacitor c=8.29898e-19 //x=59.16 \
 //y=2.77 //x2=34.53 //y2=2.465
cc_3605 ( N_D_c_4353_n N_RN_c_6506_n ) capacitor c=9.53526e-19 //x=33.42 \
 //y=2.26 //x2=34.53 //y2=2.465
cc_3606 ( N_D_c_4372_n N_RN_c_6506_n ) capacitor c=0.00135583f //x=33.51 \
 //y=2.095 //x2=34.53 //y2=2.465
cc_3607 ( N_D_c_4293_n N_RN_c_6509_n ) capacitor c=0.00340436f //x=33.42 \
 //y=2.595 //x2=34.53 //y2=4.75
cc_3608 ( N_D_c_4294_n N_RN_c_6509_n ) capacitor c=0.00779989f //x=33.42 \
 //y=2.915 //x2=34.53 //y2=4.75
cc_3609 ( N_D_c_4297_n N_RN_c_6509_n ) capacitor c=0.0518857f //x=33.42 \
 //y=4.765 //x2=34.53 //y2=4.75
cc_3610 ( N_D_c_4343_n N_RN_c_6509_n ) capacitor c=5.01652e-19 //x=33.42 \
 //y=2.77 //x2=34.53 //y2=4.75
cc_3611 ( N_D_c_4303_n N_RN_c_6509_n ) capacitor c=0.0214158f //x=59.16 \
 //y=2.77 //x2=34.53 //y2=4.75
cc_3612 ( N_D_c_4352_n N_RN_c_6509_n ) capacitor c=0.00242466f //x=33.58 \
 //y=2.755 //x2=34.53 //y2=4.75
cc_3613 ( N_D_c_4312_n N_RN_c_6509_n ) capacitor c=9.52396e-19 //x=33.42 \
 //y=4.88 //x2=34.53 //y2=4.75
cc_3614 ( N_D_c_4322_n N_RN_c_6509_n ) capacitor c=8.42568e-19 //x=33.42 \
 //y=4.88 //x2=34.53 //y2=4.75
cc_3615 ( N_D_c_4303_n N_RN_c_6667_n ) capacitor c=8.29898e-19 //x=59.16 \
 //y=2.77 //x2=42.67 //y2=2.465
cc_3616 ( N_D_c_4303_n N_RN_c_6587_n ) capacitor c=0.00399105f //x=59.16 \
 //y=2.77 //x2=46.37 //y2=2.515
cc_3617 ( N_D_c_4403_p N_RN_c_6760_n ) capacitor c=0.00665882f //x=59.32 \
 //y=2.375 //x2=60.43 //y2=2.465
cc_3618 ( N_D_c_4399_p N_RN_c_6760_n ) capacitor c=0.00158143f //x=59.32 \
 //y=2.61 //x2=60.43 //y2=2.465
cc_3619 ( N_D_c_4404_p N_RN_c_6760_n ) capacitor c=9.53526e-19 //x=59.32 \
 //y=2.26 //x2=60.43 //y2=2.465
cc_3620 ( N_D_c_4405_p N_RN_c_6760_n ) capacitor c=0.00135583f //x=59.41 \
 //y=2.095 //x2=60.43 //y2=2.465
cc_3621 ( N_D_c_4399_p N_RN_c_6764_n ) capacitor c=0.00377525f //x=59.32 \
 //y=2.61 //x2=60.43 //y2=4.75
cc_3622 ( N_D_c_4407_p N_RN_c_6764_n ) capacitor c=0.011735f //x=59.32 \
 //y=2.93 //x2=60.43 //y2=4.75
cc_3623 ( N_D_c_4398_p N_RN_c_6764_n ) capacitor c=0.0514088f //x=59.32 \
 //y=4.765 //x2=60.43 //y2=4.75
cc_3624 ( N_D_c_4409_p N_RN_c_6764_n ) capacitor c=2.99286e-19 //x=59.32 \
 //y=2.77 //x2=60.43 //y2=4.75
cc_3625 ( N_D_c_4411_p N_RN_c_6764_n ) capacitor c=0.00242466f //x=59.32 \
 //y=2.77 //x2=60.43 //y2=4.75
cc_3626 ( N_D_c_4415_p N_RN_c_6764_n ) capacitor c=9.52396e-19 //x=59.32 \
 //y=4.88 //x2=60.43 //y2=4.75
cc_3627 ( N_D_c_4416_p N_RN_c_6764_n ) capacitor c=8.42568e-19 //x=59.32 \
 //y=4.88 //x2=60.43 //y2=4.75
cc_3628 ( N_D_c_4326_n N_RN_c_6771_n ) capacitor c=0.0176192f //x=33.42 \
 //y=2.375 //x2=33.635 //y2=2.37
cc_3629 ( N_D_c_4293_n N_RN_c_6771_n ) capacitor c=0.0100518f //x=33.42 \
 //y=2.595 //x2=33.635 //y2=2.37
cc_3630 ( N_D_c_4294_n N_RN_c_6771_n ) capacitor c=0.00535216f //x=33.42 \
 //y=2.915 //x2=33.635 //y2=2.37
cc_3631 ( N_D_c_4303_n N_RN_c_6771_n ) capacitor c=0.0106577f //x=59.16 \
 //y=2.77 //x2=33.635 //y2=2.37
cc_3632 ( N_D_c_4352_n N_RN_c_6771_n ) capacitor c=0.0370844f //x=33.58 \
 //y=2.755 //x2=33.635 //y2=2.37
cc_3633 ( N_D_c_4353_n N_RN_c_6771_n ) capacitor c=2.63835e-19 //x=33.42 \
 //y=2.26 //x2=33.635 //y2=2.37
cc_3634 ( N_D_c_4372_n N_RN_c_6771_n ) capacitor c=4.01443e-19 //x=33.51 \
 //y=2.095 //x2=33.635 //y2=2.37
cc_3635 ( N_D_c_4293_n N_RN_c_6386_n ) capacitor c=7.5617e-19 //x=33.42 \
 //y=2.595 //x2=33.205 //y2=2.37
cc_3636 ( N_D_c_4197_n N_RN_c_6386_n ) capacitor c=1.17897f //x=33.26 \
 //y=2.755 //x2=33.205 //y2=2.37
cc_3637 ( N_D_c_4326_n N_RN_c_6523_n ) capacitor c=0.00355189f //x=33.42 \
 //y=2.375 //x2=34.695 //y2=2.4
cc_3638 ( N_D_c_4293_n N_RN_c_6523_n ) capacitor c=7.48695e-19 //x=33.42 \
 //y=2.595 //x2=34.695 //y2=2.4
cc_3639 ( N_D_c_4303_n N_RN_c_6523_n ) capacitor c=1.12677f //x=59.16 //y=2.77 \
 //x2=34.695 //y2=2.4
cc_3640 ( N_D_c_4403_p N_RN_c_6783_n ) capacitor c=0.0165172f //x=59.32 \
 //y=2.375 //x2=59.535 //y2=2.385
cc_3641 ( N_D_c_4399_p N_RN_c_6783_n ) capacitor c=0.0115634f //x=59.32 \
 //y=2.61 //x2=59.535 //y2=2.385
cc_3642 ( N_D_c_4407_p N_RN_c_6783_n ) capacitor c=0.00706281f //x=59.32 \
 //y=2.93 //x2=59.535 //y2=2.385
cc_3643 ( N_D_c_4411_p N_RN_c_6783_n ) capacitor c=0.0370844f //x=59.32 \
 //y=2.77 //x2=59.535 //y2=2.385
cc_3644 ( N_D_c_4404_p N_RN_c_6783_n ) capacitor c=2.63835e-19 //x=59.32 \
 //y=2.26 //x2=59.535 //y2=2.385
cc_3645 ( N_D_c_4405_p N_RN_c_6783_n ) capacitor c=4.02391e-19 //x=59.41 \
 //y=2.095 //x2=59.535 //y2=2.385
cc_3646 ( N_D_c_4399_p N_RN_c_6606_n ) capacitor c=3.78085e-19 //x=59.32 \
 //y=2.61 //x2=59.105 //y2=2.385
cc_3647 ( N_D_c_4303_n N_RN_c_6606_n ) capacitor c=1.17992f //x=59.16 //y=2.77 \
 //x2=59.105 //y2=2.385
cc_3648 ( N_D_c_4403_p N_RN_c_6791_n ) capacitor c=0.0037301f //x=59.32 \
 //y=2.375 //x2=60.595 //y2=2.4
cc_3649 ( N_D_c_4399_p N_RN_c_6791_n ) capacitor c=3.78085e-19 //x=59.32 \
 //y=2.61 //x2=60.595 //y2=2.4
cc_3650 ( N_D_c_4231_n N_RN_c_6305_n ) capacitor c=0.00526813f //x=7.52 \
 //y=2.375 //x2=8.635 //y2=2.305
cc_3651 ( N_D_c_4188_n N_RN_c_6305_n ) capacitor c=0.00216715f //x=7.52 \
 //y=2.62 //x2=8.635 //y2=2.305
cc_3652 ( N_D_c_4197_n N_RN_c_6305_n ) capacitor c=1.06502f //x=33.26 \
 //y=2.755 //x2=8.635 //y2=2.305
cc_3653 ( N_D_c_4231_n N_RN_c_6315_n ) capacitor c=6.92676e-19 //x=7.52 \
 //y=2.375 //x2=8.63 //y2=2.26
cc_3654 ( N_D_c_4255_n N_RN_c_6315_n ) capacitor c=0.00129119f //x=7.52 \
 //y=2.26 //x2=8.63 //y2=2.26
cc_3655 ( N_D_c_4274_n N_RN_c_6315_n ) capacitor c=0.00210314f //x=7.61 \
 //y=2.095 //x2=8.63 //y2=2.26
cc_3656 ( D N_RN_c_6316_n ) capacitor c=2.94497e-19 //x=7.52 //y=3.14 \
 //x2=8.63 //y2=4.88
cc_3657 ( N_D_c_4193_n N_RN_c_6316_n ) capacitor c=4.56604e-19 //x=7.52 \
 //y=4.765 //x2=8.63 //y2=4.88
cc_3658 ( N_D_c_4204_n N_RN_c_6316_n ) capacitor c=0.00113985f //x=7.52 \
 //y=4.88 //x2=8.63 //y2=4.88
cc_3659 ( N_D_c_4214_n N_RN_c_6316_n ) capacitor c=0.00129812f //x=7.52 \
 //y=4.88 //x2=8.63 //y2=4.88
cc_3660 ( N_D_c_4326_n N_RN_c_6531_n ) capacitor c=6.92676e-19 //x=33.42 \
 //y=2.375 //x2=34.53 //y2=2.26
cc_3661 ( N_D_c_4353_n N_RN_c_6531_n ) capacitor c=0.00129119f //x=33.42 \
 //y=2.26 //x2=34.53 //y2=2.26
cc_3662 ( N_D_c_4372_n N_RN_c_6531_n ) capacitor c=0.00210314f //x=33.51 \
 //y=2.095 //x2=34.53 //y2=2.26
cc_3663 ( N_D_c_4297_n N_RN_c_6532_n ) capacitor c=7.51101e-19 //x=33.42 \
 //y=4.765 //x2=34.53 //y2=4.88
cc_3664 ( N_D_c_4312_n N_RN_c_6532_n ) capacitor c=0.00113985f //x=33.42 \
 //y=4.88 //x2=34.53 //y2=4.88
cc_3665 ( N_D_c_4322_n N_RN_c_6532_n ) capacitor c=0.00129812f //x=33.42 \
 //y=4.88 //x2=34.53 //y2=4.88
cc_3666 ( N_D_c_4403_p N_RN_c_6809_n ) capacitor c=6.92676e-19 //x=59.32 \
 //y=2.375 //x2=60.43 //y2=2.26
cc_3667 ( N_D_c_4404_p N_RN_c_6809_n ) capacitor c=0.00129119f //x=59.32 \
 //y=2.26 //x2=60.43 //y2=2.26
cc_3668 ( N_D_c_4405_p N_RN_c_6809_n ) capacitor c=0.00210314f //x=59.41 \
 //y=2.095 //x2=60.43 //y2=2.26
cc_3669 ( N_D_c_4398_p N_RN_c_6812_n ) capacitor c=7.51101e-19 //x=59.32 \
 //y=4.765 //x2=60.43 //y2=4.88
cc_3670 ( N_D_c_4415_p N_RN_c_6812_n ) capacitor c=0.00113985f //x=59.32 \
 //y=4.88 //x2=60.43 //y2=4.88
cc_3671 ( N_D_c_4416_p N_RN_c_6812_n ) capacitor c=0.00129812f //x=59.32 \
 //y=4.88 //x2=60.43 //y2=4.88
cc_3672 ( N_D_M62_noxref_g N_RN_M64_noxref_g ) capacitor c=0.0101598f //x=7.49 \
 //y=6.2 //x2=8.37 //y2=6.2
cc_3673 ( N_D_M63_noxref_g N_RN_M64_noxref_g ) capacitor c=0.0607518f //x=7.93 \
 //y=6.2 //x2=8.37 //y2=6.2
cc_3674 ( N_D_M63_noxref_g N_RN_M65_noxref_g ) capacitor c=0.0101598f //x=7.93 \
 //y=6.2 //x2=8.81 //y2=6.2
cc_3675 ( N_D_M94_noxref_g N_RN_M96_noxref_g ) capacitor c=0.0101598f \
 //x=33.39 //y=6.2 //x2=34.27 //y2=6.2
cc_3676 ( N_D_M95_noxref_g N_RN_M96_noxref_g ) capacitor c=0.0607518f \
 //x=33.83 //y=6.2 //x2=34.27 //y2=6.2
cc_3677 ( N_D_M95_noxref_g N_RN_M97_noxref_g ) capacitor c=0.0101598f \
 //x=33.83 //y=6.2 //x2=34.71 //y2=6.2
cc_3678 ( N_D_M126_noxref_g N_RN_M128_noxref_g ) capacitor c=0.0101598f \
 //x=59.29 //y=6.2 //x2=60.17 //y2=6.2
cc_3679 ( N_D_M127_noxref_g N_RN_M128_noxref_g ) capacitor c=0.0607518f \
 //x=59.73 //y=6.2 //x2=60.17 //y2=6.2
cc_3680 ( N_D_M127_noxref_g N_RN_M129_noxref_g ) capacitor c=0.0101598f \
 //x=59.73 //y=6.2 //x2=60.61 //y2=6.2
cc_3681 ( N_D_c_4271_n N_RN_c_6326_n ) capacitor c=0.00456962f //x=7.61 \
 //y=1.09 //x2=8.62 //y2=1.095
cc_3682 ( N_D_c_4272_n N_RN_c_6328_n ) capacitor c=0.00438372f //x=7.61 \
 //y=1.4 //x2=8.62 //y2=1.44
cc_3683 ( N_D_c_4273_n N_RN_c_6331_n ) capacitor c=0.00438372f //x=7.61 \
 //y=1.63 //x2=8.62 //y2=1.75
cc_3684 ( N_D_c_4369_n N_RN_c_6542_n ) capacitor c=0.00456962f //x=33.51 \
 //y=1.09 //x2=34.52 //y2=1.095
cc_3685 ( N_D_c_4370_n N_RN_c_6544_n ) capacitor c=0.00438372f //x=33.51 \
 //y=1.4 //x2=34.52 //y2=1.44
cc_3686 ( N_D_c_4371_n N_RN_c_6547_n ) capacitor c=0.00438372f //x=33.51 \
 //y=1.63 //x2=34.52 //y2=1.75
cc_3687 ( N_D_c_4436_p N_RN_c_6830_n ) capacitor c=0.00456962f //x=59.41 \
 //y=1.09 //x2=60.42 //y2=1.095
cc_3688 ( N_D_c_4438_p N_RN_c_6831_n ) capacitor c=0.00438372f //x=59.41 \
 //y=1.4 //x2=60.42 //y2=1.44
cc_3689 ( N_D_c_4439_p N_RN_c_6832_n ) capacitor c=0.00438372f //x=59.41 \
 //y=1.63 //x2=60.42 //y2=1.75
cc_3690 ( N_D_c_4255_n N_RN_c_6344_n ) capacitor c=0.00155537f //x=7.52 \
 //y=2.26 //x2=8.63 //y2=2.26
cc_3691 ( N_D_c_4274_n N_RN_c_6344_n ) capacitor c=0.00831559f //x=7.61 \
 //y=2.095 //x2=8.63 //y2=2.26
cc_3692 ( N_D_c_4274_n N_RN_c_6345_n ) capacitor c=0.00438372f //x=7.61 \
 //y=2.095 //x2=8.63 //y2=2.095
cc_3693 ( N_D_c_4193_n N_RN_c_6347_n ) capacitor c=0.00124604f //x=7.52 \
 //y=4.765 //x2=8.63 //y2=4.88
cc_3694 ( N_D_c_4204_n N_RN_c_6347_n ) capacitor c=0.00187046f //x=7.52 \
 //y=4.88 //x2=8.63 //y2=4.88
cc_3695 ( N_D_c_4212_n N_RN_c_6347_n ) capacitor c=0.0616777f //x=7.855 \
 //y=4.97 //x2=8.63 //y2=4.88
cc_3696 ( N_D_c_4214_n N_RN_c_6347_n ) capacitor c=0.00487508f //x=7.52 \
 //y=4.88 //x2=8.63 //y2=4.88
cc_3697 ( N_D_c_4353_n N_RN_c_6560_n ) capacitor c=0.00155537f //x=33.42 \
 //y=2.26 //x2=34.53 //y2=2.26
cc_3698 ( N_D_c_4372_n N_RN_c_6560_n ) capacitor c=0.00831559f //x=33.51 \
 //y=2.095 //x2=34.53 //y2=2.26
cc_3699 ( N_D_c_4372_n N_RN_c_6561_n ) capacitor c=0.00438372f //x=33.51 \
 //y=2.095 //x2=34.53 //y2=2.095
cc_3700 ( N_D_c_4297_n N_RN_c_6563_n ) capacitor c=0.00124604f //x=33.42 \
 //y=4.765 //x2=34.53 //y2=4.88
cc_3701 ( N_D_c_4312_n N_RN_c_6563_n ) capacitor c=0.00187046f //x=33.42 \
 //y=4.88 //x2=34.53 //y2=4.88
cc_3702 ( N_D_c_4320_n N_RN_c_6563_n ) capacitor c=0.0616777f //x=33.755 \
 //y=4.97 //x2=34.53 //y2=4.88
cc_3703 ( N_D_c_4322_n N_RN_c_6563_n ) capacitor c=0.00487508f //x=33.42 \
 //y=4.88 //x2=34.53 //y2=4.88
cc_3704 ( N_D_c_4404_p N_RN_c_6847_n ) capacitor c=0.00155537f //x=59.32 \
 //y=2.26 //x2=60.43 //y2=2.26
cc_3705 ( N_D_c_4405_p N_RN_c_6847_n ) capacitor c=0.00831559f //x=59.41 \
 //y=2.095 //x2=60.43 //y2=2.26
cc_3706 ( N_D_c_4405_p N_RN_c_6849_n ) capacitor c=0.00438372f //x=59.41 \
 //y=2.095 //x2=60.43 //y2=2.095
cc_3707 ( N_D_c_4398_p N_RN_c_6850_n ) capacitor c=0.00124604f //x=59.32 \
 //y=4.765 //x2=60.43 //y2=4.88
cc_3708 ( N_D_c_4415_p N_RN_c_6850_n ) capacitor c=0.00187046f //x=59.32 \
 //y=4.88 //x2=60.43 //y2=4.88
cc_3709 ( N_D_c_4575_p N_RN_c_6850_n ) capacitor c=0.0616777f //x=59.655 \
 //y=4.97 //x2=60.43 //y2=4.88
cc_3710 ( N_D_c_4416_p N_RN_c_6850_n ) capacitor c=0.00487508f //x=59.32 \
 //y=4.88 //x2=60.43 //y2=4.88
cc_3711 ( N_D_c_4303_n N_noxref_14_c_7727_n ) capacitor c=0.0247328f //x=59.16 \
 //y=2.77 //x2=53.4 //y2=4.1
cc_3712 ( N_D_c_4398_p N_noxref_14_c_7732_n ) capacitor c=0.0239233f //x=59.32 \
 //y=4.765 //x2=63.925 //y2=4.25
cc_3713 ( N_D_c_4303_n N_noxref_15_c_8552_n ) capacitor c=0.0220581f //x=59.16 \
 //y=2.77 //x2=47.48 //y2=3.365
cc_3714 ( N_D_c_4303_n N_noxref_15_c_8574_n ) capacitor c=0.0232936f //x=59.16 \
 //y=2.77 //x2=51.55 //y2=3.37
cc_3715 ( N_D_c_4303_n N_noxref_15_c_8698_n ) capacitor c=0.02192f //x=59.16 \
 //y=2.77 //x2=55.62 //y2=3.35
cc_3716 ( N_D_c_4407_p N_noxref_15_c_8699_n ) capacitor c=3.95331e-19 \
 //x=59.32 //y=2.93 //x2=59.39 //y2=5.335
cc_3717 ( N_D_c_4398_p N_noxref_15_c_8699_n ) capacitor c=0.0213631f //x=59.32 \
 //y=4.765 //x2=59.39 //y2=5.335
cc_3718 ( N_D_c_4415_p N_noxref_15_c_8699_n ) capacitor c=0.00492634f \
 //x=59.32 //y=4.88 //x2=59.39 //y2=5.335
cc_3719 ( N_D_M126_noxref_g N_noxref_15_c_8699_n ) capacitor c=0.00858241f \
 //x=59.29 //y=6.2 //x2=59.39 //y2=5.335
cc_3720 ( N_D_c_4416_p N_noxref_15_c_8699_n ) capacitor c=6.02516e-19 \
 //x=59.32 //y=4.88 //x2=59.39 //y2=5.335
cc_3721 ( N_D_M127_noxref_g N_noxref_15_c_8704_n ) capacitor c=0.00955829f \
 //x=59.73 //y=6.2 //x2=60.275 //y2=5.335
cc_3722 ( N_D_c_4399_p N_noxref_15_c_8705_n ) capacitor c=3.35348e-19 \
 //x=59.32 //y=2.61 //x2=61.17 //y2=3.35
cc_3723 ( N_D_c_4407_p N_noxref_15_c_8705_n ) capacitor c=5.31749e-19 \
 //x=59.32 //y=2.93 //x2=61.17 //y2=3.35
cc_3724 ( N_D_c_4398_p N_noxref_15_c_8705_n ) capacitor c=4.07273e-19 \
 //x=59.32 //y=4.765 //x2=61.17 //y2=3.35
cc_3725 ( N_D_c_4398_p N_noxref_15_c_8708_n ) capacitor c=0.00135693f \
 //x=59.32 //y=4.765 //x2=61.17 //y2=5.25
cc_3726 ( N_D_c_4407_p N_noxref_15_c_8709_n ) capacitor c=0.00179896f \
 //x=59.32 //y=2.93 //x2=59.51 //y2=5.335
cc_3727 ( N_D_c_4398_p N_noxref_15_c_8709_n ) capacitor c=0.00239361f \
 //x=59.32 //y=4.765 //x2=59.51 //y2=5.335
cc_3728 ( N_D_c_4415_p N_noxref_15_c_8709_n ) capacitor c=0.00132214f \
 //x=59.32 //y=4.88 //x2=59.51 //y2=5.335
cc_3729 ( N_D_M126_noxref_g N_noxref_15_c_8709_n ) capacitor c=0.00229818f \
 //x=59.29 //y=6.2 //x2=59.51 //y2=5.335
cc_3730 ( N_D_M127_noxref_g N_noxref_15_c_8709_n ) capacitor c=0.00230699f \
 //x=59.73 //y=6.2 //x2=59.51 //y2=5.335
cc_3731 ( N_D_c_4575_p N_noxref_15_c_8709_n ) capacitor c=0.00209187f \
 //x=59.655 //y=4.97 //x2=59.51 //y2=5.335
cc_3732 ( N_D_c_4303_n N_noxref_15_c_8588_n ) capacitor c=0.00614905f \
 //x=59.16 //y=2.77 //x2=47.835 //y2=3.51
cc_3733 ( N_D_c_4303_n N_noxref_15_c_8589_n ) capacitor c=0.0066245f //x=59.16 \
 //y=2.77 //x2=48.435 //y2=3.48
cc_3734 ( N_D_c_4303_n N_noxref_15_c_8593_n ) capacitor c=0.00400105f \
 //x=59.16 //y=2.77 //x2=49.67 //y2=3.51
cc_3735 ( N_D_c_4303_n N_noxref_15_c_8718_n ) capacitor c=0.0281906f //x=59.16 \
 //y=2.77 //x2=55.46 //y2=3.51
cc_3736 ( N_D_c_4303_n N_noxref_15_c_8599_n ) capacitor c=0.00677029f \
 //x=59.16 //y=2.77 //x2=51.71 //y2=3.51
cc_3737 ( N_D_c_4303_n N_noxref_15_c_8720_n ) capacitor c=0.00703957f \
 //x=59.16 //y=2.77 //x2=56.58 //y2=3.5
cc_3738 ( N_D_c_4303_n N_noxref_15_c_8721_n ) capacitor c=0.00612281f \
 //x=59.16 //y=2.77 //x2=56.15 //y2=3.5
cc_3739 ( N_D_c_4303_n N_noxref_15_c_8722_n ) capacitor c=0.00396666f \
 //x=59.16 //y=2.77 //x2=57.83 //y2=3.51
cc_3740 ( N_D_c_4398_p N_noxref_15_c_8723_n ) capacitor c=0.023795f //x=59.32 \
 //y=4.765 //x2=61.335 //y2=3.51
cc_3741 ( N_D_c_4303_n N_noxref_15_c_8723_n ) capacitor c=0.00665075f \
 //x=59.16 //y=2.77 //x2=61.335 //y2=3.51
cc_3742 ( N_D_c_4407_p N_noxref_15_c_8725_n ) capacitor c=5.39699e-19 \
 //x=59.32 //y=2.93 //x2=59.51 //y2=5.56
cc_3743 ( N_D_c_4398_p N_noxref_15_c_8725_n ) capacitor c=6.21282e-19 \
 //x=59.32 //y=4.765 //x2=59.51 //y2=5.56
cc_3744 ( N_D_M126_noxref_g N_noxref_15_c_8725_n ) capacitor c=0.0179041f \
 //x=59.29 //y=6.2 //x2=59.51 //y2=5.56
cc_3745 ( N_D_M127_noxref_g N_noxref_15_c_8725_n ) capacitor c=0.0179041f \
 //x=59.73 //y=6.2 //x2=59.51 //y2=5.56
cc_3746 ( N_D_c_4575_p N_noxref_15_c_8725_n ) capacitor c=0.00290085f \
 //x=59.655 //y=4.97 //x2=59.51 //y2=5.56
cc_3747 ( N_D_c_4197_n N_noxref_16_c_9868_n ) capacitor c=0.0214825f //x=33.26 \
 //y=2.755 //x2=21.58 //y2=2.995
cc_3748 ( N_D_c_4197_n N_noxref_16_c_9874_n ) capacitor c=0.00564978f \
 //x=33.26 //y=2.755 //x2=21.58 //y2=3.315
cc_3749 ( N_D_c_4197_n N_noxref_16_c_9906_n ) capacitor c=0.0227181f //x=33.26 \
 //y=2.755 //x2=25.65 //y2=2.995
cc_3750 ( N_D_c_4197_n N_noxref_16_c_9913_n ) capacitor c=0.00613028f \
 //x=33.26 //y=2.755 //x2=25.65 //y2=3.315
cc_3751 ( N_D_c_4197_n N_noxref_16_c_9945_n ) capacitor c=0.323566f //x=33.26 \
 //y=2.755 //x2=25.49 //y2=3.14
cc_3752 ( N_D_c_4197_n N_noxref_16_c_10009_n ) capacitor c=0.280911f //x=33.26 \
 //y=2.755 //x2=29.935 //y2=3.125
cc_3753 ( N_D_c_4197_n N_noxref_16_c_9956_n ) capacitor c=0.40608f //x=33.26 \
 //y=2.755 //x2=29.505 //y2=3.125
cc_3754 ( N_D_c_4294_n N_noxref_16_c_10014_n ) capacitor c=0.00615479f \
 //x=33.42 //y=2.915 //x2=34.89 //y2=3.14
cc_3755 ( N_D_c_4297_n N_noxref_16_c_10014_n ) capacitor c=0.0229425f \
 //x=33.42 //y=4.765 //x2=34.89 //y2=3.14
cc_3756 ( N_D_c_4303_n N_noxref_16_c_10014_n ) capacitor c=0.174997f //x=59.16 \
 //y=2.77 //x2=34.89 //y2=3.14
cc_3757 ( N_D_c_4352_n N_noxref_16_c_10014_n ) capacitor c=0.0358686f \
 //x=33.58 //y=2.755 //x2=34.89 //y2=3.14
cc_3758 ( N_D_c_4303_n N_noxref_16_c_10018_n ) capacitor c=0.111738f //x=59.16 \
 //y=2.77 //x2=35.49 //y2=3.125
cc_3759 ( N_D_c_4303_n N_noxref_16_c_10022_n ) capacitor c=0.0566175f \
 //x=59.16 //y=2.77 //x2=36.735 //y2=3.14
cc_3760 ( N_D_c_4303_n N_noxref_16_c_10025_n ) capacitor c=0.0747086f \
 //x=59.16 //y=2.77 //x2=37.335 //y2=3.125
cc_3761 ( N_D_c_4303_n N_noxref_16_c_10028_n ) capacitor c=0.0567413f \
 //x=59.16 //y=2.77 //x2=38.21 //y2=3.14
cc_3762 ( N_D_c_4303_n N_noxref_16_c_10029_n ) capacitor c=0.11275f //x=59.16 \
 //y=2.77 //x2=38.81 //y2=3.13
cc_3763 ( N_D_c_4303_n N_noxref_16_c_10033_n ) capacitor c=0.0560001f \
 //x=59.16 //y=2.77 //x2=40.07 //y2=3.14
cc_3764 ( N_D_c_4303_n N_noxref_16_c_10036_n ) capacitor c=1.25356f //x=59.16 \
 //y=2.77 //x2=40.67 //y2=3.13
cc_3765 ( N_D_c_4303_n N_noxref_16_c_10055_n ) capacitor c=0.056127f //x=59.16 \
 //y=2.77 //x2=55.235 //y2=3.14
cc_3766 ( N_D_c_4303_n N_noxref_16_c_10102_n ) capacitor c=0.268827f //x=59.16 \
 //y=2.77 //x2=55.835 //y2=3.125
cc_3767 ( N_D_c_4407_p N_noxref_16_c_10103_n ) capacitor c=0.00149143f \
 //x=59.32 //y=2.93 //x2=58.935 //y2=3.14
cc_3768 ( N_D_c_4398_p N_noxref_16_c_10103_n ) capacitor c=3.78085e-19 \
 //x=59.32 //y=4.765 //x2=58.935 //y2=3.14
cc_3769 ( N_D_c_4303_n N_noxref_16_c_10103_n ) capacitor c=0.0116638f \
 //x=59.16 //y=2.77 //x2=58.935 //y2=3.14
cc_3770 ( N_D_c_4411_p N_noxref_16_c_10103_n ) capacitor c=0.0358254f \
 //x=59.32 //y=2.77 //x2=58.935 //y2=3.14
cc_3771 ( N_D_c_4407_p N_noxref_16_c_10107_n ) capacitor c=0.00626301f \
 //x=59.32 //y=2.93 //x2=59.535 //y2=3.155
cc_3772 ( N_D_c_4398_p N_noxref_16_c_10107_n ) capacitor c=0.0230684f \
 //x=59.32 //y=4.765 //x2=59.535 //y2=3.155
cc_3773 ( N_D_c_4197_n N_noxref_16_c_9957_n ) capacitor c=0.0358686f //x=33.26 \
 //y=2.755 //x2=21.735 //y2=3.155
cc_3774 ( N_D_M62_noxref_g N_VDD_c_11482_n ) capacitor c=0.00705252f //x=7.49 \
 //y=6.2 //x2=8.065 //y2=7.585
cc_3775 ( N_D_M63_noxref_g N_VDD_c_11482_n ) capacitor c=0.00755544f //x=7.93 \
 //y=6.2 //x2=8.065 //y2=7.585
cc_3776 ( N_D_M94_noxref_g N_VDD_c_11801_n ) capacitor c=0.00705252f //x=33.39 \
 //y=6.2 //x2=33.965 //y2=7.585
cc_3777 ( N_D_M95_noxref_g N_VDD_c_11801_n ) capacitor c=0.00755544f //x=33.83 \
 //y=6.2 //x2=33.965 //y2=7.585
cc_3778 ( N_D_M126_noxref_g N_VDD_c_12101_n ) capacitor c=0.00705252f \
 //x=59.29 //y=6.2 //x2=59.865 //y2=7.585
cc_3779 ( N_D_M127_noxref_g N_VDD_c_12101_n ) capacitor c=0.00755544f \
 //x=59.73 //y=6.2 //x2=59.865 //y2=7.585
cc_3780 ( N_D_M62_noxref_g N_VDD_M61_noxref_d ) capacitor c=0.015318f //x=7.49 \
 //y=6.2 //x2=7.125 //y2=5.2
cc_3781 ( N_D_M63_noxref_g N_VDD_M63_noxref_d ) capacitor c=0.015318f //x=7.93 \
 //y=6.2 //x2=8.005 //y2=5.2
cc_3782 ( N_D_M94_noxref_g N_VDD_M93_noxref_d ) capacitor c=0.015318f \
 //x=33.39 //y=6.2 //x2=33.025 //y2=5.2
cc_3783 ( N_D_M95_noxref_g N_VDD_M95_noxref_d ) capacitor c=0.015318f \
 //x=33.83 //y=6.2 //x2=33.905 //y2=5.2
cc_3784 ( N_D_M126_noxref_g N_VDD_M125_noxref_d ) capacitor c=0.015318f \
 //x=59.29 //y=6.2 //x2=58.925 //y2=5.2
cc_3785 ( N_D_M127_noxref_g N_VDD_M127_noxref_d ) capacitor c=0.015318f \
 //x=59.73 //y=6.2 //x2=59.805 //y2=5.2
cc_3786 ( N_D_c_4197_n N_noxref_21_c_12936_n ) capacitor c=0.00502763f \
 //x=33.26 //y=2.755 //x2=8.315 //y2=1.175
cc_3787 ( N_D_c_4271_n N_noxref_21_c_12936_n ) capacitor c=0.00123426f \
 //x=7.61 //y=1.09 //x2=8.315 //y2=1.175
cc_3788 ( N_D_c_4272_n N_noxref_21_c_12936_n ) capacitor c=0.0129288f //x=7.61 \
 //y=1.4 //x2=8.315 //y2=1.175
cc_3789 ( N_D_c_4273_n N_noxref_21_c_12936_n ) capacitor c=0.00132209f \
 //x=7.61 //y=1.63 //x2=8.315 //y2=1.175
cc_3790 ( N_D_c_4231_n N_noxref_21_M4_noxref_d ) capacitor c=0.00603562f \
 //x=7.52 //y=2.375 //x2=7.16 //y2=1.09
cc_3791 ( N_D_c_4189_n N_noxref_21_M4_noxref_d ) capacitor c=3.04647e-19 \
 //x=7.52 //y=2.94 //x2=7.16 //y2=1.09
cc_3792 ( N_D_c_4196_n N_noxref_21_M4_noxref_d ) capacitor c=0.00100044f \
 //x=7.675 //y=2.78 //x2=7.16 //y2=1.09
cc_3793 ( N_D_c_4255_n N_noxref_21_M4_noxref_d ) capacitor c=2.2052e-19 \
 //x=7.52 //y=2.26 //x2=7.16 //y2=1.09
cc_3794 ( N_D_c_4266_n N_noxref_21_M4_noxref_d ) capacitor c=0.00253592f \
 //x=7.085 //y=1.09 //x2=7.16 //y2=1.09
cc_3795 ( N_D_c_4269_n N_noxref_21_M4_noxref_d ) capacitor c=0.00604087f \
 //x=7.085 //y=1.4 //x2=7.16 //y2=1.09
cc_3796 ( N_D_c_4662_p N_noxref_21_M4_noxref_d ) capacitor c=0.002686f \
 //x=7.455 //y=0.935 //x2=7.16 //y2=1.09
cc_3797 ( N_D_c_4663_p N_noxref_21_M4_noxref_d ) capacitor c=0.00251995f \
 //x=7.455 //y=1.555 //x2=7.16 //y2=1.09
cc_3798 ( N_D_c_4271_n N_noxref_21_M4_noxref_d ) capacitor c=0.00314523f \
 //x=7.61 //y=1.09 //x2=7.16 //y2=1.09
cc_3799 ( N_D_c_4272_n N_noxref_21_M4_noxref_d ) capacitor c=0.00168289f \
 //x=7.61 //y=1.4 //x2=7.16 //y2=1.09
cc_3800 ( N_D_c_4273_n N_noxref_21_M4_noxref_d ) capacitor c=0.00111165f \
 //x=7.61 //y=1.63 //x2=7.16 //y2=1.09
cc_3801 ( N_D_c_4197_n N_noxref_21_M5_noxref_s ) capacitor c=0.00348185f \
 //x=33.26 //y=2.755 //x2=8.265 //y2=0.555
cc_3802 ( N_D_c_4271_n N_noxref_21_M5_noxref_s ) capacitor c=7.21316e-19 \
 //x=7.61 //y=1.09 //x2=8.265 //y2=0.555
cc_3803 ( N_D_c_4272_n N_noxref_21_M5_noxref_s ) capacitor c=0.00365271f \
 //x=7.61 //y=1.4 //x2=8.265 //y2=0.555
cc_3804 ( N_D_c_4274_n N_noxref_21_M5_noxref_s ) capacitor c=9.86711e-19 \
 //x=7.61 //y=2.095 //x2=8.265 //y2=0.555
cc_3805 ( N_D_c_4369_n N_noxref_25_c_13207_n ) capacitor c=0.00123426f \
 //x=33.51 //y=1.09 //x2=34.215 //y2=1.175
cc_3806 ( N_D_c_4370_n N_noxref_25_c_13207_n ) capacitor c=0.0129288f \
 //x=33.51 //y=1.4 //x2=34.215 //y2=1.175
cc_3807 ( N_D_c_4371_n N_noxref_25_c_13207_n ) capacitor c=0.00132209f \
 //x=33.51 //y=1.63 //x2=34.215 //y2=1.175
cc_3808 ( N_D_c_4326_n N_noxref_25_M20_noxref_d ) capacitor c=0.00600316f \
 //x=33.42 //y=2.375 //x2=33.06 //y2=1.09
cc_3809 ( N_D_c_4294_n N_noxref_25_M20_noxref_d ) capacitor c=2.63584e-19 \
 //x=33.42 //y=2.915 //x2=33.06 //y2=1.09
cc_3810 ( N_D_c_4353_n N_noxref_25_M20_noxref_d ) capacitor c=2.2052e-19 \
 //x=33.42 //y=2.26 //x2=33.06 //y2=1.09
cc_3811 ( N_D_c_4364_n N_noxref_25_M20_noxref_d ) capacitor c=0.00253592f \
 //x=32.985 //y=1.09 //x2=33.06 //y2=1.09
cc_3812 ( N_D_c_4367_n N_noxref_25_M20_noxref_d ) capacitor c=0.00604087f \
 //x=32.985 //y=1.4 //x2=33.06 //y2=1.09
cc_3813 ( N_D_c_4679_p N_noxref_25_M20_noxref_d ) capacitor c=0.002686f \
 //x=33.355 //y=0.935 //x2=33.06 //y2=1.09
cc_3814 ( N_D_c_4680_p N_noxref_25_M20_noxref_d ) capacitor c=0.00251995f \
 //x=33.355 //y=1.555 //x2=33.06 //y2=1.09
cc_3815 ( N_D_c_4369_n N_noxref_25_M20_noxref_d ) capacitor c=0.00314523f \
 //x=33.51 //y=1.09 //x2=33.06 //y2=1.09
cc_3816 ( N_D_c_4370_n N_noxref_25_M20_noxref_d ) capacitor c=0.00168289f \
 //x=33.51 //y=1.4 //x2=33.06 //y2=1.09
cc_3817 ( N_D_c_4371_n N_noxref_25_M20_noxref_d ) capacitor c=0.00111165f \
 //x=33.51 //y=1.63 //x2=33.06 //y2=1.09
cc_3818 ( N_D_c_4369_n N_noxref_25_M21_noxref_s ) capacitor c=7.21316e-19 \
 //x=33.51 //y=1.09 //x2=34.165 //y2=0.555
cc_3819 ( N_D_c_4370_n N_noxref_25_M21_noxref_s ) capacitor c=0.00365271f \
 //x=33.51 //y=1.4 //x2=34.165 //y2=0.555
cc_3820 ( N_D_c_4372_n N_noxref_25_M21_noxref_s ) capacitor c=9.86711e-19 \
 //x=33.51 //y=2.095 //x2=34.165 //y2=0.555
cc_3821 ( N_D_c_4436_p N_noxref_29_c_13465_n ) capacitor c=0.00123426f \
 //x=59.41 //y=1.09 //x2=60.115 //y2=1.175
cc_3822 ( N_D_c_4438_p N_noxref_29_c_13465_n ) capacitor c=0.0129288f \
 //x=59.41 //y=1.4 //x2=60.115 //y2=1.175
cc_3823 ( N_D_c_4439_p N_noxref_29_c_13465_n ) capacitor c=0.00132209f \
 //x=59.41 //y=1.63 //x2=60.115 //y2=1.175
cc_3824 ( N_D_c_4403_p N_noxref_29_M36_noxref_d ) capacitor c=0.00600488f \
 //x=59.32 //y=2.375 //x2=58.96 //y2=1.09
cc_3825 ( N_D_c_4407_p N_noxref_29_M36_noxref_d ) capacitor c=2.57226e-19 \
 //x=59.32 //y=2.93 //x2=58.96 //y2=1.09
cc_3826 ( N_D_c_4404_p N_noxref_29_M36_noxref_d ) capacitor c=2.2052e-19 \
 //x=59.32 //y=2.26 //x2=58.96 //y2=1.09
cc_3827 ( N_D_c_4429_p N_noxref_29_M36_noxref_d ) capacitor c=0.00253592f \
 //x=58.885 //y=1.09 //x2=58.96 //y2=1.09
cc_3828 ( N_D_c_4431_p N_noxref_29_M36_noxref_d ) capacitor c=0.00604087f \
 //x=58.885 //y=1.4 //x2=58.96 //y2=1.09
cc_3829 ( N_D_c_4695_p N_noxref_29_M36_noxref_d ) capacitor c=0.002686f \
 //x=59.255 //y=0.935 //x2=58.96 //y2=1.09
cc_3830 ( N_D_c_4696_p N_noxref_29_M36_noxref_d ) capacitor c=0.00251995f \
 //x=59.255 //y=1.555 //x2=58.96 //y2=1.09
cc_3831 ( N_D_c_4436_p N_noxref_29_M36_noxref_d ) capacitor c=0.00314523f \
 //x=59.41 //y=1.09 //x2=58.96 //y2=1.09
cc_3832 ( N_D_c_4438_p N_noxref_29_M36_noxref_d ) capacitor c=0.00168289f \
 //x=59.41 //y=1.4 //x2=58.96 //y2=1.09
cc_3833 ( N_D_c_4439_p N_noxref_29_M36_noxref_d ) capacitor c=0.00111165f \
 //x=59.41 //y=1.63 //x2=58.96 //y2=1.09
cc_3834 ( N_D_c_4436_p N_noxref_29_M37_noxref_s ) capacitor c=7.21316e-19 \
 //x=59.41 //y=1.09 //x2=60.065 //y2=0.555
cc_3835 ( N_D_c_4438_p N_noxref_29_M37_noxref_s ) capacitor c=0.00365271f \
 //x=59.41 //y=1.4 //x2=60.065 //y2=0.555
cc_3836 ( N_D_c_4405_p N_noxref_29_M37_noxref_s ) capacitor c=9.86711e-19 \
 //x=59.41 //y=2.095 //x2=60.065 //y2=0.555
cc_3837 ( N_D_c_4231_n N_GND_c_13952_n ) capacitor c=8.17745e-19 //x=7.52 \
 //y=2.375 //x2=11.205 //y2=0.175
cc_3838 ( N_D_c_4189_n N_GND_c_13952_n ) capacitor c=2.81351e-19 //x=7.52 \
 //y=2.94 //x2=11.205 //y2=0.175
cc_3839 ( N_D_c_4196_n N_GND_c_13952_n ) capacitor c=0.00248718f //x=7.675 \
 //y=2.78 //x2=11.205 //y2=0.175
cc_3840 ( N_D_c_4197_n N_GND_c_13952_n ) capacitor c=0.0242545f //x=33.26 \
 //y=2.755 //x2=11.205 //y2=0.175
cc_3841 ( N_D_c_4326_n N_GND_c_14172_n ) capacitor c=7.98028e-19 //x=33.42 \
 //y=2.375 //x2=37.105 //y2=0.175
cc_3842 ( N_D_c_4294_n N_GND_c_14172_n ) capacitor c=2.67434e-19 //x=33.42 \
 //y=2.915 //x2=37.105 //y2=0.175
cc_3843 ( N_D_c_4403_p N_GND_c_14392_n ) capacitor c=7.98988e-19 //x=59.32 \
 //y=2.375 //x2=63.005 //y2=0.175
cc_3844 ( N_D_c_4407_p N_GND_c_14392_n ) capacitor c=8.06114e-19 //x=59.32 \
 //y=2.93 //x2=63.005 //y2=0.175
cc_3845 ( D N_GND_c_13974_n ) capacitor c=0.00182567f //x=7.52 //y=2.77 \
 //x2=5.3 //y2=0.175
cc_3846 ( D N_GND_c_13977_n ) capacitor c=8.89265e-19 //x=7.52 //y=2.77 \
 //x2=10.11 //y2=0.175
cc_3847 ( N_D_c_4197_n N_GND_c_13977_n ) capacitor c=0.0129245f //x=33.26 \
 //y=2.755 //x2=10.11 //y2=0.175
cc_3848 ( N_D_c_4197_n N_GND_c_14017_n ) capacitor c=0.0130905f //x=33.26 \
 //y=2.755 //x2=13.44 //y2=0.175
cc_3849 ( N_D_c_4197_n N_GND_c_14074_n ) capacitor c=0.013814f //x=33.26 \
 //y=2.755 //x2=18.25 //y2=0.175
cc_3850 ( N_D_c_4197_n N_GND_c_14147_n ) capacitor c=0.0125588f //x=33.26 \
 //y=2.755 //x2=23.06 //y2=0.175
cc_3851 ( N_D_c_4197_n N_GND_c_14154_n ) capacitor c=0.0125588f //x=33.26 \
 //y=2.755 //x2=26.39 //y2=0.175
cc_3852 ( N_D_c_4343_n N_GND_c_14193_n ) capacitor c=0.00124946f //x=33.42 \
 //y=2.77 //x2=31.2 //y2=0.175
cc_3853 ( N_D_c_4197_n N_GND_c_14193_n ) capacitor c=0.012342f //x=33.26 \
 //y=2.755 //x2=31.2 //y2=0.175
cc_3854 ( N_D_c_4343_n N_GND_c_14196_n ) capacitor c=8.90798e-19 //x=33.42 \
 //y=2.77 //x2=36.01 //y2=0.175
cc_3855 ( N_D_c_4303_n N_GND_c_14196_n ) capacitor c=0.0123928f //x=59.16 \
 //y=2.77 //x2=36.01 //y2=0.175
cc_3856 ( N_D_c_4303_n N_GND_c_14235_n ) capacitor c=0.0125588f //x=59.16 \
 //y=2.77 //x2=39.34 //y2=0.175
cc_3857 ( N_D_c_4303_n N_GND_c_14291_n ) capacitor c=0.0126304f //x=59.16 \
 //y=2.77 //x2=44.15 //y2=0.175
cc_3858 ( N_D_c_4303_n N_GND_c_14329_n ) capacitor c=0.0125588f //x=59.16 \
 //y=2.77 //x2=48.96 //y2=0.175
cc_3859 ( N_D_c_4303_n N_GND_c_14376_n ) capacitor c=0.0125588f //x=59.16 \
 //y=2.77 //x2=52.29 //y2=0.175
cc_3860 ( N_D_c_4409_p N_GND_c_14409_n ) capacitor c=0.00124714f //x=59.32 \
 //y=2.77 //x2=57.1 //y2=0.175
cc_3861 ( N_D_c_4303_n N_GND_c_14409_n ) capacitor c=0.012342f //x=59.16 \
 //y=2.77 //x2=57.1 //y2=0.175
cc_3862 ( N_D_c_4409_p N_GND_c_14411_n ) capacitor c=0.00139524f //x=59.32 \
 //y=2.77 //x2=61.91 //y2=0.175
cc_3863 ( N_D_c_4266_n N_noxref_36_c_15606_n ) capacitor c=0.0167228f \
 //x=7.085 //y=1.09 //x2=7.745 //y2=0.72
cc_3864 ( N_D_c_4271_n N_noxref_36_c_15606_n ) capacitor c=0.00534519f \
 //x=7.61 //y=1.09 //x2=7.745 //y2=0.72
cc_3865 ( N_D_c_4231_n N_noxref_36_c_15592_n ) capacitor c=0.0048147f //x=7.52 \
 //y=2.375 //x2=7.745 //y2=1.77
cc_3866 ( N_D_c_4189_n N_noxref_36_c_15592_n ) capacitor c=0.00333171f \
 //x=7.52 //y=2.94 //x2=7.745 //y2=1.77
cc_3867 ( N_D_c_4255_n N_noxref_36_c_15592_n ) capacitor c=0.0105652f //x=7.52 \
 //y=2.26 //x2=7.745 //y2=1.77
cc_3868 ( N_D_c_4269_n N_noxref_36_c_15592_n ) capacitor c=0.0153476f \
 //x=7.085 //y=1.4 //x2=7.745 //y2=1.77
cc_3869 ( N_D_c_4274_n N_noxref_36_c_15592_n ) capacitor c=0.0215046f //x=7.61 \
 //y=2.095 //x2=7.745 //y2=1.77
cc_3870 ( N_D_c_4189_n N_noxref_36_M3_noxref_s ) capacitor c=8.07677e-19 \
 //x=7.52 //y=2.94 //x2=5.755 //y2=0.555
cc_3871 ( N_D_c_4197_n N_noxref_36_M3_noxref_s ) capacitor c=0.0024662f \
 //x=33.26 //y=2.755 //x2=5.755 //y2=0.555
cc_3872 ( N_D_c_4266_n N_noxref_36_M3_noxref_s ) capacitor c=0.00798959f \
 //x=7.085 //y=1.09 //x2=5.755 //y2=0.555
cc_3873 ( N_D_c_4273_n N_noxref_36_M3_noxref_s ) capacitor c=0.00212176f \
 //x=7.61 //y=1.63 //x2=5.755 //y2=0.555
cc_3874 ( N_D_c_4274_n N_noxref_36_M3_noxref_s ) capacitor c=0.00298115f \
 //x=7.61 //y=2.095 //x2=5.755 //y2=0.555
cc_3875 ( N_D_c_4364_n N_noxref_42_c_15969_n ) capacitor c=0.0167228f \
 //x=32.985 //y=1.09 //x2=33.645 //y2=0.72
cc_3876 ( N_D_c_4369_n N_noxref_42_c_15969_n ) capacitor c=0.00534519f \
 //x=33.51 //y=1.09 //x2=33.645 //y2=0.72
cc_3877 ( N_D_c_4326_n N_noxref_42_c_15971_n ) capacitor c=0.0048147f \
 //x=33.42 //y=2.375 //x2=33.645 //y2=1.77
cc_3878 ( N_D_c_4294_n N_noxref_42_c_15971_n ) capacitor c=0.00327831f \
 //x=33.42 //y=2.915 //x2=33.645 //y2=1.77
cc_3879 ( N_D_c_4353_n N_noxref_42_c_15971_n ) capacitor c=0.0105652f \
 //x=33.42 //y=2.26 //x2=33.645 //y2=1.77
cc_3880 ( N_D_c_4367_n N_noxref_42_c_15971_n ) capacitor c=0.0154024f \
 //x=32.985 //y=1.4 //x2=33.645 //y2=1.77
cc_3881 ( N_D_c_4372_n N_noxref_42_c_15971_n ) capacitor c=0.0214801f \
 //x=33.51 //y=2.095 //x2=33.645 //y2=1.77
cc_3882 ( N_D_c_4294_n N_noxref_42_M19_noxref_s ) capacitor c=8.07677e-19 \
 //x=33.42 //y=2.915 //x2=31.655 //y2=0.555
cc_3883 ( N_D_c_4364_n N_noxref_42_M19_noxref_s ) capacitor c=0.00798959f \
 //x=32.985 //y=1.09 //x2=31.655 //y2=0.555
cc_3884 ( N_D_c_4371_n N_noxref_42_M19_noxref_s ) capacitor c=0.00212176f \
 //x=33.51 //y=1.63 //x2=31.655 //y2=0.555
cc_3885 ( N_D_c_4372_n N_noxref_42_M19_noxref_s ) capacitor c=0.00298115f \
 //x=33.51 //y=2.095 //x2=31.655 //y2=0.555
cc_3886 ( N_D_c_4429_p N_noxref_48_c_16325_n ) capacitor c=0.0167228f \
 //x=58.885 //y=1.09 //x2=59.545 //y2=0.72
cc_3887 ( N_D_c_4436_p N_noxref_48_c_16325_n ) capacitor c=0.00534519f \
 //x=59.41 //y=1.09 //x2=59.545 //y2=0.72
cc_3888 ( N_D_c_4403_p N_noxref_48_c_16327_n ) capacitor c=0.0048147f \
 //x=59.32 //y=2.375 //x2=59.545 //y2=1.77
cc_3889 ( N_D_c_4407_p N_noxref_48_c_16327_n ) capacitor c=0.00352006f \
 //x=59.32 //y=2.93 //x2=59.545 //y2=1.77
cc_3890 ( N_D_c_4404_p N_noxref_48_c_16327_n ) capacitor c=0.0105652f \
 //x=59.32 //y=2.26 //x2=59.545 //y2=1.77
cc_3891 ( N_D_c_4431_p N_noxref_48_c_16327_n ) capacitor c=0.0153476f \
 //x=58.885 //y=1.4 //x2=59.545 //y2=1.77
cc_3892 ( N_D_c_4405_p N_noxref_48_c_16327_n ) capacitor c=0.0197712f \
 //x=59.41 //y=2.095 //x2=59.545 //y2=1.77
cc_3893 ( N_D_c_4407_p N_noxref_48_M35_noxref_s ) capacitor c=9.8454e-19 \
 //x=59.32 //y=2.93 //x2=57.555 //y2=0.555
cc_3894 ( N_D_c_4429_p N_noxref_48_M35_noxref_s ) capacitor c=0.00798959f \
 //x=58.885 //y=1.09 //x2=57.555 //y2=0.555
cc_3895 ( N_D_c_4439_p N_noxref_48_M35_noxref_s ) capacitor c=0.00212176f \
 //x=59.41 //y=1.63 //x2=57.555 //y2=0.555
cc_3896 ( N_D_c_4405_p N_noxref_48_M35_noxref_s ) capacitor c=0.00298115f \
 //x=59.41 //y=2.095 //x2=57.555 //y2=0.555
cc_3897 ( N_CLK_c_5230_p N_noxref_12_c_5847_n ) capacitor c=0.0236366f \
 //x=54.505 //y=4.835 //x2=54.58 //y2=5.335
cc_3898 ( N_CLK_c_5229_n N_noxref_12_c_5847_n ) capacitor c=0.00242901f \
 //x=63.635 //y=4.635 //x2=54.58 //y2=5.335
cc_3899 ( N_CLK_c_5232_p N_noxref_12_c_5847_n ) capacitor c=0.00492634f \
 //x=54.51 //y=4.88 //x2=54.58 //y2=5.335
cc_3900 ( N_CLK_M120_noxref_g N_noxref_12_c_5847_n ) capacitor c=0.00858222f \
 //x=54.48 //y=6.2 //x2=54.58 //y2=5.335
cc_3901 ( N_CLK_c_5234_p N_noxref_12_c_5847_n ) capacitor c=3.54644e-19 \
 //x=54.51 //y=4.88 //x2=54.58 //y2=5.335
cc_3902 ( N_CLK_M121_noxref_g N_noxref_12_c_5852_n ) capacitor c=0.00955829f \
 //x=54.92 //y=6.2 //x2=55.465 //y2=5.335
cc_3903 ( N_CLK_c_5229_n N_noxref_12_c_5853_n ) capacitor c=0.0206181f \
 //x=63.635 //y=4.635 //x2=56.275 //y2=5.335
cc_3904 ( CLK N_noxref_12_c_5800_n ) capacitor c=0.00171166f //x=54.51 \
 //y=3.88 //x2=56.36 //y2=3.725
cc_3905 ( CLK N_noxref_12_c_5803_n ) capacitor c=9.21998e-19 //x=54.51 \
 //y=3.88 //x2=56.36 //y2=5.25
cc_3906 ( N_CLK_c_5229_n N_noxref_12_c_5803_n ) capacitor c=0.0298618f \
 //x=63.635 //y=4.635 //x2=56.36 //y2=5.25
cc_3907 ( N_CLK_c_5229_n N_noxref_12_c_5815_n ) capacitor c=0.0317543f \
 //x=63.635 //y=4.635 //x2=58.21 //y2=4.755
cc_3908 ( N_CLK_c_5229_n N_noxref_12_c_5858_n ) capacitor c=0.0278748f \
 //x=63.635 //y=4.635 //x2=53.822 //y2=5.335
cc_3909 ( N_CLK_c_5230_p N_noxref_12_c_5859_n ) capacitor c=0.00512107f \
 //x=54.505 //y=4.835 //x2=54.7 //y2=5.335
cc_3910 ( N_CLK_c_5229_n N_noxref_12_c_5859_n ) capacitor c=0.0403966f \
 //x=63.635 //y=4.635 //x2=54.7 //y2=5.335
cc_3911 ( N_CLK_c_5232_p N_noxref_12_c_5859_n ) capacitor c=0.00132214f \
 //x=54.51 //y=4.88 //x2=54.7 //y2=5.335
cc_3912 ( N_CLK_M120_noxref_g N_noxref_12_c_5859_n ) capacitor c=0.00229818f \
 //x=54.48 //y=6.2 //x2=54.7 //y2=5.335
cc_3913 ( N_CLK_M121_noxref_g N_noxref_12_c_5859_n ) capacitor c=0.00230699f \
 //x=54.92 //y=6.2 //x2=54.7 //y2=5.335
cc_3914 ( N_CLK_c_5247_p N_noxref_12_c_5859_n ) capacitor c=0.00170733f \
 //x=54.845 //y=4.97 //x2=54.7 //y2=5.335
cc_3915 ( N_CLK_c_5229_n N_noxref_12_c_5865_n ) capacitor c=0.00757951f \
 //x=63.635 //y=4.635 //x2=58.055 //y2=3.88
cc_3916 ( N_CLK_c_5229_n N_noxref_12_c_5866_n ) capacitor c=0.00651789f \
 //x=63.635 //y=4.635 //x2=61.39 //y2=3.895
cc_3917 ( N_CLK_c_5229_n N_noxref_12_c_5819_n ) capacitor c=0.020402f \
 //x=63.635 //y=4.635 //x2=61.045 //y2=3.895
cc_3918 ( N_CLK_c_5229_n N_noxref_12_c_5868_n ) capacitor c=0.00369971f \
 //x=63.635 //y=4.635 //x2=62.635 //y2=3.88
cc_3919 ( N_CLK_c_5229_n N_noxref_12_c_5869_n ) capacitor c=0.00295169f \
 //x=63.635 //y=4.635 //x2=63.235 //y2=3.895
cc_3920 ( N_CLK_c_5253_p N_noxref_12_c_5870_n ) capacitor c=0.00627414f \
 //x=63.98 //y=4.635 //x2=63.98 //y2=3.865
cc_3921 ( N_CLK_c_5253_p N_noxref_12_c_5871_n ) capacitor c=0.00621235f \
 //x=63.98 //y=4.635 //x2=64.715 //y2=3.9
cc_3922 ( N_CLK_c_5253_p N_noxref_12_c_5872_n ) capacitor c=0.00307733f \
 //x=63.98 //y=4.635 //x2=65.97 //y2=3.88
cc_3923 ( N_CLK_c_5256_p N_noxref_12_c_5873_n ) capacitor c=6.63302e-19 \
 //x=67.46 //y=4.535 //x2=66.57 //y2=3.9
cc_3924 ( N_CLK_c_5253_p N_noxref_12_c_5873_n ) capacitor c=0.00555681f \
 //x=63.98 //y=4.635 //x2=66.57 //y2=3.9
cc_3925 ( N_CLK_c_5256_p N_noxref_12_c_5875_n ) capacitor c=0.0235404f \
 //x=67.46 //y=4.535 //x2=68.93 //y2=3.88
cc_3926 ( N_CLK_c_5230_p N_noxref_12_c_5876_n ) capacitor c=0.00134045f \
 //x=54.505 //y=4.835 //x2=54.7 //y2=5.56
cc_3927 ( N_CLK_M120_noxref_g N_noxref_12_c_5876_n ) capacitor c=0.0179041f \
 //x=54.48 //y=6.2 //x2=54.7 //y2=5.56
cc_3928 ( N_CLK_M121_noxref_g N_noxref_12_c_5876_n ) capacitor c=0.0179041f \
 //x=54.92 //y=6.2 //x2=54.7 //y2=5.56
cc_3929 ( N_CLK_c_5247_p N_noxref_12_c_5876_n ) capacitor c=0.00293647f \
 //x=54.845 //y=4.97 //x2=54.7 //y2=5.56
cc_3930 ( N_CLK_c_4775_n RN ) capacitor c=0.0253812f //x=11.58 //y=4.62 \
 //x2=8.63 //y2=3.14
cc_3931 ( CLK RN ) capacitor c=0.0540973f //x=15.66 //y=3.14 //x2=16.77 \
 //y2=3.14
cc_3932 ( N_CLK_c_4815_n RN ) capacitor c=0.00380533f //x=15.655 //y=4.695 \
 //x2=16.77 //y2=3.14
cc_3933 ( N_CLK_c_4822_n RN ) capacitor c=0.0261926f //x=17.385 //y=4.64 \
 //x2=16.77 //y2=3.14
cc_3934 ( N_CLK_c_4875_n RN ) capacitor c=0.0268258f //x=24.515 //y=4.62 \
 //x2=20.47 //y2=3.14
cc_3935 ( CLK RN ) capacitor c=0.0505614f //x=41.56 //y=3.51 //x2=42.67 \
 //y2=3.51
cc_3936 ( N_CLK_c_5043_n RN ) capacitor c=0.00380533f //x=41.555 //y=4.695 \
 //x2=42.67 //y2=3.51
cc_3937 ( N_CLK_c_5050_n RN ) capacitor c=0.0261926f //x=43.285 //y=4.64 \
 //x2=42.67 //y2=3.51
cc_3938 ( N_CLK_c_5105_n RN ) capacitor c=0.0268258f //x=50.415 //y=4.62 \
 //x2=46.37 //y2=3.51
cc_3939 ( N_CLK_c_4775_n N_RN_c_6301_n ) capacitor c=0.00440204f //x=11.58 \
 //y=4.62 //x2=8.63 //y2=4.75
cc_3940 ( CLK N_RN_c_6429_n ) capacitor c=0.00158143f //x=15.66 //y=3.14 \
 //x2=16.77 //y2=2.465
cc_3941 ( N_CLK_c_4812_n N_RN_c_6429_n ) capacitor c=0.0066827f //x=15.66 \
 //y=2.375 //x2=16.77 //y2=2.465
cc_3942 ( N_CLK_c_4825_n N_RN_c_6429_n ) capacitor c=9.53526e-19 //x=15.66 \
 //y=2.26 //x2=16.77 //y2=2.465
cc_3943 ( N_CLK_c_4844_n N_RN_c_6429_n ) capacitor c=0.00135583f //x=15.75 \
 //y=2.095 //x2=16.77 //y2=2.465
cc_3944 ( N_CLK_c_4815_n N_RN_c_6432_n ) capacitor c=0.00878903f //x=15.655 \
 //y=4.695 //x2=16.77 //y2=4.75
cc_3945 ( N_CLK_c_4822_n N_RN_c_6432_n ) capacitor c=0.00681368f //x=17.385 \
 //y=4.64 //x2=16.77 //y2=4.75
cc_3946 ( N_CLK_c_4829_n N_RN_c_6432_n ) capacitor c=4.56604e-19 //x=15.66 \
 //y=4.88 //x2=16.77 //y2=4.75
cc_3947 ( N_CLK_c_4847_n N_RN_c_6432_n ) capacitor c=2.32327e-19 //x=15.66 \
 //y=4.88 //x2=16.77 //y2=4.75
cc_3948 ( N_CLK_c_4875_n N_RN_c_6376_n ) capacitor c=0.00432726f //x=24.515 \
 //y=4.62 //x2=20.47 //y2=4.765
cc_3949 ( N_CLK_c_5004_n N_RN_c_6509_n ) capacitor c=0.0297832f //x=37.735 \
 //y=4.635 //x2=34.53 //y2=4.75
cc_3950 ( CLK N_RN_c_6667_n ) capacitor c=0.00158143f //x=41.56 //y=3.51 \
 //x2=42.67 //y2=2.465
cc_3951 ( N_CLK_c_5040_n N_RN_c_6667_n ) capacitor c=0.0066827f //x=41.56 \
 //y=2.375 //x2=42.67 //y2=2.465
cc_3952 ( N_CLK_c_5053_n N_RN_c_6667_n ) capacitor c=9.53526e-19 //x=41.56 \
 //y=2.26 //x2=42.67 //y2=2.465
cc_3953 ( N_CLK_c_5072_n N_RN_c_6667_n ) capacitor c=0.00135583f //x=41.65 \
 //y=2.095 //x2=42.67 //y2=2.465
cc_3954 ( N_CLK_c_5043_n N_RN_c_6670_n ) capacitor c=0.00878903f //x=41.555 \
 //y=4.695 //x2=42.67 //y2=4.75
cc_3955 ( N_CLK_c_5050_n N_RN_c_6670_n ) capacitor c=0.00681368f //x=43.285 \
 //y=4.64 //x2=42.67 //y2=4.75
cc_3956 ( N_CLK_c_5057_n N_RN_c_6670_n ) capacitor c=4.56604e-19 //x=41.56 \
 //y=4.88 //x2=42.67 //y2=4.75
cc_3957 ( N_CLK_c_5075_n N_RN_c_6670_n ) capacitor c=2.32327e-19 //x=41.56 \
 //y=4.88 //x2=42.67 //y2=4.75
cc_3958 ( N_CLK_c_5105_n N_RN_c_6591_n ) capacitor c=0.00432726f //x=50.415 \
 //y=4.62 //x2=46.37 //y2=4.765
cc_3959 ( N_CLK_c_5229_n N_RN_c_6764_n ) capacitor c=0.0297832f //x=63.635 \
 //y=4.635 //x2=60.43 //y2=4.75
cc_3960 ( N_CLK_c_5293_p N_RN_c_6884_n ) capacitor c=0.00671729f //x=67.46 \
 //y=2.375 //x2=68.57 //y2=2.465
cc_3961 ( N_CLK_c_5256_p N_RN_c_6884_n ) capacitor c=0.00158143f //x=67.46 \
 //y=4.535 //x2=68.57 //y2=2.465
cc_3962 ( N_CLK_c_5295_p N_RN_c_6884_n ) capacitor c=9.53526e-19 //x=67.46 \
 //y=2.26 //x2=68.57 //y2=2.465
cc_3963 ( N_CLK_c_5296_p N_RN_c_6884_n ) capacitor c=0.00135583f //x=67.55 \
 //y=2.095 //x2=68.57 //y2=2.465
cc_3964 ( N_CLK_c_5256_p N_RN_c_6888_n ) capacitor c=0.0501652f //x=67.46 \
 //y=4.535 //x2=68.57 //y2=4.75
cc_3965 ( N_CLK_c_5298_p N_RN_c_6888_n ) capacitor c=0.0137107f //x=67.455 \
 //y=4.695 //x2=68.57 //y2=4.75
cc_3966 ( N_CLK_c_5253_p N_RN_c_6888_n ) capacitor c=0.00601472f //x=63.98 \
 //y=4.635 //x2=68.57 //y2=4.75
cc_3967 ( N_CLK_c_5300_p N_RN_c_6888_n ) capacitor c=4.56604e-19 //x=67.46 \
 //y=4.88 //x2=68.57 //y2=4.75
cc_3968 ( N_CLK_c_5301_p N_RN_c_6888_n ) capacitor c=2.32327e-19 //x=67.46 \
 //y=4.88 //x2=68.57 //y2=4.75
cc_3969 ( CLK N_RN_c_6386_n ) capacitor c=0.0137581f //x=28.61 //y=3.51 \
 //x2=33.205 //y2=2.37
cc_3970 ( N_CLK_c_4998_n N_RN_c_6386_n ) capacitor c=0.017405f //x=28.61 \
 //y=2.375 //x2=33.205 //y2=2.37
cc_3971 ( N_CLK_c_5012_n N_RN_c_6386_n ) capacitor c=5.2767e-19 //x=28.61 \
 //y=2.26 //x2=33.205 //y2=2.37
cc_3972 ( N_CLK_c_5025_n N_RN_c_6386_n ) capacitor c=4.03361e-19 //x=28.7 \
 //y=2.095 //x2=33.205 //y2=2.37
cc_3973 ( CLK N_RN_c_6606_n ) capacitor c=0.0137581f //x=54.51 //y=3.88 \
 //x2=59.105 //y2=2.385
cc_3974 ( N_CLK_c_5307_p N_RN_c_6606_n ) capacitor c=0.017405f //x=54.51 \
 //y=2.375 //x2=59.105 //y2=2.385
cc_3975 ( N_CLK_c_5308_p N_RN_c_6606_n ) capacitor c=5.2767e-19 //x=54.51 \
 //y=2.26 //x2=59.105 //y2=2.385
cc_3976 ( N_CLK_c_5309_p N_RN_c_6606_n ) capacitor c=4.03361e-19 //x=54.6 \
 //y=2.095 //x2=59.105 //y2=2.385
cc_3977 ( CLK N_RN_c_6308_n ) capacitor c=0.0136732f //x=15.66 //y=3.14 \
 //x2=16.615 //y2=2.315
cc_3978 ( N_CLK_c_4812_n N_RN_c_6308_n ) capacitor c=0.0173156f //x=15.66 \
 //y=2.375 //x2=16.615 //y2=2.315
cc_3979 ( N_CLK_c_4825_n N_RN_c_6308_n ) capacitor c=2.63835e-19 //x=15.66 \
 //y=2.26 //x2=16.615 //y2=2.315
cc_3980 ( N_CLK_c_4844_n N_RN_c_6308_n ) capacitor c=4.03361e-19 //x=15.75 \
 //y=2.095 //x2=16.615 //y2=2.315
cc_3981 ( N_CLK_c_4812_n N_RN_c_6391_n ) capacitor c=0.00390832f //x=15.66 \
 //y=2.375 //x2=16.935 //y2=2.315
cc_3982 ( CLK N_RN_c_6525_n ) capacitor c=0.0136732f //x=41.56 //y=3.51 \
 //x2=42.515 //y2=2.315
cc_3983 ( N_CLK_c_5040_n N_RN_c_6525_n ) capacitor c=0.0173156f //x=41.56 \
 //y=2.375 //x2=42.515 //y2=2.315
cc_3984 ( N_CLK_c_5053_n N_RN_c_6525_n ) capacitor c=2.63835e-19 //x=41.56 \
 //y=2.26 //x2=42.515 //y2=2.315
cc_3985 ( N_CLK_c_5072_n N_RN_c_6525_n ) capacitor c=4.03361e-19 //x=41.65 \
 //y=2.095 //x2=42.515 //y2=2.315
cc_3986 ( N_CLK_c_5040_n N_RN_c_6686_n ) capacitor c=0.00390832f //x=41.56 \
 //y=2.375 //x2=42.835 //y2=2.315
cc_3987 ( N_CLK_c_5293_p N_RN_c_6911_n ) capacitor c=0.0173156f //x=67.46 \
 //y=2.375 //x2=68.415 //y2=2.315
cc_3988 ( N_CLK_c_5256_p N_RN_c_6911_n ) capacitor c=0.0163372f //x=67.46 \
 //y=4.535 //x2=68.415 //y2=2.315
cc_3989 ( N_CLK_c_5295_p N_RN_c_6911_n ) capacitor c=2.63835e-19 //x=67.46 \
 //y=2.26 //x2=68.415 //y2=2.315
cc_3990 ( N_CLK_c_5296_p N_RN_c_6911_n ) capacitor c=4.03361e-19 //x=67.55 \
 //y=2.095 //x2=68.415 //y2=2.315
cc_3991 ( N_CLK_c_5293_p N_RN_c_6915_n ) capacitor c=0.00390832f //x=67.46 \
 //y=2.375 //x2=68.735 //y2=2.315
cc_3992 ( N_CLK_c_4812_n N_RN_c_6460_n ) capacitor c=6.92676e-19 //x=15.66 \
 //y=2.375 //x2=16.77 //y2=2.26
cc_3993 ( N_CLK_c_4825_n N_RN_c_6460_n ) capacitor c=0.00129119f //x=15.66 \
 //y=2.26 //x2=16.77 //y2=2.26
cc_3994 ( N_CLK_c_4844_n N_RN_c_6460_n ) capacitor c=0.00210314f //x=15.75 \
 //y=2.095 //x2=16.77 //y2=2.26
cc_3995 ( N_CLK_c_4815_n N_RN_c_6461_n ) capacitor c=9.59226e-19 //x=15.655 \
 //y=4.695 //x2=16.77 //y2=4.88
cc_3996 ( N_CLK_c_4829_n N_RN_c_6461_n ) capacitor c=0.00113671f //x=15.66 \
 //y=4.88 //x2=16.77 //y2=4.88
cc_3997 ( N_CLK_c_4847_n N_RN_c_6461_n ) capacitor c=0.00104879f //x=15.66 \
 //y=4.88 //x2=16.77 //y2=4.88
cc_3998 ( N_CLK_c_5040_n N_RN_c_6688_n ) capacitor c=6.92676e-19 //x=41.56 \
 //y=2.375 //x2=42.67 //y2=2.26
cc_3999 ( N_CLK_c_5053_n N_RN_c_6688_n ) capacitor c=0.00129119f //x=41.56 \
 //y=2.26 //x2=42.67 //y2=2.26
cc_4000 ( N_CLK_c_5072_n N_RN_c_6688_n ) capacitor c=0.00210314f //x=41.65 \
 //y=2.095 //x2=42.67 //y2=2.26
cc_4001 ( N_CLK_c_5043_n N_RN_c_6689_n ) capacitor c=9.59226e-19 //x=41.555 \
 //y=4.695 //x2=42.67 //y2=4.88
cc_4002 ( N_CLK_c_5057_n N_RN_c_6689_n ) capacitor c=0.00113671f //x=41.56 \
 //y=4.88 //x2=42.67 //y2=4.88
cc_4003 ( N_CLK_c_5075_n N_RN_c_6689_n ) capacitor c=0.00104879f //x=41.56 \
 //y=4.88 //x2=42.67 //y2=4.88
cc_4004 ( N_CLK_c_5293_p N_RN_c_6928_n ) capacitor c=6.92676e-19 //x=67.46 \
 //y=2.375 //x2=68.57 //y2=2.26
cc_4005 ( N_CLK_c_5295_p N_RN_c_6928_n ) capacitor c=0.00129119f //x=67.46 \
 //y=2.26 //x2=68.57 //y2=2.26
cc_4006 ( N_CLK_c_5296_p N_RN_c_6928_n ) capacitor c=0.00210314f //x=67.55 \
 //y=2.095 //x2=68.57 //y2=2.26
cc_4007 ( N_CLK_c_5298_p N_RN_c_6931_n ) capacitor c=9.59226e-19 //x=67.455 \
 //y=4.695 //x2=68.57 //y2=4.88
cc_4008 ( N_CLK_c_5300_p N_RN_c_6931_n ) capacitor c=0.00113671f //x=67.46 \
 //y=4.88 //x2=68.57 //y2=4.88
cc_4009 ( N_CLK_c_5301_p N_RN_c_6931_n ) capacitor c=0.00104879f //x=67.46 \
 //y=4.88 //x2=68.57 //y2=4.88
cc_4010 ( N_CLK_M72_noxref_g N_RN_M74_noxref_g ) capacitor c=0.0101598f \
 //x=15.63 //y=6.2 //x2=16.51 //y2=6.2
cc_4011 ( N_CLK_M73_noxref_g N_RN_M74_noxref_g ) capacitor c=0.0607518f \
 //x=16.07 //y=6.2 //x2=16.51 //y2=6.2
cc_4012 ( N_CLK_M73_noxref_g N_RN_M75_noxref_g ) capacitor c=0.0101598f \
 //x=16.07 //y=6.2 //x2=16.95 //y2=6.2
cc_4013 ( N_CLK_M104_noxref_g N_RN_M106_noxref_g ) capacitor c=0.0101598f \
 //x=41.53 //y=6.2 //x2=42.41 //y2=6.2
cc_4014 ( N_CLK_M105_noxref_g N_RN_M106_noxref_g ) capacitor c=0.0607518f \
 //x=41.97 //y=6.2 //x2=42.41 //y2=6.2
cc_4015 ( N_CLK_M105_noxref_g N_RN_M107_noxref_g ) capacitor c=0.0101598f \
 //x=41.97 //y=6.2 //x2=42.85 //y2=6.2
cc_4016 ( N_CLK_M136_noxref_g N_RN_M138_noxref_g ) capacitor c=0.0101598f \
 //x=67.43 //y=6.2 //x2=68.31 //y2=6.2
cc_4017 ( N_CLK_M137_noxref_g N_RN_M138_noxref_g ) capacitor c=0.0607518f \
 //x=67.87 //y=6.2 //x2=68.31 //y2=6.2
cc_4018 ( N_CLK_M137_noxref_g N_RN_M139_noxref_g ) capacitor c=0.0101598f \
 //x=67.87 //y=6.2 //x2=68.75 //y2=6.2
cc_4019 ( N_CLK_c_4841_n N_RN_c_6479_n ) capacitor c=0.00456962f //x=15.75 \
 //y=1.09 //x2=16.76 //y2=1.095
cc_4020 ( N_CLK_c_4842_n N_RN_c_6481_n ) capacitor c=0.00438372f //x=15.75 \
 //y=1.4 //x2=16.76 //y2=1.44
cc_4021 ( N_CLK_c_4843_n N_RN_c_6484_n ) capacitor c=0.00438372f //x=15.75 \
 //y=1.63 //x2=16.76 //y2=1.75
cc_4022 ( N_CLK_c_5069_n N_RN_c_6699_n ) capacitor c=0.00456962f //x=41.65 \
 //y=1.09 //x2=42.66 //y2=1.095
cc_4023 ( N_CLK_c_5070_n N_RN_c_6701_n ) capacitor c=0.00438372f //x=41.65 \
 //y=1.4 //x2=42.66 //y2=1.44
cc_4024 ( N_CLK_c_5071_n N_RN_c_6704_n ) capacitor c=0.00438372f //x=41.65 \
 //y=1.63 //x2=42.66 //y2=1.75
cc_4025 ( N_CLK_c_5358_p N_RN_c_6949_n ) capacitor c=0.00456962f //x=67.55 \
 //y=1.09 //x2=68.56 //y2=1.095
cc_4026 ( N_CLK_c_5359_p N_RN_c_6950_n ) capacitor c=0.00438372f //x=67.55 \
 //y=1.4 //x2=68.56 //y2=1.44
cc_4027 ( N_CLK_c_5360_p N_RN_c_6951_n ) capacitor c=0.00438372f //x=67.55 \
 //y=1.63 //x2=68.56 //y2=1.75
cc_4028 ( N_CLK_c_4825_n N_RN_c_6499_n ) capacitor c=0.00155537f //x=15.66 \
 //y=2.26 //x2=16.77 //y2=2.26
cc_4029 ( N_CLK_c_4844_n N_RN_c_6499_n ) capacitor c=0.00831559f //x=15.75 \
 //y=2.095 //x2=16.77 //y2=2.26
cc_4030 ( N_CLK_c_4844_n N_RN_c_6500_n ) capacitor c=0.00438372f //x=15.75 \
 //y=2.095 //x2=16.77 //y2=2.095
cc_4031 ( N_CLK_c_4815_n N_RN_c_6502_n ) capacitor c=0.00139285f //x=15.655 \
 //y=4.695 //x2=16.77 //y2=4.88
cc_4032 ( N_CLK_c_4829_n N_RN_c_6502_n ) capacitor c=0.00186974f //x=15.66 \
 //y=4.88 //x2=16.77 //y2=4.88
cc_4033 ( N_CLK_c_4985_n N_RN_c_6502_n ) capacitor c=0.0616777f //x=15.995 \
 //y=4.97 //x2=16.77 //y2=4.88
cc_4034 ( N_CLK_c_4847_n N_RN_c_6502_n ) capacitor c=0.00440391f //x=15.66 \
 //y=4.88 //x2=16.77 //y2=4.88
cc_4035 ( N_CLK_c_5053_n N_RN_c_6717_n ) capacitor c=0.00155537f //x=41.56 \
 //y=2.26 //x2=42.67 //y2=2.26
cc_4036 ( N_CLK_c_5072_n N_RN_c_6717_n ) capacitor c=0.00831559f //x=41.65 \
 //y=2.095 //x2=42.67 //y2=2.26
cc_4037 ( N_CLK_c_5072_n N_RN_c_6718_n ) capacitor c=0.00438372f //x=41.65 \
 //y=2.095 //x2=42.67 //y2=2.095
cc_4038 ( N_CLK_c_5043_n N_RN_c_6720_n ) capacitor c=0.00139285f //x=41.555 \
 //y=4.695 //x2=42.67 //y2=4.88
cc_4039 ( N_CLK_c_5057_n N_RN_c_6720_n ) capacitor c=0.00186974f //x=41.56 \
 //y=4.88 //x2=42.67 //y2=4.88
cc_4040 ( N_CLK_c_5213_n N_RN_c_6720_n ) capacitor c=0.0616777f //x=41.895 \
 //y=4.97 //x2=42.67 //y2=4.88
cc_4041 ( N_CLK_c_5075_n N_RN_c_6720_n ) capacitor c=0.00440391f //x=41.56 \
 //y=4.88 //x2=42.67 //y2=4.88
cc_4042 ( N_CLK_c_5295_p N_RN_c_6966_n ) capacitor c=0.00155537f //x=67.46 \
 //y=2.26 //x2=68.57 //y2=2.26
cc_4043 ( N_CLK_c_5296_p N_RN_c_6966_n ) capacitor c=0.00831559f //x=67.55 \
 //y=2.095 //x2=68.57 //y2=2.26
cc_4044 ( N_CLK_c_5296_p N_RN_c_6968_n ) capacitor c=0.00438372f //x=67.55 \
 //y=2.095 //x2=68.57 //y2=2.095
cc_4045 ( N_CLK_c_5298_p N_RN_c_6969_n ) capacitor c=0.00139285f //x=67.455 \
 //y=4.695 //x2=68.57 //y2=4.88
cc_4046 ( N_CLK_c_5300_p N_RN_c_6969_n ) capacitor c=0.00186974f //x=67.46 \
 //y=4.88 //x2=68.57 //y2=4.88
cc_4047 ( N_CLK_c_5380_p N_RN_c_6969_n ) capacitor c=0.0616777f //x=67.795 \
 //y=4.97 //x2=68.57 //y2=4.88
cc_4048 ( N_CLK_c_5301_p N_RN_c_6969_n ) capacitor c=0.00440391f //x=67.46 \
 //y=4.88 //x2=68.57 //y2=4.88
cc_4049 ( N_CLK_c_5307_p N_noxref_14_c_7733_n ) capacitor c=0.00932261f \
 //x=54.51 //y=2.375 //x2=53.4 //y2=2.375
cc_4050 ( N_CLK_c_5308_p N_noxref_14_c_7733_n ) capacitor c=5.39999e-19 \
 //x=54.51 //y=2.26 //x2=53.4 //y2=2.375
cc_4051 ( N_CLK_c_5309_p N_noxref_14_c_7733_n ) capacitor c=0.00136403f \
 //x=54.6 //y=2.095 //x2=53.4 //y2=2.375
cc_4052 ( CLK N_noxref_14_c_7727_n ) capacitor c=0.0415076f //x=54.51 //y=3.88 \
 //x2=53.4 //y2=4.1
cc_4053 ( N_CLK_c_5308_p N_noxref_14_c_7727_n ) capacitor c=3.9149e-19 \
 //x=54.51 //y=2.26 //x2=53.4 //y2=4.1
cc_4054 ( CLK N_noxref_14_c_7738_n ) capacitor c=0.00772839f //x=54.51 \
 //y=3.88 //x2=53.4 //y2=4.42
cc_4055 ( N_CLK_c_5388_p N_noxref_14_c_7738_n ) capacitor c=0.00138888f \
 //x=53.015 //y=4.62 //x2=53.4 //y2=4.42
cc_4056 ( N_CLK_c_5389_p N_noxref_14_c_7738_n ) capacitor c=0.0064995f \
 //x=53.615 //y=4.645 //x2=53.4 //y2=4.42
cc_4057 ( CLK N_noxref_14_c_7728_n ) capacitor c=0.00539f //x=54.51 //y=3.88 \
 //x2=53.4 //y2=4.755
cc_4058 ( N_CLK_c_5230_p N_noxref_14_c_7728_n ) capacitor c=0.00880319f \
 //x=54.505 //y=4.835 //x2=53.4 //y2=4.755
cc_4059 ( N_CLK_c_5388_p N_noxref_14_c_7728_n ) capacitor c=8.46751e-19 \
 //x=53.015 //y=4.62 //x2=53.4 //y2=4.755
cc_4060 ( N_CLK_c_5389_p N_noxref_14_c_7728_n ) capacitor c=0.03052f \
 //x=53.615 //y=4.645 //x2=53.4 //y2=4.755
cc_4061 ( N_CLK_c_5229_n N_noxref_14_c_7728_n ) capacitor c=0.00694109f \
 //x=63.635 //y=4.635 //x2=53.4 //y2=4.755
cc_4062 ( N_CLK_c_5232_p N_noxref_14_c_7728_n ) capacitor c=5.64453e-19 \
 //x=54.51 //y=4.88 //x2=53.4 //y2=4.755
cc_4063 ( N_CLK_c_5253_p N_noxref_14_c_7747_n ) capacitor c=0.00232919f \
 //x=63.98 //y=4.635 //x2=63.76 //y2=4.41
cc_4064 ( N_CLK_c_5229_n N_noxref_14_c_7747_n ) capacitor c=0.00261296f \
 //x=63.635 //y=4.635 //x2=63.76 //y2=4.41
cc_4065 ( N_CLK_c_5253_p N_noxref_14_c_7749_n ) capacitor c=0.0265482f \
 //x=63.98 //y=4.635 //x2=63.76 //y2=4.735
cc_4066 ( N_CLK_c_5229_n N_noxref_14_c_7749_n ) capacitor c=3.14882e-19 \
 //x=63.635 //y=4.635 //x2=63.76 //y2=4.735
cc_4067 ( N_CLK_c_5298_p N_noxref_14_c_7751_n ) capacitor c=0.0234494f \
 //x=67.455 //y=4.695 //x2=67.53 //y2=5.335
cc_4068 ( N_CLK_c_5253_p N_noxref_14_c_7751_n ) capacitor c=0.00121614f \
 //x=63.98 //y=4.635 //x2=67.53 //y2=5.335
cc_4069 ( N_CLK_c_5300_p N_noxref_14_c_7751_n ) capacitor c=0.00492634f \
 //x=67.46 //y=4.88 //x2=67.53 //y2=5.335
cc_4070 ( N_CLK_M136_noxref_g N_noxref_14_c_7751_n ) capacitor c=0.00858239f \
 //x=67.43 //y=6.2 //x2=67.53 //y2=5.335
cc_4071 ( N_CLK_c_5301_p N_noxref_14_c_7751_n ) capacitor c=3.77911e-19 \
 //x=67.46 //y=4.88 //x2=67.53 //y2=5.335
cc_4072 ( N_CLK_M137_noxref_g N_noxref_14_c_7756_n ) capacitor c=0.0103546f \
 //x=67.87 //y=6.2 //x2=68.415 //y2=5.335
cc_4073 ( N_CLK_c_5256_p N_noxref_14_c_7757_n ) capacitor c=0.00223259f \
 //x=67.46 //y=4.535 //x2=69.31 //y2=4.095
cc_4074 ( N_CLK_c_5256_p N_noxref_14_c_7758_n ) capacitor c=2.99109e-19 \
 //x=67.46 //y=4.535 //x2=69.31 //y2=5.25
cc_4075 ( CLK N_noxref_14_c_7729_n ) capacitor c=4.22577e-19 //x=54.51 \
 //y=3.88 //x2=53.4 //y2=4.25
cc_4076 ( N_CLK_c_5253_p N_noxref_14_c_7760_n ) capacitor c=0.0278748f \
 //x=63.98 //y=4.635 //x2=66.772 //y2=5.335
cc_4077 ( N_CLK_c_5298_p N_noxref_14_c_7761_n ) capacitor c=0.00463905f \
 //x=67.455 //y=4.695 //x2=67.65 //y2=5.335
cc_4078 ( N_CLK_c_5253_p N_noxref_14_c_7761_n ) capacitor c=9.74982e-19 \
 //x=63.98 //y=4.635 //x2=67.65 //y2=5.335
cc_4079 ( N_CLK_c_5300_p N_noxref_14_c_7761_n ) capacitor c=0.00132214f \
 //x=67.46 //y=4.88 //x2=67.65 //y2=5.335
cc_4080 ( N_CLK_M136_noxref_g N_noxref_14_c_7761_n ) capacitor c=0.00229818f \
 //x=67.43 //y=6.2 //x2=67.65 //y2=5.335
cc_4081 ( N_CLK_M137_noxref_g N_noxref_14_c_7761_n ) capacitor c=0.00230699f \
 //x=67.87 //y=6.2 //x2=67.65 //y2=5.335
cc_4082 ( N_CLK_c_5380_p N_noxref_14_c_7761_n ) capacitor c=0.0017286f \
 //x=67.795 //y=4.97 //x2=67.65 //y2=5.335
cc_4083 ( CLK N_noxref_14_c_7767_n ) capacitor c=0.0255768f //x=54.51 //y=3.88 \
 //x2=55.975 //y2=4.25
cc_4084 ( N_CLK_c_5230_p N_noxref_14_c_7767_n ) capacitor c=4.73489e-19 \
 //x=54.505 //y=4.835 //x2=55.975 //y2=4.25
cc_4085 ( N_CLK_c_5389_p N_noxref_14_c_7767_n ) capacitor c=0.0108554f \
 //x=53.615 //y=4.645 //x2=55.975 //y2=4.25
cc_4086 ( N_CLK_c_5229_n N_noxref_14_c_7767_n ) capacitor c=0.279277f \
 //x=63.635 //y=4.635 //x2=55.975 //y2=4.25
cc_4087 ( N_CLK_c_5229_n N_noxref_14_c_7771_n ) capacitor c=0.113902f \
 //x=63.635 //y=4.635 //x2=56.615 //y2=4.27
cc_4088 ( N_CLK_c_5229_n N_noxref_14_c_7772_n ) capacitor c=0.0602971f \
 //x=63.635 //y=4.635 //x2=57.83 //y2=4.25
cc_4089 ( N_CLK_c_5256_p N_noxref_14_c_7773_n ) capacitor c=0.023508f \
 //x=67.46 //y=4.535 //x2=69.155 //y2=4.25
cc_4090 ( N_CLK_c_5298_p N_noxref_14_c_7773_n ) capacitor c=0.00375947f \
 //x=67.455 //y=4.695 //x2=69.155 //y2=4.25
cc_4091 ( N_CLK_c_5253_p N_noxref_14_c_7773_n ) capacitor c=0.33879f //x=63.98 \
 //y=4.635 //x2=69.155 //y2=4.25
cc_4092 ( N_CLK_c_5229_n N_noxref_14_c_7732_n ) capacitor c=0.496365f \
 //x=63.635 //y=4.635 //x2=63.925 //y2=4.25
cc_4093 ( CLK N_noxref_14_c_7730_n ) capacitor c=0.00242466f //x=54.51 \
 //y=3.88 //x2=53.56 //y2=4.26
cc_4094 ( N_CLK_c_5388_p N_noxref_14_c_7730_n ) capacitor c=0.0364798f \
 //x=53.015 //y=4.62 //x2=53.56 //y2=4.26
cc_4095 ( CLK N_noxref_14_c_7779_n ) capacitor c=3.9149e-19 //x=54.51 //y=3.88 \
 //x2=53.4 //y2=2.26
cc_4096 ( N_CLK_c_5307_p N_noxref_14_c_7779_n ) capacitor c=5.40058e-19 \
 //x=54.51 //y=2.375 //x2=53.4 //y2=2.26
cc_4097 ( N_CLK_c_5308_p N_noxref_14_c_7779_n ) capacitor c=0.00125213f \
 //x=54.51 //y=2.26 //x2=53.4 //y2=2.26
cc_4098 ( N_CLK_c_5309_p N_noxref_14_c_7779_n ) capacitor c=0.0020754f \
 //x=54.6 //y=2.095 //x2=53.4 //y2=2.26
cc_4099 ( N_CLK_c_5230_p N_noxref_14_c_7783_n ) capacitor c=6.32742e-19 \
 //x=54.505 //y=4.835 //x2=53.4 //y2=4.88
cc_4100 ( N_CLK_c_5232_p N_noxref_14_c_7783_n ) capacitor c=0.00113666f \
 //x=54.51 //y=4.88 //x2=53.4 //y2=4.88
cc_4101 ( N_CLK_c_5234_p N_noxref_14_c_7783_n ) capacitor c=0.00123917f \
 //x=54.51 //y=4.88 //x2=53.4 //y2=4.88
cc_4102 ( N_CLK_c_5298_p N_noxref_14_c_7786_n ) capacitor c=0.00169377f \
 //x=67.455 //y=4.695 //x2=67.65 //y2=5.56
cc_4103 ( N_CLK_M136_noxref_g N_noxref_14_c_7786_n ) capacitor c=0.0179041f \
 //x=67.43 //y=6.2 //x2=67.65 //y2=5.56
cc_4104 ( N_CLK_M137_noxref_g N_noxref_14_c_7786_n ) capacitor c=0.0179041f \
 //x=67.87 //y=6.2 //x2=67.65 //y2=5.56
cc_4105 ( N_CLK_c_5380_p N_noxref_14_c_7786_n ) capacitor c=0.00293647f \
 //x=67.795 //y=4.97 //x2=67.65 //y2=5.56
cc_4106 ( N_CLK_M120_noxref_g N_noxref_14_M118_noxref_g ) capacitor \
 c=0.0106276f //x=54.48 //y=6.2 //x2=53.6 //y2=6.2
cc_4107 ( N_CLK_M120_noxref_g N_noxref_14_M119_noxref_g ) capacitor \
 c=0.107144f //x=54.48 //y=6.2 //x2=54.04 //y2=6.2
cc_4108 ( N_CLK_M121_noxref_g N_noxref_14_M119_noxref_g ) capacitor \
 c=0.0101598f //x=54.92 //y=6.2 //x2=54.04 //y2=6.2
cc_4109 ( N_CLK_c_5442_p N_noxref_14_c_7793_n ) capacitor c=5.72528e-19 \
 //x=54.075 //y=1.09 //x2=53.1 //y2=1.055
cc_4110 ( N_CLK_c_5442_p N_noxref_14_c_7794_n ) capacitor c=0.00150277f \
 //x=54.075 //y=1.09 //x2=53.1 //y2=1.4
cc_4111 ( N_CLK_c_5444_p N_noxref_14_c_7795_n ) capacitor c=0.00111227f \
 //x=54.075 //y=1.4 //x2=53.1 //y2=1.71
cc_4112 ( N_CLK_c_5307_p N_noxref_14_c_7796_n ) capacitor c=0.00142893f \
 //x=54.51 //y=2.375 //x2=53.1 //y2=2.095
cc_4113 ( N_CLK_c_5308_p N_noxref_14_c_7796_n ) capacitor c=0.00214573f \
 //x=54.51 //y=2.26 //x2=53.1 //y2=2.095
cc_4114 ( N_CLK_c_5309_p N_noxref_14_c_7796_n ) capacitor c=0.00964411f \
 //x=54.6 //y=2.095 //x2=53.1 //y2=2.095
cc_4115 ( N_CLK_c_5442_p N_noxref_14_c_7799_n ) capacitor c=0.0160123f \
 //x=54.075 //y=1.09 //x2=53.63 //y2=1.055
cc_4116 ( N_CLK_c_5449_p N_noxref_14_c_7799_n ) capacitor c=9.19165e-19 \
 //x=54.6 //y=1.09 //x2=53.63 //y2=1.055
cc_4117 ( N_CLK_c_5444_p N_noxref_14_c_7801_n ) capacitor c=0.0124075f \
 //x=54.075 //y=1.4 //x2=53.63 //y2=1.4
cc_4118 ( N_CLK_c_5451_p N_noxref_14_c_7801_n ) capacitor c=0.0010154f \
 //x=54.6 //y=1.4 //x2=53.63 //y2=1.4
cc_4119 ( N_CLK_c_5452_p N_noxref_14_c_7801_n ) capacitor c=9.23422e-19 \
 //x=54.6 //y=1.63 //x2=53.63 //y2=1.4
cc_4120 ( N_CLK_c_5230_p N_noxref_14_c_7804_n ) capacitor c=7.15803e-19 \
 //x=54.505 //y=4.835 //x2=53.965 //y2=4.97
cc_4121 ( N_CLK_c_5232_p N_noxref_14_c_7804_n ) capacitor c=0.00116563f \
 //x=54.51 //y=4.88 //x2=53.965 //y2=4.97
cc_4122 ( N_CLK_c_5234_p N_noxref_14_c_7804_n ) capacitor c=0.0169508f \
 //x=54.51 //y=4.88 //x2=53.965 //y2=4.97
cc_4123 ( N_CLK_c_5230_p N_noxref_14_c_7807_n ) capacitor c=8.67242e-19 \
 //x=54.505 //y=4.835 //x2=53.675 //y2=4.97
cc_4124 ( N_CLK_c_5389_p N_noxref_14_c_7807_n ) capacitor c=0.00105879f \
 //x=53.615 //y=4.645 //x2=53.675 //y2=4.97
cc_4125 ( N_CLK_c_5232_p N_noxref_14_c_7807_n ) capacitor c=0.0012974f \
 //x=54.51 //y=4.88 //x2=53.675 //y2=4.97
cc_4126 ( N_CLK_c_5234_p N_noxref_14_c_7807_n ) capacitor c=0.00406071f \
 //x=54.51 //y=4.88 //x2=53.675 //y2=4.97
cc_4127 ( N_CLK_c_5253_p N_noxref_14_c_7811_n ) capacitor c=7.56668e-19 \
 //x=63.98 //y=4.635 //x2=63.79 //y2=4.88
cc_4128 ( N_CLK_c_5105_n N_noxref_15_c_8553_n ) capacitor c=0.029081f \
 //x=50.415 //y=4.62 //x2=47.48 //y2=4.75
cc_4129 ( N_CLK_c_5105_n N_noxref_15_c_8571_n ) capacitor c=0.00708942f \
 //x=50.415 //y=4.62 //x2=50.955 //y2=5.38
cc_4130 ( N_CLK_c_5388_p N_noxref_15_c_8653_n ) capacitor c=0.00743339f \
 //x=53.015 //y=4.62 //x2=51.465 //y2=5.38
cc_4131 ( CLK N_noxref_15_c_8574_n ) capacitor c=8.54384e-19 //x=54.51 \
 //y=3.88 //x2=51.55 //y2=3.37
cc_4132 ( N_CLK_c_5388_p N_noxref_15_c_8661_n ) capacitor c=0.00303247f \
 //x=53.015 //y=4.62 //x2=51.55 //y2=3.69
cc_4133 ( CLK N_noxref_15_c_8576_n ) capacitor c=0.00114268f //x=54.51 \
 //y=3.88 //x2=51.55 //y2=5.295
cc_4134 ( N_CLK_c_5180_n N_noxref_15_c_8576_n ) capacitor c=5.44767e-19 \
 //x=51.015 //y=4.64 //x2=51.55 //y2=5.295
cc_4135 ( N_CLK_c_5388_p N_noxref_15_c_8576_n ) capacitor c=0.0327406f \
 //x=53.015 //y=4.62 //x2=51.55 //y2=5.295
cc_4136 ( N_CLK_c_5307_p N_noxref_15_c_8738_n ) capacitor c=0.00939109f \
 //x=54.51 //y=2.375 //x2=55.62 //y2=2.375
cc_4137 ( N_CLK_c_5308_p N_noxref_15_c_8738_n ) capacitor c=5.39999e-19 \
 //x=54.51 //y=2.26 //x2=55.62 //y2=2.375
cc_4138 ( N_CLK_c_5309_p N_noxref_15_c_8738_n ) capacitor c=0.00137098f \
 //x=54.6 //y=2.095 //x2=55.62 //y2=2.375
cc_4139 ( CLK N_noxref_15_c_8698_n ) capacitor c=0.0212411f //x=54.51 //y=3.88 \
 //x2=55.62 //y2=3.35
cc_4140 ( N_CLK_c_5308_p N_noxref_15_c_8698_n ) capacitor c=3.9149e-19 \
 //x=54.51 //y=2.26 //x2=55.62 //y2=3.35
cc_4141 ( CLK N_noxref_15_c_8743_n ) capacitor c=0.00671686f //x=54.51 \
 //y=3.88 //x2=55.62 //y2=3.67
cc_4142 ( CLK N_noxref_15_c_8744_n ) capacitor c=0.0245158f //x=54.51 //y=3.88 \
 //x2=55.62 //y2=4.75
cc_4143 ( N_CLK_c_5230_p N_noxref_15_c_8744_n ) capacitor c=0.0082089f \
 //x=54.505 //y=4.835 //x2=55.62 //y2=4.75
cc_4144 ( N_CLK_c_5229_n N_noxref_15_c_8744_n ) capacitor c=0.0356159f \
 //x=63.635 //y=4.635 //x2=55.62 //y2=4.75
cc_4145 ( N_CLK_c_5232_p N_noxref_15_c_8744_n ) capacitor c=4.56604e-19 \
 //x=54.51 //y=4.88 //x2=55.62 //y2=4.75
cc_4146 ( N_CLK_c_5229_n N_noxref_15_c_8748_n ) capacitor c=0.0221996f \
 //x=63.635 //y=4.635 //x2=61.085 //y2=5.335
cc_4147 ( N_CLK_c_5229_n N_noxref_15_c_8708_n ) capacitor c=0.0300479f \
 //x=63.635 //y=4.635 //x2=61.17 //y2=5.25
cc_4148 ( N_CLK_c_5229_n N_noxref_15_c_8750_n ) capacitor c=0.00653719f \
 //x=63.635 //y=4.635 //x2=63.905 //y2=5.38
cc_4149 ( N_CLK_c_5256_p N_noxref_15_c_8751_n ) capacitor c=0.00128896f \
 //x=67.46 //y=4.535 //x2=64.5 //y2=3.355
cc_4150 ( N_CLK_c_5256_p N_noxref_15_c_8752_n ) capacitor c=7.56903e-19 \
 //x=67.46 //y=4.535 //x2=64.5 //y2=5.295
cc_4151 ( N_CLK_c_5253_p N_noxref_15_c_8752_n ) capacitor c=0.0290879f \
 //x=63.98 //y=4.635 //x2=64.5 //y2=5.295
cc_4152 ( N_CLK_c_5293_p N_noxref_15_c_8754_n ) capacitor c=0.00894339f \
 //x=67.46 //y=2.375 //x2=66.35 //y2=2.375
cc_4153 ( N_CLK_c_5295_p N_noxref_15_c_8754_n ) capacitor c=5.39999e-19 \
 //x=67.46 //y=2.26 //x2=66.35 //y2=2.375
cc_4154 ( N_CLK_c_5296_p N_noxref_15_c_8754_n ) capacitor c=0.00136403f \
 //x=67.55 //y=2.095 //x2=66.35 //y2=2.375
cc_4155 ( N_CLK_c_5256_p N_noxref_15_c_8757_n ) capacitor c=0.0250779f \
 //x=67.46 //y=4.535 //x2=66.35 //y2=3.355
cc_4156 ( N_CLK_c_5295_p N_noxref_15_c_8757_n ) capacitor c=3.9149e-19 \
 //x=67.46 //y=2.26 //x2=66.35 //y2=3.355
cc_4157 ( N_CLK_c_5256_p N_noxref_15_c_8759_n ) capacitor c=0.00678168f \
 //x=67.46 //y=4.535 //x2=66.35 //y2=3.675
cc_4158 ( N_CLK_c_5256_p N_noxref_15_c_8760_n ) capacitor c=0.0204064f \
 //x=67.46 //y=4.535 //x2=66.35 //y2=4.755
cc_4159 ( N_CLK_c_5298_p N_noxref_15_c_8760_n ) capacitor c=0.0128897f \
 //x=67.455 //y=4.695 //x2=66.35 //y2=4.755
cc_4160 ( N_CLK_c_5253_p N_noxref_15_c_8760_n ) capacitor c=0.0355055f \
 //x=63.98 //y=4.635 //x2=66.35 //y2=4.755
cc_4161 ( N_CLK_c_5300_p N_noxref_15_c_8760_n ) capacitor c=5.64453e-19 \
 //x=67.46 //y=4.88 //x2=66.35 //y2=4.755
cc_4162 ( N_CLK_c_5301_p N_noxref_15_c_8760_n ) capacitor c=5.7788e-19 \
 //x=67.46 //y=4.88 //x2=66.35 //y2=4.755
cc_4163 ( N_CLK_c_5105_n N_noxref_15_c_8579_n ) capacitor c=0.0149441f \
 //x=50.415 //y=4.62 //x2=50.19 //y2=5.56
cc_4164 ( N_CLK_c_5180_n N_noxref_15_c_8670_n ) capacitor c=0.0134553f \
 //x=51.015 //y=4.64 //x2=51.07 //y2=5.38
cc_4165 ( CLK N_noxref_15_c_8767_n ) capacitor c=2.90818e-19 //x=54.51 \
 //y=3.88 //x2=55.62 //y2=3.51
cc_4166 ( N_CLK_c_5229_n N_noxref_15_c_8768_n ) capacitor c=0.0297316f \
 //x=63.635 //y=4.635 //x2=58.632 //y2=5.335
cc_4167 ( N_CLK_c_5229_n N_noxref_15_c_8709_n ) capacitor c=0.0398856f \
 //x=63.635 //y=4.635 //x2=59.51 //y2=5.335
cc_4168 ( N_CLK_c_5229_n N_noxref_15_c_8770_n ) capacitor c=0.00404699f \
 //x=63.635 //y=4.635 //x2=63.02 //y2=4.88
cc_4169 ( N_CLK_c_5229_n N_noxref_15_c_8771_n ) capacitor c=0.0269932f \
 //x=63.635 //y=4.635 //x2=63.022 //y2=4.74
cc_4170 ( N_CLK_c_5229_n N_noxref_15_c_8772_n ) capacitor c=0.0154694f \
 //x=63.635 //y=4.635 //x2=63.14 //y2=5.56
cc_4171 ( N_CLK_c_5253_p N_noxref_15_c_8773_n ) capacitor c=0.0215488f \
 //x=63.98 //y=4.635 //x2=64.02 //y2=5.38
cc_4172 ( N_CLK_c_5256_p N_noxref_15_c_8774_n ) capacitor c=2.98349e-19 \
 //x=67.46 //y=4.535 //x2=66.35 //y2=3.51
cc_4173 ( N_CLK_c_5105_n N_noxref_15_c_8588_n ) capacitor c=0.002081f \
 //x=50.415 //y=4.62 //x2=47.835 //y2=3.51
cc_4174 ( N_CLK_c_5105_n N_noxref_15_c_8596_n ) capacitor c=6.85546e-19 \
 //x=50.415 //y=4.62 //x2=50.27 //y2=3.48
cc_4175 ( CLK N_noxref_15_c_8718_n ) capacitor c=0.0259588f //x=54.51 //y=3.88 \
 //x2=55.46 //y2=3.51
cc_4176 ( N_CLK_c_5388_p N_noxref_15_c_8718_n ) capacitor c=0.0543932f \
 //x=53.015 //y=4.62 //x2=55.46 //y2=3.51
cc_4177 ( N_CLK_c_5229_n N_noxref_15_c_8718_n ) capacitor c=0.00818932f \
 //x=63.635 //y=4.635 //x2=55.46 //y2=3.51
cc_4178 ( N_CLK_c_5105_n N_noxref_15_c_8599_n ) capacitor c=0.00727036f \
 //x=50.415 //y=4.62 //x2=51.71 //y2=3.51
cc_4179 ( N_CLK_c_5180_n N_noxref_15_c_8599_n ) capacitor c=0.00944864f \
 //x=51.015 //y=4.64 //x2=51.71 //y2=3.51
cc_4180 ( N_CLK_c_5388_p N_noxref_15_c_8599_n ) capacitor c=0.00838355f \
 //x=53.015 //y=4.62 //x2=51.71 //y2=3.51
cc_4181 ( CLK N_noxref_15_c_8721_n ) capacitor c=0.00242466f //x=54.51 \
 //y=3.88 //x2=56.15 //y2=3.5
cc_4182 ( N_CLK_c_5229_n N_noxref_15_c_8721_n ) capacitor c=0.00213285f \
 //x=63.635 //y=4.635 //x2=56.15 //y2=3.5
cc_4183 ( N_CLK_c_5256_p N_noxref_15_c_8785_n ) capacitor c=0.0257153f \
 //x=67.46 //y=4.535 //x2=70.935 //y2=3.495
cc_4184 ( CLK N_noxref_15_c_8786_n ) capacitor c=3.9149e-19 //x=54.51 //y=3.88 \
 //x2=55.62 //y2=2.26
cc_4185 ( N_CLK_c_5307_p N_noxref_15_c_8786_n ) capacitor c=5.42289e-19 \
 //x=54.51 //y=2.375 //x2=55.62 //y2=2.26
cc_4186 ( N_CLK_c_5308_p N_noxref_15_c_8786_n ) capacitor c=0.00125213f \
 //x=54.51 //y=2.26 //x2=55.62 //y2=2.26
cc_4187 ( N_CLK_c_5309_p N_noxref_15_c_8786_n ) capacitor c=0.00209664f \
 //x=54.6 //y=2.095 //x2=55.62 //y2=2.26
cc_4188 ( N_CLK_c_5230_p N_noxref_15_c_8790_n ) capacitor c=7.52809e-19 \
 //x=54.505 //y=4.835 //x2=55.62 //y2=4.88
cc_4189 ( N_CLK_c_5232_p N_noxref_15_c_8790_n ) capacitor c=0.00113671f \
 //x=54.51 //y=4.88 //x2=55.62 //y2=4.88
cc_4190 ( N_CLK_c_5234_p N_noxref_15_c_8790_n ) capacitor c=9.77556e-19 \
 //x=54.51 //y=4.88 //x2=55.62 //y2=4.88
cc_4191 ( N_CLK_c_5293_p N_noxref_15_c_8793_n ) capacitor c=5.40058e-19 \
 //x=67.46 //y=2.375 //x2=66.35 //y2=2.26
cc_4192 ( N_CLK_c_5256_p N_noxref_15_c_8793_n ) capacitor c=3.9149e-19 \
 //x=67.46 //y=4.535 //x2=66.35 //y2=2.26
cc_4193 ( N_CLK_c_5295_p N_noxref_15_c_8793_n ) capacitor c=0.00125213f \
 //x=67.46 //y=2.26 //x2=66.35 //y2=2.26
cc_4194 ( N_CLK_c_5296_p N_noxref_15_c_8793_n ) capacitor c=0.0020754f \
 //x=67.55 //y=2.095 //x2=66.35 //y2=2.26
cc_4195 ( N_CLK_c_5298_p N_noxref_15_c_8797_n ) capacitor c=8.3916e-19 \
 //x=67.455 //y=4.695 //x2=66.35 //y2=4.88
cc_4196 ( N_CLK_c_5300_p N_noxref_15_c_8797_n ) capacitor c=0.00113666f \
 //x=67.46 //y=4.88 //x2=66.35 //y2=4.88
cc_4197 ( N_CLK_c_5301_p N_noxref_15_c_8797_n ) capacitor c=0.0013104f \
 //x=67.46 //y=4.88 //x2=66.35 //y2=4.88
cc_4198 ( N_CLK_M120_noxref_g N_noxref_15_M122_noxref_g ) capacitor \
 c=0.0101598f //x=54.48 //y=6.2 //x2=55.36 //y2=6.2
cc_4199 ( N_CLK_M121_noxref_g N_noxref_15_M122_noxref_g ) capacitor \
 c=0.0607518f //x=54.92 //y=6.2 //x2=55.36 //y2=6.2
cc_4200 ( N_CLK_M121_noxref_g N_noxref_15_M123_noxref_g ) capacitor \
 c=0.0101598f //x=54.92 //y=6.2 //x2=55.8 //y2=6.2
cc_4201 ( N_CLK_M136_noxref_g N_noxref_15_M134_noxref_g ) capacitor \
 c=0.0106276f //x=67.43 //y=6.2 //x2=66.55 //y2=6.2
cc_4202 ( N_CLK_M136_noxref_g N_noxref_15_M135_noxref_g ) capacitor \
 c=0.107144f //x=67.43 //y=6.2 //x2=66.99 //y2=6.2
cc_4203 ( N_CLK_M137_noxref_g N_noxref_15_M135_noxref_g ) capacitor \
 c=0.0101598f //x=67.87 //y=6.2 //x2=66.99 //y2=6.2
cc_4204 ( N_CLK_c_5449_p N_noxref_15_c_8806_n ) capacitor c=0.00456962f \
 //x=54.6 //y=1.09 //x2=55.61 //y2=1.095
cc_4205 ( N_CLK_c_5451_p N_noxref_15_c_8807_n ) capacitor c=0.00438372f \
 //x=54.6 //y=1.4 //x2=55.61 //y2=1.44
cc_4206 ( N_CLK_c_5452_p N_noxref_15_c_8808_n ) capacitor c=0.00438372f \
 //x=54.6 //y=1.63 //x2=55.61 //y2=1.75
cc_4207 ( N_CLK_c_5540_p N_noxref_15_c_8809_n ) capacitor c=5.72528e-19 \
 //x=67.025 //y=1.09 //x2=66.05 //y2=1.055
cc_4208 ( N_CLK_c_5540_p N_noxref_15_c_8810_n ) capacitor c=0.00150277f \
 //x=67.025 //y=1.09 //x2=66.05 //y2=1.4
cc_4209 ( N_CLK_c_5542_p N_noxref_15_c_8811_n ) capacitor c=0.00111227f \
 //x=67.025 //y=1.4 //x2=66.05 //y2=1.71
cc_4210 ( N_CLK_c_5293_p N_noxref_15_c_8812_n ) capacitor c=0.00142893f \
 //x=67.46 //y=2.375 //x2=66.05 //y2=2.095
cc_4211 ( N_CLK_c_5295_p N_noxref_15_c_8812_n ) capacitor c=0.00214573f \
 //x=67.46 //y=2.26 //x2=66.05 //y2=2.095
cc_4212 ( N_CLK_c_5296_p N_noxref_15_c_8812_n ) capacitor c=0.00964411f \
 //x=67.55 //y=2.095 //x2=66.05 //y2=2.095
cc_4213 ( N_CLK_c_5540_p N_noxref_15_c_8815_n ) capacitor c=0.0160123f \
 //x=67.025 //y=1.09 //x2=66.58 //y2=1.055
cc_4214 ( N_CLK_c_5358_p N_noxref_15_c_8815_n ) capacitor c=9.19165e-19 \
 //x=67.55 //y=1.09 //x2=66.58 //y2=1.055
cc_4215 ( N_CLK_c_5542_p N_noxref_15_c_8817_n ) capacitor c=0.0124075f \
 //x=67.025 //y=1.4 //x2=66.58 //y2=1.4
cc_4216 ( N_CLK_c_5359_p N_noxref_15_c_8817_n ) capacitor c=0.0010154f \
 //x=67.55 //y=1.4 //x2=66.58 //y2=1.4
cc_4217 ( N_CLK_c_5360_p N_noxref_15_c_8817_n ) capacitor c=9.23422e-19 \
 //x=67.55 //y=1.63 //x2=66.58 //y2=1.4
cc_4218 ( N_CLK_c_5298_p N_noxref_15_c_8820_n ) capacitor c=7.66769e-19 \
 //x=67.455 //y=4.695 //x2=66.915 //y2=4.97
cc_4219 ( N_CLK_c_5300_p N_noxref_15_c_8820_n ) capacitor c=0.00116563f \
 //x=67.46 //y=4.88 //x2=66.915 //y2=4.97
cc_4220 ( N_CLK_c_5301_p N_noxref_15_c_8820_n ) capacitor c=0.0171374f \
 //x=67.46 //y=4.88 //x2=66.915 //y2=4.97
cc_4221 ( N_CLK_c_5298_p N_noxref_15_c_8823_n ) capacitor c=9.07197e-19 \
 //x=67.455 //y=4.695 //x2=66.625 //y2=4.97
cc_4222 ( N_CLK_c_5300_p N_noxref_15_c_8823_n ) capacitor c=0.0012974f \
 //x=67.46 //y=4.88 //x2=66.625 //y2=4.97
cc_4223 ( N_CLK_c_5301_p N_noxref_15_c_8823_n ) capacitor c=0.00419533f \
 //x=67.46 //y=4.88 //x2=66.625 //y2=4.97
cc_4224 ( N_CLK_c_5307_p N_noxref_15_c_8826_n ) capacitor c=0.00134951f \
 //x=54.51 //y=2.375 //x2=55.62 //y2=2.26
cc_4225 ( N_CLK_c_5308_p N_noxref_15_c_8826_n ) capacitor c=0.00204868f \
 //x=54.51 //y=2.26 //x2=55.62 //y2=2.26
cc_4226 ( N_CLK_c_5309_p N_noxref_15_c_8826_n ) capacitor c=0.00933826f \
 //x=54.6 //y=2.095 //x2=55.62 //y2=2.26
cc_4227 ( N_CLK_c_5309_p N_noxref_15_c_8829_n ) capacitor c=0.00438372f \
 //x=54.6 //y=2.095 //x2=55.62 //y2=2.095
cc_4228 ( N_CLK_c_5230_p N_noxref_15_c_8830_n ) capacitor c=0.0013272f \
 //x=54.505 //y=4.835 //x2=55.62 //y2=4.88
cc_4229 ( N_CLK_c_5232_p N_noxref_15_c_8830_n ) capacitor c=0.00186974f \
 //x=54.51 //y=4.88 //x2=55.62 //y2=4.88
cc_4230 ( N_CLK_c_5247_p N_noxref_15_c_8830_n ) capacitor c=0.0616777f \
 //x=54.845 //y=4.97 //x2=55.62 //y2=4.88
cc_4231 ( N_CLK_c_5234_p N_noxref_15_c_8830_n ) capacitor c=0.0042693f \
 //x=54.51 //y=4.88 //x2=55.62 //y2=4.88
cc_4232 ( N_CLK_c_4875_n N_noxref_16_c_9869_n ) capacitor c=0.0293751f \
 //x=24.515 //y=4.62 //x2=21.58 //y2=4.75
cc_4233 ( N_CLK_c_4875_n N_noxref_16_c_9890_n ) capacitor c=0.00708942f \
 //x=24.515 //y=4.62 //x2=25.055 //y2=5.38
cc_4234 ( N_CLK_c_5146_n N_noxref_16_c_9902_n ) capacitor c=0.00765056f \
 //x=27.115 //y=4.62 //x2=25.565 //y2=5.38
cc_4235 ( CLK N_noxref_16_c_9906_n ) capacitor c=7.19182e-19 //x=28.61 \
 //y=3.51 //x2=25.65 //y2=2.995
cc_4236 ( N_CLK_c_5146_n N_noxref_16_c_9913_n ) capacitor c=0.00234923f \
 //x=27.115 //y=4.62 //x2=25.65 //y2=3.315
cc_4237 ( CLK N_noxref_16_c_9914_n ) capacitor c=0.00138054f //x=28.61 \
 //y=3.51 //x2=25.65 //y2=5.295
cc_4238 ( N_CLK_c_4950_n N_noxref_16_c_9914_n ) capacitor c=5.44767e-19 \
 //x=25.115 //y=4.64 //x2=25.65 //y2=5.295
cc_4239 ( N_CLK_c_5146_n N_noxref_16_c_9914_n ) capacitor c=0.033873f \
 //x=27.115 //y=4.62 //x2=25.65 //y2=5.295
cc_4240 ( N_CLK_c_4875_n N_noxref_16_c_9926_n ) capacitor c=0.0146627f \
 //x=24.515 //y=4.62 //x2=24.29 //y2=5.56
cc_4241 ( N_CLK_c_4950_n N_noxref_16_c_9934_n ) capacitor c=0.0136763f \
 //x=25.115 //y=4.64 //x2=25.17 //y2=5.38
cc_4242 ( N_CLK_c_4875_n N_noxref_16_c_9945_n ) capacitor c=0.0153742f \
 //x=24.515 //y=4.62 //x2=25.49 //y2=3.14
cc_4243 ( N_CLK_c_4950_n N_noxref_16_c_9945_n ) capacitor c=0.00718866f \
 //x=25.115 //y=4.64 //x2=25.49 //y2=3.14
cc_4244 ( CLK N_noxref_16_c_9956_n ) capacitor c=0.0282115f //x=28.61 //y=3.51 \
 //x2=29.505 //y2=3.125
cc_4245 ( N_CLK_c_5146_n N_noxref_16_c_9956_n ) capacitor c=0.0470118f \
 //x=27.115 //y=4.62 //x2=29.505 //y2=3.125
cc_4246 ( N_CLK_c_5004_n N_noxref_16_c_9956_n ) capacitor c=0.006872f \
 //x=37.735 //y=4.635 //x2=29.505 //y2=3.125
cc_4247 ( CLK N_noxref_16_c_10036_n ) capacitor c=3.31651e-19 //x=41.56 \
 //y=3.51 //x2=40.67 //y2=3.13
cc_4248 ( CLK N_noxref_16_c_10055_n ) capacitor c=0.026193f //x=41.56 //y=3.51 \
 //x2=55.235 //y2=3.14
cc_4249 ( CLK N_noxref_16_c_10055_n ) capacitor c=0.02403f //x=54.51 //y=3.88 \
 //x2=55.235 //y2=3.14
cc_4250 ( N_CLK_c_5105_n N_noxref_16_c_10055_n ) capacitor c=0.00752641f \
 //x=50.415 //y=4.62 //x2=55.235 //y2=3.14
cc_4251 ( N_CLK_c_5180_n N_noxref_16_c_10055_n ) capacitor c=0.00836117f \
 //x=51.015 //y=4.64 //x2=55.235 //y2=3.14
cc_4252 ( N_CLK_c_5388_p N_noxref_16_c_10055_n ) capacitor c=4.12682e-19 \
 //x=53.015 //y=4.62 //x2=55.235 //y2=3.14
cc_4253 ( N_CLK_c_5256_p N_noxref_16_c_10131_n ) capacitor c=3.31651e-19 \
 //x=67.46 //y=4.535 //x2=66.57 //y2=3.13
cc_4254 ( N_CLK_c_5256_p N_noxref_16_c_10132_n ) capacitor c=0.026178f \
 //x=67.46 //y=4.535 //x2=78.535 //y2=3.14
cc_4255 ( N_CLK_M56_noxref_g N_VDD_c_11590_n ) capacitor c=0.00705252f \
 //x=2.68 //y=6.2 //x2=3.255 //y2=7.585
cc_4256 ( N_CLK_M57_noxref_g N_VDD_c_11590_n ) capacitor c=0.00755544f \
 //x=3.12 //y=6.2 //x2=3.255 //y2=7.585
cc_4257 ( N_CLK_M72_noxref_g N_VDD_c_11677_n ) capacitor c=0.00705252f \
 //x=15.63 //y=6.2 //x2=16.205 //y2=7.585
cc_4258 ( N_CLK_M73_noxref_g N_VDD_c_11677_n ) capacitor c=0.00755544f \
 //x=16.07 //y=6.2 //x2=16.205 //y2=7.585
cc_4259 ( N_CLK_M88_noxref_g N_VDD_c_11907_n ) capacitor c=0.00705252f \
 //x=28.58 //y=6.2 //x2=29.155 //y2=7.585
cc_4260 ( N_CLK_M89_noxref_g N_VDD_c_11907_n ) capacitor c=0.00755544f \
 //x=29.02 //y=6.2 //x2=29.155 //y2=7.585
cc_4261 ( N_CLK_M104_noxref_g N_VDD_c_12031_n ) capacitor c=0.00705252f \
 //x=41.53 //y=6.2 //x2=42.105 //y2=7.585
cc_4262 ( N_CLK_M105_noxref_g N_VDD_c_12031_n ) capacitor c=0.00755544f \
 //x=41.97 //y=6.2 //x2=42.105 //y2=7.585
cc_4263 ( N_CLK_M120_noxref_g N_VDD_c_12117_n ) capacitor c=0.00705252f \
 //x=54.48 //y=6.2 //x2=55.055 //y2=7.585
cc_4264 ( N_CLK_M121_noxref_g N_VDD_c_12117_n ) capacitor c=0.00755544f \
 //x=54.92 //y=6.2 //x2=55.055 //y2=7.585
cc_4265 ( N_CLK_M136_noxref_g N_VDD_c_12119_n ) capacitor c=0.00705252f \
 //x=67.43 //y=6.2 //x2=68.005 //y2=7.585
cc_4266 ( N_CLK_M137_noxref_g N_VDD_c_12119_n ) capacitor c=0.00755544f \
 //x=67.87 //y=6.2 //x2=68.005 //y2=7.585
cc_4267 ( N_CLK_c_4775_n N_VDD_c_11494_n ) capacitor c=0.0263783f //x=11.58 \
 //y=4.62 //x2=5.3 //y2=7.585
cc_4268 ( N_CLK_c_4775_n N_VDD_c_11498_n ) capacitor c=0.0264951f //x=11.58 \
 //y=4.62 //x2=10.11 //y2=7.585
cc_4269 ( N_CLK_c_4822_n N_VDD_c_11545_n ) capacitor c=0.0264803f //x=17.385 \
 //y=4.64 //x2=13.44 //y2=7.585
cc_4270 ( N_CLK_c_4868_n N_VDD_c_11609_n ) capacitor c=5.93375e-19 //x=17.73 \
 //y=4.64 //x2=18.25 //y2=7.585
cc_4271 ( N_CLK_c_4875_n N_VDD_c_11609_n ) capacitor c=0.0265174f //x=24.515 \
 //y=4.62 //x2=18.25 //y2=7.585
cc_4272 ( N_CLK_c_4875_n N_VDD_c_11723_n ) capacitor c=0.026125f //x=24.515 \
 //y=4.62 //x2=23.06 //y2=7.585
cc_4273 ( N_CLK_c_5146_n N_VDD_c_11735_n ) capacitor c=0.0273498f //x=27.115 \
 //y=4.62 //x2=26.39 //y2=7.585
cc_4274 ( N_CLK_c_5004_n N_VDD_c_11813_n ) capacitor c=0.0265603f //x=37.735 \
 //y=4.635 //x2=31.2 //y2=7.585
cc_4275 ( N_CLK_c_5004_n N_VDD_c_11817_n ) capacitor c=0.0264951f //x=37.735 \
 //y=4.635 //x2=36.01 //y2=7.585
cc_4276 ( N_CLK_c_5050_n N_VDD_c_11864_n ) capacitor c=0.0264803f //x=43.285 \
 //y=4.64 //x2=39.34 //y2=7.585
cc_4277 ( N_CLK_c_5098_n N_VDD_c_11928_n ) capacitor c=5.93375e-19 //x=43.63 \
 //y=4.64 //x2=44.15 //y2=7.585
cc_4278 ( N_CLK_c_5105_n N_VDD_c_11928_n ) capacitor c=0.0265174f //x=50.415 \
 //y=4.62 //x2=44.15 //y2=7.585
cc_4279 ( N_CLK_c_5105_n N_VDD_c_11988_n ) capacitor c=0.0264862f //x=50.415 \
 //y=4.62 //x2=48.96 //y2=7.585
cc_4280 ( N_CLK_c_5388_p N_VDD_c_12066_n ) capacitor c=0.0267392f //x=53.015 \
 //y=4.62 //x2=52.29 //y2=7.585
cc_4281 ( N_CLK_c_5229_n N_VDD_c_12135_n ) capacitor c=0.0265603f //x=63.635 \
 //y=4.635 //x2=57.1 //y2=7.585
cc_4282 ( N_CLK_c_5229_n N_VDD_c_12136_n ) capacitor c=0.0264951f //x=63.635 \
 //y=4.635 //x2=61.91 //y2=7.585
cc_4283 ( N_CLK_c_5253_p N_VDD_c_12137_n ) capacitor c=0.026267f //x=63.98 \
 //y=4.635 //x2=65.24 //y2=7.585
cc_4284 ( N_CLK_M56_noxref_g N_VDD_M55_noxref_d ) capacitor c=0.015318f \
 //x=2.68 //y=6.2 //x2=2.315 //y2=5.2
cc_4285 ( N_CLK_M57_noxref_g N_VDD_M57_noxref_d ) capacitor c=0.015318f \
 //x=3.12 //y=6.2 //x2=3.195 //y2=5.2
cc_4286 ( N_CLK_c_4775_n N_VDD_M60_noxref_s ) capacitor c=7.08158e-19 \
 //x=11.58 //y=4.62 //x2=6.255 //y2=5.2
cc_4287 ( N_CLK_c_4775_n N_VDD_M66_noxref_s ) capacitor c=0.00765173f \
 //x=11.58 //y=4.62 //x2=10.765 //y2=5.2
cc_4288 ( N_CLK_c_4822_n N_VDD_M70_noxref_s ) capacitor c=7.80611e-19 \
 //x=17.385 //y=4.64 //x2=14.395 //y2=5.2
cc_4289 ( N_CLK_M72_noxref_g N_VDD_M71_noxref_d ) capacitor c=0.015318f \
 //x=15.63 //y=6.2 //x2=15.265 //y2=5.2
cc_4290 ( N_CLK_M73_noxref_g N_VDD_M73_noxref_d ) capacitor c=0.015318f \
 //x=16.07 //y=6.2 //x2=16.145 //y2=5.2
cc_4291 ( N_CLK_c_4875_n N_VDD_M76_noxref_s ) capacitor c=7.08158e-19 \
 //x=24.515 //y=4.62 //x2=19.205 //y2=5.2
cc_4292 ( N_CLK_c_4875_n N_VDD_M82_noxref_s ) capacitor c=0.00732334f \
 //x=24.515 //y=4.62 //x2=23.715 //y2=5.2
cc_4293 ( N_CLK_c_5146_n N_VDD_M86_noxref_s ) capacitor c=9.11715e-19 \
 //x=27.115 //y=4.62 //x2=27.345 //y2=5.2
cc_4294 ( N_CLK_M88_noxref_g N_VDD_M87_noxref_d ) capacitor c=0.015318f \
 //x=28.58 //y=6.2 //x2=28.215 //y2=5.2
cc_4295 ( N_CLK_M89_noxref_g N_VDD_M89_noxref_d ) capacitor c=0.015318f \
 //x=29.02 //y=6.2 //x2=29.095 //y2=5.2
cc_4296 ( N_CLK_c_5004_n N_VDD_M92_noxref_s ) capacitor c=7.08158e-19 \
 //x=37.735 //y=4.635 //x2=32.155 //y2=5.2
cc_4297 ( N_CLK_c_5004_n N_VDD_M98_noxref_s ) capacitor c=0.00765173f \
 //x=37.735 //y=4.635 //x2=36.665 //y2=5.2
cc_4298 ( N_CLK_c_5050_n N_VDD_M102_noxref_s ) capacitor c=7.80611e-19 \
 //x=43.285 //y=4.64 //x2=40.295 //y2=5.2
cc_4299 ( N_CLK_M104_noxref_g N_VDD_M103_noxref_d ) capacitor c=0.015318f \
 //x=41.53 //y=6.2 //x2=41.165 //y2=5.2
cc_4300 ( N_CLK_M105_noxref_g N_VDD_M105_noxref_d ) capacitor c=0.015318f \
 //x=41.97 //y=6.2 //x2=42.045 //y2=5.2
cc_4301 ( N_CLK_c_5105_n N_VDD_M108_noxref_s ) capacitor c=7.08158e-19 \
 //x=50.415 //y=4.62 //x2=45.105 //y2=5.2
cc_4302 ( N_CLK_c_5105_n N_VDD_M114_noxref_s ) capacitor c=0.00752472f \
 //x=50.415 //y=4.62 //x2=49.615 //y2=5.2
cc_4303 ( N_CLK_c_5388_p N_VDD_M118_noxref_s ) capacitor c=9.11715e-19 \
 //x=53.015 //y=4.62 //x2=53.245 //y2=5.2
cc_4304 ( N_CLK_M120_noxref_g N_VDD_M119_noxref_d ) capacitor c=0.015318f \
 //x=54.48 //y=6.2 //x2=54.115 //y2=5.2
cc_4305 ( N_CLK_M121_noxref_g N_VDD_M121_noxref_d ) capacitor c=0.015318f \
 //x=54.92 //y=6.2 //x2=54.995 //y2=5.2
cc_4306 ( N_CLK_c_5229_n N_VDD_M124_noxref_s ) capacitor c=7.08158e-19 \
 //x=63.635 //y=4.635 //x2=58.055 //y2=5.2
cc_4307 ( N_CLK_c_5229_n N_VDD_M130_noxref_s ) capacitor c=0.00765173f \
 //x=63.635 //y=4.635 //x2=62.565 //y2=5.2
cc_4308 ( N_CLK_c_5253_p N_VDD_M134_noxref_s ) capacitor c=7.80611e-19 \
 //x=63.98 //y=4.635 //x2=66.195 //y2=5.2
cc_4309 ( N_CLK_M136_noxref_g N_VDD_M135_noxref_d ) capacitor c=0.015318f \
 //x=67.43 //y=6.2 //x2=67.065 //y2=5.2
cc_4310 ( N_CLK_M137_noxref_g N_VDD_M137_noxref_d ) capacitor c=0.015318f \
 //x=67.87 //y=6.2 //x2=67.945 //y2=5.2
cc_4311 ( N_CLK_c_4794_n N_noxref_20_c_12882_n ) capacitor c=0.00123426f \
 //x=2.8 //y=1.09 //x2=3.505 //y2=1.175
cc_4312 ( N_CLK_c_4795_n N_noxref_20_c_12882_n ) capacitor c=0.0129288f \
 //x=2.8 //y=1.4 //x2=3.505 //y2=1.175
cc_4313 ( N_CLK_c_4796_n N_noxref_20_c_12882_n ) capacitor c=0.00132209f \
 //x=2.8 //y=1.63 //x2=3.505 //y2=1.175
cc_4314 ( N_CLK_c_4769_n N_noxref_20_M1_noxref_d ) capacitor c=0.00610652f \
 //x=2.71 //y=2.375 //x2=2.35 //y2=1.09
cc_4315 ( N_CLK_c_4784_n N_noxref_20_M1_noxref_d ) capacitor c=2.2052e-19 \
 //x=2.71 //y=2.26 //x2=2.35 //y2=1.09
cc_4316 ( N_CLK_c_4974_n N_noxref_20_M1_noxref_d ) capacitor c=0.00253592f \
 //x=2.275 //y=1.09 //x2=2.35 //y2=1.09
cc_4317 ( N_CLK_c_4977_n N_noxref_20_M1_noxref_d ) capacitor c=0.00604634f \
 //x=2.275 //y=1.4 //x2=2.35 //y2=1.09
cc_4318 ( N_CLK_c_5651_p N_noxref_20_M1_noxref_d ) capacitor c=0.002686f \
 //x=2.645 //y=0.935 //x2=2.35 //y2=1.09
cc_4319 ( N_CLK_c_5652_p N_noxref_20_M1_noxref_d ) capacitor c=0.00251995f \
 //x=2.645 //y=1.555 //x2=2.35 //y2=1.09
cc_4320 ( N_CLK_c_4794_n N_noxref_20_M1_noxref_d ) capacitor c=0.00314523f \
 //x=2.8 //y=1.09 //x2=2.35 //y2=1.09
cc_4321 ( N_CLK_c_4795_n N_noxref_20_M1_noxref_d ) capacitor c=0.00168289f \
 //x=2.8 //y=1.4 //x2=2.35 //y2=1.09
cc_4322 ( N_CLK_c_4796_n N_noxref_20_M1_noxref_d ) capacitor c=0.00111165f \
 //x=2.8 //y=1.63 //x2=2.35 //y2=1.09
cc_4323 ( N_CLK_c_4794_n N_noxref_20_M2_noxref_s ) capacitor c=7.21316e-19 \
 //x=2.8 //y=1.09 //x2=3.455 //y2=0.555
cc_4324 ( N_CLK_c_4795_n N_noxref_20_M2_noxref_s ) capacitor c=0.00365271f \
 //x=2.8 //y=1.4 //x2=3.455 //y2=0.555
cc_4325 ( N_CLK_c_4797_n N_noxref_20_M2_noxref_s ) capacitor c=9.86711e-19 \
 //x=2.8 //y=2.095 //x2=3.455 //y2=0.555
cc_4326 ( N_CLK_c_4841_n N_noxref_22_c_13004_n ) capacitor c=0.00123426f \
 //x=15.75 //y=1.09 //x2=16.455 //y2=1.175
cc_4327 ( N_CLK_c_4842_n N_noxref_22_c_13004_n ) capacitor c=0.0129288f \
 //x=15.75 //y=1.4 //x2=16.455 //y2=1.175
cc_4328 ( N_CLK_c_4843_n N_noxref_22_c_13004_n ) capacitor c=0.00132209f \
 //x=15.75 //y=1.63 //x2=16.455 //y2=1.175
cc_4329 ( N_CLK_c_4812_n N_noxref_22_M9_noxref_d ) capacitor c=0.00600656f \
 //x=15.66 //y=2.375 //x2=15.3 //y2=1.09
cc_4330 ( N_CLK_c_4825_n N_noxref_22_M9_noxref_d ) capacitor c=2.2052e-19 \
 //x=15.66 //y=2.26 //x2=15.3 //y2=1.09
cc_4331 ( N_CLK_c_4836_n N_noxref_22_M9_noxref_d ) capacitor c=0.00253592f \
 //x=15.225 //y=1.09 //x2=15.3 //y2=1.09
cc_4332 ( N_CLK_c_4839_n N_noxref_22_M9_noxref_d ) capacitor c=0.00604066f \
 //x=15.225 //y=1.4 //x2=15.3 //y2=1.09
cc_4333 ( N_CLK_c_5666_p N_noxref_22_M9_noxref_d ) capacitor c=0.002686f \
 //x=15.595 //y=0.935 //x2=15.3 //y2=1.09
cc_4334 ( N_CLK_c_5667_p N_noxref_22_M9_noxref_d ) capacitor c=0.00251995f \
 //x=15.595 //y=1.555 //x2=15.3 //y2=1.09
cc_4335 ( N_CLK_c_4841_n N_noxref_22_M9_noxref_d ) capacitor c=0.00314523f \
 //x=15.75 //y=1.09 //x2=15.3 //y2=1.09
cc_4336 ( N_CLK_c_4842_n N_noxref_22_M9_noxref_d ) capacitor c=0.00168289f \
 //x=15.75 //y=1.4 //x2=15.3 //y2=1.09
cc_4337 ( N_CLK_c_4843_n N_noxref_22_M9_noxref_d ) capacitor c=0.00111165f \
 //x=15.75 //y=1.63 //x2=15.3 //y2=1.09
cc_4338 ( N_CLK_c_4841_n N_noxref_22_M10_noxref_s ) capacitor c=7.21316e-19 \
 //x=15.75 //y=1.09 //x2=16.405 //y2=0.555
cc_4339 ( N_CLK_c_4842_n N_noxref_22_M10_noxref_s ) capacitor c=0.00365271f \
 //x=15.75 //y=1.4 //x2=16.405 //y2=0.555
cc_4340 ( N_CLK_c_4844_n N_noxref_22_M10_noxref_s ) capacitor c=9.86711e-19 \
 //x=15.75 //y=2.095 //x2=16.405 //y2=0.555
cc_4341 ( N_CLK_c_5022_n N_noxref_24_c_13149_n ) capacitor c=0.00123426f \
 //x=28.7 //y=1.09 //x2=29.405 //y2=1.175
cc_4342 ( N_CLK_c_5023_n N_noxref_24_c_13149_n ) capacitor c=0.0129288f \
 //x=28.7 //y=1.4 //x2=29.405 //y2=1.175
cc_4343 ( N_CLK_c_5024_n N_noxref_24_c_13149_n ) capacitor c=0.00132209f \
 //x=28.7 //y=1.63 //x2=29.405 //y2=1.175
cc_4344 ( N_CLK_c_4998_n N_noxref_24_M17_noxref_d ) capacitor c=0.00600656f \
 //x=28.61 //y=2.375 //x2=28.25 //y2=1.09
cc_4345 ( N_CLK_c_5012_n N_noxref_24_M17_noxref_d ) capacitor c=2.2052e-19 \
 //x=28.61 //y=2.26 //x2=28.25 //y2=1.09
cc_4346 ( N_CLK_c_5202_n N_noxref_24_M17_noxref_d ) capacitor c=0.00253592f \
 //x=28.175 //y=1.09 //x2=28.25 //y2=1.09
cc_4347 ( N_CLK_c_5205_n N_noxref_24_M17_noxref_d ) capacitor c=0.00604066f \
 //x=28.175 //y=1.4 //x2=28.25 //y2=1.09
cc_4348 ( N_CLK_c_5681_p N_noxref_24_M17_noxref_d ) capacitor c=0.002686f \
 //x=28.545 //y=0.935 //x2=28.25 //y2=1.09
cc_4349 ( N_CLK_c_5682_p N_noxref_24_M17_noxref_d ) capacitor c=0.00251995f \
 //x=28.545 //y=1.555 //x2=28.25 //y2=1.09
cc_4350 ( N_CLK_c_5022_n N_noxref_24_M17_noxref_d ) capacitor c=0.00314523f \
 //x=28.7 //y=1.09 //x2=28.25 //y2=1.09
cc_4351 ( N_CLK_c_5023_n N_noxref_24_M17_noxref_d ) capacitor c=0.00168289f \
 //x=28.7 //y=1.4 //x2=28.25 //y2=1.09
cc_4352 ( N_CLK_c_5024_n N_noxref_24_M17_noxref_d ) capacitor c=0.00111165f \
 //x=28.7 //y=1.63 //x2=28.25 //y2=1.09
cc_4353 ( N_CLK_c_5022_n N_noxref_24_M18_noxref_s ) capacitor c=7.21316e-19 \
 //x=28.7 //y=1.09 //x2=29.355 //y2=0.555
cc_4354 ( N_CLK_c_5023_n N_noxref_24_M18_noxref_s ) capacitor c=0.00365271f \
 //x=28.7 //y=1.4 //x2=29.355 //y2=0.555
cc_4355 ( N_CLK_c_5025_n N_noxref_24_M18_noxref_s ) capacitor c=9.86711e-19 \
 //x=28.7 //y=2.095 //x2=29.355 //y2=0.555
cc_4356 ( N_CLK_c_5069_n N_noxref_26_c_13275_n ) capacitor c=0.00123426f \
 //x=41.65 //y=1.09 //x2=42.355 //y2=1.175
cc_4357 ( N_CLK_c_5070_n N_noxref_26_c_13275_n ) capacitor c=0.0129288f \
 //x=41.65 //y=1.4 //x2=42.355 //y2=1.175
cc_4358 ( N_CLK_c_5071_n N_noxref_26_c_13275_n ) capacitor c=0.00132209f \
 //x=41.65 //y=1.63 //x2=42.355 //y2=1.175
cc_4359 ( N_CLK_c_5040_n N_noxref_26_M25_noxref_d ) capacitor c=0.00600656f \
 //x=41.56 //y=2.375 //x2=41.2 //y2=1.09
cc_4360 ( N_CLK_c_5053_n N_noxref_26_M25_noxref_d ) capacitor c=2.2052e-19 \
 //x=41.56 //y=2.26 //x2=41.2 //y2=1.09
cc_4361 ( N_CLK_c_5064_n N_noxref_26_M25_noxref_d ) capacitor c=0.00253592f \
 //x=41.125 //y=1.09 //x2=41.2 //y2=1.09
cc_4362 ( N_CLK_c_5067_n N_noxref_26_M25_noxref_d ) capacitor c=0.00604066f \
 //x=41.125 //y=1.4 //x2=41.2 //y2=1.09
cc_4363 ( N_CLK_c_5696_p N_noxref_26_M25_noxref_d ) capacitor c=0.002686f \
 //x=41.495 //y=0.935 //x2=41.2 //y2=1.09
cc_4364 ( N_CLK_c_5697_p N_noxref_26_M25_noxref_d ) capacitor c=0.00251995f \
 //x=41.495 //y=1.555 //x2=41.2 //y2=1.09
cc_4365 ( N_CLK_c_5069_n N_noxref_26_M25_noxref_d ) capacitor c=0.00314523f \
 //x=41.65 //y=1.09 //x2=41.2 //y2=1.09
cc_4366 ( N_CLK_c_5070_n N_noxref_26_M25_noxref_d ) capacitor c=0.00168289f \
 //x=41.65 //y=1.4 //x2=41.2 //y2=1.09
cc_4367 ( N_CLK_c_5071_n N_noxref_26_M25_noxref_d ) capacitor c=0.00111165f \
 //x=41.65 //y=1.63 //x2=41.2 //y2=1.09
cc_4368 ( N_CLK_c_5069_n N_noxref_26_M26_noxref_s ) capacitor c=7.21316e-19 \
 //x=41.65 //y=1.09 //x2=42.305 //y2=0.555
cc_4369 ( N_CLK_c_5070_n N_noxref_26_M26_noxref_s ) capacitor c=0.00365271f \
 //x=41.65 //y=1.4 //x2=42.305 //y2=0.555
cc_4370 ( N_CLK_c_5072_n N_noxref_26_M26_noxref_s ) capacitor c=9.86711e-19 \
 //x=41.65 //y=2.095 //x2=42.305 //y2=0.555
cc_4371 ( N_CLK_c_5449_p N_noxref_28_c_13398_n ) capacitor c=0.00123426f \
 //x=54.6 //y=1.09 //x2=55.305 //y2=1.175
cc_4372 ( N_CLK_c_5451_p N_noxref_28_c_13398_n ) capacitor c=0.0129288f \
 //x=54.6 //y=1.4 //x2=55.305 //y2=1.175
cc_4373 ( N_CLK_c_5452_p N_noxref_28_c_13398_n ) capacitor c=0.00132209f \
 //x=54.6 //y=1.63 //x2=55.305 //y2=1.175
cc_4374 ( N_CLK_c_5307_p N_noxref_28_M33_noxref_d ) capacitor c=0.00600656f \
 //x=54.51 //y=2.375 //x2=54.15 //y2=1.09
cc_4375 ( N_CLK_c_5308_p N_noxref_28_M33_noxref_d ) capacitor c=2.2052e-19 \
 //x=54.51 //y=2.26 //x2=54.15 //y2=1.09
cc_4376 ( N_CLK_c_5442_p N_noxref_28_M33_noxref_d ) capacitor c=0.00253592f \
 //x=54.075 //y=1.09 //x2=54.15 //y2=1.09
cc_4377 ( N_CLK_c_5444_p N_noxref_28_M33_noxref_d ) capacitor c=0.00604066f \
 //x=54.075 //y=1.4 //x2=54.15 //y2=1.09
cc_4378 ( N_CLK_c_5711_p N_noxref_28_M33_noxref_d ) capacitor c=0.002686f \
 //x=54.445 //y=0.935 //x2=54.15 //y2=1.09
cc_4379 ( N_CLK_c_5712_p N_noxref_28_M33_noxref_d ) capacitor c=0.00251995f \
 //x=54.445 //y=1.555 //x2=54.15 //y2=1.09
cc_4380 ( N_CLK_c_5449_p N_noxref_28_M33_noxref_d ) capacitor c=0.00314523f \
 //x=54.6 //y=1.09 //x2=54.15 //y2=1.09
cc_4381 ( N_CLK_c_5451_p N_noxref_28_M33_noxref_d ) capacitor c=0.00168289f \
 //x=54.6 //y=1.4 //x2=54.15 //y2=1.09
cc_4382 ( N_CLK_c_5452_p N_noxref_28_M33_noxref_d ) capacitor c=0.00111165f \
 //x=54.6 //y=1.63 //x2=54.15 //y2=1.09
cc_4383 ( N_CLK_c_5449_p N_noxref_28_M34_noxref_s ) capacitor c=7.21316e-19 \
 //x=54.6 //y=1.09 //x2=55.255 //y2=0.555
cc_4384 ( N_CLK_c_5451_p N_noxref_28_M34_noxref_s ) capacitor c=0.00365271f \
 //x=54.6 //y=1.4 //x2=55.255 //y2=0.555
cc_4385 ( N_CLK_c_5309_p N_noxref_28_M34_noxref_s ) capacitor c=9.86711e-19 \
 //x=54.6 //y=2.095 //x2=55.255 //y2=0.555
cc_4386 ( N_CLK_c_5358_p N_noxref_30_c_13533_n ) capacitor c=0.00123426f \
 //x=67.55 //y=1.09 //x2=68.255 //y2=1.175
cc_4387 ( N_CLK_c_5359_p N_noxref_30_c_13533_n ) capacitor c=0.0129288f \
 //x=67.55 //y=1.4 //x2=68.255 //y2=1.175
cc_4388 ( N_CLK_c_5360_p N_noxref_30_c_13533_n ) capacitor c=0.00132209f \
 //x=67.55 //y=1.63 //x2=68.255 //y2=1.175
cc_4389 ( N_CLK_c_5293_p N_noxref_30_M41_noxref_d ) capacitor c=0.00600656f \
 //x=67.46 //y=2.375 //x2=67.1 //y2=1.09
cc_4390 ( N_CLK_c_5295_p N_noxref_30_M41_noxref_d ) capacitor c=2.2052e-19 \
 //x=67.46 //y=2.26 //x2=67.1 //y2=1.09
cc_4391 ( N_CLK_c_5540_p N_noxref_30_M41_noxref_d ) capacitor c=0.00253592f \
 //x=67.025 //y=1.09 //x2=67.1 //y2=1.09
cc_4392 ( N_CLK_c_5542_p N_noxref_30_M41_noxref_d ) capacitor c=0.00604066f \
 //x=67.025 //y=1.4 //x2=67.1 //y2=1.09
cc_4393 ( N_CLK_c_5726_p N_noxref_30_M41_noxref_d ) capacitor c=0.002686f \
 //x=67.395 //y=0.935 //x2=67.1 //y2=1.09
cc_4394 ( N_CLK_c_5727_p N_noxref_30_M41_noxref_d ) capacitor c=0.00251995f \
 //x=67.395 //y=1.555 //x2=67.1 //y2=1.09
cc_4395 ( N_CLK_c_5358_p N_noxref_30_M41_noxref_d ) capacitor c=0.00314523f \
 //x=67.55 //y=1.09 //x2=67.1 //y2=1.09
cc_4396 ( N_CLK_c_5359_p N_noxref_30_M41_noxref_d ) capacitor c=0.00168289f \
 //x=67.55 //y=1.4 //x2=67.1 //y2=1.09
cc_4397 ( N_CLK_c_5360_p N_noxref_30_M41_noxref_d ) capacitor c=0.00111165f \
 //x=67.55 //y=1.63 //x2=67.1 //y2=1.09
cc_4398 ( N_CLK_c_5358_p N_noxref_30_M42_noxref_s ) capacitor c=7.21316e-19 \
 //x=67.55 //y=1.09 //x2=68.205 //y2=0.555
cc_4399 ( N_CLK_c_5359_p N_noxref_30_M42_noxref_s ) capacitor c=0.00365271f \
 //x=67.55 //y=1.4 //x2=68.205 //y2=0.555
cc_4400 ( N_CLK_c_5296_p N_noxref_30_M42_noxref_s ) capacitor c=9.86711e-19 \
 //x=67.55 //y=2.095 //x2=68.205 //y2=0.555
cc_4401 ( N_CLK_c_4769_n N_GND_c_13951_n ) capacitor c=9.16602e-19 //x=2.71 \
 //y=2.375 //x2=6.29 //y2=0.175
cc_4402 ( N_CLK_c_4812_n N_GND_c_14098_n ) capacitor c=7.99941e-19 //x=15.66 \
 //y=2.375 //x2=19.24 //y2=0.175
cc_4403 ( N_CLK_c_4998_n N_GND_c_14171_n ) capacitor c=7.99941e-19 //x=28.61 \
 //y=2.375 //x2=32.19 //y2=0.175
cc_4404 ( N_CLK_c_5040_n N_GND_c_14347_n ) capacitor c=7.99941e-19 //x=41.56 \
 //y=2.375 //x2=45.14 //y2=0.175
cc_4405 ( N_CLK_c_5307_p N_GND_c_14416_n ) capacitor c=7.99941e-19 //x=54.51 \
 //y=2.375 //x2=58.09 //y2=0.175
cc_4406 ( N_CLK_c_5293_p N_GND_c_14417_n ) capacitor c=7.99941e-19 //x=67.46 \
 //y=2.375 //x2=71.04 //y2=0.175
cc_4407 ( N_CLK_c_4974_n N_noxref_35_c_15550_n ) capacitor c=0.0167228f \
 //x=2.275 //y=1.09 //x2=2.935 //y2=0.72
cc_4408 ( N_CLK_c_4794_n N_noxref_35_c_15550_n ) capacitor c=0.00534519f \
 //x=2.8 //y=1.09 //x2=2.935 //y2=0.72
cc_4409 ( N_CLK_c_4769_n N_noxref_35_c_15544_n ) capacitor c=0.00481455f \
 //x=2.71 //y=2.375 //x2=2.935 //y2=1.77
cc_4410 ( N_CLK_c_4772_n N_noxref_35_c_15544_n ) capacitor c=8.72493e-19 \
 //x=2.705 //y=4.835 //x2=2.935 //y2=1.77
cc_4411 ( N_CLK_c_4784_n N_noxref_35_c_15544_n ) capacitor c=0.0105652f \
 //x=2.71 //y=2.26 //x2=2.935 //y2=1.77
cc_4412 ( N_CLK_c_4977_n N_noxref_35_c_15544_n ) capacitor c=0.0153476f \
 //x=2.275 //y=1.4 //x2=2.935 //y2=1.77
cc_4413 ( N_CLK_c_4797_n N_noxref_35_c_15544_n ) capacitor c=0.020493f //x=2.8 \
 //y=2.095 //x2=2.935 //y2=1.77
cc_4414 ( N_CLK_c_4974_n N_noxref_35_M0_noxref_s ) capacitor c=0.00798959f \
 //x=2.275 //y=1.09 //x2=0.945 //y2=0.555
cc_4415 ( N_CLK_c_4796_n N_noxref_35_M0_noxref_s ) capacitor c=0.00212176f \
 //x=2.8 //y=1.63 //x2=0.945 //y2=0.555
cc_4416 ( N_CLK_c_4797_n N_noxref_35_M0_noxref_s ) capacitor c=0.00298115f \
 //x=2.8 //y=2.095 //x2=0.945 //y2=0.555
cc_4417 ( N_CLK_c_4836_n N_noxref_38_c_15728_n ) capacitor c=0.0167228f \
 //x=15.225 //y=1.09 //x2=15.885 //y2=0.72
cc_4418 ( N_CLK_c_4841_n N_noxref_38_c_15728_n ) capacitor c=0.00534519f \
 //x=15.75 //y=1.09 //x2=15.885 //y2=0.72
cc_4419 ( N_CLK_c_4812_n N_noxref_38_c_15730_n ) capacitor c=0.0048147f \
 //x=15.66 //y=2.375 //x2=15.885 //y2=1.77
cc_4420 ( N_CLK_c_4815_n N_noxref_38_c_15730_n ) capacitor c=9.0414e-19 \
 //x=15.655 //y=4.695 //x2=15.885 //y2=1.77
cc_4421 ( N_CLK_c_4825_n N_noxref_38_c_15730_n ) capacitor c=0.0105652f \
 //x=15.66 //y=2.26 //x2=15.885 //y2=1.77
cc_4422 ( N_CLK_c_4839_n N_noxref_38_c_15730_n ) capacitor c=0.0153476f \
 //x=15.225 //y=1.4 //x2=15.885 //y2=1.77
cc_4423 ( N_CLK_c_4844_n N_noxref_38_c_15730_n ) capacitor c=0.019963f \
 //x=15.75 //y=2.095 //x2=15.885 //y2=1.77
cc_4424 ( N_CLK_c_4836_n N_noxref_38_M8_noxref_s ) capacitor c=0.00798959f \
 //x=15.225 //y=1.09 //x2=13.895 //y2=0.555
cc_4425 ( N_CLK_c_4843_n N_noxref_38_M8_noxref_s ) capacitor c=0.00212176f \
 //x=15.75 //y=1.63 //x2=13.895 //y2=0.555
cc_4426 ( N_CLK_c_4844_n N_noxref_38_M8_noxref_s ) capacitor c=0.00298115f \
 //x=15.75 //y=2.095 //x2=13.895 //y2=0.555
cc_4427 ( N_CLK_c_5202_n N_noxref_41_c_15911_n ) capacitor c=0.0167228f \
 //x=28.175 //y=1.09 //x2=28.835 //y2=0.72
cc_4428 ( N_CLK_c_5022_n N_noxref_41_c_15911_n ) capacitor c=0.00534519f \
 //x=28.7 //y=1.09 //x2=28.835 //y2=0.72
cc_4429 ( N_CLK_c_4998_n N_noxref_41_c_15913_n ) capacitor c=0.0048147f \
 //x=28.61 //y=2.375 //x2=28.835 //y2=1.77
cc_4430 ( N_CLK_c_5001_n N_noxref_41_c_15913_n ) capacitor c=8.72493e-19 \
 //x=28.605 //y=4.835 //x2=28.835 //y2=1.77
cc_4431 ( N_CLK_c_5012_n N_noxref_41_c_15913_n ) capacitor c=0.0105652f \
 //x=28.61 //y=2.26 //x2=28.835 //y2=1.77
cc_4432 ( N_CLK_c_5205_n N_noxref_41_c_15913_n ) capacitor c=0.0153476f \
 //x=28.175 //y=1.4 //x2=28.835 //y2=1.77
cc_4433 ( N_CLK_c_5025_n N_noxref_41_c_15913_n ) capacitor c=0.0216832f \
 //x=28.7 //y=2.095 //x2=28.835 //y2=1.77
cc_4434 ( N_CLK_c_5202_n N_noxref_41_M16_noxref_s ) capacitor c=0.00798959f \
 //x=28.175 //y=1.09 //x2=26.845 //y2=0.555
cc_4435 ( N_CLK_c_5024_n N_noxref_41_M16_noxref_s ) capacitor c=0.00212176f \
 //x=28.7 //y=1.63 //x2=26.845 //y2=0.555
cc_4436 ( N_CLK_c_5025_n N_noxref_41_M16_noxref_s ) capacitor c=0.00298115f \
 //x=28.7 //y=2.095 //x2=26.845 //y2=0.555
cc_4437 ( N_CLK_c_5064_n N_noxref_44_c_16096_n ) capacitor c=0.0167228f \
 //x=41.125 //y=1.09 //x2=41.785 //y2=0.72
cc_4438 ( N_CLK_c_5069_n N_noxref_44_c_16096_n ) capacitor c=0.00534519f \
 //x=41.65 //y=1.09 //x2=41.785 //y2=0.72
cc_4439 ( N_CLK_c_5040_n N_noxref_44_c_16098_n ) capacitor c=0.0048147f \
 //x=41.56 //y=2.375 //x2=41.785 //y2=1.77
cc_4440 ( N_CLK_c_5043_n N_noxref_44_c_16098_n ) capacitor c=9.0414e-19 \
 //x=41.555 //y=4.695 //x2=41.785 //y2=1.77
cc_4441 ( N_CLK_c_5053_n N_noxref_44_c_16098_n ) capacitor c=0.0105652f \
 //x=41.56 //y=2.26 //x2=41.785 //y2=1.77
cc_4442 ( N_CLK_c_5067_n N_noxref_44_c_16098_n ) capacitor c=0.0153476f \
 //x=41.125 //y=1.4 //x2=41.785 //y2=1.77
cc_4443 ( N_CLK_c_5072_n N_noxref_44_c_16098_n ) capacitor c=0.019963f \
 //x=41.65 //y=2.095 //x2=41.785 //y2=1.77
cc_4444 ( N_CLK_c_5064_n N_noxref_44_M24_noxref_s ) capacitor c=0.00798959f \
 //x=41.125 //y=1.09 //x2=39.795 //y2=0.555
cc_4445 ( N_CLK_c_5071_n N_noxref_44_M24_noxref_s ) capacitor c=0.00212176f \
 //x=41.65 //y=1.63 //x2=39.795 //y2=0.555
cc_4446 ( N_CLK_c_5072_n N_noxref_44_M24_noxref_s ) capacitor c=0.00298115f \
 //x=41.65 //y=2.095 //x2=39.795 //y2=0.555
cc_4447 ( N_CLK_c_5442_p N_noxref_47_c_16267_n ) capacitor c=0.0167228f \
 //x=54.075 //y=1.09 //x2=54.735 //y2=0.72
cc_4448 ( N_CLK_c_5449_p N_noxref_47_c_16267_n ) capacitor c=0.00534519f \
 //x=54.6 //y=1.09 //x2=54.735 //y2=0.72
cc_4449 ( N_CLK_c_5307_p N_noxref_47_c_16269_n ) capacitor c=0.0048147f \
 //x=54.51 //y=2.375 //x2=54.735 //y2=1.77
cc_4450 ( N_CLK_c_5230_p N_noxref_47_c_16269_n ) capacitor c=8.72493e-19 \
 //x=54.505 //y=4.835 //x2=54.735 //y2=1.77
cc_4451 ( N_CLK_c_5308_p N_noxref_47_c_16269_n ) capacitor c=0.0105652f \
 //x=54.51 //y=2.26 //x2=54.735 //y2=1.77
cc_4452 ( N_CLK_c_5444_p N_noxref_47_c_16269_n ) capacitor c=0.0153476f \
 //x=54.075 //y=1.4 //x2=54.735 //y2=1.77
cc_4453 ( N_CLK_c_5309_p N_noxref_47_c_16269_n ) capacitor c=0.019963f \
 //x=54.6 //y=2.095 //x2=54.735 //y2=1.77
cc_4454 ( N_CLK_c_5442_p N_noxref_47_M32_noxref_s ) capacitor c=0.00798959f \
 //x=54.075 //y=1.09 //x2=52.745 //y2=0.555
cc_4455 ( N_CLK_c_5452_p N_noxref_47_M32_noxref_s ) capacitor c=0.00212176f \
 //x=54.6 //y=1.63 //x2=52.745 //y2=0.555
cc_4456 ( N_CLK_c_5309_p N_noxref_47_M32_noxref_s ) capacitor c=0.00298115f \
 //x=54.6 //y=2.095 //x2=52.745 //y2=0.555
cc_4457 ( N_CLK_c_5540_p N_noxref_50_c_16452_n ) capacitor c=0.0167228f \
 //x=67.025 //y=1.09 //x2=67.685 //y2=0.72
cc_4458 ( N_CLK_c_5358_p N_noxref_50_c_16452_n ) capacitor c=0.00534519f \
 //x=67.55 //y=1.09 //x2=67.685 //y2=0.72
cc_4459 ( N_CLK_c_5293_p N_noxref_50_c_16454_n ) capacitor c=0.0048147f \
 //x=67.46 //y=2.375 //x2=67.685 //y2=1.77
cc_4460 ( N_CLK_c_5298_p N_noxref_50_c_16454_n ) capacitor c=9.0414e-19 \
 //x=67.455 //y=4.695 //x2=67.685 //y2=1.77
cc_4461 ( N_CLK_c_5295_p N_noxref_50_c_16454_n ) capacitor c=0.0105652f \
 //x=67.46 //y=2.26 //x2=67.685 //y2=1.77
cc_4462 ( N_CLK_c_5542_p N_noxref_50_c_16454_n ) capacitor c=0.0153476f \
 //x=67.025 //y=1.4 //x2=67.685 //y2=1.77
cc_4463 ( N_CLK_c_5296_p N_noxref_50_c_16454_n ) capacitor c=0.019963f \
 //x=67.55 //y=2.095 //x2=67.685 //y2=1.77
cc_4464 ( N_CLK_c_5540_p N_noxref_50_M40_noxref_s ) capacitor c=0.00798959f \
 //x=67.025 //y=1.09 //x2=65.695 //y2=0.555
cc_4465 ( N_CLK_c_5360_p N_noxref_50_M40_noxref_s ) capacitor c=0.00212176f \
 //x=67.55 //y=1.63 //x2=65.695 //y2=0.555
cc_4466 ( N_CLK_c_5296_p N_noxref_50_M40_noxref_s ) capacitor c=0.00298115f \
 //x=67.55 //y=2.095 //x2=65.695 //y2=0.555
cc_4467 ( N_noxref_12_c_5880_p RN ) capacitor c=0.0317216f //x=71.16 //y=3.72 \
 //x2=72.27 //y2=3.88
cc_4468 ( N_noxref_12_c_5881_p RN ) capacitor c=0.00763467f //x=71.16 //y=4.04 \
 //x2=72.27 //y2=3.88
cc_4469 ( N_noxref_12_c_5882_p RN ) capacitor c=0.018308f //x=71.16 //y=4.755 \
 //x2=72.27 //y2=3.88
cc_4470 ( N_noxref_12_c_5883_p RN ) capacitor c=2.61099e-19 //x=71.15 //y=3.88 \
 //x2=72.27 //y2=3.88
cc_4471 ( N_noxref_12_c_5884_p RN ) capacitor c=0.00319795f //x=69.53 //y=3.87 \
 //x2=72.27 //y2=3.88
cc_4472 ( N_noxref_12_c_5885_p RN ) capacitor c=3.36194e-19 //x=71.16 //y=4.88 \
 //x2=72.27 //y2=3.88
cc_4473 ( N_noxref_12_c_5807_n N_RN_c_6764_n ) capacitor c=0.00171255f \
 //x=58.21 //y=3.72 //x2=60.43 //y2=4.75
cc_4474 ( N_noxref_12_c_5815_n N_RN_c_6764_n ) capacitor c=5.77971e-19 \
 //x=58.21 //y=4.755 //x2=60.43 //y2=4.75
cc_4475 ( N_noxref_12_c_5819_n N_RN_c_6764_n ) capacitor c=0.0223923f \
 //x=61.045 //y=3.895 //x2=60.43 //y2=4.75
cc_4476 ( N_noxref_12_c_5880_p N_RN_c_6888_n ) capacitor c=0.00197253f \
 //x=71.16 //y=3.72 //x2=68.57 //y2=4.75
cc_4477 ( N_noxref_12_c_5882_p N_RN_c_6888_n ) capacitor c=0.00162605f \
 //x=71.16 //y=4.755 //x2=68.57 //y2=4.75
cc_4478 ( N_noxref_12_c_5875_n N_RN_c_6888_n ) capacitor c=0.0222877f \
 //x=68.93 //y=3.88 //x2=68.57 //y2=4.75
cc_4479 ( N_noxref_12_c_5892_p N_RN_c_6985_n ) capacitor c=0.00798977f \
 //x=71.16 //y=2.375 //x2=72.27 //y2=2.515
cc_4480 ( N_noxref_12_c_5880_p N_RN_c_6985_n ) capacitor c=0.00291253f \
 //x=71.16 //y=3.72 //x2=72.27 //y2=2.515
cc_4481 ( N_noxref_12_c_5894_p N_RN_c_6985_n ) capacitor c=0.00120311f \
 //x=71.16 //y=2.26 //x2=72.27 //y2=2.515
cc_4482 ( N_noxref_12_c_5895_p N_RN_c_6985_n ) capacitor c=0.00159161f \
 //x=70.86 //y=2.095 //x2=72.27 //y2=2.515
cc_4483 ( N_noxref_12_c_5882_p N_RN_c_6989_n ) capacitor c=0.0110307f \
 //x=71.16 //y=4.755 //x2=72.27 //y2=4.765
cc_4484 ( N_noxref_12_c_5885_p N_RN_c_6989_n ) capacitor c=2.89813e-19 \
 //x=71.16 //y=4.88 //x2=72.27 //y2=4.765
cc_4485 ( N_noxref_12_c_5898_p N_RN_c_6989_n ) capacitor c=7.66769e-19 \
 //x=71.725 //y=4.97 //x2=72.27 //y2=4.765
cc_4486 ( N_noxref_12_c_5899_p N_RN_c_6989_n ) capacitor c=7.54501e-19 \
 //x=71.435 //y=4.97 //x2=72.27 //y2=4.765
cc_4487 ( N_noxref_12_c_5900_p N_RN_c_6606_n ) capacitor c=6.8859e-19 \
 //x=55.875 //y=1.305 //x2=59.105 //y2=2.385
cc_4488 ( N_noxref_12_c_5901_p N_RN_c_6606_n ) capacitor c=0.021157f //x=55.96 \
 //y=1.845 //x2=59.105 //y2=2.385
cc_4489 ( N_noxref_12_c_5800_n N_RN_c_6606_n ) capacitor c=0.0278424f \
 //x=56.36 //y=3.725 //x2=59.105 //y2=2.385
cc_4490 ( N_noxref_12_c_5804_n N_RN_c_6606_n ) capacitor c=0.0174548f \
 //x=58.21 //y=2.375 //x2=59.105 //y2=2.385
cc_4491 ( N_noxref_12_c_5807_n N_RN_c_6606_n ) capacitor c=0.014399f //x=58.21 \
 //y=3.72 //x2=59.105 //y2=2.385
cc_4492 ( N_noxref_12_c_5820_n N_RN_c_6606_n ) capacitor c=5.18204e-19 \
 //x=58.21 //y=2.26 //x2=59.105 //y2=2.385
cc_4493 ( N_noxref_12_c_5833_n N_RN_c_6606_n ) capacitor c=3.41298e-19 \
 //x=57.91 //y=2.095 //x2=59.105 //y2=2.385
cc_4494 ( N_noxref_12_c_5892_p N_RN_c_7000_n ) capacitor c=0.00279365f \
 //x=71.16 //y=2.375 //x2=72.225 //y2=2.355
cc_4495 ( N_noxref_12_c_5880_p N_RN_c_7000_n ) capacitor c=5.00559e-19 \
 //x=71.16 //y=3.72 //x2=72.225 //y2=2.355
cc_4496 ( N_noxref_12_c_5892_p N_RN_c_7002_n ) capacitor c=0.0168121f \
 //x=71.16 //y=2.375 //x2=72.065 //y2=2.355
cc_4497 ( N_noxref_12_c_5880_p N_RN_c_7002_n ) capacitor c=0.0168055f \
 //x=71.16 //y=3.72 //x2=72.065 //y2=2.355
cc_4498 ( N_noxref_12_c_5894_p N_RN_c_7002_n ) capacitor c=2.54369e-19 \
 //x=71.16 //y=2.26 //x2=72.065 //y2=2.355
cc_4499 ( N_noxref_12_c_5895_p N_RN_c_7002_n ) capacitor c=3.41298e-19 \
 //x=70.86 //y=2.095 //x2=72.065 //y2=2.355
cc_4500 ( N_noxref_12_c_5892_p N_RN_c_7006_n ) capacitor c=5.39999e-19 \
 //x=71.16 //y=2.375 //x2=72.27 //y2=2.26
cc_4501 ( N_noxref_12_c_5894_p N_RN_c_7006_n ) capacitor c=0.00124896f \
 //x=71.16 //y=2.26 //x2=72.27 //y2=2.26
cc_4502 ( N_noxref_12_c_5895_p N_RN_c_7006_n ) capacitor c=0.00214501f \
 //x=70.86 //y=2.095 //x2=72.27 //y2=2.26
cc_4503 ( N_noxref_12_c_5882_p N_RN_c_7009_n ) capacitor c=0.00103399f \
 //x=71.16 //y=4.755 //x2=72.27 //y2=4.88
cc_4504 ( N_noxref_12_c_5885_p N_RN_c_7009_n ) capacitor c=0.00113984f \
 //x=71.16 //y=4.88 //x2=72.27 //y2=4.88
cc_4505 ( N_noxref_12_c_5898_p N_RN_c_7009_n ) capacitor c=0.00116563f \
 //x=71.725 //y=4.97 //x2=72.27 //y2=4.88
cc_4506 ( N_noxref_12_c_5899_p N_RN_c_7009_n ) capacitor c=0.00129812f \
 //x=71.435 //y=4.97 //x2=72.27 //y2=4.88
cc_4507 ( N_noxref_12_M140_noxref_g N_RN_M142_noxref_g ) capacitor \
 c=0.0106276f //x=71.36 //y=6.2 //x2=72.24 //y2=6.2
cc_4508 ( N_noxref_12_M141_noxref_g N_RN_M142_noxref_g ) capacitor c=0.107144f \
 //x=71.8 //y=6.2 //x2=72.24 //y2=6.2
cc_4509 ( N_noxref_12_M141_noxref_g N_RN_M143_noxref_g ) capacitor \
 c=0.0101598f //x=71.8 //y=6.2 //x2=72.68 //y2=6.2
cc_4510 ( N_noxref_12_c_5923_p N_RN_c_7016_n ) capacitor c=5.72528e-19 \
 //x=70.86 //y=1.055 //x2=71.835 //y2=1.09
cc_4511 ( N_noxref_12_c_5924_p N_RN_c_7016_n ) capacitor c=0.00150277f \
 //x=70.86 //y=1.4 //x2=71.835 //y2=1.09
cc_4512 ( N_noxref_12_c_5925_p N_RN_c_7016_n ) capacitor c=0.0160123f \
 //x=71.39 //y=1.055 //x2=71.835 //y2=1.09
cc_4513 ( N_noxref_12_c_5926_p N_RN_c_7019_n ) capacitor c=0.00111227f \
 //x=70.86 //y=1.71 //x2=71.835 //y2=1.4
cc_4514 ( N_noxref_12_c_5927_p N_RN_c_7019_n ) capacitor c=0.0124075f \
 //x=71.39 //y=1.4 //x2=71.835 //y2=1.4
cc_4515 ( N_noxref_12_c_5925_p N_RN_c_7021_n ) capacitor c=9.19165e-19 \
 //x=71.39 //y=1.055 //x2=72.36 //y2=1.09
cc_4516 ( N_noxref_12_c_5927_p N_RN_c_7022_n ) capacitor c=0.0010154f \
 //x=71.39 //y=1.4 //x2=72.36 //y2=1.4
cc_4517 ( N_noxref_12_c_5927_p N_RN_c_7023_n ) capacitor c=9.23422e-19 \
 //x=71.39 //y=1.4 //x2=72.36 //y2=1.63
cc_4518 ( N_noxref_12_c_5892_p N_RN_c_7024_n ) capacitor c=3.54695e-19 \
 //x=71.16 //y=2.375 //x2=72.36 //y2=2.095
cc_4519 ( N_noxref_12_c_5894_p N_RN_c_7024_n ) capacitor c=0.00166305f \
 //x=71.16 //y=2.26 //x2=72.36 //y2=2.095
cc_4520 ( N_noxref_12_c_5895_p N_RN_c_7024_n ) capacitor c=0.00868554f \
 //x=70.86 //y=2.095 //x2=72.36 //y2=2.095
cc_4521 ( N_noxref_12_c_5882_p N_RN_c_7027_n ) capacitor c=0.00116212f \
 //x=71.16 //y=4.755 //x2=72.27 //y2=4.88
cc_4522 ( N_noxref_12_c_5885_p N_RN_c_7027_n ) capacitor c=0.00155973f \
 //x=71.16 //y=4.88 //x2=72.27 //y2=4.88
cc_4523 ( N_noxref_12_c_5898_p N_RN_c_7027_n ) capacitor c=0.0171374f \
 //x=71.725 //y=4.97 //x2=72.27 //y2=4.88
cc_4524 ( N_noxref_12_c_5899_p N_RN_c_7027_n ) capacitor c=0.00484466f \
 //x=71.435 //y=4.97 //x2=72.27 //y2=4.88
cc_4525 ( N_noxref_12_c_5869_n N_noxref_14_c_7812_n ) capacitor c=6.09845e-19 \
 //x=63.235 //y=3.895 //x2=63.76 //y2=4.09
cc_4526 ( N_noxref_12_c_5870_n N_noxref_14_c_7812_n ) capacitor c=0.0202193f \
 //x=63.98 //y=3.865 //x2=63.76 //y2=4.09
cc_4527 ( N_noxref_12_c_5869_n N_noxref_14_c_7747_n ) capacitor c=0.00217342f \
 //x=63.235 //y=3.895 //x2=63.76 //y2=4.41
cc_4528 ( N_noxref_12_c_5870_n N_noxref_14_c_7747_n ) capacitor c=0.00450608f \
 //x=63.98 //y=3.865 //x2=63.76 //y2=4.41
cc_4529 ( N_noxref_12_c_5892_p N_noxref_14_c_7757_n ) capacitor c=0.00324093f \
 //x=71.16 //y=2.375 //x2=69.31 //y2=4.095
cc_4530 ( N_noxref_12_c_5880_p N_noxref_14_c_7757_n ) capacitor c=0.0175959f \
 //x=71.16 //y=3.72 //x2=69.31 //y2=4.095
cc_4531 ( N_noxref_12_c_5881_p N_noxref_14_c_7757_n ) capacitor c=0.00257738f \
 //x=71.16 //y=4.04 //x2=69.31 //y2=4.095
cc_4532 ( N_noxref_12_c_5882_p N_noxref_14_c_7757_n ) capacitor c=9.84588e-19 \
 //x=71.16 //y=4.755 //x2=69.31 //y2=4.095
cc_4533 ( N_noxref_12_c_5875_n N_noxref_14_c_7757_n ) capacitor c=2.09913e-19 \
 //x=68.93 //y=3.88 //x2=69.31 //y2=4.095
cc_4534 ( N_noxref_12_c_5884_p N_noxref_14_c_7757_n ) capacitor c=0.0239353f \
 //x=69.53 //y=3.87 //x2=69.31 //y2=4.095
cc_4535 ( N_noxref_12_c_5882_p N_noxref_14_c_7822_n ) capacitor c=0.00237452f \
 //x=71.16 //y=4.755 //x2=69.31 //y2=4.415
cc_4536 ( N_noxref_12_c_5875_n N_noxref_14_c_7822_n ) capacitor c=0.0018855f \
 //x=68.93 //y=3.88 //x2=69.31 //y2=4.415
cc_4537 ( N_noxref_12_c_5884_p N_noxref_14_c_7822_n ) capacitor c=0.00583578f \
 //x=69.53 //y=3.87 //x2=69.31 //y2=4.415
cc_4538 ( N_noxref_12_c_5882_p N_noxref_14_c_7758_n ) capacitor c=0.00982178f \
 //x=71.16 //y=4.755 //x2=69.31 //y2=5.25
cc_4539 ( N_noxref_12_M141_noxref_g N_noxref_14_c_7826_n ) capacitor \
 c=0.00973141f //x=71.8 //y=6.2 //x2=72.34 //y2=5.335
cc_4540 ( N_noxref_12_M140_noxref_g N_noxref_14_c_7827_n ) capacitor \
 c=0.00461408f //x=71.36 //y=6.2 //x2=71.582 //y2=5.335
cc_4541 ( N_noxref_12_M141_noxref_g N_noxref_14_c_7827_n ) capacitor \
 c=0.00229208f //x=71.8 //y=6.2 //x2=71.582 //y2=5.335
cc_4542 ( N_noxref_12_c_5898_p N_noxref_14_c_7827_n ) capacitor c=0.00171885f \
 //x=71.725 //y=4.97 //x2=71.582 //y2=5.335
cc_4543 ( N_noxref_12_c_5956_p N_noxref_14_c_7767_n ) capacitor c=0.00118691f \
 //x=56.36 //y=4.045 //x2=55.975 //y2=4.25
cc_4544 ( N_noxref_12_c_5803_n N_noxref_14_c_7767_n ) capacitor c=4.26819e-19 \
 //x=56.36 //y=5.25 //x2=55.975 //y2=4.25
cc_4545 ( N_noxref_12_c_5958_p N_noxref_14_c_7767_n ) capacitor c=0.0358254f \
 //x=56.525 //y=3.885 //x2=55.975 //y2=4.25
cc_4546 ( N_noxref_12_c_5956_p N_noxref_14_c_7771_n ) capacitor c=0.00757286f \
 //x=56.36 //y=4.045 //x2=56.615 //y2=4.27
cc_4547 ( N_noxref_12_c_5803_n N_noxref_14_c_7771_n ) capacitor c=0.0225812f \
 //x=56.36 //y=5.25 //x2=56.615 //y2=4.27
cc_4548 ( N_noxref_12_c_5865_n N_noxref_14_c_7771_n ) capacitor c=0.127594f \
 //x=58.055 //y=3.88 //x2=56.615 //y2=4.27
cc_4549 ( N_noxref_12_c_5814_n N_noxref_14_c_7772_n ) capacitor c=0.00118033f \
 //x=58.21 //y=4.04 //x2=57.83 //y2=4.25
cc_4550 ( N_noxref_12_c_5815_n N_noxref_14_c_7772_n ) capacitor c=5.06484e-19 \
 //x=58.21 //y=4.755 //x2=57.83 //y2=4.25
cc_4551 ( N_noxref_12_c_5865_n N_noxref_14_c_7772_n ) capacitor c=0.0121043f \
 //x=58.055 //y=3.88 //x2=57.83 //y2=4.25
cc_4552 ( N_noxref_12_c_5819_n N_noxref_14_c_7772_n ) capacitor c=0.0358254f \
 //x=61.045 //y=3.895 //x2=57.83 //y2=4.25
cc_4553 ( N_noxref_12_c_5814_n N_noxref_14_c_7840_n ) capacitor c=0.00475287f \
 //x=58.21 //y=4.04 //x2=58.43 //y2=4.265
cc_4554 ( N_noxref_12_c_5815_n N_noxref_14_c_7840_n ) capacitor c=0.0235427f \
 //x=58.21 //y=4.755 //x2=58.43 //y2=4.265
cc_4555 ( N_noxref_12_c_5819_n N_noxref_14_c_7840_n ) capacitor c=0.0109313f \
 //x=61.045 //y=3.895 //x2=58.43 //y2=4.265
cc_4556 ( N_noxref_12_c_5870_n N_noxref_14_c_7773_n ) capacitor c=0.0811722f \
 //x=63.98 //y=3.865 //x2=69.155 //y2=4.25
cc_4557 ( N_noxref_12_c_5871_n N_noxref_14_c_7773_n ) capacitor c=0.112087f \
 //x=64.715 //y=3.9 //x2=69.155 //y2=4.25
cc_4558 ( N_noxref_12_c_5872_n N_noxref_14_c_7773_n ) capacitor c=0.0584235f \
 //x=65.97 //y=3.88 //x2=69.155 //y2=4.25
cc_4559 ( N_noxref_12_c_5873_n N_noxref_14_c_7773_n ) capacitor c=0.206732f \
 //x=66.57 //y=3.9 //x2=69.155 //y2=4.25
cc_4560 ( N_noxref_12_c_5875_n N_noxref_14_c_7773_n ) capacitor c=0.0113778f \
 //x=68.93 //y=3.88 //x2=69.155 //y2=4.25
cc_4561 ( N_noxref_12_c_5815_n N_noxref_14_c_7732_n ) capacitor c=3.74821e-19 \
 //x=58.21 //y=4.755 //x2=63.925 //y2=4.25
cc_4562 ( N_noxref_12_c_5866_n N_noxref_14_c_7732_n ) capacitor c=0.11095f \
 //x=61.39 //y=3.895 //x2=63.925 //y2=4.25
cc_4563 ( N_noxref_12_c_5819_n N_noxref_14_c_7732_n ) capacitor c=0.258118f \
 //x=61.045 //y=3.895 //x2=63.925 //y2=4.25
cc_4564 ( N_noxref_12_c_5868_n N_noxref_14_c_7732_n ) capacitor c=0.0563855f \
 //x=62.635 //y=3.88 //x2=63.925 //y2=4.25
cc_4565 ( N_noxref_12_c_5869_n N_noxref_14_c_7732_n ) capacitor c=0.0231836f \
 //x=63.235 //y=3.895 //x2=63.925 //y2=4.25
cc_4566 ( N_noxref_12_c_5870_n N_noxref_14_c_7732_n ) capacitor c=0.0358686f \
 //x=63.98 //y=3.865 //x2=63.925 //y2=4.25
cc_4567 ( N_noxref_12_c_5881_p N_noxref_14_c_7854_n ) capacitor c=0.00248957f \
 //x=71.16 //y=4.04 //x2=71.365 //y2=4.265
cc_4568 ( N_noxref_12_c_5882_p N_noxref_14_c_7854_n ) capacitor c=0.0301845f \
 //x=71.16 //y=4.755 //x2=71.365 //y2=4.265
cc_4569 ( N_noxref_12_c_5881_p N_noxref_14_c_7856_n ) capacitor c=0.00335139f \
 //x=71.16 //y=4.04 //x2=71.02 //y2=4.265
cc_4570 ( N_noxref_12_c_5882_p N_noxref_14_c_7856_n ) capacitor c=0.00195984f \
 //x=71.16 //y=4.755 //x2=71.02 //y2=4.265
cc_4571 ( N_noxref_12_c_5884_p N_noxref_14_c_7856_n ) capacitor c=0.212312f \
 //x=69.53 //y=3.87 //x2=71.02 //y2=4.265
cc_4572 ( N_noxref_12_c_5882_p N_noxref_14_c_7859_n ) capacitor c=3.8472e-19 \
 //x=71.16 //y=4.755 //x2=74.28 //y2=4.25
cc_4573 ( N_noxref_12_M140_noxref_g N_noxref_14_c_7860_n ) capacitor \
 c=0.0162284f //x=71.36 //y=6.2 //x2=71.58 //y2=5.56
cc_4574 ( N_noxref_12_M141_noxref_g N_noxref_14_c_7860_n ) capacitor \
 c=0.0179041f //x=71.8 //y=6.2 //x2=71.58 //y2=5.56
cc_4575 ( N_noxref_12_c_5898_p N_noxref_14_c_7860_n ) capacitor c=0.00291477f \
 //x=71.725 //y=4.97 //x2=71.58 //y2=5.56
cc_4576 ( N_noxref_12_c_5858_n N_noxref_14_M118_noxref_g ) capacitor \
 c=0.00461408f //x=53.822 //y=5.335 //x2=53.6 //y2=6.2
cc_4577 ( N_noxref_12_c_5990_p N_noxref_14_M118_noxref_g ) capacitor \
 c=0.0162284f //x=53.82 //y=5.56 //x2=53.6 //y2=6.2
cc_4578 ( N_noxref_12_c_5847_n N_noxref_14_M119_noxref_g ) capacitor \
 c=0.00893512f //x=54.58 //y=5.335 //x2=54.04 //y2=6.2
cc_4579 ( N_noxref_12_c_5858_n N_noxref_14_M119_noxref_g ) capacitor \
 c=0.00229208f //x=53.822 //y=5.335 //x2=54.04 //y2=6.2
cc_4580 ( N_noxref_12_c_5990_p N_noxref_14_M119_noxref_g ) capacitor \
 c=0.0179041f //x=53.82 //y=5.56 //x2=54.04 //y2=6.2
cc_4581 ( N_noxref_12_c_5858_n N_noxref_14_c_7804_n ) capacitor c=0.00171885f \
 //x=53.822 //y=5.335 //x2=53.965 //y2=4.97
cc_4582 ( N_noxref_12_c_5990_p N_noxref_14_c_7804_n ) capacitor c=0.00291477f \
 //x=53.82 //y=5.56 //x2=53.965 //y2=4.97
cc_4583 ( N_noxref_12_c_5996_p N_noxref_15_c_8654_n ) capacitor c=8.29536e-19 \
 //x=55.875 //y=1.76 //x2=51.465 //y2=1.835
cc_4584 ( N_noxref_12_c_5901_p N_noxref_15_c_8574_n ) capacitor c=8.29536e-19 \
 //x=55.96 //y=1.845 //x2=51.55 //y2=3.37
cc_4585 ( N_noxref_12_c_5858_n N_noxref_15_c_8576_n ) capacitor c=0.00261914f \
 //x=53.822 //y=5.335 //x2=51.55 //y2=5.295
cc_4586 ( N_noxref_12_c_5800_n N_noxref_15_c_8738_n ) capacitor c=0.0140058f \
 //x=56.36 //y=3.725 //x2=55.62 //y2=2.375
cc_4587 ( N_noxref_12_c_5800_n N_noxref_15_c_8698_n ) capacitor c=0.0376974f \
 //x=56.36 //y=3.725 //x2=55.62 //y2=3.35
cc_4588 ( N_noxref_12_c_5807_n N_noxref_15_c_8698_n ) capacitor c=0.00116776f \
 //x=58.21 //y=3.72 //x2=55.62 //y2=3.35
cc_4589 ( N_noxref_12_c_5852_n N_noxref_15_c_8743_n ) capacitor c=7.46501e-19 \
 //x=55.465 //y=5.335 //x2=55.62 //y2=3.67
cc_4590 ( N_noxref_12_c_5853_n N_noxref_15_c_8743_n ) capacitor c=0.00110101f \
 //x=56.275 //y=5.335 //x2=55.62 //y2=3.67
cc_4591 ( N_noxref_12_c_5900_p N_noxref_15_c_8743_n ) capacitor c=2.30798e-19 \
 //x=55.875 //y=1.305 //x2=55.62 //y2=3.67
cc_4592 ( N_noxref_12_c_5901_p N_noxref_15_c_8743_n ) capacitor c=0.00103023f \
 //x=55.96 //y=1.845 //x2=55.62 //y2=3.67
cc_4593 ( N_noxref_12_c_5800_n N_noxref_15_c_8743_n ) capacitor c=0.0173072f \
 //x=56.36 //y=3.725 //x2=55.62 //y2=3.67
cc_4594 ( N_noxref_12_c_5853_n N_noxref_15_c_8744_n ) capacitor c=0.00228791f \
 //x=56.275 //y=5.335 //x2=55.62 //y2=4.75
cc_4595 ( N_noxref_12_c_5800_n N_noxref_15_c_8744_n ) capacitor c=0.00244924f \
 //x=56.36 //y=3.725 //x2=55.62 //y2=4.75
cc_4596 ( N_noxref_12_c_5956_p N_noxref_15_c_8744_n ) capacitor c=0.0146933f \
 //x=56.36 //y=4.045 //x2=55.62 //y2=4.75
cc_4597 ( N_noxref_12_c_5803_n N_noxref_15_c_8744_n ) capacitor c=0.0414151f \
 //x=56.36 //y=5.25 //x2=55.62 //y2=4.75
cc_4598 ( N_noxref_12_c_5815_n N_noxref_15_c_8744_n ) capacitor c=8.5348e-19 \
 //x=58.21 //y=4.755 //x2=55.62 //y2=4.75
cc_4599 ( N_noxref_12_c_6012_p N_noxref_15_c_8744_n ) capacitor c=0.0228808f \
 //x=55.58 //y=5.335 //x2=55.62 //y2=4.75
cc_4600 ( N_noxref_12_c_6013_p N_noxref_15_c_8744_n ) capacitor c=6.15181e-19 \
 //x=56.36 //y=3.88 //x2=55.62 //y2=4.75
cc_4601 ( N_noxref_12_c_5958_p N_noxref_15_c_8744_n ) capacitor c=0.00683433f \
 //x=56.525 //y=3.885 //x2=55.62 //y2=4.75
cc_4602 ( N_noxref_12_c_6015_p N_noxref_15_c_8744_n ) capacitor c=0.00217653f \
 //x=55.58 //y=5.56 //x2=55.62 //y2=4.75
cc_4603 ( N_noxref_12_M125_noxref_g N_noxref_15_c_8699_n ) capacitor \
 c=0.00893512f //x=58.85 //y=6.2 //x2=59.39 //y2=5.335
cc_4604 ( N_noxref_12_c_6017_p N_noxref_15_c_8855_n ) capacitor c=0.00163399f \
 //x=56.275 //y=1.845 //x2=60.77 //y2=1.845
cc_4605 ( N_noxref_12_c_5866_n N_noxref_15_c_8856_n ) capacitor c=0.00771097f \
 //x=61.39 //y=3.895 //x2=61.17 //y2=3.67
cc_4606 ( N_noxref_12_c_5819_n N_noxref_15_c_8856_n ) capacitor c=0.00128047f \
 //x=61.045 //y=3.895 //x2=61.17 //y2=3.67
cc_4607 ( N_noxref_12_c_5866_n N_noxref_15_c_8708_n ) capacitor c=0.0226453f \
 //x=61.39 //y=3.895 //x2=61.17 //y2=5.25
cc_4608 ( N_noxref_12_c_5819_n N_noxref_15_c_8708_n ) capacitor c=3.14797e-19 \
 //x=61.045 //y=3.895 //x2=61.17 //y2=5.25
cc_4609 ( N_noxref_12_c_5868_n N_noxref_15_c_8860_n ) capacitor c=0.00339401f \
 //x=62.635 //y=3.88 //x2=63.02 //y2=3.67
cc_4610 ( N_noxref_12_c_5869_n N_noxref_15_c_8860_n ) capacitor c=0.00260425f \
 //x=63.235 //y=3.895 //x2=63.02 //y2=3.67
cc_4611 ( N_noxref_12_c_5870_n N_noxref_15_c_8862_n ) capacitor c=0.0013819f \
 //x=63.98 //y=3.865 //x2=64.5 //y2=3.675
cc_4612 ( N_noxref_12_c_5871_n N_noxref_15_c_8862_n ) capacitor c=0.00694169f \
 //x=64.715 //y=3.9 //x2=64.5 //y2=3.675
cc_4613 ( N_noxref_12_c_5870_n N_noxref_15_c_8752_n ) capacitor c=0.00113794f \
 //x=63.98 //y=3.865 //x2=64.5 //y2=5.295
cc_4614 ( N_noxref_12_c_5871_n N_noxref_15_c_8752_n ) capacitor c=0.022395f \
 //x=64.715 //y=3.9 //x2=64.5 //y2=5.295
cc_4615 ( N_noxref_12_c_5872_n N_noxref_15_c_8759_n ) capacitor c=0.00342064f \
 //x=65.97 //y=3.88 //x2=66.35 //y2=3.675
cc_4616 ( N_noxref_12_c_5873_n N_noxref_15_c_8759_n ) capacitor c=0.00292429f \
 //x=66.57 //y=3.9 //x2=66.35 //y2=3.675
cc_4617 ( N_noxref_12_c_5872_n N_noxref_15_c_8760_n ) capacitor c=6.75872e-19 \
 //x=65.97 //y=3.88 //x2=66.35 //y2=4.755
cc_4618 ( N_noxref_12_c_5873_n N_noxref_15_c_8760_n ) capacitor c=0.023831f \
 //x=66.57 //y=3.9 //x2=66.35 //y2=4.755
cc_4619 ( N_noxref_12_c_5858_n N_noxref_15_c_8670_n ) capacitor c=5.0812e-19 \
 //x=53.822 //y=5.335 //x2=51.07 //y2=5.38
cc_4620 ( N_noxref_12_c_5800_n N_noxref_15_c_8767_n ) capacitor c=6.78671e-19 \
 //x=56.36 //y=3.725 //x2=55.62 //y2=3.51
cc_4621 ( N_noxref_12_c_6034_p N_noxref_15_c_8768_n ) capacitor c=6.09703e-19 \
 //x=55.58 //y=5.56 //x2=58.632 //y2=5.335
cc_4622 ( N_noxref_12_c_5853_n N_noxref_15_c_8768_n ) capacitor c=0.00306432f \
 //x=56.275 //y=5.335 //x2=58.632 //y2=5.335
cc_4623 ( N_noxref_12_M124_noxref_g N_noxref_15_c_8768_n ) capacitor \
 c=0.00461408f //x=58.41 //y=6.2 //x2=58.632 //y2=5.335
cc_4624 ( N_noxref_12_M125_noxref_g N_noxref_15_c_8768_n ) capacitor \
 c=0.00229208f //x=58.85 //y=6.2 //x2=58.632 //y2=5.335
cc_4625 ( N_noxref_12_c_5841_n N_noxref_15_c_8768_n ) capacitor c=0.00171885f \
 //x=58.775 //y=4.97 //x2=58.632 //y2=5.335
cc_4626 ( N_noxref_12_c_5868_n N_noxref_15_c_8771_n ) capacitor c=5.02752e-19 \
 //x=62.635 //y=3.88 //x2=63.022 //y2=4.74
cc_4627 ( N_noxref_12_c_5869_n N_noxref_15_c_8771_n ) capacitor c=0.0229559f \
 //x=63.235 //y=3.895 //x2=63.022 //y2=4.74
cc_4628 ( N_noxref_12_c_5800_n N_noxref_15_c_8720_n ) capacitor c=0.0216482f \
 //x=56.36 //y=3.725 //x2=56.58 //y2=3.5
cc_4629 ( N_noxref_12_c_5956_p N_noxref_15_c_8720_n ) capacitor c=0.00895951f \
 //x=56.36 //y=4.045 //x2=56.58 //y2=3.5
cc_4630 ( N_noxref_12_c_5865_n N_noxref_15_c_8720_n ) capacitor c=0.128059f \
 //x=58.055 //y=3.88 //x2=56.58 //y2=3.5
cc_4631 ( N_noxref_12_c_5958_p N_noxref_15_c_8720_n ) capacitor c=0.0358686f \
 //x=56.525 //y=3.885 //x2=56.58 //y2=3.5
cc_4632 ( N_noxref_12_c_5800_n N_noxref_15_c_8721_n ) capacitor c=0.0032763f \
 //x=56.36 //y=3.725 //x2=56.15 //y2=3.5
cc_4633 ( N_noxref_12_c_5807_n N_noxref_15_c_8722_n ) capacitor c=4.95266e-19 \
 //x=58.21 //y=3.72 //x2=57.83 //y2=3.51
cc_4634 ( N_noxref_12_c_5865_n N_noxref_15_c_8722_n ) capacitor c=0.0120328f \
 //x=58.055 //y=3.88 //x2=57.83 //y2=3.51
cc_4635 ( N_noxref_12_c_5807_n N_noxref_15_c_8886_n ) capacitor c=0.023561f \
 //x=58.21 //y=3.72 //x2=58.43 //y2=3.495
cc_4636 ( N_noxref_12_c_5814_n N_noxref_15_c_8886_n ) capacitor c=0.00797853f \
 //x=58.21 //y=4.04 //x2=58.43 //y2=3.495
cc_4637 ( N_noxref_12_c_5819_n N_noxref_15_c_8886_n ) capacitor c=0.0467915f \
 //x=61.045 //y=3.895 //x2=58.43 //y2=3.495
cc_4638 ( N_noxref_12_c_5866_n N_noxref_15_c_8889_n ) capacitor c=0.127201f \
 //x=61.39 //y=3.895 //x2=62.86 //y2=3.51
cc_4639 ( N_noxref_12_c_5868_n N_noxref_15_c_8889_n ) capacitor c=0.0107648f \
 //x=62.635 //y=3.88 //x2=62.86 //y2=3.51
cc_4640 ( N_noxref_12_c_5807_n N_noxref_15_c_8723_n ) capacitor c=3.74821e-19 \
 //x=58.21 //y=3.72 //x2=61.335 //y2=3.51
cc_4641 ( N_noxref_12_c_5819_n N_noxref_15_c_8723_n ) capacitor c=0.249041f \
 //x=61.045 //y=3.895 //x2=61.335 //y2=3.51
cc_4642 ( N_noxref_12_c_5868_n N_noxref_15_c_8893_n ) capacitor c=0.0358254f \
 //x=62.635 //y=3.88 //x2=63.18 //y2=3.51
cc_4643 ( N_noxref_12_c_5871_n N_noxref_15_c_8894_n ) capacitor c=0.128042f \
 //x=64.715 //y=3.9 //x2=66.195 //y2=3.51
cc_4644 ( N_noxref_12_c_5872_n N_noxref_15_c_8894_n ) capacitor c=0.0106805f \
 //x=65.97 //y=3.88 //x2=66.195 //y2=3.51
cc_4645 ( N_noxref_12_c_5880_p N_noxref_15_c_8896_n ) capacitor c=0.0239158f \
 //x=71.16 //y=3.72 //x2=71.365 //y2=3.495
cc_4646 ( N_noxref_12_c_5881_p N_noxref_15_c_8896_n ) capacitor c=0.00498907f \
 //x=71.16 //y=4.04 //x2=71.365 //y2=3.495
cc_4647 ( N_noxref_12_c_5884_p N_noxref_15_c_8896_n ) capacitor c=0.0358686f \
 //x=69.53 //y=3.87 //x2=71.365 //y2=3.495
cc_4648 ( N_noxref_12_c_5880_p N_noxref_15_c_8785_n ) capacitor c=4.60827e-19 \
 //x=71.16 //y=3.72 //x2=70.935 //y2=3.495
cc_4649 ( N_noxref_12_c_5881_p N_noxref_15_c_8785_n ) capacitor c=0.0031005f \
 //x=71.16 //y=4.04 //x2=70.935 //y2=3.495
cc_4650 ( N_noxref_12_c_5872_n N_noxref_15_c_8785_n ) capacitor c=0.0358254f \
 //x=65.97 //y=3.88 //x2=70.935 //y2=3.495
cc_4651 ( N_noxref_12_c_5873_n N_noxref_15_c_8785_n ) capacitor c=0.213726f \
 //x=66.57 //y=3.9 //x2=70.935 //y2=3.495
cc_4652 ( N_noxref_12_c_5875_n N_noxref_15_c_8785_n ) capacitor c=0.0571466f \
 //x=68.93 //y=3.88 //x2=70.935 //y2=3.495
cc_4653 ( N_noxref_12_c_5884_p N_noxref_15_c_8785_n ) capacitor c=0.121281f \
 //x=69.53 //y=3.87 //x2=70.935 //y2=3.495
cc_4654 ( N_noxref_12_c_5869_n N_noxref_15_c_8905_n ) capacitor c=0.0809352f \
 //x=63.235 //y=3.895 //x2=64.34 //y2=3.515
cc_4655 ( N_noxref_12_c_5870_n N_noxref_15_c_8905_n ) capacitor c=0.0231516f \
 //x=63.98 //y=3.865 //x2=64.34 //y2=3.515
cc_4656 ( N_noxref_12_c_5870_n N_noxref_15_c_8907_n ) capacitor c=0.0358254f \
 //x=63.98 //y=3.865 //x2=64.66 //y2=3.515
cc_4657 ( N_noxref_12_c_5800_n N_noxref_15_c_8786_n ) capacitor c=0.0015536f \
 //x=56.36 //y=3.725 //x2=55.62 //y2=2.26
cc_4658 ( N_noxref_12_c_5853_n N_noxref_15_c_8790_n ) capacitor c=0.00130631f \
 //x=56.275 //y=5.335 //x2=55.62 //y2=4.88
cc_4659 ( N_noxref_12_c_5803_n N_noxref_15_c_8790_n ) capacitor c=0.00131258f \
 //x=56.36 //y=5.25 //x2=55.62 //y2=4.88
cc_4660 ( N_noxref_12_c_6012_p N_noxref_15_c_8790_n ) capacitor c=0.00346456f \
 //x=55.58 //y=5.335 //x2=55.62 //y2=4.88
cc_4661 ( N_noxref_12_c_6015_p N_noxref_15_c_8790_n ) capacitor c=0.00624059f \
 //x=55.58 //y=5.56 //x2=55.62 //y2=4.88
cc_4662 ( N_noxref_12_M124_noxref_g N_noxref_15_c_8913_n ) capacitor \
 c=0.0162284f //x=58.41 //y=6.2 //x2=58.63 //y2=5.56
cc_4663 ( N_noxref_12_M125_noxref_g N_noxref_15_c_8913_n ) capacitor \
 c=0.0179041f //x=58.85 //y=6.2 //x2=58.63 //y2=5.56
cc_4664 ( N_noxref_12_c_5841_n N_noxref_15_c_8913_n ) capacitor c=0.00291477f \
 //x=58.775 //y=4.97 //x2=58.63 //y2=5.56
cc_4665 ( N_noxref_12_c_5852_n N_noxref_15_M122_noxref_g ) capacitor \
 c=0.00955829f //x=55.465 //y=5.335 //x2=55.36 //y2=6.2
cc_4666 ( N_noxref_12_c_6034_p N_noxref_15_M122_noxref_g ) capacitor \
 c=0.00226521f //x=55.58 //y=5.56 //x2=55.36 //y2=6.2
cc_4667 ( N_noxref_12_c_6015_p N_noxref_15_M122_noxref_g ) capacitor \
 c=0.0178885f //x=55.58 //y=5.56 //x2=55.36 //y2=6.2
cc_4668 ( N_noxref_12_c_6034_p N_noxref_15_M123_noxref_g ) capacitor \
 c=0.00381703f //x=55.58 //y=5.56 //x2=55.8 //y2=6.2
cc_4669 ( N_noxref_12_c_5853_n N_noxref_15_M123_noxref_g ) capacitor \
 c=0.0110526f //x=56.275 //y=5.335 //x2=55.8 //y2=6.2
cc_4670 ( N_noxref_12_c_6015_p N_noxref_15_M123_noxref_g ) capacitor \
 c=0.0188608f //x=55.58 //y=5.56 //x2=55.8 //y2=6.2
cc_4671 ( N_noxref_12_c_5900_p N_noxref_15_c_8806_n ) capacitor c=4.64015e-19 \
 //x=55.875 //y=1.305 //x2=55.61 //y2=1.095
cc_4672 ( N_noxref_12_M34_noxref_d N_noxref_15_c_8806_n ) capacitor \
 c=0.00137165f //x=55.685 //y=1.095 //x2=55.61 //y2=1.095
cc_4673 ( N_noxref_12_c_5900_p N_noxref_15_c_8807_n ) capacitor c=0.0026012f \
 //x=55.875 //y=1.305 //x2=55.61 //y2=1.44
cc_4674 ( N_noxref_12_c_5996_p N_noxref_15_c_8807_n ) capacitor c=0.00127432f \
 //x=55.875 //y=1.76 //x2=55.61 //y2=1.44
cc_4675 ( N_noxref_12_M34_noxref_d N_noxref_15_c_8807_n ) capacitor \
 c=0.00237422f //x=55.685 //y=1.095 //x2=55.61 //y2=1.44
cc_4676 ( N_noxref_12_c_5996_p N_noxref_15_c_8808_n ) capacitor c=0.00429966f \
 //x=55.875 //y=1.76 //x2=55.61 //y2=1.75
cc_4677 ( N_noxref_12_c_5900_p N_noxref_15_c_8928_n ) capacitor c=5.29969e-19 \
 //x=55.875 //y=1.305 //x2=55.985 //y2=0.94
cc_4678 ( N_noxref_12_M34_noxref_d N_noxref_15_c_8928_n ) capacitor \
 c=0.0020782f //x=55.685 //y=1.095 //x2=55.985 //y2=0.94
cc_4679 ( N_noxref_12_c_5900_p N_noxref_15_c_8930_n ) capacitor c=5.01408e-19 \
 //x=55.875 //y=1.305 //x2=55.985 //y2=1.595
cc_4680 ( N_noxref_12_c_5996_p N_noxref_15_c_8930_n ) capacitor c=0.00942306f \
 //x=55.875 //y=1.76 //x2=55.985 //y2=1.595
cc_4681 ( N_noxref_12_c_6017_p N_noxref_15_c_8930_n ) capacitor c=0.00194716f \
 //x=56.275 //y=1.845 //x2=55.985 //y2=1.595
cc_4682 ( N_noxref_12_M34_noxref_d N_noxref_15_c_8930_n ) capacitor \
 c=0.00356097f //x=55.685 //y=1.095 //x2=55.985 //y2=1.595
cc_4683 ( N_noxref_12_c_5900_p N_noxref_15_c_8934_n ) capacitor c=5.24634e-19 \
 //x=55.875 //y=1.305 //x2=56.14 //y2=1.095
cc_4684 ( N_noxref_12_M34_noxref_d N_noxref_15_c_8934_n ) capacitor \
 c=0.00139206f //x=55.685 //y=1.095 //x2=56.14 //y2=1.095
cc_4685 ( N_noxref_12_c_5900_p N_noxref_15_c_8936_n ) capacitor c=0.00307978f \
 //x=55.875 //y=1.305 //x2=56.14 //y2=1.44
cc_4686 ( N_noxref_12_c_5996_p N_noxref_15_c_8936_n ) capacitor c=0.00363411f \
 //x=55.875 //y=1.76 //x2=56.14 //y2=1.44
cc_4687 ( N_noxref_12_c_6017_p N_noxref_15_c_8936_n ) capacitor c=0.00323576f \
 //x=56.275 //y=1.845 //x2=56.14 //y2=1.44
cc_4688 ( N_noxref_12_M34_noxref_d N_noxref_15_c_8936_n ) capacitor \
 c=0.00237422f //x=55.685 //y=1.095 //x2=56.14 //y2=1.44
cc_4689 ( N_noxref_12_c_5800_n N_noxref_15_c_8826_n ) capacitor c=0.0024584f \
 //x=56.36 //y=3.725 //x2=55.62 //y2=2.26
cc_4690 ( N_noxref_12_c_5996_p N_noxref_15_c_8829_n ) capacitor c=0.00362297f \
 //x=55.875 //y=1.76 //x2=55.62 //y2=2.095
cc_4691 ( N_noxref_12_c_5800_n N_noxref_15_c_8829_n ) capacitor c=0.00282067f \
 //x=56.36 //y=3.725 //x2=55.62 //y2=2.095
cc_4692 ( N_noxref_12_c_5803_n N_noxref_15_c_8830_n ) capacitor c=0.00739875f \
 //x=56.36 //y=5.25 //x2=55.62 //y2=4.88
cc_4693 ( N_noxref_12_c_6012_p N_noxref_15_c_8830_n ) capacitor c=0.00203307f \
 //x=55.58 //y=5.335 //x2=55.62 //y2=4.88
cc_4694 ( N_noxref_12_c_6015_p N_noxref_15_c_8830_n ) capacitor c=0.00375636f \
 //x=55.58 //y=5.56 //x2=55.62 //y2=4.88
cc_4695 ( N_noxref_12_c_5800_n N_noxref_16_c_10102_n ) capacitor c=7.06471e-19 \
 //x=56.36 //y=3.725 //x2=55.835 //y2=3.125
cc_4696 ( N_noxref_12_c_5800_n N_noxref_16_c_10103_n ) capacitor c=0.0230402f \
 //x=56.36 //y=3.725 //x2=58.935 //y2=3.14
cc_4697 ( N_noxref_12_c_5807_n N_noxref_16_c_10103_n ) capacitor c=0.0250812f \
 //x=58.21 //y=3.72 //x2=58.935 //y2=3.14
cc_4698 ( N_noxref_12_c_5865_n N_noxref_16_c_10103_n ) capacitor c=0.0105804f \
 //x=58.055 //y=3.88 //x2=58.935 //y2=3.14
cc_4699 ( N_noxref_12_c_5819_n N_noxref_16_c_10103_n ) capacitor c=0.0105576f \
 //x=61.045 //y=3.895 //x2=58.935 //y2=3.14
cc_4700 ( N_noxref_12_c_5819_n N_noxref_16_c_10107_n ) capacitor c=0.0101814f \
 //x=61.045 //y=3.895 //x2=59.535 //y2=3.155
cc_4701 ( N_noxref_12_c_5819_n N_noxref_16_c_10139_n ) capacitor c=0.00198889f \
 //x=61.045 //y=3.895 //x2=60.79 //y2=3.14
cc_4702 ( N_noxref_12_c_5866_n N_noxref_16_c_10140_n ) capacitor c=0.0064155f \
 //x=61.39 //y=3.895 //x2=61.39 //y2=3.125
cc_4703 ( N_noxref_12_c_5868_n N_noxref_16_c_10141_n ) capacitor c=0.00652349f \
 //x=62.635 //y=3.88 //x2=62.635 //y2=3.14
cc_4704 ( N_noxref_12_c_5869_n N_noxref_16_c_10142_n ) capacitor c=0.00571705f \
 //x=63.235 //y=3.895 //x2=63.235 //y2=3.125
cc_4705 ( N_noxref_12_c_5870_n N_noxref_16_c_10143_n ) capacitor c=0.00550589f \
 //x=63.98 //y=3.865 //x2=64.115 //y2=3.14
cc_4706 ( N_noxref_12_c_5871_n N_noxref_16_c_10144_n ) capacitor c=0.00641799f \
 //x=64.715 //y=3.9 //x2=64.715 //y2=3.13
cc_4707 ( N_noxref_12_c_5872_n N_noxref_16_c_10145_n ) capacitor c=0.00628088f \
 //x=65.97 //y=3.88 //x2=65.97 //y2=3.14
cc_4708 ( N_noxref_12_c_5873_n N_noxref_16_c_10131_n ) capacitor c=0.0118265f \
 //x=66.57 //y=3.9 //x2=66.57 //y2=3.13
cc_4709 ( N_noxref_12_c_5880_p N_noxref_16_c_10132_n ) capacitor c=0.0272422f \
 //x=71.16 //y=3.72 //x2=78.535 //y2=3.14
cc_4710 ( N_noxref_12_c_5875_n N_noxref_16_c_10132_n ) capacitor c=0.0134262f \
 //x=68.93 //y=3.88 //x2=78.535 //y2=3.14
cc_4711 ( N_noxref_12_c_5884_p N_noxref_16_c_10132_n ) capacitor c=0.00952419f \
 //x=69.53 //y=3.87 //x2=78.535 //y2=3.14
cc_4712 ( N_noxref_12_c_5880_p N_noxref_17_c_10669_n ) capacitor c=0.00149614f \
 //x=71.16 //y=3.72 //x2=73.38 //y2=3.705
cc_4713 ( N_noxref_12_c_5882_p N_noxref_17_c_10670_n ) capacitor c=0.00110871f \
 //x=71.16 //y=4.755 //x2=73.38 //y2=4.75
cc_4714 ( N_noxref_12_c_5883_p N_noxref_17_c_10671_n ) capacitor c=8.86295e-19 \
 //x=71.15 //y=3.88 //x2=73.38 //y2=3.88
cc_4715 ( N_noxref_12_c_5884_p N_noxref_17_c_10672_n ) capacitor c=0.00232834f \
 //x=69.53 //y=3.87 //x2=73.54 //y2=3.865
cc_4716 ( N_noxref_12_c_5847_n N_VDD_c_11464_n ) capacitor c=0.00599866f \
 //x=54.58 //y=5.335 //x2=78.895 //y2=7.585
cc_4717 ( N_noxref_12_c_5852_n N_VDD_c_11464_n ) capacitor c=0.00627191f \
 //x=55.465 //y=5.335 //x2=78.895 //y2=7.585
cc_4718 ( N_noxref_12_c_6034_p N_VDD_c_11464_n ) capacitor c=0.00256019f \
 //x=55.58 //y=5.56 //x2=78.895 //y2=7.585
cc_4719 ( N_noxref_12_c_5853_n N_VDD_c_11464_n ) capacitor c=0.00829248f \
 //x=56.275 //y=5.335 //x2=78.895 //y2=7.585
cc_4720 ( N_noxref_12_c_5956_p N_VDD_c_11464_n ) capacitor c=5.1373e-19 \
 //x=56.36 //y=4.045 //x2=78.895 //y2=7.585
cc_4721 ( N_noxref_12_c_5814_n N_VDD_c_11464_n ) capacitor c=3.34593e-19 \
 //x=58.21 //y=4.04 //x2=78.895 //y2=7.585
cc_4722 ( N_noxref_12_c_5881_p N_VDD_c_11464_n ) capacitor c=4.0659e-19 \
 //x=71.16 //y=4.04 //x2=78.895 //y2=7.585
cc_4723 ( N_noxref_12_c_5858_n N_VDD_c_11464_n ) capacitor c=0.00261804f \
 //x=53.822 //y=5.335 //x2=78.895 //y2=7.585
cc_4724 ( N_noxref_12_c_5859_n N_VDD_c_11464_n ) capacitor c=0.00262723f \
 //x=54.7 //y=5.335 //x2=78.895 //y2=7.585
cc_4725 ( N_noxref_12_c_5990_p N_VDD_c_11464_n ) capacitor c=0.0024232f \
 //x=53.82 //y=5.56 //x2=78.895 //y2=7.585
cc_4726 ( N_noxref_12_c_5876_n N_VDD_c_11464_n ) capacitor c=0.0024232f \
 //x=54.7 //y=5.56 //x2=78.895 //y2=7.585
cc_4727 ( N_noxref_12_c_6015_p N_VDD_c_11464_n ) capacitor c=0.0024232f \
 //x=55.58 //y=5.56 //x2=78.895 //y2=7.585
cc_4728 ( N_noxref_12_c_5847_n N_VDD_c_12177_n ) capacitor c=0.00202922f \
 //x=54.58 //y=5.335 //x2=54.175 //y2=7.585
cc_4729 ( N_noxref_12_c_5858_n N_VDD_c_12177_n ) capacitor c=9.3757e-19 \
 //x=53.822 //y=5.335 //x2=54.175 //y2=7.585
cc_4730 ( N_noxref_12_c_5990_p N_VDD_c_12177_n ) capacitor c=0.0138074f \
 //x=53.82 //y=5.56 //x2=54.175 //y2=7.585
cc_4731 ( N_noxref_12_c_5847_n N_VDD_c_12117_n ) capacitor c=0.0017708f \
 //x=54.58 //y=5.335 //x2=55.055 //y2=7.585
cc_4732 ( N_noxref_12_c_5852_n N_VDD_c_12117_n ) capacitor c=0.00202922f \
 //x=55.465 //y=5.335 //x2=55.055 //y2=7.585
cc_4733 ( N_noxref_12_c_5859_n N_VDD_c_12117_n ) capacitor c=9.4822e-19 \
 //x=54.7 //y=5.335 //x2=55.055 //y2=7.585
cc_4734 ( N_noxref_12_c_5876_n N_VDD_c_12117_n ) capacitor c=0.0138074f \
 //x=54.7 //y=5.56 //x2=55.055 //y2=7.585
cc_4735 ( N_noxref_12_c_5852_n N_VDD_c_12184_n ) capacitor c=0.00205906f \
 //x=55.465 //y=5.335 //x2=55.935 //y2=7.585
cc_4736 ( N_noxref_12_c_6034_p N_VDD_c_12184_n ) capacitor c=8.49654e-19 \
 //x=55.58 //y=5.56 //x2=55.935 //y2=7.585
cc_4737 ( N_noxref_12_c_5853_n N_VDD_c_12184_n ) capacitor c=0.00204238f \
 //x=56.275 //y=5.335 //x2=55.935 //y2=7.585
cc_4738 ( N_noxref_12_c_6015_p N_VDD_c_12184_n ) capacitor c=0.0138074f \
 //x=55.58 //y=5.56 //x2=55.935 //y2=7.585
cc_4739 ( N_noxref_12_c_5853_n N_VDD_c_12188_n ) capacitor c=0.00183742f \
 //x=56.275 //y=5.335 //x2=56.93 //y2=7.585
cc_4740 ( N_noxref_12_M124_noxref_g N_VDD_c_12189_n ) capacitor c=0.00755614f \
 //x=58.41 //y=6.2 //x2=58.985 //y2=7.585
cc_4741 ( N_noxref_12_M125_noxref_g N_VDD_c_12189_n ) capacitor c=0.00755544f \
 //x=58.85 //y=6.2 //x2=58.985 //y2=7.585
cc_4742 ( N_noxref_12_M140_noxref_g N_VDD_c_12191_n ) capacitor c=0.00755614f \
 //x=71.36 //y=6.2 //x2=71.935 //y2=7.585
cc_4743 ( N_noxref_12_M141_noxref_g N_VDD_c_12191_n ) capacitor c=0.00755544f \
 //x=71.8 //y=6.2 //x2=71.935 //y2=7.585
cc_4744 ( N_noxref_12_c_5858_n N_VDD_c_12066_n ) capacitor c=0.0022955f \
 //x=53.822 //y=5.335 //x2=52.29 //y2=7.585
cc_4745 ( N_noxref_12_c_5990_p N_VDD_c_12066_n ) capacitor c=0.00508013f \
 //x=53.82 //y=5.56 //x2=52.29 //y2=7.585
cc_4746 ( N_noxref_12_c_6034_p N_VDD_c_12135_n ) capacitor c=0.00282782f \
 //x=55.58 //y=5.56 //x2=57.1 //y2=7.585
cc_4747 ( N_noxref_12_c_5803_n N_VDD_c_12135_n ) capacitor c=0.0325571f \
 //x=56.36 //y=5.25 //x2=57.1 //y2=7.585
cc_4748 ( N_noxref_12_c_5815_n N_VDD_c_12135_n ) capacitor c=0.0118976f \
 //x=58.21 //y=4.755 //x2=57.1 //y2=7.585
cc_4749 ( N_noxref_12_c_6015_p N_VDD_c_12135_n ) capacitor c=0.00777981f \
 //x=55.58 //y=5.56 //x2=57.1 //y2=7.585
cc_4750 ( N_noxref_12_c_5824_n N_VDD_c_12135_n ) capacitor c=0.00370784f \
 //x=58.21 //y=4.88 //x2=57.1 //y2=7.585
cc_4751 ( N_noxref_12_c_5844_n N_VDD_c_12135_n ) capacitor c=0.00590568f \
 //x=58.485 //y=4.97 //x2=57.1 //y2=7.585
cc_4752 ( N_noxref_12_c_5882_p N_VDD_c_12201_n ) capacitor c=0.0138211f \
 //x=71.16 //y=4.755 //x2=70.05 //y2=7.585
cc_4753 ( N_noxref_12_c_5885_p N_VDD_c_12201_n ) capacitor c=0.00370784f \
 //x=71.16 //y=4.88 //x2=70.05 //y2=7.585
cc_4754 ( N_noxref_12_c_5899_p N_VDD_c_12201_n ) capacitor c=0.00590568f \
 //x=71.435 //y=4.97 //x2=70.05 //y2=7.585
cc_4755 ( N_noxref_12_c_5858_n N_VDD_M114_noxref_s ) capacitor c=4.22189e-19 \
 //x=53.822 //y=5.335 //x2=49.615 //y2=5.2
cc_4756 ( N_noxref_12_c_5858_n N_VDD_M118_noxref_s ) capacitor c=0.0442713f \
 //x=53.822 //y=5.335 //x2=53.245 //y2=5.2
cc_4757 ( N_noxref_12_c_5859_n N_VDD_M118_noxref_s ) capacitor c=7.80122e-19 \
 //x=54.7 //y=5.335 //x2=53.245 //y2=5.2
cc_4758 ( N_noxref_12_c_5990_p N_VDD_M118_noxref_s ) capacitor c=0.0908457f \
 //x=53.82 //y=5.56 //x2=53.245 //y2=5.2
cc_4759 ( N_noxref_12_c_5847_n N_VDD_M119_noxref_d ) capacitor c=0.00700141f \
 //x=54.58 //y=5.335 //x2=54.115 //y2=5.2
cc_4760 ( N_noxref_12_c_5990_p N_VDD_M119_noxref_d ) capacitor c=0.0673792f \
 //x=53.82 //y=5.56 //x2=54.115 //y2=5.2
cc_4761 ( N_noxref_12_c_5876_n N_VDD_M119_noxref_d ) capacitor c=0.0674762f \
 //x=54.7 //y=5.56 //x2=54.115 //y2=5.2
cc_4762 ( N_noxref_12_c_5852_n N_VDD_M121_noxref_d ) capacitor c=0.00700141f \
 //x=55.465 //y=5.335 //x2=54.995 //y2=5.2
cc_4763 ( N_noxref_12_c_5876_n N_VDD_M121_noxref_d ) capacitor c=0.067493f \
 //x=54.7 //y=5.56 //x2=54.995 //y2=5.2
cc_4764 ( N_noxref_12_c_6015_p N_VDD_M121_noxref_d ) capacitor c=0.0674979f \
 //x=55.58 //y=5.56 //x2=54.995 //y2=5.2
cc_4765 ( N_noxref_12_c_5853_n N_VDD_M123_noxref_d ) capacitor c=0.00700141f \
 //x=56.275 //y=5.335 //x2=55.875 //y2=5.2
cc_4766 ( N_noxref_12_c_6015_p N_VDD_M123_noxref_d ) capacitor c=0.0675002f \
 //x=55.58 //y=5.56 //x2=55.875 //y2=5.2
cc_4767 ( N_noxref_12_c_6034_p N_VDD_M124_noxref_s ) capacitor c=0.00492616f \
 //x=55.58 //y=5.56 //x2=58.055 //y2=5.2
cc_4768 ( N_noxref_12_c_5853_n N_VDD_M124_noxref_s ) capacitor c=9.42705e-19 \
 //x=56.275 //y=5.335 //x2=58.055 //y2=5.2
cc_4769 ( N_noxref_12_c_5814_n N_VDD_M124_noxref_s ) capacitor c=7.08613e-19 \
 //x=58.21 //y=4.04 //x2=58.055 //y2=5.2
cc_4770 ( N_noxref_12_c_5815_n N_VDD_M124_noxref_s ) capacitor c=0.0217981f \
 //x=58.21 //y=4.755 //x2=58.055 //y2=5.2
cc_4771 ( N_noxref_12_c_5859_n N_VDD_M124_noxref_s ) capacitor c=2.11884e-19 \
 //x=54.7 //y=5.335 //x2=58.055 //y2=5.2
cc_4772 ( N_noxref_12_c_5824_n N_VDD_M124_noxref_s ) capacitor c=0.00983846f \
 //x=58.21 //y=4.88 //x2=58.055 //y2=5.2
cc_4773 ( N_noxref_12_M124_noxref_g N_VDD_M124_noxref_s ) capacitor \
 c=0.053419f //x=58.41 //y=6.2 //x2=58.055 //y2=5.2
cc_4774 ( N_noxref_12_c_5844_n N_VDD_M124_noxref_s ) capacitor c=0.00604424f \
 //x=58.485 //y=4.97 //x2=58.055 //y2=5.2
cc_4775 ( N_noxref_12_M125_noxref_g N_VDD_M125_noxref_d ) capacitor \
 c=0.015318f //x=58.85 //y=6.2 //x2=58.925 //y2=5.2
cc_4776 ( N_noxref_12_c_5881_p N_VDD_M140_noxref_s ) capacitor c=7.3096e-19 \
 //x=71.16 //y=4.04 //x2=71.005 //y2=5.2
cc_4777 ( N_noxref_12_c_5882_p N_VDD_M140_noxref_s ) capacitor c=0.0224408f \
 //x=71.16 //y=4.755 //x2=71.005 //y2=5.2
cc_4778 ( N_noxref_12_c_5885_p N_VDD_M140_noxref_s ) capacitor c=0.00983846f \
 //x=71.16 //y=4.88 //x2=71.005 //y2=5.2
cc_4779 ( N_noxref_12_M140_noxref_g N_VDD_M140_noxref_s ) capacitor \
 c=0.053419f //x=71.36 //y=6.2 //x2=71.005 //y2=5.2
cc_4780 ( N_noxref_12_c_5899_p N_VDD_M140_noxref_s ) capacitor c=0.00604424f \
 //x=71.435 //y=4.97 //x2=71.005 //y2=5.2
cc_4781 ( N_noxref_12_M141_noxref_g N_VDD_M141_noxref_d ) capacitor \
 c=0.015318f //x=71.8 //y=6.2 //x2=71.875 //y2=5.2
cc_4782 ( N_noxref_12_c_5900_p N_noxref_28_c_13413_n ) capacitor c=0.0036878f \
 //x=55.875 //y=1.305 //x2=56.275 //y2=0.72
cc_4783 ( N_noxref_12_c_6017_p N_noxref_28_c_13413_n ) capacitor c=0.00399931f \
 //x=56.275 //y=1.845 //x2=56.275 //y2=0.72
cc_4784 ( N_noxref_12_M34_noxref_d N_noxref_28_c_13413_n ) capacitor \
 c=0.00910163f //x=55.685 //y=1.095 //x2=56.275 //y2=0.72
cc_4785 ( N_noxref_12_M34_noxref_d N_noxref_28_c_13416_n ) capacitor \
 c=0.00120711f //x=55.685 //y=1.095 //x2=55.39 //y2=1.175
cc_4786 ( N_noxref_12_c_5847_n N_noxref_28_M33_noxref_d ) capacitor \
 c=0.0014598f //x=54.58 //y=5.335 //x2=54.15 //y2=1.09
cc_4787 ( N_noxref_12_c_5900_p N_noxref_28_M33_noxref_d ) capacitor \
 c=0.00802417f //x=55.875 //y=1.305 //x2=54.15 //y2=1.09
cc_4788 ( N_noxref_12_c_5900_p N_noxref_28_M34_noxref_s ) capacitor \
 c=0.0098487f //x=55.875 //y=1.305 //x2=55.255 //y2=0.555
cc_4789 ( N_noxref_12_c_5996_p N_noxref_28_M34_noxref_s ) capacitor \
 c=0.0283111f //x=55.875 //y=1.76 //x2=55.255 //y2=0.555
cc_4790 ( N_noxref_12_c_6017_p N_noxref_28_M34_noxref_s ) capacitor \
 c=0.00911719f //x=56.275 //y=1.845 //x2=55.255 //y2=0.555
cc_4791 ( N_noxref_12_c_6013_p N_noxref_28_M34_noxref_s ) capacitor \
 c=0.00129723f //x=56.36 //y=3.88 //x2=55.255 //y2=0.555
cc_4792 ( N_noxref_12_M34_noxref_d N_noxref_28_M34_noxref_s ) capacitor \
 c=0.0279003f //x=55.685 //y=1.095 //x2=55.255 //y2=0.555
cc_4793 ( N_noxref_12_c_5900_p N_noxref_29_M36_noxref_d ) capacitor \
 c=3.20746e-19 //x=55.875 //y=1.305 //x2=58.96 //y2=1.09
cc_4794 ( N_noxref_12_c_5900_p N_GND_c_14416_n ) capacitor c=0.00884249f \
 //x=55.875 //y=1.305 //x2=58.09 //y2=0.175
cc_4795 ( N_noxref_12_c_6017_p N_GND_c_14416_n ) capacitor c=0.00662992f \
 //x=56.275 //y=1.845 //x2=58.09 //y2=0.175
cc_4796 ( N_noxref_12_c_5956_p N_GND_c_14416_n ) capacitor c=3.10289e-19 \
 //x=56.36 //y=4.045 //x2=58.09 //y2=0.175
cc_4797 ( N_noxref_12_M34_noxref_d N_GND_c_14416_n ) capacitor c=2.9462e-19 \
 //x=55.685 //y=1.095 //x2=58.09 //y2=0.175
cc_4798 ( N_noxref_12_c_5830_n N_GND_c_14422_n ) capacitor c=3.97665e-19 \
 //x=57.91 //y=1.055 //x2=58.175 //y2=1.015
cc_4799 ( N_noxref_12_c_6212_p N_GND_c_14422_n ) capacitor c=0.00864776f \
 //x=58.285 //y=0.9 //x2=58.175 //y2=1.015
cc_4800 ( N_noxref_12_c_5836_n N_GND_c_14422_n ) capacitor c=4.45447e-19 \
 //x=58.44 //y=1.055 //x2=58.175 //y2=1.015
cc_4801 ( N_noxref_12_c_5923_p N_GND_c_14425_n ) capacitor c=3.97665e-19 \
 //x=70.86 //y=1.055 //x2=71.125 //y2=1.015
cc_4802 ( N_noxref_12_c_6215_p N_GND_c_14425_n ) capacitor c=0.00864776f \
 //x=71.235 //y=0.9 //x2=71.125 //y2=1.015
cc_4803 ( N_noxref_12_c_5925_p N_GND_c_14425_n ) capacitor c=4.45447e-19 \
 //x=71.39 //y=1.055 //x2=71.125 //y2=1.015
cc_4804 ( N_noxref_12_c_5900_p N_GND_c_14428_n ) capacitor c=0.00543195f \
 //x=55.875 //y=1.305 //x2=58.175 //y2=1.145
cc_4805 ( N_noxref_12_c_5804_n N_GND_c_14428_n ) capacitor c=0.00772482f \
 //x=58.21 //y=2.375 //x2=58.175 //y2=1.145
cc_4806 ( N_noxref_12_c_5814_n N_GND_c_14428_n ) capacitor c=5.12587e-19 \
 //x=58.21 //y=4.04 //x2=58.175 //y2=1.145
cc_4807 ( N_noxref_12_c_5820_n N_GND_c_14428_n ) capacitor c=2.22883e-19 \
 //x=58.21 //y=2.26 //x2=58.175 //y2=1.145
cc_4808 ( N_noxref_12_c_5830_n N_GND_c_14428_n ) capacitor c=0.00156339f \
 //x=57.91 //y=1.055 //x2=58.175 //y2=1.145
cc_4809 ( N_noxref_12_c_5831_n N_GND_c_14428_n ) capacitor c=0.00352472f \
 //x=57.91 //y=1.4 //x2=58.175 //y2=1.145
cc_4810 ( N_noxref_12_c_5832_n N_GND_c_14428_n ) capacitor c=4.63388e-19 \
 //x=57.91 //y=1.71 //x2=58.175 //y2=1.145
cc_4811 ( N_noxref_12_c_6212_p N_GND_c_14428_n ) capacitor c=9.36995e-19 \
 //x=58.285 //y=0.9 //x2=58.175 //y2=1.145
cc_4812 ( N_noxref_12_c_6225_p N_GND_c_14428_n ) capacitor c=5.96388e-19 \
 //x=58.285 //y=1.555 //x2=58.175 //y2=1.145
cc_4813 ( N_noxref_12_c_5836_n N_GND_c_14428_n ) capacitor c=0.0017438f \
 //x=58.44 //y=1.055 //x2=58.175 //y2=1.145
cc_4814 ( N_noxref_12_c_5838_n N_GND_c_14428_n ) capacitor c=0.00276804f \
 //x=58.44 //y=1.4 //x2=58.175 //y2=1.145
cc_4815 ( N_noxref_12_c_5892_p N_GND_c_14439_n ) capacitor c=0.00772482f \
 //x=71.16 //y=2.375 //x2=71.125 //y2=1.145
cc_4816 ( N_noxref_12_c_5881_p N_GND_c_14439_n ) capacitor c=6.6735e-19 \
 //x=71.16 //y=4.04 //x2=71.125 //y2=1.145
cc_4817 ( N_noxref_12_c_5894_p N_GND_c_14439_n ) capacitor c=2.22883e-19 \
 //x=71.16 //y=2.26 //x2=71.125 //y2=1.145
cc_4818 ( N_noxref_12_c_5923_p N_GND_c_14439_n ) capacitor c=0.00156339f \
 //x=70.86 //y=1.055 //x2=71.125 //y2=1.145
cc_4819 ( N_noxref_12_c_5924_p N_GND_c_14439_n ) capacitor c=0.00352472f \
 //x=70.86 //y=1.4 //x2=71.125 //y2=1.145
cc_4820 ( N_noxref_12_c_5926_p N_GND_c_14439_n ) capacitor c=4.40631e-19 \
 //x=70.86 //y=1.71 //x2=71.125 //y2=1.145
cc_4821 ( N_noxref_12_c_6215_p N_GND_c_14439_n ) capacitor c=9.36995e-19 \
 //x=71.235 //y=0.9 //x2=71.125 //y2=1.145
cc_4822 ( N_noxref_12_c_6235_p N_GND_c_14439_n ) capacitor c=5.96388e-19 \
 //x=71.235 //y=1.555 //x2=71.125 //y2=1.145
cc_4823 ( N_noxref_12_c_5925_p N_GND_c_14439_n ) capacitor c=0.0017438f \
 //x=71.39 //y=1.055 //x2=71.125 //y2=1.145
cc_4824 ( N_noxref_12_c_5927_p N_GND_c_14439_n ) capacitor c=0.00276804f \
 //x=71.39 //y=1.4 //x2=71.125 //y2=1.145
cc_4825 ( N_noxref_12_c_6017_p N_GND_c_14449_n ) capacitor c=6.86343e-19 \
 //x=56.275 //y=1.845 //x2=56.93 //y2=0.175
cc_4826 ( N_noxref_12_c_5830_n N_GND_c_14450_n ) capacitor c=0.00677766f \
 //x=57.91 //y=1.055 //x2=61.74 //y2=0.175
cc_4827 ( N_noxref_12_c_5923_p N_GND_c_14451_n ) capacitor c=0.00677766f \
 //x=70.86 //y=1.055 //x2=74.69 //y2=0.175
cc_4828 ( N_noxref_12_c_5996_p N_GND_c_14409_n ) capacitor c=0.0045138f \
 //x=55.875 //y=1.76 //x2=57.1 //y2=0.175
cc_4829 ( N_noxref_12_c_6017_p N_GND_c_14409_n ) capacitor c=0.030601f \
 //x=56.275 //y=1.845 //x2=57.1 //y2=0.175
cc_4830 ( N_noxref_12_c_5804_n N_GND_c_14409_n ) capacitor c=0.00380125f \
 //x=58.21 //y=2.375 //x2=57.1 //y2=0.175
cc_4831 ( N_noxref_12_c_5807_n N_GND_c_14409_n ) capacitor c=0.00735019f \
 //x=58.21 //y=3.72 //x2=57.1 //y2=0.175
cc_4832 ( N_noxref_12_c_5820_n N_GND_c_14409_n ) capacitor c=0.00379567f \
 //x=58.21 //y=2.26 //x2=57.1 //y2=0.175
cc_4833 ( N_noxref_12_c_5832_n N_GND_c_14409_n ) capacitor c=0.00170145f \
 //x=57.91 //y=1.71 //x2=57.1 //y2=0.175
cc_4834 ( N_noxref_12_c_5833_n N_GND_c_14409_n ) capacitor c=0.0102191f \
 //x=57.91 //y=2.095 //x2=57.1 //y2=0.175
cc_4835 ( N_noxref_12_c_5892_p N_GND_c_14459_n ) capacitor c=0.00380125f \
 //x=71.16 //y=2.375 //x2=70.05 //y2=0.175
cc_4836 ( N_noxref_12_c_5880_p N_GND_c_14459_n ) capacitor c=0.0108616f \
 //x=71.16 //y=3.72 //x2=70.05 //y2=0.175
cc_4837 ( N_noxref_12_c_5894_p N_GND_c_14459_n ) capacitor c=0.00379567f \
 //x=71.16 //y=2.26 //x2=70.05 //y2=0.175
cc_4838 ( N_noxref_12_c_5926_p N_GND_c_14459_n ) capacitor c=0.00170145f \
 //x=70.86 //y=1.71 //x2=70.05 //y2=0.175
cc_4839 ( N_noxref_12_c_5895_p N_GND_c_14459_n ) capacitor c=0.0102191f \
 //x=70.86 //y=2.095 //x2=70.05 //y2=0.175
cc_4840 ( N_noxref_12_c_5804_n N_GND_M35_noxref_d ) capacitor c=4.4417e-19 \
 //x=58.21 //y=2.375 //x2=57.985 //y2=1.055
cc_4841 ( N_noxref_12_c_5830_n N_GND_M35_noxref_d ) capacitor c=0.00184354f \
 //x=57.91 //y=1.055 //x2=57.985 //y2=1.055
cc_4842 ( N_noxref_12_c_5831_n N_GND_M35_noxref_d ) capacitor c=0.00210798f \
 //x=57.91 //y=1.4 //x2=57.985 //y2=1.055
cc_4843 ( N_noxref_12_c_6212_p N_GND_M35_noxref_d ) capacitor c=0.00474029f \
 //x=58.285 //y=0.9 //x2=57.985 //y2=1.055
cc_4844 ( N_noxref_12_c_6225_p N_GND_M35_noxref_d ) capacitor c=0.00166857f \
 //x=58.285 //y=1.555 //x2=57.985 //y2=1.055
cc_4845 ( N_noxref_12_c_5836_n N_GND_M35_noxref_d ) capacitor c=0.00230174f \
 //x=58.44 //y=1.055 //x2=57.985 //y2=1.055
cc_4846 ( N_noxref_12_c_5838_n N_GND_M35_noxref_d ) capacitor c=0.00210798f \
 //x=58.44 //y=1.4 //x2=57.985 //y2=1.055
cc_4847 ( N_noxref_12_c_5892_p N_GND_M43_noxref_d ) capacitor c=4.4417e-19 \
 //x=71.16 //y=2.375 //x2=70.935 //y2=1.055
cc_4848 ( N_noxref_12_c_5923_p N_GND_M43_noxref_d ) capacitor c=0.00184354f \
 //x=70.86 //y=1.055 //x2=70.935 //y2=1.055
cc_4849 ( N_noxref_12_c_5924_p N_GND_M43_noxref_d ) capacitor c=0.00210798f \
 //x=70.86 //y=1.4 //x2=70.935 //y2=1.055
cc_4850 ( N_noxref_12_c_6215_p N_GND_M43_noxref_d ) capacitor c=0.00474029f \
 //x=71.235 //y=0.9 //x2=70.935 //y2=1.055
cc_4851 ( N_noxref_12_c_6235_p N_GND_M43_noxref_d ) capacitor c=0.00166857f \
 //x=71.235 //y=1.555 //x2=70.935 //y2=1.055
cc_4852 ( N_noxref_12_c_5925_p N_GND_M43_noxref_d ) capacitor c=0.00230174f \
 //x=71.39 //y=1.055 //x2=70.935 //y2=1.055
cc_4853 ( N_noxref_12_c_5927_p N_GND_M43_noxref_d ) capacitor c=0.00210798f \
 //x=71.39 //y=1.4 //x2=70.935 //y2=1.055
cc_4854 ( N_noxref_12_c_5833_n N_noxref_48_c_16336_n ) capacitor c=0.00262672f \
 //x=57.91 //y=2.095 //x2=57.69 //y2=1.685
cc_4855 ( N_noxref_12_c_5804_n N_noxref_48_c_16337_n ) capacitor c=0.00428451f \
 //x=58.21 //y=2.375 //x2=58.575 //y2=1.77
cc_4856 ( N_noxref_12_c_5814_n N_noxref_48_c_16337_n ) capacitor c=0.00142431f \
 //x=58.21 //y=4.04 //x2=58.575 //y2=1.77
cc_4857 ( N_noxref_12_c_5820_n N_noxref_48_c_16337_n ) capacitor c=0.0104666f \
 //x=58.21 //y=2.26 //x2=58.575 //y2=1.77
cc_4858 ( N_noxref_12_c_5832_n N_noxref_48_c_16337_n ) capacitor c=0.00705077f \
 //x=57.91 //y=1.71 //x2=58.575 //y2=1.77
cc_4859 ( N_noxref_12_c_5833_n N_noxref_48_c_16337_n ) capacitor c=0.020708f \
 //x=57.91 //y=2.095 //x2=58.575 //y2=1.77
cc_4860 ( N_noxref_12_c_6225_p N_noxref_48_c_16337_n ) capacitor c=0.00588627f \
 //x=58.285 //y=1.555 //x2=58.575 //y2=1.77
cc_4861 ( N_noxref_12_c_5838_n N_noxref_48_c_16337_n ) capacitor c=0.00698822f \
 //x=58.44 //y=1.4 //x2=58.575 //y2=1.77
cc_4862 ( N_noxref_12_c_5830_n N_noxref_48_M35_noxref_s ) capacitor \
 c=0.0295256f //x=57.91 //y=1.055 //x2=57.555 //y2=0.555
cc_4863 ( N_noxref_12_c_5832_n N_noxref_48_M35_noxref_s ) capacitor \
 c=7.99997e-19 //x=57.91 //y=1.71 //x2=57.555 //y2=0.555
cc_4864 ( N_noxref_12_c_5833_n N_noxref_48_M35_noxref_s ) capacitor \
 c=0.00122123f //x=57.91 //y=2.095 //x2=57.555 //y2=0.555
cc_4865 ( N_noxref_12_c_5836_n N_noxref_48_M35_noxref_s ) capacitor \
 c=0.0125924f //x=58.44 //y=1.055 //x2=57.555 //y2=0.555
cc_4866 ( N_noxref_12_c_5895_p N_noxref_51_c_16510_n ) capacitor c=0.00262672f \
 //x=70.86 //y=2.095 //x2=70.64 //y2=1.685
cc_4867 ( N_noxref_12_c_5892_p N_noxref_51_c_16511_n ) capacitor c=0.00428451f \
 //x=71.16 //y=2.375 //x2=71.525 //y2=1.77
cc_4868 ( N_noxref_12_c_5881_p N_noxref_51_c_16511_n ) capacitor c=0.00205403f \
 //x=71.16 //y=4.04 //x2=71.525 //y2=1.77
cc_4869 ( N_noxref_12_c_5894_p N_noxref_51_c_16511_n ) capacitor c=0.0104666f \
 //x=71.16 //y=2.26 //x2=71.525 //y2=1.77
cc_4870 ( N_noxref_12_c_5926_p N_noxref_51_c_16511_n ) capacitor c=0.00705077f \
 //x=70.86 //y=1.71 //x2=71.525 //y2=1.77
cc_4871 ( N_noxref_12_c_5895_p N_noxref_51_c_16511_n ) capacitor c=0.020708f \
 //x=70.86 //y=2.095 //x2=71.525 //y2=1.77
cc_4872 ( N_noxref_12_c_6235_p N_noxref_51_c_16511_n ) capacitor c=0.00588627f \
 //x=71.235 //y=1.555 //x2=71.525 //y2=1.77
cc_4873 ( N_noxref_12_c_5927_p N_noxref_51_c_16511_n ) capacitor c=0.00698822f \
 //x=71.39 //y=1.4 //x2=71.525 //y2=1.77
cc_4874 ( N_noxref_12_c_5923_p N_noxref_51_M43_noxref_s ) capacitor \
 c=0.0295256f //x=70.86 //y=1.055 //x2=70.505 //y2=0.555
cc_4875 ( N_noxref_12_c_5926_p N_noxref_51_M43_noxref_s ) capacitor \
 c=7.99997e-19 //x=70.86 //y=1.71 //x2=70.505 //y2=0.555
cc_4876 ( N_noxref_12_c_5895_p N_noxref_51_M43_noxref_s ) capacitor \
 c=0.00122123f //x=70.86 //y=2.095 //x2=70.505 //y2=0.555
cc_4877 ( N_noxref_12_c_5925_p N_noxref_51_M43_noxref_s ) capacitor \
 c=0.0125924f //x=71.39 //y=1.055 //x2=70.505 //y2=0.555
cc_4878 ( N_RN_c_6606_n N_noxref_14_c_7733_n ) capacitor c=0.017138f \
 //x=59.105 //y=2.385 //x2=53.4 //y2=2.375
cc_4879 ( N_RN_c_6606_n N_noxref_14_c_7727_n ) capacitor c=0.0143423f \
 //x=59.105 //y=2.385 //x2=53.4 //y2=4.1
cc_4880 ( N_RN_c_6911_n N_noxref_14_c_7812_n ) capacitor c=0.0140246f \
 //x=68.415 //y=2.315 //x2=63.76 //y2=4.09
cc_4881 ( N_RN_M138_noxref_g N_noxref_14_c_7756_n ) capacitor c=0.0103546f \
 //x=68.31 //y=6.2 //x2=68.415 //y2=5.335
cc_4882 ( N_RN_M138_noxref_g N_noxref_14_c_7874_n ) capacitor c=0.00226521f \
 //x=68.31 //y=6.2 //x2=68.53 //y2=5.56
cc_4883 ( N_RN_M139_noxref_g N_noxref_14_c_7874_n ) capacitor c=0.00381703f \
 //x=68.75 //y=6.2 //x2=68.53 //y2=5.56
cc_4884 ( N_RN_c_6884_n N_noxref_14_c_7876_n ) capacitor c=2.09588e-19 \
 //x=68.57 //y=2.465 //x2=69.225 //y2=5.335
cc_4885 ( N_RN_c_6888_n N_noxref_14_c_7876_n ) capacitor c=0.0023499f \
 //x=68.57 //y=4.75 //x2=69.225 //y2=5.335
cc_4886 ( N_RN_c_6931_n N_noxref_14_c_7876_n ) capacitor c=0.00130631f \
 //x=68.57 //y=4.88 //x2=69.225 //y2=5.335
cc_4887 ( N_RN_M139_noxref_g N_noxref_14_c_7876_n ) capacitor c=0.0112553f \
 //x=68.75 //y=6.2 //x2=69.225 //y2=5.335
cc_4888 ( N_RN_c_6884_n N_noxref_14_c_7880_n ) capacitor c=5.60322e-19 \
 //x=68.57 //y=2.465 //x2=68.825 //y2=1.305
cc_4889 ( N_RN_c_6915_n N_noxref_14_c_7880_n ) capacitor c=4.13793e-19 \
 //x=68.735 //y=2.315 //x2=68.825 //y2=1.305
cc_4890 ( N_RN_c_6949_n N_noxref_14_c_7880_n ) capacitor c=4.64015e-19 \
 //x=68.56 //y=1.095 //x2=68.825 //y2=1.305
cc_4891 ( N_RN_c_6950_n N_noxref_14_c_7880_n ) capacitor c=0.0026012f \
 //x=68.56 //y=1.44 //x2=68.825 //y2=1.305
cc_4892 ( N_RN_c_7045_p N_noxref_14_c_7880_n ) capacitor c=5.29969e-19 \
 //x=68.935 //y=0.94 //x2=68.825 //y2=1.305
cc_4893 ( N_RN_c_7046_p N_noxref_14_c_7880_n ) capacitor c=4.32061e-19 \
 //x=68.935 //y=1.595 //x2=68.825 //y2=1.305
cc_4894 ( N_RN_c_7047_p N_noxref_14_c_7880_n ) capacitor c=5.24634e-19 \
 //x=69.09 //y=1.095 //x2=68.825 //y2=1.305
cc_4895 ( N_RN_c_7048_p N_noxref_14_c_7880_n ) capacitor c=0.00307978f \
 //x=69.09 //y=1.44 //x2=68.825 //y2=1.305
cc_4896 ( N_RN_c_6950_n N_noxref_14_c_7888_n ) capacitor c=0.00127432f \
 //x=68.56 //y=1.44 //x2=68.825 //y2=1.76
cc_4897 ( N_RN_c_6951_n N_noxref_14_c_7888_n ) capacitor c=0.00441386f \
 //x=68.56 //y=1.75 //x2=68.825 //y2=1.76
cc_4898 ( N_RN_c_7046_p N_noxref_14_c_7888_n ) capacitor c=0.00942306f \
 //x=68.935 //y=1.595 //x2=68.825 //y2=1.76
cc_4899 ( N_RN_c_7048_p N_noxref_14_c_7888_n ) capacitor c=0.00363411f \
 //x=69.09 //y=1.44 //x2=68.825 //y2=1.76
cc_4900 ( N_RN_c_6968_n N_noxref_14_c_7888_n ) capacitor c=0.00362297f \
 //x=68.57 //y=2.095 //x2=68.825 //y2=1.76
cc_4901 ( N_RN_c_7046_p N_noxref_14_c_7893_n ) capacitor c=0.00194716f \
 //x=68.935 //y=1.595 //x2=69.225 //y2=1.845
cc_4902 ( N_RN_c_7048_p N_noxref_14_c_7893_n ) capacitor c=0.00323576f \
 //x=69.09 //y=1.44 //x2=69.225 //y2=1.845
cc_4903 ( N_RN_c_7002_n N_noxref_14_c_7895_n ) capacitor c=0.021696f \
 //x=72.065 //y=2.355 //x2=68.91 //y2=1.845
cc_4904 ( RN N_noxref_14_c_7757_n ) capacitor c=0.0020521f //x=72.27 //y=3.88 \
 //x2=69.31 //y2=4.095
cc_4905 ( N_RN_c_6884_n N_noxref_14_c_7757_n ) capacitor c=0.0170832f \
 //x=68.57 //y=2.465 //x2=69.31 //y2=4.095
cc_4906 ( N_RN_c_6888_n N_noxref_14_c_7757_n ) capacitor c=0.066505f //x=68.57 \
 //y=4.75 //x2=69.31 //y2=4.095
cc_4907 ( N_RN_c_6915_n N_noxref_14_c_7757_n ) capacitor c=0.00372846f \
 //x=68.735 //y=2.315 //x2=69.31 //y2=4.095
cc_4908 ( N_RN_c_7002_n N_noxref_14_c_7757_n ) capacitor c=0.0301144f \
 //x=72.065 //y=2.355 //x2=69.31 //y2=4.095
cc_4909 ( N_RN_c_6928_n N_noxref_14_c_7757_n ) capacitor c=0.00115564f \
 //x=68.57 //y=2.26 //x2=69.31 //y2=4.095
cc_4910 ( N_RN_c_6966_n N_noxref_14_c_7757_n ) capacitor c=3.96703e-19 \
 //x=68.57 //y=2.26 //x2=69.31 //y2=4.095
cc_4911 ( N_RN_c_6968_n N_noxref_14_c_7757_n ) capacitor c=0.00282067f \
 //x=68.57 //y=2.095 //x2=69.31 //y2=4.095
cc_4912 ( N_RN_c_6888_n N_noxref_14_c_7822_n ) capacitor c=0.0172847f \
 //x=68.57 //y=4.75 //x2=69.31 //y2=4.415
cc_4913 ( RN N_noxref_14_c_7758_n ) capacitor c=8.28074e-19 //x=72.27 //y=3.88 \
 //x2=69.31 //y2=5.25
cc_4914 ( N_RN_c_6888_n N_noxref_14_c_7758_n ) capacitor c=0.029264f //x=68.57 \
 //y=4.75 //x2=69.31 //y2=5.25
cc_4915 ( N_RN_c_6931_n N_noxref_14_c_7758_n ) capacitor c=0.00131258f \
 //x=68.57 //y=4.88 //x2=69.31 //y2=5.25
cc_4916 ( N_RN_c_6969_n N_noxref_14_c_7758_n ) capacitor c=0.00739875f \
 //x=68.57 //y=4.88 //x2=69.31 //y2=5.25
cc_4917 ( N_RN_c_6985_n N_noxref_14_c_7826_n ) capacitor c=6.27749e-19 \
 //x=72.27 //y=2.515 //x2=72.34 //y2=5.335
cc_4918 ( N_RN_c_6989_n N_noxref_14_c_7826_n ) capacitor c=0.0218571f \
 //x=72.27 //y=4.765 //x2=72.34 //y2=5.335
cc_4919 ( N_RN_c_7009_n N_noxref_14_c_7826_n ) capacitor c=0.00492634f \
 //x=72.27 //y=4.88 //x2=72.34 //y2=5.335
cc_4920 ( N_RN_M142_noxref_g N_noxref_14_c_7826_n ) capacitor c=0.00858241f \
 //x=72.24 //y=6.2 //x2=72.34 //y2=5.335
cc_4921 ( N_RN_c_7027_n N_noxref_14_c_7826_n ) capacitor c=6.15714e-19 \
 //x=72.27 //y=4.88 //x2=72.34 //y2=5.335
cc_4922 ( N_RN_M143_noxref_g N_noxref_14_c_7914_n ) capacitor c=0.0103546f \
 //x=72.68 //y=6.2 //x2=73.225 //y2=5.335
cc_4923 ( RN N_noxref_14_c_7915_n ) capacitor c=0.00271077f //x=72.27 //y=3.88 \
 //x2=74.12 //y2=4.13
cc_4924 ( RN N_noxref_14_c_7916_n ) capacitor c=7.8621e-19 //x=72.27 //y=3.88 \
 //x2=74.12 //y2=5.25
cc_4925 ( N_RN_c_6911_n N_noxref_14_c_7917_n ) capacitor c=0.0170024f \
 //x=68.415 //y=2.315 //x2=63.76 //y2=2.26
cc_4926 ( N_RN_c_6884_n N_noxref_14_c_7918_n ) capacitor c=4.4655e-19 \
 //x=68.57 //y=2.465 //x2=68.53 //y2=5.335
cc_4927 ( N_RN_c_6888_n N_noxref_14_c_7918_n ) capacitor c=0.0232957f \
 //x=68.57 //y=4.75 //x2=68.53 //y2=5.335
cc_4928 ( N_RN_c_6931_n N_noxref_14_c_7918_n ) capacitor c=0.00346017f \
 //x=68.57 //y=4.88 //x2=68.53 //y2=5.335
cc_4929 ( N_RN_c_6969_n N_noxref_14_c_7918_n ) capacitor c=0.00203307f \
 //x=68.57 //y=4.88 //x2=68.53 //y2=5.335
cc_4930 ( N_RN_c_6888_n N_noxref_14_c_7922_n ) capacitor c=6.89957e-19 \
 //x=68.57 //y=4.75 //x2=69.31 //y2=4.25
cc_4931 ( N_RN_c_6989_n N_noxref_14_c_7923_n ) capacitor c=0.00244335f \
 //x=72.27 //y=4.765 //x2=72.46 //y2=5.335
cc_4932 ( N_RN_c_7009_n N_noxref_14_c_7923_n ) capacitor c=0.00132214f \
 //x=72.27 //y=4.88 //x2=72.46 //y2=5.335
cc_4933 ( N_RN_M142_noxref_g N_noxref_14_c_7923_n ) capacitor c=0.00229818f \
 //x=72.24 //y=6.2 //x2=72.46 //y2=5.335
cc_4934 ( N_RN_M143_noxref_g N_noxref_14_c_7923_n ) capacitor c=0.00230699f \
 //x=72.68 //y=6.2 //x2=72.46 //y2=5.335
cc_4935 ( N_RN_c_7088_p N_noxref_14_c_7923_n ) capacitor c=0.00171075f \
 //x=72.605 //y=4.97 //x2=72.46 //y2=5.335
cc_4936 ( N_RN_c_6888_n N_noxref_14_c_7773_n ) capacitor c=0.0280264f \
 //x=68.57 //y=4.75 //x2=69.155 //y2=4.25
cc_4937 ( N_RN_c_6764_n N_noxref_14_c_7732_n ) capacitor c=0.0220634f \
 //x=60.43 //y=4.75 //x2=63.925 //y2=4.25
cc_4938 ( N_RN_c_6888_n N_noxref_14_c_7856_n ) capacitor c=0.00325739f \
 //x=68.57 //y=4.75 //x2=71.02 //y2=4.265
cc_4939 ( RN N_noxref_14_c_7859_n ) capacitor c=0.0303094f //x=72.27 //y=3.88 \
 //x2=74.28 //y2=4.25
cc_4940 ( N_RN_c_6989_n N_noxref_14_c_7859_n ) capacitor c=0.00326871f \
 //x=72.27 //y=4.765 //x2=74.28 //y2=4.25
cc_4941 ( N_RN_c_6606_n N_noxref_14_c_7779_n ) capacitor c=5.18204e-19 \
 //x=59.105 //y=2.385 //x2=53.4 //y2=2.26
cc_4942 ( N_RN_c_6888_n N_noxref_14_c_7934_n ) capacitor c=0.00266858f \
 //x=68.57 //y=4.75 //x2=68.53 //y2=5.56
cc_4943 ( N_RN_c_6931_n N_noxref_14_c_7934_n ) capacitor c=0.00624059f \
 //x=68.57 //y=4.88 //x2=68.53 //y2=5.56
cc_4944 ( N_RN_M138_noxref_g N_noxref_14_c_7934_n ) capacitor c=0.0178885f \
 //x=68.31 //y=6.2 //x2=68.53 //y2=5.56
cc_4945 ( N_RN_M139_noxref_g N_noxref_14_c_7934_n ) capacitor c=0.0188608f \
 //x=68.75 //y=6.2 //x2=68.53 //y2=5.56
cc_4946 ( N_RN_c_6969_n N_noxref_14_c_7934_n ) capacitor c=0.00375636f \
 //x=68.57 //y=4.88 //x2=68.53 //y2=5.56
cc_4947 ( N_RN_c_6989_n N_noxref_14_c_7939_n ) capacitor c=7.85344e-19 \
 //x=72.27 //y=4.765 //x2=72.46 //y2=5.56
cc_4948 ( N_RN_M142_noxref_g N_noxref_14_c_7939_n ) capacitor c=0.0179041f \
 //x=72.24 //y=6.2 //x2=72.46 //y2=5.56
cc_4949 ( N_RN_M143_noxref_g N_noxref_14_c_7939_n ) capacitor c=0.0179041f \
 //x=72.68 //y=6.2 //x2=72.46 //y2=5.56
cc_4950 ( N_RN_c_7088_p N_noxref_14_c_7939_n ) capacitor c=0.00290085f \
 //x=72.605 //y=4.97 //x2=72.46 //y2=5.56
cc_4951 ( N_RN_c_6606_n N_noxref_14_c_7796_n ) capacitor c=3.41298e-19 \
 //x=59.105 //y=2.385 //x2=53.1 //y2=2.095
cc_4952 ( N_RN_c_6911_n N_noxref_14_c_7944_n ) capacitor c=2.98635e-19 \
 //x=68.415 //y=2.315 //x2=63.76 //y2=2.26
cc_4953 ( N_RN_c_6949_n N_noxref_14_M42_noxref_d ) capacitor c=0.00137165f \
 //x=68.56 //y=1.095 //x2=68.635 //y2=1.095
cc_4954 ( N_RN_c_6950_n N_noxref_14_M42_noxref_d ) capacitor c=0.00237422f \
 //x=68.56 //y=1.44 //x2=68.635 //y2=1.095
cc_4955 ( N_RN_c_7045_p N_noxref_14_M42_noxref_d ) capacitor c=0.0020782f \
 //x=68.935 //y=0.94 //x2=68.635 //y2=1.095
cc_4956 ( N_RN_c_7046_p N_noxref_14_M42_noxref_d ) capacitor c=0.00356097f \
 //x=68.935 //y=1.595 //x2=68.635 //y2=1.095
cc_4957 ( N_RN_c_7047_p N_noxref_14_M42_noxref_d ) capacitor c=0.00139206f \
 //x=69.09 //y=1.095 //x2=68.635 //y2=1.095
cc_4958 ( N_RN_c_7048_p N_noxref_14_M42_noxref_d ) capacitor c=0.00237422f \
 //x=69.09 //y=1.44 //x2=68.635 //y2=1.095
cc_4959 ( N_RN_c_6587_n N_noxref_15_c_8554_n ) capacitor c=0.00693335f \
 //x=46.37 //y=2.515 //x2=47.48 //y2=2.375
cc_4960 ( N_RN_c_6606_n N_noxref_15_c_8554_n ) capacitor c=0.0184958f \
 //x=59.105 //y=2.385 //x2=47.48 //y2=2.375
cc_4961 ( N_RN_c_6608_n N_noxref_15_c_8554_n ) capacitor c=5.39999e-19 \
 //x=46.37 //y=2.26 //x2=47.48 //y2=2.375
cc_4962 ( N_RN_c_6626_n N_noxref_15_c_8554_n ) capacitor c=0.00137153f \
 //x=46.46 //y=2.095 //x2=47.48 //y2=2.375
cc_4963 ( RN N_noxref_15_c_8552_n ) capacitor c=0.0198749f //x=46.37 //y=3.51 \
 //x2=47.48 //y2=3.365
cc_4964 ( N_RN_c_6587_n N_noxref_15_c_8552_n ) capacitor c=0.00189715f \
 //x=46.37 //y=2.515 //x2=47.48 //y2=3.365
cc_4965 ( N_RN_c_6606_n N_noxref_15_c_8552_n ) capacitor c=0.0133861f \
 //x=59.105 //y=2.385 //x2=47.48 //y2=3.365
cc_4966 ( RN N_noxref_15_c_8557_n ) capacitor c=0.00782712f //x=46.37 //y=3.51 \
 //x2=47.48 //y2=3.685
cc_4967 ( RN N_noxref_15_c_8553_n ) capacitor c=0.0252559f //x=46.37 //y=3.51 \
 //x2=47.48 //y2=4.75
cc_4968 ( N_RN_c_6591_n N_noxref_15_c_8553_n ) capacitor c=0.0107551f \
 //x=46.37 //y=4.765 //x2=47.48 //y2=4.75
cc_4969 ( N_RN_c_6611_n N_noxref_15_c_8553_n ) capacitor c=9.52396e-19 \
 //x=46.37 //y=4.88 //x2=47.48 //y2=4.75
cc_4970 ( N_RN_c_6629_n N_noxref_15_c_8553_n ) capacitor c=8.42568e-19 \
 //x=46.37 //y=4.88 //x2=47.48 //y2=4.75
cc_4971 ( N_RN_c_6606_n N_noxref_15_c_8573_n ) capacitor c=0.0189272f \
 //x=59.105 //y=2.385 //x2=51.195 //y2=1.835
cc_4972 ( N_RN_c_6606_n N_noxref_15_c_8574_n ) capacitor c=0.0281231f \
 //x=59.105 //y=2.385 //x2=51.55 //y2=3.37
cc_4973 ( N_RN_c_6606_n N_noxref_15_c_8738_n ) capacitor c=0.0157528f \
 //x=59.105 //y=2.385 //x2=55.62 //y2=2.375
cc_4974 ( N_RN_c_6606_n N_noxref_15_c_8698_n ) capacitor c=0.0129611f \
 //x=59.105 //y=2.385 //x2=55.62 //y2=3.35
cc_4975 ( N_RN_M128_noxref_g N_noxref_15_c_8704_n ) capacitor c=0.00955829f \
 //x=60.17 //y=6.2 //x2=60.275 //y2=5.335
cc_4976 ( N_RN_M128_noxref_g N_noxref_15_c_8963_n ) capacitor c=0.00226521f \
 //x=60.17 //y=6.2 //x2=60.39 //y2=5.56
cc_4977 ( N_RN_M129_noxref_g N_noxref_15_c_8963_n ) capacitor c=0.00368945f \
 //x=60.61 //y=6.2 //x2=60.39 //y2=5.56
cc_4978 ( N_RN_c_6764_n N_noxref_15_c_8748_n ) capacitor c=0.00228791f \
 //x=60.43 //y=4.75 //x2=61.085 //y2=5.335
cc_4979 ( N_RN_c_6812_n N_noxref_15_c_8748_n ) capacitor c=0.00130631f \
 //x=60.43 //y=4.88 //x2=61.085 //y2=5.335
cc_4980 ( N_RN_M129_noxref_g N_noxref_15_c_8748_n ) capacitor c=0.0108612f \
 //x=60.61 //y=6.2 //x2=61.085 //y2=5.335
cc_4981 ( N_RN_c_6760_n N_noxref_15_c_8968_n ) capacitor c=5.60322e-19 \
 //x=60.43 //y=2.465 //x2=60.685 //y2=1.305
cc_4982 ( N_RN_c_6791_n N_noxref_15_c_8968_n ) capacitor c=4.13793e-19 \
 //x=60.595 //y=2.4 //x2=60.685 //y2=1.305
cc_4983 ( N_RN_c_6830_n N_noxref_15_c_8968_n ) capacitor c=4.64015e-19 \
 //x=60.42 //y=1.095 //x2=60.685 //y2=1.305
cc_4984 ( N_RN_c_6831_n N_noxref_15_c_8968_n ) capacitor c=0.0026012f \
 //x=60.42 //y=1.44 //x2=60.685 //y2=1.305
cc_4985 ( N_RN_c_7138_p N_noxref_15_c_8968_n ) capacitor c=5.29969e-19 \
 //x=60.795 //y=0.94 //x2=60.685 //y2=1.305
cc_4986 ( N_RN_c_7139_p N_noxref_15_c_8968_n ) capacitor c=4.32061e-19 \
 //x=60.795 //y=1.595 //x2=60.685 //y2=1.305
cc_4987 ( N_RN_c_7140_p N_noxref_15_c_8968_n ) capacitor c=5.28622e-19 \
 //x=60.95 //y=1.095 //x2=60.685 //y2=1.305
cc_4988 ( N_RN_c_7141_p N_noxref_15_c_8968_n ) capacitor c=0.00312156f \
 //x=60.95 //y=1.44 //x2=60.685 //y2=1.305
cc_4989 ( N_RN_c_6831_n N_noxref_15_c_8976_n ) capacitor c=0.00127432f \
 //x=60.42 //y=1.44 //x2=60.685 //y2=1.76
cc_4990 ( N_RN_c_6832_n N_noxref_15_c_8976_n ) capacitor c=0.00441386f \
 //x=60.42 //y=1.75 //x2=60.685 //y2=1.76
cc_4991 ( N_RN_c_7139_p N_noxref_15_c_8976_n ) capacitor c=0.00930387f \
 //x=60.795 //y=1.595 //x2=60.685 //y2=1.76
cc_4992 ( N_RN_c_7141_p N_noxref_15_c_8976_n ) capacitor c=0.00347599f \
 //x=60.95 //y=1.44 //x2=60.685 //y2=1.76
cc_4993 ( N_RN_c_6849_n N_noxref_15_c_8976_n ) capacitor c=0.0036273f \
 //x=60.43 //y=2.095 //x2=60.685 //y2=1.76
cc_4994 ( N_RN_c_7139_p N_noxref_15_c_8981_n ) capacitor c=0.00194716f \
 //x=60.795 //y=1.595 //x2=61.085 //y2=1.845
cc_4995 ( N_RN_c_7141_p N_noxref_15_c_8981_n ) capacitor c=0.00323576f \
 //x=60.95 //y=1.44 //x2=61.085 //y2=1.845
cc_4996 ( N_RN_c_6911_n N_noxref_15_c_8855_n ) capacitor c=0.0215425f \
 //x=68.415 //y=2.315 //x2=60.77 //y2=1.845
cc_4997 ( N_RN_c_6760_n N_noxref_15_c_8705_n ) capacitor c=0.0170832f \
 //x=60.43 //y=2.465 //x2=61.17 //y2=3.35
cc_4998 ( N_RN_c_6764_n N_noxref_15_c_8705_n ) capacitor c=0.0362921f \
 //x=60.43 //y=4.75 //x2=61.17 //y2=3.35
cc_4999 ( N_RN_c_6791_n N_noxref_15_c_8705_n ) capacitor c=0.00372846f \
 //x=60.595 //y=2.4 //x2=61.17 //y2=3.35
cc_5000 ( N_RN_c_6911_n N_noxref_15_c_8705_n ) capacitor c=0.0300782f \
 //x=68.415 //y=2.315 //x2=61.17 //y2=3.35
cc_5001 ( N_RN_c_6809_n N_noxref_15_c_8705_n ) capacitor c=0.00115564f \
 //x=60.43 //y=2.26 //x2=61.17 //y2=3.35
cc_5002 ( N_RN_c_6847_n N_noxref_15_c_8705_n ) capacitor c=3.96703e-19 \
 //x=60.43 //y=2.26 //x2=61.17 //y2=3.35
cc_5003 ( N_RN_c_6849_n N_noxref_15_c_8705_n ) capacitor c=0.00282067f \
 //x=60.43 //y=2.095 //x2=61.17 //y2=3.35
cc_5004 ( N_RN_c_6764_n N_noxref_15_c_8856_n ) capacitor c=0.0144538f \
 //x=60.43 //y=4.75 //x2=61.17 //y2=3.67
cc_5005 ( N_RN_c_6764_n N_noxref_15_c_8708_n ) capacitor c=0.0564508f \
 //x=60.43 //y=4.75 //x2=61.17 //y2=5.25
cc_5006 ( N_RN_c_6812_n N_noxref_15_c_8708_n ) capacitor c=0.00131258f \
 //x=60.43 //y=4.88 //x2=61.17 //y2=5.25
cc_5007 ( N_RN_c_6850_n N_noxref_15_c_8708_n ) capacitor c=0.00739875f \
 //x=60.43 //y=4.88 //x2=61.17 //y2=5.25
cc_5008 ( N_RN_c_6764_n N_noxref_15_c_8995_n ) capacitor c=0.00176257f \
 //x=60.43 //y=4.75 //x2=63.02 //y2=3.35
cc_5009 ( N_RN_c_6911_n N_noxref_15_c_8995_n ) capacitor c=0.0152523f \
 //x=68.415 //y=2.315 //x2=63.02 //y2=3.35
cc_5010 ( N_RN_c_6911_n N_noxref_15_c_8997_n ) capacitor c=0.0193939f \
 //x=68.415 //y=2.315 //x2=64.145 //y2=1.835
cc_5011 ( N_RN_c_6911_n N_noxref_15_c_8751_n ) capacitor c=0.030785f \
 //x=68.415 //y=2.315 //x2=64.5 //y2=3.355
cc_5012 ( N_RN_c_6911_n N_noxref_15_c_8754_n ) capacitor c=0.016619f \
 //x=68.415 //y=2.315 //x2=66.35 //y2=2.375
cc_5013 ( N_RN_c_6888_n N_noxref_15_c_8757_n ) capacitor c=0.001171f //x=68.57 \
 //y=4.75 //x2=66.35 //y2=3.355
cc_5014 ( N_RN_c_6911_n N_noxref_15_c_8757_n ) capacitor c=0.0169827f \
 //x=68.415 //y=2.315 //x2=66.35 //y2=3.355
cc_5015 ( N_RN_c_6888_n N_noxref_15_c_8760_n ) capacitor c=0.00126605f \
 //x=68.57 //y=4.75 //x2=66.35 //y2=4.755
cc_5016 ( RN N_noxref_15_c_8578_n ) capacitor c=5.01652e-19 //x=46.37 //y=3.51 \
 //x2=47.48 //y2=3.51
cc_5017 ( N_RN_c_6606_n N_noxref_15_c_8587_n ) capacitor c=7.09092e-19 \
 //x=59.105 //y=2.385 //x2=51.11 //y2=1.18
cc_5018 ( N_RN_c_6760_n N_noxref_15_c_9005_n ) capacitor c=4.29699e-19 \
 //x=60.43 //y=2.465 //x2=60.39 //y2=5.335
cc_5019 ( N_RN_c_6764_n N_noxref_15_c_9005_n ) capacitor c=0.0223028f \
 //x=60.43 //y=4.75 //x2=60.39 //y2=5.335
cc_5020 ( N_RN_c_6812_n N_noxref_15_c_9005_n ) capacitor c=0.00346017f \
 //x=60.43 //y=4.88 //x2=60.39 //y2=5.335
cc_5021 ( N_RN_c_6850_n N_noxref_15_c_9005_n ) capacitor c=0.00203307f \
 //x=60.43 //y=4.88 //x2=60.39 //y2=5.335
cc_5022 ( N_RN_c_6764_n N_noxref_15_c_9009_n ) capacitor c=6.03895e-19 \
 //x=60.43 //y=4.75 //x2=61.17 //y2=3.51
cc_5023 ( N_RN_c_6911_n N_noxref_15_c_9010_n ) capacitor c=0.0177708f \
 //x=68.415 //y=2.315 //x2=63.02 //y2=2.26
cc_5024 ( N_RN_c_6764_n N_noxref_15_c_8771_n ) capacitor c=0.00123473f \
 //x=60.43 //y=4.75 //x2=63.022 //y2=4.74
cc_5025 ( N_RN_c_6911_n N_noxref_15_c_9012_n ) capacitor c=7.09092e-19 \
 //x=68.415 //y=2.315 //x2=64.06 //y2=1.18
cc_5026 ( N_RN_c_6911_n N_noxref_15_c_8889_n ) capacitor c=0.00616942f \
 //x=68.415 //y=2.315 //x2=62.86 //y2=3.51
cc_5027 ( N_RN_c_6764_n N_noxref_15_c_8723_n ) capacitor c=0.0249153f \
 //x=60.43 //y=4.75 //x2=61.335 //y2=3.51
cc_5028 ( N_RN_c_6783_n N_noxref_15_c_8723_n ) capacitor c=9.60936e-19 \
 //x=59.535 //y=2.385 //x2=61.335 //y2=3.51
cc_5029 ( N_RN_c_6791_n N_noxref_15_c_8723_n ) capacitor c=0.00744464f \
 //x=60.595 //y=2.4 //x2=61.335 //y2=3.51
cc_5030 ( N_RN_c_6911_n N_noxref_15_c_8894_n ) capacitor c=0.00647974f \
 //x=68.415 //y=2.315 //x2=66.195 //y2=3.51
cc_5031 ( RN N_noxref_15_c_8896_n ) capacitor c=2.58903e-19 //x=72.27 //y=3.88 \
 //x2=71.365 //y2=3.495
cc_5032 ( N_RN_c_7002_n N_noxref_15_c_8896_n ) capacitor c=0.00375009f \
 //x=72.065 //y=2.355 //x2=71.365 //y2=3.495
cc_5033 ( N_RN_c_6888_n N_noxref_15_c_8785_n ) capacitor c=0.0220436f \
 //x=68.57 //y=4.75 //x2=70.935 //y2=3.495
cc_5034 ( N_RN_c_6911_n N_noxref_15_c_8785_n ) capacitor c=0.0212739f \
 //x=68.415 //y=2.315 //x2=70.935 //y2=3.495
cc_5035 ( N_RN_c_7002_n N_noxref_15_c_8785_n ) capacitor c=0.00296613f \
 //x=72.065 //y=2.355 //x2=70.935 //y2=3.495
cc_5036 ( RN N_noxref_15_c_9023_n ) capacitor c=0.0269862f //x=72.27 //y=3.88 \
 //x2=72.995 //y2=3.51
cc_5037 ( RN N_noxref_15_c_8600_n ) capacitor c=0.00515311f //x=46.37 //y=3.51 \
 //x2=47.64 //y2=3.525
cc_5038 ( N_RN_c_6911_n N_noxref_15_c_8905_n ) capacitor c=0.00611753f \
 //x=68.415 //y=2.315 //x2=64.34 //y2=3.515
cc_5039 ( N_RN_c_6587_n N_noxref_15_c_8601_n ) capacitor c=0.00109587f \
 //x=46.37 //y=2.515 //x2=47.48 //y2=2.26
cc_5040 ( N_RN_c_6606_n N_noxref_15_c_8601_n ) capacitor c=2.63835e-19 \
 //x=59.105 //y=2.385 //x2=47.48 //y2=2.26
cc_5041 ( N_RN_c_6608_n N_noxref_15_c_8601_n ) capacitor c=0.00124918f \
 //x=46.37 //y=2.26 //x2=47.48 //y2=2.26
cc_5042 ( N_RN_c_6626_n N_noxref_15_c_8601_n ) capacitor c=0.00209664f \
 //x=46.46 //y=2.095 //x2=47.48 //y2=2.26
cc_5043 ( RN N_noxref_15_c_8602_n ) capacitor c=2.94497e-19 //x=46.37 //y=3.51 \
 //x2=47.48 //y2=4.88
cc_5044 ( N_RN_c_6591_n N_noxref_15_c_8602_n ) capacitor c=4.56604e-19 \
 //x=46.37 //y=4.765 //x2=47.48 //y2=4.88
cc_5045 ( N_RN_c_6611_n N_noxref_15_c_8602_n ) capacitor c=0.00113985f \
 //x=46.37 //y=4.88 //x2=47.48 //y2=4.88
cc_5046 ( N_RN_c_6629_n N_noxref_15_c_8602_n ) capacitor c=0.00129812f \
 //x=46.37 //y=4.88 //x2=47.48 //y2=4.88
cc_5047 ( N_RN_c_6606_n N_noxref_15_c_8786_n ) capacitor c=2.63835e-19 \
 //x=59.105 //y=2.385 //x2=55.62 //y2=2.26
cc_5048 ( N_RN_c_6764_n N_noxref_15_c_9035_n ) capacitor c=0.00266858f \
 //x=60.43 //y=4.75 //x2=60.39 //y2=5.56
cc_5049 ( N_RN_c_6812_n N_noxref_15_c_9035_n ) capacitor c=0.00624059f \
 //x=60.43 //y=4.88 //x2=60.39 //y2=5.56
cc_5050 ( N_RN_M128_noxref_g N_noxref_15_c_9035_n ) capacitor c=0.0178885f \
 //x=60.17 //y=6.2 //x2=60.39 //y2=5.56
cc_5051 ( N_RN_M129_noxref_g N_noxref_15_c_9035_n ) capacitor c=0.0188608f \
 //x=60.61 //y=6.2 //x2=60.39 //y2=5.56
cc_5052 ( N_RN_c_6850_n N_noxref_15_c_9035_n ) capacitor c=0.00375636f \
 //x=60.43 //y=4.88 //x2=60.39 //y2=5.56
cc_5053 ( N_RN_c_6911_n N_noxref_15_c_9040_n ) capacitor c=2.20453e-19 \
 //x=68.415 //y=2.315 //x2=63.02 //y2=2.26
cc_5054 ( N_RN_c_6911_n N_noxref_15_c_8793_n ) capacitor c=5.18204e-19 \
 //x=68.415 //y=2.315 //x2=66.35 //y2=2.26
cc_5055 ( N_RN_M110_noxref_g N_noxref_15_M112_noxref_g ) capacitor \
 c=0.0101598f //x=46.34 //y=6.2 //x2=47.22 //y2=6.2
cc_5056 ( N_RN_M111_noxref_g N_noxref_15_M112_noxref_g ) capacitor \
 c=0.0607518f //x=46.78 //y=6.2 //x2=47.22 //y2=6.2
cc_5057 ( N_RN_M111_noxref_g N_noxref_15_M113_noxref_g ) capacitor \
 c=0.0101598f //x=46.78 //y=6.2 //x2=47.66 //y2=6.2
cc_5058 ( N_RN_c_6623_n N_noxref_15_c_8617_n ) capacitor c=0.00456962f \
 //x=46.46 //y=1.09 //x2=47.47 //y2=1.095
cc_5059 ( N_RN_c_6624_n N_noxref_15_c_8619_n ) capacitor c=0.00438372f \
 //x=46.46 //y=1.4 //x2=47.47 //y2=1.44
cc_5060 ( N_RN_c_6625_n N_noxref_15_c_8622_n ) capacitor c=0.00438372f \
 //x=46.46 //y=1.63 //x2=47.47 //y2=1.75
cc_5061 ( N_RN_c_6911_n N_noxref_15_c_9048_n ) capacitor c=3.61358e-19 \
 //x=68.415 //y=2.315 //x2=62.825 //y2=2.095
cc_5062 ( N_RN_c_6911_n N_noxref_15_c_8812_n ) capacitor c=3.41298e-19 \
 //x=68.415 //y=2.315 //x2=66.05 //y2=2.095
cc_5063 ( N_RN_c_6587_n N_noxref_15_c_8635_n ) capacitor c=0.00143986f \
 //x=46.37 //y=2.515 //x2=47.48 //y2=2.26
cc_5064 ( N_RN_c_6606_n N_noxref_15_c_8635_n ) capacitor c=3.41298e-19 \
 //x=59.105 //y=2.385 //x2=47.48 //y2=2.26
cc_5065 ( N_RN_c_6608_n N_noxref_15_c_8635_n ) capacitor c=0.00204796f \
 //x=46.37 //y=2.26 //x2=47.48 //y2=2.26
cc_5066 ( N_RN_c_6626_n N_noxref_15_c_8635_n ) capacitor c=0.00933826f \
 //x=46.46 //y=2.095 //x2=47.48 //y2=2.26
cc_5067 ( N_RN_c_6626_n N_noxref_15_c_8636_n ) capacitor c=0.00438372f \
 //x=46.46 //y=2.095 //x2=47.48 //y2=2.095
cc_5068 ( N_RN_c_6591_n N_noxref_15_c_8638_n ) capacitor c=0.00124604f \
 //x=46.37 //y=4.765 //x2=47.48 //y2=4.88
cc_5069 ( N_RN_c_6611_n N_noxref_15_c_8638_n ) capacitor c=0.00187046f \
 //x=46.37 //y=4.88 //x2=47.48 //y2=4.88
cc_5070 ( N_RN_c_6654_n N_noxref_15_c_8638_n ) capacitor c=0.0616777f \
 //x=46.705 //y=4.97 //x2=47.48 //y2=4.88
cc_5071 ( N_RN_c_6629_n N_noxref_15_c_8638_n ) capacitor c=0.00487508f \
 //x=46.37 //y=4.88 //x2=47.48 //y2=4.88
cc_5072 ( N_RN_c_6606_n N_noxref_15_c_8826_n ) capacitor c=3.41298e-19 \
 //x=59.105 //y=2.385 //x2=55.62 //y2=2.26
cc_5073 ( N_RN_c_6830_n N_noxref_15_M37_noxref_d ) capacitor c=0.00137165f \
 //x=60.42 //y=1.095 //x2=60.495 //y2=1.095
cc_5074 ( N_RN_c_6831_n N_noxref_15_M37_noxref_d ) capacitor c=0.00237422f \
 //x=60.42 //y=1.44 //x2=60.495 //y2=1.095
cc_5075 ( N_RN_c_7138_p N_noxref_15_M37_noxref_d ) capacitor c=0.0020782f \
 //x=60.795 //y=0.94 //x2=60.495 //y2=1.095
cc_5076 ( N_RN_c_7139_p N_noxref_15_M37_noxref_d ) capacitor c=0.00356097f \
 //x=60.795 //y=1.595 //x2=60.495 //y2=1.095
cc_5077 ( N_RN_c_7140_p N_noxref_15_M37_noxref_d ) capacitor c=0.00139206f \
 //x=60.95 //y=1.095 //x2=60.495 //y2=1.095
cc_5078 ( N_RN_c_7141_p N_noxref_15_M37_noxref_d ) capacitor c=0.00237422f \
 //x=60.95 //y=1.44 //x2=60.495 //y2=1.095
cc_5079 ( N_RN_c_6372_n N_noxref_16_c_9871_n ) capacitor c=0.00693335f \
 //x=20.47 //y=2.515 //x2=21.58 //y2=2.375
cc_5080 ( N_RN_c_6386_n N_noxref_16_c_9871_n ) capacitor c=0.0180606f \
 //x=33.205 //y=2.37 //x2=21.58 //y2=2.375
cc_5081 ( N_RN_c_6392_n N_noxref_16_c_9871_n ) capacitor c=5.39999e-19 \
 //x=20.47 //y=2.26 //x2=21.58 //y2=2.375
cc_5082 ( N_RN_c_6410_n N_noxref_16_c_9871_n ) capacitor c=0.00137153f \
 //x=20.56 //y=2.095 //x2=21.58 //y2=2.375
cc_5083 ( RN N_noxref_16_c_9868_n ) capacitor c=0.01107f //x=20.47 //y=3.14 \
 //x2=21.58 //y2=2.995
cc_5084 ( N_RN_c_6372_n N_noxref_16_c_9868_n ) capacitor c=0.00189715f \
 //x=20.47 //y=2.515 //x2=21.58 //y2=2.995
cc_5085 ( N_RN_c_6386_n N_noxref_16_c_9868_n ) capacitor c=0.0133793f \
 //x=33.205 //y=2.37 //x2=21.58 //y2=2.995
cc_5086 ( RN N_noxref_16_c_9874_n ) capacitor c=0.00788859f //x=20.47 //y=3.14 \
 //x2=21.58 //y2=3.315
cc_5087 ( RN N_noxref_16_c_9869_n ) capacitor c=0.0383501f //x=20.47 //y=3.14 \
 //x2=21.58 //y2=4.75
cc_5088 ( N_RN_c_6376_n N_noxref_16_c_9869_n ) capacitor c=0.0107551f \
 //x=20.47 //y=4.765 //x2=21.58 //y2=4.75
cc_5089 ( N_RN_c_6395_n N_noxref_16_c_9869_n ) capacitor c=9.52396e-19 \
 //x=20.47 //y=4.88 //x2=21.58 //y2=4.75
cc_5090 ( N_RN_c_6413_n N_noxref_16_c_9869_n ) capacitor c=8.42568e-19 \
 //x=20.47 //y=4.88 //x2=21.58 //y2=4.75
cc_5091 ( N_RN_c_6386_n N_noxref_16_c_9905_n ) capacitor c=0.0184839f \
 //x=33.205 //y=2.37 //x2=25.295 //y2=1.835
cc_5092 ( N_RN_c_6386_n N_noxref_16_c_9906_n ) capacitor c=0.0281163f \
 //x=33.205 //y=2.37 //x2=25.65 //y2=2.995
cc_5093 ( RN N_noxref_16_c_9925_n ) capacitor c=5.01652e-19 //x=20.47 //y=3.14 \
 //x2=21.58 //y2=3.14
cc_5094 ( N_RN_c_6386_n N_noxref_16_c_9937_n ) capacitor c=7.09092e-19 \
 //x=33.205 //y=2.37 //x2=25.21 //y2=1.18
cc_5095 ( N_RN_c_6386_n N_noxref_16_c_9945_n ) capacitor c=0.0223543f \
 //x=33.205 //y=2.37 //x2=25.49 //y2=3.14
cc_5096 ( N_RN_c_6386_n N_noxref_16_c_10009_n ) capacitor c=0.0190202f \
 //x=33.205 //y=2.37 //x2=29.935 //y2=3.125
cc_5097 ( N_RN_c_6386_n N_noxref_16_c_9956_n ) capacitor c=0.0264721f \
 //x=33.205 //y=2.37 //x2=29.505 //y2=3.125
cc_5098 ( N_RN_c_6509_n N_noxref_16_c_10014_n ) capacitor c=0.0223511f \
 //x=34.53 //y=4.75 //x2=34.89 //y2=3.14
cc_5099 ( N_RN_c_6386_n N_noxref_16_c_10014_n ) capacitor c=0.00358427f \
 //x=33.205 //y=2.37 //x2=34.89 //y2=3.14
cc_5100 ( N_RN_c_6523_n N_noxref_16_c_10014_n ) capacitor c=0.00823396f \
 //x=34.695 //y=2.4 //x2=34.89 //y2=3.14
cc_5101 ( N_RN_c_6525_n N_noxref_16_c_10014_n ) capacitor c=0.00334025f \
 //x=42.515 //y=2.315 //x2=34.89 //y2=3.14
cc_5102 ( N_RN_c_6525_n N_noxref_16_c_10018_n ) capacitor c=0.00668883f \
 //x=42.515 //y=2.315 //x2=35.49 //y2=3.125
cc_5103 ( N_RN_c_6525_n N_noxref_16_c_10022_n ) capacitor c=0.0037732f \
 //x=42.515 //y=2.315 //x2=36.735 //y2=3.14
cc_5104 ( N_RN_c_6525_n N_noxref_16_c_10025_n ) capacitor c=0.00585305f \
 //x=42.515 //y=2.315 //x2=37.335 //y2=3.125
cc_5105 ( N_RN_c_6525_n N_noxref_16_c_10028_n ) capacitor c=0.00348347f \
 //x=42.515 //y=2.315 //x2=38.21 //y2=3.14
cc_5106 ( N_RN_c_6525_n N_noxref_16_c_10029_n ) capacitor c=0.00705726f \
 //x=42.515 //y=2.315 //x2=38.81 //y2=3.13
cc_5107 ( N_RN_c_6525_n N_noxref_16_c_10033_n ) capacitor c=0.00379205f \
 //x=42.515 //y=2.315 //x2=40.07 //y2=3.14
cc_5108 ( N_RN_c_6525_n N_noxref_16_c_10036_n ) capacitor c=0.0171279f \
 //x=42.515 //y=2.315 //x2=40.67 //y2=3.13
cc_5109 ( RN N_noxref_16_c_10055_n ) capacitor c=0.0247005f //x=42.67 //y=3.51 \
 //x2=55.235 //y2=3.14
cc_5110 ( RN N_noxref_16_c_10055_n ) capacitor c=0.0277966f //x=46.37 //y=3.51 \
 //x2=55.235 //y2=3.14
cc_5111 ( N_RN_c_6606_n N_noxref_16_c_10055_n ) capacitor c=0.0588671f \
 //x=59.105 //y=2.385 //x2=55.235 //y2=3.14
cc_5112 ( N_RN_c_6686_n N_noxref_16_c_10055_n ) capacitor c=0.0171279f \
 //x=42.835 //y=2.315 //x2=55.235 //y2=3.14
cc_5113 ( N_RN_c_6606_n N_noxref_16_c_10102_n ) capacitor c=0.0190151f \
 //x=59.105 //y=2.385 //x2=55.835 //y2=3.125
cc_5114 ( N_RN_c_6606_n N_noxref_16_c_10103_n ) capacitor c=0.0039733f \
 //x=59.105 //y=2.385 //x2=58.935 //y2=3.14
cc_5115 ( N_RN_c_6764_n N_noxref_16_c_10107_n ) capacitor c=4.9496e-19 \
 //x=60.43 //y=4.75 //x2=59.535 //y2=3.155
cc_5116 ( N_RN_c_6783_n N_noxref_16_c_10107_n ) capacitor c=0.0039733f \
 //x=59.535 //y=2.385 //x2=59.535 //y2=3.155
cc_5117 ( N_RN_c_6791_n N_noxref_16_c_10107_n ) capacitor c=0.0287235f \
 //x=60.595 //y=2.4 //x2=59.535 //y2=3.155
cc_5118 ( N_RN_c_6764_n N_noxref_16_c_10139_n ) capacitor c=0.0249774f \
 //x=60.43 //y=4.75 //x2=60.79 //y2=3.14
cc_5119 ( N_RN_c_6911_n N_noxref_16_c_10139_n ) capacitor c=0.0576701f \
 //x=68.415 //y=2.315 //x2=60.79 //y2=3.14
cc_5120 ( N_RN_c_6911_n N_noxref_16_c_10140_n ) capacitor c=0.0597375f \
 //x=68.415 //y=2.315 //x2=61.39 //y2=3.125
cc_5121 ( N_RN_c_6911_n N_noxref_16_c_10141_n ) capacitor c=0.028771f \
 //x=68.415 //y=2.315 //x2=62.635 //y2=3.14
cc_5122 ( N_RN_c_6911_n N_noxref_16_c_10142_n ) capacitor c=0.0387022f \
 //x=68.415 //y=2.315 //x2=63.235 //y2=3.125
cc_5123 ( N_RN_c_6911_n N_noxref_16_c_10143_n ) capacitor c=0.0286222f \
 //x=68.415 //y=2.315 //x2=64.115 //y2=3.14
cc_5124 ( N_RN_c_6911_n N_noxref_16_c_10144_n ) capacitor c=0.0600573f \
 //x=68.415 //y=2.315 //x2=64.715 //y2=3.13
cc_5125 ( N_RN_c_6911_n N_noxref_16_c_10145_n ) capacitor c=0.0284994f \
 //x=68.415 //y=2.315 //x2=65.97 //y2=3.14
cc_5126 ( N_RN_c_6911_n N_noxref_16_c_10131_n ) capacitor c=0.123398f \
 //x=68.415 //y=2.315 //x2=66.57 //y2=3.13
cc_5127 ( RN N_noxref_16_c_10132_n ) capacitor c=0.0260011f //x=72.27 //y=3.88 \
 //x2=78.535 //y2=3.14
cc_5128 ( N_RN_c_6888_n N_noxref_16_c_10132_n ) capacitor c=0.0246498f \
 //x=68.57 //y=4.75 //x2=78.535 //y2=3.14
cc_5129 ( N_RN_c_6985_n N_noxref_16_c_10132_n ) capacitor c=0.00246418f \
 //x=72.27 //y=2.515 //x2=78.535 //y2=3.14
cc_5130 ( N_RN_c_6915_n N_noxref_16_c_10132_n ) capacitor c=0.123398f \
 //x=68.735 //y=2.315 //x2=78.535 //y2=3.14
cc_5131 ( N_RN_c_7000_n N_noxref_16_c_10132_n ) capacitor c=0.0146305f \
 //x=72.225 //y=2.355 //x2=78.535 //y2=3.14
cc_5132 ( RN N_noxref_16_c_9957_n ) capacitor c=0.0051526f //x=20.47 //y=3.14 \
 //x2=21.735 //y2=3.155
cc_5133 ( N_RN_c_6372_n N_noxref_16_c_9959_n ) capacitor c=0.00109587f \
 //x=20.47 //y=2.515 //x2=21.58 //y2=2.26
cc_5134 ( N_RN_c_6386_n N_noxref_16_c_9959_n ) capacitor c=2.63835e-19 \
 //x=33.205 //y=2.37 //x2=21.58 //y2=2.26
cc_5135 ( N_RN_c_6392_n N_noxref_16_c_9959_n ) capacitor c=0.00124918f \
 //x=20.47 //y=2.26 //x2=21.58 //y2=2.26
cc_5136 ( N_RN_c_6410_n N_noxref_16_c_9959_n ) capacitor c=0.00209664f \
 //x=20.56 //y=2.095 //x2=21.58 //y2=2.26
cc_5137 ( RN N_noxref_16_c_9960_n ) capacitor c=2.94497e-19 //x=20.47 //y=3.14 \
 //x2=21.58 //y2=4.88
cc_5138 ( N_RN_c_6376_n N_noxref_16_c_9960_n ) capacitor c=4.56604e-19 \
 //x=20.47 //y=4.765 //x2=21.58 //y2=4.88
cc_5139 ( N_RN_c_6395_n N_noxref_16_c_9960_n ) capacitor c=0.00113985f \
 //x=20.47 //y=4.88 //x2=21.58 //y2=4.88
cc_5140 ( N_RN_c_6413_n N_noxref_16_c_9960_n ) capacitor c=0.00129812f \
 //x=20.47 //y=4.88 //x2=21.58 //y2=4.88
cc_5141 ( N_RN_M78_noxref_g N_noxref_16_M80_noxref_g ) capacitor c=0.0101598f \
 //x=20.44 //y=6.2 //x2=21.32 //y2=6.2
cc_5142 ( N_RN_M79_noxref_g N_noxref_16_M80_noxref_g ) capacitor c=0.0607518f \
 //x=20.88 //y=6.2 //x2=21.32 //y2=6.2
cc_5143 ( N_RN_M79_noxref_g N_noxref_16_M81_noxref_g ) capacitor c=0.0101598f \
 //x=20.88 //y=6.2 //x2=21.76 //y2=6.2
cc_5144 ( N_RN_c_6407_n N_noxref_16_c_9979_n ) capacitor c=0.00456962f \
 //x=20.56 //y=1.09 //x2=21.57 //y2=1.095
cc_5145 ( N_RN_c_6408_n N_noxref_16_c_9981_n ) capacitor c=0.00438372f \
 //x=20.56 //y=1.4 //x2=21.57 //y2=1.44
cc_5146 ( N_RN_c_6409_n N_noxref_16_c_9984_n ) capacitor c=0.00438372f \
 //x=20.56 //y=1.63 //x2=21.57 //y2=1.75
cc_5147 ( N_RN_c_6372_n N_noxref_16_c_9997_n ) capacitor c=0.00143986f \
 //x=20.47 //y=2.515 //x2=21.58 //y2=2.26
cc_5148 ( N_RN_c_6386_n N_noxref_16_c_9997_n ) capacitor c=3.41298e-19 \
 //x=33.205 //y=2.37 //x2=21.58 //y2=2.26
cc_5149 ( N_RN_c_6392_n N_noxref_16_c_9997_n ) capacitor c=0.00204796f \
 //x=20.47 //y=2.26 //x2=21.58 //y2=2.26
cc_5150 ( N_RN_c_6410_n N_noxref_16_c_9997_n ) capacitor c=0.00933826f \
 //x=20.56 //y=2.095 //x2=21.58 //y2=2.26
cc_5151 ( N_RN_c_6410_n N_noxref_16_c_9998_n ) capacitor c=0.00438372f \
 //x=20.56 //y=2.095 //x2=21.58 //y2=2.095
cc_5152 ( N_RN_c_6376_n N_noxref_16_c_10000_n ) capacitor c=0.00124604f \
 //x=20.47 //y=4.765 //x2=21.58 //y2=4.88
cc_5153 ( N_RN_c_6395_n N_noxref_16_c_10000_n ) capacitor c=0.00187046f \
 //x=20.47 //y=4.88 //x2=21.58 //y2=4.88
cc_5154 ( N_RN_c_6497_n N_noxref_16_c_10000_n ) capacitor c=0.0616777f \
 //x=20.805 //y=4.97 //x2=21.58 //y2=4.88
cc_5155 ( N_RN_c_6413_n N_noxref_16_c_10000_n ) capacitor c=0.00487508f \
 //x=20.47 //y=4.88 //x2=21.58 //y2=4.88
cc_5156 ( N_RN_c_6985_n N_noxref_17_c_10673_n ) capacitor c=0.0076208f \
 //x=72.27 //y=2.515 //x2=73.38 //y2=2.375
cc_5157 ( N_RN_c_7000_n N_noxref_17_c_10673_n ) capacitor c=0.00407348f \
 //x=72.225 //y=2.355 //x2=73.38 //y2=2.375
cc_5158 ( N_RN_c_7006_n N_noxref_17_c_10673_n ) capacitor c=5.39999e-19 \
 //x=72.27 //y=2.26 //x2=73.38 //y2=2.375
cc_5159 ( N_RN_c_7024_n N_noxref_17_c_10673_n ) capacitor c=0.00141318f \
 //x=72.36 //y=2.095 //x2=73.38 //y2=2.375
cc_5160 ( RN N_noxref_17_c_10669_n ) capacitor c=0.0302002f //x=72.27 //y=3.88 \
 //x2=73.38 //y2=3.705
cc_5161 ( N_RN_c_6985_n N_noxref_17_c_10669_n ) capacitor c=0.00248968f \
 //x=72.27 //y=2.515 //x2=73.38 //y2=3.705
cc_5162 ( N_RN_c_7000_n N_noxref_17_c_10669_n ) capacitor c=0.00247598f \
 //x=72.225 //y=2.355 //x2=73.38 //y2=3.705
cc_5163 ( RN N_noxref_17_c_10680_n ) capacitor c=0.00782712f //x=72.27 \
 //y=3.88 //x2=73.38 //y2=4.025
cc_5164 ( RN N_noxref_17_c_10670_n ) capacitor c=0.0181354f //x=72.27 //y=3.88 \
 //x2=73.38 //y2=4.75
cc_5165 ( N_RN_c_6989_n N_noxref_17_c_10670_n ) capacitor c=0.0107551f \
 //x=72.27 //y=4.765 //x2=73.38 //y2=4.75
cc_5166 ( N_RN_c_7009_n N_noxref_17_c_10670_n ) capacitor c=9.52396e-19 \
 //x=72.27 //y=4.88 //x2=73.38 //y2=4.75
cc_5167 ( N_RN_c_7027_n N_noxref_17_c_10670_n ) capacitor c=8.42568e-19 \
 //x=72.27 //y=4.88 //x2=73.38 //y2=4.75
cc_5168 ( RN N_noxref_17_c_10671_n ) capacitor c=3.40764e-19 //x=72.27 \
 //y=3.88 //x2=73.38 //y2=3.88
cc_5169 ( RN N_noxref_17_c_10672_n ) capacitor c=0.00327026f //x=72.27 \
 //y=3.88 //x2=73.54 //y2=3.865
cc_5170 ( N_RN_c_6985_n N_noxref_17_c_10687_n ) capacitor c=8.86271e-19 \
 //x=72.27 //y=2.515 //x2=73.38 //y2=2.26
cc_5171 ( N_RN_c_7006_n N_noxref_17_c_10687_n ) capacitor c=0.00124918f \
 //x=72.27 //y=2.26 //x2=73.38 //y2=2.26
cc_5172 ( N_RN_c_7024_n N_noxref_17_c_10687_n ) capacitor c=0.00209664f \
 //x=72.36 //y=2.095 //x2=73.38 //y2=2.26
cc_5173 ( RN N_noxref_17_c_10690_n ) capacitor c=2.94497e-19 //x=72.27 \
 //y=3.88 //x2=73.38 //y2=4.88
cc_5174 ( N_RN_c_6989_n N_noxref_17_c_10690_n ) capacitor c=4.56604e-19 \
 //x=72.27 //y=4.765 //x2=73.38 //y2=4.88
cc_5175 ( N_RN_c_7009_n N_noxref_17_c_10690_n ) capacitor c=0.00113985f \
 //x=72.27 //y=4.88 //x2=73.38 //y2=4.88
cc_5176 ( N_RN_c_7027_n N_noxref_17_c_10690_n ) capacitor c=0.00129812f \
 //x=72.27 //y=4.88 //x2=73.38 //y2=4.88
cc_5177 ( N_RN_M142_noxref_g N_noxref_17_M144_noxref_g ) capacitor \
 c=0.0101598f //x=72.24 //y=6.2 //x2=73.12 //y2=6.2
cc_5178 ( N_RN_M143_noxref_g N_noxref_17_M144_noxref_g ) capacitor \
 c=0.0607518f //x=72.68 //y=6.2 //x2=73.12 //y2=6.2
cc_5179 ( N_RN_M143_noxref_g N_noxref_17_M145_noxref_g ) capacitor \
 c=0.0101598f //x=72.68 //y=6.2 //x2=73.56 //y2=6.2
cc_5180 ( N_RN_c_7021_n N_noxref_17_c_10697_n ) capacitor c=0.00456962f \
 //x=72.36 //y=1.09 //x2=73.37 //y2=1.095
cc_5181 ( N_RN_c_7022_n N_noxref_17_c_10698_n ) capacitor c=0.00438372f \
 //x=72.36 //y=1.4 //x2=73.37 //y2=1.44
cc_5182 ( N_RN_c_7023_n N_noxref_17_c_10699_n ) capacitor c=0.00438372f \
 //x=72.36 //y=1.63 //x2=73.37 //y2=1.75
cc_5183 ( N_RN_c_6985_n N_noxref_17_c_10700_n ) capacitor c=0.00156352f \
 //x=72.27 //y=2.515 //x2=73.38 //y2=2.26
cc_5184 ( N_RN_c_7006_n N_noxref_17_c_10700_n ) capacitor c=0.00204796f \
 //x=72.27 //y=2.26 //x2=73.38 //y2=2.26
cc_5185 ( N_RN_c_7024_n N_noxref_17_c_10700_n ) capacitor c=0.00933826f \
 //x=72.36 //y=2.095 //x2=73.38 //y2=2.26
cc_5186 ( N_RN_c_7024_n N_noxref_17_c_10703_n ) capacitor c=0.00438372f \
 //x=72.36 //y=2.095 //x2=73.38 //y2=2.095
cc_5187 ( N_RN_c_6989_n N_noxref_17_c_10704_n ) capacitor c=0.00124604f \
 //x=72.27 //y=4.765 //x2=73.38 //y2=4.88
cc_5188 ( N_RN_c_7009_n N_noxref_17_c_10704_n ) capacitor c=0.00187046f \
 //x=72.27 //y=4.88 //x2=73.38 //y2=4.88
cc_5189 ( N_RN_c_7088_p N_noxref_17_c_10704_n ) capacitor c=0.0616777f \
 //x=72.605 //y=4.97 //x2=73.38 //y2=4.88
cc_5190 ( N_RN_c_7027_n N_noxref_17_c_10704_n ) capacitor c=0.00487508f \
 //x=72.27 //y=4.88 //x2=73.38 //y2=4.88
cc_5191 ( N_RN_M64_noxref_g N_VDD_c_11486_n ) capacitor c=0.00755544f //x=8.37 \
 //y=6.2 //x2=8.945 //y2=7.585
cc_5192 ( N_RN_M65_noxref_g N_VDD_c_11486_n ) capacitor c=0.00755754f //x=8.81 \
 //y=6.2 //x2=8.945 //y2=7.585
cc_5193 ( N_RN_M74_noxref_g N_VDD_c_11681_n ) capacitor c=0.00755544f \
 //x=16.51 //y=6.2 //x2=17.085 //y2=7.585
cc_5194 ( N_RN_M75_noxref_g N_VDD_c_11681_n ) capacitor c=0.00755754f \
 //x=16.95 //y=6.2 //x2=17.085 //y2=7.585
cc_5195 ( N_RN_M78_noxref_g N_VDD_c_11689_n ) capacitor c=0.00705252f \
 //x=20.44 //y=6.2 //x2=21.015 //y2=7.585
cc_5196 ( N_RN_M79_noxref_g N_VDD_c_11689_n ) capacitor c=0.00755544f \
 //x=20.88 //y=6.2 //x2=21.015 //y2=7.585
cc_5197 ( N_RN_M96_noxref_g N_VDD_c_11805_n ) capacitor c=0.00755544f \
 //x=34.27 //y=6.2 //x2=34.845 //y2=7.585
cc_5198 ( N_RN_M97_noxref_g N_VDD_c_11805_n ) capacitor c=0.00755754f \
 //x=34.71 //y=6.2 //x2=34.845 //y2=7.585
cc_5199 ( N_RN_M106_noxref_g N_VDD_c_12035_n ) capacitor c=0.00755544f \
 //x=42.41 //y=6.2 //x2=42.985 //y2=7.585
cc_5200 ( N_RN_M107_noxref_g N_VDD_c_12035_n ) capacitor c=0.00755754f \
 //x=42.85 //y=6.2 //x2=42.985 //y2=7.585
cc_5201 ( N_RN_M110_noxref_g N_VDD_c_11974_n ) capacitor c=0.00705252f \
 //x=46.34 //y=6.2 //x2=46.915 //y2=7.585
cc_5202 ( N_RN_M111_noxref_g N_VDD_c_11974_n ) capacitor c=0.00755544f \
 //x=46.78 //y=6.2 //x2=46.915 //y2=7.585
cc_5203 ( N_RN_M128_noxref_g N_VDD_c_12243_n ) capacitor c=0.00755544f \
 //x=60.17 //y=6.2 //x2=60.745 //y2=7.585
cc_5204 ( N_RN_M129_noxref_g N_VDD_c_12243_n ) capacitor c=0.00755754f \
 //x=60.61 //y=6.2 //x2=60.745 //y2=7.585
cc_5205 ( N_RN_M138_noxref_g N_VDD_c_12245_n ) capacitor c=0.00755544f \
 //x=68.31 //y=6.2 //x2=68.885 //y2=7.585
cc_5206 ( N_RN_M139_noxref_g N_VDD_c_12245_n ) capacitor c=0.00755754f \
 //x=68.75 //y=6.2 //x2=68.885 //y2=7.585
cc_5207 ( N_RN_M142_noxref_g N_VDD_c_12247_n ) capacitor c=0.00705252f \
 //x=72.24 //y=6.2 //x2=72.815 //y2=7.585
cc_5208 ( N_RN_M143_noxref_g N_VDD_c_12247_n ) capacitor c=0.00755544f \
 //x=72.68 //y=6.2 //x2=72.815 //y2=7.585
cc_5209 ( N_RN_c_6316_n N_VDD_c_11498_n ) capacitor c=0.00224736f //x=8.63 \
 //y=4.88 //x2=10.11 //y2=7.585
cc_5210 ( N_RN_c_6347_n N_VDD_c_11498_n ) capacitor c=2.63786e-19 //x=8.63 \
 //y=4.88 //x2=10.11 //y2=7.585
cc_5211 ( N_RN_c_6461_n N_VDD_c_11609_n ) capacitor c=0.00224736f //x=16.77 \
 //y=4.88 //x2=18.25 //y2=7.585
cc_5212 ( N_RN_c_6502_n N_VDD_c_11609_n ) capacitor c=2.63786e-19 //x=16.77 \
 //y=4.88 //x2=18.25 //y2=7.585
cc_5213 ( N_RN_c_6532_n N_VDD_c_11817_n ) capacitor c=0.00224736f //x=34.53 \
 //y=4.88 //x2=36.01 //y2=7.585
cc_5214 ( N_RN_c_6563_n N_VDD_c_11817_n ) capacitor c=2.63786e-19 //x=34.53 \
 //y=4.88 //x2=36.01 //y2=7.585
cc_5215 ( N_RN_c_6689_n N_VDD_c_11928_n ) capacitor c=0.00224736f //x=42.67 \
 //y=4.88 //x2=44.15 //y2=7.585
cc_5216 ( N_RN_c_6720_n N_VDD_c_11928_n ) capacitor c=2.63786e-19 //x=42.67 \
 //y=4.88 //x2=44.15 //y2=7.585
cc_5217 ( N_RN_c_6812_n N_VDD_c_12136_n ) capacitor c=0.00224736f //x=60.43 \
 //y=4.88 //x2=61.91 //y2=7.585
cc_5218 ( N_RN_c_6850_n N_VDD_c_12136_n ) capacitor c=2.63786e-19 //x=60.43 \
 //y=4.88 //x2=61.91 //y2=7.585
cc_5219 ( N_RN_c_6931_n N_VDD_c_12201_n ) capacitor c=0.00224736f //x=68.57 \
 //y=4.88 //x2=70.05 //y2=7.585
cc_5220 ( N_RN_c_6969_n N_VDD_c_12201_n ) capacitor c=2.63786e-19 //x=68.57 \
 //y=4.88 //x2=70.05 //y2=7.585
cc_5221 ( N_RN_M64_noxref_g N_VDD_M63_noxref_d ) capacitor c=0.015318f \
 //x=8.37 //y=6.2 //x2=8.005 //y2=5.2
cc_5222 ( N_RN_M65_noxref_g N_VDD_M65_noxref_d ) capacitor c=0.0394719f \
 //x=8.81 //y=6.2 //x2=8.885 //y2=5.2
cc_5223 ( N_RN_M74_noxref_g N_VDD_M73_noxref_d ) capacitor c=0.015318f \
 //x=16.51 //y=6.2 //x2=16.145 //y2=5.2
cc_5224 ( N_RN_M75_noxref_g N_VDD_M75_noxref_d ) capacitor c=0.0394719f \
 //x=16.95 //y=6.2 //x2=17.025 //y2=5.2
cc_5225 ( N_RN_M78_noxref_g N_VDD_M77_noxref_d ) capacitor c=0.015318f \
 //x=20.44 //y=6.2 //x2=20.075 //y2=5.2
cc_5226 ( N_RN_M79_noxref_g N_VDD_M79_noxref_d ) capacitor c=0.015318f \
 //x=20.88 //y=6.2 //x2=20.955 //y2=5.2
cc_5227 ( N_RN_M96_noxref_g N_VDD_M95_noxref_d ) capacitor c=0.015318f \
 //x=34.27 //y=6.2 //x2=33.905 //y2=5.2
cc_5228 ( N_RN_M97_noxref_g N_VDD_M97_noxref_d ) capacitor c=0.0394719f \
 //x=34.71 //y=6.2 //x2=34.785 //y2=5.2
cc_5229 ( N_RN_M106_noxref_g N_VDD_M105_noxref_d ) capacitor c=0.015318f \
 //x=42.41 //y=6.2 //x2=42.045 //y2=5.2
cc_5230 ( N_RN_M107_noxref_g N_VDD_M107_noxref_d ) capacitor c=0.0394719f \
 //x=42.85 //y=6.2 //x2=42.925 //y2=5.2
cc_5231 ( N_RN_M110_noxref_g N_VDD_M109_noxref_d ) capacitor c=0.015318f \
 //x=46.34 //y=6.2 //x2=45.975 //y2=5.2
cc_5232 ( N_RN_M111_noxref_g N_VDD_M111_noxref_d ) capacitor c=0.015318f \
 //x=46.78 //y=6.2 //x2=46.855 //y2=5.2
cc_5233 ( N_RN_M128_noxref_g N_VDD_M127_noxref_d ) capacitor c=0.015318f \
 //x=60.17 //y=6.2 //x2=59.805 //y2=5.2
cc_5234 ( N_RN_M129_noxref_g N_VDD_M129_noxref_d ) capacitor c=0.0394719f \
 //x=60.61 //y=6.2 //x2=60.685 //y2=5.2
cc_5235 ( N_RN_M138_noxref_g N_VDD_M137_noxref_d ) capacitor c=0.015318f \
 //x=68.31 //y=6.2 //x2=67.945 //y2=5.2
cc_5236 ( N_RN_M139_noxref_g N_VDD_M139_noxref_d ) capacitor c=0.0394719f \
 //x=68.75 //y=6.2 //x2=68.825 //y2=5.2
cc_5237 ( N_RN_M142_noxref_g N_VDD_M141_noxref_d ) capacitor c=0.015318f \
 //x=72.24 //y=6.2 //x2=71.875 //y2=5.2
cc_5238 ( N_RN_M143_noxref_g N_VDD_M143_noxref_d ) capacitor c=0.015318f \
 //x=72.68 //y=6.2 //x2=72.755 //y2=5.2
cc_5239 ( RN N_noxref_21_c_12923_n ) capacitor c=0.00171044f //x=8.63 //y=2.4 \
 //x2=9.285 //y2=0.72
cc_5240 ( N_RN_c_6315_n N_noxref_21_c_12923_n ) capacitor c=0.00117306f \
 //x=8.63 //y=2.26 //x2=9.285 //y2=0.72
cc_5241 ( N_RN_c_6326_n N_noxref_21_c_12923_n ) capacitor c=0.0206349f \
 //x=8.62 //y=1.095 //x2=9.285 //y2=0.72
cc_5242 ( N_RN_c_6338_n N_noxref_21_c_12923_n ) capacitor c=0.00825432f \
 //x=9.15 //y=1.095 //x2=9.285 //y2=0.72
cc_5243 ( N_RN_c_6344_n N_noxref_21_c_12923_n ) capacitor c=2.20712e-19 \
 //x=8.63 //y=2.26 //x2=9.285 //y2=0.72
cc_5244 ( N_RN_c_6328_n N_noxref_21_c_12926_n ) capacitor c=0.0071177f \
 //x=8.62 //y=1.44 //x2=8.4 //y2=1.175
cc_5245 ( RN N_noxref_21_M5_noxref_s ) capacitor c=4.5489e-19 //x=8.63 //y=2.4 \
 //x2=8.265 //y2=0.555
cc_5246 ( N_RN_c_6326_n N_noxref_21_M5_noxref_s ) capacitor c=0.0071177f \
 //x=8.62 //y=1.095 //x2=8.265 //y2=0.555
cc_5247 ( N_RN_c_6331_n N_noxref_21_M5_noxref_s ) capacitor c=0.0071177f \
 //x=8.62 //y=1.75 //x2=8.265 //y2=0.555
cc_5248 ( N_RN_c_6338_n N_noxref_21_M5_noxref_s ) capacitor c=0.015333f \
 //x=9.15 //y=1.095 //x2=8.265 //y2=0.555
cc_5249 ( N_RN_c_6340_n N_noxref_21_M5_noxref_s ) capacitor c=0.00248746f \
 //x=9.15 //y=1.44 //x2=8.265 //y2=0.555
cc_5250 ( N_RN_c_6308_n N_noxref_22_c_13004_n ) capacitor c=0.00601428f \
 //x=16.615 //y=2.315 //x2=16.455 //y2=1.175
cc_5251 ( N_RN_c_6429_n N_noxref_22_c_12993_n ) capacitor c=0.00171044f \
 //x=16.77 //y=2.465 //x2=17.425 //y2=0.72
cc_5252 ( N_RN_c_6460_n N_noxref_22_c_12993_n ) capacitor c=0.00117306f \
 //x=16.77 //y=2.26 //x2=17.425 //y2=0.72
cc_5253 ( N_RN_c_6479_n N_noxref_22_c_12993_n ) capacitor c=0.0206349f \
 //x=16.76 //y=1.095 //x2=17.425 //y2=0.72
cc_5254 ( N_RN_c_6491_n N_noxref_22_c_12993_n ) capacitor c=0.00825432f \
 //x=17.29 //y=1.095 //x2=17.425 //y2=0.72
cc_5255 ( N_RN_c_6499_n N_noxref_22_c_12993_n ) capacitor c=2.20712e-19 \
 //x=16.77 //y=2.26 //x2=17.425 //y2=0.72
cc_5256 ( N_RN_c_6481_n N_noxref_22_c_12996_n ) capacitor c=0.0071177f \
 //x=16.76 //y=1.44 //x2=16.54 //y2=1.175
cc_5257 ( N_RN_c_6308_n N_noxref_22_M9_noxref_d ) capacitor c=0.0077966f \
 //x=16.615 //y=2.315 //x2=15.3 //y2=1.09
cc_5258 ( N_RN_c_6429_n N_noxref_22_M10_noxref_s ) capacitor c=4.5489e-19 \
 //x=16.77 //y=2.465 //x2=16.405 //y2=0.555
cc_5259 ( N_RN_c_6308_n N_noxref_22_M10_noxref_s ) capacitor c=0.00417477f \
 //x=16.615 //y=2.315 //x2=16.405 //y2=0.555
cc_5260 ( N_RN_c_6479_n N_noxref_22_M10_noxref_s ) capacitor c=0.0071177f \
 //x=16.76 //y=1.095 //x2=16.405 //y2=0.555
cc_5261 ( N_RN_c_6484_n N_noxref_22_M10_noxref_s ) capacitor c=0.0071177f \
 //x=16.76 //y=1.75 //x2=16.405 //y2=0.555
cc_5262 ( N_RN_c_6491_n N_noxref_22_M10_noxref_s ) capacitor c=0.015333f \
 //x=17.29 //y=1.095 //x2=16.405 //y2=0.555
cc_5263 ( N_RN_c_6493_n N_noxref_22_M10_noxref_s ) capacitor c=0.00248746f \
 //x=17.29 //y=1.44 //x2=16.405 //y2=0.555
cc_5264 ( N_RN_c_6386_n N_noxref_23_c_13071_n ) capacitor c=0.00601428f \
 //x=33.205 //y=2.37 //x2=21.265 //y2=1.175
cc_5265 ( N_RN_c_6407_n N_noxref_23_c_13071_n ) capacitor c=0.00123426f \
 //x=20.56 //y=1.09 //x2=21.265 //y2=1.175
cc_5266 ( N_RN_c_6408_n N_noxref_23_c_13071_n ) capacitor c=0.0129288f \
 //x=20.56 //y=1.4 //x2=21.265 //y2=1.175
cc_5267 ( N_RN_c_6409_n N_noxref_23_c_13071_n ) capacitor c=0.00132209f \
 //x=20.56 //y=1.63 //x2=21.265 //y2=1.175
cc_5268 ( N_RN_c_6386_n N_noxref_23_c_13059_n ) capacitor c=5.06634e-19 \
 //x=33.205 //y=2.37 //x2=22.235 //y2=0.72
cc_5269 ( N_RN_c_6372_n N_noxref_23_M12_noxref_d ) capacitor c=0.00745753f \
 //x=20.47 //y=2.515 //x2=20.11 //y2=1.09
cc_5270 ( N_RN_c_6380_n N_noxref_23_M12_noxref_d ) capacitor c=0.00369679f \
 //x=20.265 //y=2.4 //x2=20.11 //y2=1.09
cc_5271 ( N_RN_c_6386_n N_noxref_23_M12_noxref_d ) capacitor c=0.00198091f \
 //x=33.205 //y=2.37 //x2=20.11 //y2=1.09
cc_5272 ( N_RN_c_6392_n N_noxref_23_M12_noxref_d ) capacitor c=2.2052e-19 \
 //x=20.47 //y=2.26 //x2=20.11 //y2=1.09
cc_5273 ( N_RN_c_6402_n N_noxref_23_M12_noxref_d ) capacitor c=0.00253592f \
 //x=20.035 //y=1.09 //x2=20.11 //y2=1.09
cc_5274 ( N_RN_c_6405_n N_noxref_23_M12_noxref_d ) capacitor c=0.00604087f \
 //x=20.035 //y=1.4 //x2=20.11 //y2=1.09
cc_5275 ( N_RN_c_7428_p N_noxref_23_M12_noxref_d ) capacitor c=0.002686f \
 //x=20.405 //y=0.935 //x2=20.11 //y2=1.09
cc_5276 ( N_RN_c_7429_p N_noxref_23_M12_noxref_d ) capacitor c=0.00251995f \
 //x=20.405 //y=1.555 //x2=20.11 //y2=1.09
cc_5277 ( N_RN_c_6407_n N_noxref_23_M12_noxref_d ) capacitor c=0.00314523f \
 //x=20.56 //y=1.09 //x2=20.11 //y2=1.09
cc_5278 ( N_RN_c_6408_n N_noxref_23_M12_noxref_d ) capacitor c=0.00168289f \
 //x=20.56 //y=1.4 //x2=20.11 //y2=1.09
cc_5279 ( N_RN_c_6409_n N_noxref_23_M12_noxref_d ) capacitor c=0.00111165f \
 //x=20.56 //y=1.63 //x2=20.11 //y2=1.09
cc_5280 ( N_RN_c_6386_n N_noxref_23_M13_noxref_s ) capacitor c=0.00449218f \
 //x=33.205 //y=2.37 //x2=21.215 //y2=0.555
cc_5281 ( N_RN_c_6407_n N_noxref_23_M13_noxref_s ) capacitor c=7.21316e-19 \
 //x=20.56 //y=1.09 //x2=21.215 //y2=0.555
cc_5282 ( N_RN_c_6408_n N_noxref_23_M13_noxref_s ) capacitor c=0.00365271f \
 //x=20.56 //y=1.4 //x2=21.215 //y2=0.555
cc_5283 ( N_RN_c_6410_n N_noxref_23_M13_noxref_s ) capacitor c=9.86711e-19 \
 //x=20.56 //y=2.095 //x2=21.215 //y2=0.555
cc_5284 ( N_RN_c_6386_n N_noxref_24_c_13149_n ) capacitor c=0.00601428f \
 //x=33.205 //y=2.37 //x2=29.405 //y2=1.175
cc_5285 ( N_RN_c_6386_n N_noxref_24_c_13128_n ) capacitor c=5.06634e-19 \
 //x=33.205 //y=2.37 //x2=30.375 //y2=0.72
cc_5286 ( N_RN_c_6386_n N_noxref_24_M17_noxref_d ) capacitor c=0.00782377f \
 //x=33.205 //y=2.37 //x2=28.25 //y2=1.09
cc_5287 ( N_RN_c_6386_n N_noxref_24_M18_noxref_s ) capacitor c=0.00448124f \
 //x=33.205 //y=2.37 //x2=29.355 //y2=0.555
cc_5288 ( N_RN_c_6523_n N_noxref_25_c_13207_n ) capacitor c=0.00601428f \
 //x=34.695 //y=2.4 //x2=34.215 //y2=1.175
cc_5289 ( N_RN_c_6506_n N_noxref_25_c_13195_n ) capacitor c=0.00171044f \
 //x=34.53 //y=2.465 //x2=35.185 //y2=0.72
cc_5290 ( N_RN_c_6531_n N_noxref_25_c_13195_n ) capacitor c=0.00117306f \
 //x=34.53 //y=2.26 //x2=35.185 //y2=0.72
cc_5291 ( N_RN_c_6542_n N_noxref_25_c_13195_n ) capacitor c=0.0206349f \
 //x=34.52 //y=1.095 //x2=35.185 //y2=0.72
cc_5292 ( N_RN_c_6554_n N_noxref_25_c_13195_n ) capacitor c=0.00825432f \
 //x=35.05 //y=1.095 //x2=35.185 //y2=0.72
cc_5293 ( N_RN_c_6560_n N_noxref_25_c_13195_n ) capacitor c=2.20712e-19 \
 //x=34.53 //y=2.26 //x2=35.185 //y2=0.72
cc_5294 ( N_RN_c_6544_n N_noxref_25_c_13198_n ) capacitor c=0.0071177f \
 //x=34.52 //y=1.44 //x2=34.3 //y2=1.175
cc_5295 ( N_RN_c_6386_n N_noxref_25_M20_noxref_d ) capacitor c=0.00738072f \
 //x=33.205 //y=2.37 //x2=33.06 //y2=1.09
cc_5296 ( N_RN_c_6506_n N_noxref_25_M21_noxref_s ) capacitor c=4.5489e-19 \
 //x=34.53 //y=2.465 //x2=34.165 //y2=0.555
cc_5297 ( N_RN_c_6523_n N_noxref_25_M21_noxref_s ) capacitor c=0.00418676f \
 //x=34.695 //y=2.4 //x2=34.165 //y2=0.555
cc_5298 ( N_RN_c_6542_n N_noxref_25_M21_noxref_s ) capacitor c=0.0071177f \
 //x=34.52 //y=1.095 //x2=34.165 //y2=0.555
cc_5299 ( N_RN_c_6547_n N_noxref_25_M21_noxref_s ) capacitor c=0.0071177f \
 //x=34.52 //y=1.75 //x2=34.165 //y2=0.555
cc_5300 ( N_RN_c_6554_n N_noxref_25_M21_noxref_s ) capacitor c=0.015333f \
 //x=35.05 //y=1.095 //x2=34.165 //y2=0.555
cc_5301 ( N_RN_c_6556_n N_noxref_25_M21_noxref_s ) capacitor c=0.00248746f \
 //x=35.05 //y=1.44 //x2=34.165 //y2=0.555
cc_5302 ( N_RN_c_6525_n N_noxref_26_c_13275_n ) capacitor c=0.00601428f \
 //x=42.515 //y=2.315 //x2=42.355 //y2=1.175
cc_5303 ( N_RN_c_6667_n N_noxref_26_c_13264_n ) capacitor c=0.00171044f \
 //x=42.67 //y=2.465 //x2=43.325 //y2=0.72
cc_5304 ( N_RN_c_6688_n N_noxref_26_c_13264_n ) capacitor c=0.00117306f \
 //x=42.67 //y=2.26 //x2=43.325 //y2=0.72
cc_5305 ( N_RN_c_6699_n N_noxref_26_c_13264_n ) capacitor c=0.0206349f \
 //x=42.66 //y=1.095 //x2=43.325 //y2=0.72
cc_5306 ( N_RN_c_6711_n N_noxref_26_c_13264_n ) capacitor c=0.00825432f \
 //x=43.19 //y=1.095 //x2=43.325 //y2=0.72
cc_5307 ( N_RN_c_6717_n N_noxref_26_c_13264_n ) capacitor c=2.20712e-19 \
 //x=42.67 //y=2.26 //x2=43.325 //y2=0.72
cc_5308 ( N_RN_c_6701_n N_noxref_26_c_13267_n ) capacitor c=0.0071177f \
 //x=42.66 //y=1.44 //x2=42.44 //y2=1.175
cc_5309 ( N_RN_c_6525_n N_noxref_26_M25_noxref_d ) capacitor c=0.0077966f \
 //x=42.515 //y=2.315 //x2=41.2 //y2=1.09
cc_5310 ( N_RN_c_6667_n N_noxref_26_M26_noxref_s ) capacitor c=4.5489e-19 \
 //x=42.67 //y=2.465 //x2=42.305 //y2=0.555
cc_5311 ( N_RN_c_6525_n N_noxref_26_M26_noxref_s ) capacitor c=0.00417477f \
 //x=42.515 //y=2.315 //x2=42.305 //y2=0.555
cc_5312 ( N_RN_c_6699_n N_noxref_26_M26_noxref_s ) capacitor c=0.0071177f \
 //x=42.66 //y=1.095 //x2=42.305 //y2=0.555
cc_5313 ( N_RN_c_6704_n N_noxref_26_M26_noxref_s ) capacitor c=0.0071177f \
 //x=42.66 //y=1.75 //x2=42.305 //y2=0.555
cc_5314 ( N_RN_c_6711_n N_noxref_26_M26_noxref_s ) capacitor c=0.015333f \
 //x=43.19 //y=1.095 //x2=42.305 //y2=0.555
cc_5315 ( N_RN_c_6713_n N_noxref_26_M26_noxref_s ) capacitor c=0.00248746f \
 //x=43.19 //y=1.44 //x2=42.305 //y2=0.555
cc_5316 ( N_RN_c_6606_n N_noxref_27_c_13342_n ) capacitor c=0.00601428f \
 //x=59.105 //y=2.385 //x2=47.165 //y2=1.175
cc_5317 ( N_RN_c_6623_n N_noxref_27_c_13342_n ) capacitor c=0.00123426f \
 //x=46.46 //y=1.09 //x2=47.165 //y2=1.175
cc_5318 ( N_RN_c_6624_n N_noxref_27_c_13342_n ) capacitor c=0.0129288f \
 //x=46.46 //y=1.4 //x2=47.165 //y2=1.175
cc_5319 ( N_RN_c_6625_n N_noxref_27_c_13342_n ) capacitor c=0.00132209f \
 //x=46.46 //y=1.63 //x2=47.165 //y2=1.175
cc_5320 ( N_RN_c_6606_n N_noxref_27_c_13330_n ) capacitor c=5.06634e-19 \
 //x=59.105 //y=2.385 //x2=48.135 //y2=0.72
cc_5321 ( N_RN_c_6587_n N_noxref_27_M28_noxref_d ) capacitor c=0.00745753f \
 //x=46.37 //y=2.515 //x2=46.01 //y2=1.09
cc_5322 ( N_RN_c_6602_n N_noxref_27_M28_noxref_d ) capacitor c=0.00369679f \
 //x=46.165 //y=2.4 //x2=46.01 //y2=1.09
cc_5323 ( N_RN_c_6606_n N_noxref_27_M28_noxref_d ) capacitor c=0.00198091f \
 //x=59.105 //y=2.385 //x2=46.01 //y2=1.09
cc_5324 ( N_RN_c_6608_n N_noxref_27_M28_noxref_d ) capacitor c=2.2052e-19 \
 //x=46.37 //y=2.26 //x2=46.01 //y2=1.09
cc_5325 ( N_RN_c_6618_n N_noxref_27_M28_noxref_d ) capacitor c=0.00253592f \
 //x=45.935 //y=1.09 //x2=46.01 //y2=1.09
cc_5326 ( N_RN_c_6621_n N_noxref_27_M28_noxref_d ) capacitor c=0.00604087f \
 //x=45.935 //y=1.4 //x2=46.01 //y2=1.09
cc_5327 ( N_RN_c_7480_p N_noxref_27_M28_noxref_d ) capacitor c=0.002686f \
 //x=46.305 //y=0.935 //x2=46.01 //y2=1.09
cc_5328 ( N_RN_c_7481_p N_noxref_27_M28_noxref_d ) capacitor c=0.00251995f \
 //x=46.305 //y=1.555 //x2=46.01 //y2=1.09
cc_5329 ( N_RN_c_6623_n N_noxref_27_M28_noxref_d ) capacitor c=0.00314523f \
 //x=46.46 //y=1.09 //x2=46.01 //y2=1.09
cc_5330 ( N_RN_c_6624_n N_noxref_27_M28_noxref_d ) capacitor c=0.00168289f \
 //x=46.46 //y=1.4 //x2=46.01 //y2=1.09
cc_5331 ( N_RN_c_6625_n N_noxref_27_M28_noxref_d ) capacitor c=0.00111165f \
 //x=46.46 //y=1.63 //x2=46.01 //y2=1.09
cc_5332 ( N_RN_c_6606_n N_noxref_27_M29_noxref_s ) capacitor c=0.00448124f \
 //x=59.105 //y=2.385 //x2=47.115 //y2=0.555
cc_5333 ( N_RN_c_6623_n N_noxref_27_M29_noxref_s ) capacitor c=7.21316e-19 \
 //x=46.46 //y=1.09 //x2=47.115 //y2=0.555
cc_5334 ( N_RN_c_6624_n N_noxref_27_M29_noxref_s ) capacitor c=0.00365271f \
 //x=46.46 //y=1.4 //x2=47.115 //y2=0.555
cc_5335 ( N_RN_c_6626_n N_noxref_27_M29_noxref_s ) capacitor c=9.86711e-19 \
 //x=46.46 //y=2.095 //x2=47.115 //y2=0.555
cc_5336 ( N_RN_c_6606_n N_noxref_28_c_13398_n ) capacitor c=0.00601428f \
 //x=59.105 //y=2.385 //x2=55.305 //y2=1.175
cc_5337 ( N_RN_c_6606_n N_noxref_28_c_13413_n ) capacitor c=5.06634e-19 \
 //x=59.105 //y=2.385 //x2=56.275 //y2=0.72
cc_5338 ( N_RN_c_6606_n N_noxref_28_M33_noxref_d ) capacitor c=0.00782377f \
 //x=59.105 //y=2.385 //x2=54.15 //y2=1.09
cc_5339 ( N_RN_c_6606_n N_noxref_28_M34_noxref_s ) capacitor c=0.00448124f \
 //x=59.105 //y=2.385 //x2=55.255 //y2=0.555
cc_5340 ( N_RN_c_6791_n N_noxref_29_c_13465_n ) capacitor c=0.00601428f \
 //x=60.595 //y=2.4 //x2=60.115 //y2=1.175
cc_5341 ( N_RN_c_6760_n N_noxref_29_c_13483_n ) capacitor c=0.00171044f \
 //x=60.43 //y=2.465 //x2=61.085 //y2=0.72
cc_5342 ( N_RN_c_6809_n N_noxref_29_c_13483_n ) capacitor c=0.00117306f \
 //x=60.43 //y=2.26 //x2=61.085 //y2=0.72
cc_5343 ( N_RN_c_6830_n N_noxref_29_c_13483_n ) capacitor c=0.0206349f \
 //x=60.42 //y=1.095 //x2=61.085 //y2=0.72
cc_5344 ( N_RN_c_7140_p N_noxref_29_c_13483_n ) capacitor c=0.00825432f \
 //x=60.95 //y=1.095 //x2=61.085 //y2=0.72
cc_5345 ( N_RN_c_6847_n N_noxref_29_c_13483_n ) capacitor c=2.20712e-19 \
 //x=60.43 //y=2.26 //x2=61.085 //y2=0.72
cc_5346 ( N_RN_c_6831_n N_noxref_29_c_13488_n ) capacitor c=0.0071177f \
 //x=60.42 //y=1.44 //x2=60.2 //y2=1.175
cc_5347 ( N_RN_c_6606_n N_noxref_29_M36_noxref_d ) capacitor c=0.00732599f \
 //x=59.105 //y=2.385 //x2=58.96 //y2=1.09
cc_5348 ( N_RN_c_6760_n N_noxref_29_M37_noxref_s ) capacitor c=4.5489e-19 \
 //x=60.43 //y=2.465 //x2=60.065 //y2=0.555
cc_5349 ( N_RN_c_6791_n N_noxref_29_M37_noxref_s ) capacitor c=0.00418676f \
 //x=60.595 //y=2.4 //x2=60.065 //y2=0.555
cc_5350 ( N_RN_c_6830_n N_noxref_29_M37_noxref_s ) capacitor c=0.0071177f \
 //x=60.42 //y=1.095 //x2=60.065 //y2=0.555
cc_5351 ( N_RN_c_6832_n N_noxref_29_M37_noxref_s ) capacitor c=0.0071177f \
 //x=60.42 //y=1.75 //x2=60.065 //y2=0.555
cc_5352 ( N_RN_c_7140_p N_noxref_29_M37_noxref_s ) capacitor c=0.015333f \
 //x=60.95 //y=1.095 //x2=60.065 //y2=0.555
cc_5353 ( N_RN_c_7141_p N_noxref_29_M37_noxref_s ) capacitor c=0.00248746f \
 //x=60.95 //y=1.44 //x2=60.065 //y2=0.555
cc_5354 ( N_RN_c_6911_n N_noxref_30_c_13533_n ) capacitor c=0.00601428f \
 //x=68.415 //y=2.315 //x2=68.255 //y2=1.175
cc_5355 ( N_RN_c_6884_n N_noxref_30_c_13549_n ) capacitor c=0.00171044f \
 //x=68.57 //y=2.465 //x2=69.225 //y2=0.72
cc_5356 ( N_RN_c_6928_n N_noxref_30_c_13549_n ) capacitor c=0.00117306f \
 //x=68.57 //y=2.26 //x2=69.225 //y2=0.72
cc_5357 ( N_RN_c_6949_n N_noxref_30_c_13549_n ) capacitor c=0.0206349f \
 //x=68.56 //y=1.095 //x2=69.225 //y2=0.72
cc_5358 ( N_RN_c_7047_p N_noxref_30_c_13549_n ) capacitor c=0.00825432f \
 //x=69.09 //y=1.095 //x2=69.225 //y2=0.72
cc_5359 ( N_RN_c_6966_n N_noxref_30_c_13549_n ) capacitor c=2.20712e-19 \
 //x=68.57 //y=2.26 //x2=69.225 //y2=0.72
cc_5360 ( N_RN_c_6950_n N_noxref_30_c_13554_n ) capacitor c=0.0071177f \
 //x=68.56 //y=1.44 //x2=68.34 //y2=1.175
cc_5361 ( N_RN_c_6911_n N_noxref_30_M41_noxref_d ) capacitor c=0.0077966f \
 //x=68.415 //y=2.315 //x2=67.1 //y2=1.09
cc_5362 ( N_RN_c_6884_n N_noxref_30_M42_noxref_s ) capacitor c=4.5489e-19 \
 //x=68.57 //y=2.465 //x2=68.205 //y2=0.555
cc_5363 ( N_RN_c_6911_n N_noxref_30_M42_noxref_s ) capacitor c=0.00417477f \
 //x=68.415 //y=2.315 //x2=68.205 //y2=0.555
cc_5364 ( N_RN_c_6949_n N_noxref_30_M42_noxref_s ) capacitor c=0.0071177f \
 //x=68.56 //y=1.095 //x2=68.205 //y2=0.555
cc_5365 ( N_RN_c_6951_n N_noxref_30_M42_noxref_s ) capacitor c=0.0071177f \
 //x=68.56 //y=1.75 //x2=68.205 //y2=0.555
cc_5366 ( N_RN_c_7047_p N_noxref_30_M42_noxref_s ) capacitor c=0.015333f \
 //x=69.09 //y=1.095 //x2=68.205 //y2=0.555
cc_5367 ( N_RN_c_7048_p N_noxref_30_M42_noxref_s ) capacitor c=0.00248746f \
 //x=69.09 //y=1.44 //x2=68.205 //y2=0.555
cc_5368 ( N_RN_c_7021_n N_noxref_31_c_13600_n ) capacitor c=0.00123426f \
 //x=72.36 //y=1.09 //x2=73.065 //y2=1.175
cc_5369 ( N_RN_c_7022_n N_noxref_31_c_13600_n ) capacitor c=0.0129288f \
 //x=72.36 //y=1.4 //x2=73.065 //y2=1.175
cc_5370 ( N_RN_c_7023_n N_noxref_31_c_13600_n ) capacitor c=0.00132209f \
 //x=72.36 //y=1.63 //x2=73.065 //y2=1.175
cc_5371 ( N_RN_c_6985_n N_noxref_31_M44_noxref_d ) capacitor c=0.00745753f \
 //x=72.27 //y=2.515 //x2=71.91 //y2=1.09
cc_5372 ( N_RN_c_7000_n N_noxref_31_M44_noxref_d ) capacitor c=0.00198091f \
 //x=72.225 //y=2.355 //x2=71.91 //y2=1.09
cc_5373 ( N_RN_c_7002_n N_noxref_31_M44_noxref_d ) capacitor c=0.00369679f \
 //x=72.065 //y=2.355 //x2=71.91 //y2=1.09
cc_5374 ( N_RN_c_7006_n N_noxref_31_M44_noxref_d ) capacitor c=2.2052e-19 \
 //x=72.27 //y=2.26 //x2=71.91 //y2=1.09
cc_5375 ( N_RN_c_7016_n N_noxref_31_M44_noxref_d ) capacitor c=0.00253592f \
 //x=71.835 //y=1.09 //x2=71.91 //y2=1.09
cc_5376 ( N_RN_c_7019_n N_noxref_31_M44_noxref_d ) capacitor c=0.00604087f \
 //x=71.835 //y=1.4 //x2=71.91 //y2=1.09
cc_5377 ( N_RN_c_7530_p N_noxref_31_M44_noxref_d ) capacitor c=0.002686f \
 //x=72.205 //y=0.935 //x2=71.91 //y2=1.09
cc_5378 ( N_RN_c_7531_p N_noxref_31_M44_noxref_d ) capacitor c=0.00251995f \
 //x=72.205 //y=1.555 //x2=71.91 //y2=1.09
cc_5379 ( N_RN_c_7021_n N_noxref_31_M44_noxref_d ) capacitor c=0.00314523f \
 //x=72.36 //y=1.09 //x2=71.91 //y2=1.09
cc_5380 ( N_RN_c_7022_n N_noxref_31_M44_noxref_d ) capacitor c=0.00168289f \
 //x=72.36 //y=1.4 //x2=71.91 //y2=1.09
cc_5381 ( N_RN_c_7023_n N_noxref_31_M44_noxref_d ) capacitor c=0.00111165f \
 //x=72.36 //y=1.63 //x2=71.91 //y2=1.09
cc_5382 ( N_RN_c_7021_n N_noxref_31_M45_noxref_s ) capacitor c=7.21316e-19 \
 //x=72.36 //y=1.09 //x2=73.015 //y2=0.555
cc_5383 ( N_RN_c_7022_n N_noxref_31_M45_noxref_s ) capacitor c=0.00365271f \
 //x=72.36 //y=1.4 //x2=73.015 //y2=0.555
cc_5384 ( N_RN_c_7024_n N_noxref_31_M45_noxref_s ) capacitor c=9.86711e-19 \
 //x=72.36 //y=2.095 //x2=73.015 //y2=0.555
cc_5385 ( RN N_GND_c_13952_n ) capacitor c=0.00180101f //x=8.63 //y=2.4 \
 //x2=11.205 //y2=0.175
cc_5386 ( N_RN_c_6305_n N_GND_c_13952_n ) capacitor c=0.00547183f //x=8.635 \
 //y=2.305 //x2=11.205 //y2=0.175
cc_5387 ( N_RN_c_6308_n N_GND_c_13952_n ) capacitor c=0.0654862f //x=16.615 \
 //y=2.315 //x2=11.205 //y2=0.175
cc_5388 ( N_RN_c_6308_n N_GND_c_13992_n ) capacitor c=0.0817754f //x=16.615 \
 //y=2.315 //x2=14.43 //y2=0.175
cc_5389 ( N_RN_c_6429_n N_GND_c_14098_n ) capacitor c=0.00180101f //x=16.77 \
 //y=2.465 //x2=19.24 //y2=0.175
cc_5390 ( N_RN_c_6380_n N_GND_c_14098_n ) capacitor c=0.0636619f //x=20.265 \
 //y=2.4 //x2=19.24 //y2=0.175
cc_5391 ( N_RN_c_6308_n N_GND_c_14098_n ) capacitor c=0.0532738f //x=16.615 \
 //y=2.315 //x2=19.24 //y2=0.175
cc_5392 ( N_RN_c_6391_n N_GND_c_14098_n ) capacitor c=0.00547129f //x=16.935 \
 //y=2.315 //x2=19.24 //y2=0.175
cc_5393 ( N_RN_c_6372_n N_GND_c_14101_n ) capacitor c=7.96673e-19 //x=20.47 \
 //y=2.515 //x2=24.155 //y2=0.175
cc_5394 ( N_RN_c_6380_n N_GND_c_14101_n ) capacitor c=0.0202802f //x=20.265 \
 //y=2.4 //x2=24.155 //y2=0.175
cc_5395 ( N_RN_c_6386_n N_GND_c_14101_n ) capacitor c=0.109089f //x=33.205 \
 //y=2.37 //x2=24.155 //y2=0.175
cc_5396 ( N_RN_c_6386_n N_GND_c_14105_n ) capacitor c=0.082879f //x=33.205 \
 //y=2.37 //x2=27.38 //y2=0.175
cc_5397 ( N_RN_c_6386_n N_GND_c_14171_n ) capacitor c=0.125954f //x=33.205 \
 //y=2.37 //x2=32.19 //y2=0.175
cc_5398 ( N_RN_c_6506_n N_GND_c_14172_n ) capacitor c=0.00180101f //x=34.53 \
 //y=2.465 //x2=37.105 //y2=0.175
cc_5399 ( N_RN_c_6771_n N_GND_c_14172_n ) capacitor c=0.00749821f //x=33.635 \
 //y=2.37 //x2=37.105 //y2=0.175
cc_5400 ( N_RN_c_6386_n N_GND_c_14172_n ) capacitor c=0.0194892f //x=33.205 \
 //y=2.37 //x2=37.105 //y2=0.175
cc_5401 ( N_RN_c_6523_n N_GND_c_14172_n ) capacitor c=0.0289143f //x=34.695 \
 //y=2.4 //x2=37.105 //y2=0.175
cc_5402 ( N_RN_c_6525_n N_GND_c_14172_n ) capacitor c=0.0654862f //x=42.515 \
 //y=2.315 //x2=37.105 //y2=0.175
cc_5403 ( N_RN_c_6525_n N_GND_c_14210_n ) capacitor c=0.0817754f //x=42.515 \
 //y=2.315 //x2=40.33 //y2=0.175
cc_5404 ( N_RN_c_6667_n N_GND_c_14347_n ) capacitor c=0.00180101f //x=42.67 \
 //y=2.465 //x2=45.14 //y2=0.175
cc_5405 ( N_RN_c_6602_n N_GND_c_14347_n ) capacitor c=0.0636619f //x=46.165 \
 //y=2.4 //x2=45.14 //y2=0.175
cc_5406 ( N_RN_c_6525_n N_GND_c_14347_n ) capacitor c=0.0532738f //x=42.515 \
 //y=2.315 //x2=45.14 //y2=0.175
cc_5407 ( N_RN_c_6686_n N_GND_c_14347_n ) capacitor c=0.00547129f //x=42.835 \
 //y=2.315 //x2=45.14 //y2=0.175
cc_5408 ( N_RN_c_6587_n N_GND_c_14310_n ) capacitor c=7.96673e-19 //x=46.37 \
 //y=2.515 //x2=50.055 //y2=0.175
cc_5409 ( N_RN_c_6602_n N_GND_c_14310_n ) capacitor c=0.0202802f //x=46.165 \
 //y=2.4 //x2=50.055 //y2=0.175
cc_5410 ( N_RN_c_6606_n N_GND_c_14310_n ) capacitor c=0.108954f //x=59.105 \
 //y=2.385 //x2=50.055 //y2=0.175
cc_5411 ( N_RN_c_6606_n N_GND_c_14350_n ) capacitor c=0.0829872f //x=59.105 \
 //y=2.385 //x2=53.28 //y2=0.175
cc_5412 ( N_RN_c_6606_n N_GND_c_14416_n ) capacitor c=0.125954f //x=59.105 \
 //y=2.385 //x2=58.09 //y2=0.175
cc_5413 ( N_RN_c_6760_n N_GND_c_14392_n ) capacitor c=0.00180101f //x=60.43 \
 //y=2.465 //x2=63.005 //y2=0.175
cc_5414 ( N_RN_c_6783_n N_GND_c_14392_n ) capacitor c=0.00745614f //x=59.535 \
 //y=2.385 //x2=63.005 //y2=0.175
cc_5415 ( N_RN_c_6606_n N_GND_c_14392_n ) capacitor c=0.0194892f //x=59.105 \
 //y=2.385 //x2=63.005 //y2=0.175
cc_5416 ( N_RN_c_6791_n N_GND_c_14392_n ) capacitor c=0.0289143f //x=60.595 \
 //y=2.4 //x2=63.005 //y2=0.175
cc_5417 ( N_RN_c_6911_n N_GND_c_14392_n ) capacitor c=0.0654862f //x=68.415 \
 //y=2.315 //x2=63.005 //y2=0.175
cc_5418 ( N_RN_c_6911_n N_GND_c_14511_n ) capacitor c=0.0817754f //x=68.415 \
 //y=2.315 //x2=66.23 //y2=0.175
cc_5419 ( N_RN_c_6884_n N_GND_c_14417_n ) capacitor c=0.00180101f //x=68.57 \
 //y=2.465 //x2=71.04 //y2=0.175
cc_5420 ( N_RN_c_6911_n N_GND_c_14417_n ) capacitor c=0.0532738f //x=68.415 \
 //y=2.315 //x2=71.04 //y2=0.175
cc_5421 ( N_RN_c_6915_n N_GND_c_14417_n ) capacitor c=0.00547129f //x=68.735 \
 //y=2.315 //x2=71.04 //y2=0.175
cc_5422 ( N_RN_c_7002_n N_GND_c_14417_n ) capacitor c=0.0636619f //x=72.065 \
 //y=2.355 //x2=71.04 //y2=0.175
cc_5423 ( N_RN_c_6985_n N_GND_c_14516_n ) capacitor c=8.03219e-19 //x=72.27 \
 //y=2.515 //x2=75.955 //y2=0.175
cc_5424 ( N_RN_c_7000_n N_GND_c_14516_n ) capacitor c=0.00258052f //x=72.225 \
 //y=2.355 //x2=75.955 //y2=0.175
cc_5425 ( N_RN_c_7002_n N_GND_c_14516_n ) capacitor c=0.0202802f //x=72.065 \
 //y=2.355 //x2=75.955 //y2=0.175
cc_5426 ( N_RN_c_6308_n N_GND_c_13957_n ) capacitor c=0.00594804f //x=16.615 \
 //y=2.315 //x2=11.29 //y2=1.135
cc_5427 ( N_RN_c_6308_n N_GND_c_14002_n ) capacitor c=0.00551716f //x=16.615 \
 //y=2.315 //x2=14.515 //y2=1.145
cc_5428 ( N_RN_c_6380_n N_GND_c_14054_n ) capacitor c=0.0055656f //x=20.265 \
 //y=2.4 //x2=19.325 //y2=1.145
cc_5429 ( N_RN_c_6386_n N_GND_c_14117_n ) capacitor c=0.00611012f //x=33.205 \
 //y=2.37 //x2=24.24 //y2=1.135
cc_5430 ( N_RN_c_6386_n N_GND_c_14351_n ) capacitor c=0.00561869f //x=33.205 \
 //y=2.37 //x2=27.465 //y2=1.145
cc_5431 ( N_RN_c_6386_n N_GND_c_14260_n ) capacitor c=0.00558918f //x=33.205 \
 //y=2.37 //x2=32.275 //y2=1.145
cc_5432 ( N_RN_c_6525_n N_GND_c_14176_n ) capacitor c=0.00594804f //x=42.515 \
 //y=2.315 //x2=37.19 //y2=1.135
cc_5433 ( N_RN_c_6525_n N_GND_c_14220_n ) capacitor c=0.00551716f //x=42.515 \
 //y=2.315 //x2=40.415 //y2=1.145
cc_5434 ( N_RN_c_6602_n N_GND_c_14271_n ) capacitor c=0.0055656f //x=46.165 \
 //y=2.4 //x2=45.225 //y2=1.145
cc_5435 ( N_RN_c_6606_n N_GND_c_14314_n ) capacitor c=0.00605228f //x=59.105 \
 //y=2.385 //x2=50.14 //y2=1.135
cc_5436 ( N_RN_c_6606_n N_GND_c_14529_n ) capacitor c=0.00561869f //x=59.105 \
 //y=2.385 //x2=53.365 //y2=1.145
cc_5437 ( N_RN_c_6606_n N_GND_c_14428_n ) capacitor c=0.00558918f //x=59.105 \
 //y=2.385 //x2=58.175 //y2=1.145
cc_5438 ( N_RN_c_6911_n N_GND_c_14531_n ) capacitor c=0.00594804f //x=68.415 \
 //y=2.315 //x2=63.09 //y2=1.135
cc_5439 ( N_RN_c_6911_n N_GND_c_14532_n ) capacitor c=0.00551716f //x=68.415 \
 //y=2.315 //x2=66.315 //y2=1.145
cc_5440 ( N_RN_c_7002_n N_GND_c_14439_n ) capacitor c=0.0055656f //x=72.065 \
 //y=2.355 //x2=71.125 //y2=1.145
cc_5441 ( N_RN_c_6308_n N_GND_c_13977_n ) capacitor c=0.0212447f //x=16.615 \
 //y=2.315 //x2=10.11 //y2=0.175
cc_5442 ( N_RN_c_6315_n N_GND_c_13977_n ) capacitor c=0.00224448f //x=8.63 \
 //y=2.26 //x2=10.11 //y2=0.175
cc_5443 ( N_RN_c_6340_n N_GND_c_13977_n ) capacitor c=0.00262688f //x=9.15 \
 //y=1.44 //x2=10.11 //y2=0.175
cc_5444 ( N_RN_c_6344_n N_GND_c_13977_n ) capacitor c=2.63786e-19 //x=8.63 \
 //y=2.26 //x2=10.11 //y2=0.175
cc_5445 ( N_RN_c_6308_n N_GND_c_14017_n ) capacitor c=0.0213203f //x=16.615 \
 //y=2.315 //x2=13.44 //y2=0.175
cc_5446 ( N_RN_c_6380_n N_GND_c_14074_n ) capacitor c=0.0213456f //x=20.265 \
 //y=2.4 //x2=18.25 //y2=0.175
cc_5447 ( N_RN_c_6460_n N_GND_c_14074_n ) capacitor c=0.00218156f //x=16.77 \
 //y=2.26 //x2=18.25 //y2=0.175
cc_5448 ( N_RN_c_6493_n N_GND_c_14074_n ) capacitor c=0.00262688f //x=17.29 \
 //y=1.44 //x2=18.25 //y2=0.175
cc_5449 ( N_RN_c_6499_n N_GND_c_14074_n ) capacitor c=2.63786e-19 //x=16.77 \
 //y=2.26 //x2=18.25 //y2=0.175
cc_5450 ( N_RN_c_6386_n N_GND_c_14147_n ) capacitor c=0.0213203f //x=33.205 \
 //y=2.37 //x2=23.06 //y2=0.175
cc_5451 ( N_RN_c_6386_n N_GND_c_14154_n ) capacitor c=0.0213203f //x=33.205 \
 //y=2.37 //x2=26.39 //y2=0.175
cc_5452 ( N_RN_c_6386_n N_GND_c_14193_n ) capacitor c=0.0213079f //x=33.205 \
 //y=2.37 //x2=31.2 //y2=0.175
cc_5453 ( N_RN_c_6525_n N_GND_c_14196_n ) capacitor c=0.0212826f //x=42.515 \
 //y=2.315 //x2=36.01 //y2=0.175
cc_5454 ( N_RN_c_6531_n N_GND_c_14196_n ) capacitor c=0.00224448f //x=34.53 \
 //y=2.26 //x2=36.01 //y2=0.175
cc_5455 ( N_RN_c_6556_n N_GND_c_14196_n ) capacitor c=0.00262688f //x=35.05 \
 //y=1.44 //x2=36.01 //y2=0.175
cc_5456 ( N_RN_c_6560_n N_GND_c_14196_n ) capacitor c=2.63786e-19 //x=34.53 \
 //y=2.26 //x2=36.01 //y2=0.175
cc_5457 ( N_RN_c_6525_n N_GND_c_14235_n ) capacitor c=0.0213203f //x=42.515 \
 //y=2.315 //x2=39.34 //y2=0.175
cc_5458 ( N_RN_c_6602_n N_GND_c_14291_n ) capacitor c=0.0213456f //x=46.165 \
 //y=2.4 //x2=44.15 //y2=0.175
cc_5459 ( N_RN_c_6688_n N_GND_c_14291_n ) capacitor c=0.00224448f //x=42.67 \
 //y=2.26 //x2=44.15 //y2=0.175
cc_5460 ( N_RN_c_6713_n N_GND_c_14291_n ) capacitor c=0.00262688f //x=43.19 \
 //y=1.44 //x2=44.15 //y2=0.175
cc_5461 ( N_RN_c_6717_n N_GND_c_14291_n ) capacitor c=2.63786e-19 //x=42.67 \
 //y=2.26 //x2=44.15 //y2=0.175
cc_5462 ( N_RN_c_6606_n N_GND_c_14329_n ) capacitor c=0.0213203f //x=59.105 \
 //y=2.385 //x2=48.96 //y2=0.175
cc_5463 ( N_RN_c_6606_n N_GND_c_14376_n ) capacitor c=0.0213203f //x=59.105 \
 //y=2.385 //x2=52.29 //y2=0.175
cc_5464 ( N_RN_c_6606_n N_GND_c_14409_n ) capacitor c=0.0213267f //x=59.105 \
 //y=2.385 //x2=57.1 //y2=0.175
cc_5465 ( N_RN_c_6911_n N_GND_c_14411_n ) capacitor c=0.020546f //x=68.415 \
 //y=2.315 //x2=61.91 //y2=0.175
cc_5466 ( N_RN_c_6809_n N_GND_c_14411_n ) capacitor c=0.00218156f //x=60.43 \
 //y=2.26 //x2=61.91 //y2=0.175
cc_5467 ( N_RN_c_7141_p N_GND_c_14411_n ) capacitor c=0.00262688f //x=60.95 \
 //y=1.44 //x2=61.91 //y2=0.175
cc_5468 ( N_RN_c_6847_n N_GND_c_14411_n ) capacitor c=2.63786e-19 //x=60.43 \
 //y=2.26 //x2=61.91 //y2=0.175
cc_5469 ( N_RN_c_6911_n N_GND_c_14562_n ) capacitor c=0.0205648f //x=68.415 \
 //y=2.315 //x2=65.24 //y2=0.175
cc_5470 ( N_RN_c_7002_n N_GND_c_14459_n ) capacitor c=0.0205148f //x=72.065 \
 //y=2.355 //x2=70.05 //y2=0.175
cc_5471 ( N_RN_c_6928_n N_GND_c_14459_n ) capacitor c=0.00218156f //x=68.57 \
 //y=2.26 //x2=70.05 //y2=0.175
cc_5472 ( N_RN_c_7048_p N_GND_c_14459_n ) capacitor c=0.00262688f //x=69.09 \
 //y=1.44 //x2=70.05 //y2=0.175
cc_5473 ( N_RN_c_6966_n N_GND_c_14459_n ) capacitor c=2.63786e-19 //x=68.57 \
 //y=2.26 //x2=70.05 //y2=0.175
cc_5474 ( N_RN_c_6308_n N_noxref_37_c_15649_n ) capacitor c=0.00442321f \
 //x=16.615 //y=2.315 //x2=10.805 //y2=1.675
cc_5475 ( N_RN_c_6308_n N_noxref_37_c_15650_n ) capacitor c=0.0128916f \
 //x=16.615 //y=2.315 //x2=11.69 //y2=1.76
cc_5476 ( N_RN_c_6308_n N_noxref_37_c_15657_n ) capacitor c=0.00441768f \
 //x=16.615 //y=2.315 //x2=11.775 //y2=1.675
cc_5477 ( N_RN_c_6308_n N_noxref_37_c_15662_n ) capacitor c=9.89029e-19 \
 //x=16.615 //y=2.315 //x2=12.66 //y2=0.71
cc_5478 ( N_RN_c_6308_n N_noxref_37_M6_noxref_s ) capacitor c=0.0010705f \
 //x=16.615 //y=2.315 //x2=10.67 //y2=0.545
cc_5479 ( N_RN_c_6308_n N_noxref_38_c_15716_n ) capacitor c=0.00444844f \
 //x=16.615 //y=2.315 //x2=14.03 //y2=1.685
cc_5480 ( N_RN_c_6308_n N_noxref_38_c_15717_n ) capacitor c=0.013326f \
 //x=16.615 //y=2.315 //x2=14.915 //y2=1.77
cc_5481 ( N_RN_c_6308_n N_noxref_38_c_15730_n ) capacitor c=0.0118733f \
 //x=16.615 //y=2.315 //x2=15.885 //y2=1.77
cc_5482 ( N_RN_c_6308_n N_noxref_38_M8_noxref_s ) capacitor c=0.00828583f \
 //x=16.615 //y=2.315 //x2=13.895 //y2=0.555
cc_5483 ( N_RN_c_6380_n N_noxref_39_c_15774_n ) capacitor c=0.00444844f \
 //x=20.265 //y=2.4 //x2=18.84 //y2=1.685
cc_5484 ( N_RN_c_6380_n N_noxref_39_c_15775_n ) capacitor c=0.0133022f \
 //x=20.265 //y=2.4 //x2=19.725 //y2=1.77
cc_5485 ( N_RN_c_6402_n N_noxref_39_c_15788_n ) capacitor c=0.0167228f \
 //x=20.035 //y=1.09 //x2=20.695 //y2=0.72
cc_5486 ( N_RN_c_6407_n N_noxref_39_c_15788_n ) capacitor c=0.00534519f \
 //x=20.56 //y=1.09 //x2=20.695 //y2=0.72
cc_5487 ( N_RN_c_6372_n N_noxref_39_c_15790_n ) capacitor c=0.00739862f \
 //x=20.47 //y=2.515 //x2=20.695 //y2=1.77
cc_5488 ( N_RN_c_6380_n N_noxref_39_c_15790_n ) capacitor c=0.00737935f \
 //x=20.265 //y=2.4 //x2=20.695 //y2=1.77
cc_5489 ( N_RN_c_6386_n N_noxref_39_c_15790_n ) capacitor c=0.00242815f \
 //x=33.205 //y=2.37 //x2=20.695 //y2=1.77
cc_5490 ( N_RN_c_6392_n N_noxref_39_c_15790_n ) capacitor c=0.0105652f \
 //x=20.47 //y=2.26 //x2=20.695 //y2=1.77
cc_5491 ( N_RN_c_6405_n N_noxref_39_c_15790_n ) capacitor c=0.0155011f \
 //x=20.035 //y=1.4 //x2=20.695 //y2=1.77
cc_5492 ( N_RN_c_6410_n N_noxref_39_c_15790_n ) capacitor c=0.019963f \
 //x=20.56 //y=2.095 //x2=20.695 //y2=1.77
cc_5493 ( N_RN_c_6380_n N_noxref_39_M11_noxref_s ) capacitor c=0.00444844f \
 //x=20.265 //y=2.4 //x2=18.705 //y2=0.555
cc_5494 ( N_RN_c_6386_n N_noxref_39_M11_noxref_s ) capacitor c=0.00383739f \
 //x=33.205 //y=2.37 //x2=18.705 //y2=0.555
cc_5495 ( N_RN_c_6402_n N_noxref_39_M11_noxref_s ) capacitor c=0.00798959f \
 //x=20.035 //y=1.09 //x2=18.705 //y2=0.555
cc_5496 ( N_RN_c_6409_n N_noxref_39_M11_noxref_s ) capacitor c=0.00212176f \
 //x=20.56 //y=1.63 //x2=18.705 //y2=0.555
cc_5497 ( N_RN_c_6410_n N_noxref_39_M11_noxref_s ) capacitor c=0.00298115f \
 //x=20.56 //y=2.095 //x2=18.705 //y2=0.555
cc_5498 ( N_RN_c_6386_n N_noxref_40_c_15832_n ) capacitor c=0.00442321f \
 //x=33.205 //y=2.37 //x2=23.755 //y2=1.675
cc_5499 ( N_RN_c_6386_n N_noxref_40_c_15833_n ) capacitor c=0.012905f \
 //x=33.205 //y=2.37 //x2=24.64 //y2=1.76
cc_5500 ( N_RN_c_6386_n N_noxref_40_c_15840_n ) capacitor c=0.00441768f \
 //x=33.205 //y=2.37 //x2=24.725 //y2=1.675
cc_5501 ( N_RN_c_6386_n N_noxref_40_c_15845_n ) capacitor c=9.4973e-19 \
 //x=33.205 //y=2.37 //x2=25.61 //y2=0.71
cc_5502 ( N_RN_c_6386_n N_noxref_40_M14_noxref_s ) capacitor c=0.0010705f \
 //x=33.205 //y=2.37 //x2=23.62 //y2=0.545
cc_5503 ( N_RN_c_6386_n N_noxref_41_c_15899_n ) capacitor c=0.00444844f \
 //x=33.205 //y=2.37 //x2=26.98 //y2=1.685
cc_5504 ( N_RN_c_6386_n N_noxref_41_c_15900_n ) capacitor c=0.0133165f \
 //x=33.205 //y=2.37 //x2=27.865 //y2=1.77
cc_5505 ( N_RN_c_6386_n N_noxref_41_c_15913_n ) capacitor c=0.0118733f \
 //x=33.205 //y=2.37 //x2=28.835 //y2=1.77
cc_5506 ( N_RN_c_6386_n N_noxref_41_M16_noxref_s ) capacitor c=0.00828583f \
 //x=33.205 //y=2.37 //x2=26.845 //y2=0.555
cc_5507 ( N_RN_c_6386_n N_noxref_42_c_15957_n ) capacitor c=0.00444844f \
 //x=33.205 //y=2.37 //x2=31.79 //y2=1.685
cc_5508 ( N_RN_c_6386_n N_noxref_42_c_15958_n ) capacitor c=0.0132956f \
 //x=33.205 //y=2.37 //x2=32.675 //y2=1.77
cc_5509 ( N_RN_c_6771_n N_noxref_42_c_15971_n ) capacitor c=0.00271892f \
 //x=33.635 //y=2.37 //x2=33.645 //y2=1.77
cc_5510 ( N_RN_c_6386_n N_noxref_42_c_15971_n ) capacitor c=0.00939681f \
 //x=33.205 //y=2.37 //x2=33.645 //y2=1.77
cc_5511 ( N_RN_c_6386_n N_noxref_42_M19_noxref_s ) capacitor c=0.00444844f \
 //x=33.205 //y=2.37 //x2=31.655 //y2=0.555
cc_5512 ( N_RN_c_6523_n N_noxref_42_M19_noxref_s ) capacitor c=0.00399344f \
 //x=34.695 //y=2.4 //x2=31.655 //y2=0.555
cc_5513 ( N_RN_c_6525_n N_noxref_43_c_16017_n ) capacitor c=0.00442321f \
 //x=42.515 //y=2.315 //x2=36.705 //y2=1.675
cc_5514 ( N_RN_c_6525_n N_noxref_43_c_16018_n ) capacitor c=0.0128916f \
 //x=42.515 //y=2.315 //x2=37.59 //y2=1.76
cc_5515 ( N_RN_c_6525_n N_noxref_43_c_16025_n ) capacitor c=0.00441768f \
 //x=42.515 //y=2.315 //x2=37.675 //y2=1.675
cc_5516 ( N_RN_c_6525_n N_noxref_43_c_16030_n ) capacitor c=9.89029e-19 \
 //x=42.515 //y=2.315 //x2=38.56 //y2=0.71
cc_5517 ( N_RN_c_6525_n N_noxref_43_M22_noxref_s ) capacitor c=0.0010705f \
 //x=42.515 //y=2.315 //x2=36.57 //y2=0.545
cc_5518 ( N_RN_c_6525_n N_noxref_44_c_16084_n ) capacitor c=0.00444844f \
 //x=42.515 //y=2.315 //x2=39.93 //y2=1.685
cc_5519 ( N_RN_c_6525_n N_noxref_44_c_16085_n ) capacitor c=0.013326f \
 //x=42.515 //y=2.315 //x2=40.815 //y2=1.77
cc_5520 ( N_RN_c_6525_n N_noxref_44_c_16098_n ) capacitor c=0.0118733f \
 //x=42.515 //y=2.315 //x2=41.785 //y2=1.77
cc_5521 ( N_RN_c_6525_n N_noxref_44_M24_noxref_s ) capacitor c=0.00828583f \
 //x=42.515 //y=2.315 //x2=39.795 //y2=0.555
cc_5522 ( N_RN_c_6602_n N_noxref_45_c_16142_n ) capacitor c=0.00444844f \
 //x=46.165 //y=2.4 //x2=44.74 //y2=1.685
cc_5523 ( N_RN_c_6602_n N_noxref_45_c_16143_n ) capacitor c=0.0133022f \
 //x=46.165 //y=2.4 //x2=45.625 //y2=1.77
cc_5524 ( N_RN_c_6618_n N_noxref_45_c_16156_n ) capacitor c=0.0167228f \
 //x=45.935 //y=1.09 //x2=46.595 //y2=0.72
cc_5525 ( N_RN_c_6623_n N_noxref_45_c_16156_n ) capacitor c=0.00534519f \
 //x=46.46 //y=1.09 //x2=46.595 //y2=0.72
cc_5526 ( N_RN_c_6587_n N_noxref_45_c_16158_n ) capacitor c=0.00739862f \
 //x=46.37 //y=2.515 //x2=46.595 //y2=1.77
cc_5527 ( N_RN_c_6602_n N_noxref_45_c_16158_n ) capacitor c=0.00737935f \
 //x=46.165 //y=2.4 //x2=46.595 //y2=1.77
cc_5528 ( N_RN_c_6606_n N_noxref_45_c_16158_n ) capacitor c=0.00242815f \
 //x=59.105 //y=2.385 //x2=46.595 //y2=1.77
cc_5529 ( N_RN_c_6608_n N_noxref_45_c_16158_n ) capacitor c=0.0105652f \
 //x=46.37 //y=2.26 //x2=46.595 //y2=1.77
cc_5530 ( N_RN_c_6621_n N_noxref_45_c_16158_n ) capacitor c=0.0155011f \
 //x=45.935 //y=1.4 //x2=46.595 //y2=1.77
cc_5531 ( N_RN_c_6626_n N_noxref_45_c_16158_n ) capacitor c=0.019963f \
 //x=46.46 //y=2.095 //x2=46.595 //y2=1.77
cc_5532 ( N_RN_c_6602_n N_noxref_45_M27_noxref_s ) capacitor c=0.00444844f \
 //x=46.165 //y=2.4 //x2=44.605 //y2=0.555
cc_5533 ( N_RN_c_6606_n N_noxref_45_M27_noxref_s ) capacitor c=0.00383739f \
 //x=59.105 //y=2.385 //x2=44.605 //y2=0.555
cc_5534 ( N_RN_c_6618_n N_noxref_45_M27_noxref_s ) capacitor c=0.00798959f \
 //x=45.935 //y=1.09 //x2=44.605 //y2=0.555
cc_5535 ( N_RN_c_6625_n N_noxref_45_M27_noxref_s ) capacitor c=0.00212176f \
 //x=46.46 //y=1.63 //x2=44.605 //y2=0.555
cc_5536 ( N_RN_c_6626_n N_noxref_45_M27_noxref_s ) capacitor c=0.00298115f \
 //x=46.46 //y=2.095 //x2=44.605 //y2=0.555
cc_5537 ( N_RN_c_6606_n N_noxref_46_c_16200_n ) capacitor c=0.00442321f \
 //x=59.105 //y=2.385 //x2=49.655 //y2=1.675
cc_5538 ( N_RN_c_6606_n N_noxref_46_c_16201_n ) capacitor c=0.0128295f \
 //x=59.105 //y=2.385 //x2=50.54 //y2=1.76
cc_5539 ( N_RN_c_6606_n N_noxref_46_c_16208_n ) capacitor c=0.00441768f \
 //x=59.105 //y=2.385 //x2=50.625 //y2=1.675
cc_5540 ( N_RN_c_6606_n N_noxref_46_c_16216_n ) capacitor c=9.4973e-19 \
 //x=59.105 //y=2.385 //x2=51.51 //y2=0.71
cc_5541 ( N_RN_c_6606_n N_noxref_46_M30_noxref_s ) capacitor c=0.0010705f \
 //x=59.105 //y=2.385 //x2=49.52 //y2=0.545
cc_5542 ( N_RN_c_6606_n N_noxref_47_c_16277_n ) capacitor c=0.00444844f \
 //x=59.105 //y=2.385 //x2=52.88 //y2=1.685
cc_5543 ( N_RN_c_6606_n N_noxref_47_c_16278_n ) capacitor c=0.0133165f \
 //x=59.105 //y=2.385 //x2=53.765 //y2=1.77
cc_5544 ( N_RN_c_6606_n N_noxref_47_c_16269_n ) capacitor c=0.0118733f \
 //x=59.105 //y=2.385 //x2=54.735 //y2=1.77
cc_5545 ( N_RN_c_6606_n N_noxref_47_M32_noxref_s ) capacitor c=0.00828583f \
 //x=59.105 //y=2.385 //x2=52.745 //y2=0.555
cc_5546 ( N_RN_c_6606_n N_noxref_48_c_16336_n ) capacitor c=0.00444844f \
 //x=59.105 //y=2.385 //x2=57.69 //y2=1.685
cc_5547 ( N_RN_c_6606_n N_noxref_48_c_16337_n ) capacitor c=0.0132956f \
 //x=59.105 //y=2.385 //x2=58.575 //y2=1.77
cc_5548 ( N_RN_c_6783_n N_noxref_48_c_16327_n ) capacitor c=0.00270563f \
 //x=59.535 //y=2.385 //x2=59.545 //y2=1.77
cc_5549 ( N_RN_c_6606_n N_noxref_48_c_16327_n ) capacitor c=0.00937624f \
 //x=59.105 //y=2.385 //x2=59.545 //y2=1.77
cc_5550 ( N_RN_c_6606_n N_noxref_48_M35_noxref_s ) capacitor c=0.00444844f \
 //x=59.105 //y=2.385 //x2=57.555 //y2=0.555
cc_5551 ( N_RN_c_6791_n N_noxref_48_M35_noxref_s ) capacitor c=0.00398095f \
 //x=60.595 //y=2.4 //x2=57.555 //y2=0.555
cc_5552 ( N_RN_c_6911_n N_noxref_49_c_16385_n ) capacitor c=0.00442321f \
 //x=68.415 //y=2.315 //x2=62.605 //y2=1.675
cc_5553 ( N_RN_c_6911_n N_noxref_49_c_16386_n ) capacitor c=0.0129592f \
 //x=68.415 //y=2.315 //x2=63.49 //y2=1.76
cc_5554 ( N_RN_c_6911_n N_noxref_49_c_16387_n ) capacitor c=0.00441768f \
 //x=68.415 //y=2.315 //x2=63.575 //y2=1.675
cc_5555 ( N_RN_c_6911_n N_noxref_49_c_16388_n ) capacitor c=9.89029e-19 \
 //x=68.415 //y=2.315 //x2=64.46 //y2=0.71
cc_5556 ( N_RN_c_6911_n N_noxref_49_M38_noxref_s ) capacitor c=0.0010705f \
 //x=68.415 //y=2.315 //x2=62.47 //y2=0.545
cc_5557 ( N_RN_c_6911_n N_noxref_50_c_16462_n ) capacitor c=0.00444844f \
 //x=68.415 //y=2.315 //x2=65.83 //y2=1.685
cc_5558 ( N_RN_c_6911_n N_noxref_50_c_16463_n ) capacitor c=0.0133743f \
 //x=68.415 //y=2.315 //x2=66.715 //y2=1.77
cc_5559 ( N_RN_c_6911_n N_noxref_50_c_16454_n ) capacitor c=0.0118733f \
 //x=68.415 //y=2.315 //x2=67.685 //y2=1.77
cc_5560 ( N_RN_c_6911_n N_noxref_50_M40_noxref_s ) capacitor c=0.00828583f \
 //x=68.415 //y=2.315 //x2=65.695 //y2=0.555
cc_5561 ( N_RN_c_7002_n N_noxref_51_c_16510_n ) capacitor c=0.00444844f \
 //x=72.065 //y=2.355 //x2=70.64 //y2=1.685
cc_5562 ( N_RN_c_7002_n N_noxref_51_c_16511_n ) capacitor c=0.0133516f \
 //x=72.065 //y=2.355 //x2=71.525 //y2=1.77
cc_5563 ( N_RN_c_7016_n N_noxref_51_c_16524_n ) capacitor c=0.0167228f \
 //x=71.835 //y=1.09 //x2=72.495 //y2=0.72
cc_5564 ( N_RN_c_7021_n N_noxref_51_c_16524_n ) capacitor c=0.00534519f \
 //x=72.36 //y=1.09 //x2=72.495 //y2=0.72
cc_5565 ( N_RN_c_6985_n N_noxref_51_c_16526_n ) capacitor c=0.00739862f \
 //x=72.27 //y=2.515 //x2=72.495 //y2=1.77
cc_5566 ( N_RN_c_7002_n N_noxref_51_c_16526_n ) capacitor c=0.00737935f \
 //x=72.065 //y=2.355 //x2=72.495 //y2=1.77
cc_5567 ( N_RN_c_7006_n N_noxref_51_c_16526_n ) capacitor c=0.0105652f \
 //x=72.27 //y=2.26 //x2=72.495 //y2=1.77
cc_5568 ( N_RN_c_7019_n N_noxref_51_c_16526_n ) capacitor c=0.0155011f \
 //x=71.835 //y=1.4 //x2=72.495 //y2=1.77
cc_5569 ( N_RN_c_7024_n N_noxref_51_c_16526_n ) capacitor c=0.0202271f \
 //x=72.36 //y=2.095 //x2=72.495 //y2=1.77
cc_5570 ( N_RN_c_7002_n N_noxref_51_M43_noxref_s ) capacitor c=0.00444844f \
 //x=72.065 //y=2.355 //x2=70.505 //y2=0.555
cc_5571 ( N_RN_c_7016_n N_noxref_51_M43_noxref_s ) capacitor c=0.00798959f \
 //x=71.835 //y=1.09 //x2=70.505 //y2=0.555
cc_5572 ( N_RN_c_7023_n N_noxref_51_M43_noxref_s ) capacitor c=0.00212176f \
 //x=72.36 //y=1.63 //x2=70.505 //y2=0.555
cc_5573 ( N_RN_c_7024_n N_noxref_51_M43_noxref_s ) capacitor c=0.00298115f \
 //x=72.36 //y=2.095 //x2=70.505 //y2=0.555
cc_5574 ( N_noxref_14_c_7733_n N_noxref_15_c_8574_n ) capacitor c=0.00357748f \
 //x=53.4 //y=2.375 //x2=51.55 //y2=3.37
cc_5575 ( N_noxref_14_c_7727_n N_noxref_15_c_8574_n ) capacitor c=0.0111384f \
 //x=53.4 //y=4.1 //x2=51.55 //y2=3.37
cc_5576 ( N_noxref_14_c_7727_n N_noxref_15_c_8661_n ) capacitor c=0.00239927f \
 //x=53.4 //y=4.1 //x2=51.55 //y2=3.69
cc_5577 ( N_noxref_14_c_7727_n N_noxref_15_c_8576_n ) capacitor c=0.00763563f \
 //x=53.4 //y=4.1 //x2=51.55 //y2=5.295
cc_5578 ( N_noxref_14_c_7738_n N_noxref_15_c_8576_n ) capacitor c=0.00351049f \
 //x=53.4 //y=4.42 //x2=51.55 //y2=5.295
cc_5579 ( N_noxref_14_c_7728_n N_noxref_15_c_8576_n ) capacitor c=0.00754567f \
 //x=53.4 //y=4.755 //x2=51.55 //y2=5.295
cc_5580 ( N_noxref_14_c_7730_n N_noxref_15_c_8576_n ) capacitor c=0.00222992f \
 //x=53.56 //y=4.26 //x2=51.55 //y2=5.295
cc_5581 ( N_noxref_14_c_7727_n N_noxref_15_c_8698_n ) capacitor c=8.11351e-19 \
 //x=53.4 //y=4.1 //x2=55.62 //y2=3.35
cc_5582 ( N_noxref_14_c_7767_n N_noxref_15_c_8743_n ) capacitor c=0.0032304f \
 //x=55.975 //y=4.25 //x2=55.62 //y2=3.67
cc_5583 ( N_noxref_14_c_7727_n N_noxref_15_c_8744_n ) capacitor c=8.0808e-19 \
 //x=53.4 //y=4.1 //x2=55.62 //y2=4.75
cc_5584 ( N_noxref_14_c_7728_n N_noxref_15_c_8744_n ) capacitor c=2.96131e-19 \
 //x=53.4 //y=4.755 //x2=55.62 //y2=4.75
cc_5585 ( N_noxref_14_c_7767_n N_noxref_15_c_8744_n ) capacitor c=0.024687f \
 //x=55.975 //y=4.25 //x2=55.62 //y2=4.75
cc_5586 ( N_noxref_14_c_7812_n N_noxref_15_c_8705_n ) capacitor c=0.00176143f \
 //x=63.76 //y=4.09 //x2=61.17 //y2=3.35
cc_5587 ( N_noxref_14_c_7812_n N_noxref_15_c_8708_n ) capacitor c=3.24787e-19 \
 //x=63.76 //y=4.09 //x2=61.17 //y2=5.25
cc_5588 ( N_noxref_14_c_7749_n N_noxref_15_c_8708_n ) capacitor c=7.59756e-19 \
 //x=63.76 //y=4.735 //x2=61.17 //y2=5.25
cc_5589 ( N_noxref_14_c_7732_n N_noxref_15_c_8708_n ) capacitor c=0.0232184f \
 //x=63.925 //y=4.25 //x2=61.17 //y2=5.25
cc_5590 ( N_noxref_14_c_7812_n N_noxref_15_c_8995_n ) capacitor c=0.0384732f \
 //x=63.76 //y=4.09 //x2=63.02 //y2=3.35
cc_5591 ( N_noxref_14_c_7968_p N_noxref_15_c_8995_n ) capacitor c=3.30333e-19 \
 //x=63.76 //y=2.26 //x2=63.02 //y2=3.35
cc_5592 ( N_noxref_14_c_7812_n N_noxref_15_c_8860_n ) capacitor c=0.0146245f \
 //x=63.76 //y=4.09 //x2=63.02 //y2=3.67
cc_5593 ( N_noxref_14_c_7747_n N_noxref_15_c_8750_n ) capacitor c=0.00424065f \
 //x=63.76 //y=4.41 //x2=63.905 //y2=5.38
cc_5594 ( N_noxref_14_c_7749_n N_noxref_15_c_8750_n ) capacitor c=0.0215376f \
 //x=63.76 //y=4.735 //x2=63.905 //y2=5.38
cc_5595 ( N_noxref_14_c_7972_p N_noxref_15_c_8750_n ) capacitor c=0.00469257f \
 //x=63.79 //y=4.88 //x2=63.905 //y2=5.38
cc_5596 ( N_noxref_14_M132_noxref_g N_noxref_15_c_8750_n ) capacitor \
 c=0.00842859f //x=63.8 //y=6.2 //x2=63.905 //y2=5.38
cc_5597 ( N_noxref_14_c_7811_n N_noxref_15_c_8750_n ) capacitor c=8.42507e-19 \
 //x=63.79 //y=4.88 //x2=63.905 //y2=5.38
cc_5598 ( N_noxref_14_c_7975_p N_noxref_15_c_9090_n ) capacitor c=0.00119302f \
 //x=63.795 //y=1.43 //x2=64.06 //y2=1.75
cc_5599 ( N_noxref_14_c_7976_p N_noxref_15_c_9090_n ) capacitor c=0.00439215f \
 //x=63.795 //y=1.74 //x2=64.06 //y2=1.75
cc_5600 ( N_noxref_14_c_7977_p N_noxref_15_c_9090_n ) capacitor c=0.00929773f \
 //x=64.17 //y=1.585 //x2=64.06 //y2=1.75
cc_5601 ( N_noxref_14_c_7978_p N_noxref_15_c_9090_n ) capacitor c=0.00341295f \
 //x=64.325 //y=1.43 //x2=64.06 //y2=1.75
cc_5602 ( N_noxref_14_c_7979_p N_noxref_15_c_9090_n ) capacitor c=0.00341688f \
 //x=63.76 //y=2.095 //x2=64.06 //y2=1.75
cc_5603 ( N_noxref_14_M133_noxref_g N_noxref_15_c_9095_n ) capacitor \
 c=0.0106088f //x=64.24 //y=6.2 //x2=64.415 //y2=5.38
cc_5604 ( N_noxref_14_c_7888_n N_noxref_15_c_9096_n ) capacitor c=8.29536e-19 \
 //x=68.825 //y=1.76 //x2=64.415 //y2=1.835
cc_5605 ( N_noxref_14_c_7977_p N_noxref_15_c_9096_n ) capacitor c=0.00194324f \
 //x=64.17 //y=1.585 //x2=64.415 //y2=1.835
cc_5606 ( N_noxref_14_c_7978_p N_noxref_15_c_9096_n ) capacitor c=0.00323005f \
 //x=64.325 //y=1.43 //x2=64.415 //y2=1.835
cc_5607 ( N_noxref_14_c_7812_n N_noxref_15_c_8751_n ) capacitor c=0.0388742f \
 //x=63.76 //y=4.09 //x2=64.5 //y2=3.355
cc_5608 ( N_noxref_14_c_7895_n N_noxref_15_c_8751_n ) capacitor c=8.29536e-19 \
 //x=68.91 //y=1.845 //x2=64.5 //y2=3.355
cc_5609 ( N_noxref_14_c_7917_n N_noxref_15_c_8751_n ) capacitor c=0.0138368f \
 //x=63.76 //y=2.26 //x2=64.5 //y2=3.355
cc_5610 ( N_noxref_14_c_7968_p N_noxref_15_c_8751_n ) capacitor c=9.26054e-19 \
 //x=63.76 //y=2.26 //x2=64.5 //y2=3.355
cc_5611 ( N_noxref_14_c_7944_n N_noxref_15_c_8751_n ) capacitor c=0.00268898f \
 //x=63.76 //y=2.26 //x2=64.5 //y2=3.355
cc_5612 ( N_noxref_14_c_7979_p N_noxref_15_c_8751_n ) capacitor c=0.00309058f \
 //x=63.76 //y=2.095 //x2=64.5 //y2=3.355
cc_5613 ( N_noxref_14_c_7812_n N_noxref_15_c_8862_n ) capacitor c=0.0146245f \
 //x=63.76 //y=4.09 //x2=64.5 //y2=3.675
cc_5614 ( N_noxref_14_c_7812_n N_noxref_15_c_8752_n ) capacitor c=0.0164753f \
 //x=63.76 //y=4.09 //x2=64.5 //y2=5.295
cc_5615 ( N_noxref_14_c_7747_n N_noxref_15_c_8752_n ) capacitor c=0.0147977f \
 //x=63.76 //y=4.41 //x2=64.5 //y2=5.295
cc_5616 ( N_noxref_14_c_7749_n N_noxref_15_c_8752_n ) capacitor c=0.0284267f \
 //x=63.76 //y=4.735 //x2=64.5 //y2=5.295
cc_5617 ( N_noxref_14_c_7994_p N_noxref_15_c_8752_n ) capacitor c=6.15063e-19 \
 //x=63.76 //y=4.25 //x2=64.5 //y2=5.295
cc_5618 ( N_noxref_14_c_7760_n N_noxref_15_c_8752_n ) capacitor c=0.00261914f \
 //x=66.772 //y=5.335 //x2=64.5 //y2=5.295
cc_5619 ( N_noxref_14_c_7773_n N_noxref_15_c_8752_n ) capacitor c=0.022727f \
 //x=69.155 //y=4.25 //x2=64.5 //y2=5.295
cc_5620 ( N_noxref_14_c_7732_n N_noxref_15_c_8752_n ) capacitor c=0.00328982f \
 //x=63.925 //y=4.25 //x2=64.5 //y2=5.295
cc_5621 ( N_noxref_14_c_7972_p N_noxref_15_c_8752_n ) capacitor c=7.76118e-19 \
 //x=63.79 //y=4.88 //x2=64.5 //y2=5.295
cc_5622 ( N_noxref_14_c_7999_p N_noxref_15_c_8752_n ) capacitor c=0.00845606f \
 //x=64.165 //y=4.97 //x2=64.5 //y2=5.295
cc_5623 ( N_noxref_14_c_7811_n N_noxref_15_c_8752_n ) capacitor c=0.00142201f \
 //x=63.79 //y=4.88 //x2=64.5 //y2=5.295
cc_5624 ( N_noxref_14_c_7812_n N_noxref_15_c_8757_n ) capacitor c=0.00176427f \
 //x=63.76 //y=4.09 //x2=66.35 //y2=3.355
cc_5625 ( N_noxref_14_c_7812_n N_noxref_15_c_8760_n ) capacitor c=3.22894e-19 \
 //x=63.76 //y=4.09 //x2=66.35 //y2=4.755
cc_5626 ( N_noxref_14_c_7749_n N_noxref_15_c_8760_n ) capacitor c=4.6204e-19 \
 //x=63.76 //y=4.735 //x2=66.35 //y2=4.755
cc_5627 ( N_noxref_14_c_7773_n N_noxref_15_c_8760_n ) capacitor c=0.0246035f \
 //x=69.155 //y=4.25 //x2=66.35 //y2=4.755
cc_5628 ( N_noxref_14_c_8005_p N_noxref_15_c_9120_n ) capacitor c=0.00209632f \
 //x=76.71 //y=4.095 //x2=78.93 //y2=3.35
cc_5629 ( N_noxref_14_c_8005_p N_noxref_15_c_9121_n ) capacitor c=6.93043e-19 \
 //x=76.71 //y=4.095 //x2=78.93 //y2=4.46
cc_5630 ( N_noxref_14_c_7812_n N_noxref_15_c_9122_n ) capacitor c=5.52402e-19 \
 //x=63.76 //y=4.09 //x2=63.02 //y2=3.51
cc_5631 ( N_noxref_14_c_7917_n N_noxref_15_c_9010_n ) capacitor c=0.0179797f \
 //x=63.76 //y=2.26 //x2=63.02 //y2=2.26
cc_5632 ( N_noxref_14_c_7968_p N_noxref_15_c_9010_n ) capacitor c=5.24723e-19 \
 //x=63.76 //y=2.26 //x2=63.02 //y2=2.26
cc_5633 ( N_noxref_14_c_7944_n N_noxref_15_c_9010_n ) capacitor c=0.00161167f \
 //x=63.76 //y=2.26 //x2=63.02 //y2=2.26
cc_5634 ( N_noxref_14_c_7749_n N_noxref_15_c_8770_n ) capacitor c=0.0172939f \
 //x=63.76 //y=4.735 //x2=63.02 //y2=4.88
cc_5635 ( N_noxref_14_c_7972_p N_noxref_15_c_8770_n ) capacitor c=4.80626e-19 \
 //x=63.79 //y=4.88 //x2=63.02 //y2=4.88
cc_5636 ( N_noxref_14_c_7811_n N_noxref_15_c_8770_n ) capacitor c=0.00158715f \
 //x=63.79 //y=4.88 //x2=63.02 //y2=4.88
cc_5637 ( N_noxref_14_c_7812_n N_noxref_15_c_8771_n ) capacitor c=0.0167029f \
 //x=63.76 //y=4.09 //x2=63.022 //y2=4.74
cc_5638 ( N_noxref_14_c_7747_n N_noxref_15_c_8771_n ) capacitor c=0.0172847f \
 //x=63.76 //y=4.41 //x2=63.022 //y2=4.74
cc_5639 ( N_noxref_14_c_7749_n N_noxref_15_c_8771_n ) capacitor c=0.0117609f \
 //x=63.76 //y=4.735 //x2=63.022 //y2=4.74
cc_5640 ( N_noxref_14_c_7994_p N_noxref_15_c_8771_n ) capacitor c=6.16997e-19 \
 //x=63.76 //y=4.25 //x2=63.022 //y2=4.74
cc_5641 ( N_noxref_14_c_7732_n N_noxref_15_c_8771_n ) capacitor c=0.0253737f \
 //x=63.925 //y=4.25 //x2=63.022 //y2=4.74
cc_5642 ( N_noxref_14_c_7760_n N_noxref_15_c_8773_n ) capacitor c=5.0812e-19 \
 //x=66.772 //y=5.335 //x2=64.02 //y2=5.38
cc_5643 ( N_noxref_14_M132_noxref_g N_noxref_15_c_8773_n ) capacitor \
 c=0.00192712f //x=63.8 //y=6.2 //x2=64.02 //y2=5.38
cc_5644 ( N_noxref_14_M133_noxref_g N_noxref_15_c_8773_n ) capacitor \
 c=0.00312463f //x=64.24 //y=6.2 //x2=64.02 //y2=5.38
cc_5645 ( N_noxref_14_c_7999_p N_noxref_15_c_8773_n ) capacitor c=0.0020909f \
 //x=64.165 //y=4.97 //x2=64.02 //y2=5.38
cc_5646 ( N_noxref_14_c_8023_p N_noxref_15_c_9012_n ) capacitor c=0.00120406f \
 //x=63.795 //y=1.085 //x2=64.06 //y2=1.18
cc_5647 ( N_noxref_14_c_7975_p N_noxref_15_c_9012_n ) capacitor c=0.00218772f \
 //x=63.795 //y=1.43 //x2=64.06 //y2=1.18
cc_5648 ( N_noxref_14_c_8025_p N_noxref_15_c_9012_n ) capacitor c=5.50523e-19 \
 //x=64.17 //y=0.93 //x2=64.06 //y2=1.18
cc_5649 ( N_noxref_14_c_7977_p N_noxref_15_c_9012_n ) capacitor c=5.67071e-19 \
 //x=64.17 //y=1.585 //x2=64.06 //y2=1.18
cc_5650 ( N_noxref_14_c_8027_p N_noxref_15_c_9012_n ) capacitor c=0.00108157f \
 //x=64.325 //y=1.085 //x2=64.06 //y2=1.18
cc_5651 ( N_noxref_14_c_7978_p N_noxref_15_c_9012_n ) capacitor c=0.00312028f \
 //x=64.325 //y=1.43 //x2=64.06 //y2=1.18
cc_5652 ( N_noxref_14_c_7812_n N_noxref_15_c_9144_n ) capacitor c=5.57251e-19 \
 //x=63.76 //y=4.09 //x2=64.5 //y2=3.51
cc_5653 ( N_noxref_14_c_7727_n N_noxref_15_c_8718_n ) capacitor c=0.0269393f \
 //x=53.4 //y=4.1 //x2=55.46 //y2=3.51
cc_5654 ( N_noxref_14_c_7738_n N_noxref_15_c_8718_n ) capacitor c=0.00443629f \
 //x=53.4 //y=4.42 //x2=55.46 //y2=3.51
cc_5655 ( N_noxref_14_c_7767_n N_noxref_15_c_8718_n ) capacitor c=0.0800212f \
 //x=55.975 //y=4.25 //x2=55.46 //y2=3.51
cc_5656 ( N_noxref_14_c_7730_n N_noxref_15_c_8718_n ) capacitor c=0.0153085f \
 //x=53.56 //y=4.26 //x2=55.46 //y2=3.51
cc_5657 ( N_noxref_14_c_7727_n N_noxref_15_c_8599_n ) capacitor c=0.00160717f \
 //x=53.4 //y=4.1 //x2=51.71 //y2=3.51
cc_5658 ( N_noxref_14_c_7771_n N_noxref_15_c_8720_n ) capacitor c=0.00863702f \
 //x=56.615 //y=4.27 //x2=56.58 //y2=3.5
cc_5659 ( N_noxref_14_c_7767_n N_noxref_15_c_8721_n ) capacitor c=0.0313252f \
 //x=55.975 //y=4.25 //x2=56.15 //y2=3.5
cc_5660 ( N_noxref_14_c_7772_n N_noxref_15_c_8722_n ) capacitor c=0.00556214f \
 //x=57.83 //y=4.25 //x2=57.83 //y2=3.51
cc_5661 ( N_noxref_14_c_7840_n N_noxref_15_c_8886_n ) capacitor c=0.00123933f \
 //x=58.43 //y=4.265 //x2=58.43 //y2=3.495
cc_5662 ( N_noxref_14_c_7732_n N_noxref_15_c_8889_n ) capacitor c=0.0104445f \
 //x=63.925 //y=4.25 //x2=62.86 //y2=3.51
cc_5663 ( N_noxref_14_c_7732_n N_noxref_15_c_8723_n ) capacitor c=0.0225651f \
 //x=63.925 //y=4.25 //x2=61.335 //y2=3.51
cc_5664 ( N_noxref_14_c_7812_n N_noxref_15_c_8893_n ) capacitor c=0.00177541f \
 //x=63.76 //y=4.09 //x2=63.18 //y2=3.51
cc_5665 ( N_noxref_14_c_7773_n N_noxref_15_c_8894_n ) capacitor c=0.0103367f \
 //x=69.155 //y=4.25 //x2=66.195 //y2=3.51
cc_5666 ( N_noxref_14_c_7854_n N_noxref_15_c_8896_n ) capacitor c=0.00442841f \
 //x=71.365 //y=4.265 //x2=71.365 //y2=3.495
cc_5667 ( N_noxref_14_c_7859_n N_noxref_15_c_8896_n ) capacitor c=0.0752957f \
 //x=74.28 //y=4.25 //x2=71.365 //y2=3.495
cc_5668 ( N_noxref_14_c_7757_n N_noxref_15_c_8785_n ) capacitor c=0.023431f \
 //x=69.31 //y=4.095 //x2=70.935 //y2=3.495
cc_5669 ( N_noxref_14_c_7773_n N_noxref_15_c_8785_n ) capacitor c=0.0218257f \
 //x=69.155 //y=4.25 //x2=70.935 //y2=3.495
cc_5670 ( N_noxref_14_c_7856_n N_noxref_15_c_8785_n ) capacitor c=0.0138349f \
 //x=71.02 //y=4.265 //x2=70.935 //y2=3.495
cc_5671 ( N_noxref_14_c_7859_n N_noxref_15_c_9023_n ) capacitor c=0.0088374f \
 //x=74.28 //y=4.25 //x2=72.995 //y2=3.51
cc_5672 ( N_noxref_14_c_7915_n N_noxref_15_c_9164_n ) capacitor c=0.0243318f \
 //x=74.12 //y=4.13 //x2=73.595 //y2=3.48
cc_5673 ( N_noxref_14_c_8050_p N_noxref_15_c_9164_n ) capacitor c=0.023348f \
 //x=75.97 //y=4.125 //x2=73.595 //y2=3.48
cc_5674 ( N_noxref_14_c_8005_p N_noxref_15_c_9164_n ) capacitor c=0.0205391f \
 //x=76.71 //y=4.095 //x2=73.595 //y2=3.48
cc_5675 ( N_noxref_14_c_7859_n N_noxref_15_c_9164_n ) capacitor c=0.00291618f \
 //x=74.28 //y=4.25 //x2=73.595 //y2=3.48
cc_5676 ( N_noxref_14_c_8053_p N_noxref_15_c_9164_n ) capacitor c=0.0103904f \
 //x=75.8 //y=4.285 //x2=73.595 //y2=3.48
cc_5677 ( N_noxref_14_c_8054_p N_noxref_15_c_9164_n ) capacitor c=0.00385367f \
 //x=76.54 //y=4.255 //x2=73.595 //y2=3.48
cc_5678 ( N_noxref_14_c_7812_n N_noxref_15_c_8905_n ) capacitor c=0.0196591f \
 //x=63.76 //y=4.09 //x2=64.34 //y2=3.515
cc_5679 ( N_noxref_14_c_7773_n N_noxref_15_c_8905_n ) capacitor c=0.00417956f \
 //x=69.155 //y=4.25 //x2=64.34 //y2=3.515
cc_5680 ( N_noxref_14_c_7732_n N_noxref_15_c_8905_n ) capacitor c=0.00382789f \
 //x=63.925 //y=4.25 //x2=64.34 //y2=3.515
cc_5681 ( N_noxref_14_c_7812_n N_noxref_15_c_8907_n ) capacitor c=0.00177541f \
 //x=63.76 //y=4.09 //x2=64.66 //y2=3.515
cc_5682 ( N_noxref_14_c_7812_n N_noxref_15_c_9040_n ) capacitor c=3.30333e-19 \
 //x=63.76 //y=4.09 //x2=63.02 //y2=2.26
cc_5683 ( N_noxref_14_c_7917_n N_noxref_15_c_9040_n ) capacitor c=5.16867e-19 \
 //x=63.76 //y=2.26 //x2=63.02 //y2=2.26
cc_5684 ( N_noxref_14_c_7968_p N_noxref_15_c_9040_n ) capacitor c=0.00525888f \
 //x=63.76 //y=2.26 //x2=63.02 //y2=2.26
cc_5685 ( N_noxref_14_c_7944_n N_noxref_15_c_9040_n ) capacitor c=0.0018937f \
 //x=63.76 //y=2.26 //x2=63.02 //y2=2.26
cc_5686 ( N_noxref_14_c_7749_n N_noxref_15_c_9178_n ) capacitor c=7.51041e-19 \
 //x=63.76 //y=4.735 //x2=63.02 //y2=4.88
cc_5687 ( N_noxref_14_c_7972_p N_noxref_15_c_9178_n ) capacitor c=0.00397338f \
 //x=63.79 //y=4.88 //x2=63.02 //y2=4.88
cc_5688 ( N_noxref_14_c_7811_n N_noxref_15_c_9178_n ) capacitor c=0.00237977f \
 //x=63.79 //y=4.88 //x2=63.02 //y2=4.88
cc_5689 ( N_noxref_14_M132_noxref_g N_noxref_15_c_9181_n ) capacitor \
 c=0.0178987f //x=63.8 //y=6.2 //x2=64.02 //y2=5.56
cc_5690 ( N_noxref_14_M133_noxref_g N_noxref_15_c_9181_n ) capacitor \
 c=0.0178506f //x=64.24 //y=6.2 //x2=64.02 //y2=5.56
cc_5691 ( N_noxref_14_c_7999_p N_noxref_15_c_9181_n ) capacitor c=0.00291714f \
 //x=64.165 //y=4.97 //x2=64.02 //y2=5.56
cc_5692 ( N_noxref_14_M132_noxref_g N_noxref_15_M130_noxref_g ) capacitor \
 c=0.0104892f //x=63.8 //y=6.2 //x2=62.92 //y2=6.2
cc_5693 ( N_noxref_14_M132_noxref_g N_noxref_15_M131_noxref_g ) capacitor \
 c=0.107636f //x=63.8 //y=6.2 //x2=63.36 //y2=6.2
cc_5694 ( N_noxref_14_M133_noxref_g N_noxref_15_M131_noxref_g ) capacitor \
 c=0.0100341f //x=64.24 //y=6.2 //x2=63.36 //y2=6.2
cc_5695 ( N_noxref_14_c_7760_n N_noxref_15_M134_noxref_g ) capacitor \
 c=0.00461408f //x=66.772 //y=5.335 //x2=66.55 //y2=6.2
cc_5696 ( N_noxref_14_c_8073_p N_noxref_15_M134_noxref_g ) capacitor \
 c=0.0162284f //x=66.77 //y=5.56 //x2=66.55 //y2=6.2
cc_5697 ( N_noxref_14_c_7751_n N_noxref_15_M135_noxref_g ) capacitor \
 c=0.00893512f //x=67.53 //y=5.335 //x2=66.99 //y2=6.2
cc_5698 ( N_noxref_14_c_7760_n N_noxref_15_M135_noxref_g ) capacitor \
 c=0.00229208f //x=66.772 //y=5.335 //x2=66.99 //y2=6.2
cc_5699 ( N_noxref_14_c_8073_p N_noxref_15_M135_noxref_g ) capacitor \
 c=0.0179041f //x=66.77 //y=5.56 //x2=66.99 //y2=6.2
cc_5700 ( N_noxref_14_c_8023_p N_noxref_15_c_9192_n ) capacitor c=4.86545e-19 \
 //x=63.795 //y=1.085 //x2=62.825 //y2=1.045
cc_5701 ( N_noxref_14_c_8023_p N_noxref_15_c_9193_n ) capacitor c=0.00152405f \
 //x=63.795 //y=1.085 //x2=62.825 //y2=1.39
cc_5702 ( N_noxref_14_c_7975_p N_noxref_15_c_9194_n ) capacitor c=0.00109982f \
 //x=63.795 //y=1.43 //x2=62.825 //y2=1.7
cc_5703 ( N_noxref_14_c_7976_p N_noxref_15_c_9194_n ) capacitor c=9.58243e-19 \
 //x=63.795 //y=1.74 //x2=62.825 //y2=1.7
cc_5704 ( N_noxref_14_c_7917_n N_noxref_15_c_9048_n ) capacitor c=0.00161745f \
 //x=63.76 //y=2.26 //x2=62.825 //y2=2.095
cc_5705 ( N_noxref_14_c_7968_p N_noxref_15_c_9048_n ) capacitor c=0.00190888f \
 //x=63.76 //y=2.26 //x2=62.825 //y2=2.095
cc_5706 ( N_noxref_14_c_7976_p N_noxref_15_c_9048_n ) capacitor c=0.00662747f \
 //x=63.795 //y=1.74 //x2=62.825 //y2=2.095
cc_5707 ( N_noxref_14_c_7944_n N_noxref_15_c_9048_n ) capacitor c=0.0181449f \
 //x=63.76 //y=2.26 //x2=62.825 //y2=2.095
cc_5708 ( N_noxref_14_c_8023_p N_noxref_15_c_9200_n ) capacitor c=0.0151475f \
 //x=63.795 //y=1.085 //x2=63.355 //y2=1.045
cc_5709 ( N_noxref_14_c_8027_p N_noxref_15_c_9200_n ) capacitor c=0.00127211f \
 //x=64.325 //y=1.085 //x2=63.355 //y2=1.045
cc_5710 ( N_noxref_14_c_7975_p N_noxref_15_c_9202_n ) capacitor c=0.0111064f \
 //x=63.795 //y=1.43 //x2=63.355 //y2=1.39
cc_5711 ( N_noxref_14_c_7976_p N_noxref_15_c_9202_n ) capacitor c=0.00862358f \
 //x=63.795 //y=1.74 //x2=63.355 //y2=1.39
cc_5712 ( N_noxref_14_c_7978_p N_noxref_15_c_9202_n ) capacitor c=0.00204774f \
 //x=64.325 //y=1.43 //x2=63.355 //y2=1.39
cc_5713 ( N_noxref_14_c_7760_n N_noxref_15_c_8820_n ) capacitor c=0.00171885f \
 //x=66.772 //y=5.335 //x2=66.915 //y2=4.97
cc_5714 ( N_noxref_14_c_8073_p N_noxref_15_c_8820_n ) capacitor c=0.00291477f \
 //x=66.77 //y=5.56 //x2=66.915 //y2=4.97
cc_5715 ( N_noxref_14_c_7749_n N_noxref_15_c_9207_n ) capacitor c=0.00200732f \
 //x=63.76 //y=4.735 //x2=63.02 //y2=4.88
cc_5716 ( N_noxref_14_c_7972_p N_noxref_15_c_9207_n ) capacitor c=0.00283894f \
 //x=63.79 //y=4.88 //x2=63.02 //y2=4.88
cc_5717 ( N_noxref_14_c_7811_n N_noxref_15_c_9207_n ) capacitor c=0.0297875f \
 //x=63.79 //y=4.88 //x2=63.02 //y2=4.88
cc_5718 ( N_noxref_14_c_8023_p N_noxref_15_M39_noxref_d ) capacitor \
 c=0.00137165f //x=63.795 //y=1.085 //x2=63.87 //y2=1.085
cc_5719 ( N_noxref_14_c_7975_p N_noxref_15_M39_noxref_d ) capacitor \
 c=0.00237422f //x=63.795 //y=1.43 //x2=63.87 //y2=1.085
cc_5720 ( N_noxref_14_c_8025_p N_noxref_15_M39_noxref_d ) capacitor \
 c=0.0020782f //x=64.17 //y=0.93 //x2=63.87 //y2=1.085
cc_5721 ( N_noxref_14_c_7977_p N_noxref_15_M39_noxref_d ) capacitor \
 c=0.00356097f //x=64.17 //y=1.585 //x2=63.87 //y2=1.085
cc_5722 ( N_noxref_14_c_8027_p N_noxref_15_M39_noxref_d ) capacitor \
 c=8.50095e-19 //x=64.325 //y=1.085 //x2=63.87 //y2=1.085
cc_5723 ( N_noxref_14_c_7978_p N_noxref_15_M39_noxref_d ) capacitor \
 c=0.00237422f //x=64.325 //y=1.43 //x2=63.87 //y2=1.085
cc_5724 ( N_noxref_14_c_7727_n N_noxref_16_c_10055_n ) capacitor c=0.0247389f \
 //x=53.4 //y=4.1 //x2=55.235 //y2=3.14
cc_5725 ( N_noxref_14_c_7767_n N_noxref_16_c_10055_n ) capacitor c=0.0144922f \
 //x=55.975 //y=4.25 //x2=55.235 //y2=3.14
cc_5726 ( N_noxref_14_c_7767_n N_noxref_16_c_10102_n ) capacitor c=0.00221297f \
 //x=55.975 //y=4.25 //x2=55.835 //y2=3.125
cc_5727 ( N_noxref_14_c_7812_n N_noxref_16_c_10142_n ) capacitor c=3.75057e-19 \
 //x=63.76 //y=4.09 //x2=63.235 //y2=3.125
cc_5728 ( N_noxref_14_c_7812_n N_noxref_16_c_10143_n ) capacitor c=0.0231091f \
 //x=63.76 //y=4.09 //x2=64.115 //y2=3.14
cc_5729 ( N_noxref_14_c_7757_n N_noxref_16_c_10132_n ) capacitor c=0.0259642f \
 //x=69.31 //y=4.095 //x2=78.535 //y2=3.14
cc_5730 ( N_noxref_14_c_8107_p N_noxref_16_c_10132_n ) capacitor c=4.15306e-19 \
 //x=73.635 //y=1.305 //x2=78.535 //y2=3.14
cc_5731 ( N_noxref_14_c_8108_p N_noxref_16_c_10132_n ) capacitor c=0.0109123f \
 //x=73.72 //y=1.845 //x2=78.535 //y2=3.14
cc_5732 ( N_noxref_14_c_7915_n N_noxref_16_c_10132_n ) capacitor c=0.0289741f \
 //x=74.12 //y=4.13 //x2=78.535 //y2=3.14
cc_5733 ( N_noxref_14_c_8050_p N_noxref_16_c_10132_n ) capacitor c=0.0277388f \
 //x=75.97 //y=4.125 //x2=78.535 //y2=3.14
cc_5734 ( N_noxref_14_c_8005_p N_noxref_16_c_10132_n ) capacitor c=0.0250119f \
 //x=76.71 //y=4.095 //x2=78.535 //y2=3.14
cc_5735 ( N_noxref_14_c_8112_p N_noxref_16_c_10132_n ) capacitor c=0.00297665f \
 //x=75.97 //y=2.26 //x2=78.535 //y2=3.14
cc_5736 ( N_noxref_14_c_8113_p N_noxref_16_c_10132_n ) capacitor c=0.00275744f \
 //x=76.71 //y=2.26 //x2=78.535 //y2=3.14
cc_5737 ( N_noxref_14_c_7854_n N_noxref_16_c_10132_n ) capacitor c=7.08497e-19 \
 //x=71.365 //y=4.265 //x2=78.535 //y2=3.14
cc_5738 ( N_noxref_14_c_7859_n N_noxref_16_c_10132_n ) capacitor c=0.0117902f \
 //x=74.28 //y=4.25 //x2=78.535 //y2=3.14
cc_5739 ( N_noxref_14_c_7915_n N_noxref_17_c_10673_n ) capacitor c=0.0153006f \
 //x=74.12 //y=4.13 //x2=73.38 //y2=2.375
cc_5740 ( N_noxref_14_c_7915_n N_noxref_17_c_10669_n ) capacitor c=0.0551584f \
 //x=74.12 //y=4.13 //x2=73.38 //y2=3.705
cc_5741 ( N_noxref_14_c_8050_p N_noxref_17_c_10669_n ) capacitor c=0.00218556f \
 //x=75.97 //y=4.125 //x2=73.38 //y2=3.705
cc_5742 ( N_noxref_14_c_7914_n N_noxref_17_c_10680_n ) capacitor c=8.57871e-19 \
 //x=73.225 //y=5.335 //x2=73.38 //y2=4.025
cc_5743 ( N_noxref_14_c_8120_p N_noxref_17_c_10680_n ) capacitor c=0.00136123f \
 //x=74.035 //y=5.335 //x2=73.38 //y2=4.025
cc_5744 ( N_noxref_14_c_8107_p N_noxref_17_c_10680_n ) capacitor c=2.05468e-19 \
 //x=73.635 //y=1.305 //x2=73.38 //y2=4.025
cc_5745 ( N_noxref_14_c_8108_p N_noxref_17_c_10680_n ) capacitor c=8.68534e-19 \
 //x=73.72 //y=1.845 //x2=73.38 //y2=4.025
cc_5746 ( N_noxref_14_c_7915_n N_noxref_17_c_10680_n ) capacitor c=0.01761f \
 //x=74.12 //y=4.13 //x2=73.38 //y2=4.025
cc_5747 ( N_noxref_14_c_7859_n N_noxref_17_c_10680_n ) capacitor c=0.00530315f \
 //x=74.28 //y=4.25 //x2=73.38 //y2=4.025
cc_5748 ( N_noxref_14_c_8120_p N_noxref_17_c_10670_n ) capacitor c=0.0023499f \
 //x=74.035 //y=5.335 //x2=73.38 //y2=4.75
cc_5749 ( N_noxref_14_c_7915_n N_noxref_17_c_10670_n ) capacitor c=0.00436629f \
 //x=74.12 //y=4.13 //x2=73.38 //y2=4.75
cc_5750 ( N_noxref_14_c_8127_p N_noxref_17_c_10670_n ) capacitor c=0.0149119f \
 //x=74.12 //y=4.45 //x2=73.38 //y2=4.75
cc_5751 ( N_noxref_14_c_7916_n N_noxref_17_c_10670_n ) capacitor c=0.028407f \
 //x=74.12 //y=5.25 //x2=73.38 //y2=4.75
cc_5752 ( N_noxref_14_c_8129_p N_noxref_17_c_10670_n ) capacitor c=0.0224759f \
 //x=73.34 //y=5.335 //x2=73.38 //y2=4.75
cc_5753 ( N_noxref_14_c_8130_p N_noxref_17_c_10670_n ) capacitor c=0.00115652f \
 //x=74.12 //y=4.25 //x2=73.38 //y2=4.75
cc_5754 ( N_noxref_14_c_8131_p N_noxref_17_c_10670_n ) capacitor c=9.3515e-19 \
 //x=75.972 //y=4.74 //x2=73.38 //y2=4.75
cc_5755 ( N_noxref_14_c_7859_n N_noxref_17_c_10670_n ) capacitor c=0.0304026f \
 //x=74.28 //y=4.25 //x2=73.38 //y2=4.75
cc_5756 ( N_noxref_14_c_8133_p N_noxref_17_c_10670_n ) capacitor c=0.00217653f \
 //x=73.34 //y=5.56 //x2=73.38 //y2=4.75
cc_5757 ( N_noxref_14_c_8134_p N_noxref_17_c_10726_n ) capacitor c=0.00404759f \
 //x=76.71 //y=4.415 //x2=76.855 //y2=5.38
cc_5758 ( N_noxref_14_c_8135_p N_noxref_17_c_10726_n ) capacitor c=0.0222472f \
 //x=76.71 //y=4.735 //x2=76.855 //y2=5.38
cc_5759 ( N_noxref_14_c_8136_p N_noxref_17_c_10726_n ) capacitor c=0.0013598f \
 //x=76.7 //y=4.255 //x2=76.855 //y2=5.38
cc_5760 ( N_noxref_14_c_8054_p N_noxref_17_c_10726_n ) capacitor c=0.00141892f \
 //x=76.54 //y=4.255 //x2=76.855 //y2=5.38
cc_5761 ( N_noxref_14_c_8138_p N_noxref_17_c_10726_n ) capacitor c=0.00469257f \
 //x=76.74 //y=4.88 //x2=76.855 //y2=5.38
cc_5762 ( N_noxref_14_M147_noxref_g N_noxref_17_c_10726_n ) capacitor \
 c=0.00966507f //x=76.31 //y=6.2 //x2=76.855 //y2=5.38
cc_5763 ( N_noxref_14_M148_noxref_g N_noxref_17_c_10726_n ) capacitor \
 c=0.00842859f //x=76.75 //y=6.2 //x2=76.855 //y2=5.38
cc_5764 ( N_noxref_14_c_8141_p N_noxref_17_c_10726_n ) capacitor c=8.41897e-19 \
 //x=76.74 //y=4.88 //x2=76.855 //y2=5.38
cc_5765 ( N_noxref_14_c_8142_p N_noxref_17_c_10734_n ) capacitor c=0.00326079f \
 //x=73.635 //y=1.76 //x2=77.01 //y2=1.75
cc_5766 ( N_noxref_14_c_8143_p N_noxref_17_c_10734_n ) capacitor c=0.00119302f \
 //x=76.745 //y=1.43 //x2=77.01 //y2=1.75
cc_5767 ( N_noxref_14_c_8144_p N_noxref_17_c_10734_n ) capacitor c=0.00439215f \
 //x=76.745 //y=1.74 //x2=77.01 //y2=1.75
cc_5768 ( N_noxref_14_c_8145_p N_noxref_17_c_10734_n ) capacitor c=0.0092493f \
 //x=77.12 //y=1.585 //x2=77.01 //y2=1.75
cc_5769 ( N_noxref_14_c_8146_p N_noxref_17_c_10734_n ) capacitor c=0.00323949f \
 //x=77.275 //y=1.43 //x2=77.01 //y2=1.75
cc_5770 ( N_noxref_14_c_8147_p N_noxref_17_c_10734_n ) capacitor c=0.00341688f \
 //x=76.71 //y=2.095 //x2=77.01 //y2=1.75
cc_5771 ( N_noxref_14_M149_noxref_g N_noxref_17_c_10740_n ) capacitor \
 c=0.0110849f //x=77.19 //y=6.2 //x2=77.365 //y2=5.38
cc_5772 ( N_noxref_14_c_8145_p N_noxref_17_c_10741_n ) capacitor c=0.00194324f \
 //x=77.12 //y=1.585 //x2=77.365 //y2=1.835
cc_5773 ( N_noxref_14_c_8146_p N_noxref_17_c_10741_n ) capacitor c=0.00323005f \
 //x=77.275 //y=1.43 //x2=77.365 //y2=1.835
cc_5774 ( N_noxref_14_c_8151_p N_noxref_17_c_10743_n ) capacitor c=0.00218808f \
 //x=74.035 //y=1.845 //x2=77.095 //y2=1.835
cc_5775 ( N_noxref_14_c_8151_p N_noxref_17_c_10744_n ) capacitor c=0.00203605f \
 //x=74.035 //y=1.845 //x2=77.45 //y2=3.735
cc_5776 ( N_noxref_14_c_8050_p N_noxref_17_c_10744_n ) capacitor c=0.00363906f \
 //x=75.97 //y=4.125 //x2=77.45 //y2=3.735
cc_5777 ( N_noxref_14_c_8005_p N_noxref_17_c_10744_n ) capacitor c=0.0548503f \
 //x=76.71 //y=4.095 //x2=77.45 //y2=3.735
cc_5778 ( N_noxref_14_c_8113_p N_noxref_17_c_10744_n ) capacitor c=0.015397f \
 //x=76.71 //y=2.26 //x2=77.45 //y2=3.735
cc_5779 ( N_noxref_14_c_8156_p N_noxref_17_c_10744_n ) capacitor c=9.90728e-19 \
 //x=76.71 //y=2.26 //x2=77.45 //y2=3.735
cc_5780 ( N_noxref_14_c_8157_p N_noxref_17_c_10744_n ) capacitor c=0.00281392f \
 //x=76.71 //y=2.26 //x2=77.45 //y2=3.735
cc_5781 ( N_noxref_14_c_8147_p N_noxref_17_c_10744_n ) capacitor c=0.00309058f \
 //x=76.71 //y=2.095 //x2=77.45 //y2=3.735
cc_5782 ( N_noxref_14_c_8005_p N_noxref_17_c_10751_n ) capacitor c=0.0176899f \
 //x=76.71 //y=4.095 //x2=77.45 //y2=4.055
cc_5783 ( N_noxref_14_c_8160_p N_noxref_17_c_10751_n ) capacitor c=0.00127572f \
 //x=77.115 //y=4.97 //x2=77.45 //y2=4.055
cc_5784 ( N_noxref_14_c_7916_n N_noxref_17_c_10753_n ) capacitor c=0.00284364f \
 //x=74.12 //y=5.25 //x2=77.45 //y2=5.295
cc_5785 ( N_noxref_14_c_8005_p N_noxref_17_c_10753_n ) capacitor c=0.00177543f \
 //x=76.71 //y=4.095 //x2=77.45 //y2=5.295
cc_5786 ( N_noxref_14_c_8134_p N_noxref_17_c_10753_n ) capacitor c=0.0145387f \
 //x=76.71 //y=4.415 //x2=77.45 //y2=5.295
cc_5787 ( N_noxref_14_c_8135_p N_noxref_17_c_10753_n ) capacitor c=0.0299998f \
 //x=76.71 //y=4.735 //x2=77.45 //y2=5.295
cc_5788 ( N_noxref_14_c_8131_p N_noxref_17_c_10753_n ) capacitor c=0.00143294f \
 //x=75.972 //y=4.74 //x2=77.45 //y2=5.295
cc_5789 ( N_noxref_14_c_8166_p N_noxref_17_c_10753_n ) capacitor c=5.7399e-19 \
 //x=76.71 //y=4.25 //x2=77.45 //y2=5.295
cc_5790 ( N_noxref_14_c_8136_p N_noxref_17_c_10753_n ) capacitor c=0.00680075f \
 //x=76.7 //y=4.255 //x2=77.45 //y2=5.295
cc_5791 ( N_noxref_14_c_8138_p N_noxref_17_c_10753_n ) capacitor c=0.00386205f \
 //x=76.74 //y=4.88 //x2=77.45 //y2=5.295
cc_5792 ( N_noxref_14_c_8160_p N_noxref_17_c_10753_n ) capacitor c=0.00845606f \
 //x=77.115 //y=4.97 //x2=77.45 //y2=5.295
cc_5793 ( N_noxref_14_c_8141_p N_noxref_17_c_10753_n ) capacitor c=0.00142201f \
 //x=76.74 //y=4.88 //x2=77.45 //y2=5.295
cc_5794 ( N_noxref_14_c_7915_n N_noxref_17_c_10671_n ) capacitor c=7.6985e-19 \
 //x=74.12 //y=4.13 //x2=73.38 //y2=3.88
cc_5795 ( N_noxref_14_c_8172_p N_noxref_17_c_10764_n ) capacitor c=5.58535e-19 \
 //x=73.34 //y=5.56 //x2=76.09 //y2=5.56
cc_5796 ( N_noxref_14_c_8120_p N_noxref_17_c_10764_n ) capacitor c=0.00104762f \
 //x=74.035 //y=5.335 //x2=76.09 //y2=5.56
cc_5797 ( N_noxref_14_c_8174_p N_noxref_17_c_10764_n ) capacitor c=9.52136e-19 \
 //x=75.97 //y=4.445 //x2=76.09 //y2=5.56
cc_5798 ( N_noxref_14_c_8175_p N_noxref_17_c_10764_n ) capacitor c=0.0117948f \
 //x=75.97 //y=4.88 //x2=76.09 //y2=5.56
cc_5799 ( N_noxref_14_c_8176_p N_noxref_17_c_10764_n ) capacitor c=5.02533e-19 \
 //x=76.12 //y=4.285 //x2=76.09 //y2=5.56
cc_5800 ( N_noxref_14_c_8054_p N_noxref_17_c_10764_n ) capacitor c=0.0126267f \
 //x=76.54 //y=4.255 //x2=76.09 //y2=5.56
cc_5801 ( N_noxref_14_c_8178_p N_noxref_17_c_10764_n ) capacitor c=0.00277154f \
 //x=75.97 //y=4.88 //x2=76.09 //y2=5.56
cc_5802 ( N_noxref_14_M146_noxref_g N_noxref_17_c_10764_n ) capacitor \
 c=0.00201806f //x=75.87 //y=6.2 //x2=76.09 //y2=5.56
cc_5803 ( N_noxref_14_M147_noxref_g N_noxref_17_c_10764_n ) capacitor \
 c=0.00192712f //x=76.31 //y=6.2 //x2=76.09 //y2=5.56
cc_5804 ( N_noxref_14_c_8181_p N_noxref_17_c_10764_n ) capacitor c=0.00202806f \
 //x=75.97 //y=4.88 //x2=76.09 //y2=5.56
cc_5805 ( N_noxref_14_M148_noxref_g N_noxref_17_c_10774_n ) capacitor \
 c=0.00192712f //x=76.75 //y=6.2 //x2=76.97 //y2=5.38
cc_5806 ( N_noxref_14_M149_noxref_g N_noxref_17_c_10774_n ) capacitor \
 c=0.00297999f //x=77.19 //y=6.2 //x2=76.97 //y2=5.38
cc_5807 ( N_noxref_14_c_8160_p N_noxref_17_c_10774_n ) capacitor c=0.0020909f \
 //x=77.115 //y=4.97 //x2=76.97 //y2=5.38
cc_5808 ( N_noxref_14_c_8107_p N_noxref_17_c_10777_n ) capacitor c=6.5615e-19 \
 //x=73.635 //y=1.305 //x2=77.01 //y2=1.18
cc_5809 ( N_noxref_14_c_8186_p N_noxref_17_c_10777_n ) capacitor c=0.00120406f \
 //x=76.745 //y=1.085 //x2=77.01 //y2=1.18
cc_5810 ( N_noxref_14_c_8143_p N_noxref_17_c_10777_n ) capacitor c=0.00218772f \
 //x=76.745 //y=1.43 //x2=77.01 //y2=1.18
cc_5811 ( N_noxref_14_c_8188_p N_noxref_17_c_10777_n ) capacitor c=5.50523e-19 \
 //x=77.12 //y=0.93 //x2=77.01 //y2=1.18
cc_5812 ( N_noxref_14_c_8145_p N_noxref_17_c_10777_n ) capacitor c=5.67071e-19 \
 //x=77.12 //y=1.585 //x2=77.01 //y2=1.18
cc_5813 ( N_noxref_14_c_8190_p N_noxref_17_c_10777_n ) capacitor c=0.00109305f \
 //x=77.275 //y=1.085 //x2=77.01 //y2=1.18
cc_5814 ( N_noxref_14_c_8146_p N_noxref_17_c_10777_n ) capacitor c=0.00317556f \
 //x=77.275 //y=1.43 //x2=77.01 //y2=1.18
cc_5815 ( N_noxref_14_c_8005_p N_noxref_17_c_10784_n ) capacitor c=9.19401e-19 \
 //x=76.71 //y=4.095 //x2=77.45 //y2=3.88
cc_5816 ( N_noxref_14_c_7915_n N_noxref_17_c_10785_n ) capacitor c=0.0219312f \
 //x=74.12 //y=4.13 //x2=76.315 //y2=3.88
cc_5817 ( N_noxref_14_c_8127_p N_noxref_17_c_10785_n ) capacitor c=0.00887164f \
 //x=74.12 //y=4.45 //x2=76.315 //y2=3.88
cc_5818 ( N_noxref_14_c_8050_p N_noxref_17_c_10785_n ) capacitor c=0.0231934f \
 //x=75.97 //y=4.125 //x2=76.315 //y2=3.88
cc_5819 ( N_noxref_14_c_8174_p N_noxref_17_c_10785_n ) capacitor c=0.00713904f \
 //x=75.97 //y=4.445 //x2=76.315 //y2=3.88
cc_5820 ( N_noxref_14_c_8005_p N_noxref_17_c_10785_n ) capacitor c=2.03917e-19 \
 //x=76.71 //y=4.095 //x2=76.315 //y2=3.88
cc_5821 ( N_noxref_14_c_8134_p N_noxref_17_c_10785_n ) capacitor c=0.00187855f \
 //x=76.71 //y=4.415 //x2=76.315 //y2=3.88
cc_5822 ( N_noxref_14_c_7859_n N_noxref_17_c_10785_n ) capacitor c=0.0711607f \
 //x=74.28 //y=4.25 //x2=76.315 //y2=3.88
cc_5823 ( N_noxref_14_c_8053_p N_noxref_17_c_10785_n ) capacitor c=0.138949f \
 //x=75.8 //y=4.285 //x2=76.315 //y2=3.88
cc_5824 ( N_noxref_14_c_8176_p N_noxref_17_c_10785_n ) capacitor c=0.0348969f \
 //x=76.12 //y=4.285 //x2=76.315 //y2=3.88
cc_5825 ( N_noxref_14_c_8054_p N_noxref_17_c_10785_n ) capacitor c=0.0368325f \
 //x=76.54 //y=4.255 //x2=76.315 //y2=3.88
cc_5826 ( N_noxref_14_c_8005_p N_noxref_17_c_10795_n ) capacitor c=0.01862f \
 //x=76.71 //y=4.095 //x2=76.915 //y2=3.87
cc_5827 ( N_noxref_14_c_8134_p N_noxref_17_c_10795_n ) capacitor c=0.00450788f \
 //x=76.71 //y=4.415 //x2=76.915 //y2=3.87
cc_5828 ( N_noxref_14_c_8136_p N_noxref_17_c_10795_n ) capacitor c=0.0368432f \
 //x=76.7 //y=4.255 //x2=76.915 //y2=3.87
cc_5829 ( N_noxref_14_c_8005_p N_noxref_17_c_10798_n ) capacitor c=0.00344895f \
 //x=76.71 //y=4.095 //x2=78.79 //y2=3.895
cc_5830 ( N_noxref_14_c_7915_n N_noxref_17_c_10672_n ) capacitor c=0.00336755f \
 //x=74.12 //y=4.13 //x2=73.54 //y2=3.865
cc_5831 ( N_noxref_14_c_7859_n N_noxref_17_c_10672_n ) capacitor c=0.0365231f \
 //x=74.28 //y=4.25 //x2=73.54 //y2=3.865
cc_5832 ( N_noxref_14_c_7915_n N_noxref_17_c_10687_n ) capacitor c=0.00163444f \
 //x=74.12 //y=4.13 //x2=73.38 //y2=2.26
cc_5833 ( N_noxref_14_c_8120_p N_noxref_17_c_10690_n ) capacitor c=0.00130631f \
 //x=74.035 //y=5.335 //x2=73.38 //y2=4.88
cc_5834 ( N_noxref_14_c_7916_n N_noxref_17_c_10690_n ) capacitor c=0.00131258f \
 //x=74.12 //y=5.25 //x2=73.38 //y2=4.88
cc_5835 ( N_noxref_14_c_8129_p N_noxref_17_c_10690_n ) capacitor c=0.00346456f \
 //x=73.34 //y=5.335 //x2=73.38 //y2=4.88
cc_5836 ( N_noxref_14_c_8133_p N_noxref_17_c_10690_n ) capacitor c=0.00624059f \
 //x=73.34 //y=5.56 //x2=73.38 //y2=4.88
cc_5837 ( N_noxref_14_c_8174_p N_noxref_17_c_10806_n ) capacitor c=4.15796e-19 \
 //x=75.97 //y=4.445 //x2=76.09 //y2=5.56
cc_5838 ( N_noxref_14_c_8175_p N_noxref_17_c_10806_n ) capacitor c=0.00104426f \
 //x=75.97 //y=4.88 //x2=76.09 //y2=5.56
cc_5839 ( N_noxref_14_c_8178_p N_noxref_17_c_10806_n ) capacitor c=0.00377369f \
 //x=75.97 //y=4.88 //x2=76.09 //y2=5.56
cc_5840 ( N_noxref_14_M146_noxref_g N_noxref_17_c_10806_n ) capacitor \
 c=0.0158358f //x=75.87 //y=6.2 //x2=76.09 //y2=5.56
cc_5841 ( N_noxref_14_M147_noxref_g N_noxref_17_c_10806_n ) capacitor \
 c=0.0178987f //x=76.31 //y=6.2 //x2=76.09 //y2=5.56
cc_5842 ( N_noxref_14_c_8181_p N_noxref_17_c_10806_n ) capacitor c=0.00317595f \
 //x=75.97 //y=4.88 //x2=76.09 //y2=5.56
cc_5843 ( N_noxref_14_M148_noxref_g N_noxref_17_c_10812_n ) capacitor \
 c=0.0178987f //x=76.75 //y=6.2 //x2=76.97 //y2=5.56
cc_5844 ( N_noxref_14_M149_noxref_g N_noxref_17_c_10812_n ) capacitor \
 c=0.0178506f //x=77.19 //y=6.2 //x2=76.97 //y2=5.56
cc_5845 ( N_noxref_14_c_8160_p N_noxref_17_c_10812_n ) capacitor c=0.00291714f \
 //x=77.115 //y=4.97 //x2=76.97 //y2=5.56
cc_5846 ( N_noxref_14_c_7914_n N_noxref_17_M144_noxref_g ) capacitor \
 c=0.0103546f //x=73.225 //y=5.335 //x2=73.12 //y2=6.2
cc_5847 ( N_noxref_14_c_8172_p N_noxref_17_M144_noxref_g ) capacitor \
 c=0.00226521f //x=73.34 //y=5.56 //x2=73.12 //y2=6.2
cc_5848 ( N_noxref_14_c_8133_p N_noxref_17_M144_noxref_g ) capacitor \
 c=0.0178885f //x=73.34 //y=5.56 //x2=73.12 //y2=6.2
cc_5849 ( N_noxref_14_c_8172_p N_noxref_17_M145_noxref_g ) capacitor \
 c=0.00368945f //x=73.34 //y=5.56 //x2=73.56 //y2=6.2
cc_5850 ( N_noxref_14_c_8120_p N_noxref_17_M145_noxref_g ) capacitor \
 c=0.0110767f //x=74.035 //y=5.335 //x2=73.56 //y2=6.2
cc_5851 ( N_noxref_14_c_8133_p N_noxref_17_M145_noxref_g ) capacitor \
 c=0.0188608f //x=73.34 //y=5.56 //x2=73.56 //y2=6.2
cc_5852 ( N_noxref_14_c_8107_p N_noxref_17_c_10697_n ) capacitor c=4.64015e-19 \
 //x=73.635 //y=1.305 //x2=73.37 //y2=1.095
cc_5853 ( N_noxref_14_M45_noxref_d N_noxref_17_c_10697_n ) capacitor \
 c=0.00137165f //x=73.445 //y=1.095 //x2=73.37 //y2=1.095
cc_5854 ( N_noxref_14_c_8107_p N_noxref_17_c_10698_n ) capacitor c=0.0026012f \
 //x=73.635 //y=1.305 //x2=73.37 //y2=1.44
cc_5855 ( N_noxref_14_c_8142_p N_noxref_17_c_10698_n ) capacitor c=0.00127432f \
 //x=73.635 //y=1.76 //x2=73.37 //y2=1.44
cc_5856 ( N_noxref_14_M45_noxref_d N_noxref_17_c_10698_n ) capacitor \
 c=0.00237422f //x=73.445 //y=1.095 //x2=73.37 //y2=1.44
cc_5857 ( N_noxref_14_c_8142_p N_noxref_17_c_10699_n ) capacitor c=0.00429966f \
 //x=73.635 //y=1.76 //x2=73.37 //y2=1.75
cc_5858 ( N_noxref_14_c_8107_p N_noxref_17_c_10827_n ) capacitor c=5.29969e-19 \
 //x=73.635 //y=1.305 //x2=73.745 //y2=0.94
cc_5859 ( N_noxref_14_M45_noxref_d N_noxref_17_c_10827_n ) capacitor \
 c=0.0020782f //x=73.445 //y=1.095 //x2=73.745 //y2=0.94
cc_5860 ( N_noxref_14_c_8107_p N_noxref_17_c_10829_n ) capacitor c=5.17633e-19 \
 //x=73.635 //y=1.305 //x2=73.745 //y2=1.595
cc_5861 ( N_noxref_14_c_8142_p N_noxref_17_c_10829_n ) capacitor c=0.00930387f \
 //x=73.635 //y=1.76 //x2=73.745 //y2=1.595
cc_5862 ( N_noxref_14_c_8151_p N_noxref_17_c_10829_n ) capacitor c=0.00194716f \
 //x=74.035 //y=1.845 //x2=73.745 //y2=1.595
cc_5863 ( N_noxref_14_M45_noxref_d N_noxref_17_c_10829_n ) capacitor \
 c=0.00356097f //x=73.445 //y=1.095 //x2=73.745 //y2=1.595
cc_5864 ( N_noxref_14_c_8107_p N_noxref_17_c_10833_n ) capacitor c=5.28622e-19 \
 //x=73.635 //y=1.305 //x2=73.9 //y2=1.095
cc_5865 ( N_noxref_14_M45_noxref_d N_noxref_17_c_10833_n ) capacitor \
 c=0.00139206f //x=73.445 //y=1.095 //x2=73.9 //y2=1.095
cc_5866 ( N_noxref_14_c_8107_p N_noxref_17_c_10835_n ) capacitor c=0.00312156f \
 //x=73.635 //y=1.305 //x2=73.9 //y2=1.44
cc_5867 ( N_noxref_14_c_8142_p N_noxref_17_c_10835_n ) capacitor c=0.00347599f \
 //x=73.635 //y=1.76 //x2=73.9 //y2=1.44
cc_5868 ( N_noxref_14_c_8151_p N_noxref_17_c_10835_n ) capacitor c=0.00323576f \
 //x=74.035 //y=1.845 //x2=73.9 //y2=1.44
cc_5869 ( N_noxref_14_M45_noxref_d N_noxref_17_c_10835_n ) capacitor \
 c=0.00237422f //x=73.445 //y=1.095 //x2=73.9 //y2=1.44
cc_5870 ( N_noxref_14_c_7915_n N_noxref_17_c_10700_n ) capacitor c=0.0025845f \
 //x=74.12 //y=4.13 //x2=73.38 //y2=2.26
cc_5871 ( N_noxref_14_c_8142_p N_noxref_17_c_10703_n ) capacitor c=0.0036273f \
 //x=73.635 //y=1.76 //x2=73.38 //y2=2.095
cc_5872 ( N_noxref_14_c_7915_n N_noxref_17_c_10703_n ) capacitor c=0.00282067f \
 //x=74.12 //y=4.13 //x2=73.38 //y2=2.095
cc_5873 ( N_noxref_14_c_7916_n N_noxref_17_c_10704_n ) capacitor c=0.00739875f \
 //x=74.12 //y=5.25 //x2=73.38 //y2=4.88
cc_5874 ( N_noxref_14_c_8129_p N_noxref_17_c_10704_n ) capacitor c=0.00203307f \
 //x=73.34 //y=5.335 //x2=73.38 //y2=4.88
cc_5875 ( N_noxref_14_c_8133_p N_noxref_17_c_10704_n ) capacitor c=0.00375636f \
 //x=73.34 //y=5.56 //x2=73.38 //y2=4.88
cc_5876 ( N_noxref_14_c_8186_p N_noxref_17_M47_noxref_d ) capacitor \
 c=0.00137165f //x=76.745 //y=1.085 //x2=76.82 //y2=1.085
cc_5877 ( N_noxref_14_c_8143_p N_noxref_17_M47_noxref_d ) capacitor \
 c=0.00237422f //x=76.745 //y=1.43 //x2=76.82 //y2=1.085
cc_5878 ( N_noxref_14_c_8188_p N_noxref_17_M47_noxref_d ) capacitor \
 c=0.0020782f //x=77.12 //y=0.93 //x2=76.82 //y2=1.085
cc_5879 ( N_noxref_14_c_8145_p N_noxref_17_M47_noxref_d ) capacitor \
 c=0.00356097f //x=77.12 //y=1.585 //x2=76.82 //y2=1.085
cc_5880 ( N_noxref_14_c_8190_p N_noxref_17_M47_noxref_d ) capacitor \
 c=8.50095e-19 //x=77.275 //y=1.085 //x2=76.82 //y2=1.085
cc_5881 ( N_noxref_14_c_8146_p N_noxref_17_M47_noxref_d ) capacitor \
 c=0.00237422f //x=77.275 //y=1.43 //x2=76.82 //y2=1.085
cc_5882 ( N_noxref_14_c_7738_n N_VDD_c_11464_n ) capacitor c=3.90015e-19 \
 //x=53.4 //y=4.42 //x2=78.895 //y2=7.585
cc_5883 ( N_noxref_14_c_7751_n N_VDD_c_11464_n ) capacitor c=0.00621352f \
 //x=67.53 //y=5.335 //x2=78.895 //y2=7.585
cc_5884 ( N_noxref_14_c_7756_n N_VDD_c_11464_n ) capacitor c=0.00627192f \
 //x=68.415 //y=5.335 //x2=78.895 //y2=7.585
cc_5885 ( N_noxref_14_c_7874_n N_VDD_c_11464_n ) capacitor c=0.00256036f \
 //x=68.53 //y=5.56 //x2=78.895 //y2=7.585
cc_5886 ( N_noxref_14_c_7876_n N_VDD_c_11464_n ) capacitor c=0.00829214f \
 //x=69.225 //y=5.335 //x2=78.895 //y2=7.585
cc_5887 ( N_noxref_14_c_7822_n N_VDD_c_11464_n ) capacitor c=2.29405e-19 \
 //x=69.31 //y=4.415 //x2=78.895 //y2=7.585
cc_5888 ( N_noxref_14_c_7826_n N_VDD_c_11464_n ) capacitor c=0.00621363f \
 //x=72.34 //y=5.335 //x2=78.895 //y2=7.585
cc_5889 ( N_noxref_14_c_7914_n N_VDD_c_11464_n ) capacitor c=0.00627191f \
 //x=73.225 //y=5.335 //x2=78.895 //y2=7.585
cc_5890 ( N_noxref_14_c_8172_p N_VDD_c_11464_n ) capacitor c=0.00256019f \
 //x=73.34 //y=5.56 //x2=78.895 //y2=7.585
cc_5891 ( N_noxref_14_c_8120_p N_VDD_c_11464_n ) capacitor c=0.00829235f \
 //x=74.035 //y=5.335 //x2=78.895 //y2=7.585
cc_5892 ( N_noxref_14_c_8127_p N_VDD_c_11464_n ) capacitor c=5.01794e-19 \
 //x=74.12 //y=4.45 //x2=78.895 //y2=7.585
cc_5893 ( N_noxref_14_c_8174_p N_VDD_c_11464_n ) capacitor c=2.28686e-19 \
 //x=75.97 //y=4.445 //x2=78.895 //y2=7.585
cc_5894 ( N_noxref_14_c_7760_n N_VDD_c_11464_n ) capacitor c=0.00261804f \
 //x=66.772 //y=5.335 //x2=78.895 //y2=7.585
cc_5895 ( N_noxref_14_c_7761_n N_VDD_c_11464_n ) capacitor c=0.00270108f \
 //x=67.65 //y=5.335 //x2=78.895 //y2=7.585
cc_5896 ( N_noxref_14_c_7922_n N_VDD_c_11464_n ) capacitor c=3.94104e-19 \
 //x=69.31 //y=4.25 //x2=78.895 //y2=7.585
cc_5897 ( N_noxref_14_c_7827_n N_VDD_c_11464_n ) capacitor c=0.00261804f \
 //x=71.582 //y=5.335 //x2=78.895 //y2=7.585
cc_5898 ( N_noxref_14_c_7923_n N_VDD_c_11464_n ) capacitor c=0.00270108f \
 //x=72.46 //y=5.335 //x2=78.895 //y2=7.585
cc_5899 ( N_noxref_14_c_8130_p N_VDD_c_11464_n ) capacitor c=3.94104e-19 \
 //x=74.12 //y=4.25 //x2=78.895 //y2=7.585
cc_5900 ( N_noxref_14_c_8175_p N_VDD_c_11464_n ) capacitor c=9.07241e-19 \
 //x=75.97 //y=4.88 //x2=78.895 //y2=7.585
cc_5901 ( N_noxref_14_c_8073_p N_VDD_c_11464_n ) capacitor c=0.0024232f \
 //x=66.77 //y=5.56 //x2=78.895 //y2=7.585
cc_5902 ( N_noxref_14_c_7786_n N_VDD_c_11464_n ) capacitor c=0.0024232f \
 //x=67.65 //y=5.56 //x2=78.895 //y2=7.585
cc_5903 ( N_noxref_14_c_7934_n N_VDD_c_11464_n ) capacitor c=0.0024232f \
 //x=68.53 //y=5.56 //x2=78.895 //y2=7.585
cc_5904 ( N_noxref_14_c_7860_n N_VDD_c_11464_n ) capacitor c=0.0024232f \
 //x=71.58 //y=5.56 //x2=78.895 //y2=7.585
cc_5905 ( N_noxref_14_c_7939_n N_VDD_c_11464_n ) capacitor c=0.0024232f \
 //x=72.46 //y=5.56 //x2=78.895 //y2=7.585
cc_5906 ( N_noxref_14_c_8133_p N_VDD_c_11464_n ) capacitor c=0.0024232f \
 //x=73.34 //y=5.56 //x2=78.895 //y2=7.585
cc_5907 ( N_noxref_14_c_8178_p N_VDD_c_11464_n ) capacitor c=6.22888e-19 \
 //x=75.97 //y=4.88 //x2=78.895 //y2=7.585
cc_5908 ( N_noxref_14_c_7738_n N_VDD_c_12177_n ) capacitor c=3.24038e-19 \
 //x=53.4 //y=4.42 //x2=54.175 //y2=7.585
cc_5909 ( N_noxref_14_M118_noxref_g N_VDD_c_12177_n ) capacitor c=0.00755614f \
 //x=53.6 //y=6.2 //x2=54.175 //y2=7.585
cc_5910 ( N_noxref_14_M119_noxref_g N_VDD_c_12177_n ) capacitor c=0.00755544f \
 //x=54.04 //y=6.2 //x2=54.175 //y2=7.585
cc_5911 ( N_noxref_14_M132_noxref_g N_VDD_c_12308_n ) capacitor c=0.00697352f \
 //x=63.8 //y=6.2 //x2=64.375 //y2=7.585
cc_5912 ( N_noxref_14_M133_noxref_g N_VDD_c_12308_n ) capacitor c=0.00755544f \
 //x=64.24 //y=6.2 //x2=64.375 //y2=7.585
cc_5913 ( N_noxref_14_c_7751_n N_VDD_c_12310_n ) capacitor c=0.00202922f \
 //x=67.53 //y=5.335 //x2=67.125 //y2=7.585
cc_5914 ( N_noxref_14_c_7760_n N_VDD_c_12310_n ) capacitor c=9.3757e-19 \
 //x=66.772 //y=5.335 //x2=67.125 //y2=7.585
cc_5915 ( N_noxref_14_c_8073_p N_VDD_c_12310_n ) capacitor c=0.0138074f \
 //x=66.77 //y=5.56 //x2=67.125 //y2=7.585
cc_5916 ( N_noxref_14_c_7751_n N_VDD_c_12119_n ) capacitor c=0.0017708f \
 //x=67.53 //y=5.335 //x2=68.005 //y2=7.585
cc_5917 ( N_noxref_14_c_7756_n N_VDD_c_12119_n ) capacitor c=0.00202922f \
 //x=68.415 //y=5.335 //x2=68.005 //y2=7.585
cc_5918 ( N_noxref_14_c_7761_n N_VDD_c_12119_n ) capacitor c=9.4822e-19 \
 //x=67.65 //y=5.335 //x2=68.005 //y2=7.585
cc_5919 ( N_noxref_14_c_7786_n N_VDD_c_12119_n ) capacitor c=0.0138074f \
 //x=67.65 //y=5.56 //x2=68.005 //y2=7.585
cc_5920 ( N_noxref_14_c_7756_n N_VDD_c_12245_n ) capacitor c=0.00205906f \
 //x=68.415 //y=5.335 //x2=68.885 //y2=7.585
cc_5921 ( N_noxref_14_c_7874_n N_VDD_c_12245_n ) capacitor c=8.49654e-19 \
 //x=68.53 //y=5.56 //x2=68.885 //y2=7.585
cc_5922 ( N_noxref_14_c_7876_n N_VDD_c_12245_n ) capacitor c=0.00204238f \
 //x=69.225 //y=5.335 //x2=68.885 //y2=7.585
cc_5923 ( N_noxref_14_c_7934_n N_VDD_c_12245_n ) capacitor c=0.0138074f \
 //x=68.53 //y=5.56 //x2=68.885 //y2=7.585
cc_5924 ( N_noxref_14_c_7876_n N_VDD_c_12321_n ) capacitor c=0.00157252f \
 //x=69.225 //y=5.335 //x2=69.88 //y2=7.585
cc_5925 ( N_noxref_14_c_7826_n N_VDD_c_12191_n ) capacitor c=0.00202922f \
 //x=72.34 //y=5.335 //x2=71.935 //y2=7.585
cc_5926 ( N_noxref_14_c_7827_n N_VDD_c_12191_n ) capacitor c=9.3757e-19 \
 //x=71.582 //y=5.335 //x2=71.935 //y2=7.585
cc_5927 ( N_noxref_14_c_7860_n N_VDD_c_12191_n ) capacitor c=0.0138074f \
 //x=71.58 //y=5.56 //x2=71.935 //y2=7.585
cc_5928 ( N_noxref_14_c_7826_n N_VDD_c_12247_n ) capacitor c=0.0017708f \
 //x=72.34 //y=5.335 //x2=72.815 //y2=7.585
cc_5929 ( N_noxref_14_c_7914_n N_VDD_c_12247_n ) capacitor c=0.00202922f \
 //x=73.225 //y=5.335 //x2=72.815 //y2=7.585
cc_5930 ( N_noxref_14_c_7923_n N_VDD_c_12247_n ) capacitor c=9.4822e-19 \
 //x=72.46 //y=5.335 //x2=72.815 //y2=7.585
cc_5931 ( N_noxref_14_c_7939_n N_VDD_c_12247_n ) capacitor c=0.0138074f \
 //x=72.46 //y=5.56 //x2=72.815 //y2=7.585
cc_5932 ( N_noxref_14_c_7914_n N_VDD_c_12329_n ) capacitor c=0.00205906f \
 //x=73.225 //y=5.335 //x2=73.695 //y2=7.585
cc_5933 ( N_noxref_14_c_8172_p N_VDD_c_12329_n ) capacitor c=8.49654e-19 \
 //x=73.34 //y=5.56 //x2=73.695 //y2=7.585
cc_5934 ( N_noxref_14_c_8120_p N_VDD_c_12329_n ) capacitor c=0.00204238f \
 //x=74.035 //y=5.335 //x2=73.695 //y2=7.585
cc_5935 ( N_noxref_14_c_8133_p N_VDD_c_12329_n ) capacitor c=0.0135103f \
 //x=73.34 //y=5.56 //x2=73.695 //y2=7.585
cc_5936 ( N_noxref_14_c_8120_p N_VDD_c_12333_n ) capacitor c=0.00157252f \
 //x=74.035 //y=5.335 //x2=74.69 //y2=7.585
cc_5937 ( N_noxref_14_c_8127_p N_VDD_c_12333_n ) capacitor c=4.06473e-19 \
 //x=74.12 //y=4.45 //x2=74.69 //y2=7.585
cc_5938 ( N_noxref_14_c_8175_p N_VDD_c_12335_n ) capacitor c=6.28113e-19 \
 //x=75.97 //y=4.88 //x2=76.445 //y2=7.585
cc_5939 ( N_noxref_14_M146_noxref_g N_VDD_c_12335_n ) capacitor c=0.00732618f \
 //x=75.87 //y=6.2 //x2=76.445 //y2=7.585
cc_5940 ( N_noxref_14_M147_noxref_g N_VDD_c_12335_n ) capacitor c=0.00755544f \
 //x=76.31 //y=6.2 //x2=76.445 //y2=7.585
cc_5941 ( N_noxref_14_M148_noxref_g N_VDD_c_12338_n ) capacitor c=0.00697352f \
 //x=76.75 //y=6.2 //x2=77.325 //y2=7.585
cc_5942 ( N_noxref_14_M149_noxref_g N_VDD_c_12338_n ) capacitor c=0.00755544f \
 //x=77.19 //y=6.2 //x2=77.325 //y2=7.585
cc_5943 ( N_noxref_14_c_7738_n N_VDD_c_12066_n ) capacitor c=0.0012857f \
 //x=53.4 //y=4.42 //x2=52.29 //y2=7.585
cc_5944 ( N_noxref_14_c_7728_n N_VDD_c_12066_n ) capacitor c=0.00995973f \
 //x=53.4 //y=4.755 //x2=52.29 //y2=7.585
cc_5945 ( N_noxref_14_c_7729_n N_VDD_c_12066_n ) capacitor c=0.00268604f \
 //x=53.4 //y=4.25 //x2=52.29 //y2=7.585
cc_5946 ( N_noxref_14_c_7783_n N_VDD_c_12066_n ) capacitor c=0.00370784f \
 //x=53.4 //y=4.88 //x2=52.29 //y2=7.585
cc_5947 ( N_noxref_14_c_7807_n N_VDD_c_12066_n ) capacitor c=0.00590568f \
 //x=53.675 //y=4.97 //x2=52.29 //y2=7.585
cc_5948 ( N_noxref_14_c_7771_n N_VDD_c_12135_n ) capacitor c=5.71665e-19 \
 //x=56.615 //y=4.27 //x2=57.1 //y2=7.585
cc_5949 ( N_noxref_14_c_7772_n N_VDD_c_12135_n ) capacitor c=0.00910495f \
 //x=57.83 //y=4.25 //x2=57.1 //y2=7.585
cc_5950 ( N_noxref_14_c_7994_p N_VDD_c_12136_n ) capacitor c=8.4651e-19 \
 //x=63.76 //y=4.25 //x2=61.91 //y2=7.585
cc_5951 ( N_noxref_14_c_7732_n N_VDD_c_12136_n ) capacitor c=0.00875046f \
 //x=63.925 //y=4.25 //x2=61.91 //y2=7.585
cc_5952 ( N_noxref_14_c_7994_p N_VDD_c_12137_n ) capacitor c=0.00133334f \
 //x=63.76 //y=4.25 //x2=65.24 //y2=7.585
cc_5953 ( N_noxref_14_c_7760_n N_VDD_c_12137_n ) capacitor c=0.0022955f \
 //x=66.772 //y=5.335 //x2=65.24 //y2=7.585
cc_5954 ( N_noxref_14_c_7773_n N_VDD_c_12137_n ) capacitor c=0.00867114f \
 //x=69.155 //y=4.25 //x2=65.24 //y2=7.585
cc_5955 ( N_noxref_14_c_7972_p N_VDD_c_12137_n ) capacitor c=0.00226427f \
 //x=63.79 //y=4.88 //x2=65.24 //y2=7.585
cc_5956 ( N_noxref_14_c_8073_p N_VDD_c_12137_n ) capacitor c=0.00508013f \
 //x=66.77 //y=5.56 //x2=65.24 //y2=7.585
cc_5957 ( N_noxref_14_c_7999_p N_VDD_c_12137_n ) capacitor c=0.0129149f \
 //x=64.165 //y=4.97 //x2=65.24 //y2=7.585
cc_5958 ( N_noxref_14_c_7811_n N_VDD_c_12137_n ) capacitor c=2.73429e-19 \
 //x=63.79 //y=4.88 //x2=65.24 //y2=7.585
cc_5959 ( N_noxref_14_c_7874_n N_VDD_c_12201_n ) capacitor c=0.00282782f \
 //x=68.53 //y=5.56 //x2=70.05 //y2=7.585
cc_5960 ( N_noxref_14_c_7822_n N_VDD_c_12201_n ) capacitor c=0.00175322f \
 //x=69.31 //y=4.415 //x2=70.05 //y2=7.585
cc_5961 ( N_noxref_14_c_7758_n N_VDD_c_12201_n ) capacitor c=0.0309939f \
 //x=69.31 //y=5.25 //x2=70.05 //y2=7.585
cc_5962 ( N_noxref_14_c_7922_n N_VDD_c_12201_n ) capacitor c=0.00507985f \
 //x=69.31 //y=4.25 //x2=70.05 //y2=7.585
cc_5963 ( N_noxref_14_c_7827_n N_VDD_c_12201_n ) capacitor c=0.0022955f \
 //x=71.582 //y=5.335 //x2=70.05 //y2=7.585
cc_5964 ( N_noxref_14_c_7856_n N_VDD_c_12201_n ) capacitor c=0.0195443f \
 //x=71.02 //y=4.265 //x2=70.05 //y2=7.585
cc_5965 ( N_noxref_14_c_7934_n N_VDD_c_12201_n ) capacitor c=0.00777981f \
 //x=68.53 //y=5.56 //x2=70.05 //y2=7.585
cc_5966 ( N_noxref_14_c_7860_n N_VDD_c_12201_n ) capacitor c=0.00509469f \
 //x=71.58 //y=5.56 //x2=70.05 //y2=7.585
cc_5967 ( N_noxref_14_c_8172_p N_VDD_c_12364_n ) capacitor c=0.00269779f \
 //x=73.34 //y=5.56 //x2=74.86 //y2=7.585
cc_5968 ( N_noxref_14_c_8127_p N_VDD_c_12364_n ) capacitor c=0.00287896f \
 //x=74.12 //y=4.45 //x2=74.86 //y2=7.585
cc_5969 ( N_noxref_14_c_7916_n N_VDD_c_12364_n ) capacitor c=0.0292833f \
 //x=74.12 //y=5.25 //x2=74.86 //y2=7.585
cc_5970 ( N_noxref_14_c_8174_p N_VDD_c_12364_n ) capacitor c=0.0017489f \
 //x=75.97 //y=4.445 //x2=74.86 //y2=7.585
cc_5971 ( N_noxref_14_c_8130_p N_VDD_c_12364_n ) capacitor c=0.00506579f \
 //x=74.12 //y=4.25 //x2=74.86 //y2=7.585
cc_5972 ( N_noxref_14_c_8349_p N_VDD_c_12364_n ) capacitor c=0.0024673f \
 //x=75.97 //y=4.25 //x2=74.86 //y2=7.585
cc_5973 ( N_noxref_14_c_8175_p N_VDD_c_12364_n ) capacitor c=0.00447349f \
 //x=75.97 //y=4.88 //x2=74.86 //y2=7.585
cc_5974 ( N_noxref_14_c_8131_p N_VDD_c_12364_n ) capacitor c=0.00472491f \
 //x=75.972 //y=4.74 //x2=74.86 //y2=7.585
cc_5975 ( N_noxref_14_c_8053_p N_VDD_c_12364_n ) capacitor c=0.0187947f \
 //x=75.8 //y=4.285 //x2=74.86 //y2=7.585
cc_5976 ( N_noxref_14_c_8133_p N_VDD_c_12364_n ) capacitor c=0.00776541f \
 //x=73.34 //y=5.56 //x2=74.86 //y2=7.585
cc_5977 ( N_noxref_14_c_8178_p N_VDD_c_12364_n ) capacitor c=0.00370494f \
 //x=75.97 //y=4.88 //x2=74.86 //y2=7.585
cc_5978 ( N_noxref_14_c_8181_p N_VDD_c_12364_n ) capacitor c=0.0129564f \
 //x=75.97 //y=4.88 //x2=74.86 //y2=7.585
cc_5979 ( N_noxref_14_c_8166_p N_VDD_c_12376_n ) capacitor c=0.00143727f \
 //x=76.71 //y=4.25 //x2=78.19 //y2=7.585
cc_5980 ( N_noxref_14_c_8138_p N_VDD_c_12376_n ) capacitor c=0.00226427f \
 //x=76.74 //y=4.88 //x2=78.19 //y2=7.585
cc_5981 ( N_noxref_14_c_8160_p N_VDD_c_12376_n ) capacitor c=0.0135027f \
 //x=77.115 //y=4.97 //x2=78.19 //y2=7.585
cc_5982 ( N_noxref_14_c_8141_p N_VDD_c_12376_n ) capacitor c=2.73429e-19 \
 //x=76.74 //y=4.88 //x2=78.19 //y2=7.585
cc_5983 ( N_noxref_14_c_7738_n N_VDD_M118_noxref_s ) capacitor c=9.69442e-19 \
 //x=53.4 //y=4.42 //x2=53.245 //y2=5.2
cc_5984 ( N_noxref_14_c_7728_n N_VDD_M118_noxref_s ) capacitor c=0.0217321f \
 //x=53.4 //y=4.755 //x2=53.245 //y2=5.2
cc_5985 ( N_noxref_14_c_7783_n N_VDD_M118_noxref_s ) capacitor c=0.00983846f \
 //x=53.4 //y=4.88 //x2=53.245 //y2=5.2
cc_5986 ( N_noxref_14_M118_noxref_g N_VDD_M118_noxref_s ) capacitor \
 c=0.053419f //x=53.6 //y=6.2 //x2=53.245 //y2=5.2
cc_5987 ( N_noxref_14_c_7807_n N_VDD_M118_noxref_s ) capacitor c=0.0047643f \
 //x=53.675 //y=4.97 //x2=53.245 //y2=5.2
cc_5988 ( N_noxref_14_M119_noxref_g N_VDD_M119_noxref_d ) capacitor \
 c=0.015318f //x=54.04 //y=6.2 //x2=54.115 //y2=5.2
cc_5989 ( N_noxref_14_c_7760_n N_VDD_M130_noxref_s ) capacitor c=4.22189e-19 \
 //x=66.772 //y=5.335 //x2=62.565 //y2=5.2
cc_5990 ( N_noxref_14_M132_noxref_g N_VDD_M131_noxref_d ) capacitor \
 c=0.015318f //x=63.8 //y=6.2 //x2=63.435 //y2=5.2
cc_5991 ( N_noxref_14_c_7811_n N_VDD_M131_noxref_d ) capacitor c=3.50465e-19 \
 //x=63.79 //y=4.88 //x2=63.435 //y2=5.2
cc_5992 ( N_noxref_14_M133_noxref_g N_VDD_M133_noxref_d ) capacitor \
 c=0.0430452f //x=64.24 //y=6.2 //x2=64.315 //y2=5.2
cc_5993 ( N_noxref_14_c_7760_n N_VDD_M134_noxref_s ) capacitor c=0.0442713f \
 //x=66.772 //y=5.335 //x2=66.195 //y2=5.2
cc_5994 ( N_noxref_14_c_7761_n N_VDD_M134_noxref_s ) capacitor c=7.80122e-19 \
 //x=67.65 //y=5.335 //x2=66.195 //y2=5.2
cc_5995 ( N_noxref_14_c_8073_p N_VDD_M134_noxref_s ) capacitor c=0.0908457f \
 //x=66.77 //y=5.56 //x2=66.195 //y2=5.2
cc_5996 ( N_noxref_14_c_7751_n N_VDD_M135_noxref_d ) capacitor c=0.00700141f \
 //x=67.53 //y=5.335 //x2=67.065 //y2=5.2
cc_5997 ( N_noxref_14_c_8073_p N_VDD_M135_noxref_d ) capacitor c=0.0673792f \
 //x=66.77 //y=5.56 //x2=67.065 //y2=5.2
cc_5998 ( N_noxref_14_c_7786_n N_VDD_M135_noxref_d ) capacitor c=0.0674762f \
 //x=67.65 //y=5.56 //x2=67.065 //y2=5.2
cc_5999 ( N_noxref_14_c_7756_n N_VDD_M137_noxref_d ) capacitor c=0.00700141f \
 //x=68.415 //y=5.335 //x2=67.945 //y2=5.2
cc_6000 ( N_noxref_14_c_7786_n N_VDD_M137_noxref_d ) capacitor c=0.067493f \
 //x=67.65 //y=5.56 //x2=67.945 //y2=5.2
cc_6001 ( N_noxref_14_c_7934_n N_VDD_M137_noxref_d ) capacitor c=0.0674979f \
 //x=68.53 //y=5.56 //x2=67.945 //y2=5.2
cc_6002 ( N_noxref_14_c_7876_n N_VDD_M139_noxref_d ) capacitor c=0.00700141f \
 //x=69.225 //y=5.335 //x2=68.825 //y2=5.2
cc_6003 ( N_noxref_14_c_7934_n N_VDD_M139_noxref_d ) capacitor c=0.0675002f \
 //x=68.53 //y=5.56 //x2=68.825 //y2=5.2
cc_6004 ( N_noxref_14_c_7874_n N_VDD_M140_noxref_s ) capacitor c=0.00492616f \
 //x=68.53 //y=5.56 //x2=71.005 //y2=5.2
cc_6005 ( N_noxref_14_c_7876_n N_VDD_M140_noxref_s ) capacitor c=9.42705e-19 \
 //x=69.225 //y=5.335 //x2=71.005 //y2=5.2
cc_6006 ( N_noxref_14_c_7761_n N_VDD_M140_noxref_s ) capacitor c=2.11884e-19 \
 //x=67.65 //y=5.335 //x2=71.005 //y2=5.2
cc_6007 ( N_noxref_14_c_7827_n N_VDD_M140_noxref_s ) capacitor c=0.0441176f \
 //x=71.582 //y=5.335 //x2=71.005 //y2=5.2
cc_6008 ( N_noxref_14_c_7923_n N_VDD_M140_noxref_s ) capacitor c=7.80122e-19 \
 //x=72.46 //y=5.335 //x2=71.005 //y2=5.2
cc_6009 ( N_noxref_14_c_7856_n N_VDD_M140_noxref_s ) capacitor c=4.36524e-19 \
 //x=71.02 //y=4.265 //x2=71.005 //y2=5.2
cc_6010 ( N_noxref_14_c_7860_n N_VDD_M140_noxref_s ) capacitor c=0.09305f \
 //x=71.58 //y=5.56 //x2=71.005 //y2=5.2
cc_6011 ( N_noxref_14_c_7826_n N_VDD_M141_noxref_d ) capacitor c=0.00700141f \
 //x=72.34 //y=5.335 //x2=71.875 //y2=5.2
cc_6012 ( N_noxref_14_c_7860_n N_VDD_M141_noxref_d ) capacitor c=0.0674491f \
 //x=71.58 //y=5.56 //x2=71.875 //y2=5.2
cc_6013 ( N_noxref_14_c_7939_n N_VDD_M141_noxref_d ) capacitor c=0.0674762f \
 //x=72.46 //y=5.56 //x2=71.875 //y2=5.2
cc_6014 ( N_noxref_14_c_7914_n N_VDD_M143_noxref_d ) capacitor c=0.00700141f \
 //x=73.225 //y=5.335 //x2=72.755 //y2=5.2
cc_6015 ( N_noxref_14_c_7939_n N_VDD_M143_noxref_d ) capacitor c=0.067493f \
 //x=72.46 //y=5.56 //x2=72.755 //y2=5.2
cc_6016 ( N_noxref_14_c_8133_p N_VDD_M143_noxref_d ) capacitor c=0.0674288f \
 //x=73.34 //y=5.56 //x2=72.755 //y2=5.2
cc_6017 ( N_noxref_14_c_8120_p N_VDD_M145_noxref_d ) capacitor c=0.00700141f \
 //x=74.035 //y=5.335 //x2=73.635 //y2=5.2
cc_6018 ( N_noxref_14_c_8133_p N_VDD_M145_noxref_d ) capacitor c=0.0673824f \
 //x=73.34 //y=5.56 //x2=73.635 //y2=5.2
cc_6019 ( N_noxref_14_c_8172_p N_VDD_M146_noxref_s ) capacitor c=0.00536022f \
 //x=73.34 //y=5.56 //x2=75.515 //y2=5.2
cc_6020 ( N_noxref_14_c_8120_p N_VDD_M146_noxref_s ) capacitor c=0.00211796f \
 //x=74.035 //y=5.335 //x2=75.515 //y2=5.2
cc_6021 ( N_noxref_14_c_8174_p N_VDD_M146_noxref_s ) capacitor c=0.00222454f \
 //x=75.97 //y=4.445 //x2=75.515 //y2=5.2
cc_6022 ( N_noxref_14_c_8053_p N_VDD_M146_noxref_s ) capacitor c=0.00535656f \
 //x=75.8 //y=4.285 //x2=75.515 //y2=5.2
cc_6023 ( N_noxref_14_M146_noxref_g N_VDD_M146_noxref_s ) capacitor \
 c=0.0567929f //x=75.87 //y=6.2 //x2=75.515 //y2=5.2
cc_6024 ( N_noxref_14_M147_noxref_g N_VDD_M147_noxref_d ) capacitor \
 c=0.015318f //x=76.31 //y=6.2 //x2=76.385 //y2=5.2
cc_6025 ( N_noxref_14_M148_noxref_g N_VDD_M147_noxref_d ) capacitor \
 c=0.015318f //x=76.75 //y=6.2 //x2=76.385 //y2=5.2
cc_6026 ( N_noxref_14_c_8141_p N_VDD_M147_noxref_d ) capacitor c=3.50465e-19 \
 //x=76.74 //y=4.88 //x2=76.385 //y2=5.2
cc_6027 ( N_noxref_14_M149_noxref_g N_VDD_M149_noxref_d ) capacitor \
 c=0.0430452f //x=77.19 //y=6.2 //x2=77.265 //y2=5.2
cc_6028 ( N_noxref_14_c_7880_n N_noxref_30_c_13549_n ) capacitor c=0.0036878f \
 //x=68.825 //y=1.305 //x2=69.225 //y2=0.72
cc_6029 ( N_noxref_14_c_7893_n N_noxref_30_c_13549_n ) capacitor c=0.00399931f \
 //x=69.225 //y=1.845 //x2=69.225 //y2=0.72
cc_6030 ( N_noxref_14_M42_noxref_d N_noxref_30_c_13549_n ) capacitor \
 c=0.00910163f //x=68.635 //y=1.095 //x2=69.225 //y2=0.72
cc_6031 ( N_noxref_14_M42_noxref_d N_noxref_30_c_13554_n ) capacitor \
 c=0.00120711f //x=68.635 //y=1.095 //x2=68.34 //y2=1.175
cc_6032 ( N_noxref_14_c_7751_n N_noxref_30_M41_noxref_d ) capacitor \
 c=0.00143783f //x=67.53 //y=5.335 //x2=67.1 //y2=1.09
cc_6033 ( N_noxref_14_c_7880_n N_noxref_30_M41_noxref_d ) capacitor \
 c=0.00802417f //x=68.825 //y=1.305 //x2=67.1 //y2=1.09
cc_6034 ( N_noxref_14_c_7880_n N_noxref_30_M42_noxref_s ) capacitor \
 c=0.0098487f //x=68.825 //y=1.305 //x2=68.205 //y2=0.555
cc_6035 ( N_noxref_14_c_7888_n N_noxref_30_M42_noxref_s ) capacitor \
 c=0.0283111f //x=68.825 //y=1.76 //x2=68.205 //y2=0.555
cc_6036 ( N_noxref_14_c_7893_n N_noxref_30_M42_noxref_s ) capacitor \
 c=0.00942148f //x=69.225 //y=1.845 //x2=68.205 //y2=0.555
cc_6037 ( N_noxref_14_c_7922_n N_noxref_30_M42_noxref_s ) capacitor \
 c=0.00108527f //x=69.31 //y=4.25 //x2=68.205 //y2=0.555
cc_6038 ( N_noxref_14_M42_noxref_d N_noxref_30_M42_noxref_s ) capacitor \
 c=0.0279003f //x=68.635 //y=1.095 //x2=68.205 //y2=0.555
cc_6039 ( N_noxref_14_c_8107_p N_noxref_31_c_13617_n ) capacitor c=0.0036878f \
 //x=73.635 //y=1.305 //x2=74.035 //y2=0.72
cc_6040 ( N_noxref_14_c_8151_p N_noxref_31_c_13617_n ) capacitor c=0.00399931f \
 //x=74.035 //y=1.845 //x2=74.035 //y2=0.72
cc_6041 ( N_noxref_14_M45_noxref_d N_noxref_31_c_13617_n ) capacitor \
 c=0.00910163f //x=73.445 //y=1.095 //x2=74.035 //y2=0.72
cc_6042 ( N_noxref_14_M45_noxref_d N_noxref_31_c_13620_n ) capacitor \
 c=0.00120711f //x=73.445 //y=1.095 //x2=73.15 //y2=1.175
cc_6043 ( N_noxref_14_c_7880_n N_noxref_31_M44_noxref_d ) capacitor \
 c=3.20746e-19 //x=68.825 //y=1.305 //x2=71.91 //y2=1.09
cc_6044 ( N_noxref_14_c_7826_n N_noxref_31_M44_noxref_d ) capacitor \
 c=0.00114684f //x=72.34 //y=5.335 //x2=71.91 //y2=1.09
cc_6045 ( N_noxref_14_c_8107_p N_noxref_31_M44_noxref_d ) capacitor \
 c=0.00802836f //x=73.635 //y=1.305 //x2=71.91 //y2=1.09
cc_6046 ( N_noxref_14_c_8107_p N_noxref_31_M45_noxref_s ) capacitor \
 c=0.00993092f //x=73.635 //y=1.305 //x2=73.015 //y2=0.555
cc_6047 ( N_noxref_14_c_8142_p N_noxref_31_M45_noxref_s ) capacitor \
 c=0.0270624f //x=73.635 //y=1.76 //x2=73.015 //y2=0.555
cc_6048 ( N_noxref_14_c_8151_p N_noxref_31_M45_noxref_s ) capacitor \
 c=0.00942148f //x=74.035 //y=1.845 //x2=73.015 //y2=0.555
cc_6049 ( N_noxref_14_c_8130_p N_noxref_31_M45_noxref_s ) capacitor \
 c=0.00108527f //x=74.12 //y=4.25 //x2=73.015 //y2=0.555
cc_6050 ( N_noxref_14_M45_noxref_d N_noxref_31_M45_noxref_s ) capacitor \
 c=0.0279003f //x=73.445 //y=1.095 //x2=73.015 //y2=0.555
cc_6051 ( N_noxref_14_c_7793_n N_GND_c_14567_n ) capacitor c=3.92414e-19 \
 //x=53.1 //y=1.055 //x2=53.365 //y2=1.015
cc_6052 ( N_noxref_14_c_8429_p N_GND_c_14567_n ) capacitor c=0.0085115f \
 //x=53.475 //y=0.9 //x2=53.365 //y2=1.015
cc_6053 ( N_noxref_14_c_7799_n N_GND_c_14567_n ) capacitor c=4.45447e-19 \
 //x=53.63 //y=1.055 //x2=53.365 //y2=1.015
cc_6054 ( N_noxref_14_c_7917_n N_GND_c_14511_n ) capacitor c=0.00210951f \
 //x=63.76 //y=2.26 //x2=66.23 //y2=0.175
cc_6055 ( N_noxref_14_c_7880_n N_GND_c_14417_n ) capacitor c=0.00883621f \
 //x=68.825 //y=1.305 //x2=71.04 //y2=0.175
cc_6056 ( N_noxref_14_c_7893_n N_GND_c_14417_n ) capacitor c=0.00662992f \
 //x=69.225 //y=1.845 //x2=71.04 //y2=0.175
cc_6057 ( N_noxref_14_M42_noxref_d N_GND_c_14417_n ) capacitor c=2.9462e-19 \
 //x=68.635 //y=1.095 //x2=71.04 //y2=0.175
cc_6058 ( N_noxref_14_c_8107_p N_GND_c_14516_n ) capacitor c=0.00901861f \
 //x=73.635 //y=1.305 //x2=75.955 //y2=0.175
cc_6059 ( N_noxref_14_c_8151_p N_GND_c_14516_n ) capacitor c=0.00713708f \
 //x=74.035 //y=1.845 //x2=75.955 //y2=0.175
cc_6060 ( N_noxref_14_c_8127_p N_GND_c_14516_n ) capacitor c=4.56244e-19 \
 //x=74.12 //y=4.45 //x2=75.955 //y2=0.175
cc_6061 ( N_noxref_14_M45_noxref_d N_GND_c_14516_n ) capacitor c=2.9462e-19 \
 //x=73.445 //y=1.095 //x2=75.955 //y2=0.175
cc_6062 ( N_noxref_14_c_8134_p N_GND_c_14578_n ) capacitor c=2.49015e-19 \
 //x=76.71 //y=4.415 //x2=79.285 //y2=0.175
cc_6063 ( N_noxref_14_c_8113_p N_GND_c_14578_n ) capacitor c=0.00234561f \
 //x=76.71 //y=2.26 //x2=79.285 //y2=0.175
cc_6064 ( N_noxref_14_c_7733_n N_GND_c_14529_n ) capacitor c=0.00772482f \
 //x=53.4 //y=2.375 //x2=53.365 //y2=1.145
cc_6065 ( N_noxref_14_c_7738_n N_GND_c_14529_n ) capacitor c=5.20125e-19 \
 //x=53.4 //y=4.42 //x2=53.365 //y2=1.145
cc_6066 ( N_noxref_14_c_7779_n N_GND_c_14529_n ) capacitor c=2.22883e-19 \
 //x=53.4 //y=2.26 //x2=53.365 //y2=1.145
cc_6067 ( N_noxref_14_c_7793_n N_GND_c_14529_n ) capacitor c=0.0015128f \
 //x=53.1 //y=1.055 //x2=53.365 //y2=1.145
cc_6068 ( N_noxref_14_c_7794_n N_GND_c_14529_n ) capacitor c=0.00350108f \
 //x=53.1 //y=1.4 //x2=53.365 //y2=1.145
cc_6069 ( N_noxref_14_c_7795_n N_GND_c_14529_n ) capacitor c=4.60246e-19 \
 //x=53.1 //y=1.71 //x2=53.365 //y2=1.145
cc_6070 ( N_noxref_14_c_8429_p N_GND_c_14529_n ) capacitor c=9.36995e-19 \
 //x=53.475 //y=0.9 //x2=53.365 //y2=1.145
cc_6071 ( N_noxref_14_c_8448_p N_GND_c_14529_n ) capacitor c=6.09813e-19 \
 //x=53.475 //y=1.555 //x2=53.365 //y2=1.145
cc_6072 ( N_noxref_14_c_7799_n N_GND_c_14529_n ) capacitor c=0.0017438f \
 //x=53.63 //y=1.055 //x2=53.365 //y2=1.145
cc_6073 ( N_noxref_14_c_7801_n N_GND_c_14529_n ) capacitor c=0.00276804f \
 //x=53.63 //y=1.4 //x2=53.365 //y2=1.145
cc_6074 ( N_noxref_14_c_7880_n N_GND_c_14439_n ) capacitor c=0.00543195f \
 //x=68.825 //y=1.305 //x2=71.125 //y2=1.145
cc_6075 ( N_noxref_14_c_8107_p N_GND_c_14591_n ) capacitor c=0.00488628f \
 //x=73.635 //y=1.305 //x2=76.04 //y2=1.135
cc_6076 ( N_noxref_14_c_8112_p N_GND_c_14591_n ) capacitor c=0.00682264f \
 //x=75.97 //y=2.26 //x2=76.04 //y2=1.135
cc_6077 ( N_noxref_14_c_8454_p N_GND_c_14591_n ) capacitor c=2.13705e-19 \
 //x=75.97 //y=2.26 //x2=76.04 //y2=1.135
cc_6078 ( N_noxref_14_c_8455_p N_GND_c_14591_n ) capacitor c=0.00176535f \
 //x=75.775 //y=1.045 //x2=76.04 //y2=1.135
cc_6079 ( N_noxref_14_c_8456_p N_GND_c_14591_n ) capacitor c=0.0036005f \
 //x=75.775 //y=1.39 //x2=76.04 //y2=1.135
cc_6080 ( N_noxref_14_c_8457_p N_GND_c_14591_n ) capacitor c=4.2764e-19 \
 //x=75.775 //y=1.7 //x2=76.04 //y2=1.135
cc_6081 ( N_noxref_14_c_8458_p N_GND_c_14591_n ) capacitor c=9.36995e-19 \
 //x=76.15 //y=0.89 //x2=76.04 //y2=1.135
cc_6082 ( N_noxref_14_c_8459_p N_GND_c_14591_n ) capacitor c=6.38426e-19 \
 //x=76.15 //y=1.545 //x2=76.04 //y2=1.135
cc_6083 ( N_noxref_14_c_8460_p N_GND_c_14591_n ) capacitor c=0.00171784f \
 //x=76.305 //y=1.045 //x2=76.04 //y2=1.135
cc_6084 ( N_noxref_14_c_8461_p N_GND_c_14591_n ) capacitor c=0.00296337f \
 //x=76.305 //y=1.39 //x2=76.04 //y2=1.135
cc_6085 ( N_noxref_14_c_8455_p N_GND_c_14601_n ) capacitor c=3.51399e-19 \
 //x=75.775 //y=1.045 //x2=76.037 //y2=1.005
cc_6086 ( N_noxref_14_c_8458_p N_GND_c_14601_n ) capacitor c=0.00852202f \
 //x=76.15 //y=0.89 //x2=76.037 //y2=1.005
cc_6087 ( N_noxref_14_c_8460_p N_GND_c_14601_n ) capacitor c=4.40641e-19 \
 //x=76.305 //y=1.045 //x2=76.037 //y2=1.005
cc_6088 ( N_noxref_14_c_7793_n N_GND_c_14449_n ) capacitor c=0.00677766f \
 //x=53.1 //y=1.055 //x2=56.93 //y2=0.175
cc_6089 ( N_noxref_14_c_7917_n N_GND_c_14605_n ) capacitor c=3.77328e-19 \
 //x=63.76 //y=2.26 //x2=65.07 //y2=0.175
cc_6090 ( N_noxref_14_c_7893_n N_GND_c_14606_n ) capacitor c=6.86343e-19 \
 //x=69.225 //y=1.845 //x2=69.88 //y2=0.175
cc_6091 ( N_noxref_14_c_8151_p N_GND_c_14451_n ) capacitor c=6.86343e-19 \
 //x=74.035 //y=1.845 //x2=74.69 //y2=0.175
cc_6092 ( N_noxref_14_c_8113_p N_GND_c_14608_n ) capacitor c=3.77328e-19 \
 //x=76.71 //y=2.26 //x2=78.02 //y2=0.175
cc_6093 ( N_noxref_14_c_8455_p N_GND_c_14608_n ) capacitor c=0.00688027f \
 //x=75.775 //y=1.045 //x2=78.02 //y2=0.175
cc_6094 ( N_noxref_14_c_7733_n N_GND_c_14376_n ) capacitor c=0.00343139f \
 //x=53.4 //y=2.375 //x2=52.29 //y2=0.175
cc_6095 ( N_noxref_14_c_7727_n N_GND_c_14376_n ) capacitor c=0.00881103f \
 //x=53.4 //y=4.1 //x2=52.29 //y2=0.175
cc_6096 ( N_noxref_14_c_7779_n N_GND_c_14376_n ) capacitor c=0.00396211f \
 //x=53.4 //y=2.26 //x2=52.29 //y2=0.175
cc_6097 ( N_noxref_14_c_7795_n N_GND_c_14376_n ) capacitor c=0.00170145f \
 //x=53.1 //y=1.71 //x2=52.29 //y2=0.175
cc_6098 ( N_noxref_14_c_7796_n N_GND_c_14376_n ) capacitor c=0.0102191f \
 //x=53.1 //y=2.095 //x2=52.29 //y2=0.175
cc_6099 ( N_noxref_14_c_7968_p N_GND_c_14562_n ) capacitor c=0.00200922f \
 //x=63.76 //y=2.26 //x2=65.24 //y2=0.175
cc_6100 ( N_noxref_14_c_7978_p N_GND_c_14562_n ) capacitor c=0.00275184f \
 //x=64.325 //y=1.43 //x2=65.24 //y2=0.175
cc_6101 ( N_noxref_14_c_7944_n N_GND_c_14562_n ) capacitor c=2.63786e-19 \
 //x=63.76 //y=2.26 //x2=65.24 //y2=0.175
cc_6102 ( N_noxref_14_c_7888_n N_GND_c_14459_n ) capacitor c=0.0045138f \
 //x=68.825 //y=1.76 //x2=70.05 //y2=0.175
cc_6103 ( N_noxref_14_c_7893_n N_GND_c_14459_n ) capacitor c=0.0337719f \
 //x=69.225 //y=1.845 //x2=70.05 //y2=0.175
cc_6104 ( N_noxref_14_c_8142_p N_GND_c_14620_n ) capacitor c=0.00285697f \
 //x=73.635 //y=1.76 //x2=74.86 //y2=0.175
cc_6105 ( N_noxref_14_c_8151_p N_GND_c_14620_n ) capacitor c=0.0337353f \
 //x=74.035 //y=1.845 //x2=74.86 //y2=0.175
cc_6106 ( N_noxref_14_c_8050_p N_GND_c_14620_n ) capacitor c=0.00829739f \
 //x=75.97 //y=4.125 //x2=74.86 //y2=0.175
cc_6107 ( N_noxref_14_c_8112_p N_GND_c_14620_n ) capacitor c=0.00427323f \
 //x=75.97 //y=2.26 //x2=74.86 //y2=0.175
cc_6108 ( N_noxref_14_c_8454_p N_GND_c_14620_n ) capacitor c=0.00369427f \
 //x=75.97 //y=2.26 //x2=74.86 //y2=0.175
cc_6109 ( N_noxref_14_c_8457_p N_GND_c_14620_n ) capacitor c=0.0015404f \
 //x=75.775 //y=1.7 //x2=74.86 //y2=0.175
cc_6110 ( N_noxref_14_c_8487_p N_GND_c_14620_n ) capacitor c=0.0095324f \
 //x=75.775 //y=2.095 //x2=74.86 //y2=0.175
cc_6111 ( N_noxref_14_c_8156_p N_GND_c_14627_n ) capacitor c=0.00231028f \
 //x=76.71 //y=2.26 //x2=78.19 //y2=0.175
cc_6112 ( N_noxref_14_c_8146_p N_GND_c_14627_n ) capacitor c=0.00275184f \
 //x=77.275 //y=1.43 //x2=78.19 //y2=0.175
cc_6113 ( N_noxref_14_c_7733_n N_GND_M32_noxref_d ) capacitor c=4.4417e-19 \
 //x=53.4 //y=2.375 //x2=53.175 //y2=1.055
cc_6114 ( N_noxref_14_c_7793_n N_GND_M32_noxref_d ) capacitor c=0.00184354f \
 //x=53.1 //y=1.055 //x2=53.175 //y2=1.055
cc_6115 ( N_noxref_14_c_7794_n N_GND_M32_noxref_d ) capacitor c=0.00210798f \
 //x=53.1 //y=1.4 //x2=53.175 //y2=1.055
cc_6116 ( N_noxref_14_c_8429_p N_GND_M32_noxref_d ) capacitor c=0.00474029f \
 //x=53.475 //y=0.9 //x2=53.175 //y2=1.055
cc_6117 ( N_noxref_14_c_8448_p N_GND_M32_noxref_d ) capacitor c=0.00166857f \
 //x=53.475 //y=1.555 //x2=53.175 //y2=1.055
cc_6118 ( N_noxref_14_c_7799_n N_GND_M32_noxref_d ) capacitor c=0.00230174f \
 //x=53.63 //y=1.055 //x2=53.175 //y2=1.055
cc_6119 ( N_noxref_14_c_7801_n N_GND_M32_noxref_d ) capacitor c=0.00210798f \
 //x=53.63 //y=1.4 //x2=53.175 //y2=1.055
cc_6120 ( N_noxref_14_c_8112_p N_GND_M46_noxref_d ) capacitor c=2.20438e-19 \
 //x=75.97 //y=2.26 //x2=75.85 //y2=1.045
cc_6121 ( N_noxref_14_c_8455_p N_GND_M46_noxref_d ) capacitor c=0.00192399f \
 //x=75.775 //y=1.045 //x2=75.85 //y2=1.045
cc_6122 ( N_noxref_14_c_8456_p N_GND_M46_noxref_d ) capacitor c=0.00210798f \
 //x=75.775 //y=1.39 //x2=75.85 //y2=1.045
cc_6123 ( N_noxref_14_c_8458_p N_GND_M46_noxref_d ) capacitor c=0.00472259f \
 //x=76.15 //y=0.89 //x2=75.85 //y2=1.045
cc_6124 ( N_noxref_14_c_8459_p N_GND_M46_noxref_d ) capacitor c=0.00166857f \
 //x=76.15 //y=1.545 //x2=75.85 //y2=1.045
cc_6125 ( N_noxref_14_c_8460_p N_GND_M46_noxref_d ) capacitor c=0.00230174f \
 //x=76.305 //y=1.045 //x2=75.85 //y2=1.045
cc_6126 ( N_noxref_14_c_8461_p N_GND_M46_noxref_d ) capacitor c=0.00210798f \
 //x=76.305 //y=1.39 //x2=75.85 //y2=1.045
cc_6127 ( N_noxref_14_c_7796_n N_noxref_47_c_16277_n ) capacitor c=0.00262672f \
 //x=53.1 //y=2.095 //x2=52.88 //y2=1.685
cc_6128 ( N_noxref_14_c_7733_n N_noxref_47_c_16278_n ) capacitor c=0.00428451f \
 //x=53.4 //y=2.375 //x2=53.765 //y2=1.77
cc_6129 ( N_noxref_14_c_7738_n N_noxref_47_c_16278_n ) capacitor c=0.00110122f \
 //x=53.4 //y=4.42 //x2=53.765 //y2=1.77
cc_6130 ( N_noxref_14_c_7779_n N_noxref_47_c_16278_n ) capacitor c=0.0104666f \
 //x=53.4 //y=2.26 //x2=53.765 //y2=1.77
cc_6131 ( N_noxref_14_c_7795_n N_noxref_47_c_16278_n ) capacitor c=0.00705077f \
 //x=53.1 //y=1.71 //x2=53.765 //y2=1.77
cc_6132 ( N_noxref_14_c_7796_n N_noxref_47_c_16278_n ) capacitor c=0.020708f \
 //x=53.1 //y=2.095 //x2=53.765 //y2=1.77
cc_6133 ( N_noxref_14_c_8448_p N_noxref_47_c_16278_n ) capacitor c=0.00588627f \
 //x=53.475 //y=1.555 //x2=53.765 //y2=1.77
cc_6134 ( N_noxref_14_c_7801_n N_noxref_47_c_16278_n ) capacitor c=0.00698822f \
 //x=53.63 //y=1.4 //x2=53.765 //y2=1.77
cc_6135 ( N_noxref_14_c_7793_n N_noxref_47_M32_noxref_s ) capacitor \
 c=0.0295256f //x=53.1 //y=1.055 //x2=52.745 //y2=0.555
cc_6136 ( N_noxref_14_c_7795_n N_noxref_47_M32_noxref_s ) capacitor \
 c=7.99997e-19 //x=53.1 //y=1.71 //x2=52.745 //y2=0.555
cc_6137 ( N_noxref_14_c_7796_n N_noxref_47_M32_noxref_s ) capacitor \
 c=0.00122123f //x=53.1 //y=2.095 //x2=52.745 //y2=0.555
cc_6138 ( N_noxref_14_c_7799_n N_noxref_47_M32_noxref_s ) capacitor \
 c=0.0125924f //x=53.63 //y=1.055 //x2=52.745 //y2=0.555
cc_6139 ( N_noxref_14_c_7747_n N_noxref_49_c_16387_n ) capacitor c=9.49001e-19 \
 //x=63.76 //y=4.41 //x2=63.575 //y2=1.675
cc_6140 ( N_noxref_14_c_7917_n N_noxref_49_c_16387_n ) capacitor c=7.50092e-19 \
 //x=63.76 //y=2.26 //x2=63.575 //y2=1.675
cc_6141 ( N_noxref_14_c_7976_p N_noxref_49_c_16387_n ) capacitor c=0.00888238f \
 //x=63.795 //y=1.74 //x2=63.575 //y2=1.675
cc_6142 ( N_noxref_14_c_7944_n N_noxref_49_c_16387_n ) capacitor c=0.00175171f \
 //x=63.76 //y=2.26 //x2=63.575 //y2=1.675
cc_6143 ( N_noxref_14_c_7917_n N_noxref_49_c_16388_n ) capacitor c=0.001463f \
 //x=63.76 //y=2.26 //x2=64.46 //y2=0.71
cc_6144 ( N_noxref_14_c_7968_p N_noxref_49_c_16388_n ) capacitor c=8.82141e-19 \
 //x=63.76 //y=2.26 //x2=64.46 //y2=0.71
cc_6145 ( N_noxref_14_c_8023_p N_noxref_49_c_16388_n ) capacitor c=0.0200738f \
 //x=63.795 //y=1.085 //x2=64.46 //y2=0.71
cc_6146 ( N_noxref_14_c_8027_p N_noxref_49_c_16388_n ) capacitor c=0.00825432f \
 //x=64.325 //y=1.085 //x2=64.46 //y2=0.71
cc_6147 ( N_noxref_14_c_7944_n N_noxref_49_c_16388_n ) capacitor c=2.1838e-19 \
 //x=63.76 //y=2.26 //x2=64.46 //y2=0.71
cc_6148 ( N_noxref_14_c_8023_p N_noxref_49_M38_noxref_s ) capacitor \
 c=0.00888238f //x=63.795 //y=1.085 //x2=62.47 //y2=0.545
cc_6149 ( N_noxref_14_c_8027_p N_noxref_49_M38_noxref_s ) capacitor \
 c=0.015333f //x=64.325 //y=1.085 //x2=62.47 //y2=0.545
cc_6150 ( N_noxref_14_c_7978_p N_noxref_49_M38_noxref_s ) capacitor \
 c=0.00248746f //x=64.325 //y=1.43 //x2=62.47 //y2=0.545
cc_6151 ( N_noxref_14_c_8487_p N_noxref_52_c_16568_n ) capacitor c=0.00262672f \
 //x=75.775 //y=2.095 //x2=75.555 //y2=1.675
cc_6152 ( N_noxref_14_c_8174_p N_noxref_52_c_16569_n ) capacitor c=0.0032443f \
 //x=75.97 //y=4.445 //x2=76.44 //y2=1.76
cc_6153 ( N_noxref_14_c_8112_p N_noxref_52_c_16569_n ) capacitor c=0.00509504f \
 //x=75.97 //y=2.26 //x2=76.44 //y2=1.76
cc_6154 ( N_noxref_14_c_8454_p N_noxref_52_c_16569_n ) capacitor c=0.00763108f \
 //x=75.97 //y=2.26 //x2=76.44 //y2=1.76
cc_6155 ( N_noxref_14_c_8457_p N_noxref_52_c_16569_n ) capacitor c=0.00697076f \
 //x=75.775 //y=1.7 //x2=76.44 //y2=1.76
cc_6156 ( N_noxref_14_c_8487_p N_noxref_52_c_16569_n ) capacitor c=0.0179373f \
 //x=75.775 //y=2.095 //x2=76.44 //y2=1.76
cc_6157 ( N_noxref_14_c_8459_p N_noxref_52_c_16569_n ) capacitor c=0.00723574f \
 //x=76.15 //y=1.545 //x2=76.44 //y2=1.76
cc_6158 ( N_noxref_14_c_8461_p N_noxref_52_c_16569_n ) capacitor c=0.00339872f \
 //x=76.305 //y=1.39 //x2=76.44 //y2=1.76
cc_6159 ( N_noxref_14_c_8134_p N_noxref_52_c_16576_n ) capacitor c=9.6454e-19 \
 //x=76.71 //y=4.415 //x2=76.525 //y2=1.675
cc_6160 ( N_noxref_14_c_8113_p N_noxref_52_c_16576_n ) capacitor c=7.50092e-19 \
 //x=76.71 //y=2.26 //x2=76.525 //y2=1.675
cc_6161 ( N_noxref_14_c_8487_p N_noxref_52_c_16576_n ) capacitor c=6.71402e-19 \
 //x=75.775 //y=2.095 //x2=76.525 //y2=1.675
cc_6162 ( N_noxref_14_c_8144_p N_noxref_52_c_16576_n ) capacitor c=0.00888238f \
 //x=76.745 //y=1.74 //x2=76.525 //y2=1.675
cc_6163 ( N_noxref_14_c_8157_p N_noxref_52_c_16576_n ) capacitor c=0.00175171f \
 //x=76.71 //y=2.26 //x2=76.525 //y2=1.675
cc_6164 ( N_noxref_14_c_8113_p N_noxref_52_c_16581_n ) capacitor c=0.001463f \
 //x=76.71 //y=2.26 //x2=77.41 //y2=0.71
cc_6165 ( N_noxref_14_c_8156_p N_noxref_52_c_16581_n ) capacitor c=8.82141e-19 \
 //x=76.71 //y=2.26 //x2=77.41 //y2=0.71
cc_6166 ( N_noxref_14_c_8186_p N_noxref_52_c_16581_n ) capacitor c=0.0200738f \
 //x=76.745 //y=1.085 //x2=77.41 //y2=0.71
cc_6167 ( N_noxref_14_c_8190_p N_noxref_52_c_16581_n ) capacitor c=0.00825432f \
 //x=77.275 //y=1.085 //x2=77.41 //y2=0.71
cc_6168 ( N_noxref_14_c_8157_p N_noxref_52_c_16581_n ) capacitor c=2.1838e-19 \
 //x=76.71 //y=2.26 //x2=77.41 //y2=0.71
cc_6169 ( N_noxref_14_c_8455_p N_noxref_52_M46_noxref_s ) capacitor \
 c=0.0295366f //x=75.775 //y=1.045 //x2=75.42 //y2=0.545
cc_6170 ( N_noxref_14_c_8457_p N_noxref_52_M46_noxref_s ) capacitor \
 c=3.48408e-19 //x=75.775 //y=1.7 //x2=75.42 //y2=0.545
cc_6171 ( N_noxref_14_c_8460_p N_noxref_52_M46_noxref_s ) capacitor \
 c=0.0125442f //x=76.305 //y=1.045 //x2=75.42 //y2=0.545
cc_6172 ( N_noxref_14_c_8186_p N_noxref_52_M46_noxref_s ) capacitor \
 c=0.00888238f //x=76.745 //y=1.085 //x2=75.42 //y2=0.545
cc_6173 ( N_noxref_14_c_8190_p N_noxref_52_M46_noxref_s ) capacitor \
 c=0.015333f //x=77.275 //y=1.085 //x2=75.42 //y2=0.545
cc_6174 ( N_noxref_14_c_8146_p N_noxref_52_M46_noxref_s ) capacitor \
 c=0.00248746f //x=77.275 //y=1.43 //x2=75.42 //y2=0.545
cc_6175 ( N_noxref_15_c_9216_p N_noxref_16_c_10242_n ) capacitor c=0.0033801f \
 //x=82.63 //y=2.385 //x2=84.11 //y2=2.43
cc_6176 ( N_noxref_15_c_9217_p N_noxref_16_c_10242_n ) capacitor c=5.52227e-19 \
 //x=82.63 //y=4.475 //x2=84.11 //y2=2.43
cc_6177 ( N_noxref_15_c_9218_p N_noxref_16_c_10242_n ) capacitor c=5.86738e-19 \
 //x=82.63 //y=2.26 //x2=84.11 //y2=2.43
cc_6178 ( N_noxref_15_c_9217_p N_noxref_16_c_10245_n ) capacitor c=0.0116084f \
 //x=82.63 //y=4.475 //x2=84.11 //y2=2.97
cc_6179 ( N_noxref_15_c_9217_p N_noxref_16_c_10246_n ) capacitor c=0.00406045f \
 //x=82.63 //y=4.475 //x2=84.11 //y2=3.29
cc_6180 ( N_noxref_15_c_9217_p N_noxref_16_c_10247_n ) capacitor c=0.0256184f \
 //x=82.63 //y=4.475 //x2=84.11 //y2=4.76
cc_6181 ( N_noxref_15_c_9222_p N_noxref_16_c_10247_n ) capacitor c=0.0047666f \
 //x=82.63 //y=4.62 //x2=84.11 //y2=4.76
cc_6182 ( N_noxref_15_c_9223_p N_noxref_16_c_10247_n ) capacitor c=0.00487887f \
 //x=82.635 //y=4.64 //x2=84.11 //y2=4.76
cc_6183 ( N_noxref_15_c_9224_p N_noxref_16_c_10247_n ) capacitor c=0.00414268f \
 //x=82.63 //y=4.62 //x2=84.11 //y2=4.76
cc_6184 ( N_noxref_15_c_9225_p N_noxref_16_c_10247_n ) capacitor c=5.58186e-19 \
 //x=82.63 //y=4.885 //x2=84.11 //y2=4.76
cc_6185 ( N_noxref_15_c_9217_p N_noxref_16_c_10252_n ) capacitor c=0.00235671f \
 //x=82.63 //y=4.475 //x2=85.59 //y2=4.755
cc_6186 ( N_noxref_15_c_9217_p N_noxref_16_c_10253_n ) capacitor c=0.00263481f \
 //x=82.63 //y=4.475 //x2=84.11 //y2=3.14
cc_6187 ( N_noxref_15_c_8552_n N_noxref_16_c_10055_n ) capacitor c=0.0214911f \
 //x=47.48 //y=3.365 //x2=55.235 //y2=3.14
cc_6188 ( N_noxref_15_c_8557_n N_noxref_16_c_10055_n ) capacitor c=0.00586161f \
 //x=47.48 //y=3.685 //x2=55.235 //y2=3.14
cc_6189 ( N_noxref_15_c_8574_n N_noxref_16_c_10055_n ) capacitor c=0.0227679f \
 //x=51.55 //y=3.37 //x2=55.235 //y2=3.14
cc_6190 ( N_noxref_15_c_8661_n N_noxref_16_c_10055_n ) capacitor c=0.00634309f \
 //x=51.55 //y=3.69 //x2=55.235 //y2=3.14
cc_6191 ( N_noxref_15_c_8698_n N_noxref_16_c_10055_n ) capacitor c=3.78085e-19 \
 //x=55.62 //y=3.35 //x2=55.235 //y2=3.14
cc_6192 ( N_noxref_15_c_8588_n N_noxref_16_c_10055_n ) capacitor c=0.082153f \
 //x=47.835 //y=3.51 //x2=55.235 //y2=3.14
cc_6193 ( N_noxref_15_c_8589_n N_noxref_16_c_10055_n ) capacitor c=0.110124f \
 //x=48.435 //y=3.48 //x2=55.235 //y2=3.14
cc_6194 ( N_noxref_15_c_8593_n N_noxref_16_c_10055_n ) capacitor c=0.0582213f \
 //x=49.67 //y=3.51 //x2=55.235 //y2=3.14
cc_6195 ( N_noxref_15_c_8718_n N_noxref_16_c_10055_n ) capacitor c=0.32788f \
 //x=55.46 //y=3.51 //x2=55.235 //y2=3.14
cc_6196 ( N_noxref_15_c_8599_n N_noxref_16_c_10055_n ) capacitor c=0.122206f \
 //x=51.71 //y=3.51 //x2=55.235 //y2=3.14
cc_6197 ( N_noxref_15_c_8600_n N_noxref_16_c_10055_n ) capacitor c=0.0358686f \
 //x=47.64 //y=3.525 //x2=55.235 //y2=3.14
cc_6198 ( N_noxref_15_c_8698_n N_noxref_16_c_10102_n ) capacitor c=0.0216243f \
 //x=55.62 //y=3.35 //x2=55.835 //y2=3.125
cc_6199 ( N_noxref_15_c_8743_n N_noxref_16_c_10102_n ) capacitor c=0.00582255f \
 //x=55.62 //y=3.67 //x2=55.835 //y2=3.125
cc_6200 ( N_noxref_15_c_8721_n N_noxref_16_c_10102_n ) capacitor c=0.0874547f \
 //x=56.15 //y=3.5 //x2=55.835 //y2=3.125
cc_6201 ( N_noxref_15_c_8720_n N_noxref_16_c_10103_n ) capacitor c=0.139818f \
 //x=56.58 //y=3.5 //x2=58.935 //y2=3.14
cc_6202 ( N_noxref_15_c_8722_n N_noxref_16_c_10103_n ) capacitor c=0.056967f \
 //x=57.83 //y=3.51 //x2=58.935 //y2=3.14
cc_6203 ( N_noxref_15_c_8723_n N_noxref_16_c_10103_n ) capacitor c=0.100168f \
 //x=61.335 //y=3.51 //x2=58.935 //y2=3.14
cc_6204 ( N_noxref_15_c_8723_n N_noxref_16_c_10107_n ) capacitor c=0.106957f \
 //x=61.335 //y=3.51 //x2=59.535 //y2=3.155
cc_6205 ( N_noxref_15_c_8705_n N_noxref_16_c_10139_n ) capacitor c=3.14871e-19 \
 //x=61.17 //y=3.35 //x2=60.79 //y2=3.14
cc_6206 ( N_noxref_15_c_8723_n N_noxref_16_c_10139_n ) capacitor c=0.0116219f \
 //x=61.335 //y=3.51 //x2=60.79 //y2=3.14
cc_6207 ( N_noxref_15_c_8705_n N_noxref_16_c_10140_n ) capacitor c=0.02537f \
 //x=61.17 //y=3.35 //x2=61.39 //y2=3.125
cc_6208 ( N_noxref_15_c_8856_n N_noxref_16_c_10140_n ) capacitor c=0.00872737f \
 //x=61.17 //y=3.67 //x2=61.39 //y2=3.125
cc_6209 ( N_noxref_15_c_8889_n N_noxref_16_c_10140_n ) capacitor c=0.127185f \
 //x=62.86 //y=3.51 //x2=61.39 //y2=3.125
cc_6210 ( N_noxref_15_c_8723_n N_noxref_16_c_10140_n ) capacitor c=0.0358686f \
 //x=61.335 //y=3.51 //x2=61.39 //y2=3.125
cc_6211 ( N_noxref_15_c_8995_n N_noxref_16_c_10141_n ) capacitor c=5.02752e-19 \
 //x=63.02 //y=3.35 //x2=62.635 //y2=3.14
cc_6212 ( N_noxref_15_c_8860_n N_noxref_16_c_10141_n ) capacitor c=0.00241791f \
 //x=63.02 //y=3.67 //x2=62.635 //y2=3.14
cc_6213 ( N_noxref_15_c_8889_n N_noxref_16_c_10141_n ) capacitor c=0.0107308f \
 //x=62.86 //y=3.51 //x2=62.635 //y2=3.14
cc_6214 ( N_noxref_15_c_8995_n N_noxref_16_c_10142_n ) capacitor c=0.0251632f \
 //x=63.02 //y=3.35 //x2=63.235 //y2=3.125
cc_6215 ( N_noxref_15_c_8860_n N_noxref_16_c_10142_n ) capacitor c=0.00481227f \
 //x=63.02 //y=3.67 //x2=63.235 //y2=3.125
cc_6216 ( N_noxref_15_c_8893_n N_noxref_16_c_10142_n ) capacitor c=0.0358686f \
 //x=63.18 //y=3.51 //x2=63.235 //y2=3.125
cc_6217 ( N_noxref_15_c_8905_n N_noxref_16_c_10142_n ) capacitor c=0.0909793f \
 //x=64.34 //y=3.515 //x2=63.235 //y2=3.125
cc_6218 ( N_noxref_15_c_8751_n N_noxref_16_c_10143_n ) capacitor c=2.15578e-19 \
 //x=64.5 //y=3.355 //x2=64.115 //y2=3.14
cc_6219 ( N_noxref_15_c_8905_n N_noxref_16_c_10143_n ) capacitor c=0.011714f \
 //x=64.34 //y=3.515 //x2=64.115 //y2=3.14
cc_6220 ( N_noxref_15_c_8751_n N_noxref_16_c_10144_n ) capacitor c=0.0253976f \
 //x=64.5 //y=3.355 //x2=64.715 //y2=3.13
cc_6221 ( N_noxref_15_c_8862_n N_noxref_16_c_10144_n ) capacitor c=0.00811103f \
 //x=64.5 //y=3.675 //x2=64.715 //y2=3.13
cc_6222 ( N_noxref_15_c_8894_n N_noxref_16_c_10144_n ) capacitor c=0.12835f \
 //x=66.195 //y=3.51 //x2=64.715 //y2=3.13
cc_6223 ( N_noxref_15_c_8907_n N_noxref_16_c_10144_n ) capacitor c=0.0358686f \
 //x=64.66 //y=3.515 //x2=64.715 //y2=3.13
cc_6224 ( N_noxref_15_c_8757_n N_noxref_16_c_10145_n ) capacitor c=3.37936e-19 \
 //x=66.35 //y=3.355 //x2=65.97 //y2=3.14
cc_6225 ( N_noxref_15_c_8759_n N_noxref_16_c_10145_n ) capacitor c=0.00346018f \
 //x=66.35 //y=3.675 //x2=65.97 //y2=3.14
cc_6226 ( N_noxref_15_c_8894_n N_noxref_16_c_10145_n ) capacitor c=0.0108861f \
 //x=66.195 //y=3.51 //x2=65.97 //y2=3.14
cc_6227 ( N_noxref_15_c_8757_n N_noxref_16_c_10131_n ) capacitor c=0.0267096f \
 //x=66.35 //y=3.355 //x2=66.57 //y2=3.13
cc_6228 ( N_noxref_15_c_8759_n N_noxref_16_c_10131_n ) capacitor c=0.00505868f \
 //x=66.35 //y=3.675 //x2=66.57 //y2=3.13
cc_6229 ( N_noxref_15_c_8785_n N_noxref_16_c_10131_n ) capacitor c=0.4129f \
 //x=70.935 //y=3.495 //x2=66.57 //y2=3.13
cc_6230 ( N_noxref_15_c_9120_n N_noxref_16_c_10132_n ) capacitor c=4.21911e-19 \
 //x=78.93 //y=3.35 //x2=78.535 //y2=3.14
cc_6231 ( N_noxref_15_c_9272_p N_noxref_16_c_10132_n ) capacitor c=0.00302316f \
 //x=78.93 //y=3.67 //x2=78.535 //y2=3.14
cc_6232 ( N_noxref_15_c_8896_n N_noxref_16_c_10132_n ) capacitor c=0.142864f \
 //x=71.365 //y=3.495 //x2=78.535 //y2=3.14
cc_6233 ( N_noxref_15_c_8785_n N_noxref_16_c_10132_n ) capacitor c=0.0569996f \
 //x=70.935 //y=3.495 //x2=78.535 //y2=3.14
cc_6234 ( N_noxref_15_c_9023_n N_noxref_16_c_10132_n ) capacitor c=0.0611112f \
 //x=72.995 //y=3.51 //x2=78.535 //y2=3.14
cc_6235 ( N_noxref_15_c_9164_n N_noxref_16_c_10132_n ) capacitor c=0.458992f \
 //x=73.595 //y=3.48 //x2=78.535 //y2=3.14
cc_6236 ( N_noxref_15_c_9277_p N_noxref_16_c_10303_n ) capacitor c=0.00207822f \
 //x=78.93 //y=2.375 //x2=79.135 //y2=3.125
cc_6237 ( N_noxref_15_c_9120_n N_noxref_16_c_10303_n ) capacitor c=0.0283117f \
 //x=78.93 //y=3.35 //x2=79.135 //y2=3.125
cc_6238 ( N_noxref_15_c_9272_p N_noxref_16_c_10303_n ) capacitor c=0.0044718f \
 //x=78.93 //y=3.67 //x2=79.135 //y2=3.125
cc_6239 ( N_noxref_15_c_9216_p N_noxref_16_c_10303_n ) capacitor c=0.00270802f \
 //x=82.63 //y=2.385 //x2=79.135 //y2=3.125
cc_6240 ( N_noxref_15_c_9217_p N_noxref_16_c_10303_n ) capacitor c=0.0364061f \
 //x=82.63 //y=4.475 //x2=79.135 //y2=3.125
cc_6241 ( N_noxref_15_c_9164_n N_noxref_16_c_10303_n ) capacitor c=0.0365231f \
 //x=73.595 //y=3.48 //x2=79.135 //y2=3.125
cc_6242 ( N_noxref_15_c_9283_p N_noxref_16_c_10303_n ) capacitor c=0.0121723f \
 //x=82.475 //y=4.64 //x2=79.135 //y2=3.125
cc_6243 ( N_noxref_15_c_9216_p N_noxref_16_c_10310_n ) capacitor c=0.00564826f \
 //x=82.63 //y=2.385 //x2=84.275 //y2=2.27
cc_6244 ( N_noxref_15_c_9217_p N_noxref_16_c_10310_n ) capacitor c=8.70657e-19 \
 //x=82.63 //y=4.475 //x2=84.275 //y2=2.27
cc_6245 ( N_noxref_15_c_9216_p N_noxref_16_c_10312_n ) capacitor c=0.00362942f \
 //x=82.63 //y=2.385 //x2=84.11 //y2=2.26
cc_6246 ( N_noxref_15_c_9217_p N_noxref_16_c_10312_n ) capacitor c=3.10803e-19 \
 //x=82.63 //y=4.475 //x2=84.11 //y2=2.26
cc_6247 ( N_noxref_15_c_9218_p N_noxref_16_c_10312_n ) capacitor c=3.19688e-19 \
 //x=82.63 //y=2.26 //x2=84.11 //y2=2.26
cc_6248 ( N_noxref_15_c_9289_p N_noxref_16_c_10312_n ) capacitor c=2.35599e-19 \
 //x=82.435 //y=2.095 //x2=84.11 //y2=2.26
cc_6249 ( N_noxref_15_c_9222_p N_noxref_16_c_10316_n ) capacitor c=5.34267e-19 \
 //x=82.63 //y=4.62 //x2=84.11 //y2=4.885
cc_6250 ( N_noxref_15_c_9224_p N_noxref_16_c_10316_n ) capacitor c=8.5191e-19 \
 //x=82.63 //y=4.62 //x2=84.11 //y2=4.885
cc_6251 ( N_noxref_15_c_9225_p N_noxref_16_c_10316_n ) capacitor c=2.35599e-19 \
 //x=82.63 //y=4.885 //x2=84.11 //y2=4.885
cc_6252 ( N_noxref_15_M154_noxref_g N_noxref_16_M156_noxref_g ) capacitor \
 c=0.00948424f //x=82.52 //y=6.205 //x2=83.4 //y2=6.205
cc_6253 ( N_noxref_15_M155_noxref_g N_noxref_16_M156_noxref_g ) capacitor \
 c=0.0633522f //x=82.96 //y=6.205 //x2=83.4 //y2=6.205
cc_6254 ( N_noxref_15_M155_noxref_g N_noxref_16_M157_noxref_g ) capacitor \
 c=0.00899012f //x=82.96 //y=6.205 //x2=83.84 //y2=6.205
cc_6255 ( N_noxref_15_c_9296_p N_noxref_16_c_10322_n ) capacitor c=4.86545e-19 \
 //x=82.435 //y=1.045 //x2=83.405 //y2=1.085
cc_6256 ( N_noxref_15_c_9297_p N_noxref_16_c_10322_n ) capacitor c=0.00152104f \
 //x=82.435 //y=1.39 //x2=83.405 //y2=1.085
cc_6257 ( N_noxref_15_c_9298_p N_noxref_16_c_10322_n ) capacitor c=0.0159151f \
 //x=82.965 //y=1.045 //x2=83.405 //y2=1.085
cc_6258 ( N_noxref_15_c_9299_p N_noxref_16_c_10325_n ) capacitor c=0.00109982f \
 //x=82.435 //y=1.7 //x2=83.405 //y2=1.43
cc_6259 ( N_noxref_15_c_9300_p N_noxref_16_c_10325_n ) capacitor c=0.0158526f \
 //x=82.965 //y=1.39 //x2=83.405 //y2=1.43
cc_6260 ( N_noxref_15_c_9224_p N_noxref_16_c_10327_n ) capacitor c=0.00110488f \
 //x=82.63 //y=4.62 //x2=83.475 //y2=4.975
cc_6261 ( N_noxref_15_c_9225_p N_noxref_16_c_10327_n ) capacitor c=0.0640858f \
 //x=82.63 //y=4.885 //x2=83.475 //y2=4.975
cc_6262 ( N_noxref_15_c_9224_p N_noxref_16_c_10329_n ) capacitor c=2.35599e-19 \
 //x=82.63 //y=4.62 //x2=83.84 //y2=5.05
cc_6263 ( N_noxref_15_c_9225_p N_noxref_16_c_10329_n ) capacitor c=5.35364e-19 \
 //x=82.63 //y=4.885 //x2=83.84 //y2=5.05
cc_6264 ( N_noxref_15_c_9298_p N_noxref_16_c_10331_n ) capacitor c=0.00124821f \
 //x=82.965 //y=1.045 //x2=83.935 //y2=1.085
cc_6265 ( N_noxref_15_c_9300_p N_noxref_16_c_10332_n ) capacitor c=0.00150765f \
 //x=82.965 //y=1.39 //x2=83.935 //y2=1.43
cc_6266 ( N_noxref_15_c_9300_p N_noxref_16_c_10333_n ) capacitor c=4.38654e-19 \
 //x=82.965 //y=1.39 //x2=83.935 //y2=1.74
cc_6267 ( N_noxref_15_c_9218_p N_noxref_16_c_10334_n ) capacitor c=2.35599e-19 \
 //x=82.63 //y=2.26 //x2=83.935 //y2=2.095
cc_6268 ( N_noxref_15_c_9289_p N_noxref_16_c_10334_n ) capacitor c=4.61972e-19 \
 //x=82.435 //y=2.095 //x2=83.935 //y2=2.095
cc_6269 ( N_noxref_15_c_9023_n N_noxref_17_c_10669_n ) capacitor c=8.09433e-19 \
 //x=72.995 //y=3.51 //x2=73.38 //y2=3.705
cc_6270 ( N_noxref_15_c_9164_n N_noxref_17_c_10669_n ) capacitor c=0.0213096f \
 //x=73.595 //y=3.48 //x2=73.38 //y2=3.705
cc_6271 ( N_noxref_15_c_9164_n N_noxref_17_c_10680_n ) capacitor c=0.00601771f \
 //x=73.595 //y=3.48 //x2=73.38 //y2=4.025
cc_6272 ( N_noxref_15_c_9277_p N_noxref_17_c_10744_n ) capacitor c=0.00560518f \
 //x=78.93 //y=2.375 //x2=77.45 //y2=3.735
cc_6273 ( N_noxref_15_c_9120_n N_noxref_17_c_10744_n ) capacitor c=0.0178895f \
 //x=78.93 //y=3.35 //x2=77.45 //y2=3.735
cc_6274 ( N_noxref_15_c_9272_p N_noxref_17_c_10744_n ) capacitor c=0.00406893f \
 //x=78.93 //y=3.67 //x2=77.45 //y2=3.735
cc_6275 ( N_noxref_15_c_9121_n N_noxref_17_c_10744_n ) capacitor c=0.0013935f \
 //x=78.93 //y=4.46 //x2=77.45 //y2=3.735
cc_6276 ( N_noxref_15_c_9164_n N_noxref_17_c_10744_n ) capacitor c=0.0238952f \
 //x=73.595 //y=3.48 //x2=77.45 //y2=3.735
cc_6277 ( N_noxref_15_c_9121_n N_noxref_17_c_10751_n ) capacitor c=0.00423669f \
 //x=78.93 //y=4.46 //x2=77.45 //y2=4.055
cc_6278 ( N_noxref_15_c_9164_n N_noxref_17_c_10751_n ) capacitor c=0.0063069f \
 //x=73.595 //y=3.48 //x2=77.45 //y2=4.055
cc_6279 ( N_noxref_15_c_9121_n N_noxref_17_c_10753_n ) capacitor c=0.00815765f \
 //x=78.93 //y=4.46 //x2=77.45 //y2=5.295
cc_6280 ( N_noxref_15_c_9321_p N_noxref_17_c_10753_n ) capacitor c=0.00633548f \
 //x=78.93 //y=4.62 //x2=77.45 //y2=5.295
cc_6281 ( N_noxref_15_c_9322_p N_noxref_17_c_10753_n ) capacitor c=0.00401404f \
 //x=79.095 //y=4.62 //x2=77.45 //y2=5.295
cc_6282 ( N_noxref_15_c_9277_p N_noxref_17_c_10864_n ) capacitor c=0.0110499f \
 //x=78.93 //y=2.375 //x2=80.04 //y2=2.375
cc_6283 ( N_noxref_15_c_9216_p N_noxref_17_c_10864_n ) capacitor c=0.00273775f \
 //x=82.63 //y=2.385 //x2=80.04 //y2=2.375
cc_6284 ( N_noxref_15_c_9325_p N_noxref_17_c_10864_n ) capacitor c=0.00353903f \
 //x=78.93 //y=2.26 //x2=80.04 //y2=2.375
cc_6285 ( N_noxref_15_c_9326_p N_noxref_17_c_10864_n ) capacitor c=0.00140055f \
 //x=78.93 //y=2.26 //x2=80.04 //y2=2.375
cc_6286 ( N_noxref_15_c_9120_n N_noxref_17_c_10868_n ) capacitor c=0.025347f \
 //x=78.93 //y=3.35 //x2=80.04 //y2=4.045
cc_6287 ( N_noxref_15_c_9272_p N_noxref_17_c_10868_n ) capacitor c=0.00763467f \
 //x=78.93 //y=3.67 //x2=80.04 //y2=4.045
cc_6288 ( N_noxref_15_c_9121_n N_noxref_17_c_10868_n ) capacitor c=0.00752754f \
 //x=78.93 //y=4.46 //x2=80.04 //y2=4.045
cc_6289 ( N_noxref_15_c_9217_p N_noxref_17_c_10868_n ) capacitor c=0.0181665f \
 //x=82.63 //y=4.475 //x2=80.04 //y2=4.045
cc_6290 ( N_noxref_15_c_9331_p N_noxref_17_c_10868_n ) capacitor c=0.00388248f \
 //x=78.92 //y=3.51 //x2=80.04 //y2=4.045
cc_6291 ( N_noxref_15_c_9164_n N_noxref_17_c_10868_n ) capacitor c=0.00504602f \
 //x=73.595 //y=3.48 //x2=80.04 //y2=4.045
cc_6292 ( N_noxref_15_c_9325_p N_noxref_17_c_10868_n ) capacitor c=4.16726e-19 \
 //x=78.93 //y=2.26 //x2=80.04 //y2=4.045
cc_6293 ( N_noxref_15_c_9121_n N_noxref_17_c_10875_n ) capacitor c=0.00795456f \
 //x=78.93 //y=4.46 //x2=80.04 //y2=4.365
cc_6294 ( N_noxref_15_c_9217_p N_noxref_17_c_10875_n ) capacitor c=0.00149249f \
 //x=82.63 //y=4.475 //x2=80.04 //y2=4.365
cc_6295 ( N_noxref_15_c_9283_p N_noxref_17_c_10875_n ) capacitor c=0.00452722f \
 //x=82.475 //y=4.64 //x2=80.04 //y2=4.365
cc_6296 ( N_noxref_15_c_9121_n N_noxref_17_c_10878_n ) capacitor c=0.00234994f \
 //x=78.93 //y=4.46 //x2=80.04 //y2=4.71
cc_6297 ( N_noxref_15_c_9217_p N_noxref_17_c_10878_n ) capacitor c=0.00106529f \
 //x=82.63 //y=4.475 //x2=80.04 //y2=4.71
cc_6298 ( N_noxref_15_c_9321_p N_noxref_17_c_10878_n ) capacitor c=0.0101017f \
 //x=78.93 //y=4.62 //x2=80.04 //y2=4.71
cc_6299 ( N_noxref_15_c_9222_p N_noxref_17_c_10878_n ) capacitor c=0.00146299f \
 //x=82.63 //y=4.62 //x2=80.04 //y2=4.71
cc_6300 ( N_noxref_15_c_9322_p N_noxref_17_c_10878_n ) capacitor c=0.00282565f \
 //x=79.095 //y=4.62 //x2=80.04 //y2=4.71
cc_6301 ( N_noxref_15_c_9223_p N_noxref_17_c_10878_n ) capacitor c=0.00206738f \
 //x=82.635 //y=4.64 //x2=80.04 //y2=4.71
cc_6302 ( N_noxref_15_c_9283_p N_noxref_17_c_10878_n ) capacitor c=0.0312701f \
 //x=82.475 //y=4.64 //x2=80.04 //y2=4.71
cc_6303 ( N_noxref_15_c_9344_p N_noxref_17_c_10878_n ) capacitor c=0.00670492f \
 //x=78.93 //y=4.62 //x2=80.04 //y2=4.71
cc_6304 ( N_noxref_15_c_9345_p N_noxref_17_c_10878_n ) capacitor c=0.00117926f \
 //x=79.565 //y=4.975 //x2=80.04 //y2=4.71
cc_6305 ( N_noxref_15_c_9346_p N_noxref_17_c_10878_n ) capacitor c=0.00104403f \
 //x=79.275 //y=4.975 //x2=80.04 //y2=4.71
cc_6306 ( N_noxref_15_c_9121_n N_noxref_17_c_10784_n ) capacitor c=3.17649e-19 \
 //x=78.93 //y=4.46 //x2=77.45 //y2=3.88
cc_6307 ( N_noxref_15_c_9121_n N_noxref_17_c_10889_n ) capacitor c=5.51775e-19 \
 //x=78.93 //y=4.46 //x2=80.04 //y2=4.25
cc_6308 ( N_noxref_15_c_9164_n N_noxref_17_c_10785_n ) capacitor c=0.302237f \
 //x=73.595 //y=3.48 //x2=76.315 //y2=3.88
cc_6309 ( N_noxref_15_c_9272_p N_noxref_17_c_10891_n ) capacitor c=0.00227386f \
 //x=78.93 //y=3.67 //x2=79.135 //y2=3.895
cc_6310 ( N_noxref_15_c_9121_n N_noxref_17_c_10891_n ) capacitor c=0.0252037f \
 //x=78.93 //y=4.46 //x2=79.135 //y2=3.895
cc_6311 ( N_noxref_15_c_9321_p N_noxref_17_c_10891_n ) capacitor c=0.00317099f \
 //x=78.93 //y=4.62 //x2=79.135 //y2=3.895
cc_6312 ( N_noxref_15_c_9283_p N_noxref_17_c_10891_n ) capacitor c=0.00658616f \
 //x=82.475 //y=4.64 //x2=79.135 //y2=3.895
cc_6313 ( N_noxref_15_c_9272_p N_noxref_17_c_10798_n ) capacitor c=0.00479403f \
 //x=78.93 //y=3.67 //x2=78.79 //y2=3.895
cc_6314 ( N_noxref_15_c_9121_n N_noxref_17_c_10798_n ) capacitor c=0.00189077f \
 //x=78.93 //y=4.46 //x2=78.79 //y2=3.895
cc_6315 ( N_noxref_15_c_9321_p N_noxref_17_c_10798_n ) capacitor c=7.54025e-19 \
 //x=78.93 //y=4.62 //x2=78.79 //y2=3.895
cc_6316 ( N_noxref_15_c_9164_n N_noxref_17_c_10798_n ) capacitor c=0.203684f \
 //x=73.595 //y=3.48 //x2=78.79 //y2=3.895
cc_6317 ( N_noxref_15_c_9322_p N_noxref_17_c_10798_n ) capacitor c=0.0165785f \
 //x=79.095 //y=4.62 //x2=78.79 //y2=3.895
cc_6318 ( N_noxref_15_c_9121_n N_noxref_17_c_10900_n ) capacitor c=0.00673031f \
 //x=78.93 //y=4.46 //x2=80.2 //y2=4.252
cc_6319 ( N_noxref_15_c_9217_p N_noxref_17_c_10900_n ) capacitor c=0.00297491f \
 //x=82.63 //y=4.475 //x2=80.2 //y2=4.252
cc_6320 ( N_noxref_15_c_9283_p N_noxref_17_c_10900_n ) capacitor c=0.0654645f \
 //x=82.475 //y=4.64 //x2=80.2 //y2=4.252
cc_6321 ( N_noxref_15_c_9164_n N_noxref_17_c_10672_n ) capacitor c=0.0358686f \
 //x=73.595 //y=3.48 //x2=73.54 //y2=3.865
cc_6322 ( N_noxref_15_c_9217_p N_noxref_17_c_10904_n ) capacitor c=0.0296991f \
 //x=82.63 //y=4.475 //x2=86.555 //y2=4.21
cc_6323 ( N_noxref_15_c_9222_p N_noxref_17_c_10904_n ) capacitor c=0.0102463f \
 //x=82.63 //y=4.62 //x2=86.555 //y2=4.21
cc_6324 ( N_noxref_15_c_9223_p N_noxref_17_c_10904_n ) capacitor c=0.0369071f \
 //x=82.635 //y=4.64 //x2=86.555 //y2=4.21
cc_6325 ( N_noxref_15_c_9283_p N_noxref_17_c_10904_n ) capacitor c=0.208741f \
 //x=82.475 //y=4.64 //x2=86.555 //y2=4.21
cc_6326 ( N_noxref_15_c_9277_p N_noxref_17_c_10908_n ) capacitor c=4.56604e-19 \
 //x=78.93 //y=2.375 //x2=80.04 //y2=2.26
cc_6327 ( N_noxref_15_c_9120_n N_noxref_17_c_10908_n ) capacitor c=4.16726e-19 \
 //x=78.93 //y=3.35 //x2=80.04 //y2=2.26
cc_6328 ( N_noxref_15_c_9325_p N_noxref_17_c_10908_n ) capacitor c=0.00113699f \
 //x=78.93 //y=2.26 //x2=80.04 //y2=2.26
cc_6329 ( N_noxref_15_c_9326_p N_noxref_17_c_10908_n ) capacitor c=0.00201914f \
 //x=78.93 //y=2.26 //x2=80.04 //y2=2.26
cc_6330 ( N_noxref_15_c_9344_p N_noxref_17_c_10912_n ) capacitor c=0.00133991f \
 //x=78.93 //y=4.62 //x2=80.08 //y2=4.885
cc_6331 ( N_noxref_15_c_9345_p N_noxref_17_c_10912_n ) capacitor c=0.00122675f \
 //x=79.565 //y=4.975 //x2=80.08 //y2=4.885
cc_6332 ( N_noxref_15_c_9346_p N_noxref_17_c_10912_n ) capacitor c=0.00114302f \
 //x=79.275 //y=4.975 //x2=80.08 //y2=4.885
cc_6333 ( N_noxref_15_M150_noxref_g N_noxref_17_M152_noxref_g ) capacitor \
 c=0.0106808f //x=79.2 //y=6.205 //x2=80.08 //y2=6.205
cc_6334 ( N_noxref_15_M151_noxref_g N_noxref_17_M152_noxref_g ) capacitor \
 c=0.108153f //x=79.64 //y=6.205 //x2=80.08 //y2=6.205
cc_6335 ( N_noxref_15_M151_noxref_g N_noxref_17_M153_noxref_g ) capacitor \
 c=0.0103194f //x=79.64 //y=6.205 //x2=80.52 //y2=6.205
cc_6336 ( N_noxref_15_c_9377_p N_noxref_17_c_10918_n ) capacitor c=4.86545e-19 \
 //x=79.105 //y=1.045 //x2=80.075 //y2=1.085
cc_6337 ( N_noxref_15_c_9378_p N_noxref_17_c_10918_n ) capacitor c=0.00152405f \
 //x=79.105 //y=1.39 //x2=80.075 //y2=1.085
cc_6338 ( N_noxref_15_c_9379_p N_noxref_17_c_10918_n ) capacitor c=0.0151475f \
 //x=79.635 //y=1.045 //x2=80.075 //y2=1.085
cc_6339 ( N_noxref_15_c_9380_p N_noxref_17_c_10921_n ) capacitor c=0.00109982f \
 //x=79.105 //y=1.7 //x2=80.075 //y2=1.43
cc_6340 ( N_noxref_15_c_9381_p N_noxref_17_c_10921_n ) capacitor c=0.0111064f \
 //x=79.635 //y=1.39 //x2=80.075 //y2=1.43
cc_6341 ( N_noxref_15_c_9380_p N_noxref_17_c_10923_n ) capacitor c=0.00179029f \
 //x=79.105 //y=1.7 //x2=80.075 //y2=1.74
cc_6342 ( N_noxref_15_c_9383_p N_noxref_17_c_10923_n ) capacitor c=0.00662747f \
 //x=79.105 //y=2.095 //x2=80.075 //y2=1.74
cc_6343 ( N_noxref_15_c_9381_p N_noxref_17_c_10923_n ) capacitor c=0.00862358f \
 //x=79.635 //y=1.39 //x2=80.075 //y2=1.74
cc_6344 ( N_noxref_15_c_9379_p N_noxref_17_c_10926_n ) capacitor c=0.00124846f \
 //x=79.635 //y=1.045 //x2=80.605 //y2=1.085
cc_6345 ( N_noxref_15_c_9381_p N_noxref_17_c_10927_n ) capacitor c=0.00161183f \
 //x=79.635 //y=1.39 //x2=80.605 //y2=1.43
cc_6346 ( N_noxref_15_c_9277_p N_noxref_17_c_10928_n ) capacitor c=0.00130136f \
 //x=78.93 //y=2.375 //x2=80.04 //y2=2.26
cc_6347 ( N_noxref_15_c_9325_p N_noxref_17_c_10928_n ) capacitor c=0.00191372f \
 //x=78.93 //y=2.26 //x2=80.04 //y2=2.26
cc_6348 ( N_noxref_15_c_9326_p N_noxref_17_c_10928_n ) capacitor c=0.00949697f \
 //x=78.93 //y=2.26 //x2=80.04 //y2=2.26
cc_6349 ( N_noxref_15_c_9321_p N_noxref_17_c_10931_n ) capacitor c=2.84639e-19 \
 //x=78.93 //y=4.62 //x2=80.08 //y2=4.885
cc_6350 ( N_noxref_15_c_9344_p N_noxref_17_c_10931_n ) capacitor c=0.00197201f \
 //x=78.93 //y=4.62 //x2=80.08 //y2=4.885
cc_6351 ( N_noxref_15_c_9345_p N_noxref_17_c_10931_n ) capacitor c=0.0203213f \
 //x=79.565 //y=4.975 //x2=80.08 //y2=4.885
cc_6352 ( N_noxref_15_c_9346_p N_noxref_17_c_10931_n ) capacitor c=0.00427779f \
 //x=79.275 //y=4.975 //x2=80.08 //y2=4.885
cc_6353 ( N_noxref_15_c_9216_p N_QN_c_11251_n ) capacitor c=0.00798706f \
 //x=82.63 //y=2.385 //x2=83.54 //y2=1.405
cc_6354 ( N_noxref_15_c_9297_p N_QN_c_11251_n ) capacitor c=0.00242807f \
 //x=82.435 //y=1.39 //x2=83.54 //y2=1.405
cc_6355 ( N_noxref_15_c_9299_p N_QN_c_11251_n ) capacitor c=0.0014011f \
 //x=82.435 //y=1.7 //x2=83.54 //y2=1.405
cc_6356 ( N_noxref_15_c_9300_p N_QN_c_11251_n ) capacitor c=0.00372011f \
 //x=82.965 //y=1.39 //x2=83.54 //y2=1.405
cc_6357 ( N_noxref_15_c_8571_n N_VDD_c_11464_n ) capacitor c=0.00648267f \
 //x=50.955 //y=5.38 //x2=78.895 //y2=7.585
cc_6358 ( N_noxref_15_c_8653_n N_VDD_c_11464_n ) capacitor c=0.00492578f \
 //x=51.465 //y=5.38 //x2=78.895 //y2=7.585
cc_6359 ( N_noxref_15_c_8661_n N_VDD_c_11464_n ) capacitor c=2.01699e-19 \
 //x=51.55 //y=3.69 //x2=78.895 //y2=7.585
cc_6360 ( N_noxref_15_c_8699_n N_VDD_c_11464_n ) capacitor c=0.00621363f \
 //x=59.39 //y=5.335 //x2=78.895 //y2=7.585
cc_6361 ( N_noxref_15_c_8704_n N_VDD_c_11464_n ) capacitor c=0.00627192f \
 //x=60.275 //y=5.335 //x2=78.895 //y2=7.585
cc_6362 ( N_noxref_15_c_8963_n N_VDD_c_11464_n ) capacitor c=0.00256036f \
 //x=60.39 //y=5.56 //x2=78.895 //y2=7.585
cc_6363 ( N_noxref_15_c_8748_n N_VDD_c_11464_n ) capacitor c=0.00829251f \
 //x=61.085 //y=5.335 //x2=78.895 //y2=7.585
cc_6364 ( N_noxref_15_c_8856_n N_VDD_c_11464_n ) capacitor c=4.58912e-19 \
 //x=61.17 //y=3.67 //x2=78.895 //y2=7.585
cc_6365 ( N_noxref_15_c_8860_n N_VDD_c_11464_n ) capacitor c=2.00241e-19 \
 //x=63.02 //y=3.67 //x2=78.895 //y2=7.585
cc_6366 ( N_noxref_15_c_8750_n N_VDD_c_11464_n ) capacitor c=0.00648267f \
 //x=63.905 //y=5.38 //x2=78.895 //y2=7.585
cc_6367 ( N_noxref_15_c_9095_n N_VDD_c_11464_n ) capacitor c=0.00492584f \
 //x=64.415 //y=5.38 //x2=78.895 //y2=7.585
cc_6368 ( N_noxref_15_c_8862_n N_VDD_c_11464_n ) capacitor c=4.58709e-19 \
 //x=64.5 //y=3.675 //x2=78.895 //y2=7.585
cc_6369 ( N_noxref_15_c_8759_n N_VDD_c_11464_n ) capacitor c=3.99241e-19 \
 //x=66.35 //y=3.675 //x2=78.895 //y2=7.585
cc_6370 ( N_noxref_15_c_9272_p N_VDD_c_11464_n ) capacitor c=2.77303e-19 \
 //x=78.93 //y=3.67 //x2=78.895 //y2=7.585
cc_6371 ( N_noxref_15_c_8579_n N_VDD_c_11464_n ) capacitor c=0.00368834f \
 //x=50.19 //y=5.56 //x2=78.895 //y2=7.585
cc_6372 ( N_noxref_15_c_8670_n N_VDD_c_11464_n ) capacitor c=8.4268e-19 \
 //x=51.07 //y=5.38 //x2=78.895 //y2=7.585
cc_6373 ( N_noxref_15_c_9414_p N_VDD_c_11464_n ) capacitor c=0.00285853f \
 //x=51.07 //y=5.56 //x2=78.895 //y2=7.585
cc_6374 ( N_noxref_15_c_8768_n N_VDD_c_11464_n ) capacitor c=0.00261804f \
 //x=58.632 //y=5.335 //x2=78.895 //y2=7.585
cc_6375 ( N_noxref_15_c_8709_n N_VDD_c_11464_n ) capacitor c=0.00270108f \
 //x=59.51 //y=5.335 //x2=78.895 //y2=7.585
cc_6376 ( N_noxref_15_c_8770_n N_VDD_c_11464_n ) capacitor c=9.07241e-19 \
 //x=63.02 //y=4.88 //x2=78.895 //y2=7.585
cc_6377 ( N_noxref_15_c_8772_n N_VDD_c_11464_n ) capacitor c=0.00368834f \
 //x=63.14 //y=5.56 //x2=78.895 //y2=7.585
cc_6378 ( N_noxref_15_c_8773_n N_VDD_c_11464_n ) capacitor c=8.42594e-19 \
 //x=64.02 //y=5.38 //x2=78.895 //y2=7.585
cc_6379 ( N_noxref_15_c_9420_p N_VDD_c_11464_n ) capacitor c=0.00285853f \
 //x=64.02 //y=5.56 //x2=78.895 //y2=7.585
cc_6380 ( N_noxref_15_c_9321_p N_VDD_c_11464_n ) capacitor c=2.8981e-19 \
 //x=78.93 //y=4.62 //x2=78.895 //y2=7.585
cc_6381 ( N_noxref_15_c_8606_n N_VDD_c_11464_n ) capacitor c=0.00224881f \
 //x=50.19 //y=5.56 //x2=78.895 //y2=7.585
cc_6382 ( N_noxref_15_c_8687_n N_VDD_c_11464_n ) capacitor c=0.00224881f \
 //x=51.07 //y=5.56 //x2=78.895 //y2=7.585
cc_6383 ( N_noxref_15_c_8913_n N_VDD_c_11464_n ) capacitor c=0.0024232f \
 //x=58.63 //y=5.56 //x2=78.895 //y2=7.585
cc_6384 ( N_noxref_15_c_8725_n N_VDD_c_11464_n ) capacitor c=0.0024232f \
 //x=59.51 //y=5.56 //x2=78.895 //y2=7.585
cc_6385 ( N_noxref_15_c_9035_n N_VDD_c_11464_n ) capacitor c=0.0024232f \
 //x=60.39 //y=5.56 //x2=78.895 //y2=7.585
cc_6386 ( N_noxref_15_c_9178_n N_VDD_c_11464_n ) capacitor c=6.22888e-19 \
 //x=63.02 //y=4.88 //x2=78.895 //y2=7.585
cc_6387 ( N_noxref_15_c_9428_p N_VDD_c_11464_n ) capacitor c=0.00224881f \
 //x=63.14 //y=5.56 //x2=78.895 //y2=7.585
cc_6388 ( N_noxref_15_c_9181_n N_VDD_c_11464_n ) capacitor c=0.00224881f \
 //x=64.02 //y=5.56 //x2=78.895 //y2=7.585
cc_6389 ( N_noxref_15_M150_noxref_g N_VDD_c_12457_n ) capacitor c=0.00374549f \
 //x=79.2 //y=6.205 //x2=78.98 //y2=7.035
cc_6390 ( N_noxref_15_M150_noxref_g N_VDD_c_12458_n ) capacitor c=0.00441594f \
 //x=79.2 //y=6.205 //x2=78.98 //y2=7.41
cc_6391 ( N_noxref_15_M151_noxref_g N_VDD_c_12459_n ) capacitor c=0.00123273f \
 //x=79.64 //y=6.205 //x2=79.86 //y2=7.035
cc_6392 ( N_noxref_15_M151_noxref_g N_VDD_c_12460_n ) capacitor c=0.00137209f \
 //x=79.64 //y=6.205 //x2=79.86 //y2=7.41
cc_6393 ( N_noxref_15_M112_noxref_g N_VDD_c_11978_n ) capacitor c=0.00755544f \
 //x=47.22 //y=6.2 //x2=47.795 //y2=7.585
cc_6394 ( N_noxref_15_M113_noxref_g N_VDD_c_11978_n ) capacitor c=0.00755754f \
 //x=47.66 //y=6.2 //x2=47.795 //y2=7.585
cc_6395 ( N_noxref_15_c_8571_n N_VDD_c_11983_n ) capacitor c=0.00208087f \
 //x=50.955 //y=5.38 //x2=50.545 //y2=7.585
cc_6396 ( N_noxref_15_c_8579_n N_VDD_c_11983_n ) capacitor c=9.41185e-19 \
 //x=50.19 //y=5.56 //x2=50.545 //y2=7.585
cc_6397 ( N_noxref_15_c_8606_n N_VDD_c_11983_n ) capacitor c=0.0136705f \
 //x=50.19 //y=5.56 //x2=50.545 //y2=7.585
cc_6398 ( N_noxref_15_c_8571_n N_VDD_c_12040_n ) capacitor c=0.00180737f \
 //x=50.955 //y=5.38 //x2=51.425 //y2=7.585
cc_6399 ( N_noxref_15_c_8653_n N_VDD_c_12040_n ) capacitor c=0.00208087f \
 //x=51.465 //y=5.38 //x2=51.425 //y2=7.585
cc_6400 ( N_noxref_15_c_8670_n N_VDD_c_12040_n ) capacitor c=4.23719e-19 \
 //x=51.07 //y=5.38 //x2=51.425 //y2=7.585
cc_6401 ( N_noxref_15_c_9414_p N_VDD_c_12040_n ) capacitor c=5.77976e-19 \
 //x=51.07 //y=5.56 //x2=51.425 //y2=7.585
cc_6402 ( N_noxref_15_c_8687_n N_VDD_c_12040_n ) capacitor c=0.0136705f \
 //x=51.07 //y=5.56 //x2=51.425 //y2=7.585
cc_6403 ( N_noxref_15_M122_noxref_g N_VDD_c_12184_n ) capacitor c=0.00755544f \
 //x=55.36 //y=6.2 //x2=55.935 //y2=7.585
cc_6404 ( N_noxref_15_M123_noxref_g N_VDD_c_12184_n ) capacitor c=0.00755754f \
 //x=55.8 //y=6.2 //x2=55.935 //y2=7.585
cc_6405 ( N_noxref_15_c_8699_n N_VDD_c_12189_n ) capacitor c=0.00202922f \
 //x=59.39 //y=5.335 //x2=58.985 //y2=7.585
cc_6406 ( N_noxref_15_c_8768_n N_VDD_c_12189_n ) capacitor c=9.3757e-19 \
 //x=58.632 //y=5.335 //x2=58.985 //y2=7.585
cc_6407 ( N_noxref_15_c_8913_n N_VDD_c_12189_n ) capacitor c=0.0138074f \
 //x=58.63 //y=5.56 //x2=58.985 //y2=7.585
cc_6408 ( N_noxref_15_c_8699_n N_VDD_c_12101_n ) capacitor c=0.0017708f \
 //x=59.39 //y=5.335 //x2=59.865 //y2=7.585
cc_6409 ( N_noxref_15_c_8704_n N_VDD_c_12101_n ) capacitor c=0.00202922f \
 //x=60.275 //y=5.335 //x2=59.865 //y2=7.585
cc_6410 ( N_noxref_15_c_8709_n N_VDD_c_12101_n ) capacitor c=9.4822e-19 \
 //x=59.51 //y=5.335 //x2=59.865 //y2=7.585
cc_6411 ( N_noxref_15_c_8725_n N_VDD_c_12101_n ) capacitor c=0.0138074f \
 //x=59.51 //y=5.56 //x2=59.865 //y2=7.585
cc_6412 ( N_noxref_15_c_8704_n N_VDD_c_12243_n ) capacitor c=0.00205906f \
 //x=60.275 //y=5.335 //x2=60.745 //y2=7.585
cc_6413 ( N_noxref_15_c_8963_n N_VDD_c_12243_n ) capacitor c=8.49654e-19 \
 //x=60.39 //y=5.56 //x2=60.745 //y2=7.585
cc_6414 ( N_noxref_15_c_8748_n N_VDD_c_12243_n ) capacitor c=0.00204238f \
 //x=61.085 //y=5.335 //x2=60.745 //y2=7.585
cc_6415 ( N_noxref_15_c_9035_n N_VDD_c_12243_n ) capacitor c=0.0138074f \
 //x=60.39 //y=5.56 //x2=60.745 //y2=7.585
cc_6416 ( N_noxref_15_c_8748_n N_VDD_c_12484_n ) capacitor c=0.00183742f \
 //x=61.085 //y=5.335 //x2=61.74 //y2=7.585
cc_6417 ( N_noxref_15_c_8750_n N_VDD_c_12485_n ) capacitor c=0.00208087f \
 //x=63.905 //y=5.38 //x2=63.495 //y2=7.585
cc_6418 ( N_noxref_15_c_8770_n N_VDD_c_12485_n ) capacitor c=6.28113e-19 \
 //x=63.02 //y=4.88 //x2=63.495 //y2=7.585
cc_6419 ( N_noxref_15_c_8772_n N_VDD_c_12485_n ) capacitor c=9.41185e-19 \
 //x=63.14 //y=5.56 //x2=63.495 //y2=7.585
cc_6420 ( N_noxref_15_c_9428_p N_VDD_c_12485_n ) capacitor c=0.0136705f \
 //x=63.14 //y=5.56 //x2=63.495 //y2=7.585
cc_6421 ( N_noxref_15_M130_noxref_g N_VDD_c_12485_n ) capacitor c=0.00732618f \
 //x=62.92 //y=6.2 //x2=63.495 //y2=7.585
cc_6422 ( N_noxref_15_M131_noxref_g N_VDD_c_12485_n ) capacitor c=0.00755544f \
 //x=63.36 //y=6.2 //x2=63.495 //y2=7.585
cc_6423 ( N_noxref_15_c_8750_n N_VDD_c_12308_n ) capacitor c=0.00180737f \
 //x=63.905 //y=5.38 //x2=64.375 //y2=7.585
cc_6424 ( N_noxref_15_c_9095_n N_VDD_c_12308_n ) capacitor c=0.00208087f \
 //x=64.415 //y=5.38 //x2=64.375 //y2=7.585
cc_6425 ( N_noxref_15_c_8773_n N_VDD_c_12308_n ) capacitor c=4.23719e-19 \
 //x=64.02 //y=5.38 //x2=64.375 //y2=7.585
cc_6426 ( N_noxref_15_c_9420_p N_VDD_c_12308_n ) capacitor c=5.77976e-19 \
 //x=64.02 //y=5.56 //x2=64.375 //y2=7.585
cc_6427 ( N_noxref_15_c_9181_n N_VDD_c_12308_n ) capacitor c=0.0136705f \
 //x=64.02 //y=5.56 //x2=64.375 //y2=7.585
cc_6428 ( N_noxref_15_M134_noxref_g N_VDD_c_12310_n ) capacitor c=0.00755614f \
 //x=66.55 //y=6.2 //x2=67.125 //y2=7.585
cc_6429 ( N_noxref_15_M135_noxref_g N_VDD_c_12310_n ) capacitor c=0.00755544f \
 //x=66.99 //y=6.2 //x2=67.125 //y2=7.585
cc_6430 ( N_noxref_15_c_9321_p N_VDD_c_12498_n ) capacitor c=5.35585e-19 \
 //x=78.93 //y=4.62 //x2=81.35 //y2=7.585
cc_6431 ( N_noxref_15_M150_noxref_g N_VDD_c_12498_n ) capacitor c=0.00778439f \
 //x=79.2 //y=6.205 //x2=81.35 //y2=7.585
cc_6432 ( N_noxref_15_M151_noxref_g N_VDD_c_12498_n ) capacitor c=0.00778439f \
 //x=79.64 //y=6.205 //x2=81.35 //y2=7.585
cc_6433 ( N_noxref_15_c_9224_p N_VDD_c_12501_n ) capacitor c=2.11259e-19 \
 //x=82.63 //y=4.62 //x2=84.68 //y2=7.585
cc_6434 ( N_noxref_15_M154_noxref_g N_VDD_c_12501_n ) capacitor c=0.00763665f \
 //x=82.52 //y=6.205 //x2=84.68 //y2=7.585
cc_6435 ( N_noxref_15_M155_noxref_g N_VDD_c_12501_n ) capacitor c=0.00782837f \
 //x=82.96 //y=6.205 //x2=84.68 //y2=7.585
cc_6436 ( N_noxref_15_c_8576_n N_VDD_c_11988_n ) capacitor c=0.0013228f \
 //x=51.55 //y=5.295 //x2=48.96 //y2=7.585
cc_6437 ( N_noxref_15_c_8579_n N_VDD_c_11988_n ) capacitor c=4.91377e-19 \
 //x=50.19 //y=5.56 //x2=48.96 //y2=7.585
cc_6438 ( N_noxref_15_c_8602_n N_VDD_c_11988_n ) capacitor c=0.00224736f \
 //x=47.48 //y=4.88 //x2=48.96 //y2=7.585
cc_6439 ( N_noxref_15_c_8606_n N_VDD_c_11988_n ) capacitor c=0.0064135f \
 //x=50.19 //y=5.56 //x2=48.96 //y2=7.585
cc_6440 ( N_noxref_15_c_8638_n N_VDD_c_11988_n ) capacitor c=2.63786e-19 \
 //x=47.48 //y=4.88 //x2=48.96 //y2=7.585
cc_6441 ( N_noxref_15_c_8576_n N_VDD_c_12066_n ) capacitor c=0.0295053f \
 //x=51.55 //y=5.295 //x2=52.29 //y2=7.585
cc_6442 ( N_noxref_15_c_8670_n N_VDD_c_12066_n ) capacitor c=0.0025639f \
 //x=51.07 //y=5.38 //x2=52.29 //y2=7.585
cc_6443 ( N_noxref_15_c_9414_p N_VDD_c_12066_n ) capacitor c=4.19141e-19 \
 //x=51.07 //y=5.56 //x2=52.29 //y2=7.585
cc_6444 ( N_noxref_15_c_8718_n N_VDD_c_12066_n ) capacitor c=0.00333061f \
 //x=55.46 //y=3.51 //x2=52.29 //y2=7.585
cc_6445 ( N_noxref_15_c_8687_n N_VDD_c_12066_n ) capacitor c=0.0101861f \
 //x=51.07 //y=5.56 //x2=52.29 //y2=7.585
cc_6446 ( N_noxref_15_c_8768_n N_VDD_c_12135_n ) capacitor c=0.0022955f \
 //x=58.632 //y=5.335 //x2=57.1 //y2=7.585
cc_6447 ( N_noxref_15_c_8790_n N_VDD_c_12135_n ) capacitor c=0.00224736f \
 //x=55.62 //y=4.88 //x2=57.1 //y2=7.585
cc_6448 ( N_noxref_15_c_8913_n N_VDD_c_12135_n ) capacitor c=0.00509469f \
 //x=58.63 //y=5.56 //x2=57.1 //y2=7.585
cc_6449 ( N_noxref_15_c_8830_n N_VDD_c_12135_n ) capacitor c=2.63786e-19 \
 //x=55.62 //y=4.88 //x2=57.1 //y2=7.585
cc_6450 ( N_noxref_15_c_8963_n N_VDD_c_12136_n ) capacitor c=0.00269779f \
 //x=60.39 //y=5.56 //x2=61.91 //y2=7.585
cc_6451 ( N_noxref_15_c_8708_n N_VDD_c_12136_n ) capacitor c=0.0312736f \
 //x=61.17 //y=5.25 //x2=61.91 //y2=7.585
cc_6452 ( N_noxref_15_c_8752_n N_VDD_c_12136_n ) capacitor c=0.0013228f \
 //x=64.5 //y=5.295 //x2=61.91 //y2=7.585
cc_6453 ( N_noxref_15_c_8770_n N_VDD_c_12136_n ) capacitor c=0.00447349f \
 //x=63.02 //y=4.88 //x2=61.91 //y2=7.585
cc_6454 ( N_noxref_15_c_8771_n N_VDD_c_12136_n ) capacitor c=0.00564116f \
 //x=63.022 //y=4.74 //x2=61.91 //y2=7.585
cc_6455 ( N_noxref_15_c_8772_n N_VDD_c_12136_n ) capacitor c=4.91377e-19 \
 //x=63.14 //y=5.56 //x2=61.91 //y2=7.585
cc_6456 ( N_noxref_15_c_9035_n N_VDD_c_12136_n ) capacitor c=0.00776541f \
 //x=60.39 //y=5.56 //x2=61.91 //y2=7.585
cc_6457 ( N_noxref_15_c_9178_n N_VDD_c_12136_n ) capacitor c=0.00370494f \
 //x=63.02 //y=4.88 //x2=61.91 //y2=7.585
cc_6458 ( N_noxref_15_c_9428_p N_VDD_c_12136_n ) capacitor c=0.0064135f \
 //x=63.14 //y=5.56 //x2=61.91 //y2=7.585
cc_6459 ( N_noxref_15_c_9207_n N_VDD_c_12136_n ) capacitor c=0.0129564f \
 //x=63.02 //y=4.88 //x2=61.91 //y2=7.585
cc_6460 ( N_noxref_15_c_8752_n N_VDD_c_12137_n ) capacitor c=0.0294123f \
 //x=64.5 //y=5.295 //x2=65.24 //y2=7.585
cc_6461 ( N_noxref_15_c_8760_n N_VDD_c_12137_n ) capacitor c=0.0119111f \
 //x=66.35 //y=4.755 //x2=65.24 //y2=7.585
cc_6462 ( N_noxref_15_c_8773_n N_VDD_c_12137_n ) capacitor c=0.0025639f \
 //x=64.02 //y=5.38 //x2=65.24 //y2=7.585
cc_6463 ( N_noxref_15_c_9420_p N_VDD_c_12137_n ) capacitor c=4.19141e-19 \
 //x=64.02 //y=5.56 //x2=65.24 //y2=7.585
cc_6464 ( N_noxref_15_c_9181_n N_VDD_c_12137_n ) capacitor c=0.0101861f \
 //x=64.02 //y=5.56 //x2=65.24 //y2=7.585
cc_6465 ( N_noxref_15_c_8797_n N_VDD_c_12137_n ) capacitor c=0.00370784f \
 //x=66.35 //y=4.88 //x2=65.24 //y2=7.585
cc_6466 ( N_noxref_15_c_8823_n N_VDD_c_12137_n ) capacitor c=0.00590568f \
 //x=66.625 //y=4.97 //x2=65.24 //y2=7.585
cc_6467 ( N_noxref_15_c_9121_n N_VDD_c_12376_n ) capacitor c=0.00364769f \
 //x=78.93 //y=4.46 //x2=78.19 //y2=7.585
cc_6468 ( N_noxref_15_c_9321_p N_VDD_c_12376_n ) capacitor c=0.00528862f \
 //x=78.93 //y=4.62 //x2=78.19 //y2=7.585
cc_6469 ( N_noxref_15_c_9344_p N_VDD_c_12376_n ) capacitor c=0.0179701f \
 //x=78.93 //y=4.62 //x2=78.19 //y2=7.585
cc_6470 ( N_noxref_15_M150_noxref_g N_VDD_c_12376_n ) capacitor c=0.00973553f \
 //x=79.2 //y=6.205 //x2=78.19 //y2=7.585
cc_6471 ( N_noxref_15_c_9346_p N_VDD_c_12376_n ) capacitor c=0.00774458f \
 //x=79.275 //y=4.975 //x2=78.19 //y2=7.585
cc_6472 ( N_noxref_15_c_9217_p N_VDD_c_12540_n ) capacitor c=0.00285166f \
 //x=82.63 //y=4.475 //x2=81.52 //y2=7.585
cc_6473 ( N_noxref_15_c_9222_p N_VDD_c_12540_n ) capacitor c=0.00331684f \
 //x=82.63 //y=4.62 //x2=81.52 //y2=7.585
cc_6474 ( N_noxref_15_c_9283_p N_VDD_c_12540_n ) capacitor c=0.0167947f \
 //x=82.475 //y=4.64 //x2=81.52 //y2=7.585
cc_6475 ( N_noxref_15_c_9344_p N_VDD_c_12540_n ) capacitor c=0.00117386f \
 //x=78.93 //y=4.62 //x2=81.52 //y2=7.585
cc_6476 ( N_noxref_15_c_9224_p N_VDD_c_12540_n ) capacitor c=0.0104424f \
 //x=82.63 //y=4.62 //x2=81.52 //y2=7.585
cc_6477 ( N_noxref_15_c_9225_p N_VDD_c_12540_n ) capacitor c=0.0137051f \
 //x=82.63 //y=4.885 //x2=81.52 //y2=7.585
cc_6478 ( N_noxref_15_c_9224_p N_VDD_c_12546_n ) capacitor c=0.00221916f \
 //x=82.63 //y=4.62 //x2=84.85 //y2=7.585
cc_6479 ( N_noxref_15_M112_noxref_g N_VDD_M111_noxref_d ) capacitor \
 c=0.015318f //x=47.22 //y=6.2 //x2=46.855 //y2=5.2
cc_6480 ( N_noxref_15_M113_noxref_g N_VDD_M113_noxref_d ) capacitor \
 c=0.0394719f //x=47.66 //y=6.2 //x2=47.735 //y2=5.2
cc_6481 ( N_noxref_15_c_8579_n N_VDD_M114_noxref_s ) capacitor c=0.0611368f \
 //x=50.19 //y=5.56 //x2=49.615 //y2=5.2
cc_6482 ( N_noxref_15_c_8670_n N_VDD_M114_noxref_s ) capacitor c=6.52457e-19 \
 //x=51.07 //y=5.38 //x2=49.615 //y2=5.2
cc_6483 ( N_noxref_15_c_8606_n N_VDD_M114_noxref_s ) capacitor c=0.0887533f \
 //x=50.19 //y=5.56 //x2=49.615 //y2=5.2
cc_6484 ( N_noxref_15_c_8571_n N_VDD_M115_noxref_d ) capacitor c=0.00734094f \
 //x=50.955 //y=5.38 //x2=50.485 //y2=5.2
cc_6485 ( N_noxref_15_c_8579_n N_VDD_M115_noxref_d ) capacitor c=0.0043528f \
 //x=50.19 //y=5.56 //x2=50.485 //y2=5.2
cc_6486 ( N_noxref_15_c_9414_p N_VDD_M115_noxref_d ) capacitor c=0.0043528f \
 //x=51.07 //y=5.56 //x2=50.485 //y2=5.2
cc_6487 ( N_noxref_15_c_8606_n N_VDD_M115_noxref_d ) capacitor c=0.065554f \
 //x=50.19 //y=5.56 //x2=50.485 //y2=5.2
cc_6488 ( N_noxref_15_c_8687_n N_VDD_M115_noxref_d ) capacitor c=0.065554f \
 //x=51.07 //y=5.56 //x2=50.485 //y2=5.2
cc_6489 ( N_noxref_15_c_8653_n N_VDD_M117_noxref_d ) capacitor c=0.00934027f \
 //x=51.465 //y=5.38 //x2=51.365 //y2=5.2
cc_6490 ( N_noxref_15_c_9414_p N_VDD_M117_noxref_d ) capacitor c=0.00955781f \
 //x=51.07 //y=5.56 //x2=51.365 //y2=5.2
cc_6491 ( N_noxref_15_c_8679_n N_VDD_M117_noxref_d ) capacitor c=9.65951e-19 \
 //x=51.55 //y=3.51 //x2=51.365 //y2=5.2
cc_6492 ( N_noxref_15_c_8687_n N_VDD_M117_noxref_d ) capacitor c=0.065554f \
 //x=51.07 //y=5.56 //x2=51.365 //y2=5.2
cc_6493 ( N_noxref_15_c_8653_n N_VDD_M118_noxref_s ) capacitor c=0.00220019f \
 //x=51.465 //y=5.38 //x2=53.245 //y2=5.2
cc_6494 ( N_noxref_15_c_8670_n N_VDD_M118_noxref_s ) capacitor c=0.00371125f \
 //x=51.07 //y=5.38 //x2=53.245 //y2=5.2
cc_6495 ( N_noxref_15_c_9414_p N_VDD_M118_noxref_s ) capacitor c=9.52042e-19 \
 //x=51.07 //y=5.56 //x2=53.245 //y2=5.2
cc_6496 ( N_noxref_15_M122_noxref_g N_VDD_M121_noxref_d ) capacitor \
 c=0.015318f //x=55.36 //y=6.2 //x2=54.995 //y2=5.2
cc_6497 ( N_noxref_15_M123_noxref_g N_VDD_M123_noxref_d ) capacitor \
 c=0.0394719f //x=55.8 //y=6.2 //x2=55.875 //y2=5.2
cc_6498 ( N_noxref_15_c_8768_n N_VDD_M124_noxref_s ) capacitor c=0.0441176f \
 //x=58.632 //y=5.335 //x2=58.055 //y2=5.2
cc_6499 ( N_noxref_15_c_8709_n N_VDD_M124_noxref_s ) capacitor c=7.80122e-19 \
 //x=59.51 //y=5.335 //x2=58.055 //y2=5.2
cc_6500 ( N_noxref_15_c_8913_n N_VDD_M124_noxref_s ) capacitor c=0.09305f \
 //x=58.63 //y=5.56 //x2=58.055 //y2=5.2
cc_6501 ( N_noxref_15_c_8699_n N_VDD_M125_noxref_d ) capacitor c=0.00700141f \
 //x=59.39 //y=5.335 //x2=58.925 //y2=5.2
cc_6502 ( N_noxref_15_c_8913_n N_VDD_M125_noxref_d ) capacitor c=0.0674491f \
 //x=58.63 //y=5.56 //x2=58.925 //y2=5.2
cc_6503 ( N_noxref_15_c_8725_n N_VDD_M125_noxref_d ) capacitor c=0.0674762f \
 //x=59.51 //y=5.56 //x2=58.925 //y2=5.2
cc_6504 ( N_noxref_15_c_8704_n N_VDD_M127_noxref_d ) capacitor c=0.00700141f \
 //x=60.275 //y=5.335 //x2=59.805 //y2=5.2
cc_6505 ( N_noxref_15_c_8725_n N_VDD_M127_noxref_d ) capacitor c=0.067493f \
 //x=59.51 //y=5.56 //x2=59.805 //y2=5.2
cc_6506 ( N_noxref_15_c_9035_n N_VDD_M127_noxref_d ) capacitor c=0.0674288f \
 //x=60.39 //y=5.56 //x2=59.805 //y2=5.2
cc_6507 ( N_noxref_15_c_8748_n N_VDD_M129_noxref_d ) capacitor c=0.00700141f \
 //x=61.085 //y=5.335 //x2=60.685 //y2=5.2
cc_6508 ( N_noxref_15_c_9035_n N_VDD_M129_noxref_d ) capacitor c=0.0673824f \
 //x=60.39 //y=5.56 //x2=60.685 //y2=5.2
cc_6509 ( N_noxref_15_c_8963_n N_VDD_M130_noxref_s ) capacitor c=0.00536022f \
 //x=60.39 //y=5.56 //x2=62.565 //y2=5.2
cc_6510 ( N_noxref_15_c_8748_n N_VDD_M130_noxref_s ) capacitor c=0.00211796f \
 //x=61.085 //y=5.335 //x2=62.565 //y2=5.2
cc_6511 ( N_noxref_15_c_8860_n N_VDD_M130_noxref_s ) capacitor c=0.00111275f \
 //x=63.02 //y=3.67 //x2=62.565 //y2=5.2
cc_6512 ( N_noxref_15_c_8772_n N_VDD_M130_noxref_s ) capacitor c=0.0611368f \
 //x=63.14 //y=5.56 //x2=62.565 //y2=5.2
cc_6513 ( N_noxref_15_c_8773_n N_VDD_M130_noxref_s ) capacitor c=6.52457e-19 \
 //x=64.02 //y=5.38 //x2=62.565 //y2=5.2
cc_6514 ( N_noxref_15_c_9428_p N_VDD_M130_noxref_s ) capacitor c=0.0887533f \
 //x=63.14 //y=5.56 //x2=62.565 //y2=5.2
cc_6515 ( N_noxref_15_M130_noxref_g N_VDD_M130_noxref_s ) capacitor \
 c=0.0567929f //x=62.92 //y=6.2 //x2=62.565 //y2=5.2
cc_6516 ( N_noxref_15_c_8750_n N_VDD_M131_noxref_d ) capacitor c=0.00734094f \
 //x=63.905 //y=5.38 //x2=63.435 //y2=5.2
cc_6517 ( N_noxref_15_c_8772_n N_VDD_M131_noxref_d ) capacitor c=0.0043528f \
 //x=63.14 //y=5.56 //x2=63.435 //y2=5.2
cc_6518 ( N_noxref_15_c_9420_p N_VDD_M131_noxref_d ) capacitor c=0.0043528f \
 //x=64.02 //y=5.56 //x2=63.435 //y2=5.2
cc_6519 ( N_noxref_15_c_9428_p N_VDD_M131_noxref_d ) capacitor c=0.065554f \
 //x=63.14 //y=5.56 //x2=63.435 //y2=5.2
cc_6520 ( N_noxref_15_c_9181_n N_VDD_M131_noxref_d ) capacitor c=0.065554f \
 //x=64.02 //y=5.56 //x2=63.435 //y2=5.2
cc_6521 ( N_noxref_15_M131_noxref_g N_VDD_M131_noxref_d ) capacitor \
 c=0.015318f //x=63.36 //y=6.2 //x2=63.435 //y2=5.2
cc_6522 ( N_noxref_15_c_9095_n N_VDD_M133_noxref_d ) capacitor c=0.00934027f \
 //x=64.415 //y=5.38 //x2=64.315 //y2=5.2
cc_6523 ( N_noxref_15_c_9420_p N_VDD_M133_noxref_d ) capacitor c=0.00955781f \
 //x=64.02 //y=5.56 //x2=64.315 //y2=5.2
cc_6524 ( N_noxref_15_c_9144_n N_VDD_M133_noxref_d ) capacitor c=9.65951e-19 \
 //x=64.5 //y=3.51 //x2=64.315 //y2=5.2
cc_6525 ( N_noxref_15_c_9181_n N_VDD_M133_noxref_d ) capacitor c=0.065554f \
 //x=64.02 //y=5.56 //x2=64.315 //y2=5.2
cc_6526 ( N_noxref_15_c_9095_n N_VDD_M134_noxref_s ) capacitor c=0.00220019f \
 //x=64.415 //y=5.38 //x2=66.195 //y2=5.2
cc_6527 ( N_noxref_15_c_8759_n N_VDD_M134_noxref_s ) capacitor c=6.02115e-19 \
 //x=66.35 //y=3.675 //x2=66.195 //y2=5.2
cc_6528 ( N_noxref_15_c_8760_n N_VDD_M134_noxref_s ) capacitor c=0.0217981f \
 //x=66.35 //y=4.755 //x2=66.195 //y2=5.2
cc_6529 ( N_noxref_15_c_8773_n N_VDD_M134_noxref_s ) capacitor c=0.00371125f \
 //x=64.02 //y=5.38 //x2=66.195 //y2=5.2
cc_6530 ( N_noxref_15_c_9420_p N_VDD_M134_noxref_s ) capacitor c=9.52042e-19 \
 //x=64.02 //y=5.56 //x2=66.195 //y2=5.2
cc_6531 ( N_noxref_15_c_8797_n N_VDD_M134_noxref_s ) capacitor c=0.00983846f \
 //x=66.35 //y=4.88 //x2=66.195 //y2=5.2
cc_6532 ( N_noxref_15_M134_noxref_g N_VDD_M134_noxref_s ) capacitor \
 c=0.053419f //x=66.55 //y=6.2 //x2=66.195 //y2=5.2
cc_6533 ( N_noxref_15_c_8823_n N_VDD_M134_noxref_s ) capacitor c=0.0060625f \
 //x=66.625 //y=4.97 //x2=66.195 //y2=5.2
cc_6534 ( N_noxref_15_M135_noxref_g N_VDD_M135_noxref_d ) capacitor \
 c=0.015318f //x=66.99 //y=6.2 //x2=67.065 //y2=5.2
cc_6535 ( N_noxref_15_c_9321_p N_VDD_M150_noxref_s ) capacitor c=0.0165143f \
 //x=78.93 //y=4.62 //x2=78.845 //y2=5.205
cc_6536 ( N_noxref_15_c_9322_p N_VDD_M150_noxref_s ) capacitor c=0.00180521f \
 //x=79.095 //y=4.62 //x2=78.845 //y2=5.205
cc_6537 ( N_noxref_15_c_9344_p N_VDD_M150_noxref_s ) capacitor c=0.0122195f \
 //x=78.93 //y=4.62 //x2=78.845 //y2=5.205
cc_6538 ( N_noxref_15_M150_noxref_g N_VDD_M150_noxref_s ) capacitor \
 c=0.0510401f //x=79.2 //y=6.205 //x2=78.845 //y2=5.205
cc_6539 ( N_noxref_15_c_9346_p N_VDD_M150_noxref_s ) capacitor c=0.00621646f \
 //x=79.275 //y=4.975 //x2=78.845 //y2=5.205
cc_6540 ( N_noxref_15_M151_noxref_g N_VDD_M151_noxref_d ) capacitor \
 c=0.0127979f //x=79.64 //y=6.205 //x2=79.715 //y2=5.205
cc_6541 ( N_noxref_15_c_8554_n N_noxref_27_c_13330_n ) capacitor c=0.00177186f \
 //x=47.48 //y=2.375 //x2=48.135 //y2=0.72
cc_6542 ( N_noxref_15_c_8601_n N_noxref_27_c_13330_n ) capacitor c=0.00117306f \
 //x=47.48 //y=2.26 //x2=48.135 //y2=0.72
cc_6543 ( N_noxref_15_c_8617_n N_noxref_27_c_13330_n ) capacitor c=0.0206349f \
 //x=47.47 //y=1.095 //x2=48.135 //y2=0.72
cc_6544 ( N_noxref_15_c_8629_n N_noxref_27_c_13330_n ) capacitor c=0.00825432f \
 //x=48 //y=1.095 //x2=48.135 //y2=0.72
cc_6545 ( N_noxref_15_c_8635_n N_noxref_27_c_13330_n ) capacitor c=2.20712e-19 \
 //x=47.48 //y=2.26 //x2=48.135 //y2=0.72
cc_6546 ( N_noxref_15_c_8619_n N_noxref_27_c_13333_n ) capacitor c=0.0071177f \
 //x=47.47 //y=1.44 //x2=47.25 //y2=1.175
cc_6547 ( N_noxref_15_c_8617_n N_noxref_27_M29_noxref_s ) capacitor \
 c=0.0071177f //x=47.47 //y=1.095 //x2=47.115 //y2=0.555
cc_6548 ( N_noxref_15_c_8622_n N_noxref_27_M29_noxref_s ) capacitor \
 c=0.0071177f //x=47.47 //y=1.75 //x2=47.115 //y2=0.555
cc_6549 ( N_noxref_15_c_8629_n N_noxref_27_M29_noxref_s ) capacitor \
 c=0.015333f //x=48 //y=1.095 //x2=47.115 //y2=0.555
cc_6550 ( N_noxref_15_c_8631_n N_noxref_27_M29_noxref_s ) capacitor \
 c=0.00248746f //x=48 //y=1.44 //x2=47.115 //y2=0.555
cc_6551 ( N_noxref_15_c_8738_n N_noxref_28_c_13413_n ) capacitor c=0.00177186f \
 //x=55.62 //y=2.375 //x2=56.275 //y2=0.72
cc_6552 ( N_noxref_15_c_8786_n N_noxref_28_c_13413_n ) capacitor c=0.00117306f \
 //x=55.62 //y=2.26 //x2=56.275 //y2=0.72
cc_6553 ( N_noxref_15_c_8806_n N_noxref_28_c_13413_n ) capacitor c=0.0206349f \
 //x=55.61 //y=1.095 //x2=56.275 //y2=0.72
cc_6554 ( N_noxref_15_c_8934_n N_noxref_28_c_13413_n ) capacitor c=0.00825432f \
 //x=56.14 //y=1.095 //x2=56.275 //y2=0.72
cc_6555 ( N_noxref_15_c_8826_n N_noxref_28_c_13413_n ) capacitor c=2.20712e-19 \
 //x=55.62 //y=2.26 //x2=56.275 //y2=0.72
cc_6556 ( N_noxref_15_c_8807_n N_noxref_28_c_13416_n ) capacitor c=0.0071177f \
 //x=55.61 //y=1.44 //x2=55.39 //y2=1.175
cc_6557 ( N_noxref_15_c_8587_n N_noxref_28_M33_noxref_d ) capacitor \
 c=3.39394e-19 //x=51.11 //y=1.18 //x2=54.15 //y2=1.09
cc_6558 ( N_noxref_15_c_8806_n N_noxref_28_M34_noxref_s ) capacitor \
 c=0.0071177f //x=55.61 //y=1.095 //x2=55.255 //y2=0.555
cc_6559 ( N_noxref_15_c_8808_n N_noxref_28_M34_noxref_s ) capacitor \
 c=0.0071177f //x=55.61 //y=1.75 //x2=55.255 //y2=0.555
cc_6560 ( N_noxref_15_c_8934_n N_noxref_28_M34_noxref_s ) capacitor \
 c=0.015333f //x=56.14 //y=1.095 //x2=55.255 //y2=0.555
cc_6561 ( N_noxref_15_c_8936_n N_noxref_28_M34_noxref_s ) capacitor \
 c=0.00248746f //x=56.14 //y=1.44 //x2=55.255 //y2=0.555
cc_6562 ( N_noxref_15_c_8968_n N_noxref_29_c_13483_n ) capacitor c=0.0036878f \
 //x=60.685 //y=1.305 //x2=61.085 //y2=0.72
cc_6563 ( N_noxref_15_c_8981_n N_noxref_29_c_13483_n ) capacitor c=0.00399931f \
 //x=61.085 //y=1.845 //x2=61.085 //y2=0.72
cc_6564 ( N_noxref_15_M37_noxref_d N_noxref_29_c_13483_n ) capacitor \
 c=0.00910163f //x=60.495 //y=1.095 //x2=61.085 //y2=0.72
cc_6565 ( N_noxref_15_M37_noxref_d N_noxref_29_c_13488_n ) capacitor \
 c=0.00120711f //x=60.495 //y=1.095 //x2=60.2 //y2=1.175
cc_6566 ( N_noxref_15_c_8699_n N_noxref_29_M36_noxref_d ) capacitor \
 c=0.00132103f //x=59.39 //y=5.335 //x2=58.96 //y2=1.09
cc_6567 ( N_noxref_15_c_8968_n N_noxref_29_M36_noxref_d ) capacitor \
 c=0.00802836f //x=60.685 //y=1.305 //x2=58.96 //y2=1.09
cc_6568 ( N_noxref_15_c_8968_n N_noxref_29_M37_noxref_s ) capacitor \
 c=0.00993092f //x=60.685 //y=1.305 //x2=60.065 //y2=0.555
cc_6569 ( N_noxref_15_c_8976_n N_noxref_29_M37_noxref_s ) capacitor \
 c=0.0270624f //x=60.685 //y=1.76 //x2=60.065 //y2=0.555
cc_6570 ( N_noxref_15_c_8981_n N_noxref_29_M37_noxref_s ) capacitor \
 c=0.00871957f //x=61.085 //y=1.845 //x2=60.065 //y2=0.555
cc_6571 ( N_noxref_15_c_9009_n N_noxref_29_M37_noxref_s ) capacitor \
 c=0.0016218f //x=61.17 //y=3.51 //x2=60.065 //y2=0.555
cc_6572 ( N_noxref_15_M37_noxref_d N_noxref_29_M37_noxref_s ) capacitor \
 c=0.0279003f //x=60.495 //y=1.095 //x2=60.065 //y2=0.555
cc_6573 ( N_noxref_15_c_9012_n N_noxref_30_M41_noxref_d ) capacitor \
 c=3.39394e-19 //x=64.06 //y=1.18 //x2=67.1 //y2=1.09
cc_6574 ( N_noxref_15_c_9283_p N_noxref_32_c_13668_n ) capacitor c=0.00314988f \
 //x=82.475 //y=4.64 //x2=80.185 //y2=5.39
cc_6575 ( N_noxref_15_M151_noxref_g N_noxref_32_c_13668_n ) capacitor \
 c=0.00962216f //x=79.64 //y=6.205 //x2=80.185 //y2=5.39
cc_6576 ( N_noxref_15_c_9222_p N_noxref_32_c_13670_n ) capacitor c=0.00378061f \
 //x=82.63 //y=4.62 //x2=82.185 //y2=5.39
cc_6577 ( N_noxref_15_c_9283_p N_noxref_32_c_13670_n ) capacitor c=0.0894443f \
 //x=82.475 //y=4.64 //x2=82.185 //y2=5.39
cc_6578 ( N_noxref_15_M154_noxref_g N_noxref_32_c_13670_n ) capacitor \
 c=0.00366801f //x=82.52 //y=6.205 //x2=82.185 //y2=5.39
cc_6579 ( N_noxref_15_c_9283_p N_noxref_32_c_13673_n ) capacitor c=0.00878121f \
 //x=82.475 //y=4.64 //x2=80.415 //y2=5.39
cc_6580 ( N_noxref_15_c_9222_p N_noxref_32_c_13674_n ) capacitor c=8.16607e-19 \
 //x=82.63 //y=4.62 //x2=83.06 //y2=7.09
cc_6581 ( N_noxref_15_c_9223_p N_noxref_32_c_13674_n ) capacitor c=0.00566393f \
 //x=82.635 //y=4.64 //x2=83.06 //y2=7.09
cc_6582 ( N_noxref_15_c_9283_p N_noxref_32_c_13674_n ) capacitor c=5.18143e-19 \
 //x=82.475 //y=4.64 //x2=83.06 //y2=7.09
cc_6583 ( N_noxref_15_c_9224_p N_noxref_32_c_13674_n ) capacitor c=0.00134225f \
 //x=82.63 //y=4.62 //x2=83.06 //y2=7.09
cc_6584 ( N_noxref_15_M154_noxref_g N_noxref_32_c_13674_n ) capacitor \
 c=0.00985075f //x=82.52 //y=6.205 //x2=83.06 //y2=7.09
cc_6585 ( N_noxref_15_M155_noxref_g N_noxref_32_c_13674_n ) capacitor \
 c=0.00814026f //x=82.96 //y=6.205 //x2=83.06 //y2=7.09
cc_6586 ( N_noxref_15_c_9283_p N_noxref_32_c_13680_n ) capacitor c=0.0261994f \
 //x=82.475 //y=4.64 //x2=79.422 //y2=5.39
cc_6587 ( N_noxref_15_M150_noxref_g N_noxref_32_c_13680_n ) capacitor \
 c=0.0018075f //x=79.2 //y=6.205 //x2=79.422 //y2=5.39
cc_6588 ( N_noxref_15_M151_noxref_g N_noxref_32_c_13680_n ) capacitor \
 c=0.00310294f //x=79.64 //y=6.205 //x2=79.422 //y2=5.39
cc_6589 ( N_noxref_15_c_9345_p N_noxref_32_c_13680_n ) capacitor c=0.00218288f \
 //x=79.565 //y=4.975 //x2=79.422 //y2=5.39
cc_6590 ( N_noxref_15_M154_noxref_g N_noxref_32_c_13684_n ) capacitor \
 c=0.00395967f //x=82.52 //y=6.205 //x2=82.3 //y2=6.92
cc_6591 ( N_noxref_15_M155_noxref_g N_noxref_32_c_13685_n ) capacitor \
 c=0.00179771f //x=82.96 //y=6.205 //x2=83.177 //y2=7.09
cc_6592 ( N_noxref_15_M150_noxref_g N_noxref_32_c_13686_n ) capacitor \
 c=0.0161645f //x=79.2 //y=6.205 //x2=79.42 //y2=5.56
cc_6593 ( N_noxref_15_M151_noxref_g N_noxref_32_c_13686_n ) capacitor \
 c=0.0177598f //x=79.64 //y=6.205 //x2=79.42 //y2=5.56
cc_6594 ( N_noxref_15_c_9345_p N_noxref_32_c_13686_n ) capacitor c=0.00293723f \
 //x=79.565 //y=4.975 //x2=79.42 //y2=5.56
cc_6595 ( N_noxref_15_c_9283_p N_noxref_32_c_13689_n ) capacitor c=0.00371683f \
 //x=82.475 //y=4.64 //x2=80.3 //y2=5.39
cc_6596 ( N_noxref_15_c_9222_p N_noxref_32_c_13690_n ) capacitor c=8.93089e-19 \
 //x=82.63 //y=4.62 //x2=82.3 //y2=5.39
cc_6597 ( N_noxref_15_c_9283_p N_noxref_32_c_13690_n ) capacitor c=0.00277723f \
 //x=82.475 //y=4.64 //x2=82.3 //y2=5.39
cc_6598 ( N_noxref_15_M154_noxref_g N_noxref_32_c_13690_n ) capacitor \
 c=0.0503042f //x=82.52 //y=6.205 //x2=82.3 //y2=5.39
cc_6599 ( N_noxref_15_M150_noxref_g N_noxref_32_M150_noxref_d ) capacitor \
 c=0.00124621f //x=79.2 //y=6.205 //x2=79.275 //y2=5.205
cc_6600 ( N_noxref_15_M151_noxref_g N_noxref_32_M150_noxref_d ) capacitor \
 c=0.00125665f //x=79.64 //y=6.205 //x2=79.275 //y2=5.205
cc_6601 ( N_noxref_15_M155_noxref_g N_noxref_32_M155_noxref_d ) capacitor \
 c=0.0142133f //x=82.96 //y=6.205 //x2=83.035 //y2=5.205
cc_6602 ( N_noxref_15_M155_noxref_g N_noxref_33_c_13828_n ) capacitor \
 c=0.00969072f //x=82.96 //y=6.205 //x2=83.505 //y2=5.39
cc_6603 ( N_noxref_15_c_9222_p N_noxref_33_c_13829_n ) capacitor c=0.00879697f \
 //x=82.63 //y=4.62 //x2=82.74 //y2=5.39
cc_6604 ( N_noxref_15_c_9223_p N_noxref_33_c_13829_n ) capacitor c=0.00708476f \
 //x=82.635 //y=4.64 //x2=82.74 //y2=5.39
cc_6605 ( N_noxref_15_c_9224_p N_noxref_33_c_13829_n ) capacitor c=0.00212816f \
 //x=82.63 //y=4.62 //x2=82.74 //y2=5.39
cc_6606 ( N_noxref_15_M154_noxref_g N_noxref_33_c_13829_n ) capacitor \
 c=0.00349804f //x=82.52 //y=6.205 //x2=82.74 //y2=5.39
cc_6607 ( N_noxref_15_M155_noxref_g N_noxref_33_c_13829_n ) capacitor \
 c=0.00297228f //x=82.96 //y=6.205 //x2=82.74 //y2=5.39
cc_6608 ( N_noxref_15_c_9225_p N_noxref_33_c_13829_n ) capacitor c=0.00149603f \
 //x=82.63 //y=4.885 //x2=82.74 //y2=5.39
cc_6609 ( N_noxref_15_c_9222_p N_noxref_33_c_13835_n ) capacitor c=0.0012994f \
 //x=82.63 //y=4.62 //x2=82.74 //y2=5.56
cc_6610 ( N_noxref_15_c_9224_p N_noxref_33_c_13835_n ) capacitor c=0.00447469f \
 //x=82.63 //y=4.62 //x2=82.74 //y2=5.56
cc_6611 ( N_noxref_15_M154_noxref_g N_noxref_33_c_13835_n ) capacitor \
 c=0.0120591f //x=82.52 //y=6.205 //x2=82.74 //y2=5.56
cc_6612 ( N_noxref_15_M155_noxref_g N_noxref_33_c_13835_n ) capacitor \
 c=0.0142133f //x=82.96 //y=6.205 //x2=82.74 //y2=5.56
cc_6613 ( N_noxref_15_c_9225_p N_noxref_33_c_13835_n ) capacitor c=0.00417478f \
 //x=82.63 //y=4.885 //x2=82.74 //y2=5.56
cc_6614 ( N_noxref_15_c_8554_n N_GND_c_14310_n ) capacitor c=0.00196498f \
 //x=47.48 //y=2.375 //x2=50.055 //y2=0.175
cc_6615 ( N_noxref_15_c_8654_n N_GND_c_14350_n ) capacitor c=0.00608539f \
 //x=51.465 //y=1.835 //x2=53.28 //y2=0.175
cc_6616 ( N_noxref_15_c_8587_n N_GND_c_14350_n ) capacitor c=0.00942392f \
 //x=51.11 //y=1.18 //x2=53.28 //y2=0.175
cc_6617 ( N_noxref_15_M31_noxref_d N_GND_c_14350_n ) capacitor c=3.01769e-19 \
 //x=50.92 //y=1.085 //x2=53.28 //y2=0.175
cc_6618 ( N_noxref_15_c_8738_n N_GND_c_14416_n ) capacitor c=0.00196498f \
 //x=55.62 //y=2.375 //x2=58.09 //y2=0.175
cc_6619 ( N_noxref_15_c_8968_n N_GND_c_14392_n ) capacitor c=0.00883621f \
 //x=60.685 //y=1.305 //x2=63.005 //y2=0.175
cc_6620 ( N_noxref_15_c_8981_n N_GND_c_14392_n ) capacitor c=0.00662992f \
 //x=61.085 //y=1.845 //x2=63.005 //y2=0.175
cc_6621 ( N_noxref_15_c_8856_n N_GND_c_14392_n ) capacitor c=2.94824e-19 \
 //x=61.17 //y=3.67 //x2=63.005 //y2=0.175
cc_6622 ( N_noxref_15_M37_noxref_d N_GND_c_14392_n ) capacitor c=2.9462e-19 \
 //x=60.495 //y=1.095 //x2=63.005 //y2=0.175
cc_6623 ( N_noxref_15_c_9096_n N_GND_c_14511_n ) capacitor c=0.00608539f \
 //x=64.415 //y=1.835 //x2=66.23 //y2=0.175
cc_6624 ( N_noxref_15_c_8862_n N_GND_c_14511_n ) capacitor c=2.7199e-19 \
 //x=64.5 //y=3.675 //x2=66.23 //y2=0.175
cc_6625 ( N_noxref_15_c_9012_n N_GND_c_14511_n ) capacitor c=0.00928865f \
 //x=64.06 //y=1.18 //x2=66.23 //y2=0.175
cc_6626 ( N_noxref_15_M39_noxref_d N_GND_c_14511_n ) capacitor c=3.01769e-19 \
 //x=63.87 //y=1.085 //x2=66.23 //y2=0.175
cc_6627 ( N_noxref_15_c_8809_n N_GND_c_14656_n ) capacitor c=3.92414e-19 \
 //x=66.05 //y=1.055 //x2=66.315 //y2=1.015
cc_6628 ( N_noxref_15_c_9669_p N_GND_c_14656_n ) capacitor c=0.0085115f \
 //x=66.425 //y=0.9 //x2=66.315 //y2=1.015
cc_6629 ( N_noxref_15_c_8815_n N_GND_c_14656_n ) capacitor c=4.45447e-19 \
 //x=66.58 //y=1.055 //x2=66.315 //y2=1.015
cc_6630 ( N_noxref_15_c_9277_p N_GND_c_14578_n ) capacitor c=0.0018156f \
 //x=78.93 //y=2.375 //x2=79.285 //y2=0.175
cc_6631 ( N_noxref_15_c_9272_p N_GND_c_14578_n ) capacitor c=4.89705e-19 \
 //x=78.93 //y=3.67 //x2=79.285 //y2=0.175
cc_6632 ( N_noxref_15_c_9377_p N_GND_c_14661_n ) capacitor c=0.00173845f \
 //x=79.105 //y=1.045 //x2=79.37 //y2=1.015
cc_6633 ( N_noxref_15_c_9378_p N_GND_c_14661_n ) capacitor c=0.00322563f \
 //x=79.105 //y=1.39 //x2=79.37 //y2=1.015
cc_6634 ( N_noxref_15_c_9380_p N_GND_c_14661_n ) capacitor c=3.46977e-19 \
 //x=79.105 //y=1.7 //x2=79.37 //y2=1.015
cc_6635 ( N_noxref_15_c_9676_p N_GND_c_14661_n ) capacitor c=0.00931467f \
 //x=79.48 //y=0.89 //x2=79.37 //y2=1.015
cc_6636 ( N_noxref_15_c_9677_p N_GND_c_14661_n ) capacitor c=7.91264e-19 \
 //x=79.48 //y=1.545 //x2=79.37 //y2=1.015
cc_6637 ( N_noxref_15_c_9379_p N_GND_c_14661_n ) capacitor c=0.00205853f \
 //x=79.635 //y=1.045 //x2=79.37 //y2=1.015
cc_6638 ( N_noxref_15_c_9381_p N_GND_c_14661_n ) capacitor c=0.00402706f \
 //x=79.635 //y=1.39 //x2=79.37 //y2=1.015
cc_6639 ( N_noxref_15_c_9216_p N_GND_c_14668_n ) capacitor c=0.00457696f \
 //x=82.63 //y=2.385 //x2=82.7 //y2=1.015
cc_6640 ( N_noxref_15_c_9218_p N_GND_c_14668_n ) capacitor c=6.39474e-19 \
 //x=82.63 //y=2.26 //x2=82.7 //y2=1.015
cc_6641 ( N_noxref_15_c_9296_p N_GND_c_14668_n ) capacitor c=0.00174813f \
 //x=82.435 //y=1.045 //x2=82.7 //y2=1.015
cc_6642 ( N_noxref_15_c_9297_p N_GND_c_14668_n ) capacitor c=0.00357265f \
 //x=82.435 //y=1.39 //x2=82.7 //y2=1.015
cc_6643 ( N_noxref_15_c_9299_p N_GND_c_14668_n ) capacitor c=2.40811e-19 \
 //x=82.435 //y=1.7 //x2=82.7 //y2=1.015
cc_6644 ( N_noxref_15_c_9685_p N_GND_c_14668_n ) capacitor c=0.00937204f \
 //x=82.81 //y=0.89 //x2=82.7 //y2=1.015
cc_6645 ( N_noxref_15_c_9686_p N_GND_c_14668_n ) capacitor c=0.0022097f \
 //x=82.81 //y=1.545 //x2=82.7 //y2=1.015
cc_6646 ( N_noxref_15_c_9298_p N_GND_c_14668_n ) capacitor c=0.0019028f \
 //x=82.965 //y=1.045 //x2=82.7 //y2=1.015
cc_6647 ( N_noxref_15_c_9300_p N_GND_c_14668_n ) capacitor c=0.00374554f \
 //x=82.965 //y=1.39 //x2=82.7 //y2=1.015
cc_6648 ( N_noxref_15_c_8579_n N_GND_c_14314_n ) capacitor c=6.9353e-19 \
 //x=50.19 //y=5.56 //x2=50.14 //y2=1.135
cc_6649 ( N_noxref_15_c_8587_n N_GND_c_14314_n ) capacitor c=0.0140211f \
 //x=51.11 //y=1.18 //x2=50.14 //y2=1.135
cc_6650 ( N_noxref_15_M31_noxref_d N_GND_c_14314_n ) capacitor c=2.93544e-19 \
 //x=50.92 //y=1.085 //x2=50.14 //y2=1.135
cc_6651 ( N_noxref_15_c_8587_n N_GND_c_14529_n ) capacitor c=0.00606355f \
 //x=51.11 //y=1.18 //x2=53.365 //y2=1.145
cc_6652 ( N_noxref_15_c_8968_n N_GND_c_14531_n ) capacitor c=0.00488628f \
 //x=60.685 //y=1.305 //x2=63.09 //y2=1.135
cc_6653 ( N_noxref_15_c_9010_n N_GND_c_14531_n ) capacitor c=0.00645051f \
 //x=63.02 //y=2.26 //x2=63.09 //y2=1.135
cc_6654 ( N_noxref_15_c_8772_n N_GND_c_14531_n ) capacitor c=6.80717e-19 \
 //x=63.14 //y=5.56 //x2=63.09 //y2=1.135
cc_6655 ( N_noxref_15_c_9012_n N_GND_c_14531_n ) capacitor c=0.0140211f \
 //x=64.06 //y=1.18 //x2=63.09 //y2=1.135
cc_6656 ( N_noxref_15_c_9040_n N_GND_c_14531_n ) capacitor c=2.13705e-19 \
 //x=63.02 //y=2.26 //x2=63.09 //y2=1.135
cc_6657 ( N_noxref_15_c_9192_n N_GND_c_14531_n ) capacitor c=0.00176535f \
 //x=62.825 //y=1.045 //x2=63.09 //y2=1.135
cc_6658 ( N_noxref_15_c_9193_n N_GND_c_14531_n ) capacitor c=0.0036005f \
 //x=62.825 //y=1.39 //x2=63.09 //y2=1.135
cc_6659 ( N_noxref_15_c_9194_n N_GND_c_14531_n ) capacitor c=4.2764e-19 \
 //x=62.825 //y=1.7 //x2=63.09 //y2=1.135
cc_6660 ( N_noxref_15_c_9701_p N_GND_c_14531_n ) capacitor c=9.36995e-19 \
 //x=63.2 //y=0.89 //x2=63.09 //y2=1.135
cc_6661 ( N_noxref_15_c_9702_p N_GND_c_14531_n ) capacitor c=6.27472e-19 \
 //x=63.2 //y=1.545 //x2=63.09 //y2=1.135
cc_6662 ( N_noxref_15_c_9200_n N_GND_c_14531_n ) capacitor c=0.00171483f \
 //x=63.355 //y=1.045 //x2=63.09 //y2=1.135
cc_6663 ( N_noxref_15_c_9202_n N_GND_c_14531_n ) capacitor c=0.00296337f \
 //x=63.355 //y=1.39 //x2=63.09 //y2=1.135
cc_6664 ( N_noxref_15_M39_noxref_d N_GND_c_14531_n ) capacitor c=2.93544e-19 \
 //x=63.87 //y=1.085 //x2=63.09 //y2=1.135
cc_6665 ( N_noxref_15_c_9192_n N_GND_c_14694_n ) capacitor c=3.51399e-19 \
 //x=62.825 //y=1.045 //x2=63.087 //y2=1.005
cc_6666 ( N_noxref_15_c_9701_p N_GND_c_14694_n ) capacitor c=0.00850983f \
 //x=63.2 //y=0.89 //x2=63.087 //y2=1.005
cc_6667 ( N_noxref_15_c_9200_n N_GND_c_14694_n ) capacitor c=4.40196e-19 \
 //x=63.355 //y=1.045 //x2=63.087 //y2=1.005
cc_6668 ( N_noxref_15_c_8754_n N_GND_c_14532_n ) capacitor c=0.00772482f \
 //x=66.35 //y=2.375 //x2=66.315 //y2=1.145
cc_6669 ( N_noxref_15_c_8759_n N_GND_c_14532_n ) capacitor c=7.58937e-19 \
 //x=66.35 //y=3.675 //x2=66.315 //y2=1.145
cc_6670 ( N_noxref_15_c_9012_n N_GND_c_14532_n ) capacitor c=0.00606355f \
 //x=64.06 //y=1.18 //x2=66.315 //y2=1.145
cc_6671 ( N_noxref_15_c_8793_n N_GND_c_14532_n ) capacitor c=2.22883e-19 \
 //x=66.35 //y=2.26 //x2=66.315 //y2=1.145
cc_6672 ( N_noxref_15_c_8809_n N_GND_c_14532_n ) capacitor c=0.0015128f \
 //x=66.05 //y=1.055 //x2=66.315 //y2=1.145
cc_6673 ( N_noxref_15_c_8810_n N_GND_c_14532_n ) capacitor c=0.00350108f \
 //x=66.05 //y=1.4 //x2=66.315 //y2=1.145
cc_6674 ( N_noxref_15_c_8811_n N_GND_c_14532_n ) capacitor c=4.28277e-19 \
 //x=66.05 //y=1.71 //x2=66.315 //y2=1.145
cc_6675 ( N_noxref_15_c_9669_p N_GND_c_14532_n ) capacitor c=9.36995e-19 \
 //x=66.425 //y=0.9 //x2=66.315 //y2=1.145
cc_6676 ( N_noxref_15_c_9717_p N_GND_c_14532_n ) capacitor c=5.79535e-19 \
 //x=66.425 //y=1.555 //x2=66.315 //y2=1.145
cc_6677 ( N_noxref_15_c_8815_n N_GND_c_14532_n ) capacitor c=0.0017438f \
 //x=66.58 //y=1.055 //x2=66.315 //y2=1.145
cc_6678 ( N_noxref_15_c_8817_n N_GND_c_14532_n ) capacitor c=0.00276804f \
 //x=66.58 //y=1.4 //x2=66.315 //y2=1.145
cc_6679 ( N_noxref_15_c_8554_n N_GND_c_14283_n ) capacitor c=2.016e-19 \
 //x=47.48 //y=2.375 //x2=48.79 //y2=0.175
cc_6680 ( N_noxref_15_c_8654_n N_GND_c_14328_n ) capacitor c=7.75992e-19 \
 //x=51.465 //y=1.835 //x2=52.12 //y2=0.175
cc_6681 ( N_noxref_15_c_8738_n N_GND_c_14449_n ) capacitor c=2.016e-19 \
 //x=55.62 //y=2.375 //x2=56.93 //y2=0.175
cc_6682 ( N_noxref_15_c_8981_n N_GND_c_14450_n ) capacitor c=6.86343e-19 \
 //x=61.085 //y=1.845 //x2=61.74 //y2=0.175
cc_6683 ( N_noxref_15_c_8856_n N_GND_c_14450_n ) capacitor c=4.02711e-19 \
 //x=61.17 //y=3.67 //x2=61.74 //y2=0.175
cc_6684 ( N_noxref_15_c_9096_n N_GND_c_14605_n ) capacitor c=7.75992e-19 \
 //x=64.415 //y=1.835 //x2=65.07 //y2=0.175
cc_6685 ( N_noxref_15_c_8862_n N_GND_c_14605_n ) capacitor c=3.21092e-19 \
 //x=64.5 //y=3.675 //x2=65.07 //y2=0.175
cc_6686 ( N_noxref_15_c_9192_n N_GND_c_14605_n ) capacitor c=0.00688027f \
 //x=62.825 //y=1.045 //x2=65.07 //y2=0.175
cc_6687 ( N_noxref_15_c_8809_n N_GND_c_14606_n ) capacitor c=0.00677932f \
 //x=66.05 //y=1.055 //x2=69.88 //y2=0.175
cc_6688 ( N_noxref_15_c_9272_p N_GND_c_14717_n ) capacitor c=3.08176e-19 \
 //x=78.93 //y=3.67 //x2=81.35 //y2=0.175
cc_6689 ( N_noxref_15_c_9377_p N_GND_c_14717_n ) capacitor c=0.00694747f \
 //x=79.105 //y=1.045 //x2=81.35 //y2=0.175
cc_6690 ( N_noxref_15_c_9296_p N_GND_c_14719_n ) capacitor c=0.00688488f \
 //x=82.435 //y=1.045 //x2=84.68 //y2=0.175
cc_6691 ( N_noxref_15_c_8574_n N_GND_c_14329_n ) capacitor c=9.32616e-19 \
 //x=51.55 //y=3.37 //x2=48.96 //y2=0.175
cc_6692 ( N_noxref_15_c_8601_n N_GND_c_14329_n ) capacitor c=0.00222376f \
 //x=47.48 //y=2.26 //x2=48.96 //y2=0.175
cc_6693 ( N_noxref_15_c_8631_n N_GND_c_14329_n ) capacitor c=0.00262688f \
 //x=48 //y=1.44 //x2=48.96 //y2=0.175
cc_6694 ( N_noxref_15_c_8635_n N_GND_c_14329_n ) capacitor c=2.63786e-19 \
 //x=47.48 //y=2.26 //x2=48.96 //y2=0.175
cc_6695 ( N_noxref_15_c_8572_n N_GND_c_14376_n ) capacitor c=0.00460657f \
 //x=51.11 //y=1.75 //x2=52.29 //y2=0.175
cc_6696 ( N_noxref_15_c_8654_n N_GND_c_14376_n ) capacitor c=0.0287655f \
 //x=51.465 //y=1.835 //x2=52.29 //y2=0.175
cc_6697 ( N_noxref_15_c_8786_n N_GND_c_14409_n ) capacitor c=0.00222376f \
 //x=55.62 //y=2.26 //x2=57.1 //y2=0.175
cc_6698 ( N_noxref_15_c_8936_n N_GND_c_14409_n ) capacitor c=0.00262688f \
 //x=56.14 //y=1.44 //x2=57.1 //y2=0.175
cc_6699 ( N_noxref_15_c_8826_n N_GND_c_14409_n ) capacitor c=2.63786e-19 \
 //x=55.62 //y=2.26 //x2=57.1 //y2=0.175
cc_6700 ( N_noxref_15_c_8976_n N_GND_c_14411_n ) capacitor c=0.00285697f \
 //x=60.685 //y=1.76 //x2=61.91 //y2=0.175
cc_6701 ( N_noxref_15_c_8981_n N_GND_c_14411_n ) capacitor c=0.0299617f \
 //x=61.085 //y=1.845 //x2=61.91 //y2=0.175
cc_6702 ( N_noxref_15_c_8995_n N_GND_c_14411_n ) capacitor c=0.00781993f \
 //x=63.02 //y=3.35 //x2=61.91 //y2=0.175
cc_6703 ( N_noxref_15_c_8751_n N_GND_c_14411_n ) capacitor c=9.32616e-19 \
 //x=64.5 //y=3.355 //x2=61.91 //y2=0.175
cc_6704 ( N_noxref_15_c_9010_n N_GND_c_14411_n ) capacitor c=0.00386815f \
 //x=63.02 //y=2.26 //x2=61.91 //y2=0.175
cc_6705 ( N_noxref_15_c_9040_n N_GND_c_14411_n ) capacitor c=0.00371068f \
 //x=63.02 //y=2.26 //x2=61.91 //y2=0.175
cc_6706 ( N_noxref_15_c_9194_n N_GND_c_14411_n ) capacitor c=0.0015404f \
 //x=62.825 //y=1.7 //x2=61.91 //y2=0.175
cc_6707 ( N_noxref_15_c_9048_n N_GND_c_14411_n ) capacitor c=0.0093907f \
 //x=62.825 //y=2.095 //x2=61.91 //y2=0.175
cc_6708 ( N_noxref_15_c_9090_n N_GND_c_14562_n ) capacitor c=0.00460657f \
 //x=64.06 //y=1.75 //x2=65.24 //y2=0.175
cc_6709 ( N_noxref_15_c_9096_n N_GND_c_14562_n ) capacitor c=0.0300371f \
 //x=64.415 //y=1.835 //x2=65.24 //y2=0.175
cc_6710 ( N_noxref_15_c_8754_n N_GND_c_14562_n ) capacitor c=0.00380125f \
 //x=66.35 //y=2.375 //x2=65.24 //y2=0.175
cc_6711 ( N_noxref_15_c_8757_n N_GND_c_14562_n ) capacitor c=0.0109665f \
 //x=66.35 //y=3.355 //x2=65.24 //y2=0.175
cc_6712 ( N_noxref_15_c_8793_n N_GND_c_14562_n ) capacitor c=0.00379568f \
 //x=66.35 //y=2.26 //x2=65.24 //y2=0.175
cc_6713 ( N_noxref_15_c_8811_n N_GND_c_14562_n ) capacitor c=0.00170145f \
 //x=66.05 //y=1.71 //x2=65.24 //y2=0.175
cc_6714 ( N_noxref_15_c_8812_n N_GND_c_14562_n ) capacitor c=0.0102191f \
 //x=66.05 //y=2.095 //x2=65.24 //y2=0.175
cc_6715 ( N_noxref_15_c_9277_p N_GND_c_14627_n ) capacitor c=0.00524403f \
 //x=78.93 //y=2.375 //x2=78.19 //y2=0.175
cc_6716 ( N_noxref_15_c_9120_n N_GND_c_14627_n ) capacitor c=0.0123753f \
 //x=78.93 //y=3.35 //x2=78.19 //y2=0.175
cc_6717 ( N_noxref_15_c_9325_p N_GND_c_14627_n ) capacitor c=0.00735219f \
 //x=78.93 //y=2.26 //x2=78.19 //y2=0.175
cc_6718 ( N_noxref_15_c_9380_p N_GND_c_14627_n ) capacitor c=0.0015404f \
 //x=79.105 //y=1.7 //x2=78.19 //y2=0.175
cc_6719 ( N_noxref_15_c_9383_p N_GND_c_14627_n ) capacitor c=0.00366398f \
 //x=79.105 //y=2.095 //x2=78.19 //y2=0.175
cc_6720 ( N_noxref_15_c_9326_p N_GND_c_14627_n ) capacitor c=0.00800764f \
 //x=78.93 //y=2.26 //x2=78.19 //y2=0.175
cc_6721 ( N_noxref_15_c_9216_p N_GND_c_14750_n ) capacitor c=0.00537602f \
 //x=82.63 //y=2.385 //x2=81.52 //y2=0.175
cc_6722 ( N_noxref_15_c_9217_p N_GND_c_14750_n ) capacitor c=0.00917348f \
 //x=82.63 //y=4.475 //x2=81.52 //y2=0.175
cc_6723 ( N_noxref_15_c_9218_p N_GND_c_14750_n ) capacitor c=0.00369534f \
 //x=82.63 //y=2.26 //x2=81.52 //y2=0.175
cc_6724 ( N_noxref_15_c_9289_p N_GND_c_14750_n ) capacitor c=0.00956283f \
 //x=82.435 //y=2.095 //x2=81.52 //y2=0.175
cc_6725 ( N_noxref_15_c_8587_n N_GND_M30_noxref_d ) capacitor c=2.82748e-19 \
 //x=51.11 //y=1.18 //x2=49.95 //y2=1.045
cc_6726 ( N_noxref_15_c_9010_n N_GND_M38_noxref_d ) capacitor c=2.20438e-19 \
 //x=63.02 //y=2.26 //x2=62.9 //y2=1.045
cc_6727 ( N_noxref_15_c_9012_n N_GND_M38_noxref_d ) capacitor c=2.82748e-19 \
 //x=64.06 //y=1.18 //x2=62.9 //y2=1.045
cc_6728 ( N_noxref_15_c_9192_n N_GND_M38_noxref_d ) capacitor c=0.00192399f \
 //x=62.825 //y=1.045 //x2=62.9 //y2=1.045
cc_6729 ( N_noxref_15_c_9193_n N_GND_M38_noxref_d ) capacitor c=0.00210798f \
 //x=62.825 //y=1.39 //x2=62.9 //y2=1.045
cc_6730 ( N_noxref_15_c_9701_p N_GND_M38_noxref_d ) capacitor c=0.00472259f \
 //x=63.2 //y=0.89 //x2=62.9 //y2=1.045
cc_6731 ( N_noxref_15_c_9702_p N_GND_M38_noxref_d ) capacitor c=0.00166857f \
 //x=63.2 //y=1.545 //x2=62.9 //y2=1.045
cc_6732 ( N_noxref_15_c_9200_n N_GND_M38_noxref_d ) capacitor c=0.00230174f \
 //x=63.355 //y=1.045 //x2=62.9 //y2=1.045
cc_6733 ( N_noxref_15_c_9202_n N_GND_M38_noxref_d ) capacitor c=0.00210798f \
 //x=63.355 //y=1.39 //x2=62.9 //y2=1.045
cc_6734 ( N_noxref_15_c_8754_n N_GND_M40_noxref_d ) capacitor c=4.4417e-19 \
 //x=66.35 //y=2.375 //x2=66.125 //y2=1.055
cc_6735 ( N_noxref_15_c_8809_n N_GND_M40_noxref_d ) capacitor c=0.00184354f \
 //x=66.05 //y=1.055 //x2=66.125 //y2=1.055
cc_6736 ( N_noxref_15_c_8810_n N_GND_M40_noxref_d ) capacitor c=0.00210798f \
 //x=66.05 //y=1.4 //x2=66.125 //y2=1.055
cc_6737 ( N_noxref_15_c_9669_p N_GND_M40_noxref_d ) capacitor c=0.00474029f \
 //x=66.425 //y=0.9 //x2=66.125 //y2=1.055
cc_6738 ( N_noxref_15_c_9717_p N_GND_M40_noxref_d ) capacitor c=0.00166857f \
 //x=66.425 //y=1.555 //x2=66.125 //y2=1.055
cc_6739 ( N_noxref_15_c_8815_n N_GND_M40_noxref_d ) capacitor c=0.00230174f \
 //x=66.58 //y=1.055 //x2=66.125 //y2=1.055
cc_6740 ( N_noxref_15_c_8817_n N_GND_M40_noxref_d ) capacitor c=0.00210798f \
 //x=66.58 //y=1.4 //x2=66.125 //y2=1.055
cc_6741 ( N_noxref_15_c_9377_p N_GND_M48_noxref_d ) capacitor c=0.00192399f \
 //x=79.105 //y=1.045 //x2=79.18 //y2=1.045
cc_6742 ( N_noxref_15_c_9378_p N_GND_M48_noxref_d ) capacitor c=0.00210798f \
 //x=79.105 //y=1.39 //x2=79.18 //y2=1.045
cc_6743 ( N_noxref_15_c_9676_p N_GND_M48_noxref_d ) capacitor c=0.00472259f \
 //x=79.48 //y=0.89 //x2=79.18 //y2=1.045
cc_6744 ( N_noxref_15_c_9677_p N_GND_M48_noxref_d ) capacitor c=0.00166857f \
 //x=79.48 //y=1.545 //x2=79.18 //y2=1.045
cc_6745 ( N_noxref_15_c_9379_p N_GND_M48_noxref_d ) capacitor c=0.00230174f \
 //x=79.635 //y=1.045 //x2=79.18 //y2=1.045
cc_6746 ( N_noxref_15_c_9381_p N_GND_M48_noxref_d ) capacitor c=0.00210798f \
 //x=79.635 //y=1.39 //x2=79.18 //y2=1.045
cc_6747 ( N_noxref_15_c_9216_p N_GND_M50_noxref_d ) capacitor c=4.20217e-19 \
 //x=82.63 //y=2.385 //x2=82.51 //y2=1.045
cc_6748 ( N_noxref_15_c_9296_p N_GND_M50_noxref_d ) capacitor c=0.00192399f \
 //x=82.435 //y=1.045 //x2=82.51 //y2=1.045
cc_6749 ( N_noxref_15_c_9297_p N_GND_M50_noxref_d ) capacitor c=0.00228784f \
 //x=82.435 //y=1.39 //x2=82.51 //y2=1.045
cc_6750 ( N_noxref_15_c_9685_p N_GND_M50_noxref_d ) capacitor c=0.0047434f \
 //x=82.81 //y=0.89 //x2=82.51 //y2=1.045
cc_6751 ( N_noxref_15_c_9686_p N_GND_M50_noxref_d ) capacitor c=0.00172481f \
 //x=82.81 //y=1.545 //x2=82.51 //y2=1.045
cc_6752 ( N_noxref_15_c_9298_p N_GND_M50_noxref_d ) capacitor c=0.00230174f \
 //x=82.965 //y=1.045 //x2=82.51 //y2=1.045
cc_6753 ( N_noxref_15_c_9300_p N_GND_M50_noxref_d ) capacitor c=0.00228784f \
 //x=82.965 //y=1.39 //x2=82.51 //y2=1.045
cc_6754 ( N_noxref_15_c_8573_n N_noxref_46_c_16208_n ) capacitor c=0.00911405f \
 //x=51.195 //y=1.835 //x2=50.625 //y2=1.675
cc_6755 ( N_noxref_15_c_8654_n N_noxref_46_c_16216_n ) capacitor c=0.00399245f \
 //x=51.465 //y=1.835 //x2=51.51 //y2=0.71
cc_6756 ( N_noxref_15_c_8587_n N_noxref_46_c_16216_n ) capacitor c=0.003751f \
 //x=51.11 //y=1.18 //x2=51.51 //y2=0.71
cc_6757 ( N_noxref_15_M31_noxref_d N_noxref_46_c_16216_n ) capacitor \
 c=0.00910163f //x=50.92 //y=1.085 //x2=51.51 //y2=0.71
cc_6758 ( N_noxref_15_c_8572_n N_noxref_46_M30_noxref_s ) capacitor \
 c=0.0175063f //x=51.11 //y=1.75 //x2=49.52 //y2=0.545
cc_6759 ( N_noxref_15_c_8654_n N_noxref_46_M30_noxref_s ) capacitor \
 c=0.00640979f //x=51.465 //y=1.835 //x2=49.52 //y2=0.545
cc_6760 ( N_noxref_15_c_8661_n N_noxref_46_M30_noxref_s ) capacitor \
 c=4.10848e-19 //x=51.55 //y=3.69 //x2=49.52 //y2=0.545
cc_6761 ( N_noxref_15_c_8587_n N_noxref_46_M30_noxref_s ) capacitor \
 c=0.0089443f //x=51.11 //y=1.18 //x2=49.52 //y2=0.545
cc_6762 ( N_noxref_15_c_8679_n N_noxref_46_M30_noxref_s ) capacitor \
 c=0.0010514f //x=51.55 //y=3.51 //x2=49.52 //y2=0.545
cc_6763 ( N_noxref_15_M31_noxref_d N_noxref_46_M30_noxref_s ) capacitor \
 c=0.0275552f //x=50.92 //y=1.085 //x2=49.52 //y2=0.545
cc_6764 ( N_noxref_15_c_9048_n N_noxref_49_c_16385_n ) capacitor c=0.00262672f \
 //x=62.825 //y=2.095 //x2=62.605 //y2=1.675
cc_6765 ( N_noxref_15_c_8860_n N_noxref_49_c_16386_n ) capacitor c=0.00406558f \
 //x=63.02 //y=3.67 //x2=63.49 //y2=1.76
cc_6766 ( N_noxref_15_c_9010_n N_noxref_49_c_16386_n ) capacitor c=0.00509504f \
 //x=63.02 //y=2.26 //x2=63.49 //y2=1.76
cc_6767 ( N_noxref_15_c_9040_n N_noxref_49_c_16386_n ) capacitor c=0.00763108f \
 //x=63.02 //y=2.26 //x2=63.49 //y2=1.76
cc_6768 ( N_noxref_15_c_9194_n N_noxref_49_c_16386_n ) capacitor c=0.00697076f \
 //x=62.825 //y=1.7 //x2=63.49 //y2=1.76
cc_6769 ( N_noxref_15_c_9048_n N_noxref_49_c_16386_n ) capacitor c=0.0170561f \
 //x=62.825 //y=2.095 //x2=63.49 //y2=1.76
cc_6770 ( N_noxref_15_c_9702_p N_noxref_49_c_16386_n ) capacitor c=0.00723574f \
 //x=63.2 //y=1.545 //x2=63.49 //y2=1.76
cc_6771 ( N_noxref_15_c_9202_n N_noxref_49_c_16386_n ) capacitor c=0.00339872f \
 //x=63.355 //y=1.39 //x2=63.49 //y2=1.76
cc_6772 ( N_noxref_15_c_8997_n N_noxref_49_c_16387_n ) capacitor c=0.00911405f \
 //x=64.145 //y=1.835 //x2=63.575 //y2=1.675
cc_6773 ( N_noxref_15_c_9048_n N_noxref_49_c_16387_n ) capacitor c=6.71402e-19 \
 //x=62.825 //y=2.095 //x2=63.575 //y2=1.675
cc_6774 ( N_noxref_15_c_9096_n N_noxref_49_c_16388_n ) capacitor c=0.00399245f \
 //x=64.415 //y=1.835 //x2=64.46 //y2=0.71
cc_6775 ( N_noxref_15_c_9012_n N_noxref_49_c_16388_n ) capacitor c=0.003751f \
 //x=64.06 //y=1.18 //x2=64.46 //y2=0.71
cc_6776 ( N_noxref_15_M39_noxref_d N_noxref_49_c_16388_n ) capacitor \
 c=0.00910163f //x=63.87 //y=1.085 //x2=64.46 //y2=0.71
cc_6777 ( N_noxref_15_c_9090_n N_noxref_49_M38_noxref_s ) capacitor \
 c=0.0175063f //x=64.06 //y=1.75 //x2=62.47 //y2=0.545
cc_6778 ( N_noxref_15_c_9096_n N_noxref_49_M38_noxref_s ) capacitor \
 c=0.00640979f //x=64.415 //y=1.835 //x2=62.47 //y2=0.545
cc_6779 ( N_noxref_15_c_8862_n N_noxref_49_M38_noxref_s ) capacitor \
 c=4.15501e-19 //x=64.5 //y=3.675 //x2=62.47 //y2=0.545
cc_6780 ( N_noxref_15_c_9012_n N_noxref_49_M38_noxref_s ) capacitor \
 c=0.0089443f //x=64.06 //y=1.18 //x2=62.47 //y2=0.545
cc_6781 ( N_noxref_15_c_9144_n N_noxref_49_M38_noxref_s ) capacitor \
 c=0.0010514f //x=64.5 //y=3.51 //x2=62.47 //y2=0.545
cc_6782 ( N_noxref_15_c_9192_n N_noxref_49_M38_noxref_s ) capacitor \
 c=0.0295366f //x=62.825 //y=1.045 //x2=62.47 //y2=0.545
cc_6783 ( N_noxref_15_c_9194_n N_noxref_49_M38_noxref_s ) capacitor \
 c=3.48408e-19 //x=62.825 //y=1.7 //x2=62.47 //y2=0.545
cc_6784 ( N_noxref_15_c_9200_n N_noxref_49_M38_noxref_s ) capacitor \
 c=0.0125442f //x=63.355 //y=1.045 //x2=62.47 //y2=0.545
cc_6785 ( N_noxref_15_M39_noxref_d N_noxref_49_M38_noxref_s ) capacitor \
 c=0.0275552f //x=63.87 //y=1.085 //x2=62.47 //y2=0.545
cc_6786 ( N_noxref_15_c_8812_n N_noxref_50_c_16462_n ) capacitor c=0.00262672f \
 //x=66.05 //y=2.095 //x2=65.83 //y2=1.685
cc_6787 ( N_noxref_15_c_8754_n N_noxref_50_c_16463_n ) capacitor c=0.00428451f \
 //x=66.35 //y=2.375 //x2=66.715 //y2=1.77
cc_6788 ( N_noxref_15_c_8759_n N_noxref_50_c_16463_n ) capacitor c=0.00270049f \
 //x=66.35 //y=3.675 //x2=66.715 //y2=1.77
cc_6789 ( N_noxref_15_c_8793_n N_noxref_50_c_16463_n ) capacitor c=0.0104666f \
 //x=66.35 //y=2.26 //x2=66.715 //y2=1.77
cc_6790 ( N_noxref_15_c_8811_n N_noxref_50_c_16463_n ) capacitor c=0.00705077f \
 //x=66.05 //y=1.71 //x2=66.715 //y2=1.77
cc_6791 ( N_noxref_15_c_8812_n N_noxref_50_c_16463_n ) capacitor c=0.020708f \
 //x=66.05 //y=2.095 //x2=66.715 //y2=1.77
cc_6792 ( N_noxref_15_c_9717_p N_noxref_50_c_16463_n ) capacitor c=0.00588627f \
 //x=66.425 //y=1.555 //x2=66.715 //y2=1.77
cc_6793 ( N_noxref_15_c_8817_n N_noxref_50_c_16463_n ) capacitor c=0.00698822f \
 //x=66.58 //y=1.4 //x2=66.715 //y2=1.77
cc_6794 ( N_noxref_15_c_8809_n N_noxref_50_M40_noxref_s ) capacitor \
 c=0.0295256f //x=66.05 //y=1.055 //x2=65.695 //y2=0.555
cc_6795 ( N_noxref_15_c_8811_n N_noxref_50_M40_noxref_s ) capacitor \
 c=7.99997e-19 //x=66.05 //y=1.71 //x2=65.695 //y2=0.555
cc_6796 ( N_noxref_15_c_8812_n N_noxref_50_M40_noxref_s ) capacitor \
 c=0.00122123f //x=66.05 //y=2.095 //x2=65.695 //y2=0.555
cc_6797 ( N_noxref_15_c_8815_n N_noxref_50_M40_noxref_s ) capacitor \
 c=0.0125924f //x=66.58 //y=1.055 //x2=65.695 //y2=0.555
cc_6798 ( N_noxref_15_c_9277_p N_noxref_53_c_16635_n ) capacitor c=0.0033606f \
 //x=78.93 //y=2.375 //x2=78.885 //y2=1.675
cc_6799 ( N_noxref_15_c_9325_p N_noxref_53_c_16635_n ) capacitor c=0.00844774f \
 //x=78.93 //y=2.26 //x2=78.885 //y2=1.675
cc_6800 ( N_noxref_15_c_9383_p N_noxref_53_c_16635_n ) capacitor c=0.00262672f \
 //x=79.105 //y=2.095 //x2=78.885 //y2=1.675
cc_6801 ( N_noxref_15_c_9326_p N_noxref_53_c_16635_n ) capacitor c=0.0079898f \
 //x=78.93 //y=2.26 //x2=78.885 //y2=1.675
cc_6802 ( N_noxref_15_c_9277_p N_noxref_53_c_16639_n ) capacitor c=0.00202154f \
 //x=78.93 //y=2.375 //x2=79.77 //y2=1.76
cc_6803 ( N_noxref_15_c_9272_p N_noxref_53_c_16639_n ) capacitor c=8.70576e-19 \
 //x=78.93 //y=3.67 //x2=79.77 //y2=1.76
cc_6804 ( N_noxref_15_c_9321_p N_noxref_53_c_16639_n ) capacitor c=0.00207582f \
 //x=78.93 //y=4.62 //x2=79.77 //y2=1.76
cc_6805 ( N_noxref_15_c_9325_p N_noxref_53_c_16639_n ) capacitor c=0.00302338f \
 //x=78.93 //y=2.26 //x2=79.77 //y2=1.76
cc_6806 ( N_noxref_15_c_9380_p N_noxref_53_c_16639_n ) capacitor c=0.0072172f \
 //x=79.105 //y=1.7 //x2=79.77 //y2=1.76
cc_6807 ( N_noxref_15_c_9383_p N_noxref_53_c_16639_n ) capacitor c=0.0142197f \
 //x=79.105 //y=2.095 //x2=79.77 //y2=1.76
cc_6808 ( N_noxref_15_c_9677_p N_noxref_53_c_16639_n ) capacitor c=0.0094838f \
 //x=79.48 //y=1.545 //x2=79.77 //y2=1.76
cc_6809 ( N_noxref_15_c_9381_p N_noxref_53_c_16639_n ) capacitor c=0.00339872f \
 //x=79.635 //y=1.39 //x2=79.77 //y2=1.76
cc_6810 ( N_noxref_15_c_9326_p N_noxref_53_c_16639_n ) capacitor c=0.00168953f \
 //x=78.93 //y=2.26 //x2=79.77 //y2=1.76
cc_6811 ( N_noxref_15_c_9383_p N_noxref_53_c_16648_n ) capacitor c=6.71402e-19 \
 //x=79.105 //y=2.095 //x2=79.855 //y2=1.675
cc_6812 ( N_noxref_15_c_9377_p N_noxref_53_M48_noxref_s ) capacitor \
 c=0.0294925f //x=79.105 //y=1.045 //x2=78.75 //y2=0.545
cc_6813 ( N_noxref_15_c_9380_p N_noxref_53_M48_noxref_s ) capacitor \
 c=0.00110192f //x=79.105 //y=1.7 //x2=78.75 //y2=0.545
cc_6814 ( N_noxref_15_c_9379_p N_noxref_53_M48_noxref_s ) capacitor \
 c=0.0125442f //x=79.635 //y=1.045 //x2=78.75 //y2=0.545
cc_6815 ( N_noxref_15_c_9289_p N_noxref_54_c_16704_n ) capacitor c=0.0034165f \
 //x=82.435 //y=2.095 //x2=82.215 //y2=1.675
cc_6816 ( N_noxref_15_c_9216_p N_noxref_54_c_16705_n ) capacitor c=0.00540952f \
 //x=82.63 //y=2.385 //x2=83.1 //y2=1.76
cc_6817 ( N_noxref_15_c_9222_p N_noxref_54_c_16705_n ) capacitor c=0.00299238f \
 //x=82.63 //y=4.62 //x2=83.1 //y2=1.76
cc_6818 ( N_noxref_15_c_9218_p N_noxref_54_c_16705_n ) capacitor c=0.00763108f \
 //x=82.63 //y=2.26 //x2=83.1 //y2=1.76
cc_6819 ( N_noxref_15_c_9299_p N_noxref_54_c_16705_n ) capacitor c=0.00688171f \
 //x=82.435 //y=1.7 //x2=83.1 //y2=1.76
cc_6820 ( N_noxref_15_c_9289_p N_noxref_54_c_16705_n ) capacitor c=0.0183998f \
 //x=82.435 //y=2.095 //x2=83.1 //y2=1.76
cc_6821 ( N_noxref_15_c_9686_p N_noxref_54_c_16705_n ) capacitor c=0.00720047f \
 //x=82.81 //y=1.545 //x2=83.1 //y2=1.76
cc_6822 ( N_noxref_15_c_9300_p N_noxref_54_c_16705_n ) capacitor c=0.0059368f \
 //x=82.965 //y=1.39 //x2=83.1 //y2=1.76
cc_6823 ( N_noxref_15_c_9289_p N_noxref_54_c_16712_n ) capacitor c=0.00122123f \
 //x=82.435 //y=2.095 //x2=83.185 //y2=1.675
cc_6824 ( N_noxref_15_c_9296_p N_noxref_54_M50_noxref_s ) capacitor \
 c=0.0303347f //x=82.435 //y=1.045 //x2=82.08 //y2=0.545
cc_6825 ( N_noxref_15_c_9299_p N_noxref_54_M50_noxref_s ) capacitor \
 c=3.48408e-19 //x=82.435 //y=1.7 //x2=82.08 //y2=0.545
cc_6826 ( N_noxref_15_c_9298_p N_noxref_54_M50_noxref_s ) capacitor \
 c=0.012348f //x=82.965 //y=1.045 //x2=82.08 //y2=0.545
cc_6827 ( N_noxref_16_c_10132_n N_noxref_17_c_10673_n ) capacitor \
 c=0.00228052f //x=78.535 //y=3.14 //x2=73.38 //y2=2.375
cc_6828 ( N_noxref_16_c_10132_n N_noxref_17_c_10669_n ) capacitor c=0.0261663f \
 //x=78.535 //y=3.14 //x2=73.38 //y2=3.705
cc_6829 ( N_noxref_16_c_10132_n N_noxref_17_c_10743_n ) capacitor \
 c=0.00974796f //x=78.535 //y=3.14 //x2=77.095 //y2=1.835
cc_6830 ( N_noxref_16_c_10132_n N_noxref_17_c_10744_n ) capacitor c=0.0291422f \
 //x=78.535 //y=3.14 //x2=77.45 //y2=3.735
cc_6831 ( N_noxref_16_c_10303_n N_noxref_17_c_10864_n ) capacitor \
 c=0.00248974f //x=79.135 //y=3.125 //x2=80.04 //y2=2.375
cc_6832 ( N_noxref_16_c_10245_n N_noxref_17_c_10868_n ) capacitor \
 c=9.38003e-19 //x=84.11 //y=2.97 //x2=80.04 //y2=4.045
cc_6833 ( N_noxref_16_c_10247_n N_noxref_17_c_10868_n ) capacitor \
 c=2.43265e-19 //x=84.11 //y=4.76 //x2=80.04 //y2=4.045
cc_6834 ( N_noxref_16_c_10303_n N_noxref_17_c_10868_n ) capacitor c=0.032563f \
 //x=79.135 //y=3.125 //x2=80.04 //y2=4.045
cc_6835 ( N_noxref_16_c_10303_n N_noxref_17_c_10875_n ) capacitor c=0.0026165f \
 //x=79.135 //y=3.125 //x2=80.04 //y2=4.365
cc_6836 ( N_noxref_16_c_10247_n N_noxref_17_c_10878_n ) capacitor \
 c=0.00166637f //x=84.11 //y=4.76 //x2=80.04 //y2=4.71
cc_6837 ( N_noxref_16_c_10346_p N_noxref_17_c_10945_n ) capacitor c=0.0061363f \
 //x=85.59 //y=2.43 //x2=86.7 //y2=2.38
cc_6838 ( N_noxref_16_c_10347_p N_noxref_17_c_10945_n ) capacitor \
 c=0.00602448f //x=85.585 //y=2.27 //x2=86.7 //y2=2.38
cc_6839 ( N_noxref_16_c_10348_p N_noxref_17_c_10945_n ) capacitor \
 c=2.06418e-19 //x=85.59 //y=2.26 //x2=86.7 //y2=2.38
cc_6840 ( N_noxref_16_c_10349_p N_noxref_17_c_10945_n ) capacitor \
 c=6.73725e-19 //x=85.59 //y=2.26 //x2=86.7 //y2=2.38
cc_6841 ( N_noxref_16_c_10245_n N_noxref_17_c_10949_n ) capacitor c=0.0013756f \
 //x=84.11 //y=2.97 //x2=86.7 //y2=4.05
cc_6842 ( N_noxref_16_c_10247_n N_noxref_17_c_10949_n ) capacitor \
 c=5.67318e-19 //x=84.11 //y=4.76 //x2=86.7 //y2=4.05
cc_6843 ( N_noxref_16_c_10346_p N_noxref_17_c_10949_n ) capacitor c=0.0011922f \
 //x=85.59 //y=2.43 //x2=86.7 //y2=4.05
cc_6844 ( N_noxref_16_c_10252_n N_noxref_17_c_10949_n ) capacitor c=0.0502684f \
 //x=85.59 //y=4.755 //x2=86.7 //y2=4.05
cc_6845 ( N_noxref_16_c_10347_p N_noxref_17_c_10949_n ) capacitor \
 c=0.00107415f //x=85.585 //y=2.27 //x2=86.7 //y2=4.05
cc_6846 ( N_noxref_16_c_10252_n N_noxref_17_c_10954_n ) capacitor \
 c=0.00771726f //x=85.59 //y=4.755 //x2=86.7 //y2=4.37
cc_6847 ( N_noxref_16_c_10247_n N_noxref_17_c_10955_n ) capacitor \
 c=9.13182e-19 //x=84.11 //y=4.76 //x2=86.7 //y2=4.74
cc_6848 ( N_noxref_16_c_10252_n N_noxref_17_c_10955_n ) capacitor c=0.0218691f \
 //x=85.59 //y=4.755 //x2=86.7 //y2=4.74
cc_6849 ( N_noxref_16_c_10358_p N_noxref_17_c_10955_n ) capacitor \
 c=8.06413e-19 //x=85.59 //y=4.885 //x2=86.7 //y2=4.74
cc_6850 ( N_noxref_16_c_10359_p N_noxref_17_c_10955_n ) capacitor \
 c=0.00125146f //x=86.225 //y=4.975 //x2=86.7 //y2=4.74
cc_6851 ( N_noxref_16_c_10360_p N_noxref_17_c_10955_n ) capacitor \
 c=0.00103195f //x=85.935 //y=4.975 //x2=86.7 //y2=4.74
cc_6852 ( N_noxref_16_c_10132_n N_noxref_17_c_10777_n ) capacitor \
 c=4.69652e-19 //x=78.535 //y=3.14 //x2=77.01 //y2=1.18
cc_6853 ( N_noxref_16_c_10252_n N_noxref_17_c_10961_n ) capacitor \
 c=5.15538e-19 //x=85.59 //y=4.755 //x2=86.7 //y2=4.25
cc_6854 ( N_noxref_16_c_10132_n N_noxref_17_c_10785_n ) capacitor c=0.024968f \
 //x=78.535 //y=3.14 //x2=76.315 //y2=3.88
cc_6855 ( N_noxref_16_c_10303_n N_noxref_17_c_10891_n ) capacitor \
 c=0.00430178f //x=79.135 //y=3.125 //x2=79.135 //y2=3.895
cc_6856 ( N_noxref_16_c_10132_n N_noxref_17_c_10798_n ) capacitor c=0.0135181f \
 //x=78.535 //y=3.14 //x2=78.79 //y2=3.895
cc_6857 ( N_noxref_16_c_10303_n N_noxref_17_c_10900_n ) capacitor c=0.0438312f \
 //x=79.135 //y=3.125 //x2=80.2 //y2=4.252
cc_6858 ( N_noxref_16_c_10252_n N_noxref_17_c_10966_n ) capacitor \
 c=0.00250167f //x=85.59 //y=4.755 //x2=86.715 //y2=4.21
cc_6859 ( N_noxref_16_c_10242_n N_noxref_17_c_10904_n ) capacitor c=7.0928e-19 \
 //x=84.11 //y=2.43 //x2=86.555 //y2=4.21
cc_6860 ( N_noxref_16_c_10246_n N_noxref_17_c_10904_n ) capacitor \
 c=0.00247255f //x=84.11 //y=3.29 //x2=86.555 //y2=4.21
cc_6861 ( N_noxref_16_c_10247_n N_noxref_17_c_10904_n ) capacitor c=0.038012f \
 //x=84.11 //y=4.76 //x2=86.555 //y2=4.21
cc_6862 ( N_noxref_16_c_10346_p N_noxref_17_c_10904_n ) capacitor \
 c=0.00231693f //x=85.59 //y=2.43 //x2=86.555 //y2=4.21
cc_6863 ( N_noxref_16_c_10252_n N_noxref_17_c_10904_n ) capacitor c=0.0387859f \
 //x=85.59 //y=4.755 //x2=86.555 //y2=4.21
cc_6864 ( N_noxref_16_c_10303_n N_noxref_17_c_10904_n ) capacitor c=0.123233f \
 //x=79.135 //y=3.125 //x2=86.555 //y2=4.21
cc_6865 ( N_noxref_16_c_10310_n N_noxref_17_c_10904_n ) capacitor \
 c=5.23236e-19 //x=84.275 //y=2.27 //x2=86.555 //y2=4.21
cc_6866 ( N_noxref_16_c_10347_p N_noxref_17_c_10904_n ) capacitor \
 c=0.00472291f //x=85.585 //y=2.27 //x2=86.555 //y2=4.21
cc_6867 ( N_noxref_16_c_10376_p N_noxref_17_c_10904_n ) capacitor c=0.0202481f \
 //x=85.425 //y=2.27 //x2=86.555 //y2=4.21
cc_6868 ( N_noxref_16_c_10346_p N_noxref_17_c_10976_n ) capacitor \
 c=7.58956e-19 //x=85.59 //y=2.43 //x2=86.7 //y2=2.26
cc_6869 ( N_noxref_16_c_10348_p N_noxref_17_c_10976_n ) capacitor \
 c=0.00113671f //x=85.59 //y=2.26 //x2=86.7 //y2=2.26
cc_6870 ( N_noxref_16_c_10349_p N_noxref_17_c_10976_n ) capacitor \
 c=0.00169858f //x=85.59 //y=2.26 //x2=86.7 //y2=2.26
cc_6871 ( N_noxref_16_c_10252_n N_noxref_17_c_10979_n ) capacitor \
 c=2.02321e-19 //x=85.59 //y=4.755 //x2=86.72 //y2=4.885
cc_6872 ( N_noxref_16_c_10358_p N_noxref_17_c_10979_n ) capacitor \
 c=0.00106454f //x=85.59 //y=4.885 //x2=86.72 //y2=4.885
cc_6873 ( N_noxref_16_c_10359_p N_noxref_17_c_10979_n ) capacitor \
 c=0.00147609f //x=86.225 //y=4.975 //x2=86.72 //y2=4.885
cc_6874 ( N_noxref_16_c_10360_p N_noxref_17_c_10979_n ) capacitor \
 c=0.00127381f //x=85.935 //y=4.975 //x2=86.72 //y2=4.885
cc_6875 ( N_noxref_16_M158_noxref_g N_noxref_17_M160_noxref_g ) capacitor \
 c=0.00935155f //x=85.86 //y=6.205 //x2=86.74 //y2=6.205
cc_6876 ( N_noxref_16_M159_noxref_g N_noxref_17_M160_noxref_g ) capacitor \
 c=0.111828f //x=86.3 //y=6.205 //x2=86.74 //y2=6.205
cc_6877 ( N_noxref_16_M159_noxref_g N_noxref_17_M161_noxref_g ) capacitor \
 c=0.00876656f //x=86.3 //y=6.205 //x2=87.18 //y2=6.205
cc_6878 ( N_noxref_16_c_10387_p N_noxref_17_c_10986_n ) capacitor \
 c=4.86545e-19 //x=85.765 //y=1.045 //x2=86.735 //y2=1.085
cc_6879 ( N_noxref_16_c_10388_p N_noxref_17_c_10986_n ) capacitor \
 c=0.00152405f //x=85.765 //y=1.39 //x2=86.735 //y2=1.085
cc_6880 ( N_noxref_16_c_10389_p N_noxref_17_c_10986_n ) capacitor c=0.0151424f \
 //x=86.295 //y=1.045 //x2=86.735 //y2=1.085
cc_6881 ( N_noxref_16_c_10390_p N_noxref_17_c_10989_n ) capacitor \
 c=0.00109722f //x=85.765 //y=1.7 //x2=86.735 //y2=1.435
cc_6882 ( N_noxref_16_c_10391_p N_noxref_17_c_10989_n ) capacitor c=0.0111013f \
 //x=86.295 //y=1.39 //x2=86.735 //y2=1.435
cc_6883 ( N_noxref_16_c_10390_p N_noxref_17_c_10991_n ) capacitor \
 c=0.00179029f //x=85.765 //y=1.7 //x2=86.735 //y2=1.74
cc_6884 ( N_noxref_16_c_10393_p N_noxref_17_c_10991_n ) capacitor \
 c=0.00662747f //x=85.765 //y=2.095 //x2=86.735 //y2=1.74
cc_6885 ( N_noxref_16_c_10391_p N_noxref_17_c_10991_n ) capacitor \
 c=0.00862358f //x=86.295 //y=1.39 //x2=86.735 //y2=1.74
cc_6886 ( N_noxref_16_c_10391_p N_noxref_17_c_10994_n ) capacitor \
 c=4.75927e-19 //x=86.295 //y=1.39 //x2=87.11 //y2=1.585
cc_6887 ( N_noxref_16_c_10389_p N_noxref_17_c_10995_n ) capacitor \
 c=0.00130607f //x=86.295 //y=1.045 //x2=87.265 //y2=1.085
cc_6888 ( N_noxref_16_c_10391_p N_noxref_17_c_10996_n ) capacitor \
 c=0.00153205f //x=86.295 //y=1.39 //x2=87.265 //y2=1.435
cc_6889 ( N_noxref_16_c_10346_p N_noxref_17_c_10997_n ) capacitor \
 c=0.00157228f //x=85.59 //y=2.43 //x2=86.7 //y2=2.26
cc_6890 ( N_noxref_16_c_10348_p N_noxref_17_c_10997_n ) capacitor \
 c=0.00194209f //x=85.59 //y=2.26 //x2=86.7 //y2=2.26
cc_6891 ( N_noxref_16_c_10349_p N_noxref_17_c_10997_n ) capacitor \
 c=0.00887988f //x=85.59 //y=2.26 //x2=86.7 //y2=2.26
cc_6892 ( N_noxref_16_c_10252_n N_noxref_17_c_11000_n ) capacitor \
 c=0.00132485f //x=85.59 //y=4.755 //x2=86.72 //y2=4.885
cc_6893 ( N_noxref_16_c_10358_p N_noxref_17_c_11000_n ) capacitor \
 c=0.00167042f //x=85.59 //y=4.885 //x2=86.72 //y2=4.885
cc_6894 ( N_noxref_16_c_10359_p N_noxref_17_c_11000_n ) capacitor c=0.022796f \
 //x=86.225 //y=4.975 //x2=86.72 //y2=4.885
cc_6895 ( N_noxref_16_c_10360_p N_noxref_17_c_11000_n ) capacitor \
 c=0.00470299f //x=85.935 //y=4.975 //x2=86.72 //y2=4.885
cc_6896 ( N_noxref_16_c_10346_p QN ) capacitor c=8.05281e-19 //x=85.59 \
 //y=2.43 //x2=87.44 //y2=2.4
cc_6897 ( N_noxref_16_c_10252_n QN ) capacitor c=0.00659697f //x=85.59 \
 //y=4.755 //x2=87.44 //y2=2.4
cc_6898 ( N_noxref_16_c_10347_p QN ) capacitor c=5.18701e-19 //x=85.585 \
 //y=2.27 //x2=87.44 //y2=2.4
cc_6899 ( N_noxref_16_M159_noxref_g N_QN_c_11258_n ) capacitor c=0.00969448f \
 //x=86.3 //y=6.205 //x2=86.835 //y2=5.39
cc_6900 ( N_noxref_16_c_10303_n N_QN_c_11259_n ) capacitor c=0.00705928f \
 //x=79.135 //y=3.125 //x2=80.34 //y2=1.36
cc_6901 ( N_noxref_16_c_10303_n N_QN_c_11260_n ) capacitor c=0.00659441f \
 //x=79.135 //y=3.125 //x2=83.67 //y2=1.36
cc_6902 ( N_noxref_16_c_10322_n N_QN_c_11260_n ) capacitor c=5.10033e-19 \
 //x=83.405 //y=1.085 //x2=83.67 //y2=1.36
cc_6903 ( N_noxref_16_c_10325_n N_QN_c_11260_n ) capacitor c=0.0060683f \
 //x=83.405 //y=1.43 //x2=83.67 //y2=1.36
cc_6904 ( N_noxref_16_c_10413_p N_QN_c_11260_n ) capacitor c=4.65567e-19 \
 //x=83.78 //y=0.93 //x2=83.67 //y2=1.36
cc_6905 ( N_noxref_16_c_10414_p N_QN_c_11260_n ) capacitor c=0.00247382f \
 //x=83.78 //y=1.585 //x2=83.67 //y2=1.36
cc_6906 ( N_noxref_16_c_10331_n N_QN_c_11260_n ) capacitor c=2.15736e-19 \
 //x=83.935 //y=1.085 //x2=83.67 //y2=1.36
cc_6907 ( N_noxref_16_c_10332_n N_QN_c_11260_n ) capacitor c=0.00259159f \
 //x=83.935 //y=1.43 //x2=83.67 //y2=1.36
cc_6908 ( N_noxref_16_c_10333_n N_QN_c_11260_n ) capacitor c=0.00150348f \
 //x=83.935 //y=1.74 //x2=83.67 //y2=1.36
cc_6909 ( N_noxref_16_M158_noxref_g N_QN_c_11268_n ) capacitor c=0.00363978f \
 //x=85.86 //y=6.205 //x2=86.08 //y2=5.39
cc_6910 ( N_noxref_16_M159_noxref_g N_QN_c_11268_n ) capacitor c=0.00185829f \
 //x=86.3 //y=6.205 //x2=86.08 //y2=5.39
cc_6911 ( N_noxref_16_c_10359_p N_QN_c_11268_n ) capacitor c=0.0021827f \
 //x=86.225 //y=4.975 //x2=86.08 //y2=5.39
cc_6912 ( N_noxref_16_c_10303_n N_QN_c_11271_n ) capacitor c=0.00540971f \
 //x=79.135 //y=3.125 //x2=80.505 //y2=1.405
cc_6913 ( N_noxref_16_c_10303_n N_QN_c_11251_n ) capacitor c=0.0587935f \
 //x=79.135 //y=3.125 //x2=83.54 //y2=1.405
cc_6914 ( N_noxref_16_c_10325_n N_QN_c_11251_n ) capacitor c=0.00156453f \
 //x=83.405 //y=1.43 //x2=83.54 //y2=1.405
cc_6915 ( N_noxref_16_c_10303_n N_QN_c_11274_n ) capacitor c=0.0043555f \
 //x=79.135 //y=3.125 //x2=83.8 //y2=1.405
cc_6916 ( N_noxref_16_c_10242_n N_QN_c_11275_n ) capacitor c=0.00831558f \
 //x=84.11 //y=2.43 //x2=86.835 //y2=1.405
cc_6917 ( N_noxref_16_c_10246_n N_QN_c_11275_n ) capacitor c=0.00179311f \
 //x=84.11 //y=3.29 //x2=86.835 //y2=1.405
cc_6918 ( N_noxref_16_c_10346_p N_QN_c_11275_n ) capacitor c=0.00831552f \
 //x=85.59 //y=2.43 //x2=86.835 //y2=1.405
cc_6919 ( N_noxref_16_c_10303_n N_QN_c_11275_n ) capacitor c=0.00243772f \
 //x=79.135 //y=3.125 //x2=86.835 //y2=1.405
cc_6920 ( N_noxref_16_c_10310_n N_QN_c_11275_n ) capacitor c=0.0126877f \
 //x=84.275 //y=2.27 //x2=86.835 //y2=1.405
cc_6921 ( N_noxref_16_c_10347_p N_QN_c_11275_n ) capacitor c=0.0128597f \
 //x=85.585 //y=2.27 //x2=86.835 //y2=1.405
cc_6922 ( N_noxref_16_c_10376_p N_QN_c_11275_n ) capacitor c=0.0434154f \
 //x=85.425 //y=2.27 //x2=86.835 //y2=1.405
cc_6923 ( N_noxref_16_c_10332_n N_QN_c_11275_n ) capacitor c=0.00215337f \
 //x=83.935 //y=1.43 //x2=86.835 //y2=1.405
cc_6924 ( N_noxref_16_c_10333_n N_QN_c_11275_n ) capacitor c=0.00132351f \
 //x=83.935 //y=1.74 //x2=86.835 //y2=1.405
cc_6925 ( N_noxref_16_c_10388_p N_QN_c_11275_n ) capacitor c=0.00277413f \
 //x=85.765 //y=1.39 //x2=86.835 //y2=1.405
cc_6926 ( N_noxref_16_c_10390_p N_QN_c_11275_n ) capacitor c=0.00245466f \
 //x=85.765 //y=1.7 //x2=86.835 //y2=1.405
cc_6927 ( N_noxref_16_c_10391_p N_QN_c_11275_n ) capacitor c=0.00460244f \
 //x=86.295 //y=1.39 //x2=86.835 //y2=1.405
cc_6928 ( N_noxref_16_M158_noxref_g N_QN_c_11287_n ) capacitor c=0.0120591f \
 //x=85.86 //y=6.205 //x2=86.08 //y2=5.56
cc_6929 ( N_noxref_16_M159_noxref_g N_QN_c_11287_n ) capacitor c=0.0142133f \
 //x=86.3 //y=6.205 //x2=86.08 //y2=5.56
cc_6930 ( N_noxref_16_c_10359_p N_QN_c_11287_n ) capacitor c=0.00293135f \
 //x=86.225 //y=4.975 //x2=86.08 //y2=5.56
cc_6931 ( N_noxref_16_c_10322_n N_QN_M51_noxref_d ) capacitor c=0.00217566f \
 //x=83.405 //y=1.085 //x2=83.48 //y2=1.085
cc_6932 ( N_noxref_16_c_10325_n N_QN_M51_noxref_d ) capacitor c=0.00693963f \
 //x=83.405 //y=1.43 //x2=83.48 //y2=1.085
cc_6933 ( N_noxref_16_c_10413_p N_QN_M51_noxref_d ) capacitor c=0.00234223f \
 //x=83.78 //y=0.93 //x2=83.48 //y2=1.085
cc_6934 ( N_noxref_16_c_10414_p N_QN_M51_noxref_d ) capacitor c=0.00513213f \
 //x=83.78 //y=1.585 //x2=83.48 //y2=1.085
cc_6935 ( N_noxref_16_c_10331_n N_QN_M51_noxref_d ) capacitor c=0.00132245f \
 //x=83.935 //y=1.085 //x2=83.48 //y2=1.085
cc_6936 ( N_noxref_16_c_10332_n N_QN_M51_noxref_d ) capacitor c=0.00326247f \
 //x=83.935 //y=1.43 //x2=83.48 //y2=1.085
cc_6937 ( N_noxref_16_c_10333_n N_QN_M51_noxref_d ) capacitor c=0.00231463f \
 //x=83.935 //y=1.74 //x2=83.48 //y2=1.085
cc_6938 ( N_noxref_16_c_9890_n N_VDD_c_11464_n ) capacitor c=0.00648267f \
 //x=25.055 //y=5.38 //x2=78.895 //y2=7.585
cc_6939 ( N_noxref_16_c_9902_n N_VDD_c_11464_n ) capacitor c=0.00492578f \
 //x=25.565 //y=5.38 //x2=78.895 //y2=7.585
cc_6940 ( N_noxref_16_c_9926_n N_VDD_c_11464_n ) capacitor c=0.00368834f \
 //x=24.29 //y=5.56 //x2=78.895 //y2=7.585
cc_6941 ( N_noxref_16_c_9934_n N_VDD_c_11464_n ) capacitor c=8.4268e-19 \
 //x=25.17 //y=5.38 //x2=78.895 //y2=7.585
cc_6942 ( N_noxref_16_c_10451_p N_VDD_c_11464_n ) capacitor c=0.00285853f \
 //x=25.17 //y=5.56 //x2=78.895 //y2=7.585
cc_6943 ( N_noxref_16_c_9964_n N_VDD_c_11464_n ) capacitor c=0.00224881f \
 //x=24.29 //y=5.56 //x2=78.895 //y2=7.585
cc_6944 ( N_noxref_16_c_9970_n N_VDD_c_11464_n ) capacitor c=0.00224881f \
 //x=25.17 //y=5.56 //x2=78.895 //y2=7.585
cc_6945 ( N_noxref_16_M80_noxref_g N_VDD_c_11693_n ) capacitor c=0.00755544f \
 //x=21.32 //y=6.2 //x2=21.895 //y2=7.585
cc_6946 ( N_noxref_16_M81_noxref_g N_VDD_c_11693_n ) capacitor c=0.00755754f \
 //x=21.76 //y=6.2 //x2=21.895 //y2=7.585
cc_6947 ( N_noxref_16_c_9890_n N_VDD_c_11699_n ) capacitor c=0.00208087f \
 //x=25.055 //y=5.38 //x2=24.645 //y2=7.585
cc_6948 ( N_noxref_16_c_9926_n N_VDD_c_11699_n ) capacitor c=9.41185e-19 \
 //x=24.29 //y=5.56 //x2=24.645 //y2=7.585
cc_6949 ( N_noxref_16_c_9964_n N_VDD_c_11699_n ) capacitor c=0.0136705f \
 //x=24.29 //y=5.56 //x2=24.645 //y2=7.585
cc_6950 ( N_noxref_16_c_9890_n N_VDD_c_11702_n ) capacitor c=0.00180737f \
 //x=25.055 //y=5.38 //x2=25.525 //y2=7.585
cc_6951 ( N_noxref_16_c_9902_n N_VDD_c_11702_n ) capacitor c=0.00208087f \
 //x=25.565 //y=5.38 //x2=25.525 //y2=7.585
cc_6952 ( N_noxref_16_c_9934_n N_VDD_c_11702_n ) capacitor c=4.23719e-19 \
 //x=25.17 //y=5.38 //x2=25.525 //y2=7.585
cc_6953 ( N_noxref_16_c_10451_p N_VDD_c_11702_n ) capacitor c=5.77976e-19 \
 //x=25.17 //y=5.56 //x2=25.525 //y2=7.585
cc_6954 ( N_noxref_16_c_9970_n N_VDD_c_11702_n ) capacitor c=0.0136705f \
 //x=25.17 //y=5.56 //x2=25.525 //y2=7.585
cc_6955 ( N_noxref_16_M156_noxref_g N_VDD_c_12501_n ) capacitor c=0.00782837f \
 //x=83.4 //y=6.205 //x2=84.68 //y2=7.585
cc_6956 ( N_noxref_16_M157_noxref_g N_VDD_c_12501_n ) capacitor c=0.00782837f \
 //x=83.84 //y=6.205 //x2=84.68 //y2=7.585
cc_6957 ( N_noxref_16_M158_noxref_g N_VDD_c_12628_n ) capacitor c=0.00782837f \
 //x=85.86 //y=6.205 //x2=87.44 //y2=7.58
cc_6958 ( N_noxref_16_M159_noxref_g N_VDD_c_12628_n ) capacitor c=0.00782837f \
 //x=86.3 //y=6.205 //x2=87.44 //y2=7.58
cc_6959 ( N_noxref_16_c_9914_n N_VDD_c_11723_n ) capacitor c=0.0013228f \
 //x=25.65 //y=5.295 //x2=23.06 //y2=7.585
cc_6960 ( N_noxref_16_c_9926_n N_VDD_c_11723_n ) capacitor c=4.91377e-19 \
 //x=24.29 //y=5.56 //x2=23.06 //y2=7.585
cc_6961 ( N_noxref_16_c_9960_n N_VDD_c_11723_n ) capacitor c=0.00224736f \
 //x=21.58 //y=4.88 //x2=23.06 //y2=7.585
cc_6962 ( N_noxref_16_c_9964_n N_VDD_c_11723_n ) capacitor c=0.0064135f \
 //x=24.29 //y=5.56 //x2=23.06 //y2=7.585
cc_6963 ( N_noxref_16_c_10000_n N_VDD_c_11723_n ) capacitor c=2.63786e-19 \
 //x=21.58 //y=4.88 //x2=23.06 //y2=7.585
cc_6964 ( N_noxref_16_c_9914_n N_VDD_c_11735_n ) capacitor c=0.0295053f \
 //x=25.65 //y=5.295 //x2=26.39 //y2=7.585
cc_6965 ( N_noxref_16_c_9934_n N_VDD_c_11735_n ) capacitor c=0.0025639f \
 //x=25.17 //y=5.38 //x2=26.39 //y2=7.585
cc_6966 ( N_noxref_16_c_10451_p N_VDD_c_11735_n ) capacitor c=4.19141e-19 \
 //x=25.17 //y=5.56 //x2=26.39 //y2=7.585
cc_6967 ( N_noxref_16_c_9956_n N_VDD_c_11735_n ) capacitor c=0.00265864f \
 //x=29.505 //y=3.125 //x2=26.39 //y2=7.585
cc_6968 ( N_noxref_16_c_9970_n N_VDD_c_11735_n ) capacitor c=0.0101861f \
 //x=25.17 //y=5.56 //x2=26.39 //y2=7.585
cc_6969 ( N_noxref_16_c_10247_n N_VDD_c_12546_n ) capacitor c=0.0156004f \
 //x=84.11 //y=4.76 //x2=84.85 //y2=7.585
cc_6970 ( N_noxref_16_c_10252_n N_VDD_c_12546_n ) capacitor c=0.0163412f \
 //x=85.59 //y=4.755 //x2=84.85 //y2=7.585
cc_6971 ( N_noxref_16_c_10316_n N_VDD_c_12546_n ) capacitor c=0.00790417f \
 //x=84.11 //y=4.885 //x2=84.85 //y2=7.585
cc_6972 ( N_noxref_16_c_10358_p N_VDD_c_12546_n ) capacitor c=0.00734519f \
 //x=85.59 //y=4.885 //x2=84.85 //y2=7.585
cc_6973 ( N_noxref_16_M157_noxref_g N_VDD_c_12546_n ) capacitor c=0.01358f \
 //x=83.84 //y=6.205 //x2=84.85 //y2=7.585
cc_6974 ( N_noxref_16_M158_noxref_g N_VDD_c_12546_n ) capacitor c=0.00895835f \
 //x=85.86 //y=6.205 //x2=84.85 //y2=7.585
cc_6975 ( N_noxref_16_c_10329_n N_VDD_c_12546_n ) capacitor c=0.00722671f \
 //x=83.84 //y=5.05 //x2=84.85 //y2=7.585
cc_6976 ( N_noxref_16_c_10360_p N_VDD_c_12546_n ) capacitor c=0.00818208f \
 //x=85.935 //y=4.975 //x2=84.85 //y2=7.585
cc_6977 ( N_noxref_16_M80_noxref_g N_VDD_M79_noxref_d ) capacitor c=0.015318f \
 //x=21.32 //y=6.2 //x2=20.955 //y2=5.2
cc_6978 ( N_noxref_16_M81_noxref_g N_VDD_M81_noxref_d ) capacitor c=0.0394719f \
 //x=21.76 //y=6.2 //x2=21.835 //y2=5.2
cc_6979 ( N_noxref_16_c_9926_n N_VDD_M82_noxref_s ) capacitor c=0.0611368f \
 //x=24.29 //y=5.56 //x2=23.715 //y2=5.2
cc_6980 ( N_noxref_16_c_9934_n N_VDD_M82_noxref_s ) capacitor c=6.52457e-19 \
 //x=25.17 //y=5.38 //x2=23.715 //y2=5.2
cc_6981 ( N_noxref_16_c_9964_n N_VDD_M82_noxref_s ) capacitor c=0.0887533f \
 //x=24.29 //y=5.56 //x2=23.715 //y2=5.2
cc_6982 ( N_noxref_16_c_9890_n N_VDD_M83_noxref_d ) capacitor c=0.00734094f \
 //x=25.055 //y=5.38 //x2=24.585 //y2=5.2
cc_6983 ( N_noxref_16_c_9926_n N_VDD_M83_noxref_d ) capacitor c=0.0043528f \
 //x=24.29 //y=5.56 //x2=24.585 //y2=5.2
cc_6984 ( N_noxref_16_c_10451_p N_VDD_M83_noxref_d ) capacitor c=0.0043528f \
 //x=25.17 //y=5.56 //x2=24.585 //y2=5.2
cc_6985 ( N_noxref_16_c_9964_n N_VDD_M83_noxref_d ) capacitor c=0.065554f \
 //x=24.29 //y=5.56 //x2=24.585 //y2=5.2
cc_6986 ( N_noxref_16_c_9970_n N_VDD_M83_noxref_d ) capacitor c=0.065554f \
 //x=25.17 //y=5.56 //x2=24.585 //y2=5.2
cc_6987 ( N_noxref_16_c_9902_n N_VDD_M85_noxref_d ) capacitor c=0.00961919f \
 //x=25.565 //y=5.38 //x2=25.465 //y2=5.2
cc_6988 ( N_noxref_16_c_10451_p N_VDD_M85_noxref_d ) capacitor c=0.00955781f \
 //x=25.17 //y=5.56 //x2=25.465 //y2=5.2
cc_6989 ( N_noxref_16_c_9944_n N_VDD_M85_noxref_d ) capacitor c=8.01916e-19 \
 //x=25.65 //y=3.14 //x2=25.465 //y2=5.2
cc_6990 ( N_noxref_16_c_9970_n N_VDD_M85_noxref_d ) capacitor c=0.065554f \
 //x=25.17 //y=5.56 //x2=25.465 //y2=5.2
cc_6991 ( N_noxref_16_c_9902_n N_VDD_M86_noxref_s ) capacitor c=0.00220019f \
 //x=25.565 //y=5.38 //x2=27.345 //y2=5.2
cc_6992 ( N_noxref_16_c_9934_n N_VDD_M86_noxref_s ) capacitor c=0.00371125f \
 //x=25.17 //y=5.38 //x2=27.345 //y2=5.2
cc_6993 ( N_noxref_16_c_10451_p N_VDD_M86_noxref_s ) capacitor c=9.52042e-19 \
 //x=25.17 //y=5.56 //x2=27.345 //y2=5.2
cc_6994 ( N_noxref_16_c_9871_n N_noxref_23_c_13059_n ) capacitor c=0.00177186f \
 //x=21.58 //y=2.375 //x2=22.235 //y2=0.72
cc_6995 ( N_noxref_16_c_9959_n N_noxref_23_c_13059_n ) capacitor c=0.00117306f \
 //x=21.58 //y=2.26 //x2=22.235 //y2=0.72
cc_6996 ( N_noxref_16_c_9979_n N_noxref_23_c_13059_n ) capacitor c=0.0206349f \
 //x=21.57 //y=1.095 //x2=22.235 //y2=0.72
cc_6997 ( N_noxref_16_c_9991_n N_noxref_23_c_13059_n ) capacitor c=0.00825432f \
 //x=22.1 //y=1.095 //x2=22.235 //y2=0.72
cc_6998 ( N_noxref_16_c_9997_n N_noxref_23_c_13059_n ) capacitor c=2.20712e-19 \
 //x=21.58 //y=2.26 //x2=22.235 //y2=0.72
cc_6999 ( N_noxref_16_c_9981_n N_noxref_23_c_13062_n ) capacitor c=0.0071177f \
 //x=21.57 //y=1.44 //x2=21.35 //y2=1.175
cc_7000 ( N_noxref_16_c_9874_n N_noxref_23_M13_noxref_s ) capacitor \
 c=3.5635e-19 //x=21.58 //y=3.315 //x2=21.215 //y2=0.555
cc_7001 ( N_noxref_16_c_9979_n N_noxref_23_M13_noxref_s ) capacitor \
 c=0.0071177f //x=21.57 //y=1.095 //x2=21.215 //y2=0.555
cc_7002 ( N_noxref_16_c_9984_n N_noxref_23_M13_noxref_s ) capacitor \
 c=0.0071177f //x=21.57 //y=1.75 //x2=21.215 //y2=0.555
cc_7003 ( N_noxref_16_c_9991_n N_noxref_23_M13_noxref_s ) capacitor \
 c=0.015333f //x=22.1 //y=1.095 //x2=21.215 //y2=0.555
cc_7004 ( N_noxref_16_c_9993_n N_noxref_23_M13_noxref_s ) capacitor \
 c=0.00248746f //x=22.1 //y=1.44 //x2=21.215 //y2=0.555
cc_7005 ( N_noxref_16_c_9937_n N_noxref_24_M17_noxref_d ) capacitor \
 c=3.39394e-19 //x=25.21 //y=1.18 //x2=28.25 //y2=1.09
cc_7006 ( N_noxref_16_c_10132_n N_noxref_31_c_13600_n ) capacitor c=0.0049601f \
 //x=78.535 //y=3.14 //x2=73.065 //y2=1.175
cc_7007 ( N_noxref_16_c_10132_n N_noxref_31_c_13617_n ) capacitor \
 c=2.35453e-19 //x=78.535 //y=3.14 //x2=74.035 //y2=0.72
cc_7008 ( N_noxref_16_c_10132_n N_noxref_31_M45_noxref_s ) capacitor \
 c=0.00304131f //x=78.535 //y=3.14 //x2=73.015 //y2=0.555
cc_7009 ( N_noxref_16_M156_noxref_g N_noxref_32_c_13696_n ) capacitor \
 c=0.00814026f //x=83.4 //y=6.205 //x2=83.945 //y2=7.09
cc_7010 ( N_noxref_16_M157_noxref_g N_noxref_32_c_13696_n ) capacitor \
 c=0.00937408f //x=83.84 //y=6.205 //x2=83.945 //y2=7.09
cc_7011 ( N_noxref_16_M156_noxref_g N_noxref_32_c_13685_n ) capacitor \
 c=0.0017976f //x=83.4 //y=6.205 //x2=83.177 //y2=7.09
cc_7012 ( N_noxref_16_M157_noxref_g N_noxref_32_c_13699_n ) capacitor \
 c=0.00395674f //x=83.84 //y=6.205 //x2=84.06 //y2=6.92
cc_7013 ( N_noxref_16_M156_noxref_g N_noxref_32_M155_noxref_d ) capacitor \
 c=0.0142133f //x=83.4 //y=6.205 //x2=83.035 //y2=5.205
cc_7014 ( N_noxref_16_c_10316_n N_noxref_32_M157_noxref_d ) capacitor \
 c=0.00256087f //x=84.11 //y=4.885 //x2=83.915 //y2=5.205
cc_7015 ( N_noxref_16_M157_noxref_g N_noxref_32_M157_noxref_d ) capacitor \
 c=0.0365939f //x=83.84 //y=6.205 //x2=83.915 //y2=5.205
cc_7016 ( N_noxref_16_c_10329_n N_noxref_32_M157_noxref_d ) capacitor \
 c=0.00447202f //x=83.84 //y=5.05 //x2=83.915 //y2=5.205
cc_7017 ( N_noxref_16_M156_noxref_g N_noxref_33_c_13828_n ) capacitor \
 c=0.00998198f //x=83.4 //y=6.205 //x2=83.505 //y2=5.39
cc_7018 ( N_noxref_16_c_10242_n N_noxref_33_c_13841_n ) capacitor \
 c=7.74286e-19 //x=84.11 //y=2.43 //x2=85.525 //y2=5.39
cc_7019 ( N_noxref_16_c_10246_n N_noxref_33_c_13841_n ) capacitor \
 c=0.00154696f //x=84.11 //y=3.29 //x2=85.525 //y2=5.39
cc_7020 ( N_noxref_16_c_10247_n N_noxref_33_c_13841_n ) capacitor c=0.0227143f \
 //x=84.11 //y=4.76 //x2=85.525 //y2=5.39
cc_7021 ( N_noxref_16_c_10346_p N_noxref_33_c_13841_n ) capacitor \
 c=0.00141341f //x=85.59 //y=2.43 //x2=85.525 //y2=5.39
cc_7022 ( N_noxref_16_c_10252_n N_noxref_33_c_13841_n ) capacitor c=0.0274606f \
 //x=85.59 //y=4.755 //x2=85.525 //y2=5.39
cc_7023 ( N_noxref_16_c_10316_n N_noxref_33_c_13841_n ) capacitor c=0.0035251f \
 //x=84.11 //y=4.885 //x2=85.525 //y2=5.39
cc_7024 ( N_noxref_16_c_10358_p N_noxref_33_c_13841_n ) capacitor \
 c=0.00429429f //x=85.59 //y=4.885 //x2=85.525 //y2=5.39
cc_7025 ( N_noxref_16_M157_noxref_g N_noxref_33_c_13841_n ) capacitor \
 c=0.0117303f //x=83.84 //y=6.205 //x2=85.525 //y2=5.39
cc_7026 ( N_noxref_16_M158_noxref_g N_noxref_33_c_13841_n ) capacitor \
 c=0.00383041f //x=85.86 //y=6.205 //x2=85.525 //y2=5.39
cc_7027 ( N_noxref_16_c_10329_n N_noxref_33_c_13841_n ) capacitor \
 c=0.00489051f //x=83.84 //y=5.05 //x2=85.525 //y2=5.39
cc_7028 ( N_noxref_16_c_10360_p N_noxref_33_c_13841_n ) capacitor \
 c=0.00243015f //x=85.935 //y=4.975 //x2=85.525 //y2=5.39
cc_7029 ( N_noxref_16_M156_noxref_g N_noxref_33_c_13852_n ) capacitor \
 c=6.12451e-19 //x=83.4 //y=6.205 //x2=83.735 //y2=5.39
cc_7030 ( N_noxref_16_M157_noxref_g N_noxref_33_c_13852_n ) capacitor \
 c=8.33934e-19 //x=83.84 //y=6.205 //x2=83.735 //y2=5.39
cc_7031 ( N_noxref_16_M158_noxref_g N_noxref_33_c_13854_n ) capacitor \
 c=0.0109238f //x=85.86 //y=6.205 //x2=86.405 //y2=7.09
cc_7032 ( N_noxref_16_M159_noxref_g N_noxref_33_c_13854_n ) capacitor \
 c=0.00814026f //x=86.3 //y=6.205 //x2=86.405 //y2=7.09
cc_7033 ( N_noxref_16_M158_noxref_g N_noxref_33_c_13856_n ) capacitor \
 c=0.00394587f //x=85.86 //y=6.205 //x2=85.64 //y2=6.92
cc_7034 ( N_noxref_16_M159_noxref_g N_noxref_33_c_13857_n ) capacitor \
 c=0.00179267f //x=86.3 //y=6.205 //x2=86.52 //y2=7.09
cc_7035 ( N_noxref_16_M156_noxref_g N_noxref_33_c_13858_n ) capacitor \
 c=0.0179771f //x=83.4 //y=6.205 //x2=83.62 //y2=5.39
cc_7036 ( N_noxref_16_M157_noxref_g N_noxref_33_c_13858_n ) capacitor \
 c=0.0171712f //x=83.84 //y=6.205 //x2=83.62 //y2=5.39
cc_7037 ( N_noxref_16_c_10546_p N_noxref_33_c_13858_n ) capacitor \
 c=0.00438178f //x=83.765 //y=4.975 //x2=83.62 //y2=5.39
cc_7038 ( N_noxref_16_c_10252_n N_noxref_33_c_13861_n ) capacitor \
 c=0.00533094f //x=85.59 //y=4.755 //x2=85.64 //y2=5.39
cc_7039 ( N_noxref_16_c_10358_p N_noxref_33_c_13861_n ) capacitor c=0.013929f \
 //x=85.59 //y=4.885 //x2=85.64 //y2=5.39
cc_7040 ( N_noxref_16_M158_noxref_g N_noxref_33_c_13861_n ) capacitor \
 c=0.0510602f //x=85.86 //y=6.205 //x2=85.64 //y2=5.39
cc_7041 ( N_noxref_16_c_10360_p N_noxref_33_c_13861_n ) capacitor \
 c=0.00827092f //x=85.935 //y=4.975 //x2=85.64 //y2=5.39
cc_7042 ( N_noxref_16_M159_noxref_g N_noxref_33_M159_noxref_d ) capacitor \
 c=0.0142133f //x=86.3 //y=6.205 //x2=86.375 //y2=5.205
cc_7043 ( N_noxref_16_c_9871_n N_GND_c_14101_n ) capacitor c=0.00196498f \
 //x=21.58 //y=2.375 //x2=24.155 //y2=0.175
cc_7044 ( N_noxref_16_c_9903_n N_GND_c_14105_n ) capacitor c=0.00608539f \
 //x=25.565 //y=1.835 //x2=27.38 //y2=0.175
cc_7045 ( N_noxref_16_c_9937_n N_GND_c_14105_n ) capacitor c=0.00928865f \
 //x=25.21 //y=1.18 //x2=27.38 //y2=0.175
cc_7046 ( N_noxref_16_M15_noxref_d N_GND_c_14105_n ) capacitor c=3.01769e-19 \
 //x=25.02 //y=1.085 //x2=27.38 //y2=0.175
cc_7047 ( N_noxref_16_c_10303_n N_GND_c_14661_n ) capacitor c=0.00653833f \
 //x=79.135 //y=3.125 //x2=79.37 //y2=1.015
cc_7048 ( N_noxref_16_c_10242_n N_GND_c_14788_n ) capacitor c=9.61983e-19 \
 //x=84.11 //y=2.43 //x2=85.945 //y2=0.175
cc_7049 ( N_noxref_16_c_10346_p N_GND_c_14788_n ) capacitor c=0.00100426f \
 //x=85.59 //y=2.43 //x2=85.945 //y2=0.175
cc_7050 ( N_noxref_16_c_10348_p N_GND_c_14788_n ) capacitor c=2.64659e-19 \
 //x=85.59 //y=2.26 //x2=85.945 //y2=0.175
cc_7051 ( N_noxref_16_c_10387_p N_GND_c_14791_n ) capacitor c=0.00175529f \
 //x=85.765 //y=1.045 //x2=86.03 //y2=1.02
cc_7052 ( N_noxref_16_c_10388_p N_GND_c_14791_n ) capacitor c=0.00373063f \
 //x=85.765 //y=1.39 //x2=86.03 //y2=1.02
cc_7053 ( N_noxref_16_c_10390_p N_GND_c_14791_n ) capacitor c=3.99385e-19 \
 //x=85.765 //y=1.7 //x2=86.03 //y2=1.02
cc_7054 ( N_noxref_16_c_10563_p N_GND_c_14791_n ) capacitor c=0.00924233f \
 //x=86.14 //y=0.89 //x2=86.03 //y2=1.02
cc_7055 ( N_noxref_16_c_10564_p N_GND_c_14791_n ) capacitor c=6.20182e-19 \
 //x=86.14 //y=1.545 //x2=86.03 //y2=1.02
cc_7056 ( N_noxref_16_c_10389_p N_GND_c_14791_n ) capacitor c=0.00181958f \
 //x=86.295 //y=1.045 //x2=86.03 //y2=1.02
cc_7057 ( N_noxref_16_c_10391_p N_GND_c_14791_n ) capacitor c=0.00417834f \
 //x=86.295 //y=1.39 //x2=86.03 //y2=1.02
cc_7058 ( N_noxref_16_c_9926_n N_GND_c_14117_n ) capacitor c=5.6239e-19 \
 //x=24.29 //y=5.56 //x2=24.24 //y2=1.135
cc_7059 ( N_noxref_16_c_9937_n N_GND_c_14117_n ) capacitor c=0.0140211f \
 //x=25.21 //y=1.18 //x2=24.24 //y2=1.135
cc_7060 ( N_noxref_16_M15_noxref_d N_GND_c_14117_n ) capacitor c=2.93544e-19 \
 //x=25.02 //y=1.085 //x2=24.24 //y2=1.135
cc_7061 ( N_noxref_16_c_9937_n N_GND_c_14351_n ) capacitor c=0.00606355f \
 //x=25.21 //y=1.18 //x2=27.465 //y2=1.145
cc_7062 ( N_noxref_16_c_10132_n N_GND_c_14591_n ) capacitor c=0.00354726f \
 //x=78.535 //y=3.14 //x2=76.04 //y2=1.135
cc_7063 ( N_noxref_16_c_9871_n N_GND_c_14066_n ) capacitor c=2.016e-19 \
 //x=21.58 //y=2.375 //x2=22.89 //y2=0.175
cc_7064 ( N_noxref_16_c_9903_n N_GND_c_14140_n ) capacitor c=7.75992e-19 \
 //x=25.565 //y=1.835 //x2=26.22 //y2=0.175
cc_7065 ( N_noxref_16_c_10242_n N_GND_c_14719_n ) capacitor c=9.41767e-19 \
 //x=84.11 //y=2.43 //x2=84.68 //y2=0.175
cc_7066 ( N_noxref_16_c_10346_p N_GND_c_14806_n ) capacitor c=6.59434e-19 \
 //x=85.59 //y=2.43 //x2=87.44 //y2=0.18
cc_7067 ( N_noxref_16_c_10348_p N_GND_c_14806_n ) capacitor c=2.74348e-19 \
 //x=85.59 //y=2.26 //x2=87.44 //y2=0.18
cc_7068 ( N_noxref_16_c_10387_p N_GND_c_14806_n ) capacitor c=0.00698682f \
 //x=85.765 //y=1.045 //x2=87.44 //y2=0.18
cc_7069 ( N_noxref_16_c_9906_n N_GND_c_14147_n ) capacitor c=9.32616e-19 \
 //x=25.65 //y=2.995 //x2=23.06 //y2=0.175
cc_7070 ( N_noxref_16_c_9945_n N_GND_c_14147_n ) capacitor c=0.00411812f \
 //x=25.49 //y=3.14 //x2=23.06 //y2=0.175
cc_7071 ( N_noxref_16_c_9959_n N_GND_c_14147_n ) capacitor c=0.00222376f \
 //x=21.58 //y=2.26 //x2=23.06 //y2=0.175
cc_7072 ( N_noxref_16_c_9993_n N_GND_c_14147_n ) capacitor c=0.00262688f \
 //x=22.1 //y=1.44 //x2=23.06 //y2=0.175
cc_7073 ( N_noxref_16_c_9997_n N_GND_c_14147_n ) capacitor c=2.63786e-19 \
 //x=21.58 //y=2.26 //x2=23.06 //y2=0.175
cc_7074 ( N_noxref_16_c_9896_n N_GND_c_14154_n ) capacitor c=0.00460657f \
 //x=25.21 //y=1.75 //x2=26.39 //y2=0.175
cc_7075 ( N_noxref_16_c_9903_n N_GND_c_14154_n ) capacitor c=0.0287655f \
 //x=25.565 //y=1.835 //x2=26.39 //y2=0.175
cc_7076 ( N_noxref_16_c_9956_n N_GND_c_14154_n ) capacitor c=0.00411812f \
 //x=29.505 //y=3.125 //x2=26.39 //y2=0.175
cc_7077 ( N_noxref_16_c_10014_n N_GND_c_14193_n ) capacitor c=0.00411812f \
 //x=34.89 //y=3.14 //x2=31.2 //y2=0.175
cc_7078 ( N_noxref_16_c_10022_n N_GND_c_14196_n ) capacitor c=0.00411812f \
 //x=36.735 //y=3.14 //x2=36.01 //y2=0.175
cc_7079 ( N_noxref_16_c_10033_n N_GND_c_14235_n ) capacitor c=0.00411812f \
 //x=40.07 //y=3.14 //x2=39.34 //y2=0.175
cc_7080 ( N_noxref_16_c_10055_n N_GND_c_14291_n ) capacitor c=0.00411812f \
 //x=55.235 //y=3.14 //x2=44.15 //y2=0.175
cc_7081 ( N_noxref_16_c_10055_n N_GND_c_14329_n ) capacitor c=0.00411812f \
 //x=55.235 //y=3.14 //x2=48.96 //y2=0.175
cc_7082 ( N_noxref_16_c_10055_n N_GND_c_14376_n ) capacitor c=0.00411812f \
 //x=55.235 //y=3.14 //x2=52.29 //y2=0.175
cc_7083 ( N_noxref_16_c_10103_n N_GND_c_14409_n ) capacitor c=0.00411812f \
 //x=58.935 //y=3.14 //x2=57.1 //y2=0.175
cc_7084 ( N_noxref_16_c_10141_n N_GND_c_14411_n ) capacitor c=0.00504399f \
 //x=62.635 //y=3.14 //x2=61.91 //y2=0.175
cc_7085 ( N_noxref_16_c_10145_n N_GND_c_14562_n ) capacitor c=0.00504399f \
 //x=65.97 //y=3.14 //x2=65.24 //y2=0.175
cc_7086 ( N_noxref_16_c_10132_n N_GND_c_14459_n ) capacitor c=0.00504399f \
 //x=78.535 //y=3.14 //x2=70.05 //y2=0.175
cc_7087 ( N_noxref_16_c_10132_n N_GND_c_14620_n ) capacitor c=0.00725442f \
 //x=78.535 //y=3.14 //x2=74.86 //y2=0.175
cc_7088 ( N_noxref_16_c_10132_n N_GND_c_14627_n ) capacitor c=0.00725442f \
 //x=78.535 //y=3.14 //x2=78.19 //y2=0.175
cc_7089 ( N_noxref_16_c_10303_n N_GND_c_14750_n ) capacitor c=0.00661596f \
 //x=79.135 //y=3.125 //x2=81.52 //y2=0.175
cc_7090 ( N_noxref_16_c_10312_n N_GND_c_14750_n ) capacitor c=3.88707e-19 \
 //x=84.11 //y=2.26 //x2=81.52 //y2=0.175
cc_7091 ( N_noxref_16_c_10242_n N_GND_c_14831_n ) capacitor c=0.00414357f \
 //x=84.11 //y=2.43 //x2=84.85 //y2=0.175
cc_7092 ( N_noxref_16_c_10245_n N_GND_c_14831_n ) capacitor c=0.0117547f \
 //x=84.11 //y=2.97 //x2=84.85 //y2=0.175
cc_7093 ( N_noxref_16_c_10346_p N_GND_c_14831_n ) capacitor c=0.00414357f \
 //x=85.59 //y=2.43 //x2=84.85 //y2=0.175
cc_7094 ( N_noxref_16_c_10252_n N_GND_c_14831_n ) capacitor c=0.0117547f \
 //x=85.59 //y=4.755 //x2=84.85 //y2=0.175
cc_7095 ( N_noxref_16_c_10376_p N_GND_c_14831_n ) capacitor c=0.0153655f \
 //x=85.425 //y=2.27 //x2=84.85 //y2=0.175
cc_7096 ( N_noxref_16_c_10312_n N_GND_c_14831_n ) capacitor c=0.00780676f \
 //x=84.11 //y=2.26 //x2=84.85 //y2=0.175
cc_7097 ( N_noxref_16_c_10348_p N_GND_c_14831_n ) capacitor c=0.00780676f \
 //x=85.59 //y=2.26 //x2=84.85 //y2=0.175
cc_7098 ( N_noxref_16_c_10334_n N_GND_c_14831_n ) capacitor c=0.00989164f \
 //x=83.935 //y=2.095 //x2=84.85 //y2=0.175
cc_7099 ( N_noxref_16_c_10393_p N_GND_c_14831_n ) capacitor c=0.00369332f \
 //x=85.765 //y=2.095 //x2=84.85 //y2=0.175
cc_7100 ( N_noxref_16_c_10349_p N_GND_c_14831_n ) capacitor c=0.00619832f \
 //x=85.59 //y=2.26 //x2=84.85 //y2=0.175
cc_7101 ( N_noxref_16_c_9937_n N_GND_M14_noxref_d ) capacitor c=2.82748e-19 \
 //x=25.21 //y=1.18 //x2=24.05 //y2=1.045
cc_7102 ( N_noxref_16_c_10387_p N_GND_M52_noxref_d ) capacitor c=0.00192399f \
 //x=85.765 //y=1.045 //x2=85.84 //y2=1.045
cc_7103 ( N_noxref_16_c_10388_p N_GND_M52_noxref_d ) capacitor c=0.00210798f \
 //x=85.765 //y=1.39 //x2=85.84 //y2=1.045
cc_7104 ( N_noxref_16_c_10563_p N_GND_M52_noxref_d ) capacitor c=0.00472259f \
 //x=86.14 //y=0.89 //x2=85.84 //y2=1.045
cc_7105 ( N_noxref_16_c_10564_p N_GND_M52_noxref_d ) capacitor c=0.00166857f \
 //x=86.14 //y=1.545 //x2=85.84 //y2=1.045
cc_7106 ( N_noxref_16_c_10389_p N_GND_M52_noxref_d ) capacitor c=0.00230174f \
 //x=86.295 //y=1.045 //x2=85.84 //y2=1.045
cc_7107 ( N_noxref_16_c_10391_p N_GND_M52_noxref_d ) capacitor c=0.00210798f \
 //x=86.295 //y=1.39 //x2=85.84 //y2=1.045
cc_7108 ( N_noxref_16_c_9905_n N_noxref_40_c_15840_n ) capacitor c=0.00911405f \
 //x=25.295 //y=1.835 //x2=24.725 //y2=1.675
cc_7109 ( N_noxref_16_c_9903_n N_noxref_40_c_15845_n ) capacitor c=0.00399245f \
 //x=25.565 //y=1.835 //x2=25.61 //y2=0.71
cc_7110 ( N_noxref_16_c_9937_n N_noxref_40_c_15845_n ) capacitor c=0.003751f \
 //x=25.21 //y=1.18 //x2=25.61 //y2=0.71
cc_7111 ( N_noxref_16_M15_noxref_d N_noxref_40_c_15845_n ) capacitor \
 c=0.00910163f //x=25.02 //y=1.085 //x2=25.61 //y2=0.71
cc_7112 ( N_noxref_16_c_9896_n N_noxref_40_M14_noxref_s ) capacitor \
 c=0.0175063f //x=25.21 //y=1.75 //x2=23.62 //y2=0.545
cc_7113 ( N_noxref_16_c_9903_n N_noxref_40_M14_noxref_s ) capacitor \
 c=0.00603051f //x=25.565 //y=1.835 //x2=23.62 //y2=0.545
cc_7114 ( N_noxref_16_c_9913_n N_noxref_40_M14_noxref_s ) capacitor \
 c=5.54596e-19 //x=25.65 //y=3.315 //x2=23.62 //y2=0.545
cc_7115 ( N_noxref_16_c_9937_n N_noxref_40_M14_noxref_s ) capacitor \
 c=0.0089443f //x=25.21 //y=1.18 //x2=23.62 //y2=0.545
cc_7116 ( N_noxref_16_c_9944_n N_noxref_40_M14_noxref_s ) capacitor \
 c=0.00140776f //x=25.65 //y=3.14 //x2=23.62 //y2=0.545
cc_7117 ( N_noxref_16_M15_noxref_d N_noxref_40_M14_noxref_s ) capacitor \
 c=0.0275552f //x=25.02 //y=1.085 //x2=23.62 //y2=0.545
cc_7118 ( N_noxref_16_c_10132_n N_noxref_51_c_16526_n ) capacitor \
 c=0.00203408f //x=78.535 //y=3.14 //x2=72.495 //y2=1.77
cc_7119 ( N_noxref_16_c_10132_n N_noxref_51_M43_noxref_s ) capacitor \
 c=0.00316687f //x=78.535 //y=3.14 //x2=70.505 //y2=0.555
cc_7120 ( N_noxref_16_c_10132_n N_noxref_52_c_16568_n ) capacitor \
 c=0.00309885f //x=78.535 //y=3.14 //x2=75.555 //y2=1.675
cc_7121 ( N_noxref_16_c_10132_n N_noxref_52_c_16569_n ) capacitor \
 c=0.00974662f //x=78.535 //y=3.14 //x2=76.44 //y2=1.76
cc_7122 ( N_noxref_16_c_10132_n N_noxref_52_c_16576_n ) capacitor \
 c=0.00270472f //x=78.535 //y=3.14 //x2=76.525 //y2=1.675
cc_7123 ( N_noxref_16_c_10132_n N_noxref_52_c_16581_n ) capacitor \
 c=5.82581e-19 //x=78.535 //y=3.14 //x2=77.41 //y2=0.71
cc_7124 ( N_noxref_16_c_10132_n N_noxref_52_M46_noxref_s ) capacitor \
 c=6.40304e-19 //x=78.535 //y=3.14 //x2=75.42 //y2=0.545
cc_7125 ( N_noxref_16_c_10303_n N_noxref_53_c_16635_n ) capacitor \
 c=2.28683e-19 //x=79.135 //y=3.125 //x2=78.885 //y2=1.675
cc_7126 ( N_noxref_16_c_10303_n N_noxref_53_c_16639_n ) capacitor c=0.0120279f \
 //x=79.135 //y=3.125 //x2=79.77 //y2=1.76
cc_7127 ( N_noxref_16_c_10303_n N_noxref_53_c_16648_n ) capacitor \
 c=0.00275258f //x=79.135 //y=3.125 //x2=79.855 //y2=1.675
cc_7128 ( N_noxref_16_c_10303_n N_noxref_53_c_16655_n ) capacitor c=2.9641e-19 \
 //x=79.135 //y=3.125 //x2=80.74 //y2=0.71
cc_7129 ( N_noxref_16_c_10303_n N_noxref_53_M48_noxref_s ) capacitor \
 c=0.00237459f //x=79.135 //y=3.125 //x2=78.75 //y2=0.545
cc_7130 ( N_noxref_16_c_10303_n N_noxref_54_c_16704_n ) capacitor \
 c=0.00211705f //x=79.135 //y=3.125 //x2=82.215 //y2=1.675
cc_7131 ( N_noxref_16_c_10303_n N_noxref_54_c_16705_n ) capacitor \
 c=0.00769826f //x=79.135 //y=3.125 //x2=83.1 //y2=1.76
cc_7132 ( N_noxref_16_c_10303_n N_noxref_54_c_16712_n ) capacitor \
 c=0.00237459f //x=79.135 //y=3.125 //x2=83.185 //y2=1.675
cc_7133 ( N_noxref_16_c_10334_n N_noxref_54_c_16712_n ) capacitor c=0.0028747f \
 //x=83.935 //y=2.095 //x2=83.185 //y2=1.675
cc_7134 ( N_noxref_16_c_10242_n N_noxref_54_c_16720_n ) capacitor \
 c=6.64536e-19 //x=84.11 //y=2.43 //x2=84.07 //y2=0.71
cc_7135 ( N_noxref_16_c_10246_n N_noxref_54_c_16720_n ) capacitor \
 c=5.73229e-19 //x=84.11 //y=3.29 //x2=84.07 //y2=0.71
cc_7136 ( N_noxref_16_c_10322_n N_noxref_54_c_16720_n ) capacitor c=0.0214576f \
 //x=83.405 //y=1.085 //x2=84.07 //y2=0.71
cc_7137 ( N_noxref_16_c_10331_n N_noxref_54_c_16720_n ) capacitor \
 c=0.00781103f //x=83.935 //y=1.085 //x2=84.07 //y2=0.71
cc_7138 ( N_noxref_16_c_10242_n N_noxref_54_M50_noxref_s ) capacitor \
 c=0.00472586f //x=84.11 //y=2.43 //x2=82.08 //y2=0.545
cc_7139 ( N_noxref_16_c_10312_n N_noxref_54_M50_noxref_s ) capacitor \
 c=0.010408f //x=84.11 //y=2.26 //x2=82.08 //y2=0.545
cc_7140 ( N_noxref_16_c_10322_n N_noxref_54_M50_noxref_s ) capacitor \
 c=0.00506846f //x=83.405 //y=1.085 //x2=82.08 //y2=0.545
cc_7141 ( N_noxref_16_c_10325_n N_noxref_54_M50_noxref_s ) capacitor \
 c=0.00602248f //x=83.405 //y=1.43 //x2=82.08 //y2=0.545
cc_7142 ( N_noxref_16_c_10331_n N_noxref_54_M50_noxref_s ) capacitor \
 c=0.0291051f //x=83.935 //y=1.085 //x2=82.08 //y2=0.545
cc_7143 ( N_noxref_16_c_10333_n N_noxref_54_M50_noxref_s ) capacitor \
 c=0.00369225f //x=83.935 //y=1.74 //x2=82.08 //y2=0.545
cc_7144 ( N_noxref_16_c_10334_n N_noxref_54_M50_noxref_s ) capacitor \
 c=0.00797698f //x=83.935 //y=2.095 //x2=82.08 //y2=0.545
cc_7145 ( N_noxref_16_c_10346_p N_noxref_55_c_16767_n ) capacitor \
 c=0.00472586f //x=85.59 //y=2.43 //x2=85.545 //y2=1.675
cc_7146 ( N_noxref_16_c_10348_p N_noxref_55_c_16767_n ) capacitor c=0.010408f \
 //x=85.59 //y=2.26 //x2=85.545 //y2=1.675
cc_7147 ( N_noxref_16_c_10393_p N_noxref_55_c_16767_n ) capacitor c=0.0027748f \
 //x=85.765 //y=2.095 //x2=85.545 //y2=1.675
cc_7148 ( N_noxref_16_c_10349_p N_noxref_55_c_16767_n ) capacitor \
 c=0.00544234f //x=85.59 //y=2.26 //x2=85.545 //y2=1.675
cc_7149 ( N_noxref_16_c_10346_p N_noxref_55_c_16771_n ) capacitor \
 c=0.00350518f //x=85.59 //y=2.43 //x2=86.43 //y2=1.76
cc_7150 ( N_noxref_16_c_10348_p N_noxref_55_c_16771_n ) capacitor \
 c=0.00305795f //x=85.59 //y=2.26 //x2=86.43 //y2=1.76
cc_7151 ( N_noxref_16_c_10390_p N_noxref_55_c_16771_n ) capacitor \
 c=0.00712798f //x=85.765 //y=1.7 //x2=86.43 //y2=1.76
cc_7152 ( N_noxref_16_c_10393_p N_noxref_55_c_16771_n ) capacitor c=0.013968f \
 //x=85.765 //y=2.095 //x2=86.43 //y2=1.76
cc_7153 ( N_noxref_16_c_10564_p N_noxref_55_c_16771_n ) capacitor \
 c=0.00948889f //x=86.14 //y=1.545 //x2=86.43 //y2=1.76
cc_7154 ( N_noxref_16_c_10391_p N_noxref_55_c_16771_n ) capacitor \
 c=0.00339872f //x=86.295 //y=1.39 //x2=86.43 //y2=1.76
cc_7155 ( N_noxref_16_c_10349_p N_noxref_55_c_16771_n ) capacitor \
 c=0.00168631f //x=85.59 //y=2.26 //x2=86.43 //y2=1.76
cc_7156 ( N_noxref_16_c_10393_p N_noxref_55_c_16778_n ) capacitor \
 c=6.71402e-19 //x=85.765 //y=2.095 //x2=86.515 //y2=1.675
cc_7157 ( N_noxref_16_c_10387_p N_noxref_55_M52_noxref_s ) capacitor \
 c=0.0293163f //x=85.765 //y=1.045 //x2=85.41 //y2=0.545
cc_7158 ( N_noxref_16_c_10390_p N_noxref_55_M52_noxref_s ) capacitor \
 c=0.00110192f //x=85.765 //y=1.7 //x2=85.41 //y2=0.545
cc_7159 ( N_noxref_16_c_10389_p N_noxref_55_M52_noxref_s ) capacitor \
 c=0.0123625f //x=86.295 //y=1.045 //x2=85.41 //y2=0.545
cc_7160 ( N_noxref_17_c_10945_n QN ) capacitor c=0.0146548f //x=86.7 //y=2.38 \
 //x2=87.44 //y2=2.4
cc_7161 ( N_noxref_17_c_10949_n QN ) capacitor c=0.0776437f //x=86.7 //y=4.05 \
 //x2=87.44 //y2=2.4
cc_7162 ( N_noxref_17_c_10954_n QN ) capacitor c=0.0157342f //x=86.7 //y=4.37 \
 //x2=87.44 //y2=2.4
cc_7163 ( N_noxref_17_c_10955_n QN ) capacitor c=0.0330377f //x=86.7 //y=4.74 \
 //x2=87.44 //y2=2.4
cc_7164 ( N_noxref_17_c_10961_n QN ) capacitor c=0.00458619f //x=86.7 //y=4.25 \
 //x2=87.44 //y2=2.4
cc_7165 ( N_noxref_17_c_10966_n QN ) capacitor c=0.00730952f //x=86.715 \
 //y=4.21 //x2=87.44 //y2=2.4
cc_7166 ( N_noxref_17_c_10976_n QN ) capacitor c=0.00442101f //x=86.7 //y=2.26 \
 //x2=87.44 //y2=2.4
cc_7167 ( N_noxref_17_c_10979_n QN ) capacitor c=0.00472529f //x=86.72 \
 //y=4.885 //x2=87.44 //y2=2.4
cc_7168 ( N_noxref_17_c_11012_p QN ) capacitor c=0.00472303f //x=87.105 \
 //y=4.975 //x2=87.44 //y2=2.4
cc_7169 ( N_noxref_17_c_10997_n QN ) capacitor c=0.00284078f //x=86.7 //y=2.26 \
 //x2=87.44 //y2=2.4
cc_7170 ( N_noxref_17_c_11000_n QN ) capacitor c=0.00141883f //x=86.72 \
 //y=4.885 //x2=87.44 //y2=2.4
cc_7171 ( N_noxref_17_c_10954_n N_QN_c_11258_n ) capacitor c=0.00435926f \
 //x=86.7 //y=4.37 //x2=86.835 //y2=5.39
cc_7172 ( N_noxref_17_c_10955_n N_QN_c_11258_n ) capacitor c=0.0223378f \
 //x=86.7 //y=4.74 //x2=86.835 //y2=5.39
cc_7173 ( N_noxref_17_c_10966_n N_QN_c_11258_n ) capacitor c=7.70643e-19 \
 //x=86.715 //y=4.21 //x2=86.835 //y2=5.39
cc_7174 ( N_noxref_17_c_10904_n N_QN_c_11258_n ) capacitor c=0.0017832f \
 //x=86.555 //y=4.21 //x2=86.835 //y2=5.39
cc_7175 ( N_noxref_17_c_10979_n N_QN_c_11258_n ) capacitor c=0.00459858f \
 //x=86.72 //y=4.885 //x2=86.835 //y2=5.39
cc_7176 ( N_noxref_17_M160_noxref_g N_QN_c_11258_n ) capacitor c=0.00846675f \
 //x=86.74 //y=6.205 //x2=86.835 //y2=5.39
cc_7177 ( N_noxref_17_c_11000_n N_QN_c_11258_n ) capacitor c=7.28626e-19 \
 //x=86.72 //y=4.885 //x2=86.835 //y2=5.39
cc_7178 ( N_noxref_17_c_10945_n N_QN_c_11315_n ) capacitor c=0.00233055f \
 //x=86.7 //y=2.38 //x2=87 //y2=1.535
cc_7179 ( N_noxref_17_c_10976_n N_QN_c_11315_n ) capacitor c=8.15893e-19 \
 //x=86.7 //y=2.26 //x2=87 //y2=1.535
cc_7180 ( N_noxref_17_c_10986_n N_QN_c_11315_n ) capacitor c=5.01861e-19 \
 //x=86.735 //y=1.085 //x2=87 //y2=1.535
cc_7181 ( N_noxref_17_c_10989_n N_QN_c_11315_n ) capacitor c=0.00397521f \
 //x=86.735 //y=1.435 //x2=87 //y2=1.535
cc_7182 ( N_noxref_17_c_10991_n N_QN_c_11315_n ) capacitor c=0.00205332f \
 //x=86.735 //y=1.74 //x2=87 //y2=1.535
cc_7183 ( N_noxref_17_c_11027_p N_QN_c_11315_n ) capacitor c=3.72732e-19 \
 //x=87.11 //y=0.93 //x2=87 //y2=1.535
cc_7184 ( N_noxref_17_c_10994_n N_QN_c_11315_n ) capacitor c=0.00194493f \
 //x=87.11 //y=1.585 //x2=87 //y2=1.535
cc_7185 ( N_noxref_17_c_10995_n N_QN_c_11315_n ) capacitor c=2.0901e-19 \
 //x=87.265 //y=1.085 //x2=87 //y2=1.535
cc_7186 ( N_noxref_17_c_10996_n N_QN_c_11315_n ) capacitor c=0.00271521f \
 //x=87.265 //y=1.435 //x2=87 //y2=1.535
cc_7187 ( N_noxref_17_c_10997_n N_QN_c_11315_n ) capacitor c=2.48891e-19 \
 //x=86.7 //y=2.26 //x2=87 //y2=1.535
cc_7188 ( N_noxref_17_c_10991_n N_QN_c_11325_n ) capacitor c=0.0018678f \
 //x=86.735 //y=1.74 //x2=87 //y2=1.74
cc_7189 ( N_noxref_17_c_10994_n N_QN_c_11325_n ) capacitor c=0.0061514f \
 //x=87.11 //y=1.585 //x2=87 //y2=1.74
cc_7190 ( N_noxref_17_M161_noxref_g N_QN_c_11327_n ) capacitor c=0.0116091f \
 //x=87.18 //y=6.205 //x2=87.355 //y2=5.39
cc_7191 ( N_noxref_17_c_10994_n N_QN_c_11328_n ) capacitor c=0.0048413f \
 //x=87.11 //y=1.585 //x2=87.355 //y2=1.825
cc_7192 ( N_noxref_17_c_11036_p N_QN_c_11329_n ) capacitor c=0.00368358f \
 //x=86.7 //y=2.095 //x2=87.085 //y2=1.825
cc_7193 ( N_noxref_17_c_10734_n N_QN_c_11259_n ) capacitor c=0.00116093f \
 //x=77.01 //y=1.75 //x2=80.34 //y2=1.36
cc_7194 ( N_noxref_17_c_10777_n N_QN_c_11259_n ) capacitor c=2.97884e-19 \
 //x=77.01 //y=1.18 //x2=80.34 //y2=1.36
cc_7195 ( N_noxref_17_c_10918_n N_QN_c_11259_n ) capacitor c=3.77121e-19 \
 //x=80.075 //y=1.085 //x2=80.34 //y2=1.36
cc_7196 ( N_noxref_17_c_10921_n N_QN_c_11259_n ) capacitor c=0.00244881f \
 //x=80.075 //y=1.43 //x2=80.34 //y2=1.36
cc_7197 ( N_noxref_17_c_10923_n N_QN_c_11259_n ) capacitor c=0.00150083f \
 //x=80.075 //y=1.74 //x2=80.34 //y2=1.36
cc_7198 ( N_noxref_17_c_11042_p N_QN_c_11259_n ) capacitor c=3.38306e-19 \
 //x=80.45 //y=0.93 //x2=80.34 //y2=1.36
cc_7199 ( N_noxref_17_c_11043_p N_QN_c_11259_n ) capacitor c=0.0022369f \
 //x=80.45 //y=1.585 //x2=80.34 //y2=1.36
cc_7200 ( N_noxref_17_c_10926_n N_QN_c_11259_n ) capacitor c=3.16128e-19 \
 //x=80.605 //y=1.085 //x2=80.34 //y2=1.36
cc_7201 ( N_noxref_17_c_10927_n N_QN_c_11259_n ) capacitor c=0.00792519f \
 //x=80.605 //y=1.43 //x2=80.34 //y2=1.36
cc_7202 ( N_noxref_17_c_10904_n N_QN_c_11268_n ) capacitor c=0.0169094f \
 //x=86.555 //y=4.21 //x2=86.08 //y2=5.39
cc_7203 ( N_noxref_17_c_10966_n N_QN_c_11340_n ) capacitor c=6.25661e-19 \
 //x=86.715 //y=4.21 //x2=86.957 //y2=5.39
cc_7204 ( N_noxref_17_M160_noxref_g N_QN_c_11340_n ) capacitor c=0.00180711f \
 //x=86.74 //y=6.205 //x2=86.957 //y2=5.39
cc_7205 ( N_noxref_17_M161_noxref_g N_QN_c_11340_n ) capacitor c=0.00341268f \
 //x=87.18 //y=6.205 //x2=86.957 //y2=5.39
cc_7206 ( N_noxref_17_c_11012_p N_QN_c_11340_n ) capacitor c=0.00216603f \
 //x=87.105 //y=4.975 //x2=86.957 //y2=5.39
cc_7207 ( N_noxref_17_c_10927_n N_QN_c_11251_n ) capacitor c=0.00156453f \
 //x=80.605 //y=1.43 //x2=83.54 //y2=1.405
cc_7208 ( N_noxref_17_c_10991_n N_QN_c_11345_n ) capacitor c=0.00131018f \
 //x=86.735 //y=1.74 //x2=86.995 //y2=1.405
cc_7209 ( N_noxref_17_c_10994_n N_QN_c_11345_n ) capacitor c=0.00184285f \
 //x=87.11 //y=1.585 //x2=86.995 //y2=1.405
cc_7210 ( N_noxref_17_c_10945_n N_QN_c_11275_n ) capacitor c=0.00997796f \
 //x=86.7 //y=2.38 //x2=86.835 //y2=1.405
cc_7211 ( N_noxref_17_c_10989_n N_QN_c_11275_n ) capacitor c=0.00107668f \
 //x=86.735 //y=1.435 //x2=86.835 //y2=1.405
cc_7212 ( N_noxref_17_c_10991_n N_QN_c_11275_n ) capacitor c=8.64037e-19 \
 //x=86.735 //y=1.74 //x2=86.835 //y2=1.405
cc_7213 ( N_noxref_17_M160_noxref_g N_QN_c_11350_n ) capacitor c=0.0141401f \
 //x=86.74 //y=6.205 //x2=86.96 //y2=5.56
cc_7214 ( N_noxref_17_M161_noxref_g N_QN_c_11350_n ) capacitor c=0.0139971f \
 //x=87.18 //y=6.205 //x2=86.96 //y2=5.56
cc_7215 ( N_noxref_17_c_11012_p N_QN_c_11350_n ) capacitor c=0.00293135f \
 //x=87.105 //y=4.975 //x2=86.96 //y2=5.56
cc_7216 ( N_noxref_17_c_10918_n N_QN_M49_noxref_d ) capacitor c=0.00218556f \
 //x=80.075 //y=1.085 //x2=80.15 //y2=1.085
cc_7217 ( N_noxref_17_c_10921_n N_QN_M49_noxref_d ) capacitor c=0.00327871f \
 //x=80.075 //y=1.43 //x2=80.15 //y2=1.085
cc_7218 ( N_noxref_17_c_10923_n N_QN_M49_noxref_d ) capacitor c=0.00254845f \
 //x=80.075 //y=1.74 //x2=80.15 //y2=1.085
cc_7219 ( N_noxref_17_c_11042_p N_QN_M49_noxref_d ) capacitor c=0.00235569f \
 //x=80.45 //y=0.93 //x2=80.15 //y2=1.085
cc_7220 ( N_noxref_17_c_11043_p N_QN_M49_noxref_d ) capacitor c=0.00523156f \
 //x=80.45 //y=1.585 //x2=80.15 //y2=1.085
cc_7221 ( N_noxref_17_c_10926_n N_QN_M49_noxref_d ) capacitor c=0.00131413f \
 //x=80.605 //y=1.085 //x2=80.15 //y2=1.085
cc_7222 ( N_noxref_17_c_10927_n N_QN_M49_noxref_d ) capacitor c=0.0065758f \
 //x=80.605 //y=1.43 //x2=80.15 //y2=1.085
cc_7223 ( N_noxref_17_c_10986_n N_QN_M53_noxref_d ) capacitor c=0.00226395f \
 //x=86.735 //y=1.085 //x2=86.81 //y2=1.085
cc_7224 ( N_noxref_17_c_10989_n N_QN_M53_noxref_d ) capacitor c=0.004517f \
 //x=86.735 //y=1.435 //x2=86.81 //y2=1.085
cc_7225 ( N_noxref_17_c_10991_n N_QN_M53_noxref_d ) capacitor c=0.00275912f \
 //x=86.735 //y=1.74 //x2=86.81 //y2=1.085
cc_7226 ( N_noxref_17_c_11027_p N_QN_M53_noxref_d ) capacitor c=0.00234223f \
 //x=87.11 //y=0.93 //x2=86.81 //y2=1.085
cc_7227 ( N_noxref_17_c_10994_n N_QN_M53_noxref_d ) capacitor c=0.00707878f \
 //x=87.11 //y=1.585 //x2=86.81 //y2=1.085
cc_7228 ( N_noxref_17_c_10995_n N_QN_M53_noxref_d ) capacitor c=0.00132831f \
 //x=87.265 //y=1.085 //x2=86.81 //y2=1.085
cc_7229 ( N_noxref_17_c_10996_n N_QN_M53_noxref_d ) capacitor c=0.00330743f \
 //x=87.265 //y=1.435 //x2=86.81 //y2=1.085
cc_7230 ( N_noxref_17_c_10726_n N_VDD_c_11464_n ) capacitor c=0.00648267f \
 //x=76.855 //y=5.38 //x2=78.895 //y2=7.585
cc_7231 ( N_noxref_17_c_10740_n N_VDD_c_11464_n ) capacitor c=0.00492578f \
 //x=77.365 //y=5.38 //x2=78.895 //y2=7.585
cc_7232 ( N_noxref_17_c_10764_n N_VDD_c_11464_n ) capacitor c=0.00368834f \
 //x=76.09 //y=5.56 //x2=78.895 //y2=7.585
cc_7233 ( N_noxref_17_c_10774_n N_VDD_c_11464_n ) capacitor c=8.4268e-19 \
 //x=76.97 //y=5.38 //x2=78.895 //y2=7.585
cc_7234 ( N_noxref_17_c_11078_p N_VDD_c_11464_n ) capacitor c=0.00285853f \
 //x=76.97 //y=5.56 //x2=78.895 //y2=7.585
cc_7235 ( N_noxref_17_c_10806_n N_VDD_c_11464_n ) capacitor c=0.00224881f \
 //x=76.09 //y=5.56 //x2=78.895 //y2=7.585
cc_7236 ( N_noxref_17_c_10812_n N_VDD_c_11464_n ) capacitor c=0.00224881f \
 //x=76.97 //y=5.56 //x2=78.895 //y2=7.585
cc_7237 ( N_noxref_17_M152_noxref_g N_VDD_c_12459_n ) capacitor c=0.00125343f \
 //x=80.08 //y=6.205 //x2=79.86 //y2=7.035
cc_7238 ( N_noxref_17_M152_noxref_g N_VDD_c_12460_n ) capacitor c=0.00137209f \
 //x=80.08 //y=6.205 //x2=79.86 //y2=7.41
cc_7239 ( N_noxref_17_M153_noxref_g N_VDD_c_12674_n ) capacitor c=0.00373588f \
 //x=80.52 //y=6.205 //x2=80.74 //y2=7.035
cc_7240 ( N_noxref_17_M153_noxref_g N_VDD_c_12675_n ) capacitor c=0.00300944f \
 //x=80.52 //y=6.205 //x2=80.74 //y2=7.41
cc_7241 ( N_noxref_17_M144_noxref_g N_VDD_c_12329_n ) capacitor c=0.00755544f \
 //x=73.12 //y=6.2 //x2=73.695 //y2=7.585
cc_7242 ( N_noxref_17_M145_noxref_g N_VDD_c_12329_n ) capacitor c=0.00755754f \
 //x=73.56 //y=6.2 //x2=73.695 //y2=7.585
cc_7243 ( N_noxref_17_c_10726_n N_VDD_c_12335_n ) capacitor c=0.00208087f \
 //x=76.855 //y=5.38 //x2=76.445 //y2=7.585
cc_7244 ( N_noxref_17_c_10764_n N_VDD_c_12335_n ) capacitor c=9.41185e-19 \
 //x=76.09 //y=5.56 //x2=76.445 //y2=7.585
cc_7245 ( N_noxref_17_c_10806_n N_VDD_c_12335_n ) capacitor c=0.0136705f \
 //x=76.09 //y=5.56 //x2=76.445 //y2=7.585
cc_7246 ( N_noxref_17_c_10726_n N_VDD_c_12338_n ) capacitor c=0.00180737f \
 //x=76.855 //y=5.38 //x2=77.325 //y2=7.585
cc_7247 ( N_noxref_17_c_10740_n N_VDD_c_12338_n ) capacitor c=0.00208087f \
 //x=77.365 //y=5.38 //x2=77.325 //y2=7.585
cc_7248 ( N_noxref_17_c_10774_n N_VDD_c_12338_n ) capacitor c=4.23719e-19 \
 //x=76.97 //y=5.38 //x2=77.325 //y2=7.585
cc_7249 ( N_noxref_17_c_11078_p N_VDD_c_12338_n ) capacitor c=5.77976e-19 \
 //x=76.97 //y=5.56 //x2=77.325 //y2=7.585
cc_7250 ( N_noxref_17_c_10812_n N_VDD_c_12338_n ) capacitor c=0.0136705f \
 //x=76.97 //y=5.56 //x2=77.325 //y2=7.585
cc_7251 ( N_noxref_17_M152_noxref_g N_VDD_c_12498_n ) capacitor c=0.007206f \
 //x=80.08 //y=6.205 //x2=81.35 //y2=7.585
cc_7252 ( N_noxref_17_M153_noxref_g N_VDD_c_12498_n ) capacitor c=0.00778439f \
 //x=80.52 //y=6.205 //x2=81.35 //y2=7.585
cc_7253 ( N_noxref_17_c_10961_n N_VDD_c_12628_n ) capacitor c=0.00143077f \
 //x=86.7 //y=4.25 //x2=87.44 //y2=7.58
cc_7254 ( N_noxref_17_c_10979_n N_VDD_c_12628_n ) capacitor c=0.00237807f \
 //x=86.72 //y=4.885 //x2=87.44 //y2=7.58
cc_7255 ( N_noxref_17_M160_noxref_g N_VDD_c_12628_n ) capacitor c=0.00728344f \
 //x=86.74 //y=6.205 //x2=87.44 //y2=7.58
cc_7256 ( N_noxref_17_M161_noxref_g N_VDD_c_12628_n ) capacitor c=0.00782837f \
 //x=87.18 //y=6.205 //x2=87.44 //y2=7.58
cc_7257 ( N_noxref_17_c_11012_p N_VDD_c_12628_n ) capacitor c=0.025943f \
 //x=87.105 //y=4.975 //x2=87.44 //y2=7.58
cc_7258 ( N_noxref_17_c_11000_n N_VDD_c_12628_n ) capacitor c=2.70151e-19 \
 //x=86.72 //y=4.885 //x2=87.44 //y2=7.58
cc_7259 ( N_noxref_17_c_10753_n N_VDD_c_12364_n ) capacitor c=0.0013228f \
 //x=77.45 //y=5.295 //x2=74.86 //y2=7.585
cc_7260 ( N_noxref_17_c_10764_n N_VDD_c_12364_n ) capacitor c=4.91377e-19 \
 //x=76.09 //y=5.56 //x2=74.86 //y2=7.585
cc_7261 ( N_noxref_17_c_10690_n N_VDD_c_12364_n ) capacitor c=0.00224736f \
 //x=73.38 //y=4.88 //x2=74.86 //y2=7.585
cc_7262 ( N_noxref_17_c_10806_n N_VDD_c_12364_n ) capacitor c=0.0064135f \
 //x=76.09 //y=5.56 //x2=74.86 //y2=7.585
cc_7263 ( N_noxref_17_c_10704_n N_VDD_c_12364_n ) capacitor c=2.63786e-19 \
 //x=73.38 //y=4.88 //x2=74.86 //y2=7.585
cc_7264 ( N_noxref_17_c_10753_n N_VDD_c_12376_n ) capacitor c=0.0298637f \
 //x=77.45 //y=5.295 //x2=78.19 //y2=7.585
cc_7265 ( N_noxref_17_c_10774_n N_VDD_c_12376_n ) capacitor c=0.00240666f \
 //x=76.97 //y=5.38 //x2=78.19 //y2=7.585
cc_7266 ( N_noxref_17_c_11078_p N_VDD_c_12376_n ) capacitor c=4.09141e-19 \
 //x=76.97 //y=5.56 //x2=78.19 //y2=7.585
cc_7267 ( N_noxref_17_c_10889_n N_VDD_c_12376_n ) capacitor c=9.52781e-19 \
 //x=80.04 //y=4.25 //x2=78.19 //y2=7.585
cc_7268 ( N_noxref_17_c_10798_n N_VDD_c_12376_n ) capacitor c=0.00643448f \
 //x=78.79 //y=3.895 //x2=78.19 //y2=7.585
cc_7269 ( N_noxref_17_c_10812_n N_VDD_c_12376_n ) capacitor c=0.0101445f \
 //x=76.97 //y=5.56 //x2=78.19 //y2=7.585
cc_7270 ( N_noxref_17_c_10875_n N_VDD_c_12540_n ) capacitor c=5.31543e-19 \
 //x=80.04 //y=4.365 //x2=81.52 //y2=7.585
cc_7271 ( N_noxref_17_c_10878_n N_VDD_c_12540_n ) capacitor c=0.00746843f \
 //x=80.04 //y=4.71 //x2=81.52 //y2=7.585
cc_7272 ( N_noxref_17_c_10889_n N_VDD_c_12540_n ) capacitor c=0.00144593f \
 //x=80.04 //y=4.25 //x2=81.52 //y2=7.585
cc_7273 ( N_noxref_17_c_10904_n N_VDD_c_12540_n ) capacitor c=0.00818761f \
 //x=86.555 //y=4.21 //x2=81.52 //y2=7.585
cc_7274 ( N_noxref_17_c_10912_n N_VDD_c_12540_n ) capacitor c=0.00250302f \
 //x=80.08 //y=4.885 //x2=81.52 //y2=7.585
cc_7275 ( N_noxref_17_c_11119_p N_VDD_c_12540_n ) capacitor c=0.0117152f \
 //x=80.445 //y=4.975 //x2=81.52 //y2=7.585
cc_7276 ( N_noxref_17_c_10931_n N_VDD_c_12540_n ) capacitor c=2.76772e-19 \
 //x=80.08 //y=4.885 //x2=81.52 //y2=7.585
cc_7277 ( N_noxref_17_c_10955_n N_VDD_c_12546_n ) capacitor c=5.18027e-19 \
 //x=86.7 //y=4.74 //x2=84.85 //y2=7.585
cc_7278 ( N_noxref_17_c_10961_n N_VDD_c_12546_n ) capacitor c=8.21577e-19 \
 //x=86.7 //y=4.25 //x2=84.85 //y2=7.585
cc_7279 ( N_noxref_17_c_10904_n N_VDD_c_12546_n ) capacitor c=0.0135112f \
 //x=86.555 //y=4.21 //x2=84.85 //y2=7.585
cc_7280 ( N_noxref_17_c_10979_n N_VDD_c_12546_n ) capacitor c=6.64651e-19 \
 //x=86.72 //y=4.885 //x2=84.85 //y2=7.585
cc_7281 ( N_noxref_17_M144_noxref_g N_VDD_M143_noxref_d ) capacitor \
 c=0.015318f //x=73.12 //y=6.2 //x2=72.755 //y2=5.2
cc_7282 ( N_noxref_17_M145_noxref_g N_VDD_M145_noxref_d ) capacitor \
 c=0.0394719f //x=73.56 //y=6.2 //x2=73.635 //y2=5.2
cc_7283 ( N_noxref_17_c_10764_n N_VDD_M146_noxref_s ) capacitor c=0.0611368f \
 //x=76.09 //y=5.56 //x2=75.515 //y2=5.2
cc_7284 ( N_noxref_17_c_10774_n N_VDD_M146_noxref_s ) capacitor c=6.52457e-19 \
 //x=76.97 //y=5.38 //x2=75.515 //y2=5.2
cc_7285 ( N_noxref_17_c_10806_n N_VDD_M146_noxref_s ) capacitor c=0.0886845f \
 //x=76.09 //y=5.56 //x2=75.515 //y2=5.2
cc_7286 ( N_noxref_17_c_10726_n N_VDD_M147_noxref_d ) capacitor c=0.00734094f \
 //x=76.855 //y=5.38 //x2=76.385 //y2=5.2
cc_7287 ( N_noxref_17_c_10764_n N_VDD_M147_noxref_d ) capacitor c=0.0043528f \
 //x=76.09 //y=5.56 //x2=76.385 //y2=5.2
cc_7288 ( N_noxref_17_c_11078_p N_VDD_M147_noxref_d ) capacitor c=0.0043528f \
 //x=76.97 //y=5.56 //x2=76.385 //y2=5.2
cc_7289 ( N_noxref_17_c_10806_n N_VDD_M147_noxref_d ) capacitor c=0.0654251f \
 //x=76.09 //y=5.56 //x2=76.385 //y2=5.2
cc_7290 ( N_noxref_17_c_10812_n N_VDD_M147_noxref_d ) capacitor c=0.0653541f \
 //x=76.97 //y=5.56 //x2=76.385 //y2=5.2
cc_7291 ( N_noxref_17_c_10740_n N_VDD_M149_noxref_d ) capacitor c=0.00898356f \
 //x=77.365 //y=5.38 //x2=77.265 //y2=5.2
cc_7292 ( N_noxref_17_c_11078_p N_VDD_M149_noxref_d ) capacitor c=0.00979407f \
 //x=76.97 //y=5.56 //x2=77.265 //y2=5.2
cc_7293 ( N_noxref_17_c_10784_n N_VDD_M149_noxref_d ) capacitor c=0.00122238f \
 //x=77.45 //y=3.88 //x2=77.265 //y2=5.2
cc_7294 ( N_noxref_17_c_10812_n N_VDD_M149_noxref_d ) capacitor c=0.0651808f \
 //x=76.97 //y=5.56 //x2=77.265 //y2=5.2
cc_7295 ( N_noxref_17_c_10740_n N_VDD_M150_noxref_s ) capacitor c=0.0030269f \
 //x=77.365 //y=5.38 //x2=78.845 //y2=5.205
cc_7296 ( N_noxref_17_c_10774_n N_VDD_M150_noxref_s ) capacitor c=0.00519953f \
 //x=76.97 //y=5.38 //x2=78.845 //y2=5.205
cc_7297 ( N_noxref_17_c_11078_p N_VDD_M150_noxref_s ) capacitor c=3.28075e-19 \
 //x=76.97 //y=5.56 //x2=78.845 //y2=5.205
cc_7298 ( N_noxref_17_M152_noxref_g N_VDD_M151_noxref_d ) capacitor \
 c=0.0127979f //x=80.08 //y=6.205 //x2=79.715 //y2=5.205
cc_7299 ( N_noxref_17_M153_noxref_g N_VDD_M153_noxref_d ) capacitor \
 c=0.0463918f //x=80.52 //y=6.205 //x2=80.595 //y2=5.205
cc_7300 ( N_noxref_17_c_10673_n N_noxref_31_c_13617_n ) capacitor \
 c=0.00177186f //x=73.38 //y=2.375 //x2=74.035 //y2=0.72
cc_7301 ( N_noxref_17_c_10687_n N_noxref_31_c_13617_n ) capacitor \
 c=0.00117306f //x=73.38 //y=2.26 //x2=74.035 //y2=0.72
cc_7302 ( N_noxref_17_c_10697_n N_noxref_31_c_13617_n ) capacitor c=0.0206349f \
 //x=73.37 //y=1.095 //x2=74.035 //y2=0.72
cc_7303 ( N_noxref_17_c_10833_n N_noxref_31_c_13617_n ) capacitor \
 c=0.00825432f //x=73.9 //y=1.095 //x2=74.035 //y2=0.72
cc_7304 ( N_noxref_17_c_10700_n N_noxref_31_c_13617_n ) capacitor \
 c=2.20712e-19 //x=73.38 //y=2.26 //x2=74.035 //y2=0.72
cc_7305 ( N_noxref_17_c_10698_n N_noxref_31_c_13620_n ) capacitor c=0.0071177f \
 //x=73.37 //y=1.44 //x2=73.15 //y2=1.175
cc_7306 ( N_noxref_17_c_10697_n N_noxref_31_M45_noxref_s ) capacitor \
 c=0.0071177f //x=73.37 //y=1.095 //x2=73.015 //y2=0.555
cc_7307 ( N_noxref_17_c_10699_n N_noxref_31_M45_noxref_s ) capacitor \
 c=0.0071177f //x=73.37 //y=1.75 //x2=73.015 //y2=0.555
cc_7308 ( N_noxref_17_c_10833_n N_noxref_31_M45_noxref_s ) capacitor \
 c=0.015333f //x=73.9 //y=1.095 //x2=73.015 //y2=0.555
cc_7309 ( N_noxref_17_c_10835_n N_noxref_31_M45_noxref_s ) capacitor \
 c=0.00248746f //x=73.9 //y=1.44 //x2=73.015 //y2=0.555
cc_7310 ( N_noxref_17_c_10875_n N_noxref_32_c_13668_n ) capacitor \
 c=0.00150537f //x=80.04 //y=4.365 //x2=80.185 //y2=5.39
cc_7311 ( N_noxref_17_c_10878_n N_noxref_32_c_13668_n ) capacitor c=0.0212118f \
 //x=80.04 //y=4.71 //x2=80.185 //y2=5.39
cc_7312 ( N_noxref_17_c_10889_n N_noxref_32_c_13668_n ) capacitor \
 c=3.71828e-19 //x=80.04 //y=4.25 //x2=80.185 //y2=5.39
cc_7313 ( N_noxref_17_c_10912_n N_noxref_32_c_13668_n ) capacitor c=0.004587f \
 //x=80.08 //y=4.885 //x2=80.185 //y2=5.39
cc_7314 ( N_noxref_17_M152_noxref_g N_noxref_32_c_13668_n ) capacitor \
 c=0.00913391f //x=80.08 //y=6.205 //x2=80.185 //y2=5.39
cc_7315 ( N_noxref_17_c_10931_n N_noxref_32_c_13668_n ) capacitor \
 c=6.87087e-19 //x=80.08 //y=4.885 //x2=80.185 //y2=5.39
cc_7316 ( N_noxref_17_M153_noxref_g N_noxref_32_c_13670_n ) capacitor \
 c=0.011434f //x=80.52 //y=6.205 //x2=82.185 //y2=5.39
cc_7317 ( N_noxref_17_c_10753_n N_noxref_32_c_13673_n ) capacitor \
 c=3.80255e-19 //x=77.45 //y=5.295 //x2=80.415 //y2=5.39
cc_7318 ( N_noxref_17_c_10875_n N_noxref_32_c_13673_n ) capacitor \
 c=0.00145195f //x=80.04 //y=4.365 //x2=80.415 //y2=5.39
cc_7319 ( N_noxref_17_c_10878_n N_noxref_32_c_13673_n ) capacitor \
 c=0.00252287f //x=80.04 //y=4.71 //x2=80.415 //y2=5.39
cc_7320 ( N_noxref_17_M152_noxref_g N_noxref_32_c_13673_n ) capacitor \
 c=7.30299e-19 //x=80.08 //y=6.205 //x2=80.415 //y2=5.39
cc_7321 ( N_noxref_17_M153_noxref_g N_noxref_32_c_13673_n ) capacitor \
 c=8.30848e-19 //x=80.52 //y=6.205 //x2=80.415 //y2=5.39
cc_7322 ( N_noxref_17_c_10740_n N_noxref_32_c_13680_n ) capacitor c=7.7292e-19 \
 //x=77.365 //y=5.38 //x2=79.422 //y2=5.39
cc_7323 ( N_noxref_17_c_10774_n N_noxref_32_c_13680_n ) capacitor \
 c=5.60834e-19 //x=76.97 //y=5.38 //x2=79.422 //y2=5.39
cc_7324 ( N_noxref_17_c_10875_n N_noxref_32_c_13689_n ) capacitor \
 c=0.00167023f //x=80.04 //y=4.365 //x2=80.3 //y2=5.39
cc_7325 ( N_noxref_17_M152_noxref_g N_noxref_32_c_13689_n ) capacitor \
 c=0.021802f //x=80.08 //y=6.205 //x2=80.3 //y2=5.39
cc_7326 ( N_noxref_17_M153_noxref_g N_noxref_32_c_13689_n ) capacitor \
 c=0.0189969f //x=80.52 //y=6.205 //x2=80.3 //y2=5.39
cc_7327 ( N_noxref_17_c_11119_p N_noxref_32_c_13689_n ) capacitor \
 c=0.00449628f //x=80.445 //y=4.975 //x2=80.3 //y2=5.39
cc_7328 ( N_noxref_17_M152_noxref_g N_noxref_32_M152_noxref_d ) capacitor \
 c=0.00122946f //x=80.08 //y=6.205 //x2=80.155 //y2=5.205
cc_7329 ( N_noxref_17_M153_noxref_g N_noxref_32_M152_noxref_d ) capacitor \
 c=0.00123972f //x=80.52 //y=6.205 //x2=80.155 //y2=5.205
cc_7330 ( N_noxref_17_c_10904_n N_noxref_33_c_13841_n ) capacitor c=0.0605773f \
 //x=86.555 //y=4.21 //x2=85.525 //y2=5.39
cc_7331 ( N_noxref_17_c_10904_n N_noxref_33_c_13852_n ) capacitor \
 c=0.00869836f //x=86.555 //y=4.21 //x2=83.735 //y2=5.39
cc_7332 ( N_noxref_17_M160_noxref_g N_noxref_33_c_13868_n ) capacitor \
 c=0.00793695f //x=86.74 //y=6.205 //x2=87.27 //y2=7.09
cc_7333 ( N_noxref_17_M161_noxref_g N_noxref_33_c_13868_n ) capacitor \
 c=0.00937408f //x=87.18 //y=6.205 //x2=87.27 //y2=7.09
cc_7334 ( N_noxref_17_c_10904_n N_noxref_33_c_13829_n ) capacitor c=0.0262463f \
 //x=86.555 //y=4.21 //x2=82.74 //y2=5.39
cc_7335 ( N_noxref_17_M160_noxref_g N_noxref_33_c_13857_n ) capacitor \
 c=0.00177216f //x=86.74 //y=6.205 //x2=86.52 //y2=7.09
cc_7336 ( N_noxref_17_M161_noxref_g N_noxref_33_c_13872_n ) capacitor \
 c=0.00422002f //x=87.18 //y=6.205 //x2=87.4 //y2=6.92
cc_7337 ( N_noxref_17_c_10904_n N_noxref_33_c_13858_n ) capacitor \
 c=0.00300082f //x=86.555 //y=4.21 //x2=83.62 //y2=5.39
cc_7338 ( N_noxref_17_c_10904_n N_noxref_33_c_13861_n ) capacitor \
 c=2.11035e-19 //x=86.555 //y=4.21 //x2=85.64 //y2=5.39
cc_7339 ( N_noxref_17_M160_noxref_g N_noxref_33_M159_noxref_d ) capacitor \
 c=0.0142133f //x=86.74 //y=6.205 //x2=86.375 //y2=5.205
cc_7340 ( N_noxref_17_c_11000_n N_noxref_33_M159_noxref_d ) capacitor \
 c=6.61209e-19 //x=86.72 //y=4.885 //x2=86.375 //y2=5.205
cc_7341 ( N_noxref_17_M161_noxref_g N_noxref_33_M161_noxref_d ) capacitor \
 c=0.0365939f //x=87.18 //y=6.205 //x2=87.255 //y2=5.205
cc_7342 ( N_noxref_17_c_10673_n N_GND_c_14516_n ) capacitor c=0.0021992f \
 //x=73.38 //y=2.375 //x2=75.955 //y2=0.175
cc_7343 ( N_noxref_17_c_10741_n N_GND_c_14578_n ) capacitor c=0.00654514f \
 //x=77.365 //y=1.835 //x2=79.285 //y2=0.175
cc_7344 ( N_noxref_17_c_10777_n N_GND_c_14578_n ) capacitor c=0.00951288f \
 //x=77.01 //y=1.18 //x2=79.285 //y2=0.175
cc_7345 ( N_noxref_17_M47_noxref_d N_GND_c_14578_n ) capacitor c=3.01769e-19 \
 //x=76.82 //y=1.085 //x2=79.285 //y2=0.175
cc_7346 ( N_noxref_17_c_10777_n N_GND_c_14661_n ) capacitor c=0.00543286f \
 //x=77.01 //y=1.18 //x2=79.37 //y2=1.015
cc_7347 ( N_noxref_17_c_10864_n N_GND_c_14853_n ) capacitor c=0.00214826f \
 //x=80.04 //y=2.375 //x2=82.615 //y2=0.175
cc_7348 ( N_noxref_17_c_10945_n N_GND_c_14854_n ) capacitor c=4.6307e-19 \
 //x=86.7 //y=2.38 //x2=87.44 //y2=0.18
cc_7349 ( N_noxref_17_c_10764_n N_GND_c_14591_n ) capacitor c=7.99257e-19 \
 //x=76.09 //y=5.56 //x2=76.04 //y2=1.135
cc_7350 ( N_noxref_17_c_10777_n N_GND_c_14591_n ) capacitor c=0.0140211f \
 //x=77.01 //y=1.18 //x2=76.04 //y2=1.135
cc_7351 ( N_noxref_17_M47_noxref_d N_GND_c_14591_n ) capacitor c=2.93544e-19 \
 //x=76.82 //y=1.085 //x2=76.04 //y2=1.135
cc_7352 ( N_noxref_17_c_10673_n N_GND_c_14451_n ) capacitor c=2.016e-19 \
 //x=73.38 //y=2.375 //x2=74.69 //y2=0.175
cc_7353 ( N_noxref_17_c_10741_n N_GND_c_14608_n ) capacitor c=7.77585e-19 \
 //x=77.365 //y=1.835 //x2=78.02 //y2=0.175
cc_7354 ( N_noxref_17_c_10864_n N_GND_c_14717_n ) capacitor c=3.76947e-19 \
 //x=80.04 //y=2.375 //x2=81.35 //y2=0.175
cc_7355 ( N_noxref_17_c_10945_n N_GND_c_14806_n ) capacitor c=3.29013e-19 \
 //x=86.7 //y=2.38 //x2=87.44 //y2=0.18
cc_7356 ( N_noxref_17_c_10976_n N_GND_c_14806_n ) capacitor c=0.00231028f \
 //x=86.7 //y=2.26 //x2=87.44 //y2=0.18
cc_7357 ( N_noxref_17_c_10994_n N_GND_c_14806_n ) capacitor c=0.00278719f \
 //x=87.11 //y=1.585 //x2=87.44 //y2=0.18
cc_7358 ( N_noxref_17_c_10744_n N_GND_c_14620_n ) capacitor c=9.32616e-19 \
 //x=77.45 //y=3.735 //x2=74.86 //y2=0.175
cc_7359 ( N_noxref_17_c_10687_n N_GND_c_14620_n ) capacitor c=0.00239899f \
 //x=73.38 //y=2.26 //x2=74.86 //y2=0.175
cc_7360 ( N_noxref_17_c_10835_n N_GND_c_14620_n ) capacitor c=0.00262688f \
 //x=73.9 //y=1.44 //x2=74.86 //y2=0.175
cc_7361 ( N_noxref_17_c_10700_n N_GND_c_14620_n ) capacitor c=2.63786e-19 \
 //x=73.38 //y=2.26 //x2=74.86 //y2=0.175
cc_7362 ( N_noxref_17_c_10734_n N_GND_c_14627_n ) capacitor c=0.00495747f \
 //x=77.01 //y=1.75 //x2=78.19 //y2=0.175
cc_7363 ( N_noxref_17_c_10741_n N_GND_c_14627_n ) capacitor c=0.031386f \
 //x=77.365 //y=1.835 //x2=78.19 //y2=0.175
cc_7364 ( N_noxref_17_c_10864_n N_GND_c_14750_n ) capacitor c=0.00295886f \
 //x=80.04 //y=2.375 //x2=81.52 //y2=0.175
cc_7365 ( N_noxref_17_c_10868_n N_GND_c_14750_n ) capacitor c=0.00617359f \
 //x=80.04 //y=4.045 //x2=81.52 //y2=0.175
cc_7366 ( N_noxref_17_c_10908_n N_GND_c_14750_n ) capacitor c=0.00245228f \
 //x=80.04 //y=2.26 //x2=81.52 //y2=0.175
cc_7367 ( N_noxref_17_c_10928_n N_GND_c_14750_n ) capacitor c=2.63786e-19 \
 //x=80.04 //y=2.26 //x2=81.52 //y2=0.175
cc_7368 ( N_noxref_17_c_10904_n N_GND_c_14831_n ) capacitor c=0.0025451f \
 //x=86.555 //y=4.21 //x2=84.85 //y2=0.175
cc_7369 ( N_noxref_17_c_10777_n N_GND_M46_noxref_d ) capacitor c=2.82748e-19 \
 //x=77.01 //y=1.18 //x2=75.85 //y2=1.045
cc_7370 ( N_noxref_17_c_10743_n N_noxref_52_c_16576_n ) capacitor \
 c=0.00911405f //x=77.095 //y=1.835 //x2=76.525 //y2=1.675
cc_7371 ( N_noxref_17_c_10741_n N_noxref_52_c_16581_n ) capacitor \
 c=0.00399245f //x=77.365 //y=1.835 //x2=77.41 //y2=0.71
cc_7372 ( N_noxref_17_c_10777_n N_noxref_52_c_16581_n ) capacitor c=0.003751f \
 //x=77.01 //y=1.18 //x2=77.41 //y2=0.71
cc_7373 ( N_noxref_17_M47_noxref_d N_noxref_52_c_16581_n ) capacitor \
 c=0.00910163f //x=76.82 //y=1.085 //x2=77.41 //y2=0.71
cc_7374 ( N_noxref_17_c_10734_n N_noxref_52_M46_noxref_s ) capacitor \
 c=0.0162254f //x=77.01 //y=1.75 //x2=75.42 //y2=0.545
cc_7375 ( N_noxref_17_c_10741_n N_noxref_52_M46_noxref_s ) capacitor \
 c=0.00670006f //x=77.365 //y=1.835 //x2=75.42 //y2=0.545
cc_7376 ( N_noxref_17_c_10751_n N_noxref_52_M46_noxref_s ) capacitor \
 c=3.18043e-19 //x=77.45 //y=4.055 //x2=75.42 //y2=0.545
cc_7377 ( N_noxref_17_c_10777_n N_noxref_52_M46_noxref_s ) capacitor \
 c=0.00906354f //x=77.01 //y=1.18 //x2=75.42 //y2=0.545
cc_7378 ( N_noxref_17_c_10784_n N_noxref_52_M46_noxref_s ) capacitor \
 c=8.42257e-19 //x=77.45 //y=3.88 //x2=75.42 //y2=0.545
cc_7379 ( N_noxref_17_M47_noxref_d N_noxref_52_M46_noxref_s ) capacitor \
 c=0.0275552f //x=76.82 //y=1.085 //x2=75.42 //y2=0.545
cc_7380 ( N_noxref_17_c_10864_n N_noxref_53_c_16648_n ) capacitor \
 c=7.20375e-19 //x=80.04 //y=2.375 //x2=79.855 //y2=1.675
cc_7381 ( N_noxref_17_c_10875_n N_noxref_53_c_16648_n ) capacitor \
 c=3.32532e-19 //x=80.04 //y=4.365 //x2=79.855 //y2=1.675
cc_7382 ( N_noxref_17_c_10923_n N_noxref_53_c_16648_n ) capacitor \
 c=0.00746306f //x=80.075 //y=1.74 //x2=79.855 //y2=1.675
cc_7383 ( N_noxref_17_c_10928_n N_noxref_53_c_16648_n ) capacitor \
 c=0.00175173f //x=80.04 //y=2.26 //x2=79.855 //y2=1.675
cc_7384 ( N_noxref_17_c_10864_n N_noxref_53_c_16655_n ) capacitor \
 c=0.00135256f //x=80.04 //y=2.375 //x2=80.74 //y2=0.71
cc_7385 ( N_noxref_17_c_10908_n N_noxref_53_c_16655_n ) capacitor \
 c=8.82141e-19 //x=80.04 //y=2.26 //x2=80.74 //y2=0.71
cc_7386 ( N_noxref_17_c_10918_n N_noxref_53_c_16655_n ) capacitor c=0.0200392f \
 //x=80.075 //y=1.085 //x2=80.74 //y2=0.71
cc_7387 ( N_noxref_17_c_10926_n N_noxref_53_c_16655_n ) capacitor \
 c=0.00825432f //x=80.605 //y=1.085 //x2=80.74 //y2=0.71
cc_7388 ( N_noxref_17_c_10928_n N_noxref_53_c_16655_n ) capacitor c=2.1838e-19 \
 //x=80.04 //y=2.26 //x2=80.74 //y2=0.71
cc_7389 ( N_noxref_17_c_10918_n N_noxref_53_M48_noxref_s ) capacitor \
 c=0.00746306f //x=80.075 //y=1.085 //x2=78.75 //y2=0.545
cc_7390 ( N_noxref_17_c_10923_n N_noxref_53_M48_noxref_s ) capacitor \
 c=0.00211573f //x=80.075 //y=1.74 //x2=78.75 //y2=0.545
cc_7391 ( N_noxref_17_c_10926_n N_noxref_53_M48_noxref_s ) capacitor \
 c=0.014227f //x=80.605 //y=1.085 //x2=78.75 //y2=0.545
cc_7392 ( N_noxref_17_c_10927_n N_noxref_53_M48_noxref_s ) capacitor \
 c=0.00733269f //x=80.605 //y=1.43 //x2=78.75 //y2=0.545
cc_7393 ( N_noxref_17_c_11237_p N_noxref_53_M48_noxref_s ) capacitor \
 c=0.00287293f //x=80.04 //y=2.095 //x2=78.75 //y2=0.545
cc_7394 ( N_noxref_17_c_10904_n N_noxref_55_c_16771_n ) capacitor \
 c=0.00782785f //x=86.555 //y=4.21 //x2=86.43 //y2=1.76
cc_7395 ( N_noxref_17_c_10945_n N_noxref_55_c_16778_n ) capacitor \
 c=7.26555e-19 //x=86.7 //y=2.38 //x2=86.515 //y2=1.675
cc_7396 ( N_noxref_17_c_10954_n N_noxref_55_c_16778_n ) capacitor \
 c=9.42734e-19 //x=86.7 //y=4.37 //x2=86.515 //y2=1.675
cc_7397 ( N_noxref_17_c_10991_n N_noxref_55_c_16778_n ) capacitor \
 c=0.00838141f //x=86.735 //y=1.74 //x2=86.515 //y2=1.675
cc_7398 ( N_noxref_17_c_10997_n N_noxref_55_c_16778_n ) capacitor \
 c=0.00175172f //x=86.7 //y=2.26 //x2=86.515 //y2=1.675
cc_7399 ( N_noxref_17_c_10945_n N_noxref_55_c_16787_n ) capacitor \
 c=5.72205e-19 //x=86.7 //y=2.38 //x2=87.4 //y2=0.71
cc_7400 ( N_noxref_17_c_10976_n N_noxref_55_c_16787_n ) capacitor \
 c=8.37879e-19 //x=86.7 //y=2.26 //x2=87.4 //y2=0.71
cc_7401 ( N_noxref_17_c_10986_n N_noxref_55_c_16787_n ) capacitor c=0.0202024f \
 //x=86.735 //y=1.085 //x2=87.4 //y2=0.71
cc_7402 ( N_noxref_17_c_10995_n N_noxref_55_c_16787_n ) capacitor \
 c=0.00825432f //x=87.265 //y=1.085 //x2=87.4 //y2=0.71
cc_7403 ( N_noxref_17_c_10997_n N_noxref_55_c_16787_n ) capacitor c=2.1838e-19 \
 //x=86.7 //y=2.26 //x2=87.4 //y2=0.71
cc_7404 ( N_noxref_17_c_10986_n N_noxref_55_M52_noxref_s ) capacitor \
 c=0.00838141f //x=86.735 //y=1.085 //x2=85.41 //y2=0.545
cc_7405 ( N_noxref_17_c_10994_n N_noxref_55_M52_noxref_s ) capacitor \
 c=0.00271091f //x=87.11 //y=1.585 //x2=85.41 //y2=0.545
cc_7406 ( N_noxref_17_c_10995_n N_noxref_55_M52_noxref_s ) capacitor \
 c=0.0142835f //x=87.265 //y=1.085 //x2=85.41 //y2=0.545
cc_7407 ( N_QN_c_11327_n N_VDD_c_12735_n ) capacitor c=2.2621e-19 //x=87.355 \
 //y=5.39 //x2=87.44 //y2=7.58
cc_7408 ( QN N_VDD_c_12628_n ) capacitor c=0.0384099f //x=87.44 //y=2.4 \
 //x2=87.44 //y2=7.58
cc_7409 ( N_QN_c_11327_n N_VDD_c_12628_n ) capacitor c=0.00158608f //x=87.355 \
 //y=5.39 //x2=87.44 //y2=7.58
cc_7410 ( N_QN_c_11340_n N_VDD_c_12628_n ) capacitor c=0.00443612f //x=86.957 \
 //y=5.39 //x2=87.44 //y2=7.58
cc_7411 ( N_QN_c_11287_n N_VDD_c_12628_n ) capacitor c=0.00488797f //x=86.08 \
 //y=5.56 //x2=87.44 //y2=7.58
cc_7412 ( N_QN_c_11350_n N_VDD_c_12628_n ) capacitor c=0.0141296f //x=86.96 \
 //y=5.56 //x2=87.44 //y2=7.58
cc_7413 ( QN N_VDD_c_12546_n ) capacitor c=7.29276e-19 //x=87.44 //y=2.4 \
 //x2=84.85 //y2=7.585
cc_7414 ( N_QN_c_11287_n N_VDD_c_12546_n ) capacitor c=0.00535462f //x=86.08 \
 //y=5.56 //x2=84.85 //y2=7.585
cc_7415 ( N_QN_c_11259_n N_noxref_32_c_13670_n ) capacitor c=2.95004e-19 \
 //x=80.34 //y=1.36 //x2=82.185 //y2=5.39
cc_7416 ( N_QN_c_11259_n N_noxref_32_c_13673_n ) capacitor c=3.81263e-19 \
 //x=80.34 //y=1.36 //x2=80.415 //y2=5.39
cc_7417 ( N_QN_c_11260_n N_noxref_33_c_13841_n ) capacitor c=2.00442e-19 \
 //x=83.67 //y=1.36 //x2=85.525 //y2=5.39
cc_7418 ( N_QN_c_11268_n N_noxref_33_c_13841_n ) capacitor c=0.0327245f \
 //x=86.08 //y=5.39 //x2=85.525 //y2=5.39
cc_7419 ( N_QN_c_11287_n N_noxref_33_c_13841_n ) capacitor c=0.00238429f \
 //x=86.08 //y=5.56 //x2=85.525 //y2=5.39
cc_7420 ( N_QN_c_11260_n N_noxref_33_c_13852_n ) capacitor c=7.9511e-19 \
 //x=83.67 //y=1.36 //x2=83.735 //y2=5.39
cc_7421 ( N_QN_c_11258_n N_noxref_33_c_13854_n ) capacitor c=0.00311493f \
 //x=86.835 //y=5.39 //x2=86.405 //y2=7.09
cc_7422 ( N_QN_c_11268_n N_noxref_33_c_13854_n ) capacitor c=0.00538798f \
 //x=86.08 //y=5.39 //x2=86.405 //y2=7.09
cc_7423 ( N_QN_c_11287_n N_noxref_33_c_13854_n ) capacitor c=0.00406191f \
 //x=86.08 //y=5.56 //x2=86.405 //y2=7.09
cc_7424 ( N_QN_c_11258_n N_noxref_33_c_13868_n ) capacitor c=0.00305195f \
 //x=86.835 //y=5.39 //x2=87.27 //y2=7.09
cc_7425 ( N_QN_c_11327_n N_noxref_33_c_13868_n ) capacitor c=0.00291085f \
 //x=87.355 //y=5.39 //x2=87.27 //y2=7.09
cc_7426 ( N_QN_c_11340_n N_noxref_33_c_13868_n ) capacitor c=0.00559082f \
 //x=86.957 //y=5.39 //x2=87.27 //y2=7.09
cc_7427 ( N_QN_c_11350_n N_noxref_33_c_13868_n ) capacitor c=0.00396177f \
 //x=86.96 //y=5.56 //x2=87.27 //y2=7.09
cc_7428 ( N_QN_c_11268_n N_noxref_33_c_13829_n ) capacitor c=0.00239626f \
 //x=86.08 //y=5.39 //x2=82.74 //y2=5.39
cc_7429 ( N_QN_c_11258_n N_noxref_33_c_13857_n ) capacitor c=0.00459659f \
 //x=86.835 //y=5.39 //x2=86.52 //y2=7.09
cc_7430 ( N_QN_c_11327_n N_noxref_33_c_13872_n ) capacitor c=0.00582813f \
 //x=87.355 //y=5.39 //x2=87.4 //y2=6.92
cc_7431 ( N_QN_c_11268_n N_noxref_33_c_13861_n ) capacitor c=0.010446f \
 //x=86.08 //y=5.39 //x2=85.64 //y2=5.39
cc_7432 ( N_QN_c_11287_n N_noxref_33_c_13861_n ) capacitor c=0.0649815f \
 //x=86.08 //y=5.56 //x2=85.64 //y2=5.39
cc_7433 ( N_QN_c_11258_n N_noxref_33_M159_noxref_d ) capacitor c=0.00678641f \
 //x=86.835 //y=5.39 //x2=86.375 //y2=5.205
cc_7434 ( N_QN_c_11340_n N_noxref_33_M159_noxref_d ) capacitor c=0.00184359f \
 //x=86.957 //y=5.39 //x2=86.375 //y2=5.205
cc_7435 ( N_QN_c_11287_n N_noxref_33_M159_noxref_d ) capacitor c=0.0476949f \
 //x=86.08 //y=5.56 //x2=86.375 //y2=5.205
cc_7436 ( N_QN_c_11350_n N_noxref_33_M159_noxref_d ) capacitor c=0.0473507f \
 //x=86.96 //y=5.56 //x2=86.375 //y2=5.205
cc_7437 ( N_QN_c_11327_n N_noxref_33_M161_noxref_d ) capacitor c=0.00936945f \
 //x=87.355 //y=5.39 //x2=87.255 //y2=5.205
cc_7438 ( N_QN_c_11340_n N_noxref_33_M161_noxref_d ) capacitor c=0.00184359f \
 //x=86.957 //y=5.39 //x2=87.255 //y2=5.205
cc_7439 ( N_QN_c_11350_n N_noxref_33_M161_noxref_d ) capacitor c=0.0473507f \
 //x=86.96 //y=5.56 //x2=87.255 //y2=5.205
cc_7440 ( N_QN_c_11259_n N_GND_c_14661_n ) capacitor c=0.00185137f //x=80.34 \
 //y=1.36 //x2=79.37 //y2=1.015
cc_7441 ( N_QN_c_11271_n N_GND_c_14661_n ) capacitor c=7.42708e-19 //x=80.505 \
 //y=1.405 //x2=79.37 //y2=1.015
cc_7442 ( N_QN_M49_noxref_d N_GND_c_14661_n ) capacitor c=2.62581e-19 \
 //x=80.15 //y=1.085 //x2=79.37 //y2=1.015
cc_7443 ( N_QN_c_11259_n N_GND_c_14853_n ) capacitor c=0.00560741f //x=80.34 \
 //y=1.36 //x2=82.615 //y2=0.175
cc_7444 ( N_QN_c_11271_n N_GND_c_14853_n ) capacitor c=0.00701775f //x=80.505 \
 //y=1.405 //x2=82.615 //y2=0.175
cc_7445 ( N_QN_c_11251_n N_GND_c_14853_n ) capacitor c=0.113183f //x=83.54 \
 //y=1.405 //x2=82.615 //y2=0.175
cc_7446 ( N_QN_M49_noxref_d N_GND_c_14853_n ) capacitor c=2.01013e-19 \
 //x=80.15 //y=1.085 //x2=82.615 //y2=0.175
cc_7447 ( N_QN_c_11259_n N_GND_c_14668_n ) capacitor c=3.42222e-19 //x=80.34 \
 //y=1.36 //x2=82.7 //y2=1.015
cc_7448 ( N_QN_c_11260_n N_GND_c_14668_n ) capacitor c=0.00282022f //x=83.67 \
 //y=1.36 //x2=82.7 //y2=1.015
cc_7449 ( N_QN_c_11271_n N_GND_c_14668_n ) capacitor c=3.90037e-19 //x=80.505 \
 //y=1.405 //x2=82.7 //y2=1.015
cc_7450 ( N_QN_c_11251_n N_GND_c_14668_n ) capacitor c=0.0204281f //x=83.54 \
 //y=1.405 //x2=82.7 //y2=1.015
cc_7451 ( N_QN_M51_noxref_d N_GND_c_14668_n ) capacitor c=2.62581e-19 \
 //x=83.48 //y=1.085 //x2=82.7 //y2=1.015
cc_7452 ( N_QN_c_11260_n N_GND_c_14788_n ) capacitor c=0.00848351f //x=83.67 \
 //y=1.36 //x2=85.945 //y2=0.175
cc_7453 ( N_QN_c_11251_n N_GND_c_14788_n ) capacitor c=0.0330907f //x=83.54 \
 //y=1.405 //x2=85.945 //y2=0.175
cc_7454 ( N_QN_c_11274_n N_GND_c_14788_n ) capacitor c=0.00561615f //x=83.8 \
 //y=1.405 //x2=85.945 //y2=0.175
cc_7455 ( N_QN_c_11275_n N_GND_c_14788_n ) capacitor c=0.104343f //x=86.835 \
 //y=1.405 //x2=85.945 //y2=0.175
cc_7456 ( N_QN_M51_noxref_d N_GND_c_14788_n ) capacitor c=2.01013e-19 \
 //x=83.48 //y=1.085 //x2=85.945 //y2=0.175
cc_7457 ( N_QN_c_11315_n N_GND_c_14791_n ) capacitor c=0.00199135f //x=87 \
 //y=1.535 //x2=86.03 //y2=1.02
cc_7458 ( N_QN_c_11260_n N_GND_c_14791_n ) capacitor c=8.32974e-19 //x=83.67 \
 //y=1.36 //x2=86.03 //y2=1.02
cc_7459 ( N_QN_c_11268_n N_GND_c_14791_n ) capacitor c=9.01285e-19 //x=86.08 \
 //y=5.39 //x2=86.03 //y2=1.02
cc_7460 ( N_QN_c_11345_n N_GND_c_14791_n ) capacitor c=8.08914e-19 //x=86.995 \
 //y=1.405 //x2=86.03 //y2=1.02
cc_7461 ( N_QN_c_11275_n N_GND_c_14791_n ) capacitor c=0.0204811f //x=86.835 \
 //y=1.405 //x2=86.03 //y2=1.02
cc_7462 ( N_QN_M53_noxref_d N_GND_c_14791_n ) capacitor c=2.62581e-19 \
 //x=86.81 //y=1.085 //x2=86.03 //y2=1.02
cc_7463 ( N_QN_c_11315_n N_GND_c_14854_n ) capacitor c=0.00524308f //x=87 \
 //y=1.535 //x2=87.44 //y2=0.18
cc_7464 ( N_QN_c_11328_n N_GND_c_14854_n ) capacitor c=0.00622216f //x=87.355 \
 //y=1.825 //x2=87.44 //y2=0.18
cc_7465 ( N_QN_c_11345_n N_GND_c_14854_n ) capacitor c=0.00777895f //x=86.995 \
 //y=1.405 //x2=87.44 //y2=0.18
cc_7466 ( N_QN_c_11275_n N_GND_c_14854_n ) capacitor c=0.038217f //x=86.835 \
 //y=1.405 //x2=87.44 //y2=0.18
cc_7467 ( N_QN_M53_noxref_d N_GND_c_14854_n ) capacitor c=2.01013e-19 \
 //x=86.81 //y=1.085 //x2=87.44 //y2=0.18
cc_7468 ( N_QN_c_11325_n N_GND_c_14806_n ) capacitor c=0.00453826f //x=87 \
 //y=1.74 //x2=87.44 //y2=0.18
cc_7469 ( N_QN_c_11328_n N_GND_c_14806_n ) capacitor c=0.0412969f //x=87.355 \
 //y=1.825 //x2=87.44 //y2=0.18
cc_7470 ( N_QN_M53_noxref_d N_GND_c_14806_n ) capacitor c=0.00166394f \
 //x=86.81 //y=1.085 //x2=87.44 //y2=0.18
cc_7471 ( N_QN_c_11251_n N_GND_c_14750_n ) capacitor c=0.0198667f //x=83.54 \
 //y=1.405 //x2=81.52 //y2=0.175
cc_7472 ( N_QN_M49_noxref_d N_GND_c_14750_n ) capacitor c=0.00128657f \
 //x=80.15 //y=1.085 //x2=81.52 //y2=0.175
cc_7473 ( QN N_GND_c_14831_n ) capacitor c=4.27507e-19 //x=87.44 //y=2.4 \
 //x2=84.85 //y2=0.175
cc_7474 ( N_QN_c_11275_n N_GND_c_14831_n ) capacitor c=0.0183315f //x=86.835 \
 //y=1.405 //x2=84.85 //y2=0.175
cc_7475 ( N_QN_M51_noxref_d N_GND_c_14831_n ) capacitor c=0.00129152f \
 //x=83.48 //y=1.085 //x2=84.85 //y2=0.175
cc_7476 ( N_QN_c_11259_n N_noxref_53_c_16655_n ) capacitor c=0.00587436f \
 //x=80.34 //y=1.36 //x2=80.74 //y2=0.71
cc_7477 ( N_QN_c_11251_n N_noxref_53_c_16655_n ) capacitor c=0.00227706f \
 //x=83.54 //y=1.405 //x2=80.74 //y2=0.71
cc_7478 ( N_QN_M49_noxref_d N_noxref_53_c_16655_n ) capacitor c=0.0136817f \
 //x=80.15 //y=1.085 //x2=80.74 //y2=0.71
cc_7479 ( N_QN_c_11259_n N_noxref_53_M48_noxref_s ) capacitor c=0.0123513f \
 //x=80.34 //y=1.36 //x2=78.75 //y2=0.545
cc_7480 ( N_QN_c_11251_n N_noxref_53_M48_noxref_s ) capacitor c=0.00825327f \
 //x=83.54 //y=1.405 //x2=78.75 //y2=0.545
cc_7481 ( N_QN_M49_noxref_d N_noxref_53_M48_noxref_s ) capacitor c=0.0446285f \
 //x=80.15 //y=1.085 //x2=78.75 //y2=0.545
cc_7482 ( N_QN_c_11251_n N_noxref_54_c_16705_n ) capacitor c=0.0118655f \
 //x=83.54 //y=1.405 //x2=83.1 //y2=1.76
cc_7483 ( N_QN_c_11260_n N_noxref_54_c_16720_n ) capacitor c=0.0057298f \
 //x=83.67 //y=1.36 //x2=84.07 //y2=0.71
cc_7484 ( N_QN_c_11251_n N_noxref_54_c_16720_n ) capacitor c=0.00227706f \
 //x=83.54 //y=1.405 //x2=84.07 //y2=0.71
cc_7485 ( N_QN_c_11275_n N_noxref_54_c_16720_n ) capacitor c=0.00530355f \
 //x=86.835 //y=1.405 //x2=84.07 //y2=0.71
cc_7486 ( N_QN_M51_noxref_d N_noxref_54_c_16720_n ) capacitor c=0.0130616f \
 //x=83.48 //y=1.085 //x2=84.07 //y2=0.71
cc_7487 ( N_QN_c_11260_n N_noxref_54_M50_noxref_s ) capacitor c=0.0103793f \
 //x=83.67 //y=1.36 //x2=82.08 //y2=0.545
cc_7488 ( N_QN_c_11251_n N_noxref_54_M50_noxref_s ) capacitor c=0.0188707f \
 //x=83.54 //y=1.405 //x2=82.08 //y2=0.545
cc_7489 ( N_QN_c_11275_n N_noxref_54_M50_noxref_s ) capacitor c=0.00742061f \
 //x=86.835 //y=1.405 //x2=82.08 //y2=0.545
cc_7490 ( N_QN_M51_noxref_d N_noxref_54_M50_noxref_s ) capacitor c=0.0441243f \
 //x=83.48 //y=1.085 //x2=82.08 //y2=0.545
cc_7491 ( N_QN_c_11275_n N_noxref_55_c_16771_n ) capacitor c=0.0135245f \
 //x=86.835 //y=1.405 //x2=86.43 //y2=1.76
cc_7492 ( N_QN_c_11329_n N_noxref_55_c_16778_n ) capacitor c=0.00714695f \
 //x=87.085 //y=1.825 //x2=86.515 //y2=1.675
cc_7493 ( N_QN_c_11315_n N_noxref_55_c_16787_n ) capacitor c=0.00515582f \
 //x=87 //y=1.535 //x2=87.4 //y2=0.71
cc_7494 ( N_QN_c_11328_n N_noxref_55_c_16787_n ) capacitor c=0.00321358f \
 //x=87.355 //y=1.825 //x2=87.4 //y2=0.71
cc_7495 ( N_QN_c_11345_n N_noxref_55_c_16787_n ) capacitor c=0.00224828f \
 //x=86.995 //y=1.405 //x2=87.4 //y2=0.71
cc_7496 ( N_QN_c_11275_n N_noxref_55_c_16787_n ) capacitor c=0.00185838f \
 //x=86.835 //y=1.405 //x2=87.4 //y2=0.71
cc_7497 ( N_QN_M53_noxref_d N_noxref_55_c_16787_n ) capacitor c=0.0135038f \
 //x=86.81 //y=1.085 //x2=87.4 //y2=0.71
cc_7498 ( N_QN_c_11315_n N_noxref_55_M52_noxref_s ) capacitor c=0.0117929f \
 //x=87 //y=1.535 //x2=85.41 //y2=0.545
cc_7499 ( N_QN_c_11325_n N_noxref_55_M52_noxref_s ) capacitor c=0.00791783f \
 //x=87 //y=1.74 //x2=85.41 //y2=0.545
cc_7500 ( N_QN_c_11328_n N_noxref_55_M52_noxref_s ) capacitor c=0.00794955f \
 //x=87.355 //y=1.825 //x2=85.41 //y2=0.545
cc_7501 ( N_QN_c_11345_n N_noxref_55_M52_noxref_s ) capacitor c=0.0090031f \
 //x=86.995 //y=1.405 //x2=85.41 //y2=0.545
cc_7502 ( N_QN_c_11275_n N_noxref_55_M52_noxref_s ) capacitor c=0.0219823f \
 //x=86.835 //y=1.405 //x2=85.41 //y2=0.545
cc_7503 ( N_QN_M53_noxref_d N_noxref_55_M52_noxref_s ) capacitor c=0.0432761f \
 //x=86.81 //y=1.085 //x2=85.41 //y2=0.545
cc_7504 ( N_VDD_c_12743_p N_noxref_32_c_13668_n ) capacitor c=4.78686e-19 \
 //x=79.775 //y=7.585 //x2=80.185 //y2=5.39
cc_7505 ( N_VDD_c_12459_n N_noxref_32_c_13668_n ) capacitor c=0.00476346f \
 //x=79.86 //y=7.035 //x2=80.185 //y2=5.39
cc_7506 ( N_VDD_c_12745_p N_noxref_32_c_13668_n ) capacitor c=5.98042e-19 \
 //x=80.655 //y=7.585 //x2=80.185 //y2=5.39
cc_7507 ( N_VDD_c_12498_n N_noxref_32_c_13668_n ) capacitor c=0.00734603f \
 //x=81.35 //y=7.585 //x2=80.185 //y2=5.39
cc_7508 ( N_VDD_M151_noxref_d N_noxref_32_c_13668_n ) capacitor c=0.00679741f \
 //x=79.715 //y=5.205 //x2=80.185 //y2=5.39
cc_7509 ( N_VDD_c_12745_p N_noxref_32_c_13670_n ) capacitor c=5.52065e-19 \
 //x=80.655 //y=7.585 //x2=82.185 //y2=5.39
cc_7510 ( N_VDD_c_12674_n N_noxref_32_c_13670_n ) capacitor c=0.0040485f \
 //x=80.74 //y=7.035 //x2=82.185 //y2=5.39
cc_7511 ( N_VDD_c_12735_n N_noxref_32_c_13670_n ) capacitor c=0.0140204f \
 //x=87.44 //y=7.58 //x2=82.185 //y2=5.39
cc_7512 ( N_VDD_c_12498_n N_noxref_32_c_13670_n ) capacitor c=0.00703326f \
 //x=81.35 //y=7.585 //x2=82.185 //y2=5.39
cc_7513 ( N_VDD_c_12501_n N_noxref_32_c_13670_n ) capacitor c=0.00273146f \
 //x=84.68 //y=7.585 //x2=82.185 //y2=5.39
cc_7514 ( N_VDD_c_12540_n N_noxref_32_c_13670_n ) capacitor c=0.039327f \
 //x=81.52 //y=7.585 //x2=82.185 //y2=5.39
cc_7515 ( N_VDD_M153_noxref_d N_noxref_32_c_13670_n ) capacitor c=0.0138307f \
 //x=80.595 //y=5.205 //x2=82.185 //y2=5.39
cc_7516 ( N_VDD_c_12540_n N_noxref_32_c_13673_n ) capacitor c=3.35418e-19 \
 //x=81.52 //y=7.585 //x2=80.415 //y2=5.39
cc_7517 ( N_VDD_M153_noxref_d N_noxref_32_c_13673_n ) capacitor c=6.02701e-19 \
 //x=80.595 //y=5.205 //x2=80.415 //y2=5.39
cc_7518 ( N_VDD_M150_noxref_s N_noxref_32_c_13680_n ) capacitor c=0.0552377f \
 //x=78.845 //y=5.205 //x2=79.422 //y2=5.39
cc_7519 ( N_VDD_c_12674_n N_noxref_32_c_13684_n ) capacitor c=0.00979658f \
 //x=80.74 //y=7.035 //x2=82.3 //y2=6.92
cc_7520 ( N_VDD_c_12675_n N_noxref_32_c_13684_n ) capacitor c=0.00197255f \
 //x=80.74 //y=7.41 //x2=82.3 //y2=6.92
cc_7521 ( N_VDD_c_12735_n N_noxref_32_c_13684_n ) capacitor c=0.172144f \
 //x=87.44 //y=7.58 //x2=82.3 //y2=6.92
cc_7522 ( N_VDD_c_12501_n N_noxref_32_c_13684_n ) capacitor c=0.0401324f \
 //x=84.68 //y=7.585 //x2=82.3 //y2=6.92
cc_7523 ( N_VDD_c_12540_n N_noxref_32_c_13684_n ) capacitor c=0.00739076f \
 //x=81.52 //y=7.585 //x2=82.3 //y2=6.92
cc_7524 ( N_VDD_c_12735_n N_noxref_32_c_13699_n ) capacitor c=0.0021469f \
 //x=87.44 //y=7.58 //x2=84.06 //y2=6.92
cc_7525 ( N_VDD_c_12501_n N_noxref_32_c_13699_n ) capacitor c=4.35699e-19 \
 //x=84.68 //y=7.585 //x2=84.06 //y2=6.92
cc_7526 ( N_VDD_c_12546_n N_noxref_32_c_13699_n ) capacitor c=0.00733935f \
 //x=84.85 //y=7.585 //x2=84.06 //y2=6.92
cc_7527 ( N_VDD_c_12457_n N_noxref_32_c_13686_n ) capacitor c=0.0041288f \
 //x=78.98 //y=7.035 //x2=79.42 //y2=5.56
cc_7528 ( N_VDD_c_12458_n N_noxref_32_c_13686_n ) capacitor c=0.00145923f \
 //x=78.98 //y=7.41 //x2=79.42 //y2=5.56
cc_7529 ( N_VDD_c_12743_p N_noxref_32_c_13686_n ) capacitor c=0.00233559f \
 //x=79.775 //y=7.585 //x2=79.42 //y2=5.56
cc_7530 ( N_VDD_c_12459_n N_noxref_32_c_13686_n ) capacitor c=0.00220869f \
 //x=79.86 //y=7.035 //x2=79.42 //y2=5.56
cc_7531 ( N_VDD_c_12460_n N_noxref_32_c_13686_n ) capacitor c=0.00130452f \
 //x=79.86 //y=7.41 //x2=79.42 //y2=5.56
cc_7532 ( N_VDD_c_12498_n N_noxref_32_c_13686_n ) capacitor c=0.0112616f \
 //x=81.35 //y=7.585 //x2=79.42 //y2=5.56
cc_7533 ( N_VDD_c_12628_n N_noxref_32_c_13686_n ) capacitor c=2.28864e-19 \
 //x=87.44 //y=7.58 //x2=79.42 //y2=5.56
cc_7534 ( N_VDD_c_12376_n N_noxref_32_c_13686_n ) capacitor c=0.00722375f \
 //x=78.19 //y=7.585 //x2=79.42 //y2=5.56
cc_7535 ( N_VDD_M150_noxref_s N_noxref_32_c_13686_n ) capacitor c=0.0895437f \
 //x=78.845 //y=5.205 //x2=79.42 //y2=5.56
cc_7536 ( N_VDD_M151_noxref_d N_noxref_32_c_13686_n ) capacitor c=0.072364f \
 //x=79.715 //y=5.205 //x2=79.42 //y2=5.56
cc_7537 ( N_VDD_c_12459_n N_noxref_32_c_13689_n ) capacitor c=0.00230229f \
 //x=79.86 //y=7.035 //x2=80.3 //y2=5.39
cc_7538 ( N_VDD_c_12460_n N_noxref_32_c_13689_n ) capacitor c=0.00130452f \
 //x=79.86 //y=7.41 //x2=80.3 //y2=5.39
cc_7539 ( N_VDD_c_12745_p N_noxref_32_c_13689_n ) capacitor c=0.00233409f \
 //x=80.655 //y=7.585 //x2=80.3 //y2=5.39
cc_7540 ( N_VDD_c_12674_n N_noxref_32_c_13689_n ) capacitor c=0.00225444f \
 //x=80.74 //y=7.035 //x2=80.3 //y2=5.39
cc_7541 ( N_VDD_c_12675_n N_noxref_32_c_13689_n ) capacitor c=0.00130452f \
 //x=80.74 //y=7.41 //x2=80.3 //y2=5.39
cc_7542 ( N_VDD_c_12498_n N_noxref_32_c_13689_n ) capacitor c=0.0112507f \
 //x=81.35 //y=7.585 //x2=80.3 //y2=5.39
cc_7543 ( N_VDD_c_12628_n N_noxref_32_c_13689_n ) capacitor c=2.28864e-19 \
 //x=87.44 //y=7.58 //x2=80.3 //y2=5.39
cc_7544 ( N_VDD_c_12376_n N_noxref_32_c_13689_n ) capacitor c=0.00105173f \
 //x=78.19 //y=7.585 //x2=80.3 //y2=5.39
cc_7545 ( N_VDD_c_12540_n N_noxref_32_c_13689_n ) capacitor c=0.00924237f \
 //x=81.52 //y=7.585 //x2=80.3 //y2=5.39
cc_7546 ( N_VDD_M150_noxref_s N_noxref_32_c_13689_n ) capacitor c=0.00114869f \
 //x=78.845 //y=5.205 //x2=80.3 //y2=5.39
cc_7547 ( N_VDD_M151_noxref_d N_noxref_32_c_13689_n ) capacitor c=0.0724198f \
 //x=79.715 //y=5.205 //x2=80.3 //y2=5.39
cc_7548 ( N_VDD_M153_noxref_d N_noxref_32_c_13689_n ) capacitor c=0.0886704f \
 //x=80.595 //y=5.205 //x2=80.3 //y2=5.39
cc_7549 ( N_VDD_c_12735_n N_noxref_32_c_13690_n ) capacitor c=0.00204931f \
 //x=87.44 //y=7.58 //x2=82.3 //y2=5.39
cc_7550 ( N_VDD_c_12501_n N_noxref_32_c_13690_n ) capacitor c=0.00853641f \
 //x=84.68 //y=7.585 //x2=82.3 //y2=5.39
cc_7551 ( N_VDD_c_12628_n N_noxref_32_c_13690_n ) capacitor c=2.28864e-19 \
 //x=87.44 //y=7.58 //x2=82.3 //y2=5.39
cc_7552 ( N_VDD_c_12540_n N_noxref_32_c_13690_n ) capacitor c=0.0602194f \
 //x=81.52 //y=7.585 //x2=82.3 //y2=5.39
cc_7553 ( N_VDD_M153_noxref_d N_noxref_32_c_13690_n ) capacitor c=0.00230512f \
 //x=80.595 //y=5.205 //x2=82.3 //y2=5.39
cc_7554 ( N_VDD_c_12457_n N_noxref_32_M150_noxref_d ) capacitor c=0.0391448f \
 //x=78.98 //y=7.035 //x2=79.275 //y2=5.205
cc_7555 ( N_VDD_c_12458_n N_noxref_32_M150_noxref_d ) capacitor c=0.00985747f \
 //x=78.98 //y=7.41 //x2=79.275 //y2=5.205
cc_7556 ( N_VDD_c_12743_p N_noxref_32_M150_noxref_d ) capacitor c=0.0238892f \
 //x=79.775 //y=7.585 //x2=79.275 //y2=5.205
cc_7557 ( N_VDD_c_12459_n N_noxref_32_M150_noxref_d ) capacitor c=0.0380657f \
 //x=79.86 //y=7.035 //x2=79.275 //y2=5.205
cc_7558 ( N_VDD_c_12460_n N_noxref_32_M150_noxref_d ) capacitor c=0.0100015f \
 //x=79.86 //y=7.41 //x2=79.275 //y2=5.205
cc_7559 ( N_VDD_c_12498_n N_noxref_32_M150_noxref_d ) capacitor c=0.00302682f \
 //x=81.35 //y=7.585 //x2=79.275 //y2=5.205
cc_7560 ( N_VDD_M150_noxref_s N_noxref_32_M150_noxref_d ) capacitor \
 c=0.00271779f //x=78.845 //y=5.205 //x2=79.275 //y2=5.205
cc_7561 ( N_VDD_M151_noxref_d N_noxref_32_M150_noxref_d ) capacitor \
 c=0.00360728f //x=79.715 //y=5.205 //x2=79.275 //y2=5.205
cc_7562 ( N_VDD_c_12459_n N_noxref_32_M152_noxref_d ) capacitor c=0.0379915f \
 //x=79.86 //y=7.035 //x2=80.155 //y2=5.205
cc_7563 ( N_VDD_c_12460_n N_noxref_32_M152_noxref_d ) capacitor c=0.0100015f \
 //x=79.86 //y=7.41 //x2=80.155 //y2=5.205
cc_7564 ( N_VDD_c_12745_p N_noxref_32_M152_noxref_d ) capacitor c=0.0230655f \
 //x=80.655 //y=7.585 //x2=80.155 //y2=5.205
cc_7565 ( N_VDD_c_12674_n N_noxref_32_M152_noxref_d ) capacitor c=0.0379915f \
 //x=80.74 //y=7.035 //x2=80.155 //y2=5.205
cc_7566 ( N_VDD_c_12675_n N_noxref_32_M152_noxref_d ) capacitor c=0.0100015f \
 //x=80.74 //y=7.41 //x2=80.155 //y2=5.205
cc_7567 ( N_VDD_c_12498_n N_noxref_32_M152_noxref_d ) capacitor c=0.00283306f \
 //x=81.35 //y=7.585 //x2=80.155 //y2=5.205
cc_7568 ( N_VDD_M151_noxref_d N_noxref_32_M152_noxref_d ) capacitor \
 c=0.00351276f //x=79.715 //y=5.205 //x2=80.155 //y2=5.205
cc_7569 ( N_VDD_M153_noxref_d N_noxref_32_M152_noxref_d ) capacitor \
 c=0.00355849f //x=80.595 //y=5.205 //x2=80.155 //y2=5.205
cc_7570 ( N_VDD_c_12735_n N_noxref_32_M155_noxref_d ) capacitor c=0.00206569f \
 //x=87.44 //y=7.58 //x2=83.035 //y2=5.205
cc_7571 ( N_VDD_c_12501_n N_noxref_32_M155_noxref_d ) capacitor c=0.00856914f \
 //x=84.68 //y=7.585 //x2=83.035 //y2=5.205
cc_7572 ( N_VDD_c_12628_n N_noxref_32_M155_noxref_d ) capacitor c=2.28864e-19 \
 //x=87.44 //y=7.58 //x2=83.035 //y2=5.205
cc_7573 ( N_VDD_c_12735_n N_noxref_32_M157_noxref_d ) capacitor c=0.00206569f \
 //x=87.44 //y=7.58 //x2=83.915 //y2=5.205
cc_7574 ( N_VDD_c_12501_n N_noxref_32_M157_noxref_d ) capacitor c=0.00856914f \
 //x=84.68 //y=7.585 //x2=83.915 //y2=5.205
cc_7575 ( N_VDD_c_12628_n N_noxref_32_M157_noxref_d ) capacitor c=2.28864e-19 \
 //x=87.44 //y=7.58 //x2=83.915 //y2=5.205
cc_7576 ( N_VDD_c_12546_n N_noxref_32_M157_noxref_d ) capacitor c=0.0448255f \
 //x=84.85 //y=7.585 //x2=83.915 //y2=5.205
cc_7577 ( N_VDD_c_12735_n N_noxref_33_c_13841_n ) capacitor c=0.0143613f \
 //x=87.44 //y=7.58 //x2=85.525 //y2=5.39
cc_7578 ( N_VDD_c_12501_n N_noxref_33_c_13841_n ) capacitor c=0.00336719f \
 //x=84.68 //y=7.585 //x2=85.525 //y2=5.39
cc_7579 ( N_VDD_c_12628_n N_noxref_33_c_13841_n ) capacitor c=0.00275849f \
 //x=87.44 //y=7.58 //x2=85.525 //y2=5.39
cc_7580 ( N_VDD_c_12546_n N_noxref_33_c_13841_n ) capacitor c=0.042287f \
 //x=84.85 //y=7.585 //x2=85.525 //y2=5.39
cc_7581 ( N_VDD_c_12546_n N_noxref_33_c_13852_n ) capacitor c=6.67754e-19 \
 //x=84.85 //y=7.585 //x2=83.735 //y2=5.39
cc_7582 ( N_VDD_M150_noxref_s N_noxref_33_c_13829_n ) capacitor c=4.98377e-19 \
 //x=78.845 //y=5.205 //x2=82.74 //y2=5.39
cc_7583 ( N_VDD_c_12735_n N_noxref_33_c_13856_n ) capacitor c=0.172182f \
 //x=87.44 //y=7.58 //x2=85.64 //y2=6.92
cc_7584 ( N_VDD_c_12628_n N_noxref_33_c_13856_n ) capacitor c=0.0392605f \
 //x=87.44 //y=7.58 //x2=85.64 //y2=6.92
cc_7585 ( N_VDD_c_12546_n N_noxref_33_c_13856_n ) capacitor c=0.00730382f \
 //x=84.85 //y=7.585 //x2=85.64 //y2=6.92
cc_7586 ( N_VDD_c_12735_n N_noxref_33_c_13872_n ) capacitor c=0.00215296f \
 //x=87.44 //y=7.58 //x2=87.4 //y2=6.92
cc_7587 ( N_VDD_c_12628_n N_noxref_33_c_13872_n ) capacitor c=0.0109396f \
 //x=87.44 //y=7.58 //x2=87.4 //y2=6.92
cc_7588 ( N_VDD_c_12501_n N_noxref_33_c_13835_n ) capacitor c=0.00475693f \
 //x=84.68 //y=7.585 //x2=82.74 //y2=5.56
cc_7589 ( N_VDD_c_12540_n N_noxref_33_c_13835_n ) capacitor c=0.00539528f \
 //x=81.52 //y=7.585 //x2=82.74 //y2=5.56
cc_7590 ( N_VDD_c_12501_n N_noxref_33_c_13858_n ) capacitor c=0.00489838f \
 //x=84.68 //y=7.585 //x2=83.62 //y2=5.39
cc_7591 ( N_VDD_c_12546_n N_noxref_33_c_13858_n ) capacitor c=0.0122289f \
 //x=84.85 //y=7.585 //x2=83.62 //y2=5.39
cc_7592 ( N_VDD_c_12735_n N_noxref_33_c_13861_n ) capacitor c=0.00204931f \
 //x=87.44 //y=7.58 //x2=85.64 //y2=5.39
cc_7593 ( N_VDD_c_12628_n N_noxref_33_c_13861_n ) capacitor c=0.0097857f \
 //x=87.44 //y=7.58 //x2=85.64 //y2=5.39
cc_7594 ( N_VDD_c_12546_n N_noxref_33_c_13861_n ) capacitor c=0.0592579f \
 //x=84.85 //y=7.585 //x2=85.64 //y2=5.39
cc_7595 ( N_VDD_c_12735_n N_noxref_33_M159_noxref_d ) capacitor c=0.00206569f \
 //x=87.44 //y=7.58 //x2=86.375 //y2=5.205
cc_7596 ( N_VDD_c_12628_n N_noxref_33_M159_noxref_d ) capacitor c=0.00879801f \
 //x=87.44 //y=7.58 //x2=86.375 //y2=5.205
cc_7597 ( N_VDD_c_12735_n N_noxref_33_M161_noxref_d ) capacitor c=0.00206569f \
 //x=87.44 //y=7.58 //x2=87.255 //y2=5.205
cc_7598 ( N_VDD_c_12628_n N_noxref_33_M161_noxref_d ) capacitor c=0.053924f \
 //x=87.44 //y=7.58 //x2=87.255 //y2=5.205
cc_7599 ( N_VDD_c_11585_n N_GND_c_14132_n ) capacitor c=0.00989514f //x=1.23 \
 //y=7.58 //x2=1.23 //y2=0.18
cc_7600 ( N_VDD_c_12628_n N_GND_c_14806_n ) capacitor c=0.00989514f //x=87.44 \
 //y=7.58 //x2=87.44 //y2=0.18
cc_7601 ( N_VDD_c_11494_n N_GND_c_13974_n ) capacitor c=0.00654453f //x=5.3 \
 //y=7.585 //x2=5.3 //y2=0.175
cc_7602 ( N_VDD_c_11498_n N_GND_c_13977_n ) capacitor c=0.00654453f //x=10.11 \
 //y=7.585 //x2=10.11 //y2=0.175
cc_7603 ( N_VDD_c_11545_n N_GND_c_14017_n ) capacitor c=0.00654453f //x=13.44 \
 //y=7.585 //x2=13.44 //y2=0.175
cc_7604 ( N_VDD_c_11609_n N_GND_c_14074_n ) capacitor c=0.00663779f //x=18.25 \
 //y=7.585 //x2=18.25 //y2=0.175
cc_7605 ( N_VDD_c_11723_n N_GND_c_14147_n ) capacitor c=0.00653385f //x=23.06 \
 //y=7.585 //x2=23.06 //y2=0.175
cc_7606 ( N_VDD_c_11735_n N_GND_c_14154_n ) capacitor c=0.00915826f //x=26.39 \
 //y=7.585 //x2=26.39 //y2=0.175
cc_7607 ( N_VDD_c_11813_n N_GND_c_14193_n ) capacitor c=0.00648088f //x=31.2 \
 //y=7.585 //x2=31.2 //y2=0.175
cc_7608 ( N_VDD_c_11817_n N_GND_c_14196_n ) capacitor c=0.00648088f //x=36.01 \
 //y=7.585 //x2=36.01 //y2=0.175
cc_7609 ( N_VDD_c_11864_n N_GND_c_14235_n ) capacitor c=0.00648088f //x=39.34 \
 //y=7.585 //x2=39.34 //y2=0.175
cc_7610 ( N_VDD_c_11928_n N_GND_c_14291_n ) capacitor c=0.00648088f //x=44.15 \
 //y=7.585 //x2=44.15 //y2=0.175
cc_7611 ( N_VDD_c_11988_n N_GND_c_14329_n ) capacitor c=0.00648088f //x=48.96 \
 //y=7.585 //x2=48.96 //y2=0.175
cc_7612 ( N_VDD_c_12066_n N_GND_c_14376_n ) capacitor c=0.00906209f //x=52.29 \
 //y=7.585 //x2=52.29 //y2=0.175
cc_7613 ( N_VDD_c_12135_n N_GND_c_14409_n ) capacitor c=0.00648088f //x=57.1 \
 //y=7.585 //x2=57.1 //y2=0.175
cc_7614 ( N_VDD_c_12136_n N_GND_c_14411_n ) capacitor c=0.00648088f //x=61.91 \
 //y=7.585 //x2=61.91 //y2=0.175
cc_7615 ( N_VDD_c_12137_n N_GND_c_14562_n ) capacitor c=0.00648088f //x=65.24 \
 //y=7.585 //x2=65.24 //y2=0.175
cc_7616 ( N_VDD_c_12201_n N_GND_c_14459_n ) capacitor c=0.00648088f //x=70.05 \
 //y=7.585 //x2=70.05 //y2=0.175
cc_7617 ( N_VDD_c_12364_n N_GND_c_14620_n ) capacitor c=0.00648088f //x=74.86 \
 //y=7.585 //x2=74.86 //y2=0.175
cc_7618 ( N_VDD_c_12376_n N_GND_c_14627_n ) capacitor c=0.00897677f //x=78.19 \
 //y=7.585 //x2=78.19 //y2=0.175
cc_7619 ( N_VDD_c_12540_n N_GND_c_14750_n ) capacitor c=0.00653385f //x=81.52 \
 //y=7.585 //x2=81.52 //y2=0.175
cc_7620 ( N_VDD_c_12546_n N_GND_c_14831_n ) capacitor c=0.00684375f //x=84.85 \
 //y=7.585 //x2=84.85 //y2=0.175
cc_7621 ( N_noxref_20_c_12882_n N_GND_c_13951_n ) capacitor c=0.0079063f \
 //x=3.505 //y=1.175 //x2=6.29 //y2=0.175
cc_7622 ( N_noxref_20_c_12898_p N_GND_c_13951_n ) capacitor c=0.00673395f \
 //x=3.59 //y=0.805 //x2=6.29 //y2=0.175
cc_7623 ( N_noxref_20_c_12860_n N_GND_c_13951_n ) capacitor c=0.00958276f \
 //x=4.475 //y=0.72 //x2=6.29 //y2=0.175
cc_7624 ( N_noxref_20_c_12900_p N_GND_c_13951_n ) capacitor c=0.00232964f \
 //x=4.56 //y=0.805 //x2=6.29 //y2=0.175
cc_7625 ( N_noxref_20_M1_noxref_d N_GND_c_13951_n ) capacitor c=0.0134285f \
 //x=2.35 //y=1.09 //x2=6.29 //y2=0.175
cc_7626 ( N_noxref_20_M1_noxref_d N_GND_c_14106_n ) capacitor c=0.0156367f \
 //x=2.35 //y=1.09 //x2=1.565 //y2=1.145
cc_7627 ( N_noxref_20_c_12882_n N_GND_c_13970_n ) capacitor c=0.0080792f \
 //x=3.505 //y=1.175 //x2=5.13 //y2=0.175
cc_7628 ( N_noxref_20_c_12898_p N_GND_c_13970_n ) capacitor c=0.0140847f \
 //x=3.59 //y=0.805 //x2=5.13 //y2=0.175
cc_7629 ( N_noxref_20_c_12860_n N_GND_c_13970_n ) capacitor c=0.0364997f \
 //x=4.475 //y=0.72 //x2=5.13 //y2=0.175
cc_7630 ( N_noxref_20_c_12900_p N_GND_c_13970_n ) capacitor c=0.013886f \
 //x=4.56 //y=0.805 //x2=5.13 //y2=0.175
cc_7631 ( N_noxref_20_M2_noxref_s N_GND_c_14132_n ) capacitor c=8.16352e-19 \
 //x=3.455 //y=0.555 //x2=1.23 //y2=0.18
cc_7632 ( N_noxref_20_c_12900_p N_GND_c_13974_n ) capacitor c=0.037873f \
 //x=4.56 //y=0.805 //x2=5.3 //y2=0.175
cc_7633 ( N_noxref_20_M2_noxref_s N_GND_c_13974_n ) capacitor c=0.0051897f \
 //x=3.455 //y=0.555 //x2=5.3 //y2=0.175
cc_7634 ( N_noxref_20_M1_noxref_d N_GND_M0_noxref_d ) capacitor c=3.12752e-19 \
 //x=2.35 //y=1.09 //x2=1.375 //y2=1.055
cc_7635 ( N_noxref_20_c_12898_p N_noxref_35_c_15560_n ) capacitor \
 c=2.15937e-19 //x=3.59 //y=0.805 //x2=2.05 //y2=0.805
cc_7636 ( N_noxref_20_c_12882_n N_noxref_35_c_15550_n ) capacitor c=0.0132582f \
 //x=3.505 //y=1.175 //x2=2.935 //y2=0.72
cc_7637 ( N_noxref_20_M1_noxref_d N_noxref_35_c_15550_n ) capacitor \
 c=0.016458f //x=2.35 //y=1.09 //x2=2.935 //y2=0.72
cc_7638 ( N_noxref_20_c_12882_n N_noxref_35_c_15544_n ) capacitor \
 c=0.00954209f //x=3.505 //y=1.175 //x2=2.935 //y2=1.77
cc_7639 ( N_noxref_20_M1_noxref_d N_noxref_35_c_15544_n ) capacitor \
 c=0.0152674f //x=2.35 //y=1.09 //x2=2.935 //y2=1.77
cc_7640 ( N_noxref_20_c_12882_n N_noxref_35_M0_noxref_s ) capacitor \
 c=0.023368f //x=3.505 //y=1.175 //x2=0.945 //y2=0.555
cc_7641 ( N_noxref_20_c_12898_p N_noxref_35_M0_noxref_s ) capacitor \
 c=0.0175461f //x=3.59 //y=0.805 //x2=0.945 //y2=0.555
cc_7642 ( N_noxref_20_c_12900_p N_noxref_35_M0_noxref_s ) capacitor \
 c=2.98576e-19 //x=4.56 //y=0.805 //x2=0.945 //y2=0.555
cc_7643 ( N_noxref_20_M1_noxref_d N_noxref_35_M0_noxref_s ) capacitor \
 c=0.0187969f //x=2.35 //y=1.09 //x2=0.945 //y2=0.555
cc_7644 ( N_noxref_20_M2_noxref_s N_noxref_35_M0_noxref_s ) capacitor \
 c=0.0210819f //x=3.455 //y=0.555 //x2=0.945 //y2=0.555
cc_7645 ( N_noxref_20_c_12900_p N_noxref_36_M3_noxref_s ) capacitor \
 c=0.00368328f //x=4.56 //y=0.805 //x2=5.755 //y2=0.555
cc_7646 ( N_noxref_20_M2_noxref_s N_noxref_36_M3_noxref_s ) capacitor \
 c=0.00125282f //x=3.455 //y=0.555 //x2=5.755 //y2=0.555
cc_7647 ( N_noxref_21_c_12936_n N_GND_c_13952_n ) capacitor c=0.00533679f \
 //x=8.315 //y=1.175 //x2=11.205 //y2=0.175
cc_7648 ( N_noxref_21_c_12967_p N_GND_c_13952_n ) capacitor c=0.00428537f \
 //x=8.4 //y=0.805 //x2=11.205 //y2=0.175
cc_7649 ( N_noxref_21_c_12923_n N_GND_c_13952_n ) capacitor c=0.00948373f \
 //x=9.285 //y=0.72 //x2=11.205 //y2=0.175
cc_7650 ( N_noxref_21_c_12969_p N_GND_c_13952_n ) capacitor c=0.00232964f \
 //x=9.37 //y=0.805 //x2=11.205 //y2=0.175
cc_7651 ( N_noxref_21_M4_noxref_d N_GND_c_13952_n ) capacitor c=0.0133214f \
 //x=7.16 //y=1.09 //x2=11.205 //y2=0.175
cc_7652 ( N_noxref_21_M4_noxref_d N_GND_c_13956_n ) capacitor c=0.0154456f \
 //x=7.16 //y=1.09 //x2=6.375 //y2=1.145
cc_7653 ( N_noxref_21_c_12936_n N_GND_c_13971_n ) capacitor c=0.00919902f \
 //x=8.315 //y=1.175 //x2=9.94 //y2=0.175
cc_7654 ( N_noxref_21_c_12967_p N_GND_c_13971_n ) capacitor c=0.0142296f \
 //x=8.4 //y=0.805 //x2=9.94 //y2=0.175
cc_7655 ( N_noxref_21_c_12923_n N_GND_c_13971_n ) capacitor c=0.0365187f \
 //x=9.285 //y=0.72 //x2=9.94 //y2=0.175
cc_7656 ( N_noxref_21_c_12969_p N_GND_c_13971_n ) capacitor c=0.013886f \
 //x=9.37 //y=0.805 //x2=9.94 //y2=0.175
cc_7657 ( N_noxref_21_M5_noxref_s N_GND_c_13974_n ) capacitor c=8.16352e-19 \
 //x=8.265 //y=0.555 //x2=5.3 //y2=0.175
cc_7658 ( N_noxref_21_c_12969_p N_GND_c_13977_n ) capacitor c=0.0374312f \
 //x=9.37 //y=0.805 //x2=10.11 //y2=0.175
cc_7659 ( N_noxref_21_M5_noxref_s N_GND_c_13977_n ) capacitor c=0.00519576f \
 //x=8.265 //y=0.555 //x2=10.11 //y2=0.175
cc_7660 ( N_noxref_21_M4_noxref_d N_GND_M3_noxref_d ) capacitor c=3.12752e-19 \
 //x=7.16 //y=1.09 //x2=6.185 //y2=1.055
cc_7661 ( N_noxref_21_c_12967_p N_noxref_36_c_15620_n ) capacitor \
 c=2.15937e-19 //x=8.4 //y=0.805 //x2=6.86 //y2=0.805
cc_7662 ( N_noxref_21_c_12936_n N_noxref_36_c_15606_n ) capacitor c=0.013095f \
 //x=8.315 //y=1.175 //x2=7.745 //y2=0.72
cc_7663 ( N_noxref_21_M4_noxref_d N_noxref_36_c_15606_n ) capacitor \
 c=0.0160925f //x=7.16 //y=1.09 //x2=7.745 //y2=0.72
cc_7664 ( N_noxref_21_c_12936_n N_noxref_36_c_15592_n ) capacitor \
 c=0.00944683f //x=8.315 //y=1.175 //x2=7.745 //y2=1.77
cc_7665 ( N_noxref_21_M4_noxref_d N_noxref_36_c_15592_n ) capacitor \
 c=0.0151375f //x=7.16 //y=1.09 //x2=7.745 //y2=1.77
cc_7666 ( N_noxref_21_c_12936_n N_noxref_36_M3_noxref_s ) capacitor \
 c=0.0225369f //x=8.315 //y=1.175 //x2=5.755 //y2=0.555
cc_7667 ( N_noxref_21_c_12967_p N_noxref_36_M3_noxref_s ) capacitor \
 c=0.0175532f //x=8.4 //y=0.805 //x2=5.755 //y2=0.555
cc_7668 ( N_noxref_21_c_12969_p N_noxref_36_M3_noxref_s ) capacitor \
 c=2.98721e-19 //x=9.37 //y=0.805 //x2=5.755 //y2=0.555
cc_7669 ( N_noxref_21_M4_noxref_d N_noxref_36_M3_noxref_s ) capacitor \
 c=0.0187685f //x=7.16 //y=1.09 //x2=5.755 //y2=0.555
cc_7670 ( N_noxref_21_M5_noxref_s N_noxref_36_M3_noxref_s ) capacitor \
 c=0.021082f //x=8.265 //y=0.555 //x2=5.755 //y2=0.555
cc_7671 ( N_noxref_21_c_12969_p N_noxref_37_M6_noxref_s ) capacitor \
 c=0.00370912f //x=9.37 //y=0.805 //x2=10.67 //y2=0.545
cc_7672 ( N_noxref_21_M5_noxref_s N_noxref_37_M6_noxref_s ) capacitor \
 c=0.00101401f //x=8.265 //y=0.555 //x2=10.67 //y2=0.545
cc_7673 ( N_noxref_22_c_13004_n N_GND_c_14098_n ) capacitor c=0.00533679f \
 //x=16.455 //y=1.175 //x2=19.24 //y2=0.175
cc_7674 ( N_noxref_22_c_13034_p N_GND_c_14098_n ) capacitor c=0.00428537f \
 //x=16.54 //y=0.805 //x2=19.24 //y2=0.175
cc_7675 ( N_noxref_22_c_12993_n N_GND_c_14098_n ) capacitor c=0.00948373f \
 //x=17.425 //y=0.72 //x2=19.24 //y2=0.175
cc_7676 ( N_noxref_22_c_13036_p N_GND_c_14098_n ) capacitor c=0.00232964f \
 //x=17.51 //y=0.805 //x2=19.24 //y2=0.175
cc_7677 ( N_noxref_22_M9_noxref_d N_GND_c_14098_n ) capacitor c=0.0131076f \
 //x=15.3 //y=1.09 //x2=19.24 //y2=0.175
cc_7678 ( N_noxref_22_M9_noxref_d N_GND_c_14002_n ) capacitor c=0.0154456f \
 //x=15.3 //y=1.09 //x2=14.515 //y2=1.145
cc_7679 ( N_noxref_22_c_13004_n N_GND_c_14015_n ) capacitor c=0.0091517f \
 //x=16.455 //y=1.175 //x2=18.08 //y2=0.175
cc_7680 ( N_noxref_22_c_13034_p N_GND_c_14015_n ) capacitor c=0.0138581f \
 //x=16.54 //y=0.805 //x2=18.08 //y2=0.175
cc_7681 ( N_noxref_22_c_12993_n N_GND_c_14015_n ) capacitor c=0.0365187f \
 //x=17.425 //y=0.72 //x2=18.08 //y2=0.175
cc_7682 ( N_noxref_22_c_13036_p N_GND_c_14015_n ) capacitor c=0.013886f \
 //x=17.51 //y=0.805 //x2=18.08 //y2=0.175
cc_7683 ( N_noxref_22_M10_noxref_s N_GND_c_14017_n ) capacitor c=8.16352e-19 \
 //x=16.405 //y=0.555 //x2=13.44 //y2=0.175
cc_7684 ( N_noxref_22_c_13036_p N_GND_c_14074_n ) capacitor c=0.037873f \
 //x=17.51 //y=0.805 //x2=18.25 //y2=0.175
cc_7685 ( N_noxref_22_M10_noxref_s N_GND_c_14074_n ) capacitor c=0.0051897f \
 //x=16.405 //y=0.555 //x2=18.25 //y2=0.175
cc_7686 ( N_noxref_22_M9_noxref_d N_GND_M8_noxref_d ) capacitor c=3.12752e-19 \
 //x=15.3 //y=1.09 //x2=14.325 //y2=1.055
cc_7687 ( N_noxref_22_c_13034_p N_noxref_38_c_15742_n ) capacitor \
 c=2.15937e-19 //x=16.54 //y=0.805 //x2=15 //y2=0.805
cc_7688 ( N_noxref_22_c_13004_n N_noxref_38_c_15728_n ) capacitor c=0.0130857f \
 //x=16.455 //y=1.175 //x2=15.885 //y2=0.72
cc_7689 ( N_noxref_22_M9_noxref_d N_noxref_38_c_15728_n ) capacitor \
 c=0.0160925f //x=15.3 //y=1.09 //x2=15.885 //y2=0.72
cc_7690 ( N_noxref_22_c_13004_n N_noxref_38_c_15730_n ) capacitor \
 c=0.00944538f //x=16.455 //y=1.175 //x2=15.885 //y2=1.77
cc_7691 ( N_noxref_22_M9_noxref_d N_noxref_38_c_15730_n ) capacitor \
 c=0.0152605f //x=15.3 //y=1.09 //x2=15.885 //y2=1.77
cc_7692 ( N_noxref_22_c_13004_n N_noxref_38_M8_noxref_s ) capacitor \
 c=0.0223986f //x=16.455 //y=1.175 //x2=13.895 //y2=0.555
cc_7693 ( N_noxref_22_c_13034_p N_noxref_38_M8_noxref_s ) capacitor \
 c=0.0175461f //x=16.54 //y=0.805 //x2=13.895 //y2=0.555
cc_7694 ( N_noxref_22_c_13036_p N_noxref_38_M8_noxref_s ) capacitor \
 c=2.98576e-19 //x=17.51 //y=0.805 //x2=13.895 //y2=0.555
cc_7695 ( N_noxref_22_M9_noxref_d N_noxref_38_M8_noxref_s ) capacitor \
 c=0.0187674f //x=15.3 //y=1.09 //x2=13.895 //y2=0.555
cc_7696 ( N_noxref_22_M10_noxref_s N_noxref_38_M8_noxref_s ) capacitor \
 c=0.0210819f //x=16.405 //y=0.555 //x2=13.895 //y2=0.555
cc_7697 ( N_noxref_22_c_13036_p N_noxref_39_M11_noxref_s ) capacitor \
 c=0.00368328f //x=17.51 //y=0.805 //x2=18.705 //y2=0.555
cc_7698 ( N_noxref_22_M10_noxref_s N_noxref_39_M11_noxref_s ) capacitor \
 c=0.00125282f //x=16.405 //y=0.555 //x2=18.705 //y2=0.555
cc_7699 ( N_noxref_23_c_13071_n N_GND_c_14101_n ) capacitor c=0.00533679f \
 //x=21.265 //y=1.175 //x2=24.155 //y2=0.175
cc_7700 ( N_noxref_23_c_13103_p N_GND_c_14101_n ) capacitor c=0.0042051f \
 //x=21.35 //y=0.805 //x2=24.155 //y2=0.175
cc_7701 ( N_noxref_23_c_13059_n N_GND_c_14101_n ) capacitor c=0.00955643f \
 //x=22.235 //y=0.72 //x2=24.155 //y2=0.175
cc_7702 ( N_noxref_23_c_13105_p N_GND_c_14101_n ) capacitor c=0.00232964f \
 //x=22.32 //y=0.805 //x2=24.155 //y2=0.175
cc_7703 ( N_noxref_23_M12_noxref_d N_GND_c_14101_n ) capacitor c=0.0130717f \
 //x=20.11 //y=1.09 //x2=24.155 //y2=0.175
cc_7704 ( N_noxref_23_M12_noxref_d N_GND_c_14054_n ) capacitor c=0.0154456f \
 //x=20.11 //y=1.09 //x2=19.325 //y2=1.145
cc_7705 ( N_noxref_23_c_13071_n N_GND_c_14066_n ) capacitor c=0.0091517f \
 //x=21.265 //y=1.175 //x2=22.89 //y2=0.175
cc_7706 ( N_noxref_23_c_13103_p N_GND_c_14066_n ) capacitor c=0.0141638f \
 //x=21.35 //y=0.805 //x2=22.89 //y2=0.175
cc_7707 ( N_noxref_23_c_13059_n N_GND_c_14066_n ) capacitor c=0.0364778f \
 //x=22.235 //y=0.72 //x2=22.89 //y2=0.175
cc_7708 ( N_noxref_23_c_13105_p N_GND_c_14066_n ) capacitor c=0.013886f \
 //x=22.32 //y=0.805 //x2=22.89 //y2=0.175
cc_7709 ( N_noxref_23_M13_noxref_s N_GND_c_14074_n ) capacitor c=8.16352e-19 \
 //x=21.215 //y=0.555 //x2=18.25 //y2=0.175
cc_7710 ( N_noxref_23_c_13105_p N_GND_c_14147_n ) capacitor c=0.0374312f \
 //x=22.32 //y=0.805 //x2=23.06 //y2=0.175
cc_7711 ( N_noxref_23_M13_noxref_s N_GND_c_14147_n ) capacitor c=0.00519576f \
 //x=21.215 //y=0.555 //x2=23.06 //y2=0.175
cc_7712 ( N_noxref_23_M12_noxref_d N_GND_M11_noxref_d ) capacitor \
 c=3.12752e-19 //x=20.11 //y=1.09 //x2=19.135 //y2=1.055
cc_7713 ( N_noxref_23_c_13103_p N_noxref_39_c_15803_n ) capacitor \
 c=2.15937e-19 //x=21.35 //y=0.805 //x2=19.81 //y2=0.805
cc_7714 ( N_noxref_23_c_13071_n N_noxref_39_c_15788_n ) capacitor c=0.0130857f \
 //x=21.265 //y=1.175 //x2=20.695 //y2=0.72
cc_7715 ( N_noxref_23_M12_noxref_d N_noxref_39_c_15788_n ) capacitor \
 c=0.0160925f //x=20.11 //y=1.09 //x2=20.695 //y2=0.72
cc_7716 ( N_noxref_23_c_13071_n N_noxref_39_c_15790_n ) capacitor \
 c=0.00944538f //x=21.265 //y=1.175 //x2=20.695 //y2=1.77
cc_7717 ( N_noxref_23_M12_noxref_d N_noxref_39_c_15790_n ) capacitor \
 c=0.014937f //x=20.11 //y=1.09 //x2=20.695 //y2=1.77
cc_7718 ( N_noxref_23_c_13071_n N_noxref_39_M11_noxref_s ) capacitor \
 c=0.0223986f //x=21.265 //y=1.175 //x2=18.705 //y2=0.555
cc_7719 ( N_noxref_23_c_13103_p N_noxref_39_M11_noxref_s ) capacitor \
 c=0.0175532f //x=21.35 //y=0.805 //x2=18.705 //y2=0.555
cc_7720 ( N_noxref_23_c_13105_p N_noxref_39_M11_noxref_s ) capacitor \
 c=2.98721e-19 //x=22.32 //y=0.805 //x2=18.705 //y2=0.555
cc_7721 ( N_noxref_23_M12_noxref_d N_noxref_39_M11_noxref_s ) capacitor \
 c=0.0187685f //x=20.11 //y=1.09 //x2=18.705 //y2=0.555
cc_7722 ( N_noxref_23_M13_noxref_s N_noxref_39_M11_noxref_s ) capacitor \
 c=0.021082f //x=21.215 //y=0.555 //x2=18.705 //y2=0.555
cc_7723 ( N_noxref_23_c_13105_p N_noxref_40_M14_noxref_s ) capacitor \
 c=0.00370912f //x=22.32 //y=0.805 //x2=23.62 //y2=0.545
cc_7724 ( N_noxref_23_M13_noxref_s N_noxref_40_M14_noxref_s ) capacitor \
 c=0.00101401f //x=21.215 //y=0.555 //x2=23.62 //y2=0.545
cc_7725 ( N_noxref_24_c_13149_n N_GND_c_14171_n ) capacitor c=0.00533679f \
 //x=29.405 //y=1.175 //x2=32.19 //y2=0.175
cc_7726 ( N_noxref_24_c_13170_p N_GND_c_14171_n ) capacitor c=0.00426193f \
 //x=29.49 //y=0.805 //x2=32.19 //y2=0.175
cc_7727 ( N_noxref_24_c_13128_n N_GND_c_14171_n ) capacitor c=0.00958276f \
 //x=30.375 //y=0.72 //x2=32.19 //y2=0.175
cc_7728 ( N_noxref_24_c_13172_p N_GND_c_14171_n ) capacitor c=0.00232964f \
 //x=30.46 //y=0.805 //x2=32.19 //y2=0.175
cc_7729 ( N_noxref_24_M17_noxref_d N_GND_c_14171_n ) capacitor c=0.0131076f \
 //x=28.25 //y=1.09 //x2=32.19 //y2=0.175
cc_7730 ( N_noxref_24_M17_noxref_d N_GND_c_14351_n ) capacitor c=0.0154456f \
 //x=28.25 //y=1.09 //x2=27.465 //y2=1.145
cc_7731 ( N_noxref_24_c_13149_n N_GND_c_14189_n ) capacitor c=0.0091517f \
 //x=29.405 //y=1.175 //x2=31.03 //y2=0.175
cc_7732 ( N_noxref_24_c_13170_p N_GND_c_14189_n ) capacitor c=0.0141638f \
 //x=29.49 //y=0.805 //x2=31.03 //y2=0.175
cc_7733 ( N_noxref_24_c_13128_n N_GND_c_14189_n ) capacitor c=0.0364778f \
 //x=30.375 //y=0.72 //x2=31.03 //y2=0.175
cc_7734 ( N_noxref_24_c_13172_p N_GND_c_14189_n ) capacitor c=0.013886f \
 //x=30.46 //y=0.805 //x2=31.03 //y2=0.175
cc_7735 ( N_noxref_24_M18_noxref_s N_GND_c_14154_n ) capacitor c=8.16352e-19 \
 //x=29.355 //y=0.555 //x2=26.39 //y2=0.175
cc_7736 ( N_noxref_24_c_13172_p N_GND_c_14193_n ) capacitor c=0.037873f \
 //x=30.46 //y=0.805 //x2=31.2 //y2=0.175
cc_7737 ( N_noxref_24_M18_noxref_s N_GND_c_14193_n ) capacitor c=0.0051897f \
 //x=29.355 //y=0.555 //x2=31.2 //y2=0.175
cc_7738 ( N_noxref_24_M17_noxref_d N_GND_M16_noxref_d ) capacitor \
 c=3.12752e-19 //x=28.25 //y=1.09 //x2=27.275 //y2=1.055
cc_7739 ( N_noxref_24_c_13170_p N_noxref_41_c_15925_n ) capacitor \
 c=2.15937e-19 //x=29.49 //y=0.805 //x2=27.95 //y2=0.805
cc_7740 ( N_noxref_24_c_13149_n N_noxref_41_c_15911_n ) capacitor c=0.0130857f \
 //x=29.405 //y=1.175 //x2=28.835 //y2=0.72
cc_7741 ( N_noxref_24_M17_noxref_d N_noxref_41_c_15911_n ) capacitor \
 c=0.0160925f //x=28.25 //y=1.09 //x2=28.835 //y2=0.72
cc_7742 ( N_noxref_24_c_13149_n N_noxref_41_c_15913_n ) capacitor \
 c=0.00944538f //x=29.405 //y=1.175 //x2=28.835 //y2=1.77
cc_7743 ( N_noxref_24_M17_noxref_d N_noxref_41_c_15913_n ) capacitor \
 c=0.0152674f //x=28.25 //y=1.09 //x2=28.835 //y2=1.77
cc_7744 ( N_noxref_24_c_13149_n N_noxref_41_M16_noxref_s ) capacitor \
 c=0.0223986f //x=29.405 //y=1.175 //x2=26.845 //y2=0.555
cc_7745 ( N_noxref_24_c_13170_p N_noxref_41_M16_noxref_s ) capacitor \
 c=0.0175461f //x=29.49 //y=0.805 //x2=26.845 //y2=0.555
cc_7746 ( N_noxref_24_c_13172_p N_noxref_41_M16_noxref_s ) capacitor \
 c=2.98576e-19 //x=30.46 //y=0.805 //x2=26.845 //y2=0.555
cc_7747 ( N_noxref_24_M17_noxref_d N_noxref_41_M16_noxref_s ) capacitor \
 c=0.0187674f //x=28.25 //y=1.09 //x2=26.845 //y2=0.555
cc_7748 ( N_noxref_24_M18_noxref_s N_noxref_41_M16_noxref_s ) capacitor \
 c=0.0210819f //x=29.355 //y=0.555 //x2=26.845 //y2=0.555
cc_7749 ( N_noxref_24_c_13172_p N_noxref_42_M19_noxref_s ) capacitor \
 c=0.00368328f //x=30.46 //y=0.805 //x2=31.655 //y2=0.555
cc_7750 ( N_noxref_24_M18_noxref_s N_noxref_42_M19_noxref_s ) capacitor \
 c=0.00125282f //x=29.355 //y=0.555 //x2=31.655 //y2=0.555
cc_7751 ( N_noxref_25_c_13207_n N_GND_c_14172_n ) capacitor c=0.00533679f \
 //x=34.215 //y=1.175 //x2=37.105 //y2=0.175
cc_7752 ( N_noxref_25_c_13238_p N_GND_c_14172_n ) capacitor c=0.00428537f \
 //x=34.3 //y=0.805 //x2=37.105 //y2=0.175
cc_7753 ( N_noxref_25_c_13195_n N_GND_c_14172_n ) capacitor c=0.00948373f \
 //x=35.185 //y=0.72 //x2=37.105 //y2=0.175
cc_7754 ( N_noxref_25_c_13240_p N_GND_c_14172_n ) capacitor c=0.00232964f \
 //x=35.27 //y=0.805 //x2=37.105 //y2=0.175
cc_7755 ( N_noxref_25_M20_noxref_d N_GND_c_14172_n ) capacitor c=0.0130953f \
 //x=33.06 //y=1.09 //x2=37.105 //y2=0.175
cc_7756 ( N_noxref_25_M20_noxref_d N_GND_c_14260_n ) capacitor c=0.0154456f \
 //x=33.06 //y=1.09 //x2=32.275 //y2=1.145
cc_7757 ( N_noxref_25_c_13207_n N_GND_c_14190_n ) capacitor c=0.0091517f \
 //x=34.215 //y=1.175 //x2=35.84 //y2=0.175
cc_7758 ( N_noxref_25_c_13238_p N_GND_c_14190_n ) capacitor c=0.0138581f \
 //x=34.3 //y=0.805 //x2=35.84 //y2=0.175
cc_7759 ( N_noxref_25_c_13195_n N_GND_c_14190_n ) capacitor c=0.0365187f \
 //x=35.185 //y=0.72 //x2=35.84 //y2=0.175
cc_7760 ( N_noxref_25_c_13240_p N_GND_c_14190_n ) capacitor c=0.013886f \
 //x=35.27 //y=0.805 //x2=35.84 //y2=0.175
cc_7761 ( N_noxref_25_M21_noxref_s N_GND_c_14193_n ) capacitor c=8.16352e-19 \
 //x=34.165 //y=0.555 //x2=31.2 //y2=0.175
cc_7762 ( N_noxref_25_c_13240_p N_GND_c_14196_n ) capacitor c=0.0374312f \
 //x=35.27 //y=0.805 //x2=36.01 //y2=0.175
cc_7763 ( N_noxref_25_M21_noxref_s N_GND_c_14196_n ) capacitor c=0.00519576f \
 //x=34.165 //y=0.555 //x2=36.01 //y2=0.175
cc_7764 ( N_noxref_25_M20_noxref_d N_GND_M19_noxref_d ) capacitor \
 c=3.12752e-19 //x=33.06 //y=1.09 //x2=32.085 //y2=1.055
cc_7765 ( N_noxref_25_c_13238_p N_noxref_42_c_15988_n ) capacitor \
 c=2.15937e-19 //x=34.3 //y=0.805 //x2=32.76 //y2=0.805
cc_7766 ( N_noxref_25_c_13207_n N_noxref_42_c_15969_n ) capacitor c=0.013083f \
 //x=34.215 //y=1.175 //x2=33.645 //y2=0.72
cc_7767 ( N_noxref_25_M20_noxref_d N_noxref_42_c_15969_n ) capacitor \
 c=0.0160925f //x=33.06 //y=1.09 //x2=33.645 //y2=0.72
cc_7768 ( N_noxref_25_c_13207_n N_noxref_42_c_15971_n ) capacitor \
 c=0.00944001f //x=34.215 //y=1.175 //x2=33.645 //y2=1.77
cc_7769 ( N_noxref_25_M20_noxref_d N_noxref_42_c_15971_n ) capacitor \
 c=0.0151511f //x=33.06 //y=1.09 //x2=33.645 //y2=1.77
cc_7770 ( N_noxref_25_c_13207_n N_noxref_42_M19_noxref_s ) capacitor \
 c=0.0223912f //x=34.215 //y=1.175 //x2=31.655 //y2=0.555
cc_7771 ( N_noxref_25_c_13238_p N_noxref_42_M19_noxref_s ) capacitor \
 c=0.0175532f //x=34.3 //y=0.805 //x2=31.655 //y2=0.555
cc_7772 ( N_noxref_25_c_13240_p N_noxref_42_M19_noxref_s ) capacitor \
 c=2.98721e-19 //x=35.27 //y=0.805 //x2=31.655 //y2=0.555
cc_7773 ( N_noxref_25_M20_noxref_d N_noxref_42_M19_noxref_s ) capacitor \
 c=0.0187685f //x=33.06 //y=1.09 //x2=31.655 //y2=0.555
cc_7774 ( N_noxref_25_M21_noxref_s N_noxref_42_M19_noxref_s ) capacitor \
 c=0.021082f //x=34.165 //y=0.555 //x2=31.655 //y2=0.555
cc_7775 ( N_noxref_25_c_13240_p N_noxref_43_M22_noxref_s ) capacitor \
 c=0.00370912f //x=35.27 //y=0.805 //x2=36.57 //y2=0.545
cc_7776 ( N_noxref_25_M21_noxref_s N_noxref_43_M22_noxref_s ) capacitor \
 c=0.00101401f //x=34.165 //y=0.555 //x2=36.57 //y2=0.545
cc_7777 ( N_noxref_26_c_13275_n N_GND_c_14347_n ) capacitor c=0.00533679f \
 //x=42.355 //y=1.175 //x2=45.14 //y2=0.175
cc_7778 ( N_noxref_26_c_13305_p N_GND_c_14347_n ) capacitor c=0.00428537f \
 //x=42.44 //y=0.805 //x2=45.14 //y2=0.175
cc_7779 ( N_noxref_26_c_13264_n N_GND_c_14347_n ) capacitor c=0.00948373f \
 //x=43.325 //y=0.72 //x2=45.14 //y2=0.175
cc_7780 ( N_noxref_26_c_13307_p N_GND_c_14347_n ) capacitor c=0.00232964f \
 //x=43.41 //y=0.805 //x2=45.14 //y2=0.175
cc_7781 ( N_noxref_26_M25_noxref_d N_GND_c_14347_n ) capacitor c=0.0131076f \
 //x=41.2 //y=1.09 //x2=45.14 //y2=0.175
cc_7782 ( N_noxref_26_M25_noxref_d N_GND_c_14220_n ) capacitor c=0.0154456f \
 //x=41.2 //y=1.09 //x2=40.415 //y2=1.145
cc_7783 ( N_noxref_26_c_13275_n N_GND_c_14233_n ) capacitor c=0.0091517f \
 //x=42.355 //y=1.175 //x2=43.98 //y2=0.175
cc_7784 ( N_noxref_26_c_13305_p N_GND_c_14233_n ) capacitor c=0.0138581f \
 //x=42.44 //y=0.805 //x2=43.98 //y2=0.175
cc_7785 ( N_noxref_26_c_13264_n N_GND_c_14233_n ) capacitor c=0.0365187f \
 //x=43.325 //y=0.72 //x2=43.98 //y2=0.175
cc_7786 ( N_noxref_26_c_13307_p N_GND_c_14233_n ) capacitor c=0.013886f \
 //x=43.41 //y=0.805 //x2=43.98 //y2=0.175
cc_7787 ( N_noxref_26_M26_noxref_s N_GND_c_14235_n ) capacitor c=8.16352e-19 \
 //x=42.305 //y=0.555 //x2=39.34 //y2=0.175
cc_7788 ( N_noxref_26_c_13307_p N_GND_c_14291_n ) capacitor c=0.037873f \
 //x=43.41 //y=0.805 //x2=44.15 //y2=0.175
cc_7789 ( N_noxref_26_M26_noxref_s N_GND_c_14291_n ) capacitor c=0.0051897f \
 //x=42.305 //y=0.555 //x2=44.15 //y2=0.175
cc_7790 ( N_noxref_26_M25_noxref_d N_GND_M24_noxref_d ) capacitor \
 c=3.12752e-19 //x=41.2 //y=1.09 //x2=40.225 //y2=1.055
cc_7791 ( N_noxref_26_c_13305_p N_noxref_44_c_16110_n ) capacitor \
 c=2.15937e-19 //x=42.44 //y=0.805 //x2=40.9 //y2=0.805
cc_7792 ( N_noxref_26_c_13275_n N_noxref_44_c_16096_n ) capacitor c=0.0130857f \
 //x=42.355 //y=1.175 //x2=41.785 //y2=0.72
cc_7793 ( N_noxref_26_M25_noxref_d N_noxref_44_c_16096_n ) capacitor \
 c=0.0160925f //x=41.2 //y=1.09 //x2=41.785 //y2=0.72
cc_7794 ( N_noxref_26_c_13275_n N_noxref_44_c_16098_n ) capacitor \
 c=0.00944538f //x=42.355 //y=1.175 //x2=41.785 //y2=1.77
cc_7795 ( N_noxref_26_M25_noxref_d N_noxref_44_c_16098_n ) capacitor \
 c=0.0152605f //x=41.2 //y=1.09 //x2=41.785 //y2=1.77
cc_7796 ( N_noxref_26_c_13275_n N_noxref_44_M24_noxref_s ) capacitor \
 c=0.0223986f //x=42.355 //y=1.175 //x2=39.795 //y2=0.555
cc_7797 ( N_noxref_26_c_13305_p N_noxref_44_M24_noxref_s ) capacitor \
 c=0.0175461f //x=42.44 //y=0.805 //x2=39.795 //y2=0.555
cc_7798 ( N_noxref_26_c_13307_p N_noxref_44_M24_noxref_s ) capacitor \
 c=2.98576e-19 //x=43.41 //y=0.805 //x2=39.795 //y2=0.555
cc_7799 ( N_noxref_26_M25_noxref_d N_noxref_44_M24_noxref_s ) capacitor \
 c=0.0187674f //x=41.2 //y=1.09 //x2=39.795 //y2=0.555
cc_7800 ( N_noxref_26_M26_noxref_s N_noxref_44_M24_noxref_s ) capacitor \
 c=0.0210819f //x=42.305 //y=0.555 //x2=39.795 //y2=0.555
cc_7801 ( N_noxref_26_c_13307_p N_noxref_45_M27_noxref_s ) capacitor \
 c=0.00368328f //x=43.41 //y=0.805 //x2=44.605 //y2=0.555
cc_7802 ( N_noxref_26_M26_noxref_s N_noxref_45_M27_noxref_s ) capacitor \
 c=0.00125282f //x=42.305 //y=0.555 //x2=44.605 //y2=0.555
cc_7803 ( N_noxref_27_c_13342_n N_GND_c_14310_n ) capacitor c=0.00533679f \
 //x=47.165 //y=1.175 //x2=50.055 //y2=0.175
cc_7804 ( N_noxref_27_c_13373_p N_GND_c_14310_n ) capacitor c=0.00426228f \
 //x=47.25 //y=0.805 //x2=50.055 //y2=0.175
cc_7805 ( N_noxref_27_c_13330_n N_GND_c_14310_n ) capacitor c=0.00958383f \
 //x=48.135 //y=0.72 //x2=50.055 //y2=0.175
cc_7806 ( N_noxref_27_c_13375_p N_GND_c_14310_n ) capacitor c=0.00232964f \
 //x=48.22 //y=0.805 //x2=50.055 //y2=0.175
cc_7807 ( N_noxref_27_M28_noxref_d N_GND_c_14310_n ) capacitor c=0.0130717f \
 //x=46.01 //y=1.09 //x2=50.055 //y2=0.175
cc_7808 ( N_noxref_27_M28_noxref_d N_GND_c_14271_n ) capacitor c=0.0154456f \
 //x=46.01 //y=1.09 //x2=45.225 //y2=1.145
cc_7809 ( N_noxref_27_c_13342_n N_GND_c_14283_n ) capacitor c=0.0091517f \
 //x=47.165 //y=1.175 //x2=48.79 //y2=0.175
cc_7810 ( N_noxref_27_c_13373_p N_GND_c_14283_n ) capacitor c=0.0141638f \
 //x=47.25 //y=0.805 //x2=48.79 //y2=0.175
cc_7811 ( N_noxref_27_c_13330_n N_GND_c_14283_n ) capacitor c=0.0364778f \
 //x=48.135 //y=0.72 //x2=48.79 //y2=0.175
cc_7812 ( N_noxref_27_c_13375_p N_GND_c_14283_n ) capacitor c=0.013886f \
 //x=48.22 //y=0.805 //x2=48.79 //y2=0.175
cc_7813 ( N_noxref_27_M29_noxref_s N_GND_c_14291_n ) capacitor c=8.16352e-19 \
 //x=47.115 //y=0.555 //x2=44.15 //y2=0.175
cc_7814 ( N_noxref_27_c_13375_p N_GND_c_14329_n ) capacitor c=0.0374312f \
 //x=48.22 //y=0.805 //x2=48.96 //y2=0.175
cc_7815 ( N_noxref_27_M29_noxref_s N_GND_c_14329_n ) capacitor c=0.00519576f \
 //x=47.115 //y=0.555 //x2=48.96 //y2=0.175
cc_7816 ( N_noxref_27_M28_noxref_d N_GND_M27_noxref_d ) capacitor \
 c=3.12752e-19 //x=46.01 //y=1.09 //x2=45.035 //y2=1.055
cc_7817 ( N_noxref_27_c_13373_p N_noxref_45_c_16171_n ) capacitor \
 c=2.15937e-19 //x=47.25 //y=0.805 //x2=45.71 //y2=0.805
cc_7818 ( N_noxref_27_c_13342_n N_noxref_45_c_16156_n ) capacitor c=0.0130857f \
 //x=47.165 //y=1.175 //x2=46.595 //y2=0.72
cc_7819 ( N_noxref_27_M28_noxref_d N_noxref_45_c_16156_n ) capacitor \
 c=0.0160925f //x=46.01 //y=1.09 //x2=46.595 //y2=0.72
cc_7820 ( N_noxref_27_c_13342_n N_noxref_45_c_16158_n ) capacitor \
 c=0.00944538f //x=47.165 //y=1.175 //x2=46.595 //y2=1.77
cc_7821 ( N_noxref_27_M28_noxref_d N_noxref_45_c_16158_n ) capacitor \
 c=0.014937f //x=46.01 //y=1.09 //x2=46.595 //y2=1.77
cc_7822 ( N_noxref_27_c_13342_n N_noxref_45_M27_noxref_s ) capacitor \
 c=0.0223986f //x=47.165 //y=1.175 //x2=44.605 //y2=0.555
cc_7823 ( N_noxref_27_c_13373_p N_noxref_45_M27_noxref_s ) capacitor \
 c=0.0175532f //x=47.25 //y=0.805 //x2=44.605 //y2=0.555
cc_7824 ( N_noxref_27_c_13375_p N_noxref_45_M27_noxref_s ) capacitor \
 c=2.98721e-19 //x=48.22 //y=0.805 //x2=44.605 //y2=0.555
cc_7825 ( N_noxref_27_M28_noxref_d N_noxref_45_M27_noxref_s ) capacitor \
 c=0.0187685f //x=46.01 //y=1.09 //x2=44.605 //y2=0.555
cc_7826 ( N_noxref_27_M29_noxref_s N_noxref_45_M27_noxref_s ) capacitor \
 c=0.021082f //x=47.115 //y=0.555 //x2=44.605 //y2=0.555
cc_7827 ( N_noxref_27_c_13375_p N_noxref_46_M30_noxref_s ) capacitor \
 c=0.00370912f //x=48.22 //y=0.805 //x2=49.52 //y2=0.545
cc_7828 ( N_noxref_27_M29_noxref_s N_noxref_46_M30_noxref_s ) capacitor \
 c=0.00101401f //x=47.115 //y=0.555 //x2=49.52 //y2=0.545
cc_7829 ( N_noxref_28_c_13398_n N_GND_c_14416_n ) capacitor c=0.00533679f \
 //x=55.305 //y=1.175 //x2=58.09 //y2=0.175
cc_7830 ( N_noxref_28_c_13440_p N_GND_c_14416_n ) capacitor c=0.00426193f \
 //x=55.39 //y=0.805 //x2=58.09 //y2=0.175
cc_7831 ( N_noxref_28_c_13413_n N_GND_c_14416_n ) capacitor c=0.00958276f \
 //x=56.275 //y=0.72 //x2=58.09 //y2=0.175
cc_7832 ( N_noxref_28_c_13442_p N_GND_c_14416_n ) capacitor c=0.00232964f \
 //x=56.36 //y=0.805 //x2=58.09 //y2=0.175
cc_7833 ( N_noxref_28_M33_noxref_d N_GND_c_14416_n ) capacitor c=0.0130498f \
 //x=54.15 //y=1.09 //x2=58.09 //y2=0.175
cc_7834 ( N_noxref_28_M33_noxref_d N_GND_c_14529_n ) capacitor c=0.0154456f \
 //x=54.15 //y=1.09 //x2=53.365 //y2=1.145
cc_7835 ( N_noxref_28_c_13398_n N_GND_c_14449_n ) capacitor c=0.0091517f \
 //x=55.305 //y=1.175 //x2=56.93 //y2=0.175
cc_7836 ( N_noxref_28_c_13440_p N_GND_c_14449_n ) capacitor c=0.0141638f \
 //x=55.39 //y=0.805 //x2=56.93 //y2=0.175
cc_7837 ( N_noxref_28_c_13413_n N_GND_c_14449_n ) capacitor c=0.0364778f \
 //x=56.275 //y=0.72 //x2=56.93 //y2=0.175
cc_7838 ( N_noxref_28_c_13442_p N_GND_c_14449_n ) capacitor c=0.013886f \
 //x=56.36 //y=0.805 //x2=56.93 //y2=0.175
cc_7839 ( N_noxref_28_M34_noxref_s N_GND_c_14376_n ) capacitor c=8.16352e-19 \
 //x=55.255 //y=0.555 //x2=52.29 //y2=0.175
cc_7840 ( N_noxref_28_c_13442_p N_GND_c_14409_n ) capacitor c=0.037873f \
 //x=56.36 //y=0.805 //x2=57.1 //y2=0.175
cc_7841 ( N_noxref_28_M34_noxref_s N_GND_c_14409_n ) capacitor c=0.0051897f \
 //x=55.255 //y=0.555 //x2=57.1 //y2=0.175
cc_7842 ( N_noxref_28_M33_noxref_d N_GND_M32_noxref_d ) capacitor \
 c=3.12752e-19 //x=54.15 //y=1.09 //x2=53.175 //y2=1.055
cc_7843 ( N_noxref_28_c_13440_p N_noxref_47_c_16293_n ) capacitor \
 c=2.15937e-19 //x=55.39 //y=0.805 //x2=53.85 //y2=0.805
cc_7844 ( N_noxref_28_c_13398_n N_noxref_47_c_16267_n ) capacitor c=0.0130857f \
 //x=55.305 //y=1.175 //x2=54.735 //y2=0.72
cc_7845 ( N_noxref_28_M33_noxref_d N_noxref_47_c_16267_n ) capacitor \
 c=0.0160925f //x=54.15 //y=1.09 //x2=54.735 //y2=0.72
cc_7846 ( N_noxref_28_c_13398_n N_noxref_47_c_16269_n ) capacitor \
 c=0.00944538f //x=55.305 //y=1.175 //x2=54.735 //y2=1.77
cc_7847 ( N_noxref_28_M33_noxref_d N_noxref_47_c_16269_n ) capacitor \
 c=0.0152674f //x=54.15 //y=1.09 //x2=54.735 //y2=1.77
cc_7848 ( N_noxref_28_c_13398_n N_noxref_47_M32_noxref_s ) capacitor \
 c=0.0223986f //x=55.305 //y=1.175 //x2=52.745 //y2=0.555
cc_7849 ( N_noxref_28_c_13440_p N_noxref_47_M32_noxref_s ) capacitor \
 c=0.0175461f //x=55.39 //y=0.805 //x2=52.745 //y2=0.555
cc_7850 ( N_noxref_28_c_13442_p N_noxref_47_M32_noxref_s ) capacitor \
 c=2.98576e-19 //x=56.36 //y=0.805 //x2=52.745 //y2=0.555
cc_7851 ( N_noxref_28_M33_noxref_d N_noxref_47_M32_noxref_s ) capacitor \
 c=0.0187674f //x=54.15 //y=1.09 //x2=52.745 //y2=0.555
cc_7852 ( N_noxref_28_M34_noxref_s N_noxref_47_M32_noxref_s ) capacitor \
 c=0.0210819f //x=55.255 //y=0.555 //x2=52.745 //y2=0.555
cc_7853 ( N_noxref_28_c_13442_p N_noxref_48_M35_noxref_s ) capacitor \
 c=0.00368328f //x=56.36 //y=0.805 //x2=57.555 //y2=0.555
cc_7854 ( N_noxref_28_M34_noxref_s N_noxref_48_M35_noxref_s ) capacitor \
 c=0.00125282f //x=55.255 //y=0.555 //x2=57.555 //y2=0.555
cc_7855 ( N_noxref_29_c_13465_n N_GND_c_14392_n ) capacitor c=0.00533679f \
 //x=60.115 //y=1.175 //x2=63.005 //y2=0.175
cc_7856 ( N_noxref_29_c_13508_p N_GND_c_14392_n ) capacitor c=0.00428537f \
 //x=60.2 //y=0.805 //x2=63.005 //y2=0.175
cc_7857 ( N_noxref_29_c_13483_n N_GND_c_14392_n ) capacitor c=0.00948373f \
 //x=61.085 //y=0.72 //x2=63.005 //y2=0.175
cc_7858 ( N_noxref_29_c_13510_p N_GND_c_14392_n ) capacitor c=0.00232964f \
 //x=61.17 //y=0.805 //x2=63.005 //y2=0.175
cc_7859 ( N_noxref_29_M36_noxref_d N_GND_c_14392_n ) capacitor c=0.0129685f \
 //x=58.96 //y=1.09 //x2=63.005 //y2=0.175
cc_7860 ( N_noxref_29_M36_noxref_d N_GND_c_14428_n ) capacitor c=0.0154456f \
 //x=58.96 //y=1.09 //x2=58.175 //y2=1.145
cc_7861 ( N_noxref_29_c_13465_n N_GND_c_14450_n ) capacitor c=0.0091517f \
 //x=60.115 //y=1.175 //x2=61.74 //y2=0.175
cc_7862 ( N_noxref_29_c_13508_p N_GND_c_14450_n ) capacitor c=0.0141583f \
 //x=60.2 //y=0.805 //x2=61.74 //y2=0.175
cc_7863 ( N_noxref_29_c_13483_n N_GND_c_14450_n ) capacitor c=0.0365187f \
 //x=61.085 //y=0.72 //x2=61.74 //y2=0.175
cc_7864 ( N_noxref_29_c_13510_p N_GND_c_14450_n ) capacitor c=0.013886f \
 //x=61.17 //y=0.805 //x2=61.74 //y2=0.175
cc_7865 ( N_noxref_29_M37_noxref_s N_GND_c_14409_n ) capacitor c=8.16352e-19 \
 //x=60.065 //y=0.555 //x2=57.1 //y2=0.175
cc_7866 ( N_noxref_29_c_13510_p N_GND_c_14411_n ) capacitor c=0.0374312f \
 //x=61.17 //y=0.805 //x2=61.91 //y2=0.175
cc_7867 ( N_noxref_29_M37_noxref_s N_GND_c_14411_n ) capacitor c=0.00519576f \
 //x=60.065 //y=0.555 //x2=61.91 //y2=0.175
cc_7868 ( N_noxref_29_M36_noxref_d N_GND_M35_noxref_d ) capacitor \
 c=3.12752e-19 //x=58.96 //y=1.09 //x2=57.985 //y2=1.055
cc_7869 ( N_noxref_29_c_13508_p N_noxref_48_c_16356_n ) capacitor \
 c=2.15937e-19 //x=60.2 //y=0.805 //x2=58.66 //y2=0.805
cc_7870 ( N_noxref_29_c_13465_n N_noxref_48_c_16325_n ) capacitor c=0.0130843f \
 //x=60.115 //y=1.175 //x2=59.545 //y2=0.72
cc_7871 ( N_noxref_29_M36_noxref_d N_noxref_48_c_16325_n ) capacitor \
 c=0.0160925f //x=58.96 //y=1.09 //x2=59.545 //y2=0.72
cc_7872 ( N_noxref_29_c_13465_n N_noxref_48_c_16327_n ) capacitor \
 c=0.00944194f //x=60.115 //y=1.175 //x2=59.545 //y2=1.77
cc_7873 ( N_noxref_29_M36_noxref_d N_noxref_48_c_16327_n ) capacitor \
 c=0.0151523f //x=58.96 //y=1.09 //x2=59.545 //y2=1.77
cc_7874 ( N_noxref_29_c_13465_n N_noxref_48_M35_noxref_s ) capacitor \
 c=0.0223949f //x=60.115 //y=1.175 //x2=57.555 //y2=0.555
cc_7875 ( N_noxref_29_c_13508_p N_noxref_48_M35_noxref_s ) capacitor \
 c=0.0175532f //x=60.2 //y=0.805 //x2=57.555 //y2=0.555
cc_7876 ( N_noxref_29_c_13510_p N_noxref_48_M35_noxref_s ) capacitor \
 c=2.98721e-19 //x=61.17 //y=0.805 //x2=57.555 //y2=0.555
cc_7877 ( N_noxref_29_M36_noxref_d N_noxref_48_M35_noxref_s ) capacitor \
 c=0.0187685f //x=58.96 //y=1.09 //x2=57.555 //y2=0.555
cc_7878 ( N_noxref_29_M37_noxref_s N_noxref_48_M35_noxref_s ) capacitor \
 c=0.021082f //x=60.065 //y=0.555 //x2=57.555 //y2=0.555
cc_7879 ( N_noxref_29_c_13510_p N_noxref_49_M38_noxref_s ) capacitor \
 c=0.00370912f //x=61.17 //y=0.805 //x2=62.47 //y2=0.545
cc_7880 ( N_noxref_29_M37_noxref_s N_noxref_49_M38_noxref_s ) capacitor \
 c=0.00101401f //x=60.065 //y=0.555 //x2=62.47 //y2=0.545
cc_7881 ( N_noxref_30_c_13533_n N_GND_c_14417_n ) capacitor c=0.00533679f \
 //x=68.255 //y=1.175 //x2=71.04 //y2=0.175
cc_7882 ( N_noxref_30_c_13575_p N_GND_c_14417_n ) capacitor c=0.00428537f \
 //x=68.34 //y=0.805 //x2=71.04 //y2=0.175
cc_7883 ( N_noxref_30_c_13549_n N_GND_c_14417_n ) capacitor c=0.00948373f \
 //x=69.225 //y=0.72 //x2=71.04 //y2=0.175
cc_7884 ( N_noxref_30_c_13577_p N_GND_c_14417_n ) capacitor c=0.00232964f \
 //x=69.31 //y=0.805 //x2=71.04 //y2=0.175
cc_7885 ( N_noxref_30_M41_noxref_d N_GND_c_14417_n ) capacitor c=0.0131076f \
 //x=67.1 //y=1.09 //x2=71.04 //y2=0.175
cc_7886 ( N_noxref_30_M41_noxref_d N_GND_c_14532_n ) capacitor c=0.0154456f \
 //x=67.1 //y=1.09 //x2=66.315 //y2=1.145
cc_7887 ( N_noxref_30_c_13533_n N_GND_c_14606_n ) capacitor c=0.0091517f \
 //x=68.255 //y=1.175 //x2=69.88 //y2=0.175
cc_7888 ( N_noxref_30_c_13575_p N_GND_c_14606_n ) capacitor c=0.0141583f \
 //x=68.34 //y=0.805 //x2=69.88 //y2=0.175
cc_7889 ( N_noxref_30_c_13549_n N_GND_c_14606_n ) capacitor c=0.0365187f \
 //x=69.225 //y=0.72 //x2=69.88 //y2=0.175
cc_7890 ( N_noxref_30_c_13577_p N_GND_c_14606_n ) capacitor c=0.013886f \
 //x=69.31 //y=0.805 //x2=69.88 //y2=0.175
cc_7891 ( N_noxref_30_M42_noxref_s N_GND_c_14562_n ) capacitor c=8.16352e-19 \
 //x=68.205 //y=0.555 //x2=65.24 //y2=0.175
cc_7892 ( N_noxref_30_c_13577_p N_GND_c_14459_n ) capacitor c=0.037873f \
 //x=69.31 //y=0.805 //x2=70.05 //y2=0.175
cc_7893 ( N_noxref_30_M42_noxref_s N_GND_c_14459_n ) capacitor c=0.0051897f \
 //x=68.205 //y=0.555 //x2=70.05 //y2=0.175
cc_7894 ( N_noxref_30_M41_noxref_d N_GND_M40_noxref_d ) capacitor \
 c=3.12752e-19 //x=67.1 //y=1.09 //x2=66.125 //y2=1.055
cc_7895 ( N_noxref_30_c_13575_p N_noxref_50_c_16478_n ) capacitor \
 c=2.15937e-19 //x=68.34 //y=0.805 //x2=66.8 //y2=0.805
cc_7896 ( N_noxref_30_c_13533_n N_noxref_50_c_16452_n ) capacitor c=0.0130857f \
 //x=68.255 //y=1.175 //x2=67.685 //y2=0.72
cc_7897 ( N_noxref_30_M41_noxref_d N_noxref_50_c_16452_n ) capacitor \
 c=0.0160925f //x=67.1 //y=1.09 //x2=67.685 //y2=0.72
cc_7898 ( N_noxref_30_c_13533_n N_noxref_50_c_16454_n ) capacitor \
 c=0.00944538f //x=68.255 //y=1.175 //x2=67.685 //y2=1.77
cc_7899 ( N_noxref_30_M41_noxref_d N_noxref_50_c_16454_n ) capacitor \
 c=0.0152605f //x=67.1 //y=1.09 //x2=67.685 //y2=1.77
cc_7900 ( N_noxref_30_c_13533_n N_noxref_50_M40_noxref_s ) capacitor \
 c=0.0223986f //x=68.255 //y=1.175 //x2=65.695 //y2=0.555
cc_7901 ( N_noxref_30_c_13575_p N_noxref_50_M40_noxref_s ) capacitor \
 c=0.0175461f //x=68.34 //y=0.805 //x2=65.695 //y2=0.555
cc_7902 ( N_noxref_30_c_13577_p N_noxref_50_M40_noxref_s ) capacitor \
 c=2.98576e-19 //x=69.31 //y=0.805 //x2=65.695 //y2=0.555
cc_7903 ( N_noxref_30_M41_noxref_d N_noxref_50_M40_noxref_s ) capacitor \
 c=0.0187674f //x=67.1 //y=1.09 //x2=65.695 //y2=0.555
cc_7904 ( N_noxref_30_M42_noxref_s N_noxref_50_M40_noxref_s ) capacitor \
 c=0.0210819f //x=68.205 //y=0.555 //x2=65.695 //y2=0.555
cc_7905 ( N_noxref_30_c_13577_p N_noxref_51_M43_noxref_s ) capacitor \
 c=0.00368328f //x=69.31 //y=0.805 //x2=70.505 //y2=0.555
cc_7906 ( N_noxref_30_M42_noxref_s N_noxref_51_M43_noxref_s ) capacitor \
 c=0.00125282f //x=68.205 //y=0.555 //x2=70.505 //y2=0.555
cc_7907 ( N_noxref_31_c_13600_n N_GND_c_14516_n ) capacitor c=0.00533679f \
 //x=73.065 //y=1.175 //x2=75.955 //y2=0.175
cc_7908 ( N_noxref_31_c_13643_p N_GND_c_14516_n ) capacitor c=0.00674195f \
 //x=73.15 //y=0.805 //x2=75.955 //y2=0.175
cc_7909 ( N_noxref_31_c_13617_n N_GND_c_14516_n ) capacitor c=0.0096072f \
 //x=74.035 //y=0.72 //x2=75.955 //y2=0.175
cc_7910 ( N_noxref_31_c_13645_p N_GND_c_14516_n ) capacitor c=0.00232964f \
 //x=74.12 //y=0.805 //x2=75.955 //y2=0.175
cc_7911 ( N_noxref_31_M44_noxref_d N_GND_c_14516_n ) capacitor c=0.0130717f \
 //x=71.91 //y=1.09 //x2=75.955 //y2=0.175
cc_7912 ( N_noxref_31_M44_noxref_d N_GND_c_14439_n ) capacitor c=0.0154456f \
 //x=71.91 //y=1.09 //x2=71.125 //y2=1.145
cc_7913 ( N_noxref_31_c_13600_n N_GND_c_14451_n ) capacitor c=0.0080792f \
 //x=73.065 //y=1.175 //x2=74.69 //y2=0.175
cc_7914 ( N_noxref_31_c_13643_p N_GND_c_14451_n ) capacitor c=0.0140604f \
 //x=73.15 //y=0.805 //x2=74.69 //y2=0.175
cc_7915 ( N_noxref_31_c_13617_n N_GND_c_14451_n ) capacitor c=0.0364637f \
 //x=74.035 //y=0.72 //x2=74.69 //y2=0.175
cc_7916 ( N_noxref_31_c_13645_p N_GND_c_14451_n ) capacitor c=0.013886f \
 //x=74.12 //y=0.805 //x2=74.69 //y2=0.175
cc_7917 ( N_noxref_31_M45_noxref_s N_GND_c_14459_n ) capacitor c=8.16352e-19 \
 //x=73.015 //y=0.555 //x2=70.05 //y2=0.175
cc_7918 ( N_noxref_31_c_13645_p N_GND_c_14620_n ) capacitor c=0.0374312f \
 //x=74.12 //y=0.805 //x2=74.86 //y2=0.175
cc_7919 ( N_noxref_31_M45_noxref_s N_GND_c_14620_n ) capacitor c=0.00519576f \
 //x=73.015 //y=0.555 //x2=74.86 //y2=0.175
cc_7920 ( N_noxref_31_M44_noxref_d N_GND_M43_noxref_d ) capacitor \
 c=3.12752e-19 //x=71.91 //y=1.09 //x2=70.935 //y2=1.055
cc_7921 ( N_noxref_31_c_13643_p N_noxref_51_c_16539_n ) capacitor \
 c=2.15937e-19 //x=73.15 //y=0.805 //x2=71.61 //y2=0.805
cc_7922 ( N_noxref_31_c_13600_n N_noxref_51_c_16524_n ) capacitor c=0.0131328f \
 //x=73.065 //y=1.175 //x2=72.495 //y2=0.72
cc_7923 ( N_noxref_31_M44_noxref_d N_noxref_51_c_16524_n ) capacitor \
 c=0.0160925f //x=71.91 //y=1.09 //x2=72.495 //y2=0.72
cc_7924 ( N_noxref_31_c_13600_n N_noxref_51_c_16526_n ) capacitor \
 c=0.00950231f //x=73.065 //y=1.175 //x2=72.495 //y2=1.77
cc_7925 ( N_noxref_31_M44_noxref_d N_noxref_51_c_16526_n ) capacitor \
 c=0.014937f //x=71.91 //y=1.09 //x2=72.495 //y2=1.77
cc_7926 ( N_noxref_31_c_13600_n N_noxref_51_M43_noxref_s ) capacitor \
 c=0.0226963f //x=73.065 //y=1.175 //x2=70.505 //y2=0.555
cc_7927 ( N_noxref_31_c_13643_p N_noxref_51_M43_noxref_s ) capacitor \
 c=0.0175532f //x=73.15 //y=0.805 //x2=70.505 //y2=0.555
cc_7928 ( N_noxref_31_c_13645_p N_noxref_51_M43_noxref_s ) capacitor \
 c=2.98721e-19 //x=74.12 //y=0.805 //x2=70.505 //y2=0.555
cc_7929 ( N_noxref_31_M44_noxref_d N_noxref_51_M43_noxref_s ) capacitor \
 c=0.0187685f //x=71.91 //y=1.09 //x2=70.505 //y2=0.555
cc_7930 ( N_noxref_31_M45_noxref_s N_noxref_51_M43_noxref_s ) capacitor \
 c=0.021082f //x=73.015 //y=0.555 //x2=70.505 //y2=0.555
cc_7931 ( N_noxref_31_c_13645_p N_noxref_52_M46_noxref_s ) capacitor \
 c=0.00370912f //x=74.12 //y=0.805 //x2=75.42 //y2=0.545
cc_7932 ( N_noxref_31_M45_noxref_s N_noxref_52_M46_noxref_s ) capacitor \
 c=0.00101401f //x=73.015 //y=0.555 //x2=75.42 //y2=0.545
cc_7933 ( N_noxref_32_c_13674_n N_noxref_33_c_13828_n ) capacitor \
 c=0.00321697f //x=83.06 //y=7.09 //x2=83.505 //y2=5.39
cc_7934 ( N_noxref_32_c_13696_n N_noxref_33_c_13828_n ) capacitor \
 c=0.00331901f //x=83.945 //y=7.09 //x2=83.505 //y2=5.39
cc_7935 ( N_noxref_32_c_13685_n N_noxref_33_c_13828_n ) capacitor c=0.0047685f \
 //x=83.177 //y=7.09 //x2=83.505 //y2=5.39
cc_7936 ( N_noxref_32_M155_noxref_d N_noxref_33_c_13828_n ) capacitor \
 c=0.00678641f //x=83.035 //y=5.205 //x2=83.505 //y2=5.39
cc_7937 ( N_noxref_32_c_13696_n N_noxref_33_c_13841_n ) capacitor \
 c=0.00331329f //x=83.945 //y=7.09 //x2=85.525 //y2=5.39
cc_7938 ( N_noxref_32_c_13699_n N_noxref_33_c_13841_n ) capacitor \
 c=0.00465918f //x=84.06 //y=6.92 //x2=85.525 //y2=5.39
cc_7939 ( N_noxref_32_M157_noxref_d N_noxref_33_c_13841_n ) capacitor \
 c=0.00491419f //x=83.915 //y=5.205 //x2=85.525 //y2=5.39
cc_7940 ( N_noxref_32_c_13670_n N_noxref_33_c_13852_n ) capacitor c=9.81e-19 \
 //x=82.185 //y=5.39 //x2=83.735 //y2=5.39
cc_7941 ( N_noxref_32_c_13696_n N_noxref_33_c_13852_n ) capacitor \
 c=0.00460276f //x=83.945 //y=7.09 //x2=83.735 //y2=5.39
cc_7942 ( N_noxref_32_c_13670_n N_noxref_33_c_13829_n ) capacitor c=0.033638f \
 //x=82.185 //y=5.39 //x2=82.74 //y2=5.39
cc_7943 ( N_noxref_32_c_13674_n N_noxref_33_c_13829_n ) capacitor c=0.0048075f \
 //x=83.06 //y=7.09 //x2=82.74 //y2=5.39
cc_7944 ( N_noxref_32_c_13680_n N_noxref_33_c_13829_n ) capacitor \
 c=0.00241473f //x=79.422 //y=5.39 //x2=82.74 //y2=5.39
cc_7945 ( N_noxref_32_c_13690_n N_noxref_33_c_13829_n ) capacitor c=0.0100239f \
 //x=82.3 //y=5.39 //x2=82.74 //y2=5.39
cc_7946 ( N_noxref_32_c_13685_n N_noxref_33_c_13856_n ) capacitor \
 c=2.01993e-19 //x=83.177 //y=7.09 //x2=85.64 //y2=6.92
cc_7947 ( N_noxref_32_c_13699_n N_noxref_33_c_13856_n ) capacitor c=0.0130503f \
 //x=84.06 //y=6.92 //x2=85.64 //y2=6.92
cc_7948 ( N_noxref_32_c_13699_n N_noxref_33_c_13857_n ) capacitor \
 c=2.01769e-19 //x=84.06 //y=6.92 //x2=86.52 //y2=7.09
cc_7949 ( N_noxref_32_c_13670_n N_noxref_33_c_13835_n ) capacitor \
 c=0.00238961f //x=82.185 //y=5.39 //x2=82.74 //y2=5.56
cc_7950 ( N_noxref_32_c_13674_n N_noxref_33_c_13835_n ) capacitor \
 c=0.00406191f //x=83.06 //y=7.09 //x2=82.74 //y2=5.56
cc_7951 ( N_noxref_32_c_13690_n N_noxref_33_c_13835_n ) capacitor c=0.0651197f \
 //x=82.3 //y=5.39 //x2=82.74 //y2=5.56
cc_7952 ( N_noxref_32_M155_noxref_d N_noxref_33_c_13835_n ) capacitor \
 c=0.0479141f //x=83.035 //y=5.205 //x2=82.74 //y2=5.56
cc_7953 ( N_noxref_32_c_13670_n N_noxref_33_c_13858_n ) capacitor \
 c=5.61108e-19 //x=82.185 //y=5.39 //x2=83.62 //y2=5.39
cc_7954 ( N_noxref_32_c_13696_n N_noxref_33_c_13858_n ) capacitor \
 c=0.00424767f //x=83.945 //y=7.09 //x2=83.62 //y2=5.39
cc_7955 ( N_noxref_32_c_13690_n N_noxref_33_c_13858_n ) capacitor \
 c=0.00287683f //x=82.3 //y=5.39 //x2=83.62 //y2=5.39
cc_7956 ( N_noxref_32_M155_noxref_d N_noxref_33_c_13858_n ) capacitor \
 c=0.0479141f //x=83.035 //y=5.205 //x2=83.62 //y2=5.39
cc_7957 ( N_noxref_32_M157_noxref_d N_noxref_33_c_13858_n ) capacitor \
 c=0.0479025f //x=83.915 //y=5.205 //x2=83.62 //y2=5.39
cc_7958 ( N_noxref_32_M157_noxref_d N_noxref_33_c_13861_n ) capacitor \
 c=0.00143256f //x=83.915 //y=5.205 //x2=85.64 //y2=5.39
cc_7959 ( N_noxref_32_c_13680_n N_GND_c_14661_n ) capacitor c=0.00115718f \
 //x=79.422 //y=5.39 //x2=79.37 //y2=1.015
cc_7960 ( N_noxref_32_c_13670_n N_GND_c_14750_n ) capacitor c=0.00146427f \
 //x=82.185 //y=5.39 //x2=81.52 //y2=0.175
cc_7961 ( N_noxref_32_c_13690_n N_noxref_54_c_16704_n ) capacitor \
 c=0.00110355f //x=82.3 //y=5.39 //x2=82.215 //y2=1.675
cc_7962 ( N_noxref_33_c_13829_n N_GND_c_14668_n ) capacitor c=2.11163e-19 \
 //x=82.74 //y=5.39 //x2=82.7 //y2=1.015
cc_7963 ( N_noxref_33_c_13841_n N_GND_c_14831_n ) capacitor c=0.00146427f \
 //x=85.525 //y=5.39 //x2=84.85 //y2=0.175
cc_7964 ( N_GND_c_15106_p N_noxref_35_c_15536_n ) capacitor c=0.00293992f \
 //x=1.48 //y=0.175 //x2=1.965 //y2=1.77
cc_7965 ( N_GND_c_13951_n N_noxref_35_c_15536_n ) capacitor c=7.0078e-19 \
 //x=6.29 //y=0.175 //x2=1.965 //y2=1.77
cc_7966 ( N_GND_c_14106_n N_noxref_35_c_15536_n ) capacitor c=0.00377523f \
 //x=1.565 //y=1.145 //x2=1.965 //y2=1.77
cc_7967 ( N_GND_c_13970_n N_noxref_35_c_15536_n ) capacitor c=0.00371813f \
 //x=5.13 //y=0.175 //x2=1.965 //y2=1.77
cc_7968 ( N_GND_M0_noxref_d N_noxref_35_c_15536_n ) capacitor c=0.00578031f \
 //x=1.375 //y=1.055 //x2=1.965 //y2=1.77
cc_7969 ( N_GND_c_14094_n N_noxref_35_c_15560_n ) capacitor c=0.0169052f \
 //x=1.565 //y=1.015 //x2=2.05 //y2=0.805
cc_7970 ( N_GND_c_13951_n N_noxref_35_c_15560_n ) capacitor c=0.00710913f \
 //x=6.29 //y=0.175 //x2=2.05 //y2=0.805
cc_7971 ( N_GND_c_13970_n N_noxref_35_c_15560_n ) capacitor c=0.0140604f \
 //x=5.13 //y=0.175 //x2=2.05 //y2=0.805
cc_7972 ( N_GND_c_14132_n N_noxref_35_c_15560_n ) capacitor c=0.00323118f \
 //x=1.23 //y=0.18 //x2=2.05 //y2=0.805
cc_7973 ( N_GND_c_13951_n N_noxref_35_c_15550_n ) capacitor c=0.0138621f \
 //x=6.29 //y=0.175 //x2=2.935 //y2=0.72
cc_7974 ( N_GND_c_13970_n N_noxref_35_c_15550_n ) capacitor c=0.0356451f \
 //x=5.13 //y=0.175 //x2=2.935 //y2=0.72
cc_7975 ( N_GND_c_15106_p N_noxref_35_M0_noxref_s ) capacitor c=0.00710913f \
 //x=1.48 //y=0.175 //x2=0.945 //y2=0.555
cc_7976 ( N_GND_c_14094_n N_noxref_35_M0_noxref_s ) capacitor c=0.0173062f \
 //x=1.565 //y=1.015 //x2=0.945 //y2=0.555
cc_7977 ( N_GND_c_13951_n N_noxref_35_M0_noxref_s ) capacitor c=0.00683407f \
 //x=6.29 //y=0.175 //x2=0.945 //y2=0.555
cc_7978 ( N_GND_c_14106_n N_noxref_35_M0_noxref_s ) capacitor c=0.0113024f \
 //x=1.565 //y=1.145 //x2=0.945 //y2=0.555
cc_7979 ( N_GND_c_13970_n N_noxref_35_M0_noxref_s ) capacitor c=0.0272246f \
 //x=5.13 //y=0.175 //x2=0.945 //y2=0.555
cc_7980 ( N_GND_c_14132_n N_noxref_35_M0_noxref_s ) capacitor c=0.0675506f \
 //x=1.23 //y=0.18 //x2=0.945 //y2=0.555
cc_7981 ( N_GND_c_13974_n N_noxref_35_M0_noxref_s ) capacitor c=0.00166413f \
 //x=5.3 //y=0.175 //x2=0.945 //y2=0.555
cc_7982 ( N_GND_M0_noxref_d N_noxref_35_M0_noxref_s ) capacitor c=0.0271316f \
 //x=1.375 //y=1.055 //x2=0.945 //y2=0.555
cc_7983 ( N_GND_c_13951_n N_noxref_36_c_15590_n ) capacitor c=0.0011329f \
 //x=6.29 //y=0.175 //x2=6.775 //y2=1.77
cc_7984 ( N_GND_c_13952_n N_noxref_36_c_15590_n ) capacitor c=6.68055e-19 \
 //x=11.205 //y=0.175 //x2=6.775 //y2=1.77
cc_7985 ( N_GND_c_13956_n N_noxref_36_c_15590_n ) capacitor c=0.00375838f \
 //x=6.375 //y=1.145 //x2=6.775 //y2=1.77
cc_7986 ( N_GND_c_13971_n N_noxref_36_c_15590_n ) capacitor c=0.0038933f \
 //x=9.94 //y=0.175 //x2=6.775 //y2=1.77
cc_7987 ( N_GND_M3_noxref_d N_noxref_36_c_15590_n ) capacitor c=0.00578031f \
 //x=6.185 //y=1.055 //x2=6.775 //y2=1.77
cc_7988 ( N_GND_c_14037_n N_noxref_36_c_15620_n ) capacitor c=0.0169052f \
 //x=6.375 //y=1.015 //x2=6.86 //y2=0.805
cc_7989 ( N_GND_c_13952_n N_noxref_36_c_15620_n ) capacitor c=0.00710913f \
 //x=11.205 //y=0.175 //x2=6.86 //y2=0.805
cc_7990 ( N_GND_c_13971_n N_noxref_36_c_15620_n ) capacitor c=0.0140604f \
 //x=9.94 //y=0.175 //x2=6.86 //y2=0.805
cc_7991 ( N_GND_c_13974_n N_noxref_36_c_15620_n ) capacitor c=0.00322478f \
 //x=5.3 //y=0.175 //x2=6.86 //y2=0.805
cc_7992 ( N_GND_c_13952_n N_noxref_36_c_15606_n ) capacitor c=0.0124874f \
 //x=11.205 //y=0.175 //x2=7.745 //y2=0.72
cc_7993 ( N_GND_c_13971_n N_noxref_36_c_15606_n ) capacitor c=0.0358909f \
 //x=9.94 //y=0.175 //x2=7.745 //y2=0.72
cc_7994 ( N_GND_c_13951_n N_noxref_36_M3_noxref_s ) capacitor c=0.00710913f \
 //x=6.29 //y=0.175 //x2=5.755 //y2=0.555
cc_7995 ( N_GND_c_14037_n N_noxref_36_M3_noxref_s ) capacitor c=0.0173062f \
 //x=6.375 //y=1.015 //x2=5.755 //y2=0.555
cc_7996 ( N_GND_c_13952_n N_noxref_36_M3_noxref_s ) capacitor c=0.00402659f \
 //x=11.205 //y=0.175 //x2=5.755 //y2=0.555
cc_7997 ( N_GND_c_13956_n N_noxref_36_M3_noxref_s ) capacitor c=0.00988958f \
 //x=6.375 //y=1.145 //x2=5.755 //y2=0.555
cc_7998 ( N_GND_c_13971_n N_noxref_36_M3_noxref_s ) capacitor c=0.0273355f \
 //x=9.94 //y=0.175 //x2=5.755 //y2=0.555
cc_7999 ( N_GND_c_13974_n N_noxref_36_M3_noxref_s ) capacitor c=0.0634633f \
 //x=5.3 //y=0.175 //x2=5.755 //y2=0.555
cc_8000 ( N_GND_c_13977_n N_noxref_36_M3_noxref_s ) capacitor c=0.00166451f \
 //x=10.11 //y=0.175 //x2=5.755 //y2=0.555
cc_8001 ( N_GND_M3_noxref_d N_noxref_36_M3_noxref_s ) capacitor c=0.0271316f \
 //x=6.185 //y=1.055 //x2=5.755 //y2=0.555
cc_8002 ( N_GND_c_13952_n N_noxref_37_c_15650_n ) capacitor c=9.79596e-19 \
 //x=11.205 //y=0.175 //x2=11.69 //y2=1.76
cc_8003 ( N_GND_c_13992_n N_noxref_37_c_15650_n ) capacitor c=7.45647e-19 \
 //x=14.43 //y=0.175 //x2=11.69 //y2=1.76
cc_8004 ( N_GND_c_13957_n N_noxref_37_c_15650_n ) capacitor c=0.00398656f \
 //x=11.29 //y=1.135 //x2=11.69 //y2=1.76
cc_8005 ( N_GND_c_13973_n N_noxref_37_c_15650_n ) capacitor c=0.00395774f \
 //x=13.27 //y=0.175 //x2=11.69 //y2=1.76
cc_8006 ( N_GND_M6_noxref_d N_noxref_37_c_15650_n ) capacitor c=0.00578453f \
 //x=11.1 //y=1.045 //x2=11.69 //y2=1.76
cc_8007 ( N_GND_c_13992_n N_noxref_37_c_15695_n ) capacitor c=0.00310334f \
 //x=14.43 //y=0.175 //x2=11.775 //y2=0.795
cc_8008 ( N_GND_c_13967_n N_noxref_37_c_15695_n ) capacitor c=0.0119573f \
 //x=11.287 //y=1.005 //x2=11.775 //y2=0.795
cc_8009 ( N_GND_c_13973_n N_noxref_37_c_15695_n ) capacitor c=0.0147548f \
 //x=13.27 //y=0.175 //x2=11.775 //y2=0.795
cc_8010 ( N_GND_c_13977_n N_noxref_37_c_15695_n ) capacitor c=0.00282583f \
 //x=10.11 //y=0.175 //x2=11.775 //y2=0.795
cc_8011 ( N_GND_c_14017_n N_noxref_37_c_15695_n ) capacitor c=2.99181e-19 \
 //x=13.44 //y=0.175 //x2=11.775 //y2=0.795
cc_8012 ( N_GND_c_13977_n N_noxref_37_c_15657_n ) capacitor c=2.8386e-19 \
 //x=10.11 //y=0.175 //x2=11.775 //y2=1.675
cc_8013 ( N_GND_c_13992_n N_noxref_37_c_15662_n ) capacitor c=0.0098961f \
 //x=14.43 //y=0.175 //x2=12.66 //y2=0.71
cc_8014 ( N_GND_c_13973_n N_noxref_37_c_15662_n ) capacitor c=0.0374802f \
 //x=13.27 //y=0.175 //x2=12.66 //y2=0.71
cc_8015 ( N_GND_c_13992_n N_noxref_37_c_15703_n ) capacitor c=0.00250941f \
 //x=14.43 //y=0.175 //x2=12.745 //y2=0.795
cc_8016 ( N_GND_c_13973_n N_noxref_37_c_15703_n ) capacitor c=0.0145307f \
 //x=13.27 //y=0.175 //x2=12.745 //y2=0.795
cc_8017 ( N_GND_c_14017_n N_noxref_37_c_15703_n ) capacitor c=0.0396774f \
 //x=13.44 //y=0.175 //x2=12.745 //y2=0.795
cc_8018 ( N_GND_c_13952_n N_noxref_37_M6_noxref_s ) capacitor c=0.0045077f \
 //x=11.205 //y=0.175 //x2=10.67 //y2=0.545
cc_8019 ( N_GND_c_13957_n N_noxref_37_M6_noxref_s ) capacitor c=0.0100945f \
 //x=11.29 //y=1.135 //x2=10.67 //y2=0.545
cc_8020 ( N_GND_c_13967_n N_noxref_37_M6_noxref_s ) capacitor c=0.0170608f \
 //x=11.287 //y=1.005 //x2=10.67 //y2=0.545
cc_8021 ( N_GND_c_13973_n N_noxref_37_M6_noxref_s ) capacitor c=0.0147643f \
 //x=13.27 //y=0.175 //x2=10.67 //y2=0.545
cc_8022 ( N_GND_c_13977_n N_noxref_37_M6_noxref_s ) capacitor c=0.0528206f \
 //x=10.11 //y=0.175 //x2=10.67 //y2=0.545
cc_8023 ( N_GND_c_14017_n N_noxref_37_M6_noxref_s ) capacitor c=0.00648063f \
 //x=13.44 //y=0.175 //x2=10.67 //y2=0.545
cc_8024 ( N_GND_M6_noxref_d N_noxref_37_M6_noxref_s ) capacitor c=0.0271276f \
 //x=11.1 //y=1.045 //x2=10.67 //y2=0.545
cc_8025 ( N_GND_c_13992_n N_noxref_38_c_15717_n ) capacitor c=0.0011329f \
 //x=14.43 //y=0.175 //x2=14.915 //y2=1.77
cc_8026 ( N_GND_c_14098_n N_noxref_38_c_15717_n ) capacitor c=7.40908e-19 \
 //x=19.24 //y=0.175 //x2=14.915 //y2=1.77
cc_8027 ( N_GND_c_14002_n N_noxref_38_c_15717_n ) capacitor c=0.00365894f \
 //x=14.515 //y=1.145 //x2=14.915 //y2=1.77
cc_8028 ( N_GND_c_14015_n N_noxref_38_c_15717_n ) capacitor c=0.00392232f \
 //x=18.08 //y=0.175 //x2=14.915 //y2=1.77
cc_8029 ( N_GND_M8_noxref_d N_noxref_38_c_15717_n ) capacitor c=0.00578031f \
 //x=14.325 //y=1.055 //x2=14.915 //y2=1.77
cc_8030 ( N_GND_c_13996_n N_noxref_38_c_15742_n ) capacitor c=0.0169052f \
 //x=14.515 //y=1.015 //x2=15 //y2=0.805
cc_8031 ( N_GND_c_14098_n N_noxref_38_c_15742_n ) capacitor c=0.00439789f \
 //x=19.24 //y=0.175 //x2=15 //y2=0.805
cc_8032 ( N_GND_c_14015_n N_noxref_38_c_15742_n ) capacitor c=0.0141638f \
 //x=18.08 //y=0.175 //x2=15 //y2=0.805
cc_8033 ( N_GND_c_14017_n N_noxref_38_c_15742_n ) capacitor c=0.00322442f \
 //x=13.44 //y=0.175 //x2=15 //y2=0.805
cc_8034 ( N_GND_c_14098_n N_noxref_38_c_15728_n ) capacitor c=0.0124364f \
 //x=19.24 //y=0.175 //x2=15.885 //y2=0.72
cc_8035 ( N_GND_c_14015_n N_noxref_38_c_15728_n ) capacitor c=0.0361346f \
 //x=18.08 //y=0.175 //x2=15.885 //y2=0.72
cc_8036 ( N_GND_c_13992_n N_noxref_38_M8_noxref_s ) capacitor c=0.00439789f \
 //x=14.43 //y=0.175 //x2=13.895 //y2=0.555
cc_8037 ( N_GND_c_13996_n N_noxref_38_M8_noxref_s ) capacitor c=0.0125586f \
 //x=14.515 //y=1.015 //x2=13.895 //y2=0.555
cc_8038 ( N_GND_c_14098_n N_noxref_38_M8_noxref_s ) capacitor c=0.0044479f \
 //x=19.24 //y=0.175 //x2=13.895 //y2=0.555
cc_8039 ( N_GND_c_14002_n N_noxref_38_M8_noxref_s ) capacitor c=0.00972044f \
 //x=14.515 //y=1.145 //x2=13.895 //y2=0.555
cc_8040 ( N_GND_c_14015_n N_noxref_38_M8_noxref_s ) capacitor c=0.0273693f \
 //x=18.08 //y=0.175 //x2=13.895 //y2=0.555
cc_8041 ( N_GND_c_14017_n N_noxref_38_M8_noxref_s ) capacitor c=0.0624873f \
 //x=13.44 //y=0.175 //x2=13.895 //y2=0.555
cc_8042 ( N_GND_c_14074_n N_noxref_38_M8_noxref_s ) capacitor c=0.00166413f \
 //x=18.25 //y=0.175 //x2=13.895 //y2=0.555
cc_8043 ( N_GND_M8_noxref_d N_noxref_38_M8_noxref_s ) capacitor c=0.0271316f \
 //x=14.325 //y=1.055 //x2=13.895 //y2=0.555
cc_8044 ( N_GND_c_14098_n N_noxref_39_c_15775_n ) capacitor c=0.0011329f \
 //x=19.24 //y=0.175 //x2=19.725 //y2=1.77
cc_8045 ( N_GND_c_14101_n N_noxref_39_c_15775_n ) capacitor c=7.40908e-19 \
 //x=24.155 //y=0.175 //x2=19.725 //y2=1.77
cc_8046 ( N_GND_c_14054_n N_noxref_39_c_15775_n ) capacitor c=0.00371075f \
 //x=19.325 //y=1.145 //x2=19.725 //y2=1.77
cc_8047 ( N_GND_c_14066_n N_noxref_39_c_15775_n ) capacitor c=0.00392232f \
 //x=22.89 //y=0.175 //x2=19.725 //y2=1.77
cc_8048 ( N_GND_M11_noxref_d N_noxref_39_c_15775_n ) capacitor c=0.00578031f \
 //x=19.135 //y=1.055 //x2=19.725 //y2=1.77
cc_8049 ( N_GND_c_14040_n N_noxref_39_c_15803_n ) capacitor c=0.0169052f \
 //x=19.325 //y=1.015 //x2=19.81 //y2=0.805
cc_8050 ( N_GND_c_14101_n N_noxref_39_c_15803_n ) capacitor c=0.00439789f \
 //x=24.155 //y=0.175 //x2=19.81 //y2=0.805
cc_8051 ( N_GND_c_14066_n N_noxref_39_c_15803_n ) capacitor c=0.0141638f \
 //x=22.89 //y=0.175 //x2=19.81 //y2=0.805
cc_8052 ( N_GND_c_14074_n N_noxref_39_c_15803_n ) capacitor c=0.00322478f \
 //x=18.25 //y=0.175 //x2=19.81 //y2=0.805
cc_8053 ( N_GND_c_14101_n N_noxref_39_c_15788_n ) capacitor c=0.0126556f \
 //x=24.155 //y=0.175 //x2=20.695 //y2=0.72
cc_8054 ( N_GND_c_14066_n N_noxref_39_c_15788_n ) capacitor c=0.0361346f \
 //x=22.89 //y=0.175 //x2=20.695 //y2=0.72
cc_8055 ( N_GND_c_14098_n N_noxref_39_M11_noxref_s ) capacitor c=0.00439789f \
 //x=19.24 //y=0.175 //x2=18.705 //y2=0.555
cc_8056 ( N_GND_c_14040_n N_noxref_39_M11_noxref_s ) capacitor c=0.0173062f \
 //x=19.325 //y=1.015 //x2=18.705 //y2=0.555
cc_8057 ( N_GND_c_14101_n N_noxref_39_M11_noxref_s ) capacitor c=0.0044479f \
 //x=24.155 //y=0.175 //x2=18.705 //y2=0.555
cc_8058 ( N_GND_c_14054_n N_noxref_39_M11_noxref_s ) capacitor c=0.00988958f \
 //x=19.325 //y=1.145 //x2=18.705 //y2=0.555
cc_8059 ( N_GND_c_14066_n N_noxref_39_M11_noxref_s ) capacitor c=0.0273693f \
 //x=22.89 //y=0.175 //x2=18.705 //y2=0.555
cc_8060 ( N_GND_c_14074_n N_noxref_39_M11_noxref_s ) capacitor c=0.0634633f \
 //x=18.25 //y=0.175 //x2=18.705 //y2=0.555
cc_8061 ( N_GND_c_14147_n N_noxref_39_M11_noxref_s ) capacitor c=0.00166451f \
 //x=23.06 //y=0.175 //x2=18.705 //y2=0.555
cc_8062 ( N_GND_M11_noxref_d N_noxref_39_M11_noxref_s ) capacitor c=0.0271316f \
 //x=19.135 //y=1.055 //x2=18.705 //y2=0.555
cc_8063 ( N_GND_c_14101_n N_noxref_40_c_15833_n ) capacitor c=9.98096e-19 \
 //x=24.155 //y=0.175 //x2=24.64 //y2=1.76
cc_8064 ( N_GND_c_14105_n N_noxref_40_c_15833_n ) capacitor c=7.45647e-19 \
 //x=27.38 //y=0.175 //x2=24.64 //y2=1.76
cc_8065 ( N_GND_c_14117_n N_noxref_40_c_15833_n ) capacitor c=0.00400688f \
 //x=24.24 //y=1.135 //x2=24.64 //y2=1.76
cc_8066 ( N_GND_c_14140_n N_noxref_40_c_15833_n ) capacitor c=0.00395774f \
 //x=26.22 //y=0.175 //x2=24.64 //y2=1.76
cc_8067 ( N_GND_M14_noxref_d N_noxref_40_c_15833_n ) capacitor c=0.00578453f \
 //x=24.05 //y=1.045 //x2=24.64 //y2=1.76
cc_8068 ( N_GND_c_14105_n N_noxref_40_c_15878_n ) capacitor c=0.00310216f \
 //x=27.38 //y=0.175 //x2=24.725 //y2=0.795
cc_8069 ( N_GND_c_14128_n N_noxref_40_c_15878_n ) capacitor c=0.0119573f \
 //x=24.237 //y=1.005 //x2=24.725 //y2=0.795
cc_8070 ( N_GND_c_14140_n N_noxref_40_c_15878_n ) capacitor c=0.0147548f \
 //x=26.22 //y=0.175 //x2=24.725 //y2=0.795
cc_8071 ( N_GND_c_14147_n N_noxref_40_c_15878_n ) capacitor c=0.00282583f \
 //x=23.06 //y=0.175 //x2=24.725 //y2=0.795
cc_8072 ( N_GND_c_14154_n N_noxref_40_c_15878_n ) capacitor c=2.99181e-19 \
 //x=26.39 //y=0.175 //x2=24.725 //y2=0.795
cc_8073 ( N_GND_c_14147_n N_noxref_40_c_15840_n ) capacitor c=2.8386e-19 \
 //x=23.06 //y=0.175 //x2=24.725 //y2=1.675
cc_8074 ( N_GND_c_14105_n N_noxref_40_c_15845_n ) capacitor c=0.00998636f \
 //x=27.38 //y=0.175 //x2=25.61 //y2=0.71
cc_8075 ( N_GND_c_14140_n N_noxref_40_c_15845_n ) capacitor c=0.0374812f \
 //x=26.22 //y=0.175 //x2=25.61 //y2=0.71
cc_8076 ( N_GND_c_14105_n N_noxref_40_c_15886_n ) capacitor c=0.00248212f \
 //x=27.38 //y=0.175 //x2=25.695 //y2=0.795
cc_8077 ( N_GND_c_14140_n N_noxref_40_c_15886_n ) capacitor c=0.0145307f \
 //x=26.22 //y=0.175 //x2=25.695 //y2=0.795
cc_8078 ( N_GND_c_14154_n N_noxref_40_c_15886_n ) capacitor c=0.0396774f \
 //x=26.39 //y=0.175 //x2=25.695 //y2=0.795
cc_8079 ( N_GND_c_14101_n N_noxref_40_M14_noxref_s ) capacitor c=0.0045077f \
 //x=24.155 //y=0.175 //x2=23.62 //y2=0.545
cc_8080 ( N_GND_c_14117_n N_noxref_40_M14_noxref_s ) capacitor c=0.0100945f \
 //x=24.24 //y=1.135 //x2=23.62 //y2=0.545
cc_8081 ( N_GND_c_14128_n N_noxref_40_M14_noxref_s ) capacitor c=0.0170608f \
 //x=24.237 //y=1.005 //x2=23.62 //y2=0.545
cc_8082 ( N_GND_c_14140_n N_noxref_40_M14_noxref_s ) capacitor c=0.0147643f \
 //x=26.22 //y=0.175 //x2=23.62 //y2=0.545
cc_8083 ( N_GND_c_14147_n N_noxref_40_M14_noxref_s ) capacitor c=0.0528206f \
 //x=23.06 //y=0.175 //x2=23.62 //y2=0.545
cc_8084 ( N_GND_c_14154_n N_noxref_40_M14_noxref_s ) capacitor c=0.00648063f \
 //x=26.39 //y=0.175 //x2=23.62 //y2=0.545
cc_8085 ( N_GND_M14_noxref_d N_noxref_40_M14_noxref_s ) capacitor c=0.0271276f \
 //x=24.05 //y=1.045 //x2=23.62 //y2=0.545
cc_8086 ( N_GND_c_14105_n N_noxref_41_c_15900_n ) capacitor c=0.0011329f \
 //x=27.38 //y=0.175 //x2=27.865 //y2=1.77
cc_8087 ( N_GND_c_14171_n N_noxref_41_c_15900_n ) capacitor c=6.72491e-19 \
 //x=32.19 //y=0.175 //x2=27.865 //y2=1.77
cc_8088 ( N_GND_c_14351_n N_noxref_41_c_15900_n ) capacitor c=0.00377523f \
 //x=27.465 //y=1.145 //x2=27.865 //y2=1.77
cc_8089 ( N_GND_c_14189_n N_noxref_41_c_15900_n ) capacitor c=0.00392232f \
 //x=31.03 //y=0.175 //x2=27.865 //y2=1.77
cc_8090 ( N_GND_M16_noxref_d N_noxref_41_c_15900_n ) capacitor c=0.00578031f \
 //x=27.275 //y=1.055 //x2=27.865 //y2=1.77
cc_8091 ( N_GND_c_14343_n N_noxref_41_c_15925_n ) capacitor c=0.0169052f \
 //x=27.465 //y=1.015 //x2=27.95 //y2=0.805
cc_8092 ( N_GND_c_14171_n N_noxref_41_c_15925_n ) capacitor c=0.00439789f \
 //x=32.19 //y=0.175 //x2=27.95 //y2=0.805
cc_8093 ( N_GND_c_14189_n N_noxref_41_c_15925_n ) capacitor c=0.0141638f \
 //x=31.03 //y=0.175 //x2=27.95 //y2=0.805
cc_8094 ( N_GND_c_14154_n N_noxref_41_c_15925_n ) capacitor c=0.00322442f \
 //x=26.39 //y=0.175 //x2=27.95 //y2=0.805
cc_8095 ( N_GND_c_14171_n N_noxref_41_c_15911_n ) capacitor c=0.0124416f \
 //x=32.19 //y=0.175 //x2=28.835 //y2=0.72
cc_8096 ( N_GND_c_14189_n N_noxref_41_c_15911_n ) capacitor c=0.0361346f \
 //x=31.03 //y=0.175 //x2=28.835 //y2=0.72
cc_8097 ( N_GND_c_14105_n N_noxref_41_M16_noxref_s ) capacitor c=0.00439789f \
 //x=27.38 //y=0.175 //x2=26.845 //y2=0.555
cc_8098 ( N_GND_c_14343_n N_noxref_41_M16_noxref_s ) capacitor c=0.0125586f \
 //x=27.465 //y=1.015 //x2=26.845 //y2=0.555
cc_8099 ( N_GND_c_14171_n N_noxref_41_M16_noxref_s ) capacitor c=0.0044479f \
 //x=32.19 //y=0.175 //x2=26.845 //y2=0.555
cc_8100 ( N_GND_c_14351_n N_noxref_41_M16_noxref_s ) capacitor c=0.00972044f \
 //x=27.465 //y=1.145 //x2=26.845 //y2=0.555
cc_8101 ( N_GND_c_14189_n N_noxref_41_M16_noxref_s ) capacitor c=0.0273693f \
 //x=31.03 //y=0.175 //x2=26.845 //y2=0.555
cc_8102 ( N_GND_c_14154_n N_noxref_41_M16_noxref_s ) capacitor c=0.0624873f \
 //x=26.39 //y=0.175 //x2=26.845 //y2=0.555
cc_8103 ( N_GND_c_14193_n N_noxref_41_M16_noxref_s ) capacitor c=0.00166413f \
 //x=31.2 //y=0.175 //x2=26.845 //y2=0.555
cc_8104 ( N_GND_M16_noxref_d N_noxref_41_M16_noxref_s ) capacitor c=0.0271316f \
 //x=27.275 //y=1.055 //x2=26.845 //y2=0.555
cc_8105 ( N_GND_c_14171_n N_noxref_42_c_15958_n ) capacitor c=0.0011329f \
 //x=32.19 //y=0.175 //x2=32.675 //y2=1.77
cc_8106 ( N_GND_c_14172_n N_noxref_42_c_15958_n ) capacitor c=6.68055e-19 \
 //x=37.105 //y=0.175 //x2=32.675 //y2=1.77
cc_8107 ( N_GND_c_14260_n N_noxref_42_c_15958_n ) capacitor c=0.00375838f \
 //x=32.275 //y=1.145 //x2=32.675 //y2=1.77
cc_8108 ( N_GND_c_14190_n N_noxref_42_c_15958_n ) capacitor c=0.00392232f \
 //x=35.84 //y=0.175 //x2=32.675 //y2=1.77
cc_8109 ( N_GND_M19_noxref_d N_noxref_42_c_15958_n ) capacitor c=0.00578031f \
 //x=32.085 //y=1.055 //x2=32.675 //y2=1.77
cc_8110 ( N_GND_c_14254_n N_noxref_42_c_15988_n ) capacitor c=0.0169052f \
 //x=32.275 //y=1.015 //x2=32.76 //y2=0.805
cc_8111 ( N_GND_c_14172_n N_noxref_42_c_15988_n ) capacitor c=0.00439789f \
 //x=37.105 //y=0.175 //x2=32.76 //y2=0.805
cc_8112 ( N_GND_c_14190_n N_noxref_42_c_15988_n ) capacitor c=0.0141638f \
 //x=35.84 //y=0.175 //x2=32.76 //y2=0.805
cc_8113 ( N_GND_c_14193_n N_noxref_42_c_15988_n ) capacitor c=0.00322478f \
 //x=31.2 //y=0.175 //x2=32.76 //y2=0.805
cc_8114 ( N_GND_c_14172_n N_noxref_42_c_15969_n ) capacitor c=0.0117462f \
 //x=37.105 //y=0.175 //x2=33.645 //y2=0.72
cc_8115 ( N_GND_c_14190_n N_noxref_42_c_15969_n ) capacitor c=0.0361328f \
 //x=35.84 //y=0.175 //x2=33.645 //y2=0.72
cc_8116 ( N_GND_c_14171_n N_noxref_42_M19_noxref_s ) capacitor c=0.00439789f \
 //x=32.19 //y=0.175 //x2=31.655 //y2=0.555
cc_8117 ( N_GND_c_14254_n N_noxref_42_M19_noxref_s ) capacitor c=0.0173062f \
 //x=32.275 //y=1.015 //x2=31.655 //y2=0.555
cc_8118 ( N_GND_c_14172_n N_noxref_42_M19_noxref_s ) capacitor c=0.00402659f \
 //x=37.105 //y=0.175 //x2=31.655 //y2=0.555
cc_8119 ( N_GND_c_14260_n N_noxref_42_M19_noxref_s ) capacitor c=0.00988958f \
 //x=32.275 //y=1.145 //x2=31.655 //y2=0.555
cc_8120 ( N_GND_c_14190_n N_noxref_42_M19_noxref_s ) capacitor c=0.0273663f \
 //x=35.84 //y=0.175 //x2=31.655 //y2=0.555
cc_8121 ( N_GND_c_14193_n N_noxref_42_M19_noxref_s ) capacitor c=0.0634633f \
 //x=31.2 //y=0.175 //x2=31.655 //y2=0.555
cc_8122 ( N_GND_c_14196_n N_noxref_42_M19_noxref_s ) capacitor c=0.00166451f \
 //x=36.01 //y=0.175 //x2=31.655 //y2=0.555
cc_8123 ( N_GND_M19_noxref_d N_noxref_42_M19_noxref_s ) capacitor c=0.0271316f \
 //x=32.085 //y=1.055 //x2=31.655 //y2=0.555
cc_8124 ( N_GND_c_14172_n N_noxref_43_c_16018_n ) capacitor c=9.79596e-19 \
 //x=37.105 //y=0.175 //x2=37.59 //y2=1.76
cc_8125 ( N_GND_c_14210_n N_noxref_43_c_16018_n ) capacitor c=7.45647e-19 \
 //x=40.33 //y=0.175 //x2=37.59 //y2=1.76
cc_8126 ( N_GND_c_14176_n N_noxref_43_c_16018_n ) capacitor c=0.00398656f \
 //x=37.19 //y=1.135 //x2=37.59 //y2=1.76
cc_8127 ( N_GND_c_14192_n N_noxref_43_c_16018_n ) capacitor c=0.00395774f \
 //x=39.17 //y=0.175 //x2=37.59 //y2=1.76
cc_8128 ( N_GND_M22_noxref_d N_noxref_43_c_16018_n ) capacitor c=0.00578453f \
 //x=37 //y=1.045 //x2=37.59 //y2=1.76
cc_8129 ( N_GND_c_14210_n N_noxref_43_c_16063_n ) capacitor c=0.00310334f \
 //x=40.33 //y=0.175 //x2=37.675 //y2=0.795
cc_8130 ( N_GND_c_14186_n N_noxref_43_c_16063_n ) capacitor c=0.0119573f \
 //x=37.187 //y=1.005 //x2=37.675 //y2=0.795
cc_8131 ( N_GND_c_14192_n N_noxref_43_c_16063_n ) capacitor c=0.0147548f \
 //x=39.17 //y=0.175 //x2=37.675 //y2=0.795
cc_8132 ( N_GND_c_14196_n N_noxref_43_c_16063_n ) capacitor c=0.00282583f \
 //x=36.01 //y=0.175 //x2=37.675 //y2=0.795
cc_8133 ( N_GND_c_14235_n N_noxref_43_c_16063_n ) capacitor c=2.99181e-19 \
 //x=39.34 //y=0.175 //x2=37.675 //y2=0.795
cc_8134 ( N_GND_c_14196_n N_noxref_43_c_16025_n ) capacitor c=2.8386e-19 \
 //x=36.01 //y=0.175 //x2=37.675 //y2=1.675
cc_8135 ( N_GND_c_14210_n N_noxref_43_c_16030_n ) capacitor c=0.0098961f \
 //x=40.33 //y=0.175 //x2=38.56 //y2=0.71
cc_8136 ( N_GND_c_14192_n N_noxref_43_c_16030_n ) capacitor c=0.0374802f \
 //x=39.17 //y=0.175 //x2=38.56 //y2=0.71
cc_8137 ( N_GND_c_14210_n N_noxref_43_c_16071_n ) capacitor c=0.00250941f \
 //x=40.33 //y=0.175 //x2=38.645 //y2=0.795
cc_8138 ( N_GND_c_14192_n N_noxref_43_c_16071_n ) capacitor c=0.0145307f \
 //x=39.17 //y=0.175 //x2=38.645 //y2=0.795
cc_8139 ( N_GND_c_14235_n N_noxref_43_c_16071_n ) capacitor c=0.0396774f \
 //x=39.34 //y=0.175 //x2=38.645 //y2=0.795
cc_8140 ( N_GND_c_14172_n N_noxref_43_M22_noxref_s ) capacitor c=0.0045077f \
 //x=37.105 //y=0.175 //x2=36.57 //y2=0.545
cc_8141 ( N_GND_c_14176_n N_noxref_43_M22_noxref_s ) capacitor c=0.0100945f \
 //x=37.19 //y=1.135 //x2=36.57 //y2=0.545
cc_8142 ( N_GND_c_14186_n N_noxref_43_M22_noxref_s ) capacitor c=0.0170608f \
 //x=37.187 //y=1.005 //x2=36.57 //y2=0.545
cc_8143 ( N_GND_c_14192_n N_noxref_43_M22_noxref_s ) capacitor c=0.0147643f \
 //x=39.17 //y=0.175 //x2=36.57 //y2=0.545
cc_8144 ( N_GND_c_14196_n N_noxref_43_M22_noxref_s ) capacitor c=0.0528206f \
 //x=36.01 //y=0.175 //x2=36.57 //y2=0.545
cc_8145 ( N_GND_c_14235_n N_noxref_43_M22_noxref_s ) capacitor c=0.00648063f \
 //x=39.34 //y=0.175 //x2=36.57 //y2=0.545
cc_8146 ( N_GND_M22_noxref_d N_noxref_43_M22_noxref_s ) capacitor c=0.0271276f \
 //x=37 //y=1.045 //x2=36.57 //y2=0.545
cc_8147 ( N_GND_c_14210_n N_noxref_44_c_16085_n ) capacitor c=0.0011329f \
 //x=40.33 //y=0.175 //x2=40.815 //y2=1.77
cc_8148 ( N_GND_c_14347_n N_noxref_44_c_16085_n ) capacitor c=7.40908e-19 \
 //x=45.14 //y=0.175 //x2=40.815 //y2=1.77
cc_8149 ( N_GND_c_14220_n N_noxref_44_c_16085_n ) capacitor c=0.00365894f \
 //x=40.415 //y=1.145 //x2=40.815 //y2=1.77
cc_8150 ( N_GND_c_14233_n N_noxref_44_c_16085_n ) capacitor c=0.00392232f \
 //x=43.98 //y=0.175 //x2=40.815 //y2=1.77
cc_8151 ( N_GND_M24_noxref_d N_noxref_44_c_16085_n ) capacitor c=0.00578031f \
 //x=40.225 //y=1.055 //x2=40.815 //y2=1.77
cc_8152 ( N_GND_c_14214_n N_noxref_44_c_16110_n ) capacitor c=0.0169052f \
 //x=40.415 //y=1.015 //x2=40.9 //y2=0.805
cc_8153 ( N_GND_c_14347_n N_noxref_44_c_16110_n ) capacitor c=0.00439789f \
 //x=45.14 //y=0.175 //x2=40.9 //y2=0.805
cc_8154 ( N_GND_c_14233_n N_noxref_44_c_16110_n ) capacitor c=0.0141638f \
 //x=43.98 //y=0.175 //x2=40.9 //y2=0.805
cc_8155 ( N_GND_c_14235_n N_noxref_44_c_16110_n ) capacitor c=0.00322442f \
 //x=39.34 //y=0.175 //x2=40.9 //y2=0.805
cc_8156 ( N_GND_c_14347_n N_noxref_44_c_16096_n ) capacitor c=0.0124364f \
 //x=45.14 //y=0.175 //x2=41.785 //y2=0.72
cc_8157 ( N_GND_c_14233_n N_noxref_44_c_16096_n ) capacitor c=0.0361346f \
 //x=43.98 //y=0.175 //x2=41.785 //y2=0.72
cc_8158 ( N_GND_c_14210_n N_noxref_44_M24_noxref_s ) capacitor c=0.00439789f \
 //x=40.33 //y=0.175 //x2=39.795 //y2=0.555
cc_8159 ( N_GND_c_14214_n N_noxref_44_M24_noxref_s ) capacitor c=0.0125586f \
 //x=40.415 //y=1.015 //x2=39.795 //y2=0.555
cc_8160 ( N_GND_c_14347_n N_noxref_44_M24_noxref_s ) capacitor c=0.0044479f \
 //x=45.14 //y=0.175 //x2=39.795 //y2=0.555
cc_8161 ( N_GND_c_14220_n N_noxref_44_M24_noxref_s ) capacitor c=0.00972044f \
 //x=40.415 //y=1.145 //x2=39.795 //y2=0.555
cc_8162 ( N_GND_c_14233_n N_noxref_44_M24_noxref_s ) capacitor c=0.0273693f \
 //x=43.98 //y=0.175 //x2=39.795 //y2=0.555
cc_8163 ( N_GND_c_14235_n N_noxref_44_M24_noxref_s ) capacitor c=0.0624873f \
 //x=39.34 //y=0.175 //x2=39.795 //y2=0.555
cc_8164 ( N_GND_c_14291_n N_noxref_44_M24_noxref_s ) capacitor c=0.00166413f \
 //x=44.15 //y=0.175 //x2=39.795 //y2=0.555
cc_8165 ( N_GND_M24_noxref_d N_noxref_44_M24_noxref_s ) capacitor c=0.0271316f \
 //x=40.225 //y=1.055 //x2=39.795 //y2=0.555
cc_8166 ( N_GND_c_14347_n N_noxref_45_c_16143_n ) capacitor c=0.0011329f \
 //x=45.14 //y=0.175 //x2=45.625 //y2=1.77
cc_8167 ( N_GND_c_14310_n N_noxref_45_c_16143_n ) capacitor c=7.40908e-19 \
 //x=50.055 //y=0.175 //x2=45.625 //y2=1.77
cc_8168 ( N_GND_c_14271_n N_noxref_45_c_16143_n ) capacitor c=0.00371075f \
 //x=45.225 //y=1.145 //x2=45.625 //y2=1.77
cc_8169 ( N_GND_c_14283_n N_noxref_45_c_16143_n ) capacitor c=0.00392232f \
 //x=48.79 //y=0.175 //x2=45.625 //y2=1.77
cc_8170 ( N_GND_M27_noxref_d N_noxref_45_c_16143_n ) capacitor c=0.00578031f \
 //x=45.035 //y=1.055 //x2=45.625 //y2=1.77
cc_8171 ( N_GND_c_14257_n N_noxref_45_c_16171_n ) capacitor c=0.0169052f \
 //x=45.225 //y=1.015 //x2=45.71 //y2=0.805
cc_8172 ( N_GND_c_14310_n N_noxref_45_c_16171_n ) capacitor c=0.00439789f \
 //x=50.055 //y=0.175 //x2=45.71 //y2=0.805
cc_8173 ( N_GND_c_14283_n N_noxref_45_c_16171_n ) capacitor c=0.0141638f \
 //x=48.79 //y=0.175 //x2=45.71 //y2=0.805
cc_8174 ( N_GND_c_14291_n N_noxref_45_c_16171_n ) capacitor c=0.00322478f \
 //x=44.15 //y=0.175 //x2=45.71 //y2=0.805
cc_8175 ( N_GND_c_14310_n N_noxref_45_c_16156_n ) capacitor c=0.0126556f \
 //x=50.055 //y=0.175 //x2=46.595 //y2=0.72
cc_8176 ( N_GND_c_14283_n N_noxref_45_c_16156_n ) capacitor c=0.0361346f \
 //x=48.79 //y=0.175 //x2=46.595 //y2=0.72
cc_8177 ( N_GND_c_14347_n N_noxref_45_M27_noxref_s ) capacitor c=0.00439789f \
 //x=45.14 //y=0.175 //x2=44.605 //y2=0.555
cc_8178 ( N_GND_c_14257_n N_noxref_45_M27_noxref_s ) capacitor c=0.0173062f \
 //x=45.225 //y=1.015 //x2=44.605 //y2=0.555
cc_8179 ( N_GND_c_14310_n N_noxref_45_M27_noxref_s ) capacitor c=0.0044479f \
 //x=50.055 //y=0.175 //x2=44.605 //y2=0.555
cc_8180 ( N_GND_c_14271_n N_noxref_45_M27_noxref_s ) capacitor c=0.00988958f \
 //x=45.225 //y=1.145 //x2=44.605 //y2=0.555
cc_8181 ( N_GND_c_14283_n N_noxref_45_M27_noxref_s ) capacitor c=0.0273693f \
 //x=48.79 //y=0.175 //x2=44.605 //y2=0.555
cc_8182 ( N_GND_c_14291_n N_noxref_45_M27_noxref_s ) capacitor c=0.0634633f \
 //x=44.15 //y=0.175 //x2=44.605 //y2=0.555
cc_8183 ( N_GND_c_14329_n N_noxref_45_M27_noxref_s ) capacitor c=0.00166451f \
 //x=48.96 //y=0.175 //x2=44.605 //y2=0.555
cc_8184 ( N_GND_M27_noxref_d N_noxref_45_M27_noxref_s ) capacitor c=0.0271316f \
 //x=45.035 //y=1.055 //x2=44.605 //y2=0.555
cc_8185 ( N_GND_c_14310_n N_noxref_46_c_16201_n ) capacitor c=9.8916e-19 \
 //x=50.055 //y=0.175 //x2=50.54 //y2=1.76
cc_8186 ( N_GND_c_14350_n N_noxref_46_c_16201_n ) capacitor c=7.45647e-19 \
 //x=53.28 //y=0.175 //x2=50.54 //y2=1.76
cc_8187 ( N_GND_c_14314_n N_noxref_46_c_16201_n ) capacitor c=0.0040378f \
 //x=50.14 //y=1.135 //x2=50.54 //y2=1.76
cc_8188 ( N_GND_c_14328_n N_noxref_46_c_16201_n ) capacitor c=0.00395774f \
 //x=52.12 //y=0.175 //x2=50.54 //y2=1.76
cc_8189 ( N_GND_M30_noxref_d N_noxref_46_c_16201_n ) capacitor c=0.00578453f \
 //x=49.95 //y=1.045 //x2=50.54 //y2=1.76
cc_8190 ( N_GND_c_14350_n N_noxref_46_c_16246_n ) capacitor c=0.00310216f \
 //x=53.28 //y=0.175 //x2=50.625 //y2=0.795
cc_8191 ( N_GND_c_14324_n N_noxref_46_c_16246_n ) capacitor c=0.0119573f \
 //x=50.137 //y=1.005 //x2=50.625 //y2=0.795
cc_8192 ( N_GND_c_14328_n N_noxref_46_c_16246_n ) capacitor c=0.0147548f \
 //x=52.12 //y=0.175 //x2=50.625 //y2=0.795
cc_8193 ( N_GND_c_14329_n N_noxref_46_c_16246_n ) capacitor c=0.00282583f \
 //x=48.96 //y=0.175 //x2=50.625 //y2=0.795
cc_8194 ( N_GND_c_14376_n N_noxref_46_c_16246_n ) capacitor c=2.99181e-19 \
 //x=52.29 //y=0.175 //x2=50.625 //y2=0.795
cc_8195 ( N_GND_c_14329_n N_noxref_46_c_16208_n ) capacitor c=2.8386e-19 \
 //x=48.96 //y=0.175 //x2=50.625 //y2=1.675
cc_8196 ( N_GND_c_14350_n N_noxref_46_c_16216_n ) capacitor c=0.0100002f \
 //x=53.28 //y=0.175 //x2=51.51 //y2=0.71
cc_8197 ( N_GND_c_14328_n N_noxref_46_c_16216_n ) capacitor c=0.0374802f \
 //x=52.12 //y=0.175 //x2=51.51 //y2=0.71
cc_8198 ( N_GND_c_14350_n N_noxref_46_c_16254_n ) capacitor c=0.0025105f \
 //x=53.28 //y=0.175 //x2=51.595 //y2=0.795
cc_8199 ( N_GND_c_14328_n N_noxref_46_c_16254_n ) capacitor c=0.0145307f \
 //x=52.12 //y=0.175 //x2=51.595 //y2=0.795
cc_8200 ( N_GND_c_14376_n N_noxref_46_c_16254_n ) capacitor c=0.0396774f \
 //x=52.29 //y=0.175 //x2=51.595 //y2=0.795
cc_8201 ( N_GND_c_14310_n N_noxref_46_M30_noxref_s ) capacitor c=0.0045077f \
 //x=50.055 //y=0.175 //x2=49.52 //y2=0.545
cc_8202 ( N_GND_c_14314_n N_noxref_46_M30_noxref_s ) capacitor c=0.0100945f \
 //x=50.14 //y=1.135 //x2=49.52 //y2=0.545
cc_8203 ( N_GND_c_14324_n N_noxref_46_M30_noxref_s ) capacitor c=0.0170608f \
 //x=50.137 //y=1.005 //x2=49.52 //y2=0.545
cc_8204 ( N_GND_c_14328_n N_noxref_46_M30_noxref_s ) capacitor c=0.0147643f \
 //x=52.12 //y=0.175 //x2=49.52 //y2=0.545
cc_8205 ( N_GND_c_14329_n N_noxref_46_M30_noxref_s ) capacitor c=0.0528206f \
 //x=48.96 //y=0.175 //x2=49.52 //y2=0.545
cc_8206 ( N_GND_c_14376_n N_noxref_46_M30_noxref_s ) capacitor c=0.00648063f \
 //x=52.29 //y=0.175 //x2=49.52 //y2=0.545
cc_8207 ( N_GND_M30_noxref_d N_noxref_46_M30_noxref_s ) capacitor c=0.0271276f \
 //x=49.95 //y=1.045 //x2=49.52 //y2=0.545
cc_8208 ( N_GND_c_14350_n N_noxref_47_c_16278_n ) capacitor c=0.0011329f \
 //x=53.28 //y=0.175 //x2=53.765 //y2=1.77
cc_8209 ( N_GND_c_14416_n N_noxref_47_c_16278_n ) capacitor c=6.72491e-19 \
 //x=58.09 //y=0.175 //x2=53.765 //y2=1.77
cc_8210 ( N_GND_c_14529_n N_noxref_47_c_16278_n ) capacitor c=0.00377523f \
 //x=53.365 //y=1.145 //x2=53.765 //y2=1.77
cc_8211 ( N_GND_c_14449_n N_noxref_47_c_16278_n ) capacitor c=0.00392232f \
 //x=56.93 //y=0.175 //x2=53.765 //y2=1.77
cc_8212 ( N_GND_M32_noxref_d N_noxref_47_c_16278_n ) capacitor c=0.00578031f \
 //x=53.175 //y=1.055 //x2=53.765 //y2=1.77
cc_8213 ( N_GND_c_14567_n N_noxref_47_c_16293_n ) capacitor c=0.0169052f \
 //x=53.365 //y=1.015 //x2=53.85 //y2=0.805
cc_8214 ( N_GND_c_14416_n N_noxref_47_c_16293_n ) capacitor c=0.00439789f \
 //x=58.09 //y=0.175 //x2=53.85 //y2=0.805
cc_8215 ( N_GND_c_14449_n N_noxref_47_c_16293_n ) capacitor c=0.0141638f \
 //x=56.93 //y=0.175 //x2=53.85 //y2=0.805
cc_8216 ( N_GND_c_14376_n N_noxref_47_c_16293_n ) capacitor c=0.00322442f \
 //x=52.29 //y=0.175 //x2=53.85 //y2=0.805
cc_8217 ( N_GND_c_14416_n N_noxref_47_c_16267_n ) capacitor c=0.0124416f \
 //x=58.09 //y=0.175 //x2=54.735 //y2=0.72
cc_8218 ( N_GND_c_14449_n N_noxref_47_c_16267_n ) capacitor c=0.0361346f \
 //x=56.93 //y=0.175 //x2=54.735 //y2=0.72
cc_8219 ( N_GND_c_14350_n N_noxref_47_M32_noxref_s ) capacitor c=0.00439789f \
 //x=53.28 //y=0.175 //x2=52.745 //y2=0.555
cc_8220 ( N_GND_c_14567_n N_noxref_47_M32_noxref_s ) capacitor c=0.0125586f \
 //x=53.365 //y=1.015 //x2=52.745 //y2=0.555
cc_8221 ( N_GND_c_14416_n N_noxref_47_M32_noxref_s ) capacitor c=0.0044479f \
 //x=58.09 //y=0.175 //x2=52.745 //y2=0.555
cc_8222 ( N_GND_c_14529_n N_noxref_47_M32_noxref_s ) capacitor c=0.00972044f \
 //x=53.365 //y=1.145 //x2=52.745 //y2=0.555
cc_8223 ( N_GND_c_14449_n N_noxref_47_M32_noxref_s ) capacitor c=0.0273693f \
 //x=56.93 //y=0.175 //x2=52.745 //y2=0.555
cc_8224 ( N_GND_c_14376_n N_noxref_47_M32_noxref_s ) capacitor c=0.0624873f \
 //x=52.29 //y=0.175 //x2=52.745 //y2=0.555
cc_8225 ( N_GND_c_14409_n N_noxref_47_M32_noxref_s ) capacitor c=0.00166413f \
 //x=57.1 //y=0.175 //x2=52.745 //y2=0.555
cc_8226 ( N_GND_M32_noxref_d N_noxref_47_M32_noxref_s ) capacitor c=0.0271316f \
 //x=53.175 //y=1.055 //x2=52.745 //y2=0.555
cc_8227 ( N_GND_c_14416_n N_noxref_48_c_16337_n ) capacitor c=0.0011329f \
 //x=58.09 //y=0.175 //x2=58.575 //y2=1.77
cc_8228 ( N_GND_c_14392_n N_noxref_48_c_16337_n ) capacitor c=6.68055e-19 \
 //x=63.005 //y=0.175 //x2=58.575 //y2=1.77
cc_8229 ( N_GND_c_14428_n N_noxref_48_c_16337_n ) capacitor c=0.00375838f \
 //x=58.175 //y=1.145 //x2=58.575 //y2=1.77
cc_8230 ( N_GND_c_14450_n N_noxref_48_c_16337_n ) capacitor c=0.00392232f \
 //x=61.74 //y=0.175 //x2=58.575 //y2=1.77
cc_8231 ( N_GND_M35_noxref_d N_noxref_48_c_16337_n ) capacitor c=0.00578031f \
 //x=57.985 //y=1.055 //x2=58.575 //y2=1.77
cc_8232 ( N_GND_c_14422_n N_noxref_48_c_16356_n ) capacitor c=0.0169052f \
 //x=58.175 //y=1.015 //x2=58.66 //y2=0.805
cc_8233 ( N_GND_c_14392_n N_noxref_48_c_16356_n ) capacitor c=0.00439789f \
 //x=63.005 //y=0.175 //x2=58.66 //y2=0.805
cc_8234 ( N_GND_c_14450_n N_noxref_48_c_16356_n ) capacitor c=0.0141638f \
 //x=61.74 //y=0.175 //x2=58.66 //y2=0.805
cc_8235 ( N_GND_c_14409_n N_noxref_48_c_16356_n ) capacitor c=0.00322478f \
 //x=57.1 //y=0.175 //x2=58.66 //y2=0.805
cc_8236 ( N_GND_c_14392_n N_noxref_48_c_16325_n ) capacitor c=0.0117471f \
 //x=63.005 //y=0.175 //x2=59.545 //y2=0.72
cc_8237 ( N_GND_c_14450_n N_noxref_48_c_16325_n ) capacitor c=0.0361337f \
 //x=61.74 //y=0.175 //x2=59.545 //y2=0.72
cc_8238 ( N_GND_c_14416_n N_noxref_48_M35_noxref_s ) capacitor c=0.00439789f \
 //x=58.09 //y=0.175 //x2=57.555 //y2=0.555
cc_8239 ( N_GND_c_14422_n N_noxref_48_M35_noxref_s ) capacitor c=0.0173062f \
 //x=58.175 //y=1.015 //x2=57.555 //y2=0.555
cc_8240 ( N_GND_c_14392_n N_noxref_48_M35_noxref_s ) capacitor c=0.00402659f \
 //x=63.005 //y=0.175 //x2=57.555 //y2=0.555
cc_8241 ( N_GND_c_14428_n N_noxref_48_M35_noxref_s ) capacitor c=0.00988958f \
 //x=58.175 //y=1.145 //x2=57.555 //y2=0.555
cc_8242 ( N_GND_c_14450_n N_noxref_48_M35_noxref_s ) capacitor c=0.0276458f \
 //x=61.74 //y=0.175 //x2=57.555 //y2=0.555
cc_8243 ( N_GND_c_14409_n N_noxref_48_M35_noxref_s ) capacitor c=0.0634633f \
 //x=57.1 //y=0.175 //x2=57.555 //y2=0.555
cc_8244 ( N_GND_c_14411_n N_noxref_48_M35_noxref_s ) capacitor c=0.00166451f \
 //x=61.91 //y=0.175 //x2=57.555 //y2=0.555
cc_8245 ( N_GND_M35_noxref_d N_noxref_48_M35_noxref_s ) capacitor c=0.0271316f \
 //x=57.985 //y=1.055 //x2=57.555 //y2=0.555
cc_8246 ( N_GND_c_14392_n N_noxref_49_c_16386_n ) capacitor c=9.79596e-19 \
 //x=63.005 //y=0.175 //x2=63.49 //y2=1.76
cc_8247 ( N_GND_c_14511_n N_noxref_49_c_16386_n ) capacitor c=7.45647e-19 \
 //x=66.23 //y=0.175 //x2=63.49 //y2=1.76
cc_8248 ( N_GND_c_14531_n N_noxref_49_c_16386_n ) capacitor c=0.00398656f \
 //x=63.09 //y=1.135 //x2=63.49 //y2=1.76
cc_8249 ( N_GND_c_14605_n N_noxref_49_c_16386_n ) capacitor c=0.00395774f \
 //x=65.07 //y=0.175 //x2=63.49 //y2=1.76
cc_8250 ( N_GND_M38_noxref_d N_noxref_49_c_16386_n ) capacitor c=0.00578453f \
 //x=62.9 //y=1.045 //x2=63.49 //y2=1.76
cc_8251 ( N_GND_c_14511_n N_noxref_49_c_16431_n ) capacitor c=0.00310334f \
 //x=66.23 //y=0.175 //x2=63.575 //y2=0.795
cc_8252 ( N_GND_c_14694_n N_noxref_49_c_16431_n ) capacitor c=0.0119573f \
 //x=63.087 //y=1.005 //x2=63.575 //y2=0.795
cc_8253 ( N_GND_c_14605_n N_noxref_49_c_16431_n ) capacitor c=0.0147548f \
 //x=65.07 //y=0.175 //x2=63.575 //y2=0.795
cc_8254 ( N_GND_c_14411_n N_noxref_49_c_16431_n ) capacitor c=0.00282583f \
 //x=61.91 //y=0.175 //x2=63.575 //y2=0.795
cc_8255 ( N_GND_c_14562_n N_noxref_49_c_16431_n ) capacitor c=2.99181e-19 \
 //x=65.24 //y=0.175 //x2=63.575 //y2=0.795
cc_8256 ( N_GND_c_14411_n N_noxref_49_c_16387_n ) capacitor c=2.8386e-19 \
 //x=61.91 //y=0.175 //x2=63.575 //y2=1.675
cc_8257 ( N_GND_c_14511_n N_noxref_49_c_16388_n ) capacitor c=0.0098961f \
 //x=66.23 //y=0.175 //x2=64.46 //y2=0.71
cc_8258 ( N_GND_c_14605_n N_noxref_49_c_16388_n ) capacitor c=0.0374802f \
 //x=65.07 //y=0.175 //x2=64.46 //y2=0.71
cc_8259 ( N_GND_c_14511_n N_noxref_49_c_16439_n ) capacitor c=0.00250941f \
 //x=66.23 //y=0.175 //x2=64.545 //y2=0.795
cc_8260 ( N_GND_c_14605_n N_noxref_49_c_16439_n ) capacitor c=0.0145307f \
 //x=65.07 //y=0.175 //x2=64.545 //y2=0.795
cc_8261 ( N_GND_c_14562_n N_noxref_49_c_16439_n ) capacitor c=0.0396774f \
 //x=65.24 //y=0.175 //x2=64.545 //y2=0.795
cc_8262 ( N_GND_c_14392_n N_noxref_49_M38_noxref_s ) capacitor c=0.0045077f \
 //x=63.005 //y=0.175 //x2=62.47 //y2=0.545
cc_8263 ( N_GND_c_14531_n N_noxref_49_M38_noxref_s ) capacitor c=0.0100945f \
 //x=63.09 //y=1.135 //x2=62.47 //y2=0.545
cc_8264 ( N_GND_c_14694_n N_noxref_49_M38_noxref_s ) capacitor c=0.0170608f \
 //x=63.087 //y=1.005 //x2=62.47 //y2=0.545
cc_8265 ( N_GND_c_14605_n N_noxref_49_M38_noxref_s ) capacitor c=0.0147643f \
 //x=65.07 //y=0.175 //x2=62.47 //y2=0.545
cc_8266 ( N_GND_c_14411_n N_noxref_49_M38_noxref_s ) capacitor c=0.0528206f \
 //x=61.91 //y=0.175 //x2=62.47 //y2=0.545
cc_8267 ( N_GND_c_14562_n N_noxref_49_M38_noxref_s ) capacitor c=0.00648063f \
 //x=65.24 //y=0.175 //x2=62.47 //y2=0.545
cc_8268 ( N_GND_M38_noxref_d N_noxref_49_M38_noxref_s ) capacitor c=0.0271276f \
 //x=62.9 //y=1.045 //x2=62.47 //y2=0.545
cc_8269 ( N_GND_c_14511_n N_noxref_50_c_16463_n ) capacitor c=0.0011329f \
 //x=66.23 //y=0.175 //x2=66.715 //y2=1.77
cc_8270 ( N_GND_c_14417_n N_noxref_50_c_16463_n ) capacitor c=7.40908e-19 \
 //x=71.04 //y=0.175 //x2=66.715 //y2=1.77
cc_8271 ( N_GND_c_14532_n N_noxref_50_c_16463_n ) capacitor c=0.00365894f \
 //x=66.315 //y=1.145 //x2=66.715 //y2=1.77
cc_8272 ( N_GND_c_14606_n N_noxref_50_c_16463_n ) capacitor c=0.00392232f \
 //x=69.88 //y=0.175 //x2=66.715 //y2=1.77
cc_8273 ( N_GND_M40_noxref_d N_noxref_50_c_16463_n ) capacitor c=0.00578031f \
 //x=66.125 //y=1.055 //x2=66.715 //y2=1.77
cc_8274 ( N_GND_c_14656_n N_noxref_50_c_16478_n ) capacitor c=0.0169052f \
 //x=66.315 //y=1.015 //x2=66.8 //y2=0.805
cc_8275 ( N_GND_c_14417_n N_noxref_50_c_16478_n ) capacitor c=0.00439789f \
 //x=71.04 //y=0.175 //x2=66.8 //y2=0.805
cc_8276 ( N_GND_c_14606_n N_noxref_50_c_16478_n ) capacitor c=0.0141638f \
 //x=69.88 //y=0.175 //x2=66.8 //y2=0.805
cc_8277 ( N_GND_c_14562_n N_noxref_50_c_16478_n ) capacitor c=0.00322442f \
 //x=65.24 //y=0.175 //x2=66.8 //y2=0.805
cc_8278 ( N_GND_c_14417_n N_noxref_50_c_16452_n ) capacitor c=0.0124364f \
 //x=71.04 //y=0.175 //x2=67.685 //y2=0.72
cc_8279 ( N_GND_c_14606_n N_noxref_50_c_16452_n ) capacitor c=0.0361346f \
 //x=69.88 //y=0.175 //x2=67.685 //y2=0.72
cc_8280 ( N_GND_c_14511_n N_noxref_50_M40_noxref_s ) capacitor c=0.00439789f \
 //x=66.23 //y=0.175 //x2=65.695 //y2=0.555
cc_8281 ( N_GND_c_14656_n N_noxref_50_M40_noxref_s ) capacitor c=0.0125586f \
 //x=66.315 //y=1.015 //x2=65.695 //y2=0.555
cc_8282 ( N_GND_c_14417_n N_noxref_50_M40_noxref_s ) capacitor c=0.0044479f \
 //x=71.04 //y=0.175 //x2=65.695 //y2=0.555
cc_8283 ( N_GND_c_14532_n N_noxref_50_M40_noxref_s ) capacitor c=0.00972044f \
 //x=66.315 //y=1.145 //x2=65.695 //y2=0.555
cc_8284 ( N_GND_c_14606_n N_noxref_50_M40_noxref_s ) capacitor c=0.0273693f \
 //x=69.88 //y=0.175 //x2=65.695 //y2=0.555
cc_8285 ( N_GND_c_14562_n N_noxref_50_M40_noxref_s ) capacitor c=0.0624873f \
 //x=65.24 //y=0.175 //x2=65.695 //y2=0.555
cc_8286 ( N_GND_c_14459_n N_noxref_50_M40_noxref_s ) capacitor c=0.00166413f \
 //x=70.05 //y=0.175 //x2=65.695 //y2=0.555
cc_8287 ( N_GND_M40_noxref_d N_noxref_50_M40_noxref_s ) capacitor c=0.0271316f \
 //x=66.125 //y=1.055 //x2=65.695 //y2=0.555
cc_8288 ( N_GND_c_14417_n N_noxref_51_c_16511_n ) capacitor c=0.0011329f \
 //x=71.04 //y=0.175 //x2=71.525 //y2=1.77
cc_8289 ( N_GND_c_14516_n N_noxref_51_c_16511_n ) capacitor c=7.40908e-19 \
 //x=75.955 //y=0.175 //x2=71.525 //y2=1.77
cc_8290 ( N_GND_c_14439_n N_noxref_51_c_16511_n ) capacitor c=0.00371075f \
 //x=71.125 //y=1.145 //x2=71.525 //y2=1.77
cc_8291 ( N_GND_c_14451_n N_noxref_51_c_16511_n ) capacitor c=0.00392232f \
 //x=74.69 //y=0.175 //x2=71.525 //y2=1.77
cc_8292 ( N_GND_M43_noxref_d N_noxref_51_c_16511_n ) capacitor c=0.00578031f \
 //x=70.935 //y=1.055 //x2=71.525 //y2=1.77
cc_8293 ( N_GND_c_14425_n N_noxref_51_c_16539_n ) capacitor c=0.0169052f \
 //x=71.125 //y=1.015 //x2=71.61 //y2=0.805
cc_8294 ( N_GND_c_14516_n N_noxref_51_c_16539_n ) capacitor c=0.00439789f \
 //x=75.955 //y=0.175 //x2=71.61 //y2=0.805
cc_8295 ( N_GND_c_14451_n N_noxref_51_c_16539_n ) capacitor c=0.0141638f \
 //x=74.69 //y=0.175 //x2=71.61 //y2=0.805
cc_8296 ( N_GND_c_14459_n N_noxref_51_c_16539_n ) capacitor c=0.00322478f \
 //x=70.05 //y=0.175 //x2=71.61 //y2=0.805
cc_8297 ( N_GND_c_14516_n N_noxref_51_c_16524_n ) capacitor c=0.0126556f \
 //x=75.955 //y=0.175 //x2=72.495 //y2=0.72
cc_8298 ( N_GND_c_14451_n N_noxref_51_c_16524_n ) capacitor c=0.0358997f \
 //x=74.69 //y=0.175 //x2=72.495 //y2=0.72
cc_8299 ( N_GND_c_14417_n N_noxref_51_M43_noxref_s ) capacitor c=0.00439789f \
 //x=71.04 //y=0.175 //x2=70.505 //y2=0.555
cc_8300 ( N_GND_c_14425_n N_noxref_51_M43_noxref_s ) capacitor c=0.0173062f \
 //x=71.125 //y=1.015 //x2=70.505 //y2=0.555
cc_8301 ( N_GND_c_14516_n N_noxref_51_M43_noxref_s ) capacitor c=0.00683407f \
 //x=75.955 //y=0.175 //x2=70.505 //y2=0.555
cc_8302 ( N_GND_c_14439_n N_noxref_51_M43_noxref_s ) capacitor c=0.00988958f \
 //x=71.125 //y=1.145 //x2=70.505 //y2=0.555
cc_8303 ( N_GND_c_14451_n N_noxref_51_M43_noxref_s ) capacitor c=0.027328f \
 //x=74.69 //y=0.175 //x2=70.505 //y2=0.555
cc_8304 ( N_GND_c_14459_n N_noxref_51_M43_noxref_s ) capacitor c=0.0634633f \
 //x=70.05 //y=0.175 //x2=70.505 //y2=0.555
cc_8305 ( N_GND_c_14620_n N_noxref_51_M43_noxref_s ) capacitor c=0.00166451f \
 //x=74.86 //y=0.175 //x2=70.505 //y2=0.555
cc_8306 ( N_GND_M43_noxref_d N_noxref_51_M43_noxref_s ) capacitor c=0.0271316f \
 //x=70.935 //y=1.055 //x2=70.505 //y2=0.555
cc_8307 ( N_GND_c_14516_n N_noxref_52_c_16569_n ) capacitor c=9.98096e-19 \
 //x=75.955 //y=0.175 //x2=76.44 //y2=1.76
cc_8308 ( N_GND_c_14578_n N_noxref_52_c_16569_n ) capacitor c=7.45647e-19 \
 //x=79.285 //y=0.175 //x2=76.44 //y2=1.76
cc_8309 ( N_GND_c_14591_n N_noxref_52_c_16569_n ) capacitor c=0.00404395f \
 //x=76.04 //y=1.135 //x2=76.44 //y2=1.76
cc_8310 ( N_GND_c_14608_n N_noxref_52_c_16569_n ) capacitor c=0.00392838f \
 //x=78.02 //y=0.175 //x2=76.44 //y2=1.76
cc_8311 ( N_GND_M46_noxref_d N_noxref_52_c_16569_n ) capacitor c=0.00578453f \
 //x=75.85 //y=1.045 //x2=76.44 //y2=1.76
cc_8312 ( N_GND_c_14578_n N_noxref_52_c_16614_n ) capacitor c=0.00560241f \
 //x=79.285 //y=0.175 //x2=76.525 //y2=0.795
cc_8313 ( N_GND_c_14601_n N_noxref_52_c_16614_n ) capacitor c=0.0120153f \
 //x=76.037 //y=1.005 //x2=76.525 //y2=0.795
cc_8314 ( N_GND_c_14608_n N_noxref_52_c_16614_n ) capacitor c=0.0146605f \
 //x=78.02 //y=0.175 //x2=76.525 //y2=0.795
cc_8315 ( N_GND_c_14620_n N_noxref_52_c_16614_n ) capacitor c=0.00282583f \
 //x=74.86 //y=0.175 //x2=76.525 //y2=0.795
cc_8316 ( N_GND_c_14627_n N_noxref_52_c_16614_n ) capacitor c=2.99356e-19 \
 //x=78.19 //y=0.175 //x2=76.525 //y2=0.795
cc_8317 ( N_GND_c_14620_n N_noxref_52_c_16576_n ) capacitor c=2.8386e-19 \
 //x=74.86 //y=0.175 //x2=76.525 //y2=1.675
cc_8318 ( N_GND_c_14578_n N_noxref_52_c_16581_n ) capacitor c=0.0100002f \
 //x=79.285 //y=0.175 //x2=77.41 //y2=0.71
cc_8319 ( N_GND_c_14608_n N_noxref_52_c_16581_n ) capacitor c=0.0375602f \
 //x=78.02 //y=0.175 //x2=77.41 //y2=0.71
cc_8320 ( N_GND_c_14578_n N_noxref_52_c_16622_n ) capacitor c=0.00253605f \
 //x=79.285 //y=0.175 //x2=77.495 //y2=0.795
cc_8321 ( N_GND_c_14608_n N_noxref_52_c_16622_n ) capacitor c=0.0144893f \
 //x=78.02 //y=0.175 //x2=77.495 //y2=0.795
cc_8322 ( N_GND_c_14627_n N_noxref_52_c_16622_n ) capacitor c=0.0391997f \
 //x=78.19 //y=0.175 //x2=77.495 //y2=0.795
cc_8323 ( N_GND_c_14516_n N_noxref_52_M46_noxref_s ) capacitor c=0.00724992f \
 //x=75.955 //y=0.175 //x2=75.42 //y2=0.545
cc_8324 ( N_GND_c_14591_n N_noxref_52_M46_noxref_s ) capacitor c=0.010101f \
 //x=76.04 //y=1.135 //x2=75.42 //y2=0.545
cc_8325 ( N_GND_c_14601_n N_noxref_52_M46_noxref_s ) capacitor c=0.0170652f \
 //x=76.037 //y=1.005 //x2=75.42 //y2=0.545
cc_8326 ( N_GND_c_14608_n N_noxref_52_M46_noxref_s ) capacitor c=0.014661f \
 //x=78.02 //y=0.175 //x2=75.42 //y2=0.545
cc_8327 ( N_GND_c_14620_n N_noxref_52_M46_noxref_s ) capacitor c=0.0528206f \
 //x=74.86 //y=0.175 //x2=75.42 //y2=0.545
cc_8328 ( N_GND_c_14627_n N_noxref_52_M46_noxref_s ) capacitor c=0.00648111f \
 //x=78.19 //y=0.175 //x2=75.42 //y2=0.545
cc_8329 ( N_GND_M46_noxref_d N_noxref_52_M46_noxref_s ) capacitor c=0.0271276f \
 //x=75.85 //y=1.045 //x2=75.42 //y2=0.545
cc_8330 ( N_GND_c_14578_n N_noxref_53_c_16639_n ) capacitor c=9.39967e-19 \
 //x=79.285 //y=0.175 //x2=79.77 //y2=1.76
cc_8331 ( N_GND_c_14661_n N_noxref_53_c_16639_n ) capacitor c=0.0049241f \
 //x=79.37 //y=1.015 //x2=79.77 //y2=1.76
cc_8332 ( N_GND_c_14853_n N_noxref_53_c_16639_n ) capacitor c=7.45647e-19 \
 //x=82.615 //y=0.175 //x2=79.77 //y2=1.76
cc_8333 ( N_GND_c_14717_n N_noxref_53_c_16639_n ) capacitor c=0.00395725f \
 //x=81.35 //y=0.175 //x2=79.77 //y2=1.76
cc_8334 ( N_GND_M48_noxref_d N_noxref_53_c_16639_n ) capacitor c=0.00579662f \
 //x=79.18 //y=1.045 //x2=79.77 //y2=1.76
cc_8335 ( N_GND_c_14661_n N_noxref_53_c_16682_n ) capacitor c=0.0120153f \
 //x=79.37 //y=1.015 //x2=79.855 //y2=0.795
cc_8336 ( N_GND_c_14853_n N_noxref_53_c_16682_n ) capacitor c=0.00645839f \
 //x=82.615 //y=0.175 //x2=79.855 //y2=0.795
cc_8337 ( N_GND_c_14717_n N_noxref_53_c_16682_n ) capacitor c=0.0146613f \
 //x=81.35 //y=0.175 //x2=79.855 //y2=0.795
cc_8338 ( N_GND_c_14627_n N_noxref_53_c_16682_n ) capacitor c=0.00283156f \
 //x=78.19 //y=0.175 //x2=79.855 //y2=0.795
cc_8339 ( N_GND_c_14750_n N_noxref_53_c_16682_n ) capacitor c=2.99356e-19 \
 //x=81.52 //y=0.175 //x2=79.855 //y2=0.795
cc_8340 ( N_GND_c_14627_n N_noxref_53_c_16648_n ) capacitor c=2.89348e-19 \
 //x=78.19 //y=0.175 //x2=79.855 //y2=1.675
cc_8341 ( N_GND_c_14853_n N_noxref_53_c_16655_n ) capacitor c=0.0109835f \
 //x=82.615 //y=0.175 //x2=80.74 //y2=0.71
cc_8342 ( N_GND_c_14717_n N_noxref_53_c_16655_n ) capacitor c=0.0375489f \
 //x=81.35 //y=0.175 //x2=80.74 //y2=0.71
cc_8343 ( N_GND_c_14853_n N_noxref_53_c_16690_n ) capacitor c=0.0045077f \
 //x=82.615 //y=0.175 //x2=80.825 //y2=0.795
cc_8344 ( N_GND_c_14717_n N_noxref_53_c_16690_n ) capacitor c=0.0144994f \
 //x=81.35 //y=0.175 //x2=80.825 //y2=0.795
cc_8345 ( N_GND_c_14750_n N_noxref_53_c_16690_n ) capacitor c=0.0540893f \
 //x=81.52 //y=0.175 //x2=80.825 //y2=0.795
cc_8346 ( N_GND_c_14578_n N_noxref_53_M48_noxref_s ) capacitor c=0.00255389f \
 //x=79.285 //y=0.175 //x2=78.75 //y2=0.545
cc_8347 ( N_GND_c_14661_n N_noxref_53_M48_noxref_s ) capacitor c=0.0240655f \
 //x=79.37 //y=1.015 //x2=78.75 //y2=0.545
cc_8348 ( N_GND_c_14717_n N_noxref_53_M48_noxref_s ) capacitor c=0.014683f \
 //x=81.35 //y=0.175 //x2=78.75 //y2=0.545
cc_8349 ( N_GND_c_14627_n N_noxref_53_M48_noxref_s ) capacitor c=0.0526823f \
 //x=78.19 //y=0.175 //x2=78.75 //y2=0.545
cc_8350 ( N_GND_c_14750_n N_noxref_53_M48_noxref_s ) capacitor c=0.00250794f \
 //x=81.52 //y=0.175 //x2=78.75 //y2=0.545
cc_8351 ( N_GND_M48_noxref_d N_noxref_53_M48_noxref_s ) capacitor c=0.0271433f \
 //x=79.18 //y=1.045 //x2=78.75 //y2=0.545
cc_8352 ( N_GND_c_14853_n N_noxref_54_c_16705_n ) capacitor c=0.0010065f \
 //x=82.615 //y=0.175 //x2=83.1 //y2=1.76
cc_8353 ( N_GND_c_14668_n N_noxref_54_c_16705_n ) capacitor c=0.00377178f \
 //x=82.7 //y=1.015 //x2=83.1 //y2=1.76
cc_8354 ( N_GND_c_14788_n N_noxref_54_c_16705_n ) capacitor c=7.45647e-19 \
 //x=85.945 //y=0.175 //x2=83.1 //y2=1.76
cc_8355 ( N_GND_c_14719_n N_noxref_54_c_16705_n ) capacitor c=0.00358227f \
 //x=84.68 //y=0.175 //x2=83.1 //y2=1.76
cc_8356 ( N_GND_M50_noxref_d N_noxref_54_c_16705_n ) capacitor c=0.00750663f \
 //x=82.51 //y=1.045 //x2=83.1 //y2=1.76
cc_8357 ( N_GND_c_14668_n N_noxref_54_c_16746_n ) capacitor c=0.0120153f \
 //x=82.7 //y=1.015 //x2=83.185 //y2=0.795
cc_8358 ( N_GND_c_14788_n N_noxref_54_c_16746_n ) capacitor c=0.0045077f \
 //x=85.945 //y=0.175 //x2=83.185 //y2=0.795
cc_8359 ( N_GND_c_14719_n N_noxref_54_c_16746_n ) capacitor c=0.0144994f \
 //x=84.68 //y=0.175 //x2=83.185 //y2=0.795
cc_8360 ( N_GND_c_14750_n N_noxref_54_c_16746_n ) capacitor c=0.00226009f \
 //x=81.52 //y=0.175 //x2=83.185 //y2=0.795
cc_8361 ( N_GND_c_14831_n N_noxref_54_c_16746_n ) capacitor c=2.99356e-19 \
 //x=84.85 //y=0.175 //x2=83.185 //y2=0.795
cc_8362 ( N_GND_c_14750_n N_noxref_54_c_16712_n ) capacitor c=2.91423e-19 \
 //x=81.52 //y=0.175 //x2=83.185 //y2=1.675
cc_8363 ( N_GND_c_14788_n N_noxref_54_c_16720_n ) capacitor c=0.0113631f \
 //x=85.945 //y=0.175 //x2=84.07 //y2=0.71
cc_8364 ( N_GND_c_14719_n N_noxref_54_c_16720_n ) capacitor c=0.0374965f \
 //x=84.68 //y=0.175 //x2=84.07 //y2=0.71
cc_8365 ( N_GND_c_14788_n N_noxref_54_c_16754_n ) capacitor c=0.00251499f \
 //x=85.945 //y=0.175 //x2=84.155 //y2=0.795
cc_8366 ( N_GND_c_14719_n N_noxref_54_c_16754_n ) capacitor c=0.0144994f \
 //x=84.68 //y=0.175 //x2=84.155 //y2=0.795
cc_8367 ( N_GND_c_14831_n N_noxref_54_c_16754_n ) capacitor c=0.0528624f \
 //x=84.85 //y=0.175 //x2=84.155 //y2=0.795
cc_8368 ( N_GND_c_14853_n N_noxref_54_M50_noxref_s ) capacitor c=0.0045077f \
 //x=82.615 //y=0.175 //x2=82.08 //y2=0.545
cc_8369 ( N_GND_c_14668_n N_noxref_54_M50_noxref_s ) capacitor c=0.025162f \
 //x=82.7 //y=1.015 //x2=82.08 //y2=0.545
cc_8370 ( N_GND_c_14719_n N_noxref_54_M50_noxref_s ) capacitor c=0.0144994f \
 //x=84.68 //y=0.175 //x2=82.08 //y2=0.545
cc_8371 ( N_GND_c_14750_n N_noxref_54_M50_noxref_s ) capacitor c=0.0536455f \
 //x=81.52 //y=0.175 //x2=82.08 //y2=0.545
cc_8372 ( N_GND_c_14831_n N_noxref_54_M50_noxref_s ) capacitor c=0.00291802f \
 //x=84.85 //y=0.175 //x2=82.08 //y2=0.545
cc_8373 ( N_GND_M50_noxref_d N_noxref_54_M50_noxref_s ) capacitor c=0.0296559f \
 //x=82.51 //y=1.045 //x2=82.08 //y2=0.545
cc_8374 ( N_GND_c_14788_n N_noxref_55_c_16771_n ) capacitor c=9.5216e-19 \
 //x=85.945 //y=0.175 //x2=86.43 //y2=1.76
cc_8375 ( N_GND_c_14791_n N_noxref_55_c_16771_n ) capacitor c=0.0048201f \
 //x=86.03 //y=1.02 //x2=86.43 //y2=1.76
cc_8376 ( N_GND_c_14854_n N_noxref_55_c_16771_n ) capacitor c=0.00204479f \
 //x=87.44 //y=0.18 //x2=86.43 //y2=1.76
cc_8377 ( N_GND_c_14806_n N_noxref_55_c_16771_n ) capacitor c=0.00357558f \
 //x=87.44 //y=0.18 //x2=86.43 //y2=1.76
cc_8378 ( N_GND_M52_noxref_d N_noxref_55_c_16771_n ) capacitor c=0.00579662f \
 //x=85.84 //y=1.045 //x2=86.43 //y2=1.76
cc_8379 ( N_GND_c_14791_n N_noxref_55_c_16813_n ) capacitor c=0.0167642f \
 //x=86.03 //y=1.02 //x2=86.515 //y2=0.795
cc_8380 ( N_GND_c_14854_n N_noxref_55_c_16813_n ) capacitor c=0.00310354f \
 //x=87.44 //y=0.18 //x2=86.515 //y2=0.795
cc_8381 ( N_GND_c_14806_n N_noxref_55_c_16813_n ) capacitor c=0.0147212f \
 //x=87.44 //y=0.18 //x2=86.515 //y2=0.795
cc_8382 ( N_GND_c_14831_n N_noxref_55_c_16813_n ) capacitor c=0.00225073f \
 //x=84.85 //y=0.175 //x2=86.515 //y2=0.795
cc_8383 ( N_GND_c_14831_n N_noxref_55_c_16778_n ) capacitor c=2.86846e-19 \
 //x=84.85 //y=0.175 //x2=86.515 //y2=1.675
cc_8384 ( N_GND_c_14854_n N_noxref_55_c_16787_n ) capacitor c=0.00940517f \
 //x=87.44 //y=0.18 //x2=87.4 //y2=0.71
cc_8385 ( N_GND_c_14806_n N_noxref_55_c_16787_n ) capacitor c=0.0375173f \
 //x=87.44 //y=0.18 //x2=87.4 //y2=0.71
cc_8386 ( N_GND_c_14854_n N_noxref_55_c_16820_n ) capacitor c=0.00364318f \
 //x=87.44 //y=0.18 //x2=87.485 //y2=0.795
cc_8387 ( N_GND_c_14806_n N_noxref_55_c_16820_n ) capacitor c=0.0571907f \
 //x=87.44 //y=0.18 //x2=87.485 //y2=0.795
cc_8388 ( N_GND_c_14788_n N_noxref_55_M52_noxref_s ) capacitor c=0.00251499f \
 //x=85.945 //y=0.175 //x2=85.41 //y2=0.545
cc_8389 ( N_GND_c_14791_n N_noxref_55_M52_noxref_s ) capacitor c=0.0256947f \
 //x=86.03 //y=1.02 //x2=85.41 //y2=0.545
cc_8390 ( N_GND_c_14806_n N_noxref_55_M52_noxref_s ) capacitor c=0.0205269f \
 //x=87.44 //y=0.18 //x2=85.41 //y2=0.545
cc_8391 ( N_GND_c_14831_n N_noxref_55_M52_noxref_s ) capacitor c=0.0528977f \
 //x=84.85 //y=0.175 //x2=85.41 //y2=0.545
cc_8392 ( N_GND_M52_noxref_d N_noxref_55_M52_noxref_s ) capacitor c=0.0272383f \
 //x=85.84 //y=1.045 //x2=85.41 //y2=0.545
cc_8393 ( N_noxref_37_c_15657_n N_noxref_38_c_15716_n ) capacitor \
 c=6.40432e-19 //x=11.775 //y=1.675 //x2=14.03 //y2=1.685
cc_8394 ( N_noxref_37_c_15703_n N_noxref_38_M8_noxref_s ) capacitor \
 c=0.00453771f //x=12.745 //y=0.795 //x2=13.895 //y2=0.555
cc_8395 ( N_noxref_37_M6_noxref_s N_noxref_38_M8_noxref_s ) capacitor \
 c=6.40432e-19 //x=10.67 //y=0.545 //x2=13.895 //y2=0.555
cc_8396 ( N_noxref_40_c_15840_n N_noxref_41_c_15899_n ) capacitor \
 c=6.40432e-19 //x=24.725 //y=1.675 //x2=26.98 //y2=1.685
cc_8397 ( N_noxref_40_c_15886_n N_noxref_41_M16_noxref_s ) capacitor \
 c=0.00453771f //x=25.695 //y=0.795 //x2=26.845 //y2=0.555
cc_8398 ( N_noxref_40_M14_noxref_s N_noxref_41_M16_noxref_s ) capacitor \
 c=6.40432e-19 //x=23.62 //y=0.545 //x2=26.845 //y2=0.555
cc_8399 ( N_noxref_43_c_16025_n N_noxref_44_c_16084_n ) capacitor \
 c=6.40432e-19 //x=37.675 //y=1.675 //x2=39.93 //y2=1.685
cc_8400 ( N_noxref_43_c_16071_n N_noxref_44_M24_noxref_s ) capacitor \
 c=0.00453771f //x=38.645 //y=0.795 //x2=39.795 //y2=0.555
cc_8401 ( N_noxref_43_M22_noxref_s N_noxref_44_M24_noxref_s ) capacitor \
 c=6.40432e-19 //x=36.57 //y=0.545 //x2=39.795 //y2=0.555
cc_8402 ( N_noxref_46_c_16208_n N_noxref_47_c_16277_n ) capacitor \
 c=6.40432e-19 //x=50.625 //y=1.675 //x2=52.88 //y2=1.685
cc_8403 ( N_noxref_46_c_16254_n N_noxref_47_M32_noxref_s ) capacitor \
 c=0.00453771f //x=51.595 //y=0.795 //x2=52.745 //y2=0.555
cc_8404 ( N_noxref_46_M30_noxref_s N_noxref_47_M32_noxref_s ) capacitor \
 c=6.40432e-19 //x=49.52 //y=0.545 //x2=52.745 //y2=0.555
cc_8405 ( N_noxref_49_c_16387_n N_noxref_50_c_16462_n ) capacitor \
 c=6.40432e-19 //x=63.575 //y=1.675 //x2=65.83 //y2=1.685
cc_8406 ( N_noxref_49_c_16439_n N_noxref_50_M40_noxref_s ) capacitor \
 c=0.00453771f //x=64.545 //y=0.795 //x2=65.695 //y2=0.555
cc_8407 ( N_noxref_49_M38_noxref_s N_noxref_50_M40_noxref_s ) capacitor \
 c=6.40432e-19 //x=62.47 //y=0.545 //x2=65.695 //y2=0.555
cc_8408 ( N_noxref_52_c_16576_n N_noxref_53_c_16635_n ) capacitor \
 c=5.34352e-19 //x=76.525 //y=1.675 //x2=78.885 //y2=1.675
cc_8409 ( N_noxref_52_c_16622_n N_noxref_53_M48_noxref_s ) capacitor \
 c=0.00453248f //x=77.495 //y=0.795 //x2=78.75 //y2=0.545
cc_8410 ( N_noxref_52_M46_noxref_s N_noxref_53_M48_noxref_s ) capacitor \
 c=5.34352e-19 //x=75.42 //y=0.545 //x2=78.75 //y2=0.545
cc_8411 ( N_noxref_53_M48_noxref_s N_noxref_54_c_16704_n ) capacitor \
 c=0.00220043f //x=78.75 //y=0.545 //x2=82.215 //y2=1.675
cc_8412 ( N_noxref_53_c_16690_n N_noxref_54_M50_noxref_s ) capacitor \
 c=0.00220043f //x=80.825 //y=0.795 //x2=82.08 //y2=0.545
cc_8413 ( N_noxref_54_M50_noxref_s N_noxref_55_c_16767_n ) capacitor \
 c=0.00243895f //x=82.08 //y=0.545 //x2=85.545 //y2=1.675
cc_8414 ( N_noxref_54_c_16754_n N_noxref_55_M52_noxref_s ) capacitor \
 c=0.00243895f //x=84.155 //y=0.795 //x2=85.41 //y2=0.545
