// File: XOR2X1.spi.pex
// Created: Sun Apr 12 08:38:23 2026
// Program "Calibre xRC"
// Version "v2023.2_27.15"
// Nominal Temperature: 30C
// Circuit Temperature: 30C
//
simulator lang=spectre
subckt PM_XOR2X1\%A ( 1 2 3 4 5 6 7 8 9 10 11 12 13 20 21 23 28 29 32 50 55 56 \
 59 68 73 82 86 87 88 89 90 91 92 93 94 95 99 100 101 103 109 110 111 112 113 \
 114 118 120 123 124 129 143 )
c235 ( 143 0 ) capacitor c=0.066434f //x=3.82 //y=4.88
c236 ( 129 0 ) capacitor c=0.0564228f //x=1.23 //y=2.265
c237 ( 124 0 ) capacitor c=0.0318956f //x=4.155 //y=1.395
c238 ( 123 0 ) capacitor c=0.0186836f //x=4.155 //y=1.05
c239 ( 120 0 ) capacitor c=0.0141821f //x=4 //y=1.55
c240 ( 118 0 ) capacitor c=0.0158569f //x=4 //y=0.895
c241 ( 114 0 ) capacitor c=0.0900967f //x=3.625 //y=2.1
c242 ( 113 0 ) capacitor c=0.0230021f //x=3.625 //y=1.705
c243 ( 112 0 ) capacitor c=0.0234359f //x=3.625 //y=1.395
c244 ( 111 0 ) capacitor c=0.0198787f //x=3.625 //y=1.05
c245 ( 110 0 ) capacitor c=0.0439576f //x=1.87 //y=1.435
c246 ( 109 0 ) capacitor c=0.0201087f //x=1.87 //y=1.09
c247 ( 103 0 ) capacitor c=0.0161986f //x=1.715 //y=1.59
c248 ( 101 0 ) capacitor c=0.0157807f //x=1.715 //y=0.935
c249 ( 100 0 ) capacitor c=0.0497323f //x=1.46 //y=4.97
c250 ( 99 0 ) capacitor c=0.0399032f //x=1.75 //y=4.97
c251 ( 95 0 ) capacitor c=0.0301471f //x=1.34 //y=2.1
c252 ( 94 0 ) capacitor c=0.0255349f //x=1.34 //y=1.745
c253 ( 93 0 ) capacitor c=0.0234346f //x=1.34 //y=1.435
c254 ( 92 0 ) capacitor c=0.02013f //x=1.34 //y=1.09
c255 ( 91 0 ) capacitor c=0.110998f //x=4.16 //y=6.2
c256 ( 90 0 ) capacitor c=0.155253f //x=3.72 //y=6.2
c257 ( 89 0 ) capacitor c=0.153944f //x=1.825 //y=6.2
c258 ( 88 0 ) capacitor c=0.154411f //x=1.385 //y=6.2
c259 ( 82 0 ) capacitor c=0.00101672f //x=3.82 //y=4.88
c260 ( 73 0 ) capacitor c=0.00134654f //x=3.82 //y=2.265
c261 ( 68 0 ) capacitor c=6.76693e-19 //x=1.23 //y=4.88
c262 ( 59 0 ) capacitor c=9.11699e-19 //x=1.23 //y=2.265
c263 ( 56 0 ) capacitor c=0.0790837f //x=3.655 //y=4.255
c264 ( 55 0 ) capacitor c=0.00269492f //x=3.815 //y=4.255
c265 ( 50 0 ) capacitor c=0.0100228f //x=1.39 //y=4.25
c266 ( 32 0 ) capacitor c=0.0139259f //x=1.23 //y=2.265
c267 ( 29 0 ) capacitor c=0.00548543f //x=3.82 //y=4.765
c268 ( 28 0 ) capacitor c=0.0120877f //x=3.82 //y=4.415
c269 ( 23 0 ) capacitor c=0.00729001f //x=3.82 //y=2.42
c270 ( 21 0 ) capacitor c=0.00952436f //x=1.23 //y=4.76
c271 ( 20 0 ) capacitor c=0.0121029f //x=1.23 //y=4.41
c272 ( 13 0 ) capacitor c=0.0152624f //x=3.82 //y=4.25
c273 ( 11 0 ) capacitor c=0.0154384f //x=1.23 //y=4.25
c274 ( 9 0 ) capacitor c=0.00786414f //x=3.82 //y=4.62
c275 ( 6 0 ) capacitor c=0.0569556f //x=3.82 //y=3.14
c276 ( 5 0 ) capacitor c=0.00884265f //x=1.23 //y=4.62
c277 ( 1 0 ) capacitor c=0.0760032f //x=1.23 //y=2.77
r278 (  141 143 ) resistor r=20.6867 //w=0.233 //l=0.1 //layer=ply \
 //thickness=0.18 //x=3.72 //y=4.88 //x2=3.82 //y2=4.88
r279 (  129 130 ) resistor r=17.5563 //w=0.302 //l=0.11 //layer=ply \
 //thickness=0.18 //x=1.23 //y=2.265 //x2=1.34 //y2=2.265
r280 (  125 143 ) resistor r=70.3348 //w=0.233 //l=0.414367 //layer=ply \
 //thickness=0.18 //x=4.16 //y=5.045 //x2=3.82 //y2=4.88
r281 (  124 145 ) resistor r=45.1352 //w=0.168 //l=0.173853 //layer=ply \
 //thickness=0.18 //x=4.155 //y=1.395 //x2=4.115 //y2=1.55
r282 (  123 144 ) resistor r=45.1352 //w=0.168 //l=0.173853 //layer=ply \
 //thickness=0.18 //x=4.155 //y=1.05 //x2=4.115 //y2=0.895
r283 (  123 124 ) resistor r=176.904 //w=0.094 //l=0.345 //layer=ply \
 //thickness=0.18 //x=4.155 //y=1.05 //x2=4.155 //y2=1.395
r284 (  121 140 ) resistor r=10.701 //w=0.21 //l=0.115 //layer=ply \
 //thickness=0.18 //x=3.78 //y=1.55 //x2=3.665 //y2=1.55
r285 (  120 145 ) resistor r=5.52526 //w=0.168 //l=0.115 //layer=ply \
 //thickness=0.18 //x=4 //y=1.55 //x2=4.115 //y2=1.55
r286 (  119 139 ) resistor r=5.52526 //w=0.168 //l=0.115 //layer=ply \
 //thickness=0.18 //x=3.78 //y=0.895 //x2=3.665 //y2=0.895
r287 (  118 144 ) resistor r=5.52526 //w=0.168 //l=0.115 //layer=ply \
 //thickness=0.18 //x=4 //y=0.895 //x2=4.115 //y2=0.895
r288 (  118 119 ) resistor r=112.809 //w=0.094 //l=0.22 //layer=ply \
 //thickness=0.18 //x=4 //y=0.895 //x2=3.78 //y2=0.895
r289 (  115 141 ) resistor r=13.0941 //w=0.233 //l=0.165 //layer=ply \
 //thickness=0.18 //x=3.72 //y=5.045 //x2=3.72 //y2=4.88
r290 (  114 138 ) resistor r=34.8111 //w=0.27 //l=0.264953 //layer=ply \
 //thickness=0.18 //x=3.625 //y=2.1 //x2=3.82 //y2=2.265
r291 (  113 140 ) resistor r=39.5823 //w=0.21 //l=0.173853 //layer=ply \
 //thickness=0.18 //x=3.625 //y=1.705 //x2=3.665 //y2=1.55
r292 (  113 114 ) resistor r=202.543 //w=0.094 //l=0.395 //layer=ply \
 //thickness=0.18 //x=3.625 //y=1.705 //x2=3.625 //y2=2.1
r293 (  112 140 ) resistor r=39.5823 //w=0.21 //l=0.173853 //layer=ply \
 //thickness=0.18 //x=3.625 //y=1.395 //x2=3.665 //y2=1.55
r294 (  111 139 ) resistor r=45.1352 //w=0.168 //l=0.173853 //layer=ply \
 //thickness=0.18 //x=3.625 //y=1.05 //x2=3.665 //y2=0.895
r295 (  111 112 ) resistor r=176.904 //w=0.094 //l=0.345 //layer=ply \
 //thickness=0.18 //x=3.625 //y=1.05 //x2=3.625 //y2=1.395
r296 (  110 136 ) resistor r=45.1352 //w=0.168 //l=0.173853 //layer=ply \
 //thickness=0.18 //x=1.87 //y=1.435 //x2=1.83 //y2=1.59
r297 (  109 135 ) resistor r=45.1352 //w=0.168 //l=0.173853 //layer=ply \
 //thickness=0.18 //x=1.87 //y=1.09 //x2=1.83 //y2=0.935
r298 (  109 110 ) resistor r=176.904 //w=0.094 //l=0.345 //layer=ply \
 //thickness=0.18 //x=1.87 //y=1.09 //x2=1.87 //y2=1.435
r299 (  104 134 ) resistor r=10.701 //w=0.21 //l=0.115 //layer=ply \
 //thickness=0.18 //x=1.495 //y=1.59 //x2=1.38 //y2=1.59
r300 (  103 136 ) resistor r=5.52526 //w=0.168 //l=0.115 //layer=ply \
 //thickness=0.18 //x=1.715 //y=1.59 //x2=1.83 //y2=1.59
r301 (  102 133 ) resistor r=5.52526 //w=0.168 //l=0.115 //layer=ply \
 //thickness=0.18 //x=1.495 //y=0.935 //x2=1.38 //y2=0.935
r302 (  101 135 ) resistor r=5.52526 //w=0.168 //l=0.115 //layer=ply \
 //thickness=0.18 //x=1.715 //y=0.935 //x2=1.83 //y2=0.935
r303 (  101 102 ) resistor r=112.809 //w=0.094 //l=0.22 //layer=ply \
 //thickness=0.18 //x=1.715 //y=0.935 //x2=1.495 //y2=0.935
r304 (  99 106 ) resistor r=26.9307 //w=0.15 //l=0.106066 //layer=ply \
 //thickness=0.18 //x=1.75 //y=4.97 //x2=1.825 //y2=5.045
r305 (  99 100 ) resistor r=148.702 //w=0.094 //l=0.29 //layer=ply \
 //thickness=0.18 //x=1.75 //y=4.97 //x2=1.46 //y2=4.97
r306 (  96 100 ) resistor r=23.403 //w=0.284 //l=0.106066 //layer=ply \
 //thickness=0.18 //x=1.385 //y=5.045 //x2=1.46 //y2=4.97
r307 (  96 132 ) resistor r=26.3063 //w=0.284 //l=0.229783 //layer=ply \
 //thickness=0.18 //x=1.385 //y=5.045 //x2=1.23 //y2=4.88
r308 (  95 130 ) resistor r=19.1248 //w=0.302 //l=0.165 //layer=ply \
 //thickness=0.18 //x=1.34 //y=2.1 //x2=1.34 //y2=2.265
r309 (  94 134 ) resistor r=39.5823 //w=0.21 //l=0.173853 //layer=ply \
 //thickness=0.18 //x=1.34 //y=1.745 //x2=1.38 //y2=1.59
r310 (  94 95 ) resistor r=182.032 //w=0.094 //l=0.355 //layer=ply \
 //thickness=0.18 //x=1.34 //y=1.745 //x2=1.34 //y2=2.1
r311 (  93 134 ) resistor r=39.5823 //w=0.21 //l=0.173853 //layer=ply \
 //thickness=0.18 //x=1.34 //y=1.435 //x2=1.38 //y2=1.59
r312 (  92 133 ) resistor r=45.1352 //w=0.168 //l=0.173853 //layer=ply \
 //thickness=0.18 //x=1.34 //y=1.09 //x2=1.38 //y2=0.935
r313 (  92 93 ) resistor r=176.904 //w=0.094 //l=0.345 //layer=ply \
 //thickness=0.18 //x=1.34 //y=1.09 //x2=1.34 //y2=1.435
r314 (  91 125 ) resistor r=592.245 //w=0.094 //l=1.155 //layer=ply \
 //thickness=0.18 //x=4.16 //y=6.2 //x2=4.16 //y2=5.045
r315 (  90 115 ) resistor r=592.245 //w=0.094 //l=1.155 //layer=ply \
 //thickness=0.18 //x=3.72 //y=6.2 //x2=3.72 //y2=5.045
r316 (  89 106 ) resistor r=592.245 //w=0.094 //l=1.155 //layer=ply \
 //thickness=0.18 //x=1.825 //y=6.2 //x2=1.825 //y2=5.045
r317 (  88 96 ) resistor r=592.245 //w=0.094 //l=1.155 //layer=ply \
 //thickness=0.18 //x=1.385 //y=6.2 //x2=1.385 //y2=5.045
r318 (  87 120 ) resistor r=56.4043 //w=0.094 //l=0.11 //layer=ply \
 //thickness=0.18 //x=3.89 //y=1.55 //x2=4 //y2=1.55
r319 (  87 121 ) resistor r=56.4043 //w=0.094 //l=0.11 //layer=ply \
 //thickness=0.18 //x=3.89 //y=1.55 //x2=3.78 //y2=1.55
r320 (  86 103 ) resistor r=56.4043 //w=0.094 //l=0.11 //layer=ply \
 //thickness=0.18 //x=1.605 //y=1.59 //x2=1.715 //y2=1.59
r321 (  86 104 ) resistor r=56.4043 //w=0.094 //l=0.11 //layer=ply \
 //thickness=0.18 //x=1.605 //y=1.59 //x2=1.495 //y2=1.59
r322 (  82 143 ) resistor r=152 //w=0.17 //l=0.17 //layer=licon //count=1 \
 //x=3.82 //y=4.88 //x2=3.82 //y2=4.88
r323 (  73 138 ) resistor r=152 //w=0.17 //l=0.17 //layer=licon //count=1 \
 //x=3.82 //y=2.265 //x2=3.82 //y2=2.265
r324 (  68 132 ) resistor r=152 //w=0.17 //l=0.17 //layer=licon //count=1 \
 //x=1.23 //y=4.88 //x2=1.23 //y2=4.88
r325 (  59 129 ) resistor r=152 //w=0.17 //l=0.17 //layer=licon //count=1 \
 //x=1.23 //y=2.265 //x2=1.23 //y2=2.265
r326 (  55 56 ) resistor r=0.10734 //w=0.281 //l=0.16 //layer=m2 \
 //thickness=0.36 //x=3.815 //y=4.255 //x2=3.655 //y2=4.255
r327 (  50 52 ) resistor r=0.10734 //w=0.281 //l=0.16 //layer=m2 \
 //thickness=0.36 //x=1.39 //y=4.25 //x2=1.23 //y2=4.25
r328 (  50 56 ) resistor r=2.16126 //w=0.131 //l=2.265 //layer=m2 \
 //thickness=0.36 //x=1.39 //y=4.25 //x2=3.655 //y2=4.25
r329 (  48 82 ) resistor r=9.3 //w=0.17 //l=0.17 //layer=mcon //count=1 \
 //x=3.82 //y=4.88 //x2=3.82 //y2=4.88
r330 (  45 73 ) resistor r=9.3 //w=0.17 //l=0.17 //layer=mcon //count=1 \
 //x=3.82 //y=2.265 //x2=3.82 //y2=2.265
r331 (  43 55 ) resistor r=4.5 //w=0.15 //l=0.15 //layer=via1 //count=1 \
 //x=3.815 //y=4.255 //x2=3.815 //y2=4.255
r332 (  36 68 ) resistor r=9.3 //w=0.17 //l=0.17 //layer=mcon //count=1 \
 //x=1.23 //y=4.88 //x2=1.23 //y2=4.88
r333 (  32 59 ) resistor r=9.3 //w=0.17 //l=0.17 //layer=mcon //count=1 \
 //x=1.23 //y=2.265 //x2=1.23 //y2=2.265
r334 (  29 48 ) resistor r=0.0717383 //w=0.224 //l=0.115 //layer=m1 \
 //thickness=0.36 //x=3.82 //y=4.765 //x2=3.82 //y2=4.88
r335 (  28 43 ) resistor r=0.0910802 //w=0.374 //l=0.185472 //layer=m1 \
 //thickness=0.36 //x=3.82 //y=4.415 //x2=3.765 //y2=4.255
r336 (  21 36 ) resistor r=0.0731974 //w=0.242 //l=0.122474 //layer=m1 \
 //thickness=0.36 //x=1.23 //y=4.76 //x2=1.235 //y2=4.88
r337 (  13 43 ) resistor r=0.00167112 //w=0.374 //l=0.005 //layer=m1 \
 //thickness=0.36 //x=3.765 //y=4.25 //x2=3.765 //y2=4.255
r338 (  13 24 ) resistor r=0.089409 //w=0.374 //l=0.180416 //layer=m1 \
 //thickness=0.36 //x=3.765 //y=4.25 //x2=3.82 //y2=4.095
r339 (  12 23 ) resistor r=0.0210553 //w=0.239 //l=0.0214476 //layer=m1 \
 //thickness=0.36 //x=3.817 //y=2.4 //x2=3.82 //y2=2.42
r340 (  12 45 ) resistor r=0.0706067 //w=0.239 //l=0.135 //layer=m1 \
 //thickness=0.36 //x=3.817 //y=2.4 //x2=3.817 //y2=2.265
r341 (  11 52 ) resistor r=4.5 //w=0.15 //l=0.15 //layer=via1 //count=1 \
 //x=1.23 //y=4.25 //x2=1.23 //y2=4.25
r342 (  11 20 ) resistor r=0.0911593 //w=0.376 //l=0.184174 //layer=m1 \
 //thickness=0.36 //x=1.282 //y=4.25 //x2=1.23 //y2=4.41
r343 (  11 15 ) resistor r=0.0911593 //w=0.376 //l=0.184174 //layer=m1 \
 //thickness=0.36 //x=1.282 //y=4.25 //x2=1.23 //y2=4.09
r344 (  10 14 ) resistor r=0.0360744 //w=0.211 //l=0.03 //layer=m1 \
 //thickness=0.36 //x=1.23 //y=2.4 //x2=1.23 //y2=2.43
r345 (  10 32 ) resistor r=0.0799763 //w=0.211 //l=0.135 //layer=m1 \
 //thickness=0.36 //x=1.23 //y=2.4 //x2=1.23 //y2=2.265
r346 (  9 29 ) resistor r=0.138359 //w=0.131 //l=0.145 //layer=m1 \
 //thickness=0.36 //x=3.82 //y=4.62 //x2=3.82 //y2=4.765
r347 (  9 28 ) resistor r=0.195611 //w=0.131 //l=0.205 //layer=m1 \
 //thickness=0.36 //x=3.82 //y=4.62 //x2=3.82 //y2=4.415
r348 (  8 24 ) resistor r=0.205153 //w=0.131 //l=0.215 //layer=m1 \
 //thickness=0.36 //x=3.82 //y=3.88 //x2=3.82 //y2=4.095
r349 (  7 8 ) resistor r=0.353053 //w=0.131 //l=0.37 //layer=m1 \
 //thickness=0.36 //x=3.82 //y=3.51 //x2=3.82 //y2=3.88
r350 (  6 7 ) resistor r=0.353053 //w=0.131 //l=0.37 //layer=m1 \
 //thickness=0.36 //x=3.82 //y=3.14 //x2=3.82 //y2=3.51
r351 (  6 23 ) resistor r=0.687023 //w=0.131 //l=0.72 //layer=m1 \
 //thickness=0.36 //x=3.82 //y=3.14 //x2=3.82 //y2=2.42
r352 (  5 21 ) resistor r=0.133588 //w=0.131 //l=0.14 //layer=m1 \
 //thickness=0.36 //x=1.23 //y=4.62 //x2=1.23 //y2=4.76
r353 (  5 20 ) resistor r=0.200382 //w=0.131 //l=0.21 //layer=m1 \
 //thickness=0.36 //x=1.23 //y=4.62 //x2=1.23 //y2=4.41
r354 (  4 15 ) resistor r=0.200382 //w=0.131 //l=0.21 //layer=m1 \
 //thickness=0.36 //x=1.23 //y=3.88 //x2=1.23 //y2=4.09
r355 (  3 4 ) resistor r=0.353053 //w=0.131 //l=0.37 //layer=m1 \
 //thickness=0.36 //x=1.23 //y=3.51 //x2=1.23 //y2=3.88
r356 (  2 3 ) resistor r=0.353053 //w=0.131 //l=0.37 //layer=m1 \
 //thickness=0.36 //x=1.23 //y=3.14 //x2=1.23 //y2=3.51
r357 (  1 2 ) resistor r=0.353053 //w=0.131 //l=0.37 //layer=m1 \
 //thickness=0.36 //x=1.23 //y=2.77 //x2=1.23 //y2=3.14
r358 (  1 14 ) resistor r=0.324427 //w=0.131 //l=0.34 //layer=m1 \
 //thickness=0.36 //x=1.23 //y=2.77 //x2=1.23 //y2=2.43
ends PM_XOR2X1\%A

subckt PM_XOR2X1\%noxref_2 ( 2 4 5 6 7 8 10 11 12 13 14 15 16 18 23 28 31 35 \
 40 41 49 61 70 74 75 76 77 78 79 80 84 86 92 93 101 103 105 )
c289 ( 103 0 ) capacitor c=0.00869746f //x=1.415 //y=1.09
c290 ( 101 0 ) capacitor c=0.069457f //x=8.26 //y=4.88
c291 ( 93 0 ) capacitor c=0.0423887f //x=8.455 //y=1.435
c292 ( 92 0 ) capacitor c=0.0191585f //x=8.455 //y=1.09
c293 ( 86 0 ) capacitor c=0.0125357f //x=8.3 //y=1.59
c294 ( 84 0 ) capacitor c=0.0157807f //x=8.3 //y=0.935
c295 ( 80 0 ) capacitor c=0.0959389f //x=7.925 //y=2.1
c296 ( 79 0 ) capacitor c=0.0197088f //x=7.925 //y=1.745
c297 ( 78 0 ) capacitor c=0.0168511f //x=7.925 //y=1.435
c298 ( 77 0 ) capacitor c=0.0174128f //x=7.925 //y=1.09
c299 ( 76 0 ) capacitor c=0.155893f //x=8.37 //y=6.2
c300 ( 75 0 ) capacitor c=0.110553f //x=7.93 //y=6.2
c301 ( 70 0 ) capacitor c=8.33342e-19 //x=8.26 //y=4.88
c302 ( 61 0 ) capacitor c=6.44043e-19 //x=8.26 //y=2.265
c303 ( 49 0 ) capacitor c=0.0261398f //x=1.605 //y=5.56
c304 ( 41 0 ) capacitor c=0.180402f //x=8.085 //y=2.755
c305 ( 40 0 ) capacitor c=0.00351837f //x=8.245 //y=2.755
c306 ( 35 0 ) capacitor c=0.00290249f //x=2.13 //y=2.77
c307 ( 31 0 ) capacitor c=0.00861163f //x=8.14 //y=4.877
c308 ( 28 0 ) capacitor c=0.0149988f //x=8.26 //y=2.77
c309 ( 23 0 ) capacitor c=0.0140935f //x=1.97 //y=2.77
c310 ( 18 0 ) capacitor c=0.0191391f //x=1.6 //y=1.185
c311 ( 16 0 ) capacitor c=0.00313372f //x=8.26 //y=2.595
c312 ( 15 0 ) capacitor c=0.00460007f //x=8.26 //y=2.41
c313 ( 14 0 ) capacitor c=0.0399807f //x=8.14 //y=4.73
c314 ( 13 0 ) capacitor c=0.00872805f //x=8.14 //y=2.915
c315 ( 12 0 ) capacitor c=0.0613235f //x=1.97 //y=5.055
c316 ( 11 0 ) capacitor c=0.0126342f //x=1.97 //y=2.93
c317 ( 10 0 ) capacitor c=0.00946852f //x=1.97 //y=2.61
c318 ( 8 0 ) capacitor c=0.00632795f //x=1.69 //y=5.14
c319 ( 7 0 ) capacitor c=0.00769652f //x=1.885 //y=5.14
c320 ( 6 0 ) capacitor c=0.00882254f //x=1.685 //y=2.02
c321 ( 5 0 ) capacitor c=0.0120888f //x=1.885 //y=2.02
c322 ( 4 0 ) capacitor c=0.0119286f //x=1.605 //y=5.42
c323 ( 2 0 ) capacitor c=0.0184592f //x=1.6 //y=1.935
r324 (  101 102 ) resistor r=22.7554 //w=0.233 //l=0.11 //layer=ply \
 //thickness=0.18 //x=8.26 //y=4.88 //x2=8.37 //y2=4.88
r325 (  93 99 ) resistor r=45.1352 //w=0.168 //l=0.173853 //layer=ply \
 //thickness=0.18 //x=8.455 //y=1.435 //x2=8.415 //y2=1.59
r326 (  92 98 ) resistor r=45.1352 //w=0.168 //l=0.173853 //layer=ply \
 //thickness=0.18 //x=8.455 //y=1.09 //x2=8.415 //y2=0.935
r327 (  92 93 ) resistor r=176.904 //w=0.094 //l=0.345 //layer=ply \
 //thickness=0.18 //x=8.455 //y=1.09 //x2=8.455 //y2=1.435
r328 (  89 102 ) resistor r=13.0941 //w=0.233 //l=0.165 //layer=ply \
 //thickness=0.18 //x=8.37 //y=5.045 //x2=8.37 //y2=4.88
r329 (  87 95 ) resistor r=10.701 //w=0.21 //l=0.115 //layer=ply \
 //thickness=0.18 //x=8.08 //y=1.59 //x2=7.965 //y2=1.59
r330 (  86 99 ) resistor r=5.52526 //w=0.168 //l=0.115 //layer=ply \
 //thickness=0.18 //x=8.3 //y=1.59 //x2=8.415 //y2=1.59
r331 (  85 94 ) resistor r=5.52526 //w=0.168 //l=0.115 //layer=ply \
 //thickness=0.18 //x=8.08 //y=0.935 //x2=7.965 //y2=0.935
r332 (  84 98 ) resistor r=5.52526 //w=0.168 //l=0.115 //layer=ply \
 //thickness=0.18 //x=8.3 //y=0.935 //x2=8.415 //y2=0.935
r333 (  84 85 ) resistor r=112.809 //w=0.094 //l=0.22 //layer=ply \
 //thickness=0.18 //x=8.3 //y=0.935 //x2=8.08 //y2=0.935
r334 (  81 101 ) resistor r=68.2661 //w=0.233 //l=0.404166 //layer=ply \
 //thickness=0.18 //x=7.93 //y=5.045 //x2=8.26 //y2=4.88
r335 (  80 97 ) resistor r=67.2792 //w=0.24 //l=0.438891 //layer=ply \
 //thickness=0.18 //x=7.925 //y=2.1 //x2=8.26 //y2=2.34
r336 (  79 95 ) resistor r=39.5823 //w=0.21 //l=0.173853 //layer=ply \
 //thickness=0.18 //x=7.925 //y=1.745 //x2=7.965 //y2=1.59
r337 (  79 80 ) resistor r=182.032 //w=0.094 //l=0.355 //layer=ply \
 //thickness=0.18 //x=7.925 //y=1.745 //x2=7.925 //y2=2.1
r338 (  78 95 ) resistor r=39.5823 //w=0.21 //l=0.173853 //layer=ply \
 //thickness=0.18 //x=7.925 //y=1.435 //x2=7.965 //y2=1.59
r339 (  77 94 ) resistor r=45.1352 //w=0.168 //l=0.173853 //layer=ply \
 //thickness=0.18 //x=7.925 //y=1.09 //x2=7.965 //y2=0.935
r340 (  77 78 ) resistor r=176.904 //w=0.094 //l=0.345 //layer=ply \
 //thickness=0.18 //x=7.925 //y=1.09 //x2=7.925 //y2=1.435
r341 (  76 89 ) resistor r=592.245 //w=0.094 //l=1.155 //layer=ply \
 //thickness=0.18 //x=8.37 //y=6.2 //x2=8.37 //y2=5.045
r342 (  75 81 ) resistor r=592.245 //w=0.094 //l=1.155 //layer=ply \
 //thickness=0.18 //x=7.93 //y=6.2 //x2=7.93 //y2=5.045
r343 (  74 86 ) resistor r=56.4043 //w=0.094 //l=0.11 //layer=ply \
 //thickness=0.18 //x=8.19 //y=1.59 //x2=8.3 //y2=1.59
r344 (  74 87 ) resistor r=56.4043 //w=0.094 //l=0.11 //layer=ply \
 //thickness=0.18 //x=8.19 //y=1.59 //x2=8.08 //y2=1.59
r345 (  70 101 ) resistor r=152 //w=0.17 //l=0.17 //layer=licon //count=1 \
 //x=8.26 //y=4.88 //x2=8.26 //y2=4.88
r346 (  61 97 ) resistor r=152 //w=0.17 //l=0.17 //layer=licon //count=1 \
 //x=8.26 //y=2.265 //x2=8.26 //y2=2.265
r347 (  49 105 ) resistor r=23.615 //w=0.187 //l=0.345 //layer=li \
 //thickness=0.1 //x=1.605 //y=5.56 //x2=1.605 //y2=5.905
r348 (  40 41 ) resistor r=0.10734 //w=0.281 //l=0.16 //layer=m2 \
 //thickness=0.36 //x=8.245 //y=2.755 //x2=8.085 //y2=2.755
r349 (  35 37 ) resistor r=0.10734 //w=0.281 //l=0.16 //layer=m2 \
 //thickness=0.36 //x=2.13 //y=2.77 //x2=1.97 //y2=2.77
r350 (  35 41 ) resistor r=5.68225 //w=0.131 //l=5.955 //layer=m2 \
 //thickness=0.36 //x=2.13 //y=2.77 //x2=8.085 //y2=2.77
r351 (  33 70 ) resistor r=9.3 //w=0.17 //l=0.17 //layer=mcon //count=1 \
 //x=8.26 //y=4.88 //x2=8.26 //y2=4.88
r352 (  31 33 ) resistor r=0.0528169 //w=0.284 //l=0.12 //layer=m1 \
 //thickness=0.36 //x=8.14 //y=4.877 //x2=8.26 //y2=4.877
r353 (  30 61 ) resistor r=9.3 //w=0.17 //l=0.17 //layer=mcon //count=1 \
 //x=8.26 //y=2.265 //x2=8.26 //y2=2.265
r354 (  26 40 ) resistor r=4.5 //w=0.15 //l=0.15 //layer=via1 //count=1 \
 //x=8.245 //y=2.755 //x2=8.245 //y2=2.755
r355 (  26 28 ) resistor r=0.00501337 //w=0.374 //l=0.015 //layer=m1 \
 //thickness=0.36 //x=8.2 //y=2.755 //x2=8.2 //y2=2.77
r356 (  23 37 ) resistor r=4.5 //w=0.15 //l=0.15 //layer=via1 //count=1 \
 //x=1.97 //y=2.77 //x2=1.97 //y2=2.77
r357 (  21 49 ) resistor r=9.3 //w=0.17 //l=0.17 //layer=mcon //count=1 \
 //x=1.605 //y=5.56 //x2=1.605 //y2=5.56
r358 (  18 103 ) resistor r=9.3 //w=0.17 //l=0.17 //layer=mcon //count=1 \
 //x=1.6 //y=1.185 //x2=1.6 //y2=1.185
r359 (  16 26 ) resistor r=0.0910802 //w=0.374 //l=0.187617 //layer=m1 \
 //thickness=0.36 //x=8.26 //y=2.595 //x2=8.2 //y2=2.755
r360 (  15 30 ) resistor r=0.0853765 //w=0.25 //l=0.146492 //layer=m1 \
 //thickness=0.36 //x=8.26 //y=2.41 //x2=8.257 //y2=2.265
r361 (  15 16 ) resistor r=0.176527 //w=0.131 //l=0.185 //layer=m1 \
 //thickness=0.36 //x=8.26 //y=2.41 //x2=8.26 //y2=2.595
r362 (  14 31 ) resistor r=0.0383145 //w=0.284 //l=0.147 //layer=m1 \
 //thickness=0.36 //x=8.14 //y=4.73 //x2=8.14 //y2=4.877
r363 (  13 28 ) resistor r=0.0860668 //w=0.374 //l=0.172409 //layer=m1 \
 //thickness=0.36 //x=8.14 //y=2.915 //x2=8.2 //y2=2.77
r364 (  13 14 ) resistor r=1.73187 //w=0.131 //l=1.815 //layer=m1 \
 //thickness=0.36 //x=8.14 //y=2.915 //x2=8.14 //y2=4.73
r365 (  11 23 ) resistor r=0.0911593 //w=0.376 //l=0.184174 //layer=m1 \
 //thickness=0.36 //x=1.97 //y=2.93 //x2=2.022 //y2=2.77
r366 (  11 12 ) resistor r=2.02767 //w=0.131 //l=2.125 //layer=m1 \
 //thickness=0.36 //x=1.97 //y=2.93 //x2=1.97 //y2=5.055
r367 (  10 23 ) resistor r=0.0911593 //w=0.376 //l=0.184174 //layer=m1 \
 //thickness=0.36 //x=1.97 //y=2.61 //x2=2.022 //y2=2.77
r368 (  9 10 ) resistor r=0.48187 //w=0.131 //l=0.505 //layer=m1 \
 //thickness=0.36 //x=1.97 //y=2.105 //x2=1.97 //y2=2.61
r369 (  7 12 ) resistor r=0.0698411 //w=0.17 //l=0.120208 //layer=m1 \
 //thickness=0.36 //x=1.885 //y=5.14 //x2=1.97 //y2=5.055
r370 (  7 8 ) resistor r=0.186069 //w=0.131 //l=0.195 //layer=m1 \
 //thickness=0.36 //x=1.885 //y=5.14 //x2=1.69 //y2=5.14
r371 (  5 9 ) resistor r=0.0698411 //w=0.17 //l=0.120208 //layer=m1 \
 //thickness=0.36 //x=1.885 //y=2.02 //x2=1.97 //y2=2.105
r372 (  5 6 ) resistor r=0.19084 //w=0.131 //l=0.2 //layer=m1 //thickness=0.36 \
 //x=1.885 //y=2.02 //x2=1.685 //y2=2.02
r373 (  4 21 ) resistor r=0.086672 //w=0.218 //l=0.14 //layer=m1 \
 //thickness=0.36 //x=1.605 //y=5.42 //x2=1.605 //y2=5.56
r374 (  3 8 ) resistor r=0.0698411 //w=0.17 //l=0.120208 //layer=m1 \
 //thickness=0.36 //x=1.605 //y=5.225 //x2=1.69 //y2=5.14
r375 (  3 4 ) resistor r=0.186069 //w=0.131 //l=0.195 //layer=m1 \
 //thickness=0.36 //x=1.605 //y=5.225 //x2=1.605 //y2=5.42
r376 (  2 6 ) resistor r=0.0698411 //w=0.17 //l=0.120208 //layer=m1 \
 //thickness=0.36 //x=1.6 //y=1.935 //x2=1.685 //y2=2.02
r377 (  1 18 ) resistor r=0.105739 //w=0.201 //l=0.145 //layer=m1 \
 //thickness=0.36 //x=1.6 //y=1.33 //x2=1.6 //y2=1.185
r378 (  1 2 ) resistor r=0.57729 //w=0.131 //l=0.605 //layer=m1 \
 //thickness=0.36 //x=1.6 //y=1.33 //x2=1.6 //y2=1.935
ends PM_XOR2X1\%noxref_2

subckt PM_XOR2X1\%Y ( 1 2 3 4 5 6 7 8 9 10 11 12 14 15 20 24 25 26 28 29 34 37 \
 46 60 62 63 66 83 99 100 103 104 )
c294 ( 100 0 ) capacitor c=0.00849198f //x=8 //y=1.09
c295 ( 99 0 ) capacitor c=0.00849198f //x=4.67 //y=1.09
c296 ( 83 0 ) capacitor c=0.0232369f //x=8.15 //y=5.555
c297 ( 66 0 ) capacitor c=0.0235809f //x=4.82 //y=5.555
c298 ( 63 0 ) capacitor c=0.0332019f //x=8.485 //y=3.895
c299 ( 62 0 ) capacitor c=0.0137849f //x=8.645 //y=3.895
c300 ( 60 0 ) capacitor c=0.00975284f //x=5.625 //y=3.895
c301 ( 46 0 ) capacitor c=0.01028f //x=8.15 //y=5.385
c302 ( 37 0 ) capacitor c=0.0123291f //x=4.82 //y=5.385
c303 ( 34 0 ) capacitor c=0.0122447f //x=8.63 //y=4.055
c304 ( 29 0 ) capacitor c=0.00233399f //x=8.275 //y=1.835
c305 ( 28 0 ) capacitor c=0.0103724f //x=8.545 //y=1.835
c306 ( 26 0 ) capacitor c=0.00837307f //x=8.545 //y=5.385
c307 ( 25 0 ) capacitor c=0.00892846f //x=8.19 //y=1.75
c308 ( 24 0 ) capacitor c=0.00950665f //x=8.19 //y=1.3
c309 ( 20 0 ) capacitor c=0.0213684f //x=5.42 //y=4.055
c310 ( 15 0 ) capacitor c=0.00266748f //x=4.945 //y=1.835
c311 ( 14 0 ) capacitor c=0.0136504f //x=5.335 //y=1.835
c312 ( 12 0 ) capacitor c=0.0121686f //x=5.335 //y=5.385
c313 ( 11 0 ) capacitor c=0.00993239f //x=4.86 //y=1.75
c314 ( 10 0 ) capacitor c=0.0101596f //x=4.86 //y=1.305
c315 ( 9 0 ) capacitor c=0.0170398f //x=8.63 //y=3.88
c316 ( 8 0 ) capacitor c=0.0184853f //x=5.3 //y=3.88
c317 ( 7 0 ) capacitor c=0.0240725f //x=8.63 //y=4.99
c318 ( 5 0 ) capacitor c=0.0358152f //x=8.63 //y=2.4
c319 ( 3 0 ) capacitor c=0.0269411f //x=5.42 //y=4.62
c320 ( 1 0 ) capacitor c=0.0460606f //x=5.42 //y=2.4
r321 (  83 104 ) resistor r=23.2727 //w=0.187 //l=0.34 //layer=li \
 //thickness=0.1 //x=8.15 //y=5.555 //x2=8.15 //y2=5.895
r322 (  66 103 ) resistor r=23.2727 //w=0.187 //l=0.34 //layer=li \
 //thickness=0.1 //x=4.82 //y=5.555 //x2=4.82 //y2=5.895
r323 (  62 63 ) resistor r=0.10734 //w=0.281 //l=0.16 //layer=m2 \
 //thickness=0.36 //x=8.645 //y=3.895 //x2=8.485 //y2=3.895
r324 (  60 63 ) resistor r=2.72901 //w=0.131 //l=2.86 //layer=m2 \
 //thickness=0.36 //x=5.625 //y=3.91 //x2=8.485 //y2=3.91
r325 (  58 60 ) resistor r=0.10734 //w=0.281 //l=0.16 //layer=m2 \
 //thickness=0.36 //x=5.465 //y=3.895 //x2=5.625 //y2=3.895
r326 (  54 62 ) resistor r=4.5 //w=0.15 //l=0.15 //layer=via1 //count=1 \
 //x=8.645 //y=3.895 //x2=8.645 //y2=3.895
r327 (  50 100 ) resistor r=9.3 //w=0.17 //l=0.17 //layer=mcon //count=1 \
 //x=8.19 //y=1.185 //x2=8.19 //y2=1.185
r328 (  48 83 ) resistor r=9.3 //w=0.17 //l=0.17 //layer=mcon //count=1 \
 //x=8.15 //y=5.555 //x2=8.15 //y2=5.555
r329 (  46 48 ) resistor r=0.100236 //w=0.212 //l=0.17 //layer=m1 \
 //thickness=0.36 //x=8.15 //y=5.385 //x2=8.15 //y2=5.555
r330 (  45 58 ) resistor r=4.5 //w=0.15 //l=0.15 //layer=via1 //count=1 \
 //x=5.465 //y=3.895 //x2=5.465 //y2=3.895
r331 (  41 99 ) resistor r=9.3 //w=0.17 //l=0.17 //layer=mcon //count=1 \
 //x=4.86 //y=1.185 //x2=4.86 //y2=1.185
r332 (  39 66 ) resistor r=9.3 //w=0.17 //l=0.17 //layer=mcon //count=1 \
 //x=4.82 //y=5.555 //x2=4.82 //y2=5.555
r333 (  37 39 ) resistor r=0.100236 //w=0.212 //l=0.17 //layer=m1 \
 //thickness=0.36 //x=4.82 //y=5.385 //x2=4.82 //y2=5.555
r334 (  34 54 ) resistor r=0.0910802 //w=0.374 //l=0.183303 //layer=m1 \
 //thickness=0.36 //x=8.63 //y=4.055 //x2=8.58 //y2=3.895
r335 (  28 30 ) resistor r=0.0698411 //w=0.17 //l=0.120208 //layer=m1 \
 //thickness=0.36 //x=8.545 //y=1.835 //x2=8.63 //y2=1.92
r336 (  28 29 ) resistor r=0.257634 //w=0.131 //l=0.27 //layer=m1 \
 //thickness=0.36 //x=8.545 //y=1.835 //x2=8.275 //y2=1.835
r337 (  27 46 ) resistor r=0.0208269 //w=0.212 //l=0.115 //layer=m1 \
 //thickness=0.36 //x=8.265 //y=5.385 //x2=8.15 //y2=5.385
r338 (  26 35 ) resistor r=0.0698411 //w=0.17 //l=0.120208 //layer=m1 \
 //thickness=0.36 //x=8.545 //y=5.385 //x2=8.63 //y2=5.3
r339 (  26 27 ) resistor r=0.267176 //w=0.131 //l=0.28 //layer=m1 \
 //thickness=0.36 //x=8.545 //y=5.385 //x2=8.265 //y2=5.385
r340 (  25 29 ) resistor r=0.0698411 //w=0.17 //l=0.120208 //layer=m1 \
 //thickness=0.36 //x=8.19 //y=1.75 //x2=8.275 //y2=1.835
r341 (  24 50 ) resistor r=0.0717383 //w=0.224 //l=0.115 //layer=m1 \
 //thickness=0.36 //x=8.19 //y=1.3 //x2=8.19 //y2=1.185
r342 (  24 25 ) resistor r=0.429389 //w=0.131 //l=0.45 //layer=m1 \
 //thickness=0.36 //x=8.19 //y=1.3 //x2=8.19 //y2=1.75
r343 (  20 45 ) resistor r=0.0934942 //w=0.424 //l=0.185472 //layer=m1 \
 //thickness=0.36 //x=5.42 //y=4.055 //x2=5.475 //y2=3.895
r344 (  14 16 ) resistor r=0.0698411 //w=0.17 //l=0.120208 //layer=m1 \
 //thickness=0.36 //x=5.335 //y=1.835 //x2=5.42 //y2=1.92
r345 (  14 15 ) resistor r=0.372137 //w=0.131 //l=0.39 //layer=m1 \
 //thickness=0.36 //x=5.335 //y=1.835 //x2=4.945 //y2=1.835
r346 (  13 37 ) resistor r=0.0208269 //w=0.212 //l=0.115 //layer=m1 \
 //thickness=0.36 //x=4.935 //y=5.385 //x2=4.82 //y2=5.385
r347 (  12 21 ) resistor r=0.0698411 //w=0.17 //l=0.120208 //layer=m1 \
 //thickness=0.36 //x=5.335 //y=5.385 //x2=5.42 //y2=5.3
r348 (  12 13 ) resistor r=0.381679 //w=0.131 //l=0.4 //layer=m1 \
 //thickness=0.36 //x=5.335 //y=5.385 //x2=4.935 //y2=5.385
r349 (  11 15 ) resistor r=0.0698411 //w=0.17 //l=0.120208 //layer=m1 \
 //thickness=0.36 //x=4.86 //y=1.75 //x2=4.945 //y2=1.835
r350 (  10 41 ) resistor r=0.0740619 //w=0.229 //l=0.120996 //layer=m1 \
 //thickness=0.36 //x=4.86 //y=1.305 //x2=4.862 //y2=1.185
r351 (  10 11 ) resistor r=0.424618 //w=0.131 //l=0.445 //layer=m1 \
 //thickness=0.36 //x=4.86 //y=1.305 //x2=4.86 //y2=1.75
r352 (  9 54 ) resistor r=0.00501337 //w=0.374 //l=0.015 //layer=m1 \
 //thickness=0.36 //x=8.58 //y=3.88 //x2=8.58 //y2=3.895
r353 (  9 31 ) resistor r=0.0860668 //w=0.374 //l=0.168152 //layer=m1 \
 //thickness=0.36 //x=8.58 //y=3.88 //x2=8.63 //y2=3.735
r354 (  8 45 ) resistor r=0.00442217 //w=0.424 //l=0.015 //layer=m1 \
 //thickness=0.36 //x=5.475 //y=3.88 //x2=5.475 //y2=3.895
r355 (  8 17 ) resistor r=0.0890721 //w=0.424 //l=0.170294 //layer=m1 \
 //thickness=0.36 //x=5.475 //y=3.88 //x2=5.42 //y2=3.735
r356 (  7 35 ) resistor r=0.295802 //w=0.131 //l=0.31 //layer=m1 \
 //thickness=0.36 //x=8.63 //y=4.99 //x2=8.63 //y2=5.3
r357 (  7 34 ) resistor r=0.892176 //w=0.131 //l=0.935 //layer=m1 \
 //thickness=0.36 //x=8.63 //y=4.99 //x2=8.63 //y2=4.055
r358 (  6 31 ) resistor r=0.920802 //w=0.131 //l=0.965 //layer=m1 \
 //thickness=0.36 //x=8.63 //y=2.77 //x2=8.63 //y2=3.735
r359 (  5 6 ) resistor r=0.353053 //w=0.131 //l=0.37 //layer=m1 \
 //thickness=0.36 //x=8.63 //y=2.4 //x2=8.63 //y2=2.77
r360 (  5 30 ) resistor r=0.458015 //w=0.131 //l=0.48 //layer=m1 \
 //thickness=0.36 //x=8.63 //y=2.4 //x2=8.63 //y2=1.92
r361 (  4 21 ) resistor r=0.295802 //w=0.131 //l=0.31 //layer=m1 \
 //thickness=0.36 //x=5.42 //y=4.99 //x2=5.42 //y2=5.3
r362 (  3 4 ) resistor r=0.353053 //w=0.131 //l=0.37 //layer=m1 \
 //thickness=0.36 //x=5.42 //y=4.62 //x2=5.42 //y2=4.99
r363 (  3 20 ) resistor r=0.539122 //w=0.131 //l=0.565 //layer=m1 \
 //thickness=0.36 //x=5.42 //y=4.62 //x2=5.42 //y2=4.055
r364 (  2 17 ) resistor r=0.214695 //w=0.131 //l=0.225 //layer=m1 \
 //thickness=0.36 //x=5.42 //y=3.51 //x2=5.42 //y2=3.735
r365 (  1 2 ) resistor r=1.05916 //w=0.131 //l=1.11 //layer=m1 \
 //thickness=0.36 //x=5.42 //y=2.4 //x2=5.42 //y2=3.51
r366 (  1 16 ) resistor r=0.458015 //w=0.131 //l=0.48 //layer=m1 \
 //thickness=0.36 //x=5.42 //y=2.4 //x2=5.42 //y2=1.92
ends PM_XOR2X1\%Y

subckt PM_XOR2X1\%noxref_4 ( 1 2 3 4 6 7 8 9 10 11 12 13 14 16 18 24 28 34 36 \
 40 48 54 56 57 60 61 68 73 90 102 103 104 111 112 113 114 115 117 120 121 123 \
 131 133 )
c295 ( 131 0 ) capacitor c=0.00869746f //x=10.285 //y=1.09
c296 ( 123 0 ) capacitor c=0.0652604f //x=4.93 //y=4.88
c297 ( 121 0 ) capacitor c=0.0318956f //x=7.485 //y=1.395
c298 ( 120 0 ) capacitor c=0.0186836f //x=7.485 //y=1.05
c299 ( 117 0 ) capacitor c=0.0141821f //x=7.33 //y=1.55
c300 ( 115 0 ) capacitor c=0.0158569f //x=7.33 //y=0.895
c301 ( 114 0 ) capacitor c=0.0874759f //x=6.955 //y=2.1
c302 ( 113 0 ) capacitor c=0.0230012f //x=6.955 //y=1.705
c303 ( 112 0 ) capacitor c=0.0234359f //x=6.955 //y=1.395
c304 ( 111 0 ) capacitor c=0.0198787f //x=6.955 //y=1.05
c305 ( 104 0 ) capacitor c=0.155893f //x=5.04 //y=6.2
c306 ( 103 0 ) capacitor c=0.110553f //x=4.6 //y=6.2
c307 ( 90 0 ) capacitor c=0.0261682f //x=10.475 //y=5.56
c308 ( 73 0 ) capacitor c=0.00142446f //x=7.15 //y=2.265
c309 ( 68 0 ) capacitor c=5.34577e-19 //x=4.93 //y=4.88
c310 ( 61 0 ) capacitor c=0.0256835f //x=9.985 //y=3.495
c311 ( 60 0 ) capacitor c=3.18161e-19 //x=10.145 //y=3.495
c312 ( 57 0 ) capacitor c=0.0765403f //x=9.955 //y=4.27
c313 ( 56 0 ) capacitor c=0.00326455f //x=10.115 //y=4.27
c314 ( 54 0 ) capacitor c=0.00256557f //x=7.31 //y=3.525
c315 ( 48 0 ) capacitor c=0.00536919f //x=4.975 //y=4.28
c316 ( 40 0 ) capacitor c=0.0190626f //x=10.48 //y=1.185
c317 ( 36 0 ) capacitor c=0.0136176f //x=10.11 //y=4.25
c318 ( 34 0 ) capacitor c=0.0164436f //x=10.11 //y=3.51
c319 ( 28 0 ) capacitor c=0.0312924f //x=7.15 //y=3.51
c320 ( 24 0 ) capacitor c=0.0153143f //x=4.975 //y=4.415
c321 ( 18 0 ) capacitor c=0.0169987f //x=10.48 //y=1.935
c322 ( 16 0 ) capacitor c=0.0116416f //x=10.475 //y=5.42
c323 ( 14 0 ) capacitor c=0.0026268f //x=10.195 //y=5.14
c324 ( 13 0 ) capacitor c=0.00884994f //x=10.39 //y=5.14
c325 ( 12 0 ) capacitor c=0.00445515f //x=10.195 //y=2.02
c326 ( 11 0 ) capacitor c=0.014706f //x=10.395 //y=2.02
c327 ( 10 0 ) capacitor c=0.00919778f //x=10.11 //y=5.055
c328 ( 9 0 ) capacitor c=0.0114708f //x=10.11 //y=4.43
c329 ( 8 0 ) capacitor c=0.0112194f //x=10.11 //y=4.135
c330 ( 7 0 ) capacitor c=0.0126935f //x=10.11 //y=3.655
c331 ( 6 0 ) capacitor c=0.0252511f //x=10.11 //y=3.335
c332 ( 4 0 ) capacitor c=0.0259221f //x=7.15 //y=3.385
c333 ( 3 0 ) capacitor c=0.00668061f //x=7.15 //y=2.385
c334 ( 2 0 ) capacitor c=0.00688284f //x=4.93 //y=4.765
c335 ( 1 0 ) capacitor c=0.0149303f //x=4.93 //y=4.575
r336 (  123 124 ) resistor r=22.7554 //w=0.233 //l=0.11 //layer=ply \
 //thickness=0.18 //x=4.93 //y=4.88 //x2=5.04 //y2=4.88
r337 (  121 130 ) resistor r=45.1352 //w=0.168 //l=0.173853 //layer=ply \
 //thickness=0.18 //x=7.485 //y=1.395 //x2=7.445 //y2=1.55
r338 (  120 129 ) resistor r=45.1352 //w=0.168 //l=0.173853 //layer=ply \
 //thickness=0.18 //x=7.485 //y=1.05 //x2=7.445 //y2=0.895
r339 (  120 121 ) resistor r=176.904 //w=0.094 //l=0.345 //layer=ply \
 //thickness=0.18 //x=7.485 //y=1.05 //x2=7.485 //y2=1.395
r340 (  118 128 ) resistor r=10.701 //w=0.21 //l=0.115 //layer=ply \
 //thickness=0.18 //x=7.11 //y=1.55 //x2=6.995 //y2=1.55
r341 (  117 130 ) resistor r=5.52526 //w=0.168 //l=0.115 //layer=ply \
 //thickness=0.18 //x=7.33 //y=1.55 //x2=7.445 //y2=1.55
r342 (  116 127 ) resistor r=5.52526 //w=0.168 //l=0.115 //layer=ply \
 //thickness=0.18 //x=7.11 //y=0.895 //x2=6.995 //y2=0.895
r343 (  115 129 ) resistor r=5.52526 //w=0.168 //l=0.115 //layer=ply \
 //thickness=0.18 //x=7.33 //y=0.895 //x2=7.445 //y2=0.895
r344 (  115 116 ) resistor r=112.809 //w=0.094 //l=0.22 //layer=ply \
 //thickness=0.18 //x=7.33 //y=0.895 //x2=7.11 //y2=0.895
r345 (  114 126 ) resistor r=34.8111 //w=0.27 //l=0.264953 //layer=ply \
 //thickness=0.18 //x=6.955 //y=2.1 //x2=7.15 //y2=2.265
r346 (  113 128 ) resistor r=39.5823 //w=0.21 //l=0.173853 //layer=ply \
 //thickness=0.18 //x=6.955 //y=1.705 //x2=6.995 //y2=1.55
r347 (  113 114 ) resistor r=202.543 //w=0.094 //l=0.395 //layer=ply \
 //thickness=0.18 //x=6.955 //y=1.705 //x2=6.955 //y2=2.1
r348 (  112 128 ) resistor r=39.5823 //w=0.21 //l=0.173853 //layer=ply \
 //thickness=0.18 //x=6.955 //y=1.395 //x2=6.995 //y2=1.55
r349 (  111 127 ) resistor r=45.1352 //w=0.168 //l=0.173853 //layer=ply \
 //thickness=0.18 //x=6.955 //y=1.05 //x2=6.995 //y2=0.895
r350 (  111 112 ) resistor r=176.904 //w=0.094 //l=0.345 //layer=ply \
 //thickness=0.18 //x=6.955 //y=1.05 //x2=6.955 //y2=1.395
r351 (  108 124 ) resistor r=13.0941 //w=0.233 //l=0.165 //layer=ply \
 //thickness=0.18 //x=5.04 //y=5.045 //x2=5.04 //y2=4.88
r352 (  105 123 ) resistor r=68.2661 //w=0.233 //l=0.404166 //layer=ply \
 //thickness=0.18 //x=4.6 //y=5.045 //x2=4.93 //y2=4.88
r353 (  104 108 ) resistor r=592.245 //w=0.094 //l=1.155 //layer=ply \
 //thickness=0.18 //x=5.04 //y=6.2 //x2=5.04 //y2=5.045
r354 (  103 105 ) resistor r=592.245 //w=0.094 //l=1.155 //layer=ply \
 //thickness=0.18 //x=4.6 //y=6.2 //x2=4.6 //y2=5.045
r355 (  102 117 ) resistor r=56.4043 //w=0.094 //l=0.11 //layer=ply \
 //thickness=0.18 //x=7.22 //y=1.55 //x2=7.33 //y2=1.55
r356 (  102 118 ) resistor r=56.4043 //w=0.094 //l=0.11 //layer=ply \
 //thickness=0.18 //x=7.22 //y=1.55 //x2=7.11 //y2=1.55
r357 (  90 133 ) resistor r=23.615 //w=0.187 //l=0.345 //layer=li \
 //thickness=0.1 //x=10.475 //y=5.56 //x2=10.475 //y2=5.905
r358 (  73 126 ) resistor r=152 //w=0.17 //l=0.17 //layer=licon //count=1 \
 //x=7.15 //y=2.265 //x2=7.15 //y2=2.265
r359 (  68 123 ) resistor r=152 //w=0.17 //l=0.17 //layer=licon //count=1 \
 //x=4.93 //y=4.88 //x2=4.93 //y2=4.88
r360 (  60 61 ) resistor r=0.10734 //w=0.281 //l=0.16 //layer=m2 \
 //thickness=0.36 //x=10.145 //y=3.495 //x2=9.985 //y2=3.495
r361 (  56 57 ) resistor r=0.10734 //w=0.281 //l=0.16 //layer=m2 \
 //thickness=0.36 //x=10.115 //y=4.27 //x2=9.955 //y2=4.27
r362 (  54 61 ) resistor r=2.55248 //w=0.131 //l=2.675 //layer=m2 \
 //thickness=0.36 //x=7.31 //y=3.51 //x2=9.985 //y2=3.51
r363 (  52 54 ) resistor r=0.10734 //w=0.281 //l=0.16 //layer=m2 \
 //thickness=0.36 //x=7.15 //y=3.525 //x2=7.31 //y2=3.525
r364 (  48 50 ) resistor r=0.0539137 //w=0.313 //l=0.135 //layer=m2 \
 //thickness=0.36 //x=4.975 //y=4.28 //x2=4.975 //y2=4.415
r365 (  45 48 ) resistor r=0.0441684 //w=0.313 //l=0.16 //layer=m2 \
 //thickness=0.36 //x=5.135 //y=4.28 //x2=4.975 //y2=4.28
r366 (  45 57 ) resistor r=4.59924 //w=0.131 //l=4.82 //layer=m2 \
 //thickness=0.36 //x=5.135 //y=4.28 //x2=9.955 //y2=4.28
r367 (  43 90 ) resistor r=9.3 //w=0.17 //l=0.17 //layer=mcon //count=1 \
 //x=10.475 //y=5.56 //x2=10.475 //y2=5.56
r368 (  40 131 ) resistor r=9.3 //w=0.17 //l=0.17 //layer=mcon //count=1 \
 //x=10.48 //y=1.185 //x2=10.48 //y2=1.185
r369 (  38 56 ) resistor r=4.5 //w=0.15 //l=0.15 //layer=via1 //count=1 \
 //x=10.115 //y=4.27 //x2=10.115 //y2=4.27
r370 (  36 38 ) resistor r=0.0065445 //w=0.382 //l=0.02 //layer=m1 \
 //thickness=0.36 //x=10.06 //y=4.25 //x2=10.06 //y2=4.27
r371 (  32 60 ) resistor r=4.5 //w=0.15 //l=0.15 //layer=via1 //count=1 \
 //x=10.145 //y=3.495 //x2=10.145 //y2=3.495
r372 (  32 34 ) resistor r=0.00474684 //w=0.395 //l=0.015 //layer=m1 \
 //thickness=0.36 //x=10.075 //y=3.495 //x2=10.075 //y2=3.51
r373 (  30 52 ) resistor r=4.5 //w=0.15 //l=0.15 //layer=via1 //count=1 \
 //x=7.15 //y=3.525 //x2=7.15 //y2=3.525
r374 (  28 30 ) resistor r=0.00493421 //w=0.38 //l=0.015 //layer=m1 \
 //thickness=0.36 //x=7.202 //y=3.51 //x2=7.202 //y2=3.525
r375 (  26 73 ) resistor r=9.3 //w=0.17 //l=0.17 //layer=mcon //count=1 \
 //x=7.15 //y=2.265 //x2=7.15 //y2=2.265
r376 (  24 50 ) resistor r=4.5 //w=0.15 //l=0.15 //layer=via1 //count=1 \
 //x=4.975 //y=4.415 //x2=4.975 //y2=4.415
r377 (  20 68 ) resistor r=9.3 //w=0.17 //l=0.17 //layer=mcon //count=1 \
 //x=4.93 //y=4.88 //x2=4.93 //y2=4.88
r378 (  17 40 ) resistor r=0.105739 //w=0.201 //l=0.145 //layer=m1 \
 //thickness=0.36 //x=10.48 //y=1.33 //x2=10.48 //y2=1.185
r379 (  17 18 ) resistor r=0.57729 //w=0.131 //l=0.605 //layer=m1 \
 //thickness=0.36 //x=10.48 //y=1.33 //x2=10.48 //y2=1.935
r380 (  16 43 ) resistor r=0.086672 //w=0.218 //l=0.14 //layer=m1 \
 //thickness=0.36 //x=10.475 //y=5.42 //x2=10.475 //y2=5.56
r381 (  15 16 ) resistor r=0.186069 //w=0.131 //l=0.195 //layer=m1 \
 //thickness=0.36 //x=10.475 //y=5.225 //x2=10.475 //y2=5.42
r382 (  13 15 ) resistor r=0.0698411 //w=0.17 //l=0.120208 //layer=m1 \
 //thickness=0.36 //x=10.39 //y=5.14 //x2=10.475 //y2=5.225
r383 (  13 14 ) resistor r=0.186069 //w=0.131 //l=0.195 //layer=m1 \
 //thickness=0.36 //x=10.39 //y=5.14 //x2=10.195 //y2=5.14
r384 (  11 18 ) resistor r=0.0698411 //w=0.17 //l=0.120208 //layer=m1 \
 //thickness=0.36 //x=10.395 //y=2.02 //x2=10.48 //y2=1.935
r385 (  11 12 ) resistor r=0.19084 //w=0.131 //l=0.2 //layer=m1 \
 //thickness=0.36 //x=10.395 //y=2.02 //x2=10.195 //y2=2.02
r386 (  10 14 ) resistor r=0.0698411 //w=0.17 //l=0.120208 //layer=m1 \
 //thickness=0.36 //x=10.11 //y=5.055 //x2=10.195 //y2=5.14
r387 (  9 38 ) resistor r=0.0914072 //w=0.382 //l=0.183303 //layer=m1 \
 //thickness=0.36 //x=10.11 //y=4.43 //x2=10.06 //y2=4.27
r388 (  9 10 ) resistor r=0.596374 //w=0.131 //l=0.625 //layer=m1 \
 //thickness=0.36 //x=10.11 //y=4.43 //x2=10.11 //y2=5.055
r389 (  8 36 ) resistor r=0.0766821 //w=0.382 //l=0.13775 //layer=m1 \
 //thickness=0.36 //x=10.11 //y=4.135 //x2=10.06 //y2=4.25
r390 (  7 34 ) resistor r=0.087246 //w=0.395 //l=0.161555 //layer=m1 \
 //thickness=0.36 //x=10.11 //y=3.655 //x2=10.075 //y2=3.51
r391 (  7 8 ) resistor r=0.458015 //w=0.131 //l=0.48 //layer=m1 \
 //thickness=0.36 //x=10.11 //y=3.655 //x2=10.11 //y2=4.135
r392 (  6 32 ) resistor r=0.0919929 //w=0.395 //l=0.176635 //layer=m1 \
 //thickness=0.36 //x=10.11 //y=3.335 //x2=10.075 //y2=3.495
r393 (  5 12 ) resistor r=0.0698411 //w=0.17 //l=0.120208 //layer=m1 \
 //thickness=0.36 //x=10.11 //y=2.105 //x2=10.195 //y2=2.02
r394 (  5 6 ) resistor r=1.17366 //w=0.131 //l=1.23 //layer=m1 \
 //thickness=0.36 //x=10.11 //y=2.105 //x2=10.11 //y2=3.335
r395 (  4 28 ) resistor r=0.0798098 //w=0.38 //l=0.148745 //layer=m1 \
 //thickness=0.36 //x=7.15 //y=3.385 //x2=7.202 //y2=3.51
r396 (  3 26 ) resistor r=0.0736049 //w=0.235 //l=0.12 //layer=m1 \
 //thickness=0.36 //x=7.15 //y=2.385 //x2=7.15 //y2=2.265
r397 (  3 4 ) resistor r=0.954198 //w=0.131 //l=1 //layer=m1 //thickness=0.36 \
 //x=7.15 //y=2.385 //x2=7.15 //y2=3.385
r398 (  2 20 ) resistor r=0.0704783 //w=0.246 //l=0.115 //layer=m1 \
 //thickness=0.36 //x=4.93 //y=4.765 //x2=4.93 //y2=4.88
r399 (  1 24 ) resistor r=0.0902587 //w=0.349 //l=0.187617 //layer=m1 \
 //thickness=0.36 //x=4.93 //y=4.575 //x2=4.99 //y2=4.415
r400 (  1 2 ) resistor r=0.181298 //w=0.131 //l=0.19 //layer=m1 \
 //thickness=0.36 //x=4.93 //y=4.575 //x2=4.93 //y2=4.765
ends PM_XOR2X1\%noxref_4

subckt PM_XOR2X1\%B ( 1 2 3 4 5 6 7 8 9 10 11 12 16 37 43 46 48 50 51 55 63 72 \
 78 87 91 92 93 94 95 96 97 98 99 100 101 103 106 107 114 115 119 120 121 123 \
 126 129 130 131 132 141 146 )
c273 ( 146 0 ) capacitor c=0.052693f //x=10.74 //y=2.265
c274 ( 141 0 ) capacitor c=0.0660028f //x=7.15 //y=4.88
c275 ( 132 0 ) capacitor c=0.0301471f //x=10.74 //y=2.1
c276 ( 131 0 ) capacitor c=0.0255528f //x=10.74 //y=1.745
c277 ( 130 0 ) capacitor c=0.0234346f //x=10.74 //y=1.435
c278 ( 129 0 ) capacitor c=0.0201416f //x=10.74 //y=1.09
c279 ( 126 0 ) capacitor c=0.0550305f //x=10.695 //y=5.045
c280 ( 123 0 ) capacitor c=0.0161986f //x=10.585 //y=1.59
c281 ( 121 0 ) capacitor c=0.0157807f //x=10.585 //y=0.935
c282 ( 120 0 ) capacitor c=0.0146709f //x=10.33 //y=4.97
c283 ( 119 0 ) capacitor c=0.0244235f //x=10.62 //y=4.97
c284 ( 115 0 ) capacitor c=0.0439428f //x=10.21 //y=1.435
c285 ( 114 0 ) capacitor c=0.020097f //x=10.21 //y=1.09
c286 ( 107 0 ) capacitor c=0.0423887f //x=5.125 //y=1.435
c287 ( 106 0 ) capacitor c=0.0192582f //x=5.125 //y=1.09
c288 ( 103 0 ) capacitor c=0.0126237f //x=4.97 //y=1.59
c289 ( 101 0 ) capacitor c=0.0157807f //x=4.97 //y=0.935
c290 ( 100 0 ) capacitor c=0.0975376f //x=4.595 //y=2.1
c291 ( 99 0 ) capacitor c=0.0197088f //x=4.595 //y=1.745
c292 ( 98 0 ) capacitor c=0.0168511f //x=4.595 //y=1.435
c293 ( 97 0 ) capacitor c=0.0175047f //x=4.595 //y=1.09
c294 ( 96 0 ) capacitor c=0.154411f //x=10.695 //y=6.2
c295 ( 95 0 ) capacitor c=0.153944f //x=10.255 //y=6.2
c296 ( 94 0 ) capacitor c=0.110998f //x=7.49 //y=6.2
c297 ( 93 0 ) capacitor c=0.155254f //x=7.05 //y=6.2
c298 ( 87 0 ) capacitor c=9.53968e-19 //x=10.85 //y=4.88
c299 ( 78 0 ) capacitor c=6.43121e-19 //x=10.85 //y=2.265
c300 ( 72 0 ) capacitor c=0.0143211f //x=7.15 //y=4.62
c301 ( 63 0 ) capacitor c=5.55171e-19 //x=4.93 //y=2.265
c302 ( 55 0 ) capacitor c=3.76718e-19 //x=5.09 //y=3.155
c303 ( 51 0 ) capacitor c=0.0641543f //x=9.985 //y=4.655
c304 ( 50 0 ) capacitor c=0.0205912f //x=10.33 //y=4.655
c305 ( 48 0 ) capacitor c=0.0260571f //x=10.36 //y=3.11
c306 ( 46 0 ) capacitor c=0.0842412f //x=9.76 //y=3.14
c307 ( 43 0 ) capacitor c=0.01346f //x=10.85 //y=2.265
c308 ( 37 0 ) capacitor c=0.00618588f //x=10.85 //y=4.88
c309 ( 16 0 ) capacitor c=0.0140818f //x=10.85 //y=3.3
c310 ( 12 0 ) capacitor c=0.011511f //x=4.93 //y=2.995
c311 ( 11 0 ) capacitor c=0.0047199f //x=4.93 //y=2.415
c312 ( 10 0 ) capacitor c=0.0169856f //x=10.85 //y=3.14
c313 ( 8 0 ) capacitor c=0.013641f //x=7.15 //y=4.62
c314 ( 7 0 ) capacitor c=0.0271598f //x=4.93 //y=3.14
c315 ( 2 0 ) capacitor c=0.0565408f //x=10.85 //y=3.51
c316 ( 1 0 ) capacitor c=0.0178622f //x=10.85 //y=2.77
r317 (  146 148 ) resistor r=17.5563 //w=0.302 //l=0.11 //layer=ply \
 //thickness=0.18 //x=10.74 //y=2.265 //x2=10.85 //y2=2.265
r318 (  139 141 ) resistor r=20.6867 //w=0.233 //l=0.1 //layer=ply \
 //thickness=0.18 //x=7.05 //y=4.88 //x2=7.15 //y2=4.88
r319 (  132 146 ) resistor r=19.1248 //w=0.302 //l=0.165 //layer=ply \
 //thickness=0.18 //x=10.74 //y=2.1 //x2=10.74 //y2=2.265
r320 (  131 145 ) resistor r=39.5823 //w=0.21 //l=0.173853 //layer=ply \
 //thickness=0.18 //x=10.74 //y=1.745 //x2=10.7 //y2=1.59
r321 (  131 132 ) resistor r=182.032 //w=0.094 //l=0.355 //layer=ply \
 //thickness=0.18 //x=10.74 //y=1.745 //x2=10.74 //y2=2.1
r322 (  130 145 ) resistor r=39.5823 //w=0.21 //l=0.173853 //layer=ply \
 //thickness=0.18 //x=10.74 //y=1.435 //x2=10.7 //y2=1.59
r323 (  129 144 ) resistor r=45.1352 //w=0.168 //l=0.173853 //layer=ply \
 //thickness=0.18 //x=10.74 //y=1.09 //x2=10.7 //y2=0.935
r324 (  129 130 ) resistor r=176.904 //w=0.094 //l=0.345 //layer=ply \
 //thickness=0.18 //x=10.74 //y=1.09 //x2=10.74 //y2=1.435
r325 (  126 150 ) resistor r=26.3063 //w=0.284 //l=0.229783 //layer=ply \
 //thickness=0.18 //x=10.695 //y=5.045 //x2=10.85 //y2=4.88
r326 (  124 143 ) resistor r=5.52526 //w=0.168 //l=0.115 //layer=ply \
 //thickness=0.18 //x=10.365 //y=1.59 //x2=10.25 //y2=1.59
r327 (  123 145 ) resistor r=10.701 //w=0.21 //l=0.115 //layer=ply \
 //thickness=0.18 //x=10.585 //y=1.59 //x2=10.7 //y2=1.59
r328 (  122 142 ) resistor r=5.52526 //w=0.168 //l=0.115 //layer=ply \
 //thickness=0.18 //x=10.365 //y=0.935 //x2=10.25 //y2=0.935
r329 (  121 144 ) resistor r=5.52526 //w=0.168 //l=0.115 //layer=ply \
 //thickness=0.18 //x=10.585 //y=0.935 //x2=10.7 //y2=0.935
r330 (  121 122 ) resistor r=112.809 //w=0.094 //l=0.22 //layer=ply \
 //thickness=0.18 //x=10.585 //y=0.935 //x2=10.365 //y2=0.935
r331 (  119 126 ) resistor r=23.403 //w=0.284 //l=0.106066 //layer=ply \
 //thickness=0.18 //x=10.62 //y=4.97 //x2=10.695 //y2=5.045
r332 (  119 120 ) resistor r=148.702 //w=0.094 //l=0.29 //layer=ply \
 //thickness=0.18 //x=10.62 //y=4.97 //x2=10.33 //y2=4.97
r333 (  116 120 ) resistor r=26.9307 //w=0.15 //l=0.106066 //layer=ply \
 //thickness=0.18 //x=10.255 //y=5.045 //x2=10.33 //y2=4.97
r334 (  115 143 ) resistor r=45.1352 //w=0.168 //l=0.173853 //layer=ply \
 //thickness=0.18 //x=10.21 //y=1.435 //x2=10.25 //y2=1.59
r335 (  114 142 ) resistor r=45.1352 //w=0.168 //l=0.173853 //layer=ply \
 //thickness=0.18 //x=10.21 //y=1.09 //x2=10.25 //y2=0.935
r336 (  114 115 ) resistor r=176.904 //w=0.094 //l=0.345 //layer=ply \
 //thickness=0.18 //x=10.21 //y=1.09 //x2=10.21 //y2=1.435
r337 (  111 141 ) resistor r=70.3348 //w=0.233 //l=0.414367 //layer=ply \
 //thickness=0.18 //x=7.49 //y=5.045 //x2=7.15 //y2=4.88
r338 (  108 139 ) resistor r=13.0941 //w=0.233 //l=0.165 //layer=ply \
 //thickness=0.18 //x=7.05 //y=5.045 //x2=7.05 //y2=4.88
r339 (  107 138 ) resistor r=45.1352 //w=0.168 //l=0.173853 //layer=ply \
 //thickness=0.18 //x=5.125 //y=1.435 //x2=5.085 //y2=1.59
r340 (  106 137 ) resistor r=45.1352 //w=0.168 //l=0.173853 //layer=ply \
 //thickness=0.18 //x=5.125 //y=1.09 //x2=5.085 //y2=0.935
r341 (  106 107 ) resistor r=176.904 //w=0.094 //l=0.345 //layer=ply \
 //thickness=0.18 //x=5.125 //y=1.09 //x2=5.125 //y2=1.435
r342 (  104 134 ) resistor r=10.701 //w=0.21 //l=0.115 //layer=ply \
 //thickness=0.18 //x=4.75 //y=1.59 //x2=4.635 //y2=1.59
r343 (  103 138 ) resistor r=5.52526 //w=0.168 //l=0.115 //layer=ply \
 //thickness=0.18 //x=4.97 //y=1.59 //x2=5.085 //y2=1.59
r344 (  102 133 ) resistor r=5.52526 //w=0.168 //l=0.115 //layer=ply \
 //thickness=0.18 //x=4.75 //y=0.935 //x2=4.635 //y2=0.935
r345 (  101 137 ) resistor r=5.52526 //w=0.168 //l=0.115 //layer=ply \
 //thickness=0.18 //x=4.97 //y=0.935 //x2=5.085 //y2=0.935
r346 (  101 102 ) resistor r=112.809 //w=0.094 //l=0.22 //layer=ply \
 //thickness=0.18 //x=4.97 //y=0.935 //x2=4.75 //y2=0.935
r347 (  100 136 ) resistor r=67.2792 //w=0.24 //l=0.438891 //layer=ply \
 //thickness=0.18 //x=4.595 //y=2.1 //x2=4.93 //y2=2.34
r348 (  99 134 ) resistor r=39.5823 //w=0.21 //l=0.173853 //layer=ply \
 //thickness=0.18 //x=4.595 //y=1.745 //x2=4.635 //y2=1.59
r349 (  99 100 ) resistor r=182.032 //w=0.094 //l=0.355 //layer=ply \
 //thickness=0.18 //x=4.595 //y=1.745 //x2=4.595 //y2=2.1
r350 (  98 134 ) resistor r=39.5823 //w=0.21 //l=0.173853 //layer=ply \
 //thickness=0.18 //x=4.595 //y=1.435 //x2=4.635 //y2=1.59
r351 (  97 133 ) resistor r=45.1352 //w=0.168 //l=0.173853 //layer=ply \
 //thickness=0.18 //x=4.595 //y=1.09 //x2=4.635 //y2=0.935
r352 (  97 98 ) resistor r=176.904 //w=0.094 //l=0.345 //layer=ply \
 //thickness=0.18 //x=4.595 //y=1.09 //x2=4.595 //y2=1.435
r353 (  96 126 ) resistor r=592.245 //w=0.094 //l=1.155 //layer=ply \
 //thickness=0.18 //x=10.695 //y=6.2 //x2=10.695 //y2=5.045
r354 (  95 116 ) resistor r=592.245 //w=0.094 //l=1.155 //layer=ply \
 //thickness=0.18 //x=10.255 //y=6.2 //x2=10.255 //y2=5.045
r355 (  94 111 ) resistor r=592.245 //w=0.094 //l=1.155 //layer=ply \
 //thickness=0.18 //x=7.49 //y=6.2 //x2=7.49 //y2=5.045
r356 (  93 108 ) resistor r=592.245 //w=0.094 //l=1.155 //layer=ply \
 //thickness=0.18 //x=7.05 //y=6.2 //x2=7.05 //y2=5.045
r357 (  92 123 ) resistor r=56.4043 //w=0.094 //l=0.11 //layer=ply \
 //thickness=0.18 //x=10.475 //y=1.59 //x2=10.585 //y2=1.59
r358 (  92 124 ) resistor r=56.4043 //w=0.094 //l=0.11 //layer=ply \
 //thickness=0.18 //x=10.475 //y=1.59 //x2=10.365 //y2=1.59
r359 (  91 103 ) resistor r=56.4043 //w=0.094 //l=0.11 //layer=ply \
 //thickness=0.18 //x=4.86 //y=1.59 //x2=4.97 //y2=1.59
r360 (  91 104 ) resistor r=56.4043 //w=0.094 //l=0.11 //layer=ply \
 //thickness=0.18 //x=4.86 //y=1.59 //x2=4.75 //y2=1.59
r361 (  87 150 ) resistor r=152 //w=0.17 //l=0.17 //layer=licon //count=1 \
 //x=10.85 //y=4.88 //x2=10.85 //y2=4.88
r362 (  78 148 ) resistor r=152 //w=0.17 //l=0.17 //layer=licon //count=1 \
 //x=10.85 //y=2.265 //x2=10.85 //y2=2.265
r363 (  75 141 ) resistor r=152 //w=0.17 //l=0.17 //layer=licon //count=1 \
 //x=7.15 //y=4.88 //x2=7.15 //y2=4.88
r364 (  72 75 ) resistor r=17.7968 //w=0.187 //l=0.26 //layer=li \
 //thickness=0.1 //x=7.15 //y=4.62 //x2=7.15 //y2=4.88
r365 (  63 136 ) resistor r=152 //w=0.17 //l=0.17 //layer=licon //count=1 \
 //x=4.93 //y=2.265 //x2=4.93 //y2=2.265
r366 (  53 55 ) resistor r=0.10734 //w=0.281 //l=0.16 //layer=m2 \
 //thickness=0.36 //x=4.93 //y=3.155 //x2=5.09 //y2=3.155
r367 (  51 57 ) resistor r=1.89634 //w=0.187 //l=2.8584 //layer=m2 \
 //thickness=0.36 //x=9.985 //y=4.655 //x2=7.15 //y2=4.702
r368 (  50 61 ) resistor r=0.244112 //w=0.3 //l=0.630476 //layer=m2 \
 //thickness=0.36 //x=10.33 //y=4.655 //x2=10.86 //y2=4.875
r369 (  50 51 ) resistor r=0.329198 //w=0.131 //l=0.345 //layer=m2 \
 //thickness=0.36 //x=10.33 //y=4.655 //x2=9.985 //y2=4.655
r370 (  48 59 ) resistor r=0.259285 //w=0.245 //l=0.499775 //layer=m2 \
 //thickness=0.36 //x=10.36 //y=3.11 //x2=10.845 //y2=3.14
r371 (  48 49 ) resistor r=0.410305 //w=0.131 //l=0.43 //layer=m2 \
 //thickness=0.36 //x=10.36 //y=3.11 //x2=9.93 //y2=3.11
r372 (  46 49 ) resistor r=0.125 //w=0.17 //l=0.184391 //layer=m2 \
 //thickness=0.36 //x=9.76 //y=3.14 //x2=9.93 //y2=3.11
r373 (  46 55 ) resistor r=4.45611 //w=0.131 //l=4.67 //layer=m2 \
 //thickness=0.36 //x=9.76 //y=3.14 //x2=5.09 //y2=3.14
r374 (  43 78 ) resistor r=9.3 //w=0.17 //l=0.17 //layer=mcon //count=1 \
 //x=10.85 //y=2.265 //x2=10.85 //y2=2.265
r375 (  40 61 ) resistor r=4.5 //w=0.15 //l=0.15 //layer=via1 //count=1 \
 //x=10.86 //y=4.885 //x2=10.86 //y2=4.885
r376 (  37 87 ) resistor r=9.3 //w=0.17 //l=0.17 //layer=mcon //count=1 \
 //x=10.85 //y=4.88 //x2=10.85 //y2=4.88
r377 (  37 40 ) resistor r=0.0022242 //w=0.281 //l=0.005 //layer=m1 \
 //thickness=0.36 //x=10.86 //y=4.88 //x2=10.86 //y2=4.885
r378 (  37 38 ) resistor r=0.105116 //w=0.281 //l=0.155 //layer=m1 \
 //thickness=0.36 //x=10.86 //y=4.88 //x2=10.86 //y2=4.725
r379 (  32 57 ) resistor r=4.5 //w=0.15 //l=0.15 //layer=via1 //count=1 \
 //x=7.15 //y=4.71 //x2=7.15 //y2=4.71
r380 (  28 53 ) resistor r=4.5 //w=0.15 //l=0.15 //layer=via1 //count=1 \
 //x=4.93 //y=3.155 //x2=4.93 //y2=3.155
r381 (  23 63 ) resistor r=9.3 //w=0.17 //l=0.17 //layer=mcon //count=1 \
 //x=4.93 //y=2.265 //x2=4.93 //y2=2.265
r382 (  11 12 ) resistor r=0.553435 //w=0.131 //l=0.58 //layer=m1 \
 //thickness=0.36 //x=4.93 //y=2.415 //x2=4.93 //y2=2.995
r383 (  10 59 ) resistor r=4.5 //w=0.15 //l=0.15 //layer=via1 //count=1 \
 //x=10.845 //y=3.14 //x2=10.845 //y2=3.14
r384 (  10 16 ) resistor r=0.0910802 //w=0.374 //l=0.185472 //layer=m1 \
 //thickness=0.36 //x=10.795 //y=3.14 //x2=10.85 //y2=3.3
r385 (  10 14 ) resistor r=0.0910802 //w=0.374 //l=0.185472 //layer=m1 \
 //thickness=0.36 //x=10.795 //y=3.14 //x2=10.85 //y2=2.98
r386 (  9 13 ) resistor r=0.0360744 //w=0.211 //l=0.03 //layer=m1 \
 //thickness=0.36 //x=10.85 //y=2.4 //x2=10.85 //y2=2.43
r387 (  9 43 ) resistor r=0.0799763 //w=0.211 //l=0.135 //layer=m1 \
 //thickness=0.36 //x=10.85 //y=2.4 //x2=10.85 //y2=2.265
r388 (  8 72 ) resistor r=9.3 //w=0.17 //l=0.17 //layer=mcon //count=1 \
 //x=7.15 //y=4.62 //x2=7.15 //y2=4.62
r389 (  8 32 ) resistor r=0.0317797 //w=0.354 //l=0.09 //layer=m1 \
 //thickness=0.36 //x=7.202 //y=4.62 //x2=7.202 //y2=4.71
r390 (  7 28 ) resistor r=0.0049867 //w=0.376 //l=0.015 //layer=m1 \
 //thickness=0.36 //x=4.982 //y=3.14 //x2=4.982 //y2=3.155
r391 (  7 12 ) resistor r=0.0861726 //w=0.376 //l=0.169012 //layer=m1 \
 //thickness=0.36 //x=4.982 //y=3.14 //x2=4.93 //y2=2.995
r392 (  6 11 ) resistor r=0.0182676 //w=0.238 //l=0.0164317 //layer=m1 \
 //thickness=0.36 //x=4.927 //y=2.4 //x2=4.93 //y2=2.415
r393 (  6 23 ) resistor r=0.0709034 //w=0.238 //l=0.135 //layer=m1 \
 //thickness=0.36 //x=4.927 //y=2.4 //x2=4.927 //y2=2.265
r394 (  5 38 ) resistor r=0.100191 //w=0.131 //l=0.105 //layer=m1 \
 //thickness=0.36 //x=10.85 //y=4.62 //x2=10.85 //y2=4.725
r395 (  4 5 ) resistor r=0.353053 //w=0.131 //l=0.37 //layer=m1 \
 //thickness=0.36 //x=10.85 //y=4.25 //x2=10.85 //y2=4.62
r396 (  3 4 ) resistor r=0.353053 //w=0.131 //l=0.37 //layer=m1 \
 //thickness=0.36 //x=10.85 //y=3.88 //x2=10.85 //y2=4.25
r397 (  2 3 ) resistor r=0.353053 //w=0.131 //l=0.37 //layer=m1 \
 //thickness=0.36 //x=10.85 //y=3.51 //x2=10.85 //y2=3.88
r398 (  2 16 ) resistor r=0.200382 //w=0.131 //l=0.21 //layer=m1 \
 //thickness=0.36 //x=10.85 //y=3.51 //x2=10.85 //y2=3.3
r399 (  1 14 ) resistor r=0.200382 //w=0.131 //l=0.21 //layer=m1 \
 //thickness=0.36 //x=10.85 //y=2.77 //x2=10.85 //y2=2.98
r400 (  1 13 ) resistor r=0.324427 //w=0.131 //l=0.34 //layer=m1 \
 //thickness=0.36 //x=10.85 //y=2.77 //x2=10.85 //y2=2.43
ends PM_XOR2X1\%B

subckt PM_XOR2X1\%VDD ( 1 2 10 11 12 19 20 29 57 73 87 113 128 130 131 132 136 \
 137 138 139 140 141 142 )
c244 ( 142 0 ) capacitor c=0.0599797f //x=10.77 //y=5.2
c245 ( 141 0 ) capacitor c=0.0577654f //x=9.91 //y=5.2
c246 ( 140 0 ) capacitor c=0.0170134f //x=7.125 //y=5.2
c247 ( 139 0 ) capacitor c=0.0170965f //x=3.795 //y=5.2
c248 ( 138 0 ) capacitor c=0.0586397f //x=1.9 //y=5.2
c249 ( 137 0 ) capacitor c=0.0605586f //x=1.03 //y=5.2
c250 ( 136 0 ) capacitor c=0.257467f //x=10.85 //y=7.58
c251 ( 134 0 ) capacitor c=0.00597439f //x=10.11 //y=7.58
c252 ( 132 0 ) capacitor c=0.118169f //x=9.37 //y=7.585
c253 ( 131 0 ) capacitor c=0.118893f //x=6.04 //y=7.585
c254 ( 130 0 ) capacitor c=0.121818f //x=2.71 //y=7.585
c255 ( 129 0 ) capacitor c=0.00597439f //x=2.045 //y=7.585
c256 ( 128 0 ) capacitor c=0.25643f //x=1.23 //y=7.58
c257 ( 113 0 ) capacitor c=0.0290691f //x=10.83 //y=7.585
c258 ( 103 0 ) capacitor c=0.0208042f //x=9.95 //y=7.585
c259 ( 87 0 ) capacitor c=0.139876f //x=9.2 //y=7.585
c260 ( 73 0 ) capacitor c=0.1391f //x=5.87 //y=7.585
c261 ( 67 0 ) capacitor c=0.0211939f //x=2.54 //y=7.585
c262 ( 57 0 ) capacitor c=0.0287132f //x=1.96 //y=7.585
c263 ( 38 0 ) capacitor c=0.00510714f //x=7.27 //y=7.585
c264 ( 35 0 ) capacitor c=0.00510714f //x=3.94 //y=7.585
c265 ( 29 0 ) capacitor c=0.181594f //x=10.85 //y=7.58
c266 ( 20 0 ) capacitor c=0.0147928f //x=7.27 //y=7.41
c267 ( 19 0 ) capacitor c=0.0127236f //x=7.27 //y=6.69
c268 ( 12 0 ) capacitor c=0.110467f //x=7.185 //y=7.585
c269 ( 11 0 ) capacitor c=0.0153981f //x=3.94 //y=7.41
c270 ( 10 0 ) capacitor c=0.013349f //x=3.94 //y=6.7
c271 ( 2 0 ) capacitor c=0.158536f //x=3.855 //y=7.585
r272 (  115 136 ) resistor r=4.23183 //w=0.7 //l=0.175 //layer=li \
 //thickness=0.1 //x=10.915 //y=7.41 //x2=10.915 //y2=7.585
r273 (  115 142 ) resistor r=56.4706 //w=0.187 //l=0.825 //layer=li \
 //thickness=0.1 //x=10.915 //y=7.41 //x2=10.915 //y2=6.585
r274 (  114 134 ) resistor r=2.87058 //w=0.35 //l=0.085 //layer=li \
 //thickness=0.1 //x=10.12 //y=7.585 //x2=10.035 //y2=7.585
r275 (  113 136 ) resistor r=2.87058 //w=0.35 //l=0.085 //layer=li \
 //thickness=0.1 //x=10.83 //y=7.585 //x2=10.915 //y2=7.585
r276 (  113 114 ) resistor r=24.7629 //w=0.367 //l=0.71 //layer=li \
 //thickness=0.1 //x=10.83 //y=7.585 //x2=10.12 //y2=7.585
r277 (  105 134 ) resistor r=4.23183 //w=0.7 //l=0.175 //layer=li \
 //thickness=0.1 //x=10.035 //y=7.41 //x2=10.035 //y2=7.585
r278 (  105 141 ) resistor r=56.4706 //w=0.187 //l=0.825 //layer=li \
 //thickness=0.1 //x=10.035 //y=7.41 //x2=10.035 //y2=6.585
r279 (  104 132 ) resistor r=5.29055 //w=0.35 //l=0.17 //layer=li \
 //thickness=0.1 //x=9.54 //y=7.585 //x2=9.37 //y2=7.585
r280 (  103 134 ) resistor r=2.87058 //w=0.35 //l=0.085 //layer=li \
 //thickness=0.1 //x=9.95 //y=7.585 //x2=10.035 //y2=7.585
r281 (  103 104 ) resistor r=14.2997 //w=0.367 //l=0.41 //layer=li \
 //thickness=0.1 //x=9.95 //y=7.585 //x2=9.54 //y2=7.585
r282 (  99 140 ) resistor r=23.2727 //w=0.187 //l=0.34 //layer=li \
 //thickness=0.1 //x=7.27 //y=6.575 //x2=7.27 //y2=6.235
r283 (  92 94 ) resistor r=38.7139 //w=0.367 //l=1.11 //layer=li \
 //thickness=0.1 //x=7.52 //y=7.585 //x2=8.63 //y2=7.585
r284 (  90 92 ) resistor r=38.7139 //w=0.367 //l=1.11 //layer=li \
 //thickness=0.1 //x=6.41 //y=7.585 //x2=7.52 //y2=7.585
r285 (  88 131 ) resistor r=5.29055 //w=0.35 //l=0.17 //layer=li \
 //thickness=0.1 //x=6.21 //y=7.585 //x2=6.04 //y2=7.585
r286 (  88 90 ) resistor r=6.97548 //w=0.367 //l=0.2 //layer=li \
 //thickness=0.1 //x=6.21 //y=7.585 //x2=6.41 //y2=7.585
r287 (  87 132 ) resistor r=5.29055 //w=0.35 //l=0.17 //layer=li \
 //thickness=0.1 //x=9.2 //y=7.585 //x2=9.37 //y2=7.585
r288 (  87 94 ) resistor r=19.8801 //w=0.367 //l=0.57 //layer=li \
 //thickness=0.1 //x=9.2 //y=7.585 //x2=8.63 //y2=7.585
r289 (  83 139 ) resistor r=23.2727 //w=0.187 //l=0.34 //layer=li \
 //thickness=0.1 //x=3.94 //y=6.575 //x2=3.94 //y2=6.235
r290 (  76 78 ) resistor r=38.7139 //w=0.367 //l=1.11 //layer=li \
 //thickness=0.1 //x=3.82 //y=7.585 //x2=4.93 //y2=7.585
r291 (  74 130 ) resistor r=5.29055 //w=0.35 //l=0.17 //layer=li \
 //thickness=0.1 //x=2.88 //y=7.585 //x2=2.71 //y2=7.585
r292 (  74 76 ) resistor r=32.7847 //w=0.367 //l=0.94 //layer=li \
 //thickness=0.1 //x=2.88 //y=7.585 //x2=3.82 //y2=7.585
r293 (  73 131 ) resistor r=5.29055 //w=0.35 //l=0.17 //layer=li \
 //thickness=0.1 //x=5.87 //y=7.585 //x2=6.04 //y2=7.585
r294 (  73 78 ) resistor r=32.7847 //w=0.367 //l=0.94 //layer=li \
 //thickness=0.1 //x=5.87 //y=7.585 //x2=4.93 //y2=7.585
r295 (  68 129 ) resistor r=2.87058 //w=0.35 //l=0.085 //layer=li \
 //thickness=0.1 //x=2.13 //y=7.585 //x2=2.045 //y2=7.585
r296 (  68 70 ) resistor r=7.32425 //w=0.367 //l=0.21 //layer=li \
 //thickness=0.1 //x=2.13 //y=7.585 //x2=2.34 //y2=7.585
r297 (  67 130 ) resistor r=5.29055 //w=0.35 //l=0.17 //layer=li \
 //thickness=0.1 //x=2.54 //y=7.585 //x2=2.71 //y2=7.585
r298 (  67 70 ) resistor r=6.97548 //w=0.367 //l=0.2 //layer=li \
 //thickness=0.1 //x=2.54 //y=7.585 //x2=2.34 //y2=7.585
r299 (  59 129 ) resistor r=4.23183 //w=0.7 //l=0.175 //layer=li \
 //thickness=0.1 //x=2.045 //y=7.41 //x2=2.045 //y2=7.585
r300 (  59 138 ) resistor r=56.4706 //w=0.187 //l=0.825 //layer=li \
 //thickness=0.1 //x=2.045 //y=7.41 //x2=2.045 //y2=6.585
r301 (  58 128 ) resistor r=2.87058 //w=0.35 //l=0.085 //layer=li \
 //thickness=0.1 //x=1.25 //y=7.585 //x2=1.165 //y2=7.585
r302 (  57 129 ) resistor r=2.87058 //w=0.35 //l=0.085 //layer=li \
 //thickness=0.1 //x=1.96 //y=7.585 //x2=2.045 //y2=7.585
r303 (  57 58 ) resistor r=24.7629 //w=0.367 //l=0.71 //layer=li \
 //thickness=0.1 //x=1.96 //y=7.585 //x2=1.25 //y2=7.585
r304 (  49 128 ) resistor r=4.23183 //w=0.7 //l=0.175 //layer=li \
 //thickness=0.1 //x=1.165 //y=7.41 //x2=1.165 //y2=7.585
r305 (  49 137 ) resistor r=56.4706 //w=0.187 //l=0.825 //layer=li \
 //thickness=0.1 //x=1.165 //y=7.41 //x2=1.165 //y2=6.585
r306 (  40 99 ) resistor r=9.3 //w=0.17 //l=0.17 //layer=mcon //count=1 \
 //x=7.27 //y=6.575 //x2=7.27 //y2=6.575
r307 (  37 83 ) resistor r=9.3 //w=0.17 //l=0.17 //layer=mcon //count=1 \
 //x=3.94 //y=6.575 //x2=3.94 //y2=6.575
r308 (  29 136 ) resistor r=4.65 //w=0.17 //l=0.34 //layer=mcon //count=2 \
 //x=10.85 //y=7.58 //x2=10.85 //y2=7.58
r309 (  27 134 ) resistor r=3.1 //w=0.17 //l=0.51 //layer=mcon //count=3 \
 //x=10.11 //y=7.58 //x2=10.11 //y2=7.58
r310 (  27 29 ) resistor r=0.297428 //w=0.311 //l=0.74 //layer=m1 \
 //thickness=0.36 //x=10.11 //y=7.585 //x2=10.85 //y2=7.585
r311 (  25 94 ) resistor r=3.1 //w=0.17 //l=0.51 //layer=mcon //count=3 \
 //x=8.63 //y=7.58 //x2=8.63 //y2=7.58
r312 (  25 27 ) resistor r=0.594855 //w=0.311 //l=1.48 //layer=m1 \
 //thickness=0.36 //x=8.63 //y=7.585 //x2=10.11 //y2=7.585
r313 (  23 92 ) resistor r=3.1 //w=0.17 //l=0.51 //layer=mcon //count=3 \
 //x=7.52 //y=7.58 //x2=7.52 //y2=7.58
r314 (  23 25 ) resistor r=0.446141 //w=0.311 //l=1.11 //layer=m1 \
 //thickness=0.36 //x=7.52 //y=7.585 //x2=8.63 //y2=7.585
r315 (  21 38 ) resistor r=0.028033 //w=0.35 //l=0.085 //layer=m1 \
 //thickness=0.36 //x=7.355 //y=7.585 //x2=7.27 //y2=7.585
r316 (  21 23 ) resistor r=0.0663183 //w=0.311 //l=0.165 //layer=m1 \
 //thickness=0.36 //x=7.355 //y=7.585 //x2=7.52 //y2=7.585
r317 (  20 38 ) resistor r=0.0413265 //w=0.7 //l=0.175 //layer=m1 \
 //thickness=0.36 //x=7.27 //y=7.41 //x2=7.27 //y2=7.585
r318 (  19 40 ) resistor r=0.0717383 //w=0.224 //l=0.115 //layer=m1 \
 //thickness=0.36 //x=7.27 //y=6.69 //x2=7.27 //y2=6.575
r319 (  19 20 ) resistor r=0.687023 //w=0.131 //l=0.72 //layer=m1 \
 //thickness=0.36 //x=7.27 //y=6.69 //x2=7.27 //y2=7.41
r320 (  18 90 ) resistor r=3.1 //w=0.17 //l=0.51 //layer=mcon //count=3 \
 //x=6.41 //y=7.58 //x2=6.41 //y2=7.58
r321 (  15 78 ) resistor r=3.1 //w=0.17 //l=0.51 //layer=mcon //count=3 \
 //x=4.93 //y=7.58 //x2=4.93 //y2=7.58
r322 (  13 35 ) resistor r=0.028033 //w=0.35 //l=0.085 //layer=m1 \
 //thickness=0.36 //x=4.025 //y=7.585 //x2=3.94 //y2=7.585
r323 (  13 15 ) resistor r=0.363746 //w=0.311 //l=0.905 //layer=m1 \
 //thickness=0.36 //x=4.025 //y=7.585 //x2=4.93 //y2=7.585
r324 (  12 38 ) resistor r=0.028033 //w=0.35 //l=0.085 //layer=m1 \
 //thickness=0.36 //x=7.185 //y=7.585 //x2=7.27 //y2=7.585
r325 (  12 18 ) resistor r=0.311495 //w=0.311 //l=0.775 //layer=m1 \
 //thickness=0.36 //x=7.185 //y=7.585 //x2=6.41 //y2=7.585
r326 (  11 35 ) resistor r=0.0413265 //w=0.7 //l=0.175 //layer=m1 \
 //thickness=0.36 //x=3.94 //y=7.41 //x2=3.94 //y2=7.585
r327 (  10 37 ) resistor r=0.0773187 //w=0.224 //l=0.125 //layer=m1 \
 //thickness=0.36 //x=3.94 //y=6.7 //x2=3.94 //y2=6.575
r328 (  10 11 ) resistor r=0.677481 //w=0.131 //l=0.71 //layer=m1 \
 //thickness=0.36 //x=3.94 //y=6.7 //x2=3.94 //y2=7.41
r329 (  9 76 ) resistor r=3.1 //w=0.17 //l=0.51 //layer=mcon //count=3 \
 //x=3.82 //y=7.58 //x2=3.82 //y2=7.58
r330 (  7 70 ) resistor r=3.1 //w=0.17 //l=0.51 //layer=mcon //count=3 \
 //x=2.34 //y=7.58 //x2=2.34 //y2=7.58
r331 (  7 9 ) resistor r=0.594855 //w=0.311 //l=1.48 //layer=m1 \
 //thickness=0.36 //x=2.34 //y=7.585 //x2=3.82 //y2=7.585
r332 (  4 128 ) resistor r=3.1 //w=0.17 //l=0.51 //layer=mcon //count=3 \
 //x=1.23 //y=7.58 //x2=1.23 //y2=7.58
r333 (  4 7 ) resistor r=0.446141 //w=0.311 //l=1.11 //layer=m1 \
 //thickness=0.36 //x=1.23 //y=7.585 //x2=2.34 //y2=7.585
r334 (  2 35 ) resistor r=0.028033 //w=0.35 //l=0.085 //layer=m1 \
 //thickness=0.36 //x=3.855 //y=7.585 //x2=3.94 //y2=7.585
r335 (  2 9 ) resistor r=0.0140675 //w=0.311 //l=0.035 //layer=m1 \
 //thickness=0.36 //x=3.855 //y=7.585 //x2=3.82 //y2=7.585
r336 (  1 18 ) resistor r=0.148714 //w=0.311 //l=0.37 //layer=m1 \
 //thickness=0.36 //x=6.04 //y=7.585 //x2=6.41 //y2=7.585
r337 (  1 15 ) resistor r=0.446141 //w=0.311 //l=1.11 //layer=m1 \
 //thickness=0.36 //x=6.04 //y=7.585 //x2=4.93 //y2=7.585
ends PM_XOR2X1\%VDD

subckt PM_XOR2X1\%noxref_7 ( 1 3 5 10 14 17 20 30 46 47 48 )
c83 ( 48 0 ) capacitor c=0.0367727f //x=5.115 //y=5.2
c84 ( 46 0 ) capacitor c=0.0184616f //x=3.365 //y=5.2
c85 ( 30 0 ) capacitor c=0.0317225f //x=4.38 //y=5.555
c86 ( 20 0 ) capacitor c=0.0447371f //x=3.5 //y=5.555
c87 ( 17 0 ) capacitor c=0.0100496f //x=5.26 //y=6.915
c88 ( 14 0 ) capacitor c=0.00636436f //x=4.38 //y=6.915
c89 ( 10 0 ) capacitor c=0.0123428f //x=4.38 //y=5.385
c90 ( 5 0 ) capacitor c=0.0123915f //x=3.507 //y=5.385
c91 ( 3 0 ) capacitor c=0.00891704f //x=5.145 //y=7.085
c92 ( 1 0 ) capacitor c=0.0141892f //x=4.26 //y=5.385
r93 (  37 47 ) resistor r=23.2727 //w=0.187 //l=0.34 //layer=li \
 //thickness=0.1 //x=4.38 //y=6.915 //x2=4.38 //y2=6.575
r94 (  30 47 ) resistor r=23.2727 //w=0.187 //l=0.34 //layer=li \
 //thickness=0.1 //x=4.38 //y=5.555 //x2=4.38 //y2=5.895
r95 (  20 46 ) resistor r=23.2727 //w=0.187 //l=0.34 //layer=li \
 //thickness=0.1 //x=3.5 //y=5.555 //x2=3.5 //y2=5.895
r96 (  17 48 ) resistor r=9.3 //w=0.17 //l=0.17 //layer=mcon //count=1 \
 //x=5.26 //y=6.915 //x2=5.26 //y2=6.915
r97 (  17 18 ) resistor r=0.0997653 //w=0.213 //l=0.17 //layer=m1 \
 //thickness=0.36 //x=5.26 //y=6.915 //x2=5.26 //y2=7.085
r98 (  14 37 ) resistor r=9.3 //w=0.17 //l=0.17 //layer=mcon //count=1 \
 //x=4.38 //y=6.915 //x2=4.38 //y2=6.915
r99 (  14 15 ) resistor r=0.100236 //w=0.212 //l=0.17 //layer=m1 \
 //thickness=0.36 //x=4.38 //y=6.915 //x2=4.38 //y2=7.085
r100 (  12 30 ) resistor r=9.3 //w=0.17 //l=0.17 //layer=mcon //count=1 \
 //x=4.38 //y=5.555 //x2=4.38 //y2=5.555
r101 (  10 12 ) resistor r=0.0965909 //w=0.22 //l=0.17 //layer=m1 \
 //thickness=0.36 //x=4.38 //y=5.385 //x2=4.38 //y2=5.555
r102 (  7 20 ) resistor r=9.3 //w=0.17 //l=0.17 //layer=mcon //count=1 //x=3.5 \
 //y=5.555 //x2=3.5 //y2=5.555
r103 (  5 7 ) resistor r=0.0912017 //w=0.233 //l=0.17 //layer=m1 \
 //thickness=0.36 //x=3.507 //y=5.385 //x2=3.507 //y2=5.555
r104 (  4 15 ) resistor r=0.0208269 //w=0.212 //l=0.115 //layer=m1 \
 //thickness=0.36 //x=4.495 //y=7.085 //x2=4.38 //y2=7.085
r105 (  3 18 ) resistor r=0.0211096 //w=0.213 //l=0.115 //layer=m1 \
 //thickness=0.36 //x=5.145 //y=7.085 //x2=5.26 //y2=7.085
r106 (  3 4 ) resistor r=0.620229 //w=0.131 //l=0.65 //layer=m1 \
 //thickness=0.36 //x=5.145 //y=7.085 //x2=4.495 //y2=7.085
r107 (  2 5 ) resistor r=0.0264833 //w=0.233 //l=0.128 //layer=m1 \
 //thickness=0.36 //x=3.635 //y=5.385 //x2=3.507 //y2=5.385
r108 (  1 10 ) resistor r=0.0230492 //w=0.22 //l=0.12 //layer=m1 \
 //thickness=0.36 //x=4.26 //y=5.385 //x2=4.38 //y2=5.385
r109 (  1 2 ) resistor r=0.596374 //w=0.131 //l=0.625 //layer=m1 \
 //thickness=0.36 //x=4.26 //y=5.385 //x2=3.635 //y2=5.385
ends PM_XOR2X1\%noxref_7

subckt PM_XOR2X1\%noxref_8 ( 1 3 5 10 14 17 20 30 46 47 48 )
c81 ( 48 0 ) capacitor c=0.0344743f //x=8.445 //y=5.2
c82 ( 46 0 ) capacitor c=0.0123991f //x=6.695 //y=5.2
c83 ( 30 0 ) capacitor c=0.0304667f //x=7.71 //y=5.555
c84 ( 20 0 ) capacitor c=0.0472305f //x=6.83 //y=5.555
c85 ( 17 0 ) capacitor c=0.0161402f //x=8.59 //y=6.915
c86 ( 14 0 ) capacitor c=0.00620376f //x=7.71 //y=6.915
c87 ( 10 0 ) capacitor c=0.0090232f //x=7.71 //y=5.385
c88 ( 5 0 ) capacitor c=0.0125427f //x=6.83 //y=5.385
c89 ( 3 0 ) capacitor c=0.00902211f //x=8.47 //y=7.085
c90 ( 1 0 ) capacitor c=0.0120258f //x=7.595 //y=5.385
r91 (  37 47 ) resistor r=23.2727 //w=0.187 //l=0.34 //layer=li \
 //thickness=0.1 //x=7.71 //y=6.915 //x2=7.71 //y2=6.575
r92 (  30 47 ) resistor r=23.2727 //w=0.187 //l=0.34 //layer=li \
 //thickness=0.1 //x=7.71 //y=5.555 //x2=7.71 //y2=5.895
r93 (  20 46 ) resistor r=23.2727 //w=0.187 //l=0.34 //layer=li \
 //thickness=0.1 //x=6.83 //y=5.555 //x2=6.83 //y2=5.895
r94 (  17 48 ) resistor r=9.3 //w=0.17 //l=0.17 //layer=mcon //count=1 \
 //x=8.59 //y=6.915 //x2=8.59 //y2=6.915
r95 (  17 18 ) resistor r=0.097032 //w=0.219 //l=0.17 //layer=m1 \
 //thickness=0.36 //x=8.587 //y=6.915 //x2=8.587 //y2=7.085
r96 (  14 37 ) resistor r=9.3 //w=0.17 //l=0.17 //layer=mcon //count=1 \
 //x=7.71 //y=6.915 //x2=7.71 //y2=6.915
r97 (  14 15 ) resistor r=0.100236 //w=0.212 //l=0.17 //layer=m1 \
 //thickness=0.36 //x=7.71 //y=6.915 //x2=7.71 //y2=7.085
r98 (  12 30 ) resistor r=9.3 //w=0.17 //l=0.17 //layer=mcon //count=1 \
 //x=7.71 //y=5.555 //x2=7.71 //y2=5.555
r99 (  10 12 ) resistor r=0.100236 //w=0.212 //l=0.17 //layer=m1 \
 //thickness=0.36 //x=7.71 //y=5.385 //x2=7.71 //y2=5.555
r100 (  7 20 ) resistor r=9.3 //w=0.17 //l=0.17 //layer=mcon //count=1 \
 //x=6.83 //y=5.555 //x2=6.83 //y2=5.555
r101 (  5 7 ) resistor r=0.100236 //w=0.212 //l=0.17 //layer=m1 \
 //thickness=0.36 //x=6.83 //y=5.385 //x2=6.83 //y2=5.555
r102 (  4 15 ) resistor r=0.0208269 //w=0.212 //l=0.115 //layer=m1 \
 //thickness=0.36 //x=7.825 //y=7.085 //x2=7.71 //y2=7.085
r103 (  3 18 ) resistor r=0.0227762 //w=0.219 //l=0.117 //layer=m1 \
 //thickness=0.36 //x=8.47 //y=7.085 //x2=8.587 //y2=7.085
r104 (  3 4 ) resistor r=0.615458 //w=0.131 //l=0.645 //layer=m1 \
 //thickness=0.36 //x=8.47 //y=7.085 //x2=7.825 //y2=7.085
r105 (  2 5 ) resistor r=0.0208269 //w=0.212 //l=0.115 //layer=m1 \
 //thickness=0.36 //x=6.945 //y=5.385 //x2=6.83 //y2=5.385
r106 (  1 10 ) resistor r=0.0208269 //w=0.212 //l=0.115 //layer=m1 \
 //thickness=0.36 //x=7.595 //y=5.385 //x2=7.71 //y2=5.385
r107 (  1 2 ) resistor r=0.620229 //w=0.131 //l=0.65 //layer=m1 \
 //thickness=0.36 //x=7.595 //y=5.385 //x2=6.945 //y2=5.385
ends PM_XOR2X1\%noxref_8

subckt PM_XOR2X1\%GND ( 1 2 9 10 18 27 46 50 53 64 77 95 100 104 116 127 128 \
 129 136 143 144 145 146 )
c241 ( 146 0 ) capacitor c=0.0634172f //x=9.865 //y=0.55
c242 ( 145 0 ) capacitor c=0.00839739f //x=7.03 //y=1.05
c243 ( 144 0 ) capacitor c=0.00839739f //x=3.7 //y=1.05
c244 ( 143 0 ) capacitor c=0.0629136f //x=0.985 //y=0.55
c245 ( 136 0 ) capacitor c=0.253666f //x=10.96 //y=0.175
c246 ( 129 0 ) capacitor c=0.113187f //x=9.37 //y=0.175
c247 ( 128 0 ) capacitor c=0.111601f //x=6.04 //y=0.175
c248 ( 127 0 ) capacitor c=0.108471f //x=2.71 //y=0.175
c249 ( 116 0 ) capacitor c=0.215034f //x=1.12 //y=0.175
c250 ( 107 0 ) capacitor c=0.00590583f //x=10.96 //y=0.63
c251 ( 104 0 ) capacitor c=0.00599833f //x=10.875 //y=0.715
c252 ( 103 0 ) capacitor c=0.00479851f //x=10.48 //y=0.63
c253 ( 100 0 ) capacitor c=0.0061439f //x=10.395 //y=0.715
c254 ( 95 0 ) capacitor c=0.00589014f //x=9.99 //y=0.63
c255 ( 92 0 ) capacitor c=0.0185464f //x=9.905 //y=0.175
c256 ( 77 0 ) capacitor c=0.126479f //x=9.2 //y=0.175
c257 ( 64 0 ) capacitor c=0.125892f //x=5.87 //y=0.175
c258 ( 59 0 ) capacitor c=0.0366946f //x=2.175 //y=0.175
c259 ( 58 0 ) capacitor c=0.0185573f //x=2.54 //y=0.175
c260 ( 53 0 ) capacitor c=0.00589014f //x=2.09 //y=0.63
c261 ( 50 0 ) capacitor c=0.00605867f //x=2.005 //y=0.715
c262 ( 49 0 ) capacitor c=0.00479851f //x=1.6 //y=0.63
c263 ( 46 0 ) capacitor c=0.00645303f //x=1.515 //y=0.715
c264 ( 41 0 ) capacitor c=0.00590583f //x=1.12 //y=0.63
c265 ( 33 0 ) capacitor c=0.00509249f //x=7.22 //y=0.175
c266 ( 30 0 ) capacitor c=0.00509249f //x=3.82 //y=0.18
c267 ( 27 0 ) capacitor c=0.180096f //x=10.85 //y=0.18
c268 ( 18 0 ) capacitor c=0.0338236f //x=7.22 //y=1.025
c269 ( 10 0 ) capacitor c=0.108721f //x=7.135 //y=0.175
c270 ( 9 0 ) capacitor c=0.0343697f //x=3.89 //y=1.025
c271 ( 2 0 ) capacitor c=0.153907f //x=3.805 //y=0.175
r272 (  135 136 ) resistor r=3.83651 //w=0.367 //l=0.11 //layer=li \
 //thickness=0.1 //x=10.85 //y=0.175 //x2=10.96 //y2=0.175
r273 (  133 135 ) resistor r=12.9046 //w=0.367 //l=0.37 //layer=li \
 //thickness=0.1 //x=10.48 //y=0.175 //x2=10.85 //y2=0.175
r274 (  132 133 ) resistor r=12.9046 //w=0.367 //l=0.37 //layer=li \
 //thickness=0.1 //x=10.11 //y=0.175 //x2=10.48 //y2=0.175
r275 (  130 132 ) resistor r=4.18529 //w=0.367 //l=0.12 //layer=li \
 //thickness=0.1 //x=9.99 //y=0.175 //x2=10.11 //y2=0.175
r276 (  119 120 ) resistor r=17.0899 //w=0.367 //l=0.49 //layer=li \
 //thickness=0.1 //x=1.6 //y=0.175 //x2=2.09 //y2=0.175
r277 (  118 119 ) resistor r=12.9046 //w=0.367 //l=0.37 //layer=li \
 //thickness=0.1 //x=1.23 //y=0.175 //x2=1.6 //y2=0.175
r278 (  116 118 ) resistor r=3.83651 //w=0.367 //l=0.11 //layer=li \
 //thickness=0.1 //x=1.12 //y=0.175 //x2=1.23 //y2=0.175
r279 (  108 146 ) resistor r=5.4201 //w=0.17 //l=0.085 //layer=li \
 //thickness=0.1 //x=10.96 //y=0.8 //x2=10.96 //y2=0.715
r280 (  108 146 ) resistor r=41.4118 //w=0.187 //l=0.605 //layer=li \
 //thickness=0.1 //x=10.96 //y=0.8 //x2=10.96 //y2=1.405
r281 (  107 146 ) resistor r=5.4201 //w=0.17 //l=0.085 //layer=li \
 //thickness=0.1 //x=10.96 //y=0.63 //x2=10.96 //y2=0.715
r282 (  106 136 ) resistor r=5.21862 //w=0.35 //l=0.175 //layer=li \
 //thickness=0.1 //x=10.96 //y=0.35 //x2=10.96 //y2=0.175
r283 (  106 107 ) resistor r=19.1658 //w=0.187 //l=0.28 //layer=li \
 //thickness=0.1 //x=10.96 //y=0.35 //x2=10.96 //y2=0.63
r284 (  105 146 ) resistor r=5.4201 //w=0.17 //l=0.085 //layer=li \
 //thickness=0.1 //x=10.565 //y=0.715 //x2=10.48 //y2=0.715
r285 (  104 146 ) resistor r=1.40859 //w=0.34 //l=0.085 //layer=li \
 //thickness=0.1 //x=10.875 //y=0.715 //x2=10.96 //y2=0.715
r286 (  104 105 ) resistor r=21.2193 //w=0.187 //l=0.31 //layer=li \
 //thickness=0.1 //x=10.875 //y=0.715 //x2=10.565 //y2=0.715
r287 (  103 146 ) resistor r=1.40859 //w=0.34 //l=0.085 //layer=li \
 //thickness=0.1 //x=10.48 //y=0.63 //x2=10.48 //y2=0.715
r288 (  102 133 ) resistor r=5.21862 //w=0.35 //l=0.175 //layer=li \
 //thickness=0.1 //x=10.48 //y=0.35 //x2=10.48 //y2=0.175
r289 (  102 103 ) resistor r=19.1658 //w=0.187 //l=0.28 //layer=li \
 //thickness=0.1 //x=10.48 //y=0.35 //x2=10.48 //y2=0.63
r290 (  101 146 ) resistor r=1.40859 //w=0.34 //l=0.085 //layer=li \
 //thickness=0.1 //x=10.075 //y=0.715 //x2=9.99 //y2=0.715
r291 (  100 146 ) resistor r=5.4201 //w=0.17 //l=0.085 //layer=li \
 //thickness=0.1 //x=10.395 //y=0.715 //x2=10.48 //y2=0.715
r292 (  100 101 ) resistor r=21.9037 //w=0.187 //l=0.32 //layer=li \
 //thickness=0.1 //x=10.395 //y=0.715 //x2=10.075 //y2=0.715
r293 (  96 146 ) resistor r=5.4201 //w=0.17 //l=0.085 //layer=li \
 //thickness=0.1 //x=9.99 //y=0.8 //x2=9.99 //y2=0.715
r294 (  96 146 ) resistor r=41.4118 //w=0.187 //l=0.605 //layer=li \
 //thickness=0.1 //x=9.99 //y=0.8 //x2=9.99 //y2=1.405
r295 (  95 146 ) resistor r=5.4201 //w=0.17 //l=0.085 //layer=li \
 //thickness=0.1 //x=9.99 //y=0.63 //x2=9.99 //y2=0.715
r296 (  94 130 ) resistor r=5.21862 //w=0.35 //l=0.175 //layer=li \
 //thickness=0.1 //x=9.99 //y=0.35 //x2=9.99 //y2=0.175
r297 (  94 95 ) resistor r=19.1658 //w=0.187 //l=0.28 //layer=li \
 //thickness=0.1 //x=9.99 //y=0.35 //x2=9.99 //y2=0.63
r298 (  93 129 ) resistor r=5.29055 //w=0.35 //l=0.17 //layer=li \
 //thickness=0.1 //x=9.54 //y=0.175 //x2=9.37 //y2=0.175
r299 (  92 130 ) resistor r=2.96458 //w=0.367 //l=0.085 //layer=li \
 //thickness=0.1 //x=9.905 //y=0.175 //x2=9.99 //y2=0.175
r300 (  92 93 ) resistor r=12.7302 //w=0.367 //l=0.365 //layer=li \
 //thickness=0.1 //x=9.905 //y=0.175 //x2=9.54 //y2=0.175
r301 (  82 84 ) resistor r=38.7139 //w=0.367 //l=1.11 //layer=li \
 //thickness=0.1 //x=7.52 //y=0.175 //x2=8.63 //y2=0.175
r302 (  80 82 ) resistor r=38.7139 //w=0.367 //l=1.11 //layer=li \
 //thickness=0.1 //x=6.41 //y=0.175 //x2=7.52 //y2=0.175
r303 (  78 128 ) resistor r=5.29055 //w=0.35 //l=0.17 //layer=li \
 //thickness=0.1 //x=6.21 //y=0.175 //x2=6.04 //y2=0.175
r304 (  78 80 ) resistor r=6.97548 //w=0.367 //l=0.2 //layer=li \
 //thickness=0.1 //x=6.21 //y=0.175 //x2=6.41 //y2=0.175
r305 (  77 129 ) resistor r=5.29055 //w=0.35 //l=0.17 //layer=li \
 //thickness=0.1 //x=9.2 //y=0.175 //x2=9.37 //y2=0.175
r306 (  77 84 ) resistor r=19.8801 //w=0.367 //l=0.57 //layer=li \
 //thickness=0.1 //x=9.2 //y=0.175 //x2=8.63 //y2=0.175
r307 (  67 69 ) resistor r=38.7139 //w=0.367 //l=1.11 //layer=li \
 //thickness=0.1 //x=3.82 //y=0.175 //x2=4.93 //y2=0.175
r308 (  65 127 ) resistor r=5.29055 //w=0.35 //l=0.17 //layer=li \
 //thickness=0.1 //x=2.88 //y=0.175 //x2=2.71 //y2=0.175
r309 (  65 67 ) resistor r=32.7847 //w=0.367 //l=0.94 //layer=li \
 //thickness=0.1 //x=2.88 //y=0.175 //x2=3.82 //y2=0.175
r310 (  64 128 ) resistor r=5.29055 //w=0.35 //l=0.17 //layer=li \
 //thickness=0.1 //x=5.87 //y=0.175 //x2=6.04 //y2=0.175
r311 (  64 69 ) resistor r=32.7847 //w=0.367 //l=0.94 //layer=li \
 //thickness=0.1 //x=5.87 //y=0.175 //x2=4.93 //y2=0.175
r312 (  59 120 ) resistor r=2.96458 //w=0.367 //l=0.085 //layer=li \
 //thickness=0.1 //x=2.175 //y=0.175 //x2=2.09 //y2=0.175
r313 (  59 61 ) resistor r=5.75477 //w=0.367 //l=0.165 //layer=li \
 //thickness=0.1 //x=2.175 //y=0.175 //x2=2.34 //y2=0.175
r314 (  58 127 ) resistor r=5.29055 //w=0.35 //l=0.17 //layer=li \
 //thickness=0.1 //x=2.54 //y=0.175 //x2=2.71 //y2=0.175
r315 (  58 61 ) resistor r=6.97548 //w=0.367 //l=0.2 //layer=li \
 //thickness=0.1 //x=2.54 //y=0.175 //x2=2.34 //y2=0.175
r316 (  54 143 ) resistor r=5.4201 //w=0.17 //l=0.085 //layer=li \
 //thickness=0.1 //x=2.09 //y=0.8 //x2=2.09 //y2=0.715
r317 (  54 143 ) resistor r=41.4118 //w=0.187 //l=0.605 //layer=li \
 //thickness=0.1 //x=2.09 //y=0.8 //x2=2.09 //y2=1.405
r318 (  53 143 ) resistor r=5.4201 //w=0.17 //l=0.085 //layer=li \
 //thickness=0.1 //x=2.09 //y=0.63 //x2=2.09 //y2=0.715
r319 (  52 120 ) resistor r=5.21862 //w=0.35 //l=0.175 //layer=li \
 //thickness=0.1 //x=2.09 //y=0.35 //x2=2.09 //y2=0.175
r320 (  52 53 ) resistor r=19.1658 //w=0.187 //l=0.28 //layer=li \
 //thickness=0.1 //x=2.09 //y=0.35 //x2=2.09 //y2=0.63
r321 (  51 143 ) resistor r=5.4201 //w=0.17 //l=0.085 //layer=li \
 //thickness=0.1 //x=1.685 //y=0.715 //x2=1.6 //y2=0.715
r322 (  50 143 ) resistor r=1.40859 //w=0.34 //l=0.085 //layer=li \
 //thickness=0.1 //x=2.005 //y=0.715 //x2=2.09 //y2=0.715
r323 (  50 51 ) resistor r=21.9037 //w=0.187 //l=0.32 //layer=li \
 //thickness=0.1 //x=2.005 //y=0.715 //x2=1.685 //y2=0.715
r324 (  49 143 ) resistor r=1.40859 //w=0.34 //l=0.085 //layer=li \
 //thickness=0.1 //x=1.6 //y=0.63 //x2=1.6 //y2=0.715
r325 (  48 119 ) resistor r=5.21862 //w=0.35 //l=0.175 //layer=li \
 //thickness=0.1 //x=1.6 //y=0.35 //x2=1.6 //y2=0.175
r326 (  48 49 ) resistor r=19.1658 //w=0.187 //l=0.28 //layer=li \
 //thickness=0.1 //x=1.6 //y=0.35 //x2=1.6 //y2=0.63
r327 (  47 143 ) resistor r=1.40859 //w=0.34 //l=0.085 //layer=li \
 //thickness=0.1 //x=1.205 //y=0.715 //x2=1.12 //y2=0.715
r328 (  46 143 ) resistor r=5.4201 //w=0.17 //l=0.085 //layer=li \
 //thickness=0.1 //x=1.515 //y=0.715 //x2=1.6 //y2=0.715
r329 (  46 47 ) resistor r=21.2193 //w=0.187 //l=0.31 //layer=li \
 //thickness=0.1 //x=1.515 //y=0.715 //x2=1.205 //y2=0.715
r330 (  42 143 ) resistor r=5.4201 //w=0.17 //l=0.085 //layer=li \
 //thickness=0.1 //x=1.12 //y=0.8 //x2=1.12 //y2=0.715
r331 (  42 143 ) resistor r=41.4118 //w=0.187 //l=0.605 //layer=li \
 //thickness=0.1 //x=1.12 //y=0.8 //x2=1.12 //y2=1.405
r332 (  41 143 ) resistor r=5.4201 //w=0.17 //l=0.085 //layer=li \
 //thickness=0.1 //x=1.12 //y=0.63 //x2=1.12 //y2=0.715
r333 (  40 116 ) resistor r=5.21862 //w=0.35 //l=0.175 //layer=li \
 //thickness=0.1 //x=1.12 //y=0.35 //x2=1.12 //y2=0.175
r334 (  40 41 ) resistor r=19.1658 //w=0.187 //l=0.28 //layer=li \
 //thickness=0.1 //x=1.12 //y=0.35 //x2=1.12 //y2=0.63
r335 (  35 145 ) resistor r=9.3 //w=0.17 //l=0.17 //layer=mcon //count=1 \
 //x=7.22 //y=1.14 //x2=7.22 //y2=1.14
r336 (  32 144 ) resistor r=9.3 //w=0.17 //l=0.17 //layer=mcon //count=1 \
 //x=3.89 //y=1.14 //x2=3.89 //y2=1.14
r337 (  30 67 ) resistor r=3.1 //w=0.17 //l=0.51 //layer=mcon //count=3 \
 //x=3.82 //y=0.18 //x2=3.82 //y2=0.18
r338 (  27 135 ) resistor r=4.65 //w=0.17 //l=0.34 //layer=mcon //count=2 \
 //x=10.85 //y=0.18 //x2=10.85 //y2=0.18
r339 (  25 132 ) resistor r=3.1 //w=0.17 //l=0.51 //layer=mcon //count=3 \
 //x=10.11 //y=0.18 //x2=10.11 //y2=0.18
r340 (  25 27 ) resistor r=0.297428 //w=0.311 //l=0.74 //layer=m1 \
 //thickness=0.36 //x=10.11 //y=0.175 //x2=10.85 //y2=0.175
r341 (  23 84 ) resistor r=3.1 //w=0.17 //l=0.51 //layer=mcon //count=3 \
 //x=8.63 //y=0.18 //x2=8.63 //y2=0.18
r342 (  23 25 ) resistor r=0.594855 //w=0.311 //l=1.48 //layer=m1 \
 //thickness=0.36 //x=8.63 //y=0.175 //x2=10.11 //y2=0.175
r343 (  21 82 ) resistor r=3.1 //w=0.17 //l=0.51 //layer=mcon //count=3 \
 //x=7.52 //y=0.18 //x2=7.52 //y2=0.18
r344 (  21 23 ) resistor r=0.446141 //w=0.311 //l=1.11 //layer=m1 \
 //thickness=0.36 //x=7.52 //y=0.175 //x2=8.63 //y2=0.175
r345 (  19 33 ) resistor r=0.028033 //w=0.35 //l=0.085 //layer=m1 \
 //thickness=0.36 //x=7.305 //y=0.175 //x2=7.22 //y2=0.175
r346 (  19 21 ) resistor r=0.0864148 //w=0.311 //l=0.215 //layer=m1 \
 //thickness=0.36 //x=7.305 //y=0.175 //x2=7.52 //y2=0.175
r347 (  18 35 ) resistor r=0.0717383 //w=0.224 //l=0.115 //layer=m1 \
 //thickness=0.36 //x=7.22 //y=1.025 //x2=7.22 //y2=1.14
r348 (  17 33 ) resistor r=0.0413265 //w=0.7 //l=0.175 //layer=m1 \
 //thickness=0.36 //x=7.22 //y=0.35 //x2=7.22 //y2=0.175
r349 (  17 18 ) resistor r=0.644084 //w=0.131 //l=0.675 //layer=m1 \
 //thickness=0.36 //x=7.22 //y=0.35 //x2=7.22 //y2=1.025
r350 (  16 80 ) resistor r=3.1 //w=0.17 //l=0.51 //layer=mcon //count=3 \
 //x=6.41 //y=0.18 //x2=6.41 //y2=0.18
r351 (  13 69 ) resistor r=3.1 //w=0.17 //l=0.51 //layer=mcon //count=3 \
 //x=4.93 //y=0.18 //x2=4.93 //y2=0.18
r352 (  11 30 ) resistor r=0.028033 //w=0.35 //l=0.085 //layer=m1 \
 //thickness=0.36 //x=3.975 //y=0.175 //x2=3.89 //y2=0.175
r353 (  11 13 ) resistor r=0.383842 //w=0.311 //l=0.955 //layer=m1 \
 //thickness=0.36 //x=3.975 //y=0.175 //x2=4.93 //y2=0.175
r354 (  10 33 ) resistor r=0.028033 //w=0.35 //l=0.085 //layer=m1 \
 //thickness=0.36 //x=7.135 //y=0.175 //x2=7.22 //y2=0.175
r355 (  10 16 ) resistor r=0.291399 //w=0.311 //l=0.725 //layer=m1 \
 //thickness=0.36 //x=7.135 //y=0.175 //x2=6.41 //y2=0.175
r356 (  9 32 ) resistor r=0.0713327 //w=0.229 //l=0.115996 //layer=m1 \
 //thickness=0.36 //x=3.89 //y=1.025 //x2=3.892 //y2=1.14
r357 (  8 30 ) resistor r=0.0413265 //w=0.7 //l=0.175 //layer=m1 \
 //thickness=0.36 //x=3.89 //y=0.35 //x2=3.89 //y2=0.175
r358 (  8 9 ) resistor r=0.644084 //w=0.131 //l=0.675 //layer=m1 \
 //thickness=0.36 //x=3.89 //y=0.35 //x2=3.89 //y2=1.025
r359 (  7 61 ) resistor r=3.1 //w=0.17 //l=0.51 //layer=mcon //count=3 \
 //x=2.34 //y=0.18 //x2=2.34 //y2=0.18
r360 (  4 118 ) resistor r=3.1 //w=0.17 //l=0.51 //layer=mcon //count=3 \
 //x=1.23 //y=0.18 //x2=1.23 //y2=0.18
r361 (  4 7 ) resistor r=0.446141 //w=0.311 //l=1.11 //layer=m1 \
 //thickness=0.36 //x=1.23 //y=0.175 //x2=2.34 //y2=0.175
r362 (  2 30 ) resistor r=0.028033 //w=0.35 //l=0.085 //layer=m1 \
 //thickness=0.36 //x=3.805 //y=0.175 //x2=3.89 //y2=0.175
r363 (  2 7 ) resistor r=0.588826 //w=0.311 //l=1.465 //layer=m1 \
 //thickness=0.36 //x=3.805 //y=0.175 //x2=2.34 //y2=0.175
r364 (  1 16 ) resistor r=0.148714 //w=0.311 //l=0.37 //layer=m1 \
 //thickness=0.36 //x=6.04 //y=0.175 //x2=6.41 //y2=0.175
r365 (  1 13 ) resistor r=0.446141 //w=0.311 //l=1.11 //layer=m1 \
 //thickness=0.36 //x=6.04 //y=0.175 //x2=4.93 //y2=0.175
ends PM_XOR2X1\%GND

subckt PM_XOR2X1\%noxref_10 ( 1 5 9 10 13 17 29 )
c64 ( 29 0 ) capacitor c=0.0666923f //x=3.27 //y=0.55
c65 ( 17 0 ) capacitor c=0.00679669f //x=5.345 //y=0.8
c66 ( 13 0 ) capacitor c=0.0160622f //x=5.26 //y=0.715
c67 ( 10 0 ) capacitor c=0.0074137f //x=4.375 //y=1.68
c68 ( 9 0 ) capacitor c=0.00771051f //x=4.375 //y=0.8
c69 ( 5 0 ) capacitor c=0.0183783f //x=4.29 //y=1.765
c70 ( 1 0 ) capacitor c=0.00784591f //x=3.405 //y=1.68
r71 (  17 29 ) resistor r=3.57586 //w=0.17 //l=0.125 //layer=li \
 //thickness=0.1 //x=5.345 //y=0.8 //x2=5.345 //y2=0.675
r72 (  17 29 ) resistor r=18.139 //w=0.187 //l=0.265 //layer=li \
 //thickness=0.1 //x=5.345 //y=0.8 //x2=5.345 //y2=1.065
r73 (  14 29 ) resistor r=3.57586 //w=0.17 //l=0.103078 //layer=li \
 //thickness=0.1 //x=4.46 //y=0.715 //x2=4.375 //y2=0.675
r74 (  14 29 ) resistor r=27.3797 //w=0.187 //l=0.4 //layer=li //thickness=0.1 \
 //x=4.46 //y=0.715 //x2=4.86 //y2=0.715
r75 (  13 29 ) resistor r=3.57586 //w=0.17 //l=0.103078 //layer=li \
 //thickness=0.1 //x=5.26 //y=0.715 //x2=5.345 //y2=0.675
r76 (  13 29 ) resistor r=27.3797 //w=0.187 //l=0.4 //layer=li //thickness=0.1 \
 //x=5.26 //y=0.715 //x2=4.86 //y2=0.715
r77 (  10 29 ) resistor r=3.57586 //w=0.17 //l=0.125 //layer=li \
 //thickness=0.1 //x=4.375 //y=1.68 //x2=4.375 //y2=1.805
r78 (  10 29 ) resistor r=42.0963 //w=0.187 //l=0.615 //layer=li \
 //thickness=0.1 //x=4.375 //y=1.68 //x2=4.375 //y2=1.065
r79 (  9 29 ) resistor r=3.57586 //w=0.17 //l=0.125 //layer=li //thickness=0.1 \
 //x=4.375 //y=0.8 //x2=4.375 //y2=0.675
r80 (  9 29 ) resistor r=18.139 //w=0.187 //l=0.265 //layer=li //thickness=0.1 \
 //x=4.375 //y=0.8 //x2=4.375 //y2=1.065
r81 (  6 29 ) resistor r=3.57586 //w=0.17 //l=0.103078 //layer=li \
 //thickness=0.1 //x=3.49 //y=1.765 //x2=3.405 //y2=1.805
r82 (  6 29 ) resistor r=27.3797 //w=0.187 //l=0.4 //layer=li //thickness=0.1 \
 //x=3.49 //y=1.765 //x2=3.89 //y2=1.765
r83 (  5 29 ) resistor r=3.57586 //w=0.17 //l=0.103078 //layer=li \
 //thickness=0.1 //x=4.29 //y=1.765 //x2=4.375 //y2=1.805
r84 (  5 29 ) resistor r=27.3797 //w=0.187 //l=0.4 //layer=li //thickness=0.1 \
 //x=4.29 //y=1.765 //x2=3.89 //y2=1.765
r85 (  1 29 ) resistor r=3.57586 //w=0.17 //l=0.125 //layer=li //thickness=0.1 \
 //x=3.405 //y=1.68 //x2=3.405 //y2=1.805
r86 (  1 29 ) resistor r=42.0963 //w=0.187 //l=0.615 //layer=li \
 //thickness=0.1 //x=3.405 //y=1.68 //x2=3.405 //y2=1.065
ends PM_XOR2X1\%noxref_10

subckt PM_XOR2X1\%noxref_11 ( 1 5 9 10 13 17 29 )
c67 ( 29 0 ) capacitor c=0.0670706f //x=6.6 //y=0.55
c68 ( 17 0 ) capacitor c=0.0071081f //x=8.675 //y=0.8
c69 ( 13 0 ) capacitor c=0.0160456f //x=8.59 //y=0.715
c70 ( 10 0 ) capacitor c=0.00742709f //x=7.705 //y=1.68
c71 ( 9 0 ) capacitor c=0.00771051f //x=7.705 //y=0.8
c72 ( 5 0 ) capacitor c=0.0183314f //x=7.62 //y=1.765
c73 ( 1 0 ) capacitor c=0.00772931f //x=6.735 //y=1.68
r74 (  17 29 ) resistor r=3.57586 //w=0.17 //l=0.125 //layer=li \
 //thickness=0.1 //x=8.675 //y=0.8 //x2=8.675 //y2=0.675
r75 (  17 29 ) resistor r=18.139 //w=0.187 //l=0.265 //layer=li \
 //thickness=0.1 //x=8.675 //y=0.8 //x2=8.675 //y2=1.065
r76 (  14 29 ) resistor r=3.57586 //w=0.17 //l=0.103078 //layer=li \
 //thickness=0.1 //x=7.79 //y=0.715 //x2=7.705 //y2=0.675
r77 (  14 29 ) resistor r=27.3797 //w=0.187 //l=0.4 //layer=li //thickness=0.1 \
 //x=7.79 //y=0.715 //x2=8.19 //y2=0.715
r78 (  13 29 ) resistor r=3.57586 //w=0.17 //l=0.103078 //layer=li \
 //thickness=0.1 //x=8.59 //y=0.715 //x2=8.675 //y2=0.675
r79 (  13 29 ) resistor r=27.3797 //w=0.187 //l=0.4 //layer=li //thickness=0.1 \
 //x=8.59 //y=0.715 //x2=8.19 //y2=0.715
r80 (  10 29 ) resistor r=3.57586 //w=0.17 //l=0.125 //layer=li \
 //thickness=0.1 //x=7.705 //y=1.68 //x2=7.705 //y2=1.805
r81 (  10 29 ) resistor r=42.0963 //w=0.187 //l=0.615 //layer=li \
 //thickness=0.1 //x=7.705 //y=1.68 //x2=7.705 //y2=1.065
r82 (  9 29 ) resistor r=3.57586 //w=0.17 //l=0.125 //layer=li //thickness=0.1 \
 //x=7.705 //y=0.8 //x2=7.705 //y2=0.675
r83 (  9 29 ) resistor r=18.139 //w=0.187 //l=0.265 //layer=li //thickness=0.1 \
 //x=7.705 //y=0.8 //x2=7.705 //y2=1.065
r84 (  6 29 ) resistor r=3.57586 //w=0.17 //l=0.103078 //layer=li \
 //thickness=0.1 //x=6.82 //y=1.765 //x2=6.735 //y2=1.805
r85 (  6 29 ) resistor r=27.3797 //w=0.187 //l=0.4 //layer=li //thickness=0.1 \
 //x=6.82 //y=1.765 //x2=7.22 //y2=1.765
r86 (  5 29 ) resistor r=3.57586 //w=0.17 //l=0.103078 //layer=li \
 //thickness=0.1 //x=7.62 //y=1.765 //x2=7.705 //y2=1.805
r87 (  5 29 ) resistor r=27.3797 //w=0.187 //l=0.4 //layer=li //thickness=0.1 \
 //x=7.62 //y=1.765 //x2=7.22 //y2=1.765
r88 (  1 29 ) resistor r=3.57586 //w=0.17 //l=0.125 //layer=li //thickness=0.1 \
 //x=6.735 //y=1.68 //x2=6.735 //y2=1.805
r89 (  1 29 ) resistor r=42.0963 //w=0.187 //l=0.615 //layer=li \
 //thickness=0.1 //x=6.735 //y=1.68 //x2=6.735 //y2=1.065
ends PM_XOR2X1\%noxref_11
