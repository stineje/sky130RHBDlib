// File: XOR2X1.spi.pex
// Created: Tue Apr 29 10:47:15 2025
// Program "Calibre xRC"
// Version "v2023.2_27.15"
// Nominal Temperature: 30C
// Circuit Temperature: 30C
//
simulator lang=spectre
subckt PM_XOR2X1\%GND ( 1 21 33 37 40 45 51 57 63 71 79 82 87 91 103 114 117 \
 119 126 133 134 135 136 )
c165 ( 136 0 ) capacitor c=0.0583166f //x=9.865 //y=0.55
c166 ( 135 0 ) capacitor c=0.0210152f //x=7.03 //y=1.05
c167 ( 134 0 ) capacitor c=0.0210152f //x=3.7 //y=1.05
c168 ( 133 0 ) capacitor c=0.0582171f //x=0.985 //y=0.55
c169 ( 126 0 ) capacitor c=0.248641f //x=10.96 //y=0.175
c170 ( 119 0 ) capacitor c=0.103738f //x=9.37 //y=0.175
c171 ( 118 0 ) capacitor c=0.0044644f //x=7.22 //y=0.175
c172 ( 117 0 ) capacitor c=0.104713f //x=6.04 //y=0.175
c173 ( 116 0 ) capacitor c=0.0044644f //x=3.82 //y=0.18
c174 ( 114 0 ) capacitor c=0.102511f //x=2.71 //y=0.175
c175 ( 103 0 ) capacitor c=0.211321f //x=1.12 //y=0.175
c176 ( 94 0 ) capacitor c=0.00592191f //x=10.96 //y=0.63
c177 ( 91 0 ) capacitor c=0.00644318f //x=10.875 //y=0.715
c178 ( 90 0 ) capacitor c=0.00479856f //x=10.475 //y=0.63
c179 ( 87 0 ) capacitor c=0.00531815f //x=10.39 //y=0.715
c180 ( 82 0 ) capacitor c=0.00587411f //x=9.99 //y=0.63
c181 ( 79 0 ) capacitor c=0.0161513f //x=9.905 //y=0.175
c182 ( 71 0 ) capacitor c=0.0729544f //x=9.2 //y=0.175
c183 ( 63 0 ) capacitor c=0.0392748f //x=7.135 //y=0.175
c184 ( 57 0 ) capacitor c=0.072938f //x=5.87 //y=0.175
c185 ( 51 0 ) capacitor c=0.0392748f //x=3.805 //y=0.175
c186 ( 46 0 ) capacitor c=0.0366794f //x=2.175 //y=0.175
c187 ( 45 0 ) capacitor c=0.0161513f //x=2.54 //y=0.175
c188 ( 40 0 ) capacitor c=0.00587411f //x=2.09 //y=0.63
c189 ( 37 0 ) capacitor c=0.0053436f //x=2.005 //y=0.715
c190 ( 36 0 ) capacitor c=0.00479856f //x=1.605 //y=0.63
c191 ( 33 0 ) capacitor c=0.00707849f //x=1.52 //y=0.715
c192 ( 28 0 ) capacitor c=0.00592191f //x=1.12 //y=0.63
c193 ( 21 0 ) capacitor c=0.424185f //x=10.85 //y=0.18
r194 (  125 126 ) resistor r=3.83651 //w=0.367 //l=0.11 //layer=li \
 //thickness=0.1 //x=10.85 //y=0.175 //x2=10.96 //y2=0.175
r195 (  123 125 ) resistor r=13.079 //w=0.367 //l=0.375 //layer=li \
 //thickness=0.1 //x=10.475 //y=0.175 //x2=10.85 //y2=0.175
r196 (  122 123 ) resistor r=12.7302 //w=0.367 //l=0.365 //layer=li \
 //thickness=0.1 //x=10.11 //y=0.175 //x2=10.475 //y2=0.175
r197 (  120 122 ) resistor r=4.18529 //w=0.367 //l=0.12 //layer=li \
 //thickness=0.1 //x=9.99 //y=0.175 //x2=10.11 //y2=0.175
r198 (  106 107 ) resistor r=16.9155 //w=0.367 //l=0.485 //layer=li \
 //thickness=0.1 //x=1.605 //y=0.175 //x2=2.09 //y2=0.175
r199 (  105 106 ) resistor r=13.079 //w=0.367 //l=0.375 //layer=li \
 //thickness=0.1 //x=1.23 //y=0.175 //x2=1.605 //y2=0.175
r200 (  103 105 ) resistor r=3.83651 //w=0.367 //l=0.11 //layer=li \
 //thickness=0.1 //x=1.12 //y=0.175 //x2=1.23 //y2=0.175
r201 (  95 136 ) resistor r=5.4201 //w=0.17 //l=0.085 //layer=li \
 //thickness=0.1 //x=10.96 //y=0.8 //x2=10.96 //y2=0.715
r202 (  95 136 ) resistor r=41.4118 //w=0.187 //l=0.605 //layer=li \
 //thickness=0.1 //x=10.96 //y=0.8 //x2=10.96 //y2=1.405
r203 (  94 136 ) resistor r=5.4201 //w=0.17 //l=0.085 //layer=li \
 //thickness=0.1 //x=10.96 //y=0.63 //x2=10.96 //y2=0.715
r204 (  93 126 ) resistor r=5.21862 //w=0.35 //l=0.175 //layer=li \
 //thickness=0.1 //x=10.96 //y=0.35 //x2=10.96 //y2=0.175
r205 (  93 94 ) resistor r=19.1658 //w=0.187 //l=0.28 //layer=li \
 //thickness=0.1 //x=10.96 //y=0.35 //x2=10.96 //y2=0.63
r206 (  92 136 ) resistor r=5.4201 //w=0.17 //l=0.085 //layer=li \
 //thickness=0.1 //x=10.56 //y=0.715 //x2=10.475 //y2=0.715
r207 (  91 136 ) resistor r=1.40859 //w=0.34 //l=0.085 //layer=li \
 //thickness=0.1 //x=10.875 //y=0.715 //x2=10.96 //y2=0.715
r208 (  91 92 ) resistor r=21.5615 //w=0.187 //l=0.315 //layer=li \
 //thickness=0.1 //x=10.875 //y=0.715 //x2=10.56 //y2=0.715
r209 (  90 136 ) resistor r=1.40859 //w=0.34 //l=0.085 //layer=li \
 //thickness=0.1 //x=10.475 //y=0.63 //x2=10.475 //y2=0.715
r210 (  89 123 ) resistor r=5.21862 //w=0.35 //l=0.175 //layer=li \
 //thickness=0.1 //x=10.475 //y=0.35 //x2=10.475 //y2=0.175
r211 (  89 90 ) resistor r=19.1658 //w=0.187 //l=0.28 //layer=li \
 //thickness=0.1 //x=10.475 //y=0.35 //x2=10.475 //y2=0.63
r212 (  88 136 ) resistor r=1.40859 //w=0.34 //l=0.085 //layer=li \
 //thickness=0.1 //x=10.075 //y=0.715 //x2=9.99 //y2=0.715
r213 (  87 136 ) resistor r=5.4201 //w=0.17 //l=0.085 //layer=li \
 //thickness=0.1 //x=10.39 //y=0.715 //x2=10.475 //y2=0.715
r214 (  87 88 ) resistor r=21.5615 //w=0.187 //l=0.315 //layer=li \
 //thickness=0.1 //x=10.39 //y=0.715 //x2=10.075 //y2=0.715
r215 (  83 136 ) resistor r=5.4201 //w=0.17 //l=0.085 //layer=li \
 //thickness=0.1 //x=9.99 //y=0.8 //x2=9.99 //y2=0.715
r216 (  83 136 ) resistor r=41.4118 //w=0.187 //l=0.605 //layer=li \
 //thickness=0.1 //x=9.99 //y=0.8 //x2=9.99 //y2=1.405
r217 (  82 136 ) resistor r=5.4201 //w=0.17 //l=0.085 //layer=li \
 //thickness=0.1 //x=9.99 //y=0.63 //x2=9.99 //y2=0.715
r218 (  81 120 ) resistor r=5.21862 //w=0.35 //l=0.175 //layer=li \
 //thickness=0.1 //x=9.99 //y=0.35 //x2=9.99 //y2=0.175
r219 (  81 82 ) resistor r=19.1658 //w=0.187 //l=0.28 //layer=li \
 //thickness=0.1 //x=9.99 //y=0.35 //x2=9.99 //y2=0.63
r220 (  80 119 ) resistor r=5.29055 //w=0.35 //l=0.17 //layer=li \
 //thickness=0.1 //x=9.54 //y=0.175 //x2=9.37 //y2=0.175
r221 (  79 120 ) resistor r=2.96458 //w=0.367 //l=0.085 //layer=li \
 //thickness=0.1 //x=9.905 //y=0.175 //x2=9.99 //y2=0.175
r222 (  79 80 ) resistor r=12.7302 //w=0.367 //l=0.365 //layer=li \
 //thickness=0.1 //x=9.905 //y=0.175 //x2=9.54 //y2=0.175
r223 (  74 76 ) resistor r=38.7139 //w=0.367 //l=1.11 //layer=li \
 //thickness=0.1 //x=7.52 //y=0.175 //x2=8.63 //y2=0.175
r224 (  72 118 ) resistor r=2.87058 //w=0.35 //l=0.085 //layer=li \
 //thickness=0.1 //x=7.305 //y=0.175 //x2=7.22 //y2=0.175
r225 (  72 74 ) resistor r=7.49864 //w=0.367 //l=0.215 //layer=li \
 //thickness=0.1 //x=7.305 //y=0.175 //x2=7.52 //y2=0.175
r226 (  71 119 ) resistor r=5.29055 //w=0.35 //l=0.17 //layer=li \
 //thickness=0.1 //x=9.2 //y=0.175 //x2=9.37 //y2=0.175
r227 (  71 76 ) resistor r=19.8801 //w=0.367 //l=0.57 //layer=li \
 //thickness=0.1 //x=9.2 //y=0.175 //x2=8.63 //y2=0.175
r228 (  67 118 ) resistor r=4.23183 //w=0.7 //l=0.175 //layer=li \
 //thickness=0.1 //x=7.22 //y=0.35 //x2=7.22 //y2=0.175
r229 (  67 135 ) resistor r=54.0749 //w=0.187 //l=0.79 //layer=li \
 //thickness=0.1 //x=7.22 //y=0.35 //x2=7.22 //y2=1.14
r230 (  64 117 ) resistor r=5.29055 //w=0.35 //l=0.17 //layer=li \
 //thickness=0.1 //x=6.21 //y=0.175 //x2=6.04 //y2=0.175
r231 (  64 66 ) resistor r=6.97548 //w=0.367 //l=0.2 //layer=li \
 //thickness=0.1 //x=6.21 //y=0.175 //x2=6.41 //y2=0.175
r232 (  63 118 ) resistor r=2.87058 //w=0.35 //l=0.085 //layer=li \
 //thickness=0.1 //x=7.135 //y=0.175 //x2=7.22 //y2=0.175
r233 (  63 66 ) resistor r=25.2861 //w=0.367 //l=0.725 //layer=li \
 //thickness=0.1 //x=7.135 //y=0.175 //x2=6.41 //y2=0.175
r234 (  58 116 ) resistor r=2.87058 //w=0.35 //l=0.085 //layer=li \
 //thickness=0.1 //x=3.975 //y=0.175 //x2=3.89 //y2=0.175
r235 (  58 60 ) resistor r=33.3079 //w=0.367 //l=0.955 //layer=li \
 //thickness=0.1 //x=3.975 //y=0.175 //x2=4.93 //y2=0.175
r236 (  57 117 ) resistor r=5.29055 //w=0.35 //l=0.17 //layer=li \
 //thickness=0.1 //x=5.87 //y=0.175 //x2=6.04 //y2=0.175
r237 (  57 60 ) resistor r=32.7847 //w=0.367 //l=0.94 //layer=li \
 //thickness=0.1 //x=5.87 //y=0.175 //x2=4.93 //y2=0.175
r238 (  53 116 ) resistor r=4.23183 //w=0.7 //l=0.175 //layer=li \
 //thickness=0.1 //x=3.89 //y=0.35 //x2=3.89 //y2=0.175
r239 (  53 134 ) resistor r=54.0749 //w=0.187 //l=0.79 //layer=li \
 //thickness=0.1 //x=3.89 //y=0.35 //x2=3.89 //y2=1.14
r240 (  52 114 ) resistor r=5.29055 //w=0.35 //l=0.17 //layer=li \
 //thickness=0.1 //x=2.88 //y=0.175 //x2=2.71 //y2=0.175
r241 (  51 116 ) resistor r=2.87058 //w=0.35 //l=0.085 //layer=li \
 //thickness=0.1 //x=3.805 //y=0.175 //x2=3.89 //y2=0.175
r242 (  51 52 ) resistor r=32.2616 //w=0.367 //l=0.925 //layer=li \
 //thickness=0.1 //x=3.805 //y=0.175 //x2=2.88 //y2=0.175
r243 (  46 107 ) resistor r=2.96458 //w=0.367 //l=0.085 //layer=li \
 //thickness=0.1 //x=2.175 //y=0.175 //x2=2.09 //y2=0.175
r244 (  46 48 ) resistor r=5.75477 //w=0.367 //l=0.165 //layer=li \
 //thickness=0.1 //x=2.175 //y=0.175 //x2=2.34 //y2=0.175
r245 (  45 114 ) resistor r=5.29055 //w=0.35 //l=0.17 //layer=li \
 //thickness=0.1 //x=2.54 //y=0.175 //x2=2.71 //y2=0.175
r246 (  45 48 ) resistor r=6.97548 //w=0.367 //l=0.2 //layer=li \
 //thickness=0.1 //x=2.54 //y=0.175 //x2=2.34 //y2=0.175
r247 (  41 133 ) resistor r=5.4201 //w=0.17 //l=0.085 //layer=li \
 //thickness=0.1 //x=2.09 //y=0.8 //x2=2.09 //y2=0.715
r248 (  41 133 ) resistor r=41.4118 //w=0.187 //l=0.605 //layer=li \
 //thickness=0.1 //x=2.09 //y=0.8 //x2=2.09 //y2=1.405
r249 (  40 133 ) resistor r=5.4201 //w=0.17 //l=0.085 //layer=li \
 //thickness=0.1 //x=2.09 //y=0.63 //x2=2.09 //y2=0.715
r250 (  39 107 ) resistor r=5.21862 //w=0.35 //l=0.175 //layer=li \
 //thickness=0.1 //x=2.09 //y=0.35 //x2=2.09 //y2=0.175
r251 (  39 40 ) resistor r=19.1658 //w=0.187 //l=0.28 //layer=li \
 //thickness=0.1 //x=2.09 //y=0.35 //x2=2.09 //y2=0.63
r252 (  38 133 ) resistor r=5.4201 //w=0.17 //l=0.085 //layer=li \
 //thickness=0.1 //x=1.69 //y=0.715 //x2=1.605 //y2=0.715
r253 (  37 133 ) resistor r=1.40859 //w=0.34 //l=0.085 //layer=li \
 //thickness=0.1 //x=2.005 //y=0.715 //x2=2.09 //y2=0.715
r254 (  37 38 ) resistor r=21.5615 //w=0.187 //l=0.315 //layer=li \
 //thickness=0.1 //x=2.005 //y=0.715 //x2=1.69 //y2=0.715
r255 (  36 133 ) resistor r=1.40859 //w=0.34 //l=0.085 //layer=li \
 //thickness=0.1 //x=1.605 //y=0.63 //x2=1.605 //y2=0.715
r256 (  35 106 ) resistor r=5.21862 //w=0.35 //l=0.175 //layer=li \
 //thickness=0.1 //x=1.605 //y=0.35 //x2=1.605 //y2=0.175
r257 (  35 36 ) resistor r=19.1658 //w=0.187 //l=0.28 //layer=li \
 //thickness=0.1 //x=1.605 //y=0.35 //x2=1.605 //y2=0.63
r258 (  34 133 ) resistor r=1.40859 //w=0.34 //l=0.085 //layer=li \
 //thickness=0.1 //x=1.205 //y=0.715 //x2=1.12 //y2=0.715
r259 (  33 133 ) resistor r=5.4201 //w=0.17 //l=0.085 //layer=li \
 //thickness=0.1 //x=1.52 //y=0.715 //x2=1.605 //y2=0.715
r260 (  33 34 ) resistor r=21.5615 //w=0.187 //l=0.315 //layer=li \
 //thickness=0.1 //x=1.52 //y=0.715 //x2=1.205 //y2=0.715
r261 (  29 133 ) resistor r=5.4201 //w=0.17 //l=0.085 //layer=li \
 //thickness=0.1 //x=1.12 //y=0.8 //x2=1.12 //y2=0.715
r262 (  29 133 ) resistor r=41.4118 //w=0.187 //l=0.605 //layer=li \
 //thickness=0.1 //x=1.12 //y=0.8 //x2=1.12 //y2=1.405
r263 (  28 133 ) resistor r=5.4201 //w=0.17 //l=0.085 //layer=li \
 //thickness=0.1 //x=1.12 //y=0.63 //x2=1.12 //y2=0.715
r264 (  27 103 ) resistor r=5.21862 //w=0.35 //l=0.175 //layer=li \
 //thickness=0.1 //x=1.12 //y=0.35 //x2=1.12 //y2=0.175
r265 (  27 28 ) resistor r=19.1658 //w=0.187 //l=0.28 //layer=li \
 //thickness=0.1 //x=1.12 //y=0.35 //x2=1.12 //y2=0.63
r266 (  21 125 ) resistor r=4.65 //w=0.17 //l=0.34 //layer=mcon //count=2 \
 //x=10.85 //y=0.18 //x2=10.85 //y2=0.18
r267 (  19 122 ) resistor r=3.1 //w=0.17 //l=0.51 //layer=mcon //count=3 \
 //x=10.11 //y=0.18 //x2=10.11 //y2=0.18
r268 (  19 21 ) resistor r=0.297428 //w=0.311 //l=0.74 //layer=m1 \
 //thickness=0.36 //x=10.11 //y=0.175 //x2=10.85 //y2=0.175
r269 (  17 76 ) resistor r=3.1 //w=0.17 //l=0.51 //layer=mcon //count=3 \
 //x=8.63 //y=0.18 //x2=8.63 //y2=0.18
r270 (  17 19 ) resistor r=0.594855 //w=0.311 //l=1.48 //layer=m1 \
 //thickness=0.36 //x=8.63 //y=0.175 //x2=10.11 //y2=0.175
r271 (  15 74 ) resistor r=3.1 //w=0.17 //l=0.51 //layer=mcon //count=3 \
 //x=7.52 //y=0.18 //x2=7.52 //y2=0.18
r272 (  15 17 ) resistor r=0.446141 //w=0.311 //l=1.11 //layer=m1 \
 //thickness=0.36 //x=7.52 //y=0.175 //x2=8.63 //y2=0.175
r273 (  13 66 ) resistor r=3.1 //w=0.17 //l=0.51 //layer=mcon //count=3 \
 //x=6.41 //y=0.18 //x2=6.41 //y2=0.18
r274 (  13 15 ) resistor r=0.446141 //w=0.311 //l=1.11 //layer=m1 \
 //thickness=0.36 //x=6.41 //y=0.175 //x2=7.52 //y2=0.175
r275 (  10 60 ) resistor r=3.1 //w=0.17 //l=0.51 //layer=mcon //count=3 \
 //x=4.93 //y=0.18 //x2=4.93 //y2=0.18
r276 (  8 116 ) resistor r=3.1 //w=0.17 //l=0.51 //layer=mcon //count=3 \
 //x=3.82 //y=0.18 //x2=3.82 //y2=0.18
r277 (  8 10 ) resistor r=0.446141 //w=0.311 //l=1.11 //layer=m1 \
 //thickness=0.36 //x=3.82 //y=0.175 //x2=4.93 //y2=0.175
r278 (  6 48 ) resistor r=3.1 //w=0.17 //l=0.51 //layer=mcon //count=3 \
 //x=2.34 //y=0.18 //x2=2.34 //y2=0.18
r279 (  6 8 ) resistor r=0.594855 //w=0.311 //l=1.48 //layer=m1 \
 //thickness=0.36 //x=2.34 //y=0.175 //x2=3.82 //y2=0.175
r280 (  3 105 ) resistor r=3.1 //w=0.17 //l=0.51 //layer=mcon //count=3 \
 //x=1.23 //y=0.18 //x2=1.23 //y2=0.18
r281 (  3 6 ) resistor r=0.446141 //w=0.311 //l=1.11 //layer=m1 \
 //thickness=0.36 //x=1.23 //y=0.175 //x2=2.34 //y2=0.175
r282 (  1 13 ) resistor r=0.148714 //w=0.311 //l=0.37 //layer=m1 \
 //thickness=0.36 //x=6.04 //y=0.175 //x2=6.41 //y2=0.175
r283 (  1 10 ) resistor r=0.446141 //w=0.311 //l=1.11 //layer=m1 \
 //thickness=0.36 //x=6.04 //y=0.175 //x2=4.93 //y2=0.175
ends PM_XOR2X1\%GND

subckt PM_XOR2X1\%VDD ( 1 21 33 41 47 55 61 69 77 85 98 100 102 104 108 109 \
 110 111 112 113 114 )
c156 ( 114 0 ) capacitor c=0.0420686f //x=10.77 //y=5.2
c157 ( 113 0 ) capacitor c=0.0433635f //x=9.91 //y=5.2
c158 ( 112 0 ) capacitor c=0.0266033f //x=7.125 //y=5.2
c159 ( 111 0 ) capacitor c=0.0265297f //x=3.795 //y=5.2
c160 ( 110 0 ) capacitor c=0.0432965f //x=1.9 //y=5.2
c161 ( 109 0 ) capacitor c=0.0421444f //x=1.03 //y=5.2
c162 ( 108 0 ) capacitor c=0.251447f //x=10.85 //y=7.58
c163 ( 106 0 ) capacitor c=0.00597439f //x=10.11 //y=7.58
c164 ( 104 0 ) capacitor c=0.105826f //x=9.37 //y=7.585
c165 ( 103 0 ) capacitor c=0.00597439f //x=7.27 //y=7.585
c166 ( 102 0 ) capacitor c=0.111887f //x=6.04 //y=7.585
c167 ( 101 0 ) capacitor c=0.00597439f //x=3.94 //y=7.585
c168 ( 100 0 ) capacitor c=0.111682f //x=2.71 //y=7.585
c169 ( 99 0 ) capacitor c=0.00597439f //x=2.045 //y=7.585
c170 ( 98 0 ) capacitor c=0.25188f //x=1.23 //y=7.58
c171 ( 85 0 ) capacitor c=0.029202f //x=10.83 //y=7.585
c172 ( 77 0 ) capacitor c=0.0183091f //x=9.95 //y=7.585
c173 ( 69 0 ) capacitor c=0.075456f //x=9.2 //y=7.585
c174 ( 61 0 ) capacitor c=0.0432521f //x=7.185 //y=7.585
c175 ( 55 0 ) capacitor c=0.0753262f //x=5.87 //y=7.585
c176 ( 47 0 ) capacitor c=0.0432541f //x=3.855 //y=7.585
c177 ( 41 0 ) capacitor c=0.0183091f //x=2.54 //y=7.585
c178 ( 33 0 ) capacitor c=0.0293728f //x=1.96 //y=7.585
c179 ( 21 0 ) capacitor c=0.436209f //x=10.85 //y=7.58
r180 (  87 108 ) resistor r=4.23183 //w=0.7 //l=0.175 //layer=li \
 //thickness=0.1 //x=10.915 //y=7.41 //x2=10.915 //y2=7.585
r181 (  87 114 ) resistor r=56.4706 //w=0.187 //l=0.825 //layer=li \
 //thickness=0.1 //x=10.915 //y=7.41 //x2=10.915 //y2=6.585
r182 (  86 106 ) resistor r=2.87058 //w=0.35 //l=0.085 //layer=li \
 //thickness=0.1 //x=10.12 //y=7.585 //x2=10.035 //y2=7.585
r183 (  85 108 ) resistor r=2.87058 //w=0.35 //l=0.085 //layer=li \
 //thickness=0.1 //x=10.83 //y=7.585 //x2=10.915 //y2=7.585
r184 (  85 86 ) resistor r=24.7629 //w=0.367 //l=0.71 //layer=li \
 //thickness=0.1 //x=10.83 //y=7.585 //x2=10.12 //y2=7.585
r185 (  79 106 ) resistor r=4.23183 //w=0.7 //l=0.175 //layer=li \
 //thickness=0.1 //x=10.035 //y=7.41 //x2=10.035 //y2=7.585
r186 (  79 113 ) resistor r=56.4706 //w=0.187 //l=0.825 //layer=li \
 //thickness=0.1 //x=10.035 //y=7.41 //x2=10.035 //y2=6.585
r187 (  78 104 ) resistor r=5.29055 //w=0.35 //l=0.17 //layer=li \
 //thickness=0.1 //x=9.54 //y=7.585 //x2=9.37 //y2=7.585
r188 (  77 106 ) resistor r=2.87058 //w=0.35 //l=0.085 //layer=li \
 //thickness=0.1 //x=9.95 //y=7.585 //x2=10.035 //y2=7.585
r189 (  77 78 ) resistor r=14.2997 //w=0.367 //l=0.41 //layer=li \
 //thickness=0.1 //x=9.95 //y=7.585 //x2=9.54 //y2=7.585
r190 (  72 74 ) resistor r=38.7139 //w=0.367 //l=1.11 //layer=li \
 //thickness=0.1 //x=7.52 //y=7.585 //x2=8.63 //y2=7.585
r191 (  70 103 ) resistor r=2.87058 //w=0.35 //l=0.085 //layer=li \
 //thickness=0.1 //x=7.355 //y=7.585 //x2=7.27 //y2=7.585
r192 (  70 72 ) resistor r=5.75477 //w=0.367 //l=0.165 //layer=li \
 //thickness=0.1 //x=7.355 //y=7.585 //x2=7.52 //y2=7.585
r193 (  69 104 ) resistor r=5.29055 //w=0.35 //l=0.17 //layer=li \
 //thickness=0.1 //x=9.2 //y=7.585 //x2=9.37 //y2=7.585
r194 (  69 74 ) resistor r=19.8801 //w=0.367 //l=0.57 //layer=li \
 //thickness=0.1 //x=9.2 //y=7.585 //x2=8.63 //y2=7.585
r195 (  65 103 ) resistor r=4.23183 //w=0.7 //l=0.175 //layer=li \
 //thickness=0.1 //x=7.27 //y=7.41 //x2=7.27 //y2=7.585
r196 (  65 112 ) resistor r=80.4278 //w=0.187 //l=1.175 //layer=li \
 //thickness=0.1 //x=7.27 //y=7.41 //x2=7.27 //y2=6.235
r197 (  62 102 ) resistor r=5.29055 //w=0.35 //l=0.17 //layer=li \
 //thickness=0.1 //x=6.21 //y=7.585 //x2=6.04 //y2=7.585
r198 (  62 64 ) resistor r=6.97548 //w=0.367 //l=0.2 //layer=li \
 //thickness=0.1 //x=6.21 //y=7.585 //x2=6.41 //y2=7.585
r199 (  61 103 ) resistor r=2.87058 //w=0.35 //l=0.085 //layer=li \
 //thickness=0.1 //x=7.185 //y=7.585 //x2=7.27 //y2=7.585
r200 (  61 64 ) resistor r=27.03 //w=0.367 //l=0.775 //layer=li \
 //thickness=0.1 //x=7.185 //y=7.585 //x2=6.41 //y2=7.585
r201 (  56 101 ) resistor r=2.87058 //w=0.35 //l=0.085 //layer=li \
 //thickness=0.1 //x=4.025 //y=7.585 //x2=3.94 //y2=7.585
r202 (  56 58 ) resistor r=31.564 //w=0.367 //l=0.905 //layer=li \
 //thickness=0.1 //x=4.025 //y=7.585 //x2=4.93 //y2=7.585
r203 (  55 102 ) resistor r=5.29055 //w=0.35 //l=0.17 //layer=li \
 //thickness=0.1 //x=5.87 //y=7.585 //x2=6.04 //y2=7.585
r204 (  55 58 ) resistor r=32.7847 //w=0.367 //l=0.94 //layer=li \
 //thickness=0.1 //x=5.87 //y=7.585 //x2=4.93 //y2=7.585
r205 (  51 101 ) resistor r=4.23183 //w=0.7 //l=0.175 //layer=li \
 //thickness=0.1 //x=3.94 //y=7.41 //x2=3.94 //y2=7.585
r206 (  51 111 ) resistor r=80.4278 //w=0.187 //l=1.175 //layer=li \
 //thickness=0.1 //x=3.94 //y=7.41 //x2=3.94 //y2=6.235
r207 (  48 100 ) resistor r=5.29055 //w=0.35 //l=0.17 //layer=li \
 //thickness=0.1 //x=2.88 //y=7.585 //x2=2.71 //y2=7.585
r208 (  48 50 ) resistor r=32.7847 //w=0.367 //l=0.94 //layer=li \
 //thickness=0.1 //x=2.88 //y=7.585 //x2=3.82 //y2=7.585
r209 (  47 101 ) resistor r=2.87058 //w=0.35 //l=0.085 //layer=li \
 //thickness=0.1 //x=3.855 //y=7.585 //x2=3.94 //y2=7.585
r210 (  47 50 ) resistor r=1.22071 //w=0.367 //l=0.035 //layer=li \
 //thickness=0.1 //x=3.855 //y=7.585 //x2=3.82 //y2=7.585
r211 (  42 99 ) resistor r=2.87058 //w=0.35 //l=0.085 //layer=li \
 //thickness=0.1 //x=2.13 //y=7.585 //x2=2.045 //y2=7.585
r212 (  42 44 ) resistor r=7.32425 //w=0.367 //l=0.21 //layer=li \
 //thickness=0.1 //x=2.13 //y=7.585 //x2=2.34 //y2=7.585
r213 (  41 100 ) resistor r=5.29055 //w=0.35 //l=0.17 //layer=li \
 //thickness=0.1 //x=2.54 //y=7.585 //x2=2.71 //y2=7.585
r214 (  41 44 ) resistor r=6.97548 //w=0.367 //l=0.2 //layer=li \
 //thickness=0.1 //x=2.54 //y=7.585 //x2=2.34 //y2=7.585
r215 (  35 99 ) resistor r=4.23183 //w=0.7 //l=0.175 //layer=li \
 //thickness=0.1 //x=2.045 //y=7.41 //x2=2.045 //y2=7.585
r216 (  35 110 ) resistor r=56.4706 //w=0.187 //l=0.825 //layer=li \
 //thickness=0.1 //x=2.045 //y=7.41 //x2=2.045 //y2=6.585
r217 (  34 98 ) resistor r=2.87058 //w=0.35 //l=0.085 //layer=li \
 //thickness=0.1 //x=1.25 //y=7.585 //x2=1.165 //y2=7.585
r218 (  33 99 ) resistor r=2.87058 //w=0.35 //l=0.085 //layer=li \
 //thickness=0.1 //x=1.96 //y=7.585 //x2=2.045 //y2=7.585
r219 (  33 34 ) resistor r=24.7629 //w=0.367 //l=0.71 //layer=li \
 //thickness=0.1 //x=1.96 //y=7.585 //x2=1.25 //y2=7.585
r220 (  27 98 ) resistor r=4.23183 //w=0.7 //l=0.175 //layer=li \
 //thickness=0.1 //x=1.165 //y=7.41 //x2=1.165 //y2=7.585
r221 (  27 109 ) resistor r=56.4706 //w=0.187 //l=0.825 //layer=li \
 //thickness=0.1 //x=1.165 //y=7.41 //x2=1.165 //y2=6.585
r222 (  21 108 ) resistor r=4.65 //w=0.17 //l=0.34 //layer=mcon //count=2 \
 //x=10.85 //y=7.58 //x2=10.85 //y2=7.58
r223 (  19 106 ) resistor r=3.1 //w=0.17 //l=0.51 //layer=mcon //count=3 \
 //x=10.11 //y=7.58 //x2=10.11 //y2=7.58
r224 (  19 21 ) resistor r=0.297428 //w=0.311 //l=0.74 //layer=m1 \
 //thickness=0.36 //x=10.11 //y=7.585 //x2=10.85 //y2=7.585
r225 (  17 74 ) resistor r=3.1 //w=0.17 //l=0.51 //layer=mcon //count=3 \
 //x=8.63 //y=7.58 //x2=8.63 //y2=7.58
r226 (  17 19 ) resistor r=0.594855 //w=0.311 //l=1.48 //layer=m1 \
 //thickness=0.36 //x=8.63 //y=7.585 //x2=10.11 //y2=7.585
r227 (  15 72 ) resistor r=3.1 //w=0.17 //l=0.51 //layer=mcon //count=3 \
 //x=7.52 //y=7.58 //x2=7.52 //y2=7.58
r228 (  15 17 ) resistor r=0.446141 //w=0.311 //l=1.11 //layer=m1 \
 //thickness=0.36 //x=7.52 //y=7.585 //x2=8.63 //y2=7.585
r229 (  13 64 ) resistor r=3.1 //w=0.17 //l=0.51 //layer=mcon //count=3 \
 //x=6.41 //y=7.58 //x2=6.41 //y2=7.58
r230 (  13 15 ) resistor r=0.446141 //w=0.311 //l=1.11 //layer=m1 \
 //thickness=0.36 //x=6.41 //y=7.585 //x2=7.52 //y2=7.585
r231 (  10 58 ) resistor r=3.1 //w=0.17 //l=0.51 //layer=mcon //count=3 \
 //x=4.93 //y=7.58 //x2=4.93 //y2=7.58
r232 (  8 50 ) resistor r=3.1 //w=0.17 //l=0.51 //layer=mcon //count=3 \
 //x=3.82 //y=7.58 //x2=3.82 //y2=7.58
r233 (  8 10 ) resistor r=0.446141 //w=0.311 //l=1.11 //layer=m1 \
 //thickness=0.36 //x=3.82 //y=7.585 //x2=4.93 //y2=7.585
r234 (  6 44 ) resistor r=3.1 //w=0.17 //l=0.51 //layer=mcon //count=3 \
 //x=2.34 //y=7.58 //x2=2.34 //y2=7.58
r235 (  6 8 ) resistor r=0.594855 //w=0.311 //l=1.48 //layer=m1 \
 //thickness=0.36 //x=2.34 //y=7.585 //x2=3.82 //y2=7.585
r236 (  3 98 ) resistor r=3.1 //w=0.17 //l=0.51 //layer=mcon //count=3 \
 //x=1.23 //y=7.58 //x2=1.23 //y2=7.58
r237 (  3 6 ) resistor r=0.446141 //w=0.311 //l=1.11 //layer=m1 \
 //thickness=0.36 //x=1.23 //y=7.585 //x2=2.34 //y2=7.585
r238 (  1 13 ) resistor r=0.148714 //w=0.311 //l=0.37 //layer=m1 \
 //thickness=0.36 //x=6.04 //y=7.585 //x2=6.41 //y2=7.585
r239 (  1 10 ) resistor r=0.446141 //w=0.311 //l=1.11 //layer=m1 \
 //thickness=0.36 //x=6.04 //y=7.585 //x2=4.93 //y2=7.585
ends PM_XOR2X1\%VDD

subckt PM_XOR2X1\%A ( 1 2 7 8 9 10 11 12 13 14 15 16 17 18 19 21 35 47 48 49 \
 50 51 52 53 54 55 56 60 61 62 64 70 71 72 73 74 75 79 81 84 85 90 104 )
c133 ( 104 0 ) capacitor c=0.0661295f //x=3.82 //y=4.88
c134 ( 90 0 ) capacitor c=0.0537799f //x=1.23 //y=2.265
c135 ( 85 0 ) capacitor c=0.0318948f //x=4.155 //y=1.395
c136 ( 84 0 ) capacitor c=0.0187407f //x=4.155 //y=1.05
c137 ( 81 0 ) capacitor c=0.0141798f //x=4 //y=1.55
c138 ( 79 0 ) capacitor c=0.0149852f //x=4 //y=0.895
c139 ( 75 0 ) capacitor c=0.0836807f //x=3.625 //y=2.1
c140 ( 74 0 ) capacitor c=0.0229722f //x=3.625 //y=1.705
c141 ( 73 0 ) capacitor c=0.0234352f //x=3.625 //y=1.395
c142 ( 72 0 ) capacitor c=0.0199366f //x=3.625 //y=1.05
c143 ( 71 0 ) capacitor c=0.0435629f //x=1.87 //y=1.435
c144 ( 70 0 ) capacitor c=0.0200386f //x=1.87 //y=1.09
c145 ( 64 0 ) capacitor c=0.0152946f //x=1.715 //y=1.59
c146 ( 62 0 ) capacitor c=0.0157804f //x=1.715 //y=0.935
c147 ( 61 0 ) capacitor c=0.048995f //x=1.46 //y=4.97
c148 ( 60 0 ) capacitor c=0.0303096f //x=1.75 //y=4.97
c149 ( 56 0 ) capacitor c=0.0290017f //x=1.34 //y=2.1
c150 ( 55 0 ) capacitor c=0.0250027f //x=1.34 //y=1.745
c151 ( 54 0 ) capacitor c=0.0234316f //x=1.34 //y=1.435
c152 ( 53 0 ) capacitor c=0.0200596f //x=1.34 //y=1.09
c153 ( 52 0 ) capacitor c=0.110797f //x=4.16 //y=6.2
c154 ( 51 0 ) capacitor c=0.154322f //x=3.72 //y=6.2
c155 ( 50 0 ) capacitor c=0.154218f //x=1.825 //y=6.2
c156 ( 49 0 ) capacitor c=0.154243f //x=1.385 //y=6.2
c157 ( 35 0 ) capacitor c=0.109612f //x=3.82 //y=2.265
c158 ( 21 0 ) capacitor c=0.11095f //x=1.23 //y=2.265
c159 ( 2 0 ) capacitor c=0.0144526f //x=1.345 //y=4.25
c160 ( 1 0 ) capacitor c=0.0971867f //x=3.705 //y=4.25
r161 (  102 104 ) resistor r=20.6867 //w=0.233 //l=0.1 //layer=ply \
 //thickness=0.18 //x=3.72 //y=4.88 //x2=3.82 //y2=4.88
r162 (  90 91 ) resistor r=17.5563 //w=0.302 //l=0.11 //layer=ply \
 //thickness=0.18 //x=1.23 //y=2.265 //x2=1.34 //y2=2.265
r163 (  86 104 ) resistor r=70.3348 //w=0.233 //l=0.414367 //layer=ply \
 //thickness=0.18 //x=4.16 //y=5.045 //x2=3.82 //y2=4.88
r164 (  85 106 ) resistor r=45.1352 //w=0.168 //l=0.173853 //layer=ply \
 //thickness=0.18 //x=4.155 //y=1.395 //x2=4.115 //y2=1.55
r165 (  84 105 ) resistor r=45.1352 //w=0.168 //l=0.173853 //layer=ply \
 //thickness=0.18 //x=4.155 //y=1.05 //x2=4.115 //y2=0.895
r166 (  84 85 ) resistor r=176.904 //w=0.094 //l=0.345 //layer=ply \
 //thickness=0.18 //x=4.155 //y=1.05 //x2=4.155 //y2=1.395
r167 (  82 101 ) resistor r=10.701 //w=0.21 //l=0.115 //layer=ply \
 //thickness=0.18 //x=3.78 //y=1.55 //x2=3.665 //y2=1.55
r168 (  81 106 ) resistor r=5.52526 //w=0.168 //l=0.115 //layer=ply \
 //thickness=0.18 //x=4 //y=1.55 //x2=4.115 //y2=1.55
r169 (  80 100 ) resistor r=5.52526 //w=0.168 //l=0.115 //layer=ply \
 //thickness=0.18 //x=3.78 //y=0.895 //x2=3.665 //y2=0.895
r170 (  79 105 ) resistor r=5.52526 //w=0.168 //l=0.115 //layer=ply \
 //thickness=0.18 //x=4 //y=0.895 //x2=4.115 //y2=0.895
r171 (  79 80 ) resistor r=112.809 //w=0.094 //l=0.22 //layer=ply \
 //thickness=0.18 //x=4 //y=0.895 //x2=3.78 //y2=0.895
r172 (  76 102 ) resistor r=13.0941 //w=0.233 //l=0.165 //layer=ply \
 //thickness=0.18 //x=3.72 //y=5.045 //x2=3.72 //y2=4.88
r173 (  75 99 ) resistor r=34.8111 //w=0.27 //l=0.264953 //layer=ply \
 //thickness=0.18 //x=3.625 //y=2.1 //x2=3.82 //y2=2.265
r174 (  74 101 ) resistor r=39.5823 //w=0.21 //l=0.173853 //layer=ply \
 //thickness=0.18 //x=3.625 //y=1.705 //x2=3.665 //y2=1.55
r175 (  74 75 ) resistor r=202.543 //w=0.094 //l=0.395 //layer=ply \
 //thickness=0.18 //x=3.625 //y=1.705 //x2=3.625 //y2=2.1
r176 (  73 101 ) resistor r=39.5823 //w=0.21 //l=0.173853 //layer=ply \
 //thickness=0.18 //x=3.625 //y=1.395 //x2=3.665 //y2=1.55
r177 (  72 100 ) resistor r=45.1352 //w=0.168 //l=0.173853 //layer=ply \
 //thickness=0.18 //x=3.625 //y=1.05 //x2=3.665 //y2=0.895
r178 (  72 73 ) resistor r=176.904 //w=0.094 //l=0.345 //layer=ply \
 //thickness=0.18 //x=3.625 //y=1.05 //x2=3.625 //y2=1.395
r179 (  71 97 ) resistor r=45.1352 //w=0.168 //l=0.173853 //layer=ply \
 //thickness=0.18 //x=1.87 //y=1.435 //x2=1.83 //y2=1.59
r180 (  70 96 ) resistor r=45.1352 //w=0.168 //l=0.173853 //layer=ply \
 //thickness=0.18 //x=1.87 //y=1.09 //x2=1.83 //y2=0.935
r181 (  70 71 ) resistor r=176.904 //w=0.094 //l=0.345 //layer=ply \
 //thickness=0.18 //x=1.87 //y=1.09 //x2=1.87 //y2=1.435
r182 (  65 95 ) resistor r=10.701 //w=0.21 //l=0.115 //layer=ply \
 //thickness=0.18 //x=1.495 //y=1.59 //x2=1.38 //y2=1.59
r183 (  64 97 ) resistor r=5.52526 //w=0.168 //l=0.115 //layer=ply \
 //thickness=0.18 //x=1.715 //y=1.59 //x2=1.83 //y2=1.59
r184 (  63 94 ) resistor r=5.52526 //w=0.168 //l=0.115 //layer=ply \
 //thickness=0.18 //x=1.495 //y=0.935 //x2=1.38 //y2=0.935
r185 (  62 96 ) resistor r=5.52526 //w=0.168 //l=0.115 //layer=ply \
 //thickness=0.18 //x=1.715 //y=0.935 //x2=1.83 //y2=0.935
r186 (  62 63 ) resistor r=112.809 //w=0.094 //l=0.22 //layer=ply \
 //thickness=0.18 //x=1.715 //y=0.935 //x2=1.495 //y2=0.935
r187 (  60 67 ) resistor r=26.9307 //w=0.15 //l=0.106066 //layer=ply \
 //thickness=0.18 //x=1.75 //y=4.97 //x2=1.825 //y2=5.045
r188 (  60 61 ) resistor r=148.702 //w=0.094 //l=0.29 //layer=ply \
 //thickness=0.18 //x=1.75 //y=4.97 //x2=1.46 //y2=4.97
r189 (  57 61 ) resistor r=23.403 //w=0.284 //l=0.106066 //layer=ply \
 //thickness=0.18 //x=1.385 //y=5.045 //x2=1.46 //y2=4.97
r190 (  57 93 ) resistor r=26.3063 //w=0.284 //l=0.229783 //layer=ply \
 //thickness=0.18 //x=1.385 //y=5.045 //x2=1.23 //y2=4.88
r191 (  56 91 ) resistor r=19.1248 //w=0.302 //l=0.165 //layer=ply \
 //thickness=0.18 //x=1.34 //y=2.1 //x2=1.34 //y2=2.265
r192 (  55 95 ) resistor r=39.5823 //w=0.21 //l=0.173853 //layer=ply \
 //thickness=0.18 //x=1.34 //y=1.745 //x2=1.38 //y2=1.59
r193 (  55 56 ) resistor r=182.032 //w=0.094 //l=0.355 //layer=ply \
 //thickness=0.18 //x=1.34 //y=1.745 //x2=1.34 //y2=2.1
r194 (  54 95 ) resistor r=39.5823 //w=0.21 //l=0.173853 //layer=ply \
 //thickness=0.18 //x=1.34 //y=1.435 //x2=1.38 //y2=1.59
r195 (  53 94 ) resistor r=45.1352 //w=0.168 //l=0.173853 //layer=ply \
 //thickness=0.18 //x=1.34 //y=1.09 //x2=1.38 //y2=0.935
r196 (  53 54 ) resistor r=176.904 //w=0.094 //l=0.345 //layer=ply \
 //thickness=0.18 //x=1.34 //y=1.09 //x2=1.34 //y2=1.435
r197 (  52 86 ) resistor r=592.245 //w=0.094 //l=1.155 //layer=ply \
 //thickness=0.18 //x=4.16 //y=6.2 //x2=4.16 //y2=5.045
r198 (  51 76 ) resistor r=592.245 //w=0.094 //l=1.155 //layer=ply \
 //thickness=0.18 //x=3.72 //y=6.2 //x2=3.72 //y2=5.045
r199 (  50 67 ) resistor r=592.245 //w=0.094 //l=1.155 //layer=ply \
 //thickness=0.18 //x=1.825 //y=6.2 //x2=1.825 //y2=5.045
r200 (  49 57 ) resistor r=592.245 //w=0.094 //l=1.155 //layer=ply \
 //thickness=0.18 //x=1.385 //y=6.2 //x2=1.385 //y2=5.045
r201 (  48 81 ) resistor r=56.4043 //w=0.094 //l=0.11 //layer=ply \
 //thickness=0.18 //x=3.89 //y=1.55 //x2=4 //y2=1.55
r202 (  48 82 ) resistor r=56.4043 //w=0.094 //l=0.11 //layer=ply \
 //thickness=0.18 //x=3.89 //y=1.55 //x2=3.78 //y2=1.55
r203 (  47 64 ) resistor r=56.4043 //w=0.094 //l=0.11 //layer=ply \
 //thickness=0.18 //x=1.605 //y=1.59 //x2=1.715 //y2=1.59
r204 (  47 65 ) resistor r=56.4043 //w=0.094 //l=0.11 //layer=ply \
 //thickness=0.18 //x=1.605 //y=1.59 //x2=1.495 //y2=1.59
r205 (  45 104 ) resistor r=152 //w=0.17 //l=0.17 //layer=licon //count=1 \
 //x=3.82 //y=4.88 //x2=3.82 //y2=4.88
r206 (  35 99 ) resistor r=152 //w=0.17 //l=0.17 //layer=licon //count=1 \
 //x=3.82 //y=2.265 //x2=3.82 //y2=2.265
r207 (  32 93 ) resistor r=152 //w=0.17 //l=0.17 //layer=licon //count=1 \
 //x=1.23 //y=4.88 //x2=1.23 //y2=4.88
r208 (  21 90 ) resistor r=152 //w=0.17 //l=0.17 //layer=licon //count=1 \
 //x=1.23 //y=2.265 //x2=1.23 //y2=2.265
r209 (  19 45 ) resistor r=17.7968 //w=0.187 //l=0.26 //layer=li \
 //thickness=0.1 //x=3.82 //y=4.62 //x2=3.82 //y2=4.88
r210 (  18 19 ) resistor r=25.3262 //w=0.187 //l=0.37 //layer=li \
 //thickness=0.1 //x=3.82 //y=4.25 //x2=3.82 //y2=4.62
r211 (  17 18 ) resistor r=25.3262 //w=0.187 //l=0.37 //layer=li \
 //thickness=0.1 //x=3.82 //y=3.88 //x2=3.82 //y2=4.25
r212 (  16 17 ) resistor r=25.3262 //w=0.187 //l=0.37 //layer=li \
 //thickness=0.1 //x=3.82 //y=3.51 //x2=3.82 //y2=3.88
r213 (  15 16 ) resistor r=25.3262 //w=0.187 //l=0.37 //layer=li \
 //thickness=0.1 //x=3.82 //y=3.14 //x2=3.82 //y2=3.51
r214 (  14 15 ) resistor r=50.6524 //w=0.187 //l=0.74 //layer=li \
 //thickness=0.1 //x=3.82 //y=2.4 //x2=3.82 //y2=3.14
r215 (  14 35 ) resistor r=9.24064 //w=0.187 //l=0.135 //layer=li \
 //thickness=0.1 //x=3.82 //y=2.4 //x2=3.82 //y2=2.265
r216 (  13 32 ) resistor r=17.7968 //w=0.187 //l=0.26 //layer=li \
 //thickness=0.1 //x=1.23 //y=4.62 //x2=1.23 //y2=4.88
r217 (  12 13 ) resistor r=25.3262 //w=0.187 //l=0.37 //layer=li \
 //thickness=0.1 //x=1.23 //y=4.25 //x2=1.23 //y2=4.62
r218 (  11 12 ) resistor r=25.3262 //w=0.187 //l=0.37 //layer=li \
 //thickness=0.1 //x=1.23 //y=3.88 //x2=1.23 //y2=4.25
r219 (  10 11 ) resistor r=25.3262 //w=0.187 //l=0.37 //layer=li \
 //thickness=0.1 //x=1.23 //y=3.51 //x2=1.23 //y2=3.88
r220 (  9 10 ) resistor r=25.3262 //w=0.187 //l=0.37 //layer=li \
 //thickness=0.1 //x=1.23 //y=3.14 //x2=1.23 //y2=3.51
r221 (  8 9 ) resistor r=25.3262 //w=0.187 //l=0.37 //layer=li //thickness=0.1 \
 //x=1.23 //y=2.77 //x2=1.23 //y2=3.14
r222 (  7 8 ) resistor r=25.3262 //w=0.187 //l=0.37 //layer=li //thickness=0.1 \
 //x=1.23 //y=2.4 //x2=1.23 //y2=2.77
r223 (  7 21 ) resistor r=9.24064 //w=0.187 //l=0.135 //layer=li \
 //thickness=0.1 //x=1.23 //y=2.4 //x2=1.23 //y2=2.265
r224 (  6 18 ) resistor r=9.3 //w=0.17 //l=0.17 //layer=mcon //count=1 \
 //x=3.82 //y=4.25 //x2=3.82 //y2=4.25
r225 (  4 12 ) resistor r=9.3 //w=0.17 //l=0.17 //layer=mcon //count=1 \
 //x=1.23 //y=4.25 //x2=1.23 //y2=4.25
r226 (  2 4 ) resistor r=0.0717383 //w=0.224 //l=0.115 //layer=m1 \
 //thickness=0.36 //x=1.345 //y=4.25 //x2=1.23 //y2=4.25
r227 (  1 6 ) resistor r=0.0717383 //w=0.224 //l=0.115 //layer=m1 \
 //thickness=0.36 //x=3.705 //y=4.25 //x2=3.82 //y2=4.25
r228 (  1 2 ) resistor r=2.25191 //w=0.131 //l=2.36 //layer=m1 \
 //thickness=0.36 //x=3.705 //y=4.25 //x2=1.345 //y2=4.25
ends PM_XOR2X1\%A

subckt PM_XOR2X1\%noxref_4 ( 1 2 17 18 19 20 24 26 33 34 35 36 37 38 39 43 45 \
 51 52 60 62 64 )
c169 ( 64 0 ) capacitor c=0.0288629f //x=1.46 //y=5.2
c170 ( 62 0 ) capacitor c=0.0173218f //x=1.415 //y=1.09
c171 ( 60 0 ) capacitor c=0.058481f //x=8.26 //y=4.88
c172 ( 52 0 ) capacitor c=0.0417768f //x=8.455 //y=1.435
c173 ( 51 0 ) capacitor c=0.0192208f //x=8.455 //y=1.09
c174 ( 45 0 ) capacitor c=0.0124204f //x=8.3 //y=1.59
c175 ( 43 0 ) capacitor c=0.0157803f //x=8.3 //y=0.935
c176 ( 39 0 ) capacitor c=0.0903287f //x=7.925 //y=2.1
c177 ( 38 0 ) capacitor c=0.0194674f //x=7.925 //y=1.745
c178 ( 37 0 ) capacitor c=0.0168481f //x=7.925 //y=1.435
c179 ( 36 0 ) capacitor c=0.0174345f //x=7.925 //y=1.09
c180 ( 35 0 ) capacitor c=0.153255f //x=8.37 //y=6.2
c181 ( 34 0 ) capacitor c=0.110227f //x=7.93 //y=6.2
c182 ( 26 0 ) capacitor c=0.0737449f //x=8.26 //y=2.265
c183 ( 24 0 ) capacitor c=0.0868472f //x=1.97 //y=2.77
c184 ( 20 0 ) capacitor c=0.00417404f //x=1.69 //y=4.76
c185 ( 19 0 ) capacitor c=0.0118896f //x=1.885 //y=4.76
c186 ( 18 0 ) capacitor c=0.00621372f //x=1.685 //y=2.26
c187 ( 17 0 ) capacitor c=0.013454f //x=1.885 //y=2.26
c188 ( 2 0 ) capacitor c=0.0163395f //x=2.085 //y=2.77
c189 ( 1 0 ) capacitor c=0.188407f //x=8.145 //y=2.77
r190 (  60 61 ) resistor r=22.7554 //w=0.233 //l=0.11 //layer=ply \
 //thickness=0.18 //x=8.26 //y=4.88 //x2=8.37 //y2=4.88
r191 (  52 58 ) resistor r=45.1352 //w=0.168 //l=0.173853 //layer=ply \
 //thickness=0.18 //x=8.455 //y=1.435 //x2=8.415 //y2=1.59
r192 (  51 57 ) resistor r=45.1352 //w=0.168 //l=0.173853 //layer=ply \
 //thickness=0.18 //x=8.455 //y=1.09 //x2=8.415 //y2=0.935
r193 (  51 52 ) resistor r=176.904 //w=0.094 //l=0.345 //layer=ply \
 //thickness=0.18 //x=8.455 //y=1.09 //x2=8.455 //y2=1.435
r194 (  48 61 ) resistor r=13.0941 //w=0.233 //l=0.165 //layer=ply \
 //thickness=0.18 //x=8.37 //y=5.045 //x2=8.37 //y2=4.88
r195 (  46 54 ) resistor r=10.701 //w=0.21 //l=0.115 //layer=ply \
 //thickness=0.18 //x=8.08 //y=1.59 //x2=7.965 //y2=1.59
r196 (  45 58 ) resistor r=5.52526 //w=0.168 //l=0.115 //layer=ply \
 //thickness=0.18 //x=8.3 //y=1.59 //x2=8.415 //y2=1.59
r197 (  44 53 ) resistor r=5.52526 //w=0.168 //l=0.115 //layer=ply \
 //thickness=0.18 //x=8.08 //y=0.935 //x2=7.965 //y2=0.935
r198 (  43 57 ) resistor r=5.52526 //w=0.168 //l=0.115 //layer=ply \
 //thickness=0.18 //x=8.3 //y=0.935 //x2=8.415 //y2=0.935
r199 (  43 44 ) resistor r=112.809 //w=0.094 //l=0.22 //layer=ply \
 //thickness=0.18 //x=8.3 //y=0.935 //x2=8.08 //y2=0.935
r200 (  40 60 ) resistor r=68.2661 //w=0.233 //l=0.404166 //layer=ply \
 //thickness=0.18 //x=7.93 //y=5.045 //x2=8.26 //y2=4.88
r201 (  39 56 ) resistor r=67.2792 //w=0.24 //l=0.438891 //layer=ply \
 //thickness=0.18 //x=7.925 //y=2.1 //x2=8.26 //y2=2.34
r202 (  38 54 ) resistor r=39.5823 //w=0.21 //l=0.173853 //layer=ply \
 //thickness=0.18 //x=7.925 //y=1.745 //x2=7.965 //y2=1.59
r203 (  38 39 ) resistor r=182.032 //w=0.094 //l=0.355 //layer=ply \
 //thickness=0.18 //x=7.925 //y=1.745 //x2=7.925 //y2=2.1
r204 (  37 54 ) resistor r=39.5823 //w=0.21 //l=0.173853 //layer=ply \
 //thickness=0.18 //x=7.925 //y=1.435 //x2=7.965 //y2=1.59
r205 (  36 53 ) resistor r=45.1352 //w=0.168 //l=0.173853 //layer=ply \
 //thickness=0.18 //x=7.925 //y=1.09 //x2=7.965 //y2=0.935
r206 (  36 37 ) resistor r=176.904 //w=0.094 //l=0.345 //layer=ply \
 //thickness=0.18 //x=7.925 //y=1.09 //x2=7.925 //y2=1.435
r207 (  35 48 ) resistor r=592.245 //w=0.094 //l=1.155 //layer=ply \
 //thickness=0.18 //x=8.37 //y=6.2 //x2=8.37 //y2=5.045
r208 (  34 40 ) resistor r=592.245 //w=0.094 //l=1.155 //layer=ply \
 //thickness=0.18 //x=7.93 //y=6.2 //x2=7.93 //y2=5.045
r209 (  33 45 ) resistor r=56.4043 //w=0.094 //l=0.11 //layer=ply \
 //thickness=0.18 //x=8.19 //y=1.59 //x2=8.3 //y2=1.59
r210 (  33 46 ) resistor r=56.4043 //w=0.094 //l=0.11 //layer=ply \
 //thickness=0.18 //x=8.19 //y=1.59 //x2=8.08 //y2=1.59
r211 (  31 60 ) resistor r=152 //w=0.17 //l=0.17 //layer=licon //count=1 \
 //x=8.26 //y=4.88 //x2=8.26 //y2=4.88
r212 (  29 31 ) resistor r=144.428 //w=0.187 //l=2.11 //layer=li \
 //thickness=0.1 //x=8.26 //y=2.77 //x2=8.26 //y2=4.88
r213 (  26 56 ) resistor r=152 //w=0.17 //l=0.17 //layer=licon //count=1 \
 //x=8.26 //y=2.265 //x2=8.26 //y2=2.265
r214 (  26 29 ) resistor r=34.5668 //w=0.187 //l=0.505 //layer=li \
 //thickness=0.1 //x=8.26 //y=2.265 //x2=8.26 //y2=2.77
r215 (  22 24 ) resistor r=130.396 //w=0.187 //l=1.905 //layer=li \
 //thickness=0.1 //x=1.97 //y=4.675 //x2=1.97 //y2=2.77
r216 (  21 24 ) resistor r=29.0909 //w=0.187 //l=0.425 //layer=li \
 //thickness=0.1 //x=1.97 //y=2.345 //x2=1.97 //y2=2.77
r217 (  19 22 ) resistor r=7.15173 //w=0.17 //l=0.120208 //layer=li \
 //thickness=0.1 //x=1.885 //y=4.76 //x2=1.97 //y2=4.675
r218 (  19 20 ) resistor r=13.3476 //w=0.187 //l=0.195 //layer=li \
 //thickness=0.1 //x=1.885 //y=4.76 //x2=1.69 //y2=4.76
r219 (  17 21 ) resistor r=7.15173 //w=0.17 //l=0.120208 //layer=li \
 //thickness=0.1 //x=1.885 //y=2.26 //x2=1.97 //y2=2.345
r220 (  17 18 ) resistor r=13.6898 //w=0.187 //l=0.2 //layer=li \
 //thickness=0.1 //x=1.885 //y=2.26 //x2=1.685 //y2=2.26
r221 (  11 20 ) resistor r=7.15173 //w=0.17 //l=0.120208 //layer=li \
 //thickness=0.1 //x=1.605 //y=4.845 //x2=1.69 //y2=4.76
r222 (  11 64 ) resistor r=72.5562 //w=0.187 //l=1.06 //layer=li \
 //thickness=0.1 //x=1.605 //y=4.845 //x2=1.605 //y2=5.905
r223 (  7 18 ) resistor r=7.15173 //w=0.17 //l=0.120208 //layer=li \
 //thickness=0.1 //x=1.6 //y=2.175 //x2=1.685 //y2=2.26
r224 (  7 62 ) resistor r=67.7647 //w=0.187 //l=0.99 //layer=li \
 //thickness=0.1 //x=1.6 //y=2.175 //x2=1.6 //y2=1.185
r225 (  6 29 ) resistor r=9.3 //w=0.17 //l=0.17 //layer=mcon //count=1 \
 //x=8.26 //y=2.77 //x2=8.26 //y2=2.77
r226 (  4 24 ) resistor r=9.3 //w=0.17 //l=0.17 //layer=mcon //count=1 \
 //x=1.97 //y=2.77 //x2=1.97 //y2=2.77
r227 (  2 4 ) resistor r=0.0717383 //w=0.224 //l=0.115 //layer=m1 \
 //thickness=0.36 //x=2.085 //y=2.77 //x2=1.97 //y2=2.77
r228 (  1 6 ) resistor r=0.0717383 //w=0.224 //l=0.115 //layer=m1 \
 //thickness=0.36 //x=8.145 //y=2.77 //x2=8.26 //y2=2.77
r229 (  1 2 ) resistor r=5.78244 //w=0.131 //l=6.06 //layer=m1 \
 //thickness=0.36 //x=8.145 //y=2.77 //x2=2.085 //y2=2.77
ends PM_XOR2X1\%noxref_4

subckt PM_XOR2X1\%Y ( 1 2 7 8 9 10 11 12 13 14 15 26 27 28 29 48 49 50 51 59 \
 60 63 64 )
c149 ( 64 0 ) capacitor c=0.0159588f //x=8.005 //y=5.2
c150 ( 63 0 ) capacitor c=0.0159588f //x=4.675 //y=5.2
c151 ( 60 0 ) capacitor c=0.00827922f //x=8 //y=1.09
c152 ( 59 0 ) capacitor c=0.00846882f //x=4.67 //y=1.09
c153 ( 51 0 ) capacitor c=0.00178322f //x=8.275 //y=1.835
c154 ( 50 0 ) capacitor c=0.0112025f //x=8.545 //y=1.835
c155 ( 49 0 ) capacitor c=0.00235465f //x=8.235 //y=5.385
c156 ( 48 0 ) capacitor c=0.0121398f //x=8.545 //y=5.385
c157 ( 29 0 ) capacitor c=0.00178606f //x=4.945 //y=1.835
c158 ( 28 0 ) capacitor c=0.0109582f //x=5.215 //y=1.835
c159 ( 27 0 ) capacitor c=0.0027221f //x=4.905 //y=5.385
c160 ( 26 0 ) capacitor c=0.0121701f //x=5.215 //y=5.385
c161 ( 12 0 ) capacitor c=0.0892717f //x=8.63 //y=2.4
c162 ( 7 0 ) capacitor c=0.10559f //x=5.3 //y=2.4
c163 ( 2 0 ) capacitor c=0.0132457f //x=5.415 //y=3.88
c164 ( 1 0 ) capacitor c=0.0664267f //x=8.515 //y=3.88
r165 (  50 52 ) resistor r=7.15173 //w=0.17 //l=0.120208 //layer=li \
 //thickness=0.1 //x=8.545 //y=1.835 //x2=8.63 //y2=1.92
r166 (  50 51 ) resistor r=18.4813 //w=0.187 //l=0.27 //layer=li \
 //thickness=0.1 //x=8.545 //y=1.835 //x2=8.275 //y2=1.835
r167 (  48 53 ) resistor r=7.15173 //w=0.17 //l=0.120208 //layer=li \
 //thickness=0.1 //x=8.545 //y=5.385 //x2=8.63 //y2=5.3
r168 (  48 49 ) resistor r=21.2193 //w=0.187 //l=0.31 //layer=li \
 //thickness=0.1 //x=8.545 //y=5.385 //x2=8.235 //y2=5.385
r169 (  44 51 ) resistor r=7.15173 //w=0.17 //l=0.120208 //layer=li \
 //thickness=0.1 //x=8.19 //y=1.75 //x2=8.275 //y2=1.835
r170 (  44 60 ) resistor r=38.6738 //w=0.187 //l=0.565 //layer=li \
 //thickness=0.1 //x=8.19 //y=1.75 //x2=8.19 //y2=1.185
r171 (  38 49 ) resistor r=7.15173 //w=0.17 //l=0.120208 //layer=li \
 //thickness=0.1 //x=8.15 //y=5.47 //x2=8.235 //y2=5.385
r172 (  38 64 ) resistor r=29.0909 //w=0.187 //l=0.425 //layer=li \
 //thickness=0.1 //x=8.15 //y=5.47 //x2=8.15 //y2=5.895
r173 (  28 30 ) resistor r=7.15173 //w=0.17 //l=0.120208 //layer=li \
 //thickness=0.1 //x=5.215 //y=1.835 //x2=5.3 //y2=1.92
r174 (  28 29 ) resistor r=18.4813 //w=0.187 //l=0.27 //layer=li \
 //thickness=0.1 //x=5.215 //y=1.835 //x2=4.945 //y2=1.835
r175 (  26 31 ) resistor r=7.15173 //w=0.17 //l=0.120208 //layer=li \
 //thickness=0.1 //x=5.215 //y=5.385 //x2=5.3 //y2=5.3
r176 (  26 27 ) resistor r=21.2193 //w=0.187 //l=0.31 //layer=li \
 //thickness=0.1 //x=5.215 //y=5.385 //x2=4.905 //y2=5.385
r177 (  22 29 ) resistor r=7.15173 //w=0.17 //l=0.120208 //layer=li \
 //thickness=0.1 //x=4.86 //y=1.75 //x2=4.945 //y2=1.835
r178 (  22 59 ) resistor r=38.6738 //w=0.187 //l=0.565 //layer=li \
 //thickness=0.1 //x=4.86 //y=1.75 //x2=4.86 //y2=1.185
r179 (  16 27 ) resistor r=7.15173 //w=0.17 //l=0.120208 //layer=li \
 //thickness=0.1 //x=4.82 //y=5.47 //x2=4.905 //y2=5.385
r180 (  16 63 ) resistor r=29.0909 //w=0.187 //l=0.425 //layer=li \
 //thickness=0.1 //x=4.82 //y=5.47 //x2=4.82 //y2=5.895
r181 (  15 53 ) resistor r=21.2193 //w=0.187 //l=0.31 //layer=li \
 //thickness=0.1 //x=8.63 //y=4.99 //x2=8.63 //y2=5.3
r182 (  14 15 ) resistor r=75.9786 //w=0.187 //l=1.11 //layer=li \
 //thickness=0.1 //x=8.63 //y=3.88 //x2=8.63 //y2=4.99
r183 (  13 14 ) resistor r=75.9786 //w=0.187 //l=1.11 //layer=li \
 //thickness=0.1 //x=8.63 //y=2.77 //x2=8.63 //y2=3.88
r184 (  12 13 ) resistor r=25.3262 //w=0.187 //l=0.37 //layer=li \
 //thickness=0.1 //x=8.63 //y=2.4 //x2=8.63 //y2=2.77
r185 (  12 52 ) resistor r=32.8556 //w=0.187 //l=0.48 //layer=li \
 //thickness=0.1 //x=8.63 //y=2.4 //x2=8.63 //y2=1.92
r186 (  11 31 ) resistor r=21.2193 //w=0.187 //l=0.31 //layer=li \
 //thickness=0.1 //x=5.3 //y=4.99 //x2=5.3 //y2=5.3
r187 (  10 11 ) resistor r=25.3262 //w=0.187 //l=0.37 //layer=li \
 //thickness=0.1 //x=5.3 //y=4.62 //x2=5.3 //y2=4.99
r188 (  9 10 ) resistor r=50.6524 //w=0.187 //l=0.74 //layer=li \
 //thickness=0.1 //x=5.3 //y=3.88 //x2=5.3 //y2=4.62
r189 (  8 9 ) resistor r=25.3262 //w=0.187 //l=0.37 //layer=li //thickness=0.1 \
 //x=5.3 //y=3.51 //x2=5.3 //y2=3.88
r190 (  7 8 ) resistor r=75.9786 //w=0.187 //l=1.11 //layer=li //thickness=0.1 \
 //x=5.3 //y=2.4 //x2=5.3 //y2=3.51
r191 (  7 30 ) resistor r=32.8556 //w=0.187 //l=0.48 //layer=li \
 //thickness=0.1 //x=5.3 //y=2.4 //x2=5.3 //y2=1.92
r192 (  6 14 ) resistor r=9.3 //w=0.17 //l=0.17 //layer=mcon //count=1 \
 //x=8.63 //y=3.88 //x2=8.63 //y2=3.88
r193 (  4 9 ) resistor r=9.3 //w=0.17 //l=0.17 //layer=mcon //count=1 //x=5.3 \
 //y=3.88 //x2=5.3 //y2=3.88
r194 (  2 4 ) resistor r=0.0717383 //w=0.224 //l=0.115 //layer=m1 \
 //thickness=0.36 //x=5.415 //y=3.88 //x2=5.3 //y2=3.88
r195 (  1 6 ) resistor r=0.0717383 //w=0.224 //l=0.115 //layer=m1 \
 //thickness=0.36 //x=8.515 //y=3.88 //x2=8.63 //y2=3.88
r196 (  1 2 ) resistor r=2.95802 //w=0.131 //l=3.1 //layer=m1 //thickness=0.36 \
 //x=8.515 //y=3.88 //x2=5.415 //y2=3.88
ends PM_XOR2X1\%Y

subckt PM_XOR2X1\%noxref_6 ( 1 2 3 4 14 20 28 31 32 33 34 45 46 47 54 55 56 57 \
 58 60 63 64 66 74 76 )
c165 ( 76 0 ) capacitor c=0.028734f //x=10.33 //y=5.2
c166 ( 74 0 ) capacitor c=0.0173218f //x=10.285 //y=1.09
c167 ( 66 0 ) capacitor c=0.0636249f //x=4.93 //y=4.88
c168 ( 64 0 ) capacitor c=0.0318948f //x=7.485 //y=1.395
c169 ( 63 0 ) capacitor c=0.0187407f //x=7.485 //y=1.05
c170 ( 60 0 ) capacitor c=0.0141798f //x=7.33 //y=1.55
c171 ( 58 0 ) capacitor c=0.0149852f //x=7.33 //y=0.895
c172 ( 57 0 ) capacitor c=0.0836807f //x=6.955 //y=2.1
c173 ( 56 0 ) capacitor c=0.0229722f //x=6.955 //y=1.705
c174 ( 55 0 ) capacitor c=0.0234352f //x=6.955 //y=1.395
c175 ( 54 0 ) capacitor c=0.0199366f //x=6.955 //y=1.05
c176 ( 47 0 ) capacitor c=0.153255f //x=5.04 //y=6.2
c177 ( 46 0 ) capacitor c=0.110227f //x=4.6 //y=6.2
c178 ( 34 0 ) capacitor c=0.00670488f //x=10.195 //y=4.76
c179 ( 33 0 ) capacitor c=0.0137356f //x=10.39 //y=4.76
c180 ( 32 0 ) capacitor c=0.00580686f //x=10.195 //y=2.26
c181 ( 31 0 ) capacitor c=0.0128831f //x=10.395 //y=2.26
c182 ( 28 0 ) capacitor c=0.0775793f //x=10.11 //y=3.51
c183 ( 20 0 ) capacitor c=0.0551449f //x=7.15 //y=2.265
c184 ( 14 0 ) capacitor c=0.024985f //x=4.93 //y=4.25
c185 ( 4 0 ) capacitor c=0.0126928f //x=7.265 //y=3.51
c186 ( 3 0 ) capacitor c=0.0544915f //x=9.995 //y=3.51
c187 ( 2 0 ) capacitor c=0.01091f //x=5.045 //y=4.25
c188 ( 1 0 ) capacitor c=0.109416f //x=9.995 //y=4.25
r189 (  66 67 ) resistor r=22.7554 //w=0.233 //l=0.11 //layer=ply \
 //thickness=0.18 //x=4.93 //y=4.88 //x2=5.04 //y2=4.88
r190 (  64 73 ) resistor r=45.1352 //w=0.168 //l=0.173853 //layer=ply \
 //thickness=0.18 //x=7.485 //y=1.395 //x2=7.445 //y2=1.55
r191 (  63 72 ) resistor r=45.1352 //w=0.168 //l=0.173853 //layer=ply \
 //thickness=0.18 //x=7.485 //y=1.05 //x2=7.445 //y2=0.895
r192 (  63 64 ) resistor r=176.904 //w=0.094 //l=0.345 //layer=ply \
 //thickness=0.18 //x=7.485 //y=1.05 //x2=7.485 //y2=1.395
r193 (  61 71 ) resistor r=10.701 //w=0.21 //l=0.115 //layer=ply \
 //thickness=0.18 //x=7.11 //y=1.55 //x2=6.995 //y2=1.55
r194 (  60 73 ) resistor r=5.52526 //w=0.168 //l=0.115 //layer=ply \
 //thickness=0.18 //x=7.33 //y=1.55 //x2=7.445 //y2=1.55
r195 (  59 70 ) resistor r=5.52526 //w=0.168 //l=0.115 //layer=ply \
 //thickness=0.18 //x=7.11 //y=0.895 //x2=6.995 //y2=0.895
r196 (  58 72 ) resistor r=5.52526 //w=0.168 //l=0.115 //layer=ply \
 //thickness=0.18 //x=7.33 //y=0.895 //x2=7.445 //y2=0.895
r197 (  58 59 ) resistor r=112.809 //w=0.094 //l=0.22 //layer=ply \
 //thickness=0.18 //x=7.33 //y=0.895 //x2=7.11 //y2=0.895
r198 (  57 69 ) resistor r=34.8111 //w=0.27 //l=0.264953 //layer=ply \
 //thickness=0.18 //x=6.955 //y=2.1 //x2=7.15 //y2=2.265
r199 (  56 71 ) resistor r=39.5823 //w=0.21 //l=0.173853 //layer=ply \
 //thickness=0.18 //x=6.955 //y=1.705 //x2=6.995 //y2=1.55
r200 (  56 57 ) resistor r=202.543 //w=0.094 //l=0.395 //layer=ply \
 //thickness=0.18 //x=6.955 //y=1.705 //x2=6.955 //y2=2.1
r201 (  55 71 ) resistor r=39.5823 //w=0.21 //l=0.173853 //layer=ply \
 //thickness=0.18 //x=6.955 //y=1.395 //x2=6.995 //y2=1.55
r202 (  54 70 ) resistor r=45.1352 //w=0.168 //l=0.173853 //layer=ply \
 //thickness=0.18 //x=6.955 //y=1.05 //x2=6.995 //y2=0.895
r203 (  54 55 ) resistor r=176.904 //w=0.094 //l=0.345 //layer=ply \
 //thickness=0.18 //x=6.955 //y=1.05 //x2=6.955 //y2=1.395
r204 (  51 67 ) resistor r=13.0941 //w=0.233 //l=0.165 //layer=ply \
 //thickness=0.18 //x=5.04 //y=5.045 //x2=5.04 //y2=4.88
r205 (  48 66 ) resistor r=68.2661 //w=0.233 //l=0.404166 //layer=ply \
 //thickness=0.18 //x=4.6 //y=5.045 //x2=4.93 //y2=4.88
r206 (  47 51 ) resistor r=592.245 //w=0.094 //l=1.155 //layer=ply \
 //thickness=0.18 //x=5.04 //y=6.2 //x2=5.04 //y2=5.045
r207 (  46 48 ) resistor r=592.245 //w=0.094 //l=1.155 //layer=ply \
 //thickness=0.18 //x=4.6 //y=6.2 //x2=4.6 //y2=5.045
r208 (  45 60 ) resistor r=56.4043 //w=0.094 //l=0.11 //layer=ply \
 //thickness=0.18 //x=7.22 //y=1.55 //x2=7.33 //y2=1.55
r209 (  45 61 ) resistor r=56.4043 //w=0.094 //l=0.11 //layer=ply \
 //thickness=0.18 //x=7.22 //y=1.55 //x2=7.11 //y2=1.55
r210 (  41 74 ) resistor r=67.7647 //w=0.187 //l=0.99 //layer=li \
 //thickness=0.1 //x=10.48 //y=2.175 //x2=10.48 //y2=1.185
r211 (  35 76 ) resistor r=72.5562 //w=0.187 //l=1.06 //layer=li \
 //thickness=0.1 //x=10.475 //y=4.845 //x2=10.475 //y2=5.905
r212 (  33 35 ) resistor r=7.15173 //w=0.17 //l=0.120208 //layer=li \
 //thickness=0.1 //x=10.39 //y=4.76 //x2=10.475 //y2=4.845
r213 (  33 34 ) resistor r=13.3476 //w=0.187 //l=0.195 //layer=li \
 //thickness=0.1 //x=10.39 //y=4.76 //x2=10.195 //y2=4.76
r214 (  31 41 ) resistor r=7.15173 //w=0.17 //l=0.120208 //layer=li \
 //thickness=0.1 //x=10.395 //y=2.26 //x2=10.48 //y2=2.175
r215 (  31 32 ) resistor r=13.6898 //w=0.187 //l=0.2 //layer=li \
 //thickness=0.1 //x=10.395 //y=2.26 //x2=10.195 //y2=2.26
r216 (  28 30 ) resistor r=50.6524 //w=0.187 //l=0.74 //layer=li \
 //thickness=0.1 //x=10.11 //y=3.51 //x2=10.11 //y2=4.25
r217 (  26 34 ) resistor r=7.15173 //w=0.17 //l=0.120208 //layer=li \
 //thickness=0.1 //x=10.11 //y=4.675 //x2=10.195 //y2=4.76
r218 (  26 30 ) resistor r=29.0909 //w=0.187 //l=0.425 //layer=li \
 //thickness=0.1 //x=10.11 //y=4.675 //x2=10.11 //y2=4.25
r219 (  25 32 ) resistor r=7.15173 //w=0.17 //l=0.120208 //layer=li \
 //thickness=0.1 //x=10.11 //y=2.345 //x2=10.195 //y2=2.26
r220 (  25 28 ) resistor r=79.7433 //w=0.187 //l=1.165 //layer=li \
 //thickness=0.1 //x=10.11 //y=2.345 //x2=10.11 //y2=3.51
r221 (  20 69 ) resistor r=152 //w=0.17 //l=0.17 //layer=licon //count=1 \
 //x=7.15 //y=2.265 //x2=7.15 //y2=2.265
r222 (  20 23 ) resistor r=85.2193 //w=0.187 //l=1.245 //layer=li \
 //thickness=0.1 //x=7.15 //y=2.265 //x2=7.15 //y2=3.51
r223 (  17 66 ) resistor r=152 //w=0.17 //l=0.17 //layer=licon //count=1 \
 //x=4.93 //y=4.88 //x2=4.93 //y2=4.88
r224 (  14 17 ) resistor r=43.123 //w=0.187 //l=0.63 //layer=li \
 //thickness=0.1 //x=4.93 //y=4.25 //x2=4.93 //y2=4.88
r225 (  12 30 ) resistor r=9.3 //w=0.17 //l=0.17 //layer=mcon //count=1 \
 //x=10.11 //y=4.25 //x2=10.11 //y2=4.25
r226 (  10 28 ) resistor r=9.3 //w=0.17 //l=0.17 //layer=mcon //count=1 \
 //x=10.11 //y=3.51 //x2=10.11 //y2=3.51
r227 (  8 23 ) resistor r=9.3 //w=0.17 //l=0.17 //layer=mcon //count=1 \
 //x=7.15 //y=3.51 //x2=7.15 //y2=3.51
r228 (  6 14 ) resistor r=9.3 //w=0.17 //l=0.17 //layer=mcon //count=1 \
 //x=4.93 //y=4.25 //x2=4.93 //y2=4.25
r229 (  4 8 ) resistor r=0.0717383 //w=0.224 //l=0.115 //layer=m1 \
 //thickness=0.36 //x=7.265 //y=3.51 //x2=7.15 //y2=3.51
r230 (  3 10 ) resistor r=0.0717383 //w=0.224 //l=0.115 //layer=m1 \
 //thickness=0.36 //x=9.995 //y=3.51 //x2=10.11 //y2=3.51
r231 (  3 4 ) resistor r=2.60496 //w=0.131 //l=2.73 //layer=m1 \
 //thickness=0.36 //x=9.995 //y=3.51 //x2=7.265 //y2=3.51
r232 (  2 6 ) resistor r=0.0717383 //w=0.224 //l=0.115 //layer=m1 \
 //thickness=0.36 //x=5.045 //y=4.25 //x2=4.93 //y2=4.25
r233 (  1 12 ) resistor r=0.0717383 //w=0.224 //l=0.115 //layer=m1 \
 //thickness=0.36 //x=9.995 //y=4.25 //x2=10.11 //y2=4.25
r234 (  1 2 ) resistor r=4.72328 //w=0.131 //l=4.95 //layer=m1 \
 //thickness=0.36 //x=9.995 //y=4.25 //x2=5.045 //y2=4.25
ends PM_XOR2X1\%noxref_6

subckt PM_XOR2X1\%B ( 1 2 3 4 13 14 15 16 17 18 19 20 21 22 24 37 51 52 53 54 \
 55 56 57 58 59 60 61 63 66 67 74 75 79 80 81 83 86 89 90 91 92 101 106 )
c173 ( 106 0 ) capacitor c=0.051138f //x=10.74 //y=2.265
c174 ( 101 0 ) capacitor c=0.0606915f //x=7.15 //y=4.88
c175 ( 92 0 ) capacitor c=0.0290017f //x=10.74 //y=2.1
c176 ( 91 0 ) capacitor c=0.0250171f //x=10.74 //y=1.745
c177 ( 90 0 ) capacitor c=0.0234316f //x=10.74 //y=1.435
c178 ( 89 0 ) capacitor c=0.0200712f //x=10.74 //y=1.09
c179 ( 86 0 ) capacitor c=0.0488625f //x=10.695 //y=5.045
c180 ( 83 0 ) capacitor c=0.0152946f //x=10.585 //y=1.59
c181 ( 81 0 ) capacitor c=0.0157804f //x=10.585 //y=0.935
c182 ( 80 0 ) capacitor c=0.0129718f //x=10.33 //y=4.97
c183 ( 79 0 ) capacitor c=0.0172687f //x=10.62 //y=4.97
c184 ( 75 0 ) capacitor c=0.0435512f //x=10.21 //y=1.435
c185 ( 74 0 ) capacitor c=0.0200269f //x=10.21 //y=1.09
c186 ( 67 0 ) capacitor c=0.0417768f //x=5.125 //y=1.435
c187 ( 66 0 ) capacitor c=0.0192208f //x=5.125 //y=1.09
c188 ( 63 0 ) capacitor c=0.0124204f //x=4.97 //y=1.59
c189 ( 61 0 ) capacitor c=0.0157803f //x=4.97 //y=0.935
c190 ( 60 0 ) capacitor c=0.0903325f //x=4.595 //y=2.1
c191 ( 59 0 ) capacitor c=0.0194674f //x=4.595 //y=1.745
c192 ( 58 0 ) capacitor c=0.0168481f //x=4.595 //y=1.435
c193 ( 57 0 ) capacitor c=0.0174345f //x=4.595 //y=1.09
c194 ( 56 0 ) capacitor c=0.154243f //x=10.695 //y=6.2
c195 ( 55 0 ) capacitor c=0.154218f //x=10.255 //y=6.2
c196 ( 54 0 ) capacitor c=0.110797f //x=7.49 //y=6.2
c197 ( 53 0 ) capacitor c=0.154322f //x=7.05 //y=6.2
c198 ( 37 0 ) capacitor c=0.106666f //x=10.85 //y=2.265
c199 ( 24 0 ) capacitor c=0.0306114f //x=4.93 //y=2.265
c200 ( 15 0 ) capacitor c=0.0150587f //x=7.15 //y=4.62
c201 ( 4 0 ) capacitor c=0.015004f //x=7.265 //y=4.62
c202 ( 3 0 ) capacitor c=0.0929962f //x=10.735 //y=4.62
c203 ( 2 0 ) capacitor c=0.0154186f //x=5.045 //y=3.14
c204 ( 1 0 ) capacitor c=0.130205f //x=10.735 //y=3.14
r205 (  106 108 ) resistor r=17.5563 //w=0.302 //l=0.11 //layer=ply \
 //thickness=0.18 //x=10.74 //y=2.265 //x2=10.85 //y2=2.265
r206 (  99 101 ) resistor r=20.6867 //w=0.233 //l=0.1 //layer=ply \
 //thickness=0.18 //x=7.05 //y=4.88 //x2=7.15 //y2=4.88
r207 (  92 106 ) resistor r=19.1248 //w=0.302 //l=0.165 //layer=ply \
 //thickness=0.18 //x=10.74 //y=2.1 //x2=10.74 //y2=2.265
r208 (  91 105 ) resistor r=39.5823 //w=0.21 //l=0.173853 //layer=ply \
 //thickness=0.18 //x=10.74 //y=1.745 //x2=10.7 //y2=1.59
r209 (  91 92 ) resistor r=182.032 //w=0.094 //l=0.355 //layer=ply \
 //thickness=0.18 //x=10.74 //y=1.745 //x2=10.74 //y2=2.1
r210 (  90 105 ) resistor r=39.5823 //w=0.21 //l=0.173853 //layer=ply \
 //thickness=0.18 //x=10.74 //y=1.435 //x2=10.7 //y2=1.59
r211 (  89 104 ) resistor r=45.1352 //w=0.168 //l=0.173853 //layer=ply \
 //thickness=0.18 //x=10.74 //y=1.09 //x2=10.7 //y2=0.935
r212 (  89 90 ) resistor r=176.904 //w=0.094 //l=0.345 //layer=ply \
 //thickness=0.18 //x=10.74 //y=1.09 //x2=10.74 //y2=1.435
r213 (  86 110 ) resistor r=26.3063 //w=0.284 //l=0.229783 //layer=ply \
 //thickness=0.18 //x=10.695 //y=5.045 //x2=10.85 //y2=4.88
r214 (  84 103 ) resistor r=5.52526 //w=0.168 //l=0.115 //layer=ply \
 //thickness=0.18 //x=10.365 //y=1.59 //x2=10.25 //y2=1.59
r215 (  83 105 ) resistor r=10.701 //w=0.21 //l=0.115 //layer=ply \
 //thickness=0.18 //x=10.585 //y=1.59 //x2=10.7 //y2=1.59
r216 (  82 102 ) resistor r=5.52526 //w=0.168 //l=0.115 //layer=ply \
 //thickness=0.18 //x=10.365 //y=0.935 //x2=10.25 //y2=0.935
r217 (  81 104 ) resistor r=5.52526 //w=0.168 //l=0.115 //layer=ply \
 //thickness=0.18 //x=10.585 //y=0.935 //x2=10.7 //y2=0.935
r218 (  81 82 ) resistor r=112.809 //w=0.094 //l=0.22 //layer=ply \
 //thickness=0.18 //x=10.585 //y=0.935 //x2=10.365 //y2=0.935
r219 (  79 86 ) resistor r=23.403 //w=0.284 //l=0.106066 //layer=ply \
 //thickness=0.18 //x=10.62 //y=4.97 //x2=10.695 //y2=5.045
r220 (  79 80 ) resistor r=148.702 //w=0.094 //l=0.29 //layer=ply \
 //thickness=0.18 //x=10.62 //y=4.97 //x2=10.33 //y2=4.97
r221 (  76 80 ) resistor r=26.9307 //w=0.15 //l=0.106066 //layer=ply \
 //thickness=0.18 //x=10.255 //y=5.045 //x2=10.33 //y2=4.97
r222 (  75 103 ) resistor r=45.1352 //w=0.168 //l=0.173853 //layer=ply \
 //thickness=0.18 //x=10.21 //y=1.435 //x2=10.25 //y2=1.59
r223 (  74 102 ) resistor r=45.1352 //w=0.168 //l=0.173853 //layer=ply \
 //thickness=0.18 //x=10.21 //y=1.09 //x2=10.25 //y2=0.935
r224 (  74 75 ) resistor r=176.904 //w=0.094 //l=0.345 //layer=ply \
 //thickness=0.18 //x=10.21 //y=1.09 //x2=10.21 //y2=1.435
r225 (  71 101 ) resistor r=70.3348 //w=0.233 //l=0.414367 //layer=ply \
 //thickness=0.18 //x=7.49 //y=5.045 //x2=7.15 //y2=4.88
r226 (  68 99 ) resistor r=13.0941 //w=0.233 //l=0.165 //layer=ply \
 //thickness=0.18 //x=7.05 //y=5.045 //x2=7.05 //y2=4.88
r227 (  67 98 ) resistor r=45.1352 //w=0.168 //l=0.173853 //layer=ply \
 //thickness=0.18 //x=5.125 //y=1.435 //x2=5.085 //y2=1.59
r228 (  66 97 ) resistor r=45.1352 //w=0.168 //l=0.173853 //layer=ply \
 //thickness=0.18 //x=5.125 //y=1.09 //x2=5.085 //y2=0.935
r229 (  66 67 ) resistor r=176.904 //w=0.094 //l=0.345 //layer=ply \
 //thickness=0.18 //x=5.125 //y=1.09 //x2=5.125 //y2=1.435
r230 (  64 94 ) resistor r=10.701 //w=0.21 //l=0.115 //layer=ply \
 //thickness=0.18 //x=4.75 //y=1.59 //x2=4.635 //y2=1.59
r231 (  63 98 ) resistor r=5.52526 //w=0.168 //l=0.115 //layer=ply \
 //thickness=0.18 //x=4.97 //y=1.59 //x2=5.085 //y2=1.59
r232 (  62 93 ) resistor r=5.52526 //w=0.168 //l=0.115 //layer=ply \
 //thickness=0.18 //x=4.75 //y=0.935 //x2=4.635 //y2=0.935
r233 (  61 97 ) resistor r=5.52526 //w=0.168 //l=0.115 //layer=ply \
 //thickness=0.18 //x=4.97 //y=0.935 //x2=5.085 //y2=0.935
r234 (  61 62 ) resistor r=112.809 //w=0.094 //l=0.22 //layer=ply \
 //thickness=0.18 //x=4.97 //y=0.935 //x2=4.75 //y2=0.935
r235 (  60 96 ) resistor r=67.2792 //w=0.24 //l=0.438891 //layer=ply \
 //thickness=0.18 //x=4.595 //y=2.1 //x2=4.93 //y2=2.34
r236 (  59 94 ) resistor r=39.5823 //w=0.21 //l=0.173853 //layer=ply \
 //thickness=0.18 //x=4.595 //y=1.745 //x2=4.635 //y2=1.59
r237 (  59 60 ) resistor r=182.032 //w=0.094 //l=0.355 //layer=ply \
 //thickness=0.18 //x=4.595 //y=1.745 //x2=4.595 //y2=2.1
r238 (  58 94 ) resistor r=39.5823 //w=0.21 //l=0.173853 //layer=ply \
 //thickness=0.18 //x=4.595 //y=1.435 //x2=4.635 //y2=1.59
r239 (  57 93 ) resistor r=45.1352 //w=0.168 //l=0.173853 //layer=ply \
 //thickness=0.18 //x=4.595 //y=1.09 //x2=4.635 //y2=0.935
r240 (  57 58 ) resistor r=176.904 //w=0.094 //l=0.345 //layer=ply \
 //thickness=0.18 //x=4.595 //y=1.09 //x2=4.595 //y2=1.435
r241 (  56 86 ) resistor r=592.245 //w=0.094 //l=1.155 //layer=ply \
 //thickness=0.18 //x=10.695 //y=6.2 //x2=10.695 //y2=5.045
r242 (  55 76 ) resistor r=592.245 //w=0.094 //l=1.155 //layer=ply \
 //thickness=0.18 //x=10.255 //y=6.2 //x2=10.255 //y2=5.045
r243 (  54 71 ) resistor r=592.245 //w=0.094 //l=1.155 //layer=ply \
 //thickness=0.18 //x=7.49 //y=6.2 //x2=7.49 //y2=5.045
r244 (  53 68 ) resistor r=592.245 //w=0.094 //l=1.155 //layer=ply \
 //thickness=0.18 //x=7.05 //y=6.2 //x2=7.05 //y2=5.045
r245 (  52 83 ) resistor r=56.4043 //w=0.094 //l=0.11 //layer=ply \
 //thickness=0.18 //x=10.475 //y=1.59 //x2=10.585 //y2=1.59
r246 (  52 84 ) resistor r=56.4043 //w=0.094 //l=0.11 //layer=ply \
 //thickness=0.18 //x=10.475 //y=1.59 //x2=10.365 //y2=1.59
r247 (  51 63 ) resistor r=56.4043 //w=0.094 //l=0.11 //layer=ply \
 //thickness=0.18 //x=4.86 //y=1.59 //x2=4.97 //y2=1.59
r248 (  51 64 ) resistor r=56.4043 //w=0.094 //l=0.11 //layer=ply \
 //thickness=0.18 //x=4.86 //y=1.59 //x2=4.75 //y2=1.59
r249 (  49 110 ) resistor r=152 //w=0.17 //l=0.17 //layer=licon //count=1 \
 //x=10.85 //y=4.88 //x2=10.85 //y2=4.88
r250 (  37 108 ) resistor r=152 //w=0.17 //l=0.17 //layer=licon //count=1 \
 //x=10.85 //y=2.265 //x2=10.85 //y2=2.265
r251 (  34 101 ) resistor r=152 //w=0.17 //l=0.17 //layer=licon //count=1 \
 //x=7.15 //y=4.88 //x2=7.15 //y2=4.88
r252 (  24 96 ) resistor r=152 //w=0.17 //l=0.17 //layer=licon //count=1 \
 //x=4.93 //y=2.265 //x2=4.93 //y2=2.265
r253 (  22 49 ) resistor r=17.7968 //w=0.187 //l=0.26 //layer=li \
 //thickness=0.1 //x=10.85 //y=4.62 //x2=10.85 //y2=4.88
r254 (  21 22 ) resistor r=25.3262 //w=0.187 //l=0.37 //layer=li \
 //thickness=0.1 //x=10.85 //y=4.25 //x2=10.85 //y2=4.62
r255 (  20 21 ) resistor r=25.3262 //w=0.187 //l=0.37 //layer=li \
 //thickness=0.1 //x=10.85 //y=3.88 //x2=10.85 //y2=4.25
r256 (  19 20 ) resistor r=25.3262 //w=0.187 //l=0.37 //layer=li \
 //thickness=0.1 //x=10.85 //y=3.51 //x2=10.85 //y2=3.88
r257 (  18 19 ) resistor r=25.3262 //w=0.187 //l=0.37 //layer=li \
 //thickness=0.1 //x=10.85 //y=3.14 //x2=10.85 //y2=3.51
r258 (  17 18 ) resistor r=25.3262 //w=0.187 //l=0.37 //layer=li \
 //thickness=0.1 //x=10.85 //y=2.77 //x2=10.85 //y2=3.14
r259 (  16 17 ) resistor r=25.3262 //w=0.187 //l=0.37 //layer=li \
 //thickness=0.1 //x=10.85 //y=2.4 //x2=10.85 //y2=2.77
r260 (  16 37 ) resistor r=9.24064 //w=0.187 //l=0.135 //layer=li \
 //thickness=0.1 //x=10.85 //y=2.4 //x2=10.85 //y2=2.265
r261 (  15 34 ) resistor r=17.7968 //w=0.187 //l=0.26 //layer=li \
 //thickness=0.1 //x=7.15 //y=4.62 //x2=7.15 //y2=4.88
r262 (  13 14 ) resistor r=50.6524 //w=0.187 //l=0.74 //layer=li \
 //thickness=0.1 //x=4.93 //y=2.4 //x2=4.93 //y2=3.14
r263 (  13 24 ) resistor r=9.24064 //w=0.187 //l=0.135 //layer=li \
 //thickness=0.1 //x=4.93 //y=2.4 //x2=4.93 //y2=2.265
r264 (  12 22 ) resistor r=9.3 //w=0.17 //l=0.17 //layer=mcon //count=1 \
 //x=10.85 //y=4.62 //x2=10.85 //y2=4.62
r265 (  10 18 ) resistor r=9.3 //w=0.17 //l=0.17 //layer=mcon //count=1 \
 //x=10.85 //y=3.14 //x2=10.85 //y2=3.14
r266 (  8 15 ) resistor r=9.3 //w=0.17 //l=0.17 //layer=mcon //count=1 \
 //x=7.15 //y=4.62 //x2=7.15 //y2=4.62
r267 (  6 14 ) resistor r=9.3 //w=0.17 //l=0.17 //layer=mcon //count=1 \
 //x=4.93 //y=3.14 //x2=4.93 //y2=3.14
r268 (  4 8 ) resistor r=0.0717383 //w=0.224 //l=0.115 //layer=m1 \
 //thickness=0.36 //x=7.265 //y=4.62 //x2=7.15 //y2=4.62
r269 (  3 12 ) resistor r=0.0717383 //w=0.224 //l=0.115 //layer=m1 \
 //thickness=0.36 //x=10.735 //y=4.62 //x2=10.85 //y2=4.62
r270 (  3 4 ) resistor r=3.31107 //w=0.131 //l=3.47 //layer=m1 \
 //thickness=0.36 //x=10.735 //y=4.62 //x2=7.265 //y2=4.62
r271 (  2 6 ) resistor r=0.0717383 //w=0.224 //l=0.115 //layer=m1 \
 //thickness=0.36 //x=5.045 //y=3.14 //x2=4.93 //y2=3.14
r272 (  1 10 ) resistor r=0.0717383 //w=0.224 //l=0.115 //layer=m1 \
 //thickness=0.36 //x=10.735 //y=3.14 //x2=10.85 //y2=3.14
r273 (  1 2 ) resistor r=5.42939 //w=0.131 //l=5.69 //layer=m1 \
 //thickness=0.36 //x=10.735 //y=3.14 //x2=5.045 //y2=3.14
ends PM_XOR2X1\%B

subckt PM_XOR2X1\%noxref_8 ( 7 8 15 16 23 24 25 )
c40 ( 25 0 ) capacitor c=0.0306618f //x=5.115 //y=5.2
c41 ( 24 0 ) capacitor c=0.0185379f //x=4.235 //y=5.2
c42 ( 23 0 ) capacitor c=0.0384176f //x=3.365 //y=5.2
c43 ( 16 0 ) capacitor c=0.00194711f //x=4.465 //y=7.085
c44 ( 15 0 ) capacitor c=0.014216f //x=5.175 //y=7.085
c45 ( 8 0 ) capacitor c=0.00644339f //x=3.585 //y=5.385
c46 ( 7 0 ) capacitor c=0.0212224f //x=4.295 //y=5.385
r47 (  17 25 ) resistor r=5.81818 //w=0.187 //l=0.085 //layer=li \
 //thickness=0.1 //x=5.26 //y=7 //x2=5.26 //y2=6.915
r48 (  15 17 ) resistor r=7.15173 //w=0.17 //l=0.120208 //layer=li \
 //thickness=0.1 //x=5.175 //y=7.085 //x2=5.26 //y2=7
r49 (  15 16 ) resistor r=48.5989 //w=0.187 //l=0.71 //layer=li \
 //thickness=0.1 //x=5.175 //y=7.085 //x2=4.465 //y2=7.085
r50 (  10 16 ) resistor r=7.15173 //w=0.17 //l=0.120208 //layer=li \
 //thickness=0.1 //x=4.38 //y=7 //x2=4.465 //y2=7.085
r51 (  10 24 ) resistor r=29.0909 //w=0.187 //l=0.425 //layer=li \
 //thickness=0.1 //x=4.38 //y=7 //x2=4.38 //y2=6.575
r52 (  9 24 ) resistor r=29.0909 //w=0.187 //l=0.425 //layer=li \
 //thickness=0.1 //x=4.38 //y=5.47 //x2=4.38 //y2=5.895
r53 (  7 9 ) resistor r=7.15173 //w=0.17 //l=0.120208 //layer=li \
 //thickness=0.1 //x=4.295 //y=5.385 //x2=4.38 //y2=5.47
r54 (  7 8 ) resistor r=48.5989 //w=0.187 //l=0.71 //layer=li //thickness=0.1 \
 //x=4.295 //y=5.385 //x2=3.585 //y2=5.385
r55 (  1 8 ) resistor r=7.15173 //w=0.17 //l=0.120208 //layer=li \
 //thickness=0.1 //x=3.5 //y=5.47 //x2=3.585 //y2=5.385
r56 (  1 23 ) resistor r=29.0909 //w=0.187 //l=0.425 //layer=li \
 //thickness=0.1 //x=3.5 //y=5.47 //x2=3.5 //y2=5.895
ends PM_XOR2X1\%noxref_8

subckt PM_XOR2X1\%noxref_9 ( 1 5 9 10 13 17 29 )
c52 ( 29 0 ) capacitor c=0.0632228f //x=3.27 //y=0.55
c53 ( 17 0 ) capacitor c=0.00723243f //x=5.345 //y=0.8
c54 ( 13 0 ) capacitor c=0.0153475f //x=5.26 //y=0.715
c55 ( 10 0 ) capacitor c=0.00656687f //x=4.375 //y=1.68
c56 ( 9 0 ) capacitor c=0.00677124f //x=4.375 //y=0.8
c57 ( 5 0 ) capacitor c=0.0181169f //x=4.29 //y=1.765
c58 ( 1 0 ) capacitor c=0.0076549f //x=3.405 //y=1.68
r59 (  17 29 ) resistor r=3.57586 //w=0.17 //l=0.125 //layer=li \
 //thickness=0.1 //x=5.345 //y=0.8 //x2=5.345 //y2=0.675
r60 (  17 29 ) resistor r=18.139 //w=0.187 //l=0.265 //layer=li \
 //thickness=0.1 //x=5.345 //y=0.8 //x2=5.345 //y2=1.065
r61 (  14 29 ) resistor r=3.57586 //w=0.17 //l=0.103078 //layer=li \
 //thickness=0.1 //x=4.46 //y=0.715 //x2=4.375 //y2=0.675
r62 (  14 29 ) resistor r=27.3797 //w=0.187 //l=0.4 //layer=li //thickness=0.1 \
 //x=4.46 //y=0.715 //x2=4.86 //y2=0.715
r63 (  13 29 ) resistor r=3.57586 //w=0.17 //l=0.103078 //layer=li \
 //thickness=0.1 //x=5.26 //y=0.715 //x2=5.345 //y2=0.675
r64 (  13 29 ) resistor r=27.3797 //w=0.187 //l=0.4 //layer=li //thickness=0.1 \
 //x=5.26 //y=0.715 //x2=4.86 //y2=0.715
r65 (  10 29 ) resistor r=3.57586 //w=0.17 //l=0.125 //layer=li \
 //thickness=0.1 //x=4.375 //y=1.68 //x2=4.375 //y2=1.805
r66 (  10 29 ) resistor r=42.0963 //w=0.187 //l=0.615 //layer=li \
 //thickness=0.1 //x=4.375 //y=1.68 //x2=4.375 //y2=1.065
r67 (  9 29 ) resistor r=3.57586 //w=0.17 //l=0.125 //layer=li //thickness=0.1 \
 //x=4.375 //y=0.8 //x2=4.375 //y2=0.675
r68 (  9 29 ) resistor r=18.139 //w=0.187 //l=0.265 //layer=li //thickness=0.1 \
 //x=4.375 //y=0.8 //x2=4.375 //y2=1.065
r69 (  6 29 ) resistor r=3.57586 //w=0.17 //l=0.103078 //layer=li \
 //thickness=0.1 //x=3.49 //y=1.765 //x2=3.405 //y2=1.805
r70 (  6 29 ) resistor r=27.3797 //w=0.187 //l=0.4 //layer=li //thickness=0.1 \
 //x=3.49 //y=1.765 //x2=3.89 //y2=1.765
r71 (  5 29 ) resistor r=3.57586 //w=0.17 //l=0.103078 //layer=li \
 //thickness=0.1 //x=4.29 //y=1.765 //x2=4.375 //y2=1.805
r72 (  5 29 ) resistor r=27.3797 //w=0.187 //l=0.4 //layer=li //thickness=0.1 \
 //x=4.29 //y=1.765 //x2=3.89 //y2=1.765
r73 (  1 29 ) resistor r=3.57586 //w=0.17 //l=0.125 //layer=li //thickness=0.1 \
 //x=3.405 //y=1.68 //x2=3.405 //y2=1.805
r74 (  1 29 ) resistor r=42.0963 //w=0.187 //l=0.615 //layer=li \
 //thickness=0.1 //x=3.405 //y=1.68 //x2=3.405 //y2=1.065
ends PM_XOR2X1\%noxref_9

subckt PM_XOR2X1\%noxref_10 ( 7 8 15 16 23 24 25 )
c43 ( 25 0 ) capacitor c=0.0305804f //x=8.445 //y=5.2
c44 ( 24 0 ) capacitor c=0.0185379f //x=7.565 //y=5.2
c45 ( 23 0 ) capacitor c=0.0384176f //x=6.695 //y=5.2
c46 ( 16 0 ) capacitor c=0.00194711f //x=7.795 //y=7.085
c47 ( 15 0 ) capacitor c=0.0133643f //x=8.505 //y=7.085
c48 ( 8 0 ) capacitor c=0.00631451f //x=6.915 //y=5.385
c49 ( 7 0 ) capacitor c=0.0183784f //x=7.625 //y=5.385
r50 (  17 25 ) resistor r=5.81818 //w=0.187 //l=0.085 //layer=li \
 //thickness=0.1 //x=8.59 //y=7 //x2=8.59 //y2=6.915
r51 (  15 17 ) resistor r=7.15173 //w=0.17 //l=0.120208 //layer=li \
 //thickness=0.1 //x=8.505 //y=7.085 //x2=8.59 //y2=7
r52 (  15 16 ) resistor r=48.5989 //w=0.187 //l=0.71 //layer=li \
 //thickness=0.1 //x=8.505 //y=7.085 //x2=7.795 //y2=7.085
r53 (  10 16 ) resistor r=7.15173 //w=0.17 //l=0.120208 //layer=li \
 //thickness=0.1 //x=7.71 //y=7 //x2=7.795 //y2=7.085
r54 (  10 24 ) resistor r=29.0909 //w=0.187 //l=0.425 //layer=li \
 //thickness=0.1 //x=7.71 //y=7 //x2=7.71 //y2=6.575
r55 (  9 24 ) resistor r=29.0909 //w=0.187 //l=0.425 //layer=li \
 //thickness=0.1 //x=7.71 //y=5.47 //x2=7.71 //y2=5.895
r56 (  7 9 ) resistor r=7.15173 //w=0.17 //l=0.120208 //layer=li \
 //thickness=0.1 //x=7.625 //y=5.385 //x2=7.71 //y2=5.47
r57 (  7 8 ) resistor r=48.5989 //w=0.187 //l=0.71 //layer=li //thickness=0.1 \
 //x=7.625 //y=5.385 //x2=6.915 //y2=5.385
r58 (  1 8 ) resistor r=7.15173 //w=0.17 //l=0.120208 //layer=li \
 //thickness=0.1 //x=6.83 //y=5.47 //x2=6.915 //y2=5.385
r59 (  1 23 ) resistor r=29.0909 //w=0.187 //l=0.425 //layer=li \
 //thickness=0.1 //x=6.83 //y=5.47 //x2=6.83 //y2=5.895
ends PM_XOR2X1\%noxref_10

subckt PM_XOR2X1\%noxref_11 ( 1 5 9 10 13 17 29 )
c53 ( 29 0 ) capacitor c=0.063541f //x=6.6 //y=0.55
c54 ( 17 0 ) capacitor c=0.00723243f //x=8.675 //y=0.8
c55 ( 13 0 ) capacitor c=0.0153645f //x=8.59 //y=0.715
c56 ( 10 0 ) capacitor c=0.00656687f //x=7.705 //y=1.68
c57 ( 9 0 ) capacitor c=0.00677124f //x=7.705 //y=0.8
c58 ( 5 0 ) capacitor c=0.0181169f //x=7.62 //y=1.765
c59 ( 1 0 ) capacitor c=0.0076549f //x=6.735 //y=1.68
r60 (  17 29 ) resistor r=3.57586 //w=0.17 //l=0.125 //layer=li \
 //thickness=0.1 //x=8.675 //y=0.8 //x2=8.675 //y2=0.675
r61 (  17 29 ) resistor r=18.139 //w=0.187 //l=0.265 //layer=li \
 //thickness=0.1 //x=8.675 //y=0.8 //x2=8.675 //y2=1.065
r62 (  14 29 ) resistor r=3.57586 //w=0.17 //l=0.103078 //layer=li \
 //thickness=0.1 //x=7.79 //y=0.715 //x2=7.705 //y2=0.675
r63 (  14 29 ) resistor r=27.3797 //w=0.187 //l=0.4 //layer=li //thickness=0.1 \
 //x=7.79 //y=0.715 //x2=8.19 //y2=0.715
r64 (  13 29 ) resistor r=3.57586 //w=0.17 //l=0.103078 //layer=li \
 //thickness=0.1 //x=8.59 //y=0.715 //x2=8.675 //y2=0.675
r65 (  13 29 ) resistor r=27.3797 //w=0.187 //l=0.4 //layer=li //thickness=0.1 \
 //x=8.59 //y=0.715 //x2=8.19 //y2=0.715
r66 (  10 29 ) resistor r=3.57586 //w=0.17 //l=0.125 //layer=li \
 //thickness=0.1 //x=7.705 //y=1.68 //x2=7.705 //y2=1.805
r67 (  10 29 ) resistor r=42.0963 //w=0.187 //l=0.615 //layer=li \
 //thickness=0.1 //x=7.705 //y=1.68 //x2=7.705 //y2=1.065
r68 (  9 29 ) resistor r=3.57586 //w=0.17 //l=0.125 //layer=li //thickness=0.1 \
 //x=7.705 //y=0.8 //x2=7.705 //y2=0.675
r69 (  9 29 ) resistor r=18.139 //w=0.187 //l=0.265 //layer=li //thickness=0.1 \
 //x=7.705 //y=0.8 //x2=7.705 //y2=1.065
r70 (  6 29 ) resistor r=3.57586 //w=0.17 //l=0.103078 //layer=li \
 //thickness=0.1 //x=6.82 //y=1.765 //x2=6.735 //y2=1.805
r71 (  6 29 ) resistor r=27.3797 //w=0.187 //l=0.4 //layer=li //thickness=0.1 \
 //x=6.82 //y=1.765 //x2=7.22 //y2=1.765
r72 (  5 29 ) resistor r=3.57586 //w=0.17 //l=0.103078 //layer=li \
 //thickness=0.1 //x=7.62 //y=1.765 //x2=7.705 //y2=1.805
r73 (  5 29 ) resistor r=27.3797 //w=0.187 //l=0.4 //layer=li //thickness=0.1 \
 //x=7.62 //y=1.765 //x2=7.22 //y2=1.765
r74 (  1 29 ) resistor r=3.57586 //w=0.17 //l=0.125 //layer=li //thickness=0.1 \
 //x=6.735 //y=1.68 //x2=6.735 //y2=1.805
r75 (  1 29 ) resistor r=42.0963 //w=0.187 //l=0.615 //layer=li \
 //thickness=0.1 //x=6.735 //y=1.68 //x2=6.735 //y2=1.065
ends PM_XOR2X1\%noxref_11
