// File: DLATCH.spi.pex
// Created: Tue Apr 29 10:41:54 2025
// Program "Calibre xRC"
// Version "v2023.2_27.15"
// Nominal Temperature: 30C
// Circuit Temperature: 30C
//
simulator lang=spectre
subckt PM_DLATCH\%GND ( 1 35 47 51 54 65 71 77 82 87 91 94 99 103 111 119 122 \
 127 131 153 157 165 169 177 181 189 193 201 205 217 228 231 243 245 257 277 \
 288 299 300 301 302 303 304 305 )
c278 ( 305 0 ) capacitor c=0.0706784f //x=17.7 //y=0.545
c279 ( 304 0 ) capacitor c=0.0706548f //x=14.37 //y=0.545
c280 ( 303 0 ) capacitor c=0.057872f //x=12.085 //y=0.55
c281 ( 302 0 ) capacitor c=0.0207878f //x=9.25 //y=1.045
c282 ( 301 0 ) capacitor c=0.0572698f //x=6.535 //y=0.55
c283 ( 300 0 ) capacitor c=0.0208124f //x=3.7 //y=1.045
c284 ( 299 0 ) capacitor c=0.058929f //x=0.985 //y=0.55
c285 ( 288 0 ) capacitor c=0.29047f //x=19.775 //y=0.175
c286 ( 277 0 ) capacitor c=0.105466f //x=17.14 //y=0.175
c287 ( 257 0 ) capacitor c=0.103937f //x=13.81 //y=0.175
c288 ( 245 0 ) capacitor c=0.101616f //x=11.59 //y=0.175
c289 ( 244 0 ) capacitor c=0.00446416f //x=9.44 //y=0.175
c290 ( 243 0 ) capacitor c=0.102357f //x=8.26 //y=0.175
c291 ( 231 0 ) capacitor c=0.101096f //x=6.04 //y=0.175
c292 ( 230 0 ) capacitor c=0.00446416f //x=3.82 //y=0.18
c293 ( 228 0 ) capacitor c=0.103408f //x=2.71 //y=0.175
c294 ( 217 0 ) capacitor c=0.211791f //x=1.12 //y=0.175
c295 ( 208 0 ) capacitor c=0.00609805f //x=19.775 //y=0.625
c296 ( 205 0 ) capacitor c=0.00505641f //x=19.69 //y=0.71
c297 ( 204 0 ) capacitor c=0.00468234f //x=19.29 //y=0.625
c298 ( 201 0 ) capacitor c=0.00537084f //x=19.205 //y=0.71
c299 ( 196 0 ) capacitor c=0.00468234f //x=18.805 //y=0.625
c300 ( 193 0 ) capacitor c=0.00537084f //x=18.72 //y=0.71
c301 ( 192 0 ) capacitor c=0.00468234f //x=18.32 //y=0.625
c302 ( 189 0 ) capacitor c=0.00634508f //x=18.235 //y=0.71
c303 ( 184 0 ) capacitor c=0.00609805f //x=17.835 //y=0.625
c304 ( 181 0 ) capacitor c=0.0197476f //x=17.75 //y=0.175
c305 ( 178 0 ) capacitor c=0.0671134f //x=16.53 //y=0.175
c306 ( 177 0 ) capacitor c=0.0197476f //x=16.97 //y=0.175
c307 ( 172 0 ) capacitor c=0.00609805f //x=16.445 //y=0.625
c308 ( 169 0 ) capacitor c=0.00505131f //x=16.36 //y=0.71
c309 ( 168 0 ) capacitor c=0.00468234f //x=15.96 //y=0.625
c310 ( 165 0 ) capacitor c=0.00537002f //x=15.875 //y=0.71
c311 ( 160 0 ) capacitor c=0.00468234f //x=15.475 //y=0.625
c312 ( 157 0 ) capacitor c=0.00556167f //x=15.39 //y=0.71
c313 ( 156 0 ) capacitor c=0.00468234f //x=14.99 //y=0.625
c314 ( 153 0 ) capacitor c=0.00642897f //x=14.905 //y=0.71
c315 ( 148 0 ) capacitor c=0.00609805f //x=14.505 //y=0.625
c316 ( 143 0 ) capacitor c=0.0229116f //x=14.42 //y=0.175
c317 ( 140 0 ) capacitor c=0.036681f //x=13.275 //y=0.175
c318 ( 139 0 ) capacitor c=0.0186173f //x=13.64 //y=0.175
c319 ( 134 0 ) capacitor c=0.00583665f //x=13.19 //y=0.63
c320 ( 131 0 ) capacitor c=0.00536924f //x=13.105 //y=0.715
c321 ( 130 0 ) capacitor c=0.00479856f //x=12.705 //y=0.63
c322 ( 127 0 ) capacitor c=0.00640467f //x=12.62 //y=0.715
c323 ( 122 0 ) capacitor c=0.00588377f //x=12.22 //y=0.63
c324 ( 119 0 ) capacitor c=0.0166308f //x=12.135 //y=0.175
c325 ( 111 0 ) capacitor c=0.0729464f //x=11.42 //y=0.175
c326 ( 103 0 ) capacitor c=0.0392687f //x=9.355 //y=0.175
c327 ( 100 0 ) capacitor c=0.0367f //x=7.725 //y=0.175
c328 ( 99 0 ) capacitor c=0.0161513f //x=8.09 //y=0.175
c329 ( 94 0 ) capacitor c=0.00583665f //x=7.64 //y=0.63
c330 ( 91 0 ) capacitor c=0.00531815f //x=7.555 //y=0.715
c331 ( 90 0 ) capacitor c=0.00479856f //x=7.155 //y=0.63
c332 ( 87 0 ) capacitor c=0.006266f //x=7.07 //y=0.715
c333 ( 82 0 ) capacitor c=0.00588377f //x=6.67 //y=0.63
c334 ( 77 0 ) capacitor c=0.0166308f //x=6.585 //y=0.175
c335 ( 71 0 ) capacitor c=0.0731816f //x=5.87 //y=0.175
c336 ( 65 0 ) capacitor c=0.0430284f //x=3.805 //y=0.175
c337 ( 60 0 ) capacitor c=0.0366606f //x=2.175 //y=0.175
c338 ( 59 0 ) capacitor c=0.0186173f //x=2.54 //y=0.175
c339 ( 54 0 ) capacitor c=0.00583665f //x=2.09 //y=0.63
c340 ( 51 0 ) capacitor c=0.0053944f //x=2.005 //y=0.715
c341 ( 50 0 ) capacitor c=0.00479856f //x=1.605 //y=0.63
c342 ( 47 0 ) capacitor c=0.00707849f //x=1.52 //y=0.715
c343 ( 42 0 ) capacitor c=0.00592191f //x=1.12 //y=0.63
c344 ( 35 0 ) capacitor c=0.71471f //x=19.73 //y=0.18
r345 (  287 288 ) resistor r=1.56948 //w=0.367 //l=0.045 //layer=li \
 //thickness=0.1 //x=19.73 //y=0.175 //x2=19.775 //y2=0.175
r346 (  285 287 ) resistor r=15.346 //w=0.367 //l=0.44 //layer=li \
 //thickness=0.1 //x=19.29 //y=0.175 //x2=19.73 //y2=0.175
r347 (  284 285 ) resistor r=10.4632 //w=0.367 //l=0.3 //layer=li \
 //thickness=0.1 //x=18.99 //y=0.175 //x2=19.29 //y2=0.175
r348 (  282 284 ) resistor r=6.45232 //w=0.367 //l=0.185 //layer=li \
 //thickness=0.1 //x=18.805 //y=0.175 //x2=18.99 //y2=0.175
r349 (  281 282 ) resistor r=16.9155 //w=0.367 //l=0.485 //layer=li \
 //thickness=0.1 //x=18.32 //y=0.175 //x2=18.805 //y2=0.175
r350 (  280 281 ) resistor r=15.346 //w=0.367 //l=0.44 //layer=li \
 //thickness=0.1 //x=17.88 //y=0.175 //x2=18.32 //y2=0.175
r351 (  278 280 ) resistor r=1.56948 //w=0.367 //l=0.045 //layer=li \
 //thickness=0.1 //x=17.835 //y=0.175 //x2=17.88 //y2=0.175
r352 (  265 266 ) resistor r=1.56948 //w=0.367 //l=0.045 //layer=li \
 //thickness=0.1 //x=16.4 //y=0.175 //x2=16.445 //y2=0.175
r353 (  263 265 ) resistor r=15.346 //w=0.367 //l=0.44 //layer=li \
 //thickness=0.1 //x=15.96 //y=0.175 //x2=16.4 //y2=0.175
r354 (  262 263 ) resistor r=16.9155 //w=0.367 //l=0.485 //layer=li \
 //thickness=0.1 //x=15.475 //y=0.175 //x2=15.96 //y2=0.175
r355 (  261 262 ) resistor r=6.45232 //w=0.367 //l=0.185 //layer=li \
 //thickness=0.1 //x=15.29 //y=0.175 //x2=15.475 //y2=0.175
r356 (  259 261 ) resistor r=10.4632 //w=0.367 //l=0.3 //layer=li \
 //thickness=0.1 //x=14.99 //y=0.175 //x2=15.29 //y2=0.175
r357 (  258 259 ) resistor r=16.9155 //w=0.367 //l=0.485 //layer=li \
 //thickness=0.1 //x=14.505 //y=0.175 //x2=14.99 //y2=0.175
r358 (  249 250 ) resistor r=16.9155 //w=0.367 //l=0.485 //layer=li \
 //thickness=0.1 //x=12.705 //y=0.175 //x2=13.19 //y2=0.175
r359 (  248 249 ) resistor r=0.174387 //w=0.367 //l=0.005 //layer=li \
 //thickness=0.1 //x=12.7 //y=0.175 //x2=12.705 //y2=0.175
r360 (  246 248 ) resistor r=16.7411 //w=0.367 //l=0.48 //layer=li \
 //thickness=0.1 //x=12.22 //y=0.175 //x2=12.7 //y2=0.175
r361 (  235 236 ) resistor r=4.18529 //w=0.367 //l=0.12 //layer=li \
 //thickness=0.1 //x=7.52 //y=0.175 //x2=7.64 //y2=0.175
r362 (  233 235 ) resistor r=12.7302 //w=0.367 //l=0.365 //layer=li \
 //thickness=0.1 //x=7.155 //y=0.175 //x2=7.52 //y2=0.175
r363 (  232 233 ) resistor r=16.9155 //w=0.367 //l=0.485 //layer=li \
 //thickness=0.1 //x=6.67 //y=0.175 //x2=7.155 //y2=0.175
r364 (  220 221 ) resistor r=16.9155 //w=0.367 //l=0.485 //layer=li \
 //thickness=0.1 //x=1.605 //y=0.175 //x2=2.09 //y2=0.175
r365 (  219 220 ) resistor r=13.079 //w=0.367 //l=0.375 //layer=li \
 //thickness=0.1 //x=1.23 //y=0.175 //x2=1.605 //y2=0.175
r366 (  217 219 ) resistor r=3.83651 //w=0.367 //l=0.11 //layer=li \
 //thickness=0.1 //x=1.12 //y=0.175 //x2=1.23 //y2=0.175
r367 (  209 305 ) resistor r=5.4201 //w=0.17 //l=0.085 //layer=li \
 //thickness=0.1 //x=19.775 //y=0.795 //x2=19.775 //y2=0.71
r368 (  209 305 ) resistor r=18.139 //w=0.187 //l=0.265 //layer=li \
 //thickness=0.1 //x=19.775 //y=0.795 //x2=19.775 //y2=1.06
r369 (  208 305 ) resistor r=5.4201 //w=0.17 //l=0.085 //layer=li \
 //thickness=0.1 //x=19.775 //y=0.625 //x2=19.775 //y2=0.71
r370 (  207 288 ) resistor r=5.21862 //w=0.35 //l=0.175 //layer=li \
 //thickness=0.1 //x=19.775 //y=0.35 //x2=19.775 //y2=0.175
r371 (  207 208 ) resistor r=18.8235 //w=0.187 //l=0.275 //layer=li \
 //thickness=0.1 //x=19.775 //y=0.35 //x2=19.775 //y2=0.625
r372 (  206 305 ) resistor r=5.4201 //w=0.17 //l=0.085 //layer=li \
 //thickness=0.1 //x=19.375 //y=0.71 //x2=19.29 //y2=0.71
r373 (  205 305 ) resistor r=1.40859 //w=0.34 //l=0.085 //layer=li \
 //thickness=0.1 //x=19.69 //y=0.71 //x2=19.775 //y2=0.71
r374 (  205 206 ) resistor r=21.5615 //w=0.187 //l=0.315 //layer=li \
 //thickness=0.1 //x=19.69 //y=0.71 //x2=19.375 //y2=0.71
r375 (  204 305 ) resistor r=1.40859 //w=0.34 //l=0.085 //layer=li \
 //thickness=0.1 //x=19.29 //y=0.625 //x2=19.29 //y2=0.71
r376 (  203 285 ) resistor r=5.21862 //w=0.35 //l=0.175 //layer=li \
 //thickness=0.1 //x=19.29 //y=0.35 //x2=19.29 //y2=0.175
r377 (  203 204 ) resistor r=18.8235 //w=0.187 //l=0.275 //layer=li \
 //thickness=0.1 //x=19.29 //y=0.35 //x2=19.29 //y2=0.625
r378 (  202 305 ) resistor r=6.4 //w=0.17 //l=0.085 //layer=li //thickness=0.1 \
 //x=18.89 //y=0.71 //x2=18.805 //y2=0.71
r379 (  201 305 ) resistor r=5.4201 //w=0.17 //l=0.085 //layer=li \
 //thickness=0.1 //x=19.205 //y=0.71 //x2=19.29 //y2=0.71
r380 (  201 202 ) resistor r=21.5615 //w=0.187 //l=0.315 //layer=li \
 //thickness=0.1 //x=19.205 //y=0.71 //x2=18.89 //y2=0.71
r381 (  197 305 ) resistor r=6.4 //w=0.17 //l=0.085 //layer=li //thickness=0.1 \
 //x=18.805 //y=0.795 //x2=18.805 //y2=0.71
r382 (  197 305 ) resistor r=18.139 //w=0.187 //l=0.265 //layer=li \
 //thickness=0.1 //x=18.805 //y=0.795 //x2=18.805 //y2=1.06
r383 (  196 305 ) resistor r=6.4 //w=0.17 //l=0.085 //layer=li //thickness=0.1 \
 //x=18.805 //y=0.625 //x2=18.805 //y2=0.71
r384 (  195 282 ) resistor r=5.21862 //w=0.35 //l=0.175 //layer=li \
 //thickness=0.1 //x=18.805 //y=0.35 //x2=18.805 //y2=0.175
r385 (  195 196 ) resistor r=18.8235 //w=0.187 //l=0.275 //layer=li \
 //thickness=0.1 //x=18.805 //y=0.35 //x2=18.805 //y2=0.625
r386 (  194 305 ) resistor r=5.4201 //w=0.17 //l=0.085 //layer=li \
 //thickness=0.1 //x=18.405 //y=0.71 //x2=18.32 //y2=0.71
r387 (  193 305 ) resistor r=6.4 //w=0.17 //l=0.085 //layer=li //thickness=0.1 \
 //x=18.72 //y=0.71 //x2=18.805 //y2=0.71
r388 (  193 194 ) resistor r=21.5615 //w=0.187 //l=0.315 //layer=li \
 //thickness=0.1 //x=18.72 //y=0.71 //x2=18.405 //y2=0.71
r389 (  192 305 ) resistor r=1.40859 //w=0.34 //l=0.085 //layer=li \
 //thickness=0.1 //x=18.32 //y=0.625 //x2=18.32 //y2=0.71
r390 (  191 281 ) resistor r=5.21862 //w=0.35 //l=0.175 //layer=li \
 //thickness=0.1 //x=18.32 //y=0.35 //x2=18.32 //y2=0.175
r391 (  191 192 ) resistor r=18.8235 //w=0.187 //l=0.275 //layer=li \
 //thickness=0.1 //x=18.32 //y=0.35 //x2=18.32 //y2=0.625
r392 (  190 305 ) resistor r=1.40859 //w=0.34 //l=0.085 //layer=li \
 //thickness=0.1 //x=17.92 //y=0.71 //x2=17.835 //y2=0.71
r393 (  189 305 ) resistor r=5.4201 //w=0.17 //l=0.085 //layer=li \
 //thickness=0.1 //x=18.235 //y=0.71 //x2=18.32 //y2=0.71
r394 (  189 190 ) resistor r=21.5615 //w=0.187 //l=0.315 //layer=li \
 //thickness=0.1 //x=18.235 //y=0.71 //x2=17.92 //y2=0.71
r395 (  185 305 ) resistor r=5.4201 //w=0.17 //l=0.085 //layer=li \
 //thickness=0.1 //x=17.835 //y=0.795 //x2=17.835 //y2=0.71
r396 (  185 305 ) resistor r=41.4118 //w=0.187 //l=0.605 //layer=li \
 //thickness=0.1 //x=17.835 //y=0.795 //x2=17.835 //y2=1.4
r397 (  184 305 ) resistor r=5.4201 //w=0.17 //l=0.085 //layer=li \
 //thickness=0.1 //x=17.835 //y=0.625 //x2=17.835 //y2=0.71
r398 (  183 278 ) resistor r=5.21862 //w=0.35 //l=0.175 //layer=li \
 //thickness=0.1 //x=17.835 //y=0.35 //x2=17.835 //y2=0.175
r399 (  183 184 ) resistor r=18.8235 //w=0.187 //l=0.275 //layer=li \
 //thickness=0.1 //x=17.835 //y=0.35 //x2=17.835 //y2=0.625
r400 (  182 277 ) resistor r=5.29055 //w=0.35 //l=0.17 //layer=li \
 //thickness=0.1 //x=17.31 //y=0.175 //x2=17.14 //y2=0.175
r401 (  181 278 ) resistor r=2.96458 //w=0.367 //l=0.085 //layer=li \
 //thickness=0.1 //x=17.75 //y=0.175 //x2=17.835 //y2=0.175
r402 (  181 182 ) resistor r=15.346 //w=0.367 //l=0.44 //layer=li \
 //thickness=0.1 //x=17.75 //y=0.175 //x2=17.31 //y2=0.175
r403 (  178 266 ) resistor r=2.96458 //w=0.367 //l=0.085 //layer=li \
 //thickness=0.1 //x=16.53 //y=0.175 //x2=16.445 //y2=0.175
r404 (  177 277 ) resistor r=5.29055 //w=0.35 //l=0.17 //layer=li \
 //thickness=0.1 //x=16.97 //y=0.175 //x2=17.14 //y2=0.175
r405 (  177 178 ) resistor r=15.346 //w=0.367 //l=0.44 //layer=li \
 //thickness=0.1 //x=16.97 //y=0.175 //x2=16.53 //y2=0.175
r406 (  173 304 ) resistor r=5.4201 //w=0.17 //l=0.085 //layer=li \
 //thickness=0.1 //x=16.445 //y=0.795 //x2=16.445 //y2=0.71
r407 (  173 304 ) resistor r=18.139 //w=0.187 //l=0.265 //layer=li \
 //thickness=0.1 //x=16.445 //y=0.795 //x2=16.445 //y2=1.06
r408 (  172 304 ) resistor r=5.4201 //w=0.17 //l=0.085 //layer=li \
 //thickness=0.1 //x=16.445 //y=0.625 //x2=16.445 //y2=0.71
r409 (  171 266 ) resistor r=5.21862 //w=0.35 //l=0.175 //layer=li \
 //thickness=0.1 //x=16.445 //y=0.35 //x2=16.445 //y2=0.175
r410 (  171 172 ) resistor r=18.8235 //w=0.187 //l=0.275 //layer=li \
 //thickness=0.1 //x=16.445 //y=0.35 //x2=16.445 //y2=0.625
r411 (  170 304 ) resistor r=5.4201 //w=0.17 //l=0.085 //layer=li \
 //thickness=0.1 //x=16.045 //y=0.71 //x2=15.96 //y2=0.71
r412 (  169 304 ) resistor r=1.40859 //w=0.34 //l=0.085 //layer=li \
 //thickness=0.1 //x=16.36 //y=0.71 //x2=16.445 //y2=0.71
r413 (  169 170 ) resistor r=21.5615 //w=0.187 //l=0.315 //layer=li \
 //thickness=0.1 //x=16.36 //y=0.71 //x2=16.045 //y2=0.71
r414 (  168 304 ) resistor r=1.40859 //w=0.34 //l=0.085 //layer=li \
 //thickness=0.1 //x=15.96 //y=0.625 //x2=15.96 //y2=0.71
r415 (  167 263 ) resistor r=5.21862 //w=0.35 //l=0.175 //layer=li \
 //thickness=0.1 //x=15.96 //y=0.35 //x2=15.96 //y2=0.175
r416 (  167 168 ) resistor r=18.8235 //w=0.187 //l=0.275 //layer=li \
 //thickness=0.1 //x=15.96 //y=0.35 //x2=15.96 //y2=0.625
r417 (  166 304 ) resistor r=6.4 //w=0.17 //l=0.085 //layer=li //thickness=0.1 \
 //x=15.56 //y=0.71 //x2=15.475 //y2=0.71
r418 (  165 304 ) resistor r=5.4201 //w=0.17 //l=0.085 //layer=li \
 //thickness=0.1 //x=15.875 //y=0.71 //x2=15.96 //y2=0.71
r419 (  165 166 ) resistor r=21.5615 //w=0.187 //l=0.315 //layer=li \
 //thickness=0.1 //x=15.875 //y=0.71 //x2=15.56 //y2=0.71
r420 (  161 304 ) resistor r=6.4 //w=0.17 //l=0.085 //layer=li //thickness=0.1 \
 //x=15.475 //y=0.795 //x2=15.475 //y2=0.71
r421 (  161 304 ) resistor r=18.139 //w=0.187 //l=0.265 //layer=li \
 //thickness=0.1 //x=15.475 //y=0.795 //x2=15.475 //y2=1.06
r422 (  160 304 ) resistor r=6.4 //w=0.17 //l=0.085 //layer=li //thickness=0.1 \
 //x=15.475 //y=0.625 //x2=15.475 //y2=0.71
r423 (  159 262 ) resistor r=5.21862 //w=0.35 //l=0.175 //layer=li \
 //thickness=0.1 //x=15.475 //y=0.35 //x2=15.475 //y2=0.175
r424 (  159 160 ) resistor r=18.8235 //w=0.187 //l=0.275 //layer=li \
 //thickness=0.1 //x=15.475 //y=0.35 //x2=15.475 //y2=0.625
r425 (  158 304 ) resistor r=5.4201 //w=0.17 //l=0.085 //layer=li \
 //thickness=0.1 //x=15.075 //y=0.71 //x2=14.99 //y2=0.71
r426 (  157 304 ) resistor r=6.4 //w=0.17 //l=0.085 //layer=li //thickness=0.1 \
 //x=15.39 //y=0.71 //x2=15.475 //y2=0.71
r427 (  157 158 ) resistor r=21.5615 //w=0.187 //l=0.315 //layer=li \
 //thickness=0.1 //x=15.39 //y=0.71 //x2=15.075 //y2=0.71
r428 (  156 304 ) resistor r=1.40859 //w=0.34 //l=0.085 //layer=li \
 //thickness=0.1 //x=14.99 //y=0.625 //x2=14.99 //y2=0.71
r429 (  155 259 ) resistor r=5.21862 //w=0.35 //l=0.175 //layer=li \
 //thickness=0.1 //x=14.99 //y=0.35 //x2=14.99 //y2=0.175
r430 (  155 156 ) resistor r=18.8235 //w=0.187 //l=0.275 //layer=li \
 //thickness=0.1 //x=14.99 //y=0.35 //x2=14.99 //y2=0.625
r431 (  154 304 ) resistor r=1.40859 //w=0.34 //l=0.085 //layer=li \
 //thickness=0.1 //x=14.59 //y=0.71 //x2=14.505 //y2=0.71
r432 (  153 304 ) resistor r=5.4201 //w=0.17 //l=0.085 //layer=li \
 //thickness=0.1 //x=14.905 //y=0.71 //x2=14.99 //y2=0.71
r433 (  153 154 ) resistor r=21.5615 //w=0.187 //l=0.315 //layer=li \
 //thickness=0.1 //x=14.905 //y=0.71 //x2=14.59 //y2=0.71
r434 (  149 304 ) resistor r=5.4201 //w=0.17 //l=0.085 //layer=li \
 //thickness=0.1 //x=14.505 //y=0.795 //x2=14.505 //y2=0.71
r435 (  149 304 ) resistor r=41.4118 //w=0.187 //l=0.605 //layer=li \
 //thickness=0.1 //x=14.505 //y=0.795 //x2=14.505 //y2=1.4
r436 (  148 304 ) resistor r=5.4201 //w=0.17 //l=0.085 //layer=li \
 //thickness=0.1 //x=14.505 //y=0.625 //x2=14.505 //y2=0.71
r437 (  147 258 ) resistor r=5.21862 //w=0.35 //l=0.175 //layer=li \
 //thickness=0.1 //x=14.505 //y=0.35 //x2=14.505 //y2=0.175
r438 (  147 148 ) resistor r=18.8235 //w=0.187 //l=0.275 //layer=li \
 //thickness=0.1 //x=14.505 //y=0.35 //x2=14.505 //y2=0.625
r439 (  144 257 ) resistor r=5.29055 //w=0.35 //l=0.17 //layer=li \
 //thickness=0.1 //x=13.98 //y=0.175 //x2=13.81 //y2=0.175
r440 (  144 146 ) resistor r=6.97548 //w=0.367 //l=0.2 //layer=li \
 //thickness=0.1 //x=13.98 //y=0.175 //x2=14.18 //y2=0.175
r441 (  143 258 ) resistor r=2.96458 //w=0.367 //l=0.085 //layer=li \
 //thickness=0.1 //x=14.42 //y=0.175 //x2=14.505 //y2=0.175
r442 (  143 146 ) resistor r=8.37057 //w=0.367 //l=0.24 //layer=li \
 //thickness=0.1 //x=14.42 //y=0.175 //x2=14.18 //y2=0.175
r443 (  140 250 ) resistor r=2.96458 //w=0.367 //l=0.085 //layer=li \
 //thickness=0.1 //x=13.275 //y=0.175 //x2=13.19 //y2=0.175
r444 (  139 257 ) resistor r=5.29055 //w=0.35 //l=0.17 //layer=li \
 //thickness=0.1 //x=13.64 //y=0.175 //x2=13.81 //y2=0.175
r445 (  139 140 ) resistor r=12.7302 //w=0.367 //l=0.365 //layer=li \
 //thickness=0.1 //x=13.64 //y=0.175 //x2=13.275 //y2=0.175
r446 (  135 303 ) resistor r=5.4201 //w=0.17 //l=0.085 //layer=li \
 //thickness=0.1 //x=13.19 //y=0.8 //x2=13.19 //y2=0.715
r447 (  135 303 ) resistor r=41.4118 //w=0.187 //l=0.605 //layer=li \
 //thickness=0.1 //x=13.19 //y=0.8 //x2=13.19 //y2=1.405
r448 (  134 303 ) resistor r=5.4201 //w=0.17 //l=0.085 //layer=li \
 //thickness=0.1 //x=13.19 //y=0.63 //x2=13.19 //y2=0.715
r449 (  133 250 ) resistor r=5.21862 //w=0.35 //l=0.175 //layer=li \
 //thickness=0.1 //x=13.19 //y=0.35 //x2=13.19 //y2=0.175
r450 (  133 134 ) resistor r=19.1658 //w=0.187 //l=0.28 //layer=li \
 //thickness=0.1 //x=13.19 //y=0.35 //x2=13.19 //y2=0.63
r451 (  132 303 ) resistor r=5.4201 //w=0.17 //l=0.085 //layer=li \
 //thickness=0.1 //x=12.79 //y=0.715 //x2=12.705 //y2=0.715
r452 (  131 303 ) resistor r=1.40859 //w=0.34 //l=0.085 //layer=li \
 //thickness=0.1 //x=13.105 //y=0.715 //x2=13.19 //y2=0.715
r453 (  131 132 ) resistor r=21.5615 //w=0.187 //l=0.315 //layer=li \
 //thickness=0.1 //x=13.105 //y=0.715 //x2=12.79 //y2=0.715
r454 (  130 303 ) resistor r=1.40859 //w=0.34 //l=0.085 //layer=li \
 //thickness=0.1 //x=12.705 //y=0.63 //x2=12.705 //y2=0.715
r455 (  129 249 ) resistor r=5.21862 //w=0.35 //l=0.175 //layer=li \
 //thickness=0.1 //x=12.705 //y=0.35 //x2=12.705 //y2=0.175
r456 (  129 130 ) resistor r=19.1658 //w=0.187 //l=0.28 //layer=li \
 //thickness=0.1 //x=12.705 //y=0.35 //x2=12.705 //y2=0.63
r457 (  128 303 ) resistor r=1.40859 //w=0.34 //l=0.085 //layer=li \
 //thickness=0.1 //x=12.305 //y=0.715 //x2=12.22 //y2=0.715
r458 (  127 303 ) resistor r=5.4201 //w=0.17 //l=0.085 //layer=li \
 //thickness=0.1 //x=12.62 //y=0.715 //x2=12.705 //y2=0.715
r459 (  127 128 ) resistor r=21.5615 //w=0.187 //l=0.315 //layer=li \
 //thickness=0.1 //x=12.62 //y=0.715 //x2=12.305 //y2=0.715
r460 (  123 303 ) resistor r=5.4201 //w=0.17 //l=0.085 //layer=li \
 //thickness=0.1 //x=12.22 //y=0.8 //x2=12.22 //y2=0.715
r461 (  123 303 ) resistor r=41.4118 //w=0.187 //l=0.605 //layer=li \
 //thickness=0.1 //x=12.22 //y=0.8 //x2=12.22 //y2=1.405
r462 (  122 303 ) resistor r=5.4201 //w=0.17 //l=0.085 //layer=li \
 //thickness=0.1 //x=12.22 //y=0.63 //x2=12.22 //y2=0.715
r463 (  121 246 ) resistor r=5.21862 //w=0.35 //l=0.175 //layer=li \
 //thickness=0.1 //x=12.22 //y=0.35 //x2=12.22 //y2=0.175
r464 (  121 122 ) resistor r=19.1658 //w=0.187 //l=0.28 //layer=li \
 //thickness=0.1 //x=12.22 //y=0.35 //x2=12.22 //y2=0.63
r465 (  120 245 ) resistor r=5.29055 //w=0.35 //l=0.17 //layer=li \
 //thickness=0.1 //x=11.76 //y=0.175 //x2=11.59 //y2=0.175
r466 (  119 246 ) resistor r=2.96458 //w=0.367 //l=0.085 //layer=li \
 //thickness=0.1 //x=12.135 //y=0.175 //x2=12.22 //y2=0.175
r467 (  119 120 ) resistor r=13.079 //w=0.367 //l=0.375 //layer=li \
 //thickness=0.1 //x=12.135 //y=0.175 //x2=11.76 //y2=0.175
r468 (  114 116 ) resistor r=38.7139 //w=0.367 //l=1.11 //layer=li \
 //thickness=0.1 //x=10.11 //y=0.175 //x2=11.22 //y2=0.175
r469 (  112 244 ) resistor r=2.87058 //w=0.35 //l=0.085 //layer=li \
 //thickness=0.1 //x=9.525 //y=0.175 //x2=9.44 //y2=0.175
r470 (  112 114 ) resistor r=20.4033 //w=0.367 //l=0.585 //layer=li \
 //thickness=0.1 //x=9.525 //y=0.175 //x2=10.11 //y2=0.175
r471 (  111 245 ) resistor r=5.29055 //w=0.35 //l=0.17 //layer=li \
 //thickness=0.1 //x=11.42 //y=0.175 //x2=11.59 //y2=0.175
r472 (  111 116 ) resistor r=6.97548 //w=0.367 //l=0.2 //layer=li \
 //thickness=0.1 //x=11.42 //y=0.175 //x2=11.22 //y2=0.175
r473 (  107 244 ) resistor r=4.23183 //w=0.7 //l=0.175 //layer=li \
 //thickness=0.1 //x=9.44 //y=0.35 //x2=9.44 //y2=0.175
r474 (  107 302 ) resistor r=53.7326 //w=0.187 //l=0.785 //layer=li \
 //thickness=0.1 //x=9.44 //y=0.35 //x2=9.44 //y2=1.135
r475 (  104 243 ) resistor r=5.29055 //w=0.35 //l=0.17 //layer=li \
 //thickness=0.1 //x=8.43 //y=0.175 //x2=8.26 //y2=0.175
r476 (  104 106 ) resistor r=19.8801 //w=0.367 //l=0.57 //layer=li \
 //thickness=0.1 //x=8.43 //y=0.175 //x2=9 //y2=0.175
r477 (  103 244 ) resistor r=2.87058 //w=0.35 //l=0.085 //layer=li \
 //thickness=0.1 //x=9.355 //y=0.175 //x2=9.44 //y2=0.175
r478 (  103 106 ) resistor r=12.3815 //w=0.367 //l=0.355 //layer=li \
 //thickness=0.1 //x=9.355 //y=0.175 //x2=9 //y2=0.175
r479 (  100 236 ) resistor r=2.96458 //w=0.367 //l=0.085 //layer=li \
 //thickness=0.1 //x=7.725 //y=0.175 //x2=7.64 //y2=0.175
r480 (  99 243 ) resistor r=5.29055 //w=0.35 //l=0.17 //layer=li \
 //thickness=0.1 //x=8.09 //y=0.175 //x2=8.26 //y2=0.175
r481 (  99 100 ) resistor r=12.7302 //w=0.367 //l=0.365 //layer=li \
 //thickness=0.1 //x=8.09 //y=0.175 //x2=7.725 //y2=0.175
r482 (  95 301 ) resistor r=5.4201 //w=0.17 //l=0.085 //layer=li \
 //thickness=0.1 //x=7.64 //y=0.8 //x2=7.64 //y2=0.715
r483 (  95 301 ) resistor r=41.4118 //w=0.187 //l=0.605 //layer=li \
 //thickness=0.1 //x=7.64 //y=0.8 //x2=7.64 //y2=1.405
r484 (  94 301 ) resistor r=5.4201 //w=0.17 //l=0.085 //layer=li \
 //thickness=0.1 //x=7.64 //y=0.63 //x2=7.64 //y2=0.715
r485 (  93 236 ) resistor r=5.21862 //w=0.35 //l=0.175 //layer=li \
 //thickness=0.1 //x=7.64 //y=0.35 //x2=7.64 //y2=0.175
r486 (  93 94 ) resistor r=19.1658 //w=0.187 //l=0.28 //layer=li \
 //thickness=0.1 //x=7.64 //y=0.35 //x2=7.64 //y2=0.63
r487 (  92 301 ) resistor r=5.4201 //w=0.17 //l=0.085 //layer=li \
 //thickness=0.1 //x=7.24 //y=0.715 //x2=7.155 //y2=0.715
r488 (  91 301 ) resistor r=1.40859 //w=0.34 //l=0.085 //layer=li \
 //thickness=0.1 //x=7.555 //y=0.715 //x2=7.64 //y2=0.715
r489 (  91 92 ) resistor r=21.5615 //w=0.187 //l=0.315 //layer=li \
 //thickness=0.1 //x=7.555 //y=0.715 //x2=7.24 //y2=0.715
r490 (  90 301 ) resistor r=1.40859 //w=0.34 //l=0.085 //layer=li \
 //thickness=0.1 //x=7.155 //y=0.63 //x2=7.155 //y2=0.715
r491 (  89 233 ) resistor r=5.21862 //w=0.35 //l=0.175 //layer=li \
 //thickness=0.1 //x=7.155 //y=0.35 //x2=7.155 //y2=0.175
r492 (  89 90 ) resistor r=19.1658 //w=0.187 //l=0.28 //layer=li \
 //thickness=0.1 //x=7.155 //y=0.35 //x2=7.155 //y2=0.63
r493 (  88 301 ) resistor r=1.40859 //w=0.34 //l=0.085 //layer=li \
 //thickness=0.1 //x=6.755 //y=0.715 //x2=6.67 //y2=0.715
r494 (  87 301 ) resistor r=5.4201 //w=0.17 //l=0.085 //layer=li \
 //thickness=0.1 //x=7.07 //y=0.715 //x2=7.155 //y2=0.715
r495 (  87 88 ) resistor r=21.5615 //w=0.187 //l=0.315 //layer=li \
 //thickness=0.1 //x=7.07 //y=0.715 //x2=6.755 //y2=0.715
r496 (  83 301 ) resistor r=5.4201 //w=0.17 //l=0.085 //layer=li \
 //thickness=0.1 //x=6.67 //y=0.8 //x2=6.67 //y2=0.715
r497 (  83 301 ) resistor r=41.4118 //w=0.187 //l=0.605 //layer=li \
 //thickness=0.1 //x=6.67 //y=0.8 //x2=6.67 //y2=1.405
r498 (  82 301 ) resistor r=5.4201 //w=0.17 //l=0.085 //layer=li \
 //thickness=0.1 //x=6.67 //y=0.63 //x2=6.67 //y2=0.715
r499 (  81 232 ) resistor r=5.21862 //w=0.35 //l=0.175 //layer=li \
 //thickness=0.1 //x=6.67 //y=0.35 //x2=6.67 //y2=0.175
r500 (  81 82 ) resistor r=19.1658 //w=0.187 //l=0.28 //layer=li \
 //thickness=0.1 //x=6.67 //y=0.35 //x2=6.67 //y2=0.63
r501 (  78 231 ) resistor r=5.29055 //w=0.35 //l=0.17 //layer=li \
 //thickness=0.1 //x=6.21 //y=0.175 //x2=6.04 //y2=0.175
r502 (  78 80 ) resistor r=6.97548 //w=0.367 //l=0.2 //layer=li \
 //thickness=0.1 //x=6.21 //y=0.175 //x2=6.41 //y2=0.175
r503 (  77 232 ) resistor r=2.96458 //w=0.367 //l=0.085 //layer=li \
 //thickness=0.1 //x=6.585 //y=0.175 //x2=6.67 //y2=0.175
r504 (  77 80 ) resistor r=6.10354 //w=0.367 //l=0.175 //layer=li \
 //thickness=0.1 //x=6.585 //y=0.175 //x2=6.41 //y2=0.175
r505 (  72 230 ) resistor r=2.87058 //w=0.35 //l=0.085 //layer=li \
 //thickness=0.1 //x=3.975 //y=0.175 //x2=3.89 //y2=0.175
r506 (  72 74 ) resistor r=33.3079 //w=0.367 //l=0.955 //layer=li \
 //thickness=0.1 //x=3.975 //y=0.175 //x2=4.93 //y2=0.175
r507 (  71 231 ) resistor r=5.29055 //w=0.35 //l=0.17 //layer=li \
 //thickness=0.1 //x=5.87 //y=0.175 //x2=6.04 //y2=0.175
r508 (  71 74 ) resistor r=32.7847 //w=0.367 //l=0.94 //layer=li \
 //thickness=0.1 //x=5.87 //y=0.175 //x2=4.93 //y2=0.175
r509 (  67 230 ) resistor r=4.23183 //w=0.7 //l=0.175 //layer=li \
 //thickness=0.1 //x=3.89 //y=0.35 //x2=3.89 //y2=0.175
r510 (  67 300 ) resistor r=53.7326 //w=0.187 //l=0.785 //layer=li \
 //thickness=0.1 //x=3.89 //y=0.35 //x2=3.89 //y2=1.135
r511 (  66 228 ) resistor r=5.29055 //w=0.35 //l=0.17 //layer=li \
 //thickness=0.1 //x=2.88 //y=0.175 //x2=2.71 //y2=0.175
r512 (  65 230 ) resistor r=2.87058 //w=0.35 //l=0.085 //layer=li \
 //thickness=0.1 //x=3.805 //y=0.175 //x2=3.89 //y2=0.175
r513 (  65 66 ) resistor r=32.2616 //w=0.367 //l=0.925 //layer=li \
 //thickness=0.1 //x=3.805 //y=0.175 //x2=2.88 //y2=0.175
r514 (  60 221 ) resistor r=2.96458 //w=0.367 //l=0.085 //layer=li \
 //thickness=0.1 //x=2.175 //y=0.175 //x2=2.09 //y2=0.175
r515 (  60 62 ) resistor r=5.75477 //w=0.367 //l=0.165 //layer=li \
 //thickness=0.1 //x=2.175 //y=0.175 //x2=2.34 //y2=0.175
r516 (  59 228 ) resistor r=5.29055 //w=0.35 //l=0.17 //layer=li \
 //thickness=0.1 //x=2.54 //y=0.175 //x2=2.71 //y2=0.175
r517 (  59 62 ) resistor r=6.97548 //w=0.367 //l=0.2 //layer=li \
 //thickness=0.1 //x=2.54 //y=0.175 //x2=2.34 //y2=0.175
r518 (  55 299 ) resistor r=5.4201 //w=0.17 //l=0.085 //layer=li \
 //thickness=0.1 //x=2.09 //y=0.8 //x2=2.09 //y2=0.715
r519 (  55 299 ) resistor r=41.4118 //w=0.187 //l=0.605 //layer=li \
 //thickness=0.1 //x=2.09 //y=0.8 //x2=2.09 //y2=1.405
r520 (  54 299 ) resistor r=5.4201 //w=0.17 //l=0.085 //layer=li \
 //thickness=0.1 //x=2.09 //y=0.63 //x2=2.09 //y2=0.715
r521 (  53 221 ) resistor r=5.21862 //w=0.35 //l=0.175 //layer=li \
 //thickness=0.1 //x=2.09 //y=0.35 //x2=2.09 //y2=0.175
r522 (  53 54 ) resistor r=19.1658 //w=0.187 //l=0.28 //layer=li \
 //thickness=0.1 //x=2.09 //y=0.35 //x2=2.09 //y2=0.63
r523 (  52 299 ) resistor r=5.4201 //w=0.17 //l=0.085 //layer=li \
 //thickness=0.1 //x=1.69 //y=0.715 //x2=1.605 //y2=0.715
r524 (  51 299 ) resistor r=1.40859 //w=0.34 //l=0.085 //layer=li \
 //thickness=0.1 //x=2.005 //y=0.715 //x2=2.09 //y2=0.715
r525 (  51 52 ) resistor r=21.5615 //w=0.187 //l=0.315 //layer=li \
 //thickness=0.1 //x=2.005 //y=0.715 //x2=1.69 //y2=0.715
r526 (  50 299 ) resistor r=1.40859 //w=0.34 //l=0.085 //layer=li \
 //thickness=0.1 //x=1.605 //y=0.63 //x2=1.605 //y2=0.715
r527 (  49 220 ) resistor r=5.21862 //w=0.35 //l=0.175 //layer=li \
 //thickness=0.1 //x=1.605 //y=0.35 //x2=1.605 //y2=0.175
r528 (  49 50 ) resistor r=19.1658 //w=0.187 //l=0.28 //layer=li \
 //thickness=0.1 //x=1.605 //y=0.35 //x2=1.605 //y2=0.63
r529 (  48 299 ) resistor r=1.40859 //w=0.34 //l=0.085 //layer=li \
 //thickness=0.1 //x=1.205 //y=0.715 //x2=1.12 //y2=0.715
r530 (  47 299 ) resistor r=5.4201 //w=0.17 //l=0.085 //layer=li \
 //thickness=0.1 //x=1.52 //y=0.715 //x2=1.605 //y2=0.715
r531 (  47 48 ) resistor r=21.5615 //w=0.187 //l=0.315 //layer=li \
 //thickness=0.1 //x=1.52 //y=0.715 //x2=1.205 //y2=0.715
r532 (  43 299 ) resistor r=5.4201 //w=0.17 //l=0.085 //layer=li \
 //thickness=0.1 //x=1.12 //y=0.8 //x2=1.12 //y2=0.715
r533 (  43 299 ) resistor r=41.4118 //w=0.187 //l=0.605 //layer=li \
 //thickness=0.1 //x=1.12 //y=0.8 //x2=1.12 //y2=1.405
r534 (  42 299 ) resistor r=5.4201 //w=0.17 //l=0.085 //layer=li \
 //thickness=0.1 //x=1.12 //y=0.63 //x2=1.12 //y2=0.715
r535 (  41 217 ) resistor r=5.21862 //w=0.35 //l=0.175 //layer=li \
 //thickness=0.1 //x=1.12 //y=0.35 //x2=1.12 //y2=0.175
r536 (  41 42 ) resistor r=19.1658 //w=0.187 //l=0.28 //layer=li \
 //thickness=0.1 //x=1.12 //y=0.35 //x2=1.12 //y2=0.63
r537 (  35 287 ) resistor r=4.65 //w=0.17 //l=0.34 //layer=mcon //count=2 \
 //x=19.73 //y=0.18 //x2=19.73 //y2=0.18
r538 (  33 284 ) resistor r=3.1 //w=0.17 //l=0.51 //layer=mcon //count=3 \
 //x=18.99 //y=0.18 //x2=18.99 //y2=0.18
r539 (  33 35 ) resistor r=0.297428 //w=0.311 //l=0.74 //layer=m1 \
 //thickness=0.36 //x=18.99 //y=0.175 //x2=19.73 //y2=0.175
r540 (  31 280 ) resistor r=3.1 //w=0.17 //l=0.51 //layer=mcon //count=3 \
 //x=17.88 //y=0.18 //x2=17.88 //y2=0.18
r541 (  31 33 ) resistor r=0.446141 //w=0.311 //l=1.11 //layer=m1 \
 //thickness=0.36 //x=17.88 //y=0.175 //x2=18.99 //y2=0.175
r542 (  29 265 ) resistor r=3.1 //w=0.17 //l=0.51 //layer=mcon //count=3 \
 //x=16.4 //y=0.18 //x2=16.4 //y2=0.18
r543 (  29 31 ) resistor r=0.594855 //w=0.311 //l=1.48 //layer=m1 \
 //thickness=0.36 //x=16.4 //y=0.175 //x2=17.88 //y2=0.175
r544 (  27 261 ) resistor r=3.1 //w=0.17 //l=0.51 //layer=mcon //count=3 \
 //x=15.29 //y=0.18 //x2=15.29 //y2=0.18
r545 (  27 29 ) resistor r=0.446141 //w=0.311 //l=1.11 //layer=m1 \
 //thickness=0.36 //x=15.29 //y=0.175 //x2=16.4 //y2=0.175
r546 (  25 146 ) resistor r=3.1 //w=0.17 //l=0.51 //layer=mcon //count=3 \
 //x=14.18 //y=0.18 //x2=14.18 //y2=0.18
r547 (  25 27 ) resistor r=0.446141 //w=0.311 //l=1.11 //layer=m1 \
 //thickness=0.36 //x=14.18 //y=0.175 //x2=15.29 //y2=0.175
r548 (  23 248 ) resistor r=3.1 //w=0.17 //l=0.51 //layer=mcon //count=3 \
 //x=12.7 //y=0.18 //x2=12.7 //y2=0.18
r549 (  23 25 ) resistor r=0.594855 //w=0.311 //l=1.48 //layer=m1 \
 //thickness=0.36 //x=12.7 //y=0.175 //x2=14.18 //y2=0.175
r550 (  21 116 ) resistor r=3.1 //w=0.17 //l=0.51 //layer=mcon //count=3 \
 //x=11.22 //y=0.18 //x2=11.22 //y2=0.18
r551 (  21 23 ) resistor r=0.594855 //w=0.311 //l=1.48 //layer=m1 \
 //thickness=0.36 //x=11.22 //y=0.175 //x2=12.7 //y2=0.175
r552 (  18 114 ) resistor r=3.1 //w=0.17 //l=0.51 //layer=mcon //count=3 \
 //x=10.11 //y=0.18 //x2=10.11 //y2=0.18
r553 (  16 106 ) resistor r=3.1 //w=0.17 //l=0.51 //layer=mcon //count=3 //x=9 \
 //y=0.18 //x2=9 //y2=0.18
r554 (  16 18 ) resistor r=0.446141 //w=0.311 //l=1.11 //layer=m1 \
 //thickness=0.36 //x=9 //y=0.175 //x2=10.11 //y2=0.175
r555 (  14 235 ) resistor r=3.1 //w=0.17 //l=0.51 //layer=mcon //count=3 \
 //x=7.52 //y=0.18 //x2=7.52 //y2=0.18
r556 (  14 16 ) resistor r=0.594855 //w=0.311 //l=1.48 //layer=m1 \
 //thickness=0.36 //x=7.52 //y=0.175 //x2=9 //y2=0.175
r557 (  12 80 ) resistor r=3.1 //w=0.17 //l=0.51 //layer=mcon //count=3 \
 //x=6.41 //y=0.18 //x2=6.41 //y2=0.18
r558 (  12 14 ) resistor r=0.446141 //w=0.311 //l=1.11 //layer=m1 \
 //thickness=0.36 //x=6.41 //y=0.175 //x2=7.52 //y2=0.175
r559 (  10 74 ) resistor r=3.1 //w=0.17 //l=0.51 //layer=mcon //count=3 \
 //x=4.93 //y=0.18 //x2=4.93 //y2=0.18
r560 (  10 12 ) resistor r=0.594855 //w=0.311 //l=1.48 //layer=m1 \
 //thickness=0.36 //x=4.93 //y=0.175 //x2=6.41 //y2=0.175
r561 (  8 230 ) resistor r=3.1 //w=0.17 //l=0.51 //layer=mcon //count=3 \
 //x=3.82 //y=0.18 //x2=3.82 //y2=0.18
r562 (  8 10 ) resistor r=0.446141 //w=0.311 //l=1.11 //layer=m1 \
 //thickness=0.36 //x=3.82 //y=0.175 //x2=4.93 //y2=0.175
r563 (  6 62 ) resistor r=3.1 //w=0.17 //l=0.51 //layer=mcon //count=3 \
 //x=2.34 //y=0.18 //x2=2.34 //y2=0.18
r564 (  6 8 ) resistor r=0.594855 //w=0.311 //l=1.48 //layer=m1 \
 //thickness=0.36 //x=2.34 //y=0.175 //x2=3.82 //y2=0.175
r565 (  3 219 ) resistor r=3.1 //w=0.17 //l=0.51 //layer=mcon //count=3 \
 //x=1.23 //y=0.18 //x2=1.23 //y2=0.18
r566 (  3 6 ) resistor r=0.446141 //w=0.311 //l=1.11 //layer=m1 \
 //thickness=0.36 //x=1.23 //y=0.175 //x2=2.34 //y2=0.175
r567 (  1 21 ) resistor r=0.297428 //w=0.311 //l=0.74 //layer=m1 \
 //thickness=0.36 //x=10.48 //y=0.175 //x2=11.22 //y2=0.175
r568 (  1 18 ) resistor r=0.148714 //w=0.311 //l=0.37 //layer=m1 \
 //thickness=0.36 //x=10.48 //y=0.175 //x2=10.11 //y2=0.175
ends PM_DLATCH\%GND

subckt PM_DLATCH\%VDD ( 1 35 47 55 61 69 79 89 93 103 111 115 123 131 155 165 \
 169 179 187 202 206 208 212 216 221 224 226 228 229 230 231 232 233 234 235 \
 236 237 238 239 240 241 )
c267 ( 241 0 ) capacitor c=0.0255389f //x=18.225 //y=5.205
c268 ( 240 0 ) capacitor c=0.025574f //x=14.895 //y=5.205
c269 ( 239 0 ) capacitor c=0.0433931f //x=13 //y=5.2
c270 ( 238 0 ) capacitor c=0.0422979f //x=12.13 //y=5.2
c271 ( 237 0 ) capacitor c=0.0382118f //x=10.665 //y=5.2
c272 ( 236 0 ) capacitor c=0.0240874f //x=9.785 //y=5.2
c273 ( 235 0 ) capacitor c=0.0494572f //x=8.915 //y=5.2
c274 ( 234 0 ) capacitor c=0.0432965f //x=7.45 //y=5.2
c275 ( 233 0 ) capacitor c=0.0422219f //x=6.58 //y=5.2
c276 ( 232 0 ) capacitor c=0.0381506f //x=5.115 //y=5.2
c277 ( 231 0 ) capacitor c=0.0240879f //x=4.235 //y=5.2
c278 ( 230 0 ) capacitor c=0.0494572f //x=3.365 //y=5.2
c279 ( 229 0 ) capacitor c=0.0432965f //x=1.9 //y=5.2
c280 ( 228 0 ) capacitor c=0.0421444f //x=1.03 //y=5.2
c281 ( 227 0 ) capacitor c=0.00597439f //x=18.37 //y=7.585
c282 ( 226 0 ) capacitor c=0.111498f //x=17.14 //y=7.585
c283 ( 225 0 ) capacitor c=0.00597439f //x=15.04 //y=7.585
c284 ( 224 0 ) capacitor c=0.110007f //x=13.81 //y=7.585
c285 ( 223 0 ) capacitor c=0.00597439f //x=13.145 //y=7.585
c286 ( 222 0 ) capacitor c=0.00597439f //x=12.265 //y=7.585
c287 ( 221 0 ) capacitor c=0.110046f //x=11.59 //y=7.585
c288 ( 220 0 ) capacitor c=0.00597439f //x=10.81 //y=7.585
c289 ( 219 0 ) capacitor c=0.00597439f //x=9.93 //y=7.585
c290 ( 218 0 ) capacitor c=0.00597439f //x=9 //y=7.58
c291 ( 216 0 ) capacitor c=0.114352f //x=8.26 //y=7.585
c292 ( 215 0 ) capacitor c=0.00597439f //x=7.52 //y=7.58
c293 ( 213 0 ) capacitor c=0.00597439f //x=6.715 //y=7.585
c294 ( 212 0 ) capacitor c=0.108466f //x=6.04 //y=7.585
c295 ( 211 0 ) capacitor c=0.00597439f //x=5.26 //y=7.585
c296 ( 210 0 ) capacitor c=0.00597439f //x=4.38 //y=7.585
c297 ( 209 0 ) capacitor c=0.00597439f //x=3.5 //y=7.585
c298 ( 208 0 ) capacitor c=0.11435f //x=2.71 //y=7.585
c299 ( 207 0 ) capacitor c=0.00597439f //x=2.045 //y=7.585
c300 ( 206 0 ) capacitor c=0.25188f //x=1.23 //y=7.58
c301 ( 202 0 ) capacitor c=0.306601f //x=19.73 //y=7.58
c302 ( 187 0 ) capacitor c=0.0431573f //x=18.285 //y=7.585
c303 ( 179 0 ) capacitor c=0.0754212f //x=16.97 //y=7.585
c304 ( 169 0 ) capacitor c=0.0431573f //x=14.955 //y=7.585
c305 ( 165 0 ) capacitor c=0.0183091f //x=13.64 //y=7.585
c306 ( 155 0 ) capacitor c=0.0291131f //x=13.06 //y=7.585
c307 ( 147 0 ) capacitor c=0.0217664f //x=12.18 //y=7.585
c308 ( 141 0 ) capacitor c=0.0277785f //x=11.42 //y=7.585
c309 ( 131 0 ) capacitor c=0.028702f //x=10.725 //y=7.585
c310 ( 123 0 ) capacitor c=0.0291291f //x=9.845 //y=7.585
c311 ( 115 0 ) capacitor c=0.024303f //x=8.965 //y=7.585
c312 ( 111 0 ) capacitor c=0.0183091f //x=8.09 //y=7.585
c313 ( 103 0 ) capacitor c=0.0292288f //x=7.51 //y=7.585
c314 ( 93 0 ) capacitor c=0.0187886f //x=6.63 //y=7.585
c315 ( 89 0 ) capacitor c=0.0238235f //x=5.87 //y=7.585
c316 ( 79 0 ) capacitor c=0.0291288f //x=5.175 //y=7.585
c317 ( 69 0 ) capacitor c=0.0291291f //x=4.295 //y=7.585
c318 ( 61 0 ) capacitor c=0.024303f //x=3.415 //y=7.585
c319 ( 55 0 ) capacitor c=0.0183091f //x=2.54 //y=7.585
c320 ( 47 0 ) capacitor c=0.0293728f //x=1.96 //y=7.585
c321 ( 35 0 ) capacitor c=0.728316f //x=19.73 //y=7.58
r322 (  200 202 ) resistor r=25.8093 //w=0.367 //l=0.74 //layer=li \
 //thickness=0.1 //x=18.99 //y=7.585 //x2=19.73 //y2=7.585
r323 (  198 227 ) resistor r=2.87058 //w=0.35 //l=0.085 //layer=li \
 //thickness=0.1 //x=18.455 //y=7.585 //x2=18.37 //y2=7.585
r324 (  198 200 ) resistor r=18.6594 //w=0.367 //l=0.535 //layer=li \
 //thickness=0.1 //x=18.455 //y=7.585 //x2=18.99 //y2=7.585
r325 (  191 227 ) resistor r=4.23183 //w=0.7 //l=0.175 //layer=li \
 //thickness=0.1 //x=18.37 //y=7.41 //x2=18.37 //y2=7.585
r326 (  191 241 ) resistor r=33.5401 //w=0.187 //l=0.49 //layer=li \
 //thickness=0.1 //x=18.37 //y=7.41 //x2=18.37 //y2=6.92
r327 (  188 226 ) resistor r=5.29055 //w=0.35 //l=0.17 //layer=li \
 //thickness=0.1 //x=17.31 //y=7.585 //x2=17.14 //y2=7.585
r328 (  188 190 ) resistor r=19.8801 //w=0.367 //l=0.57 //layer=li \
 //thickness=0.1 //x=17.31 //y=7.585 //x2=17.88 //y2=7.585
r329 (  187 227 ) resistor r=2.87058 //w=0.35 //l=0.085 //layer=li \
 //thickness=0.1 //x=18.285 //y=7.585 //x2=18.37 //y2=7.585
r330 (  187 190 ) resistor r=14.1253 //w=0.367 //l=0.405 //layer=li \
 //thickness=0.1 //x=18.285 //y=7.585 //x2=17.88 //y2=7.585
r331 (  182 184 ) resistor r=38.7139 //w=0.367 //l=1.11 //layer=li \
 //thickness=0.1 //x=15.29 //y=7.585 //x2=16.4 //y2=7.585
r332 (  180 225 ) resistor r=2.87058 //w=0.35 //l=0.085 //layer=li \
 //thickness=0.1 //x=15.125 //y=7.585 //x2=15.04 //y2=7.585
r333 (  180 182 ) resistor r=5.75477 //w=0.367 //l=0.165 //layer=li \
 //thickness=0.1 //x=15.125 //y=7.585 //x2=15.29 //y2=7.585
r334 (  179 226 ) resistor r=5.29055 //w=0.35 //l=0.17 //layer=li \
 //thickness=0.1 //x=16.97 //y=7.585 //x2=17.14 //y2=7.585
r335 (  179 184 ) resistor r=19.8801 //w=0.367 //l=0.57 //layer=li \
 //thickness=0.1 //x=16.97 //y=7.585 //x2=16.4 //y2=7.585
r336 (  173 225 ) resistor r=4.23183 //w=0.7 //l=0.175 //layer=li \
 //thickness=0.1 //x=15.04 //y=7.41 //x2=15.04 //y2=7.585
r337 (  173 240 ) resistor r=33.5401 //w=0.187 //l=0.49 //layer=li \
 //thickness=0.1 //x=15.04 //y=7.41 //x2=15.04 //y2=6.92
r338 (  170 224 ) resistor r=5.29055 //w=0.35 //l=0.17 //layer=li \
 //thickness=0.1 //x=13.98 //y=7.585 //x2=13.81 //y2=7.585
r339 (  170 172 ) resistor r=6.97548 //w=0.367 //l=0.2 //layer=li \
 //thickness=0.1 //x=13.98 //y=7.585 //x2=14.18 //y2=7.585
r340 (  169 225 ) resistor r=2.87058 //w=0.35 //l=0.085 //layer=li \
 //thickness=0.1 //x=14.955 //y=7.585 //x2=15.04 //y2=7.585
r341 (  169 172 ) resistor r=27.03 //w=0.367 //l=0.775 //layer=li \
 //thickness=0.1 //x=14.955 //y=7.585 //x2=14.18 //y2=7.585
r342 (  166 223 ) resistor r=2.87058 //w=0.35 //l=0.085 //layer=li \
 //thickness=0.1 //x=13.23 //y=7.585 //x2=13.145 //y2=7.585
r343 (  165 224 ) resistor r=5.29055 //w=0.35 //l=0.17 //layer=li \
 //thickness=0.1 //x=13.64 //y=7.585 //x2=13.81 //y2=7.585
r344 (  165 166 ) resistor r=14.2997 //w=0.367 //l=0.41 //layer=li \
 //thickness=0.1 //x=13.64 //y=7.585 //x2=13.23 //y2=7.585
r345 (  159 223 ) resistor r=4.23183 //w=0.7 //l=0.175 //layer=li \
 //thickness=0.1 //x=13.145 //y=7.41 //x2=13.145 //y2=7.585
r346 (  159 239 ) resistor r=56.4706 //w=0.187 //l=0.825 //layer=li \
 //thickness=0.1 //x=13.145 //y=7.41 //x2=13.145 //y2=6.585
r347 (  156 222 ) resistor r=2.87058 //w=0.35 //l=0.085 //layer=li \
 //thickness=0.1 //x=12.35 //y=7.585 //x2=12.265 //y2=7.585
r348 (  156 158 ) resistor r=12.2071 //w=0.367 //l=0.35 //layer=li \
 //thickness=0.1 //x=12.35 //y=7.585 //x2=12.7 //y2=7.585
r349 (  155 223 ) resistor r=2.87058 //w=0.35 //l=0.085 //layer=li \
 //thickness=0.1 //x=13.06 //y=7.585 //x2=13.145 //y2=7.585
r350 (  155 158 ) resistor r=12.5559 //w=0.367 //l=0.36 //layer=li \
 //thickness=0.1 //x=13.06 //y=7.585 //x2=12.7 //y2=7.585
r351 (  149 222 ) resistor r=4.23183 //w=0.7 //l=0.175 //layer=li \
 //thickness=0.1 //x=12.265 //y=7.41 //x2=12.265 //y2=7.585
r352 (  149 238 ) resistor r=56.4706 //w=0.187 //l=0.825 //layer=li \
 //thickness=0.1 //x=12.265 //y=7.41 //x2=12.265 //y2=6.585
r353 (  148 221 ) resistor r=5.29055 //w=0.35 //l=0.17 //layer=li \
 //thickness=0.1 //x=11.76 //y=7.585 //x2=11.59 //y2=7.585
r354 (  147 222 ) resistor r=2.87058 //w=0.35 //l=0.085 //layer=li \
 //thickness=0.1 //x=12.18 //y=7.585 //x2=12.265 //y2=7.585
r355 (  147 148 ) resistor r=14.6485 //w=0.367 //l=0.42 //layer=li \
 //thickness=0.1 //x=12.18 //y=7.585 //x2=11.76 //y2=7.585
r356 (  142 220 ) resistor r=2.87058 //w=0.35 //l=0.085 //layer=li \
 //thickness=0.1 //x=10.895 //y=7.585 //x2=10.81 //y2=7.585
r357 (  142 144 ) resistor r=11.3351 //w=0.367 //l=0.325 //layer=li \
 //thickness=0.1 //x=10.895 //y=7.585 //x2=11.22 //y2=7.585
r358 (  141 221 ) resistor r=5.29055 //w=0.35 //l=0.17 //layer=li \
 //thickness=0.1 //x=11.42 //y=7.585 //x2=11.59 //y2=7.585
r359 (  141 144 ) resistor r=6.97548 //w=0.367 //l=0.2 //layer=li \
 //thickness=0.1 //x=11.42 //y=7.585 //x2=11.22 //y2=7.585
r360 (  135 220 ) resistor r=4.23183 //w=0.7 //l=0.175 //layer=li \
 //thickness=0.1 //x=10.81 //y=7.41 //x2=10.81 //y2=7.585
r361 (  135 237 ) resistor r=33.1979 //w=0.187 //l=0.485 //layer=li \
 //thickness=0.1 //x=10.81 //y=7.41 //x2=10.81 //y2=6.925
r362 (  132 219 ) resistor r=2.87058 //w=0.35 //l=0.085 //layer=li \
 //thickness=0.1 //x=10.015 //y=7.585 //x2=9.93 //y2=7.585
r363 (  132 134 ) resistor r=3.31335 //w=0.367 //l=0.095 //layer=li \
 //thickness=0.1 //x=10.015 //y=7.585 //x2=10.11 //y2=7.585
r364 (  131 220 ) resistor r=2.87058 //w=0.35 //l=0.085 //layer=li \
 //thickness=0.1 //x=10.725 //y=7.585 //x2=10.81 //y2=7.585
r365 (  131 134 ) resistor r=21.4496 //w=0.367 //l=0.615 //layer=li \
 //thickness=0.1 //x=10.725 //y=7.585 //x2=10.11 //y2=7.585
r366 (  125 219 ) resistor r=4.23183 //w=0.7 //l=0.175 //layer=li \
 //thickness=0.1 //x=9.93 //y=7.41 //x2=9.93 //y2=7.585
r367 (  125 236 ) resistor r=33.1979 //w=0.187 //l=0.485 //layer=li \
 //thickness=0.1 //x=9.93 //y=7.41 //x2=9.93 //y2=6.925
r368 (  124 218 ) resistor r=2.87058 //w=0.35 //l=0.085 //layer=li \
 //thickness=0.1 //x=9.135 //y=7.585 //x2=9.05 //y2=7.585
r369 (  123 219 ) resistor r=2.87058 //w=0.35 //l=0.085 //layer=li \
 //thickness=0.1 //x=9.845 //y=7.585 //x2=9.93 //y2=7.585
r370 (  123 124 ) resistor r=24.7629 //w=0.367 //l=0.71 //layer=li \
 //thickness=0.1 //x=9.845 //y=7.585 //x2=9.135 //y2=7.585
r371 (  117 218 ) resistor r=4.23183 //w=0.7 //l=0.175 //layer=li \
 //thickness=0.1 //x=9.05 //y=7.41 //x2=9.05 //y2=7.585
r372 (  117 235 ) resistor r=56.4706 //w=0.187 //l=0.825 //layer=li \
 //thickness=0.1 //x=9.05 //y=7.41 //x2=9.05 //y2=6.585
r373 (  116 216 ) resistor r=5.29055 //w=0.35 //l=0.17 //layer=li \
 //thickness=0.1 //x=8.43 //y=7.585 //x2=8.26 //y2=7.585
r374 (  115 218 ) resistor r=2.87058 //w=0.35 //l=0.085 //layer=li \
 //thickness=0.1 //x=8.965 //y=7.585 //x2=9.05 //y2=7.585
r375 (  115 116 ) resistor r=18.6594 //w=0.367 //l=0.535 //layer=li \
 //thickness=0.1 //x=8.965 //y=7.585 //x2=8.43 //y2=7.585
r376 (  112 215 ) resistor r=2.87058 //w=0.35 //l=0.085 //layer=li \
 //thickness=0.1 //x=7.68 //y=7.585 //x2=7.595 //y2=7.585
r377 (  111 216 ) resistor r=5.29055 //w=0.35 //l=0.17 //layer=li \
 //thickness=0.1 //x=8.09 //y=7.585 //x2=8.26 //y2=7.585
r378 (  111 112 ) resistor r=14.2997 //w=0.367 //l=0.41 //layer=li \
 //thickness=0.1 //x=8.09 //y=7.585 //x2=7.68 //y2=7.585
r379 (  105 215 ) resistor r=4.23183 //w=0.7 //l=0.175 //layer=li \
 //thickness=0.1 //x=7.595 //y=7.41 //x2=7.595 //y2=7.585
r380 (  105 234 ) resistor r=56.4706 //w=0.187 //l=0.825 //layer=li \
 //thickness=0.1 //x=7.595 //y=7.41 //x2=7.595 //y2=6.585
r381 (  104 213 ) resistor r=2.87058 //w=0.35 //l=0.085 //layer=li \
 //thickness=0.1 //x=6.8 //y=7.585 //x2=6.715 //y2=7.585
r382 (  103 215 ) resistor r=2.87058 //w=0.35 //l=0.085 //layer=li \
 //thickness=0.1 //x=7.51 //y=7.585 //x2=7.595 //y2=7.585
r383 (  103 104 ) resistor r=24.7629 //w=0.367 //l=0.71 //layer=li \
 //thickness=0.1 //x=7.51 //y=7.585 //x2=6.8 //y2=7.585
r384 (  97 213 ) resistor r=4.23183 //w=0.7 //l=0.175 //layer=li \
 //thickness=0.1 //x=6.715 //y=7.41 //x2=6.715 //y2=7.585
r385 (  97 233 ) resistor r=56.4706 //w=0.187 //l=0.825 //layer=li \
 //thickness=0.1 //x=6.715 //y=7.41 //x2=6.715 //y2=6.585
r386 (  94 212 ) resistor r=5.29055 //w=0.35 //l=0.17 //layer=li \
 //thickness=0.1 //x=6.21 //y=7.585 //x2=6.04 //y2=7.585
r387 (  94 96 ) resistor r=6.97548 //w=0.367 //l=0.2 //layer=li \
 //thickness=0.1 //x=6.21 //y=7.585 //x2=6.41 //y2=7.585
r388 (  93 213 ) resistor r=2.87058 //w=0.35 //l=0.085 //layer=li \
 //thickness=0.1 //x=6.63 //y=7.585 //x2=6.715 //y2=7.585
r389 (  93 96 ) resistor r=7.67302 //w=0.367 //l=0.22 //layer=li \
 //thickness=0.1 //x=6.63 //y=7.585 //x2=6.41 //y2=7.585
r390 (  90 211 ) resistor r=2.87058 //w=0.35 //l=0.085 //layer=li \
 //thickness=0.1 //x=5.345 //y=7.585 //x2=5.26 //y2=7.585
r391 (  89 212 ) resistor r=5.29055 //w=0.35 //l=0.17 //layer=li \
 //thickness=0.1 //x=5.87 //y=7.585 //x2=6.04 //y2=7.585
r392 (  89 90 ) resistor r=18.3106 //w=0.367 //l=0.525 //layer=li \
 //thickness=0.1 //x=5.87 //y=7.585 //x2=5.345 //y2=7.585
r393 (  83 211 ) resistor r=4.23183 //w=0.7 //l=0.175 //layer=li \
 //thickness=0.1 //x=5.26 //y=7.41 //x2=5.26 //y2=7.585
r394 (  83 232 ) resistor r=33.1979 //w=0.187 //l=0.485 //layer=li \
 //thickness=0.1 //x=5.26 //y=7.41 //x2=5.26 //y2=6.925
r395 (  80 210 ) resistor r=2.87058 //w=0.35 //l=0.085 //layer=li \
 //thickness=0.1 //x=4.465 //y=7.585 //x2=4.38 //y2=7.585
r396 (  80 82 ) resistor r=16.218 //w=0.367 //l=0.465 //layer=li \
 //thickness=0.1 //x=4.465 //y=7.585 //x2=4.93 //y2=7.585
r397 (  79 211 ) resistor r=2.87058 //w=0.35 //l=0.085 //layer=li \
 //thickness=0.1 //x=5.175 //y=7.585 //x2=5.26 //y2=7.585
r398 (  79 82 ) resistor r=8.54496 //w=0.367 //l=0.245 //layer=li \
 //thickness=0.1 //x=5.175 //y=7.585 //x2=4.93 //y2=7.585
r399 (  73 210 ) resistor r=4.23183 //w=0.7 //l=0.175 //layer=li \
 //thickness=0.1 //x=4.38 //y=7.41 //x2=4.38 //y2=7.585
r400 (  73 231 ) resistor r=33.1979 //w=0.187 //l=0.485 //layer=li \
 //thickness=0.1 //x=4.38 //y=7.41 //x2=4.38 //y2=6.925
r401 (  70 209 ) resistor r=2.87058 //w=0.35 //l=0.085 //layer=li \
 //thickness=0.1 //x=3.585 //y=7.585 //x2=3.5 //y2=7.585
r402 (  70 72 ) resistor r=8.19619 //w=0.367 //l=0.235 //layer=li \
 //thickness=0.1 //x=3.585 //y=7.585 //x2=3.82 //y2=7.585
r403 (  69 210 ) resistor r=2.87058 //w=0.35 //l=0.085 //layer=li \
 //thickness=0.1 //x=4.295 //y=7.585 //x2=4.38 //y2=7.585
r404 (  69 72 ) resistor r=16.5668 //w=0.367 //l=0.475 //layer=li \
 //thickness=0.1 //x=4.295 //y=7.585 //x2=3.82 //y2=7.585
r405 (  63 209 ) resistor r=4.23183 //w=0.7 //l=0.175 //layer=li \
 //thickness=0.1 //x=3.5 //y=7.41 //x2=3.5 //y2=7.585
r406 (  63 230 ) resistor r=56.4706 //w=0.187 //l=0.825 //layer=li \
 //thickness=0.1 //x=3.5 //y=7.41 //x2=3.5 //y2=6.585
r407 (  62 208 ) resistor r=5.29055 //w=0.35 //l=0.17 //layer=li \
 //thickness=0.1 //x=2.88 //y=7.585 //x2=2.71 //y2=7.585
r408 (  61 209 ) resistor r=2.87058 //w=0.35 //l=0.085 //layer=li \
 //thickness=0.1 //x=3.415 //y=7.585 //x2=3.5 //y2=7.585
r409 (  61 62 ) resistor r=18.6594 //w=0.367 //l=0.535 //layer=li \
 //thickness=0.1 //x=3.415 //y=7.585 //x2=2.88 //y2=7.585
r410 (  56 207 ) resistor r=2.87058 //w=0.35 //l=0.085 //layer=li \
 //thickness=0.1 //x=2.13 //y=7.585 //x2=2.045 //y2=7.585
r411 (  56 58 ) resistor r=7.32425 //w=0.367 //l=0.21 //layer=li \
 //thickness=0.1 //x=2.13 //y=7.585 //x2=2.34 //y2=7.585
r412 (  55 208 ) resistor r=5.29055 //w=0.35 //l=0.17 //layer=li \
 //thickness=0.1 //x=2.54 //y=7.585 //x2=2.71 //y2=7.585
r413 (  55 58 ) resistor r=6.97548 //w=0.367 //l=0.2 //layer=li \
 //thickness=0.1 //x=2.54 //y=7.585 //x2=2.34 //y2=7.585
r414 (  49 207 ) resistor r=4.23183 //w=0.7 //l=0.175 //layer=li \
 //thickness=0.1 //x=2.045 //y=7.41 //x2=2.045 //y2=7.585
r415 (  49 229 ) resistor r=56.4706 //w=0.187 //l=0.825 //layer=li \
 //thickness=0.1 //x=2.045 //y=7.41 //x2=2.045 //y2=6.585
r416 (  48 206 ) resistor r=2.87058 //w=0.35 //l=0.085 //layer=li \
 //thickness=0.1 //x=1.25 //y=7.585 //x2=1.165 //y2=7.585
r417 (  47 207 ) resistor r=2.87058 //w=0.35 //l=0.085 //layer=li \
 //thickness=0.1 //x=1.96 //y=7.585 //x2=2.045 //y2=7.585
r418 (  47 48 ) resistor r=24.7629 //w=0.367 //l=0.71 //layer=li \
 //thickness=0.1 //x=1.96 //y=7.585 //x2=1.25 //y2=7.585
r419 (  41 206 ) resistor r=4.23183 //w=0.7 //l=0.175 //layer=li \
 //thickness=0.1 //x=1.165 //y=7.41 //x2=1.165 //y2=7.585
r420 (  41 228 ) resistor r=56.4706 //w=0.187 //l=0.825 //layer=li \
 //thickness=0.1 //x=1.165 //y=7.41 //x2=1.165 //y2=6.585
r421 (  35 202 ) resistor r=4.65 //w=0.17 //l=0.34 //layer=mcon //count=2 \
 //x=19.73 //y=7.58 //x2=19.73 //y2=7.58
r422 (  33 200 ) resistor r=3.1 //w=0.17 //l=0.51 //layer=mcon //count=3 \
 //x=18.99 //y=7.58 //x2=18.99 //y2=7.58
r423 (  33 35 ) resistor r=0.297428 //w=0.311 //l=0.74 //layer=m1 \
 //thickness=0.36 //x=18.99 //y=7.585 //x2=19.73 //y2=7.585
r424 (  31 190 ) resistor r=3.1 //w=0.17 //l=0.51 //layer=mcon //count=3 \
 //x=17.88 //y=7.58 //x2=17.88 //y2=7.58
r425 (  31 33 ) resistor r=0.446141 //w=0.311 //l=1.11 //layer=m1 \
 //thickness=0.36 //x=17.88 //y=7.585 //x2=18.99 //y2=7.585
r426 (  29 184 ) resistor r=3.1 //w=0.17 //l=0.51 //layer=mcon //count=3 \
 //x=16.4 //y=7.58 //x2=16.4 //y2=7.58
r427 (  29 31 ) resistor r=0.594855 //w=0.311 //l=1.48 //layer=m1 \
 //thickness=0.36 //x=16.4 //y=7.585 //x2=17.88 //y2=7.585
r428 (  27 182 ) resistor r=3.1 //w=0.17 //l=0.51 //layer=mcon //count=3 \
 //x=15.29 //y=7.58 //x2=15.29 //y2=7.58
r429 (  27 29 ) resistor r=0.446141 //w=0.311 //l=1.11 //layer=m1 \
 //thickness=0.36 //x=15.29 //y=7.585 //x2=16.4 //y2=7.585
r430 (  25 172 ) resistor r=3.1 //w=0.17 //l=0.51 //layer=mcon //count=3 \
 //x=14.18 //y=7.58 //x2=14.18 //y2=7.58
r431 (  25 27 ) resistor r=0.446141 //w=0.311 //l=1.11 //layer=m1 \
 //thickness=0.36 //x=14.18 //y=7.585 //x2=15.29 //y2=7.585
r432 (  23 158 ) resistor r=3.1 //w=0.17 //l=0.51 //layer=mcon //count=3 \
 //x=12.7 //y=7.58 //x2=12.7 //y2=7.58
r433 (  23 25 ) resistor r=0.594855 //w=0.311 //l=1.48 //layer=m1 \
 //thickness=0.36 //x=12.7 //y=7.585 //x2=14.18 //y2=7.585
r434 (  21 144 ) resistor r=3.1 //w=0.17 //l=0.51 //layer=mcon //count=3 \
 //x=11.22 //y=7.58 //x2=11.22 //y2=7.58
r435 (  21 23 ) resistor r=0.594855 //w=0.311 //l=1.48 //layer=m1 \
 //thickness=0.36 //x=11.22 //y=7.585 //x2=12.7 //y2=7.585
r436 (  18 134 ) resistor r=3.1 //w=0.17 //l=0.51 //layer=mcon //count=3 \
 //x=10.11 //y=7.58 //x2=10.11 //y2=7.58
r437 (  16 218 ) resistor r=3.1 //w=0.17 //l=0.51 //layer=mcon //count=3 //x=9 \
 //y=7.58 //x2=9 //y2=7.58
r438 (  16 18 ) resistor r=0.446141 //w=0.311 //l=1.11 //layer=m1 \
 //thickness=0.36 //x=9 //y=7.585 //x2=10.11 //y2=7.585
r439 (  14 215 ) resistor r=3.1 //w=0.17 //l=0.51 //layer=mcon //count=3 \
 //x=7.52 //y=7.58 //x2=7.52 //y2=7.58
r440 (  14 16 ) resistor r=0.594855 //w=0.311 //l=1.48 //layer=m1 \
 //thickness=0.36 //x=7.52 //y=7.585 //x2=9 //y2=7.585
r441 (  12 96 ) resistor r=3.1 //w=0.17 //l=0.51 //layer=mcon //count=3 \
 //x=6.41 //y=7.58 //x2=6.41 //y2=7.58
r442 (  12 14 ) resistor r=0.446141 //w=0.311 //l=1.11 //layer=m1 \
 //thickness=0.36 //x=6.41 //y=7.585 //x2=7.52 //y2=7.585
r443 (  10 82 ) resistor r=3.1 //w=0.17 //l=0.51 //layer=mcon //count=3 \
 //x=4.93 //y=7.58 //x2=4.93 //y2=7.58
r444 (  10 12 ) resistor r=0.594855 //w=0.311 //l=1.48 //layer=m1 \
 //thickness=0.36 //x=4.93 //y=7.585 //x2=6.41 //y2=7.585
r445 (  8 72 ) resistor r=3.1 //w=0.17 //l=0.51 //layer=mcon //count=3 \
 //x=3.82 //y=7.58 //x2=3.82 //y2=7.58
r446 (  8 10 ) resistor r=0.446141 //w=0.311 //l=1.11 //layer=m1 \
 //thickness=0.36 //x=3.82 //y=7.585 //x2=4.93 //y2=7.585
r447 (  6 58 ) resistor r=3.1 //w=0.17 //l=0.51 //layer=mcon //count=3 \
 //x=2.34 //y=7.58 //x2=2.34 //y2=7.58
r448 (  6 8 ) resistor r=0.594855 //w=0.311 //l=1.48 //layer=m1 \
 //thickness=0.36 //x=2.34 //y=7.585 //x2=3.82 //y2=7.585
r449 (  3 206 ) resistor r=3.1 //w=0.17 //l=0.51 //layer=mcon //count=3 \
 //x=1.23 //y=7.58 //x2=1.23 //y2=7.58
r450 (  3 6 ) resistor r=0.446141 //w=0.311 //l=1.11 //layer=m1 \
 //thickness=0.36 //x=1.23 //y=7.585 //x2=2.34 //y2=7.585
r451 (  1 21 ) resistor r=0.297428 //w=0.311 //l=0.74 //layer=m1 \
 //thickness=0.36 //x=10.48 //y=7.585 //x2=11.22 //y2=7.585
r452 (  1 18 ) resistor r=0.148714 //w=0.311 //l=0.37 //layer=m1 \
 //thickness=0.36 //x=10.48 //y=7.585 //x2=10.11 //y2=7.585
ends PM_DLATCH\%VDD

subckt PM_DLATCH\%noxref_3 ( 1 2 17 18 19 20 24 26 33 34 35 36 37 38 39 43 45 \
 48 49 59 62 64 )
c117 ( 64 0 ) capacitor c=0.0288745f //x=1.46 //y=5.2
c118 ( 62 0 ) capacitor c=0.0173218f //x=1.415 //y=1.09
c119 ( 59 0 ) capacitor c=0.0593152f //x=3.82 //y=4.88
c120 ( 49 0 ) capacitor c=0.0318948f //x=4.155 //y=1.39
c121 ( 48 0 ) capacitor c=0.0187384f //x=4.155 //y=1.045
c122 ( 45 0 ) capacitor c=0.0141798f //x=4 //y=1.545
c123 ( 43 0 ) capacitor c=0.0149844f //x=4 //y=0.89
c124 ( 39 0 ) capacitor c=0.0860049f //x=3.625 //y=2.095
c125 ( 38 0 ) capacitor c=0.0229722f //x=3.625 //y=1.7
c126 ( 37 0 ) capacitor c=0.0234352f //x=3.625 //y=1.39
c127 ( 36 0 ) capacitor c=0.0199343f //x=3.625 //y=1.045
c128 ( 35 0 ) capacitor c=0.110275f //x=4.16 //y=6.2
c129 ( 34 0 ) capacitor c=0.154305f //x=3.72 //y=6.2
c130 ( 26 0 ) capacitor c=0.0954186f //x=3.82 //y=2.26
c131 ( 24 0 ) capacitor c=0.0861298f //x=1.97 //y=3.88
c132 ( 20 0 ) capacitor c=0.00417404f //x=1.69 //y=4.76
c133 ( 19 0 ) capacitor c=0.0118896f //x=1.885 //y=4.76
c134 ( 18 0 ) capacitor c=0.00621372f //x=1.685 //y=2.26
c135 ( 17 0 ) capacitor c=0.0139616f //x=1.885 //y=2.26
c136 ( 2 0 ) capacitor c=0.0139226f //x=2.085 //y=3.88
c137 ( 1 0 ) capacitor c=0.0681917f //x=3.705 //y=3.88
r138 (  57 59 ) resistor r=20.6867 //w=0.233 //l=0.1 //layer=ply \
 //thickness=0.18 //x=3.72 //y=4.88 //x2=3.82 //y2=4.88
r139 (  50 59 ) resistor r=70.3348 //w=0.233 //l=0.414367 //layer=ply \
 //thickness=0.18 //x=4.16 //y=5.045 //x2=3.82 //y2=4.88
r140 (  49 61 ) resistor r=45.1352 //w=0.168 //l=0.173853 //layer=ply \
 //thickness=0.18 //x=4.155 //y=1.39 //x2=4.115 //y2=1.545
r141 (  48 60 ) resistor r=45.1352 //w=0.168 //l=0.173853 //layer=ply \
 //thickness=0.18 //x=4.155 //y=1.045 //x2=4.115 //y2=0.89
r142 (  48 49 ) resistor r=176.904 //w=0.094 //l=0.345 //layer=ply \
 //thickness=0.18 //x=4.155 //y=1.045 //x2=4.155 //y2=1.39
r143 (  46 56 ) resistor r=10.701 //w=0.21 //l=0.115 //layer=ply \
 //thickness=0.18 //x=3.78 //y=1.545 //x2=3.665 //y2=1.545
r144 (  45 61 ) resistor r=5.52526 //w=0.168 //l=0.115 //layer=ply \
 //thickness=0.18 //x=4 //y=1.545 //x2=4.115 //y2=1.545
r145 (  44 55 ) resistor r=5.52526 //w=0.168 //l=0.115 //layer=ply \
 //thickness=0.18 //x=3.78 //y=0.89 //x2=3.665 //y2=0.89
r146 (  43 60 ) resistor r=5.52526 //w=0.168 //l=0.115 //layer=ply \
 //thickness=0.18 //x=4 //y=0.89 //x2=4.115 //y2=0.89
r147 (  43 44 ) resistor r=112.809 //w=0.094 //l=0.22 //layer=ply \
 //thickness=0.18 //x=4 //y=0.89 //x2=3.78 //y2=0.89
r148 (  40 57 ) resistor r=13.0941 //w=0.233 //l=0.165 //layer=ply \
 //thickness=0.18 //x=3.72 //y=5.045 //x2=3.72 //y2=4.88
r149 (  39 54 ) resistor r=34.8111 //w=0.27 //l=0.264953 //layer=ply \
 //thickness=0.18 //x=3.625 //y=2.095 //x2=3.82 //y2=2.26
r150 (  38 56 ) resistor r=39.5823 //w=0.21 //l=0.173853 //layer=ply \
 //thickness=0.18 //x=3.625 //y=1.7 //x2=3.665 //y2=1.545
r151 (  38 39 ) resistor r=202.543 //w=0.094 //l=0.395 //layer=ply \
 //thickness=0.18 //x=3.625 //y=1.7 //x2=3.625 //y2=2.095
r152 (  37 56 ) resistor r=39.5823 //w=0.21 //l=0.173853 //layer=ply \
 //thickness=0.18 //x=3.625 //y=1.39 //x2=3.665 //y2=1.545
r153 (  36 55 ) resistor r=45.1352 //w=0.168 //l=0.173853 //layer=ply \
 //thickness=0.18 //x=3.625 //y=1.045 //x2=3.665 //y2=0.89
r154 (  36 37 ) resistor r=176.904 //w=0.094 //l=0.345 //layer=ply \
 //thickness=0.18 //x=3.625 //y=1.045 //x2=3.625 //y2=1.39
r155 (  35 50 ) resistor r=592.245 //w=0.094 //l=1.155 //layer=ply \
 //thickness=0.18 //x=4.16 //y=6.2 //x2=4.16 //y2=5.045
r156 (  34 40 ) resistor r=592.245 //w=0.094 //l=1.155 //layer=ply \
 //thickness=0.18 //x=3.72 //y=6.2 //x2=3.72 //y2=5.045
r157 (  33 45 ) resistor r=56.4043 //w=0.094 //l=0.11 //layer=ply \
 //thickness=0.18 //x=3.89 //y=1.545 //x2=4 //y2=1.545
r158 (  33 46 ) resistor r=56.4043 //w=0.094 //l=0.11 //layer=ply \
 //thickness=0.18 //x=3.89 //y=1.545 //x2=3.78 //y2=1.545
r159 (  31 59 ) resistor r=152 //w=0.17 //l=0.17 //layer=licon //count=1 \
 //x=3.82 //y=4.88 //x2=3.82 //y2=4.88
r160 (  29 31 ) resistor r=68.4492 //w=0.187 //l=1 //layer=li //thickness=0.1 \
 //x=3.82 //y=3.88 //x2=3.82 //y2=4.88
r161 (  26 54 ) resistor r=152 //w=0.17 //l=0.17 //layer=licon //count=1 \
 //x=3.82 //y=2.26 //x2=3.82 //y2=2.26
r162 (  26 29 ) resistor r=110.888 //w=0.187 //l=1.62 //layer=li \
 //thickness=0.1 //x=3.82 //y=2.26 //x2=3.82 //y2=3.88
r163 (  22 24 ) resistor r=54.4171 //w=0.187 //l=0.795 //layer=li \
 //thickness=0.1 //x=1.97 //y=4.675 //x2=1.97 //y2=3.88
r164 (  21 24 ) resistor r=105.07 //w=0.187 //l=1.535 //layer=li \
 //thickness=0.1 //x=1.97 //y=2.345 //x2=1.97 //y2=3.88
r165 (  19 22 ) resistor r=7.15173 //w=0.17 //l=0.120208 //layer=li \
 //thickness=0.1 //x=1.885 //y=4.76 //x2=1.97 //y2=4.675
r166 (  19 20 ) resistor r=13.3476 //w=0.187 //l=0.195 //layer=li \
 //thickness=0.1 //x=1.885 //y=4.76 //x2=1.69 //y2=4.76
r167 (  17 21 ) resistor r=7.15173 //w=0.17 //l=0.120208 //layer=li \
 //thickness=0.1 //x=1.885 //y=2.26 //x2=1.97 //y2=2.345
r168 (  17 18 ) resistor r=13.6898 //w=0.187 //l=0.2 //layer=li \
 //thickness=0.1 //x=1.885 //y=2.26 //x2=1.685 //y2=2.26
r169 (  11 20 ) resistor r=7.15173 //w=0.17 //l=0.120208 //layer=li \
 //thickness=0.1 //x=1.605 //y=4.845 //x2=1.69 //y2=4.76
r170 (  11 64 ) resistor r=72.5562 //w=0.187 //l=1.06 //layer=li \
 //thickness=0.1 //x=1.605 //y=4.845 //x2=1.605 //y2=5.905
r171 (  7 18 ) resistor r=7.15173 //w=0.17 //l=0.120208 //layer=li \
 //thickness=0.1 //x=1.6 //y=2.175 //x2=1.685 //y2=2.26
r172 (  7 62 ) resistor r=67.7647 //w=0.187 //l=0.99 //layer=li \
 //thickness=0.1 //x=1.6 //y=2.175 //x2=1.6 //y2=1.185
r173 (  6 29 ) resistor r=9.3 //w=0.17 //l=0.17 //layer=mcon //count=1 \
 //x=3.82 //y=3.88 //x2=3.82 //y2=3.88
r174 (  4 24 ) resistor r=9.3 //w=0.17 //l=0.17 //layer=mcon //count=1 \
 //x=1.97 //y=3.88 //x2=1.97 //y2=3.88
r175 (  2 4 ) resistor r=0.0717383 //w=0.224 //l=0.115 //layer=m1 \
 //thickness=0.36 //x=2.085 //y=3.88 //x2=1.97 //y2=3.88
r176 (  1 6 ) resistor r=0.0717383 //w=0.224 //l=0.115 //layer=m1 \
 //thickness=0.36 //x=3.705 //y=3.88 //x2=3.82 //y2=3.88
r177 (  1 2 ) resistor r=1.5458 //w=0.131 //l=1.62 //layer=m1 //thickness=0.36 \
 //x=3.705 //y=3.88 //x2=2.085 //y2=3.88
ends PM_DLATCH\%noxref_3

subckt PM_DLATCH\%noxref_4 ( 1 2 13 14 25 27 28 32 34 41 42 43 44 45 46 47 48 \
 52 53 54 56 62 63 65 73 75 76 )
c134 ( 76 0 ) capacitor c=0.0220291f //x=4.675 //y=5.2
c135 ( 75 0 ) capacitor c=0.0217503f //x=3.795 //y=5.2
c136 ( 73 0 ) capacitor c=0.0084702f //x=4.67 //y=1.085
c137 ( 65 0 ) capacitor c=0.0511458f //x=6.78 //y=2.265
c138 ( 63 0 ) capacitor c=0.0435629f //x=7.42 //y=1.435
c139 ( 62 0 ) capacitor c=0.0200386f //x=7.42 //y=1.09
c140 ( 56 0 ) capacitor c=0.0152946f //x=7.265 //y=1.59
c141 ( 54 0 ) capacitor c=0.0157804f //x=7.265 //y=0.935
c142 ( 53 0 ) capacitor c=0.0490829f //x=7.01 //y=4.97
c143 ( 52 0 ) capacitor c=0.0303096f //x=7.3 //y=4.97
c144 ( 48 0 ) capacitor c=0.0290017f //x=6.89 //y=2.1
c145 ( 47 0 ) capacitor c=0.0250027f //x=6.89 //y=1.745
c146 ( 46 0 ) capacitor c=0.0234316f //x=6.89 //y=1.435
c147 ( 45 0 ) capacitor c=0.0200596f //x=6.89 //y=1.09
c148 ( 44 0 ) capacitor c=0.154218f //x=7.375 //y=6.2
c149 ( 43 0 ) capacitor c=0.154243f //x=6.935 //y=6.2
c150 ( 41 0 ) capacitor c=0.0023043f //x=4.82 //y=5.38
c151 ( 34 0 ) capacitor c=0.0884605f //x=6.78 //y=2.265
c152 ( 32 0 ) capacitor c=0.10682f //x=5.3 //y=3.51
c153 ( 28 0 ) capacitor c=0.00468667f //x=4.945 //y=1.835
c154 ( 27 0 ) capacitor c=0.0131863f //x=5.215 //y=1.835
c155 ( 25 0 ) capacitor c=0.0141863f //x=5.215 //y=5.38
c156 ( 14 0 ) capacitor c=0.00265825f //x=4.025 //y=5.38
c157 ( 13 0 ) capacitor c=0.0149089f //x=4.735 //y=5.38
c158 ( 2 0 ) capacitor c=0.0120846f //x=5.415 //y=3.51
c159 ( 1 0 ) capacitor c=0.0361557f //x=6.665 //y=3.51
r160 (  65 66 ) resistor r=17.5563 //w=0.302 //l=0.11 //layer=ply \
 //thickness=0.18 //x=6.78 //y=2.265 //x2=6.89 //y2=2.265
r161 (  63 72 ) resistor r=45.1352 //w=0.168 //l=0.173853 //layer=ply \
 //thickness=0.18 //x=7.42 //y=1.435 //x2=7.38 //y2=1.59
r162 (  62 71 ) resistor r=45.1352 //w=0.168 //l=0.173853 //layer=ply \
 //thickness=0.18 //x=7.42 //y=1.09 //x2=7.38 //y2=0.935
r163 (  62 63 ) resistor r=176.904 //w=0.094 //l=0.345 //layer=ply \
 //thickness=0.18 //x=7.42 //y=1.09 //x2=7.42 //y2=1.435
r164 (  57 70 ) resistor r=10.701 //w=0.21 //l=0.115 //layer=ply \
 //thickness=0.18 //x=7.045 //y=1.59 //x2=6.93 //y2=1.59
r165 (  56 72 ) resistor r=5.52526 //w=0.168 //l=0.115 //layer=ply \
 //thickness=0.18 //x=7.265 //y=1.59 //x2=7.38 //y2=1.59
r166 (  55 69 ) resistor r=5.52526 //w=0.168 //l=0.115 //layer=ply \
 //thickness=0.18 //x=7.045 //y=0.935 //x2=6.93 //y2=0.935
r167 (  54 71 ) resistor r=5.52526 //w=0.168 //l=0.115 //layer=ply \
 //thickness=0.18 //x=7.265 //y=0.935 //x2=7.38 //y2=0.935
r168 (  54 55 ) resistor r=112.809 //w=0.094 //l=0.22 //layer=ply \
 //thickness=0.18 //x=7.265 //y=0.935 //x2=7.045 //y2=0.935
r169 (  52 59 ) resistor r=26.9307 //w=0.15 //l=0.106066 //layer=ply \
 //thickness=0.18 //x=7.3 //y=4.97 //x2=7.375 //y2=5.045
r170 (  52 53 ) resistor r=148.702 //w=0.094 //l=0.29 //layer=ply \
 //thickness=0.18 //x=7.3 //y=4.97 //x2=7.01 //y2=4.97
r171 (  49 53 ) resistor r=23.403 //w=0.284 //l=0.106066 //layer=ply \
 //thickness=0.18 //x=6.935 //y=5.045 //x2=7.01 //y2=4.97
r172 (  49 68 ) resistor r=26.3063 //w=0.284 //l=0.229783 //layer=ply \
 //thickness=0.18 //x=6.935 //y=5.045 //x2=6.78 //y2=4.88
r173 (  48 66 ) resistor r=19.1248 //w=0.302 //l=0.165 //layer=ply \
 //thickness=0.18 //x=6.89 //y=2.1 //x2=6.89 //y2=2.265
r174 (  47 70 ) resistor r=39.5823 //w=0.21 //l=0.173853 //layer=ply \
 //thickness=0.18 //x=6.89 //y=1.745 //x2=6.93 //y2=1.59
r175 (  47 48 ) resistor r=182.032 //w=0.094 //l=0.355 //layer=ply \
 //thickness=0.18 //x=6.89 //y=1.745 //x2=6.89 //y2=2.1
r176 (  46 70 ) resistor r=39.5823 //w=0.21 //l=0.173853 //layer=ply \
 //thickness=0.18 //x=6.89 //y=1.435 //x2=6.93 //y2=1.59
r177 (  45 69 ) resistor r=45.1352 //w=0.168 //l=0.173853 //layer=ply \
 //thickness=0.18 //x=6.89 //y=1.09 //x2=6.93 //y2=0.935
r178 (  45 46 ) resistor r=176.904 //w=0.094 //l=0.345 //layer=ply \
 //thickness=0.18 //x=6.89 //y=1.09 //x2=6.89 //y2=1.435
r179 (  44 59 ) resistor r=592.245 //w=0.094 //l=1.155 //layer=ply \
 //thickness=0.18 //x=7.375 //y=6.2 //x2=7.375 //y2=5.045
r180 (  43 49 ) resistor r=592.245 //w=0.094 //l=1.155 //layer=ply \
 //thickness=0.18 //x=6.935 //y=6.2 //x2=6.935 //y2=5.045
r181 (  42 56 ) resistor r=56.4043 //w=0.094 //l=0.11 //layer=ply \
 //thickness=0.18 //x=7.155 //y=1.59 //x2=7.265 //y2=1.59
r182 (  42 57 ) resistor r=56.4043 //w=0.094 //l=0.11 //layer=ply \
 //thickness=0.18 //x=7.155 //y=1.59 //x2=7.045 //y2=1.59
r183 (  39 68 ) resistor r=152 //w=0.17 //l=0.17 //layer=licon //count=1 \
 //x=6.78 //y=4.88 //x2=6.78 //y2=4.88
r184 (  37 39 ) resistor r=93.7754 //w=0.187 //l=1.37 //layer=li \
 //thickness=0.1 //x=6.78 //y=3.51 //x2=6.78 //y2=4.88
r185 (  34 65 ) resistor r=152 //w=0.17 //l=0.17 //layer=licon //count=1 \
 //x=6.78 //y=2.265 //x2=6.78 //y2=2.265
r186 (  34 37 ) resistor r=85.2193 //w=0.187 //l=1.245 //layer=li \
 //thickness=0.1 //x=6.78 //y=2.265 //x2=6.78 //y2=3.51
r187 (  30 32 ) resistor r=122.182 //w=0.187 //l=1.785 //layer=li \
 //thickness=0.1 //x=5.3 //y=5.295 //x2=5.3 //y2=3.51
r188 (  29 32 ) resistor r=108.834 //w=0.187 //l=1.59 //layer=li \
 //thickness=0.1 //x=5.3 //y=1.92 //x2=5.3 //y2=3.51
r189 (  27 29 ) resistor r=7.15173 //w=0.17 //l=0.120208 //layer=li \
 //thickness=0.1 //x=5.215 //y=1.835 //x2=5.3 //y2=1.92
r190 (  27 28 ) resistor r=18.4813 //w=0.187 //l=0.27 //layer=li \
 //thickness=0.1 //x=5.215 //y=1.835 //x2=4.945 //y2=1.835
r191 (  26 41 ) resistor r=5.4201 //w=0.17 //l=0.085 //layer=li \
 //thickness=0.1 //x=4.905 //y=5.38 //x2=4.82 //y2=5.38
r192 (  25 30 ) resistor r=7.15173 //w=0.17 //l=0.120208 //layer=li \
 //thickness=0.1 //x=5.215 //y=5.38 //x2=5.3 //y2=5.295
r193 (  25 26 ) resistor r=21.2193 //w=0.187 //l=0.31 //layer=li \
 //thickness=0.1 //x=5.215 //y=5.38 //x2=4.905 //y2=5.38
r194 (  21 28 ) resistor r=7.15173 //w=0.17 //l=0.120208 //layer=li \
 //thickness=0.1 //x=4.86 //y=1.75 //x2=4.945 //y2=1.835
r195 (  21 73 ) resistor r=39.016 //w=0.187 //l=0.57 //layer=li \
 //thickness=0.1 //x=4.86 //y=1.75 //x2=4.86 //y2=1.18
r196 (  15 41 ) resistor r=1.40859 //w=0.34 //l=0.085 //layer=li \
 //thickness=0.1 //x=4.82 //y=5.465 //x2=4.82 //y2=5.38
r197 (  15 76 ) resistor r=30.1176 //w=0.187 //l=0.44 //layer=li \
 //thickness=0.1 //x=4.82 //y=5.465 //x2=4.82 //y2=5.905
r198 (  13 41 ) resistor r=5.4201 //w=0.17 //l=0.085 //layer=li \
 //thickness=0.1 //x=4.735 //y=5.38 //x2=4.82 //y2=5.38
r199 (  13 14 ) resistor r=48.5989 //w=0.187 //l=0.71 //layer=li \
 //thickness=0.1 //x=4.735 //y=5.38 //x2=4.025 //y2=5.38
r200 (  7 14 ) resistor r=7.15173 //w=0.17 //l=0.120208 //layer=li \
 //thickness=0.1 //x=3.94 //y=5.465 //x2=4.025 //y2=5.38
r201 (  7 75 ) resistor r=30.1176 //w=0.187 //l=0.44 //layer=li \
 //thickness=0.1 //x=3.94 //y=5.465 //x2=3.94 //y2=5.905
r202 (  6 37 ) resistor r=9.3 //w=0.17 //l=0.17 //layer=mcon //count=1 \
 //x=6.78 //y=3.51 //x2=6.78 //y2=3.51
r203 (  4 32 ) resistor r=9.3 //w=0.17 //l=0.17 //layer=mcon //count=1 //x=5.3 \
 //y=3.51 //x2=5.3 //y2=3.51
r204 (  2 4 ) resistor r=0.0717383 //w=0.224 //l=0.115 //layer=m1 \
 //thickness=0.36 //x=5.415 //y=3.51 //x2=5.3 //y2=3.51
r205 (  1 6 ) resistor r=0.0717383 //w=0.224 //l=0.115 //layer=m1 \
 //thickness=0.36 //x=6.665 //y=3.51 //x2=6.78 //y2=3.51
r206 (  1 2 ) resistor r=1.19275 //w=0.131 //l=1.25 //layer=m1 \
 //thickness=0.36 //x=6.665 //y=3.51 //x2=5.415 //y2=3.51
ends PM_DLATCH\%noxref_4

subckt PM_DLATCH\%GATE ( 1 2 7 8 9 10 11 12 13 14 15 16 18 27 39 40 41 42 43 \
 44 45 46 47 52 54 56 62 63 64 65 66 67 71 73 76 77 82 83 86 100 )
c161 ( 100 0 ) capacitor c=0.0593152f //x=9.37 //y=4.88
c162 ( 86 0 ) capacitor c=0.0331552f //x=4.59 //y=4.88
c163 ( 83 0 ) capacitor c=0.0279499f //x=4.56 //y=2.095
c164 ( 82 0 ) capacitor c=0.0422509f //x=4.56 //y=2.26
c165 ( 77 0 ) capacitor c=0.0318948f //x=9.705 //y=1.39
c166 ( 76 0 ) capacitor c=0.0187384f //x=9.705 //y=1.045
c167 ( 73 0 ) capacitor c=0.0141798f //x=9.55 //y=1.545
c168 ( 71 0 ) capacitor c=0.0149844f //x=9.55 //y=0.89
c169 ( 67 0 ) capacitor c=0.0819722f //x=9.175 //y=2.095
c170 ( 66 0 ) capacitor c=0.0229722f //x=9.175 //y=1.7
c171 ( 65 0 ) capacitor c=0.0234352f //x=9.175 //y=1.39
c172 ( 64 0 ) capacitor c=0.0199343f //x=9.175 //y=1.045
c173 ( 63 0 ) capacitor c=0.0429696f //x=5.125 //y=1.43
c174 ( 62 0 ) capacitor c=0.0192208f //x=5.125 //y=1.085
c175 ( 56 0 ) capacitor c=0.0158629f //x=4.97 //y=1.585
c176 ( 54 0 ) capacitor c=0.0157803f //x=4.97 //y=0.93
c177 ( 52 0 ) capacitor c=0.0300505f //x=4.965 //y=4.97
c178 ( 47 0 ) capacitor c=0.0205163f //x=4.595 //y=1.74
c179 ( 46 0 ) capacitor c=0.0168481f //x=4.595 //y=1.43
c180 ( 45 0 ) capacitor c=0.0174783f //x=4.595 //y=1.085
c181 ( 44 0 ) capacitor c=0.110275f //x=9.71 //y=6.2
c182 ( 43 0 ) capacitor c=0.154305f //x=9.27 //y=6.2
c183 ( 42 0 ) capacitor c=0.15358f //x=5.04 //y=6.2
c184 ( 41 0 ) capacitor c=0.110281f //x=4.6 //y=6.2
c185 ( 27 0 ) capacitor c=0.0925986f //x=9.37 //y=2.26
c186 ( 18 0 ) capacitor c=0.0756836f //x=4.56 //y=2.26
c187 ( 16 0 ) capacitor c=0.00453889f //x=4.56 //y=4.715
c188 ( 2 0 ) capacitor c=0.0165748f //x=4.675 //y=3.14
c189 ( 1 0 ) capacitor c=0.14924f //x=9.255 //y=3.14
r190 (  98 100 ) resistor r=20.6867 //w=0.233 //l=0.1 //layer=ply \
 //thickness=0.18 //x=9.27 //y=4.88 //x2=9.37 //y2=4.88
r191 (  88 89 ) resistor r=32.4568 //w=0.214 //l=0.075 //layer=ply \
 //thickness=0.18 //x=4.59 //y=4.97 //x2=4.59 //y2=5.045
r192 (  86 88 ) resistor r=20.271 //w=0.214 //l=0.09 //layer=ply \
 //thickness=0.18 //x=4.59 //y=4.88 //x2=4.59 //y2=4.97
r193 (  82 83 ) resistor r=52.7279 //w=0.214 //l=0.165 //layer=ply \
 //thickness=0.18 //x=4.56 //y=2.26 //x2=4.56 //y2=2.095
r194 (  78 100 ) resistor r=70.3348 //w=0.233 //l=0.414367 //layer=ply \
 //thickness=0.18 //x=9.71 //y=5.045 //x2=9.37 //y2=4.88
r195 (  77 102 ) resistor r=45.1352 //w=0.168 //l=0.173853 //layer=ply \
 //thickness=0.18 //x=9.705 //y=1.39 //x2=9.665 //y2=1.545
r196 (  76 101 ) resistor r=45.1352 //w=0.168 //l=0.173853 //layer=ply \
 //thickness=0.18 //x=9.705 //y=1.045 //x2=9.665 //y2=0.89
r197 (  76 77 ) resistor r=176.904 //w=0.094 //l=0.345 //layer=ply \
 //thickness=0.18 //x=9.705 //y=1.045 //x2=9.705 //y2=1.39
r198 (  74 97 ) resistor r=10.701 //w=0.21 //l=0.115 //layer=ply \
 //thickness=0.18 //x=9.33 //y=1.545 //x2=9.215 //y2=1.545
r199 (  73 102 ) resistor r=5.52526 //w=0.168 //l=0.115 //layer=ply \
 //thickness=0.18 //x=9.55 //y=1.545 //x2=9.665 //y2=1.545
r200 (  72 96 ) resistor r=5.52526 //w=0.168 //l=0.115 //layer=ply \
 //thickness=0.18 //x=9.33 //y=0.89 //x2=9.215 //y2=0.89
r201 (  71 101 ) resistor r=5.52526 //w=0.168 //l=0.115 //layer=ply \
 //thickness=0.18 //x=9.55 //y=0.89 //x2=9.665 //y2=0.89
r202 (  71 72 ) resistor r=112.809 //w=0.094 //l=0.22 //layer=ply \
 //thickness=0.18 //x=9.55 //y=0.89 //x2=9.33 //y2=0.89
r203 (  68 98 ) resistor r=13.0941 //w=0.233 //l=0.165 //layer=ply \
 //thickness=0.18 //x=9.27 //y=5.045 //x2=9.27 //y2=4.88
r204 (  67 95 ) resistor r=34.8111 //w=0.27 //l=0.264953 //layer=ply \
 //thickness=0.18 //x=9.175 //y=2.095 //x2=9.37 //y2=2.26
r205 (  66 97 ) resistor r=39.5823 //w=0.21 //l=0.173853 //layer=ply \
 //thickness=0.18 //x=9.175 //y=1.7 //x2=9.215 //y2=1.545
r206 (  66 67 ) resistor r=202.543 //w=0.094 //l=0.395 //layer=ply \
 //thickness=0.18 //x=9.175 //y=1.7 //x2=9.175 //y2=2.095
r207 (  65 97 ) resistor r=39.5823 //w=0.21 //l=0.173853 //layer=ply \
 //thickness=0.18 //x=9.175 //y=1.39 //x2=9.215 //y2=1.545
r208 (  64 96 ) resistor r=45.1352 //w=0.168 //l=0.173853 //layer=ply \
 //thickness=0.18 //x=9.175 //y=1.045 //x2=9.215 //y2=0.89
r209 (  64 65 ) resistor r=176.904 //w=0.094 //l=0.345 //layer=ply \
 //thickness=0.18 //x=9.175 //y=1.045 //x2=9.175 //y2=1.39
r210 (  63 93 ) resistor r=45.1352 //w=0.168 //l=0.173853 //layer=ply \
 //thickness=0.18 //x=5.125 //y=1.43 //x2=5.085 //y2=1.585
r211 (  62 92 ) resistor r=45.1352 //w=0.168 //l=0.173853 //layer=ply \
 //thickness=0.18 //x=5.125 //y=1.085 //x2=5.085 //y2=0.93
r212 (  62 63 ) resistor r=176.904 //w=0.094 //l=0.345 //layer=ply \
 //thickness=0.18 //x=5.125 //y=1.085 //x2=5.125 //y2=1.43
r213 (  57 91 ) resistor r=10.701 //w=0.21 //l=0.115 //layer=ply \
 //thickness=0.18 //x=4.75 //y=1.585 //x2=4.635 //y2=1.585
r214 (  56 93 ) resistor r=5.52526 //w=0.168 //l=0.115 //layer=ply \
 //thickness=0.18 //x=4.97 //y=1.585 //x2=5.085 //y2=1.585
r215 (  55 90 ) resistor r=5.52526 //w=0.168 //l=0.115 //layer=ply \
 //thickness=0.18 //x=4.75 //y=0.93 //x2=4.635 //y2=0.93
r216 (  54 92 ) resistor r=5.52526 //w=0.168 //l=0.115 //layer=ply \
 //thickness=0.18 //x=4.97 //y=0.93 //x2=5.085 //y2=0.93
r217 (  54 55 ) resistor r=112.809 //w=0.094 //l=0.22 //layer=ply \
 //thickness=0.18 //x=4.97 //y=0.93 //x2=4.75 //y2=0.93
r218 (  53 88 ) resistor r=16.5046 //w=0.27 //l=0.135 //layer=ply \
 //thickness=0.18 //x=4.725 //y=4.97 //x2=4.59 //y2=4.97
r219 (  52 59 ) resistor r=26.9307 //w=0.15 //l=0.106066 //layer=ply \
 //thickness=0.18 //x=4.965 //y=4.97 //x2=5.04 //y2=5.045
r220 (  52 53 ) resistor r=123.064 //w=0.094 //l=0.24 //layer=ply \
 //thickness=0.18 //x=4.965 //y=4.97 //x2=4.725 //y2=4.97
r221 (  47 91 ) resistor r=39.5823 //w=0.21 //l=0.173853 //layer=ply \
 //thickness=0.18 //x=4.595 //y=1.74 //x2=4.635 //y2=1.585
r222 (  47 83 ) resistor r=182.032 //w=0.094 //l=0.355 //layer=ply \
 //thickness=0.18 //x=4.595 //y=1.74 //x2=4.595 //y2=2.095
r223 (  46 91 ) resistor r=39.5823 //w=0.21 //l=0.173853 //layer=ply \
 //thickness=0.18 //x=4.595 //y=1.43 //x2=4.635 //y2=1.585
r224 (  45 90 ) resistor r=45.1352 //w=0.168 //l=0.173853 //layer=ply \
 //thickness=0.18 //x=4.595 //y=1.085 //x2=4.635 //y2=0.93
r225 (  45 46 ) resistor r=176.904 //w=0.094 //l=0.345 //layer=ply \
 //thickness=0.18 //x=4.595 //y=1.085 //x2=4.595 //y2=1.43
r226 (  44 78 ) resistor r=592.245 //w=0.094 //l=1.155 //layer=ply \
 //thickness=0.18 //x=9.71 //y=6.2 //x2=9.71 //y2=5.045
r227 (  43 68 ) resistor r=592.245 //w=0.094 //l=1.155 //layer=ply \
 //thickness=0.18 //x=9.27 //y=6.2 //x2=9.27 //y2=5.045
r228 (  42 59 ) resistor r=592.245 //w=0.094 //l=1.155 //layer=ply \
 //thickness=0.18 //x=5.04 //y=6.2 //x2=5.04 //y2=5.045
r229 (  41 89 ) resistor r=592.245 //w=0.094 //l=1.155 //layer=ply \
 //thickness=0.18 //x=4.6 //y=6.2 //x2=4.6 //y2=5.045
r230 (  40 73 ) resistor r=56.4043 //w=0.094 //l=0.11 //layer=ply \
 //thickness=0.18 //x=9.44 //y=1.545 //x2=9.55 //y2=1.545
r231 (  40 74 ) resistor r=56.4043 //w=0.094 //l=0.11 //layer=ply \
 //thickness=0.18 //x=9.44 //y=1.545 //x2=9.33 //y2=1.545
r232 (  39 56 ) resistor r=56.4043 //w=0.094 //l=0.11 //layer=ply \
 //thickness=0.18 //x=4.86 //y=1.585 //x2=4.97 //y2=1.585
r233 (  39 57 ) resistor r=56.4043 //w=0.094 //l=0.11 //layer=ply \
 //thickness=0.18 //x=4.86 //y=1.585 //x2=4.75 //y2=1.585
r234 (  38 86 ) resistor r=152 //w=0.17 //l=0.17 //layer=licon //count=1 \
 //x=4.59 //y=4.88 //x2=4.59 //y2=4.88
r235 (  35 100 ) resistor r=152 //w=0.17 //l=0.17 //layer=licon //count=1 \
 //x=9.37 //y=4.88 //x2=9.37 //y2=4.88
r236 (  27 95 ) resistor r=152 //w=0.17 //l=0.17 //layer=licon //count=1 \
 //x=9.37 //y=2.26 //x2=9.37 //y2=2.26
r237 (  18 82 ) resistor r=152 //w=0.17 //l=0.17 //layer=licon //count=1 \
 //x=4.56 //y=2.26 //x2=4.56 //y2=2.26
r238 (  16 38 ) resistor r=11.4737 //w=0.186 //l=0.172337 //layer=li \
 //thickness=0.1 //x=4.56 //y=4.715 //x2=4.575 //y2=4.88
r239 (  15 35 ) resistor r=17.7968 //w=0.187 //l=0.26 //layer=li \
 //thickness=0.1 //x=9.37 //y=4.62 //x2=9.37 //y2=4.88
r240 (  14 15 ) resistor r=75.9786 //w=0.187 //l=1.11 //layer=li \
 //thickness=0.1 //x=9.37 //y=3.51 //x2=9.37 //y2=4.62
r241 (  13 14 ) resistor r=25.3262 //w=0.187 //l=0.37 //layer=li \
 //thickness=0.1 //x=9.37 //y=3.14 //x2=9.37 //y2=3.51
r242 (  12 13 ) resistor r=25.3262 //w=0.187 //l=0.37 //layer=li \
 //thickness=0.1 //x=9.37 //y=2.77 //x2=9.37 //y2=3.14
r243 (  12 27 ) resistor r=34.9091 //w=0.187 //l=0.51 //layer=li \
 //thickness=0.1 //x=9.37 //y=2.77 //x2=9.37 //y2=2.26
r244 (  11 16 ) resistor r=6.50267 //w=0.187 //l=0.095 //layer=li \
 //thickness=0.1 //x=4.56 //y=4.62 //x2=4.56 //y2=4.715
r245 (  10 11 ) resistor r=50.6524 //w=0.187 //l=0.74 //layer=li \
 //thickness=0.1 //x=4.56 //y=3.88 //x2=4.56 //y2=4.62
r246 (  9 10 ) resistor r=25.3262 //w=0.187 //l=0.37 //layer=li \
 //thickness=0.1 //x=4.56 //y=3.51 //x2=4.56 //y2=3.88
r247 (  8 9 ) resistor r=25.3262 //w=0.187 //l=0.37 //layer=li //thickness=0.1 \
 //x=4.56 //y=3.14 //x2=4.56 //y2=3.51
r248 (  7 8 ) resistor r=25.3262 //w=0.187 //l=0.37 //layer=li //thickness=0.1 \
 //x=4.56 //y=2.77 //x2=4.56 //y2=3.14
r249 (  7 18 ) resistor r=34.9091 //w=0.187 //l=0.51 //layer=li \
 //thickness=0.1 //x=4.56 //y=2.77 //x2=4.56 //y2=2.26
r250 (  6 13 ) resistor r=9.3 //w=0.17 //l=0.17 //layer=mcon //count=1 \
 //x=9.37 //y=3.14 //x2=9.37 //y2=3.14
r251 (  4 8 ) resistor r=9.3 //w=0.17 //l=0.17 //layer=mcon //count=1 //x=4.56 \
 //y=3.14 //x2=4.56 //y2=3.14
r252 (  2 4 ) resistor r=0.0717383 //w=0.224 //l=0.115 //layer=m1 \
 //thickness=0.36 //x=4.675 //y=3.14 //x2=4.56 //y2=3.14
r253 (  1 6 ) resistor r=0.0717383 //w=0.224 //l=0.115 //layer=m1 \
 //thickness=0.36 //x=9.255 //y=3.14 //x2=9.37 //y2=3.14
r254 (  1 2 ) resistor r=4.37023 //w=0.131 //l=4.58 //layer=m1 \
 //thickness=0.36 //x=9.255 //y=3.14 //x2=4.675 //y2=3.14
ends PM_DLATCH\%GATE

subckt PM_DLATCH\%D ( 1 2 7 8 9 10 11 12 13 14 15 16 17 18 19 21 34 36 47 48 \
 49 50 51 52 53 54 55 56 60 61 62 64 70 71 72 73 74 79 81 83 89 90 92 101 102 \
 105 )
c177 ( 105 0 ) capacitor c=0.0331844f //x=10.14 //y=4.88
c178 ( 102 0 ) capacitor c=0.0279499f //x=10.11 //y=2.095
c179 ( 101 0 ) capacitor c=0.0437302f //x=10.11 //y=2.26
c180 ( 92 0 ) capacitor c=0.0537799f //x=1.23 //y=2.265
c181 ( 90 0 ) capacitor c=0.0429696f //x=10.675 //y=1.43
c182 ( 89 0 ) capacitor c=0.0192208f //x=10.675 //y=1.085
c183 ( 83 0 ) capacitor c=0.0158629f //x=10.52 //y=1.585
c184 ( 81 0 ) capacitor c=0.0157803f //x=10.52 //y=0.93
c185 ( 79 0 ) capacitor c=0.0307199f //x=10.515 //y=4.97
c186 ( 74 0 ) capacitor c=0.0205163f //x=10.145 //y=1.74
c187 ( 73 0 ) capacitor c=0.0168481f //x=10.145 //y=1.43
c188 ( 72 0 ) capacitor c=0.0174783f //x=10.145 //y=1.085
c189 ( 71 0 ) capacitor c=0.0435629f //x=1.87 //y=1.435
c190 ( 70 0 ) capacitor c=0.0200386f //x=1.87 //y=1.09
c191 ( 64 0 ) capacitor c=0.0152946f //x=1.715 //y=1.59
c192 ( 62 0 ) capacitor c=0.0157804f //x=1.715 //y=0.935
c193 ( 61 0 ) capacitor c=0.048995f //x=1.46 //y=4.97
c194 ( 60 0 ) capacitor c=0.0303096f //x=1.75 //y=4.97
c195 ( 56 0 ) capacitor c=0.0290017f //x=1.34 //y=2.1
c196 ( 55 0 ) capacitor c=0.0250027f //x=1.34 //y=1.745
c197 ( 54 0 ) capacitor c=0.0234316f //x=1.34 //y=1.435
c198 ( 53 0 ) capacitor c=0.0200596f //x=1.34 //y=1.09
c199 ( 52 0 ) capacitor c=0.15358f //x=10.59 //y=6.2
c200 ( 51 0 ) capacitor c=0.110281f //x=10.15 //y=6.2
c201 ( 50 0 ) capacitor c=0.154218f //x=1.825 //y=6.2
c202 ( 49 0 ) capacitor c=0.154243f //x=1.385 //y=6.2
c203 ( 36 0 ) capacitor c=0.0762219f //x=10.11 //y=2.26
c204 ( 34 0 ) capacitor c=0.00453889f //x=10.11 //y=4.715
c205 ( 21 0 ) capacitor c=0.11071f //x=1.23 //y=2.265
c206 ( 2 0 ) capacitor c=0.016217f //x=1.345 //y=4.25
c207 ( 1 0 ) capacitor c=0.257694f //x=9.995 //y=4.25
r208 (  107 108 ) resistor r=32.4568 //w=0.214 //l=0.075 //layer=ply \
 //thickness=0.18 //x=10.14 //y=4.97 //x2=10.14 //y2=5.045
r209 (  105 107 ) resistor r=20.271 //w=0.214 //l=0.09 //layer=ply \
 //thickness=0.18 //x=10.14 //y=4.88 //x2=10.14 //y2=4.97
r210 (  101 102 ) resistor r=52.7279 //w=0.214 //l=0.165 //layer=ply \
 //thickness=0.18 //x=10.11 //y=2.26 //x2=10.11 //y2=2.095
r211 (  92 93 ) resistor r=17.5563 //w=0.302 //l=0.11 //layer=ply \
 //thickness=0.18 //x=1.23 //y=2.265 //x2=1.34 //y2=2.265
r212 (  90 112 ) resistor r=45.1352 //w=0.168 //l=0.173853 //layer=ply \
 //thickness=0.18 //x=10.675 //y=1.43 //x2=10.635 //y2=1.585
r213 (  89 111 ) resistor r=45.1352 //w=0.168 //l=0.173853 //layer=ply \
 //thickness=0.18 //x=10.675 //y=1.085 //x2=10.635 //y2=0.93
r214 (  89 90 ) resistor r=176.904 //w=0.094 //l=0.345 //layer=ply \
 //thickness=0.18 //x=10.675 //y=1.085 //x2=10.675 //y2=1.43
r215 (  84 110 ) resistor r=10.701 //w=0.21 //l=0.115 //layer=ply \
 //thickness=0.18 //x=10.3 //y=1.585 //x2=10.185 //y2=1.585
r216 (  83 112 ) resistor r=5.52526 //w=0.168 //l=0.115 //layer=ply \
 //thickness=0.18 //x=10.52 //y=1.585 //x2=10.635 //y2=1.585
r217 (  82 109 ) resistor r=5.52526 //w=0.168 //l=0.115 //layer=ply \
 //thickness=0.18 //x=10.3 //y=0.93 //x2=10.185 //y2=0.93
r218 (  81 111 ) resistor r=5.52526 //w=0.168 //l=0.115 //layer=ply \
 //thickness=0.18 //x=10.52 //y=0.93 //x2=10.635 //y2=0.93
r219 (  81 82 ) resistor r=112.809 //w=0.094 //l=0.22 //layer=ply \
 //thickness=0.18 //x=10.52 //y=0.93 //x2=10.3 //y2=0.93
r220 (  80 107 ) resistor r=16.5046 //w=0.27 //l=0.135 //layer=ply \
 //thickness=0.18 //x=10.275 //y=4.97 //x2=10.14 //y2=4.97
r221 (  79 86 ) resistor r=26.9307 //w=0.15 //l=0.106066 //layer=ply \
 //thickness=0.18 //x=10.515 //y=4.97 //x2=10.59 //y2=5.045
r222 (  79 80 ) resistor r=123.064 //w=0.094 //l=0.24 //layer=ply \
 //thickness=0.18 //x=10.515 //y=4.97 //x2=10.275 //y2=4.97
r223 (  74 110 ) resistor r=39.5823 //w=0.21 //l=0.173853 //layer=ply \
 //thickness=0.18 //x=10.145 //y=1.74 //x2=10.185 //y2=1.585
r224 (  74 102 ) resistor r=182.032 //w=0.094 //l=0.355 //layer=ply \
 //thickness=0.18 //x=10.145 //y=1.74 //x2=10.145 //y2=2.095
r225 (  73 110 ) resistor r=39.5823 //w=0.21 //l=0.173853 //layer=ply \
 //thickness=0.18 //x=10.145 //y=1.43 //x2=10.185 //y2=1.585
r226 (  72 109 ) resistor r=45.1352 //w=0.168 //l=0.173853 //layer=ply \
 //thickness=0.18 //x=10.145 //y=1.085 //x2=10.185 //y2=0.93
r227 (  72 73 ) resistor r=176.904 //w=0.094 //l=0.345 //layer=ply \
 //thickness=0.18 //x=10.145 //y=1.085 //x2=10.145 //y2=1.43
r228 (  71 99 ) resistor r=45.1352 //w=0.168 //l=0.173853 //layer=ply \
 //thickness=0.18 //x=1.87 //y=1.435 //x2=1.83 //y2=1.59
r229 (  70 98 ) resistor r=45.1352 //w=0.168 //l=0.173853 //layer=ply \
 //thickness=0.18 //x=1.87 //y=1.09 //x2=1.83 //y2=0.935
r230 (  70 71 ) resistor r=176.904 //w=0.094 //l=0.345 //layer=ply \
 //thickness=0.18 //x=1.87 //y=1.09 //x2=1.87 //y2=1.435
r231 (  65 97 ) resistor r=10.701 //w=0.21 //l=0.115 //layer=ply \
 //thickness=0.18 //x=1.495 //y=1.59 //x2=1.38 //y2=1.59
r232 (  64 99 ) resistor r=5.52526 //w=0.168 //l=0.115 //layer=ply \
 //thickness=0.18 //x=1.715 //y=1.59 //x2=1.83 //y2=1.59
r233 (  63 96 ) resistor r=5.52526 //w=0.168 //l=0.115 //layer=ply \
 //thickness=0.18 //x=1.495 //y=0.935 //x2=1.38 //y2=0.935
r234 (  62 98 ) resistor r=5.52526 //w=0.168 //l=0.115 //layer=ply \
 //thickness=0.18 //x=1.715 //y=0.935 //x2=1.83 //y2=0.935
r235 (  62 63 ) resistor r=112.809 //w=0.094 //l=0.22 //layer=ply \
 //thickness=0.18 //x=1.715 //y=0.935 //x2=1.495 //y2=0.935
r236 (  60 67 ) resistor r=26.9307 //w=0.15 //l=0.106066 //layer=ply \
 //thickness=0.18 //x=1.75 //y=4.97 //x2=1.825 //y2=5.045
r237 (  60 61 ) resistor r=148.702 //w=0.094 //l=0.29 //layer=ply \
 //thickness=0.18 //x=1.75 //y=4.97 //x2=1.46 //y2=4.97
r238 (  57 61 ) resistor r=23.403 //w=0.284 //l=0.106066 //layer=ply \
 //thickness=0.18 //x=1.385 //y=5.045 //x2=1.46 //y2=4.97
r239 (  57 95 ) resistor r=26.3063 //w=0.284 //l=0.229783 //layer=ply \
 //thickness=0.18 //x=1.385 //y=5.045 //x2=1.23 //y2=4.88
r240 (  56 93 ) resistor r=19.1248 //w=0.302 //l=0.165 //layer=ply \
 //thickness=0.18 //x=1.34 //y=2.1 //x2=1.34 //y2=2.265
r241 (  55 97 ) resistor r=39.5823 //w=0.21 //l=0.173853 //layer=ply \
 //thickness=0.18 //x=1.34 //y=1.745 //x2=1.38 //y2=1.59
r242 (  55 56 ) resistor r=182.032 //w=0.094 //l=0.355 //layer=ply \
 //thickness=0.18 //x=1.34 //y=1.745 //x2=1.34 //y2=2.1
r243 (  54 97 ) resistor r=39.5823 //w=0.21 //l=0.173853 //layer=ply \
 //thickness=0.18 //x=1.34 //y=1.435 //x2=1.38 //y2=1.59
r244 (  53 96 ) resistor r=45.1352 //w=0.168 //l=0.173853 //layer=ply \
 //thickness=0.18 //x=1.34 //y=1.09 //x2=1.38 //y2=0.935
r245 (  53 54 ) resistor r=176.904 //w=0.094 //l=0.345 //layer=ply \
 //thickness=0.18 //x=1.34 //y=1.09 //x2=1.34 //y2=1.435
r246 (  52 86 ) resistor r=592.245 //w=0.094 //l=1.155 //layer=ply \
 //thickness=0.18 //x=10.59 //y=6.2 //x2=10.59 //y2=5.045
r247 (  51 108 ) resistor r=592.245 //w=0.094 //l=1.155 //layer=ply \
 //thickness=0.18 //x=10.15 //y=6.2 //x2=10.15 //y2=5.045
r248 (  50 67 ) resistor r=592.245 //w=0.094 //l=1.155 //layer=ply \
 //thickness=0.18 //x=1.825 //y=6.2 //x2=1.825 //y2=5.045
r249 (  49 57 ) resistor r=592.245 //w=0.094 //l=1.155 //layer=ply \
 //thickness=0.18 //x=1.385 //y=6.2 //x2=1.385 //y2=5.045
r250 (  48 83 ) resistor r=56.4043 //w=0.094 //l=0.11 //layer=ply \
 //thickness=0.18 //x=10.41 //y=1.585 //x2=10.52 //y2=1.585
r251 (  48 84 ) resistor r=56.4043 //w=0.094 //l=0.11 //layer=ply \
 //thickness=0.18 //x=10.41 //y=1.585 //x2=10.3 //y2=1.585
r252 (  47 64 ) resistor r=56.4043 //w=0.094 //l=0.11 //layer=ply \
 //thickness=0.18 //x=1.605 //y=1.59 //x2=1.715 //y2=1.59
r253 (  47 65 ) resistor r=56.4043 //w=0.094 //l=0.11 //layer=ply \
 //thickness=0.18 //x=1.605 //y=1.59 //x2=1.495 //y2=1.59
r254 (  46 105 ) resistor r=152 //w=0.17 //l=0.17 //layer=licon //count=1 \
 //x=10.14 //y=4.88 //x2=10.14 //y2=4.88
r255 (  36 101 ) resistor r=152 //w=0.17 //l=0.17 //layer=licon //count=1 \
 //x=10.11 //y=2.26 //x2=10.11 //y2=2.26
r256 (  34 46 ) resistor r=11.4737 //w=0.186 //l=0.172337 //layer=li \
 //thickness=0.1 //x=10.11 //y=4.715 //x2=10.125 //y2=4.88
r257 (  32 95 ) resistor r=152 //w=0.17 //l=0.17 //layer=licon //count=1 \
 //x=1.23 //y=4.88 //x2=1.23 //y2=4.88
r258 (  21 92 ) resistor r=152 //w=0.17 //l=0.17 //layer=licon //count=1 \
 //x=1.23 //y=2.265 //x2=1.23 //y2=2.265
r259 (  19 34 ) resistor r=6.50267 //w=0.187 //l=0.095 //layer=li \
 //thickness=0.1 //x=10.11 //y=4.62 //x2=10.11 //y2=4.715
r260 (  18 19 ) resistor r=25.3262 //w=0.187 //l=0.37 //layer=li \
 //thickness=0.1 //x=10.11 //y=4.25 //x2=10.11 //y2=4.62
r261 (  17 18 ) resistor r=50.6524 //w=0.187 //l=0.74 //layer=li \
 //thickness=0.1 //x=10.11 //y=3.51 //x2=10.11 //y2=4.25
r262 (  16 17 ) resistor r=25.3262 //w=0.187 //l=0.37 //layer=li \
 //thickness=0.1 //x=10.11 //y=3.14 //x2=10.11 //y2=3.51
r263 (  15 16 ) resistor r=25.3262 //w=0.187 //l=0.37 //layer=li \
 //thickness=0.1 //x=10.11 //y=2.77 //x2=10.11 //y2=3.14
r264 (  14 15 ) resistor r=25.3262 //w=0.187 //l=0.37 //layer=li \
 //thickness=0.1 //x=10.11 //y=2.4 //x2=10.11 //y2=2.77
r265 (  14 36 ) resistor r=9.58289 //w=0.187 //l=0.14 //layer=li \
 //thickness=0.1 //x=10.11 //y=2.4 //x2=10.11 //y2=2.26
r266 (  13 32 ) resistor r=17.7968 //w=0.187 //l=0.26 //layer=li \
 //thickness=0.1 //x=1.23 //y=4.62 //x2=1.23 //y2=4.88
r267 (  12 13 ) resistor r=25.3262 //w=0.187 //l=0.37 //layer=li \
 //thickness=0.1 //x=1.23 //y=4.25 //x2=1.23 //y2=4.62
r268 (  11 12 ) resistor r=25.3262 //w=0.187 //l=0.37 //layer=li \
 //thickness=0.1 //x=1.23 //y=3.88 //x2=1.23 //y2=4.25
r269 (  10 11 ) resistor r=25.3262 //w=0.187 //l=0.37 //layer=li \
 //thickness=0.1 //x=1.23 //y=3.51 //x2=1.23 //y2=3.88
r270 (  9 10 ) resistor r=25.3262 //w=0.187 //l=0.37 //layer=li \
 //thickness=0.1 //x=1.23 //y=3.14 //x2=1.23 //y2=3.51
r271 (  8 9 ) resistor r=25.3262 //w=0.187 //l=0.37 //layer=li //thickness=0.1 \
 //x=1.23 //y=2.77 //x2=1.23 //y2=3.14
r272 (  7 8 ) resistor r=25.3262 //w=0.187 //l=0.37 //layer=li //thickness=0.1 \
 //x=1.23 //y=2.4 //x2=1.23 //y2=2.77
r273 (  7 21 ) resistor r=9.24064 //w=0.187 //l=0.135 //layer=li \
 //thickness=0.1 //x=1.23 //y=2.4 //x2=1.23 //y2=2.265
r274 (  6 18 ) resistor r=9.3 //w=0.17 //l=0.17 //layer=mcon //count=1 \
 //x=10.11 //y=4.25 //x2=10.11 //y2=4.25
r275 (  4 12 ) resistor r=9.3 //w=0.17 //l=0.17 //layer=mcon //count=1 \
 //x=1.23 //y=4.25 //x2=1.23 //y2=4.25
r276 (  2 4 ) resistor r=0.0717383 //w=0.224 //l=0.115 //layer=m1 \
 //thickness=0.36 //x=1.345 //y=4.25 //x2=1.23 //y2=4.25
r277 (  1 6 ) resistor r=0.0717383 //w=0.224 //l=0.115 //layer=m1 \
 //thickness=0.36 //x=9.995 //y=4.25 //x2=10.11 //y2=4.25
r278 (  1 2 ) resistor r=8.25382 //w=0.131 //l=8.65 //layer=m1 \
 //thickness=0.36 //x=9.995 //y=4.25 //x2=1.345 //y2=4.25
ends PM_DLATCH\%D

subckt PM_DLATCH\%noxref_7 ( 1 2 13 14 25 27 28 32 34 41 42 43 44 45 46 47 48 \
 52 53 54 56 62 63 65 73 75 76 )
c139 ( 76 0 ) capacitor c=0.0220291f //x=10.225 //y=5.2
c140 ( 75 0 ) capacitor c=0.0217503f //x=9.345 //y=5.2
c141 ( 73 0 ) capacitor c=0.0084702f //x=10.22 //y=1.085
c142 ( 65 0 ) capacitor c=0.0528806f //x=12.33 //y=2.265
c143 ( 63 0 ) capacitor c=0.0435629f //x=12.97 //y=1.435
c144 ( 62 0 ) capacitor c=0.0200386f //x=12.97 //y=1.09
c145 ( 56 0 ) capacitor c=0.0152946f //x=12.815 //y=1.59
c146 ( 54 0 ) capacitor c=0.0157804f //x=12.815 //y=0.935
c147 ( 53 0 ) capacitor c=0.0493989f //x=12.56 //y=4.97
c148 ( 52 0 ) capacitor c=0.0304843f //x=12.85 //y=4.97
c149 ( 48 0 ) capacitor c=0.0290017f //x=12.44 //y=2.1
c150 ( 47 0 ) capacitor c=0.0250027f //x=12.44 //y=1.745
c151 ( 46 0 ) capacitor c=0.0234316f //x=12.44 //y=1.435
c152 ( 45 0 ) capacitor c=0.0200596f //x=12.44 //y=1.09
c153 ( 44 0 ) capacitor c=0.154218f //x=12.925 //y=6.2
c154 ( 43 0 ) capacitor c=0.154243f //x=12.485 //y=6.2
c155 ( 41 0 ) capacitor c=0.0024826f //x=10.37 //y=5.38
c156 ( 34 0 ) capacitor c=0.0908494f //x=12.33 //y=2.265
c157 ( 32 0 ) capacitor c=0.108527f //x=10.85 //y=3.51
c158 ( 28 0 ) capacitor c=0.00525782f //x=10.495 //y=1.835
c159 ( 27 0 ) capacitor c=0.0139525f //x=10.765 //y=1.835
c160 ( 25 0 ) capacitor c=0.0144648f //x=10.765 //y=5.38
c161 ( 14 0 ) capacitor c=0.00265825f //x=9.575 //y=5.38
c162 ( 13 0 ) capacitor c=0.0150834f //x=10.285 //y=5.38
c163 ( 2 0 ) capacitor c=0.0111323f //x=10.965 //y=3.51
c164 ( 1 0 ) capacitor c=0.0522233f //x=12.215 //y=3.51
r165 (  65 66 ) resistor r=17.5563 //w=0.302 //l=0.11 //layer=ply \
 //thickness=0.18 //x=12.33 //y=2.265 //x2=12.44 //y2=2.265
r166 (  63 72 ) resistor r=45.1352 //w=0.168 //l=0.173853 //layer=ply \
 //thickness=0.18 //x=12.97 //y=1.435 //x2=12.93 //y2=1.59
r167 (  62 71 ) resistor r=45.1352 //w=0.168 //l=0.173853 //layer=ply \
 //thickness=0.18 //x=12.97 //y=1.09 //x2=12.93 //y2=0.935
r168 (  62 63 ) resistor r=176.904 //w=0.094 //l=0.345 //layer=ply \
 //thickness=0.18 //x=12.97 //y=1.09 //x2=12.97 //y2=1.435
r169 (  57 70 ) resistor r=10.701 //w=0.21 //l=0.115 //layer=ply \
 //thickness=0.18 //x=12.595 //y=1.59 //x2=12.48 //y2=1.59
r170 (  56 72 ) resistor r=5.52526 //w=0.168 //l=0.115 //layer=ply \
 //thickness=0.18 //x=12.815 //y=1.59 //x2=12.93 //y2=1.59
r171 (  55 69 ) resistor r=5.52526 //w=0.168 //l=0.115 //layer=ply \
 //thickness=0.18 //x=12.595 //y=0.935 //x2=12.48 //y2=0.935
r172 (  54 71 ) resistor r=5.52526 //w=0.168 //l=0.115 //layer=ply \
 //thickness=0.18 //x=12.815 //y=0.935 //x2=12.93 //y2=0.935
r173 (  54 55 ) resistor r=112.809 //w=0.094 //l=0.22 //layer=ply \
 //thickness=0.18 //x=12.815 //y=0.935 //x2=12.595 //y2=0.935
r174 (  52 59 ) resistor r=26.9307 //w=0.15 //l=0.106066 //layer=ply \
 //thickness=0.18 //x=12.85 //y=4.97 //x2=12.925 //y2=5.045
r175 (  52 53 ) resistor r=148.702 //w=0.094 //l=0.29 //layer=ply \
 //thickness=0.18 //x=12.85 //y=4.97 //x2=12.56 //y2=4.97
r176 (  49 53 ) resistor r=23.403 //w=0.284 //l=0.106066 //layer=ply \
 //thickness=0.18 //x=12.485 //y=5.045 //x2=12.56 //y2=4.97
r177 (  49 68 ) resistor r=26.3063 //w=0.284 //l=0.229783 //layer=ply \
 //thickness=0.18 //x=12.485 //y=5.045 //x2=12.33 //y2=4.88
r178 (  48 66 ) resistor r=19.1248 //w=0.302 //l=0.165 //layer=ply \
 //thickness=0.18 //x=12.44 //y=2.1 //x2=12.44 //y2=2.265
r179 (  47 70 ) resistor r=39.5823 //w=0.21 //l=0.173853 //layer=ply \
 //thickness=0.18 //x=12.44 //y=1.745 //x2=12.48 //y2=1.59
r180 (  47 48 ) resistor r=182.032 //w=0.094 //l=0.355 //layer=ply \
 //thickness=0.18 //x=12.44 //y=1.745 //x2=12.44 //y2=2.1
r181 (  46 70 ) resistor r=39.5823 //w=0.21 //l=0.173853 //layer=ply \
 //thickness=0.18 //x=12.44 //y=1.435 //x2=12.48 //y2=1.59
r182 (  45 69 ) resistor r=45.1352 //w=0.168 //l=0.173853 //layer=ply \
 //thickness=0.18 //x=12.44 //y=1.09 //x2=12.48 //y2=0.935
r183 (  45 46 ) resistor r=176.904 //w=0.094 //l=0.345 //layer=ply \
 //thickness=0.18 //x=12.44 //y=1.09 //x2=12.44 //y2=1.435
r184 (  44 59 ) resistor r=592.245 //w=0.094 //l=1.155 //layer=ply \
 //thickness=0.18 //x=12.925 //y=6.2 //x2=12.925 //y2=5.045
r185 (  43 49 ) resistor r=592.245 //w=0.094 //l=1.155 //layer=ply \
 //thickness=0.18 //x=12.485 //y=6.2 //x2=12.485 //y2=5.045
r186 (  42 56 ) resistor r=56.4043 //w=0.094 //l=0.11 //layer=ply \
 //thickness=0.18 //x=12.705 //y=1.59 //x2=12.815 //y2=1.59
r187 (  42 57 ) resistor r=56.4043 //w=0.094 //l=0.11 //layer=ply \
 //thickness=0.18 //x=12.705 //y=1.59 //x2=12.595 //y2=1.59
r188 (  39 68 ) resistor r=152 //w=0.17 //l=0.17 //layer=licon //count=1 \
 //x=12.33 //y=4.88 //x2=12.33 //y2=4.88
r189 (  37 39 ) resistor r=93.7754 //w=0.187 //l=1.37 //layer=li \
 //thickness=0.1 //x=12.33 //y=3.51 //x2=12.33 //y2=4.88
r190 (  34 65 ) resistor r=152 //w=0.17 //l=0.17 //layer=licon //count=1 \
 //x=12.33 //y=2.265 //x2=12.33 //y2=2.265
r191 (  34 37 ) resistor r=85.2193 //w=0.187 //l=1.245 //layer=li \
 //thickness=0.1 //x=12.33 //y=2.265 //x2=12.33 //y2=3.51
r192 (  30 32 ) resistor r=122.182 //w=0.187 //l=1.785 //layer=li \
 //thickness=0.1 //x=10.85 //y=5.295 //x2=10.85 //y2=3.51
r193 (  29 32 ) resistor r=108.834 //w=0.187 //l=1.59 //layer=li \
 //thickness=0.1 //x=10.85 //y=1.92 //x2=10.85 //y2=3.51
r194 (  27 29 ) resistor r=7.15173 //w=0.17 //l=0.120208 //layer=li \
 //thickness=0.1 //x=10.765 //y=1.835 //x2=10.85 //y2=1.92
r195 (  27 28 ) resistor r=18.4813 //w=0.187 //l=0.27 //layer=li \
 //thickness=0.1 //x=10.765 //y=1.835 //x2=10.495 //y2=1.835
r196 (  26 41 ) resistor r=5.4201 //w=0.17 //l=0.085 //layer=li \
 //thickness=0.1 //x=10.455 //y=5.38 //x2=10.37 //y2=5.38
r197 (  25 30 ) resistor r=7.15173 //w=0.17 //l=0.120208 //layer=li \
 //thickness=0.1 //x=10.765 //y=5.38 //x2=10.85 //y2=5.295
r198 (  25 26 ) resistor r=21.2193 //w=0.187 //l=0.31 //layer=li \
 //thickness=0.1 //x=10.765 //y=5.38 //x2=10.455 //y2=5.38
r199 (  21 28 ) resistor r=7.15173 //w=0.17 //l=0.120208 //layer=li \
 //thickness=0.1 //x=10.41 //y=1.75 //x2=10.495 //y2=1.835
r200 (  21 73 ) resistor r=39.016 //w=0.187 //l=0.57 //layer=li \
 //thickness=0.1 //x=10.41 //y=1.75 //x2=10.41 //y2=1.18
r201 (  15 41 ) resistor r=1.40859 //w=0.34 //l=0.085 //layer=li \
 //thickness=0.1 //x=10.37 //y=5.465 //x2=10.37 //y2=5.38
r202 (  15 76 ) resistor r=30.1176 //w=0.187 //l=0.44 //layer=li \
 //thickness=0.1 //x=10.37 //y=5.465 //x2=10.37 //y2=5.905
r203 (  13 41 ) resistor r=5.4201 //w=0.17 //l=0.085 //layer=li \
 //thickness=0.1 //x=10.285 //y=5.38 //x2=10.37 //y2=5.38
r204 (  13 14 ) resistor r=48.5989 //w=0.187 //l=0.71 //layer=li \
 //thickness=0.1 //x=10.285 //y=5.38 //x2=9.575 //y2=5.38
r205 (  7 14 ) resistor r=7.15173 //w=0.17 //l=0.120208 //layer=li \
 //thickness=0.1 //x=9.49 //y=5.465 //x2=9.575 //y2=5.38
r206 (  7 75 ) resistor r=30.1176 //w=0.187 //l=0.44 //layer=li \
 //thickness=0.1 //x=9.49 //y=5.465 //x2=9.49 //y2=5.905
r207 (  6 37 ) resistor r=9.3 //w=0.17 //l=0.17 //layer=mcon //count=1 \
 //x=12.33 //y=3.51 //x2=12.33 //y2=3.51
r208 (  4 32 ) resistor r=9.3 //w=0.17 //l=0.17 //layer=mcon //count=1 \
 //x=10.85 //y=3.51 //x2=10.85 //y2=3.51
r209 (  2 4 ) resistor r=0.0717383 //w=0.224 //l=0.115 //layer=m1 \
 //thickness=0.36 //x=10.965 //y=3.51 //x2=10.85 //y2=3.51
r210 (  1 6 ) resistor r=0.0717383 //w=0.224 //l=0.115 //layer=m1 \
 //thickness=0.36 //x=12.215 //y=3.51 //x2=12.33 //y2=3.51
r211 (  1 2 ) resistor r=1.19275 //w=0.131 //l=1.25 //layer=m1 \
 //thickness=0.36 //x=12.215 //y=3.51 //x2=10.965 //y2=3.51
ends PM_DLATCH\%noxref_7

subckt PM_DLATCH\%noxref_8 ( 1 2 17 18 19 20 24 27 32 34 35 36 37 38 39 40 44 \
 46 49 51 52 57 67 69 )
c164 ( 69 0 ) capacitor c=0.0288745f //x=7.01 //y=5.2
c165 ( 67 0 ) capacitor c=0.0173218f //x=6.965 //y=1.09
c166 ( 57 0 ) capacitor c=0.0403405f //x=14.765 //y=4.885
c167 ( 52 0 ) capacitor c=0.0321911f //x=15.255 //y=1.43
c168 ( 51 0 ) capacitor c=0.0185201f //x=15.255 //y=1.085
c169 ( 49 0 ) capacitor c=0.0288104f //x=15.185 //y=4.975
c170 ( 46 0 ) capacitor c=0.0133656f //x=15.1 //y=1.585
c171 ( 44 0 ) capacitor c=0.0157804f //x=15.1 //y=0.93
c172 ( 40 0 ) capacitor c=0.0828832f //x=14.725 //y=2.095
c173 ( 39 0 ) capacitor c=0.022867f //x=14.725 //y=1.74
c174 ( 38 0 ) capacitor c=0.0234318f //x=14.725 //y=1.43
c175 ( 37 0 ) capacitor c=0.0192004f //x=14.725 //y=1.085
c176 ( 36 0 ) capacitor c=0.110795f //x=15.26 //y=6.205
c177 ( 35 0 ) capacitor c=0.153847f //x=14.82 //y=6.205
c178 ( 32 0 ) capacitor c=0.00993392f //x=14.765 //y=4.885
c179 ( 27 0 ) capacitor c=0.0921227f //x=14.92 //y=2.26
c180 ( 24 0 ) capacitor c=0.0820607f //x=7.52 //y=3.88
c181 ( 20 0 ) capacitor c=0.00417404f //x=7.24 //y=4.76
c182 ( 19 0 ) capacitor c=0.0118896f //x=7.435 //y=4.76
c183 ( 18 0 ) capacitor c=0.00549299f //x=7.235 //y=2.26
c184 ( 17 0 ) capacitor c=0.013178f //x=7.435 //y=2.26
c185 ( 2 0 ) capacitor c=0.0108199f //x=7.635 //y=3.88
c186 ( 1 0 ) capacitor c=0.214055f //x=14.805 //y=3.88
r187 (  59 60 ) resistor r=32.4568 //w=0.214 //l=0.075 //layer=ply \
 //thickness=0.18 //x=14.765 //y=4.975 //x2=14.765 //y2=5.05
r188 (  57 59 ) resistor r=20.271 //w=0.214 //l=0.09 //layer=ply \
 //thickness=0.18 //x=14.765 //y=4.885 //x2=14.765 //y2=4.975
r189 (  52 66 ) resistor r=45.1352 //w=0.168 //l=0.173853 //layer=ply \
 //thickness=0.18 //x=15.255 //y=1.43 //x2=15.215 //y2=1.585
r190 (  51 65 ) resistor r=45.1352 //w=0.168 //l=0.173853 //layer=ply \
 //thickness=0.18 //x=15.255 //y=1.085 //x2=15.215 //y2=0.93
r191 (  51 52 ) resistor r=176.904 //w=0.094 //l=0.345 //layer=ply \
 //thickness=0.18 //x=15.255 //y=1.085 //x2=15.255 //y2=1.43
r192 (  50 59 ) resistor r=16.5046 //w=0.27 //l=0.135 //layer=ply \
 //thickness=0.18 //x=14.9 //y=4.975 //x2=14.765 //y2=4.975
r193 (  49 53 ) resistor r=26.9307 //w=0.15 //l=0.106066 //layer=ply \
 //thickness=0.18 //x=15.185 //y=4.975 //x2=15.26 //y2=5.05
r194 (  49 50 ) resistor r=146.138 //w=0.094 //l=0.285 //layer=ply \
 //thickness=0.18 //x=15.185 //y=4.975 //x2=14.9 //y2=4.975
r195 (  47 64 ) resistor r=10.701 //w=0.21 //l=0.115 //layer=ply \
 //thickness=0.18 //x=14.88 //y=1.585 //x2=14.765 //y2=1.585
r196 (  46 66 ) resistor r=5.52526 //w=0.168 //l=0.115 //layer=ply \
 //thickness=0.18 //x=15.1 //y=1.585 //x2=15.215 //y2=1.585
r197 (  45 63 ) resistor r=5.52526 //w=0.168 //l=0.115 //layer=ply \
 //thickness=0.18 //x=14.88 //y=0.93 //x2=14.765 //y2=0.93
r198 (  44 65 ) resistor r=5.52526 //w=0.168 //l=0.115 //layer=ply \
 //thickness=0.18 //x=15.1 //y=0.93 //x2=15.215 //y2=0.93
r199 (  44 45 ) resistor r=112.809 //w=0.094 //l=0.22 //layer=ply \
 //thickness=0.18 //x=15.1 //y=0.93 //x2=14.88 //y2=0.93
r200 (  40 62 ) resistor r=34.8111 //w=0.27 //l=0.264953 //layer=ply \
 //thickness=0.18 //x=14.725 //y=2.095 //x2=14.92 //y2=2.26
r201 (  39 64 ) resistor r=39.5823 //w=0.21 //l=0.173853 //layer=ply \
 //thickness=0.18 //x=14.725 //y=1.74 //x2=14.765 //y2=1.585
r202 (  39 40 ) resistor r=182.032 //w=0.094 //l=0.355 //layer=ply \
 //thickness=0.18 //x=14.725 //y=1.74 //x2=14.725 //y2=2.095
r203 (  38 64 ) resistor r=39.5823 //w=0.21 //l=0.173853 //layer=ply \
 //thickness=0.18 //x=14.725 //y=1.43 //x2=14.765 //y2=1.585
r204 (  37 63 ) resistor r=45.1352 //w=0.168 //l=0.173853 //layer=ply \
 //thickness=0.18 //x=14.725 //y=1.085 //x2=14.765 //y2=0.93
r205 (  37 38 ) resistor r=176.904 //w=0.094 //l=0.345 //layer=ply \
 //thickness=0.18 //x=14.725 //y=1.085 //x2=14.725 //y2=1.43
r206 (  36 53 ) resistor r=592.245 //w=0.094 //l=1.155 //layer=ply \
 //thickness=0.18 //x=15.26 //y=6.205 //x2=15.26 //y2=5.05
r207 (  35 60 ) resistor r=592.245 //w=0.094 //l=1.155 //layer=ply \
 //thickness=0.18 //x=14.82 //y=6.205 //x2=14.82 //y2=5.05
r208 (  34 46 ) resistor r=56.4043 //w=0.094 //l=0.11 //layer=ply \
 //thickness=0.18 //x=14.99 //y=1.585 //x2=15.1 //y2=1.585
r209 (  34 47 ) resistor r=56.4043 //w=0.094 //l=0.11 //layer=ply \
 //thickness=0.18 //x=14.99 //y=1.585 //x2=14.88 //y2=1.585
r210 (  32 57 ) resistor r=152 //w=0.17 //l=0.17 //layer=licon //count=1 \
 //x=14.765 //y=4.885 //x2=14.765 //y2=4.885
r211 (  32 33 ) resistor r=7.81102 //w=0.254 //l=0.155 //layer=li \
 //thickness=0.1 //x=14.765 //y=4.885 //x2=14.92 //y2=4.885
r212 (  27 62 ) resistor r=152 //w=0.17 //l=0.17 //layer=licon //count=1 \
 //x=14.92 //y=2.26 //x2=14.92 //y2=2.26
r213 (  27 30 ) resistor r=110.888 //w=0.187 //l=1.62 //layer=li \
 //thickness=0.1 //x=14.92 //y=2.26 //x2=14.92 //y2=3.88
r214 (  25 33 ) resistor r=3.23951 //w=0.254 //l=0.165 //layer=li \
 //thickness=0.1 //x=14.92 //y=4.72 //x2=14.92 //y2=4.885
r215 (  25 30 ) resistor r=57.4973 //w=0.187 //l=0.84 //layer=li \
 //thickness=0.1 //x=14.92 //y=4.72 //x2=14.92 //y2=3.88
r216 (  22 24 ) resistor r=54.4171 //w=0.187 //l=0.795 //layer=li \
 //thickness=0.1 //x=7.52 //y=4.675 //x2=7.52 //y2=3.88
r217 (  21 24 ) resistor r=105.07 //w=0.187 //l=1.535 //layer=li \
 //thickness=0.1 //x=7.52 //y=2.345 //x2=7.52 //y2=3.88
r218 (  19 22 ) resistor r=7.15173 //w=0.17 //l=0.120208 //layer=li \
 //thickness=0.1 //x=7.435 //y=4.76 //x2=7.52 //y2=4.675
r219 (  19 20 ) resistor r=13.3476 //w=0.187 //l=0.195 //layer=li \
 //thickness=0.1 //x=7.435 //y=4.76 //x2=7.24 //y2=4.76
r220 (  17 21 ) resistor r=7.15173 //w=0.17 //l=0.120208 //layer=li \
 //thickness=0.1 //x=7.435 //y=2.26 //x2=7.52 //y2=2.345
r221 (  17 18 ) resistor r=13.6898 //w=0.187 //l=0.2 //layer=li \
 //thickness=0.1 //x=7.435 //y=2.26 //x2=7.235 //y2=2.26
r222 (  11 20 ) resistor r=7.15173 //w=0.17 //l=0.120208 //layer=li \
 //thickness=0.1 //x=7.155 //y=4.845 //x2=7.24 //y2=4.76
r223 (  11 69 ) resistor r=72.5562 //w=0.187 //l=1.06 //layer=li \
 //thickness=0.1 //x=7.155 //y=4.845 //x2=7.155 //y2=5.905
r224 (  7 18 ) resistor r=7.15173 //w=0.17 //l=0.120208 //layer=li \
 //thickness=0.1 //x=7.15 //y=2.175 //x2=7.235 //y2=2.26
r225 (  7 67 ) resistor r=67.7647 //w=0.187 //l=0.99 //layer=li \
 //thickness=0.1 //x=7.15 //y=2.175 //x2=7.15 //y2=1.185
r226 (  6 30 ) resistor r=9.3 //w=0.17 //l=0.17 //layer=mcon //count=1 \
 //x=14.92 //y=3.88 //x2=14.92 //y2=3.88
r227 (  4 24 ) resistor r=9.3 //w=0.17 //l=0.17 //layer=mcon //count=1 \
 //x=7.52 //y=3.88 //x2=7.52 //y2=3.88
r228 (  2 4 ) resistor r=0.0717383 //w=0.224 //l=0.115 //layer=m1 \
 //thickness=0.36 //x=7.635 //y=3.88 //x2=7.52 //y2=3.88
r229 (  1 6 ) resistor r=0.0717383 //w=0.224 //l=0.115 //layer=m1 \
 //thickness=0.36 //x=14.805 //y=3.88 //x2=14.92 //y2=3.88
r230 (  1 2 ) resistor r=6.8416 //w=0.131 //l=7.17 //layer=m1 //thickness=0.36 \
 //x=14.805 //y=3.88 //x2=7.635 //y2=3.88
ends PM_DLATCH\%noxref_8

subckt PM_DLATCH\%Q ( 1 2 7 8 9 10 11 12 13 14 15 16 21 22 33 34 35 47 57 59 \
 60 61 62 63 64 65 69 71 74 76 77 82 92 93 96 )
c167 ( 96 0 ) capacitor c=0.0159573f //x=15.775 //y=5.205
c168 ( 93 0 ) capacitor c=0.00923651f //x=15.77 //y=1.085
c169 ( 92 0 ) capacitor c=0.007684f //x=14.8 //y=1.085
c170 ( 82 0 ) capacitor c=0.0402699f //x=18.095 //y=4.885
c171 ( 77 0 ) capacitor c=0.0321911f //x=18.585 //y=1.43
c172 ( 76 0 ) capacitor c=0.0185201f //x=18.585 //y=1.085
c173 ( 74 0 ) capacitor c=0.0288104f //x=18.515 //y=4.975
c174 ( 71 0 ) capacitor c=0.0133656f //x=18.43 //y=1.585
c175 ( 69 0 ) capacitor c=0.0157804f //x=18.43 //y=0.93
c176 ( 65 0 ) capacitor c=0.0822075f //x=18.055 //y=2.095
c177 ( 64 0 ) capacitor c=0.022867f //x=18.055 //y=1.74
c178 ( 63 0 ) capacitor c=0.0234318f //x=18.055 //y=1.43
c179 ( 62 0 ) capacitor c=0.0192004f //x=18.055 //y=1.085
c180 ( 61 0 ) capacitor c=0.110795f //x=18.59 //y=6.205
c181 ( 60 0 ) capacitor c=0.153847f //x=18.15 //y=6.205
c182 ( 57 0 ) capacitor c=0.00993392f //x=18.095 //y=4.885
c183 ( 55 0 ) capacitor c=0.00454201f //x=15.96 //y=1.835
c184 ( 47 0 ) capacitor c=0.0893171f //x=18.25 //y=2.26
c185 ( 35 0 ) capacitor c=0.0140918f //x=16.315 //y=1.835
c186 ( 34 0 ) capacitor c=0.00308317f //x=16.005 //y=5.39
c187 ( 33 0 ) capacitor c=0.0137261f //x=16.315 //y=5.39
c188 ( 22 0 ) capacitor c=0.00224268f //x=15.075 //y=1.835
c189 ( 21 0 ) capacitor c=0.0218623f //x=15.875 //y=1.835
c190 ( 7 0 ) capacitor c=0.110461f //x=16.4 //y=2.4
c191 ( 2 0 ) capacitor c=0.0112178f //x=16.515 //y=3.51
c192 ( 1 0 ) capacitor c=0.0678125f //x=18.135 //y=3.51
r193 (  84 85 ) resistor r=32.4568 //w=0.214 //l=0.075 //layer=ply \
 //thickness=0.18 //x=18.095 //y=4.975 //x2=18.095 //y2=5.05
r194 (  82 84 ) resistor r=20.271 //w=0.214 //l=0.09 //layer=ply \
 //thickness=0.18 //x=18.095 //y=4.885 //x2=18.095 //y2=4.975
r195 (  77 91 ) resistor r=45.1352 //w=0.168 //l=0.173853 //layer=ply \
 //thickness=0.18 //x=18.585 //y=1.43 //x2=18.545 //y2=1.585
r196 (  76 90 ) resistor r=45.1352 //w=0.168 //l=0.173853 //layer=ply \
 //thickness=0.18 //x=18.585 //y=1.085 //x2=18.545 //y2=0.93
r197 (  76 77 ) resistor r=176.904 //w=0.094 //l=0.345 //layer=ply \
 //thickness=0.18 //x=18.585 //y=1.085 //x2=18.585 //y2=1.43
r198 (  75 84 ) resistor r=16.5046 //w=0.27 //l=0.135 //layer=ply \
 //thickness=0.18 //x=18.23 //y=4.975 //x2=18.095 //y2=4.975
r199 (  74 78 ) resistor r=26.9307 //w=0.15 //l=0.106066 //layer=ply \
 //thickness=0.18 //x=18.515 //y=4.975 //x2=18.59 //y2=5.05
r200 (  74 75 ) resistor r=146.138 //w=0.094 //l=0.285 //layer=ply \
 //thickness=0.18 //x=18.515 //y=4.975 //x2=18.23 //y2=4.975
r201 (  72 89 ) resistor r=10.701 //w=0.21 //l=0.115 //layer=ply \
 //thickness=0.18 //x=18.21 //y=1.585 //x2=18.095 //y2=1.585
r202 (  71 91 ) resistor r=5.52526 //w=0.168 //l=0.115 //layer=ply \
 //thickness=0.18 //x=18.43 //y=1.585 //x2=18.545 //y2=1.585
r203 (  70 88 ) resistor r=5.52526 //w=0.168 //l=0.115 //layer=ply \
 //thickness=0.18 //x=18.21 //y=0.93 //x2=18.095 //y2=0.93
r204 (  69 90 ) resistor r=5.52526 //w=0.168 //l=0.115 //layer=ply \
 //thickness=0.18 //x=18.43 //y=0.93 //x2=18.545 //y2=0.93
r205 (  69 70 ) resistor r=112.809 //w=0.094 //l=0.22 //layer=ply \
 //thickness=0.18 //x=18.43 //y=0.93 //x2=18.21 //y2=0.93
r206 (  65 87 ) resistor r=34.8111 //w=0.27 //l=0.264953 //layer=ply \
 //thickness=0.18 //x=18.055 //y=2.095 //x2=18.25 //y2=2.26
r207 (  64 89 ) resistor r=39.5823 //w=0.21 //l=0.173853 //layer=ply \
 //thickness=0.18 //x=18.055 //y=1.74 //x2=18.095 //y2=1.585
r208 (  64 65 ) resistor r=182.032 //w=0.094 //l=0.355 //layer=ply \
 //thickness=0.18 //x=18.055 //y=1.74 //x2=18.055 //y2=2.095
r209 (  63 89 ) resistor r=39.5823 //w=0.21 //l=0.173853 //layer=ply \
 //thickness=0.18 //x=18.055 //y=1.43 //x2=18.095 //y2=1.585
r210 (  62 88 ) resistor r=45.1352 //w=0.168 //l=0.173853 //layer=ply \
 //thickness=0.18 //x=18.055 //y=1.085 //x2=18.095 //y2=0.93
r211 (  62 63 ) resistor r=176.904 //w=0.094 //l=0.345 //layer=ply \
 //thickness=0.18 //x=18.055 //y=1.085 //x2=18.055 //y2=1.43
r212 (  61 78 ) resistor r=592.245 //w=0.094 //l=1.155 //layer=ply \
 //thickness=0.18 //x=18.59 //y=6.205 //x2=18.59 //y2=5.05
r213 (  60 85 ) resistor r=592.245 //w=0.094 //l=1.155 //layer=ply \
 //thickness=0.18 //x=18.15 //y=6.205 //x2=18.15 //y2=5.05
r214 (  59 71 ) resistor r=56.4043 //w=0.094 //l=0.11 //layer=ply \
 //thickness=0.18 //x=18.32 //y=1.585 //x2=18.43 //y2=1.585
r215 (  59 72 ) resistor r=56.4043 //w=0.094 //l=0.11 //layer=ply \
 //thickness=0.18 //x=18.32 //y=1.585 //x2=18.21 //y2=1.585
r216 (  57 82 ) resistor r=152 //w=0.17 //l=0.17 //layer=licon //count=1 \
 //x=18.095 //y=4.885 //x2=18.095 //y2=4.885
r217 (  57 58 ) resistor r=7.81102 //w=0.254 //l=0.155 //layer=li \
 //thickness=0.1 //x=18.095 //y=4.885 //x2=18.25 //y2=4.885
r218 (  47 87 ) resistor r=152 //w=0.17 //l=0.17 //layer=licon //count=1 \
 //x=18.25 //y=2.26 //x2=18.25 //y2=2.26
r219 (  45 58 ) resistor r=3.23951 //w=0.254 //l=0.165 //layer=li \
 //thickness=0.1 //x=18.25 //y=4.72 //x2=18.25 //y2=4.885
r220 (  36 55 ) resistor r=5.4201 //w=0.17 //l=0.085 //layer=li \
 //thickness=0.1 //x=16.045 //y=1.835 //x2=15.96 //y2=1.835
r221 (  35 37 ) resistor r=7.15173 //w=0.17 //l=0.120208 //layer=li \
 //thickness=0.1 //x=16.315 //y=1.835 //x2=16.4 //y2=1.92
r222 (  35 36 ) resistor r=18.4813 //w=0.187 //l=0.27 //layer=li \
 //thickness=0.1 //x=16.315 //y=1.835 //x2=16.045 //y2=1.835
r223 (  33 38 ) resistor r=7.15173 //w=0.17 //l=0.120208 //layer=li \
 //thickness=0.1 //x=16.315 //y=5.39 //x2=16.4 //y2=5.305
r224 (  33 34 ) resistor r=21.2193 //w=0.187 //l=0.31 //layer=li \
 //thickness=0.1 //x=16.315 //y=5.39 //x2=16.005 //y2=5.39
r225 (  29 55 ) resistor r=1.40859 //w=0.34 //l=0.085 //layer=li \
 //thickness=0.1 //x=15.96 //y=1.75 //x2=15.96 //y2=1.835
r226 (  29 93 ) resistor r=39.016 //w=0.187 //l=0.57 //layer=li \
 //thickness=0.1 //x=15.96 //y=1.75 //x2=15.96 //y2=1.18
r227 (  23 34 ) resistor r=7.15173 //w=0.17 //l=0.120208 //layer=li \
 //thickness=0.1 //x=15.92 //y=5.475 //x2=16.005 //y2=5.39
r228 (  23 96 ) resistor r=29.0909 //w=0.187 //l=0.425 //layer=li \
 //thickness=0.1 //x=15.92 //y=5.475 //x2=15.92 //y2=5.9
r229 (  21 55 ) resistor r=5.4201 //w=0.17 //l=0.085 //layer=li \
 //thickness=0.1 //x=15.875 //y=1.835 //x2=15.96 //y2=1.835
r230 (  21 22 ) resistor r=54.7594 //w=0.187 //l=0.8 //layer=li \
 //thickness=0.1 //x=15.875 //y=1.835 //x2=15.075 //y2=1.835
r231 (  17 22 ) resistor r=7.15173 //w=0.17 //l=0.120208 //layer=li \
 //thickness=0.1 //x=14.99 //y=1.75 //x2=15.075 //y2=1.835
r232 (  17 92 ) resistor r=39.016 //w=0.187 //l=0.57 //layer=li \
 //thickness=0.1 //x=14.99 //y=1.75 //x2=14.99 //y2=1.18
r233 (  16 45 ) resistor r=6.84492 //w=0.187 //l=0.1 //layer=li \
 //thickness=0.1 //x=18.25 //y=4.62 //x2=18.25 //y2=4.72
r234 (  15 16 ) resistor r=75.9786 //w=0.187 //l=1.11 //layer=li \
 //thickness=0.1 //x=18.25 //y=3.51 //x2=18.25 //y2=4.62
r235 (  14 15 ) resistor r=25.3262 //w=0.187 //l=0.37 //layer=li \
 //thickness=0.1 //x=18.25 //y=3.14 //x2=18.25 //y2=3.51
r236 (  13 14 ) resistor r=25.3262 //w=0.187 //l=0.37 //layer=li \
 //thickness=0.1 //x=18.25 //y=2.77 //x2=18.25 //y2=3.14
r237 (  12 13 ) resistor r=25.3262 //w=0.187 //l=0.37 //layer=li \
 //thickness=0.1 //x=18.25 //y=2.4 //x2=18.25 //y2=2.77
r238 (  12 47 ) resistor r=9.58289 //w=0.187 //l=0.14 //layer=li \
 //thickness=0.1 //x=18.25 //y=2.4 //x2=18.25 //y2=2.26
r239 (  11 38 ) resistor r=46.8877 //w=0.187 //l=0.685 //layer=li \
 //thickness=0.1 //x=16.4 //y=4.62 //x2=16.4 //y2=5.305
r240 (  10 11 ) resistor r=75.9786 //w=0.187 //l=1.11 //layer=li \
 //thickness=0.1 //x=16.4 //y=3.51 //x2=16.4 //y2=4.62
r241 (  9 10 ) resistor r=25.3262 //w=0.187 //l=0.37 //layer=li \
 //thickness=0.1 //x=16.4 //y=3.14 //x2=16.4 //y2=3.51
r242 (  8 9 ) resistor r=25.3262 //w=0.187 //l=0.37 //layer=li //thickness=0.1 \
 //x=16.4 //y=2.77 //x2=16.4 //y2=3.14
r243 (  7 8 ) resistor r=25.3262 //w=0.187 //l=0.37 //layer=li //thickness=0.1 \
 //x=16.4 //y=2.4 //x2=16.4 //y2=2.77
r244 (  7 37 ) resistor r=32.8556 //w=0.187 //l=0.48 //layer=li \
 //thickness=0.1 //x=16.4 //y=2.4 //x2=16.4 //y2=1.92
r245 (  6 15 ) resistor r=9.3 //w=0.17 //l=0.17 //layer=mcon //count=1 \
 //x=18.25 //y=3.51 //x2=18.25 //y2=3.51
r246 (  4 10 ) resistor r=9.3 //w=0.17 //l=0.17 //layer=mcon //count=1 \
 //x=16.4 //y=3.51 //x2=16.4 //y2=3.51
r247 (  2 4 ) resistor r=0.0717383 //w=0.224 //l=0.115 //layer=m1 \
 //thickness=0.36 //x=16.515 //y=3.51 //x2=16.4 //y2=3.51
r248 (  1 6 ) resistor r=0.0717383 //w=0.224 //l=0.115 //layer=m1 \
 //thickness=0.36 //x=18.135 //y=3.51 //x2=18.25 //y2=3.51
r249 (  1 2 ) resistor r=1.5458 //w=0.131 //l=1.62 //layer=m1 //thickness=0.36 \
 //x=18.135 //y=3.51 //x2=16.515 //y2=3.51
ends PM_DLATCH\%Q

subckt PM_DLATCH\%noxref_10 ( 1 2 17 18 19 20 24 25 27 33 34 35 36 37 38 43 45 \
 47 53 54 56 57 60 68 70 )
c162 ( 70 0 ) capacitor c=0.028853f //x=12.56 //y=5.2
c163 ( 68 0 ) capacitor c=0.0173218f //x=12.515 //y=1.09
c164 ( 60 0 ) capacitor c=0.0354945f //x=19.025 //y=4.885
c165 ( 57 0 ) capacitor c=0.0279572f //x=18.99 //y=2.095
c166 ( 56 0 ) capacitor c=0.0422144f //x=18.99 //y=2.26
c167 ( 54 0 ) capacitor c=0.0237734f //x=19.555 //y=1.435
c168 ( 53 0 ) capacitor c=0.0191782f //x=19.555 //y=1.085
c169 ( 47 0 ) capacitor c=0.0346941f //x=19.4 //y=1.585
c170 ( 45 0 ) capacitor c=0.0157803f //x=19.4 //y=0.93
c171 ( 43 0 ) capacitor c=0.030194f //x=19.395 //y=4.975
c172 ( 38 0 ) capacitor c=0.0199921f //x=19.025 //y=1.74
c173 ( 37 0 ) capacitor c=0.0169608f //x=19.025 //y=1.435
c174 ( 36 0 ) capacitor c=0.0185462f //x=19.025 //y=1.085
c175 ( 35 0 ) capacitor c=0.15325f //x=19.47 //y=6.205
c176 ( 34 0 ) capacitor c=0.110232f //x=19.03 //y=6.205
c177 ( 27 0 ) capacitor c=0.0760752f //x=18.99 //y=2.26
c178 ( 25 0 ) capacitor c=0.00514985f //x=18.99 //y=4.72
c179 ( 24 0 ) capacitor c=0.0855616f //x=13.07 //y=4.25
c180 ( 20 0 ) capacitor c=0.00497659f //x=12.79 //y=4.76
c181 ( 19 0 ) capacitor c=0.012509f //x=12.985 //y=4.76
c182 ( 18 0 ) capacitor c=0.00612032f //x=12.785 //y=2.26
c183 ( 17 0 ) capacitor c=0.0138937f //x=12.985 //y=2.26
c184 ( 2 0 ) capacitor c=0.0119147f //x=13.185 //y=4.25
c185 ( 1 0 ) capacitor c=0.169542f //x=18.875 //y=4.25
r186 (  62 63 ) resistor r=32.4568 //w=0.214 //l=0.075 //layer=ply \
 //thickness=0.18 //x=19.025 //y=4.975 //x2=19.025 //y2=5.05
r187 (  60 62 ) resistor r=20.271 //w=0.214 //l=0.09 //layer=ply \
 //thickness=0.18 //x=19.025 //y=4.885 //x2=19.025 //y2=4.975
r188 (  56 57 ) resistor r=52.7279 //w=0.214 //l=0.165 //layer=ply \
 //thickness=0.18 //x=18.99 //y=2.26 //x2=18.99 //y2=2.095
r189 (  54 67 ) resistor r=4.95774 //w=0.164 //l=0.112 //layer=ply \
 //thickness=0.18 //x=19.555 //y=1.435 //x2=19.555 //y2=1.547
r190 (  53 66 ) resistor r=45.1352 //w=0.168 //l=0.173853 //layer=ply \
 //thickness=0.18 //x=19.555 //y=1.085 //x2=19.515 //y2=0.93
r191 (  53 54 ) resistor r=179.468 //w=0.094 //l=0.35 //layer=ply \
 //thickness=0.18 //x=19.555 //y=1.085 //x2=19.555 //y2=1.435
r192 (  48 65 ) resistor r=10.8103 //w=0.211 //l=0.115 //layer=ply \
 //thickness=0.18 //x=19.18 //y=1.585 //x2=19.065 //y2=1.585
r193 (  47 67 ) resistor r=45.9962 //w=0.164 //l=0.17296 //layer=ply \
 //thickness=0.18 //x=19.4 //y=1.585 //x2=19.555 //y2=1.547
r194 (  46 64 ) resistor r=5.52526 //w=0.168 //l=0.115 //layer=ply \
 //thickness=0.18 //x=19.18 //y=0.93 //x2=19.065 //y2=0.93
r195 (  45 66 ) resistor r=5.52526 //w=0.168 //l=0.115 //layer=ply \
 //thickness=0.18 //x=19.4 //y=0.93 //x2=19.515 //y2=0.93
r196 (  45 46 ) resistor r=112.809 //w=0.094 //l=0.22 //layer=ply \
 //thickness=0.18 //x=19.4 //y=0.93 //x2=19.18 //y2=0.93
r197 (  44 62 ) resistor r=16.5046 //w=0.27 //l=0.135 //layer=ply \
 //thickness=0.18 //x=19.16 //y=4.975 //x2=19.025 //y2=4.975
r198 (  43 50 ) resistor r=26.9307 //w=0.15 //l=0.106066 //layer=ply \
 //thickness=0.18 //x=19.395 //y=4.975 //x2=19.47 //y2=5.05
r199 (  43 44 ) resistor r=120.5 //w=0.094 //l=0.235 //layer=ply \
 //thickness=0.18 //x=19.395 //y=4.975 //x2=19.16 //y2=4.975
r200 (  38 65 ) resistor r=39.5036 //w=0.211 //l=0.173853 //layer=ply \
 //thickness=0.18 //x=19.025 //y=1.74 //x2=19.065 //y2=1.585
r201 (  38 57 ) resistor r=182.032 //w=0.094 //l=0.355 //layer=ply \
 //thickness=0.18 //x=19.025 //y=1.74 //x2=19.025 //y2=2.095
r202 (  37 65 ) resistor r=38.3614 //w=0.211 //l=0.168819 //layer=ply \
 //thickness=0.18 //x=19.025 //y=1.435 //x2=19.065 //y2=1.585
r203 (  36 64 ) resistor r=45.1352 //w=0.168 //l=0.173853 //layer=ply \
 //thickness=0.18 //x=19.025 //y=1.085 //x2=19.065 //y2=0.93
r204 (  36 37 ) resistor r=179.468 //w=0.094 //l=0.35 //layer=ply \
 //thickness=0.18 //x=19.025 //y=1.085 //x2=19.025 //y2=1.435
r205 (  35 50 ) resistor r=592.245 //w=0.094 //l=1.155 //layer=ply \
 //thickness=0.18 //x=19.47 //y=6.205 //x2=19.47 //y2=5.05
r206 (  34 63 ) resistor r=592.245 //w=0.094 //l=1.155 //layer=ply \
 //thickness=0.18 //x=19.03 //y=6.205 //x2=19.03 //y2=5.05
r207 (  33 47 ) resistor r=56.4043 //w=0.094 //l=0.11 //layer=ply \
 //thickness=0.18 //x=19.29 //y=1.585 //x2=19.4 //y2=1.585
r208 (  33 48 ) resistor r=56.4043 //w=0.094 //l=0.11 //layer=ply \
 //thickness=0.18 //x=19.29 //y=1.585 //x2=19.18 //y2=1.585
r209 (  32 60 ) resistor r=152 //w=0.17 //l=0.17 //layer=licon //count=1 \
 //x=19.025 //y=4.885 //x2=19.025 //y2=4.885
r210 (  27 56 ) resistor r=152 //w=0.17 //l=0.17 //layer=licon //count=1 \
 //x=18.99 //y=2.26 //x2=18.99 //y2=2.26
r211 (  27 30 ) resistor r=136.214 //w=0.187 //l=1.99 //layer=li \
 //thickness=0.1 //x=18.99 //y=2.26 //x2=18.99 //y2=4.25
r212 (  25 32 ) resistor r=11.332 //w=0.189 //l=0.173292 //layer=li \
 //thickness=0.1 //x=18.99 //y=4.72 //x2=19.007 //y2=4.885
r213 (  25 30 ) resistor r=32.1711 //w=0.187 //l=0.47 //layer=li \
 //thickness=0.1 //x=18.99 //y=4.72 //x2=18.99 //y2=4.25
r214 (  22 24 ) resistor r=29.0909 //w=0.187 //l=0.425 //layer=li \
 //thickness=0.1 //x=13.07 //y=4.675 //x2=13.07 //y2=4.25
r215 (  21 24 ) resistor r=130.396 //w=0.187 //l=1.905 //layer=li \
 //thickness=0.1 //x=13.07 //y=2.345 //x2=13.07 //y2=4.25
r216 (  19 22 ) resistor r=7.15173 //w=0.17 //l=0.120208 //layer=li \
 //thickness=0.1 //x=12.985 //y=4.76 //x2=13.07 //y2=4.675
r217 (  19 20 ) resistor r=13.3476 //w=0.187 //l=0.195 //layer=li \
 //thickness=0.1 //x=12.985 //y=4.76 //x2=12.79 //y2=4.76
r218 (  17 21 ) resistor r=7.15173 //w=0.17 //l=0.120208 //layer=li \
 //thickness=0.1 //x=12.985 //y=2.26 //x2=13.07 //y2=2.345
r219 (  17 18 ) resistor r=13.6898 //w=0.187 //l=0.2 //layer=li \
 //thickness=0.1 //x=12.985 //y=2.26 //x2=12.785 //y2=2.26
r220 (  11 20 ) resistor r=7.15173 //w=0.17 //l=0.120208 //layer=li \
 //thickness=0.1 //x=12.705 //y=4.845 //x2=12.79 //y2=4.76
r221 (  11 70 ) resistor r=72.5562 //w=0.187 //l=1.06 //layer=li \
 //thickness=0.1 //x=12.705 //y=4.845 //x2=12.705 //y2=5.905
r222 (  7 18 ) resistor r=7.15173 //w=0.17 //l=0.120208 //layer=li \
 //thickness=0.1 //x=12.7 //y=2.175 //x2=12.785 //y2=2.26
r223 (  7 68 ) resistor r=67.7647 //w=0.187 //l=0.99 //layer=li \
 //thickness=0.1 //x=12.7 //y=2.175 //x2=12.7 //y2=1.185
r224 (  6 30 ) resistor r=9.3 //w=0.17 //l=0.17 //layer=mcon //count=1 \
 //x=18.99 //y=4.25 //x2=18.99 //y2=4.25
r225 (  4 24 ) resistor r=9.3 //w=0.17 //l=0.17 //layer=mcon //count=1 \
 //x=13.07 //y=4.25 //x2=13.07 //y2=4.25
r226 (  2 4 ) resistor r=0.0717383 //w=0.224 //l=0.115 //layer=m1 \
 //thickness=0.36 //x=13.185 //y=4.25 //x2=13.07 //y2=4.25
r227 (  1 6 ) resistor r=0.0717383 //w=0.224 //l=0.115 //layer=m1 \
 //thickness=0.36 //x=18.875 //y=4.25 //x2=18.99 //y2=4.25
r228 (  1 2 ) resistor r=5.42939 //w=0.131 //l=5.69 //layer=m1 \
 //thickness=0.36 //x=18.875 //y=4.25 //x2=13.185 //y2=4.25
ends PM_DLATCH\%noxref_10

subckt PM_DLATCH\%noxref_11 ( 1 2 7 9 17 18 29 30 31 36 40 41 42 43 44 45 50 \
 52 54 60 61 63 64 67 75 76 79 )
c162 ( 79 0 ) capacitor c=0.0159573f //x=19.105 //y=5.205
c163 ( 76 0 ) capacitor c=0.00905936f //x=19.1 //y=1.085
c164 ( 75 0 ) capacitor c=0.007684f //x=18.13 //y=1.085
c165 ( 67 0 ) capacitor c=0.0354569f //x=15.695 //y=4.885
c166 ( 64 0 ) capacitor c=0.0279572f //x=15.66 //y=2.095
c167 ( 63 0 ) capacitor c=0.0422144f //x=15.66 //y=2.26
c168 ( 61 0 ) capacitor c=0.0237734f //x=16.225 //y=1.435
c169 ( 60 0 ) capacitor c=0.0191782f //x=16.225 //y=1.085
c170 ( 54 0 ) capacitor c=0.0346941f //x=16.07 //y=1.585
c171 ( 52 0 ) capacitor c=0.0157803f //x=16.07 //y=0.93
c172 ( 50 0 ) capacitor c=0.0295389f //x=16.065 //y=4.975
c173 ( 45 0 ) capacitor c=0.0199921f //x=15.695 //y=1.74
c174 ( 44 0 ) capacitor c=0.0169608f //x=15.695 //y=1.435
c175 ( 43 0 ) capacitor c=0.0185462f //x=15.695 //y=1.085
c176 ( 42 0 ) capacitor c=0.15325f //x=16.14 //y=6.205
c177 ( 41 0 ) capacitor c=0.110232f //x=15.7 //y=6.205
c178 ( 39 0 ) capacitor c=0.00454201f //x=19.29 //y=1.835
c179 ( 36 0 ) capacitor c=0.128643f //x=19.73 //y=3.88
c180 ( 31 0 ) capacitor c=0.0141769f //x=19.645 //y=1.835
c181 ( 30 0 ) capacitor c=0.00326058f //x=19.335 //y=5.39
c182 ( 29 0 ) capacitor c=0.014f //x=19.645 //y=5.39
c183 ( 18 0 ) capacitor c=0.00217843f //x=18.405 //y=1.835
c184 ( 17 0 ) capacitor c=0.0212471f //x=19.205 //y=1.835
c185 ( 9 0 ) capacitor c=0.0762833f //x=15.66 //y=2.26
c186 ( 7 0 ) capacitor c=0.00514991f //x=15.66 //y=4.72
c187 ( 2 0 ) capacitor c=0.00669602f //x=15.775 //y=3.88
c188 ( 1 0 ) capacitor c=0.100901f //x=19.615 //y=3.88
r189 (  69 70 ) resistor r=32.4568 //w=0.214 //l=0.075 //layer=ply \
 //thickness=0.18 //x=15.695 //y=4.975 //x2=15.695 //y2=5.05
r190 (  67 69 ) resistor r=20.271 //w=0.214 //l=0.09 //layer=ply \
 //thickness=0.18 //x=15.695 //y=4.885 //x2=15.695 //y2=4.975
r191 (  63 64 ) resistor r=52.7279 //w=0.214 //l=0.165 //layer=ply \
 //thickness=0.18 //x=15.66 //y=2.26 //x2=15.66 //y2=2.095
r192 (  61 74 ) resistor r=4.95774 //w=0.164 //l=0.112 //layer=ply \
 //thickness=0.18 //x=16.225 //y=1.435 //x2=16.225 //y2=1.547
r193 (  60 73 ) resistor r=45.1352 //w=0.168 //l=0.173853 //layer=ply \
 //thickness=0.18 //x=16.225 //y=1.085 //x2=16.185 //y2=0.93
r194 (  60 61 ) resistor r=179.468 //w=0.094 //l=0.35 //layer=ply \
 //thickness=0.18 //x=16.225 //y=1.085 //x2=16.225 //y2=1.435
r195 (  55 72 ) resistor r=10.8103 //w=0.211 //l=0.115 //layer=ply \
 //thickness=0.18 //x=15.85 //y=1.585 //x2=15.735 //y2=1.585
r196 (  54 74 ) resistor r=45.9962 //w=0.164 //l=0.17296 //layer=ply \
 //thickness=0.18 //x=16.07 //y=1.585 //x2=16.225 //y2=1.547
r197 (  53 71 ) resistor r=5.52526 //w=0.168 //l=0.115 //layer=ply \
 //thickness=0.18 //x=15.85 //y=0.93 //x2=15.735 //y2=0.93
r198 (  52 73 ) resistor r=5.52526 //w=0.168 //l=0.115 //layer=ply \
 //thickness=0.18 //x=16.07 //y=0.93 //x2=16.185 //y2=0.93
r199 (  52 53 ) resistor r=112.809 //w=0.094 //l=0.22 //layer=ply \
 //thickness=0.18 //x=16.07 //y=0.93 //x2=15.85 //y2=0.93
r200 (  51 69 ) resistor r=16.5046 //w=0.27 //l=0.135 //layer=ply \
 //thickness=0.18 //x=15.83 //y=4.975 //x2=15.695 //y2=4.975
r201 (  50 57 ) resistor r=26.9307 //w=0.15 //l=0.106066 //layer=ply \
 //thickness=0.18 //x=16.065 //y=4.975 //x2=16.14 //y2=5.05
r202 (  50 51 ) resistor r=120.5 //w=0.094 //l=0.235 //layer=ply \
 //thickness=0.18 //x=16.065 //y=4.975 //x2=15.83 //y2=4.975
r203 (  45 72 ) resistor r=39.5036 //w=0.211 //l=0.173853 //layer=ply \
 //thickness=0.18 //x=15.695 //y=1.74 //x2=15.735 //y2=1.585
r204 (  45 64 ) resistor r=182.032 //w=0.094 //l=0.355 //layer=ply \
 //thickness=0.18 //x=15.695 //y=1.74 //x2=15.695 //y2=2.095
r205 (  44 72 ) resistor r=38.3614 //w=0.211 //l=0.168819 //layer=ply \
 //thickness=0.18 //x=15.695 //y=1.435 //x2=15.735 //y2=1.585
r206 (  43 71 ) resistor r=45.1352 //w=0.168 //l=0.173853 //layer=ply \
 //thickness=0.18 //x=15.695 //y=1.085 //x2=15.735 //y2=0.93
r207 (  43 44 ) resistor r=179.468 //w=0.094 //l=0.35 //layer=ply \
 //thickness=0.18 //x=15.695 //y=1.085 //x2=15.695 //y2=1.435
r208 (  42 57 ) resistor r=592.245 //w=0.094 //l=1.155 //layer=ply \
 //thickness=0.18 //x=16.14 //y=6.205 //x2=16.14 //y2=5.05
r209 (  41 70 ) resistor r=592.245 //w=0.094 //l=1.155 //layer=ply \
 //thickness=0.18 //x=15.7 //y=6.205 //x2=15.7 //y2=5.05
r210 (  40 54 ) resistor r=56.4043 //w=0.094 //l=0.11 //layer=ply \
 //thickness=0.18 //x=15.96 //y=1.585 //x2=16.07 //y2=1.585
r211 (  40 55 ) resistor r=56.4043 //w=0.094 //l=0.11 //layer=ply \
 //thickness=0.18 //x=15.96 //y=1.585 //x2=15.85 //y2=1.585
r212 (  38 67 ) resistor r=152 //w=0.17 //l=0.17 //layer=licon //count=1 \
 //x=15.695 //y=4.885 //x2=15.695 //y2=4.885
r213 (  34 36 ) resistor r=97.5401 //w=0.187 //l=1.425 //layer=li \
 //thickness=0.1 //x=19.73 //y=5.305 //x2=19.73 //y2=3.88
r214 (  33 36 ) resistor r=134.16 //w=0.187 //l=1.96 //layer=li \
 //thickness=0.1 //x=19.73 //y=1.92 //x2=19.73 //y2=3.88
r215 (  32 39 ) resistor r=5.4201 //w=0.17 //l=0.085 //layer=li \
 //thickness=0.1 //x=19.375 //y=1.835 //x2=19.29 //y2=1.835
r216 (  31 33 ) resistor r=7.15173 //w=0.17 //l=0.120208 //layer=li \
 //thickness=0.1 //x=19.645 //y=1.835 //x2=19.73 //y2=1.92
r217 (  31 32 ) resistor r=18.4813 //w=0.187 //l=0.27 //layer=li \
 //thickness=0.1 //x=19.645 //y=1.835 //x2=19.375 //y2=1.835
r218 (  29 34 ) resistor r=7.15173 //w=0.17 //l=0.120208 //layer=li \
 //thickness=0.1 //x=19.645 //y=5.39 //x2=19.73 //y2=5.305
r219 (  29 30 ) resistor r=21.2193 //w=0.187 //l=0.31 //layer=li \
 //thickness=0.1 //x=19.645 //y=5.39 //x2=19.335 //y2=5.39
r220 (  25 39 ) resistor r=1.40859 //w=0.34 //l=0.085 //layer=li \
 //thickness=0.1 //x=19.29 //y=1.75 //x2=19.29 //y2=1.835
r221 (  25 76 ) resistor r=39.016 //w=0.187 //l=0.57 //layer=li \
 //thickness=0.1 //x=19.29 //y=1.75 //x2=19.29 //y2=1.18
r222 (  19 30 ) resistor r=7.15173 //w=0.17 //l=0.120208 //layer=li \
 //thickness=0.1 //x=19.25 //y=5.475 //x2=19.335 //y2=5.39
r223 (  19 79 ) resistor r=29.0909 //w=0.187 //l=0.425 //layer=li \
 //thickness=0.1 //x=19.25 //y=5.475 //x2=19.25 //y2=5.9
r224 (  17 39 ) resistor r=5.4201 //w=0.17 //l=0.085 //layer=li \
 //thickness=0.1 //x=19.205 //y=1.835 //x2=19.29 //y2=1.835
r225 (  17 18 ) resistor r=54.7594 //w=0.187 //l=0.8 //layer=li \
 //thickness=0.1 //x=19.205 //y=1.835 //x2=18.405 //y2=1.835
r226 (  13 18 ) resistor r=7.15173 //w=0.17 //l=0.120208 //layer=li \
 //thickness=0.1 //x=18.32 //y=1.75 //x2=18.405 //y2=1.835
r227 (  13 75 ) resistor r=39.016 //w=0.187 //l=0.57 //layer=li \
 //thickness=0.1 //x=18.32 //y=1.75 //x2=18.32 //y2=1.18
r228 (  9 63 ) resistor r=152 //w=0.17 //l=0.17 //layer=licon //count=1 \
 //x=15.66 //y=2.26 //x2=15.66 //y2=2.26
r229 (  9 12 ) resistor r=110.888 //w=0.187 //l=1.62 //layer=li \
 //thickness=0.1 //x=15.66 //y=2.26 //x2=15.66 //y2=3.88
r230 (  7 38 ) resistor r=11.332 //w=0.189 //l=0.173292 //layer=li \
 //thickness=0.1 //x=15.66 //y=4.72 //x2=15.677 //y2=4.885
r231 (  7 12 ) resistor r=57.4973 //w=0.187 //l=0.84 //layer=li \
 //thickness=0.1 //x=15.66 //y=4.72 //x2=15.66 //y2=3.88
r232 (  6 36 ) resistor r=9.3 //w=0.17 //l=0.17 //layer=mcon //count=1 \
 //x=19.73 //y=3.88 //x2=19.73 //y2=3.88
r233 (  4 12 ) resistor r=9.3 //w=0.17 //l=0.17 //layer=mcon //count=1 \
 //x=15.66 //y=3.88 //x2=15.66 //y2=3.88
r234 (  2 4 ) resistor r=0.0717383 //w=0.224 //l=0.115 //layer=m1 \
 //thickness=0.36 //x=15.775 //y=3.88 //x2=15.66 //y2=3.88
r235 (  1 6 ) resistor r=0.0717383 //w=0.224 //l=0.115 //layer=m1 \
 //thickness=0.36 //x=19.615 //y=3.88 //x2=19.73 //y2=3.88
r236 (  1 2 ) resistor r=3.66412 //w=0.131 //l=3.84 //layer=m1 \
 //thickness=0.36 //x=19.615 //y=3.88 //x2=15.775 //y2=3.88
ends PM_DLATCH\%noxref_11

subckt PM_DLATCH\%noxref_12 ( 1 5 9 10 13 17 29 )
c55 ( 29 0 ) capacitor c=0.0631306f //x=3.27 //y=0.545
c56 ( 17 0 ) capacitor c=0.00722223f //x=5.345 //y=0.795
c57 ( 13 0 ) capacitor c=0.0149611f //x=5.26 //y=0.71
c58 ( 10 0 ) capacitor c=0.00698743f //x=4.375 //y=1.675
c59 ( 9 0 ) capacitor c=0.006761f //x=4.375 //y=0.795
c60 ( 5 0 ) capacitor c=0.0207245f //x=4.29 //y=1.76
c61 ( 1 0 ) capacitor c=0.00856252f //x=3.405 //y=1.675
r62 (  17 29 ) resistor r=3.57586 //w=0.17 //l=0.125 //layer=li \
 //thickness=0.1 //x=5.345 //y=0.795 //x2=5.345 //y2=0.67
r63 (  17 29 ) resistor r=18.139 //w=0.187 //l=0.265 //layer=li \
 //thickness=0.1 //x=5.345 //y=0.795 //x2=5.345 //y2=1.06
r64 (  14 29 ) resistor r=3.57586 //w=0.17 //l=0.103078 //layer=li \
 //thickness=0.1 //x=4.46 //y=0.71 //x2=4.375 //y2=0.67
r65 (  14 29 ) resistor r=27.3797 //w=0.187 //l=0.4 //layer=li //thickness=0.1 \
 //x=4.46 //y=0.71 //x2=4.86 //y2=0.71
r66 (  13 29 ) resistor r=3.57586 //w=0.17 //l=0.103078 //layer=li \
 //thickness=0.1 //x=5.26 //y=0.71 //x2=5.345 //y2=0.67
r67 (  13 29 ) resistor r=27.3797 //w=0.187 //l=0.4 //layer=li //thickness=0.1 \
 //x=5.26 //y=0.71 //x2=4.86 //y2=0.71
r68 (  10 29 ) resistor r=3.57586 //w=0.17 //l=0.125 //layer=li \
 //thickness=0.1 //x=4.375 //y=1.675 //x2=4.375 //y2=1.8
r69 (  10 29 ) resistor r=42.0963 //w=0.187 //l=0.615 //layer=li \
 //thickness=0.1 //x=4.375 //y=1.675 //x2=4.375 //y2=1.06
r70 (  9 29 ) resistor r=3.57586 //w=0.17 //l=0.125 //layer=li //thickness=0.1 \
 //x=4.375 //y=0.795 //x2=4.375 //y2=0.67
r71 (  9 29 ) resistor r=18.139 //w=0.187 //l=0.265 //layer=li //thickness=0.1 \
 //x=4.375 //y=0.795 //x2=4.375 //y2=1.06
r72 (  6 29 ) resistor r=3.57586 //w=0.17 //l=0.103078 //layer=li \
 //thickness=0.1 //x=3.49 //y=1.76 //x2=3.405 //y2=1.8
r73 (  6 29 ) resistor r=27.3797 //w=0.187 //l=0.4 //layer=li //thickness=0.1 \
 //x=3.49 //y=1.76 //x2=3.89 //y2=1.76
r74 (  5 29 ) resistor r=3.57586 //w=0.17 //l=0.103078 //layer=li \
 //thickness=0.1 //x=4.29 //y=1.76 //x2=4.375 //y2=1.8
r75 (  5 29 ) resistor r=27.3797 //w=0.187 //l=0.4 //layer=li //thickness=0.1 \
 //x=4.29 //y=1.76 //x2=3.89 //y2=1.76
r76 (  1 29 ) resistor r=3.57586 //w=0.17 //l=0.125 //layer=li //thickness=0.1 \
 //x=3.405 //y=1.675 //x2=3.405 //y2=1.8
r77 (  1 29 ) resistor r=42.0963 //w=0.187 //l=0.615 //layer=li \
 //thickness=0.1 //x=3.405 //y=1.675 //x2=3.405 //y2=1.06
ends PM_DLATCH\%noxref_12

subckt PM_DLATCH\%noxref_13 ( 1 5 9 10 13 17 29 )
c54 ( 29 0 ) capacitor c=0.0633899f //x=8.82 //y=0.545
c55 ( 17 0 ) capacitor c=0.00722223f //x=10.895 //y=0.795
c56 ( 13 0 ) capacitor c=0.0149613f //x=10.81 //y=0.71
c57 ( 10 0 ) capacitor c=0.00687696f //x=9.925 //y=1.675
c58 ( 9 0 ) capacitor c=0.006761f //x=9.925 //y=0.795
c59 ( 5 0 ) capacitor c=0.0199444f //x=9.84 //y=1.76
c60 ( 1 0 ) capacitor c=0.00798521f //x=8.955 //y=1.675
r61 (  17 29 ) resistor r=3.57586 //w=0.17 //l=0.125 //layer=li \
 //thickness=0.1 //x=10.895 //y=0.795 //x2=10.895 //y2=0.67
r62 (  17 29 ) resistor r=18.139 //w=0.187 //l=0.265 //layer=li \
 //thickness=0.1 //x=10.895 //y=0.795 //x2=10.895 //y2=1.06
r63 (  14 29 ) resistor r=3.57586 //w=0.17 //l=0.103078 //layer=li \
 //thickness=0.1 //x=10.01 //y=0.71 //x2=9.925 //y2=0.67
r64 (  14 29 ) resistor r=27.3797 //w=0.187 //l=0.4 //layer=li //thickness=0.1 \
 //x=10.01 //y=0.71 //x2=10.41 //y2=0.71
r65 (  13 29 ) resistor r=3.57586 //w=0.17 //l=0.103078 //layer=li \
 //thickness=0.1 //x=10.81 //y=0.71 //x2=10.895 //y2=0.67
r66 (  13 29 ) resistor r=27.3797 //w=0.187 //l=0.4 //layer=li //thickness=0.1 \
 //x=10.81 //y=0.71 //x2=10.41 //y2=0.71
r67 (  10 29 ) resistor r=3.57586 //w=0.17 //l=0.125 //layer=li \
 //thickness=0.1 //x=9.925 //y=1.675 //x2=9.925 //y2=1.8
r68 (  10 29 ) resistor r=42.0963 //w=0.187 //l=0.615 //layer=li \
 //thickness=0.1 //x=9.925 //y=1.675 //x2=9.925 //y2=1.06
r69 (  9 29 ) resistor r=3.57586 //w=0.17 //l=0.125 //layer=li //thickness=0.1 \
 //x=9.925 //y=0.795 //x2=9.925 //y2=0.67
r70 (  9 29 ) resistor r=18.139 //w=0.187 //l=0.265 //layer=li //thickness=0.1 \
 //x=9.925 //y=0.795 //x2=9.925 //y2=1.06
r71 (  6 29 ) resistor r=3.57586 //w=0.17 //l=0.103078 //layer=li \
 //thickness=0.1 //x=9.04 //y=1.76 //x2=8.955 //y2=1.8
r72 (  6 29 ) resistor r=27.3797 //w=0.187 //l=0.4 //layer=li //thickness=0.1 \
 //x=9.04 //y=1.76 //x2=9.44 //y2=1.76
r73 (  5 29 ) resistor r=3.57586 //w=0.17 //l=0.103078 //layer=li \
 //thickness=0.1 //x=9.84 //y=1.76 //x2=9.925 //y2=1.8
r74 (  5 29 ) resistor r=27.3797 //w=0.187 //l=0.4 //layer=li //thickness=0.1 \
 //x=9.84 //y=1.76 //x2=9.44 //y2=1.76
r75 (  1 29 ) resistor r=3.57586 //w=0.17 //l=0.125 //layer=li //thickness=0.1 \
 //x=8.955 //y=1.675 //x2=8.955 //y2=1.8
r76 (  1 29 ) resistor r=42.0963 //w=0.187 //l=0.615 //layer=li \
 //thickness=0.1 //x=8.955 //y=1.675 //x2=8.955 //y2=1.06
ends PM_DLATCH\%noxref_13

subckt PM_DLATCH\%noxref_14 ( 7 8 15 16 23 24 25 )
c43 ( 25 0 ) capacitor c=0.0306628f //x=16.215 //y=5.205
c44 ( 24 0 ) capacitor c=0.0185379f //x=15.335 //y=5.205
c45 ( 23 0 ) capacitor c=0.0409962f //x=14.465 //y=5.205
c46 ( 16 0 ) capacitor c=0.00193672f //x=15.565 //y=7.09
c47 ( 15 0 ) capacitor c=0.0129692f //x=16.275 //y=7.09
c48 ( 8 0 ) capacitor c=0.00576007f //x=14.685 //y=5.39
c49 ( 7 0 ) capacitor c=0.0170172f //x=15.395 //y=5.39
r50 (  17 25 ) resistor r=5.81818 //w=0.187 //l=0.085 //layer=li \
 //thickness=0.1 //x=16.36 //y=7.005 //x2=16.36 //y2=6.92
r51 (  15 17 ) resistor r=7.15173 //w=0.17 //l=0.120208 //layer=li \
 //thickness=0.1 //x=16.275 //y=7.09 //x2=16.36 //y2=7.005
r52 (  15 16 ) resistor r=48.5989 //w=0.187 //l=0.71 //layer=li \
 //thickness=0.1 //x=16.275 //y=7.09 //x2=15.565 //y2=7.09
r53 (  10 16 ) resistor r=7.15173 //w=0.17 //l=0.120208 //layer=li \
 //thickness=0.1 //x=15.48 //y=7.005 //x2=15.565 //y2=7.09
r54 (  10 24 ) resistor r=29.0909 //w=0.187 //l=0.425 //layer=li \
 //thickness=0.1 //x=15.48 //y=7.005 //x2=15.48 //y2=6.58
r55 (  9 24 ) resistor r=29.0909 //w=0.187 //l=0.425 //layer=li \
 //thickness=0.1 //x=15.48 //y=5.475 //x2=15.48 //y2=5.9
r56 (  7 9 ) resistor r=7.15173 //w=0.17 //l=0.120208 //layer=li \
 //thickness=0.1 //x=15.395 //y=5.39 //x2=15.48 //y2=5.475
r57 (  7 8 ) resistor r=48.5989 //w=0.187 //l=0.71 //layer=li //thickness=0.1 \
 //x=15.395 //y=5.39 //x2=14.685 //y2=5.39
r58 (  1 8 ) resistor r=7.15173 //w=0.17 //l=0.120208 //layer=li \
 //thickness=0.1 //x=14.6 //y=5.475 //x2=14.685 //y2=5.39
r59 (  1 23 ) resistor r=29.0909 //w=0.187 //l=0.425 //layer=li \
 //thickness=0.1 //x=14.6 //y=5.475 //x2=14.6 //y2=5.9
ends PM_DLATCH\%noxref_14

subckt PM_DLATCH\%noxref_15 ( 7 8 15 16 23 24 25 )
c42 ( 25 0 ) capacitor c=0.0307189f //x=19.545 //y=5.205
c43 ( 24 0 ) capacitor c=0.0185379f //x=18.665 //y=5.205
c44 ( 23 0 ) capacitor c=0.0410313f //x=17.795 //y=5.205
c45 ( 16 0 ) capacitor c=0.00193672f //x=18.895 //y=7.09
c46 ( 15 0 ) capacitor c=0.0132919f //x=19.605 //y=7.09
c47 ( 8 0 ) capacitor c=0.0056411f //x=18.015 //y=5.39
c48 ( 7 0 ) capacitor c=0.0169676f //x=18.725 //y=5.39
r49 (  17 25 ) resistor r=5.81818 //w=0.187 //l=0.085 //layer=li \
 //thickness=0.1 //x=19.69 //y=7.005 //x2=19.69 //y2=6.92
r50 (  15 17 ) resistor r=7.15173 //w=0.17 //l=0.120208 //layer=li \
 //thickness=0.1 //x=19.605 //y=7.09 //x2=19.69 //y2=7.005
r51 (  15 16 ) resistor r=48.5989 //w=0.187 //l=0.71 //layer=li \
 //thickness=0.1 //x=19.605 //y=7.09 //x2=18.895 //y2=7.09
r52 (  10 16 ) resistor r=7.15173 //w=0.17 //l=0.120208 //layer=li \
 //thickness=0.1 //x=18.81 //y=7.005 //x2=18.895 //y2=7.09
r53 (  10 24 ) resistor r=29.0909 //w=0.187 //l=0.425 //layer=li \
 //thickness=0.1 //x=18.81 //y=7.005 //x2=18.81 //y2=6.58
r54 (  9 24 ) resistor r=29.0909 //w=0.187 //l=0.425 //layer=li \
 //thickness=0.1 //x=18.81 //y=5.475 //x2=18.81 //y2=5.9
r55 (  7 9 ) resistor r=7.15173 //w=0.17 //l=0.120208 //layer=li \
 //thickness=0.1 //x=18.725 //y=5.39 //x2=18.81 //y2=5.475
r56 (  7 8 ) resistor r=48.5989 //w=0.187 //l=0.71 //layer=li //thickness=0.1 \
 //x=18.725 //y=5.39 //x2=18.015 //y2=5.39
r57 (  1 8 ) resistor r=7.15173 //w=0.17 //l=0.120208 //layer=li \
 //thickness=0.1 //x=17.93 //y=5.475 //x2=18.015 //y2=5.39
r58 (  1 23 ) resistor r=29.0909 //w=0.187 //l=0.425 //layer=li \
 //thickness=0.1 //x=17.93 //y=5.475 //x2=17.93 //y2=5.9
ends PM_DLATCH\%noxref_15
