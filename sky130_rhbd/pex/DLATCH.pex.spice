// File: DLATCH.spi.pex
// Created: Thu Jan 22 07:05:41 2026
// Program "Calibre xRC"
// Version "v2023.2_27.15"
// Nominal Temperature: 30C
// Circuit Temperature: 30C
//
simulator lang=spectre
subckt PM_DLATCH\%noxref_1 ( 2 4 5 6 7 8 10 11 12 14 15 18 25 29 31 34 35 42 \
 44 45 53 65 74 78 79 80 81 82 83 84 88 90 93 94 104 107 109 )
c220 ( 107 0 ) capacitor c=0.00875839f //x=1.415 //y=1.09
c221 ( 104 0 ) capacitor c=0.0644594f //x=3.82 //y=4.88
c222 ( 94 0 ) capacitor c=0.0318956f //x=4.155 //y=1.39
c223 ( 93 0 ) capacitor c=0.0186809f //x=4.155 //y=1.045
c224 ( 90 0 ) capacitor c=0.0141821f //x=4 //y=1.545
c225 ( 88 0 ) capacitor c=0.0158553f //x=4 //y=0.89
c226 ( 84 0 ) capacitor c=0.088055f //x=3.625 //y=2.095
c227 ( 83 0 ) capacitor c=0.0229235f //x=3.625 //y=1.7
c228 ( 82 0 ) capacitor c=0.0234359f //x=3.625 //y=1.39
c229 ( 81 0 ) capacitor c=0.0198759f //x=3.625 //y=1.045
c230 ( 80 0 ) capacitor c=0.110369f //x=4.16 //y=6.2
c231 ( 79 0 ) capacitor c=0.154619f //x=3.72 //y=6.2
c232 ( 74 0 ) capacitor c=8.13425e-19 //x=3.82 //y=4.88
c233 ( 65 0 ) capacitor c=7.85889e-19 //x=3.82 //y=2.26
c234 ( 53 0 ) capacitor c=0.0262474f //x=1.605 //y=5.56
c235 ( 45 0 ) capacitor c=0.0507769f //x=3.67 //y=3.872
c236 ( 44 0 ) capacitor c=0.00312991f //x=3.83 //y=3.865
c237 ( 42 0 ) capacitor c=0.00268304f //x=2.125 //y=3.872
c238 ( 35 0 ) capacitor c=0.018119f //x=3.822 //y=4.74
c239 ( 34 0 ) capacitor c=0.00598864f //x=3.82 //y=4.88
c240 ( 31 0 ) capacitor c=0.00594663f //x=3.82 //y=2.26
c241 ( 29 0 ) capacitor c=0.016442f //x=3.82 //y=3.88
c242 ( 25 0 ) capacitor c=0.0173193f //x=1.97 //y=3.88
c243 ( 18 0 ) capacitor c=0.0191371f //x=1.6 //y=1.185
c244 ( 15 0 ) capacitor c=0.0122016f //x=3.82 //y=4.025
c245 ( 14 0 ) capacitor c=0.0374247f //x=3.82 //y=3.72
c246 ( 12 0 ) capacitor c=0.020111f //x=1.97 //y=5.055
c247 ( 11 0 ) capacitor c=0.0122401f //x=1.97 //y=4.025
c248 ( 10 0 ) capacitor c=0.0458323f //x=1.97 //y=3.72
c249 ( 8 0 ) capacitor c=0.00632795f //x=1.69 //y=5.14
c250 ( 7 0 ) capacitor c=0.00726293f //x=1.885 //y=5.14
c251 ( 6 0 ) capacitor c=0.00882254f //x=1.685 //y=2.02
c252 ( 5 0 ) capacitor c=0.012819f //x=1.885 //y=2.02
c253 ( 4 0 ) capacitor c=0.0119203f //x=1.605 //y=5.42
c254 ( 2 0 ) capacitor c=0.0184708f //x=1.6 //y=1.935
r255 (  102 104 ) resistor r=20.6867 //w=0.233 //l=0.1 //layer=ply \
 //thickness=0.18 //x=3.72 //y=4.88 //x2=3.82 //y2=4.88
r256 (  95 104 ) resistor r=70.3348 //w=0.233 //l=0.414367 //layer=ply \
 //thickness=0.18 //x=4.16 //y=5.045 //x2=3.82 //y2=4.88
r257 (  94 106 ) resistor r=45.1352 //w=0.168 //l=0.173853 //layer=ply \
 //thickness=0.18 //x=4.155 //y=1.39 //x2=4.115 //y2=1.545
r258 (  93 105 ) resistor r=45.1352 //w=0.168 //l=0.173853 //layer=ply \
 //thickness=0.18 //x=4.155 //y=1.045 //x2=4.115 //y2=0.89
r259 (  93 94 ) resistor r=176.904 //w=0.094 //l=0.345 //layer=ply \
 //thickness=0.18 //x=4.155 //y=1.045 //x2=4.155 //y2=1.39
r260 (  91 101 ) resistor r=10.701 //w=0.21 //l=0.115 //layer=ply \
 //thickness=0.18 //x=3.78 //y=1.545 //x2=3.665 //y2=1.545
r261 (  90 106 ) resistor r=5.52526 //w=0.168 //l=0.115 //layer=ply \
 //thickness=0.18 //x=4 //y=1.545 //x2=4.115 //y2=1.545
r262 (  89 100 ) resistor r=5.52526 //w=0.168 //l=0.115 //layer=ply \
 //thickness=0.18 //x=3.78 //y=0.89 //x2=3.665 //y2=0.89
r263 (  88 105 ) resistor r=5.52526 //w=0.168 //l=0.115 //layer=ply \
 //thickness=0.18 //x=4 //y=0.89 //x2=4.115 //y2=0.89
r264 (  88 89 ) resistor r=112.809 //w=0.094 //l=0.22 //layer=ply \
 //thickness=0.18 //x=4 //y=0.89 //x2=3.78 //y2=0.89
r265 (  85 102 ) resistor r=13.0941 //w=0.233 //l=0.165 //layer=ply \
 //thickness=0.18 //x=3.72 //y=5.045 //x2=3.72 //y2=4.88
r266 (  84 99 ) resistor r=34.8111 //w=0.27 //l=0.264953 //layer=ply \
 //thickness=0.18 //x=3.625 //y=2.095 //x2=3.82 //y2=2.26
r267 (  83 101 ) resistor r=39.5823 //w=0.21 //l=0.173853 //layer=ply \
 //thickness=0.18 //x=3.625 //y=1.7 //x2=3.665 //y2=1.545
r268 (  83 84 ) resistor r=202.543 //w=0.094 //l=0.395 //layer=ply \
 //thickness=0.18 //x=3.625 //y=1.7 //x2=3.625 //y2=2.095
r269 (  82 101 ) resistor r=39.5823 //w=0.21 //l=0.173853 //layer=ply \
 //thickness=0.18 //x=3.625 //y=1.39 //x2=3.665 //y2=1.545
r270 (  81 100 ) resistor r=45.1352 //w=0.168 //l=0.173853 //layer=ply \
 //thickness=0.18 //x=3.625 //y=1.045 //x2=3.665 //y2=0.89
r271 (  81 82 ) resistor r=176.904 //w=0.094 //l=0.345 //layer=ply \
 //thickness=0.18 //x=3.625 //y=1.045 //x2=3.625 //y2=1.39
r272 (  80 95 ) resistor r=592.245 //w=0.094 //l=1.155 //layer=ply \
 //thickness=0.18 //x=4.16 //y=6.2 //x2=4.16 //y2=5.045
r273 (  79 85 ) resistor r=592.245 //w=0.094 //l=1.155 //layer=ply \
 //thickness=0.18 //x=3.72 //y=6.2 //x2=3.72 //y2=5.045
r274 (  78 90 ) resistor r=56.4043 //w=0.094 //l=0.11 //layer=ply \
 //thickness=0.18 //x=3.89 //y=1.545 //x2=4 //y2=1.545
r275 (  78 91 ) resistor r=56.4043 //w=0.094 //l=0.11 //layer=ply \
 //thickness=0.18 //x=3.89 //y=1.545 //x2=3.78 //y2=1.545
r276 (  74 104 ) resistor r=152 //w=0.17 //l=0.17 //layer=licon //count=1 \
 //x=3.82 //y=4.88 //x2=3.82 //y2=4.88
r277 (  65 99 ) resistor r=152 //w=0.17 //l=0.17 //layer=licon //count=1 \
 //x=3.82 //y=2.26 //x2=3.82 //y2=2.26
r278 (  53 109 ) resistor r=23.615 //w=0.187 //l=0.345 //layer=li \
 //thickness=0.1 //x=1.605 //y=5.56 //x2=1.605 //y2=5.905
r279 (  44 45 ) resistor r=0.107671 //w=0.266 //l=0.16 //layer=m2 \
 //thickness=0.36 //x=3.83 //y=3.872 //x2=3.67 //y2=3.872
r280 (  42 45 ) resistor r=1.47424 //w=0.131 //l=1.545 //layer=m2 \
 //thickness=0.36 //x=2.125 //y=3.88 //x2=3.67 //y2=3.88
r281 (  40 42 ) resistor r=0.107671 //w=0.266 //l=0.16 //layer=m2 \
 //thickness=0.36 //x=1.965 //y=3.872 //x2=2.125 //y2=3.872
r282 (  34 74 ) resistor r=9.3 //w=0.17 //l=0.17 //layer=mcon //count=1 \
 //x=3.82 //y=4.88 //x2=3.82 //y2=4.88
r283 (  34 35 ) resistor r=0.103207 //w=0.196 //l=0.14 //layer=m1 \
 //thickness=0.36 //x=3.822 //y=4.88 //x2=3.822 //y2=4.74
r284 (  31 65 ) resistor r=9.3 //w=0.17 //l=0.17 //layer=mcon //count=1 \
 //x=3.82 //y=2.26 //x2=3.82 //y2=2.26
r285 (  27 44 ) resistor r=4.5 //w=0.15 //l=0.15 //layer=via1 //count=1 \
 //x=3.83 //y=3.865 //x2=3.83 //y2=3.865
r286 (  27 29 ) resistor r=0.00487013 //w=0.385 //l=0.015 //layer=m1 \
 //thickness=0.36 //x=3.772 //y=3.865 //x2=3.772 //y2=3.88
r287 (  23 40 ) resistor r=4.5 //w=0.15 //l=0.15 //layer=via1 //count=1 \
 //x=1.965 //y=3.865 //x2=1.965 //y2=3.865
r288 (  23 25 ) resistor r=0.00490838 //w=0.382 //l=0.015 //layer=m1 \
 //thickness=0.36 //x=2.02 //y=3.865 //x2=2.02 //y2=3.88
r289 (  21 53 ) resistor r=9.3 //w=0.17 //l=0.17 //layer=mcon //count=1 \
 //x=1.605 //y=5.56 //x2=1.605 //y2=5.56
r290 (  18 107 ) resistor r=9.3 //w=0.17 //l=0.17 //layer=mcon //count=1 \
 //x=1.6 //y=1.185 //x2=1.6 //y2=1.185
r291 (  15 29 ) resistor r=0.0866666 //w=0.385 //l=0.167287 //layer=m1 \
 //thickness=0.36 //x=3.82 //y=4.025 //x2=3.772 //y2=3.88
r292 (  15 35 ) resistor r=0.682252 //w=0.131 //l=0.715 //layer=m1 \
 //thickness=0.36 //x=3.82 //y=4.025 //x2=3.82 //y2=4.74
r293 (  14 27 ) resistor r=0.0866666 //w=0.385 //l=0.167287 //layer=m1 \
 //thickness=0.36 //x=3.82 //y=3.72 //x2=3.772 //y2=3.865
r294 (  13 31 ) resistor r=0.0933015 //w=0.201 //l=0.125 //layer=m1 \
 //thickness=0.36 //x=3.82 //y=2.385 //x2=3.82 //y2=2.26
r295 (  13 14 ) resistor r=1.27385 //w=0.131 //l=1.335 //layer=m1 \
 //thickness=0.36 //x=3.82 //y=2.385 //x2=3.82 //y2=3.72
r296 (  11 25 ) resistor r=0.0864989 //w=0.382 //l=0.168152 //layer=m1 \
 //thickness=0.36 //x=1.97 //y=4.025 //x2=2.02 //y2=3.88
r297 (  11 12 ) resistor r=0.982824 //w=0.131 //l=1.03 //layer=m1 \
 //thickness=0.36 //x=1.97 //y=4.025 //x2=1.97 //y2=5.055
r298 (  10 23 ) resistor r=0.0864989 //w=0.382 //l=0.168152 //layer=m1 \
 //thickness=0.36 //x=1.97 //y=3.72 //x2=2.02 //y2=3.865
r299 (  9 10 ) resistor r=1.54103 //w=0.131 //l=1.615 //layer=m1 \
 //thickness=0.36 //x=1.97 //y=2.105 //x2=1.97 //y2=3.72
r300 (  7 12 ) resistor r=0.0698411 //w=0.17 //l=0.120208 //layer=m1 \
 //thickness=0.36 //x=1.885 //y=5.14 //x2=1.97 //y2=5.055
r301 (  7 8 ) resistor r=0.186069 //w=0.131 //l=0.195 //layer=m1 \
 //thickness=0.36 //x=1.885 //y=5.14 //x2=1.69 //y2=5.14
r302 (  5 9 ) resistor r=0.0698411 //w=0.17 //l=0.120208 //layer=m1 \
 //thickness=0.36 //x=1.885 //y=2.02 //x2=1.97 //y2=2.105
r303 (  5 6 ) resistor r=0.19084 //w=0.131 //l=0.2 //layer=m1 //thickness=0.36 \
 //x=1.885 //y=2.02 //x2=1.685 //y2=2.02
r304 (  4 21 ) resistor r=0.086672 //w=0.218 //l=0.14 //layer=m1 \
 //thickness=0.36 //x=1.605 //y=5.42 //x2=1.605 //y2=5.56
r305 (  3 8 ) resistor r=0.0698411 //w=0.17 //l=0.120208 //layer=m1 \
 //thickness=0.36 //x=1.605 //y=5.225 //x2=1.69 //y2=5.14
r306 (  3 4 ) resistor r=0.186069 //w=0.131 //l=0.195 //layer=m1 \
 //thickness=0.36 //x=1.605 //y=5.225 //x2=1.605 //y2=5.42
r307 (  2 6 ) resistor r=0.0698411 //w=0.17 //l=0.120208 //layer=m1 \
 //thickness=0.36 //x=1.6 //y=1.935 //x2=1.685 //y2=2.02
r308 (  1 18 ) resistor r=0.105739 //w=0.201 //l=0.145 //layer=m1 \
 //thickness=0.36 //x=1.6 //y=1.33 //x2=1.6 //y2=1.185
r309 (  1 2 ) resistor r=0.57729 //w=0.131 //l=0.605 //layer=m1 \
 //thickness=0.36 //x=1.6 //y=1.33 //x2=1.6 //y2=1.935
ends PM_DLATCH\%noxref_1

subckt PM_DLATCH\%noxref_2 ( 3 8 9 11 12 14 15 16 18 19 20 23 24 27 29 32 35 \
 38 42 43 48 51 59 76 85 89 90 91 92 93 94 95 99 100 101 103 109 110 112 120 \
 122 123 )
c261 ( 120 0 ) capacitor c=0.00878249f //x=4.67 //y=1.085
c262 ( 112 0 ) capacitor c=0.0545922f //x=6.78 //y=2.265
c263 ( 110 0 ) capacitor c=0.0439576f //x=7.42 //y=1.435
c264 ( 109 0 ) capacitor c=0.0201087f //x=7.42 //y=1.09
c265 ( 103 0 ) capacitor c=0.0161986f //x=7.265 //y=1.59
c266 ( 101 0 ) capacitor c=0.0157807f //x=7.265 //y=0.935
c267 ( 100 0 ) capacitor c=0.055513f //x=7.01 //y=4.97
c268 ( 99 0 ) capacitor c=0.0394958f //x=7.3 //y=4.97
c269 ( 95 0 ) capacitor c=0.0301471f //x=6.89 //y=2.1
c270 ( 94 0 ) capacitor c=0.0255349f //x=6.89 //y=1.745
c271 ( 93 0 ) capacitor c=0.0234346f //x=6.89 //y=1.435
c272 ( 92 0 ) capacitor c=0.02013f //x=6.89 //y=1.09
c273 ( 91 0 ) capacitor c=0.153927f //x=7.375 //y=6.2
c274 ( 90 0 ) capacitor c=0.154397f //x=6.935 //y=6.2
c275 ( 85 0 ) capacitor c=9.4527e-19 //x=6.78 //y=4.88
c276 ( 76 0 ) capacitor c=9.11699e-19 //x=6.78 //y=2.265
c277 ( 59 0 ) capacitor c=0.0321204f //x=4.82 //y=5.56
c278 ( 51 0 ) capacitor c=0.0289608f //x=3.94 //y=5.56
c279 ( 48 0 ) capacitor c=5.85852e-19 //x=6.775 //y=3.51
c280 ( 43 0 ) capacitor c=8.28329e-19 //x=5.46 //y=3.51
c281 ( 42 0 ) capacitor c=0.016775f //x=6.615 //y=3.51
c282 ( 38 0 ) capacitor c=0.00754811f //x=6.78 //y=2.265
c283 ( 35 0 ) capacitor c=0.0159873f //x=6.775 //y=3.51
c284 ( 32 0 ) capacitor c=0.0165963f //x=5.3 //y=3.51
c285 ( 29 0 ) capacitor c=0.0112429f //x=4.86 //y=1.18
c286 ( 27 0 ) capacitor c=7.81299e-19 //x=4.82 //y=5.56
c287 ( 24 0 ) capacitor c=0.0116506f //x=4.82 //y=5.38
c288 ( 23 0 ) capacitor c=0.00912688f //x=3.94 //y=5.56
c289 ( 20 0 ) capacitor c=0.0290083f //x=6.78 //y=4.76
c290 ( 19 0 ) capacitor c=0.0128138f //x=6.78 //y=3.67
c291 ( 18 0 ) capacitor c=0.0211626f //x=6.78 //y=3.35
c292 ( 16 0 ) capacitor c=0.0386409f //x=5.3 //y=5.295
c293 ( 15 0 ) capacitor c=0.013123f //x=5.3 //y=3.67
c294 ( 14 0 ) capacitor c=0.0331698f //x=5.3 //y=3.35
c295 ( 12 0 ) capacitor c=0.00568795f //x=4.945 //y=1.835
c296 ( 11 0 ) capacitor c=0.0132448f //x=5.215 //y=1.835
c297 ( 9 0 ) capacitor c=0.0117467f //x=5.215 //y=5.38
c298 ( 8 0 ) capacitor c=0.0090797f //x=4.86 //y=1.75
c299 ( 3 0 ) capacitor c=0.0148971f //x=4.705 //y=5.38
r300 (  112 113 ) resistor r=17.5563 //w=0.302 //l=0.11 //layer=ply \
 //thickness=0.18 //x=6.78 //y=2.265 //x2=6.89 //y2=2.265
r301 (  110 119 ) resistor r=45.1352 //w=0.168 //l=0.173853 //layer=ply \
 //thickness=0.18 //x=7.42 //y=1.435 //x2=7.38 //y2=1.59
r302 (  109 118 ) resistor r=45.1352 //w=0.168 //l=0.173853 //layer=ply \
 //thickness=0.18 //x=7.42 //y=1.09 //x2=7.38 //y2=0.935
r303 (  109 110 ) resistor r=176.904 //w=0.094 //l=0.345 //layer=ply \
 //thickness=0.18 //x=7.42 //y=1.09 //x2=7.42 //y2=1.435
r304 (  104 117 ) resistor r=10.701 //w=0.21 //l=0.115 //layer=ply \
 //thickness=0.18 //x=7.045 //y=1.59 //x2=6.93 //y2=1.59
r305 (  103 119 ) resistor r=5.52526 //w=0.168 //l=0.115 //layer=ply \
 //thickness=0.18 //x=7.265 //y=1.59 //x2=7.38 //y2=1.59
r306 (  102 116 ) resistor r=5.52526 //w=0.168 //l=0.115 //layer=ply \
 //thickness=0.18 //x=7.045 //y=0.935 //x2=6.93 //y2=0.935
r307 (  101 118 ) resistor r=5.52526 //w=0.168 //l=0.115 //layer=ply \
 //thickness=0.18 //x=7.265 //y=0.935 //x2=7.38 //y2=0.935
r308 (  101 102 ) resistor r=112.809 //w=0.094 //l=0.22 //layer=ply \
 //thickness=0.18 //x=7.265 //y=0.935 //x2=7.045 //y2=0.935
r309 (  99 106 ) resistor r=26.9307 //w=0.15 //l=0.106066 //layer=ply \
 //thickness=0.18 //x=7.3 //y=4.97 //x2=7.375 //y2=5.045
r310 (  99 100 ) resistor r=148.702 //w=0.094 //l=0.29 //layer=ply \
 //thickness=0.18 //x=7.3 //y=4.97 //x2=7.01 //y2=4.97
r311 (  96 100 ) resistor r=23.403 //w=0.284 //l=0.106066 //layer=ply \
 //thickness=0.18 //x=6.935 //y=5.045 //x2=7.01 //y2=4.97
r312 (  96 115 ) resistor r=26.3063 //w=0.284 //l=0.229783 //layer=ply \
 //thickness=0.18 //x=6.935 //y=5.045 //x2=6.78 //y2=4.88
r313 (  95 113 ) resistor r=19.1248 //w=0.302 //l=0.165 //layer=ply \
 //thickness=0.18 //x=6.89 //y=2.1 //x2=6.89 //y2=2.265
r314 (  94 117 ) resistor r=39.5823 //w=0.21 //l=0.173853 //layer=ply \
 //thickness=0.18 //x=6.89 //y=1.745 //x2=6.93 //y2=1.59
r315 (  94 95 ) resistor r=182.032 //w=0.094 //l=0.355 //layer=ply \
 //thickness=0.18 //x=6.89 //y=1.745 //x2=6.89 //y2=2.1
r316 (  93 117 ) resistor r=39.5823 //w=0.21 //l=0.173853 //layer=ply \
 //thickness=0.18 //x=6.89 //y=1.435 //x2=6.93 //y2=1.59
r317 (  92 116 ) resistor r=45.1352 //w=0.168 //l=0.173853 //layer=ply \
 //thickness=0.18 //x=6.89 //y=1.09 //x2=6.93 //y2=0.935
r318 (  92 93 ) resistor r=176.904 //w=0.094 //l=0.345 //layer=ply \
 //thickness=0.18 //x=6.89 //y=1.09 //x2=6.89 //y2=1.435
r319 (  91 106 ) resistor r=592.245 //w=0.094 //l=1.155 //layer=ply \
 //thickness=0.18 //x=7.375 //y=6.2 //x2=7.375 //y2=5.045
r320 (  90 96 ) resistor r=592.245 //w=0.094 //l=1.155 //layer=ply \
 //thickness=0.18 //x=6.935 //y=6.2 //x2=6.935 //y2=5.045
r321 (  89 103 ) resistor r=56.4043 //w=0.094 //l=0.11 //layer=ply \
 //thickness=0.18 //x=7.155 //y=1.59 //x2=7.265 //y2=1.59
r322 (  89 104 ) resistor r=56.4043 //w=0.094 //l=0.11 //layer=ply \
 //thickness=0.18 //x=7.155 //y=1.59 //x2=7.045 //y2=1.59
r323 (  85 115 ) resistor r=152 //w=0.17 //l=0.17 //layer=licon //count=1 \
 //x=6.78 //y=4.88 //x2=6.78 //y2=4.88
r324 (  76 112 ) resistor r=152 //w=0.17 //l=0.17 //layer=licon //count=1 \
 //x=6.78 //y=2.265 //x2=6.78 //y2=2.265
r325 (  59 123 ) resistor r=23.615 //w=0.187 //l=0.345 //layer=li \
 //thickness=0.1 //x=4.82 //y=5.56 //x2=4.82 //y2=5.905
r326 (  51 122 ) resistor r=23.615 //w=0.187 //l=0.345 //layer=li \
 //thickness=0.1 //x=3.94 //y=5.56 //x2=3.94 //y2=5.905
r327 (  43 45 ) resistor r=0.10734 //w=0.281 //l=0.16 //layer=m2 \
 //thickness=0.36 //x=5.46 //y=3.51 //x2=5.3 //y2=3.51
r328 (  42 48 ) resistor r=0.10734 //w=0.281 //l=0.16 //layer=m2 \
 //thickness=0.36 //x=6.615 //y=3.51 //x2=6.775 //y2=3.51
r329 (  42 43 ) resistor r=1.1021 //w=0.131 //l=1.155 //layer=m2 \
 //thickness=0.36 //x=6.615 //y=3.51 //x2=5.46 //y2=3.51
r330 (  41 85 ) resistor r=9.3 //w=0.17 //l=0.17 //layer=mcon //count=1 \
 //x=6.78 //y=4.88 //x2=6.78 //y2=4.88
r331 (  38 76 ) resistor r=9.3 //w=0.17 //l=0.17 //layer=mcon //count=1 \
 //x=6.78 //y=2.265 //x2=6.78 //y2=2.265
r332 (  35 48 ) resistor r=4.5 //w=0.15 //l=0.15 //layer=via1 //count=1 \
 //x=6.775 //y=3.51 //x2=6.775 //y2=3.51
r333 (  32 45 ) resistor r=4.5 //w=0.15 //l=0.15 //layer=via1 //count=1 \
 //x=5.3 //y=3.51 //x2=5.3 //y2=3.51
r334 (  29 120 ) resistor r=9.3 //w=0.17 //l=0.17 //layer=mcon //count=1 \
 //x=4.86 //y=1.18 //x2=4.86 //y2=1.18
r335 (  27 59 ) resistor r=9.3 //w=0.17 //l=0.17 //layer=mcon //count=1 \
 //x=4.82 //y=5.56 //x2=4.82 //y2=5.56
r336 (  24 27 ) resistor r=0.117801 //w=0.191 //l=0.18 //layer=m1 \
 //thickness=0.36 //x=4.82 //y=5.38 //x2=4.82 //y2=5.56
r337 (  23 51 ) resistor r=9.3 //w=0.17 //l=0.17 //layer=mcon //count=1 \
 //x=3.94 //y=5.56 //x2=3.94 //y2=5.56
r338 (  21 23 ) resistor r=0.10274 //w=0.219 //l=0.18 //layer=m1 \
 //thickness=0.36 //x=3.94 //y=5.38 //x2=3.94 //y2=5.56
r339 (  20 41 ) resistor r=0.0732479 //w=0.241 //l=0.122474 //layer=m1 \
 //thickness=0.36 //x=6.78 //y=4.76 //x2=6.785 //y2=4.88
r340 (  19 35 ) resistor r=0.0910802 //w=0.374 //l=0.185472 //layer=m1 \
 //thickness=0.36 //x=6.78 //y=3.67 //x2=6.725 //y2=3.51
r341 (  19 20 ) resistor r=1.04008 //w=0.131 //l=1.09 //layer=m1 \
 //thickness=0.36 //x=6.78 //y=3.67 //x2=6.78 //y2=4.76
r342 (  18 35 ) resistor r=0.0910802 //w=0.374 //l=0.185472 //layer=m1 \
 //thickness=0.36 //x=6.78 //y=3.35 //x2=6.725 //y2=3.51
r343 (  17 38 ) resistor r=0.116051 //w=0.211 //l=0.165 //layer=m1 \
 //thickness=0.36 //x=6.78 //y=2.43 //x2=6.78 //y2=2.265
r344 (  17 18 ) resistor r=0.877863 //w=0.131 //l=0.92 //layer=m1 \
 //thickness=0.36 //x=6.78 //y=2.43 //x2=6.78 //y2=3.35
r345 (  15 32 ) resistor r=0.0911593 //w=0.376 //l=0.184174 //layer=m1 \
 //thickness=0.36 //x=5.3 //y=3.67 //x2=5.352 //y2=3.51
r346 (  15 16 ) resistor r=1.55057 //w=0.131 //l=1.625 //layer=m1 \
 //thickness=0.36 //x=5.3 //y=3.67 //x2=5.3 //y2=5.295
r347 (  14 32 ) resistor r=0.0911593 //w=0.376 //l=0.184174 //layer=m1 \
 //thickness=0.36 //x=5.3 //y=3.35 //x2=5.352 //y2=3.51
r348 (  13 14 ) resistor r=1.3645 //w=0.131 //l=1.43 //layer=m1 \
 //thickness=0.36 //x=5.3 //y=1.92 //x2=5.3 //y2=3.35
r349 (  11 13 ) resistor r=0.0698411 //w=0.17 //l=0.120208 //layer=m1 \
 //thickness=0.36 //x=5.215 //y=1.835 //x2=5.3 //y2=1.92
r350 (  11 12 ) resistor r=0.257634 //w=0.131 //l=0.27 //layer=m1 \
 //thickness=0.36 //x=5.215 //y=1.835 //x2=4.945 //y2=1.835
r351 (  10 24 ) resistor r=0.0257089 //w=0.23 //l=0.115 //layer=m1 \
 //thickness=0.36 //x=4.935 //y=5.38 //x2=4.82 //y2=5.38
r352 (  9 16 ) resistor r=0.0698411 //w=0.17 //l=0.120208 //layer=m1 \
 //thickness=0.36 //x=5.215 //y=5.38 //x2=5.3 //y2=5.295
r353 (  9 10 ) resistor r=0.267176 //w=0.131 //l=0.28 //layer=m1 \
 //thickness=0.36 //x=5.215 //y=5.38 //x2=4.935 //y2=5.38
r354 (  8 12 ) resistor r=0.0698411 //w=0.17 //l=0.120208 //layer=m1 \
 //thickness=0.36 //x=4.86 //y=1.75 //x2=4.945 //y2=1.835
r355 (  7 29 ) resistor r=0.0913624 //w=0.191 //l=0.12 //layer=m1 \
 //thickness=0.36 //x=4.86 //y=1.3 //x2=4.86 //y2=1.18
r356 (  7 8 ) resistor r=0.429389 //w=0.131 //l=0.45 //layer=m1 \
 //thickness=0.36 //x=4.86 //y=1.3 //x2=4.86 //y2=1.75
r357 (  4 21 ) resistor r=0.0227762 //w=0.219 //l=0.115 //layer=m1 \
 //thickness=0.36 //x=4.055 //y=5.38 //x2=3.94 //y2=5.38
r358 (  3 24 ) resistor r=0.0257089 //w=0.23 //l=0.115 //layer=m1 \
 //thickness=0.36 //x=4.705 //y=5.38 //x2=4.82 //y2=5.38
r359 (  3 4 ) resistor r=0.620229 //w=0.131 //l=0.65 //layer=m1 \
 //thickness=0.36 //x=4.705 //y=5.38 //x2=4.055 //y2=5.38
ends PM_DLATCH\%noxref_2

subckt PM_DLATCH\%GATE ( 1 2 3 4 5 6 7 8 9 13 14 21 26 40 43 46 48 50 52 57 61 \
 70 75 84 88 89 90 91 92 93 94 95 96 101 103 105 111 112 113 114 115 116 120 \
 122 125 126 131 132 135 149 )
c286 ( 149 0 ) capacitor c=0.0682508f //x=9.37 //y=4.88
c287 ( 135 0 ) capacitor c=0.0393541f //x=4.59 //y=4.88
c288 ( 132 0 ) capacitor c=0.0284095f //x=4.56 //y=2.095
c289 ( 131 0 ) capacitor c=0.044011f //x=4.56 //y=2.26
c290 ( 126 0 ) capacitor c=0.0318956f //x=9.705 //y=1.39
c291 ( 125 0 ) capacitor c=0.0186809f //x=9.705 //y=1.045
c292 ( 122 0 ) capacitor c=0.0141821f //x=9.55 //y=1.545
c293 ( 120 0 ) capacitor c=0.0158553f //x=9.55 //y=0.89
c294 ( 116 0 ) capacitor c=0.0818405f //x=9.175 //y=2.095
c295 ( 115 0 ) capacitor c=0.0229235f //x=9.175 //y=1.7
c296 ( 114 0 ) capacitor c=0.0234359f //x=9.175 //y=1.39
c297 ( 113 0 ) capacitor c=0.0198759f //x=9.175 //y=1.045
c298 ( 112 0 ) capacitor c=0.0439708f //x=5.125 //y=1.43
c299 ( 111 0 ) capacitor c=0.0192582f //x=5.125 //y=1.085
c300 ( 105 0 ) capacitor c=0.0162526f //x=4.97 //y=1.585
c301 ( 103 0 ) capacitor c=0.0157807f //x=4.97 //y=0.93
c302 ( 101 0 ) capacitor c=0.0373491f //x=4.965 //y=4.97
c303 ( 96 0 ) capacitor c=0.0210762f //x=4.595 //y=1.74
c304 ( 95 0 ) capacitor c=0.0168511f //x=4.595 //y=1.43
c305 ( 94 0 ) capacitor c=0.0175485f //x=4.595 //y=1.085
c306 ( 93 0 ) capacitor c=0.110369f //x=9.71 //y=6.2
c307 ( 92 0 ) capacitor c=0.154619f //x=9.27 //y=6.2
c308 ( 91 0 ) capacitor c=0.155269f //x=5.04 //y=6.2
c309 ( 90 0 ) capacitor c=0.110375f //x=4.6 //y=6.2
c310 ( 84 0 ) capacitor c=8.13425e-19 //x=9.37 //y=4.88
c311 ( 75 0 ) capacitor c=5.17312e-19 //x=9.37 //y=2.26
c312 ( 70 0 ) capacitor c=8.90417e-19 //x=4.59 //y=4.88
c313 ( 61 0 ) capacitor c=3.09518e-19 //x=4.56 //y=2.26
c314 ( 57 0 ) capacitor c=0.00307575f //x=4.715 //y=3.152
c315 ( 52 0 ) capacitor c=0.0805698f //x=6.99 //y=3.125
c316 ( 50 0 ) capacitor c=0.0261542f //x=6.39 //y=3.14
c317 ( 48 0 ) capacitor c=0.018479f //x=5.515 //y=3.125
c318 ( 46 0 ) capacitor c=0.00940581f //x=4.915 //y=3.14
c319 ( 43 0 ) capacitor c=0.00623458f //x=9.37 //y=4.88
c320 ( 40 0 ) capacitor c=0.00628406f //x=9.37 //y=2.26
c321 ( 26 0 ) capacitor c=0.00626136f //x=4.56 //y=2.26
c322 ( 21 0 ) capacitor c=0.0131591f //x=9.37 //y=3.305
c323 ( 14 0 ) capacitor c=0.00444393f //x=4.56 //y=4.735
c324 ( 13 0 ) capacitor c=0.0105599f //x=4.56 //y=3.305
c325 ( 9 0 ) capacitor c=0.0147345f //x=9.37 //y=3.14
c326 ( 8 0 ) capacitor c=0.0141141f //x=4.56 //y=3.14
c327 ( 6 0 ) capacitor c=0.0371904f //x=9.37 //y=3.51
c328 ( 5 0 ) capacitor c=0.0151375f //x=9.37 //y=2.77
c329 ( 2 0 ) capacitor c=0.0293595f //x=4.56 //y=3.51
c330 ( 1 0 ) capacitor c=0.0120346f //x=4.56 //y=2.77
r331 (  147 149 ) resistor r=20.6867 //w=0.233 //l=0.1 //layer=ply \
 //thickness=0.18 //x=9.27 //y=4.88 //x2=9.37 //y2=4.88
r332 (  137 138 ) resistor r=32.4568 //w=0.214 //l=0.075 //layer=ply \
 //thickness=0.18 //x=4.59 //y=4.97 //x2=4.59 //y2=5.045
r333 (  135 137 ) resistor r=20.271 //w=0.214 //l=0.09 //layer=ply \
 //thickness=0.18 //x=4.59 //y=4.88 //x2=4.59 //y2=4.97
r334 (  131 132 ) resistor r=52.7279 //w=0.214 //l=0.165 //layer=ply \
 //thickness=0.18 //x=4.56 //y=2.26 //x2=4.56 //y2=2.095
r335 (  127 149 ) resistor r=70.3348 //w=0.233 //l=0.414367 //layer=ply \
 //thickness=0.18 //x=9.71 //y=5.045 //x2=9.37 //y2=4.88
r336 (  126 151 ) resistor r=45.1352 //w=0.168 //l=0.173853 //layer=ply \
 //thickness=0.18 //x=9.705 //y=1.39 //x2=9.665 //y2=1.545
r337 (  125 150 ) resistor r=45.1352 //w=0.168 //l=0.173853 //layer=ply \
 //thickness=0.18 //x=9.705 //y=1.045 //x2=9.665 //y2=0.89
r338 (  125 126 ) resistor r=176.904 //w=0.094 //l=0.345 //layer=ply \
 //thickness=0.18 //x=9.705 //y=1.045 //x2=9.705 //y2=1.39
r339 (  123 146 ) resistor r=10.701 //w=0.21 //l=0.115 //layer=ply \
 //thickness=0.18 //x=9.33 //y=1.545 //x2=9.215 //y2=1.545
r340 (  122 151 ) resistor r=5.52526 //w=0.168 //l=0.115 //layer=ply \
 //thickness=0.18 //x=9.55 //y=1.545 //x2=9.665 //y2=1.545
r341 (  121 145 ) resistor r=5.52526 //w=0.168 //l=0.115 //layer=ply \
 //thickness=0.18 //x=9.33 //y=0.89 //x2=9.215 //y2=0.89
r342 (  120 150 ) resistor r=5.52526 //w=0.168 //l=0.115 //layer=ply \
 //thickness=0.18 //x=9.55 //y=0.89 //x2=9.665 //y2=0.89
r343 (  120 121 ) resistor r=112.809 //w=0.094 //l=0.22 //layer=ply \
 //thickness=0.18 //x=9.55 //y=0.89 //x2=9.33 //y2=0.89
r344 (  117 147 ) resistor r=13.0941 //w=0.233 //l=0.165 //layer=ply \
 //thickness=0.18 //x=9.27 //y=5.045 //x2=9.27 //y2=4.88
r345 (  116 144 ) resistor r=34.8111 //w=0.27 //l=0.264953 //layer=ply \
 //thickness=0.18 //x=9.175 //y=2.095 //x2=9.37 //y2=2.26
r346 (  115 146 ) resistor r=39.5823 //w=0.21 //l=0.173853 //layer=ply \
 //thickness=0.18 //x=9.175 //y=1.7 //x2=9.215 //y2=1.545
r347 (  115 116 ) resistor r=202.543 //w=0.094 //l=0.395 //layer=ply \
 //thickness=0.18 //x=9.175 //y=1.7 //x2=9.175 //y2=2.095
r348 (  114 146 ) resistor r=39.5823 //w=0.21 //l=0.173853 //layer=ply \
 //thickness=0.18 //x=9.175 //y=1.39 //x2=9.215 //y2=1.545
r349 (  113 145 ) resistor r=45.1352 //w=0.168 //l=0.173853 //layer=ply \
 //thickness=0.18 //x=9.175 //y=1.045 //x2=9.215 //y2=0.89
r350 (  113 114 ) resistor r=176.904 //w=0.094 //l=0.345 //layer=ply \
 //thickness=0.18 //x=9.175 //y=1.045 //x2=9.175 //y2=1.39
r351 (  112 142 ) resistor r=45.1352 //w=0.168 //l=0.173853 //layer=ply \
 //thickness=0.18 //x=5.125 //y=1.43 //x2=5.085 //y2=1.585
r352 (  111 141 ) resistor r=45.1352 //w=0.168 //l=0.173853 //layer=ply \
 //thickness=0.18 //x=5.125 //y=1.085 //x2=5.085 //y2=0.93
r353 (  111 112 ) resistor r=176.904 //w=0.094 //l=0.345 //layer=ply \
 //thickness=0.18 //x=5.125 //y=1.085 //x2=5.125 //y2=1.43
r354 (  106 140 ) resistor r=10.701 //w=0.21 //l=0.115 //layer=ply \
 //thickness=0.18 //x=4.75 //y=1.585 //x2=4.635 //y2=1.585
r355 (  105 142 ) resistor r=5.52526 //w=0.168 //l=0.115 //layer=ply \
 //thickness=0.18 //x=4.97 //y=1.585 //x2=5.085 //y2=1.585
r356 (  104 139 ) resistor r=5.52526 //w=0.168 //l=0.115 //layer=ply \
 //thickness=0.18 //x=4.75 //y=0.93 //x2=4.635 //y2=0.93
r357 (  103 141 ) resistor r=5.52526 //w=0.168 //l=0.115 //layer=ply \
 //thickness=0.18 //x=4.97 //y=0.93 //x2=5.085 //y2=0.93
r358 (  103 104 ) resistor r=112.809 //w=0.094 //l=0.22 //layer=ply \
 //thickness=0.18 //x=4.97 //y=0.93 //x2=4.75 //y2=0.93
r359 (  102 137 ) resistor r=16.5046 //w=0.27 //l=0.135 //layer=ply \
 //thickness=0.18 //x=4.725 //y=4.97 //x2=4.59 //y2=4.97
r360 (  101 108 ) resistor r=26.9307 //w=0.15 //l=0.106066 //layer=ply \
 //thickness=0.18 //x=4.965 //y=4.97 //x2=5.04 //y2=5.045
r361 (  101 102 ) resistor r=123.064 //w=0.094 //l=0.24 //layer=ply \
 //thickness=0.18 //x=4.965 //y=4.97 //x2=4.725 //y2=4.97
r362 (  96 140 ) resistor r=39.5823 //w=0.21 //l=0.173853 //layer=ply \
 //thickness=0.18 //x=4.595 //y=1.74 //x2=4.635 //y2=1.585
r363 (  96 132 ) resistor r=182.032 //w=0.094 //l=0.355 //layer=ply \
 //thickness=0.18 //x=4.595 //y=1.74 //x2=4.595 //y2=2.095
r364 (  95 140 ) resistor r=39.5823 //w=0.21 //l=0.173853 //layer=ply \
 //thickness=0.18 //x=4.595 //y=1.43 //x2=4.635 //y2=1.585
r365 (  94 139 ) resistor r=45.1352 //w=0.168 //l=0.173853 //layer=ply \
 //thickness=0.18 //x=4.595 //y=1.085 //x2=4.635 //y2=0.93
r366 (  94 95 ) resistor r=176.904 //w=0.094 //l=0.345 //layer=ply \
 //thickness=0.18 //x=4.595 //y=1.085 //x2=4.595 //y2=1.43
r367 (  93 127 ) resistor r=592.245 //w=0.094 //l=1.155 //layer=ply \
 //thickness=0.18 //x=9.71 //y=6.2 //x2=9.71 //y2=5.045
r368 (  92 117 ) resistor r=592.245 //w=0.094 //l=1.155 //layer=ply \
 //thickness=0.18 //x=9.27 //y=6.2 //x2=9.27 //y2=5.045
r369 (  91 108 ) resistor r=592.245 //w=0.094 //l=1.155 //layer=ply \
 //thickness=0.18 //x=5.04 //y=6.2 //x2=5.04 //y2=5.045
r370 (  90 138 ) resistor r=592.245 //w=0.094 //l=1.155 //layer=ply \
 //thickness=0.18 //x=4.6 //y=6.2 //x2=4.6 //y2=5.045
r371 (  89 122 ) resistor r=56.4043 //w=0.094 //l=0.11 //layer=ply \
 //thickness=0.18 //x=9.44 //y=1.545 //x2=9.55 //y2=1.545
r372 (  89 123 ) resistor r=56.4043 //w=0.094 //l=0.11 //layer=ply \
 //thickness=0.18 //x=9.44 //y=1.545 //x2=9.33 //y2=1.545
r373 (  88 105 ) resistor r=56.4043 //w=0.094 //l=0.11 //layer=ply \
 //thickness=0.18 //x=4.86 //y=1.585 //x2=4.97 //y2=1.585
r374 (  88 106 ) resistor r=56.4043 //w=0.094 //l=0.11 //layer=ply \
 //thickness=0.18 //x=4.86 //y=1.585 //x2=4.75 //y2=1.585
r375 (  84 149 ) resistor r=152 //w=0.17 //l=0.17 //layer=licon //count=1 \
 //x=9.37 //y=4.88 //x2=9.37 //y2=4.88
r376 (  75 144 ) resistor r=152 //w=0.17 //l=0.17 //layer=licon //count=1 \
 //x=9.37 //y=2.26 //x2=9.37 //y2=2.26
r377 (  70 135 ) resistor r=152 //w=0.17 //l=0.17 //layer=licon //count=1 \
 //x=4.59 //y=4.88 //x2=4.59 //y2=4.88
r378 (  61 131 ) resistor r=152 //w=0.17 //l=0.17 //layer=licon //count=1 \
 //x=4.56 //y=2.26 //x2=4.56 //y2=2.26
r379 (  55 57 ) resistor r=0.107671 //w=0.266 //l=0.16 //layer=m2 \
 //thickness=0.36 //x=4.555 //y=3.152 //x2=4.715 //y2=3.152
r380 (  52 59 ) resistor r=1.58385 //w=0.188 //l=2.39346 //layer=m2 \
 //thickness=0.36 //x=6.99 //y=3.125 //x2=9.37 //y2=3.152
r381 (  52 53 ) resistor r=0.410305 //w=0.131 //l=0.43 //layer=m2 \
 //thickness=0.36 //x=6.99 //y=3.125 //x2=6.56 //y2=3.125
r382 (  50 53 ) resistor r=0.125 //w=0.17 //l=0.177341 //layer=m2 \
 //thickness=0.36 //x=6.39 //y=3.14 //x2=6.56 //y2=3.125
r383 (  50 51 ) resistor r=0.591603 //w=0.131 //l=0.62 //layer=m2 \
 //thickness=0.36 //x=6.39 //y=3.14 //x2=5.77 //y2=3.14
r384 (  48 51 ) resistor r=0.1875 //w=0.17 //l=0.262393 //layer=m2 \
 //thickness=0.36 //x=5.515 //y=3.125 //x2=5.77 //y2=3.14
r385 (  48 49 ) resistor r=0.410305 //w=0.131 //l=0.43 //layer=m2 \
 //thickness=0.36 //x=5.515 //y=3.125 //x2=5.085 //y2=3.125
r386 (  46 49 ) resistor r=0.125 //w=0.17 //l=0.177341 //layer=m2 \
 //thickness=0.36 //x=4.915 //y=3.14 //x2=5.085 //y2=3.125
r387 (  46 57 ) resistor r=0.19084 //w=0.131 //l=0.2 //layer=m2 \
 //thickness=0.36 //x=4.915 //y=3.14 //x2=4.715 //y2=3.14
r388 (  43 84 ) resistor r=9.3 //w=0.17 //l=0.17 //layer=mcon //count=1 \
 //x=9.37 //y=4.88 //x2=9.37 //y2=4.88
r389 (  43 44 ) resistor r=0.103207 //w=0.196 //l=0.14 //layer=m1 \
 //thickness=0.36 //x=9.372 //y=4.88 //x2=9.372 //y2=4.74
r390 (  40 75 ) resistor r=9.3 //w=0.17 //l=0.17 //layer=mcon //count=1 \
 //x=9.37 //y=2.26 //x2=9.37 //y2=2.26
r391 (  38 59 ) resistor r=4.5 //w=0.15 //l=0.15 //layer=via1 //count=1 \
 //x=9.37 //y=3.145 //x2=9.37 //y2=3.145
r392 (  34 55 ) resistor r=4.5 //w=0.15 //l=0.15 //layer=via1 //count=1 \
 //x=4.555 //y=3.145 //x2=4.555 //y2=3.145
r393 (  30 70 ) resistor r=9.3 //w=0.17 //l=0.17 //layer=mcon //count=1 \
 //x=4.59 //y=4.88 //x2=4.59 //y2=4.88
r394 (  26 61 ) resistor r=9.3 //w=0.17 //l=0.17 //layer=mcon //count=1 \
 //x=4.56 //y=2.26 //x2=4.56 //y2=2.26
r395 (  26 28 ) resistor r=0.0936408 //w=0.196 //l=0.125 //layer=m1 \
 //thickness=0.36 //x=4.562 //y=2.26 //x2=4.562 //y2=2.385
r396 (  21 38 ) resistor r=0.0912814 //w=0.379 //l=0.184608 //layer=m1 \
 //thickness=0.36 //x=9.37 //y=3.305 //x2=9.317 //y2=3.145
r397 (  18 40 ) resistor r=0.0933015 //w=0.201 //l=0.125 //layer=m1 \
 //thickness=0.36 //x=9.37 //y=2.385 //x2=9.37 //y2=2.26
r398 (  14 30 ) resistor r=0.0878548 //w=0.228 //l=0.159295 //layer=m1 \
 //thickness=0.36 //x=4.56 //y=4.735 //x2=4.59 //y2=4.88
r399 (  13 34 ) resistor r=0.0914072 //w=0.382 //l=0.183303 //layer=m1 \
 //thickness=0.36 //x=4.56 //y=3.305 //x2=4.61 //y2=3.145
r400 (  9 38 ) resistor r=0.00164908 //w=0.379 //l=0.005 //layer=m1 \
 //thickness=0.36 //x=9.317 //y=3.14 //x2=9.317 //y2=3.145
r401 (  9 19 ) resistor r=0.0846851 //w=0.379 //l=0.164378 //layer=m1 \
 //thickness=0.36 //x=9.317 //y=3.14 //x2=9.37 //y2=3
r402 (  8 34 ) resistor r=0.00163613 //w=0.382 //l=0.005 //layer=m1 \
 //thickness=0.36 //x=4.61 //y=3.14 //x2=4.61 //y2=3.145
r403 (  8 11 ) resistor r=0.0848627 //w=0.382 //l=0.163095 //layer=m1 \
 //thickness=0.36 //x=4.61 //y=3.14 //x2=4.56 //y2=3
r404 (  7 44 ) resistor r=0.114504 //w=0.131 //l=0.12 //layer=m1 \
 //thickness=0.36 //x=9.37 //y=4.62 //x2=9.37 //y2=4.74
r405 (  6 7 ) resistor r=1.05916 //w=0.131 //l=1.11 //layer=m1 \
 //thickness=0.36 //x=9.37 //y=3.51 //x2=9.37 //y2=4.62
r406 (  6 21 ) resistor r=0.195611 //w=0.131 //l=0.205 //layer=m1 \
 //thickness=0.36 //x=9.37 //y=3.51 //x2=9.37 //y2=3.305
r407 (  5 19 ) resistor r=0.219466 //w=0.131 //l=0.23 //layer=m1 \
 //thickness=0.36 //x=9.37 //y=2.77 //x2=9.37 //y2=3
r408 (  5 18 ) resistor r=0.367366 //w=0.131 //l=0.385 //layer=m1 \
 //thickness=0.36 //x=9.37 //y=2.77 //x2=9.37 //y2=2.385
r409 (  4 14 ) resistor r=0.109733 //w=0.131 //l=0.115 //layer=m1 \
 //thickness=0.36 //x=4.56 //y=4.62 //x2=4.56 //y2=4.735
r410 (  3 4 ) resistor r=0.706107 //w=0.131 //l=0.74 //layer=m1 \
 //thickness=0.36 //x=4.56 //y=3.88 //x2=4.56 //y2=4.62
r411 (  2 3 ) resistor r=0.353053 //w=0.131 //l=0.37 //layer=m1 \
 //thickness=0.36 //x=4.56 //y=3.51 //x2=4.56 //y2=3.88
r412 (  2 13 ) resistor r=0.195611 //w=0.131 //l=0.205 //layer=m1 \
 //thickness=0.36 //x=4.56 //y=3.51 //x2=4.56 //y2=3.305
r413 (  1 11 ) resistor r=0.219466 //w=0.131 //l=0.23 //layer=m1 \
 //thickness=0.36 //x=4.56 //y=2.77 //x2=4.56 //y2=3
r414 (  1 28 ) resistor r=0.367366 //w=0.131 //l=0.385 //layer=m1 \
 //thickness=0.36 //x=4.56 //y=2.77 //x2=4.56 //y2=2.385
ends PM_DLATCH\%GATE

subckt PM_DLATCH\%D ( 1 2 3 4 5 6 7 8 9 10 11 12 13 20 21 29 30 33 47 57 59 60 \
 63 72 77 86 90 91 92 93 94 95 96 97 98 99 103 104 105 107 113 114 115 116 117 \
 122 124 126 132 133 135 144 145 148 )
c272 ( 148 0 ) capacitor c=0.0355993f //x=10.14 //y=4.88
c273 ( 145 0 ) capacitor c=0.0284095f //x=10.11 //y=2.095
c274 ( 144 0 ) capacitor c=0.0476356f //x=10.11 //y=2.26
c275 ( 135 0 ) capacitor c=0.0564228f //x=1.23 //y=2.265
c276 ( 133 0 ) capacitor c=0.0439708f //x=10.675 //y=1.43
c277 ( 132 0 ) capacitor c=0.0192582f //x=10.675 //y=1.085
c278 ( 126 0 ) capacitor c=0.0162526f //x=10.52 //y=1.585
c279 ( 124 0 ) capacitor c=0.0157807f //x=10.52 //y=0.93
c280 ( 122 0 ) capacitor c=0.0373491f //x=10.515 //y=4.97
c281 ( 117 0 ) capacitor c=0.0210762f //x=10.145 //y=1.74
c282 ( 116 0 ) capacitor c=0.0168511f //x=10.145 //y=1.43
c283 ( 115 0 ) capacitor c=0.0175485f //x=10.145 //y=1.085
c284 ( 114 0 ) capacitor c=0.0439576f //x=1.87 //y=1.435
c285 ( 113 0 ) capacitor c=0.0201087f //x=1.87 //y=1.09
c286 ( 107 0 ) capacitor c=0.0161986f //x=1.715 //y=1.59
c287 ( 105 0 ) capacitor c=0.0157807f //x=1.715 //y=0.935
c288 ( 104 0 ) capacitor c=0.0497305f //x=1.46 //y=4.97
c289 ( 103 0 ) capacitor c=0.0387091f //x=1.75 //y=4.97
c290 ( 99 0 ) capacitor c=0.0301471f //x=1.34 //y=2.1
c291 ( 98 0 ) capacitor c=0.0255349f //x=1.34 //y=1.745
c292 ( 97 0 ) capacitor c=0.0234346f //x=1.34 //y=1.435
c293 ( 96 0 ) capacitor c=0.02013f //x=1.34 //y=1.09
c294 ( 95 0 ) capacitor c=0.155269f //x=10.59 //y=6.2
c295 ( 94 0 ) capacitor c=0.110375f //x=10.15 //y=6.2
c296 ( 93 0 ) capacitor c=0.153944f //x=1.825 //y=6.2
c297 ( 92 0 ) capacitor c=0.154411f //x=1.385 //y=6.2
c298 ( 86 0 ) capacitor c=5.80994e-19 //x=10.14 //y=4.88
c299 ( 77 0 ) capacitor c=5.78095e-19 //x=10.11 //y=2.26
c300 ( 72 0 ) capacitor c=6.76693e-19 //x=1.23 //y=4.88
c301 ( 63 0 ) capacitor c=9.11699e-19 //x=1.23 //y=2.265
c302 ( 60 0 ) capacitor c=0.238017f //x=9.95 //y=4.262
c303 ( 59 0 ) capacitor c=0.00235605f //x=10.11 //y=4.255
c304 ( 57 0 ) capacitor c=0.00973018f //x=1.39 //y=4.262
c305 ( 47 0 ) capacitor c=0.00662976f //x=10.11 //y=2.26
c306 ( 33 0 ) capacitor c=0.0139338f //x=1.23 //y=2.265
c307 ( 30 0 ) capacitor c=0.00410868f //x=10.11 //y=4.735
c308 ( 29 0 ) capacitor c=0.00985065f //x=10.11 //y=4.415
c309 ( 21 0 ) capacitor c=0.00937704f //x=1.23 //y=4.76
c310 ( 20 0 ) capacitor c=0.0117491f //x=1.23 //y=4.415
c311 ( 13 0 ) capacitor c=0.0151972f //x=10.11 //y=4.25
c312 ( 12 0 ) capacitor c=0.0147983f //x=1.23 //y=4.25
c313 ( 10 0 ) capacitor c=0.00572789f //x=10.11 //y=4.62
c314 ( 6 0 ) capacitor c=0.0361787f //x=10.11 //y=2.4
c315 ( 5 0 ) capacitor c=0.00881554f //x=1.23 //y=4.62
c316 ( 1 0 ) capacitor c=0.0748289f //x=1.23 //y=2.77
r317 (  150 151 ) resistor r=32.4568 //w=0.214 //l=0.075 //layer=ply \
 //thickness=0.18 //x=10.14 //y=4.97 //x2=10.14 //y2=5.045
r318 (  148 150 ) resistor r=20.271 //w=0.214 //l=0.09 //layer=ply \
 //thickness=0.18 //x=10.14 //y=4.88 //x2=10.14 //y2=4.97
r319 (  144 145 ) resistor r=52.7279 //w=0.214 //l=0.165 //layer=ply \
 //thickness=0.18 //x=10.11 //y=2.26 //x2=10.11 //y2=2.095
r320 (  135 136 ) resistor r=17.5563 //w=0.302 //l=0.11 //layer=ply \
 //thickness=0.18 //x=1.23 //y=2.265 //x2=1.34 //y2=2.265
r321 (  133 155 ) resistor r=45.1352 //w=0.168 //l=0.173853 //layer=ply \
 //thickness=0.18 //x=10.675 //y=1.43 //x2=10.635 //y2=1.585
r322 (  132 154 ) resistor r=45.1352 //w=0.168 //l=0.173853 //layer=ply \
 //thickness=0.18 //x=10.675 //y=1.085 //x2=10.635 //y2=0.93
r323 (  132 133 ) resistor r=176.904 //w=0.094 //l=0.345 //layer=ply \
 //thickness=0.18 //x=10.675 //y=1.085 //x2=10.675 //y2=1.43
r324 (  127 153 ) resistor r=10.701 //w=0.21 //l=0.115 //layer=ply \
 //thickness=0.18 //x=10.3 //y=1.585 //x2=10.185 //y2=1.585
r325 (  126 155 ) resistor r=5.52526 //w=0.168 //l=0.115 //layer=ply \
 //thickness=0.18 //x=10.52 //y=1.585 //x2=10.635 //y2=1.585
r326 (  125 152 ) resistor r=5.52526 //w=0.168 //l=0.115 //layer=ply \
 //thickness=0.18 //x=10.3 //y=0.93 //x2=10.185 //y2=0.93
r327 (  124 154 ) resistor r=5.52526 //w=0.168 //l=0.115 //layer=ply \
 //thickness=0.18 //x=10.52 //y=0.93 //x2=10.635 //y2=0.93
r328 (  124 125 ) resistor r=112.809 //w=0.094 //l=0.22 //layer=ply \
 //thickness=0.18 //x=10.52 //y=0.93 //x2=10.3 //y2=0.93
r329 (  123 150 ) resistor r=16.5046 //w=0.27 //l=0.135 //layer=ply \
 //thickness=0.18 //x=10.275 //y=4.97 //x2=10.14 //y2=4.97
r330 (  122 129 ) resistor r=26.9307 //w=0.15 //l=0.106066 //layer=ply \
 //thickness=0.18 //x=10.515 //y=4.97 //x2=10.59 //y2=5.045
r331 (  122 123 ) resistor r=123.064 //w=0.094 //l=0.24 //layer=ply \
 //thickness=0.18 //x=10.515 //y=4.97 //x2=10.275 //y2=4.97
r332 (  117 153 ) resistor r=39.5823 //w=0.21 //l=0.173853 //layer=ply \
 //thickness=0.18 //x=10.145 //y=1.74 //x2=10.185 //y2=1.585
r333 (  117 145 ) resistor r=182.032 //w=0.094 //l=0.355 //layer=ply \
 //thickness=0.18 //x=10.145 //y=1.74 //x2=10.145 //y2=2.095
r334 (  116 153 ) resistor r=39.5823 //w=0.21 //l=0.173853 //layer=ply \
 //thickness=0.18 //x=10.145 //y=1.43 //x2=10.185 //y2=1.585
r335 (  115 152 ) resistor r=45.1352 //w=0.168 //l=0.173853 //layer=ply \
 //thickness=0.18 //x=10.145 //y=1.085 //x2=10.185 //y2=0.93
r336 (  115 116 ) resistor r=176.904 //w=0.094 //l=0.345 //layer=ply \
 //thickness=0.18 //x=10.145 //y=1.085 //x2=10.145 //y2=1.43
r337 (  114 142 ) resistor r=45.1352 //w=0.168 //l=0.173853 //layer=ply \
 //thickness=0.18 //x=1.87 //y=1.435 //x2=1.83 //y2=1.59
r338 (  113 141 ) resistor r=45.1352 //w=0.168 //l=0.173853 //layer=ply \
 //thickness=0.18 //x=1.87 //y=1.09 //x2=1.83 //y2=0.935
r339 (  113 114 ) resistor r=176.904 //w=0.094 //l=0.345 //layer=ply \
 //thickness=0.18 //x=1.87 //y=1.09 //x2=1.87 //y2=1.435
r340 (  108 140 ) resistor r=10.701 //w=0.21 //l=0.115 //layer=ply \
 //thickness=0.18 //x=1.495 //y=1.59 //x2=1.38 //y2=1.59
r341 (  107 142 ) resistor r=5.52526 //w=0.168 //l=0.115 //layer=ply \
 //thickness=0.18 //x=1.715 //y=1.59 //x2=1.83 //y2=1.59
r342 (  106 139 ) resistor r=5.52526 //w=0.168 //l=0.115 //layer=ply \
 //thickness=0.18 //x=1.495 //y=0.935 //x2=1.38 //y2=0.935
r343 (  105 141 ) resistor r=5.52526 //w=0.168 //l=0.115 //layer=ply \
 //thickness=0.18 //x=1.715 //y=0.935 //x2=1.83 //y2=0.935
r344 (  105 106 ) resistor r=112.809 //w=0.094 //l=0.22 //layer=ply \
 //thickness=0.18 //x=1.715 //y=0.935 //x2=1.495 //y2=0.935
r345 (  103 110 ) resistor r=26.9307 //w=0.15 //l=0.106066 //layer=ply \
 //thickness=0.18 //x=1.75 //y=4.97 //x2=1.825 //y2=5.045
r346 (  103 104 ) resistor r=148.702 //w=0.094 //l=0.29 //layer=ply \
 //thickness=0.18 //x=1.75 //y=4.97 //x2=1.46 //y2=4.97
r347 (  100 104 ) resistor r=23.403 //w=0.284 //l=0.106066 //layer=ply \
 //thickness=0.18 //x=1.385 //y=5.045 //x2=1.46 //y2=4.97
r348 (  100 138 ) resistor r=26.3063 //w=0.284 //l=0.229783 //layer=ply \
 //thickness=0.18 //x=1.385 //y=5.045 //x2=1.23 //y2=4.88
r349 (  99 136 ) resistor r=19.1248 //w=0.302 //l=0.165 //layer=ply \
 //thickness=0.18 //x=1.34 //y=2.1 //x2=1.34 //y2=2.265
r350 (  98 140 ) resistor r=39.5823 //w=0.21 //l=0.173853 //layer=ply \
 //thickness=0.18 //x=1.34 //y=1.745 //x2=1.38 //y2=1.59
r351 (  98 99 ) resistor r=182.032 //w=0.094 //l=0.355 //layer=ply \
 //thickness=0.18 //x=1.34 //y=1.745 //x2=1.34 //y2=2.1
r352 (  97 140 ) resistor r=39.5823 //w=0.21 //l=0.173853 //layer=ply \
 //thickness=0.18 //x=1.34 //y=1.435 //x2=1.38 //y2=1.59
r353 (  96 139 ) resistor r=45.1352 //w=0.168 //l=0.173853 //layer=ply \
 //thickness=0.18 //x=1.34 //y=1.09 //x2=1.38 //y2=0.935
r354 (  96 97 ) resistor r=176.904 //w=0.094 //l=0.345 //layer=ply \
 //thickness=0.18 //x=1.34 //y=1.09 //x2=1.34 //y2=1.435
r355 (  95 129 ) resistor r=592.245 //w=0.094 //l=1.155 //layer=ply \
 //thickness=0.18 //x=10.59 //y=6.2 //x2=10.59 //y2=5.045
r356 (  94 151 ) resistor r=592.245 //w=0.094 //l=1.155 //layer=ply \
 //thickness=0.18 //x=10.15 //y=6.2 //x2=10.15 //y2=5.045
r357 (  93 110 ) resistor r=592.245 //w=0.094 //l=1.155 //layer=ply \
 //thickness=0.18 //x=1.825 //y=6.2 //x2=1.825 //y2=5.045
r358 (  92 100 ) resistor r=592.245 //w=0.094 //l=1.155 //layer=ply \
 //thickness=0.18 //x=1.385 //y=6.2 //x2=1.385 //y2=5.045
r359 (  91 126 ) resistor r=56.4043 //w=0.094 //l=0.11 //layer=ply \
 //thickness=0.18 //x=10.41 //y=1.585 //x2=10.52 //y2=1.585
r360 (  91 127 ) resistor r=56.4043 //w=0.094 //l=0.11 //layer=ply \
 //thickness=0.18 //x=10.41 //y=1.585 //x2=10.3 //y2=1.585
r361 (  90 107 ) resistor r=56.4043 //w=0.094 //l=0.11 //layer=ply \
 //thickness=0.18 //x=1.605 //y=1.59 //x2=1.715 //y2=1.59
r362 (  90 108 ) resistor r=56.4043 //w=0.094 //l=0.11 //layer=ply \
 //thickness=0.18 //x=1.605 //y=1.59 //x2=1.495 //y2=1.59
r363 (  86 148 ) resistor r=152 //w=0.17 //l=0.17 //layer=licon //count=1 \
 //x=10.14 //y=4.88 //x2=10.14 //y2=4.88
r364 (  77 144 ) resistor r=152 //w=0.17 //l=0.17 //layer=licon //count=1 \
 //x=10.11 //y=2.26 //x2=10.11 //y2=2.26
r365 (  72 138 ) resistor r=152 //w=0.17 //l=0.17 //layer=licon //count=1 \
 //x=1.23 //y=4.88 //x2=1.23 //y2=4.88
r366 (  63 135 ) resistor r=152 //w=0.17 //l=0.17 //layer=licon //count=1 \
 //x=1.23 //y=2.265 //x2=1.23 //y2=2.265
r367 (  59 60 ) resistor r=0.107671 //w=0.266 //l=0.16 //layer=m2 \
 //thickness=0.36 //x=10.11 //y=4.262 //x2=9.95 //y2=4.262
r368 (  57 60 ) resistor r=8.16794 //w=0.131 //l=8.56 //layer=m2 \
 //thickness=0.36 //x=1.39 //y=4.25 //x2=9.95 //y2=4.25
r369 (  55 57 ) resistor r=0.107671 //w=0.266 //l=0.16 //layer=m2 \
 //thickness=0.36 //x=1.23 //y=4.262 //x2=1.39 //y2=4.262
r370 (  51 86 ) resistor r=9.3 //w=0.17 //l=0.17 //layer=mcon //count=1 \
 //x=10.14 //y=4.88 //x2=10.14 //y2=4.88
r371 (  47 77 ) resistor r=9.3 //w=0.17 //l=0.17 //layer=mcon //count=1 \
 //x=10.11 //y=2.26 //x2=10.11 //y2=2.26
r372 (  47 49 ) resistor r=0.0936408 //w=0.196 //l=0.125 //layer=m1 \
 //thickness=0.36 //x=10.112 //y=2.26 //x2=10.112 //y2=2.385
r373 (  45 59 ) resistor r=4.5 //w=0.15 //l=0.15 //layer=via1 //count=1 \
 //x=10.11 //y=4.255 //x2=10.11 //y2=4.255
r374 (  41 55 ) resistor r=4.5 //w=0.15 //l=0.15 //layer=via1 //count=1 \
 //x=1.23 //y=4.255 //x2=1.23 //y2=4.255
r375 (  37 72 ) resistor r=9.3 //w=0.17 //l=0.17 //layer=mcon //count=1 \
 //x=1.23 //y=4.88 //x2=1.23 //y2=4.88
r376 (  33 63 ) resistor r=9.3 //w=0.17 //l=0.17 //layer=mcon //count=1 \
 //x=1.23 //y=2.265 //x2=1.23 //y2=2.265
r377 (  30 51 ) resistor r=0.0878548 //w=0.228 //l=0.159295 //layer=m1 \
 //thickness=0.36 //x=10.11 //y=4.735 //x2=10.14 //y2=4.88
r378 (  29 45 ) resistor r=0.0912814 //w=0.379 //l=0.184608 //layer=m1 \
 //thickness=0.36 //x=10.11 //y=4.415 //x2=10.057 //y2=4.255
r379 (  21 37 ) resistor r=0.0732479 //w=0.241 //l=0.122474 //layer=m1 \
 //thickness=0.36 //x=1.23 //y=4.76 //x2=1.235 //y2=4.88
r380 (  20 41 ) resistor r=0.0912814 //w=0.379 //l=0.184174 //layer=m1 \
 //thickness=0.36 //x=1.23 //y=4.415 //x2=1.282 //y2=4.255
r381 (  13 45 ) resistor r=0.00164908 //w=0.379 //l=0.005 //layer=m1 \
 //thickness=0.36 //x=10.057 //y=4.25 //x2=10.057 //y2=4.255
r382 (  13 24 ) resistor r=0.0846851 //w=0.379 //l=0.164378 //layer=m1 \
 //thickness=0.36 //x=10.057 //y=4.25 //x2=10.11 //y2=4.11
r383 (  12 41 ) resistor r=0.00164908 //w=0.379 //l=0.005 //layer=m1 \
 //thickness=0.36 //x=1.282 //y=4.25 //x2=1.282 //y2=4.255
r384 (  12 15 ) resistor r=0.0846851 //w=0.379 //l=0.163951 //layer=m1 \
 //thickness=0.36 //x=1.282 //y=4.25 //x2=1.23 //y2=4.11
r385 (  11 14 ) resistor r=0.0360744 //w=0.211 //l=0.03 //layer=m1 \
 //thickness=0.36 //x=1.23 //y=2.4 //x2=1.23 //y2=2.43
r386 (  11 33 ) resistor r=0.0799763 //w=0.211 //l=0.135 //layer=m1 \
 //thickness=0.36 //x=1.23 //y=2.4 //x2=1.23 //y2=2.265
r387 (  10 30 ) resistor r=0.109733 //w=0.131 //l=0.115 //layer=m1 \
 //thickness=0.36 //x=10.11 //y=4.62 //x2=10.11 //y2=4.735
r388 (  10 29 ) resistor r=0.195611 //w=0.131 //l=0.205 //layer=m1 \
 //thickness=0.36 //x=10.11 //y=4.62 //x2=10.11 //y2=4.415
r389 (  9 24 ) resistor r=0.572519 //w=0.131 //l=0.6 //layer=m1 \
 //thickness=0.36 //x=10.11 //y=3.51 //x2=10.11 //y2=4.11
r390 (  8 9 ) resistor r=0.353053 //w=0.131 //l=0.37 //layer=m1 \
 //thickness=0.36 //x=10.11 //y=3.14 //x2=10.11 //y2=3.51
r391 (  7 8 ) resistor r=0.353053 //w=0.131 //l=0.37 //layer=m1 \
 //thickness=0.36 //x=10.11 //y=2.77 //x2=10.11 //y2=3.14
r392 (  6 7 ) resistor r=0.353053 //w=0.131 //l=0.37 //layer=m1 \
 //thickness=0.36 //x=10.11 //y=2.4 //x2=10.11 //y2=2.77
r393 (  6 49 ) resistor r=0.014313 //w=0.131 //l=0.015 //layer=m1 \
 //thickness=0.36 //x=10.11 //y=2.4 //x2=10.11 //y2=2.385
r394 (  5 21 ) resistor r=0.133588 //w=0.131 //l=0.14 //layer=m1 \
 //thickness=0.36 //x=1.23 //y=4.62 //x2=1.23 //y2=4.76
r395 (  5 20 ) resistor r=0.195611 //w=0.131 //l=0.205 //layer=m1 \
 //thickness=0.36 //x=1.23 //y=4.62 //x2=1.23 //y2=4.415
r396 (  4 15 ) resistor r=0.219466 //w=0.131 //l=0.23 //layer=m1 \
 //thickness=0.36 //x=1.23 //y=3.88 //x2=1.23 //y2=4.11
r397 (  3 4 ) resistor r=0.353053 //w=0.131 //l=0.37 //layer=m1 \
 //thickness=0.36 //x=1.23 //y=3.51 //x2=1.23 //y2=3.88
r398 (  2 3 ) resistor r=0.353053 //w=0.131 //l=0.37 //layer=m1 \
 //thickness=0.36 //x=1.23 //y=3.14 //x2=1.23 //y2=3.51
r399 (  1 2 ) resistor r=0.353053 //w=0.131 //l=0.37 //layer=m1 \
 //thickness=0.36 //x=1.23 //y=2.77 //x2=1.23 //y2=3.14
r400 (  1 14 ) resistor r=0.324427 //w=0.131 //l=0.34 //layer=m1 \
 //thickness=0.36 //x=1.23 //y=2.77 //x2=1.23 //y2=2.43
ends PM_DLATCH\%D

subckt PM_DLATCH\%noxref_5 ( 3 8 9 11 12 14 15 16 18 19 20 23 24 27 29 32 35 \
 38 42 43 48 51 59 76 85 89 90 91 92 93 94 95 99 100 101 103 109 110 112 120 \
 122 123 )
c258 ( 120 0 ) capacitor c=0.00878249f //x=10.22 //y=1.085
c259 ( 112 0 ) capacitor c=0.0545922f //x=12.33 //y=2.265
c260 ( 110 0 ) capacitor c=0.0439576f //x=12.97 //y=1.435
c261 ( 109 0 ) capacitor c=0.0201087f //x=12.97 //y=1.09
c262 ( 103 0 ) capacitor c=0.0161986f //x=12.815 //y=1.59
c263 ( 101 0 ) capacitor c=0.0157807f //x=12.815 //y=0.935
c264 ( 100 0 ) capacitor c=0.055513f //x=12.56 //y=4.97
c265 ( 99 0 ) capacitor c=0.0392651f //x=12.85 //y=4.97
c266 ( 95 0 ) capacitor c=0.0301471f //x=12.44 //y=2.1
c267 ( 94 0 ) capacitor c=0.0255349f //x=12.44 //y=1.745
c268 ( 93 0 ) capacitor c=0.0234346f //x=12.44 //y=1.435
c269 ( 92 0 ) capacitor c=0.02013f //x=12.44 //y=1.09
c270 ( 91 0 ) capacitor c=0.153927f //x=12.925 //y=6.2
c271 ( 90 0 ) capacitor c=0.154397f //x=12.485 //y=6.2
c272 ( 85 0 ) capacitor c=9.4527e-19 //x=12.33 //y=4.88
c273 ( 76 0 ) capacitor c=9.11699e-19 //x=12.33 //y=2.265
c274 ( 59 0 ) capacitor c=0.0321204f //x=10.37 //y=5.56
c275 ( 51 0 ) capacitor c=0.0289608f //x=9.49 //y=5.56
c276 ( 48 0 ) capacitor c=0.00220219f //x=12.325 //y=3.51
c277 ( 43 0 ) capacitor c=0.00305592f //x=11.01 //y=3.51
c278 ( 42 0 ) capacitor c=0.0369863f //x=12.165 //y=3.51
c279 ( 38 0 ) capacitor c=0.00754811f //x=12.33 //y=2.265
c280 ( 35 0 ) capacitor c=0.0159873f //x=12.325 //y=3.51
c281 ( 32 0 ) capacitor c=0.0165963f //x=10.85 //y=3.51
c282 ( 29 0 ) capacitor c=0.0114519f //x=10.41 //y=1.18
c283 ( 27 0 ) capacitor c=7.81299e-19 //x=10.37 //y=5.56
c284 ( 24 0 ) capacitor c=0.0113101f //x=10.37 //y=5.38
c285 ( 23 0 ) capacitor c=0.00950475f //x=9.49 //y=5.56
c286 ( 20 0 ) capacitor c=0.0286278f //x=12.33 //y=4.76
c287 ( 19 0 ) capacitor c=0.0125679f //x=12.33 //y=3.67
c288 ( 18 0 ) capacitor c=0.0237855f //x=12.33 //y=3.35
c289 ( 16 0 ) capacitor c=0.0375219f //x=10.85 //y=5.295
c290 ( 15 0 ) capacitor c=0.013044f //x=10.85 //y=3.67
c291 ( 14 0 ) capacitor c=0.0348316f //x=10.85 //y=3.35
c292 ( 12 0 ) capacitor c=0.00681098f //x=10.495 //y=1.835
c293 ( 11 0 ) capacitor c=0.0138793f //x=10.765 //y=1.835
c294 ( 9 0 ) capacitor c=0.0119111f //x=10.765 //y=5.38
c295 ( 8 0 ) capacitor c=0.0090797f //x=10.41 //y=1.75
c296 ( 3 0 ) capacitor c=0.0136603f //x=10.255 //y=5.38
r297 (  112 113 ) resistor r=17.5563 //w=0.302 //l=0.11 //layer=ply \
 //thickness=0.18 //x=12.33 //y=2.265 //x2=12.44 //y2=2.265
r298 (  110 119 ) resistor r=45.1352 //w=0.168 //l=0.173853 //layer=ply \
 //thickness=0.18 //x=12.97 //y=1.435 //x2=12.93 //y2=1.59
r299 (  109 118 ) resistor r=45.1352 //w=0.168 //l=0.173853 //layer=ply \
 //thickness=0.18 //x=12.97 //y=1.09 //x2=12.93 //y2=0.935
r300 (  109 110 ) resistor r=176.904 //w=0.094 //l=0.345 //layer=ply \
 //thickness=0.18 //x=12.97 //y=1.09 //x2=12.97 //y2=1.435
r301 (  104 117 ) resistor r=10.701 //w=0.21 //l=0.115 //layer=ply \
 //thickness=0.18 //x=12.595 //y=1.59 //x2=12.48 //y2=1.59
r302 (  103 119 ) resistor r=5.52526 //w=0.168 //l=0.115 //layer=ply \
 //thickness=0.18 //x=12.815 //y=1.59 //x2=12.93 //y2=1.59
r303 (  102 116 ) resistor r=5.52526 //w=0.168 //l=0.115 //layer=ply \
 //thickness=0.18 //x=12.595 //y=0.935 //x2=12.48 //y2=0.935
r304 (  101 118 ) resistor r=5.52526 //w=0.168 //l=0.115 //layer=ply \
 //thickness=0.18 //x=12.815 //y=0.935 //x2=12.93 //y2=0.935
r305 (  101 102 ) resistor r=112.809 //w=0.094 //l=0.22 //layer=ply \
 //thickness=0.18 //x=12.815 //y=0.935 //x2=12.595 //y2=0.935
r306 (  99 106 ) resistor r=26.9307 //w=0.15 //l=0.106066 //layer=ply \
 //thickness=0.18 //x=12.85 //y=4.97 //x2=12.925 //y2=5.045
r307 (  99 100 ) resistor r=148.702 //w=0.094 //l=0.29 //layer=ply \
 //thickness=0.18 //x=12.85 //y=4.97 //x2=12.56 //y2=4.97
r308 (  96 100 ) resistor r=23.403 //w=0.284 //l=0.106066 //layer=ply \
 //thickness=0.18 //x=12.485 //y=5.045 //x2=12.56 //y2=4.97
r309 (  96 115 ) resistor r=26.3063 //w=0.284 //l=0.229783 //layer=ply \
 //thickness=0.18 //x=12.485 //y=5.045 //x2=12.33 //y2=4.88
r310 (  95 113 ) resistor r=19.1248 //w=0.302 //l=0.165 //layer=ply \
 //thickness=0.18 //x=12.44 //y=2.1 //x2=12.44 //y2=2.265
r311 (  94 117 ) resistor r=39.5823 //w=0.21 //l=0.173853 //layer=ply \
 //thickness=0.18 //x=12.44 //y=1.745 //x2=12.48 //y2=1.59
r312 (  94 95 ) resistor r=182.032 //w=0.094 //l=0.355 //layer=ply \
 //thickness=0.18 //x=12.44 //y=1.745 //x2=12.44 //y2=2.1
r313 (  93 117 ) resistor r=39.5823 //w=0.21 //l=0.173853 //layer=ply \
 //thickness=0.18 //x=12.44 //y=1.435 //x2=12.48 //y2=1.59
r314 (  92 116 ) resistor r=45.1352 //w=0.168 //l=0.173853 //layer=ply \
 //thickness=0.18 //x=12.44 //y=1.09 //x2=12.48 //y2=0.935
r315 (  92 93 ) resistor r=176.904 //w=0.094 //l=0.345 //layer=ply \
 //thickness=0.18 //x=12.44 //y=1.09 //x2=12.44 //y2=1.435
r316 (  91 106 ) resistor r=592.245 //w=0.094 //l=1.155 //layer=ply \
 //thickness=0.18 //x=12.925 //y=6.2 //x2=12.925 //y2=5.045
r317 (  90 96 ) resistor r=592.245 //w=0.094 //l=1.155 //layer=ply \
 //thickness=0.18 //x=12.485 //y=6.2 //x2=12.485 //y2=5.045
r318 (  89 103 ) resistor r=56.4043 //w=0.094 //l=0.11 //layer=ply \
 //thickness=0.18 //x=12.705 //y=1.59 //x2=12.815 //y2=1.59
r319 (  89 104 ) resistor r=56.4043 //w=0.094 //l=0.11 //layer=ply \
 //thickness=0.18 //x=12.705 //y=1.59 //x2=12.595 //y2=1.59
r320 (  85 115 ) resistor r=152 //w=0.17 //l=0.17 //layer=licon //count=1 \
 //x=12.33 //y=4.88 //x2=12.33 //y2=4.88
r321 (  76 112 ) resistor r=152 //w=0.17 //l=0.17 //layer=licon //count=1 \
 //x=12.33 //y=2.265 //x2=12.33 //y2=2.265
r322 (  59 123 ) resistor r=23.615 //w=0.187 //l=0.345 //layer=li \
 //thickness=0.1 //x=10.37 //y=5.56 //x2=10.37 //y2=5.905
r323 (  51 122 ) resistor r=23.615 //w=0.187 //l=0.345 //layer=li \
 //thickness=0.1 //x=9.49 //y=5.56 //x2=9.49 //y2=5.905
r324 (  43 45 ) resistor r=0.10734 //w=0.281 //l=0.16 //layer=m2 \
 //thickness=0.36 //x=11.01 //y=3.51 //x2=10.85 //y2=3.51
r325 (  42 48 ) resistor r=0.10734 //w=0.281 //l=0.16 //layer=m2 \
 //thickness=0.36 //x=12.165 //y=3.51 //x2=12.325 //y2=3.51
r326 (  42 43 ) resistor r=1.1021 //w=0.131 //l=1.155 //layer=m2 \
 //thickness=0.36 //x=12.165 //y=3.51 //x2=11.01 //y2=3.51
r327 (  41 85 ) resistor r=9.3 //w=0.17 //l=0.17 //layer=mcon //count=1 \
 //x=12.33 //y=4.88 //x2=12.33 //y2=4.88
r328 (  38 76 ) resistor r=9.3 //w=0.17 //l=0.17 //layer=mcon //count=1 \
 //x=12.33 //y=2.265 //x2=12.33 //y2=2.265
r329 (  35 48 ) resistor r=4.5 //w=0.15 //l=0.15 //layer=via1 //count=1 \
 //x=12.325 //y=3.51 //x2=12.325 //y2=3.51
r330 (  32 45 ) resistor r=4.5 //w=0.15 //l=0.15 //layer=via1 //count=1 \
 //x=10.85 //y=3.51 //x2=10.85 //y2=3.51
r331 (  29 120 ) resistor r=9.3 //w=0.17 //l=0.17 //layer=mcon //count=1 \
 //x=10.41 //y=1.18 //x2=10.41 //y2=1.18
r332 (  27 59 ) resistor r=9.3 //w=0.17 //l=0.17 //layer=mcon //count=1 \
 //x=10.37 //y=5.56 //x2=10.37 //y2=5.56
r333 (  24 27 ) resistor r=0.117801 //w=0.191 //l=0.18 //layer=m1 \
 //thickness=0.36 //x=10.37 //y=5.38 //x2=10.37 //y2=5.56
r334 (  23 51 ) resistor r=9.3 //w=0.17 //l=0.17 //layer=mcon //count=1 \
 //x=9.49 //y=5.56 //x2=9.49 //y2=5.56
r335 (  21 23 ) resistor r=0.10274 //w=0.219 //l=0.18 //layer=m1 \
 //thickness=0.36 //x=9.49 //y=5.38 //x2=9.49 //y2=5.56
r336 (  20 41 ) resistor r=0.0732479 //w=0.241 //l=0.122474 //layer=m1 \
 //thickness=0.36 //x=12.33 //y=4.76 //x2=12.335 //y2=4.88
r337 (  19 35 ) resistor r=0.0910802 //w=0.374 //l=0.185472 //layer=m1 \
 //thickness=0.36 //x=12.33 //y=3.67 //x2=12.275 //y2=3.51
r338 (  19 20 ) resistor r=1.04008 //w=0.131 //l=1.09 //layer=m1 \
 //thickness=0.36 //x=12.33 //y=3.67 //x2=12.33 //y2=4.76
r339 (  18 35 ) resistor r=0.0910802 //w=0.374 //l=0.185472 //layer=m1 \
 //thickness=0.36 //x=12.33 //y=3.35 //x2=12.275 //y2=3.51
r340 (  17 38 ) resistor r=0.116051 //w=0.211 //l=0.165 //layer=m1 \
 //thickness=0.36 //x=12.33 //y=2.43 //x2=12.33 //y2=2.265
r341 (  17 18 ) resistor r=0.877863 //w=0.131 //l=0.92 //layer=m1 \
 //thickness=0.36 //x=12.33 //y=2.43 //x2=12.33 //y2=3.35
r342 (  15 32 ) resistor r=0.0911593 //w=0.376 //l=0.184174 //layer=m1 \
 //thickness=0.36 //x=10.85 //y=3.67 //x2=10.902 //y2=3.51
r343 (  15 16 ) resistor r=1.55057 //w=0.131 //l=1.625 //layer=m1 \
 //thickness=0.36 //x=10.85 //y=3.67 //x2=10.85 //y2=5.295
r344 (  14 32 ) resistor r=0.0911593 //w=0.376 //l=0.184174 //layer=m1 \
 //thickness=0.36 //x=10.85 //y=3.35 //x2=10.902 //y2=3.51
r345 (  13 14 ) resistor r=1.3645 //w=0.131 //l=1.43 //layer=m1 \
 //thickness=0.36 //x=10.85 //y=1.92 //x2=10.85 //y2=3.35
r346 (  11 13 ) resistor r=0.0698411 //w=0.17 //l=0.120208 //layer=m1 \
 //thickness=0.36 //x=10.765 //y=1.835 //x2=10.85 //y2=1.92
r347 (  11 12 ) resistor r=0.257634 //w=0.131 //l=0.27 //layer=m1 \
 //thickness=0.36 //x=10.765 //y=1.835 //x2=10.495 //y2=1.835
r348 (  10 24 ) resistor r=0.0257089 //w=0.23 //l=0.115 //layer=m1 \
 //thickness=0.36 //x=10.485 //y=5.38 //x2=10.37 //y2=5.38
r349 (  9 16 ) resistor r=0.0698411 //w=0.17 //l=0.120208 //layer=m1 \
 //thickness=0.36 //x=10.765 //y=5.38 //x2=10.85 //y2=5.295
r350 (  9 10 ) resistor r=0.267176 //w=0.131 //l=0.28 //layer=m1 \
 //thickness=0.36 //x=10.765 //y=5.38 //x2=10.485 //y2=5.38
r351 (  8 12 ) resistor r=0.0698411 //w=0.17 //l=0.120208 //layer=m1 \
 //thickness=0.36 //x=10.41 //y=1.75 //x2=10.495 //y2=1.835
r352 (  7 29 ) resistor r=0.0913624 //w=0.191 //l=0.12 //layer=m1 \
 //thickness=0.36 //x=10.41 //y=1.3 //x2=10.41 //y2=1.18
r353 (  7 8 ) resistor r=0.429389 //w=0.131 //l=0.45 //layer=m1 \
 //thickness=0.36 //x=10.41 //y=1.3 //x2=10.41 //y2=1.75
r354 (  4 21 ) resistor r=0.0227762 //w=0.219 //l=0.115 //layer=m1 \
 //thickness=0.36 //x=9.605 //y=5.38 //x2=9.49 //y2=5.38
r355 (  3 24 ) resistor r=0.0257089 //w=0.23 //l=0.115 //layer=m1 \
 //thickness=0.36 //x=10.255 //y=5.38 //x2=10.37 //y2=5.38
r356 (  3 4 ) resistor r=0.620229 //w=0.131 //l=0.65 //layer=m1 \
 //thickness=0.36 //x=10.255 //y=5.38 //x2=9.605 //y2=5.38
ends PM_DLATCH\%noxref_5

subckt PM_DLATCH\%noxref_6 ( 2 4 5 6 7 8 10 11 12 14 15 16 18 25 29 31 35 37 \
 39 41 43 48 57 69 74 82 83 84 85 86 87 88 92 94 97 99 100 105 115 117 )
c299 ( 115 0 ) capacitor c=0.00875839f //x=6.965 //y=1.09
c300 ( 105 0 ) capacitor c=0.041107f //x=14.765 //y=4.885
c301 ( 100 0 ) capacitor c=0.0337825f //x=15.255 //y=1.43
c302 ( 99 0 ) capacitor c=0.0183823f //x=15.255 //y=1.085
c303 ( 97 0 ) capacitor c=0.0343555f //x=15.185 //y=4.975
c304 ( 94 0 ) capacitor c=0.013578f //x=15.1 //y=1.585
c305 ( 92 0 ) capacitor c=0.0157803f //x=15.1 //y=0.93
c306 ( 88 0 ) capacitor c=0.085272f //x=14.725 //y=2.095
c307 ( 87 0 ) capacitor c=0.0230165f //x=14.725 //y=1.74
c308 ( 86 0 ) capacitor c=0.0234348f //x=14.725 //y=1.43
c309 ( 85 0 ) capacitor c=0.019134f //x=14.725 //y=1.085
c310 ( 84 0 ) capacitor c=0.110994f //x=15.26 //y=6.205
c311 ( 83 0 ) capacitor c=0.154777f //x=14.82 //y=6.205
c312 ( 74 0 ) capacitor c=7.43216e-19 //x=14.92 //y=2.26
c313 ( 69 0 ) capacitor c=0.0070524f //x=14.765 //y=4.885
c314 ( 57 0 ) capacitor c=0.0261756f //x=7.155 //y=5.56
c315 ( 48 0 ) capacitor c=6.49987e-19 //x=7.68 //y=3.872
c316 ( 43 0 ) capacitor c=0.0818045f //x=12.54 //y=3.895
c317 ( 41 0 ) capacitor c=0.0320946f //x=11.94 //y=3.88
c318 ( 39 0 ) capacitor c=0.0133628f //x=11.068 //y=3.892
c319 ( 37 0 ) capacitor c=0.0590048f //x=10.465 //y=3.88
c320 ( 35 0 ) capacitor c=0.00928045f //x=14.765 //y=4.885
c321 ( 31 0 ) capacitor c=0.0067534f //x=14.92 //y=2.26
c322 ( 29 0 ) capacitor c=0.0150763f //x=14.92 //y=3.88
c323 ( 25 0 ) capacitor c=0.015696f //x=7.52 //y=3.88
c324 ( 18 0 ) capacitor c=0.015253f //x=7.15 //y=1.185
c325 ( 16 0 ) capacitor c=0.0179237f //x=14.92 //y=4.765
c326 ( 15 0 ) capacitor c=0.0109029f //x=14.92 //y=4.025
c327 ( 14 0 ) capacitor c=0.0402106f //x=14.92 //y=3.72
c328 ( 12 0 ) capacitor c=0.0211643f //x=7.52 //y=5.055
c329 ( 11 0 ) capacitor c=0.0126045f //x=7.52 //y=4.025
c330 ( 10 0 ) capacitor c=0.0389499f //x=7.52 //y=3.72
c331 ( 8 0 ) capacitor c=0.00475217f //x=7.24 //y=5.14
c332 ( 7 0 ) capacitor c=0.00730223f //x=7.435 //y=5.14
c333 ( 6 0 ) capacitor c=0.00649906f //x=7.235 //y=2.02
c334 ( 5 0 ) capacitor c=0.0122625f //x=7.435 //y=2.02
c335 ( 4 0 ) capacitor c=0.010593f //x=7.155 //y=5.42
c336 ( 2 0 ) capacitor c=0.0122563f //x=7.15 //y=1.935
r337 (  107 108 ) resistor r=32.4568 //w=0.214 //l=0.075 //layer=ply \
 //thickness=0.18 //x=14.765 //y=4.975 //x2=14.765 //y2=5.05
r338 (  105 107 ) resistor r=20.271 //w=0.214 //l=0.09 //layer=ply \
 //thickness=0.18 //x=14.765 //y=4.885 //x2=14.765 //y2=4.975
r339 (  100 114 ) resistor r=45.1352 //w=0.168 //l=0.173853 //layer=ply \
 //thickness=0.18 //x=15.255 //y=1.43 //x2=15.215 //y2=1.585
r340 (  99 113 ) resistor r=45.1352 //w=0.168 //l=0.173853 //layer=ply \
 //thickness=0.18 //x=15.255 //y=1.085 //x2=15.215 //y2=0.93
r341 (  99 100 ) resistor r=176.904 //w=0.094 //l=0.345 //layer=ply \
 //thickness=0.18 //x=15.255 //y=1.085 //x2=15.255 //y2=1.43
r342 (  98 107 ) resistor r=16.5046 //w=0.27 //l=0.135 //layer=ply \
 //thickness=0.18 //x=14.9 //y=4.975 //x2=14.765 //y2=4.975
r343 (  97 101 ) resistor r=26.9307 //w=0.15 //l=0.106066 //layer=ply \
 //thickness=0.18 //x=15.185 //y=4.975 //x2=15.26 //y2=5.05
r344 (  97 98 ) resistor r=146.138 //w=0.094 //l=0.285 //layer=ply \
 //thickness=0.18 //x=15.185 //y=4.975 //x2=14.9 //y2=4.975
r345 (  95 112 ) resistor r=10.701 //w=0.21 //l=0.115 //layer=ply \
 //thickness=0.18 //x=14.88 //y=1.585 //x2=14.765 //y2=1.585
r346 (  94 114 ) resistor r=5.52526 //w=0.168 //l=0.115 //layer=ply \
 //thickness=0.18 //x=15.1 //y=1.585 //x2=15.215 //y2=1.585
r347 (  93 111 ) resistor r=5.52526 //w=0.168 //l=0.115 //layer=ply \
 //thickness=0.18 //x=14.88 //y=0.93 //x2=14.765 //y2=0.93
r348 (  92 113 ) resistor r=5.52526 //w=0.168 //l=0.115 //layer=ply \
 //thickness=0.18 //x=15.1 //y=0.93 //x2=15.215 //y2=0.93
r349 (  92 93 ) resistor r=112.809 //w=0.094 //l=0.22 //layer=ply \
 //thickness=0.18 //x=15.1 //y=0.93 //x2=14.88 //y2=0.93
r350 (  88 110 ) resistor r=34.8111 //w=0.27 //l=0.264953 //layer=ply \
 //thickness=0.18 //x=14.725 //y=2.095 //x2=14.92 //y2=2.26
r351 (  87 112 ) resistor r=39.5823 //w=0.21 //l=0.173853 //layer=ply \
 //thickness=0.18 //x=14.725 //y=1.74 //x2=14.765 //y2=1.585
r352 (  87 88 ) resistor r=182.032 //w=0.094 //l=0.355 //layer=ply \
 //thickness=0.18 //x=14.725 //y=1.74 //x2=14.725 //y2=2.095
r353 (  86 112 ) resistor r=39.5823 //w=0.21 //l=0.173853 //layer=ply \
 //thickness=0.18 //x=14.725 //y=1.43 //x2=14.765 //y2=1.585
r354 (  85 111 ) resistor r=45.1352 //w=0.168 //l=0.173853 //layer=ply \
 //thickness=0.18 //x=14.725 //y=1.085 //x2=14.765 //y2=0.93
r355 (  85 86 ) resistor r=176.904 //w=0.094 //l=0.345 //layer=ply \
 //thickness=0.18 //x=14.725 //y=1.085 //x2=14.725 //y2=1.43
r356 (  84 101 ) resistor r=592.245 //w=0.094 //l=1.155 //layer=ply \
 //thickness=0.18 //x=15.26 //y=6.205 //x2=15.26 //y2=5.05
r357 (  83 108 ) resistor r=592.245 //w=0.094 //l=1.155 //layer=ply \
 //thickness=0.18 //x=14.82 //y=6.205 //x2=14.82 //y2=5.05
r358 (  82 94 ) resistor r=56.4043 //w=0.094 //l=0.11 //layer=ply \
 //thickness=0.18 //x=14.99 //y=1.585 //x2=15.1 //y2=1.585
r359 (  82 95 ) resistor r=56.4043 //w=0.094 //l=0.11 //layer=ply \
 //thickness=0.18 //x=14.99 //y=1.585 //x2=14.88 //y2=1.585
r360 (  74 110 ) resistor r=152 //w=0.17 //l=0.17 //layer=licon //count=1 \
 //x=14.92 //y=2.26 //x2=14.92 //y2=2.26
r361 (  69 105 ) resistor r=152 //w=0.17 //l=0.17 //layer=licon //count=1 \
 //x=14.765 //y=4.885 //x2=14.765 //y2=4.885
r362 (  57 117 ) resistor r=23.615 //w=0.187 //l=0.345 //layer=li \
 //thickness=0.1 //x=7.155 //y=5.56 //x2=7.155 //y2=5.905
r363 (  46 48 ) resistor r=0.107671 //w=0.266 //l=0.16 //layer=m2 \
 //thickness=0.36 //x=7.52 //y=3.872 //x2=7.68 //y2=3.872
r364 (  43 50 ) resistor r=1.58385 //w=0.188 //l=2.39147 //layer=m2 \
 //thickness=0.36 //x=12.54 //y=3.895 //x2=14.92 //y2=3.872
r365 (  43 44 ) resistor r=0.329198 //w=0.131 //l=0.345 //layer=m2 \
 //thickness=0.36 //x=12.54 //y=3.895 //x2=12.195 //y2=3.895
r366 (  41 44 ) resistor r=0.1875 //w=0.17 //l=0.262393 //layer=m2 \
 //thickness=0.36 //x=11.94 //y=3.88 //x2=12.195 //y2=3.895
r367 (  41 42 ) resistor r=0.67271 //w=0.131 //l=0.705 //layer=m2 \
 //thickness=0.36 //x=11.94 //y=3.88 //x2=11.235 //y2=3.88
r368 (  39 42 ) resistor r=0.124256 //w=0.168 //l=0.172896 //layer=m2 \
 //thickness=0.36 //x=11.068 //y=3.892 //x2=11.235 //y2=3.88
r369 (  39 40 ) resistor r=0.350198 //w=0.126 //l=0.353 //layer=m2 \
 //thickness=0.36 //x=11.068 //y=3.892 //x2=10.715 //y2=3.892
r370 (  37 40 ) resistor r=0.187126 //w=0.167 //l=0.25593 //layer=m2 \
 //thickness=0.36 //x=10.465 //y=3.88 //x2=10.715 //y2=3.892
r371 (  37 48 ) resistor r=2.65744 //w=0.131 //l=2.785 //layer=m2 \
 //thickness=0.36 //x=10.465 //y=3.88 //x2=7.68 //y2=3.88
r372 (  35 69 ) resistor r=9.3 //w=0.17 //l=0.17 //layer=mcon //count=1 \
 //x=14.765 //y=4.885 //x2=14.765 //y2=4.885
r373 (  35 36 ) resistor r=0.0853524 //w=0.227 //l=0.155 //layer=m1 \
 //thickness=0.36 //x=14.765 //y=4.882 //x2=14.92 //y2=4.882
r374 (  31 74 ) resistor r=9.3 //w=0.17 //l=0.17 //layer=mcon //count=1 \
 //x=14.92 //y=2.26 //x2=14.92 //y2=2.26
r375 (  31 33 ) resistor r=0.0985786 //w=0.206 //l=0.135 //layer=m1 \
 //thickness=0.36 //x=14.917 //y=2.26 //x2=14.917 //y2=2.395
r376 (  27 50 ) resistor r=4.5 //w=0.15 //l=0.15 //layer=via1 //count=1 \
 //x=14.92 //y=3.865 //x2=14.92 //y2=3.865
r377 (  27 29 ) resistor r=0.00494723 //w=0.379 //l=0.015 //layer=m1 \
 //thickness=0.36 //x=14.867 //y=3.865 //x2=14.867 //y2=3.88
r378 (  23 46 ) resistor r=4.5 //w=0.15 //l=0.15 //layer=via1 //count=1 \
 //x=7.52 //y=3.865 //x2=7.52 //y2=3.865
r379 (  23 25 ) resistor r=0.00494723 //w=0.379 //l=0.015 //layer=m1 \
 //thickness=0.36 //x=7.572 //y=3.865 //x2=7.572 //y2=3.88
r380 (  21 57 ) resistor r=9.3 //w=0.17 //l=0.17 //layer=mcon //count=1 \
 //x=7.155 //y=5.56 //x2=7.155 //y2=5.56
r381 (  18 115 ) resistor r=9.3 //w=0.17 //l=0.17 //layer=mcon //count=1 \
 //x=7.15 //y=1.185 //x2=7.15 //y2=1.185
r382 (  16 36 ) resistor r=0.0249239 //w=0.227 //l=0.117 //layer=m1 \
 //thickness=0.36 //x=14.92 //y=4.765 //x2=14.92 //y2=4.882
r383 (  15 29 ) resistor r=0.0863342 //w=0.379 //l=0.16944 //layer=m1 \
 //thickness=0.36 //x=14.92 //y=4.025 //x2=14.867 //y2=3.88
r384 (  15 16 ) resistor r=0.706107 //w=0.131 //l=0.74 //layer=m1 \
 //thickness=0.36 //x=14.92 //y=4.025 //x2=14.92 //y2=4.765
r385 (  14 27 ) resistor r=0.0863342 //w=0.379 //l=0.16944 //layer=m1 \
 //thickness=0.36 //x=14.92 //y=3.72 //x2=14.867 //y2=3.865
r386 (  14 33 ) resistor r=1.26431 //w=0.131 //l=1.325 //layer=m1 \
 //thickness=0.36 //x=14.92 //y=3.72 //x2=14.92 //y2=2.395
r387 (  11 25 ) resistor r=0.0863342 //w=0.379 //l=0.169012 //layer=m1 \
 //thickness=0.36 //x=7.52 //y=4.025 //x2=7.572 //y2=3.88
r388 (  11 12 ) resistor r=0.982824 //w=0.131 //l=1.03 //layer=m1 \
 //thickness=0.36 //x=7.52 //y=4.025 //x2=7.52 //y2=5.055
r389 (  10 23 ) resistor r=0.0863342 //w=0.379 //l=0.169012 //layer=m1 \
 //thickness=0.36 //x=7.52 //y=3.72 //x2=7.572 //y2=3.865
r390 (  9 10 ) resistor r=1.54103 //w=0.131 //l=1.615 //layer=m1 \
 //thickness=0.36 //x=7.52 //y=2.105 //x2=7.52 //y2=3.72
r391 (  7 12 ) resistor r=0.0698411 //w=0.17 //l=0.120208 //layer=m1 \
 //thickness=0.36 //x=7.435 //y=5.14 //x2=7.52 //y2=5.055
r392 (  7 8 ) resistor r=0.186069 //w=0.131 //l=0.195 //layer=m1 \
 //thickness=0.36 //x=7.435 //y=5.14 //x2=7.24 //y2=5.14
r393 (  5 9 ) resistor r=0.0698411 //w=0.17 //l=0.120208 //layer=m1 \
 //thickness=0.36 //x=7.435 //y=2.02 //x2=7.52 //y2=2.105
r394 (  5 6 ) resistor r=0.19084 //w=0.131 //l=0.2 //layer=m1 //thickness=0.36 \
 //x=7.435 //y=2.02 //x2=7.235 //y2=2.02
r395 (  4 21 ) resistor r=0.086672 //w=0.218 //l=0.14 //layer=m1 \
 //thickness=0.36 //x=7.155 //y=5.42 //x2=7.155 //y2=5.56
r396 (  3 8 ) resistor r=0.0698411 //w=0.17 //l=0.120208 //layer=m1 \
 //thickness=0.36 //x=7.155 //y=5.225 //x2=7.24 //y2=5.14
r397 (  3 4 ) resistor r=0.186069 //w=0.131 //l=0.195 //layer=m1 \
 //thickness=0.36 //x=7.155 //y=5.225 //x2=7.155 //y2=5.42
r398 (  2 6 ) resistor r=0.0698411 //w=0.17 //l=0.120208 //layer=m1 \
 //thickness=0.36 //x=7.15 //y=1.935 //x2=7.235 //y2=2.02
r399 (  1 18 ) resistor r=0.105739 //w=0.201 //l=0.145 //layer=m1 \
 //thickness=0.36 //x=7.15 //y=1.33 //x2=7.15 //y2=1.185
r400 (  1 2 ) resistor r=0.57729 //w=0.131 //l=0.605 //layer=m1 \
 //thickness=0.36 //x=7.15 //y=1.33 //x2=7.15 //y2=1.935
ends PM_DLATCH\%noxref_6

subckt PM_DLATCH\%Q ( 1 2 3 4 5 6 7 8 9 10 11 12 13 14 15 16 17 19 26 34 39 40 \
 54 58 65 67 68 76 93 98 106 107 108 109 110 111 112 116 118 121 123 124 129 \
 139 140 143 )
c304 ( 140 0 ) capacitor c=0.00901091f //x=15.77 //y=1.085
c305 ( 139 0 ) capacitor c=0.00876479f //x=14.8 //y=1.085
c306 ( 129 0 ) capacitor c=0.0426341f //x=18.095 //y=4.885
c307 ( 124 0 ) capacitor c=0.0337825f //x=18.585 //y=1.43
c308 ( 123 0 ) capacitor c=0.0183823f //x=18.585 //y=1.085
c309 ( 121 0 ) capacitor c=0.0350928f //x=18.515 //y=4.975
c310 ( 118 0 ) capacitor c=0.013578f //x=18.43 //y=1.585
c311 ( 116 0 ) capacitor c=0.0157803f //x=18.43 //y=0.93
c312 ( 112 0 ) capacitor c=0.0826366f //x=18.055 //y=2.095
c313 ( 111 0 ) capacitor c=0.0230165f //x=18.055 //y=1.74
c314 ( 110 0 ) capacitor c=0.0234348f //x=18.055 //y=1.43
c315 ( 109 0 ) capacitor c=0.019134f //x=18.055 //y=1.085
c316 ( 108 0 ) capacitor c=0.110994f //x=18.59 //y=6.205
c317 ( 107 0 ) capacitor c=0.154777f //x=18.15 //y=6.205
c318 ( 98 0 ) capacitor c=7.43216e-19 //x=18.25 //y=2.26
c319 ( 93 0 ) capacitor c=0.0070524f //x=18.095 //y=4.885
c320 ( 76 0 ) capacitor c=0.0241851f //x=15.92 //y=5.56
c321 ( 68 0 ) capacitor c=0.0508872f //x=18.09 //y=3.502
c322 ( 67 0 ) capacitor c=0.00222672f //x=18.25 //y=3.495
c323 ( 65 0 ) capacitor c=0.00303723f //x=16.56 //y=3.502
c324 ( 58 0 ) capacitor c=0.00712318f //x=18.095 //y=4.885
c325 ( 54 0 ) capacitor c=0.00660764f //x=18.25 //y=2.26
c326 ( 40 0 ) capacitor c=0.0127946f //x=15.915 //y=5.39
c327 ( 39 0 ) capacitor c=0.00439923f //x=15.96 //y=1.835
c328 ( 34 0 ) capacitor c=0.0111989f //x=18.25 //y=3.655
c329 ( 26 0 ) capacitor c=0.0133321f //x=16.4 //y=3.655
c330 ( 19 0 ) capacitor c=0.0140849f //x=16.315 //y=1.835
c331 ( 17 0 ) capacitor c=0.0104385f //x=16.315 //y=5.39
c332 ( 16 0 ) capacitor c=0.00708518f //x=15.96 //y=1.75
c333 ( 15 0 ) capacitor c=0.00854148f //x=15.96 //y=1.3
c334 ( 14 0 ) capacitor c=0.00272031f //x=15.075 //y=1.835
c335 ( 13 0 ) capacitor c=0.0202407f //x=15.875 //y=1.835
c336 ( 12 0 ) capacitor c=0.00630911f //x=14.99 //y=1.75
c337 ( 11 0 ) capacitor c=0.00844045f //x=14.99 //y=1.305
c338 ( 10 0 ) capacitor c=0.0168245f //x=18.25 //y=3.51
c339 ( 9 0 ) capacitor c=0.0171695f //x=16.4 //y=3.51
c340 ( 8 0 ) capacitor c=0.0277328f //x=18.25 //y=4.62
c341 ( 5 0 ) capacitor c=0.0288045f //x=18.25 //y=2.4
c342 ( 4 0 ) capacitor c=0.0405306f //x=16.4 //y=4.62
c343 ( 1 0 ) capacitor c=0.0398447f //x=16.4 //y=2.4
r344 (  131 132 ) resistor r=32.4568 //w=0.214 //l=0.075 //layer=ply \
 //thickness=0.18 //x=18.095 //y=4.975 //x2=18.095 //y2=5.05
r345 (  129 131 ) resistor r=20.271 //w=0.214 //l=0.09 //layer=ply \
 //thickness=0.18 //x=18.095 //y=4.885 //x2=18.095 //y2=4.975
r346 (  124 138 ) resistor r=45.1352 //w=0.168 //l=0.173853 //layer=ply \
 //thickness=0.18 //x=18.585 //y=1.43 //x2=18.545 //y2=1.585
r347 (  123 137 ) resistor r=45.1352 //w=0.168 //l=0.173853 //layer=ply \
 //thickness=0.18 //x=18.585 //y=1.085 //x2=18.545 //y2=0.93
r348 (  123 124 ) resistor r=176.904 //w=0.094 //l=0.345 //layer=ply \
 //thickness=0.18 //x=18.585 //y=1.085 //x2=18.585 //y2=1.43
r349 (  122 131 ) resistor r=16.5046 //w=0.27 //l=0.135 //layer=ply \
 //thickness=0.18 //x=18.23 //y=4.975 //x2=18.095 //y2=4.975
r350 (  121 125 ) resistor r=26.9307 //w=0.15 //l=0.106066 //layer=ply \
 //thickness=0.18 //x=18.515 //y=4.975 //x2=18.59 //y2=5.05
r351 (  121 122 ) resistor r=146.138 //w=0.094 //l=0.285 //layer=ply \
 //thickness=0.18 //x=18.515 //y=4.975 //x2=18.23 //y2=4.975
r352 (  119 136 ) resistor r=10.701 //w=0.21 //l=0.115 //layer=ply \
 //thickness=0.18 //x=18.21 //y=1.585 //x2=18.095 //y2=1.585
r353 (  118 138 ) resistor r=5.52526 //w=0.168 //l=0.115 //layer=ply \
 //thickness=0.18 //x=18.43 //y=1.585 //x2=18.545 //y2=1.585
r354 (  117 135 ) resistor r=5.52526 //w=0.168 //l=0.115 //layer=ply \
 //thickness=0.18 //x=18.21 //y=0.93 //x2=18.095 //y2=0.93
r355 (  116 137 ) resistor r=5.52526 //w=0.168 //l=0.115 //layer=ply \
 //thickness=0.18 //x=18.43 //y=0.93 //x2=18.545 //y2=0.93
r356 (  116 117 ) resistor r=112.809 //w=0.094 //l=0.22 //layer=ply \
 //thickness=0.18 //x=18.43 //y=0.93 //x2=18.21 //y2=0.93
r357 (  112 134 ) resistor r=34.8111 //w=0.27 //l=0.264953 //layer=ply \
 //thickness=0.18 //x=18.055 //y=2.095 //x2=18.25 //y2=2.26
r358 (  111 136 ) resistor r=39.5823 //w=0.21 //l=0.173853 //layer=ply \
 //thickness=0.18 //x=18.055 //y=1.74 //x2=18.095 //y2=1.585
r359 (  111 112 ) resistor r=182.032 //w=0.094 //l=0.355 //layer=ply \
 //thickness=0.18 //x=18.055 //y=1.74 //x2=18.055 //y2=2.095
r360 (  110 136 ) resistor r=39.5823 //w=0.21 //l=0.173853 //layer=ply \
 //thickness=0.18 //x=18.055 //y=1.43 //x2=18.095 //y2=1.585
r361 (  109 135 ) resistor r=45.1352 //w=0.168 //l=0.173853 //layer=ply \
 //thickness=0.18 //x=18.055 //y=1.085 //x2=18.095 //y2=0.93
r362 (  109 110 ) resistor r=176.904 //w=0.094 //l=0.345 //layer=ply \
 //thickness=0.18 //x=18.055 //y=1.085 //x2=18.055 //y2=1.43
r363 (  108 125 ) resistor r=592.245 //w=0.094 //l=1.155 //layer=ply \
 //thickness=0.18 //x=18.59 //y=6.205 //x2=18.59 //y2=5.05
r364 (  107 132 ) resistor r=592.245 //w=0.094 //l=1.155 //layer=ply \
 //thickness=0.18 //x=18.15 //y=6.205 //x2=18.15 //y2=5.05
r365 (  106 118 ) resistor r=56.4043 //w=0.094 //l=0.11 //layer=ply \
 //thickness=0.18 //x=18.32 //y=1.585 //x2=18.43 //y2=1.585
r366 (  106 119 ) resistor r=56.4043 //w=0.094 //l=0.11 //layer=ply \
 //thickness=0.18 //x=18.32 //y=1.585 //x2=18.21 //y2=1.585
r367 (  98 134 ) resistor r=152 //w=0.17 //l=0.17 //layer=licon //count=1 \
 //x=18.25 //y=2.26 //x2=18.25 //y2=2.26
r368 (  93 129 ) resistor r=152 //w=0.17 //l=0.17 //layer=licon //count=1 \
 //x=18.095 //y=4.885 //x2=18.095 //y2=4.885
r369 (  76 143 ) resistor r=23.2727 //w=0.187 //l=0.34 //layer=li \
 //thickness=0.1 //x=15.92 //y=5.56 //x2=15.92 //y2=5.9
r370 (  67 68 ) resistor r=0.107671 //w=0.266 //l=0.16 //layer=m2 \
 //thickness=0.36 //x=18.25 //y=3.502 //x2=18.09 //y2=3.502
r371 (  65 68 ) resistor r=1.45992 //w=0.131 //l=1.53 //layer=m2 \
 //thickness=0.36 //x=16.56 //y=3.51 //x2=18.09 //y2=3.51
r372 (  63 65 ) resistor r=0.107671 //w=0.266 //l=0.16 //layer=m2 \
 //thickness=0.36 //x=16.4 //y=3.502 //x2=16.56 //y2=3.502
r373 (  58 93 ) resistor r=9.3 //w=0.17 //l=0.17 //layer=mcon //count=1 \
 //x=18.095 //y=4.885 //x2=18.095 //y2=4.885
r374 (  58 59 ) resistor r=0.0853524 //w=0.227 //l=0.155 //layer=m1 \
 //thickness=0.36 //x=18.095 //y=4.882 //x2=18.25 //y2=4.882
r375 (  54 98 ) resistor r=9.3 //w=0.17 //l=0.17 //layer=mcon //count=1 \
 //x=18.25 //y=2.26 //x2=18.25 //y2=2.26
r376 (  54 56 ) resistor r=0.0985786 //w=0.206 //l=0.135 //layer=m1 \
 //thickness=0.36 //x=18.247 //y=2.26 //x2=18.247 //y2=2.395
r377 (  50 67 ) resistor r=4.5 //w=0.15 //l=0.15 //layer=via1 //count=1 \
 //x=18.25 //y=3.495 //x2=18.25 //y2=3.495
r378 (  46 63 ) resistor r=4.5 //w=0.15 //l=0.15 //layer=via1 //count=1 \
 //x=16.4 //y=3.495 //x2=16.4 //y2=3.495
r379 (  44 140 ) resistor r=9.3 //w=0.17 //l=0.17 //layer=mcon //count=1 \
 //x=15.96 //y=1.18 //x2=15.96 //y2=1.18
r380 (  42 76 ) resistor r=9.3 //w=0.17 //l=0.17 //layer=mcon //count=1 \
 //x=15.92 //y=5.56 //x2=15.92 //y2=5.56
r381 (  40 42 ) resistor r=0.0974771 //w=0.218 //l=0.17 //layer=m1 \
 //thickness=0.36 //x=15.915 //y=5.39 //x2=15.915 //y2=5.56
r382 (  38 139 ) resistor r=9.3 //w=0.17 //l=0.17 //layer=mcon //count=1 \
 //x=14.99 //y=1.18 //x2=14.99 //y2=1.18
r383 (  35 59 ) resistor r=0.0249239 //w=0.227 //l=0.117 //layer=m1 \
 //thickness=0.36 //x=18.25 //y=4.765 //x2=18.25 //y2=4.882
r384 (  30 50 ) resistor r=0.0863342 //w=0.379 //l=0.16944 //layer=m1 \
 //thickness=0.36 //x=18.25 //y=3.35 //x2=18.197 //y2=3.495
r385 (  22 46 ) resistor r=0.0863342 //w=0.379 //l=0.169012 //layer=m1 \
 //thickness=0.36 //x=16.4 //y=3.35 //x2=16.452 //y2=3.495
r386 (  20 39 ) resistor r=0.0529306 //w=0.17 //l=0.085 //layer=m1 \
 //thickness=0.36 //x=16.045 //y=1.835 //x2=15.96 //y2=1.835
r387 (  19 21 ) resistor r=0.0698411 //w=0.17 //l=0.120208 //layer=m1 \
 //thickness=0.36 //x=16.315 //y=1.835 //x2=16.4 //y2=1.92
r388 (  19 20 ) resistor r=0.257634 //w=0.131 //l=0.27 //layer=m1 \
 //thickness=0.36 //x=16.315 //y=1.835 //x2=16.045 //y2=1.835
r389 (  18 40 ) resistor r=0.0225019 //w=0.218 //l=0.12 //layer=m1 \
 //thickness=0.36 //x=16.035 //y=5.39 //x2=15.915 //y2=5.39
r390 (  17 27 ) resistor r=0.0698411 //w=0.17 //l=0.120208 //layer=m1 \
 //thickness=0.36 //x=16.315 //y=5.39 //x2=16.4 //y2=5.305
r391 (  17 18 ) resistor r=0.267176 //w=0.131 //l=0.28 //layer=m1 \
 //thickness=0.36 //x=16.315 //y=5.39 //x2=16.035 //y2=5.39
r392 (  16 39 ) resistor r=0.0137558 //w=0.34 //l=0.085 //layer=m1 \
 //thickness=0.36 //x=15.96 //y=1.75 //x2=15.96 //y2=1.835
r393 (  15 44 ) resistor r=0.0728765 //w=0.25 //l=0.121491 //layer=m1 \
 //thickness=0.36 //x=15.96 //y=1.3 //x2=15.957 //y2=1.18
r394 (  15 16 ) resistor r=0.429389 //w=0.131 //l=0.45 //layer=m1 \
 //thickness=0.36 //x=15.96 //y=1.3 //x2=15.96 //y2=1.75
r395 (  13 39 ) resistor r=0.0529306 //w=0.17 //l=0.085 //layer=m1 \
 //thickness=0.36 //x=15.875 //y=1.835 //x2=15.96 //y2=1.835
r396 (  13 14 ) resistor r=0.763359 //w=0.131 //l=0.8 //layer=m1 \
 //thickness=0.36 //x=15.875 //y=1.835 //x2=15.075 //y2=1.835
r397 (  12 14 ) resistor r=0.0698411 //w=0.17 //l=0.120208 //layer=m1 \
 //thickness=0.36 //x=14.99 //y=1.75 //x2=15.075 //y2=1.835
r398 (  11 38 ) resistor r=0.0764279 //w=0.233 //l=0.126491 //layer=m1 \
 //thickness=0.36 //x=14.99 //y=1.305 //x2=14.987 //y2=1.18
r399 (  11 12 ) resistor r=0.424618 //w=0.131 //l=0.445 //layer=m1 \
 //thickness=0.36 //x=14.99 //y=1.305 //x2=14.99 //y2=1.75
r400 (  10 34 ) resistor r=0.0863342 //w=0.379 //l=0.16944 //layer=m1 \
 //thickness=0.36 //x=18.197 //y=3.51 //x2=18.25 //y2=3.655
r401 (  10 50 ) resistor r=0.00494723 //w=0.379 //l=0.015 //layer=m1 \
 //thickness=0.36 //x=18.197 //y=3.51 //x2=18.197 //y2=3.495
r402 (  9 26 ) resistor r=0.0863342 //w=0.379 //l=0.169012 //layer=m1 \
 //thickness=0.36 //x=16.452 //y=3.51 //x2=16.4 //y2=3.655
r403 (  9 46 ) resistor r=0.00494723 //w=0.379 //l=0.015 //layer=m1 \
 //thickness=0.36 //x=16.452 //y=3.51 //x2=16.452 //y2=3.495
r404 (  8 35 ) resistor r=0.138359 //w=0.131 //l=0.145 //layer=m1 \
 //thickness=0.36 //x=18.25 //y=4.62 //x2=18.25 //y2=4.765
r405 (  8 34 ) resistor r=0.920802 //w=0.131 //l=0.965 //layer=m1 \
 //thickness=0.36 //x=18.25 //y=4.62 //x2=18.25 //y2=3.655
r406 (  7 30 ) resistor r=0.200382 //w=0.131 //l=0.21 //layer=m1 \
 //thickness=0.36 //x=18.25 //y=3.14 //x2=18.25 //y2=3.35
r407 (  6 7 ) resistor r=0.353053 //w=0.131 //l=0.37 //layer=m1 \
 //thickness=0.36 //x=18.25 //y=2.77 //x2=18.25 //y2=3.14
r408 (  5 6 ) resistor r=0.353053 //w=0.131 //l=0.37 //layer=m1 \
 //thickness=0.36 //x=18.25 //y=2.4 //x2=18.25 //y2=2.77
r409 (  5 56 ) resistor r=0.00477099 //w=0.131 //l=0.005 //layer=m1 \
 //thickness=0.36 //x=18.25 //y=2.4 //x2=18.25 //y2=2.395
r410 (  4 27 ) resistor r=0.653626 //w=0.131 //l=0.685 //layer=m1 \
 //thickness=0.36 //x=16.4 //y=4.62 //x2=16.4 //y2=5.305
r411 (  4 26 ) resistor r=0.920802 //w=0.131 //l=0.965 //layer=m1 \
 //thickness=0.36 //x=16.4 //y=4.62 //x2=16.4 //y2=3.655
r412 (  3 22 ) resistor r=0.200382 //w=0.131 //l=0.21 //layer=m1 \
 //thickness=0.36 //x=16.4 //y=3.14 //x2=16.4 //y2=3.35
r413 (  2 3 ) resistor r=0.353053 //w=0.131 //l=0.37 //layer=m1 \
 //thickness=0.36 //x=16.4 //y=2.77 //x2=16.4 //y2=3.14
r414 (  1 2 ) resistor r=0.353053 //w=0.131 //l=0.37 //layer=m1 \
 //thickness=0.36 //x=16.4 //y=2.4 //x2=16.4 //y2=2.77
r415 (  1 21 ) resistor r=0.458015 //w=0.131 //l=0.48 //layer=m1 \
 //thickness=0.36 //x=16.4 //y=2.4 //x2=16.4 //y2=1.92
ends PM_DLATCH\%Q

subckt PM_DLATCH\%noxref_8 ( 2 4 5 6 7 8 10 11 12 14 15 18 23 26 29 33 34 41 \
 43 44 52 64 73 77 78 79 80 81 82 87 89 91 97 98 100 101 104 112 114 )
c280 ( 112 0 ) capacitor c=0.00875839f //x=12.515 //y=1.09
c281 ( 104 0 ) capacitor c=0.0367972f //x=19.025 //y=4.885
c282 ( 101 0 ) capacitor c=0.0292709f //x=18.99 //y=2.095
c283 ( 100 0 ) capacitor c=0.0468503f //x=18.99 //y=2.26
c284 ( 98 0 ) capacitor c=0.0237765f //x=19.555 //y=1.435
c285 ( 97 0 ) capacitor c=0.0191782f //x=19.555 //y=1.085
c286 ( 91 0 ) capacitor c=0.035988f //x=19.4 //y=1.585
c287 ( 89 0 ) capacitor c=0.0157803f //x=19.4 //y=0.93
c288 ( 87 0 ) capacitor c=0.0352992f //x=19.395 //y=4.975
c289 ( 82 0 ) capacitor c=0.0206674f //x=19.025 //y=1.74
c290 ( 81 0 ) capacitor c=0.0169638f //x=19.025 //y=1.435
c291 ( 80 0 ) capacitor c=0.0185462f //x=19.025 //y=1.085
c292 ( 79 0 ) capacitor c=0.155887f //x=19.47 //y=6.205
c293 ( 78 0 ) capacitor c=0.110534f //x=19.03 //y=6.205
c294 ( 73 0 ) capacitor c=8.21778e-19 //x=19.025 //y=4.885
c295 ( 64 0 ) capacitor c=7.18762e-19 //x=18.99 //y=2.26
c296 ( 52 0 ) capacitor c=0.0261198f //x=12.705 //y=5.56
c297 ( 44 0 ) capacitor c=0.146523f //x=18.83 //y=4.257
c298 ( 43 0 ) capacitor c=0.00234035f //x=18.99 //y=4.25
c299 ( 41 0 ) capacitor c=0.00217925f //x=13.23 //y=4.257
c300 ( 34 0 ) capacitor c=0.00585181f //x=19.025 //y=4.74
c301 ( 33 0 ) capacitor c=0.00544801f //x=19.025 //y=4.885
c302 ( 29 0 ) capacitor c=0.00539963f //x=18.99 //y=2.26
c303 ( 26 0 ) capacitor c=0.0142663f //x=18.99 //y=4.25
c304 ( 23 0 ) capacitor c=0.015868f //x=13.07 //y=4.25
c305 ( 18 0 ) capacitor c=0.015389f //x=12.7 //y=1.185
c306 ( 15 0 ) capacitor c=0.00985916f //x=18.99 //y=4.41
c307 ( 14 0 ) capacitor c=0.0381974f //x=18.99 //y=4.105
c308 ( 12 0 ) capacitor c=0.0105586f //x=13.07 //y=5.055
c309 ( 11 0 ) capacitor c=0.0126052f //x=13.07 //y=4.41
c310 ( 10 0 ) capacitor c=0.0540318f //x=13.07 //y=4.105
c311 ( 8 0 ) capacitor c=0.00514161f //x=12.79 //y=5.14
c312 ( 7 0 ) capacitor c=0.00735405f //x=12.985 //y=5.14
c313 ( 6 0 ) capacitor c=0.00704518f //x=12.785 //y=2.02
c314 ( 5 0 ) capacitor c=0.0128967f //x=12.985 //y=2.02
c315 ( 4 0 ) capacitor c=0.0106845f //x=12.705 //y=5.42
c316 ( 2 0 ) capacitor c=0.0111267f //x=12.7 //y=1.935
r317 (  106 107 ) resistor r=32.4568 //w=0.214 //l=0.075 //layer=ply \
 //thickness=0.18 //x=19.025 //y=4.975 //x2=19.025 //y2=5.05
r318 (  104 106 ) resistor r=20.271 //w=0.214 //l=0.09 //layer=ply \
 //thickness=0.18 //x=19.025 //y=4.885 //x2=19.025 //y2=4.975
r319 (  100 101 ) resistor r=52.7279 //w=0.214 //l=0.165 //layer=ply \
 //thickness=0.18 //x=18.99 //y=2.26 //x2=18.99 //y2=2.095
r320 (  98 111 ) resistor r=4.95774 //w=0.164 //l=0.112 //layer=ply \
 //thickness=0.18 //x=19.555 //y=1.435 //x2=19.555 //y2=1.547
r321 (  97 110 ) resistor r=45.1352 //w=0.168 //l=0.173853 //layer=ply \
 //thickness=0.18 //x=19.555 //y=1.085 //x2=19.515 //y2=0.93
r322 (  97 98 ) resistor r=179.468 //w=0.094 //l=0.35 //layer=ply \
 //thickness=0.18 //x=19.555 //y=1.085 //x2=19.555 //y2=1.435
r323 (  92 109 ) resistor r=10.8103 //w=0.211 //l=0.115 //layer=ply \
 //thickness=0.18 //x=19.18 //y=1.585 //x2=19.065 //y2=1.585
r324 (  91 111 ) resistor r=45.9962 //w=0.164 //l=0.17296 //layer=ply \
 //thickness=0.18 //x=19.4 //y=1.585 //x2=19.555 //y2=1.547
r325 (  90 108 ) resistor r=5.52526 //w=0.168 //l=0.115 //layer=ply \
 //thickness=0.18 //x=19.18 //y=0.93 //x2=19.065 //y2=0.93
r326 (  89 110 ) resistor r=5.52526 //w=0.168 //l=0.115 //layer=ply \
 //thickness=0.18 //x=19.4 //y=0.93 //x2=19.515 //y2=0.93
r327 (  89 90 ) resistor r=112.809 //w=0.094 //l=0.22 //layer=ply \
 //thickness=0.18 //x=19.4 //y=0.93 //x2=19.18 //y2=0.93
r328 (  88 106 ) resistor r=16.5046 //w=0.27 //l=0.135 //layer=ply \
 //thickness=0.18 //x=19.16 //y=4.975 //x2=19.025 //y2=4.975
r329 (  87 94 ) resistor r=26.9307 //w=0.15 //l=0.106066 //layer=ply \
 //thickness=0.18 //x=19.395 //y=4.975 //x2=19.47 //y2=5.05
r330 (  87 88 ) resistor r=120.5 //w=0.094 //l=0.235 //layer=ply \
 //thickness=0.18 //x=19.395 //y=4.975 //x2=19.16 //y2=4.975
r331 (  82 109 ) resistor r=39.5036 //w=0.211 //l=0.173853 //layer=ply \
 //thickness=0.18 //x=19.025 //y=1.74 //x2=19.065 //y2=1.585
r332 (  82 101 ) resistor r=182.032 //w=0.094 //l=0.355 //layer=ply \
 //thickness=0.18 //x=19.025 //y=1.74 //x2=19.025 //y2=2.095
r333 (  81 109 ) resistor r=38.3614 //w=0.211 //l=0.168819 //layer=ply \
 //thickness=0.18 //x=19.025 //y=1.435 //x2=19.065 //y2=1.585
r334 (  80 108 ) resistor r=45.1352 //w=0.168 //l=0.173853 //layer=ply \
 //thickness=0.18 //x=19.025 //y=1.085 //x2=19.065 //y2=0.93
r335 (  80 81 ) resistor r=179.468 //w=0.094 //l=0.35 //layer=ply \
 //thickness=0.18 //x=19.025 //y=1.085 //x2=19.025 //y2=1.435
r336 (  79 94 ) resistor r=592.245 //w=0.094 //l=1.155 //layer=ply \
 //thickness=0.18 //x=19.47 //y=6.205 //x2=19.47 //y2=5.05
r337 (  78 107 ) resistor r=592.245 //w=0.094 //l=1.155 //layer=ply \
 //thickness=0.18 //x=19.03 //y=6.205 //x2=19.03 //y2=5.05
r338 (  77 91 ) resistor r=56.4043 //w=0.094 //l=0.11 //layer=ply \
 //thickness=0.18 //x=19.29 //y=1.585 //x2=19.4 //y2=1.585
r339 (  77 92 ) resistor r=56.4043 //w=0.094 //l=0.11 //layer=ply \
 //thickness=0.18 //x=19.29 //y=1.585 //x2=19.18 //y2=1.585
r340 (  73 104 ) resistor r=152 //w=0.17 //l=0.17 //layer=licon //count=1 \
 //x=19.025 //y=4.885 //x2=19.025 //y2=4.885
r341 (  64 100 ) resistor r=152 //w=0.17 //l=0.17 //layer=licon //count=1 \
 //x=18.99 //y=2.26 //x2=18.99 //y2=2.26
r342 (  52 114 ) resistor r=23.615 //w=0.187 //l=0.345 //layer=li \
 //thickness=0.1 //x=12.705 //y=5.56 //x2=12.705 //y2=5.905
r343 (  43 44 ) resistor r=0.107671 //w=0.266 //l=0.16 //layer=m2 \
 //thickness=0.36 //x=18.99 //y=4.257 //x2=18.83 //y2=4.257
r344 (  41 44 ) resistor r=5.34351 //w=0.131 //l=5.6 //layer=m2 \
 //thickness=0.36 //x=13.23 //y=4.25 //x2=18.83 //y2=4.25
r345 (  39 41 ) resistor r=0.107671 //w=0.266 //l=0.16 //layer=m2 \
 //thickness=0.36 //x=13.07 //y=4.257 //x2=13.23 //y2=4.257
r346 (  33 73 ) resistor r=9.3 //w=0.17 //l=0.17 //layer=mcon //count=1 \
 //x=19.025 //y=4.885 //x2=19.025 //y2=4.885
r347 (  33 34 ) resistor r=0.105739 //w=0.201 //l=0.145 //layer=m1 \
 //thickness=0.36 //x=19.025 //y=4.885 //x2=19.025 //y2=4.74
r348 (  29 64 ) resistor r=9.3 //w=0.17 //l=0.17 //layer=mcon //count=1 \
 //x=18.99 //y=2.26 //x2=18.99 //y2=2.26
r349 (  29 31 ) resistor r=0.0977888 //w=0.216 //l=0.135 //layer=m1 \
 //thickness=0.36 //x=18.987 //y=2.26 //x2=18.987 //y2=2.395
r350 (  26 43 ) resistor r=4.5 //w=0.15 //l=0.15 //layer=via1 //count=1 \
 //x=18.99 //y=4.25 //x2=18.99 //y2=4.25
r351 (  23 39 ) resistor r=4.5 //w=0.15 //l=0.15 //layer=via1 //count=1 \
 //x=13.07 //y=4.25 //x2=13.07 //y2=4.25
r352 (  21 52 ) resistor r=9.3 //w=0.17 //l=0.17 //layer=mcon //count=1 \
 //x=12.705 //y=5.56 //x2=12.705 //y2=5.56
r353 (  18 112 ) resistor r=9.3 //w=0.17 //l=0.17 //layer=mcon //count=1 \
 //x=12.7 //y=1.185 //x2=12.7 //y2=1.185
r354 (  15 26 ) resistor r=0.0912814 //w=0.379 //l=0.184608 //layer=m1 \
 //thickness=0.36 //x=18.99 //y=4.41 //x2=18.937 //y2=4.25
r355 (  15 34 ) resistor r=0.314885 //w=0.131 //l=0.33 //layer=m1 \
 //thickness=0.36 //x=18.99 //y=4.41 //x2=18.99 //y2=4.74
r356 (  14 26 ) resistor r=0.0863342 //w=0.379 //l=0.16944 //layer=m1 \
 //thickness=0.36 //x=18.99 //y=4.105 //x2=18.937 //y2=4.25
r357 (  14 31 ) resistor r=1.63168 //w=0.131 //l=1.71 //layer=m1 \
 //thickness=0.36 //x=18.99 //y=4.105 //x2=18.99 //y2=2.395
r358 (  11 23 ) resistor r=0.0912814 //w=0.379 //l=0.184174 //layer=m1 \
 //thickness=0.36 //x=13.07 //y=4.41 //x2=13.122 //y2=4.25
r359 (  11 12 ) resistor r=0.615458 //w=0.131 //l=0.645 //layer=m1 \
 //thickness=0.36 //x=13.07 //y=4.41 //x2=13.07 //y2=5.055
r360 (  10 23 ) resistor r=0.0863342 //w=0.379 //l=0.169012 //layer=m1 \
 //thickness=0.36 //x=13.07 //y=4.105 //x2=13.122 //y2=4.25
r361 (  9 10 ) resistor r=1.9084 //w=0.131 //l=2 //layer=m1 //thickness=0.36 \
 //x=13.07 //y=2.105 //x2=13.07 //y2=4.105
r362 (  7 12 ) resistor r=0.0698411 //w=0.17 //l=0.120208 //layer=m1 \
 //thickness=0.36 //x=12.985 //y=5.14 //x2=13.07 //y2=5.055
r363 (  7 8 ) resistor r=0.186069 //w=0.131 //l=0.195 //layer=m1 \
 //thickness=0.36 //x=12.985 //y=5.14 //x2=12.79 //y2=5.14
r364 (  5 9 ) resistor r=0.0698411 //w=0.17 //l=0.120208 //layer=m1 \
 //thickness=0.36 //x=12.985 //y=2.02 //x2=13.07 //y2=2.105
r365 (  5 6 ) resistor r=0.19084 //w=0.131 //l=0.2 //layer=m1 //thickness=0.36 \
 //x=12.985 //y=2.02 //x2=12.785 //y2=2.02
r366 (  4 21 ) resistor r=0.086672 //w=0.218 //l=0.14 //layer=m1 \
 //thickness=0.36 //x=12.705 //y=5.42 //x2=12.705 //y2=5.56
r367 (  3 8 ) resistor r=0.0698411 //w=0.17 //l=0.120208 //layer=m1 \
 //thickness=0.36 //x=12.705 //y=5.225 //x2=12.79 //y2=5.14
r368 (  3 4 ) resistor r=0.186069 //w=0.131 //l=0.195 //layer=m1 \
 //thickness=0.36 //x=12.705 //y=5.225 //x2=12.705 //y2=5.42
r369 (  2 6 ) resistor r=0.0698411 //w=0.17 //l=0.120208 //layer=m1 \
 //thickness=0.36 //x=12.7 //y=1.935 //x2=12.785 //y2=2.02
r370 (  1 18 ) resistor r=0.105739 //w=0.201 //l=0.145 //layer=m1 \
 //thickness=0.36 //x=12.7 //y=1.33 //x2=12.7 //y2=1.185
r371 (  1 2 ) resistor r=0.57729 //w=0.131 //l=0.605 //layer=m1 \
 //thickness=0.36 //x=12.7 //y=1.33 //x2=12.7 //y2=1.935
ends PM_DLATCH\%noxref_8

subckt PM_DLATCH\%noxref_9 ( 2 3 5 6 7 8 9 10 11 13 16 17 18 20 24 25 30 34 40 \
 48 50 51 54 63 73 89 90 91 92 93 94 99 101 103 109 110 112 113 116 124 125 \
 128 )
c283 ( 125 0 ) capacitor c=0.00901091f //x=19.1 //y=1.085
c284 ( 124 0 ) capacitor c=0.00876479f //x=18.13 //y=1.085
c285 ( 116 0 ) capacitor c=0.0376036f //x=15.695 //y=4.885
c286 ( 113 0 ) capacitor c=0.0292709f //x=15.66 //y=2.095
c287 ( 112 0 ) capacitor c=0.0468503f //x=15.66 //y=2.26
c288 ( 110 0 ) capacitor c=0.0237765f //x=16.225 //y=1.435
c289 ( 109 0 ) capacitor c=0.0191782f //x=16.225 //y=1.085
c290 ( 103 0 ) capacitor c=0.035988f //x=16.07 //y=1.585
c291 ( 101 0 ) capacitor c=0.0157803f //x=16.07 //y=0.93
c292 ( 99 0 ) capacitor c=0.0355f //x=16.065 //y=4.975
c293 ( 94 0 ) capacitor c=0.0206674f //x=15.695 //y=1.74
c294 ( 93 0 ) capacitor c=0.0169638f //x=15.695 //y=1.435
c295 ( 92 0 ) capacitor c=0.0185462f //x=15.695 //y=1.085
c296 ( 91 0 ) capacitor c=0.155887f //x=16.14 //y=6.205
c297 ( 90 0 ) capacitor c=0.110534f //x=15.7 //y=6.205
c298 ( 73 0 ) capacitor c=0.024193f //x=19.25 //y=5.56
c299 ( 63 0 ) capacitor c=0.0011312f //x=15.695 //y=4.885
c300 ( 54 0 ) capacitor c=7.18762e-19 //x=15.66 //y=2.26
c301 ( 51 0 ) capacitor c=0.056897f //x=19.565 //y=3.892
c302 ( 50 0 ) capacitor c=0.0127384f //x=19.725 //y=3.885
c303 ( 48 0 ) capacitor c=0.00129109f //x=15.82 //y=3.872
c304 ( 40 0 ) capacitor c=0.0184483f //x=19.73 //y=3.88
c305 ( 34 0 ) capacitor c=0.0161717f //x=19.245 //y=5.39
c306 ( 33 0 ) capacitor c=0.00489134f //x=19.29 //y=1.835
c307 ( 30 0 ) capacitor c=0.013939f //x=15.66 //y=3.88
c308 ( 25 0 ) capacitor c=0.0142982f //x=15.695 //y=4.74
c309 ( 24 0 ) capacitor c=0.00557256f //x=15.695 //y=4.885
c310 ( 20 0 ) capacitor c=0.0052372f //x=15.66 //y=2.26
c311 ( 18 0 ) capacitor c=0.0434339f //x=19.73 //y=5.305
c312 ( 17 0 ) capacitor c=0.0120967f //x=19.73 //y=4.045
c313 ( 16 0 ) capacitor c=0.0747545f //x=19.73 //y=3.74
c314 ( 13 0 ) capacitor c=0.0152288f //x=19.645 //y=1.835
c315 ( 11 0 ) capacitor c=0.0115067f //x=19.645 //y=5.39
c316 ( 10 0 ) capacitor c=0.0111615f //x=19.29 //y=1.75
c317 ( 9 0 ) capacitor c=0.0117617f //x=19.29 //y=1.3
c318 ( 8 0 ) capacitor c=0.00249512f //x=18.405 //y=1.835
c319 ( 7 0 ) capacitor c=0.0178101f //x=19.205 //y=1.835
c320 ( 6 0 ) capacitor c=0.00638036f //x=18.32 //y=1.75
c321 ( 5 0 ) capacitor c=0.00822463f //x=18.32 //y=1.305
c322 ( 3 0 ) capacitor c=0.00914459f //x=15.66 //y=4.025
c323 ( 2 0 ) capacitor c=0.0304287f //x=15.66 //y=3.72
r324 (  118 119 ) resistor r=32.4568 //w=0.214 //l=0.075 //layer=ply \
 //thickness=0.18 //x=15.695 //y=4.975 //x2=15.695 //y2=5.05
r325 (  116 118 ) resistor r=20.271 //w=0.214 //l=0.09 //layer=ply \
 //thickness=0.18 //x=15.695 //y=4.885 //x2=15.695 //y2=4.975
r326 (  112 113 ) resistor r=52.7279 //w=0.214 //l=0.165 //layer=ply \
 //thickness=0.18 //x=15.66 //y=2.26 //x2=15.66 //y2=2.095
r327 (  110 123 ) resistor r=4.95774 //w=0.164 //l=0.112 //layer=ply \
 //thickness=0.18 //x=16.225 //y=1.435 //x2=16.225 //y2=1.547
r328 (  109 122 ) resistor r=45.1352 //w=0.168 //l=0.173853 //layer=ply \
 //thickness=0.18 //x=16.225 //y=1.085 //x2=16.185 //y2=0.93
r329 (  109 110 ) resistor r=179.468 //w=0.094 //l=0.35 //layer=ply \
 //thickness=0.18 //x=16.225 //y=1.085 //x2=16.225 //y2=1.435
r330 (  104 121 ) resistor r=10.8103 //w=0.211 //l=0.115 //layer=ply \
 //thickness=0.18 //x=15.85 //y=1.585 //x2=15.735 //y2=1.585
r331 (  103 123 ) resistor r=45.9962 //w=0.164 //l=0.17296 //layer=ply \
 //thickness=0.18 //x=16.07 //y=1.585 //x2=16.225 //y2=1.547
r332 (  102 120 ) resistor r=5.52526 //w=0.168 //l=0.115 //layer=ply \
 //thickness=0.18 //x=15.85 //y=0.93 //x2=15.735 //y2=0.93
r333 (  101 122 ) resistor r=5.52526 //w=0.168 //l=0.115 //layer=ply \
 //thickness=0.18 //x=16.07 //y=0.93 //x2=16.185 //y2=0.93
r334 (  101 102 ) resistor r=112.809 //w=0.094 //l=0.22 //layer=ply \
 //thickness=0.18 //x=16.07 //y=0.93 //x2=15.85 //y2=0.93
r335 (  100 118 ) resistor r=16.5046 //w=0.27 //l=0.135 //layer=ply \
 //thickness=0.18 //x=15.83 //y=4.975 //x2=15.695 //y2=4.975
r336 (  99 106 ) resistor r=26.9307 //w=0.15 //l=0.106066 //layer=ply \
 //thickness=0.18 //x=16.065 //y=4.975 //x2=16.14 //y2=5.05
r337 (  99 100 ) resistor r=120.5 //w=0.094 //l=0.235 //layer=ply \
 //thickness=0.18 //x=16.065 //y=4.975 //x2=15.83 //y2=4.975
r338 (  94 121 ) resistor r=39.5036 //w=0.211 //l=0.173853 //layer=ply \
 //thickness=0.18 //x=15.695 //y=1.74 //x2=15.735 //y2=1.585
r339 (  94 113 ) resistor r=182.032 //w=0.094 //l=0.355 //layer=ply \
 //thickness=0.18 //x=15.695 //y=1.74 //x2=15.695 //y2=2.095
r340 (  93 121 ) resistor r=38.3614 //w=0.211 //l=0.168819 //layer=ply \
 //thickness=0.18 //x=15.695 //y=1.435 //x2=15.735 //y2=1.585
r341 (  92 120 ) resistor r=45.1352 //w=0.168 //l=0.173853 //layer=ply \
 //thickness=0.18 //x=15.695 //y=1.085 //x2=15.735 //y2=0.93
r342 (  92 93 ) resistor r=179.468 //w=0.094 //l=0.35 //layer=ply \
 //thickness=0.18 //x=15.695 //y=1.085 //x2=15.695 //y2=1.435
r343 (  91 106 ) resistor r=592.245 //w=0.094 //l=1.155 //layer=ply \
 //thickness=0.18 //x=16.14 //y=6.205 //x2=16.14 //y2=5.05
r344 (  90 119 ) resistor r=592.245 //w=0.094 //l=1.155 //layer=ply \
 //thickness=0.18 //x=15.7 //y=6.205 //x2=15.7 //y2=5.05
r345 (  89 103 ) resistor r=56.4043 //w=0.094 //l=0.11 //layer=ply \
 //thickness=0.18 //x=15.96 //y=1.585 //x2=16.07 //y2=1.585
r346 (  89 104 ) resistor r=56.4043 //w=0.094 //l=0.11 //layer=ply \
 //thickness=0.18 //x=15.96 //y=1.585 //x2=15.85 //y2=1.585
r347 (  73 128 ) resistor r=23.2727 //w=0.187 //l=0.34 //layer=li \
 //thickness=0.1 //x=19.25 //y=5.56 //x2=19.25 //y2=5.9
r348 (  63 116 ) resistor r=152 //w=0.17 //l=0.17 //layer=licon //count=1 \
 //x=15.695 //y=4.885 //x2=15.695 //y2=4.885
r349 (  54 112 ) resistor r=152 //w=0.17 //l=0.17 //layer=licon //count=1 \
 //x=15.66 //y=2.26 //x2=15.66 //y2=2.26
r350 (  50 51 ) resistor r=0.107671 //w=0.266 //l=0.16 //layer=m2 \
 //thickness=0.36 //x=19.725 //y=3.892 //x2=19.565 //y2=3.892
r351 (  48 51 ) resistor r=3.57347 //w=0.131 //l=3.745 //layer=m2 \
 //thickness=0.36 //x=15.82 //y=3.88 //x2=19.565 //y2=3.88
r352 (  46 48 ) resistor r=0.107671 //w=0.266 //l=0.16 //layer=m2 \
 //thickness=0.36 //x=15.66 //y=3.872 //x2=15.82 //y2=3.872
r353 (  42 50 ) resistor r=4.5 //w=0.15 //l=0.15 //layer=via1 //count=1 \
 //x=19.725 //y=3.885 //x2=19.725 //y2=3.885
r354 (  40 42 ) resistor r=0.00166223 //w=0.376 //l=0.005 //layer=m1 \
 //thickness=0.36 //x=19.675 //y=3.88 //x2=19.675 //y2=3.885
r355 (  38 125 ) resistor r=9.3 //w=0.17 //l=0.17 //layer=mcon //count=1 \
 //x=19.29 //y=1.18 //x2=19.29 //y2=1.18
r356 (  36 73 ) resistor r=9.3 //w=0.17 //l=0.17 //layer=mcon //count=1 \
 //x=19.25 //y=5.56 //x2=19.25 //y2=5.56
r357 (  34 36 ) resistor r=0.0974771 //w=0.218 //l=0.17 //layer=m1 \
 //thickness=0.36 //x=19.245 //y=5.39 //x2=19.245 //y2=5.56
r358 (  32 124 ) resistor r=9.3 //w=0.17 //l=0.17 //layer=mcon //count=1 \
 //x=18.32 //y=1.18 //x2=18.32 //y2=1.18
r359 (  28 46 ) resistor r=4.5 //w=0.15 //l=0.15 //layer=via1 //count=1 \
 //x=15.66 //y=3.865 //x2=15.66 //y2=3.865
r360 (  28 30 ) resistor r=0.00494723 //w=0.379 //l=0.015 //layer=m1 \
 //thickness=0.36 //x=15.712 //y=3.865 //x2=15.712 //y2=3.88
r361 (  24 63 ) resistor r=9.3 //w=0.17 //l=0.17 //layer=mcon //count=1 \
 //x=15.695 //y=4.885 //x2=15.695 //y2=4.885
r362 (  24 25 ) resistor r=0.105739 //w=0.201 //l=0.145 //layer=m1 \
 //thickness=0.36 //x=15.695 //y=4.885 //x2=15.695 //y2=4.74
r363 (  20 54 ) resistor r=9.3 //w=0.17 //l=0.17 //layer=mcon //count=1 \
 //x=15.66 //y=2.26 //x2=15.66 //y2=2.26
r364 (  20 22 ) resistor r=0.0977888 //w=0.216 //l=0.135 //layer=m1 \
 //thickness=0.36 //x=15.657 //y=2.26 //x2=15.657 //y2=2.395
r365 (  17 42 ) resistor r=0.0911593 //w=0.376 //l=0.185472 //layer=m1 \
 //thickness=0.36 //x=19.73 //y=4.045 //x2=19.675 //y2=3.885
r366 (  17 18 ) resistor r=1.20229 //w=0.131 //l=1.26 //layer=m1 \
 //thickness=0.36 //x=19.73 //y=4.045 //x2=19.73 //y2=5.305
r367 (  16 40 ) resistor r=0.0845104 //w=0.376 //l=0.165227 //layer=m1 \
 //thickness=0.36 //x=19.73 //y=3.74 //x2=19.675 //y2=3.88
r368 (  15 16 ) resistor r=1.73664 //w=0.131 //l=1.82 //layer=m1 \
 //thickness=0.36 //x=19.73 //y=1.92 //x2=19.73 //y2=3.74
r369 (  14 33 ) resistor r=0.0529306 //w=0.17 //l=0.085 //layer=m1 \
 //thickness=0.36 //x=19.375 //y=1.835 //x2=19.29 //y2=1.835
r370 (  13 15 ) resistor r=0.0698411 //w=0.17 //l=0.120208 //layer=m1 \
 //thickness=0.36 //x=19.645 //y=1.835 //x2=19.73 //y2=1.92
r371 (  13 14 ) resistor r=0.257634 //w=0.131 //l=0.27 //layer=m1 \
 //thickness=0.36 //x=19.645 //y=1.835 //x2=19.375 //y2=1.835
r372 (  12 34 ) resistor r=0.0225019 //w=0.218 //l=0.12 //layer=m1 \
 //thickness=0.36 //x=19.365 //y=5.39 //x2=19.245 //y2=5.39
r373 (  11 18 ) resistor r=0.0698411 //w=0.17 //l=0.120208 //layer=m1 \
 //thickness=0.36 //x=19.645 //y=5.39 //x2=19.73 //y2=5.305
r374 (  11 12 ) resistor r=0.267176 //w=0.131 //l=0.28 //layer=m1 \
 //thickness=0.36 //x=19.645 //y=5.39 //x2=19.365 //y2=5.39
r375 (  10 33 ) resistor r=0.0137558 //w=0.34 //l=0.085 //layer=m1 \
 //thickness=0.36 //x=19.29 //y=1.75 //x2=19.29 //y2=1.835
r376 (  9 38 ) resistor r=0.0728765 //w=0.25 //l=0.121491 //layer=m1 \
 //thickness=0.36 //x=19.29 //y=1.3 //x2=19.287 //y2=1.18
r377 (  9 10 ) resistor r=0.429389 //w=0.131 //l=0.45 //layer=m1 \
 //thickness=0.36 //x=19.29 //y=1.3 //x2=19.29 //y2=1.75
r378 (  7 33 ) resistor r=0.0529306 //w=0.17 //l=0.085 //layer=m1 \
 //thickness=0.36 //x=19.205 //y=1.835 //x2=19.29 //y2=1.835
r379 (  7 8 ) resistor r=0.763359 //w=0.131 //l=0.8 //layer=m1 \
 //thickness=0.36 //x=19.205 //y=1.835 //x2=18.405 //y2=1.835
r380 (  6 8 ) resistor r=0.0698411 //w=0.17 //l=0.120208 //layer=m1 \
 //thickness=0.36 //x=18.32 //y=1.75 //x2=18.405 //y2=1.835
r381 (  5 32 ) resistor r=0.0764279 //w=0.233 //l=0.126491 //layer=m1 \
 //thickness=0.36 //x=18.32 //y=1.305 //x2=18.317 //y2=1.18
r382 (  5 6 ) resistor r=0.424618 //w=0.131 //l=0.445 //layer=m1 \
 //thickness=0.36 //x=18.32 //y=1.305 //x2=18.32 //y2=1.75
r383 (  3 30 ) resistor r=0.0863342 //w=0.379 //l=0.169012 //layer=m1 \
 //thickness=0.36 //x=15.66 //y=4.025 //x2=15.712 //y2=3.88
r384 (  3 25 ) resistor r=0.682252 //w=0.131 //l=0.715 //layer=m1 \
 //thickness=0.36 //x=15.66 //y=4.025 //x2=15.66 //y2=4.74
r385 (  2 28 ) resistor r=0.0863342 //w=0.379 //l=0.169012 //layer=m1 \
 //thickness=0.36 //x=15.66 //y=3.72 //x2=15.712 //y2=3.865
r386 (  2 22 ) resistor r=1.26431 //w=0.131 //l=1.325 //layer=m1 \
 //thickness=0.36 //x=15.66 //y=3.72 //x2=15.66 //y2=2.395
ends PM_DLATCH\%noxref_9

subckt PM_DLATCH\%VDD ( 1 2 27 28 29 37 38 43 79 105 115 141 165 173 199 215 \
 239 250 252 256 260 265 268 269 270 271 272 273 274 275 276 277 278 279 280 \
 281 282 283 )
c408 ( 283 0 ) capacitor c=0.023004f //x=18.225 //y=5.205
c409 ( 282 0 ) capacitor c=0.0229185f //x=14.895 //y=5.205
c410 ( 281 0 ) capacitor c=0.0572791f //x=13 //y=5.2
c411 ( 280 0 ) capacitor c=0.057866f //x=12.13 //y=5.2
c412 ( 279 0 ) capacitor c=0.039544f //x=10.665 //y=5.2
c413 ( 278 0 ) capacitor c=0.0248174f //x=9.785 //y=5.2
c414 ( 277 0 ) capacitor c=0.059201f //x=8.915 //y=5.2
c415 ( 276 0 ) capacitor c=0.0541231f //x=7.45 //y=5.2
c416 ( 275 0 ) capacitor c=0.0578811f //x=6.58 //y=5.2
c417 ( 274 0 ) capacitor c=0.039544f //x=5.115 //y=5.2
c418 ( 273 0 ) capacitor c=0.0248174f //x=4.235 //y=5.2
c419 ( 272 0 ) capacitor c=0.0589273f //x=3.365 //y=5.2
c420 ( 271 0 ) capacitor c=0.0540412f //x=1.9 //y=5.2
c421 ( 270 0 ) capacitor c=0.0606324f //x=1.03 //y=5.2
c422 ( 269 0 ) capacitor c=0.123055f //x=17.14 //y=7.585
c423 ( 268 0 ) capacitor c=0.120244f //x=13.81 //y=7.585
c424 ( 267 0 ) capacitor c=0.00597439f //x=13.145 //y=7.585
c425 ( 266 0 ) capacitor c=0.00597439f //x=12.265 //y=7.585
c426 ( 265 0 ) capacitor c=0.121632f //x=11.59 //y=7.585
c427 ( 264 0 ) capacitor c=0.00597439f //x=10.81 //y=7.585
c428 ( 263 0 ) capacitor c=0.00597439f //x=9.93 //y=7.585
c429 ( 262 0 ) capacitor c=0.00597439f //x=9 //y=7.58
c430 ( 260 0 ) capacitor c=0.125529f //x=8.26 //y=7.585
c431 ( 259 0 ) capacitor c=0.00597439f //x=7.52 //y=7.58
c432 ( 257 0 ) capacitor c=0.00597439f //x=6.715 //y=7.585
c433 ( 256 0 ) capacitor c=0.121128f //x=6.04 //y=7.585
c434 ( 255 0 ) capacitor c=0.00597439f //x=5.26 //y=7.585
c435 ( 254 0 ) capacitor c=0.00597439f //x=4.38 //y=7.585
c436 ( 253 0 ) capacitor c=0.00597439f //x=3.5 //y=7.585
c437 ( 252 0 ) capacitor c=0.125518f //x=2.71 //y=7.585
c438 ( 251 0 ) capacitor c=0.00597439f //x=2.045 //y=7.585
c439 ( 250 0 ) capacitor c=0.256429f //x=1.23 //y=7.58
c440 ( 239 0 ) capacitor c=0.372812f //x=19.73 //y=7.58
c441 ( 215 0 ) capacitor c=0.138943f //x=16.97 //y=7.585
c442 ( 211 0 ) capacitor c=0.0208042f //x=13.64 //y=7.585
c443 ( 199 0 ) capacitor c=0.0290691f //x=13.06 //y=7.585
c444 ( 189 0 ) capacitor c=0.0217664f //x=12.18 //y=7.585
c445 ( 183 0 ) capacitor c=0.0277785f //x=11.42 //y=7.585
c446 ( 173 0 ) capacitor c=0.0287376f //x=10.725 //y=7.585
c447 ( 165 0 ) capacitor c=0.0291078f //x=9.845 //y=7.585
c448 ( 155 0 ) capacitor c=0.0283511f //x=8.965 //y=7.585
c449 ( 151 0 ) capacitor c=0.0211939f //x=8.09 //y=7.585
c450 ( 141 0 ) capacitor c=0.0289924f //x=7.51 //y=7.585
c451 ( 129 0 ) capacitor c=0.0217664f //x=6.63 //y=7.585
c452 ( 125 0 ) capacitor c=0.0277785f //x=5.87 //y=7.585
c453 ( 115 0 ) capacitor c=0.0287375f //x=5.175 //y=7.585
c454 ( 105 0 ) capacitor c=0.0291078f //x=4.295 //y=7.585
c455 ( 95 0 ) capacitor c=0.0283511f //x=3.415 //y=7.585
c456 ( 89 0 ) capacitor c=0.0211939f //x=2.54 //y=7.585
c457 ( 79 0 ) capacitor c=0.0287132f //x=1.96 //y=7.585
c458 ( 64 0 ) capacitor c=0.00499323f //x=18.37 //y=7.585
c459 ( 61 0 ) capacitor c=0.00499323f //x=15.04 //y=7.585
c460 ( 43 0 ) capacitor c=0.102506f //x=19.73 //y=7.58
c461 ( 38 0 ) capacitor c=0.00808586f //x=18.37 //y=7.41
c462 ( 37 0 ) capacitor c=0.00611471f //x=18.37 //y=7.035
c463 ( 29 0 ) capacitor c=0.113102f //x=18.285 //y=7.585
c464 ( 28 0 ) capacitor c=0.00828545f //x=15.04 //y=7.41
c465 ( 27 0 ) capacitor c=0.00617747f //x=15.04 //y=7.035
c466 ( 2 0 ) capacitor c=0.54928f //x=14.955 //y=7.585
r467 (  237 239 ) resistor r=25.8093 //w=0.367 //l=0.74 //layer=li \
 //thickness=0.1 //x=18.99 //y=7.585 //x2=19.73 //y2=7.585
r468 (  235 237 ) resistor r=38.7139 //w=0.367 //l=1.11 //layer=li \
 //thickness=0.1 //x=17.88 //y=7.585 //x2=18.99 //y2=7.585
r469 (  233 269 ) resistor r=5.29055 //w=0.35 //l=0.17 //layer=li \
 //thickness=0.1 //x=17.31 //y=7.585 //x2=17.14 //y2=7.585
r470 (  233 235 ) resistor r=19.8801 //w=0.367 //l=0.57 //layer=li \
 //thickness=0.1 //x=17.31 //y=7.585 //x2=17.88 //y2=7.585
r471 (  220 222 ) resistor r=38.7139 //w=0.367 //l=1.11 //layer=li \
 //thickness=0.1 //x=15.29 //y=7.585 //x2=16.4 //y2=7.585
r472 (  218 220 ) resistor r=38.7139 //w=0.367 //l=1.11 //layer=li \
 //thickness=0.1 //x=14.18 //y=7.585 //x2=15.29 //y2=7.585
r473 (  216 268 ) resistor r=5.29055 //w=0.35 //l=0.17 //layer=li \
 //thickness=0.1 //x=13.98 //y=7.585 //x2=13.81 //y2=7.585
r474 (  216 218 ) resistor r=6.97548 //w=0.367 //l=0.2 //layer=li \
 //thickness=0.1 //x=13.98 //y=7.585 //x2=14.18 //y2=7.585
r475 (  215 269 ) resistor r=5.29055 //w=0.35 //l=0.17 //layer=li \
 //thickness=0.1 //x=16.97 //y=7.585 //x2=17.14 //y2=7.585
r476 (  215 222 ) resistor r=19.8801 //w=0.367 //l=0.57 //layer=li \
 //thickness=0.1 //x=16.97 //y=7.585 //x2=16.4 //y2=7.585
r477 (  212 267 ) resistor r=2.87058 //w=0.35 //l=0.085 //layer=li \
 //thickness=0.1 //x=13.23 //y=7.585 //x2=13.145 //y2=7.585
r478 (  211 268 ) resistor r=5.29055 //w=0.35 //l=0.17 //layer=li \
 //thickness=0.1 //x=13.64 //y=7.585 //x2=13.81 //y2=7.585
r479 (  211 212 ) resistor r=14.2997 //w=0.367 //l=0.41 //layer=li \
 //thickness=0.1 //x=13.64 //y=7.585 //x2=13.23 //y2=7.585
r480 (  203 267 ) resistor r=4.23183 //w=0.7 //l=0.175 //layer=li \
 //thickness=0.1 //x=13.145 //y=7.41 //x2=13.145 //y2=7.585
r481 (  203 281 ) resistor r=56.4706 //w=0.187 //l=0.825 //layer=li \
 //thickness=0.1 //x=13.145 //y=7.41 //x2=13.145 //y2=6.585
r482 (  200 266 ) resistor r=2.87058 //w=0.35 //l=0.085 //layer=li \
 //thickness=0.1 //x=12.35 //y=7.585 //x2=12.265 //y2=7.585
r483 (  200 202 ) resistor r=12.2071 //w=0.367 //l=0.35 //layer=li \
 //thickness=0.1 //x=12.35 //y=7.585 //x2=12.7 //y2=7.585
r484 (  199 267 ) resistor r=2.87058 //w=0.35 //l=0.085 //layer=li \
 //thickness=0.1 //x=13.06 //y=7.585 //x2=13.145 //y2=7.585
r485 (  199 202 ) resistor r=12.5559 //w=0.367 //l=0.36 //layer=li \
 //thickness=0.1 //x=13.06 //y=7.585 //x2=12.7 //y2=7.585
r486 (  191 266 ) resistor r=4.23183 //w=0.7 //l=0.175 //layer=li \
 //thickness=0.1 //x=12.265 //y=7.41 //x2=12.265 //y2=7.585
r487 (  191 280 ) resistor r=56.4706 //w=0.187 //l=0.825 //layer=li \
 //thickness=0.1 //x=12.265 //y=7.41 //x2=12.265 //y2=6.585
r488 (  190 265 ) resistor r=5.29055 //w=0.35 //l=0.17 //layer=li \
 //thickness=0.1 //x=11.76 //y=7.585 //x2=11.59 //y2=7.585
r489 (  189 266 ) resistor r=2.87058 //w=0.35 //l=0.085 //layer=li \
 //thickness=0.1 //x=12.18 //y=7.585 //x2=12.265 //y2=7.585
r490 (  189 190 ) resistor r=14.6485 //w=0.367 //l=0.42 //layer=li \
 //thickness=0.1 //x=12.18 //y=7.585 //x2=11.76 //y2=7.585
r491 (  184 264 ) resistor r=2.87058 //w=0.35 //l=0.085 //layer=li \
 //thickness=0.1 //x=10.895 //y=7.585 //x2=10.81 //y2=7.585
r492 (  184 186 ) resistor r=11.3351 //w=0.367 //l=0.325 //layer=li \
 //thickness=0.1 //x=10.895 //y=7.585 //x2=11.22 //y2=7.585
r493 (  183 265 ) resistor r=5.29055 //w=0.35 //l=0.17 //layer=li \
 //thickness=0.1 //x=11.42 //y=7.585 //x2=11.59 //y2=7.585
r494 (  183 186 ) resistor r=6.97548 //w=0.367 //l=0.2 //layer=li \
 //thickness=0.1 //x=11.42 //y=7.585 //x2=11.22 //y2=7.585
r495 (  177 264 ) resistor r=4.23183 //w=0.7 //l=0.175 //layer=li \
 //thickness=0.1 //x=10.81 //y=7.41 //x2=10.81 //y2=7.585
r496 (  177 279 ) resistor r=33.1979 //w=0.187 //l=0.485 //layer=li \
 //thickness=0.1 //x=10.81 //y=7.41 //x2=10.81 //y2=6.925
r497 (  174 263 ) resistor r=2.87058 //w=0.35 //l=0.085 //layer=li \
 //thickness=0.1 //x=10.015 //y=7.585 //x2=9.93 //y2=7.585
r498 (  174 176 ) resistor r=3.31335 //w=0.367 //l=0.095 //layer=li \
 //thickness=0.1 //x=10.015 //y=7.585 //x2=10.11 //y2=7.585
r499 (  173 264 ) resistor r=2.87058 //w=0.35 //l=0.085 //layer=li \
 //thickness=0.1 //x=10.725 //y=7.585 //x2=10.81 //y2=7.585
r500 (  173 176 ) resistor r=21.4496 //w=0.367 //l=0.615 //layer=li \
 //thickness=0.1 //x=10.725 //y=7.585 //x2=10.11 //y2=7.585
r501 (  167 263 ) resistor r=4.23183 //w=0.7 //l=0.175 //layer=li \
 //thickness=0.1 //x=9.93 //y=7.41 //x2=9.93 //y2=7.585
r502 (  167 278 ) resistor r=33.1979 //w=0.187 //l=0.485 //layer=li \
 //thickness=0.1 //x=9.93 //y=7.41 //x2=9.93 //y2=6.925
r503 (  166 262 ) resistor r=2.87058 //w=0.35 //l=0.085 //layer=li \
 //thickness=0.1 //x=9.135 //y=7.585 //x2=9.05 //y2=7.585
r504 (  165 263 ) resistor r=2.87058 //w=0.35 //l=0.085 //layer=li \
 //thickness=0.1 //x=9.845 //y=7.585 //x2=9.93 //y2=7.585
r505 (  165 166 ) resistor r=24.7629 //w=0.367 //l=0.71 //layer=li \
 //thickness=0.1 //x=9.845 //y=7.585 //x2=9.135 //y2=7.585
r506 (  157 262 ) resistor r=4.23183 //w=0.7 //l=0.175 //layer=li \
 //thickness=0.1 //x=9.05 //y=7.41 //x2=9.05 //y2=7.585
r507 (  157 277 ) resistor r=56.4706 //w=0.187 //l=0.825 //layer=li \
 //thickness=0.1 //x=9.05 //y=7.41 //x2=9.05 //y2=6.585
r508 (  156 260 ) resistor r=5.29055 //w=0.35 //l=0.17 //layer=li \
 //thickness=0.1 //x=8.43 //y=7.585 //x2=8.26 //y2=7.585
r509 (  155 262 ) resistor r=2.87058 //w=0.35 //l=0.085 //layer=li \
 //thickness=0.1 //x=8.965 //y=7.585 //x2=9.05 //y2=7.585
r510 (  155 156 ) resistor r=18.6594 //w=0.367 //l=0.535 //layer=li \
 //thickness=0.1 //x=8.965 //y=7.585 //x2=8.43 //y2=7.585
r511 (  152 259 ) resistor r=2.87058 //w=0.35 //l=0.085 //layer=li \
 //thickness=0.1 //x=7.68 //y=7.585 //x2=7.595 //y2=7.585
r512 (  151 260 ) resistor r=5.29055 //w=0.35 //l=0.17 //layer=li \
 //thickness=0.1 //x=8.09 //y=7.585 //x2=8.26 //y2=7.585
r513 (  151 152 ) resistor r=14.2997 //w=0.367 //l=0.41 //layer=li \
 //thickness=0.1 //x=8.09 //y=7.585 //x2=7.68 //y2=7.585
r514 (  143 259 ) resistor r=4.23183 //w=0.7 //l=0.175 //layer=li \
 //thickness=0.1 //x=7.595 //y=7.41 //x2=7.595 //y2=7.585
r515 (  143 276 ) resistor r=56.4706 //w=0.187 //l=0.825 //layer=li \
 //thickness=0.1 //x=7.595 //y=7.41 //x2=7.595 //y2=6.585
r516 (  142 257 ) resistor r=2.87058 //w=0.35 //l=0.085 //layer=li \
 //thickness=0.1 //x=6.8 //y=7.585 //x2=6.715 //y2=7.585
r517 (  141 259 ) resistor r=2.87058 //w=0.35 //l=0.085 //layer=li \
 //thickness=0.1 //x=7.51 //y=7.585 //x2=7.595 //y2=7.585
r518 (  141 142 ) resistor r=24.7629 //w=0.367 //l=0.71 //layer=li \
 //thickness=0.1 //x=7.51 //y=7.585 //x2=6.8 //y2=7.585
r519 (  133 257 ) resistor r=4.23183 //w=0.7 //l=0.175 //layer=li \
 //thickness=0.1 //x=6.715 //y=7.41 //x2=6.715 //y2=7.585
r520 (  133 275 ) resistor r=56.4706 //w=0.187 //l=0.825 //layer=li \
 //thickness=0.1 //x=6.715 //y=7.41 //x2=6.715 //y2=6.585
r521 (  130 256 ) resistor r=5.29055 //w=0.35 //l=0.17 //layer=li \
 //thickness=0.1 //x=6.21 //y=7.585 //x2=6.04 //y2=7.585
r522 (  130 132 ) resistor r=6.97548 //w=0.367 //l=0.2 //layer=li \
 //thickness=0.1 //x=6.21 //y=7.585 //x2=6.41 //y2=7.585
r523 (  129 257 ) resistor r=2.87058 //w=0.35 //l=0.085 //layer=li \
 //thickness=0.1 //x=6.63 //y=7.585 //x2=6.715 //y2=7.585
r524 (  129 132 ) resistor r=7.67302 //w=0.367 //l=0.22 //layer=li \
 //thickness=0.1 //x=6.63 //y=7.585 //x2=6.41 //y2=7.585
r525 (  126 255 ) resistor r=2.87058 //w=0.35 //l=0.085 //layer=li \
 //thickness=0.1 //x=5.345 //y=7.585 //x2=5.26 //y2=7.585
r526 (  125 256 ) resistor r=5.29055 //w=0.35 //l=0.17 //layer=li \
 //thickness=0.1 //x=5.87 //y=7.585 //x2=6.04 //y2=7.585
r527 (  125 126 ) resistor r=18.3106 //w=0.367 //l=0.525 //layer=li \
 //thickness=0.1 //x=5.87 //y=7.585 //x2=5.345 //y2=7.585
r528 (  119 255 ) resistor r=4.23183 //w=0.7 //l=0.175 //layer=li \
 //thickness=0.1 //x=5.26 //y=7.41 //x2=5.26 //y2=7.585
r529 (  119 274 ) resistor r=33.1979 //w=0.187 //l=0.485 //layer=li \
 //thickness=0.1 //x=5.26 //y=7.41 //x2=5.26 //y2=6.925
r530 (  116 254 ) resistor r=2.87058 //w=0.35 //l=0.085 //layer=li \
 //thickness=0.1 //x=4.465 //y=7.585 //x2=4.38 //y2=7.585
r531 (  116 118 ) resistor r=16.218 //w=0.367 //l=0.465 //layer=li \
 //thickness=0.1 //x=4.465 //y=7.585 //x2=4.93 //y2=7.585
r532 (  115 255 ) resistor r=2.87058 //w=0.35 //l=0.085 //layer=li \
 //thickness=0.1 //x=5.175 //y=7.585 //x2=5.26 //y2=7.585
r533 (  115 118 ) resistor r=8.54496 //w=0.367 //l=0.245 //layer=li \
 //thickness=0.1 //x=5.175 //y=7.585 //x2=4.93 //y2=7.585
r534 (  109 254 ) resistor r=4.23183 //w=0.7 //l=0.175 //layer=li \
 //thickness=0.1 //x=4.38 //y=7.41 //x2=4.38 //y2=7.585
r535 (  109 273 ) resistor r=33.1979 //w=0.187 //l=0.485 //layer=li \
 //thickness=0.1 //x=4.38 //y=7.41 //x2=4.38 //y2=6.925
r536 (  106 253 ) resistor r=2.87058 //w=0.35 //l=0.085 //layer=li \
 //thickness=0.1 //x=3.585 //y=7.585 //x2=3.5 //y2=7.585
r537 (  106 108 ) resistor r=8.19619 //w=0.367 //l=0.235 //layer=li \
 //thickness=0.1 //x=3.585 //y=7.585 //x2=3.82 //y2=7.585
r538 (  105 254 ) resistor r=2.87058 //w=0.35 //l=0.085 //layer=li \
 //thickness=0.1 //x=4.295 //y=7.585 //x2=4.38 //y2=7.585
r539 (  105 108 ) resistor r=16.5668 //w=0.367 //l=0.475 //layer=li \
 //thickness=0.1 //x=4.295 //y=7.585 //x2=3.82 //y2=7.585
r540 (  97 253 ) resistor r=4.23183 //w=0.7 //l=0.175 //layer=li \
 //thickness=0.1 //x=3.5 //y=7.41 //x2=3.5 //y2=7.585
r541 (  97 272 ) resistor r=56.4706 //w=0.187 //l=0.825 //layer=li \
 //thickness=0.1 //x=3.5 //y=7.41 //x2=3.5 //y2=6.585
r542 (  96 252 ) resistor r=5.29055 //w=0.35 //l=0.17 //layer=li \
 //thickness=0.1 //x=2.88 //y=7.585 //x2=2.71 //y2=7.585
r543 (  95 253 ) resistor r=2.87058 //w=0.35 //l=0.085 //layer=li \
 //thickness=0.1 //x=3.415 //y=7.585 //x2=3.5 //y2=7.585
r544 (  95 96 ) resistor r=18.6594 //w=0.367 //l=0.535 //layer=li \
 //thickness=0.1 //x=3.415 //y=7.585 //x2=2.88 //y2=7.585
r545 (  90 251 ) resistor r=2.87058 //w=0.35 //l=0.085 //layer=li \
 //thickness=0.1 //x=2.13 //y=7.585 //x2=2.045 //y2=7.585
r546 (  90 92 ) resistor r=7.32425 //w=0.367 //l=0.21 //layer=li \
 //thickness=0.1 //x=2.13 //y=7.585 //x2=2.34 //y2=7.585
r547 (  89 252 ) resistor r=5.29055 //w=0.35 //l=0.17 //layer=li \
 //thickness=0.1 //x=2.54 //y=7.585 //x2=2.71 //y2=7.585
r548 (  89 92 ) resistor r=6.97548 //w=0.367 //l=0.2 //layer=li \
 //thickness=0.1 //x=2.54 //y=7.585 //x2=2.34 //y2=7.585
r549 (  81 251 ) resistor r=4.23183 //w=0.7 //l=0.175 //layer=li \
 //thickness=0.1 //x=2.045 //y=7.41 //x2=2.045 //y2=7.585
r550 (  81 271 ) resistor r=56.4706 //w=0.187 //l=0.825 //layer=li \
 //thickness=0.1 //x=2.045 //y=7.41 //x2=2.045 //y2=6.585
r551 (  80 250 ) resistor r=2.87058 //w=0.35 //l=0.085 //layer=li \
 //thickness=0.1 //x=1.25 //y=7.585 //x2=1.165 //y2=7.585
r552 (  79 251 ) resistor r=2.87058 //w=0.35 //l=0.085 //layer=li \
 //thickness=0.1 //x=1.96 //y=7.585 //x2=2.045 //y2=7.585
r553 (  79 80 ) resistor r=24.7629 //w=0.367 //l=0.71 //layer=li \
 //thickness=0.1 //x=1.96 //y=7.585 //x2=1.25 //y2=7.585
r554 (  71 250 ) resistor r=4.23183 //w=0.7 //l=0.175 //layer=li \
 //thickness=0.1 //x=1.165 //y=7.41 //x2=1.165 //y2=7.585
r555 (  71 270 ) resistor r=56.4706 //w=0.187 //l=0.825 //layer=li \
 //thickness=0.1 //x=1.165 //y=7.41 //x2=1.165 //y2=6.585
r556 (  66 283 ) resistor r=9.3 //w=0.17 //l=0.17 //layer=mcon //count=1 \
 //x=18.37 //y=6.92 //x2=18.37 //y2=6.92
r557 (  63 282 ) resistor r=9.3 //w=0.17 //l=0.17 //layer=mcon //count=1 \
 //x=15.04 //y=6.92 //x2=15.04 //y2=6.92
r558 (  43 239 ) resistor r=4.65 //w=0.17 //l=0.34 //layer=mcon //count=2 \
 //x=19.73 //y=7.58 //x2=19.73 //y2=7.58
r559 (  41 237 ) resistor r=3.1 //w=0.17 //l=0.51 //layer=mcon //count=3 \
 //x=18.99 //y=7.58 //x2=18.99 //y2=7.58
r560 (  41 43 ) resistor r=0.297428 //w=0.311 //l=0.74 //layer=m1 \
 //thickness=0.36 //x=18.99 //y=7.585 //x2=19.73 //y2=7.585
r561 (  39 64 ) resistor r=0.028033 //w=0.35 //l=0.085 //layer=m1 \
 //thickness=0.36 //x=18.455 //y=7.585 //x2=18.37 //y2=7.585
r562 (  39 41 ) resistor r=0.215032 //w=0.311 //l=0.535 //layer=m1 \
 //thickness=0.36 //x=18.455 //y=7.585 //x2=18.99 //y2=7.585
r563 (  38 64 ) resistor r=0.0413265 //w=0.7 //l=0.175 //layer=m1 \
 //thickness=0.36 //x=18.37 //y=7.41 //x2=18.37 //y2=7.585
r564 (  37 66 ) resistor r=0.0723371 //w=0.218 //l=0.115 //layer=m1 \
 //thickness=0.36 //x=18.37 //y=7.035 //x2=18.37 //y2=6.92
r565 (  37 38 ) resistor r=0.357824 //w=0.131 //l=0.375 //layer=m1 \
 //thickness=0.36 //x=18.37 //y=7.035 //x2=18.37 //y2=7.41
r566 (  36 235 ) resistor r=3.1 //w=0.17 //l=0.51 //layer=mcon //count=3 \
 //x=17.88 //y=7.58 //x2=17.88 //y2=7.58
r567 (  34 222 ) resistor r=3.1 //w=0.17 //l=0.51 //layer=mcon //count=3 \
 //x=16.4 //y=7.58 //x2=16.4 //y2=7.58
r568 (  34 36 ) resistor r=0.594855 //w=0.311 //l=1.48 //layer=m1 \
 //thickness=0.36 //x=16.4 //y=7.585 //x2=17.88 //y2=7.585
r569 (  32 220 ) resistor r=3.1 //w=0.17 //l=0.51 //layer=mcon //count=3 \
 //x=15.29 //y=7.58 //x2=15.29 //y2=7.58
r570 (  32 34 ) resistor r=0.446141 //w=0.311 //l=1.11 //layer=m1 \
 //thickness=0.36 //x=15.29 //y=7.585 //x2=16.4 //y2=7.585
r571 (  30 61 ) resistor r=0.028033 //w=0.35 //l=0.085 //layer=m1 \
 //thickness=0.36 //x=15.125 //y=7.585 //x2=15.04 //y2=7.585
r572 (  30 32 ) resistor r=0.0663183 //w=0.311 //l=0.165 //layer=m1 \
 //thickness=0.36 //x=15.125 //y=7.585 //x2=15.29 //y2=7.585
r573 (  29 64 ) resistor r=0.028033 //w=0.35 //l=0.085 //layer=m1 \
 //thickness=0.36 //x=18.285 //y=7.585 //x2=18.37 //y2=7.585
r574 (  29 36 ) resistor r=0.162781 //w=0.311 //l=0.405 //layer=m1 \
 //thickness=0.36 //x=18.285 //y=7.585 //x2=17.88 //y2=7.585
r575 (  28 61 ) resistor r=0.0413265 //w=0.7 //l=0.175 //layer=m1 \
 //thickness=0.36 //x=15.04 //y=7.41 //x2=15.04 //y2=7.585
r576 (  27 63 ) resistor r=0.0723371 //w=0.218 //l=0.115 //layer=m1 \
 //thickness=0.36 //x=15.04 //y=7.035 //x2=15.04 //y2=6.92
r577 (  27 28 ) resistor r=0.357824 //w=0.131 //l=0.375 //layer=m1 \
 //thickness=0.36 //x=15.04 //y=7.035 //x2=15.04 //y2=7.41
r578 (  26 218 ) resistor r=3.1 //w=0.17 //l=0.51 //layer=mcon //count=3 \
 //x=14.18 //y=7.58 //x2=14.18 //y2=7.58
r579 (  24 202 ) resistor r=3.1 //w=0.17 //l=0.51 //layer=mcon //count=3 \
 //x=12.7 //y=7.58 //x2=12.7 //y2=7.58
r580 (  24 26 ) resistor r=0.594855 //w=0.311 //l=1.48 //layer=m1 \
 //thickness=0.36 //x=12.7 //y=7.585 //x2=14.18 //y2=7.585
r581 (  22 186 ) resistor r=3.1 //w=0.17 //l=0.51 //layer=mcon //count=3 \
 //x=11.22 //y=7.58 //x2=11.22 //y2=7.58
r582 (  22 24 ) resistor r=0.594855 //w=0.311 //l=1.48 //layer=m1 \
 //thickness=0.36 //x=11.22 //y=7.585 //x2=12.7 //y2=7.585
r583 (  19 176 ) resistor r=3.1 //w=0.17 //l=0.51 //layer=mcon //count=3 \
 //x=10.11 //y=7.58 //x2=10.11 //y2=7.58
r584 (  17 262 ) resistor r=3.1 //w=0.17 //l=0.51 //layer=mcon //count=3 //x=9 \
 //y=7.58 //x2=9 //y2=7.58
r585 (  17 19 ) resistor r=0.446141 //w=0.311 //l=1.11 //layer=m1 \
 //thickness=0.36 //x=9 //y=7.585 //x2=10.11 //y2=7.585
r586 (  15 259 ) resistor r=3.1 //w=0.17 //l=0.51 //layer=mcon //count=3 \
 //x=7.52 //y=7.58 //x2=7.52 //y2=7.58
r587 (  15 17 ) resistor r=0.594855 //w=0.311 //l=1.48 //layer=m1 \
 //thickness=0.36 //x=7.52 //y=7.585 //x2=9 //y2=7.585
r588 (  13 132 ) resistor r=3.1 //w=0.17 //l=0.51 //layer=mcon //count=3 \
 //x=6.41 //y=7.58 //x2=6.41 //y2=7.58
r589 (  13 15 ) resistor r=0.446141 //w=0.311 //l=1.11 //layer=m1 \
 //thickness=0.36 //x=6.41 //y=7.585 //x2=7.52 //y2=7.585
r590 (  11 118 ) resistor r=3.1 //w=0.17 //l=0.51 //layer=mcon //count=3 \
 //x=4.93 //y=7.58 //x2=4.93 //y2=7.58
r591 (  11 13 ) resistor r=0.594855 //w=0.311 //l=1.48 //layer=m1 \
 //thickness=0.36 //x=4.93 //y=7.585 //x2=6.41 //y2=7.585
r592 (  9 108 ) resistor r=3.1 //w=0.17 //l=0.51 //layer=mcon //count=3 \
 //x=3.82 //y=7.58 //x2=3.82 //y2=7.58
r593 (  9 11 ) resistor r=0.446141 //w=0.311 //l=1.11 //layer=m1 \
 //thickness=0.36 //x=3.82 //y=7.585 //x2=4.93 //y2=7.585
r594 (  7 92 ) resistor r=3.1 //w=0.17 //l=0.51 //layer=mcon //count=3 \
 //x=2.34 //y=7.58 //x2=2.34 //y2=7.58
r595 (  7 9 ) resistor r=0.594855 //w=0.311 //l=1.48 //layer=m1 \
 //thickness=0.36 //x=2.34 //y=7.585 //x2=3.82 //y2=7.585
r596 (  4 250 ) resistor r=3.1 //w=0.17 //l=0.51 //layer=mcon //count=3 \
 //x=1.23 //y=7.58 //x2=1.23 //y2=7.58
r597 (  4 7 ) resistor r=0.446141 //w=0.311 //l=1.11 //layer=m1 \
 //thickness=0.36 //x=1.23 //y=7.585 //x2=2.34 //y2=7.585
r598 (  2 61 ) resistor r=0.028033 //w=0.35 //l=0.085 //layer=m1 \
 //thickness=0.36 //x=14.955 //y=7.585 //x2=15.04 //y2=7.585
r599 (  2 26 ) resistor r=0.311495 //w=0.311 //l=0.775 //layer=m1 \
 //thickness=0.36 //x=14.955 //y=7.585 //x2=14.18 //y2=7.585
r600 (  1 22 ) resistor r=0.297428 //w=0.311 //l=0.74 //layer=m1 \
 //thickness=0.36 //x=10.48 //y=7.585 //x2=11.22 //y2=7.585
r601 (  1 19 ) resistor r=0.148714 //w=0.311 //l=0.37 //layer=m1 \
 //thickness=0.36 //x=10.48 //y=7.585 //x2=10.11 //y2=7.585
ends PM_DLATCH\%VDD

subckt PM_DLATCH\%GND ( 1 2 10 41 44 45 50 51 64 68 71 82 100 105 109 112 121 \
 139 144 148 174 186 210 224 238 249 250 262 263 274 285 294 297 298 299 300 \
 301 302 303 )
c401 ( 303 0 ) capacitor c=0.0751269f //x=17.7 //y=0.545
c402 ( 302 0 ) capacitor c=0.074864f //x=14.37 //y=0.545
c403 ( 301 0 ) capacitor c=0.0633685f //x=12.085 //y=0.55
c404 ( 300 0 ) capacitor c=0.00843555f //x=9.25 //y=1.045
c405 ( 299 0 ) capacitor c=0.0629514f //x=6.535 //y=0.55
c406 ( 298 0 ) capacitor c=0.00843555f //x=3.7 //y=1.045
c407 ( 297 0 ) capacitor c=0.0639254f //x=0.985 //y=0.55
c408 ( 294 0 ) capacitor c=0.237929f //x=19.73 //y=0.18
c409 ( 290 0 ) capacitor c=0.00597439f //x=18.805 //y=0.175
c410 ( 287 0 ) capacitor c=0.00597439f //x=17.88 //y=0.18
c411 ( 285 0 ) capacitor c=0.118141f //x=17.14 //y=0.175
c412 ( 282 0 ) capacitor c=0.00597439f //x=16.4 //y=0.18
c413 ( 278 0 ) capacitor c=0.00597439f //x=15.475 //y=0.175
c414 ( 275 0 ) capacitor c=0.00597439f //x=14.505 //y=0.175
c415 ( 274 0 ) capacitor c=0.113151f //x=13.81 //y=0.175
c416 ( 263 0 ) capacitor c=0.113044f //x=11.59 //y=0.175
c417 ( 262 0 ) capacitor c=0.112336f //x=8.26 //y=0.175
c418 ( 250 0 ) capacitor c=0.112889f //x=6.04 //y=0.175
c419 ( 249 0 ) capacitor c=0.11273f //x=2.71 //y=0.175
c420 ( 238 0 ) capacitor c=0.216606f //x=1.12 //y=0.175
c421 ( 229 0 ) capacitor c=0.00739123f //x=19.775 //y=0.625
c422 ( 224 0 ) capacitor c=0.0152893f //x=19.69 //y=0.71
c423 ( 220 0 ) capacitor c=0.0258125f //x=19.69 //y=0.175
c424 ( 215 0 ) capacitor c=0.00726869f //x=18.805 //y=0.625
c425 ( 210 0 ) capacitor c=0.0166441f //x=18.72 //y=0.71
c426 ( 208 0 ) capacitor c=0.0257966f //x=18.72 //y=0.175
c427 ( 203 0 ) capacitor c=0.00739123f //x=17.835 //y=0.625
c428 ( 200 0 ) capacitor c=0.0229116f //x=17.75 //y=0.175
c429 ( 196 0 ) capacitor c=0.0223094f //x=16.97 //y=0.175
c430 ( 191 0 ) capacitor c=0.00739123f //x=16.445 //y=0.625
c431 ( 186 0 ) capacitor c=0.0151627f //x=16.36 //y=0.71
c432 ( 184 0 ) capacitor c=0.0258125f //x=16.36 //y=0.175
c433 ( 179 0 ) capacitor c=0.00726869f //x=15.475 //y=0.625
c434 ( 174 0 ) capacitor c=0.0166957f //x=15.39 //y=0.71
c435 ( 170 0 ) capacitor c=0.0257966f //x=15.39 //y=0.175
c436 ( 165 0 ) capacitor c=0.00739123f //x=14.505 //y=0.625
c437 ( 160 0 ) capacitor c=0.0229116f //x=14.42 //y=0.175
c438 ( 157 0 ) capacitor c=0.0366946f //x=13.275 //y=0.175
c439 ( 156 0 ) capacitor c=0.0186173f //x=13.64 //y=0.175
c440 ( 151 0 ) capacitor c=0.00585268f //x=13.19 //y=0.63
c441 ( 148 0 ) capacitor c=0.0061991f //x=13.105 //y=0.715
c442 ( 147 0 ) capacitor c=0.00479851f //x=12.7 //y=0.63
c443 ( 144 0 ) capacitor c=0.00647872f //x=12.615 //y=0.715
c444 ( 139 0 ) capacitor c=0.00586769f //x=12.22 //y=0.63
c445 ( 136 0 ) capacitor c=0.0190482f //x=12.135 //y=0.175
c446 ( 121 0 ) capacitor c=0.125157f //x=11.42 //y=0.175
c447 ( 118 0 ) capacitor c=0.0366946f //x=7.725 //y=0.175
c448 ( 117 0 ) capacitor c=0.0186173f //x=8.09 //y=0.175
c449 ( 112 0 ) capacitor c=0.00585268f //x=7.64 //y=0.63
c450 ( 109 0 ) capacitor c=0.00617458f //x=7.555 //y=0.715
c451 ( 108 0 ) capacitor c=0.00479851f //x=7.15 //y=0.63
c452 ( 105 0 ) capacitor c=0.00647872f //x=7.065 //y=0.715
c453 ( 100 0 ) capacitor c=0.00586769f //x=6.67 //y=0.63
c454 ( 95 0 ) capacitor c=0.0190482f //x=6.585 //y=0.175
c455 ( 82 0 ) capacitor c=0.12534f //x=5.87 //y=0.175
c456 ( 77 0 ) capacitor c=0.0366946f //x=2.175 //y=0.175
c457 ( 76 0 ) capacitor c=0.0186173f //x=2.54 //y=0.175
c458 ( 71 0 ) capacitor c=0.00585268f //x=2.09 //y=0.63
c459 ( 68 0 ) capacitor c=0.00617458f //x=2.005 //y=0.715
c460 ( 67 0 ) capacitor c=0.00479851f //x=1.6 //y=0.63
c461 ( 64 0 ) capacitor c=0.0064899f //x=1.515 //y=0.715
c462 ( 59 0 ) capacitor c=0.00590583f //x=1.12 //y=0.63
c463 ( 53 0 ) capacitor c=0.00509083f //x=9.44 //y=0.175
c464 ( 51 0 ) capacitor c=0.0278993f //x=9.437 //y=1.005
c465 ( 50 0 ) capacitor c=0.0139141f //x=9.44 //y=1.135
c466 ( 48 0 ) capacitor c=0.00509083f //x=3.82 //y=0.18
c467 ( 45 0 ) capacitor c=0.0278993f //x=3.887 //y=1.005
c468 ( 44 0 ) capacitor c=0.0138339f //x=3.89 //y=1.135
c469 ( 41 0 ) capacitor c=0.400825f //x=19.73 //y=0.18
c470 ( 10 0 ) capacitor c=0.188145f //x=9.355 //y=0.175
c471 ( 2 0 ) capacitor c=0.15403f //x=3.805 //y=0.175
r472 (  266 267 ) resistor r=17.0899 //w=0.367 //l=0.49 //layer=li \
 //thickness=0.1 //x=12.7 //y=0.175 //x2=13.19 //y2=0.175
r473 (  264 266 ) resistor r=16.7411 //w=0.367 //l=0.48 //layer=li \
 //thickness=0.1 //x=12.22 //y=0.175 //x2=12.7 //y2=0.175
r474 (  254 255 ) resistor r=4.18529 //w=0.367 //l=0.12 //layer=li \
 //thickness=0.1 //x=7.52 //y=0.175 //x2=7.64 //y2=0.175
r475 (  252 254 ) resistor r=12.9046 //w=0.367 //l=0.37 //layer=li \
 //thickness=0.1 //x=7.15 //y=0.175 //x2=7.52 //y2=0.175
r476 (  251 252 ) resistor r=16.7411 //w=0.367 //l=0.48 //layer=li \
 //thickness=0.1 //x=6.67 //y=0.175 //x2=7.15 //y2=0.175
r477 (  241 242 ) resistor r=17.0899 //w=0.367 //l=0.49 //layer=li \
 //thickness=0.1 //x=1.6 //y=0.175 //x2=2.09 //y2=0.175
r478 (  240 241 ) resistor r=12.9046 //w=0.367 //l=0.37 //layer=li \
 //thickness=0.1 //x=1.23 //y=0.175 //x2=1.6 //y2=0.175
r479 (  238 240 ) resistor r=3.83651 //w=0.367 //l=0.11 //layer=li \
 //thickness=0.1 //x=1.12 //y=0.175 //x2=1.23 //y2=0.175
r480 (  230 303 ) resistor r=5.4201 //w=0.17 //l=0.085 //layer=li \
 //thickness=0.1 //x=19.775 //y=0.795 //x2=19.775 //y2=0.71
r481 (  230 303 ) resistor r=18.139 //w=0.187 //l=0.265 //layer=li \
 //thickness=0.1 //x=19.775 //y=0.795 //x2=19.775 //y2=1.06
r482 (  229 303 ) resistor r=5.4201 //w=0.17 //l=0.085 //layer=li \
 //thickness=0.1 //x=19.775 //y=0.625 //x2=19.775 //y2=0.71
r483 (  228 294 ) resistor r=4.23183 //w=0.7 //l=0.175 //layer=li \
 //thickness=0.1 //x=19.775 //y=0.35 //x2=19.775 //y2=0.175
r484 (  228 229 ) resistor r=18.8235 //w=0.187 //l=0.275 //layer=li \
 //thickness=0.1 //x=19.775 //y=0.35 //x2=19.775 //y2=0.625
r485 (  225 303 ) resistor r=6.4 //w=0.17 //l=0.085 //layer=li //thickness=0.1 \
 //x=18.89 //y=0.71 //x2=18.805 //y2=0.71
r486 (  225 303 ) resistor r=27.3797 //w=0.187 //l=0.4 //layer=li \
 //thickness=0.1 //x=18.89 //y=0.71 //x2=19.29 //y2=0.71
r487 (  224 303 ) resistor r=1.40859 //w=0.34 //l=0.085 //layer=li \
 //thickness=0.1 //x=19.69 //y=0.71 //x2=19.775 //y2=0.71
r488 (  224 303 ) resistor r=27.3797 //w=0.187 //l=0.4 //layer=li \
 //thickness=0.1 //x=19.69 //y=0.71 //x2=19.29 //y2=0.71
r489 (  221 290 ) resistor r=2.87058 //w=0.35 //l=0.085 //layer=li \
 //thickness=0.1 //x=18.89 //y=0.175 //x2=18.805 //y2=0.175
r490 (  221 223 ) resistor r=3.48774 //w=0.367 //l=0.1 //layer=li \
 //thickness=0.1 //x=18.89 //y=0.175 //x2=18.99 //y2=0.175
r491 (  220 294 ) resistor r=2.87058 //w=0.35 //l=0.085 //layer=li \
 //thickness=0.1 //x=19.69 //y=0.175 //x2=19.775 //y2=0.175
r492 (  220 223 ) resistor r=24.4142 //w=0.367 //l=0.7 //layer=li \
 //thickness=0.1 //x=19.69 //y=0.175 //x2=18.99 //y2=0.175
r493 (  216 303 ) resistor r=6.4 //w=0.17 //l=0.085 //layer=li //thickness=0.1 \
 //x=18.805 //y=0.795 //x2=18.805 //y2=0.71
r494 (  216 303 ) resistor r=18.139 //w=0.187 //l=0.265 //layer=li \
 //thickness=0.1 //x=18.805 //y=0.795 //x2=18.805 //y2=1.06
r495 (  215 303 ) resistor r=6.4 //w=0.17 //l=0.085 //layer=li //thickness=0.1 \
 //x=18.805 //y=0.625 //x2=18.805 //y2=0.71
r496 (  214 290 ) resistor r=4.23183 //w=0.7 //l=0.175 //layer=li \
 //thickness=0.1 //x=18.805 //y=0.35 //x2=18.805 //y2=0.175
r497 (  214 215 ) resistor r=18.8235 //w=0.187 //l=0.275 //layer=li \
 //thickness=0.1 //x=18.805 //y=0.35 //x2=18.805 //y2=0.625
r498 (  211 303 ) resistor r=1.40859 //w=0.34 //l=0.085 //layer=li \
 //thickness=0.1 //x=17.92 //y=0.71 //x2=17.835 //y2=0.71
r499 (  211 303 ) resistor r=27.3797 //w=0.187 //l=0.4 //layer=li \
 //thickness=0.1 //x=17.92 //y=0.71 //x2=18.32 //y2=0.71
r500 (  210 303 ) resistor r=6.4 //w=0.17 //l=0.085 //layer=li //thickness=0.1 \
 //x=18.72 //y=0.71 //x2=18.805 //y2=0.71
r501 (  210 303 ) resistor r=27.3797 //w=0.187 //l=0.4 //layer=li \
 //thickness=0.1 //x=18.72 //y=0.71 //x2=18.32 //y2=0.71
r502 (  209 287 ) resistor r=2.87058 //w=0.35 //l=0.085 //layer=li \
 //thickness=0.1 //x=17.92 //y=0.175 //x2=17.835 //y2=0.175
r503 (  208 290 ) resistor r=2.87058 //w=0.35 //l=0.085 //layer=li \
 //thickness=0.1 //x=18.72 //y=0.175 //x2=18.805 //y2=0.175
r504 (  208 209 ) resistor r=27.9019 //w=0.367 //l=0.8 //layer=li \
 //thickness=0.1 //x=18.72 //y=0.175 //x2=17.92 //y2=0.175
r505 (  204 303 ) resistor r=5.4201 //w=0.17 //l=0.085 //layer=li \
 //thickness=0.1 //x=17.835 //y=0.795 //x2=17.835 //y2=0.71
r506 (  204 303 ) resistor r=41.4118 //w=0.187 //l=0.605 //layer=li \
 //thickness=0.1 //x=17.835 //y=0.795 //x2=17.835 //y2=1.4
r507 (  203 303 ) resistor r=5.4201 //w=0.17 //l=0.085 //layer=li \
 //thickness=0.1 //x=17.835 //y=0.625 //x2=17.835 //y2=0.71
r508 (  202 287 ) resistor r=4.23183 //w=0.7 //l=0.175 //layer=li \
 //thickness=0.1 //x=17.835 //y=0.35 //x2=17.835 //y2=0.175
r509 (  202 203 ) resistor r=18.8235 //w=0.187 //l=0.275 //layer=li \
 //thickness=0.1 //x=17.835 //y=0.35 //x2=17.835 //y2=0.625
r510 (  201 285 ) resistor r=5.29055 //w=0.35 //l=0.17 //layer=li \
 //thickness=0.1 //x=17.31 //y=0.175 //x2=17.14 //y2=0.175
r511 (  200 287 ) resistor r=2.87058 //w=0.35 //l=0.085 //layer=li \
 //thickness=0.1 //x=17.75 //y=0.175 //x2=17.835 //y2=0.175
r512 (  200 201 ) resistor r=15.346 //w=0.367 //l=0.44 //layer=li \
 //thickness=0.1 //x=17.75 //y=0.175 //x2=17.31 //y2=0.175
r513 (  197 282 ) resistor r=2.87058 //w=0.35 //l=0.085 //layer=li \
 //thickness=0.1 //x=16.53 //y=0.175 //x2=16.445 //y2=0.175
r514 (  196 285 ) resistor r=5.29055 //w=0.35 //l=0.17 //layer=li \
 //thickness=0.1 //x=16.97 //y=0.175 //x2=17.14 //y2=0.175
r515 (  196 197 ) resistor r=15.346 //w=0.367 //l=0.44 //layer=li \
 //thickness=0.1 //x=16.97 //y=0.175 //x2=16.53 //y2=0.175
r516 (  192 302 ) resistor r=5.4201 //w=0.17 //l=0.085 //layer=li \
 //thickness=0.1 //x=16.445 //y=0.795 //x2=16.445 //y2=0.71
r517 (  192 302 ) resistor r=18.139 //w=0.187 //l=0.265 //layer=li \
 //thickness=0.1 //x=16.445 //y=0.795 //x2=16.445 //y2=1.06
r518 (  191 302 ) resistor r=5.4201 //w=0.17 //l=0.085 //layer=li \
 //thickness=0.1 //x=16.445 //y=0.625 //x2=16.445 //y2=0.71
r519 (  190 282 ) resistor r=4.23183 //w=0.7 //l=0.175 //layer=li \
 //thickness=0.1 //x=16.445 //y=0.35 //x2=16.445 //y2=0.175
r520 (  190 191 ) resistor r=18.8235 //w=0.187 //l=0.275 //layer=li \
 //thickness=0.1 //x=16.445 //y=0.35 //x2=16.445 //y2=0.625
r521 (  187 302 ) resistor r=6.4 //w=0.17 //l=0.085 //layer=li //thickness=0.1 \
 //x=15.56 //y=0.71 //x2=15.475 //y2=0.71
r522 (  187 302 ) resistor r=27.3797 //w=0.187 //l=0.4 //layer=li \
 //thickness=0.1 //x=15.56 //y=0.71 //x2=15.96 //y2=0.71
r523 (  186 302 ) resistor r=1.40859 //w=0.34 //l=0.085 //layer=li \
 //thickness=0.1 //x=16.36 //y=0.71 //x2=16.445 //y2=0.71
r524 (  186 302 ) resistor r=27.3797 //w=0.187 //l=0.4 //layer=li \
 //thickness=0.1 //x=16.36 //y=0.71 //x2=15.96 //y2=0.71
r525 (  185 278 ) resistor r=2.87058 //w=0.35 //l=0.085 //layer=li \
 //thickness=0.1 //x=15.56 //y=0.175 //x2=15.475 //y2=0.175
r526 (  184 282 ) resistor r=2.87058 //w=0.35 //l=0.085 //layer=li \
 //thickness=0.1 //x=16.36 //y=0.175 //x2=16.445 //y2=0.175
r527 (  184 185 ) resistor r=27.9019 //w=0.367 //l=0.8 //layer=li \
 //thickness=0.1 //x=16.36 //y=0.175 //x2=15.56 //y2=0.175
r528 (  180 302 ) resistor r=6.4 //w=0.17 //l=0.085 //layer=li //thickness=0.1 \
 //x=15.475 //y=0.795 //x2=15.475 //y2=0.71
r529 (  180 302 ) resistor r=18.139 //w=0.187 //l=0.265 //layer=li \
 //thickness=0.1 //x=15.475 //y=0.795 //x2=15.475 //y2=1.06
r530 (  179 302 ) resistor r=6.4 //w=0.17 //l=0.085 //layer=li //thickness=0.1 \
 //x=15.475 //y=0.625 //x2=15.475 //y2=0.71
r531 (  178 278 ) resistor r=4.23183 //w=0.7 //l=0.175 //layer=li \
 //thickness=0.1 //x=15.475 //y=0.35 //x2=15.475 //y2=0.175
r532 (  178 179 ) resistor r=18.8235 //w=0.187 //l=0.275 //layer=li \
 //thickness=0.1 //x=15.475 //y=0.35 //x2=15.475 //y2=0.625
r533 (  175 302 ) resistor r=1.40859 //w=0.34 //l=0.085 //layer=li \
 //thickness=0.1 //x=14.59 //y=0.71 //x2=14.505 //y2=0.71
r534 (  175 302 ) resistor r=27.3797 //w=0.187 //l=0.4 //layer=li \
 //thickness=0.1 //x=14.59 //y=0.71 //x2=14.99 //y2=0.71
r535 (  174 302 ) resistor r=6.4 //w=0.17 //l=0.085 //layer=li //thickness=0.1 \
 //x=15.39 //y=0.71 //x2=15.475 //y2=0.71
r536 (  174 302 ) resistor r=27.3797 //w=0.187 //l=0.4 //layer=li \
 //thickness=0.1 //x=15.39 //y=0.71 //x2=14.99 //y2=0.71
r537 (  171 275 ) resistor r=2.87058 //w=0.35 //l=0.085 //layer=li \
 //thickness=0.1 //x=14.59 //y=0.175 //x2=14.505 //y2=0.175
r538 (  171 173 ) resistor r=24.4142 //w=0.367 //l=0.7 //layer=li \
 //thickness=0.1 //x=14.59 //y=0.175 //x2=15.29 //y2=0.175
r539 (  170 278 ) resistor r=2.87058 //w=0.35 //l=0.085 //layer=li \
 //thickness=0.1 //x=15.39 //y=0.175 //x2=15.475 //y2=0.175
r540 (  170 173 ) resistor r=3.48774 //w=0.367 //l=0.1 //layer=li \
 //thickness=0.1 //x=15.39 //y=0.175 //x2=15.29 //y2=0.175
r541 (  166 302 ) resistor r=5.4201 //w=0.17 //l=0.085 //layer=li \
 //thickness=0.1 //x=14.505 //y=0.795 //x2=14.505 //y2=0.71
r542 (  166 302 ) resistor r=41.4118 //w=0.187 //l=0.605 //layer=li \
 //thickness=0.1 //x=14.505 //y=0.795 //x2=14.505 //y2=1.4
r543 (  165 302 ) resistor r=5.4201 //w=0.17 //l=0.085 //layer=li \
 //thickness=0.1 //x=14.505 //y=0.625 //x2=14.505 //y2=0.71
r544 (  164 275 ) resistor r=4.23183 //w=0.7 //l=0.175 //layer=li \
 //thickness=0.1 //x=14.505 //y=0.35 //x2=14.505 //y2=0.175
r545 (  164 165 ) resistor r=18.8235 //w=0.187 //l=0.275 //layer=li \
 //thickness=0.1 //x=14.505 //y=0.35 //x2=14.505 //y2=0.625
r546 (  161 274 ) resistor r=5.29055 //w=0.35 //l=0.17 //layer=li \
 //thickness=0.1 //x=13.98 //y=0.175 //x2=13.81 //y2=0.175
r547 (  161 163 ) resistor r=6.97548 //w=0.367 //l=0.2 //layer=li \
 //thickness=0.1 //x=13.98 //y=0.175 //x2=14.18 //y2=0.175
r548 (  160 275 ) resistor r=2.87058 //w=0.35 //l=0.085 //layer=li \
 //thickness=0.1 //x=14.42 //y=0.175 //x2=14.505 //y2=0.175
r549 (  160 163 ) resistor r=8.37057 //w=0.367 //l=0.24 //layer=li \
 //thickness=0.1 //x=14.42 //y=0.175 //x2=14.18 //y2=0.175
r550 (  157 267 ) resistor r=2.96458 //w=0.367 //l=0.085 //layer=li \
 //thickness=0.1 //x=13.275 //y=0.175 //x2=13.19 //y2=0.175
r551 (  156 274 ) resistor r=5.29055 //w=0.35 //l=0.17 //layer=li \
 //thickness=0.1 //x=13.64 //y=0.175 //x2=13.81 //y2=0.175
r552 (  156 157 ) resistor r=12.7302 //w=0.367 //l=0.365 //layer=li \
 //thickness=0.1 //x=13.64 //y=0.175 //x2=13.275 //y2=0.175
r553 (  152 301 ) resistor r=5.4201 //w=0.17 //l=0.085 //layer=li \
 //thickness=0.1 //x=13.19 //y=0.8 //x2=13.19 //y2=0.715
r554 (  152 301 ) resistor r=41.4118 //w=0.187 //l=0.605 //layer=li \
 //thickness=0.1 //x=13.19 //y=0.8 //x2=13.19 //y2=1.405
r555 (  151 301 ) resistor r=5.4201 //w=0.17 //l=0.085 //layer=li \
 //thickness=0.1 //x=13.19 //y=0.63 //x2=13.19 //y2=0.715
r556 (  150 267 ) resistor r=5.21862 //w=0.35 //l=0.175 //layer=li \
 //thickness=0.1 //x=13.19 //y=0.35 //x2=13.19 //y2=0.175
r557 (  150 151 ) resistor r=19.1658 //w=0.187 //l=0.28 //layer=li \
 //thickness=0.1 //x=13.19 //y=0.35 //x2=13.19 //y2=0.63
r558 (  149 301 ) resistor r=5.4201 //w=0.17 //l=0.085 //layer=li \
 //thickness=0.1 //x=12.785 //y=0.715 //x2=12.7 //y2=0.715
r559 (  148 301 ) resistor r=1.40859 //w=0.34 //l=0.085 //layer=li \
 //thickness=0.1 //x=13.105 //y=0.715 //x2=13.19 //y2=0.715
r560 (  148 149 ) resistor r=21.9037 //w=0.187 //l=0.32 //layer=li \
 //thickness=0.1 //x=13.105 //y=0.715 //x2=12.785 //y2=0.715
r561 (  147 301 ) resistor r=1.40859 //w=0.34 //l=0.085 //layer=li \
 //thickness=0.1 //x=12.7 //y=0.63 //x2=12.7 //y2=0.715
r562 (  146 266 ) resistor r=5.21862 //w=0.35 //l=0.175 //layer=li \
 //thickness=0.1 //x=12.7 //y=0.35 //x2=12.7 //y2=0.175
r563 (  146 147 ) resistor r=19.1658 //w=0.187 //l=0.28 //layer=li \
 //thickness=0.1 //x=12.7 //y=0.35 //x2=12.7 //y2=0.63
r564 (  145 301 ) resistor r=1.40859 //w=0.34 //l=0.085 //layer=li \
 //thickness=0.1 //x=12.305 //y=0.715 //x2=12.22 //y2=0.715
r565 (  144 301 ) resistor r=5.4201 //w=0.17 //l=0.085 //layer=li \
 //thickness=0.1 //x=12.615 //y=0.715 //x2=12.7 //y2=0.715
r566 (  144 145 ) resistor r=21.2193 //w=0.187 //l=0.31 //layer=li \
 //thickness=0.1 //x=12.615 //y=0.715 //x2=12.305 //y2=0.715
r567 (  140 301 ) resistor r=5.4201 //w=0.17 //l=0.085 //layer=li \
 //thickness=0.1 //x=12.22 //y=0.8 //x2=12.22 //y2=0.715
r568 (  140 301 ) resistor r=41.4118 //w=0.187 //l=0.605 //layer=li \
 //thickness=0.1 //x=12.22 //y=0.8 //x2=12.22 //y2=1.405
r569 (  139 301 ) resistor r=5.4201 //w=0.17 //l=0.085 //layer=li \
 //thickness=0.1 //x=12.22 //y=0.63 //x2=12.22 //y2=0.715
r570 (  138 264 ) resistor r=5.21862 //w=0.35 //l=0.175 //layer=li \
 //thickness=0.1 //x=12.22 //y=0.35 //x2=12.22 //y2=0.175
r571 (  138 139 ) resistor r=19.1658 //w=0.187 //l=0.28 //layer=li \
 //thickness=0.1 //x=12.22 //y=0.35 //x2=12.22 //y2=0.63
r572 (  137 263 ) resistor r=5.29055 //w=0.35 //l=0.17 //layer=li \
 //thickness=0.1 //x=11.76 //y=0.175 //x2=11.59 //y2=0.175
r573 (  136 264 ) resistor r=2.96458 //w=0.367 //l=0.085 //layer=li \
 //thickness=0.1 //x=12.135 //y=0.175 //x2=12.22 //y2=0.175
r574 (  136 137 ) resistor r=13.079 //w=0.367 //l=0.375 //layer=li \
 //thickness=0.1 //x=12.135 //y=0.175 //x2=11.76 //y2=0.175
r575 (  126 128 ) resistor r=38.7139 //w=0.367 //l=1.11 //layer=li \
 //thickness=0.1 //x=10.11 //y=0.175 //x2=11.22 //y2=0.175
r576 (  124 126 ) resistor r=38.7139 //w=0.367 //l=1.11 //layer=li \
 //thickness=0.1 //x=9 //y=0.175 //x2=10.11 //y2=0.175
r577 (  122 262 ) resistor r=5.29055 //w=0.35 //l=0.17 //layer=li \
 //thickness=0.1 //x=8.43 //y=0.175 //x2=8.26 //y2=0.175
r578 (  122 124 ) resistor r=19.8801 //w=0.367 //l=0.57 //layer=li \
 //thickness=0.1 //x=8.43 //y=0.175 //x2=9 //y2=0.175
r579 (  121 263 ) resistor r=5.29055 //w=0.35 //l=0.17 //layer=li \
 //thickness=0.1 //x=11.42 //y=0.175 //x2=11.59 //y2=0.175
r580 (  121 128 ) resistor r=6.97548 //w=0.367 //l=0.2 //layer=li \
 //thickness=0.1 //x=11.42 //y=0.175 //x2=11.22 //y2=0.175
r581 (  118 255 ) resistor r=2.96458 //w=0.367 //l=0.085 //layer=li \
 //thickness=0.1 //x=7.725 //y=0.175 //x2=7.64 //y2=0.175
r582 (  117 262 ) resistor r=5.29055 //w=0.35 //l=0.17 //layer=li \
 //thickness=0.1 //x=8.09 //y=0.175 //x2=8.26 //y2=0.175
r583 (  117 118 ) resistor r=12.7302 //w=0.367 //l=0.365 //layer=li \
 //thickness=0.1 //x=8.09 //y=0.175 //x2=7.725 //y2=0.175
r584 (  113 299 ) resistor r=5.4201 //w=0.17 //l=0.085 //layer=li \
 //thickness=0.1 //x=7.64 //y=0.8 //x2=7.64 //y2=0.715
r585 (  113 299 ) resistor r=41.4118 //w=0.187 //l=0.605 //layer=li \
 //thickness=0.1 //x=7.64 //y=0.8 //x2=7.64 //y2=1.405
r586 (  112 299 ) resistor r=5.4201 //w=0.17 //l=0.085 //layer=li \
 //thickness=0.1 //x=7.64 //y=0.63 //x2=7.64 //y2=0.715
r587 (  111 255 ) resistor r=5.21862 //w=0.35 //l=0.175 //layer=li \
 //thickness=0.1 //x=7.64 //y=0.35 //x2=7.64 //y2=0.175
r588 (  111 112 ) resistor r=19.1658 //w=0.187 //l=0.28 //layer=li \
 //thickness=0.1 //x=7.64 //y=0.35 //x2=7.64 //y2=0.63
r589 (  110 299 ) resistor r=5.4201 //w=0.17 //l=0.085 //layer=li \
 //thickness=0.1 //x=7.235 //y=0.715 //x2=7.15 //y2=0.715
r590 (  109 299 ) resistor r=1.40859 //w=0.34 //l=0.085 //layer=li \
 //thickness=0.1 //x=7.555 //y=0.715 //x2=7.64 //y2=0.715
r591 (  109 110 ) resistor r=21.9037 //w=0.187 //l=0.32 //layer=li \
 //thickness=0.1 //x=7.555 //y=0.715 //x2=7.235 //y2=0.715
r592 (  108 299 ) resistor r=1.40859 //w=0.34 //l=0.085 //layer=li \
 //thickness=0.1 //x=7.15 //y=0.63 //x2=7.15 //y2=0.715
r593 (  107 252 ) resistor r=5.21862 //w=0.35 //l=0.175 //layer=li \
 //thickness=0.1 //x=7.15 //y=0.35 //x2=7.15 //y2=0.175
r594 (  107 108 ) resistor r=19.1658 //w=0.187 //l=0.28 //layer=li \
 //thickness=0.1 //x=7.15 //y=0.35 //x2=7.15 //y2=0.63
r595 (  106 299 ) resistor r=1.40859 //w=0.34 //l=0.085 //layer=li \
 //thickness=0.1 //x=6.755 //y=0.715 //x2=6.67 //y2=0.715
r596 (  105 299 ) resistor r=5.4201 //w=0.17 //l=0.085 //layer=li \
 //thickness=0.1 //x=7.065 //y=0.715 //x2=7.15 //y2=0.715
r597 (  105 106 ) resistor r=21.2193 //w=0.187 //l=0.31 //layer=li \
 //thickness=0.1 //x=7.065 //y=0.715 //x2=6.755 //y2=0.715
r598 (  101 299 ) resistor r=5.4201 //w=0.17 //l=0.085 //layer=li \
 //thickness=0.1 //x=6.67 //y=0.8 //x2=6.67 //y2=0.715
r599 (  101 299 ) resistor r=41.4118 //w=0.187 //l=0.605 //layer=li \
 //thickness=0.1 //x=6.67 //y=0.8 //x2=6.67 //y2=1.405
r600 (  100 299 ) resistor r=5.4201 //w=0.17 //l=0.085 //layer=li \
 //thickness=0.1 //x=6.67 //y=0.63 //x2=6.67 //y2=0.715
r601 (  99 251 ) resistor r=5.21862 //w=0.35 //l=0.175 //layer=li \
 //thickness=0.1 //x=6.67 //y=0.35 //x2=6.67 //y2=0.175
r602 (  99 100 ) resistor r=19.1658 //w=0.187 //l=0.28 //layer=li \
 //thickness=0.1 //x=6.67 //y=0.35 //x2=6.67 //y2=0.63
r603 (  96 250 ) resistor r=5.29055 //w=0.35 //l=0.17 //layer=li \
 //thickness=0.1 //x=6.21 //y=0.175 //x2=6.04 //y2=0.175
r604 (  96 98 ) resistor r=6.97548 //w=0.367 //l=0.2 //layer=li \
 //thickness=0.1 //x=6.21 //y=0.175 //x2=6.41 //y2=0.175
r605 (  95 251 ) resistor r=2.96458 //w=0.367 //l=0.085 //layer=li \
 //thickness=0.1 //x=6.585 //y=0.175 //x2=6.67 //y2=0.175
r606 (  95 98 ) resistor r=6.10354 //w=0.367 //l=0.175 //layer=li \
 //thickness=0.1 //x=6.585 //y=0.175 //x2=6.41 //y2=0.175
r607 (  85 87 ) resistor r=38.7139 //w=0.367 //l=1.11 //layer=li \
 //thickness=0.1 //x=3.82 //y=0.175 //x2=4.93 //y2=0.175
r608 (  83 249 ) resistor r=5.29055 //w=0.35 //l=0.17 //layer=li \
 //thickness=0.1 //x=2.88 //y=0.175 //x2=2.71 //y2=0.175
r609 (  83 85 ) resistor r=32.7847 //w=0.367 //l=0.94 //layer=li \
 //thickness=0.1 //x=2.88 //y=0.175 //x2=3.82 //y2=0.175
r610 (  82 250 ) resistor r=5.29055 //w=0.35 //l=0.17 //layer=li \
 //thickness=0.1 //x=5.87 //y=0.175 //x2=6.04 //y2=0.175
r611 (  82 87 ) resistor r=32.7847 //w=0.367 //l=0.94 //layer=li \
 //thickness=0.1 //x=5.87 //y=0.175 //x2=4.93 //y2=0.175
r612 (  77 242 ) resistor r=2.96458 //w=0.367 //l=0.085 //layer=li \
 //thickness=0.1 //x=2.175 //y=0.175 //x2=2.09 //y2=0.175
r613 (  77 79 ) resistor r=5.75477 //w=0.367 //l=0.165 //layer=li \
 //thickness=0.1 //x=2.175 //y=0.175 //x2=2.34 //y2=0.175
r614 (  76 249 ) resistor r=5.29055 //w=0.35 //l=0.17 //layer=li \
 //thickness=0.1 //x=2.54 //y=0.175 //x2=2.71 //y2=0.175
r615 (  76 79 ) resistor r=6.97548 //w=0.367 //l=0.2 //layer=li \
 //thickness=0.1 //x=2.54 //y=0.175 //x2=2.34 //y2=0.175
r616 (  72 297 ) resistor r=5.4201 //w=0.17 //l=0.085 //layer=li \
 //thickness=0.1 //x=2.09 //y=0.8 //x2=2.09 //y2=0.715
r617 (  72 297 ) resistor r=41.4118 //w=0.187 //l=0.605 //layer=li \
 //thickness=0.1 //x=2.09 //y=0.8 //x2=2.09 //y2=1.405
r618 (  71 297 ) resistor r=5.4201 //w=0.17 //l=0.085 //layer=li \
 //thickness=0.1 //x=2.09 //y=0.63 //x2=2.09 //y2=0.715
r619 (  70 242 ) resistor r=5.21862 //w=0.35 //l=0.175 //layer=li \
 //thickness=0.1 //x=2.09 //y=0.35 //x2=2.09 //y2=0.175
r620 (  70 71 ) resistor r=19.1658 //w=0.187 //l=0.28 //layer=li \
 //thickness=0.1 //x=2.09 //y=0.35 //x2=2.09 //y2=0.63
r621 (  69 297 ) resistor r=5.4201 //w=0.17 //l=0.085 //layer=li \
 //thickness=0.1 //x=1.685 //y=0.715 //x2=1.6 //y2=0.715
r622 (  68 297 ) resistor r=1.40859 //w=0.34 //l=0.085 //layer=li \
 //thickness=0.1 //x=2.005 //y=0.715 //x2=2.09 //y2=0.715
r623 (  68 69 ) resistor r=21.9037 //w=0.187 //l=0.32 //layer=li \
 //thickness=0.1 //x=2.005 //y=0.715 //x2=1.685 //y2=0.715
r624 (  67 297 ) resistor r=1.40859 //w=0.34 //l=0.085 //layer=li \
 //thickness=0.1 //x=1.6 //y=0.63 //x2=1.6 //y2=0.715
r625 (  66 241 ) resistor r=5.21862 //w=0.35 //l=0.175 //layer=li \
 //thickness=0.1 //x=1.6 //y=0.35 //x2=1.6 //y2=0.175
r626 (  66 67 ) resistor r=19.1658 //w=0.187 //l=0.28 //layer=li \
 //thickness=0.1 //x=1.6 //y=0.35 //x2=1.6 //y2=0.63
r627 (  65 297 ) resistor r=1.40859 //w=0.34 //l=0.085 //layer=li \
 //thickness=0.1 //x=1.205 //y=0.715 //x2=1.12 //y2=0.715
r628 (  64 297 ) resistor r=5.4201 //w=0.17 //l=0.085 //layer=li \
 //thickness=0.1 //x=1.515 //y=0.715 //x2=1.6 //y2=0.715
r629 (  64 65 ) resistor r=21.2193 //w=0.187 //l=0.31 //layer=li \
 //thickness=0.1 //x=1.515 //y=0.715 //x2=1.205 //y2=0.715
r630 (  60 297 ) resistor r=5.4201 //w=0.17 //l=0.085 //layer=li \
 //thickness=0.1 //x=1.12 //y=0.8 //x2=1.12 //y2=0.715
r631 (  60 297 ) resistor r=41.4118 //w=0.187 //l=0.605 //layer=li \
 //thickness=0.1 //x=1.12 //y=0.8 //x2=1.12 //y2=1.405
r632 (  59 297 ) resistor r=5.4201 //w=0.17 //l=0.085 //layer=li \
 //thickness=0.1 //x=1.12 //y=0.63 //x2=1.12 //y2=0.715
r633 (  58 238 ) resistor r=5.21862 //w=0.35 //l=0.175 //layer=li \
 //thickness=0.1 //x=1.12 //y=0.35 //x2=1.12 //y2=0.175
r634 (  58 59 ) resistor r=19.1658 //w=0.187 //l=0.28 //layer=li \
 //thickness=0.1 //x=1.12 //y=0.35 //x2=1.12 //y2=0.63
r635 (  50 300 ) resistor r=9.3 //w=0.17 //l=0.17 //layer=mcon //count=1 \
 //x=9.44 //y=1.135 //x2=9.44 //y2=1.135
r636 (  50 51 ) resistor r=0.0939994 //w=0.226 //l=0.13 //layer=m1 \
 //thickness=0.36 //x=9.437 //y=1.135 //x2=9.437 //y2=1.005
r637 (  48 85 ) resistor r=3.1 //w=0.17 //l=0.51 //layer=mcon //count=3 \
 //x=3.82 //y=0.18 //x2=3.82 //y2=0.18
r638 (  44 298 ) resistor r=9.3 //w=0.17 //l=0.17 //layer=mcon //count=1 \
 //x=3.89 //y=1.135 //x2=3.89 //y2=1.135
r639 (  44 45 ) resistor r=0.0939994 //w=0.226 //l=0.13 //layer=m1 \
 //thickness=0.36 //x=3.887 //y=1.135 //x2=3.887 //y2=1.005
r640 (  41 294 ) resistor r=4.65 //w=0.17 //l=0.34 //layer=mcon //count=2 \
 //x=19.73 //y=0.18 //x2=19.73 //y2=0.18
r641 (  39 223 ) resistor r=3.1 //w=0.17 //l=0.51 //layer=mcon //count=3 \
 //x=18.99 //y=0.18 //x2=18.99 //y2=0.18
r642 (  39 41 ) resistor r=0.297428 //w=0.311 //l=0.74 //layer=m1 \
 //thickness=0.36 //x=18.99 //y=0.175 //x2=19.73 //y2=0.175
r643 (  37 287 ) resistor r=3.1 //w=0.17 //l=0.51 //layer=mcon //count=3 \
 //x=17.88 //y=0.18 //x2=17.88 //y2=0.18
r644 (  37 39 ) resistor r=0.446141 //w=0.311 //l=1.11 //layer=m1 \
 //thickness=0.36 //x=17.88 //y=0.175 //x2=18.99 //y2=0.175
r645 (  35 282 ) resistor r=3.1 //w=0.17 //l=0.51 //layer=mcon //count=3 \
 //x=16.4 //y=0.18 //x2=16.4 //y2=0.18
r646 (  35 37 ) resistor r=0.594855 //w=0.311 //l=1.48 //layer=m1 \
 //thickness=0.36 //x=16.4 //y=0.175 //x2=17.88 //y2=0.175
r647 (  33 173 ) resistor r=3.1 //w=0.17 //l=0.51 //layer=mcon //count=3 \
 //x=15.29 //y=0.18 //x2=15.29 //y2=0.18
r648 (  33 35 ) resistor r=0.446141 //w=0.311 //l=1.11 //layer=m1 \
 //thickness=0.36 //x=15.29 //y=0.175 //x2=16.4 //y2=0.175
r649 (  31 163 ) resistor r=3.1 //w=0.17 //l=0.51 //layer=mcon //count=3 \
 //x=14.18 //y=0.18 //x2=14.18 //y2=0.18
r650 (  31 33 ) resistor r=0.446141 //w=0.311 //l=1.11 //layer=m1 \
 //thickness=0.36 //x=14.18 //y=0.175 //x2=15.29 //y2=0.175
r651 (  29 266 ) resistor r=3.1 //w=0.17 //l=0.51 //layer=mcon //count=3 \
 //x=12.7 //y=0.18 //x2=12.7 //y2=0.18
r652 (  29 31 ) resistor r=0.594855 //w=0.311 //l=1.48 //layer=m1 \
 //thickness=0.36 //x=12.7 //y=0.175 //x2=14.18 //y2=0.175
r653 (  27 128 ) resistor r=3.1 //w=0.17 //l=0.51 //layer=mcon //count=3 \
 //x=11.22 //y=0.18 //x2=11.22 //y2=0.18
r654 (  27 29 ) resistor r=0.594855 //w=0.311 //l=1.48 //layer=m1 \
 //thickness=0.36 //x=11.22 //y=0.175 //x2=12.7 //y2=0.175
r655 (  24 126 ) resistor r=3.1 //w=0.17 //l=0.51 //layer=mcon //count=3 \
 //x=10.11 //y=0.18 //x2=10.11 //y2=0.18
r656 (  22 53 ) resistor r=0.028033 //w=0.35 //l=0.085 //layer=m1 \
 //thickness=0.36 //x=9.525 //y=0.175 //x2=9.44 //y2=0.175
r657 (  22 24 ) resistor r=0.235129 //w=0.311 //l=0.585 //layer=m1 \
 //thickness=0.36 //x=9.525 //y=0.175 //x2=10.11 //y2=0.175
r658 (  20 53 ) resistor r=0.0413265 //w=0.7 //l=0.175 //layer=m1 \
 //thickness=0.36 //x=9.44 //y=0.35 //x2=9.44 //y2=0.175
r659 (  20 51 ) resistor r=0.625 //w=0.131 //l=0.655 //layer=m1 \
 //thickness=0.36 //x=9.44 //y=0.35 //x2=9.44 //y2=1.005
r660 (  19 124 ) resistor r=3.1 //w=0.17 //l=0.51 //layer=mcon //count=3 //x=9 \
 //y=0.18 //x2=9 //y2=0.18
r661 (  17 254 ) resistor r=3.1 //w=0.17 //l=0.51 //layer=mcon //count=3 \
 //x=7.52 //y=0.18 //x2=7.52 //y2=0.18
r662 (  17 19 ) resistor r=0.594855 //w=0.311 //l=1.48 //layer=m1 \
 //thickness=0.36 //x=7.52 //y=0.175 //x2=9 //y2=0.175
r663 (  15 98 ) resistor r=3.1 //w=0.17 //l=0.51 //layer=mcon //count=3 \
 //x=6.41 //y=0.18 //x2=6.41 //y2=0.18
r664 (  15 17 ) resistor r=0.446141 //w=0.311 //l=1.11 //layer=m1 \
 //thickness=0.36 //x=6.41 //y=0.175 //x2=7.52 //y2=0.175
r665 (  13 87 ) resistor r=3.1 //w=0.17 //l=0.51 //layer=mcon //count=3 \
 //x=4.93 //y=0.18 //x2=4.93 //y2=0.18
r666 (  13 15 ) resistor r=0.594855 //w=0.311 //l=1.48 //layer=m1 \
 //thickness=0.36 //x=4.93 //y=0.175 //x2=6.41 //y2=0.175
r667 (  11 48 ) resistor r=0.028033 //w=0.35 //l=0.085 //layer=m1 \
 //thickness=0.36 //x=3.975 //y=0.175 //x2=3.89 //y2=0.175
r668 (  11 13 ) resistor r=0.383842 //w=0.311 //l=0.955 //layer=m1 \
 //thickness=0.36 //x=3.975 //y=0.175 //x2=4.93 //y2=0.175
r669 (  10 53 ) resistor r=0.028033 //w=0.35 //l=0.085 //layer=m1 \
 //thickness=0.36 //x=9.355 //y=0.175 //x2=9.44 //y2=0.175
r670 (  10 19 ) resistor r=0.142685 //w=0.311 //l=0.355 //layer=m1 \
 //thickness=0.36 //x=9.355 //y=0.175 //x2=9 //y2=0.175
r671 (  8 48 ) resistor r=0.0413265 //w=0.7 //l=0.175 //layer=m1 \
 //thickness=0.36 //x=3.89 //y=0.35 //x2=3.89 //y2=0.175
r672 (  8 45 ) resistor r=0.625 //w=0.131 //l=0.655 //layer=m1 \
 //thickness=0.36 //x=3.89 //y=0.35 //x2=3.89 //y2=1.005
r673 (  7 79 ) resistor r=3.1 //w=0.17 //l=0.51 //layer=mcon //count=3 \
 //x=2.34 //y=0.18 //x2=2.34 //y2=0.18
r674 (  4 240 ) resistor r=3.1 //w=0.17 //l=0.51 //layer=mcon //count=3 \
 //x=1.23 //y=0.18 //x2=1.23 //y2=0.18
r675 (  4 7 ) resistor r=0.446141 //w=0.311 //l=1.11 //layer=m1 \
 //thickness=0.36 //x=1.23 //y=0.175 //x2=2.34 //y2=0.175
r676 (  2 48 ) resistor r=0.028033 //w=0.35 //l=0.085 //layer=m1 \
 //thickness=0.36 //x=3.805 //y=0.175 //x2=3.89 //y2=0.175
r677 (  2 7 ) resistor r=0.588826 //w=0.311 //l=1.465 //layer=m1 \
 //thickness=0.36 //x=3.805 //y=0.175 //x2=2.34 //y2=0.175
r678 (  1 27 ) resistor r=0.297428 //w=0.311 //l=0.74 //layer=m1 \
 //thickness=0.36 //x=10.48 //y=0.175 //x2=11.22 //y2=0.175
r679 (  1 24 ) resistor r=0.148714 //w=0.311 //l=0.37 //layer=m1 \
 //thickness=0.36 //x=10.48 //y=0.175 //x2=10.11 //y2=0.175
ends PM_DLATCH\%GND

subckt PM_DLATCH\%noxref_12 ( 1 3 5 10 14 17 20 30 46 47 48 )
c95 ( 48 0 ) capacitor c=0.0375089f //x=16.215 //y=5.205
c96 ( 46 0 ) capacitor c=0.0118024f //x=14.465 //y=5.205
c97 ( 30 0 ) capacitor c=0.0293159f //x=15.48 //y=5.56
c98 ( 20 0 ) capacitor c=0.0452975f //x=14.6 //y=5.56
c99 ( 17 0 ) capacitor c=0.0105999f //x=16.36 //y=6.92
c100 ( 14 0 ) capacitor c=0.00602515f //x=15.48 //y=6.92
c101 ( 10 0 ) capacitor c=0.0101589f //x=15.48 //y=5.39
c102 ( 5 0 ) capacitor c=0.010995f //x=14.6 //y=5.39
c103 ( 3 0 ) capacitor c=0.00691991f //x=16.23 //y=7.09
c104 ( 1 0 ) capacitor c=0.0122217f //x=15.36 //y=5.39
r105 (  37 47 ) resistor r=23.2727 //w=0.187 //l=0.34 //layer=li \
 //thickness=0.1 //x=15.48 //y=6.92 //x2=15.48 //y2=6.58
r106 (  30 47 ) resistor r=23.2727 //w=0.187 //l=0.34 //layer=li \
 //thickness=0.1 //x=15.48 //y=5.56 //x2=15.48 //y2=5.9
r107 (  20 46 ) resistor r=23.2727 //w=0.187 //l=0.34 //layer=li \
 //thickness=0.1 //x=14.6 //y=5.56 //x2=14.6 //y2=5.9
r108 (  17 48 ) resistor r=9.3 //w=0.17 //l=0.17 //layer=mcon //count=1 \
 //x=16.36 //y=6.92 //x2=16.36 //y2=6.92
r109 (  17 18 ) resistor r=0.0932018 //w=0.228 //l=0.17 //layer=m1 \
 //thickness=0.36 //x=16.352 //y=6.92 //x2=16.352 //y2=7.09
r110 (  14 37 ) resistor r=9.3 //w=0.17 //l=0.17 //layer=mcon //count=1 \
 //x=15.48 //y=6.92 //x2=15.48 //y2=6.92
r111 (  14 15 ) resistor r=0.0992991 //w=0.214 //l=0.17 //layer=m1 \
 //thickness=0.36 //x=15.48 //y=6.92 //x2=15.48 //y2=7.09
r112 (  12 30 ) resistor r=9.3 //w=0.17 //l=0.17 //layer=mcon //count=1 \
 //x=15.48 //y=5.56 //x2=15.48 //y2=5.56
r113 (  10 12 ) resistor r=0.097032 //w=0.219 //l=0.17 //layer=m1 \
 //thickness=0.36 //x=15.48 //y=5.39 //x2=15.48 //y2=5.56
r114 (  7 20 ) resistor r=9.3 //w=0.17 //l=0.17 //layer=mcon //count=1 \
 //x=14.6 //y=5.56 //x2=14.6 //y2=5.56
r115 (  5 7 ) resistor r=0.0997653 //w=0.213 //l=0.17 //layer=m1 \
 //thickness=0.36 //x=14.6 //y=5.39 //x2=14.6 //y2=5.56
r116 (  4 15 ) resistor r=0.0213909 //w=0.214 //l=0.115 //layer=m1 \
 //thickness=0.36 //x=15.595 //y=7.09 //x2=15.48 //y2=7.09
r117 (  3 18 ) resistor r=0.0251868 //w=0.228 //l=0.122 //layer=m1 \
 //thickness=0.36 //x=16.23 //y=7.09 //x2=16.352 //y2=7.09
r118 (  3 4 ) resistor r=0.605916 //w=0.131 //l=0.635 //layer=m1 \
 //thickness=0.36 //x=16.23 //y=7.09 //x2=15.595 //y2=7.09
r119 (  2 5 ) resistor r=0.0211096 //w=0.213 //l=0.115 //layer=m1 \
 //thickness=0.36 //x=14.715 //y=5.39 //x2=14.6 //y2=5.39
r120 (  1 10 ) resistor r=0.0227762 //w=0.219 //l=0.12 //layer=m1 \
 //thickness=0.36 //x=15.36 //y=5.39 //x2=15.48 //y2=5.39
r121 (  1 2 ) resistor r=0.615458 //w=0.131 //l=0.645 //layer=m1 \
 //thickness=0.36 //x=15.36 //y=5.39 //x2=14.715 //y2=5.39
ends PM_DLATCH\%noxref_12

subckt PM_DLATCH\%noxref_13 ( 1 3 5 10 14 17 20 30 46 47 48 )
c91 ( 48 0 ) capacitor c=0.0347637f //x=19.545 //y=5.205
c92 ( 46 0 ) capacitor c=0.00778013f //x=17.795 //y=5.205
c93 ( 30 0 ) capacitor c=0.0293376f //x=18.81 //y=5.56
c94 ( 20 0 ) capacitor c=0.0487118f //x=17.93 //y=5.56
c95 ( 17 0 ) capacitor c=0.0163469f //x=19.69 //y=6.92
c96 ( 14 0 ) capacitor c=0.00601681f //x=18.81 //y=6.92
c97 ( 10 0 ) capacitor c=0.00856065f //x=18.81 //y=5.39
c98 ( 5 0 ) capacitor c=0.0114718f //x=17.93 //y=5.39
c99 ( 3 0 ) capacitor c=0.00691332f //x=19.56 //y=7.09
c100 ( 1 0 ) capacitor c=0.0120818f //x=18.69 //y=5.39
r101 (  37 47 ) resistor r=23.2727 //w=0.187 //l=0.34 //layer=li \
 //thickness=0.1 //x=18.81 //y=6.92 //x2=18.81 //y2=6.58
r102 (  30 47 ) resistor r=23.2727 //w=0.187 //l=0.34 //layer=li \
 //thickness=0.1 //x=18.81 //y=5.56 //x2=18.81 //y2=5.9
r103 (  20 46 ) resistor r=23.2727 //w=0.187 //l=0.34 //layer=li \
 //thickness=0.1 //x=17.93 //y=5.56 //x2=17.93 //y2=5.9
r104 (  17 48 ) resistor r=9.3 //w=0.17 //l=0.17 //layer=mcon //count=1 \
 //x=19.69 //y=6.92 //x2=19.69 //y2=6.92
r105 (  17 18 ) resistor r=0.0932018 //w=0.228 //l=0.17 //layer=m1 \
 //thickness=0.36 //x=19.682 //y=6.92 //x2=19.682 //y2=7.09
r106 (  14 37 ) resistor r=9.3 //w=0.17 //l=0.17 //layer=mcon //count=1 \
 //x=18.81 //y=6.92 //x2=18.81 //y2=6.92
r107 (  14 15 ) resistor r=0.0992991 //w=0.214 //l=0.17 //layer=m1 \
 //thickness=0.36 //x=18.81 //y=6.92 //x2=18.81 //y2=7.09
r108 (  12 30 ) resistor r=9.3 //w=0.17 //l=0.17 //layer=mcon //count=1 \
 //x=18.81 //y=5.56 //x2=18.81 //y2=5.56
r109 (  10 12 ) resistor r=0.097032 //w=0.219 //l=0.17 //layer=m1 \
 //thickness=0.36 //x=18.81 //y=5.39 //x2=18.81 //y2=5.56
r110 (  7 20 ) resistor r=9.3 //w=0.17 //l=0.17 //layer=mcon //count=1 \
 //x=17.93 //y=5.56 //x2=17.93 //y2=5.56
r111 (  5 7 ) resistor r=0.0997653 //w=0.213 //l=0.17 //layer=m1 \
 //thickness=0.36 //x=17.93 //y=5.39 //x2=17.93 //y2=5.56
r112 (  4 15 ) resistor r=0.0213909 //w=0.214 //l=0.115 //layer=m1 \
 //thickness=0.36 //x=18.925 //y=7.09 //x2=18.81 //y2=7.09
r113 (  3 18 ) resistor r=0.0251868 //w=0.228 //l=0.122 //layer=m1 \
 //thickness=0.36 //x=19.56 //y=7.09 //x2=19.682 //y2=7.09
r114 (  3 4 ) resistor r=0.605916 //w=0.131 //l=0.635 //layer=m1 \
 //thickness=0.36 //x=19.56 //y=7.09 //x2=18.925 //y2=7.09
r115 (  2 5 ) resistor r=0.0211096 //w=0.213 //l=0.115 //layer=m1 \
 //thickness=0.36 //x=18.045 //y=5.39 //x2=17.93 //y2=5.39
r116 (  1 10 ) resistor r=0.0227762 //w=0.219 //l=0.12 //layer=m1 \
 //thickness=0.36 //x=18.69 //y=5.39 //x2=18.81 //y2=5.39
r117 (  1 2 ) resistor r=0.615458 //w=0.131 //l=0.645 //layer=m1 \
 //thickness=0.36 //x=18.69 //y=5.39 //x2=18.045 //y2=5.39
ends PM_DLATCH\%noxref_13

subckt PM_DLATCH\%noxref_14 ( 1 5 9 10 13 17 29 )
c66 ( 29 0 ) capacitor c=0.0668358f //x=3.27 //y=0.545
c67 ( 17 0 ) capacitor c=0.00709791f //x=5.345 //y=0.795
c68 ( 13 0 ) capacitor c=0.0155344f //x=5.26 //y=0.71
c69 ( 10 0 ) capacitor c=0.00890841f //x=4.375 //y=1.675
c70 ( 9 0 ) capacitor c=0.00770028f //x=4.375 //y=0.795
c71 ( 5 0 ) capacitor c=0.0231118f //x=4.29 //y=1.76
c72 ( 1 0 ) capacitor c=0.00852433f //x=3.405 //y=1.675
r73 (  17 29 ) resistor r=3.57586 //w=0.17 //l=0.125 //layer=li \
 //thickness=0.1 //x=5.345 //y=0.795 //x2=5.345 //y2=0.67
r74 (  17 29 ) resistor r=18.139 //w=0.187 //l=0.265 //layer=li \
 //thickness=0.1 //x=5.345 //y=0.795 //x2=5.345 //y2=1.06
r75 (  14 29 ) resistor r=3.57586 //w=0.17 //l=0.103078 //layer=li \
 //thickness=0.1 //x=4.46 //y=0.71 //x2=4.375 //y2=0.67
r76 (  14 29 ) resistor r=27.3797 //w=0.187 //l=0.4 //layer=li //thickness=0.1 \
 //x=4.46 //y=0.71 //x2=4.86 //y2=0.71
r77 (  13 29 ) resistor r=3.57586 //w=0.17 //l=0.103078 //layer=li \
 //thickness=0.1 //x=5.26 //y=0.71 //x2=5.345 //y2=0.67
r78 (  13 29 ) resistor r=27.3797 //w=0.187 //l=0.4 //layer=li //thickness=0.1 \
 //x=5.26 //y=0.71 //x2=4.86 //y2=0.71
r79 (  10 29 ) resistor r=3.57586 //w=0.17 //l=0.125 //layer=li \
 //thickness=0.1 //x=4.375 //y=1.675 //x2=4.375 //y2=1.8
r80 (  10 29 ) resistor r=42.0963 //w=0.187 //l=0.615 //layer=li \
 //thickness=0.1 //x=4.375 //y=1.675 //x2=4.375 //y2=1.06
r81 (  9 29 ) resistor r=3.57586 //w=0.17 //l=0.125 //layer=li //thickness=0.1 \
 //x=4.375 //y=0.795 //x2=4.375 //y2=0.67
r82 (  9 29 ) resistor r=18.139 //w=0.187 //l=0.265 //layer=li //thickness=0.1 \
 //x=4.375 //y=0.795 //x2=4.375 //y2=1.06
r83 (  6 29 ) resistor r=3.57586 //w=0.17 //l=0.103078 //layer=li \
 //thickness=0.1 //x=3.49 //y=1.76 //x2=3.405 //y2=1.8
r84 (  6 29 ) resistor r=27.3797 //w=0.187 //l=0.4 //layer=li //thickness=0.1 \
 //x=3.49 //y=1.76 //x2=3.89 //y2=1.76
r85 (  5 29 ) resistor r=3.57586 //w=0.17 //l=0.103078 //layer=li \
 //thickness=0.1 //x=4.29 //y=1.76 //x2=4.375 //y2=1.8
r86 (  5 29 ) resistor r=27.3797 //w=0.187 //l=0.4 //layer=li //thickness=0.1 \
 //x=4.29 //y=1.76 //x2=3.89 //y2=1.76
r87 (  1 29 ) resistor r=3.57586 //w=0.17 //l=0.125 //layer=li //thickness=0.1 \
 //x=3.405 //y=1.675 //x2=3.405 //y2=1.8
r88 (  1 29 ) resistor r=42.0963 //w=0.187 //l=0.615 //layer=li \
 //thickness=0.1 //x=3.405 //y=1.675 //x2=3.405 //y2=1.06
ends PM_DLATCH\%noxref_14

subckt PM_DLATCH\%noxref_15 ( 1 5 9 10 13 17 29 )
c66 ( 29 0 ) capacitor c=0.0668459f //x=8.82 //y=0.545
c67 ( 17 0 ) capacitor c=0.00709791f //x=10.895 //y=0.795
c68 ( 13 0 ) capacitor c=0.0157877f //x=10.81 //y=0.71
c69 ( 10 0 ) capacitor c=0.00743655f //x=9.925 //y=1.675
c70 ( 9 0 ) capacitor c=0.00770028f //x=9.925 //y=0.795
c71 ( 5 0 ) capacitor c=0.0195165f //x=9.84 //y=1.76
c72 ( 1 0 ) capacitor c=0.00806643f //x=8.955 //y=1.675
r73 (  17 29 ) resistor r=3.57586 //w=0.17 //l=0.125 //layer=li \
 //thickness=0.1 //x=10.895 //y=0.795 //x2=10.895 //y2=0.67
r74 (  17 29 ) resistor r=18.139 //w=0.187 //l=0.265 //layer=li \
 //thickness=0.1 //x=10.895 //y=0.795 //x2=10.895 //y2=1.06
r75 (  14 29 ) resistor r=3.57586 //w=0.17 //l=0.103078 //layer=li \
 //thickness=0.1 //x=10.01 //y=0.71 //x2=9.925 //y2=0.67
r76 (  14 29 ) resistor r=27.3797 //w=0.187 //l=0.4 //layer=li //thickness=0.1 \
 //x=10.01 //y=0.71 //x2=10.41 //y2=0.71
r77 (  13 29 ) resistor r=3.57586 //w=0.17 //l=0.103078 //layer=li \
 //thickness=0.1 //x=10.81 //y=0.71 //x2=10.895 //y2=0.67
r78 (  13 29 ) resistor r=27.3797 //w=0.187 //l=0.4 //layer=li //thickness=0.1 \
 //x=10.81 //y=0.71 //x2=10.41 //y2=0.71
r79 (  10 29 ) resistor r=3.57586 //w=0.17 //l=0.125 //layer=li \
 //thickness=0.1 //x=9.925 //y=1.675 //x2=9.925 //y2=1.8
r80 (  10 29 ) resistor r=42.0963 //w=0.187 //l=0.615 //layer=li \
 //thickness=0.1 //x=9.925 //y=1.675 //x2=9.925 //y2=1.06
r81 (  9 29 ) resistor r=3.57586 //w=0.17 //l=0.125 //layer=li //thickness=0.1 \
 //x=9.925 //y=0.795 //x2=9.925 //y2=0.67
r82 (  9 29 ) resistor r=18.139 //w=0.187 //l=0.265 //layer=li //thickness=0.1 \
 //x=9.925 //y=0.795 //x2=9.925 //y2=1.06
r83 (  6 29 ) resistor r=3.57586 //w=0.17 //l=0.103078 //layer=li \
 //thickness=0.1 //x=9.04 //y=1.76 //x2=8.955 //y2=1.8
r84 (  6 29 ) resistor r=27.3797 //w=0.187 //l=0.4 //layer=li //thickness=0.1 \
 //x=9.04 //y=1.76 //x2=9.44 //y2=1.76
r85 (  5 29 ) resistor r=3.57586 //w=0.17 //l=0.103078 //layer=li \
 //thickness=0.1 //x=9.84 //y=1.76 //x2=9.925 //y2=1.8
r86 (  5 29 ) resistor r=27.3797 //w=0.187 //l=0.4 //layer=li //thickness=0.1 \
 //x=9.84 //y=1.76 //x2=9.44 //y2=1.76
r87 (  1 29 ) resistor r=3.57586 //w=0.17 //l=0.125 //layer=li //thickness=0.1 \
 //x=8.955 //y=1.675 //x2=8.955 //y2=1.8
r88 (  1 29 ) resistor r=42.0963 //w=0.187 //l=0.615 //layer=li \
 //thickness=0.1 //x=8.955 //y=1.675 //x2=8.955 //y2=1.06
ends PM_DLATCH\%noxref_15
