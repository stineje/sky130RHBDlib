// File: or2x1_pcell.spi
// Created: Thu Jan 22 07:16:06 2026
// Program "Calibre xRC"
// Version "v2023.2_27.15"
//
simulator lang=spectre
include "/import/yukari1/lrburle/sky130RHBDlib/sky130_rhbd/pex/or2x1_pcell.pex.spice"
subckt or2x1_pcell (  )
//
M0_noxref ( N_noxref_1_M0_noxref_d N_noxref_4_M0_noxref_g \
 N_noxref_2_M0_noxref_s noxref_78 ) NMOS l=0.163346 w=2.31104 m=1
M1_noxref ( N_noxref_1_M1_noxref_d N_noxref_6_M1_noxref_g \
 N_noxref_2_M0_noxref_s noxref_78 ) NMOS l=0.163129 w=2.31397 m=1
M2_noxref ( N_noxref_7_M2_noxref_d N_noxref_1_M2_noxref_g \
 N_noxref_2_M2_noxref_s noxref_78 ) NMOS l=0.163346 w=2.31104 m=1
M3_noxref ( N_noxref_5_M3_noxref_d N_noxref_4_M3_noxref_g \
 N_noxref_3_M3_noxref_s noxref_76 ) PMOS l=0.15 w=2 ad=0.57 as=0.57 pd=2.57 \
 ps=2.57 nrd=0 nrs=0 m=1
M4_noxref ( N_noxref_3_M4_noxref_d N_noxref_4_M4_noxref_g \
 N_noxref_5_M3_noxref_d noxref_76 ) PMOS l=0.15 w=2 ad=0.58 as=0.58 pd=2.58 \
 ps=2.58 nrd=0 nrs=0 m=1
M5_noxref ( N_noxref_1_M5_noxref_d N_noxref_6_M5_noxref_g \
 N_noxref_3_M4_noxref_d noxref_76 ) PMOS l=0.15 w=2 ad=0.58 as=0.58 pd=2.58 \
 ps=2.58 nrd=0 nrs=0 m=1
M6_noxref ( N_noxref_3_M6_noxref_d N_noxref_6_M6_noxref_g \
 N_noxref_1_M5_noxref_d noxref_76 ) PMOS l=0.15 w=2 ad=0.56 as=0.56 pd=2.56 \
 ps=2.56 nrd=0 nrs=0 m=1
M7_noxref ( N_noxref_7_M7_noxref_d N_noxref_1_M7_noxref_g \
 N_noxref_5_M7_noxref_s noxref_76 ) PMOS l=0.15 w=2 ad=0.57 as=0.57 pd=2.57 \
 ps=2.57 nrd=0 nrs=0 m=1
M8_noxref ( N_noxref_5_M8_noxref_d N_noxref_1_M8_noxref_g \
 N_noxref_7_M7_noxref_d noxref_76 ) PMOS l=0.15 w=2 ad=0.56 as=0.56 pd=2.56 \
 ps=2.56 nrd=0 nrs=0 m=1
//
include "/import/yukari1/lrburle/sky130RHBDlib/sky130_rhbd/pex/or2x1_pcell.pxi.spice"
//
ends OR2X1_PCELL
//
//
