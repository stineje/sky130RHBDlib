// File: NOR2X1.spi.pex
// Created: Tue Apr 29 10:43:38 2025
// Program "Calibre xRC"
// Version "v2023.2_27.15"
// Nominal Temperature: 30C
// Circuit Temperature: 30C
//
simulator lang=spectre
subckt PM_NOR2X1\%GND ( 1 9 21 25 33 37 49 59 70 )
c37 ( 70 0 ) capacitor c=0.0747061f //x=1.05 //y=0.545
c38 ( 59 0 ) capacitor c=0.29045f //x=3.125 //y=0.175
c39 ( 49 0 ) capacitor c=0.221616f //x=1.185 //y=0.175
c40 ( 40 0 ) capacitor c=0.00609805f //x=3.125 //y=0.625
c41 ( 37 0 ) capacitor c=0.00510321f //x=3.04 //y=0.71
c42 ( 36 0 ) capacitor c=0.00468234f //x=2.64 //y=0.625
c43 ( 33 0 ) capacitor c=0.00556167f //x=2.555 //y=0.71
c44 ( 28 0 ) capacitor c=0.00468234f //x=2.155 //y=0.625
c45 ( 25 0 ) capacitor c=0.00556167f //x=2.07 //y=0.71
c46 ( 24 0 ) capacitor c=0.00468234f //x=1.67 //y=0.625
c47 ( 21 0 ) capacitor c=0.00709098f //x=1.585 //y=0.71
c48 ( 16 0 ) capacitor c=0.00609805f //x=1.185 //y=0.625
c49 ( 9 0 ) capacitor c=0.184851f //x=3.08 //y=0.18
r50 (  58 59 ) resistor r=1.56948 //w=0.367 //l=0.045 //layer=li \
 //thickness=0.1 //x=3.08 //y=0.175 //x2=3.125 //y2=0.175
r51 (  56 58 ) resistor r=15.346 //w=0.367 //l=0.44 //layer=li //thickness=0.1 \
 //x=2.64 //y=0.175 //x2=3.08 //y2=0.175
r52 (  55 56 ) resistor r=10.4632 //w=0.367 //l=0.3 //layer=li //thickness=0.1 \
 //x=2.34 //y=0.175 //x2=2.64 //y2=0.175
r53 (  53 55 ) resistor r=6.45232 //w=0.367 //l=0.185 //layer=li \
 //thickness=0.1 //x=2.155 //y=0.175 //x2=2.34 //y2=0.175
r54 (  52 53 ) resistor r=16.9155 //w=0.367 //l=0.485 //layer=li \
 //thickness=0.1 //x=1.67 //y=0.175 //x2=2.155 //y2=0.175
r55 (  51 52 ) resistor r=15.346 //w=0.367 //l=0.44 //layer=li //thickness=0.1 \
 //x=1.23 //y=0.175 //x2=1.67 //y2=0.175
r56 (  49 51 ) resistor r=1.56948 //w=0.367 //l=0.045 //layer=li \
 //thickness=0.1 //x=1.185 //y=0.175 //x2=1.23 //y2=0.175
r57 (  41 70 ) resistor r=5.4201 //w=0.17 //l=0.085 //layer=li //thickness=0.1 \
 //x=3.125 //y=0.795 //x2=3.125 //y2=0.71
r58 (  41 70 ) resistor r=18.139 //w=0.187 //l=0.265 //layer=li \
 //thickness=0.1 //x=3.125 //y=0.795 //x2=3.125 //y2=1.06
r59 (  40 70 ) resistor r=5.4201 //w=0.17 //l=0.085 //layer=li //thickness=0.1 \
 //x=3.125 //y=0.625 //x2=3.125 //y2=0.71
r60 (  39 59 ) resistor r=5.21862 //w=0.35 //l=0.175 //layer=li \
 //thickness=0.1 //x=3.125 //y=0.35 //x2=3.125 //y2=0.175
r61 (  39 40 ) resistor r=18.8235 //w=0.187 //l=0.275 //layer=li \
 //thickness=0.1 //x=3.125 //y=0.35 //x2=3.125 //y2=0.625
r62 (  38 70 ) resistor r=5.4201 //w=0.17 //l=0.085 //layer=li //thickness=0.1 \
 //x=2.725 //y=0.71 //x2=2.64 //y2=0.71
r63 (  37 70 ) resistor r=1.40859 //w=0.34 //l=0.085 //layer=li \
 //thickness=0.1 //x=3.04 //y=0.71 //x2=3.125 //y2=0.71
r64 (  37 38 ) resistor r=21.5615 //w=0.187 //l=0.315 //layer=li \
 //thickness=0.1 //x=3.04 //y=0.71 //x2=2.725 //y2=0.71
r65 (  36 70 ) resistor r=1.40859 //w=0.34 //l=0.085 //layer=li \
 //thickness=0.1 //x=2.64 //y=0.625 //x2=2.64 //y2=0.71
r66 (  35 56 ) resistor r=5.21862 //w=0.35 //l=0.175 //layer=li \
 //thickness=0.1 //x=2.64 //y=0.35 //x2=2.64 //y2=0.175
r67 (  35 36 ) resistor r=18.8235 //w=0.187 //l=0.275 //layer=li \
 //thickness=0.1 //x=2.64 //y=0.35 //x2=2.64 //y2=0.625
r68 (  34 70 ) resistor r=6.4 //w=0.17 //l=0.085 //layer=li //thickness=0.1 \
 //x=2.24 //y=0.71 //x2=2.155 //y2=0.71
r69 (  33 70 ) resistor r=5.4201 //w=0.17 //l=0.085 //layer=li //thickness=0.1 \
 //x=2.555 //y=0.71 //x2=2.64 //y2=0.71
r70 (  33 34 ) resistor r=21.5615 //w=0.187 //l=0.315 //layer=li \
 //thickness=0.1 //x=2.555 //y=0.71 //x2=2.24 //y2=0.71
r71 (  29 70 ) resistor r=6.4 //w=0.17 //l=0.085 //layer=li //thickness=0.1 \
 //x=2.155 //y=0.795 //x2=2.155 //y2=0.71
r72 (  29 70 ) resistor r=18.139 //w=0.187 //l=0.265 //layer=li \
 //thickness=0.1 //x=2.155 //y=0.795 //x2=2.155 //y2=1.06
r73 (  28 70 ) resistor r=6.4 //w=0.17 //l=0.085 //layer=li //thickness=0.1 \
 //x=2.155 //y=0.625 //x2=2.155 //y2=0.71
r74 (  27 53 ) resistor r=5.21862 //w=0.35 //l=0.175 //layer=li \
 //thickness=0.1 //x=2.155 //y=0.35 //x2=2.155 //y2=0.175
r75 (  27 28 ) resistor r=18.8235 //w=0.187 //l=0.275 //layer=li \
 //thickness=0.1 //x=2.155 //y=0.35 //x2=2.155 //y2=0.625
r76 (  26 70 ) resistor r=5.4201 //w=0.17 //l=0.085 //layer=li //thickness=0.1 \
 //x=1.755 //y=0.71 //x2=1.67 //y2=0.71
r77 (  25 70 ) resistor r=6.4 //w=0.17 //l=0.085 //layer=li //thickness=0.1 \
 //x=2.07 //y=0.71 //x2=2.155 //y2=0.71
r78 (  25 26 ) resistor r=21.5615 //w=0.187 //l=0.315 //layer=li \
 //thickness=0.1 //x=2.07 //y=0.71 //x2=1.755 //y2=0.71
r79 (  24 70 ) resistor r=1.40859 //w=0.34 //l=0.085 //layer=li \
 //thickness=0.1 //x=1.67 //y=0.625 //x2=1.67 //y2=0.71
r80 (  23 52 ) resistor r=5.21862 //w=0.35 //l=0.175 //layer=li \
 //thickness=0.1 //x=1.67 //y=0.35 //x2=1.67 //y2=0.175
r81 (  23 24 ) resistor r=18.8235 //w=0.187 //l=0.275 //layer=li \
 //thickness=0.1 //x=1.67 //y=0.35 //x2=1.67 //y2=0.625
r82 (  22 70 ) resistor r=1.40859 //w=0.34 //l=0.085 //layer=li \
 //thickness=0.1 //x=1.27 //y=0.71 //x2=1.185 //y2=0.71
r83 (  21 70 ) resistor r=5.4201 //w=0.17 //l=0.085 //layer=li //thickness=0.1 \
 //x=1.585 //y=0.71 //x2=1.67 //y2=0.71
r84 (  21 22 ) resistor r=21.5615 //w=0.187 //l=0.315 //layer=li \
 //thickness=0.1 //x=1.585 //y=0.71 //x2=1.27 //y2=0.71
r85 (  17 70 ) resistor r=5.4201 //w=0.17 //l=0.085 //layer=li //thickness=0.1 \
 //x=1.185 //y=0.795 //x2=1.185 //y2=0.71
r86 (  17 70 ) resistor r=41.4118 //w=0.187 //l=0.605 //layer=li \
 //thickness=0.1 //x=1.185 //y=0.795 //x2=1.185 //y2=1.4
r87 (  16 70 ) resistor r=5.4201 //w=0.17 //l=0.085 //layer=li //thickness=0.1 \
 //x=1.185 //y=0.625 //x2=1.185 //y2=0.71
r88 (  15 49 ) resistor r=5.21862 //w=0.35 //l=0.175 //layer=li \
 //thickness=0.1 //x=1.185 //y=0.35 //x2=1.185 //y2=0.175
r89 (  15 16 ) resistor r=18.8235 //w=0.187 //l=0.275 //layer=li \
 //thickness=0.1 //x=1.185 //y=0.35 //x2=1.185 //y2=0.625
r90 (  9 58 ) resistor r=4.65 //w=0.17 //l=0.34 //layer=mcon //count=2 \
 //x=3.08 //y=0.18 //x2=3.08 //y2=0.18
r91 (  7 55 ) resistor r=3.1 //w=0.17 //l=0.51 //layer=mcon //count=3 //x=2.34 \
 //y=0.18 //x2=2.34 //y2=0.18
r92 (  7 9 ) resistor r=0.297428 //w=0.311 //l=0.74 //layer=m1 \
 //thickness=0.36 //x=2.34 //y=0.175 //x2=3.08 //y2=0.175
r93 (  3 51 ) resistor r=3.1 //w=0.17 //l=0.51 //layer=mcon //count=3 //x=1.23 \
 //y=0.18 //x2=1.23 //y2=0.18
r94 (  1 7 ) resistor r=0.0743569 //w=0.311 //l=0.185 //layer=m1 \
 //thickness=0.36 //x=2.155 //y=0.175 //x2=2.34 //y2=0.175
r95 (  1 3 ) resistor r=0.371785 //w=0.311 //l=0.925 //layer=m1 \
 //thickness=0.36 //x=2.155 //y=0.175 //x2=1.23 //y2=0.175
ends PM_NOR2X1\%GND

subckt PM_NOR2X1\%VDD ( 1 9 13 16 28 32 )
c36 ( 32 0 ) capacitor c=0.0256797f //x=1.575 //y=5.205
c37 ( 31 0 ) capacitor c=0.00597439f //x=1.72 //y=7.585
c38 ( 28 0 ) capacitor c=0.306462f //x=3.08 //y=7.58
c39 ( 16 0 ) capacitor c=0.228778f //x=1.23 //y=7.58
c40 ( 13 0 ) capacitor c=0.046953f //x=1.635 //y=7.585
c41 ( 9 0 ) capacitor c=0.186946f //x=3.08 //y=7.58
r42 (  26 28 ) resistor r=25.8093 //w=0.367 //l=0.74 //layer=li \
 //thickness=0.1 //x=2.34 //y=7.585 //x2=3.08 //y2=7.585
r43 (  24 31 ) resistor r=2.87058 //w=0.35 //l=0.085 //layer=li \
 //thickness=0.1 //x=1.805 //y=7.585 //x2=1.72 //y2=7.585
r44 (  24 26 ) resistor r=18.6594 //w=0.367 //l=0.535 //layer=li \
 //thickness=0.1 //x=1.805 //y=7.585 //x2=2.34 //y2=7.585
r45 (  17 31 ) resistor r=4.23183 //w=0.7 //l=0.175 //layer=li //thickness=0.1 \
 //x=1.72 //y=7.41 //x2=1.72 //y2=7.585
r46 (  17 32 ) resistor r=33.5401 //w=0.187 //l=0.49 //layer=li \
 //thickness=0.1 //x=1.72 //y=7.41 //x2=1.72 //y2=6.92
r47 (  13 31 ) resistor r=2.87058 //w=0.35 //l=0.085 //layer=li \
 //thickness=0.1 //x=1.635 //y=7.585 //x2=1.72 //y2=7.585
r48 (  13 16 ) resistor r=14.1253 //w=0.367 //l=0.405 //layer=li \
 //thickness=0.1 //x=1.635 //y=7.585 //x2=1.23 //y2=7.585
r49 (  9 28 ) resistor r=4.65 //w=0.17 //l=0.34 //layer=mcon //count=2 \
 //x=3.08 //y=7.58 //x2=3.08 //y2=7.58
r50 (  7 26 ) resistor r=3.1 //w=0.17 //l=0.51 //layer=mcon //count=3 //x=2.34 \
 //y=7.58 //x2=2.34 //y2=7.58
r51 (  7 9 ) resistor r=0.297428 //w=0.311 //l=0.74 //layer=m1 \
 //thickness=0.36 //x=2.34 //y=7.585 //x2=3.08 //y2=7.585
r52 (  3 16 ) resistor r=3.1 //w=0.17 //l=0.51 //layer=mcon //count=3 //x=1.23 \
 //y=7.58 //x2=1.23 //y2=7.58
r53 (  1 7 ) resistor r=0.0743569 //w=0.311 //l=0.185 //layer=m1 \
 //thickness=0.36 //x=2.155 //y=7.585 //x2=2.34 //y2=7.585
r54 (  1 3 ) resistor r=0.371785 //w=0.311 //l=0.925 //layer=m1 \
 //thickness=0.36 //x=2.155 //y=7.585 //x2=1.23 //y2=7.585
ends PM_NOR2X1\%VDD

subckt PM_NOR2X1\%A ( 1 2 3 4 5 6 7 10 20 22 23 24 25 26 27 28 32 34 37 39 40 \
 45 )
c65 ( 45 0 ) capacitor c=0.04214f //x=1.445 //y=4.885
c66 ( 40 0 ) capacitor c=0.0321911f //x=1.935 //y=1.43
c67 ( 39 0 ) capacitor c=0.0185201f //x=1.935 //y=1.085
c68 ( 37 0 ) capacitor c=0.0344254f //x=1.865 //y=4.975
c69 ( 34 0 ) capacitor c=0.0133656f //x=1.78 //y=1.585
c70 ( 32 0 ) capacitor c=0.0157804f //x=1.78 //y=0.93
c71 ( 28 0 ) capacitor c=0.0828832f //x=1.405 //y=2.095
c72 ( 27 0 ) capacitor c=0.022867f //x=1.405 //y=1.74
c73 ( 26 0 ) capacitor c=0.0234318f //x=1.405 //y=1.43
c74 ( 25 0 ) capacitor c=0.0192004f //x=1.405 //y=1.085
c75 ( 24 0 ) capacitor c=0.110795f //x=1.94 //y=6.205
c76 ( 23 0 ) capacitor c=0.153847f //x=1.5 //y=6.205
c77 ( 20 0 ) capacitor c=0.00995068f //x=1.445 //y=4.885
c78 ( 10 0 ) capacitor c=0.112895f //x=1.6 //y=2.26
r79 (  47 48 ) resistor r=32.4568 //w=0.214 //l=0.075 //layer=ply \
 //thickness=0.18 //x=1.445 //y=4.975 //x2=1.445 //y2=5.05
r80 (  45 47 ) resistor r=20.271 //w=0.214 //l=0.09 //layer=ply \
 //thickness=0.18 //x=1.445 //y=4.885 //x2=1.445 //y2=4.975
r81 (  40 54 ) resistor r=45.1352 //w=0.168 //l=0.173853 //layer=ply \
 //thickness=0.18 //x=1.935 //y=1.43 //x2=1.895 //y2=1.585
r82 (  39 53 ) resistor r=45.1352 //w=0.168 //l=0.173853 //layer=ply \
 //thickness=0.18 //x=1.935 //y=1.085 //x2=1.895 //y2=0.93
r83 (  39 40 ) resistor r=176.904 //w=0.094 //l=0.345 //layer=ply \
 //thickness=0.18 //x=1.935 //y=1.085 //x2=1.935 //y2=1.43
r84 (  38 47 ) resistor r=16.5046 //w=0.27 //l=0.135 //layer=ply \
 //thickness=0.18 //x=1.58 //y=4.975 //x2=1.445 //y2=4.975
r85 (  37 41 ) resistor r=26.9307 //w=0.15 //l=0.106066 //layer=ply \
 //thickness=0.18 //x=1.865 //y=4.975 //x2=1.94 //y2=5.05
r86 (  37 38 ) resistor r=146.138 //w=0.094 //l=0.285 //layer=ply \
 //thickness=0.18 //x=1.865 //y=4.975 //x2=1.58 //y2=4.975
r87 (  35 52 ) resistor r=10.701 //w=0.21 //l=0.115 //layer=ply \
 //thickness=0.18 //x=1.56 //y=1.585 //x2=1.445 //y2=1.585
r88 (  34 54 ) resistor r=5.52526 //w=0.168 //l=0.115 //layer=ply \
 //thickness=0.18 //x=1.78 //y=1.585 //x2=1.895 //y2=1.585
r89 (  33 51 ) resistor r=5.52526 //w=0.168 //l=0.115 //layer=ply \
 //thickness=0.18 //x=1.56 //y=0.93 //x2=1.445 //y2=0.93
r90 (  32 53 ) resistor r=5.52526 //w=0.168 //l=0.115 //layer=ply \
 //thickness=0.18 //x=1.78 //y=0.93 //x2=1.895 //y2=0.93
r91 (  32 33 ) resistor r=112.809 //w=0.094 //l=0.22 //layer=ply \
 //thickness=0.18 //x=1.78 //y=0.93 //x2=1.56 //y2=0.93
r92 (  28 50 ) resistor r=34.8111 //w=0.27 //l=0.264953 //layer=ply \
 //thickness=0.18 //x=1.405 //y=2.095 //x2=1.6 //y2=2.26
r93 (  27 52 ) resistor r=39.5823 //w=0.21 //l=0.173853 //layer=ply \
 //thickness=0.18 //x=1.405 //y=1.74 //x2=1.445 //y2=1.585
r94 (  27 28 ) resistor r=182.032 //w=0.094 //l=0.355 //layer=ply \
 //thickness=0.18 //x=1.405 //y=1.74 //x2=1.405 //y2=2.095
r95 (  26 52 ) resistor r=39.5823 //w=0.21 //l=0.173853 //layer=ply \
 //thickness=0.18 //x=1.405 //y=1.43 //x2=1.445 //y2=1.585
r96 (  25 51 ) resistor r=45.1352 //w=0.168 //l=0.173853 //layer=ply \
 //thickness=0.18 //x=1.405 //y=1.085 //x2=1.445 //y2=0.93
r97 (  25 26 ) resistor r=176.904 //w=0.094 //l=0.345 //layer=ply \
 //thickness=0.18 //x=1.405 //y=1.085 //x2=1.405 //y2=1.43
r98 (  24 41 ) resistor r=592.245 //w=0.094 //l=1.155 //layer=ply \
 //thickness=0.18 //x=1.94 //y=6.205 //x2=1.94 //y2=5.05
r99 (  23 48 ) resistor r=592.245 //w=0.094 //l=1.155 //layer=ply \
 //thickness=0.18 //x=1.5 //y=6.205 //x2=1.5 //y2=5.05
r100 (  22 34 ) resistor r=56.4043 //w=0.094 //l=0.11 //layer=ply \
 //thickness=0.18 //x=1.67 //y=1.585 //x2=1.78 //y2=1.585
r101 (  22 35 ) resistor r=56.4043 //w=0.094 //l=0.11 //layer=ply \
 //thickness=0.18 //x=1.67 //y=1.585 //x2=1.56 //y2=1.585
r102 (  20 45 ) resistor r=152 //w=0.17 //l=0.17 //layer=licon //count=1 \
 //x=1.445 //y=4.885 //x2=1.445 //y2=4.885
r103 (  20 21 ) resistor r=7.81102 //w=0.254 //l=0.155 //layer=li \
 //thickness=0.1 //x=1.445 //y=4.885 //x2=1.6 //y2=4.885
r104 (  10 50 ) resistor r=152 //w=0.17 //l=0.17 //layer=licon //count=1 \
 //x=1.6 //y=2.26 //x2=1.6 //y2=2.26
r105 (  8 21 ) resistor r=3.23951 //w=0.254 //l=0.165 //layer=li \
 //thickness=0.1 //x=1.6 //y=4.72 //x2=1.6 //y2=4.885
r106 (  7 8 ) resistor r=6.84492 //w=0.187 //l=0.1 //layer=li //thickness=0.1 \
 //x=1.6 //y=4.62 //x2=1.6 //y2=4.72
r107 (  6 7 ) resistor r=25.3262 //w=0.187 //l=0.37 //layer=li //thickness=0.1 \
 //x=1.6 //y=4.25 //x2=1.6 //y2=4.62
r108 (  5 6 ) resistor r=25.3262 //w=0.187 //l=0.37 //layer=li //thickness=0.1 \
 //x=1.6 //y=3.88 //x2=1.6 //y2=4.25
r109 (  4 5 ) resistor r=25.3262 //w=0.187 //l=0.37 //layer=li //thickness=0.1 \
 //x=1.6 //y=3.51 //x2=1.6 //y2=3.88
r110 (  3 4 ) resistor r=25.3262 //w=0.187 //l=0.37 //layer=li //thickness=0.1 \
 //x=1.6 //y=3.14 //x2=1.6 //y2=3.51
r111 (  2 3 ) resistor r=25.3262 //w=0.187 //l=0.37 //layer=li //thickness=0.1 \
 //x=1.6 //y=2.77 //x2=1.6 //y2=3.14
r112 (  1 2 ) resistor r=25.3262 //w=0.187 //l=0.37 //layer=li //thickness=0.1 \
 //x=1.6 //y=2.4 //x2=1.6 //y2=2.77
r113 (  1 10 ) resistor r=9.58289 //w=0.187 //l=0.14 //layer=li \
 //thickness=0.1 //x=1.6 //y=2.4 //x2=1.6 //y2=2.26
ends PM_NOR2X1\%A

subckt PM_NOR2X1\%B ( 1 2 3 4 5 6 7 8 10 21 22 23 24 25 26 31 33 35 41 42 44 \
 45 48 )
c66 ( 48 0 ) capacitor c=0.0369822f //x=2.375 //y=4.885
c67 ( 45 0 ) capacitor c=0.0279572f //x=2.34 //y=2.095
c68 ( 44 0 ) capacitor c=0.0422144f //x=2.34 //y=2.26
c69 ( 42 0 ) capacitor c=0.0237734f //x=2.905 //y=1.435
c70 ( 41 0 ) capacitor c=0.0191782f //x=2.905 //y=1.085
c71 ( 35 0 ) capacitor c=0.0346941f //x=2.75 //y=1.585
c72 ( 33 0 ) capacitor c=0.0157803f //x=2.75 //y=0.93
c73 ( 31 0 ) capacitor c=0.0359964f //x=2.745 //y=4.975
c74 ( 26 0 ) capacitor c=0.0199921f //x=2.375 //y=1.74
c75 ( 25 0 ) capacitor c=0.0169608f //x=2.375 //y=1.435
c76 ( 24 0 ) capacitor c=0.0185462f //x=2.375 //y=1.085
c77 ( 23 0 ) capacitor c=0.15325f //x=2.82 //y=6.205
c78 ( 22 0 ) capacitor c=0.110232f //x=2.38 //y=6.205
c79 ( 10 0 ) capacitor c=0.0818408f //x=2.34 //y=2.26
c80 ( 8 0 ) capacitor c=0.00521267f //x=2.34 //y=4.72
r81 (  50 51 ) resistor r=32.4568 //w=0.214 //l=0.075 //layer=ply \
 //thickness=0.18 //x=2.375 //y=4.975 //x2=2.375 //y2=5.05
r82 (  48 50 ) resistor r=20.271 //w=0.214 //l=0.09 //layer=ply \
 //thickness=0.18 //x=2.375 //y=4.885 //x2=2.375 //y2=4.975
r83 (  44 45 ) resistor r=52.7279 //w=0.214 //l=0.165 //layer=ply \
 //thickness=0.18 //x=2.34 //y=2.26 //x2=2.34 //y2=2.095
r84 (  42 55 ) resistor r=4.95774 //w=0.164 //l=0.112 //layer=ply \
 //thickness=0.18 //x=2.905 //y=1.435 //x2=2.905 //y2=1.547
r85 (  41 54 ) resistor r=45.1352 //w=0.168 //l=0.173853 //layer=ply \
 //thickness=0.18 //x=2.905 //y=1.085 //x2=2.865 //y2=0.93
r86 (  41 42 ) resistor r=179.468 //w=0.094 //l=0.35 //layer=ply \
 //thickness=0.18 //x=2.905 //y=1.085 //x2=2.905 //y2=1.435
r87 (  36 53 ) resistor r=10.8103 //w=0.211 //l=0.115 //layer=ply \
 //thickness=0.18 //x=2.53 //y=1.585 //x2=2.415 //y2=1.585
r88 (  35 55 ) resistor r=45.9962 //w=0.164 //l=0.17296 //layer=ply \
 //thickness=0.18 //x=2.75 //y=1.585 //x2=2.905 //y2=1.547
r89 (  34 52 ) resistor r=5.52526 //w=0.168 //l=0.115 //layer=ply \
 //thickness=0.18 //x=2.53 //y=0.93 //x2=2.415 //y2=0.93
r90 (  33 54 ) resistor r=5.52526 //w=0.168 //l=0.115 //layer=ply \
 //thickness=0.18 //x=2.75 //y=0.93 //x2=2.865 //y2=0.93
r91 (  33 34 ) resistor r=112.809 //w=0.094 //l=0.22 //layer=ply \
 //thickness=0.18 //x=2.75 //y=0.93 //x2=2.53 //y2=0.93
r92 (  32 50 ) resistor r=16.5046 //w=0.27 //l=0.135 //layer=ply \
 //thickness=0.18 //x=2.51 //y=4.975 //x2=2.375 //y2=4.975
r93 (  31 38 ) resistor r=26.9307 //w=0.15 //l=0.106066 //layer=ply \
 //thickness=0.18 //x=2.745 //y=4.975 //x2=2.82 //y2=5.05
r94 (  31 32 ) resistor r=120.5 //w=0.094 //l=0.235 //layer=ply \
 //thickness=0.18 //x=2.745 //y=4.975 //x2=2.51 //y2=4.975
r95 (  26 53 ) resistor r=39.5036 //w=0.211 //l=0.173853 //layer=ply \
 //thickness=0.18 //x=2.375 //y=1.74 //x2=2.415 //y2=1.585
r96 (  26 45 ) resistor r=182.032 //w=0.094 //l=0.355 //layer=ply \
 //thickness=0.18 //x=2.375 //y=1.74 //x2=2.375 //y2=2.095
r97 (  25 53 ) resistor r=38.3614 //w=0.211 //l=0.168819 //layer=ply \
 //thickness=0.18 //x=2.375 //y=1.435 //x2=2.415 //y2=1.585
r98 (  24 52 ) resistor r=45.1352 //w=0.168 //l=0.173853 //layer=ply \
 //thickness=0.18 //x=2.375 //y=1.085 //x2=2.415 //y2=0.93
r99 (  24 25 ) resistor r=179.468 //w=0.094 //l=0.35 //layer=ply \
 //thickness=0.18 //x=2.375 //y=1.085 //x2=2.375 //y2=1.435
r100 (  23 38 ) resistor r=592.245 //w=0.094 //l=1.155 //layer=ply \
 //thickness=0.18 //x=2.82 //y=6.205 //x2=2.82 //y2=5.05
r101 (  22 51 ) resistor r=592.245 //w=0.094 //l=1.155 //layer=ply \
 //thickness=0.18 //x=2.38 //y=6.205 //x2=2.38 //y2=5.05
r102 (  21 35 ) resistor r=56.4043 //w=0.094 //l=0.11 //layer=ply \
 //thickness=0.18 //x=2.64 //y=1.585 //x2=2.75 //y2=1.585
r103 (  21 36 ) resistor r=56.4043 //w=0.094 //l=0.11 //layer=ply \
 //thickness=0.18 //x=2.64 //y=1.585 //x2=2.53 //y2=1.585
r104 (  20 48 ) resistor r=152 //w=0.17 //l=0.17 //layer=licon //count=1 \
 //x=2.375 //y=4.885 //x2=2.375 //y2=4.885
r105 (  10 44 ) resistor r=152 //w=0.17 //l=0.17 //layer=licon //count=1 \
 //x=2.34 //y=2.26 //x2=2.34 //y2=2.26
r106 (  8 20 ) resistor r=11.332 //w=0.189 //l=0.173292 //layer=li \
 //thickness=0.1 //x=2.34 //y=4.72 //x2=2.357 //y2=4.885
r107 (  7 8 ) resistor r=6.84492 //w=0.187 //l=0.1 //layer=li //thickness=0.1 \
 //x=2.34 //y=4.62 //x2=2.34 //y2=4.72
r108 (  6 7 ) resistor r=25.3262 //w=0.187 //l=0.37 //layer=li //thickness=0.1 \
 //x=2.34 //y=4.25 //x2=2.34 //y2=4.62
r109 (  5 6 ) resistor r=25.3262 //w=0.187 //l=0.37 //layer=li //thickness=0.1 \
 //x=2.34 //y=3.88 //x2=2.34 //y2=4.25
r110 (  4 5 ) resistor r=25.3262 //w=0.187 //l=0.37 //layer=li //thickness=0.1 \
 //x=2.34 //y=3.51 //x2=2.34 //y2=3.88
r111 (  3 4 ) resistor r=25.3262 //w=0.187 //l=0.37 //layer=li //thickness=0.1 \
 //x=2.34 //y=3.14 //x2=2.34 //y2=3.51
r112 (  2 3 ) resistor r=25.3262 //w=0.187 //l=0.37 //layer=li //thickness=0.1 \
 //x=2.34 //y=2.77 //x2=2.34 //y2=3.14
r113 (  1 2 ) resistor r=25.3262 //w=0.187 //l=0.37 //layer=li //thickness=0.1 \
 //x=2.34 //y=2.4 //x2=2.34 //y2=2.77
r114 (  1 10 ) resistor r=9.58289 //w=0.187 //l=0.14 //layer=li \
 //thickness=0.1 //x=2.34 //y=2.4 //x2=2.34 //y2=2.26
ends PM_NOR2X1\%B

subckt PM_NOR2X1\%Y ( 1 2 3 4 5 6 7 12 13 24 25 26 38 39 42 )
c65 ( 42 0 ) capacitor c=0.0159573f //x=2.455 //y=5.205
c66 ( 39 0 ) capacitor c=0.00905936f //x=2.45 //y=1.085
c67 ( 38 0 ) capacitor c=0.007684f //x=1.48 //y=1.085
c68 ( 37 0 ) capacitor c=0.00710337f //x=2.64 //y=1.835
c69 ( 26 0 ) capacitor c=0.0169019f //x=2.995 //y=1.835
c70 ( 25 0 ) capacitor c=0.00499395f //x=2.685 //y=5.39
c71 ( 24 0 ) capacitor c=0.0164583f //x=2.995 //y=5.39
c72 ( 13 0 ) capacitor c=0.00277607f //x=1.755 //y=1.835
c73 ( 12 0 ) capacitor c=0.0280953f //x=2.555 //y=1.835
c74 ( 1 0 ) capacitor c=0.133888f //x=3.08 //y=2.4
r75 (  27 37 ) resistor r=5.4201 //w=0.17 //l=0.085 //layer=li //thickness=0.1 \
 //x=2.725 //y=1.835 //x2=2.64 //y2=1.835
r76 (  26 28 ) resistor r=7.15173 //w=0.17 //l=0.120208 //layer=li \
 //thickness=0.1 //x=2.995 //y=1.835 //x2=3.08 //y2=1.92
r77 (  26 27 ) resistor r=18.4813 //w=0.187 //l=0.27 //layer=li \
 //thickness=0.1 //x=2.995 //y=1.835 //x2=2.725 //y2=1.835
r78 (  24 29 ) resistor r=7.15173 //w=0.17 //l=0.120208 //layer=li \
 //thickness=0.1 //x=2.995 //y=5.39 //x2=3.08 //y2=5.305
r79 (  24 25 ) resistor r=21.2193 //w=0.187 //l=0.31 //layer=li \
 //thickness=0.1 //x=2.995 //y=5.39 //x2=2.685 //y2=5.39
r80 (  20 37 ) resistor r=1.40859 //w=0.34 //l=0.085 //layer=li \
 //thickness=0.1 //x=2.64 //y=1.75 //x2=2.64 //y2=1.835
r81 (  20 39 ) resistor r=39.016 //w=0.187 //l=0.57 //layer=li //thickness=0.1 \
 //x=2.64 //y=1.75 //x2=2.64 //y2=1.18
r82 (  14 25 ) resistor r=7.15173 //w=0.17 //l=0.120208 //layer=li \
 //thickness=0.1 //x=2.6 //y=5.475 //x2=2.685 //y2=5.39
r83 (  14 42 ) resistor r=29.0909 //w=0.187 //l=0.425 //layer=li \
 //thickness=0.1 //x=2.6 //y=5.475 //x2=2.6 //y2=5.9
r84 (  12 37 ) resistor r=5.4201 //w=0.17 //l=0.085 //layer=li //thickness=0.1 \
 //x=2.555 //y=1.835 //x2=2.64 //y2=1.835
r85 (  12 13 ) resistor r=54.7594 //w=0.187 //l=0.8 //layer=li //thickness=0.1 \
 //x=2.555 //y=1.835 //x2=1.755 //y2=1.835
r86 (  8 13 ) resistor r=7.15173 //w=0.17 //l=0.120208 //layer=li \
 //thickness=0.1 //x=1.67 //y=1.75 //x2=1.755 //y2=1.835
r87 (  8 38 ) resistor r=39.016 //w=0.187 //l=0.57 //layer=li //thickness=0.1 \
 //x=1.67 //y=1.75 //x2=1.67 //y2=1.18
r88 (  7 29 ) resistor r=46.8877 //w=0.187 //l=0.685 //layer=li \
 //thickness=0.1 //x=3.08 //y=4.62 //x2=3.08 //y2=5.305
r89 (  6 7 ) resistor r=25.3262 //w=0.187 //l=0.37 //layer=li //thickness=0.1 \
 //x=3.08 //y=4.25 //x2=3.08 //y2=4.62
r90 (  5 6 ) resistor r=25.3262 //w=0.187 //l=0.37 //layer=li //thickness=0.1 \
 //x=3.08 //y=3.88 //x2=3.08 //y2=4.25
r91 (  4 5 ) resistor r=25.3262 //w=0.187 //l=0.37 //layer=li //thickness=0.1 \
 //x=3.08 //y=3.51 //x2=3.08 //y2=3.88
r92 (  3 4 ) resistor r=25.3262 //w=0.187 //l=0.37 //layer=li //thickness=0.1 \
 //x=3.08 //y=3.14 //x2=3.08 //y2=3.51
r93 (  2 3 ) resistor r=25.3262 //w=0.187 //l=0.37 //layer=li //thickness=0.1 \
 //x=3.08 //y=2.77 //x2=3.08 //y2=3.14
r94 (  1 2 ) resistor r=25.3262 //w=0.187 //l=0.37 //layer=li //thickness=0.1 \
 //x=3.08 //y=2.4 //x2=3.08 //y2=2.77
r95 (  1 28 ) resistor r=32.8556 //w=0.187 //l=0.48 //layer=li //thickness=0.1 \
 //x=3.08 //y=2.4 //x2=3.08 //y2=1.92
ends PM_NOR2X1\%Y

subckt PM_NOR2X1\%noxref_6 ( 7 8 15 16 23 24 25 )
c37 ( 25 0 ) capacitor c=0.0308836f //x=2.895 //y=5.205
c38 ( 24 0 ) capacitor c=0.0185379f //x=2.015 //y=5.205
c39 ( 23 0 ) capacitor c=0.0409962f //x=1.145 //y=5.205
c40 ( 16 0 ) capacitor c=0.00193672f //x=2.245 //y=7.09
c41 ( 15 0 ) capacitor c=0.01354f //x=2.955 //y=7.09
c42 ( 8 0 ) capacitor c=0.00844339f //x=1.365 //y=5.39
c43 ( 7 0 ) capacitor c=0.0252644f //x=2.075 //y=5.39
r44 (  17 25 ) resistor r=5.81818 //w=0.187 //l=0.085 //layer=li \
 //thickness=0.1 //x=3.04 //y=7.005 //x2=3.04 //y2=6.92
r45 (  15 17 ) resistor r=7.15173 //w=0.17 //l=0.120208 //layer=li \
 //thickness=0.1 //x=2.955 //y=7.09 //x2=3.04 //y2=7.005
r46 (  15 16 ) resistor r=48.5989 //w=0.187 //l=0.71 //layer=li \
 //thickness=0.1 //x=2.955 //y=7.09 //x2=2.245 //y2=7.09
r47 (  10 16 ) resistor r=7.15173 //w=0.17 //l=0.120208 //layer=li \
 //thickness=0.1 //x=2.16 //y=7.005 //x2=2.245 //y2=7.09
r48 (  10 24 ) resistor r=29.0909 //w=0.187 //l=0.425 //layer=li \
 //thickness=0.1 //x=2.16 //y=7.005 //x2=2.16 //y2=6.58
r49 (  9 24 ) resistor r=29.0909 //w=0.187 //l=0.425 //layer=li \
 //thickness=0.1 //x=2.16 //y=5.475 //x2=2.16 //y2=5.9
r50 (  7 9 ) resistor r=7.15173 //w=0.17 //l=0.120208 //layer=li \
 //thickness=0.1 //x=2.075 //y=5.39 //x2=2.16 //y2=5.475
r51 (  7 8 ) resistor r=48.5989 //w=0.187 //l=0.71 //layer=li //thickness=0.1 \
 //x=2.075 //y=5.39 //x2=1.365 //y2=5.39
r52 (  1 8 ) resistor r=7.15173 //w=0.17 //l=0.120208 //layer=li \
 //thickness=0.1 //x=1.28 //y=5.475 //x2=1.365 //y2=5.39
r53 (  1 23 ) resistor r=29.0909 //w=0.187 //l=0.425 //layer=li \
 //thickness=0.1 //x=1.28 //y=5.475 //x2=1.28 //y2=5.9
ends PM_NOR2X1\%noxref_6
