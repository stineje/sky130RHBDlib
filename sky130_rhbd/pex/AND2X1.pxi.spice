// File: AND2X1.spi.AND2X1.pxi
// Created: Tue Apr 29 10:37:57 2025
//
simulator lang=spectre
x_PM_AND2X1\%GND ( GND N_GND_c_4_p N_GND_c_34_p N_GND_c_2_p N_GND_c_5_p \
 N_GND_c_6_p N_GND_c_60_p N_GND_c_7_p N_GND_c_23_p N_GND_c_1_p N_GND_c_3_p \
 N_GND_M0_noxref_d N_GND_M2_noxref_s )  PM_AND2X1\%GND
x_PM_AND2X1\%VDD ( VDD N_VDD_c_82_p N_VDD_c_88_p N_VDD_c_89_p N_VDD_c_102_p \
 N_VDD_c_79_n N_VDD_c_80_n N_VDD_c_81_n N_VDD_M3_noxref_s N_VDD_M4_noxref_d \
 N_VDD_M6_noxref_d N_VDD_M7_noxref_s N_VDD_M8_noxref_d )  PM_AND2X1\%VDD
x_PM_AND2X1\%noxref_3 ( N_noxref_3_c_149_n N_noxref_3_c_155_n \
 N_noxref_3_c_183_n N_noxref_3_c_187_n N_noxref_3_c_189_n N_noxref_3_c_156_n \
 N_noxref_3_c_250_p N_noxref_3_c_158_n N_noxref_3_c_159_n N_noxref_3_c_238_p \
 N_noxref_3_M2_noxref_g N_noxref_3_M7_noxref_g N_noxref_3_M8_noxref_g \
 N_noxref_3_c_164_n N_noxref_3_c_269_p N_noxref_3_c_270_p N_noxref_3_c_166_n \
 N_noxref_3_c_203_n N_noxref_3_c_204_n N_noxref_3_c_167_n N_noxref_3_c_261_p \
 N_noxref_3_c_168_n N_noxref_3_c_170_n N_noxref_3_c_171_n \
 N_noxref_3_M1_noxref_d N_noxref_3_M3_noxref_d N_noxref_3_M5_noxref_d )  \
 PM_AND2X1\%noxref_3
x_PM_AND2X1\%A ( A A A A A A A N_A_c_281_n N_A_M0_noxref_g N_A_M3_noxref_g \
 N_A_M4_noxref_g N_A_c_282_n N_A_c_284_n N_A_c_285_n N_A_c_286_n N_A_c_287_n \
 N_A_c_288_n N_A_c_289_n N_A_c_291_n N_A_c_299_n )  PM_AND2X1\%A
x_PM_AND2X1\%B ( B B B B B B B N_B_c_346_n N_B_c_337_n N_B_M1_noxref_g \
 N_B_M5_noxref_g N_B_M6_noxref_g N_B_c_355_n N_B_c_356_n N_B_c_357_n \
 N_B_c_358_n N_B_c_360_n N_B_c_361_n N_B_c_363_n N_B_c_364_n N_B_c_366_n \
 N_B_c_367_n N_B_c_369_n )  PM_AND2X1\%B
x_PM_AND2X1\%noxref_6 ( N_noxref_6_c_425_n N_noxref_6_c_401_n \
 N_noxref_6_c_405_n N_noxref_6_c_409_n N_noxref_6_c_410_n N_noxref_6_c_413_n \
 N_noxref_6_M0_noxref_s )  PM_AND2X1\%noxref_6
x_PM_AND2X1\%Y ( Y Y Y Y Y Y Y N_Y_c_452_n N_Y_c_476_n N_Y_c_462_n N_Y_c_465_n \
 N_Y_M2_noxref_d N_Y_M7_noxref_d )  PM_AND2X1\%Y
cc_1 ( N_GND_c_1_p N_VDD_c_79_n ) capacitor c=0.00989514f //x=5.67 //y=0.18 \
 //x2=5.67 //y2=7.58
cc_2 ( N_GND_c_2_p N_VDD_c_80_n ) capacitor c=0.00989514f //x=1.23 //y=0.18 \
 //x2=1.23 //y2=7.58
cc_3 ( N_GND_c_3_p N_VDD_c_81_n ) capacitor c=0.00856126f //x=3.82 //y=0.175 \
 //x2=3.82 //y2=7.585
cc_4 ( N_GND_c_4_p N_noxref_3_c_149_n ) capacitor c=0.0116248f //x=5.67 \
 //y=0.18 //x2=4.445 //y2=3.51
cc_5 ( N_GND_c_5_p N_noxref_3_c_149_n ) capacitor c=0.00157084f //x=3.65 \
 //y=0.175 //x2=4.445 //y2=3.51
cc_6 ( N_GND_c_6_p N_noxref_3_c_149_n ) capacitor c=0.00110287f //x=4.365 \
 //y=0.175 //x2=4.445 //y2=3.51
cc_7 ( N_GND_c_7_p N_noxref_3_c_149_n ) capacitor c=2.76195e-19 //x=4.85 \
 //y=0.715 //x2=4.445 //y2=3.51
cc_8 ( N_GND_c_3_p N_noxref_3_c_149_n ) capacitor c=0.00820859f //x=3.82 \
 //y=0.175 //x2=4.445 //y2=3.51
cc_9 ( N_GND_M2_noxref_s N_noxref_3_c_149_n ) capacitor c=0.00164589f \
 //x=4.315 //y=0.55 //x2=4.445 //y2=3.51
cc_10 ( N_GND_c_4_p N_noxref_3_c_155_n ) capacitor c=0.00174433f //x=5.67 \
 //y=0.18 //x2=3.195 //y2=3.51
cc_11 ( N_GND_c_3_p N_noxref_3_c_156_n ) capacitor c=0.0461206f //x=3.82 \
 //y=0.175 //x2=2.995 //y2=1.835
cc_12 ( N_GND_M2_noxref_s N_noxref_3_c_156_n ) capacitor c=3.37896e-19 \
 //x=4.315 //y=0.55 //x2=2.995 //y2=1.835
cc_13 ( N_GND_c_2_p N_noxref_3_c_158_n ) capacitor c=0.00101801f //x=1.23 \
 //y=0.18 //x2=3.08 //y2=3.51
cc_14 ( N_GND_c_4_p N_noxref_3_c_159_n ) capacitor c=0.00184912f //x=5.67 \
 //y=0.18 //x2=4.56 //y2=2.265
cc_15 ( N_GND_c_7_p N_noxref_3_c_159_n ) capacitor c=7.87839e-19 //x=4.85 \
 //y=0.715 //x2=4.56 //y2=2.265
cc_16 ( N_GND_c_1_p N_noxref_3_c_159_n ) capacitor c=0.00118981f //x=5.67 \
 //y=0.18 //x2=4.56 //y2=2.265
cc_17 ( N_GND_c_3_p N_noxref_3_c_159_n ) capacitor c=0.029021f //x=3.82 \
 //y=0.175 //x2=4.56 //y2=2.265
cc_18 ( N_GND_M2_noxref_s N_noxref_3_c_159_n ) capacitor c=0.0108553f \
 //x=4.315 //y=0.55 //x2=4.56 //y2=2.265
cc_19 ( N_GND_c_7_p N_noxref_3_c_164_n ) capacitor c=0.0121786f //x=4.85 \
 //y=0.715 //x2=4.67 //y2=1.09
cc_20 ( N_GND_M2_noxref_s N_noxref_3_c_164_n ) capacitor c=0.0317689f \
 //x=4.315 //y=0.55 //x2=4.67 //y2=1.09
cc_21 ( N_GND_c_3_p N_noxref_3_c_166_n ) capacitor c=0.00562003f //x=3.82 \
 //y=0.175 //x2=4.67 //y2=2.1
cc_22 ( N_GND_M2_noxref_s N_noxref_3_c_167_n ) capacitor c=0.00483567f \
 //x=4.315 //y=0.55 //x2=5.045 //y2=0.935
cc_23 ( N_GND_c_23_p N_noxref_3_c_168_n ) capacitor c=0.0118631f //x=5.335 \
 //y=0.715 //x2=5.2 //y2=1.09
cc_24 ( N_GND_M2_noxref_s N_noxref_3_c_168_n ) capacitor c=0.0143355f \
 //x=4.315 //y=0.55 //x2=5.2 //y2=1.09
cc_25 ( N_GND_M2_noxref_s N_noxref_3_c_170_n ) capacitor c=0.0074042f \
 //x=4.315 //y=0.55 //x2=5.2 //y2=1.435
cc_26 ( N_GND_c_7_p N_noxref_3_c_171_n ) capacitor c=2.1838e-19 //x=4.85 \
 //y=0.715 //x2=4.56 //y2=2.265
cc_27 ( N_GND_c_3_p N_noxref_3_c_171_n ) capacitor c=0.0108179f //x=3.82 \
 //y=0.175 //x2=4.56 //y2=2.265
cc_28 ( N_GND_M2_noxref_s N_noxref_3_c_171_n ) capacitor c=0.006558f //x=4.315 \
 //y=0.55 //x2=4.56 //y2=2.265
cc_29 ( N_GND_c_2_p N_noxref_3_M1_noxref_d ) capacitor c=8.58106e-19 //x=1.23 \
 //y=0.18 //x2=2.45 //y2=1.085
cc_30 ( N_GND_c_3_p N_noxref_3_M1_noxref_d ) capacitor c=0.00616547f //x=3.82 \
 //y=0.175 //x2=2.45 //y2=1.085
cc_31 ( N_GND_M0_noxref_d N_noxref_3_M1_noxref_d ) capacitor c=0.00143464f \
 //x=1.48 //y=1.045 //x2=2.45 //y2=1.085
cc_32 ( N_GND_M2_noxref_s N_noxref_3_M1_noxref_d ) capacitor c=2.09402e-19 \
 //x=4.315 //y=0.55 //x2=2.45 //y2=1.085
cc_33 ( N_GND_c_2_p N_A_c_281_n ) capacitor c=0.0180518f //x=1.23 //y=0.18 \
 //x2=1.6 //y2=2.26
cc_34 ( N_GND_c_34_p N_A_c_282_n ) capacitor c=0.00135783f //x=1.585 //y=0.175 \
 //x2=1.405 //y2=1.045
cc_35 ( N_GND_M0_noxref_d N_A_c_282_n ) capacitor c=0.00220047f //x=1.48 \
 //y=1.045 //x2=1.405 //y2=1.045
cc_36 ( N_GND_M0_noxref_d N_A_c_284_n ) capacitor c=0.00255985f //x=1.48 \
 //y=1.045 //x2=1.405 //y2=1.39
cc_37 ( N_GND_c_2_p N_A_c_285_n ) capacitor c=0.00264481f //x=1.23 //y=0.18 \
 //x2=1.405 //y2=1.7
cc_38 ( N_GND_c_2_p N_A_c_286_n ) capacitor c=0.0121947f //x=1.23 //y=0.18 \
 //x2=1.405 //y2=2.095
cc_39 ( N_GND_M0_noxref_d N_A_c_287_n ) capacitor c=0.0131374f //x=1.48 \
 //y=1.045 //x2=1.78 //y2=0.89
cc_40 ( N_GND_M0_noxref_d N_A_c_288_n ) capacitor c=0.00193146f //x=1.48 \
 //y=1.045 //x2=1.78 //y2=1.545
cc_41 ( N_GND_c_5_p N_A_c_289_n ) capacitor c=0.00131234f //x=3.65 //y=0.175 \
 //x2=1.935 //y2=1.045
cc_42 ( N_GND_M0_noxref_d N_A_c_289_n ) capacitor c=0.00257848f //x=1.48 \
 //y=1.045 //x2=1.935 //y2=1.045
cc_43 ( N_GND_M0_noxref_d N_A_c_291_n ) capacitor c=0.00255985f //x=1.48 \
 //y=1.045 //x2=1.935 //y2=1.39
cc_44 ( N_GND_c_2_p N_B_c_337_n ) capacitor c=9.2064e-19 //x=1.23 //y=0.18 \
 //x2=2.34 //y2=2.26
cc_45 ( N_GND_c_3_p N_B_c_337_n ) capacitor c=9.53263e-19 //x=3.82 //y=0.175 \
 //x2=2.34 //y2=2.26
cc_46 ( N_GND_c_4_p N_noxref_6_c_401_n ) capacitor c=0.00711001f //x=5.67 \
 //y=0.18 //x2=2.07 //y2=1.76
cc_47 ( N_GND_c_34_p N_noxref_6_c_401_n ) capacitor c=0.00111556f //x=1.585 \
 //y=0.175 //x2=2.07 //y2=1.76
cc_48 ( N_GND_c_5_p N_noxref_6_c_401_n ) capacitor c=0.00181083f //x=3.65 \
 //y=0.175 //x2=2.07 //y2=1.76
cc_49 ( N_GND_M0_noxref_d N_noxref_6_c_401_n ) capacitor c=0.00909955f \
 //x=1.48 //y=1.045 //x2=2.07 //y2=1.76
cc_50 ( N_GND_c_4_p N_noxref_6_c_405_n ) capacitor c=0.00724992f //x=5.67 \
 //y=0.18 //x2=2.155 //y2=0.795
cc_51 ( N_GND_c_5_p N_noxref_6_c_405_n ) capacitor c=0.014661f //x=3.65 \
 //y=0.175 //x2=2.155 //y2=0.795
cc_52 ( N_GND_c_1_p N_noxref_6_c_405_n ) capacitor c=0.00145873f //x=5.67 \
 //y=0.18 //x2=2.155 //y2=0.795
cc_53 ( N_GND_M0_noxref_d N_noxref_6_c_405_n ) capacitor c=0.033812f //x=1.48 \
 //y=1.045 //x2=2.155 //y2=0.795
cc_54 ( N_GND_c_2_p N_noxref_6_c_409_n ) capacitor c=2.91423e-19 //x=1.23 \
 //y=0.18 //x2=2.155 //y2=1.675
cc_55 ( N_GND_c_4_p N_noxref_6_c_410_n ) capacitor c=0.0182975f //x=5.67 \
 //y=0.18 //x2=3.04 //y2=0.71
cc_56 ( N_GND_c_5_p N_noxref_6_c_410_n ) capacitor c=0.0373555f //x=3.65 \
 //y=0.175 //x2=3.04 //y2=0.71
cc_57 ( N_GND_c_1_p N_noxref_6_c_410_n ) capacitor c=0.00198448f //x=5.67 \
 //y=0.18 //x2=3.04 //y2=0.71
cc_58 ( N_GND_c_4_p N_noxref_6_c_413_n ) capacitor c=0.00292583f //x=5.67 \
 //y=0.18 //x2=3.125 //y2=0.795
cc_59 ( N_GND_c_5_p N_noxref_6_c_413_n ) capacitor c=0.0148875f //x=3.65 \
 //y=0.175 //x2=3.125 //y2=0.795
cc_60 ( N_GND_c_60_p N_noxref_6_c_413_n ) capacitor c=9.77746e-19 //x=4.45 \
 //y=0.63 //x2=3.125 //y2=0.795
cc_61 ( N_GND_c_1_p N_noxref_6_c_413_n ) capacitor c=0.00145015f //x=5.67 \
 //y=0.18 //x2=3.125 //y2=0.795
cc_62 ( N_GND_c_3_p N_noxref_6_c_413_n ) capacitor c=0.0431718f //x=3.82 \
 //y=0.175 //x2=3.125 //y2=0.795
cc_63 ( N_GND_c_4_p N_noxref_6_M0_noxref_s ) capacitor c=0.00724992f //x=5.67 \
 //y=0.18 //x2=1.05 //y2=0.545
cc_64 ( N_GND_c_34_p N_noxref_6_M0_noxref_s ) capacitor c=0.014661f //x=1.585 \
 //y=0.175 //x2=1.05 //y2=0.545
cc_65 ( N_GND_c_2_p N_noxref_6_M0_noxref_s ) capacitor c=0.0594057f //x=1.23 \
 //y=0.18 //x2=1.05 //y2=0.545
cc_66 ( N_GND_c_1_p N_noxref_6_M0_noxref_s ) capacitor c=0.00145873f //x=5.67 \
 //y=0.18 //x2=1.05 //y2=0.545
cc_67 ( N_GND_c_3_p N_noxref_6_M0_noxref_s ) capacitor c=0.00198098f //x=3.82 \
 //y=0.175 //x2=1.05 //y2=0.545
cc_68 ( N_GND_M0_noxref_d N_noxref_6_M0_noxref_s ) capacitor c=0.0334197f \
 //x=1.48 //y=1.045 //x2=1.05 //y2=0.545
cc_69 ( N_GND_M2_noxref_s N_noxref_6_M0_noxref_s ) capacitor c=9.77746e-19 \
 //x=4.315 //y=0.55 //x2=1.05 //y2=0.545
cc_70 ( N_GND_c_3_p Y ) capacitor c=8.10282e-19 //x=3.82 //y=0.175 //x2=5.3 \
 //y2=2.4
cc_71 ( N_GND_c_4_p N_Y_c_452_n ) capacitor c=0.00181107f //x=5.67 //y=0.18 \
 //x2=5.215 //y2=2.26
cc_72 ( N_GND_c_1_p N_Y_c_452_n ) capacitor c=0.0301661f //x=5.67 //y=0.18 \
 //x2=5.215 //y2=2.26
cc_73 ( N_GND_M2_noxref_s N_Y_c_452_n ) capacitor c=0.0099963f //x=4.315 \
 //y=0.55 //x2=5.215 //y2=2.26
cc_74 ( N_GND_c_4_p N_Y_M2_noxref_d ) capacitor c=0.00194747f //x=5.67 \
 //y=0.18 //x2=4.745 //y2=1.09
cc_75 ( N_GND_c_7_p N_Y_M2_noxref_d ) capacitor c=0.014622f //x=4.85 //y=0.715 \
 //x2=4.745 //y2=1.09
cc_76 ( N_GND_c_1_p N_Y_M2_noxref_d ) capacitor c=0.00973758f //x=5.67 \
 //y=0.18 //x2=4.745 //y2=1.09
cc_77 ( N_GND_c_3_p N_Y_M2_noxref_d ) capacitor c=0.00924905f //x=3.82 \
 //y=0.175 //x2=4.745 //y2=1.09
cc_78 ( N_GND_M2_noxref_s N_Y_M2_noxref_d ) capacitor c=0.076995f //x=4.315 \
 //y=0.55 //x2=4.745 //y2=1.09
cc_79 ( N_VDD_c_82_p N_noxref_3_c_149_n ) capacitor c=0.00921913f //x=5.67 \
 //y=7.58 //x2=4.445 //y2=3.51
cc_80 ( N_VDD_c_81_n N_noxref_3_c_149_n ) capacitor c=0.00694659f //x=3.82 \
 //y=7.585 //x2=4.445 //y2=3.51
cc_81 ( N_VDD_M7_noxref_s N_noxref_3_c_149_n ) capacitor c=0.0010609f //x=4.36 \
 //y=5.2 //x2=4.445 //y2=3.51
cc_82 ( N_VDD_c_82_p N_noxref_3_c_155_n ) capacitor c=0.00162099f //x=5.67 \
 //y=7.58 //x2=3.195 //y2=3.51
cc_83 ( N_VDD_M6_noxref_d N_noxref_3_c_155_n ) capacitor c=3.30856e-19 \
 //x=2.895 //y=5.2 //x2=3.195 //y2=3.51
cc_84 ( N_VDD_c_82_p N_noxref_3_c_183_n ) capacitor c=0.00596577f //x=5.67 \
 //y=7.58 //x2=2.515 //y2=5.38
cc_85 ( N_VDD_c_88_p N_noxref_3_c_183_n ) capacitor c=4.34465e-19 //x=2.075 \
 //y=7.585 //x2=2.515 //y2=5.38
cc_86 ( N_VDD_c_89_p N_noxref_3_c_183_n ) capacitor c=4.34465e-19 //x=2.955 \
 //y=7.585 //x2=2.515 //y2=5.38
cc_87 ( N_VDD_M4_noxref_d N_noxref_3_c_183_n ) capacitor c=0.0131301f \
 //x=2.015 //y=5.2 //x2=2.515 //y2=5.38
cc_88 ( N_VDD_c_80_n N_noxref_3_c_187_n ) capacitor c=0.00989999f //x=1.23 \
 //y=7.58 //x2=1.805 //y2=5.38
cc_89 ( N_VDD_M3_noxref_s N_noxref_3_c_187_n ) capacitor c=0.087833f //x=1.145 \
 //y=5.2 //x2=1.805 //y2=5.38
cc_90 ( N_VDD_c_82_p N_noxref_3_c_189_n ) capacitor c=0.00362415f //x=5.67 \
 //y=7.58 //x2=2.995 //y2=5.38
cc_91 ( N_VDD_c_89_p N_noxref_3_c_189_n ) capacitor c=7.22416e-19 //x=2.955 \
 //y=7.585 //x2=2.995 //y2=5.38
cc_92 ( N_VDD_M6_noxref_d N_noxref_3_c_189_n ) capacitor c=0.0164743f \
 //x=2.895 //y=5.2 //x2=2.995 //y2=5.38
cc_93 ( N_VDD_c_80_n N_noxref_3_c_158_n ) capacitor c=0.00159771f //x=1.23 \
 //y=7.58 //x2=3.08 //y2=3.51
cc_94 ( N_VDD_c_81_n N_noxref_3_c_158_n ) capacitor c=0.0461201f //x=3.82 \
 //y=7.585 //x2=3.08 //y2=3.51
cc_95 ( N_VDD_c_82_p N_noxref_3_c_159_n ) capacitor c=0.00160062f //x=5.67 \
 //y=7.58 //x2=4.56 //y2=2.265
cc_96 ( N_VDD_c_79_n N_noxref_3_c_159_n ) capacitor c=0.00144809f //x=5.67 \
 //y=7.58 //x2=4.56 //y2=2.265
cc_97 ( N_VDD_c_81_n N_noxref_3_c_159_n ) capacitor c=0.0272885f //x=3.82 \
 //y=7.585 //x2=4.56 //y2=2.265
cc_98 ( N_VDD_M7_noxref_s N_noxref_3_c_159_n ) capacitor c=0.00971925f \
 //x=4.36 //y=5.2 //x2=4.56 //y2=2.265
cc_99 ( N_VDD_c_102_p N_noxref_3_M7_noxref_g ) capacitor c=0.00753931f \
 //x=5.29 //y=7.585 //x2=4.715 //y2=6.2
cc_100 ( N_VDD_c_81_n N_noxref_3_M7_noxref_g ) capacitor c=0.00895557f \
 //x=3.82 //y=7.585 //x2=4.715 //y2=6.2
cc_101 ( N_VDD_M7_noxref_s N_noxref_3_M7_noxref_g ) capacitor c=0.0528676f \
 //x=4.36 //y=5.2 //x2=4.715 //y2=6.2
cc_102 ( N_VDD_c_102_p N_noxref_3_M8_noxref_g ) capacitor c=0.00702238f \
 //x=5.29 //y=7.585 //x2=5.155 //y2=6.2
cc_103 ( N_VDD_M8_noxref_d N_noxref_3_M8_noxref_g ) capacitor c=0.0528676f \
 //x=5.23 //y=5.2 //x2=5.155 //y2=6.2
cc_104 ( N_VDD_c_79_n N_noxref_3_c_203_n ) capacitor c=0.0287802f //x=5.67 \
 //y=7.58 //x2=5.08 //y2=4.97
cc_105 ( N_VDD_c_81_n N_noxref_3_c_204_n ) capacitor c=0.011132f //x=3.82 \
 //y=7.585 //x2=4.79 //y2=4.97
cc_106 ( N_VDD_M7_noxref_s N_noxref_3_c_204_n ) capacitor c=0.0052728f \
 //x=4.36 //y=5.2 //x2=4.79 //y2=4.97
cc_107 ( N_VDD_c_82_p N_noxref_3_M3_noxref_d ) capacitor c=0.00707767f \
 //x=5.67 //y=7.58 //x2=1.575 //y2=5.2
cc_108 ( N_VDD_c_88_p N_noxref_3_M3_noxref_d ) capacitor c=0.0138506f \
 //x=2.075 //y=7.585 //x2=1.575 //y2=5.2
cc_109 ( N_VDD_c_79_n N_noxref_3_M3_noxref_d ) capacitor c=0.00135231f \
 //x=5.67 //y=7.58 //x2=1.575 //y2=5.2
cc_110 ( N_VDD_c_81_n N_noxref_3_M3_noxref_d ) capacitor c=6.94454e-19 \
 //x=3.82 //y=7.585 //x2=1.575 //y2=5.2
cc_111 ( N_VDD_M4_noxref_d N_noxref_3_M3_noxref_d ) capacitor c=0.0664752f \
 //x=2.015 //y=5.2 //x2=1.575 //y2=5.2
cc_112 ( N_VDD_c_82_p N_noxref_3_M5_noxref_d ) capacitor c=0.00707767f \
 //x=5.67 //y=7.58 //x2=2.455 //y2=5.2
cc_113 ( N_VDD_c_89_p N_noxref_3_M5_noxref_d ) capacitor c=0.0138783f \
 //x=2.955 //y=7.585 //x2=2.455 //y2=5.2
cc_114 ( N_VDD_c_79_n N_noxref_3_M5_noxref_d ) capacitor c=0.00135231f \
 //x=5.67 //y=7.58 //x2=2.455 //y2=5.2
cc_115 ( N_VDD_c_81_n N_noxref_3_M5_noxref_d ) capacitor c=0.0120541f //x=3.82 \
 //y=7.585 //x2=2.455 //y2=5.2
cc_116 ( N_VDD_M3_noxref_s N_noxref_3_M5_noxref_d ) capacitor c=0.00111971f \
 //x=1.145 //y=5.2 //x2=2.455 //y2=5.2
cc_117 ( N_VDD_M4_noxref_d N_noxref_3_M5_noxref_d ) capacitor c=0.0664752f \
 //x=2.015 //y=5.2 //x2=2.455 //y2=5.2
cc_118 ( N_VDD_M6_noxref_d N_noxref_3_M5_noxref_d ) capacitor c=0.0664752f \
 //x=2.895 //y=5.2 //x2=2.455 //y2=5.2
cc_119 ( N_VDD_M7_noxref_s N_noxref_3_M5_noxref_d ) capacitor c=5.1407e-19 \
 //x=4.36 //y=5.2 //x2=2.455 //y2=5.2
cc_120 ( N_VDD_c_82_p N_A_c_281_n ) capacitor c=0.00140336f //x=5.67 //y=7.58 \
 //x2=1.6 //y2=2.26
cc_121 ( N_VDD_c_88_p N_A_c_281_n ) capacitor c=2.64671e-19 //x=2.075 \
 //y=7.585 //x2=1.6 //y2=2.26
cc_122 ( N_VDD_c_80_n N_A_c_281_n ) capacitor c=0.016845f //x=1.23 //y=7.58 \
 //x2=1.6 //y2=2.26
cc_123 ( N_VDD_c_88_p N_A_M3_noxref_g ) capacitor c=0.00732332f //x=2.075 \
 //y=7.585 //x2=1.5 //y2=6.2
cc_124 ( N_VDD_M3_noxref_s N_A_M3_noxref_g ) capacitor c=0.054195f //x=1.145 \
 //y=5.2 //x2=1.5 //y2=6.2
cc_125 ( N_VDD_c_88_p N_A_M4_noxref_g ) capacitor c=0.00677553f //x=2.075 \
 //y=7.585 //x2=1.94 //y2=6.2
cc_126 ( N_VDD_M4_noxref_d N_A_M4_noxref_g ) capacitor c=0.015318f //x=2.015 \
 //y=5.2 //x2=1.94 //y2=6.2
cc_127 ( N_VDD_c_80_n N_A_c_299_n ) capacitor c=0.0292267f //x=1.23 //y=7.58 \
 //x2=1.6 //y2=4.88
cc_128 ( N_VDD_c_80_n N_B_c_337_n ) capacitor c=6.61004e-19 //x=1.23 //y=7.58 \
 //x2=2.34 //y2=2.26
cc_129 ( N_VDD_c_81_n N_B_c_337_n ) capacitor c=6.09526e-19 //x=3.82 //y=7.585 \
 //x2=2.34 //y2=2.26
cc_130 ( N_VDD_c_89_p N_B_M5_noxref_g ) capacitor c=0.00678607f //x=2.955 \
 //y=7.585 //x2=2.38 //y2=6.2
cc_131 ( N_VDD_M4_noxref_d N_B_M5_noxref_g ) capacitor c=0.015318f //x=2.015 \
 //y=5.2 //x2=2.38 //y2=6.2
cc_132 ( N_VDD_c_89_p N_B_M6_noxref_g ) capacitor c=0.00677553f //x=2.955 \
 //y=7.585 //x2=2.82 //y2=6.2
cc_133 ( N_VDD_c_81_n N_B_M6_noxref_g ) capacitor c=0.00904525f //x=3.82 \
 //y=7.585 //x2=2.82 //y2=6.2
cc_134 ( N_VDD_M6_noxref_d N_B_M6_noxref_g ) capacitor c=0.0430452f //x=2.895 \
 //y=5.2 //x2=2.82 //y2=6.2
cc_135 ( N_VDD_c_79_n Y ) capacitor c=0.0232778f //x=5.67 //y=7.58 //x2=5.3 \
 //y2=2.4
cc_136 ( N_VDD_c_81_n Y ) capacitor c=4.80934e-19 //x=3.82 //y=7.585 //x2=5.3 \
 //y2=2.4
cc_137 ( N_VDD_c_82_p N_Y_c_462_n ) capacitor c=0.00191195f //x=5.67 //y=7.58 \
 //x2=5.215 //y2=4.76
cc_138 ( N_VDD_c_102_p N_Y_c_462_n ) capacitor c=8.83313e-19 //x=5.29 \
 //y=7.585 //x2=5.215 //y2=4.76
cc_139 ( N_VDD_M8_noxref_d N_Y_c_462_n ) capacitor c=0.00641652f //x=5.23 \
 //y=5.2 //x2=5.215 //y2=4.76
cc_140 ( N_VDD_c_81_n N_Y_c_465_n ) capacitor c=0.017572f //x=3.82 //y=7.585 \
 //x2=5.02 //y2=4.76
cc_141 ( N_VDD_c_82_p N_Y_M7_noxref_d ) capacitor c=0.00710215f //x=5.67 \
 //y=7.58 //x2=4.79 //y2=5.2
cc_142 ( N_VDD_c_102_p N_Y_M7_noxref_d ) capacitor c=0.0139426f //x=5.29 \
 //y=7.585 //x2=4.79 //y2=5.2
cc_143 ( N_VDD_c_79_n N_Y_M7_noxref_d ) capacitor c=0.0219131f //x=5.67 \
 //y=7.58 //x2=4.79 //y2=5.2
cc_144 ( N_VDD_M7_noxref_s N_Y_M7_noxref_d ) capacitor c=0.0843065f //x=4.36 \
 //y=5.2 //x2=4.79 //y2=5.2
cc_145 ( N_VDD_M8_noxref_d N_Y_M7_noxref_d ) capacitor c=0.0832641f //x=5.23 \
 //y=5.2 //x2=4.79 //y2=5.2
cc_146 ( N_noxref_3_c_187_n N_A_c_281_n ) capacitor c=0.00569255f //x=1.805 \
 //y=5.38 //x2=1.6 //y2=2.26
cc_147 ( N_noxref_3_c_158_n N_A_c_281_n ) capacitor c=0.00407922f //x=3.08 \
 //y=3.51 //x2=1.6 //y2=2.26
cc_148 ( N_noxref_3_c_187_n N_A_M3_noxref_g ) capacitor c=0.0177326f //x=1.805 \
 //y=5.38 //x2=1.5 //y2=6.2
cc_149 ( N_noxref_3_c_183_n N_A_M4_noxref_g ) capacitor c=0.0203837f //x=2.515 \
 //y=5.38 //x2=1.94 //y2=6.2
cc_150 ( N_noxref_3_M3_noxref_d N_A_M4_noxref_g ) capacitor c=0.0173476f \
 //x=1.575 //y=5.2 //x2=1.94 //y2=6.2
cc_151 ( N_noxref_3_c_187_n N_A_c_299_n ) capacitor c=0.00571434f //x=1.805 \
 //y=5.38 //x2=1.6 //y2=4.88
cc_152 ( N_noxref_3_c_183_n N_B_c_346_n ) capacitor c=0.0130171f //x=2.515 \
 //y=5.38 //x2=2.34 //y2=4.715
cc_153 ( N_noxref_3_c_158_n N_B_c_346_n ) capacitor c=0.0101115f //x=3.08 \
 //y=3.51 //x2=2.34 //y2=4.715
cc_154 ( N_noxref_3_c_155_n N_B_c_337_n ) capacitor c=0.00717888f //x=3.195 \
 //y=3.51 //x2=2.34 //y2=2.26
cc_155 ( N_noxref_3_c_158_n N_B_c_337_n ) capacitor c=0.0813981f //x=3.08 \
 //y=3.51 //x2=2.34 //y2=2.26
cc_156 ( N_noxref_3_c_159_n N_B_c_337_n ) capacitor c=0.00126776f //x=4.56 \
 //y=2.265 //x2=2.34 //y2=2.26
cc_157 ( N_noxref_3_c_183_n N_B_M5_noxref_g ) capacitor c=0.0166421f //x=2.515 \
 //y=5.38 //x2=2.38 //y2=6.2
cc_158 ( N_noxref_3_M5_noxref_d N_B_M5_noxref_g ) capacitor c=0.0173476f \
 //x=2.455 //y=5.2 //x2=2.38 //y2=6.2
cc_159 ( N_noxref_3_c_189_n N_B_M6_noxref_g ) capacitor c=0.0223536f //x=2.995 \
 //y=5.38 //x2=2.82 //y2=6.2
cc_160 ( N_noxref_3_M5_noxref_d N_B_M6_noxref_g ) capacitor c=0.0179769f \
 //x=2.455 //y=5.2 //x2=2.82 //y2=6.2
cc_161 ( N_noxref_3_M1_noxref_d N_B_c_355_n ) capacitor c=0.00217566f //x=2.45 \
 //y=1.085 //x2=2.375 //y2=1.085
cc_162 ( N_noxref_3_M1_noxref_d N_B_c_356_n ) capacitor c=0.0034598f //x=2.45 \
 //y=1.085 //x2=2.375 //y2=1.43
cc_163 ( N_noxref_3_M1_noxref_d N_B_c_357_n ) capacitor c=0.0065582f //x=2.45 \
 //y=1.085 //x2=2.375 //y2=1.74
cc_164 ( N_noxref_3_c_158_n N_B_c_358_n ) capacitor c=0.0142673f //x=3.08 \
 //y=3.51 //x2=2.745 //y2=4.97
cc_165 ( N_noxref_3_c_238_p N_B_c_358_n ) capacitor c=0.00414324f //x=2.6 \
 //y=5.38 //x2=2.745 //y2=4.97
cc_166 ( N_noxref_3_M1_noxref_d N_B_c_360_n ) capacitor c=0.00241102f //x=2.45 \
 //y=1.085 //x2=2.75 //y2=0.93
cc_167 ( N_noxref_3_c_156_n N_B_c_361_n ) capacitor c=0.00359704f //x=2.995 \
 //y=1.835 //x2=2.75 //y2=1.585
cc_168 ( N_noxref_3_M1_noxref_d N_B_c_361_n ) capacitor c=0.0138845f //x=2.45 \
 //y=1.085 //x2=2.75 //y2=1.585
cc_169 ( N_noxref_3_M1_noxref_d N_B_c_363_n ) capacitor c=0.00132245f //x=2.45 \
 //y=1.085 //x2=2.905 //y2=1.085
cc_170 ( N_noxref_3_c_156_n N_B_c_364_n ) capacitor c=0.00457401f //x=2.995 \
 //y=1.835 //x2=2.905 //y2=1.43
cc_171 ( N_noxref_3_M1_noxref_d N_B_c_364_n ) capacitor c=0.00566463f //x=2.45 \
 //y=1.085 //x2=2.905 //y2=1.43
cc_172 ( N_noxref_3_c_158_n N_B_c_366_n ) capacitor c=0.00877984f //x=3.08 \
 //y=3.51 //x2=2.34 //y2=2.26
cc_173 ( N_noxref_3_c_158_n N_B_c_367_n ) capacitor c=0.00306024f //x=3.08 \
 //y=3.51 //x2=2.34 //y2=2.095
cc_174 ( N_noxref_3_M1_noxref_d N_B_c_367_n ) capacitor c=0.00660593f //x=2.45 \
 //y=1.085 //x2=2.34 //y2=2.095
cc_175 ( N_noxref_3_c_183_n N_B_c_369_n ) capacitor c=0.00344394f //x=2.515 \
 //y=5.38 //x2=2.37 //y2=4.88
cc_176 ( N_noxref_3_c_158_n N_B_c_369_n ) capacitor c=0.00533692f //x=3.08 \
 //y=3.51 //x2=2.37 //y2=4.88
cc_177 ( N_noxref_3_c_250_p N_noxref_6_c_425_n ) capacitor c=3.15806e-19 \
 //x=2.725 //y=1.835 //x2=1.185 //y2=1.675
cc_178 ( N_noxref_3_c_250_p N_noxref_6_c_409_n ) capacitor c=0.0201674f \
 //x=2.725 //y=1.835 //x2=2.155 //y2=1.675
cc_179 ( N_noxref_3_c_156_n N_noxref_6_c_410_n ) capacitor c=0.0046844f \
 //x=2.995 //y=1.835 //x2=3.04 //y2=0.71
cc_180 ( N_noxref_3_M1_noxref_d N_noxref_6_c_410_n ) capacitor c=0.0118355f \
 //x=2.45 //y=1.085 //x2=3.04 //y2=0.71
cc_181 ( N_noxref_3_c_155_n N_noxref_6_M0_noxref_s ) capacitor c=3.12455e-19 \
 //x=3.195 //y=3.51 //x2=1.05 //y2=0.545
cc_182 ( N_noxref_3_c_156_n N_noxref_6_M0_noxref_s ) capacitor c=0.0141735f \
 //x=2.995 //y=1.835 //x2=1.05 //y2=0.545
cc_183 ( N_noxref_3_M1_noxref_d N_noxref_6_M0_noxref_s ) capacitor \
 c=0.0437911f //x=2.45 //y=1.085 //x2=1.05 //y2=0.545
cc_184 ( N_noxref_3_c_149_n Y ) capacitor c=0.00582634f //x=4.445 //y=3.51 \
 //x2=5.3 //y2=2.4
cc_185 ( N_noxref_3_c_158_n Y ) capacitor c=0.00126776f //x=3.08 //y=3.51 \
 //x2=5.3 //y2=2.4
cc_186 ( N_noxref_3_c_159_n Y ) capacitor c=0.0711303f //x=4.56 //y=2.265 \
 //x2=5.3 //y2=2.4
cc_187 ( N_noxref_3_c_171_n Y ) capacitor c=8.49451e-19 //x=4.56 //y=2.265 \
 //x2=5.3 //y2=2.4
cc_188 ( N_noxref_3_c_261_p N_Y_c_452_n ) capacitor c=0.0023507f //x=5.045 \
 //y=1.59 //x2=5.215 //y2=2.26
cc_189 ( N_noxref_3_c_171_n N_Y_c_476_n ) capacitor c=0.0167852f //x=4.56 \
 //y=2.265 //x2=5.015 //y2=2.26
cc_190 ( N_noxref_3_c_203_n N_Y_c_462_n ) capacitor c=0.0101013f //x=5.08 \
 //y=4.97 //x2=5.215 //y2=4.76
cc_191 ( N_noxref_3_c_159_n N_Y_c_465_n ) capacitor c=0.0250789f //x=4.56 \
 //y=2.265 //x2=5.02 //y2=4.76
cc_192 ( N_noxref_3_c_204_n N_Y_c_465_n ) capacitor c=0.00962086f //x=4.79 \
 //y=4.97 //x2=5.02 //y2=4.76
cc_193 ( N_noxref_3_c_158_n N_Y_M2_noxref_d ) capacitor c=3.35192e-19 //x=3.08 \
 //y=3.51 //x2=4.745 //y2=1.09
cc_194 ( N_noxref_3_c_159_n N_Y_M2_noxref_d ) capacitor c=0.0175773f //x=4.56 \
 //y=2.265 //x2=4.745 //y2=1.09
cc_195 ( N_noxref_3_c_164_n N_Y_M2_noxref_d ) capacitor c=0.00218556f //x=4.67 \
 //y=1.09 //x2=4.745 //y2=1.09
cc_196 ( N_noxref_3_c_269_p N_Y_M2_noxref_d ) capacitor c=0.00347355f //x=4.67 \
 //y=1.435 //x2=4.745 //y2=1.09
cc_197 ( N_noxref_3_c_270_p N_Y_M2_noxref_d ) capacitor c=0.00742431f //x=4.67 \
 //y=1.745 //x2=4.745 //y2=1.09
cc_198 ( N_noxref_3_c_166_n N_Y_M2_noxref_d ) capacitor c=0.00957707f //x=4.67 \
 //y=2.1 //x2=4.745 //y2=1.09
cc_199 ( N_noxref_3_c_167_n N_Y_M2_noxref_d ) capacitor c=0.00220879f \
 //x=5.045 //y=0.935 //x2=4.745 //y2=1.09
cc_200 ( N_noxref_3_c_261_p N_Y_M2_noxref_d ) capacitor c=0.0138447f //x=5.045 \
 //y=1.59 //x2=4.745 //y2=1.09
cc_201 ( N_noxref_3_c_168_n N_Y_M2_noxref_d ) capacitor c=0.00218624f //x=5.2 \
 //y=1.09 //x2=4.745 //y2=1.09
cc_202 ( N_noxref_3_c_170_n N_Y_M2_noxref_d ) capacitor c=0.00601286f //x=5.2 \
 //y=1.435 //x2=4.745 //y2=1.09
cc_203 ( N_noxref_3_c_158_n N_Y_M7_noxref_d ) capacitor c=6.3502e-19 //x=3.08 \
 //y=3.51 //x2=4.79 //y2=5.2
cc_204 ( N_noxref_3_M7_noxref_g N_Y_M7_noxref_d ) capacitor c=0.0219309f \
 //x=4.715 //y=6.2 //x2=4.79 //y2=5.2
cc_205 ( N_noxref_3_M8_noxref_g N_Y_M7_noxref_d ) capacitor c=0.021902f \
 //x=5.155 //y=6.2 //x2=4.79 //y2=5.2
cc_206 ( N_noxref_3_c_203_n N_Y_M7_noxref_d ) capacitor c=0.0148755f //x=5.08 \
 //y=4.97 //x2=4.79 //y2=5.2
cc_207 ( N_noxref_3_c_204_n N_Y_M7_noxref_d ) capacitor c=0.00307344f //x=4.79 \
 //y=4.97 //x2=4.79 //y2=5.2
cc_208 ( N_A_c_281_n N_B_c_346_n ) capacitor c=0.00400249f //x=1.6 //y=2.26 \
 //x2=2.34 //y2=4.715
cc_209 ( N_A_c_299_n N_B_c_346_n ) capacitor c=0.00417994f //x=1.6 //y=4.88 \
 //x2=2.34 //y2=4.715
cc_210 ( N_A_c_281_n N_B_c_337_n ) capacitor c=0.0887263f //x=1.6 //y=2.26 \
 //x2=2.34 //y2=2.26
cc_211 ( N_A_c_286_n N_B_c_337_n ) capacitor c=0.00308814f //x=1.405 //y=2.095 \
 //x2=2.34 //y2=2.26
cc_212 ( N_A_M3_noxref_g N_B_M5_noxref_g ) capacitor c=0.0104611f //x=1.5 \
 //y=6.2 //x2=2.38 //y2=6.2
cc_213 ( N_A_M4_noxref_g N_B_M5_noxref_g ) capacitor c=0.106811f //x=1.94 \
 //y=6.2 //x2=2.38 //y2=6.2
cc_214 ( N_A_M4_noxref_g N_B_M6_noxref_g ) capacitor c=0.0100341f //x=1.94 \
 //y=6.2 //x2=2.82 //y2=6.2
cc_215 ( N_A_c_282_n N_B_c_355_n ) capacitor c=4.86506e-19 //x=1.405 //y=1.045 \
 //x2=2.375 //y2=1.085
cc_216 ( N_A_c_284_n N_B_c_355_n ) capacitor c=0.00152104f //x=1.405 //y=1.39 \
 //x2=2.375 //y2=1.085
cc_217 ( N_A_c_289_n N_B_c_355_n ) capacitor c=0.0151475f //x=1.935 //y=1.045 \
 //x2=2.375 //y2=1.085
cc_218 ( N_A_c_285_n N_B_c_356_n ) capacitor c=0.00109982f //x=1.405 //y=1.7 \
 //x2=2.375 //y2=1.43
cc_219 ( N_A_c_291_n N_B_c_356_n ) capacitor c=0.0111064f //x=1.935 //y=1.39 \
 //x2=2.375 //y2=1.43
cc_220 ( N_A_c_285_n N_B_c_357_n ) capacitor c=9.57794e-19 //x=1.405 //y=1.7 \
 //x2=2.375 //y2=1.74
cc_221 ( N_A_c_286_n N_B_c_357_n ) capacitor c=0.00662747f //x=1.405 //y=2.095 \
 //x2=2.375 //y2=1.74
cc_222 ( N_A_c_291_n N_B_c_357_n ) capacitor c=0.00862358f //x=1.935 //y=1.39 \
 //x2=2.375 //y2=1.74
cc_223 ( N_A_c_289_n N_B_c_363_n ) capacitor c=0.00124821f //x=1.935 //y=1.045 \
 //x2=2.905 //y2=1.085
cc_224 ( N_A_c_291_n N_B_c_364_n ) capacitor c=0.00200715f //x=1.935 //y=1.39 \
 //x2=2.905 //y2=1.43
cc_225 ( N_A_c_281_n N_B_c_366_n ) capacitor c=0.00307062f //x=1.6 //y=2.26 \
 //x2=2.34 //y2=2.26
cc_226 ( N_A_c_286_n N_B_c_366_n ) capacitor c=0.0179092f //x=1.405 //y=2.095 \
 //x2=2.34 //y2=2.26
cc_227 ( N_A_c_281_n N_B_c_369_n ) capacitor c=0.00344981f //x=1.6 //y=2.26 \
 //x2=2.37 //y2=4.88
cc_228 ( N_A_c_299_n N_B_c_369_n ) capacitor c=0.0293367f //x=1.6 //y=4.88 \
 //x2=2.37 //y2=4.88
cc_229 ( N_A_c_286_n N_noxref_6_c_425_n ) capacitor c=0.0034165f //x=1.405 \
 //y=2.095 //x2=1.185 //y2=1.675
cc_230 ( N_A_c_281_n N_noxref_6_c_401_n ) capacitor c=0.0118986f //x=1.6 \
 //y=2.26 //x2=2.07 //y2=1.76
cc_231 ( N_A_c_285_n N_noxref_6_c_401_n ) capacitor c=0.00703567f //x=1.405 \
 //y=1.7 //x2=2.07 //y2=1.76
cc_232 ( N_A_c_286_n N_noxref_6_c_401_n ) capacitor c=0.0216532f //x=1.405 \
 //y=2.095 //x2=2.07 //y2=1.76
cc_233 ( N_A_c_288_n N_noxref_6_c_401_n ) capacitor c=0.00780629f //x=1.78 \
 //y=1.545 //x2=2.07 //y2=1.76
cc_234 ( N_A_c_291_n N_noxref_6_c_401_n ) capacitor c=0.00339872f //x=1.935 \
 //y=1.39 //x2=2.07 //y2=1.76
cc_235 ( N_A_c_286_n N_noxref_6_c_409_n ) capacitor c=6.71402e-19 //x=1.405 \
 //y=2.095 //x2=2.155 //y2=1.675
cc_236 ( N_A_c_282_n N_noxref_6_M0_noxref_s ) capacitor c=0.0326577f //x=1.405 \
 //y=1.045 //x2=1.05 //y2=0.545
cc_237 ( N_A_c_285_n N_noxref_6_M0_noxref_s ) capacitor c=3.48408e-19 \
 //x=1.405 //y=1.7 //x2=1.05 //y2=0.545
cc_238 ( N_A_c_289_n N_noxref_6_M0_noxref_s ) capacitor c=0.0120759f //x=1.935 \
 //y=1.045 //x2=1.05 //y2=0.545
cc_239 ( N_B_c_357_n N_noxref_6_c_409_n ) capacitor c=0.00623646f //x=2.375 \
 //y=1.74 //x2=2.155 //y2=1.675
cc_240 ( N_B_c_366_n N_noxref_6_c_409_n ) capacitor c=0.00172768f //x=2.34 \
 //y=2.26 //x2=2.155 //y2=1.675
cc_241 ( N_B_c_337_n N_noxref_6_c_410_n ) capacitor c=0.00161845f //x=2.34 \
 //y=2.26 //x2=3.04 //y2=0.71
cc_242 ( N_B_c_355_n N_noxref_6_c_410_n ) capacitor c=0.0186143f //x=2.375 \
 //y=1.085 //x2=3.04 //y2=0.71
cc_243 ( N_B_c_363_n N_noxref_6_c_410_n ) capacitor c=0.00656458f //x=2.905 \
 //y=1.085 //x2=3.04 //y2=0.71
cc_244 ( N_B_c_366_n N_noxref_6_c_410_n ) capacitor c=2.1838e-19 //x=2.34 \
 //y=2.26 //x2=3.04 //y2=0.71
cc_245 ( N_B_c_355_n N_noxref_6_M0_noxref_s ) capacitor c=0.00623646f \
 //x=2.375 //y=1.085 //x2=1.05 //y2=0.545
cc_246 ( N_B_c_363_n N_noxref_6_M0_noxref_s ) capacitor c=0.0143002f //x=2.905 \
 //y=1.085 //x2=1.05 //y2=0.545
cc_247 ( N_B_c_364_n N_noxref_6_M0_noxref_s ) capacitor c=0.00290153f \
 //x=2.905 //y=1.43 //x2=1.05 //y2=0.545
