// File: DLATCHN.spi.pex
// Created: Thu Jan 22 07:05:53 2026
// Program "Calibre xRC"
// Version "v2023.2_27.15"
// Nominal Temperature: 30C
// Circuit Temperature: 30C
//
simulator lang=spectre
subckt PM_DLATCHN\%noxref_1 ( 2 4 5 6 7 8 10 11 12 14 15 18 25 29 31 34 35 42 \
 44 45 53 65 74 78 79 80 81 82 83 84 88 90 93 94 104 107 109 )
c230 ( 107 0 ) capacitor c=0.00875839f //x=3.635 //y=1.09
c231 ( 104 0 ) capacitor c=0.0646027f //x=6.04 //y=4.88
c232 ( 94 0 ) capacitor c=0.0318956f //x=6.375 //y=1.39
c233 ( 93 0 ) capacitor c=0.0186809f //x=6.375 //y=1.045
c234 ( 90 0 ) capacitor c=0.0141821f //x=6.22 //y=1.545
c235 ( 88 0 ) capacitor c=0.0158553f //x=6.22 //y=0.89
c236 ( 84 0 ) capacitor c=0.088055f //x=5.845 //y=2.095
c237 ( 83 0 ) capacitor c=0.0229235f //x=5.845 //y=1.7
c238 ( 82 0 ) capacitor c=0.0234359f //x=5.845 //y=1.39
c239 ( 81 0 ) capacitor c=0.0198759f //x=5.845 //y=1.045
c240 ( 80 0 ) capacitor c=0.110369f //x=6.38 //y=6.2
c241 ( 79 0 ) capacitor c=0.154619f //x=5.94 //y=6.2
c242 ( 74 0 ) capacitor c=8.13425e-19 //x=6.04 //y=4.88
c243 ( 65 0 ) capacitor c=7.85889e-19 //x=6.04 //y=2.26
c244 ( 53 0 ) capacitor c=0.0262345f //x=3.825 //y=5.56
c245 ( 45 0 ) capacitor c=0.0232965f //x=5.875 //y=3.865
c246 ( 44 0 ) capacitor c=8.85755e-19 //x=6.035 //y=3.865
c247 ( 42 0 ) capacitor c=6.24988e-19 //x=4.345 //y=3.865
c248 ( 35 0 ) capacitor c=0.0180986f //x=6.042 //y=4.74
c249 ( 34 0 ) capacitor c=0.00598864f //x=6.04 //y=4.88
c250 ( 31 0 ) capacitor c=0.00594127f //x=6.04 //y=2.26
c251 ( 29 0 ) capacitor c=0.0165932f //x=6.04 //y=3.88
c252 ( 25 0 ) capacitor c=0.0174551f //x=4.19 //y=3.88
c253 ( 18 0 ) capacitor c=0.0150311f //x=3.82 //y=1.185
c254 ( 15 0 ) capacitor c=0.0122411f //x=6.04 //y=4.025
c255 ( 14 0 ) capacitor c=0.0360003f //x=6.04 //y=3.705
c256 ( 12 0 ) capacitor c=0.0200433f //x=4.19 //y=5.055
c257 ( 11 0 ) capacitor c=0.0127484f //x=4.19 //y=4.025
c258 ( 10 0 ) capacitor c=0.042368f //x=4.19 //y=3.705
c259 ( 8 0 ) capacitor c=0.00475217f //x=3.91 //y=5.14
c260 ( 7 0 ) capacitor c=0.00726293f //x=4.105 //y=5.14
c261 ( 6 0 ) capacitor c=0.00650032f //x=3.905 //y=2.02
c262 ( 5 0 ) capacitor c=0.0122371f //x=4.105 //y=2.02
c263 ( 4 0 ) capacitor c=0.0107001f //x=3.825 //y=5.42
c264 ( 2 0 ) capacitor c=0.0123222f //x=3.82 //y=1.935
r265 (  102 104 ) resistor r=20.6867 //w=0.233 //l=0.1 //layer=ply \
 //thickness=0.18 //x=5.94 //y=4.88 //x2=6.04 //y2=4.88
r266 (  95 104 ) resistor r=70.3348 //w=0.233 //l=0.414367 //layer=ply \
 //thickness=0.18 //x=6.38 //y=5.045 //x2=6.04 //y2=4.88
r267 (  94 106 ) resistor r=45.1352 //w=0.168 //l=0.173853 //layer=ply \
 //thickness=0.18 //x=6.375 //y=1.39 //x2=6.335 //y2=1.545
r268 (  93 105 ) resistor r=45.1352 //w=0.168 //l=0.173853 //layer=ply \
 //thickness=0.18 //x=6.375 //y=1.045 //x2=6.335 //y2=0.89
r269 (  93 94 ) resistor r=176.904 //w=0.094 //l=0.345 //layer=ply \
 //thickness=0.18 //x=6.375 //y=1.045 //x2=6.375 //y2=1.39
r270 (  91 101 ) resistor r=10.701 //w=0.21 //l=0.115 //layer=ply \
 //thickness=0.18 //x=6 //y=1.545 //x2=5.885 //y2=1.545
r271 (  90 106 ) resistor r=5.52526 //w=0.168 //l=0.115 //layer=ply \
 //thickness=0.18 //x=6.22 //y=1.545 //x2=6.335 //y2=1.545
r272 (  89 100 ) resistor r=5.52526 //w=0.168 //l=0.115 //layer=ply \
 //thickness=0.18 //x=6 //y=0.89 //x2=5.885 //y2=0.89
r273 (  88 105 ) resistor r=5.52526 //w=0.168 //l=0.115 //layer=ply \
 //thickness=0.18 //x=6.22 //y=0.89 //x2=6.335 //y2=0.89
r274 (  88 89 ) resistor r=112.809 //w=0.094 //l=0.22 //layer=ply \
 //thickness=0.18 //x=6.22 //y=0.89 //x2=6 //y2=0.89
r275 (  85 102 ) resistor r=13.0941 //w=0.233 //l=0.165 //layer=ply \
 //thickness=0.18 //x=5.94 //y=5.045 //x2=5.94 //y2=4.88
r276 (  84 99 ) resistor r=34.8111 //w=0.27 //l=0.264953 //layer=ply \
 //thickness=0.18 //x=5.845 //y=2.095 //x2=6.04 //y2=2.26
r277 (  83 101 ) resistor r=39.5823 //w=0.21 //l=0.173853 //layer=ply \
 //thickness=0.18 //x=5.845 //y=1.7 //x2=5.885 //y2=1.545
r278 (  83 84 ) resistor r=202.543 //w=0.094 //l=0.395 //layer=ply \
 //thickness=0.18 //x=5.845 //y=1.7 //x2=5.845 //y2=2.095
r279 (  82 101 ) resistor r=39.5823 //w=0.21 //l=0.173853 //layer=ply \
 //thickness=0.18 //x=5.845 //y=1.39 //x2=5.885 //y2=1.545
r280 (  81 100 ) resistor r=45.1352 //w=0.168 //l=0.173853 //layer=ply \
 //thickness=0.18 //x=5.845 //y=1.045 //x2=5.885 //y2=0.89
r281 (  81 82 ) resistor r=176.904 //w=0.094 //l=0.345 //layer=ply \
 //thickness=0.18 //x=5.845 //y=1.045 //x2=5.845 //y2=1.39
r282 (  80 95 ) resistor r=592.245 //w=0.094 //l=1.155 //layer=ply \
 //thickness=0.18 //x=6.38 //y=6.2 //x2=6.38 //y2=5.045
r283 (  79 85 ) resistor r=592.245 //w=0.094 //l=1.155 //layer=ply \
 //thickness=0.18 //x=5.94 //y=6.2 //x2=5.94 //y2=5.045
r284 (  78 90 ) resistor r=56.4043 //w=0.094 //l=0.11 //layer=ply \
 //thickness=0.18 //x=6.11 //y=1.545 //x2=6.22 //y2=1.545
r285 (  78 91 ) resistor r=56.4043 //w=0.094 //l=0.11 //layer=ply \
 //thickness=0.18 //x=6.11 //y=1.545 //x2=6 //y2=1.545
r286 (  74 104 ) resistor r=152 //w=0.17 //l=0.17 //layer=licon //count=1 \
 //x=6.04 //y=4.88 //x2=6.04 //y2=4.88
r287 (  65 99 ) resistor r=152 //w=0.17 //l=0.17 //layer=licon //count=1 \
 //x=6.04 //y=2.26 //x2=6.04 //y2=2.26
r288 (  53 109 ) resistor r=23.615 //w=0.187 //l=0.345 //layer=li \
 //thickness=0.1 //x=3.825 //y=5.56 //x2=3.825 //y2=5.905
r289 (  44 45 ) resistor r=0.10734 //w=0.281 //l=0.16 //layer=m2 \
 //thickness=0.36 //x=6.035 //y=3.865 //x2=5.875 //y2=3.865
r290 (  42 45 ) resistor r=1.45992 //w=0.131 //l=1.53 //layer=m2 \
 //thickness=0.36 //x=4.345 //y=3.88 //x2=5.875 //y2=3.88
r291 (  40 42 ) resistor r=0.10734 //w=0.281 //l=0.16 //layer=m2 \
 //thickness=0.36 //x=4.185 //y=3.865 //x2=4.345 //y2=3.865
r292 (  34 74 ) resistor r=9.3 //w=0.17 //l=0.17 //layer=mcon //count=1 \
 //x=6.04 //y=4.88 //x2=6.04 //y2=4.88
r293 (  34 35 ) resistor r=0.103207 //w=0.196 //l=0.14 //layer=m1 \
 //thickness=0.36 //x=6.042 //y=4.88 //x2=6.042 //y2=4.74
r294 (  31 65 ) resistor r=9.3 //w=0.17 //l=0.17 //layer=mcon //count=1 \
 //x=6.04 //y=2.26 //x2=6.04 //y2=2.26
r295 (  27 44 ) resistor r=4.5 //w=0.15 //l=0.15 //layer=via1 //count=1 \
 //x=6.035 //y=3.865 //x2=6.035 //y2=3.865
r296 (  27 29 ) resistor r=0.00501337 //w=0.374 //l=0.015 //layer=m1 \
 //thickness=0.36 //x=5.985 //y=3.865 //x2=5.985 //y2=3.88
r297 (  23 40 ) resistor r=4.5 //w=0.15 //l=0.15 //layer=via1 //count=1 \
 //x=4.185 //y=3.865 //x2=4.185 //y2=3.865
r298 (  23 25 ) resistor r=0.00494723 //w=0.379 //l=0.015 //layer=m1 \
 //thickness=0.36 //x=4.24 //y=3.865 //x2=4.24 //y2=3.88
r299 (  21 53 ) resistor r=9.3 //w=0.17 //l=0.17 //layer=mcon //count=1 \
 //x=3.825 //y=5.56 //x2=3.825 //y2=5.56
r300 (  18 107 ) resistor r=9.3 //w=0.17 //l=0.17 //layer=mcon //count=1 \
 //x=3.82 //y=1.185 //x2=3.82 //y2=1.185
r301 (  15 29 ) resistor r=0.0860668 //w=0.374 //l=0.170294 //layer=m1 \
 //thickness=0.36 //x=6.04 //y=4.025 //x2=5.985 //y2=3.88
r302 (  15 35 ) resistor r=0.682252 //w=0.131 //l=0.715 //layer=m1 \
 //thickness=0.36 //x=6.04 //y=4.025 //x2=6.04 //y2=4.74
r303 (  14 27 ) resistor r=0.0910802 //w=0.374 //l=0.185472 //layer=m1 \
 //thickness=0.36 //x=6.04 //y=3.705 //x2=5.985 //y2=3.865
r304 (  13 31 ) resistor r=0.0933015 //w=0.201 //l=0.125 //layer=m1 \
 //thickness=0.36 //x=6.04 //y=2.385 //x2=6.04 //y2=2.26
r305 (  13 14 ) resistor r=1.25954 //w=0.131 //l=1.32 //layer=m1 \
 //thickness=0.36 //x=6.04 //y=2.385 //x2=6.04 //y2=3.705
r306 (  11 25 ) resistor r=0.0863342 //w=0.379 //l=0.168152 //layer=m1 \
 //thickness=0.36 //x=4.19 //y=4.025 //x2=4.24 //y2=3.88
r307 (  11 12 ) resistor r=0.982824 //w=0.131 //l=1.03 //layer=m1 \
 //thickness=0.36 //x=4.19 //y=4.025 //x2=4.19 //y2=5.055
r308 (  10 23 ) resistor r=0.0912814 //w=0.379 //l=0.183303 //layer=m1 \
 //thickness=0.36 //x=4.19 //y=3.705 //x2=4.24 //y2=3.865
r309 (  9 10 ) resistor r=1.52672 //w=0.131 //l=1.6 //layer=m1 \
 //thickness=0.36 //x=4.19 //y=2.105 //x2=4.19 //y2=3.705
r310 (  7 12 ) resistor r=0.0698411 //w=0.17 //l=0.120208 //layer=m1 \
 //thickness=0.36 //x=4.105 //y=5.14 //x2=4.19 //y2=5.055
r311 (  7 8 ) resistor r=0.186069 //w=0.131 //l=0.195 //layer=m1 \
 //thickness=0.36 //x=4.105 //y=5.14 //x2=3.91 //y2=5.14
r312 (  5 9 ) resistor r=0.0698411 //w=0.17 //l=0.120208 //layer=m1 \
 //thickness=0.36 //x=4.105 //y=2.02 //x2=4.19 //y2=2.105
r313 (  5 6 ) resistor r=0.19084 //w=0.131 //l=0.2 //layer=m1 //thickness=0.36 \
 //x=4.105 //y=2.02 //x2=3.905 //y2=2.02
r314 (  4 21 ) resistor r=0.086672 //w=0.218 //l=0.14 //layer=m1 \
 //thickness=0.36 //x=3.825 //y=5.42 //x2=3.825 //y2=5.56
r315 (  3 8 ) resistor r=0.0698411 //w=0.17 //l=0.120208 //layer=m1 \
 //thickness=0.36 //x=3.825 //y=5.225 //x2=3.91 //y2=5.14
r316 (  3 4 ) resistor r=0.186069 //w=0.131 //l=0.195 //layer=m1 \
 //thickness=0.36 //x=3.825 //y=5.225 //x2=3.825 //y2=5.42
r317 (  2 6 ) resistor r=0.0698411 //w=0.17 //l=0.120208 //layer=m1 \
 //thickness=0.36 //x=3.82 //y=1.935 //x2=3.905 //y2=2.02
r318 (  1 18 ) resistor r=0.105739 //w=0.201 //l=0.145 //layer=m1 \
 //thickness=0.36 //x=3.82 //y=1.33 //x2=3.82 //y2=1.185
r319 (  1 2 ) resistor r=0.57729 //w=0.131 //l=0.605 //layer=m1 \
 //thickness=0.36 //x=3.82 //y=1.33 //x2=3.82 //y2=1.935
ends PM_DLATCHN\%noxref_1

subckt PM_DLATCHN\%noxref_2 ( 3 8 9 11 12 14 15 16 18 19 20 23 24 27 29 32 35 \
 38 42 43 48 51 59 76 85 89 90 91 92 93 94 95 99 100 101 103 109 110 112 120 \
 122 123 )
c259 ( 120 0 ) capacitor c=0.00878249f //x=6.89 //y=1.085
c260 ( 112 0 ) capacitor c=0.0545922f //x=9 //y=2.265
c261 ( 110 0 ) capacitor c=0.0439576f //x=9.64 //y=1.435
c262 ( 109 0 ) capacitor c=0.0201087f //x=9.64 //y=1.09
c263 ( 103 0 ) capacitor c=0.0161986f //x=9.485 //y=1.59
c264 ( 101 0 ) capacitor c=0.0157807f //x=9.485 //y=0.935
c265 ( 100 0 ) capacitor c=0.055513f //x=9.23 //y=4.97
c266 ( 99 0 ) capacitor c=0.0394958f //x=9.52 //y=4.97
c267 ( 95 0 ) capacitor c=0.0301471f //x=9.11 //y=2.1
c268 ( 94 0 ) capacitor c=0.0255349f //x=9.11 //y=1.745
c269 ( 93 0 ) capacitor c=0.0234346f //x=9.11 //y=1.435
c270 ( 92 0 ) capacitor c=0.02013f //x=9.11 //y=1.09
c271 ( 91 0 ) capacitor c=0.153927f //x=9.595 //y=6.2
c272 ( 90 0 ) capacitor c=0.154397f //x=9.155 //y=6.2
c273 ( 85 0 ) capacitor c=9.4527e-19 //x=9 //y=4.88
c274 ( 76 0 ) capacitor c=9.11699e-19 //x=9 //y=2.265
c275 ( 59 0 ) capacitor c=0.0321204f //x=7.04 //y=5.56
c276 ( 51 0 ) capacitor c=0.0289608f //x=6.16 //y=5.56
c277 ( 48 0 ) capacitor c=5.85852e-19 //x=8.995 //y=3.51
c278 ( 43 0 ) capacitor c=8.28329e-19 //x=7.68 //y=3.51
c279 ( 42 0 ) capacitor c=0.016775f //x=8.835 //y=3.51
c280 ( 38 0 ) capacitor c=0.00754811f //x=9 //y=2.265
c281 ( 35 0 ) capacitor c=0.0159873f //x=8.995 //y=3.51
c282 ( 32 0 ) capacitor c=0.0165963f //x=7.52 //y=3.51
c283 ( 29 0 ) capacitor c=0.0112429f //x=7.08 //y=1.18
c284 ( 27 0 ) capacitor c=7.81299e-19 //x=7.04 //y=5.56
c285 ( 24 0 ) capacitor c=0.0116497f //x=7.04 //y=5.38
c286 ( 23 0 ) capacitor c=0.00935658f //x=6.16 //y=5.56
c287 ( 20 0 ) capacitor c=0.0289376f //x=9 //y=4.76
c288 ( 19 0 ) capacitor c=0.0128138f //x=9 //y=3.67
c289 ( 18 0 ) capacitor c=0.0211888f //x=9 //y=3.35
c290 ( 16 0 ) capacitor c=0.0385357f //x=7.52 //y=5.295
c291 ( 15 0 ) capacitor c=0.013123f //x=7.52 //y=3.67
c292 ( 14 0 ) capacitor c=0.0331337f //x=7.52 //y=3.35
c293 ( 12 0 ) capacitor c=0.00568795f //x=7.165 //y=1.835
c294 ( 11 0 ) capacitor c=0.0132448f //x=7.435 //y=1.835
c295 ( 9 0 ) capacitor c=0.0117467f //x=7.435 //y=5.38
c296 ( 8 0 ) capacitor c=0.0090797f //x=7.08 //y=1.75
c297 ( 3 0 ) capacitor c=0.0149274f //x=6.925 //y=5.38
r298 (  112 113 ) resistor r=17.5563 //w=0.302 //l=0.11 //layer=ply \
 //thickness=0.18 //x=9 //y=2.265 //x2=9.11 //y2=2.265
r299 (  110 119 ) resistor r=45.1352 //w=0.168 //l=0.173853 //layer=ply \
 //thickness=0.18 //x=9.64 //y=1.435 //x2=9.6 //y2=1.59
r300 (  109 118 ) resistor r=45.1352 //w=0.168 //l=0.173853 //layer=ply \
 //thickness=0.18 //x=9.64 //y=1.09 //x2=9.6 //y2=0.935
r301 (  109 110 ) resistor r=176.904 //w=0.094 //l=0.345 //layer=ply \
 //thickness=0.18 //x=9.64 //y=1.09 //x2=9.64 //y2=1.435
r302 (  104 117 ) resistor r=10.701 //w=0.21 //l=0.115 //layer=ply \
 //thickness=0.18 //x=9.265 //y=1.59 //x2=9.15 //y2=1.59
r303 (  103 119 ) resistor r=5.52526 //w=0.168 //l=0.115 //layer=ply \
 //thickness=0.18 //x=9.485 //y=1.59 //x2=9.6 //y2=1.59
r304 (  102 116 ) resistor r=5.52526 //w=0.168 //l=0.115 //layer=ply \
 //thickness=0.18 //x=9.265 //y=0.935 //x2=9.15 //y2=0.935
r305 (  101 118 ) resistor r=5.52526 //w=0.168 //l=0.115 //layer=ply \
 //thickness=0.18 //x=9.485 //y=0.935 //x2=9.6 //y2=0.935
r306 (  101 102 ) resistor r=112.809 //w=0.094 //l=0.22 //layer=ply \
 //thickness=0.18 //x=9.485 //y=0.935 //x2=9.265 //y2=0.935
r307 (  99 106 ) resistor r=26.9307 //w=0.15 //l=0.106066 //layer=ply \
 //thickness=0.18 //x=9.52 //y=4.97 //x2=9.595 //y2=5.045
r308 (  99 100 ) resistor r=148.702 //w=0.094 //l=0.29 //layer=ply \
 //thickness=0.18 //x=9.52 //y=4.97 //x2=9.23 //y2=4.97
r309 (  96 100 ) resistor r=23.403 //w=0.284 //l=0.106066 //layer=ply \
 //thickness=0.18 //x=9.155 //y=5.045 //x2=9.23 //y2=4.97
r310 (  96 115 ) resistor r=26.3063 //w=0.284 //l=0.229783 //layer=ply \
 //thickness=0.18 //x=9.155 //y=5.045 //x2=9 //y2=4.88
r311 (  95 113 ) resistor r=19.1248 //w=0.302 //l=0.165 //layer=ply \
 //thickness=0.18 //x=9.11 //y=2.1 //x2=9.11 //y2=2.265
r312 (  94 117 ) resistor r=39.5823 //w=0.21 //l=0.173853 //layer=ply \
 //thickness=0.18 //x=9.11 //y=1.745 //x2=9.15 //y2=1.59
r313 (  94 95 ) resistor r=182.032 //w=0.094 //l=0.355 //layer=ply \
 //thickness=0.18 //x=9.11 //y=1.745 //x2=9.11 //y2=2.1
r314 (  93 117 ) resistor r=39.5823 //w=0.21 //l=0.173853 //layer=ply \
 //thickness=0.18 //x=9.11 //y=1.435 //x2=9.15 //y2=1.59
r315 (  92 116 ) resistor r=45.1352 //w=0.168 //l=0.173853 //layer=ply \
 //thickness=0.18 //x=9.11 //y=1.09 //x2=9.15 //y2=0.935
r316 (  92 93 ) resistor r=176.904 //w=0.094 //l=0.345 //layer=ply \
 //thickness=0.18 //x=9.11 //y=1.09 //x2=9.11 //y2=1.435
r317 (  91 106 ) resistor r=592.245 //w=0.094 //l=1.155 //layer=ply \
 //thickness=0.18 //x=9.595 //y=6.2 //x2=9.595 //y2=5.045
r318 (  90 96 ) resistor r=592.245 //w=0.094 //l=1.155 //layer=ply \
 //thickness=0.18 //x=9.155 //y=6.2 //x2=9.155 //y2=5.045
r319 (  89 103 ) resistor r=56.4043 //w=0.094 //l=0.11 //layer=ply \
 //thickness=0.18 //x=9.375 //y=1.59 //x2=9.485 //y2=1.59
r320 (  89 104 ) resistor r=56.4043 //w=0.094 //l=0.11 //layer=ply \
 //thickness=0.18 //x=9.375 //y=1.59 //x2=9.265 //y2=1.59
r321 (  85 115 ) resistor r=152 //w=0.17 //l=0.17 //layer=licon //count=1 \
 //x=9 //y=4.88 //x2=9 //y2=4.88
r322 (  76 112 ) resistor r=152 //w=0.17 //l=0.17 //layer=licon //count=1 \
 //x=9 //y=2.265 //x2=9 //y2=2.265
r323 (  59 123 ) resistor r=23.615 //w=0.187 //l=0.345 //layer=li \
 //thickness=0.1 //x=7.04 //y=5.56 //x2=7.04 //y2=5.905
r324 (  51 122 ) resistor r=23.615 //w=0.187 //l=0.345 //layer=li \
 //thickness=0.1 //x=6.16 //y=5.56 //x2=6.16 //y2=5.905
r325 (  43 45 ) resistor r=0.10734 //w=0.281 //l=0.16 //layer=m2 \
 //thickness=0.36 //x=7.68 //y=3.51 //x2=7.52 //y2=3.51
r326 (  42 48 ) resistor r=0.10734 //w=0.281 //l=0.16 //layer=m2 \
 //thickness=0.36 //x=8.835 //y=3.51 //x2=8.995 //y2=3.51
r327 (  42 43 ) resistor r=1.1021 //w=0.131 //l=1.155 //layer=m2 \
 //thickness=0.36 //x=8.835 //y=3.51 //x2=7.68 //y2=3.51
r328 (  41 85 ) resistor r=9.3 //w=0.17 //l=0.17 //layer=mcon //count=1 //x=9 \
 //y=4.88 //x2=9 //y2=4.88
r329 (  38 76 ) resistor r=9.3 //w=0.17 //l=0.17 //layer=mcon //count=1 //x=9 \
 //y=2.265 //x2=9 //y2=2.265
r330 (  35 48 ) resistor r=4.5 //w=0.15 //l=0.15 //layer=via1 //count=1 \
 //x=8.995 //y=3.51 //x2=8.995 //y2=3.51
r331 (  32 45 ) resistor r=4.5 //w=0.15 //l=0.15 //layer=via1 //count=1 \
 //x=7.52 //y=3.51 //x2=7.52 //y2=3.51
r332 (  29 120 ) resistor r=9.3 //w=0.17 //l=0.17 //layer=mcon //count=1 \
 //x=7.08 //y=1.18 //x2=7.08 //y2=1.18
r333 (  27 59 ) resistor r=9.3 //w=0.17 //l=0.17 //layer=mcon //count=1 \
 //x=7.04 //y=5.56 //x2=7.04 //y2=5.56
r334 (  24 27 ) resistor r=0.117801 //w=0.191 //l=0.18 //layer=m1 \
 //thickness=0.36 //x=7.04 //y=5.38 //x2=7.04 //y2=5.56
r335 (  23 51 ) resistor r=9.3 //w=0.17 //l=0.17 //layer=mcon //count=1 \
 //x=6.16 //y=5.56 //x2=6.16 //y2=5.56
r336 (  21 23 ) resistor r=0.10274 //w=0.219 //l=0.18 //layer=m1 \
 //thickness=0.36 //x=6.16 //y=5.38 //x2=6.16 //y2=5.56
r337 (  20 41 ) resistor r=0.0732479 //w=0.241 //l=0.122474 //layer=m1 \
 //thickness=0.36 //x=9 //y=4.76 //x2=9.005 //y2=4.88
r338 (  19 35 ) resistor r=0.0910802 //w=0.374 //l=0.185472 //layer=m1 \
 //thickness=0.36 //x=9 //y=3.67 //x2=8.945 //y2=3.51
r339 (  19 20 ) resistor r=1.04008 //w=0.131 //l=1.09 //layer=m1 \
 //thickness=0.36 //x=9 //y=3.67 //x2=9 //y2=4.76
r340 (  18 35 ) resistor r=0.0910802 //w=0.374 //l=0.185472 //layer=m1 \
 //thickness=0.36 //x=9 //y=3.35 //x2=8.945 //y2=3.51
r341 (  17 38 ) resistor r=0.116051 //w=0.211 //l=0.165 //layer=m1 \
 //thickness=0.36 //x=9 //y=2.43 //x2=9 //y2=2.265
r342 (  17 18 ) resistor r=0.877863 //w=0.131 //l=0.92 //layer=m1 \
 //thickness=0.36 //x=9 //y=2.43 //x2=9 //y2=3.35
r343 (  15 32 ) resistor r=0.0911593 //w=0.376 //l=0.184174 //layer=m1 \
 //thickness=0.36 //x=7.52 //y=3.67 //x2=7.572 //y2=3.51
r344 (  15 16 ) resistor r=1.55057 //w=0.131 //l=1.625 //layer=m1 \
 //thickness=0.36 //x=7.52 //y=3.67 //x2=7.52 //y2=5.295
r345 (  14 32 ) resistor r=0.0911593 //w=0.376 //l=0.184174 //layer=m1 \
 //thickness=0.36 //x=7.52 //y=3.35 //x2=7.572 //y2=3.51
r346 (  13 14 ) resistor r=1.3645 //w=0.131 //l=1.43 //layer=m1 \
 //thickness=0.36 //x=7.52 //y=1.92 //x2=7.52 //y2=3.35
r347 (  11 13 ) resistor r=0.0698411 //w=0.17 //l=0.120208 //layer=m1 \
 //thickness=0.36 //x=7.435 //y=1.835 //x2=7.52 //y2=1.92
r348 (  11 12 ) resistor r=0.257634 //w=0.131 //l=0.27 //layer=m1 \
 //thickness=0.36 //x=7.435 //y=1.835 //x2=7.165 //y2=1.835
r349 (  10 24 ) resistor r=0.0257089 //w=0.23 //l=0.115 //layer=m1 \
 //thickness=0.36 //x=7.155 //y=5.38 //x2=7.04 //y2=5.38
r350 (  9 16 ) resistor r=0.0698411 //w=0.17 //l=0.120208 //layer=m1 \
 //thickness=0.36 //x=7.435 //y=5.38 //x2=7.52 //y2=5.295
r351 (  9 10 ) resistor r=0.267176 //w=0.131 //l=0.28 //layer=m1 \
 //thickness=0.36 //x=7.435 //y=5.38 //x2=7.155 //y2=5.38
r352 (  8 12 ) resistor r=0.0698411 //w=0.17 //l=0.120208 //layer=m1 \
 //thickness=0.36 //x=7.08 //y=1.75 //x2=7.165 //y2=1.835
r353 (  7 29 ) resistor r=0.0913624 //w=0.191 //l=0.12 //layer=m1 \
 //thickness=0.36 //x=7.08 //y=1.3 //x2=7.08 //y2=1.18
r354 (  7 8 ) resistor r=0.429389 //w=0.131 //l=0.45 //layer=m1 \
 //thickness=0.36 //x=7.08 //y=1.3 //x2=7.08 //y2=1.75
r355 (  4 21 ) resistor r=0.0227762 //w=0.219 //l=0.115 //layer=m1 \
 //thickness=0.36 //x=6.275 //y=5.38 //x2=6.16 //y2=5.38
r356 (  3 24 ) resistor r=0.0257089 //w=0.23 //l=0.115 //layer=m1 \
 //thickness=0.36 //x=6.925 //y=5.38 //x2=7.04 //y2=5.38
r357 (  3 4 ) resistor r=0.620229 //w=0.131 //l=0.65 //layer=m1 \
 //thickness=0.36 //x=6.925 //y=5.38 //x2=6.275 //y2=5.38
ends PM_DLATCHN\%noxref_2

subckt PM_DLATCHN\%noxref_3 ( 2 4 5 6 7 8 10 11 12 14 15 16 18 19 22 27 31 39 \
 41 44 47 48 50 52 53 54 56 61 72 84 93 98 107 111 112 113 114 115 116 117 118 \
 119 124 126 128 134 135 136 137 138 139 143 145 148 149 154 155 158 172 175 \
 177 )
c396 ( 175 0 ) capacitor c=0.00875839f //x=1.415 //y=1.09
c397 ( 172 0 ) capacitor c=0.0682508f //x=11.59 //y=4.88
c398 ( 158 0 ) capacitor c=0.0393541f //x=6.81 //y=4.88
c399 ( 155 0 ) capacitor c=0.0284095f //x=6.78 //y=2.095
c400 ( 154 0 ) capacitor c=0.0440007f //x=6.78 //y=2.26
c401 ( 149 0 ) capacitor c=0.0318956f //x=11.925 //y=1.39
c402 ( 148 0 ) capacitor c=0.0186809f //x=11.925 //y=1.045
c403 ( 145 0 ) capacitor c=0.0141821f //x=11.77 //y=1.545
c404 ( 143 0 ) capacitor c=0.0158553f //x=11.77 //y=0.89
c405 ( 139 0 ) capacitor c=0.0818281f //x=11.395 //y=2.095
c406 ( 138 0 ) capacitor c=0.0229235f //x=11.395 //y=1.7
c407 ( 137 0 ) capacitor c=0.0234359f //x=11.395 //y=1.39
c408 ( 136 0 ) capacitor c=0.0198759f //x=11.395 //y=1.045
c409 ( 135 0 ) capacitor c=0.0439708f //x=7.345 //y=1.43
c410 ( 134 0 ) capacitor c=0.0192582f //x=7.345 //y=1.085
c411 ( 128 0 ) capacitor c=0.0162526f //x=7.19 //y=1.585
c412 ( 126 0 ) capacitor c=0.0157807f //x=7.19 //y=0.93
c413 ( 124 0 ) capacitor c=0.0373491f //x=7.185 //y=4.97
c414 ( 119 0 ) capacitor c=0.0210762f //x=6.815 //y=1.74
c415 ( 118 0 ) capacitor c=0.0168511f //x=6.815 //y=1.43
c416 ( 117 0 ) capacitor c=0.0175485f //x=6.815 //y=1.085
c417 ( 116 0 ) capacitor c=0.110369f //x=11.93 //y=6.2
c418 ( 115 0 ) capacitor c=0.154619f //x=11.49 //y=6.2
c419 ( 114 0 ) capacitor c=0.155269f //x=7.26 //y=6.2
c420 ( 113 0 ) capacitor c=0.110375f //x=6.82 //y=6.2
c421 ( 107 0 ) capacitor c=8.13425e-19 //x=11.59 //y=4.88
c422 ( 98 0 ) capacitor c=5.17312e-19 //x=11.59 //y=2.26
c423 ( 93 0 ) capacitor c=8.90417e-19 //x=6.81 //y=4.88
c424 ( 84 0 ) capacitor c=3.09518e-19 //x=6.78 //y=2.26
c425 ( 72 0 ) capacitor c=0.0263113f //x=1.605 //y=5.56
c426 ( 61 0 ) capacitor c=0.00404549f //x=2.13 //y=3.145
c427 ( 56 0 ) capacitor c=0.0805677f //x=9.21 //y=3.125
c428 ( 54 0 ) capacitor c=0.0261542f //x=8.61 //y=3.14
c429 ( 53 0 ) capacitor c=0.012561f //x=7.305 //y=3.125
c430 ( 52 0 ) capacitor c=0.018479f //x=7.735 //y=3.125
c431 ( 50 0 ) capacitor c=0.161215f //x=6.62 //y=3.14
c432 ( 48 0 ) capacitor c=0.0372475f //x=11.592 //y=4.74
c433 ( 47 0 ) capacitor c=0.00623622f //x=11.59 //y=4.88
c434 ( 44 0 ) capacitor c=0.00627713f //x=11.59 //y=2.26
c435 ( 41 0 ) capacitor c=0.0143984f //x=11.585 //y=3.14
c436 ( 39 0 ) capacitor c=0.0141141f //x=6.78 //y=3.14
c437 ( 31 0 ) capacitor c=0.00625333f //x=6.78 //y=2.26
c438 ( 27 0 ) capacitor c=0.0158444f //x=1.97 //y=3.14
c439 ( 22 0 ) capacitor c=0.0189199f //x=1.6 //y=1.185
c440 ( 19 0 ) capacitor c=0.0134454f //x=11.59 //y=3.3
c441 ( 18 0 ) capacitor c=0.0147324f //x=11.59 //y=2.98
c442 ( 16 0 ) capacitor c=0.0338961f //x=6.78 //y=4.735
c443 ( 15 0 ) capacitor c=0.01066f //x=6.78 //y=3.295
c444 ( 14 0 ) capacitor c=0.011728f //x=6.78 //y=2.975
c445 ( 12 0 ) capacitor c=0.0437118f //x=1.97 //y=5.055
c446 ( 11 0 ) capacitor c=0.0118059f //x=1.97 //y=3.305
c447 ( 10 0 ) capacitor c=0.0177418f //x=1.97 //y=2.985
c448 ( 8 0 ) capacitor c=0.00714889f //x=1.69 //y=5.14
c449 ( 7 0 ) capacitor c=0.0074193f //x=1.885 //y=5.14
c450 ( 6 0 ) capacitor c=0.00882254f //x=1.685 //y=2.02
c451 ( 5 0 ) capacitor c=0.0118411f //x=1.885 //y=2.02
c452 ( 4 0 ) capacitor c=0.0120411f //x=1.605 //y=5.42
c453 ( 2 0 ) capacitor c=0.0170679f //x=1.6 //y=1.935
r454 (  170 172 ) resistor r=20.6867 //w=0.233 //l=0.1 //layer=ply \
 //thickness=0.18 //x=11.49 //y=4.88 //x2=11.59 //y2=4.88
r455 (  160 161 ) resistor r=32.4568 //w=0.214 //l=0.075 //layer=ply \
 //thickness=0.18 //x=6.81 //y=4.97 //x2=6.81 //y2=5.045
r456 (  158 160 ) resistor r=20.271 //w=0.214 //l=0.09 //layer=ply \
 //thickness=0.18 //x=6.81 //y=4.88 //x2=6.81 //y2=4.97
r457 (  154 155 ) resistor r=52.7279 //w=0.214 //l=0.165 //layer=ply \
 //thickness=0.18 //x=6.78 //y=2.26 //x2=6.78 //y2=2.095
r458 (  150 172 ) resistor r=70.3348 //w=0.233 //l=0.414367 //layer=ply \
 //thickness=0.18 //x=11.93 //y=5.045 //x2=11.59 //y2=4.88
r459 (  149 174 ) resistor r=45.1352 //w=0.168 //l=0.173853 //layer=ply \
 //thickness=0.18 //x=11.925 //y=1.39 //x2=11.885 //y2=1.545
r460 (  148 173 ) resistor r=45.1352 //w=0.168 //l=0.173853 //layer=ply \
 //thickness=0.18 //x=11.925 //y=1.045 //x2=11.885 //y2=0.89
r461 (  148 149 ) resistor r=176.904 //w=0.094 //l=0.345 //layer=ply \
 //thickness=0.18 //x=11.925 //y=1.045 //x2=11.925 //y2=1.39
r462 (  146 169 ) resistor r=10.701 //w=0.21 //l=0.115 //layer=ply \
 //thickness=0.18 //x=11.55 //y=1.545 //x2=11.435 //y2=1.545
r463 (  145 174 ) resistor r=5.52526 //w=0.168 //l=0.115 //layer=ply \
 //thickness=0.18 //x=11.77 //y=1.545 //x2=11.885 //y2=1.545
r464 (  144 168 ) resistor r=5.52526 //w=0.168 //l=0.115 //layer=ply \
 //thickness=0.18 //x=11.55 //y=0.89 //x2=11.435 //y2=0.89
r465 (  143 173 ) resistor r=5.52526 //w=0.168 //l=0.115 //layer=ply \
 //thickness=0.18 //x=11.77 //y=0.89 //x2=11.885 //y2=0.89
r466 (  143 144 ) resistor r=112.809 //w=0.094 //l=0.22 //layer=ply \
 //thickness=0.18 //x=11.77 //y=0.89 //x2=11.55 //y2=0.89
r467 (  140 170 ) resistor r=13.0941 //w=0.233 //l=0.165 //layer=ply \
 //thickness=0.18 //x=11.49 //y=5.045 //x2=11.49 //y2=4.88
r468 (  139 167 ) resistor r=34.8111 //w=0.27 //l=0.264953 //layer=ply \
 //thickness=0.18 //x=11.395 //y=2.095 //x2=11.59 //y2=2.26
r469 (  138 169 ) resistor r=39.5823 //w=0.21 //l=0.173853 //layer=ply \
 //thickness=0.18 //x=11.395 //y=1.7 //x2=11.435 //y2=1.545
r470 (  138 139 ) resistor r=202.543 //w=0.094 //l=0.395 //layer=ply \
 //thickness=0.18 //x=11.395 //y=1.7 //x2=11.395 //y2=2.095
r471 (  137 169 ) resistor r=39.5823 //w=0.21 //l=0.173853 //layer=ply \
 //thickness=0.18 //x=11.395 //y=1.39 //x2=11.435 //y2=1.545
r472 (  136 168 ) resistor r=45.1352 //w=0.168 //l=0.173853 //layer=ply \
 //thickness=0.18 //x=11.395 //y=1.045 //x2=11.435 //y2=0.89
r473 (  136 137 ) resistor r=176.904 //w=0.094 //l=0.345 //layer=ply \
 //thickness=0.18 //x=11.395 //y=1.045 //x2=11.395 //y2=1.39
r474 (  135 165 ) resistor r=45.1352 //w=0.168 //l=0.173853 //layer=ply \
 //thickness=0.18 //x=7.345 //y=1.43 //x2=7.305 //y2=1.585
r475 (  134 164 ) resistor r=45.1352 //w=0.168 //l=0.173853 //layer=ply \
 //thickness=0.18 //x=7.345 //y=1.085 //x2=7.305 //y2=0.93
r476 (  134 135 ) resistor r=176.904 //w=0.094 //l=0.345 //layer=ply \
 //thickness=0.18 //x=7.345 //y=1.085 //x2=7.345 //y2=1.43
r477 (  129 163 ) resistor r=10.701 //w=0.21 //l=0.115 //layer=ply \
 //thickness=0.18 //x=6.97 //y=1.585 //x2=6.855 //y2=1.585
r478 (  128 165 ) resistor r=5.52526 //w=0.168 //l=0.115 //layer=ply \
 //thickness=0.18 //x=7.19 //y=1.585 //x2=7.305 //y2=1.585
r479 (  127 162 ) resistor r=5.52526 //w=0.168 //l=0.115 //layer=ply \
 //thickness=0.18 //x=6.97 //y=0.93 //x2=6.855 //y2=0.93
r480 (  126 164 ) resistor r=5.52526 //w=0.168 //l=0.115 //layer=ply \
 //thickness=0.18 //x=7.19 //y=0.93 //x2=7.305 //y2=0.93
r481 (  126 127 ) resistor r=112.809 //w=0.094 //l=0.22 //layer=ply \
 //thickness=0.18 //x=7.19 //y=0.93 //x2=6.97 //y2=0.93
r482 (  125 160 ) resistor r=16.5046 //w=0.27 //l=0.135 //layer=ply \
 //thickness=0.18 //x=6.945 //y=4.97 //x2=6.81 //y2=4.97
r483 (  124 131 ) resistor r=26.9307 //w=0.15 //l=0.106066 //layer=ply \
 //thickness=0.18 //x=7.185 //y=4.97 //x2=7.26 //y2=5.045
r484 (  124 125 ) resistor r=123.064 //w=0.094 //l=0.24 //layer=ply \
 //thickness=0.18 //x=7.185 //y=4.97 //x2=6.945 //y2=4.97
r485 (  119 163 ) resistor r=39.5823 //w=0.21 //l=0.173853 //layer=ply \
 //thickness=0.18 //x=6.815 //y=1.74 //x2=6.855 //y2=1.585
r486 (  119 155 ) resistor r=182.032 //w=0.094 //l=0.355 //layer=ply \
 //thickness=0.18 //x=6.815 //y=1.74 //x2=6.815 //y2=2.095
r487 (  118 163 ) resistor r=39.5823 //w=0.21 //l=0.173853 //layer=ply \
 //thickness=0.18 //x=6.815 //y=1.43 //x2=6.855 //y2=1.585
r488 (  117 162 ) resistor r=45.1352 //w=0.168 //l=0.173853 //layer=ply \
 //thickness=0.18 //x=6.815 //y=1.085 //x2=6.855 //y2=0.93
r489 (  117 118 ) resistor r=176.904 //w=0.094 //l=0.345 //layer=ply \
 //thickness=0.18 //x=6.815 //y=1.085 //x2=6.815 //y2=1.43
r490 (  116 150 ) resistor r=592.245 //w=0.094 //l=1.155 //layer=ply \
 //thickness=0.18 //x=11.93 //y=6.2 //x2=11.93 //y2=5.045
r491 (  115 140 ) resistor r=592.245 //w=0.094 //l=1.155 //layer=ply \
 //thickness=0.18 //x=11.49 //y=6.2 //x2=11.49 //y2=5.045
r492 (  114 131 ) resistor r=592.245 //w=0.094 //l=1.155 //layer=ply \
 //thickness=0.18 //x=7.26 //y=6.2 //x2=7.26 //y2=5.045
r493 (  113 161 ) resistor r=592.245 //w=0.094 //l=1.155 //layer=ply \
 //thickness=0.18 //x=6.82 //y=6.2 //x2=6.82 //y2=5.045
r494 (  112 145 ) resistor r=56.4043 //w=0.094 //l=0.11 //layer=ply \
 //thickness=0.18 //x=11.66 //y=1.545 //x2=11.77 //y2=1.545
r495 (  112 146 ) resistor r=56.4043 //w=0.094 //l=0.11 //layer=ply \
 //thickness=0.18 //x=11.66 //y=1.545 //x2=11.55 //y2=1.545
r496 (  111 128 ) resistor r=56.4043 //w=0.094 //l=0.11 //layer=ply \
 //thickness=0.18 //x=7.08 //y=1.585 //x2=7.19 //y2=1.585
r497 (  111 129 ) resistor r=56.4043 //w=0.094 //l=0.11 //layer=ply \
 //thickness=0.18 //x=7.08 //y=1.585 //x2=6.97 //y2=1.585
r498 (  107 172 ) resistor r=152 //w=0.17 //l=0.17 //layer=licon //count=1 \
 //x=11.59 //y=4.88 //x2=11.59 //y2=4.88
r499 (  98 167 ) resistor r=152 //w=0.17 //l=0.17 //layer=licon //count=1 \
 //x=11.59 //y=2.26 //x2=11.59 //y2=2.26
r500 (  93 158 ) resistor r=152 //w=0.17 //l=0.17 //layer=licon //count=1 \
 //x=6.81 //y=4.88 //x2=6.81 //y2=4.88
r501 (  84 154 ) resistor r=152 //w=0.17 //l=0.17 //layer=licon //count=1 \
 //x=6.78 //y=2.26 //x2=6.78 //y2=2.26
r502 (  72 177 ) resistor r=23.615 //w=0.187 //l=0.345 //layer=li \
 //thickness=0.1 //x=1.605 //y=5.56 //x2=1.605 //y2=5.905
r503 (  59 61 ) resistor r=0.10734 //w=0.281 //l=0.16 //layer=m2 \
 //thickness=0.36 //x=1.97 //y=3.145 //x2=2.13 //y2=3.145
r504 (  56 65 ) resistor r=1.5723 //w=0.189 //l=2.38249 //layer=m2 \
 //thickness=0.36 //x=9.21 //y=3.125 //x2=11.585 //y2=3.14
r505 (  56 57 ) resistor r=0.410305 //w=0.131 //l=0.43 //layer=m2 \
 //thickness=0.36 //x=9.21 //y=3.125 //x2=8.78 //y2=3.125
r506 (  54 57 ) resistor r=0.125 //w=0.17 //l=0.177341 //layer=m2 \
 //thickness=0.36 //x=8.61 //y=3.14 //x2=8.78 //y2=3.125
r507 (  54 55 ) resistor r=0.591603 //w=0.131 //l=0.62 //layer=m2 \
 //thickness=0.36 //x=8.61 //y=3.14 //x2=7.99 //y2=3.14
r508 (  53 63 ) resistor r=0.28331 //w=0.241 //l=0.529976 //layer=m2 \
 //thickness=0.36 //x=7.305 //y=3.125 //x2=6.78 //y2=3.135
r509 (  52 55 ) resistor r=0.1875 //w=0.17 //l=0.262393 //layer=m2 \
 //thickness=0.36 //x=7.735 //y=3.125 //x2=7.99 //y2=3.14
r510 (  52 53 ) resistor r=0.410305 //w=0.131 //l=0.43 //layer=m2 \
 //thickness=0.36 //x=7.735 //y=3.125 //x2=7.305 //y2=3.125
r511 (  50 63 ) resistor r=0.0939948 //w=0.241 //l=0.162481 //layer=m2 \
 //thickness=0.36 //x=6.62 //y=3.14 //x2=6.78 //y2=3.135
r512 (  50 61 ) resistor r=4.28435 //w=0.131 //l=4.49 //layer=m2 \
 //thickness=0.36 //x=6.62 //y=3.14 //x2=2.13 //y2=3.14
r513 (  47 107 ) resistor r=9.3 //w=0.17 //l=0.17 //layer=mcon //count=1 \
 //x=11.59 //y=4.88 //x2=11.59 //y2=4.88
r514 (  47 48 ) resistor r=0.103207 //w=0.196 //l=0.14 //layer=m1 \
 //thickness=0.36 //x=11.592 //y=4.88 //x2=11.592 //y2=4.74
r515 (  44 98 ) resistor r=9.3 //w=0.17 //l=0.17 //layer=mcon //count=1 \
 //x=11.59 //y=2.26 //x2=11.59 //y2=2.26
r516 (  41 65 ) resistor r=4.5 //w=0.15 //l=0.15 //layer=via1 //count=1 \
 //x=11.585 //y=3.14 //x2=11.585 //y2=3.14
r517 (  37 63 ) resistor r=4.5 //w=0.15 //l=0.15 //layer=via1 //count=1 \
 //x=6.78 //y=3.135 //x2=6.78 //y2=3.135
r518 (  37 39 ) resistor r=0.00166223 //w=0.376 //l=0.005 //layer=m1 \
 //thickness=0.36 //x=6.832 //y=3.135 //x2=6.832 //y2=3.14
r519 (  35 93 ) resistor r=9.3 //w=0.17 //l=0.17 //layer=mcon //count=1 \
 //x=6.81 //y=4.88 //x2=6.81 //y2=4.88
r520 (  31 84 ) resistor r=9.3 //w=0.17 //l=0.17 //layer=mcon //count=1 \
 //x=6.78 //y=2.26 //x2=6.78 //y2=2.26
r521 (  31 33 ) resistor r=0.0936408 //w=0.196 //l=0.125 //layer=m1 \
 //thickness=0.36 //x=6.782 //y=2.26 //x2=6.782 //y2=2.385
r522 (  29 59 ) resistor r=4.5 //w=0.15 //l=0.15 //layer=via1 //count=1 \
 //x=1.97 //y=3.145 //x2=1.97 //y2=3.145
r523 (  27 29 ) resistor r=0.00166223 //w=0.376 //l=0.005 //layer=m1 \
 //thickness=0.36 //x=2.022 //y=3.14 //x2=2.022 //y2=3.145
r524 (  25 72 ) resistor r=9.3 //w=0.17 //l=0.17 //layer=mcon //count=1 \
 //x=1.605 //y=5.56 //x2=1.605 //y2=5.56
r525 (  22 175 ) resistor r=9.3 //w=0.17 //l=0.17 //layer=mcon //count=1 \
 //x=1.6 //y=1.185 //x2=1.6 //y2=1.185
r526 (  19 41 ) resistor r=0.0910802 //w=0.374 //l=0.185472 //layer=m1 \
 //thickness=0.36 //x=11.59 //y=3.3 //x2=11.535 //y2=3.14
r527 (  19 48 ) resistor r=1.37405 //w=0.131 //l=1.44 //layer=m1 \
 //thickness=0.36 //x=11.59 //y=3.3 //x2=11.59 //y2=4.74
r528 (  18 41 ) resistor r=0.0910802 //w=0.374 //l=0.185472 //layer=m1 \
 //thickness=0.36 //x=11.59 //y=2.98 //x2=11.535 //y2=3.14
r529 (  17 44 ) resistor r=0.0933015 //w=0.201 //l=0.125 //layer=m1 \
 //thickness=0.36 //x=11.59 //y=2.385 //x2=11.59 //y2=2.26
r530 (  17 18 ) resistor r=0.567748 //w=0.131 //l=0.595 //layer=m1 \
 //thickness=0.36 //x=11.59 //y=2.385 //x2=11.59 //y2=2.98
r531 (  16 35 ) resistor r=0.0878548 //w=0.228 //l=0.159295 //layer=m1 \
 //thickness=0.36 //x=6.78 //y=4.735 //x2=6.81 //y2=4.88
r532 (  15 39 ) resistor r=0.0894971 //w=0.376 //l=0.179123 //layer=m1 \
 //thickness=0.36 //x=6.78 //y=3.295 //x2=6.832 //y2=3.14
r533 (  15 16 ) resistor r=1.37405 //w=0.131 //l=1.44 //layer=m1 \
 //thickness=0.36 //x=6.78 //y=3.295 //x2=6.78 //y2=4.735
r534 (  14 37 ) resistor r=0.0911593 //w=0.376 //l=0.184174 //layer=m1 \
 //thickness=0.36 //x=6.78 //y=2.975 //x2=6.832 //y2=3.135
r535 (  14 33 ) resistor r=0.562977 //w=0.131 //l=0.59 //layer=m1 \
 //thickness=0.36 //x=6.78 //y=2.975 //x2=6.78 //y2=2.385
r536 (  11 29 ) resistor r=0.0911593 //w=0.376 //l=0.184174 //layer=m1 \
 //thickness=0.36 //x=1.97 //y=3.305 //x2=2.022 //y2=3.145
r537 (  11 12 ) resistor r=1.66985 //w=0.131 //l=1.75 //layer=m1 \
 //thickness=0.36 //x=1.97 //y=3.305 //x2=1.97 //y2=5.055
r538 (  10 27 ) resistor r=0.0894971 //w=0.376 //l=0.179123 //layer=m1 \
 //thickness=0.36 //x=1.97 //y=2.985 //x2=2.022 //y2=3.14
r539 (  9 10 ) resistor r=0.839695 //w=0.131 //l=0.88 //layer=m1 \
 //thickness=0.36 //x=1.97 //y=2.105 //x2=1.97 //y2=2.985
r540 (  7 12 ) resistor r=0.0698411 //w=0.17 //l=0.120208 //layer=m1 \
 //thickness=0.36 //x=1.885 //y=5.14 //x2=1.97 //y2=5.055
r541 (  7 8 ) resistor r=0.186069 //w=0.131 //l=0.195 //layer=m1 \
 //thickness=0.36 //x=1.885 //y=5.14 //x2=1.69 //y2=5.14
r542 (  5 9 ) resistor r=0.0698411 //w=0.17 //l=0.120208 //layer=m1 \
 //thickness=0.36 //x=1.885 //y=2.02 //x2=1.97 //y2=2.105
r543 (  5 6 ) resistor r=0.19084 //w=0.131 //l=0.2 //layer=m1 //thickness=0.36 \
 //x=1.885 //y=2.02 //x2=1.685 //y2=2.02
r544 (  4 25 ) resistor r=0.086672 //w=0.218 //l=0.14 //layer=m1 \
 //thickness=0.36 //x=1.605 //y=5.42 //x2=1.605 //y2=5.56
r545 (  3 8 ) resistor r=0.0698411 //w=0.17 //l=0.120208 //layer=m1 \
 //thickness=0.36 //x=1.605 //y=5.225 //x2=1.69 //y2=5.14
r546 (  3 4 ) resistor r=0.186069 //w=0.131 //l=0.195 //layer=m1 \
 //thickness=0.36 //x=1.605 //y=5.225 //x2=1.605 //y2=5.42
r547 (  2 6 ) resistor r=0.0698411 //w=0.17 //l=0.120208 //layer=m1 \
 //thickness=0.36 //x=1.6 //y=1.935 //x2=1.685 //y2=2.02
r548 (  1 22 ) resistor r=0.105739 //w=0.201 //l=0.145 //layer=m1 \
 //thickness=0.36 //x=1.6 //y=1.33 //x2=1.6 //y2=1.185
r549 (  1 2 ) resistor r=0.57729 //w=0.131 //l=0.605 //layer=m1 \
 //thickness=0.36 //x=1.6 //y=1.33 //x2=1.6 //y2=1.935
ends PM_DLATCHN\%noxref_3

subckt PM_DLATCHN\%D ( 1 2 3 4 5 6 7 8 9 10 16 17 24 25 28 40 46 51 52 55 64 \
 69 78 82 83 84 85 86 87 88 89 90 91 95 96 97 99 105 106 107 108 109 114 116 \
 118 124 125 127 136 137 140 )
c285 ( 140 0 ) capacitor c=0.0357047f //x=12.36 //y=4.88
c286 ( 137 0 ) capacitor c=0.0284095f //x=12.33 //y=2.095
c287 ( 136 0 ) capacitor c=0.0476356f //x=12.33 //y=2.26
c288 ( 127 0 ) capacitor c=0.0564228f //x=3.45 //y=2.265
c289 ( 125 0 ) capacitor c=0.0439708f //x=12.895 //y=1.43
c290 ( 124 0 ) capacitor c=0.0192582f //x=12.895 //y=1.085
c291 ( 118 0 ) capacitor c=0.0162526f //x=12.74 //y=1.585
c292 ( 116 0 ) capacitor c=0.0157807f //x=12.74 //y=0.93
c293 ( 114 0 ) capacitor c=0.0373491f //x=12.735 //y=4.97
c294 ( 109 0 ) capacitor c=0.0210762f //x=12.365 //y=1.74
c295 ( 108 0 ) capacitor c=0.0168511f //x=12.365 //y=1.43
c296 ( 107 0 ) capacitor c=0.0175485f //x=12.365 //y=1.085
c297 ( 106 0 ) capacitor c=0.0439576f //x=4.09 //y=1.435
c298 ( 105 0 ) capacitor c=0.0201087f //x=4.09 //y=1.09
c299 ( 99 0 ) capacitor c=0.0161986f //x=3.935 //y=1.59
c300 ( 97 0 ) capacitor c=0.0157807f //x=3.935 //y=0.935
c301 ( 96 0 ) capacitor c=0.049833f //x=3.68 //y=4.97
c302 ( 95 0 ) capacitor c=0.0387091f //x=3.97 //y=4.97
c303 ( 91 0 ) capacitor c=0.0301471f //x=3.56 //y=2.1
c304 ( 90 0 ) capacitor c=0.0255349f //x=3.56 //y=1.745
c305 ( 89 0 ) capacitor c=0.0234346f //x=3.56 //y=1.435
c306 ( 88 0 ) capacitor c=0.02013f //x=3.56 //y=1.09
c307 ( 87 0 ) capacitor c=0.155269f //x=12.81 //y=6.2
c308 ( 86 0 ) capacitor c=0.110375f //x=12.37 //y=6.2
c309 ( 85 0 ) capacitor c=0.153927f //x=4.045 //y=6.2
c310 ( 84 0 ) capacitor c=0.154397f //x=3.605 //y=6.2
c311 ( 78 0 ) capacitor c=5.80994e-19 //x=12.36 //y=4.88
c312 ( 69 0 ) capacitor c=5.78095e-19 //x=12.33 //y=2.26
c313 ( 64 0 ) capacitor c=7.71118e-19 //x=3.45 //y=4.88
c314 ( 55 0 ) capacitor c=0.00100612f //x=3.45 //y=2.265
c315 ( 52 0 ) capacitor c=0.222872f //x=12.165 //y=4.265
c316 ( 51 0 ) capacitor c=0.00254616f //x=12.325 //y=4.265
c317 ( 46 0 ) capacitor c=0.003168f //x=3.61 //y=4.25
c318 ( 40 0 ) capacitor c=0.00662823f //x=12.33 //y=2.26
c319 ( 28 0 ) capacitor c=0.00785811f //x=3.45 //y=2.265
c320 ( 25 0 ) capacitor c=0.00410674f //x=12.33 //y=4.735
c321 ( 24 0 ) capacitor c=0.00989327f //x=12.33 //y=4.425
c322 ( 17 0 ) capacitor c=0.00450927f //x=3.45 //y=4.76
c323 ( 16 0 ) capacitor c=0.0122445f //x=3.45 //y=4.41
c324 ( 10 0 ) capacitor c=0.0153165f //x=12.33 //y=4.25
c325 ( 9 0 ) capacitor c=0.01319f //x=3.45 //y=4.25
c326 ( 8 0 ) capacitor c=0.00555882f //x=12.33 //y=4.62
c327 ( 5 0 ) capacitor c=0.0361265f //x=12.33 //y=2.77
c328 ( 4 0 ) capacitor c=0.00538522f //x=3.45 //y=4.62
c329 ( 1 0 ) capacitor c=0.0440982f //x=3.45 //y=2.77
r330 (  142 143 ) resistor r=32.4568 //w=0.214 //l=0.075 //layer=ply \
 //thickness=0.18 //x=12.36 //y=4.97 //x2=12.36 //y2=5.045
r331 (  140 142 ) resistor r=20.271 //w=0.214 //l=0.09 //layer=ply \
 //thickness=0.18 //x=12.36 //y=4.88 //x2=12.36 //y2=4.97
r332 (  136 137 ) resistor r=52.7279 //w=0.214 //l=0.165 //layer=ply \
 //thickness=0.18 //x=12.33 //y=2.26 //x2=12.33 //y2=2.095
r333 (  127 128 ) resistor r=17.5563 //w=0.302 //l=0.11 //layer=ply \
 //thickness=0.18 //x=3.45 //y=2.265 //x2=3.56 //y2=2.265
r334 (  125 147 ) resistor r=45.1352 //w=0.168 //l=0.173853 //layer=ply \
 //thickness=0.18 //x=12.895 //y=1.43 //x2=12.855 //y2=1.585
r335 (  124 146 ) resistor r=45.1352 //w=0.168 //l=0.173853 //layer=ply \
 //thickness=0.18 //x=12.895 //y=1.085 //x2=12.855 //y2=0.93
r336 (  124 125 ) resistor r=176.904 //w=0.094 //l=0.345 //layer=ply \
 //thickness=0.18 //x=12.895 //y=1.085 //x2=12.895 //y2=1.43
r337 (  119 145 ) resistor r=10.701 //w=0.21 //l=0.115 //layer=ply \
 //thickness=0.18 //x=12.52 //y=1.585 //x2=12.405 //y2=1.585
r338 (  118 147 ) resistor r=5.52526 //w=0.168 //l=0.115 //layer=ply \
 //thickness=0.18 //x=12.74 //y=1.585 //x2=12.855 //y2=1.585
r339 (  117 144 ) resistor r=5.52526 //w=0.168 //l=0.115 //layer=ply \
 //thickness=0.18 //x=12.52 //y=0.93 //x2=12.405 //y2=0.93
r340 (  116 146 ) resistor r=5.52526 //w=0.168 //l=0.115 //layer=ply \
 //thickness=0.18 //x=12.74 //y=0.93 //x2=12.855 //y2=0.93
r341 (  116 117 ) resistor r=112.809 //w=0.094 //l=0.22 //layer=ply \
 //thickness=0.18 //x=12.74 //y=0.93 //x2=12.52 //y2=0.93
r342 (  115 142 ) resistor r=16.5046 //w=0.27 //l=0.135 //layer=ply \
 //thickness=0.18 //x=12.495 //y=4.97 //x2=12.36 //y2=4.97
r343 (  114 121 ) resistor r=26.9307 //w=0.15 //l=0.106066 //layer=ply \
 //thickness=0.18 //x=12.735 //y=4.97 //x2=12.81 //y2=5.045
r344 (  114 115 ) resistor r=123.064 //w=0.094 //l=0.24 //layer=ply \
 //thickness=0.18 //x=12.735 //y=4.97 //x2=12.495 //y2=4.97
r345 (  109 145 ) resistor r=39.5823 //w=0.21 //l=0.173853 //layer=ply \
 //thickness=0.18 //x=12.365 //y=1.74 //x2=12.405 //y2=1.585
r346 (  109 137 ) resistor r=182.032 //w=0.094 //l=0.355 //layer=ply \
 //thickness=0.18 //x=12.365 //y=1.74 //x2=12.365 //y2=2.095
r347 (  108 145 ) resistor r=39.5823 //w=0.21 //l=0.173853 //layer=ply \
 //thickness=0.18 //x=12.365 //y=1.43 //x2=12.405 //y2=1.585
r348 (  107 144 ) resistor r=45.1352 //w=0.168 //l=0.173853 //layer=ply \
 //thickness=0.18 //x=12.365 //y=1.085 //x2=12.405 //y2=0.93
r349 (  107 108 ) resistor r=176.904 //w=0.094 //l=0.345 //layer=ply \
 //thickness=0.18 //x=12.365 //y=1.085 //x2=12.365 //y2=1.43
r350 (  106 134 ) resistor r=45.1352 //w=0.168 //l=0.173853 //layer=ply \
 //thickness=0.18 //x=4.09 //y=1.435 //x2=4.05 //y2=1.59
r351 (  105 133 ) resistor r=45.1352 //w=0.168 //l=0.173853 //layer=ply \
 //thickness=0.18 //x=4.09 //y=1.09 //x2=4.05 //y2=0.935
r352 (  105 106 ) resistor r=176.904 //w=0.094 //l=0.345 //layer=ply \
 //thickness=0.18 //x=4.09 //y=1.09 //x2=4.09 //y2=1.435
r353 (  100 132 ) resistor r=10.701 //w=0.21 //l=0.115 //layer=ply \
 //thickness=0.18 //x=3.715 //y=1.59 //x2=3.6 //y2=1.59
r354 (  99 134 ) resistor r=5.52526 //w=0.168 //l=0.115 //layer=ply \
 //thickness=0.18 //x=3.935 //y=1.59 //x2=4.05 //y2=1.59
r355 (  98 131 ) resistor r=5.52526 //w=0.168 //l=0.115 //layer=ply \
 //thickness=0.18 //x=3.715 //y=0.935 //x2=3.6 //y2=0.935
r356 (  97 133 ) resistor r=5.52526 //w=0.168 //l=0.115 //layer=ply \
 //thickness=0.18 //x=3.935 //y=0.935 //x2=4.05 //y2=0.935
r357 (  97 98 ) resistor r=112.809 //w=0.094 //l=0.22 //layer=ply \
 //thickness=0.18 //x=3.935 //y=0.935 //x2=3.715 //y2=0.935
r358 (  95 102 ) resistor r=26.9307 //w=0.15 //l=0.106066 //layer=ply \
 //thickness=0.18 //x=3.97 //y=4.97 //x2=4.045 //y2=5.045
r359 (  95 96 ) resistor r=148.702 //w=0.094 //l=0.29 //layer=ply \
 //thickness=0.18 //x=3.97 //y=4.97 //x2=3.68 //y2=4.97
r360 (  92 96 ) resistor r=23.403 //w=0.284 //l=0.106066 //layer=ply \
 //thickness=0.18 //x=3.605 //y=5.045 //x2=3.68 //y2=4.97
r361 (  92 130 ) resistor r=26.3063 //w=0.284 //l=0.229783 //layer=ply \
 //thickness=0.18 //x=3.605 //y=5.045 //x2=3.45 //y2=4.88
r362 (  91 128 ) resistor r=19.1248 //w=0.302 //l=0.165 //layer=ply \
 //thickness=0.18 //x=3.56 //y=2.1 //x2=3.56 //y2=2.265
r363 (  90 132 ) resistor r=39.5823 //w=0.21 //l=0.173853 //layer=ply \
 //thickness=0.18 //x=3.56 //y=1.745 //x2=3.6 //y2=1.59
r364 (  90 91 ) resistor r=182.032 //w=0.094 //l=0.355 //layer=ply \
 //thickness=0.18 //x=3.56 //y=1.745 //x2=3.56 //y2=2.1
r365 (  89 132 ) resistor r=39.5823 //w=0.21 //l=0.173853 //layer=ply \
 //thickness=0.18 //x=3.56 //y=1.435 //x2=3.6 //y2=1.59
r366 (  88 131 ) resistor r=45.1352 //w=0.168 //l=0.173853 //layer=ply \
 //thickness=0.18 //x=3.56 //y=1.09 //x2=3.6 //y2=0.935
r367 (  88 89 ) resistor r=176.904 //w=0.094 //l=0.345 //layer=ply \
 //thickness=0.18 //x=3.56 //y=1.09 //x2=3.56 //y2=1.435
r368 (  87 121 ) resistor r=592.245 //w=0.094 //l=1.155 //layer=ply \
 //thickness=0.18 //x=12.81 //y=6.2 //x2=12.81 //y2=5.045
r369 (  86 143 ) resistor r=592.245 //w=0.094 //l=1.155 //layer=ply \
 //thickness=0.18 //x=12.37 //y=6.2 //x2=12.37 //y2=5.045
r370 (  85 102 ) resistor r=592.245 //w=0.094 //l=1.155 //layer=ply \
 //thickness=0.18 //x=4.045 //y=6.2 //x2=4.045 //y2=5.045
r371 (  84 92 ) resistor r=592.245 //w=0.094 //l=1.155 //layer=ply \
 //thickness=0.18 //x=3.605 //y=6.2 //x2=3.605 //y2=5.045
r372 (  83 118 ) resistor r=56.4043 //w=0.094 //l=0.11 //layer=ply \
 //thickness=0.18 //x=12.63 //y=1.585 //x2=12.74 //y2=1.585
r373 (  83 119 ) resistor r=56.4043 //w=0.094 //l=0.11 //layer=ply \
 //thickness=0.18 //x=12.63 //y=1.585 //x2=12.52 //y2=1.585
r374 (  82 99 ) resistor r=56.4043 //w=0.094 //l=0.11 //layer=ply \
 //thickness=0.18 //x=3.825 //y=1.59 //x2=3.935 //y2=1.59
r375 (  82 100 ) resistor r=56.4043 //w=0.094 //l=0.11 //layer=ply \
 //thickness=0.18 //x=3.825 //y=1.59 //x2=3.715 //y2=1.59
r376 (  78 140 ) resistor r=152 //w=0.17 //l=0.17 //layer=licon //count=1 \
 //x=12.36 //y=4.88 //x2=12.36 //y2=4.88
r377 (  69 136 ) resistor r=152 //w=0.17 //l=0.17 //layer=licon //count=1 \
 //x=12.33 //y=2.26 //x2=12.33 //y2=2.26
r378 (  64 130 ) resistor r=152 //w=0.17 //l=0.17 //layer=licon //count=1 \
 //x=3.45 //y=4.88 //x2=3.45 //y2=4.88
r379 (  55 127 ) resistor r=152 //w=0.17 //l=0.17 //layer=licon //count=1 \
 //x=3.45 //y=2.265 //x2=3.45 //y2=2.265
r380 (  51 52 ) resistor r=0.10734 //w=0.281 //l=0.16 //layer=m2 \
 //thickness=0.36 //x=12.325 //y=4.265 //x2=12.165 //y2=4.265
r381 (  46 48 ) resistor r=0.10734 //w=0.281 //l=0.16 //layer=m2 \
 //thickness=0.36 //x=3.61 //y=4.25 //x2=3.45 //y2=4.25
r382 (  46 52 ) resistor r=8.16317 //w=0.131 //l=8.555 //layer=m2 \
 //thickness=0.36 //x=3.61 //y=4.25 //x2=12.165 //y2=4.25
r383 (  44 78 ) resistor r=9.3 //w=0.17 //l=0.17 //layer=mcon //count=1 \
 //x=12.36 //y=4.88 //x2=12.36 //y2=4.88
r384 (  40 69 ) resistor r=9.3 //w=0.17 //l=0.17 //layer=mcon //count=1 \
 //x=12.33 //y=2.26 //x2=12.33 //y2=2.26
r385 (  40 42 ) resistor r=0.0936408 //w=0.196 //l=0.125 //layer=m1 \
 //thickness=0.36 //x=12.332 //y=2.26 //x2=12.332 //y2=2.385
r386 (  38 51 ) resistor r=4.5 //w=0.15 //l=0.15 //layer=via1 //count=1 \
 //x=12.325 //y=4.265 //x2=12.325 //y2=4.265
r387 (  31 64 ) resistor r=9.3 //w=0.17 //l=0.17 //layer=mcon //count=1 \
 //x=3.45 //y=4.88 //x2=3.45 //y2=4.88
r388 (  28 55 ) resistor r=9.3 //w=0.17 //l=0.17 //layer=mcon //count=1 \
 //x=3.45 //y=2.265 //x2=3.45 //y2=2.265
r389 (  25 44 ) resistor r=0.0878548 //w=0.228 //l=0.159295 //layer=m1 \
 //thickness=0.36 //x=12.33 //y=4.735 //x2=12.36 //y2=4.88
r390 (  24 38 ) resistor r=0.0910802 //w=0.374 //l=0.185472 //layer=m1 \
 //thickness=0.36 //x=12.33 //y=4.425 //x2=12.275 //y2=4.265
r391 (  17 31 ) resistor r=0.0732479 //w=0.241 //l=0.122474 //layer=m1 \
 //thickness=0.36 //x=3.45 //y=4.76 //x2=3.455 //y2=4.88
r392 (  11 28 ) resistor r=0.116051 //w=0.211 //l=0.165 //layer=m1 \
 //thickness=0.36 //x=3.45 //y=2.43 //x2=3.45 //y2=2.265
r393 (  10 38 ) resistor r=0.00501337 //w=0.374 //l=0.015 //layer=m1 \
 //thickness=0.36 //x=12.275 //y=4.25 //x2=12.275 //y2=4.265
r394 (  10 20 ) resistor r=0.0860668 //w=0.374 //l=0.170294 //layer=m1 \
 //thickness=0.36 //x=12.275 //y=4.25 //x2=12.33 //y2=4.105
r395 (  9 48 ) resistor r=4.5 //w=0.15 //l=0.15 //layer=via1 //count=1 \
 //x=3.45 //y=4.25 //x2=3.45 //y2=4.25
r396 (  9 16 ) resistor r=0.0911593 //w=0.376 //l=0.184174 //layer=m1 \
 //thickness=0.36 //x=3.502 //y=4.25 //x2=3.45 //y2=4.41
r397 (  9 12 ) resistor r=0.0911593 //w=0.376 //l=0.184174 //layer=m1 \
 //thickness=0.36 //x=3.502 //y=4.25 //x2=3.45 //y2=4.09
r398 (  8 25 ) resistor r=0.109733 //w=0.131 //l=0.115 //layer=m1 \
 //thickness=0.36 //x=12.33 //y=4.62 //x2=12.33 //y2=4.735
r399 (  8 24 ) resistor r=0.186069 //w=0.131 //l=0.195 //layer=m1 \
 //thickness=0.36 //x=12.33 //y=4.62 //x2=12.33 //y2=4.425
r400 (  7 20 ) resistor r=0.567748 //w=0.131 //l=0.595 //layer=m1 \
 //thickness=0.36 //x=12.33 //y=3.51 //x2=12.33 //y2=4.105
r401 (  6 7 ) resistor r=0.353053 //w=0.131 //l=0.37 //layer=m1 \
 //thickness=0.36 //x=12.33 //y=3.14 //x2=12.33 //y2=3.51
r402 (  5 6 ) resistor r=0.353053 //w=0.131 //l=0.37 //layer=m1 \
 //thickness=0.36 //x=12.33 //y=2.77 //x2=12.33 //y2=3.14
r403 (  5 42 ) resistor r=0.367366 //w=0.131 //l=0.385 //layer=m1 \
 //thickness=0.36 //x=12.33 //y=2.77 //x2=12.33 //y2=2.385
r404 (  4 17 ) resistor r=0.133588 //w=0.131 //l=0.14 //layer=m1 \
 //thickness=0.36 //x=3.45 //y=4.62 //x2=3.45 //y2=4.76
r405 (  4 16 ) resistor r=0.200382 //w=0.131 //l=0.21 //layer=m1 \
 //thickness=0.36 //x=3.45 //y=4.62 //x2=3.45 //y2=4.41
r406 (  3 12 ) resistor r=0.200382 //w=0.131 //l=0.21 //layer=m1 \
 //thickness=0.36 //x=3.45 //y=3.88 //x2=3.45 //y2=4.09
r407 (  2 3 ) resistor r=0.353053 //w=0.131 //l=0.37 //layer=m1 \
 //thickness=0.36 //x=3.45 //y=3.51 //x2=3.45 //y2=3.88
r408 (  1 2 ) resistor r=0.706107 //w=0.131 //l=0.74 //layer=m1 \
 //thickness=0.36 //x=3.45 //y=2.77 //x2=3.45 //y2=3.51
r409 (  1 11 ) resistor r=0.324427 //w=0.131 //l=0.34 //layer=m1 \
 //thickness=0.36 //x=3.45 //y=2.77 //x2=3.45 //y2=2.43
ends PM_DLATCHN\%D

subckt PM_DLATCHN\%noxref_5 ( 3 8 9 11 12 14 15 16 18 19 20 23 24 27 29 32 35 \
 38 42 43 48 51 59 76 85 89 90 91 92 93 94 95 99 100 101 103 109 110 112 120 \
 122 123 )
c258 ( 120 0 ) capacitor c=0.00878249f //x=12.44 //y=1.085
c259 ( 112 0 ) capacitor c=0.0545922f //x=14.55 //y=2.265
c260 ( 110 0 ) capacitor c=0.0439576f //x=15.19 //y=1.435
c261 ( 109 0 ) capacitor c=0.0201087f //x=15.19 //y=1.09
c262 ( 103 0 ) capacitor c=0.0161986f //x=15.035 //y=1.59
c263 ( 101 0 ) capacitor c=0.0157807f //x=15.035 //y=0.935
c264 ( 100 0 ) capacitor c=0.055513f //x=14.78 //y=4.97
c265 ( 99 0 ) capacitor c=0.039162f //x=15.07 //y=4.97
c266 ( 95 0 ) capacitor c=0.0301471f //x=14.66 //y=2.1
c267 ( 94 0 ) capacitor c=0.0255349f //x=14.66 //y=1.745
c268 ( 93 0 ) capacitor c=0.0234346f //x=14.66 //y=1.435
c269 ( 92 0 ) capacitor c=0.02013f //x=14.66 //y=1.09
c270 ( 91 0 ) capacitor c=0.153927f //x=15.145 //y=6.2
c271 ( 90 0 ) capacitor c=0.154397f //x=14.705 //y=6.2
c272 ( 85 0 ) capacitor c=9.4527e-19 //x=14.55 //y=4.88
c273 ( 76 0 ) capacitor c=9.11699e-19 //x=14.55 //y=2.265
c274 ( 59 0 ) capacitor c=0.0321204f //x=12.59 //y=5.56
c275 ( 51 0 ) capacitor c=0.0289608f //x=11.71 //y=5.56
c276 ( 48 0 ) capacitor c=0.00220219f //x=14.545 //y=3.51
c277 ( 43 0 ) capacitor c=0.00305592f //x=13.23 //y=3.51
c278 ( 42 0 ) capacitor c=0.0369863f //x=14.385 //y=3.51
c279 ( 38 0 ) capacitor c=0.00754811f //x=14.55 //y=2.265
c280 ( 35 0 ) capacitor c=0.0159873f //x=14.545 //y=3.51
c281 ( 32 0 ) capacitor c=0.0165963f //x=13.07 //y=3.51
c282 ( 29 0 ) capacitor c=0.0114519f //x=12.63 //y=1.18
c283 ( 27 0 ) capacitor c=7.81299e-19 //x=12.59 //y=5.56
c284 ( 24 0 ) capacitor c=0.0115324f //x=12.59 //y=5.38
c285 ( 23 0 ) capacitor c=0.00954491f //x=11.71 //y=5.56
c286 ( 20 0 ) capacitor c=0.0285769f //x=14.55 //y=4.76
c287 ( 19 0 ) capacitor c=0.0125679f //x=14.55 //y=3.67
c288 ( 18 0 ) capacitor c=0.0237855f //x=14.55 //y=3.35
c289 ( 16 0 ) capacitor c=0.0373371f //x=13.07 //y=5.295
c290 ( 15 0 ) capacitor c=0.013044f //x=13.07 //y=3.67
c291 ( 14 0 ) capacitor c=0.0348076f //x=13.07 //y=3.35
c292 ( 12 0 ) capacitor c=0.00681098f //x=12.715 //y=1.835
c293 ( 11 0 ) capacitor c=0.0138793f //x=12.985 //y=1.835
c294 ( 9 0 ) capacitor c=0.0119101f //x=12.985 //y=5.38
c295 ( 8 0 ) capacitor c=0.0090797f //x=12.63 //y=1.75
c296 ( 3 0 ) capacitor c=0.0136519f //x=12.475 //y=5.38
r297 (  112 113 ) resistor r=17.5563 //w=0.302 //l=0.11 //layer=ply \
 //thickness=0.18 //x=14.55 //y=2.265 //x2=14.66 //y2=2.265
r298 (  110 119 ) resistor r=45.1352 //w=0.168 //l=0.173853 //layer=ply \
 //thickness=0.18 //x=15.19 //y=1.435 //x2=15.15 //y2=1.59
r299 (  109 118 ) resistor r=45.1352 //w=0.168 //l=0.173853 //layer=ply \
 //thickness=0.18 //x=15.19 //y=1.09 //x2=15.15 //y2=0.935
r300 (  109 110 ) resistor r=176.904 //w=0.094 //l=0.345 //layer=ply \
 //thickness=0.18 //x=15.19 //y=1.09 //x2=15.19 //y2=1.435
r301 (  104 117 ) resistor r=10.701 //w=0.21 //l=0.115 //layer=ply \
 //thickness=0.18 //x=14.815 //y=1.59 //x2=14.7 //y2=1.59
r302 (  103 119 ) resistor r=5.52526 //w=0.168 //l=0.115 //layer=ply \
 //thickness=0.18 //x=15.035 //y=1.59 //x2=15.15 //y2=1.59
r303 (  102 116 ) resistor r=5.52526 //w=0.168 //l=0.115 //layer=ply \
 //thickness=0.18 //x=14.815 //y=0.935 //x2=14.7 //y2=0.935
r304 (  101 118 ) resistor r=5.52526 //w=0.168 //l=0.115 //layer=ply \
 //thickness=0.18 //x=15.035 //y=0.935 //x2=15.15 //y2=0.935
r305 (  101 102 ) resistor r=112.809 //w=0.094 //l=0.22 //layer=ply \
 //thickness=0.18 //x=15.035 //y=0.935 //x2=14.815 //y2=0.935
r306 (  99 106 ) resistor r=26.9307 //w=0.15 //l=0.106066 //layer=ply \
 //thickness=0.18 //x=15.07 //y=4.97 //x2=15.145 //y2=5.045
r307 (  99 100 ) resistor r=148.702 //w=0.094 //l=0.29 //layer=ply \
 //thickness=0.18 //x=15.07 //y=4.97 //x2=14.78 //y2=4.97
r308 (  96 100 ) resistor r=23.403 //w=0.284 //l=0.106066 //layer=ply \
 //thickness=0.18 //x=14.705 //y=5.045 //x2=14.78 //y2=4.97
r309 (  96 115 ) resistor r=26.3063 //w=0.284 //l=0.229783 //layer=ply \
 //thickness=0.18 //x=14.705 //y=5.045 //x2=14.55 //y2=4.88
r310 (  95 113 ) resistor r=19.1248 //w=0.302 //l=0.165 //layer=ply \
 //thickness=0.18 //x=14.66 //y=2.1 //x2=14.66 //y2=2.265
r311 (  94 117 ) resistor r=39.5823 //w=0.21 //l=0.173853 //layer=ply \
 //thickness=0.18 //x=14.66 //y=1.745 //x2=14.7 //y2=1.59
r312 (  94 95 ) resistor r=182.032 //w=0.094 //l=0.355 //layer=ply \
 //thickness=0.18 //x=14.66 //y=1.745 //x2=14.66 //y2=2.1
r313 (  93 117 ) resistor r=39.5823 //w=0.21 //l=0.173853 //layer=ply \
 //thickness=0.18 //x=14.66 //y=1.435 //x2=14.7 //y2=1.59
r314 (  92 116 ) resistor r=45.1352 //w=0.168 //l=0.173853 //layer=ply \
 //thickness=0.18 //x=14.66 //y=1.09 //x2=14.7 //y2=0.935
r315 (  92 93 ) resistor r=176.904 //w=0.094 //l=0.345 //layer=ply \
 //thickness=0.18 //x=14.66 //y=1.09 //x2=14.66 //y2=1.435
r316 (  91 106 ) resistor r=592.245 //w=0.094 //l=1.155 //layer=ply \
 //thickness=0.18 //x=15.145 //y=6.2 //x2=15.145 //y2=5.045
r317 (  90 96 ) resistor r=592.245 //w=0.094 //l=1.155 //layer=ply \
 //thickness=0.18 //x=14.705 //y=6.2 //x2=14.705 //y2=5.045
r318 (  89 103 ) resistor r=56.4043 //w=0.094 //l=0.11 //layer=ply \
 //thickness=0.18 //x=14.925 //y=1.59 //x2=15.035 //y2=1.59
r319 (  89 104 ) resistor r=56.4043 //w=0.094 //l=0.11 //layer=ply \
 //thickness=0.18 //x=14.925 //y=1.59 //x2=14.815 //y2=1.59
r320 (  85 115 ) resistor r=152 //w=0.17 //l=0.17 //layer=licon //count=1 \
 //x=14.55 //y=4.88 //x2=14.55 //y2=4.88
r321 (  76 112 ) resistor r=152 //w=0.17 //l=0.17 //layer=licon //count=1 \
 //x=14.55 //y=2.265 //x2=14.55 //y2=2.265
r322 (  59 123 ) resistor r=23.615 //w=0.187 //l=0.345 //layer=li \
 //thickness=0.1 //x=12.59 //y=5.56 //x2=12.59 //y2=5.905
r323 (  51 122 ) resistor r=23.615 //w=0.187 //l=0.345 //layer=li \
 //thickness=0.1 //x=11.71 //y=5.56 //x2=11.71 //y2=5.905
r324 (  43 45 ) resistor r=0.10734 //w=0.281 //l=0.16 //layer=m2 \
 //thickness=0.36 //x=13.23 //y=3.51 //x2=13.07 //y2=3.51
r325 (  42 48 ) resistor r=0.10734 //w=0.281 //l=0.16 //layer=m2 \
 //thickness=0.36 //x=14.385 //y=3.51 //x2=14.545 //y2=3.51
r326 (  42 43 ) resistor r=1.1021 //w=0.131 //l=1.155 //layer=m2 \
 //thickness=0.36 //x=14.385 //y=3.51 //x2=13.23 //y2=3.51
r327 (  41 85 ) resistor r=9.3 //w=0.17 //l=0.17 //layer=mcon //count=1 \
 //x=14.55 //y=4.88 //x2=14.55 //y2=4.88
r328 (  38 76 ) resistor r=9.3 //w=0.17 //l=0.17 //layer=mcon //count=1 \
 //x=14.55 //y=2.265 //x2=14.55 //y2=2.265
r329 (  35 48 ) resistor r=4.5 //w=0.15 //l=0.15 //layer=via1 //count=1 \
 //x=14.545 //y=3.51 //x2=14.545 //y2=3.51
r330 (  32 45 ) resistor r=4.5 //w=0.15 //l=0.15 //layer=via1 //count=1 \
 //x=13.07 //y=3.51 //x2=13.07 //y2=3.51
r331 (  29 120 ) resistor r=9.3 //w=0.17 //l=0.17 //layer=mcon //count=1 \
 //x=12.63 //y=1.18 //x2=12.63 //y2=1.18
r332 (  27 59 ) resistor r=9.3 //w=0.17 //l=0.17 //layer=mcon //count=1 \
 //x=12.59 //y=5.56 //x2=12.59 //y2=5.56
r333 (  24 27 ) resistor r=0.117801 //w=0.191 //l=0.18 //layer=m1 \
 //thickness=0.36 //x=12.59 //y=5.38 //x2=12.59 //y2=5.56
r334 (  23 51 ) resistor r=9.3 //w=0.17 //l=0.17 //layer=mcon //count=1 \
 //x=11.71 //y=5.56 //x2=11.71 //y2=5.56
r335 (  21 23 ) resistor r=0.10274 //w=0.219 //l=0.18 //layer=m1 \
 //thickness=0.36 //x=11.71 //y=5.38 //x2=11.71 //y2=5.56
r336 (  20 41 ) resistor r=0.0732479 //w=0.241 //l=0.122474 //layer=m1 \
 //thickness=0.36 //x=14.55 //y=4.76 //x2=14.555 //y2=4.88
r337 (  19 35 ) resistor r=0.0910802 //w=0.374 //l=0.185472 //layer=m1 \
 //thickness=0.36 //x=14.55 //y=3.67 //x2=14.495 //y2=3.51
r338 (  19 20 ) resistor r=1.04008 //w=0.131 //l=1.09 //layer=m1 \
 //thickness=0.36 //x=14.55 //y=3.67 //x2=14.55 //y2=4.76
r339 (  18 35 ) resistor r=0.0910802 //w=0.374 //l=0.185472 //layer=m1 \
 //thickness=0.36 //x=14.55 //y=3.35 //x2=14.495 //y2=3.51
r340 (  17 38 ) resistor r=0.116051 //w=0.211 //l=0.165 //layer=m1 \
 //thickness=0.36 //x=14.55 //y=2.43 //x2=14.55 //y2=2.265
r341 (  17 18 ) resistor r=0.877863 //w=0.131 //l=0.92 //layer=m1 \
 //thickness=0.36 //x=14.55 //y=2.43 //x2=14.55 //y2=3.35
r342 (  15 32 ) resistor r=0.0911593 //w=0.376 //l=0.184174 //layer=m1 \
 //thickness=0.36 //x=13.07 //y=3.67 //x2=13.122 //y2=3.51
r343 (  15 16 ) resistor r=1.55057 //w=0.131 //l=1.625 //layer=m1 \
 //thickness=0.36 //x=13.07 //y=3.67 //x2=13.07 //y2=5.295
r344 (  14 32 ) resistor r=0.0911593 //w=0.376 //l=0.184174 //layer=m1 \
 //thickness=0.36 //x=13.07 //y=3.35 //x2=13.122 //y2=3.51
r345 (  13 14 ) resistor r=1.3645 //w=0.131 //l=1.43 //layer=m1 \
 //thickness=0.36 //x=13.07 //y=1.92 //x2=13.07 //y2=3.35
r346 (  11 13 ) resistor r=0.0698411 //w=0.17 //l=0.120208 //layer=m1 \
 //thickness=0.36 //x=12.985 //y=1.835 //x2=13.07 //y2=1.92
r347 (  11 12 ) resistor r=0.257634 //w=0.131 //l=0.27 //layer=m1 \
 //thickness=0.36 //x=12.985 //y=1.835 //x2=12.715 //y2=1.835
r348 (  10 24 ) resistor r=0.0257089 //w=0.23 //l=0.115 //layer=m1 \
 //thickness=0.36 //x=12.705 //y=5.38 //x2=12.59 //y2=5.38
r349 (  9 16 ) resistor r=0.0698411 //w=0.17 //l=0.120208 //layer=m1 \
 //thickness=0.36 //x=12.985 //y=5.38 //x2=13.07 //y2=5.295
r350 (  9 10 ) resistor r=0.267176 //w=0.131 //l=0.28 //layer=m1 \
 //thickness=0.36 //x=12.985 //y=5.38 //x2=12.705 //y2=5.38
r351 (  8 12 ) resistor r=0.0698411 //w=0.17 //l=0.120208 //layer=m1 \
 //thickness=0.36 //x=12.63 //y=1.75 //x2=12.715 //y2=1.835
r352 (  7 29 ) resistor r=0.0913624 //w=0.191 //l=0.12 //layer=m1 \
 //thickness=0.36 //x=12.63 //y=1.3 //x2=12.63 //y2=1.18
r353 (  7 8 ) resistor r=0.429389 //w=0.131 //l=0.45 //layer=m1 \
 //thickness=0.36 //x=12.63 //y=1.3 //x2=12.63 //y2=1.75
r354 (  4 21 ) resistor r=0.0227762 //w=0.219 //l=0.115 //layer=m1 \
 //thickness=0.36 //x=11.825 //y=5.38 //x2=11.71 //y2=5.38
r355 (  3 24 ) resistor r=0.0257089 //w=0.23 //l=0.115 //layer=m1 \
 //thickness=0.36 //x=12.475 //y=5.38 //x2=12.59 //y2=5.38
r356 (  3 4 ) resistor r=0.620229 //w=0.131 //l=0.65 //layer=m1 \
 //thickness=0.36 //x=12.475 //y=5.38 //x2=11.825 //y2=5.38
ends PM_DLATCHN\%noxref_5

subckt PM_DLATCHN\%noxref_6 ( 2 4 5 6 7 8 10 11 12 14 15 16 18 25 29 31 35 37 \
 39 41 43 48 57 69 74 82 83 84 85 86 87 88 92 94 97 99 100 105 115 117 )
c299 ( 115 0 ) capacitor c=0.00875839f //x=9.185 //y=1.09
c300 ( 105 0 ) capacitor c=0.041107f //x=16.985 //y=4.885
c301 ( 100 0 ) capacitor c=0.0337825f //x=17.475 //y=1.43
c302 ( 99 0 ) capacitor c=0.0183823f //x=17.475 //y=1.085
c303 ( 97 0 ) capacitor c=0.0344046f //x=17.405 //y=4.975
c304 ( 94 0 ) capacitor c=0.013578f //x=17.32 //y=1.585
c305 ( 92 0 ) capacitor c=0.0157803f //x=17.32 //y=0.93
c306 ( 88 0 ) capacitor c=0.085272f //x=16.945 //y=2.095
c307 ( 87 0 ) capacitor c=0.0230165f //x=16.945 //y=1.74
c308 ( 86 0 ) capacitor c=0.0234348f //x=16.945 //y=1.43
c309 ( 85 0 ) capacitor c=0.019134f //x=16.945 //y=1.085
c310 ( 84 0 ) capacitor c=0.110994f //x=17.48 //y=6.205
c311 ( 83 0 ) capacitor c=0.154777f //x=17.04 //y=6.205
c312 ( 74 0 ) capacitor c=7.43216e-19 //x=17.14 //y=2.26
c313 ( 69 0 ) capacitor c=0.0070524f //x=16.985 //y=4.885
c314 ( 57 0 ) capacitor c=0.0261756f //x=9.375 //y=5.56
c315 ( 48 0 ) capacitor c=6.46644e-19 //x=9.9 //y=3.865
c316 ( 43 0 ) capacitor c=0.0817668f //x=14.76 //y=3.895
c317 ( 41 0 ) capacitor c=0.031956f //x=14.16 //y=3.88
c318 ( 39 0 ) capacitor c=0.0132735f //x=13.285 //y=3.895
c319 ( 37 0 ) capacitor c=0.0593419f //x=12.685 //y=3.88
c320 ( 35 0 ) capacitor c=0.009279f //x=16.985 //y=4.885
c321 ( 31 0 ) capacitor c=0.00674761f //x=17.14 //y=2.26
c322 ( 29 0 ) capacitor c=0.0151323f //x=17.14 //y=3.88
c323 ( 25 0 ) capacitor c=0.0159903f //x=9.74 //y=3.88
c324 ( 18 0 ) capacitor c=0.015253f //x=9.37 //y=1.185
c325 ( 16 0 ) capacitor c=0.0177264f //x=17.14 //y=4.765
c326 ( 15 0 ) capacitor c=0.0110628f //x=17.14 //y=4.025
c327 ( 14 0 ) capacitor c=0.0396888f //x=17.14 //y=3.705
c328 ( 12 0 ) capacitor c=0.0211592f //x=9.74 //y=5.055
c329 ( 11 0 ) capacitor c=0.0128696f //x=9.74 //y=4.025
c330 ( 10 0 ) capacitor c=0.0383669f //x=9.74 //y=3.705
c331 ( 8 0 ) capacitor c=0.00475217f //x=9.46 //y=5.14
c332 ( 7 0 ) capacitor c=0.00730223f //x=9.655 //y=5.14
c333 ( 6 0 ) capacitor c=0.00649906f //x=9.455 //y=2.02
c334 ( 5 0 ) capacitor c=0.0122561f //x=9.655 //y=2.02
c335 ( 4 0 ) capacitor c=0.010593f //x=9.375 //y=5.42
c336 ( 2 0 ) capacitor c=0.0122563f //x=9.37 //y=1.935
r337 (  107 108 ) resistor r=32.4568 //w=0.214 //l=0.075 //layer=ply \
 //thickness=0.18 //x=16.985 //y=4.975 //x2=16.985 //y2=5.05
r338 (  105 107 ) resistor r=20.271 //w=0.214 //l=0.09 //layer=ply \
 //thickness=0.18 //x=16.985 //y=4.885 //x2=16.985 //y2=4.975
r339 (  100 114 ) resistor r=45.1352 //w=0.168 //l=0.173853 //layer=ply \
 //thickness=0.18 //x=17.475 //y=1.43 //x2=17.435 //y2=1.585
r340 (  99 113 ) resistor r=45.1352 //w=0.168 //l=0.173853 //layer=ply \
 //thickness=0.18 //x=17.475 //y=1.085 //x2=17.435 //y2=0.93
r341 (  99 100 ) resistor r=176.904 //w=0.094 //l=0.345 //layer=ply \
 //thickness=0.18 //x=17.475 //y=1.085 //x2=17.475 //y2=1.43
r342 (  98 107 ) resistor r=16.5046 //w=0.27 //l=0.135 //layer=ply \
 //thickness=0.18 //x=17.12 //y=4.975 //x2=16.985 //y2=4.975
r343 (  97 101 ) resistor r=26.9307 //w=0.15 //l=0.106066 //layer=ply \
 //thickness=0.18 //x=17.405 //y=4.975 //x2=17.48 //y2=5.05
r344 (  97 98 ) resistor r=146.138 //w=0.094 //l=0.285 //layer=ply \
 //thickness=0.18 //x=17.405 //y=4.975 //x2=17.12 //y2=4.975
r345 (  95 112 ) resistor r=10.701 //w=0.21 //l=0.115 //layer=ply \
 //thickness=0.18 //x=17.1 //y=1.585 //x2=16.985 //y2=1.585
r346 (  94 114 ) resistor r=5.52526 //w=0.168 //l=0.115 //layer=ply \
 //thickness=0.18 //x=17.32 //y=1.585 //x2=17.435 //y2=1.585
r347 (  93 111 ) resistor r=5.52526 //w=0.168 //l=0.115 //layer=ply \
 //thickness=0.18 //x=17.1 //y=0.93 //x2=16.985 //y2=0.93
r348 (  92 113 ) resistor r=5.52526 //w=0.168 //l=0.115 //layer=ply \
 //thickness=0.18 //x=17.32 //y=0.93 //x2=17.435 //y2=0.93
r349 (  92 93 ) resistor r=112.809 //w=0.094 //l=0.22 //layer=ply \
 //thickness=0.18 //x=17.32 //y=0.93 //x2=17.1 //y2=0.93
r350 (  88 110 ) resistor r=34.8111 //w=0.27 //l=0.264953 //layer=ply \
 //thickness=0.18 //x=16.945 //y=2.095 //x2=17.14 //y2=2.26
r351 (  87 112 ) resistor r=39.5823 //w=0.21 //l=0.173853 //layer=ply \
 //thickness=0.18 //x=16.945 //y=1.74 //x2=16.985 //y2=1.585
r352 (  87 88 ) resistor r=182.032 //w=0.094 //l=0.355 //layer=ply \
 //thickness=0.18 //x=16.945 //y=1.74 //x2=16.945 //y2=2.095
r353 (  86 112 ) resistor r=39.5823 //w=0.21 //l=0.173853 //layer=ply \
 //thickness=0.18 //x=16.945 //y=1.43 //x2=16.985 //y2=1.585
r354 (  85 111 ) resistor r=45.1352 //w=0.168 //l=0.173853 //layer=ply \
 //thickness=0.18 //x=16.945 //y=1.085 //x2=16.985 //y2=0.93
r355 (  85 86 ) resistor r=176.904 //w=0.094 //l=0.345 //layer=ply \
 //thickness=0.18 //x=16.945 //y=1.085 //x2=16.945 //y2=1.43
r356 (  84 101 ) resistor r=592.245 //w=0.094 //l=1.155 //layer=ply \
 //thickness=0.18 //x=17.48 //y=6.205 //x2=17.48 //y2=5.05
r357 (  83 108 ) resistor r=592.245 //w=0.094 //l=1.155 //layer=ply \
 //thickness=0.18 //x=17.04 //y=6.205 //x2=17.04 //y2=5.05
r358 (  82 94 ) resistor r=56.4043 //w=0.094 //l=0.11 //layer=ply \
 //thickness=0.18 //x=17.21 //y=1.585 //x2=17.32 //y2=1.585
r359 (  82 95 ) resistor r=56.4043 //w=0.094 //l=0.11 //layer=ply \
 //thickness=0.18 //x=17.21 //y=1.585 //x2=17.1 //y2=1.585
r360 (  74 110 ) resistor r=152 //w=0.17 //l=0.17 //layer=licon //count=1 \
 //x=17.14 //y=2.26 //x2=17.14 //y2=2.26
r361 (  69 105 ) resistor r=152 //w=0.17 //l=0.17 //layer=licon //count=1 \
 //x=16.985 //y=4.885 //x2=16.985 //y2=4.885
r362 (  57 117 ) resistor r=23.615 //w=0.187 //l=0.345 //layer=li \
 //thickness=0.1 //x=9.375 //y=5.56 //x2=9.375 //y2=5.905
r363 (  46 48 ) resistor r=0.10734 //w=0.281 //l=0.16 //layer=m2 \
 //thickness=0.36 //x=9.74 //y=3.865 //x2=9.9 //y2=3.865
r364 (  43 50 ) resistor r=1.5723 //w=0.189 //l=2.38995 //layer=m2 \
 //thickness=0.36 //x=14.76 //y=3.895 //x2=17.135 //y2=3.865
r365 (  43 44 ) resistor r=0.329198 //w=0.131 //l=0.345 //layer=m2 \
 //thickness=0.36 //x=14.76 //y=3.895 //x2=14.415 //y2=3.895
r366 (  41 44 ) resistor r=0.1875 //w=0.17 //l=0.262393 //layer=m2 \
 //thickness=0.36 //x=14.16 //y=3.88 //x2=14.415 //y2=3.895
r367 (  41 42 ) resistor r=0.67271 //w=0.131 //l=0.705 //layer=m2 \
 //thickness=0.36 //x=14.16 //y=3.88 //x2=13.455 //y2=3.88
r368 (  39 42 ) resistor r=0.125 //w=0.17 //l=0.177341 //layer=m2 \
 //thickness=0.36 //x=13.285 //y=3.895 //x2=13.455 //y2=3.88
r369 (  39 40 ) resistor r=0.329198 //w=0.131 //l=0.345 //layer=m2 \
 //thickness=0.36 //x=13.285 //y=3.895 //x2=12.94 //y2=3.895
r370 (  37 40 ) resistor r=0.1875 //w=0.17 //l=0.262393 //layer=m2 \
 //thickness=0.36 //x=12.685 //y=3.88 //x2=12.94 //y2=3.895
r371 (  37 48 ) resistor r=2.65744 //w=0.131 //l=2.785 //layer=m2 \
 //thickness=0.36 //x=12.685 //y=3.88 //x2=9.9 //y2=3.88
r372 (  35 69 ) resistor r=9.3 //w=0.17 //l=0.17 //layer=mcon //count=1 \
 //x=16.985 //y=4.885 //x2=16.985 //y2=4.885
r373 (  35 36 ) resistor r=0.0853524 //w=0.227 //l=0.155 //layer=m1 \
 //thickness=0.36 //x=16.985 //y=4.882 //x2=17.14 //y2=4.882
r374 (  31 74 ) resistor r=9.3 //w=0.17 //l=0.17 //layer=mcon //count=1 \
 //x=17.14 //y=2.26 //x2=17.14 //y2=2.26
r375 (  31 33 ) resistor r=0.0985786 //w=0.206 //l=0.135 //layer=m1 \
 //thickness=0.36 //x=17.137 //y=2.26 //x2=17.137 //y2=2.395
r376 (  27 50 ) resistor r=4.5 //w=0.15 //l=0.15 //layer=via1 //count=1 \
 //x=17.135 //y=3.865 //x2=17.135 //y2=3.865
r377 (  27 29 ) resistor r=0.00501337 //w=0.374 //l=0.015 //layer=m1 \
 //thickness=0.36 //x=17.085 //y=3.865 //x2=17.085 //y2=3.88
r378 (  23 46 ) resistor r=4.5 //w=0.15 //l=0.15 //layer=via1 //count=1 \
 //x=9.74 //y=3.865 //x2=9.74 //y2=3.865
r379 (  23 25 ) resistor r=0.0049867 //w=0.376 //l=0.015 //layer=m1 \
 //thickness=0.36 //x=9.792 //y=3.865 //x2=9.792 //y2=3.88
r380 (  21 57 ) resistor r=9.3 //w=0.17 //l=0.17 //layer=mcon //count=1 \
 //x=9.375 //y=5.56 //x2=9.375 //y2=5.56
r381 (  18 115 ) resistor r=9.3 //w=0.17 //l=0.17 //layer=mcon //count=1 \
 //x=9.37 //y=1.185 //x2=9.37 //y2=1.185
r382 (  16 36 ) resistor r=0.0249239 //w=0.227 //l=0.117 //layer=m1 \
 //thickness=0.36 //x=17.14 //y=4.765 //x2=17.14 //y2=4.882
r383 (  15 29 ) resistor r=0.0860668 //w=0.374 //l=0.170294 //layer=m1 \
 //thickness=0.36 //x=17.14 //y=4.025 //x2=17.085 //y2=3.88
r384 (  15 16 ) resistor r=0.706107 //w=0.131 //l=0.74 //layer=m1 \
 //thickness=0.36 //x=17.14 //y=4.025 //x2=17.14 //y2=4.765
r385 (  14 27 ) resistor r=0.0910802 //w=0.374 //l=0.185472 //layer=m1 \
 //thickness=0.36 //x=17.14 //y=3.705 //x2=17.085 //y2=3.865
r386 (  14 33 ) resistor r=1.25 //w=0.131 //l=1.31 //layer=m1 //thickness=0.36 \
 //x=17.14 //y=3.705 //x2=17.14 //y2=2.395
r387 (  11 25 ) resistor r=0.0861726 //w=0.376 //l=0.169012 //layer=m1 \
 //thickness=0.36 //x=9.74 //y=4.025 //x2=9.792 //y2=3.88
r388 (  11 12 ) resistor r=0.982824 //w=0.131 //l=1.03 //layer=m1 \
 //thickness=0.36 //x=9.74 //y=4.025 //x2=9.74 //y2=5.055
r389 (  10 23 ) resistor r=0.0911593 //w=0.376 //l=0.184174 //layer=m1 \
 //thickness=0.36 //x=9.74 //y=3.705 //x2=9.792 //y2=3.865
r390 (  9 10 ) resistor r=1.52672 //w=0.131 //l=1.6 //layer=m1 \
 //thickness=0.36 //x=9.74 //y=2.105 //x2=9.74 //y2=3.705
r391 (  7 12 ) resistor r=0.0698411 //w=0.17 //l=0.120208 //layer=m1 \
 //thickness=0.36 //x=9.655 //y=5.14 //x2=9.74 //y2=5.055
r392 (  7 8 ) resistor r=0.186069 //w=0.131 //l=0.195 //layer=m1 \
 //thickness=0.36 //x=9.655 //y=5.14 //x2=9.46 //y2=5.14
r393 (  5 9 ) resistor r=0.0698411 //w=0.17 //l=0.120208 //layer=m1 \
 //thickness=0.36 //x=9.655 //y=2.02 //x2=9.74 //y2=2.105
r394 (  5 6 ) resistor r=0.19084 //w=0.131 //l=0.2 //layer=m1 //thickness=0.36 \
 //x=9.655 //y=2.02 //x2=9.455 //y2=2.02
r395 (  4 21 ) resistor r=0.086672 //w=0.218 //l=0.14 //layer=m1 \
 //thickness=0.36 //x=9.375 //y=5.42 //x2=9.375 //y2=5.56
r396 (  3 8 ) resistor r=0.0698411 //w=0.17 //l=0.120208 //layer=m1 \
 //thickness=0.36 //x=9.375 //y=5.225 //x2=9.46 //y2=5.14
r397 (  3 4 ) resistor r=0.186069 //w=0.131 //l=0.195 //layer=m1 \
 //thickness=0.36 //x=9.375 //y=5.225 //x2=9.375 //y2=5.42
r398 (  2 6 ) resistor r=0.0698411 //w=0.17 //l=0.120208 //layer=m1 \
 //thickness=0.36 //x=9.37 //y=1.935 //x2=9.455 //y2=2.02
r399 (  1 18 ) resistor r=0.105739 //w=0.201 //l=0.145 //layer=m1 \
 //thickness=0.36 //x=9.37 //y=1.33 //x2=9.37 //y2=1.185
r400 (  1 2 ) resistor r=0.57729 //w=0.131 //l=0.605 //layer=m1 \
 //thickness=0.36 //x=9.37 //y=1.33 //x2=9.37 //y2=1.935
ends PM_DLATCHN\%noxref_6

subckt PM_DLATCHN\%Q ( 1 2 3 4 5 6 7 8 9 10 11 12 13 14 15 16 17 19 26 34 39 \
 40 54 58 65 67 68 76 93 98 106 107 108 109 110 111 112 116 118 121 123 124 \
 129 139 140 143 )
c304 ( 140 0 ) capacitor c=0.00901091f //x=17.99 //y=1.085
c305 ( 139 0 ) capacitor c=0.00876479f //x=17.02 //y=1.085
c306 ( 129 0 ) capacitor c=0.0426341f //x=20.315 //y=4.885
c307 ( 124 0 ) capacitor c=0.0337825f //x=20.805 //y=1.43
c308 ( 123 0 ) capacitor c=0.0183823f //x=20.805 //y=1.085
c309 ( 121 0 ) capacitor c=0.0350928f //x=20.735 //y=4.975
c310 ( 118 0 ) capacitor c=0.013578f //x=20.65 //y=1.585
c311 ( 116 0 ) capacitor c=0.0157803f //x=20.65 //y=0.93
c312 ( 112 0 ) capacitor c=0.0826293f //x=20.275 //y=2.095
c313 ( 111 0 ) capacitor c=0.0230165f //x=20.275 //y=1.74
c314 ( 110 0 ) capacitor c=0.0234348f //x=20.275 //y=1.43
c315 ( 109 0 ) capacitor c=0.019134f //x=20.275 //y=1.085
c316 ( 108 0 ) capacitor c=0.110994f //x=20.81 //y=6.205
c317 ( 107 0 ) capacitor c=0.154777f //x=20.37 //y=6.205
c318 ( 98 0 ) capacitor c=7.43216e-19 //x=20.47 //y=2.26
c319 ( 93 0 ) capacitor c=0.0070524f //x=20.315 //y=4.885
c320 ( 76 0 ) capacitor c=0.0241851f //x=18.14 //y=5.56
c321 ( 68 0 ) capacitor c=0.0509039f //x=20.305 //y=3.495
c322 ( 67 0 ) capacitor c=0.00235966f //x=20.465 //y=3.495
c323 ( 65 0 ) capacitor c=0.0029374f //x=18.775 //y=3.495
c324 ( 58 0 ) capacitor c=0.00712184f //x=20.315 //y=4.885
c325 ( 54 0 ) capacitor c=0.00660165f //x=20.47 //y=2.26
c326 ( 40 0 ) capacitor c=0.0127946f //x=18.135 //y=5.39
c327 ( 39 0 ) capacitor c=0.00439923f //x=18.18 //y=1.835
c328 ( 34 0 ) capacitor c=0.0113724f //x=20.47 //y=3.655
c329 ( 26 0 ) capacitor c=0.0137382f //x=18.62 //y=3.655
c330 ( 19 0 ) capacitor c=0.0140296f //x=18.535 //y=1.835
c331 ( 17 0 ) capacitor c=0.0104198f //x=18.535 //y=5.39
c332 ( 16 0 ) capacitor c=0.00708518f //x=18.18 //y=1.75
c333 ( 15 0 ) capacitor c=0.00854148f //x=18.18 //y=1.3
c334 ( 14 0 ) capacitor c=0.00271708f //x=17.295 //y=1.835
c335 ( 13 0 ) capacitor c=0.0203551f //x=18.095 //y=1.835
c336 ( 12 0 ) capacitor c=0.00630911f //x=17.21 //y=1.75
c337 ( 11 0 ) capacitor c=0.00847965f //x=17.21 //y=1.305
c338 ( 10 0 ) capacitor c=0.0169762f //x=20.47 //y=3.51
c339 ( 9 0 ) capacitor c=0.01732f //x=18.62 //y=3.51
c340 ( 8 0 ) capacitor c=0.0275737f //x=20.47 //y=4.62
c341 ( 5 0 ) capacitor c=0.028438f //x=20.47 //y=2.4
c342 ( 4 0 ) capacitor c=0.0404303f //x=18.62 //y=4.62
c343 ( 1 0 ) capacitor c=0.0394782f //x=18.62 //y=2.4
r344 (  131 132 ) resistor r=32.4568 //w=0.214 //l=0.075 //layer=ply \
 //thickness=0.18 //x=20.315 //y=4.975 //x2=20.315 //y2=5.05
r345 (  129 131 ) resistor r=20.271 //w=0.214 //l=0.09 //layer=ply \
 //thickness=0.18 //x=20.315 //y=4.885 //x2=20.315 //y2=4.975
r346 (  124 138 ) resistor r=45.1352 //w=0.168 //l=0.173853 //layer=ply \
 //thickness=0.18 //x=20.805 //y=1.43 //x2=20.765 //y2=1.585
r347 (  123 137 ) resistor r=45.1352 //w=0.168 //l=0.173853 //layer=ply \
 //thickness=0.18 //x=20.805 //y=1.085 //x2=20.765 //y2=0.93
r348 (  123 124 ) resistor r=176.904 //w=0.094 //l=0.345 //layer=ply \
 //thickness=0.18 //x=20.805 //y=1.085 //x2=20.805 //y2=1.43
r349 (  122 131 ) resistor r=16.5046 //w=0.27 //l=0.135 //layer=ply \
 //thickness=0.18 //x=20.45 //y=4.975 //x2=20.315 //y2=4.975
r350 (  121 125 ) resistor r=26.9307 //w=0.15 //l=0.106066 //layer=ply \
 //thickness=0.18 //x=20.735 //y=4.975 //x2=20.81 //y2=5.05
r351 (  121 122 ) resistor r=146.138 //w=0.094 //l=0.285 //layer=ply \
 //thickness=0.18 //x=20.735 //y=4.975 //x2=20.45 //y2=4.975
r352 (  119 136 ) resistor r=10.701 //w=0.21 //l=0.115 //layer=ply \
 //thickness=0.18 //x=20.43 //y=1.585 //x2=20.315 //y2=1.585
r353 (  118 138 ) resistor r=5.52526 //w=0.168 //l=0.115 //layer=ply \
 //thickness=0.18 //x=20.65 //y=1.585 //x2=20.765 //y2=1.585
r354 (  117 135 ) resistor r=5.52526 //w=0.168 //l=0.115 //layer=ply \
 //thickness=0.18 //x=20.43 //y=0.93 //x2=20.315 //y2=0.93
r355 (  116 137 ) resistor r=5.52526 //w=0.168 //l=0.115 //layer=ply \
 //thickness=0.18 //x=20.65 //y=0.93 //x2=20.765 //y2=0.93
r356 (  116 117 ) resistor r=112.809 //w=0.094 //l=0.22 //layer=ply \
 //thickness=0.18 //x=20.65 //y=0.93 //x2=20.43 //y2=0.93
r357 (  112 134 ) resistor r=34.8111 //w=0.27 //l=0.264953 //layer=ply \
 //thickness=0.18 //x=20.275 //y=2.095 //x2=20.47 //y2=2.26
r358 (  111 136 ) resistor r=39.5823 //w=0.21 //l=0.173853 //layer=ply \
 //thickness=0.18 //x=20.275 //y=1.74 //x2=20.315 //y2=1.585
r359 (  111 112 ) resistor r=182.032 //w=0.094 //l=0.355 //layer=ply \
 //thickness=0.18 //x=20.275 //y=1.74 //x2=20.275 //y2=2.095
r360 (  110 136 ) resistor r=39.5823 //w=0.21 //l=0.173853 //layer=ply \
 //thickness=0.18 //x=20.275 //y=1.43 //x2=20.315 //y2=1.585
r361 (  109 135 ) resistor r=45.1352 //w=0.168 //l=0.173853 //layer=ply \
 //thickness=0.18 //x=20.275 //y=1.085 //x2=20.315 //y2=0.93
r362 (  109 110 ) resistor r=176.904 //w=0.094 //l=0.345 //layer=ply \
 //thickness=0.18 //x=20.275 //y=1.085 //x2=20.275 //y2=1.43
r363 (  108 125 ) resistor r=592.245 //w=0.094 //l=1.155 //layer=ply \
 //thickness=0.18 //x=20.81 //y=6.205 //x2=20.81 //y2=5.05
r364 (  107 132 ) resistor r=592.245 //w=0.094 //l=1.155 //layer=ply \
 //thickness=0.18 //x=20.37 //y=6.205 //x2=20.37 //y2=5.05
r365 (  106 118 ) resistor r=56.4043 //w=0.094 //l=0.11 //layer=ply \
 //thickness=0.18 //x=20.54 //y=1.585 //x2=20.65 //y2=1.585
r366 (  106 119 ) resistor r=56.4043 //w=0.094 //l=0.11 //layer=ply \
 //thickness=0.18 //x=20.54 //y=1.585 //x2=20.43 //y2=1.585
r367 (  98 134 ) resistor r=152 //w=0.17 //l=0.17 //layer=licon //count=1 \
 //x=20.47 //y=2.26 //x2=20.47 //y2=2.26
r368 (  93 129 ) resistor r=152 //w=0.17 //l=0.17 //layer=licon //count=1 \
 //x=20.315 //y=4.885 //x2=20.315 //y2=4.885
r369 (  76 143 ) resistor r=23.2727 //w=0.187 //l=0.34 //layer=li \
 //thickness=0.1 //x=18.14 //y=5.56 //x2=18.14 //y2=5.9
r370 (  67 68 ) resistor r=0.10734 //w=0.281 //l=0.16 //layer=m2 \
 //thickness=0.36 //x=20.465 //y=3.495 //x2=20.305 //y2=3.495
r371 (  65 68 ) resistor r=1.45992 //w=0.131 //l=1.53 //layer=m2 \
 //thickness=0.36 //x=18.775 //y=3.51 //x2=20.305 //y2=3.51
r372 (  63 65 ) resistor r=0.10734 //w=0.281 //l=0.16 //layer=m2 \
 //thickness=0.36 //x=18.615 //y=3.495 //x2=18.775 //y2=3.495
r373 (  58 93 ) resistor r=9.3 //w=0.17 //l=0.17 //layer=mcon //count=1 \
 //x=20.315 //y=4.885 //x2=20.315 //y2=4.885
r374 (  58 59 ) resistor r=0.0853524 //w=0.227 //l=0.155 //layer=m1 \
 //thickness=0.36 //x=20.315 //y=4.882 //x2=20.47 //y2=4.882
r375 (  54 98 ) resistor r=9.3 //w=0.17 //l=0.17 //layer=mcon //count=1 \
 //x=20.47 //y=2.26 //x2=20.47 //y2=2.26
r376 (  54 56 ) resistor r=0.0985786 //w=0.206 //l=0.135 //layer=m1 \
 //thickness=0.36 //x=20.467 //y=2.26 //x2=20.467 //y2=2.395
r377 (  50 67 ) resistor r=4.5 //w=0.15 //l=0.15 //layer=via1 //count=1 \
 //x=20.465 //y=3.495 //x2=20.465 //y2=3.495
r378 (  46 63 ) resistor r=4.5 //w=0.15 //l=0.15 //layer=via1 //count=1 \
 //x=18.615 //y=3.495 //x2=18.615 //y2=3.495
r379 (  44 140 ) resistor r=9.3 //w=0.17 //l=0.17 //layer=mcon //count=1 \
 //x=18.18 //y=1.18 //x2=18.18 //y2=1.18
r380 (  42 76 ) resistor r=9.3 //w=0.17 //l=0.17 //layer=mcon //count=1 \
 //x=18.14 //y=5.56 //x2=18.14 //y2=5.56
r381 (  40 42 ) resistor r=0.0974771 //w=0.218 //l=0.17 //layer=m1 \
 //thickness=0.36 //x=18.135 //y=5.39 //x2=18.135 //y2=5.56
r382 (  38 139 ) resistor r=9.3 //w=0.17 //l=0.17 //layer=mcon //count=1 \
 //x=17.21 //y=1.18 //x2=17.21 //y2=1.18
r383 (  35 59 ) resistor r=0.0249239 //w=0.227 //l=0.117 //layer=m1 \
 //thickness=0.36 //x=20.47 //y=4.765 //x2=20.47 //y2=4.882
r384 (  30 50 ) resistor r=0.0910802 //w=0.374 //l=0.185472 //layer=m1 \
 //thickness=0.36 //x=20.47 //y=3.335 //x2=20.415 //y2=3.495
r385 (  22 46 ) resistor r=0.0912814 //w=0.379 //l=0.183303 //layer=m1 \
 //thickness=0.36 //x=18.62 //y=3.335 //x2=18.67 //y2=3.495
r386 (  20 39 ) resistor r=0.0529306 //w=0.17 //l=0.085 //layer=m1 \
 //thickness=0.36 //x=18.265 //y=1.835 //x2=18.18 //y2=1.835
r387 (  19 21 ) resistor r=0.0698411 //w=0.17 //l=0.120208 //layer=m1 \
 //thickness=0.36 //x=18.535 //y=1.835 //x2=18.62 //y2=1.92
r388 (  19 20 ) resistor r=0.257634 //w=0.131 //l=0.27 //layer=m1 \
 //thickness=0.36 //x=18.535 //y=1.835 //x2=18.265 //y2=1.835
r389 (  18 40 ) resistor r=0.0225019 //w=0.218 //l=0.12 //layer=m1 \
 //thickness=0.36 //x=18.255 //y=5.39 //x2=18.135 //y2=5.39
r390 (  17 27 ) resistor r=0.0698411 //w=0.17 //l=0.120208 //layer=m1 \
 //thickness=0.36 //x=18.535 //y=5.39 //x2=18.62 //y2=5.305
r391 (  17 18 ) resistor r=0.267176 //w=0.131 //l=0.28 //layer=m1 \
 //thickness=0.36 //x=18.535 //y=5.39 //x2=18.255 //y2=5.39
r392 (  16 39 ) resistor r=0.0137558 //w=0.34 //l=0.085 //layer=m1 \
 //thickness=0.36 //x=18.18 //y=1.75 //x2=18.18 //y2=1.835
r393 (  15 44 ) resistor r=0.0728765 //w=0.25 //l=0.121491 //layer=m1 \
 //thickness=0.36 //x=18.18 //y=1.3 //x2=18.177 //y2=1.18
r394 (  15 16 ) resistor r=0.429389 //w=0.131 //l=0.45 //layer=m1 \
 //thickness=0.36 //x=18.18 //y=1.3 //x2=18.18 //y2=1.75
r395 (  13 39 ) resistor r=0.0529306 //w=0.17 //l=0.085 //layer=m1 \
 //thickness=0.36 //x=18.095 //y=1.835 //x2=18.18 //y2=1.835
r396 (  13 14 ) resistor r=0.763359 //w=0.131 //l=0.8 //layer=m1 \
 //thickness=0.36 //x=18.095 //y=1.835 //x2=17.295 //y2=1.835
r397 (  12 14 ) resistor r=0.0698411 //w=0.17 //l=0.120208 //layer=m1 \
 //thickness=0.36 //x=17.21 //y=1.75 //x2=17.295 //y2=1.835
r398 (  11 38 ) resistor r=0.0764279 //w=0.233 //l=0.126491 //layer=m1 \
 //thickness=0.36 //x=17.21 //y=1.305 //x2=17.207 //y2=1.18
r399 (  11 12 ) resistor r=0.424618 //w=0.131 //l=0.445 //layer=m1 \
 //thickness=0.36 //x=17.21 //y=1.305 //x2=17.21 //y2=1.75
r400 (  10 34 ) resistor r=0.0860668 //w=0.374 //l=0.170294 //layer=m1 \
 //thickness=0.36 //x=20.415 //y=3.51 //x2=20.47 //y2=3.655
r401 (  10 50 ) resistor r=0.00501337 //w=0.374 //l=0.015 //layer=m1 \
 //thickness=0.36 //x=20.415 //y=3.51 //x2=20.415 //y2=3.495
r402 (  9 26 ) resistor r=0.0863342 //w=0.379 //l=0.168152 //layer=m1 \
 //thickness=0.36 //x=18.67 //y=3.51 //x2=18.62 //y2=3.655
r403 (  9 46 ) resistor r=0.00494723 //w=0.379 //l=0.015 //layer=m1 \
 //thickness=0.36 //x=18.67 //y=3.51 //x2=18.67 //y2=3.495
r404 (  8 35 ) resistor r=0.138359 //w=0.131 //l=0.145 //layer=m1 \
 //thickness=0.36 //x=20.47 //y=4.62 //x2=20.47 //y2=4.765
r405 (  8 34 ) resistor r=0.920802 //w=0.131 //l=0.965 //layer=m1 \
 //thickness=0.36 //x=20.47 //y=4.62 //x2=20.47 //y2=3.655
r406 (  7 30 ) resistor r=0.186069 //w=0.131 //l=0.195 //layer=m1 \
 //thickness=0.36 //x=20.47 //y=3.14 //x2=20.47 //y2=3.335
r407 (  6 7 ) resistor r=0.353053 //w=0.131 //l=0.37 //layer=m1 \
 //thickness=0.36 //x=20.47 //y=2.77 //x2=20.47 //y2=3.14
r408 (  5 6 ) resistor r=0.353053 //w=0.131 //l=0.37 //layer=m1 \
 //thickness=0.36 //x=20.47 //y=2.4 //x2=20.47 //y2=2.77
r409 (  5 56 ) resistor r=0.00477099 //w=0.131 //l=0.005 //layer=m1 \
 //thickness=0.36 //x=20.47 //y=2.4 //x2=20.47 //y2=2.395
r410 (  4 27 ) resistor r=0.653626 //w=0.131 //l=0.685 //layer=m1 \
 //thickness=0.36 //x=18.62 //y=4.62 //x2=18.62 //y2=5.305
r411 (  4 26 ) resistor r=0.920802 //w=0.131 //l=0.965 //layer=m1 \
 //thickness=0.36 //x=18.62 //y=4.62 //x2=18.62 //y2=3.655
r412 (  3 22 ) resistor r=0.186069 //w=0.131 //l=0.195 //layer=m1 \
 //thickness=0.36 //x=18.62 //y=3.14 //x2=18.62 //y2=3.335
r413 (  2 3 ) resistor r=0.353053 //w=0.131 //l=0.37 //layer=m1 \
 //thickness=0.36 //x=18.62 //y=2.77 //x2=18.62 //y2=3.14
r414 (  1 2 ) resistor r=0.353053 //w=0.131 //l=0.37 //layer=m1 \
 //thickness=0.36 //x=18.62 //y=2.4 //x2=18.62 //y2=2.77
r415 (  1 21 ) resistor r=0.458015 //w=0.131 //l=0.48 //layer=m1 \
 //thickness=0.36 //x=18.62 //y=2.4 //x2=18.62 //y2=1.92
ends PM_DLATCHN\%Q

subckt PM_DLATCHN\%noxref_8 ( 2 4 5 6 7 8 10 11 12 14 15 18 23 27 31 35 36 43 \
 45 46 54 66 75 79 80 81 82 83 84 89 91 93 99 100 102 103 106 114 116 )
c281 ( 114 0 ) capacitor c=0.00875839f //x=14.735 //y=1.09
c282 ( 106 0 ) capacitor c=0.0369014f //x=21.245 //y=4.885
c283 ( 103 0 ) capacitor c=0.0292709f //x=21.21 //y=2.095
c284 ( 102 0 ) capacitor c=0.0468503f //x=21.21 //y=2.26
c285 ( 100 0 ) capacitor c=0.0237765f //x=21.775 //y=1.435
c286 ( 99 0 ) capacitor c=0.0191782f //x=21.775 //y=1.085
c287 ( 93 0 ) capacitor c=0.035988f //x=21.62 //y=1.585
c288 ( 91 0 ) capacitor c=0.0157803f //x=21.62 //y=0.93
c289 ( 89 0 ) capacitor c=0.0352992f //x=21.615 //y=4.975
c290 ( 84 0 ) capacitor c=0.0206674f //x=21.245 //y=1.74
c291 ( 83 0 ) capacitor c=0.0169638f //x=21.245 //y=1.435
c292 ( 82 0 ) capacitor c=0.0185462f //x=21.245 //y=1.085
c293 ( 81 0 ) capacitor c=0.155887f //x=21.69 //y=6.205
c294 ( 80 0 ) capacitor c=0.110534f //x=21.25 //y=6.205
c295 ( 75 0 ) capacitor c=8.21778e-19 //x=21.245 //y=4.885
c296 ( 66 0 ) capacitor c=7.18762e-19 //x=21.21 //y=2.26
c297 ( 54 0 ) capacitor c=0.0261198f //x=14.925 //y=5.56
c298 ( 46 0 ) capacitor c=0.146665f //x=21.045 //y=4.265
c299 ( 45 0 ) capacitor c=0.00230378f //x=21.205 //y=4.265
c300 ( 43 0 ) capacitor c=0.00223728f //x=15.445 //y=4.28
c301 ( 36 0 ) capacitor c=0.00566583f //x=21.245 //y=4.74
c302 ( 35 0 ) capacitor c=0.00544462f //x=21.245 //y=4.885
c303 ( 31 0 ) capacitor c=0.00539963f //x=21.21 //y=2.26
c304 ( 27 0 ) capacitor c=0.014405f //x=21.21 //y=4.25
c305 ( 23 0 ) capacitor c=0.0159723f //x=15.29 //y=4.25
c306 ( 18 0 ) capacitor c=0.015389f //x=14.92 //y=1.185
c307 ( 15 0 ) capacitor c=0.00974087f //x=21.21 //y=4.425
c308 ( 14 0 ) capacitor c=0.0380986f //x=21.21 //y=4.105
c309 ( 12 0 ) capacitor c=0.0101258f //x=15.29 //y=5.055
c310 ( 11 0 ) capacitor c=0.0129343f //x=15.29 //y=4.44
c311 ( 10 0 ) capacitor c=0.0541957f //x=15.29 //y=4.12
c312 ( 8 0 ) capacitor c=0.00514161f //x=15.01 //y=5.14
c313 ( 7 0 ) capacitor c=0.00729445f //x=15.205 //y=5.14
c314 ( 6 0 ) capacitor c=0.00704518f //x=15.005 //y=2.02
c315 ( 5 0 ) capacitor c=0.0128841f //x=15.205 //y=2.02
c316 ( 4 0 ) capacitor c=0.0106845f //x=14.925 //y=5.42
c317 ( 2 0 ) capacitor c=0.0111267f //x=14.92 //y=1.935
r318 (  108 109 ) resistor r=32.4568 //w=0.214 //l=0.075 //layer=ply \
 //thickness=0.18 //x=21.245 //y=4.975 //x2=21.245 //y2=5.05
r319 (  106 108 ) resistor r=20.271 //w=0.214 //l=0.09 //layer=ply \
 //thickness=0.18 //x=21.245 //y=4.885 //x2=21.245 //y2=4.975
r320 (  102 103 ) resistor r=52.7279 //w=0.214 //l=0.165 //layer=ply \
 //thickness=0.18 //x=21.21 //y=2.26 //x2=21.21 //y2=2.095
r321 (  100 113 ) resistor r=4.95774 //w=0.164 //l=0.112 //layer=ply \
 //thickness=0.18 //x=21.775 //y=1.435 //x2=21.775 //y2=1.547
r322 (  99 112 ) resistor r=45.1352 //w=0.168 //l=0.173853 //layer=ply \
 //thickness=0.18 //x=21.775 //y=1.085 //x2=21.735 //y2=0.93
r323 (  99 100 ) resistor r=179.468 //w=0.094 //l=0.35 //layer=ply \
 //thickness=0.18 //x=21.775 //y=1.085 //x2=21.775 //y2=1.435
r324 (  94 111 ) resistor r=10.8103 //w=0.211 //l=0.115 //layer=ply \
 //thickness=0.18 //x=21.4 //y=1.585 //x2=21.285 //y2=1.585
r325 (  93 113 ) resistor r=45.9962 //w=0.164 //l=0.17296 //layer=ply \
 //thickness=0.18 //x=21.62 //y=1.585 //x2=21.775 //y2=1.547
r326 (  92 110 ) resistor r=5.52526 //w=0.168 //l=0.115 //layer=ply \
 //thickness=0.18 //x=21.4 //y=0.93 //x2=21.285 //y2=0.93
r327 (  91 112 ) resistor r=5.52526 //w=0.168 //l=0.115 //layer=ply \
 //thickness=0.18 //x=21.62 //y=0.93 //x2=21.735 //y2=0.93
r328 (  91 92 ) resistor r=112.809 //w=0.094 //l=0.22 //layer=ply \
 //thickness=0.18 //x=21.62 //y=0.93 //x2=21.4 //y2=0.93
r329 (  90 108 ) resistor r=16.5046 //w=0.27 //l=0.135 //layer=ply \
 //thickness=0.18 //x=21.38 //y=4.975 //x2=21.245 //y2=4.975
r330 (  89 96 ) resistor r=26.9307 //w=0.15 //l=0.106066 //layer=ply \
 //thickness=0.18 //x=21.615 //y=4.975 //x2=21.69 //y2=5.05
r331 (  89 90 ) resistor r=120.5 //w=0.094 //l=0.235 //layer=ply \
 //thickness=0.18 //x=21.615 //y=4.975 //x2=21.38 //y2=4.975
r332 (  84 111 ) resistor r=39.5036 //w=0.211 //l=0.173853 //layer=ply \
 //thickness=0.18 //x=21.245 //y=1.74 //x2=21.285 //y2=1.585
r333 (  84 103 ) resistor r=182.032 //w=0.094 //l=0.355 //layer=ply \
 //thickness=0.18 //x=21.245 //y=1.74 //x2=21.245 //y2=2.095
r334 (  83 111 ) resistor r=38.3614 //w=0.211 //l=0.168819 //layer=ply \
 //thickness=0.18 //x=21.245 //y=1.435 //x2=21.285 //y2=1.585
r335 (  82 110 ) resistor r=45.1352 //w=0.168 //l=0.173853 //layer=ply \
 //thickness=0.18 //x=21.245 //y=1.085 //x2=21.285 //y2=0.93
r336 (  82 83 ) resistor r=179.468 //w=0.094 //l=0.35 //layer=ply \
 //thickness=0.18 //x=21.245 //y=1.085 //x2=21.245 //y2=1.435
r337 (  81 96 ) resistor r=592.245 //w=0.094 //l=1.155 //layer=ply \
 //thickness=0.18 //x=21.69 //y=6.205 //x2=21.69 //y2=5.05
r338 (  80 109 ) resistor r=592.245 //w=0.094 //l=1.155 //layer=ply \
 //thickness=0.18 //x=21.25 //y=6.205 //x2=21.25 //y2=5.05
r339 (  79 93 ) resistor r=56.4043 //w=0.094 //l=0.11 //layer=ply \
 //thickness=0.18 //x=21.51 //y=1.585 //x2=21.62 //y2=1.585
r340 (  79 94 ) resistor r=56.4043 //w=0.094 //l=0.11 //layer=ply \
 //thickness=0.18 //x=21.51 //y=1.585 //x2=21.4 //y2=1.585
r341 (  75 106 ) resistor r=152 //w=0.17 //l=0.17 //layer=licon //count=1 \
 //x=21.245 //y=4.885 //x2=21.245 //y2=4.885
r342 (  66 102 ) resistor r=152 //w=0.17 //l=0.17 //layer=licon //count=1 \
 //x=21.21 //y=2.26 //x2=21.21 //y2=2.26
r343 (  54 116 ) resistor r=23.615 //w=0.187 //l=0.345 //layer=li \
 //thickness=0.1 //x=14.925 //y=5.56 //x2=14.925 //y2=5.905
r344 (  45 46 ) resistor r=0.10734 //w=0.281 //l=0.16 //layer=m2 \
 //thickness=0.36 //x=21.205 //y=4.265 //x2=21.045 //y2=4.265
r345 (  43 46 ) resistor r=5.34351 //w=0.131 //l=5.6 //layer=m2 \
 //thickness=0.36 //x=15.445 //y=4.25 //x2=21.045 //y2=4.25
r346 (  41 43 ) resistor r=0.10734 //w=0.281 //l=0.16 //layer=m2 \
 //thickness=0.36 //x=15.285 //y=4.28 //x2=15.445 //y2=4.28
r347 (  35 75 ) resistor r=9.3 //w=0.17 //l=0.17 //layer=mcon //count=1 \
 //x=21.245 //y=4.885 //x2=21.245 //y2=4.885
r348 (  35 36 ) resistor r=0.105739 //w=0.201 //l=0.145 //layer=m1 \
 //thickness=0.36 //x=21.245 //y=4.885 //x2=21.245 //y2=4.74
r349 (  31 66 ) resistor r=9.3 //w=0.17 //l=0.17 //layer=mcon //count=1 \
 //x=21.21 //y=2.26 //x2=21.21 //y2=2.26
r350 (  31 33 ) resistor r=0.0977888 //w=0.216 //l=0.135 //layer=m1 \
 //thickness=0.36 //x=21.207 //y=2.26 //x2=21.207 //y2=2.395
r351 (  29 45 ) resistor r=4.5 //w=0.15 //l=0.15 //layer=via1 //count=1 \
 //x=21.205 //y=4.265 //x2=21.205 //y2=4.265
r352 (  27 29 ) resistor r=0.00501337 //w=0.374 //l=0.015 //layer=m1 \
 //thickness=0.36 //x=21.155 //y=4.25 //x2=21.155 //y2=4.265
r353 (  25 41 ) resistor r=4.5 //w=0.15 //l=0.15 //layer=via1 //count=1 \
 //x=15.285 //y=4.28 //x2=15.285 //y2=4.28
r354 (  23 25 ) resistor r=0.00989446 //w=0.379 //l=0.03 //layer=m1 \
 //thickness=0.36 //x=15.34 //y=4.25 //x2=15.34 //y2=4.28
r355 (  21 54 ) resistor r=9.3 //w=0.17 //l=0.17 //layer=mcon //count=1 \
 //x=14.925 //y=5.56 //x2=14.925 //y2=5.56
r356 (  18 114 ) resistor r=9.3 //w=0.17 //l=0.17 //layer=mcon //count=1 \
 //x=14.92 //y=1.185 //x2=14.92 //y2=1.185
r357 (  15 29 ) resistor r=0.0910802 //w=0.374 //l=0.185472 //layer=m1 \
 //thickness=0.36 //x=21.21 //y=4.425 //x2=21.155 //y2=4.265
r358 (  15 36 ) resistor r=0.300573 //w=0.131 //l=0.315 //layer=m1 \
 //thickness=0.36 //x=21.21 //y=4.425 //x2=21.21 //y2=4.74
r359 (  14 27 ) resistor r=0.0860668 //w=0.374 //l=0.170294 //layer=m1 \
 //thickness=0.36 //x=21.21 //y=4.105 //x2=21.155 //y2=4.25
r360 (  14 33 ) resistor r=1.63168 //w=0.131 //l=1.71 //layer=m1 \
 //thickness=0.36 //x=21.21 //y=4.105 //x2=21.21 //y2=2.395
r361 (  11 25 ) resistor r=0.0912814 //w=0.379 //l=0.183303 //layer=m1 \
 //thickness=0.36 //x=15.29 //y=4.44 //x2=15.34 //y2=4.28
r362 (  11 12 ) resistor r=0.586832 //w=0.131 //l=0.615 //layer=m1 \
 //thickness=0.36 //x=15.29 //y=4.44 //x2=15.29 //y2=5.055
r363 (  10 23 ) resistor r=0.0813869 //w=0.379 //l=0.152971 //layer=m1 \
 //thickness=0.36 //x=15.29 //y=4.12 //x2=15.34 //y2=4.25
r364 (  9 10 ) resistor r=1.92271 //w=0.131 //l=2.015 //layer=m1 \
 //thickness=0.36 //x=15.29 //y=2.105 //x2=15.29 //y2=4.12
r365 (  7 12 ) resistor r=0.0698411 //w=0.17 //l=0.120208 //layer=m1 \
 //thickness=0.36 //x=15.205 //y=5.14 //x2=15.29 //y2=5.055
r366 (  7 8 ) resistor r=0.186069 //w=0.131 //l=0.195 //layer=m1 \
 //thickness=0.36 //x=15.205 //y=5.14 //x2=15.01 //y2=5.14
r367 (  5 9 ) resistor r=0.0698411 //w=0.17 //l=0.120208 //layer=m1 \
 //thickness=0.36 //x=15.205 //y=2.02 //x2=15.29 //y2=2.105
r368 (  5 6 ) resistor r=0.19084 //w=0.131 //l=0.2 //layer=m1 //thickness=0.36 \
 //x=15.205 //y=2.02 //x2=15.005 //y2=2.02
r369 (  4 21 ) resistor r=0.086672 //w=0.218 //l=0.14 //layer=m1 \
 //thickness=0.36 //x=14.925 //y=5.42 //x2=14.925 //y2=5.56
r370 (  3 8 ) resistor r=0.0698411 //w=0.17 //l=0.120208 //layer=m1 \
 //thickness=0.36 //x=14.925 //y=5.225 //x2=15.01 //y2=5.14
r371 (  3 4 ) resistor r=0.186069 //w=0.131 //l=0.195 //layer=m1 \
 //thickness=0.36 //x=14.925 //y=5.225 //x2=14.925 //y2=5.42
r372 (  2 6 ) resistor r=0.0698411 //w=0.17 //l=0.120208 //layer=m1 \
 //thickness=0.36 //x=14.92 //y=1.935 //x2=15.005 //y2=2.02
r373 (  1 18 ) resistor r=0.105739 //w=0.201 //l=0.145 //layer=m1 \
 //thickness=0.36 //x=14.92 //y=1.33 //x2=14.92 //y2=1.185
r374 (  1 2 ) resistor r=0.57729 //w=0.131 //l=0.605 //layer=m1 \
 //thickness=0.36 //x=14.92 //y=1.33 //x2=14.92 //y2=1.935
ends PM_DLATCHN\%noxref_8

subckt PM_DLATCHN\%noxref_9 ( 2 3 5 6 7 8 9 10 11 13 16 17 18 20 24 25 30 34 \
 40 42 47 49 52 61 71 87 88 89 90 91 92 97 99 101 107 108 110 111 114 122 123 \
 126 )
c283 ( 123 0 ) capacitor c=0.00901091f //x=21.32 //y=1.085
c284 ( 122 0 ) capacitor c=0.00876479f //x=20.35 //y=1.085
c285 ( 114 0 ) capacitor c=0.0376036f //x=17.915 //y=4.885
c286 ( 111 0 ) capacitor c=0.0292709f //x=17.88 //y=2.095
c287 ( 110 0 ) capacitor c=0.0468503f //x=17.88 //y=2.26
c288 ( 108 0 ) capacitor c=0.0237765f //x=18.445 //y=1.435
c289 ( 107 0 ) capacitor c=0.0191782f //x=18.445 //y=1.085
c290 ( 101 0 ) capacitor c=0.035988f //x=18.29 //y=1.585
c291 ( 99 0 ) capacitor c=0.0157803f //x=18.29 //y=0.93
c292 ( 97 0 ) capacitor c=0.0355f //x=18.285 //y=4.975
c293 ( 92 0 ) capacitor c=0.0206674f //x=17.915 //y=1.74
c294 ( 91 0 ) capacitor c=0.0169638f //x=17.915 //y=1.435
c295 ( 90 0 ) capacitor c=0.0185462f //x=17.915 //y=1.085
c296 ( 89 0 ) capacitor c=0.155887f //x=18.36 //y=6.205
c297 ( 88 0 ) capacitor c=0.110534f //x=17.92 //y=6.205
c298 ( 71 0 ) capacitor c=0.024193f //x=21.47 //y=5.56
c299 ( 61 0 ) capacitor c=0.0011312f //x=17.915 //y=4.885
c300 ( 52 0 ) capacitor c=7.18762e-19 //x=17.88 //y=2.26
c301 ( 49 0 ) capacitor c=0.0131f //x=21.945 //y=3.88
c302 ( 47 0 ) capacitor c=0.00130807f //x=18.04 //y=3.865
c303 ( 42 0 ) capacitor c=0.0569815f //x=21.785 //y=3.88
c304 ( 40 0 ) capacitor c=0.0181232f //x=21.945 //y=3.88
c305 ( 34 0 ) capacitor c=0.0160196f //x=21.465 //y=5.39
c306 ( 33 0 ) capacitor c=0.00489134f //x=21.51 //y=1.835
c307 ( 30 0 ) capacitor c=0.0140274f //x=17.88 //y=3.88
c308 ( 25 0 ) capacitor c=0.0143363f //x=17.915 //y=4.74
c309 ( 24 0 ) capacitor c=0.00557256f //x=17.915 //y=4.885
c310 ( 20 0 ) capacitor c=0.00523064f //x=17.88 //y=2.26
c311 ( 18 0 ) capacitor c=0.0434347f //x=21.95 //y=5.305
c312 ( 17 0 ) capacitor c=0.012383f //x=21.95 //y=4.04
c313 ( 16 0 ) capacitor c=0.073898f //x=21.95 //y=3.72
c314 ( 13 0 ) capacitor c=0.0152185f //x=21.865 //y=1.835
c315 ( 11 0 ) capacitor c=0.0115102f //x=21.865 //y=5.39
c316 ( 10 0 ) capacitor c=0.0111615f //x=21.51 //y=1.75
c317 ( 9 0 ) capacitor c=0.0117617f //x=21.51 //y=1.3
c318 ( 8 0 ) capacitor c=0.00249162f //x=20.625 //y=1.835
c319 ( 7 0 ) capacitor c=0.017936f //x=21.425 //y=1.835
c320 ( 6 0 ) capacitor c=0.00638036f //x=20.54 //y=1.75
c321 ( 5 0 ) capacitor c=0.00826102f //x=20.54 //y=1.305
c322 ( 3 0 ) capacitor c=0.00933955f //x=17.88 //y=4.025
c323 ( 2 0 ) capacitor c=0.0300235f //x=17.88 //y=3.705
r324 (  116 117 ) resistor r=32.4568 //w=0.214 //l=0.075 //layer=ply \
 //thickness=0.18 //x=17.915 //y=4.975 //x2=17.915 //y2=5.05
r325 (  114 116 ) resistor r=20.271 //w=0.214 //l=0.09 //layer=ply \
 //thickness=0.18 //x=17.915 //y=4.885 //x2=17.915 //y2=4.975
r326 (  110 111 ) resistor r=52.7279 //w=0.214 //l=0.165 //layer=ply \
 //thickness=0.18 //x=17.88 //y=2.26 //x2=17.88 //y2=2.095
r327 (  108 121 ) resistor r=4.95774 //w=0.164 //l=0.112 //layer=ply \
 //thickness=0.18 //x=18.445 //y=1.435 //x2=18.445 //y2=1.547
r328 (  107 120 ) resistor r=45.1352 //w=0.168 //l=0.173853 //layer=ply \
 //thickness=0.18 //x=18.445 //y=1.085 //x2=18.405 //y2=0.93
r329 (  107 108 ) resistor r=179.468 //w=0.094 //l=0.35 //layer=ply \
 //thickness=0.18 //x=18.445 //y=1.085 //x2=18.445 //y2=1.435
r330 (  102 119 ) resistor r=10.8103 //w=0.211 //l=0.115 //layer=ply \
 //thickness=0.18 //x=18.07 //y=1.585 //x2=17.955 //y2=1.585
r331 (  101 121 ) resistor r=45.9962 //w=0.164 //l=0.17296 //layer=ply \
 //thickness=0.18 //x=18.29 //y=1.585 //x2=18.445 //y2=1.547
r332 (  100 118 ) resistor r=5.52526 //w=0.168 //l=0.115 //layer=ply \
 //thickness=0.18 //x=18.07 //y=0.93 //x2=17.955 //y2=0.93
r333 (  99 120 ) resistor r=5.52526 //w=0.168 //l=0.115 //layer=ply \
 //thickness=0.18 //x=18.29 //y=0.93 //x2=18.405 //y2=0.93
r334 (  99 100 ) resistor r=112.809 //w=0.094 //l=0.22 //layer=ply \
 //thickness=0.18 //x=18.29 //y=0.93 //x2=18.07 //y2=0.93
r335 (  98 116 ) resistor r=16.5046 //w=0.27 //l=0.135 //layer=ply \
 //thickness=0.18 //x=18.05 //y=4.975 //x2=17.915 //y2=4.975
r336 (  97 104 ) resistor r=26.9307 //w=0.15 //l=0.106066 //layer=ply \
 //thickness=0.18 //x=18.285 //y=4.975 //x2=18.36 //y2=5.05
r337 (  97 98 ) resistor r=120.5 //w=0.094 //l=0.235 //layer=ply \
 //thickness=0.18 //x=18.285 //y=4.975 //x2=18.05 //y2=4.975
r338 (  92 119 ) resistor r=39.5036 //w=0.211 //l=0.173853 //layer=ply \
 //thickness=0.18 //x=17.915 //y=1.74 //x2=17.955 //y2=1.585
r339 (  92 111 ) resistor r=182.032 //w=0.094 //l=0.355 //layer=ply \
 //thickness=0.18 //x=17.915 //y=1.74 //x2=17.915 //y2=2.095
r340 (  91 119 ) resistor r=38.3614 //w=0.211 //l=0.168819 //layer=ply \
 //thickness=0.18 //x=17.915 //y=1.435 //x2=17.955 //y2=1.585
r341 (  90 118 ) resistor r=45.1352 //w=0.168 //l=0.173853 //layer=ply \
 //thickness=0.18 //x=17.915 //y=1.085 //x2=17.955 //y2=0.93
r342 (  90 91 ) resistor r=179.468 //w=0.094 //l=0.35 //layer=ply \
 //thickness=0.18 //x=17.915 //y=1.085 //x2=17.915 //y2=1.435
r343 (  89 104 ) resistor r=592.245 //w=0.094 //l=1.155 //layer=ply \
 //thickness=0.18 //x=18.36 //y=6.205 //x2=18.36 //y2=5.05
r344 (  88 117 ) resistor r=592.245 //w=0.094 //l=1.155 //layer=ply \
 //thickness=0.18 //x=17.92 //y=6.205 //x2=17.92 //y2=5.05
r345 (  87 101 ) resistor r=56.4043 //w=0.094 //l=0.11 //layer=ply \
 //thickness=0.18 //x=18.18 //y=1.585 //x2=18.29 //y2=1.585
r346 (  87 102 ) resistor r=56.4043 //w=0.094 //l=0.11 //layer=ply \
 //thickness=0.18 //x=18.18 //y=1.585 //x2=18.07 //y2=1.585
r347 (  71 126 ) resistor r=23.2727 //w=0.187 //l=0.34 //layer=li \
 //thickness=0.1 //x=21.47 //y=5.56 //x2=21.47 //y2=5.9
r348 (  61 114 ) resistor r=152 //w=0.17 //l=0.17 //layer=licon //count=1 \
 //x=17.915 //y=4.885 //x2=17.915 //y2=4.885
r349 (  52 110 ) resistor r=152 //w=0.17 //l=0.17 //layer=licon //count=1 \
 //x=17.88 //y=2.26 //x2=17.88 //y2=2.26
r350 (  45 47 ) resistor r=0.10734 //w=0.281 //l=0.16 //layer=m2 \
 //thickness=0.36 //x=17.88 //y=3.865 //x2=18.04 //y2=3.865
r351 (  42 49 ) resistor r=0.10734 //w=0.281 //l=0.16 //layer=m2 \
 //thickness=0.36 //x=21.785 //y=3.88 //x2=21.945 //y2=3.88
r352 (  42 47 ) resistor r=3.57347 //w=0.131 //l=3.745 //layer=m2 \
 //thickness=0.36 //x=21.785 //y=3.88 //x2=18.04 //y2=3.88
r353 (  40 49 ) resistor r=4.5 //w=0.15 //l=0.15 //layer=via1 //count=1 \
 //x=21.945 //y=3.88 //x2=21.945 //y2=3.88
r354 (  38 123 ) resistor r=9.3 //w=0.17 //l=0.17 //layer=mcon //count=1 \
 //x=21.51 //y=1.18 //x2=21.51 //y2=1.18
r355 (  36 71 ) resistor r=9.3 //w=0.17 //l=0.17 //layer=mcon //count=1 \
 //x=21.47 //y=5.56 //x2=21.47 //y2=5.56
r356 (  34 36 ) resistor r=0.0974771 //w=0.218 //l=0.17 //layer=m1 \
 //thickness=0.36 //x=21.465 //y=5.39 //x2=21.465 //y2=5.56
r357 (  32 122 ) resistor r=9.3 //w=0.17 //l=0.17 //layer=mcon //count=1 \
 //x=20.54 //y=1.18 //x2=20.54 //y2=1.18
r358 (  28 45 ) resistor r=4.5 //w=0.15 //l=0.15 //layer=via1 //count=1 \
 //x=17.88 //y=3.865 //x2=17.88 //y2=3.865
r359 (  28 30 ) resistor r=0.0049867 //w=0.376 //l=0.015 //layer=m1 \
 //thickness=0.36 //x=17.932 //y=3.865 //x2=17.932 //y2=3.88
r360 (  24 61 ) resistor r=9.3 //w=0.17 //l=0.17 //layer=mcon //count=1 \
 //x=17.915 //y=4.885 //x2=17.915 //y2=4.885
r361 (  24 25 ) resistor r=0.105739 //w=0.201 //l=0.145 //layer=m1 \
 //thickness=0.36 //x=17.915 //y=4.885 //x2=17.915 //y2=4.74
r362 (  20 52 ) resistor r=9.3 //w=0.17 //l=0.17 //layer=mcon //count=1 \
 //x=17.88 //y=2.26 //x2=17.88 //y2=2.26
r363 (  20 22 ) resistor r=0.0977888 //w=0.216 //l=0.135 //layer=m1 \
 //thickness=0.36 //x=17.877 //y=2.26 //x2=17.877 //y2=2.395
r364 (  17 40 ) resistor r=0.0910802 //w=0.374 //l=0.185472 //layer=m1 \
 //thickness=0.36 //x=21.95 //y=4.04 //x2=21.895 //y2=3.88
r365 (  17 18 ) resistor r=1.20706 //w=0.131 //l=1.265 //layer=m1 \
 //thickness=0.36 //x=21.95 //y=4.04 //x2=21.95 //y2=5.305
r366 (  16 40 ) resistor r=0.0910802 //w=0.374 //l=0.185472 //layer=m1 \
 //thickness=0.36 //x=21.95 //y=3.72 //x2=21.895 //y2=3.88
r367 (  15 16 ) resistor r=1.71756 //w=0.131 //l=1.8 //layer=m1 \
 //thickness=0.36 //x=21.95 //y=1.92 //x2=21.95 //y2=3.72
r368 (  14 33 ) resistor r=0.0529306 //w=0.17 //l=0.085 //layer=m1 \
 //thickness=0.36 //x=21.595 //y=1.835 //x2=21.51 //y2=1.835
r369 (  13 15 ) resistor r=0.0698411 //w=0.17 //l=0.120208 //layer=m1 \
 //thickness=0.36 //x=21.865 //y=1.835 //x2=21.95 //y2=1.92
r370 (  13 14 ) resistor r=0.257634 //w=0.131 //l=0.27 //layer=m1 \
 //thickness=0.36 //x=21.865 //y=1.835 //x2=21.595 //y2=1.835
r371 (  12 34 ) resistor r=0.0225019 //w=0.218 //l=0.12 //layer=m1 \
 //thickness=0.36 //x=21.585 //y=5.39 //x2=21.465 //y2=5.39
r372 (  11 18 ) resistor r=0.0698411 //w=0.17 //l=0.120208 //layer=m1 \
 //thickness=0.36 //x=21.865 //y=5.39 //x2=21.95 //y2=5.305
r373 (  11 12 ) resistor r=0.267176 //w=0.131 //l=0.28 //layer=m1 \
 //thickness=0.36 //x=21.865 //y=5.39 //x2=21.585 //y2=5.39
r374 (  10 33 ) resistor r=0.0137558 //w=0.34 //l=0.085 //layer=m1 \
 //thickness=0.36 //x=21.51 //y=1.75 //x2=21.51 //y2=1.835
r375 (  9 38 ) resistor r=0.0728765 //w=0.25 //l=0.121491 //layer=m1 \
 //thickness=0.36 //x=21.51 //y=1.3 //x2=21.507 //y2=1.18
r376 (  9 10 ) resistor r=0.429389 //w=0.131 //l=0.45 //layer=m1 \
 //thickness=0.36 //x=21.51 //y=1.3 //x2=21.51 //y2=1.75
r377 (  7 33 ) resistor r=0.0529306 //w=0.17 //l=0.085 //layer=m1 \
 //thickness=0.36 //x=21.425 //y=1.835 //x2=21.51 //y2=1.835
r378 (  7 8 ) resistor r=0.763359 //w=0.131 //l=0.8 //layer=m1 \
 //thickness=0.36 //x=21.425 //y=1.835 //x2=20.625 //y2=1.835
r379 (  6 8 ) resistor r=0.0698411 //w=0.17 //l=0.120208 //layer=m1 \
 //thickness=0.36 //x=20.54 //y=1.75 //x2=20.625 //y2=1.835
r380 (  5 32 ) resistor r=0.0764279 //w=0.233 //l=0.126491 //layer=m1 \
 //thickness=0.36 //x=20.54 //y=1.305 //x2=20.537 //y2=1.18
r381 (  5 6 ) resistor r=0.424618 //w=0.131 //l=0.445 //layer=m1 \
 //thickness=0.36 //x=20.54 //y=1.305 //x2=20.54 //y2=1.75
r382 (  3 30 ) resistor r=0.0861726 //w=0.376 //l=0.169012 //layer=m1 \
 //thickness=0.36 //x=17.88 //y=4.025 //x2=17.932 //y2=3.88
r383 (  3 25 ) resistor r=0.682252 //w=0.131 //l=0.715 //layer=m1 \
 //thickness=0.36 //x=17.88 //y=4.025 //x2=17.88 //y2=4.74
r384 (  2 28 ) resistor r=0.0911593 //w=0.376 //l=0.184174 //layer=m1 \
 //thickness=0.36 //x=17.88 //y=3.705 //x2=17.932 //y2=3.865
r385 (  2 22 ) resistor r=1.25 //w=0.131 //l=1.31 //layer=m1 //thickness=0.36 \
 //x=17.88 //y=3.705 //x2=17.88 //y2=2.395
ends PM_DLATCHN\%noxref_9

subckt PM_DLATCHN\%VDD ( 1 2 30 31 32 40 41 46 86 112 140 150 172 198 208 234 \
 248 272 283 285 288 293 297 301 305 306 307 308 309 310 311 312 313 314 315 \
 316 317 318 319 320 321 322 )
c444 ( 322 0 ) capacitor c=0.023004f //x=20.445 //y=5.205
c445 ( 321 0 ) capacitor c=0.0229185f //x=17.115 //y=5.205
c446 ( 320 0 ) capacitor c=0.0574244f //x=15.22 //y=5.2
c447 ( 319 0 ) capacitor c=0.057866f //x=14.35 //y=5.2
c448 ( 318 0 ) capacitor c=0.039544f //x=12.885 //y=5.2
c449 ( 317 0 ) capacitor c=0.0248174f //x=12.005 //y=5.2
c450 ( 316 0 ) capacitor c=0.059201f //x=11.135 //y=5.2
c451 ( 315 0 ) capacitor c=0.0541231f //x=9.67 //y=5.2
c452 ( 314 0 ) capacitor c=0.0578811f //x=8.8 //y=5.2
c453 ( 313 0 ) capacitor c=0.039544f //x=7.335 //y=5.2
c454 ( 312 0 ) capacitor c=0.0248174f //x=6.455 //y=5.2
c455 ( 311 0 ) capacitor c=0.0590127f //x=5.585 //y=5.2
c456 ( 310 0 ) capacitor c=0.0540412f //x=4.12 //y=5.2
c457 ( 309 0 ) capacitor c=0.0531358f //x=3.25 //y=5.2
c458 ( 308 0 ) capacitor c=0.0550258f //x=1.9 //y=5.2
c459 ( 307 0 ) capacitor c=0.0616797f //x=1.03 //y=5.2
c460 ( 306 0 ) capacitor c=0.123055f //x=19.36 //y=7.585
c461 ( 305 0 ) capacitor c=0.120223f //x=16.03 //y=7.585
c462 ( 304 0 ) capacitor c=0.00597439f //x=15.29 //y=7.58
c463 ( 302 0 ) capacitor c=0.00597439f //x=14.485 //y=7.585
c464 ( 301 0 ) capacitor c=0.121632f //x=13.81 //y=7.585
c465 ( 300 0 ) capacitor c=0.00597439f //x=13.03 //y=7.585
c466 ( 299 0 ) capacitor c=0.00597439f //x=12.15 //y=7.585
c467 ( 298 0 ) capacitor c=0.00597439f //x=11.27 //y=7.585
c468 ( 297 0 ) capacitor c=0.125529f //x=10.48 //y=7.585
c469 ( 296 0 ) capacitor c=0.00597439f //x=9.815 //y=7.585
c470 ( 295 0 ) capacitor c=0.00597439f //x=9 //y=7.58
c471 ( 293 0 ) capacitor c=0.121128f //x=8.26 //y=7.585
c472 ( 292 0 ) capacitor c=0.00597439f //x=7.52 //y=7.58
c473 ( 290 0 ) capacitor c=0.00597439f //x=6.6 //y=7.585
c474 ( 289 0 ) capacitor c=0.00597439f //x=5.72 //y=7.585
c475 ( 288 0 ) capacitor c=0.125518f //x=4.93 //y=7.585
c476 ( 287 0 ) capacitor c=0.00597439f //x=4.265 //y=7.585
c477 ( 286 0 ) capacitor c=0.00597439f //x=3.385 //y=7.585
c478 ( 285 0 ) capacitor c=0.119526f //x=2.71 //y=7.585
c479 ( 284 0 ) capacitor c=0.00597439f //x=2.045 //y=7.585
c480 ( 283 0 ) capacitor c=0.257865f //x=1.23 //y=7.58
c481 ( 272 0 ) capacitor c=0.372812f //x=22.32 //y=7.58
c482 ( 248 0 ) capacitor c=0.138943f //x=19.19 //y=7.585
c483 ( 244 0 ) capacitor c=0.0208042f //x=15.86 //y=7.585
c484 ( 234 0 ) capacitor c=0.0290691f //x=15.28 //y=7.585
c485 ( 222 0 ) capacitor c=0.0217664f //x=14.4 //y=7.585
c486 ( 218 0 ) capacitor c=0.0277785f //x=13.64 //y=7.585
c487 ( 208 0 ) capacitor c=0.0287376f //x=12.945 //y=7.585
c488 ( 198 0 ) capacitor c=0.0291078f //x=12.065 //y=7.585
c489 ( 188 0 ) capacitor c=0.0283511f //x=11.185 //y=7.585
c490 ( 182 0 ) capacitor c=0.0211939f //x=10.31 //y=7.585
c491 ( 172 0 ) capacitor c=0.0289924f //x=9.73 //y=7.585
c492 ( 162 0 ) capacitor c=0.0217664f //x=8.85 //y=7.585
c493 ( 158 0 ) capacitor c=0.0277785f //x=8.09 //y=7.585
c494 ( 150 0 ) capacitor c=0.0287375f //x=7.395 //y=7.585
c495 ( 140 0 ) capacitor c=0.0291078f //x=6.515 //y=7.585
c496 ( 128 0 ) capacitor c=0.0283511f //x=5.635 //y=7.585
c497 ( 124 0 ) capacitor c=0.0211939f //x=4.76 //y=7.585
c498 ( 112 0 ) capacitor c=0.0287132f //x=4.18 //y=7.585
c499 ( 102 0 ) capacitor c=0.0217664f //x=3.3 //y=7.585
c500 ( 96 0 ) capacitor c=0.0211939f //x=2.54 //y=7.585
c501 ( 86 0 ) capacitor c=0.0289924f //x=1.96 //y=7.585
c502 ( 71 0 ) capacitor c=0.00499323f //x=20.59 //y=7.585
c503 ( 68 0 ) capacitor c=0.00499323f //x=17.26 //y=7.585
c504 ( 46 0 ) capacitor c=0.102507f //x=22.32 //y=7.58
c505 ( 41 0 ) capacitor c=0.00808586f //x=20.59 //y=7.41
c506 ( 40 0 ) capacitor c=0.00611471f //x=20.59 //y=7.035
c507 ( 32 0 ) capacitor c=0.113102f //x=20.505 //y=7.585
c508 ( 31 0 ) capacitor c=0.00828545f //x=17.26 //y=7.41
c509 ( 30 0 ) capacitor c=0.00617747f //x=17.26 //y=7.035
c510 ( 2 0 ) capacitor c=0.628912f //x=17.175 //y=7.585
r511 (  270 272 ) resistor r=25.8093 //w=0.367 //l=0.74 //layer=li \
 //thickness=0.1 //x=21.58 //y=7.585 //x2=22.32 //y2=7.585
r512 (  268 270 ) resistor r=38.7139 //w=0.367 //l=1.11 //layer=li \
 //thickness=0.1 //x=20.47 //y=7.585 //x2=21.58 //y2=7.585
r513 (  266 306 ) resistor r=5.29055 //w=0.35 //l=0.17 //layer=li \
 //thickness=0.1 //x=19.53 //y=7.585 //x2=19.36 //y2=7.585
r514 (  266 268 ) resistor r=32.7847 //w=0.367 //l=0.94 //layer=li \
 //thickness=0.1 //x=19.53 //y=7.585 //x2=20.47 //y2=7.585
r515 (  253 255 ) resistor r=38.7139 //w=0.367 //l=1.11 //layer=li \
 //thickness=0.1 //x=17.88 //y=7.585 //x2=18.99 //y2=7.585
r516 (  251 253 ) resistor r=38.7139 //w=0.367 //l=1.11 //layer=li \
 //thickness=0.1 //x=16.77 //y=7.585 //x2=17.88 //y2=7.585
r517 (  249 305 ) resistor r=5.29055 //w=0.35 //l=0.17 //layer=li \
 //thickness=0.1 //x=16.2 //y=7.585 //x2=16.03 //y2=7.585
r518 (  249 251 ) resistor r=19.8801 //w=0.367 //l=0.57 //layer=li \
 //thickness=0.1 //x=16.2 //y=7.585 //x2=16.77 //y2=7.585
r519 (  248 306 ) resistor r=5.29055 //w=0.35 //l=0.17 //layer=li \
 //thickness=0.1 //x=19.19 //y=7.585 //x2=19.36 //y2=7.585
r520 (  248 255 ) resistor r=6.97548 //w=0.367 //l=0.2 //layer=li \
 //thickness=0.1 //x=19.19 //y=7.585 //x2=18.99 //y2=7.585
r521 (  245 304 ) resistor r=2.87058 //w=0.35 //l=0.085 //layer=li \
 //thickness=0.1 //x=15.45 //y=7.585 //x2=15.365 //y2=7.585
r522 (  244 305 ) resistor r=5.29055 //w=0.35 //l=0.17 //layer=li \
 //thickness=0.1 //x=15.86 //y=7.585 //x2=16.03 //y2=7.585
r523 (  244 245 ) resistor r=14.2997 //w=0.367 //l=0.41 //layer=li \
 //thickness=0.1 //x=15.86 //y=7.585 //x2=15.45 //y2=7.585
r524 (  236 304 ) resistor r=4.23183 //w=0.7 //l=0.175 //layer=li \
 //thickness=0.1 //x=15.365 //y=7.41 //x2=15.365 //y2=7.585
r525 (  236 320 ) resistor r=56.4706 //w=0.187 //l=0.825 //layer=li \
 //thickness=0.1 //x=15.365 //y=7.41 //x2=15.365 //y2=6.585
r526 (  235 302 ) resistor r=2.87058 //w=0.35 //l=0.085 //layer=li \
 //thickness=0.1 //x=14.57 //y=7.585 //x2=14.485 //y2=7.585
r527 (  234 304 ) resistor r=2.87058 //w=0.35 //l=0.085 //layer=li \
 //thickness=0.1 //x=15.28 //y=7.585 //x2=15.365 //y2=7.585
r528 (  234 235 ) resistor r=24.7629 //w=0.367 //l=0.71 //layer=li \
 //thickness=0.1 //x=15.28 //y=7.585 //x2=14.57 //y2=7.585
r529 (  226 302 ) resistor r=4.23183 //w=0.7 //l=0.175 //layer=li \
 //thickness=0.1 //x=14.485 //y=7.41 //x2=14.485 //y2=7.585
r530 (  226 319 ) resistor r=56.4706 //w=0.187 //l=0.825 //layer=li \
 //thickness=0.1 //x=14.485 //y=7.41 //x2=14.485 //y2=6.585
r531 (  223 301 ) resistor r=5.29055 //w=0.35 //l=0.17 //layer=li \
 //thickness=0.1 //x=13.98 //y=7.585 //x2=13.81 //y2=7.585
r532 (  223 225 ) resistor r=6.97548 //w=0.367 //l=0.2 //layer=li \
 //thickness=0.1 //x=13.98 //y=7.585 //x2=14.18 //y2=7.585
r533 (  222 302 ) resistor r=2.87058 //w=0.35 //l=0.085 //layer=li \
 //thickness=0.1 //x=14.4 //y=7.585 //x2=14.485 //y2=7.585
r534 (  222 225 ) resistor r=7.67302 //w=0.367 //l=0.22 //layer=li \
 //thickness=0.1 //x=14.4 //y=7.585 //x2=14.18 //y2=7.585
r535 (  219 300 ) resistor r=2.87058 //w=0.35 //l=0.085 //layer=li \
 //thickness=0.1 //x=13.115 //y=7.585 //x2=13.03 //y2=7.585
r536 (  218 301 ) resistor r=5.29055 //w=0.35 //l=0.17 //layer=li \
 //thickness=0.1 //x=13.64 //y=7.585 //x2=13.81 //y2=7.585
r537 (  218 219 ) resistor r=18.3106 //w=0.367 //l=0.525 //layer=li \
 //thickness=0.1 //x=13.64 //y=7.585 //x2=13.115 //y2=7.585
r538 (  212 300 ) resistor r=4.23183 //w=0.7 //l=0.175 //layer=li \
 //thickness=0.1 //x=13.03 //y=7.41 //x2=13.03 //y2=7.585
r539 (  212 318 ) resistor r=33.1979 //w=0.187 //l=0.485 //layer=li \
 //thickness=0.1 //x=13.03 //y=7.41 //x2=13.03 //y2=6.925
r540 (  209 299 ) resistor r=2.87058 //w=0.35 //l=0.085 //layer=li \
 //thickness=0.1 //x=12.235 //y=7.585 //x2=12.15 //y2=7.585
r541 (  209 211 ) resistor r=16.218 //w=0.367 //l=0.465 //layer=li \
 //thickness=0.1 //x=12.235 //y=7.585 //x2=12.7 //y2=7.585
r542 (  208 300 ) resistor r=2.87058 //w=0.35 //l=0.085 //layer=li \
 //thickness=0.1 //x=12.945 //y=7.585 //x2=13.03 //y2=7.585
r543 (  208 211 ) resistor r=8.54496 //w=0.367 //l=0.245 //layer=li \
 //thickness=0.1 //x=12.945 //y=7.585 //x2=12.7 //y2=7.585
r544 (  202 299 ) resistor r=4.23183 //w=0.7 //l=0.175 //layer=li \
 //thickness=0.1 //x=12.15 //y=7.41 //x2=12.15 //y2=7.585
r545 (  202 317 ) resistor r=33.1979 //w=0.187 //l=0.485 //layer=li \
 //thickness=0.1 //x=12.15 //y=7.41 //x2=12.15 //y2=6.925
r546 (  199 298 ) resistor r=2.87058 //w=0.35 //l=0.085 //layer=li \
 //thickness=0.1 //x=11.355 //y=7.585 //x2=11.27 //y2=7.585
r547 (  199 201 ) resistor r=8.19619 //w=0.367 //l=0.235 //layer=li \
 //thickness=0.1 //x=11.355 //y=7.585 //x2=11.59 //y2=7.585
r548 (  198 299 ) resistor r=2.87058 //w=0.35 //l=0.085 //layer=li \
 //thickness=0.1 //x=12.065 //y=7.585 //x2=12.15 //y2=7.585
r549 (  198 201 ) resistor r=16.5668 //w=0.367 //l=0.475 //layer=li \
 //thickness=0.1 //x=12.065 //y=7.585 //x2=11.59 //y2=7.585
r550 (  190 298 ) resistor r=4.23183 //w=0.7 //l=0.175 //layer=li \
 //thickness=0.1 //x=11.27 //y=7.41 //x2=11.27 //y2=7.585
r551 (  190 316 ) resistor r=56.4706 //w=0.187 //l=0.825 //layer=li \
 //thickness=0.1 //x=11.27 //y=7.41 //x2=11.27 //y2=6.585
r552 (  189 297 ) resistor r=5.29055 //w=0.35 //l=0.17 //layer=li \
 //thickness=0.1 //x=10.65 //y=7.585 //x2=10.48 //y2=7.585
r553 (  188 298 ) resistor r=2.87058 //w=0.35 //l=0.085 //layer=li \
 //thickness=0.1 //x=11.185 //y=7.585 //x2=11.27 //y2=7.585
r554 (  188 189 ) resistor r=18.6594 //w=0.367 //l=0.535 //layer=li \
 //thickness=0.1 //x=11.185 //y=7.585 //x2=10.65 //y2=7.585
r555 (  183 296 ) resistor r=2.87058 //w=0.35 //l=0.085 //layer=li \
 //thickness=0.1 //x=9.9 //y=7.585 //x2=9.815 //y2=7.585
r556 (  183 185 ) resistor r=7.32425 //w=0.367 //l=0.21 //layer=li \
 //thickness=0.1 //x=9.9 //y=7.585 //x2=10.11 //y2=7.585
r557 (  182 297 ) resistor r=5.29055 //w=0.35 //l=0.17 //layer=li \
 //thickness=0.1 //x=10.31 //y=7.585 //x2=10.48 //y2=7.585
r558 (  182 185 ) resistor r=6.97548 //w=0.367 //l=0.2 //layer=li \
 //thickness=0.1 //x=10.31 //y=7.585 //x2=10.11 //y2=7.585
r559 (  174 296 ) resistor r=4.23183 //w=0.7 //l=0.175 //layer=li \
 //thickness=0.1 //x=9.815 //y=7.41 //x2=9.815 //y2=7.585
r560 (  174 315 ) resistor r=56.4706 //w=0.187 //l=0.825 //layer=li \
 //thickness=0.1 //x=9.815 //y=7.41 //x2=9.815 //y2=6.585
r561 (  173 295 ) resistor r=2.87058 //w=0.35 //l=0.085 //layer=li \
 //thickness=0.1 //x=9.02 //y=7.585 //x2=8.935 //y2=7.585
r562 (  172 296 ) resistor r=2.87058 //w=0.35 //l=0.085 //layer=li \
 //thickness=0.1 //x=9.73 //y=7.585 //x2=9.815 //y2=7.585
r563 (  172 173 ) resistor r=24.7629 //w=0.367 //l=0.71 //layer=li \
 //thickness=0.1 //x=9.73 //y=7.585 //x2=9.02 //y2=7.585
r564 (  164 295 ) resistor r=4.23183 //w=0.7 //l=0.175 //layer=li \
 //thickness=0.1 //x=8.935 //y=7.41 //x2=8.935 //y2=7.585
r565 (  164 314 ) resistor r=56.4706 //w=0.187 //l=0.825 //layer=li \
 //thickness=0.1 //x=8.935 //y=7.41 //x2=8.935 //y2=6.585
r566 (  163 293 ) resistor r=5.29055 //w=0.35 //l=0.17 //layer=li \
 //thickness=0.1 //x=8.43 //y=7.585 //x2=8.26 //y2=7.585
r567 (  162 295 ) resistor r=2.87058 //w=0.35 //l=0.085 //layer=li \
 //thickness=0.1 //x=8.85 //y=7.585 //x2=8.935 //y2=7.585
r568 (  162 163 ) resistor r=14.6485 //w=0.367 //l=0.42 //layer=li \
 //thickness=0.1 //x=8.85 //y=7.585 //x2=8.43 //y2=7.585
r569 (  159 292 ) resistor r=2.87058 //w=0.35 //l=0.085 //layer=li \
 //thickness=0.1 //x=7.565 //y=7.585 //x2=7.48 //y2=7.585
r570 (  158 293 ) resistor r=5.29055 //w=0.35 //l=0.17 //layer=li \
 //thickness=0.1 //x=8.09 //y=7.585 //x2=8.26 //y2=7.585
r571 (  158 159 ) resistor r=18.3106 //w=0.367 //l=0.525 //layer=li \
 //thickness=0.1 //x=8.09 //y=7.585 //x2=7.565 //y2=7.585
r572 (  152 292 ) resistor r=4.23183 //w=0.7 //l=0.175 //layer=li \
 //thickness=0.1 //x=7.48 //y=7.41 //x2=7.48 //y2=7.585
r573 (  152 313 ) resistor r=33.1979 //w=0.187 //l=0.485 //layer=li \
 //thickness=0.1 //x=7.48 //y=7.41 //x2=7.48 //y2=6.925
r574 (  151 290 ) resistor r=2.87058 //w=0.35 //l=0.085 //layer=li \
 //thickness=0.1 //x=6.685 //y=7.585 //x2=6.6 //y2=7.585
r575 (  150 292 ) resistor r=2.87058 //w=0.35 //l=0.085 //layer=li \
 //thickness=0.1 //x=7.395 //y=7.585 //x2=7.48 //y2=7.585
r576 (  150 151 ) resistor r=24.7629 //w=0.367 //l=0.71 //layer=li \
 //thickness=0.1 //x=7.395 //y=7.585 //x2=6.685 //y2=7.585
r577 (  144 290 ) resistor r=4.23183 //w=0.7 //l=0.175 //layer=li \
 //thickness=0.1 //x=6.6 //y=7.41 //x2=6.6 //y2=7.585
r578 (  144 312 ) resistor r=33.1979 //w=0.187 //l=0.485 //layer=li \
 //thickness=0.1 //x=6.6 //y=7.41 //x2=6.6 //y2=6.925
r579 (  141 289 ) resistor r=2.87058 //w=0.35 //l=0.085 //layer=li \
 //thickness=0.1 //x=5.805 //y=7.585 //x2=5.72 //y2=7.585
r580 (  141 143 ) resistor r=21.1008 //w=0.367 //l=0.605 //layer=li \
 //thickness=0.1 //x=5.805 //y=7.585 //x2=6.41 //y2=7.585
r581 (  140 290 ) resistor r=2.87058 //w=0.35 //l=0.085 //layer=li \
 //thickness=0.1 //x=6.515 //y=7.585 //x2=6.6 //y2=7.585
r582 (  140 143 ) resistor r=3.66213 //w=0.367 //l=0.105 //layer=li \
 //thickness=0.1 //x=6.515 //y=7.585 //x2=6.41 //y2=7.585
r583 (  132 289 ) resistor r=4.23183 //w=0.7 //l=0.175 //layer=li \
 //thickness=0.1 //x=5.72 //y=7.41 //x2=5.72 //y2=7.585
r584 (  132 311 ) resistor r=56.4706 //w=0.187 //l=0.825 //layer=li \
 //thickness=0.1 //x=5.72 //y=7.41 //x2=5.72 //y2=6.585
r585 (  129 288 ) resistor r=5.29055 //w=0.35 //l=0.17 //layer=li \
 //thickness=0.1 //x=5.1 //y=7.585 //x2=4.93 //y2=7.585
r586 (  129 131 ) resistor r=6.97548 //w=0.367 //l=0.2 //layer=li \
 //thickness=0.1 //x=5.1 //y=7.585 //x2=5.3 //y2=7.585
r587 (  128 289 ) resistor r=2.87058 //w=0.35 //l=0.085 //layer=li \
 //thickness=0.1 //x=5.635 //y=7.585 //x2=5.72 //y2=7.585
r588 (  128 131 ) resistor r=11.6839 //w=0.367 //l=0.335 //layer=li \
 //thickness=0.1 //x=5.635 //y=7.585 //x2=5.3 //y2=7.585
r589 (  125 287 ) resistor r=2.87058 //w=0.35 //l=0.085 //layer=li \
 //thickness=0.1 //x=4.35 //y=7.585 //x2=4.265 //y2=7.585
r590 (  124 288 ) resistor r=5.29055 //w=0.35 //l=0.17 //layer=li \
 //thickness=0.1 //x=4.76 //y=7.585 //x2=4.93 //y2=7.585
r591 (  124 125 ) resistor r=14.2997 //w=0.367 //l=0.41 //layer=li \
 //thickness=0.1 //x=4.76 //y=7.585 //x2=4.35 //y2=7.585
r592 (  116 287 ) resistor r=4.23183 //w=0.7 //l=0.175 //layer=li \
 //thickness=0.1 //x=4.265 //y=7.41 //x2=4.265 //y2=7.585
r593 (  116 310 ) resistor r=56.4706 //w=0.187 //l=0.825 //layer=li \
 //thickness=0.1 //x=4.265 //y=7.41 //x2=4.265 //y2=6.585
r594 (  113 286 ) resistor r=2.87058 //w=0.35 //l=0.085 //layer=li \
 //thickness=0.1 //x=3.47 //y=7.585 //x2=3.385 //y2=7.585
r595 (  113 115 ) resistor r=12.2071 //w=0.367 //l=0.35 //layer=li \
 //thickness=0.1 //x=3.47 //y=7.585 //x2=3.82 //y2=7.585
r596 (  112 287 ) resistor r=2.87058 //w=0.35 //l=0.085 //layer=li \
 //thickness=0.1 //x=4.18 //y=7.585 //x2=4.265 //y2=7.585
r597 (  112 115 ) resistor r=12.5559 //w=0.367 //l=0.36 //layer=li \
 //thickness=0.1 //x=4.18 //y=7.585 //x2=3.82 //y2=7.585
r598 (  104 286 ) resistor r=4.23183 //w=0.7 //l=0.175 //layer=li \
 //thickness=0.1 //x=3.385 //y=7.41 //x2=3.385 //y2=7.585
r599 (  104 309 ) resistor r=56.4706 //w=0.187 //l=0.825 //layer=li \
 //thickness=0.1 //x=3.385 //y=7.41 //x2=3.385 //y2=6.585
r600 (  103 285 ) resistor r=5.29055 //w=0.35 //l=0.17 //layer=li \
 //thickness=0.1 //x=2.88 //y=7.585 //x2=2.71 //y2=7.585
r601 (  102 286 ) resistor r=2.87058 //w=0.35 //l=0.085 //layer=li \
 //thickness=0.1 //x=3.3 //y=7.585 //x2=3.385 //y2=7.585
r602 (  102 103 ) resistor r=14.6485 //w=0.367 //l=0.42 //layer=li \
 //thickness=0.1 //x=3.3 //y=7.585 //x2=2.88 //y2=7.585
r603 (  97 284 ) resistor r=2.87058 //w=0.35 //l=0.085 //layer=li \
 //thickness=0.1 //x=2.13 //y=7.585 //x2=2.045 //y2=7.585
r604 (  97 99 ) resistor r=7.32425 //w=0.367 //l=0.21 //layer=li \
 //thickness=0.1 //x=2.13 //y=7.585 //x2=2.34 //y2=7.585
r605 (  96 285 ) resistor r=5.29055 //w=0.35 //l=0.17 //layer=li \
 //thickness=0.1 //x=2.54 //y=7.585 //x2=2.71 //y2=7.585
r606 (  96 99 ) resistor r=6.97548 //w=0.367 //l=0.2 //layer=li \
 //thickness=0.1 //x=2.54 //y=7.585 //x2=2.34 //y2=7.585
r607 (  88 284 ) resistor r=4.23183 //w=0.7 //l=0.175 //layer=li \
 //thickness=0.1 //x=2.045 //y=7.41 //x2=2.045 //y2=7.585
r608 (  88 308 ) resistor r=56.4706 //w=0.187 //l=0.825 //layer=li \
 //thickness=0.1 //x=2.045 //y=7.41 //x2=2.045 //y2=6.585
r609 (  87 283 ) resistor r=2.87058 //w=0.35 //l=0.085 //layer=li \
 //thickness=0.1 //x=1.25 //y=7.585 //x2=1.165 //y2=7.585
r610 (  86 284 ) resistor r=2.87058 //w=0.35 //l=0.085 //layer=li \
 //thickness=0.1 //x=1.96 //y=7.585 //x2=2.045 //y2=7.585
r611 (  86 87 ) resistor r=24.7629 //w=0.367 //l=0.71 //layer=li \
 //thickness=0.1 //x=1.96 //y=7.585 //x2=1.25 //y2=7.585
r612 (  78 283 ) resistor r=4.23183 //w=0.7 //l=0.175 //layer=li \
 //thickness=0.1 //x=1.165 //y=7.41 //x2=1.165 //y2=7.585
r613 (  78 307 ) resistor r=56.4706 //w=0.187 //l=0.825 //layer=li \
 //thickness=0.1 //x=1.165 //y=7.41 //x2=1.165 //y2=6.585
r614 (  73 322 ) resistor r=9.3 //w=0.17 //l=0.17 //layer=mcon //count=1 \
 //x=20.59 //y=6.92 //x2=20.59 //y2=6.92
r615 (  70 321 ) resistor r=9.3 //w=0.17 //l=0.17 //layer=mcon //count=1 \
 //x=17.26 //y=6.92 //x2=17.26 //y2=6.92
r616 (  46 272 ) resistor r=9.3 //w=0.17 //l=0.17 //layer=mcon //count=1 \
 //x=22.32 //y=7.58 //x2=22.32 //y2=7.58
r617 (  44 270 ) resistor r=3.1 //w=0.17 //l=0.51 //layer=mcon //count=3 \
 //x=21.58 //y=7.58 //x2=21.58 //y2=7.58
r618 (  44 46 ) resistor r=0.297428 //w=0.311 //l=0.74 //layer=m1 \
 //thickness=0.36 //x=21.58 //y=7.585 //x2=22.32 //y2=7.585
r619 (  42 71 ) resistor r=0.028033 //w=0.35 //l=0.085 //layer=m1 \
 //thickness=0.36 //x=20.675 //y=7.585 //x2=20.59 //y2=7.585
r620 (  42 44 ) resistor r=0.363746 //w=0.311 //l=0.905 //layer=m1 \
 //thickness=0.36 //x=20.675 //y=7.585 //x2=21.58 //y2=7.585
r621 (  41 71 ) resistor r=0.0413265 //w=0.7 //l=0.175 //layer=m1 \
 //thickness=0.36 //x=20.59 //y=7.41 //x2=20.59 //y2=7.585
r622 (  40 73 ) resistor r=0.0723371 //w=0.218 //l=0.115 //layer=m1 \
 //thickness=0.36 //x=20.59 //y=7.035 //x2=20.59 //y2=6.92
r623 (  40 41 ) resistor r=0.357824 //w=0.131 //l=0.375 //layer=m1 \
 //thickness=0.36 //x=20.59 //y=7.035 //x2=20.59 //y2=7.41
r624 (  39 268 ) resistor r=3.1 //w=0.17 //l=0.51 //layer=mcon //count=3 \
 //x=20.47 //y=7.58 //x2=20.47 //y2=7.58
r625 (  37 255 ) resistor r=3.1 //w=0.17 //l=0.51 //layer=mcon //count=3 \
 //x=18.99 //y=7.58 //x2=18.99 //y2=7.58
r626 (  37 39 ) resistor r=0.594855 //w=0.311 //l=1.48 //layer=m1 \
 //thickness=0.36 //x=18.99 //y=7.585 //x2=20.47 //y2=7.585
r627 (  35 253 ) resistor r=3.1 //w=0.17 //l=0.51 //layer=mcon //count=3 \
 //x=17.88 //y=7.58 //x2=17.88 //y2=7.58
r628 (  35 37 ) resistor r=0.446141 //w=0.311 //l=1.11 //layer=m1 \
 //thickness=0.36 //x=17.88 //y=7.585 //x2=18.99 //y2=7.585
r629 (  33 68 ) resistor r=0.028033 //w=0.35 //l=0.085 //layer=m1 \
 //thickness=0.36 //x=17.345 //y=7.585 //x2=17.26 //y2=7.585
r630 (  33 35 ) resistor r=0.215032 //w=0.311 //l=0.535 //layer=m1 \
 //thickness=0.36 //x=17.345 //y=7.585 //x2=17.88 //y2=7.585
r631 (  32 71 ) resistor r=0.028033 //w=0.35 //l=0.085 //layer=m1 \
 //thickness=0.36 //x=20.505 //y=7.585 //x2=20.59 //y2=7.585
r632 (  32 39 ) resistor r=0.0140675 //w=0.311 //l=0.035 //layer=m1 \
 //thickness=0.36 //x=20.505 //y=7.585 //x2=20.47 //y2=7.585
r633 (  31 68 ) resistor r=0.0413265 //w=0.7 //l=0.175 //layer=m1 \
 //thickness=0.36 //x=17.26 //y=7.41 //x2=17.26 //y2=7.585
r634 (  30 70 ) resistor r=0.0723371 //w=0.218 //l=0.115 //layer=m1 \
 //thickness=0.36 //x=17.26 //y=7.035 //x2=17.26 //y2=6.92
r635 (  30 31 ) resistor r=0.357824 //w=0.131 //l=0.375 //layer=m1 \
 //thickness=0.36 //x=17.26 //y=7.035 //x2=17.26 //y2=7.41
r636 (  29 251 ) resistor r=3.1 //w=0.17 //l=0.51 //layer=mcon //count=3 \
 //x=16.77 //y=7.58 //x2=16.77 //y2=7.58
r637 (  27 304 ) resistor r=3.1 //w=0.17 //l=0.51 //layer=mcon //count=3 \
 //x=15.29 //y=7.58 //x2=15.29 //y2=7.58
r638 (  27 29 ) resistor r=0.594855 //w=0.311 //l=1.48 //layer=m1 \
 //thickness=0.36 //x=15.29 //y=7.585 //x2=16.77 //y2=7.585
r639 (  25 225 ) resistor r=3.1 //w=0.17 //l=0.51 //layer=mcon //count=3 \
 //x=14.18 //y=7.58 //x2=14.18 //y2=7.58
r640 (  25 27 ) resistor r=0.446141 //w=0.311 //l=1.11 //layer=m1 \
 //thickness=0.36 //x=14.18 //y=7.585 //x2=15.29 //y2=7.585
r641 (  23 211 ) resistor r=3.1 //w=0.17 //l=0.51 //layer=mcon //count=3 \
 //x=12.7 //y=7.58 //x2=12.7 //y2=7.58
r642 (  23 25 ) resistor r=0.594855 //w=0.311 //l=1.48 //layer=m1 \
 //thickness=0.36 //x=12.7 //y=7.585 //x2=14.18 //y2=7.585
r643 (  19 185 ) resistor r=3.1 //w=0.17 //l=0.51 //layer=mcon //count=3 \
 //x=10.11 //y=7.58 //x2=10.11 //y2=7.58
r644 (  17 295 ) resistor r=3.1 //w=0.17 //l=0.51 //layer=mcon //count=3 //x=9 \
 //y=7.58 //x2=9 //y2=7.58
r645 (  17 19 ) resistor r=0.446141 //w=0.311 //l=1.11 //layer=m1 \
 //thickness=0.36 //x=9 //y=7.585 //x2=10.11 //y2=7.585
r646 (  15 292 ) resistor r=3.1 //w=0.17 //l=0.51 //layer=mcon //count=3 \
 //x=7.52 //y=7.58 //x2=7.52 //y2=7.58
r647 (  15 17 ) resistor r=0.594855 //w=0.311 //l=1.48 //layer=m1 \
 //thickness=0.36 //x=7.52 //y=7.585 //x2=9 //y2=7.585
r648 (  13 143 ) resistor r=3.1 //w=0.17 //l=0.51 //layer=mcon //count=3 \
 //x=6.41 //y=7.58 //x2=6.41 //y2=7.58
r649 (  13 15 ) resistor r=0.446141 //w=0.311 //l=1.11 //layer=m1 \
 //thickness=0.36 //x=6.41 //y=7.585 //x2=7.52 //y2=7.585
r650 (  11 131 ) resistor r=3.1 //w=0.17 //l=0.51 //layer=mcon //count=3 \
 //x=5.3 //y=7.58 //x2=5.3 //y2=7.58
r651 (  11 13 ) resistor r=0.446141 //w=0.311 //l=1.11 //layer=m1 \
 //thickness=0.36 //x=5.3 //y=7.585 //x2=6.41 //y2=7.585
r652 (  9 115 ) resistor r=3.1 //w=0.17 //l=0.51 //layer=mcon //count=3 \
 //x=3.82 //y=7.58 //x2=3.82 //y2=7.58
r653 (  9 11 ) resistor r=0.594855 //w=0.311 //l=1.48 //layer=m1 \
 //thickness=0.36 //x=3.82 //y=7.585 //x2=5.3 //y2=7.585
r654 (  7 99 ) resistor r=3.1 //w=0.17 //l=0.51 //layer=mcon //count=3 \
 //x=2.34 //y=7.58 //x2=2.34 //y2=7.58
r655 (  7 9 ) resistor r=0.594855 //w=0.311 //l=1.48 //layer=m1 \
 //thickness=0.36 //x=2.34 //y=7.585 //x2=3.82 //y2=7.585
r656 (  4 283 ) resistor r=3.1 //w=0.17 //l=0.51 //layer=mcon //count=3 \
 //x=1.23 //y=7.58 //x2=1.23 //y2=7.58
r657 (  4 7 ) resistor r=0.446141 //w=0.311 //l=1.11 //layer=m1 \
 //thickness=0.36 //x=1.23 //y=7.585 //x2=2.34 //y2=7.585
r658 (  2 68 ) resistor r=0.028033 //w=0.35 //l=0.085 //layer=m1 \
 //thickness=0.36 //x=17.175 //y=7.585 //x2=17.26 //y2=7.585
r659 (  2 29 ) resistor r=0.162781 //w=0.311 //l=0.405 //layer=m1 \
 //thickness=0.36 //x=17.175 //y=7.585 //x2=16.77 //y2=7.585
r660 (  1 201 ) resistor r=3.1 //w=0.17 //l=0.51 //layer=mcon //count=3 \
 //x=11.59 //y=7.58 //x2=11.59 //y2=7.58
r661 (  1 23 ) resistor r=0.446141 //w=0.311 //l=1.11 //layer=m1 \
 //thickness=0.36 //x=11.59 //y=7.585 //x2=12.7 //y2=7.585
r662 (  1 19 ) resistor r=0.594855 //w=0.311 //l=1.48 //layer=m1 \
 //thickness=0.36 //x=11.59 //y=7.585 //x2=10.11 //y2=7.585
ends PM_DLATCHN\%VDD

subckt PM_DLATCHN\%GATE_N ( 1 2 3 4 5 6 8 16 21 26 30 31 32 33 34 35 36 40 41 \
 42 44 50 51 53 )
c82 ( 53 0 ) capacitor c=0.0564228f //x=1.23 //y=2.265
c83 ( 51 0 ) capacitor c=0.0439576f //x=1.87 //y=1.435
c84 ( 50 0 ) capacitor c=0.0201087f //x=1.87 //y=1.09
c85 ( 44 0 ) capacitor c=0.0161986f //x=1.715 //y=1.59
c86 ( 42 0 ) capacitor c=0.0157807f //x=1.715 //y=0.935
c87 ( 41 0 ) capacitor c=0.0554306f //x=1.46 //y=4.97
c88 ( 40 0 ) capacitor c=0.0407054f //x=1.75 //y=4.97
c89 ( 36 0 ) capacitor c=0.0301471f //x=1.34 //y=2.1
c90 ( 35 0 ) capacitor c=0.0255349f //x=1.34 //y=1.745
c91 ( 34 0 ) capacitor c=0.0234346f //x=1.34 //y=1.435
c92 ( 33 0 ) capacitor c=0.02013f //x=1.34 //y=1.09
c93 ( 32 0 ) capacitor c=0.153944f //x=1.825 //y=6.2
c94 ( 31 0 ) capacitor c=0.154411f //x=1.385 //y=6.2
c95 ( 26 0 ) capacitor c=9.4527e-19 //x=1.23 //y=4.88
c96 ( 21 0 ) capacitor c=9.11699e-19 //x=1.23 //y=2.265
c97 ( 16 0 ) capacitor c=0.0143254f //x=1.23 //y=2.265
c98 ( 8 0 ) capacitor c=0.0101842f //x=1.23 //y=4.76
c99 ( 1 0 ) capacitor c=0.0971797f //x=1.23 //y=2.77
r100 (  53 54 ) resistor r=17.5563 //w=0.302 //l=0.11 //layer=ply \
 //thickness=0.18 //x=1.23 //y=2.265 //x2=1.34 //y2=2.265
r101 (  51 60 ) resistor r=45.1352 //w=0.168 //l=0.173853 //layer=ply \
 //thickness=0.18 //x=1.87 //y=1.435 //x2=1.83 //y2=1.59
r102 (  50 59 ) resistor r=45.1352 //w=0.168 //l=0.173853 //layer=ply \
 //thickness=0.18 //x=1.87 //y=1.09 //x2=1.83 //y2=0.935
r103 (  50 51 ) resistor r=176.904 //w=0.094 //l=0.345 //layer=ply \
 //thickness=0.18 //x=1.87 //y=1.09 //x2=1.87 //y2=1.435
r104 (  45 58 ) resistor r=10.701 //w=0.21 //l=0.115 //layer=ply \
 //thickness=0.18 //x=1.495 //y=1.59 //x2=1.38 //y2=1.59
r105 (  44 60 ) resistor r=5.52526 //w=0.168 //l=0.115 //layer=ply \
 //thickness=0.18 //x=1.715 //y=1.59 //x2=1.83 //y2=1.59
r106 (  43 57 ) resistor r=5.52526 //w=0.168 //l=0.115 //layer=ply \
 //thickness=0.18 //x=1.495 //y=0.935 //x2=1.38 //y2=0.935
r107 (  42 59 ) resistor r=5.52526 //w=0.168 //l=0.115 //layer=ply \
 //thickness=0.18 //x=1.715 //y=0.935 //x2=1.83 //y2=0.935
r108 (  42 43 ) resistor r=112.809 //w=0.094 //l=0.22 //layer=ply \
 //thickness=0.18 //x=1.715 //y=0.935 //x2=1.495 //y2=0.935
r109 (  40 47 ) resistor r=26.9307 //w=0.15 //l=0.106066 //layer=ply \
 //thickness=0.18 //x=1.75 //y=4.97 //x2=1.825 //y2=5.045
r110 (  40 41 ) resistor r=148.702 //w=0.094 //l=0.29 //layer=ply \
 //thickness=0.18 //x=1.75 //y=4.97 //x2=1.46 //y2=4.97
r111 (  37 41 ) resistor r=23.403 //w=0.284 //l=0.106066 //layer=ply \
 //thickness=0.18 //x=1.385 //y=5.045 //x2=1.46 //y2=4.97
r112 (  37 56 ) resistor r=26.3063 //w=0.284 //l=0.229783 //layer=ply \
 //thickness=0.18 //x=1.385 //y=5.045 //x2=1.23 //y2=4.88
r113 (  36 54 ) resistor r=19.1248 //w=0.302 //l=0.165 //layer=ply \
 //thickness=0.18 //x=1.34 //y=2.1 //x2=1.34 //y2=2.265
r114 (  35 58 ) resistor r=39.5823 //w=0.21 //l=0.173853 //layer=ply \
 //thickness=0.18 //x=1.34 //y=1.745 //x2=1.38 //y2=1.59
r115 (  35 36 ) resistor r=182.032 //w=0.094 //l=0.355 //layer=ply \
 //thickness=0.18 //x=1.34 //y=1.745 //x2=1.34 //y2=2.1
r116 (  34 58 ) resistor r=39.5823 //w=0.21 //l=0.173853 //layer=ply \
 //thickness=0.18 //x=1.34 //y=1.435 //x2=1.38 //y2=1.59
r117 (  33 57 ) resistor r=45.1352 //w=0.168 //l=0.173853 //layer=ply \
 //thickness=0.18 //x=1.34 //y=1.09 //x2=1.38 //y2=0.935
r118 (  33 34 ) resistor r=176.904 //w=0.094 //l=0.345 //layer=ply \
 //thickness=0.18 //x=1.34 //y=1.09 //x2=1.34 //y2=1.435
r119 (  32 47 ) resistor r=592.245 //w=0.094 //l=1.155 //layer=ply \
 //thickness=0.18 //x=1.825 //y=6.2 //x2=1.825 //y2=5.045
r120 (  31 37 ) resistor r=592.245 //w=0.094 //l=1.155 //layer=ply \
 //thickness=0.18 //x=1.385 //y=6.2 //x2=1.385 //y2=5.045
r121 (  30 44 ) resistor r=56.4043 //w=0.094 //l=0.11 //layer=ply \
 //thickness=0.18 //x=1.605 //y=1.59 //x2=1.715 //y2=1.59
r122 (  30 45 ) resistor r=56.4043 //w=0.094 //l=0.11 //layer=ply \
 //thickness=0.18 //x=1.605 //y=1.59 //x2=1.495 //y2=1.59
r123 (  26 56 ) resistor r=152 //w=0.17 //l=0.17 //layer=licon //count=1 \
 //x=1.23 //y=4.88 //x2=1.23 //y2=4.88
r124 (  21 53 ) resistor r=152 //w=0.17 //l=0.17 //layer=licon //count=1 \
 //x=1.23 //y=2.265 //x2=1.23 //y2=2.265
r125 (  19 26 ) resistor r=9.3 //w=0.17 //l=0.17 //layer=mcon //count=1 \
 //x=1.23 //y=4.88 //x2=1.23 //y2=4.88
r126 (  16 21 ) resistor r=9.3 //w=0.17 //l=0.17 //layer=mcon //count=1 \
 //x=1.23 //y=2.265 //x2=1.23 //y2=2.265
r127 (  8 19 ) resistor r=0.0732479 //w=0.241 //l=0.122474 //layer=m1 \
 //thickness=0.36 //x=1.23 //y=4.76 //x2=1.235 //y2=4.88
r128 (  7 16 ) resistor r=0.116051 //w=0.211 //l=0.165 //layer=m1 \
 //thickness=0.36 //x=1.23 //y=2.43 //x2=1.23 //y2=2.265
r129 (  6 8 ) resistor r=0.133588 //w=0.131 //l=0.14 //layer=m1 \
 //thickness=0.36 //x=1.23 //y=4.62 //x2=1.23 //y2=4.76
r130 (  5 6 ) resistor r=0.353053 //w=0.131 //l=0.37 //layer=m1 \
 //thickness=0.36 //x=1.23 //y=4.25 //x2=1.23 //y2=4.62
r131 (  4 5 ) resistor r=0.353053 //w=0.131 //l=0.37 //layer=m1 \
 //thickness=0.36 //x=1.23 //y=3.88 //x2=1.23 //y2=4.25
r132 (  3 4 ) resistor r=0.353053 //w=0.131 //l=0.37 //layer=m1 \
 //thickness=0.36 //x=1.23 //y=3.51 //x2=1.23 //y2=3.88
r133 (  2 3 ) resistor r=0.353053 //w=0.131 //l=0.37 //layer=m1 \
 //thickness=0.36 //x=1.23 //y=3.14 //x2=1.23 //y2=3.51
r134 (  1 2 ) resistor r=0.353053 //w=0.131 //l=0.37 //layer=m1 \
 //thickness=0.36 //x=1.23 //y=2.77 //x2=1.23 //y2=3.14
r135 (  1 7 ) resistor r=0.324427 //w=0.131 //l=0.34 //layer=m1 \
 //thickness=0.36 //x=1.23 //y=2.77 //x2=1.23 //y2=2.43
ends PM_DLATCHN\%GATE_N

subckt PM_DLATCHN\%GND ( 1 2 14 44 47 48 52 53 67 71 93 97 100 109 127 132 136 \
 139 150 168 173 177 199 213 241 255 268 271 282 293 294 306 307 319 330 340 \
 341 342 343 344 345 346 347 )
c444 ( 347 0 ) capacitor c=0.0751235f //x=19.92 //y=0.545
c445 ( 346 0 ) capacitor c=0.0748611f //x=16.59 //y=0.545
c446 ( 345 0 ) capacitor c=0.0633685f //x=14.305 //y=0.55
c447 ( 344 0 ) capacitor c=0.00843555f //x=11.47 //y=1.045
c448 ( 343 0 ) capacitor c=0.0629514f //x=8.755 //y=0.55
c449 ( 342 0 ) capacitor c=0.00843555f //x=5.92 //y=1.045
c450 ( 341 0 ) capacitor c=0.0629571f //x=3.205 //y=0.55
c451 ( 340 0 ) capacitor c=0.0637405f //x=0.985 //y=0.55
c452 ( 337 0 ) capacitor c=0.00597439f //x=21.995 //y=0.175
c453 ( 334 0 ) capacitor c=0.00597439f //x=21.025 //y=0.175
c454 ( 331 0 ) capacitor c=0.00597439f //x=20.055 //y=0.175
c455 ( 330 0 ) capacitor c=0.118141f //x=19.36 //y=0.175
c456 ( 327 0 ) capacitor c=0.00597439f //x=18.665 //y=0.175
c457 ( 324 0 ) capacitor c=0.00597439f //x=17.695 //y=0.175
c458 ( 321 0 ) capacitor c=0.00597439f //x=16.77 //y=0.18
c459 ( 319 0 ) capacitor c=0.113151f //x=16.03 //y=0.175
c460 ( 307 0 ) capacitor c=0.113044f //x=13.81 //y=0.175
c461 ( 306 0 ) capacitor c=0.112336f //x=10.48 //y=0.175
c462 ( 294 0 ) capacitor c=0.112889f //x=8.26 //y=0.175
c463 ( 293 0 ) capacitor c=0.112336f //x=4.93 //y=0.175
c464 ( 282 0 ) capacitor c=0.107661f //x=2.71 //y=0.175
c465 ( 271 0 ) capacitor c=0.216606f //x=1.12 //y=0.175
c466 ( 268 0 ) capacitor c=0.232015f //x=22.32 //y=0.18
c467 ( 260 0 ) capacitor c=0.00739123f //x=21.995 //y=0.625
c468 ( 255 0 ) capacitor c=0.0152893f //x=21.91 //y=0.71
c469 ( 251 0 ) capacitor c=0.0258125f //x=21.91 //y=0.175
c470 ( 246 0 ) capacitor c=0.00726869f //x=21.025 //y=0.625
c471 ( 241 0 ) capacitor c=0.0166431f //x=20.94 //y=0.71
c472 ( 237 0 ) capacitor c=0.0257966f //x=20.94 //y=0.175
c473 ( 232 0 ) capacitor c=0.00739123f //x=20.055 //y=0.625
c474 ( 229 0 ) capacitor c=0.0229116f //x=19.97 //y=0.175
c475 ( 223 0 ) capacitor c=0.0223094f //x=19.19 //y=0.175
c476 ( 218 0 ) capacitor c=0.00739123f //x=18.665 //y=0.625
c477 ( 213 0 ) capacitor c=0.0151622f //x=18.58 //y=0.71
c478 ( 209 0 ) capacitor c=0.0258125f //x=18.58 //y=0.175
c479 ( 204 0 ) capacitor c=0.00726869f //x=17.695 //y=0.625
c480 ( 199 0 ) capacitor c=0.0166948f //x=17.61 //y=0.71
c481 ( 197 0 ) capacitor c=0.0257966f //x=17.61 //y=0.175
c482 ( 192 0 ) capacitor c=0.00739123f //x=16.725 //y=0.625
c483 ( 189 0 ) capacitor c=0.0229116f //x=16.64 //y=0.175
c484 ( 186 0 ) capacitor c=0.0366946f //x=15.495 //y=0.175
c485 ( 185 0 ) capacitor c=0.0186173f //x=15.86 //y=0.175
c486 ( 180 0 ) capacitor c=0.00585268f //x=15.41 //y=0.63
c487 ( 177 0 ) capacitor c=0.0061991f //x=15.325 //y=0.715
c488 ( 176 0 ) capacitor c=0.00479851f //x=14.92 //y=0.63
c489 ( 173 0 ) capacitor c=0.00647872f //x=14.835 //y=0.715
c490 ( 168 0 ) capacitor c=0.00586769f //x=14.44 //y=0.63
c491 ( 163 0 ) capacitor c=0.0190482f //x=14.355 //y=0.175
c492 ( 150 0 ) capacitor c=0.125256f //x=13.64 //y=0.175
c493 ( 145 0 ) capacitor c=0.0366946f //x=9.945 //y=0.175
c494 ( 144 0 ) capacitor c=0.0186173f //x=10.31 //y=0.175
c495 ( 139 0 ) capacitor c=0.00585268f //x=9.86 //y=0.63
c496 ( 136 0 ) capacitor c=0.00617458f //x=9.775 //y=0.715
c497 ( 135 0 ) capacitor c=0.00479851f //x=9.37 //y=0.63
c498 ( 132 0 ) capacitor c=0.00647872f //x=9.285 //y=0.715
c499 ( 127 0 ) capacitor c=0.00586769f //x=8.89 //y=0.63
c500 ( 124 0 ) capacitor c=0.0190482f //x=8.805 //y=0.175
c501 ( 109 0 ) capacitor c=0.125331f //x=8.09 //y=0.175
c502 ( 106 0 ) capacitor c=0.0366946f //x=4.395 //y=0.175
c503 ( 105 0 ) capacitor c=0.0186173f //x=4.76 //y=0.175
c504 ( 100 0 ) capacitor c=0.00585268f //x=4.31 //y=0.63
c505 ( 97 0 ) capacitor c=0.00617458f //x=4.225 //y=0.715
c506 ( 96 0 ) capacitor c=0.00479851f //x=3.82 //y=0.63
c507 ( 93 0 ) capacitor c=0.00645303f //x=3.735 //y=0.715
c508 ( 88 0 ) capacitor c=0.00590583f //x=3.34 //y=0.63
c509 ( 85 0 ) capacitor c=0.0191899f //x=3.255 //y=0.175
c510 ( 80 0 ) capacitor c=0.0366946f //x=2.175 //y=0.175
c511 ( 79 0 ) capacitor c=0.0185511f //x=2.54 //y=0.175
c512 ( 74 0 ) capacitor c=0.00589014f //x=2.09 //y=0.63
c513 ( 71 0 ) capacitor c=0.00610579f //x=2.005 //y=0.715
c514 ( 70 0 ) capacitor c=0.00479851f //x=1.6 //y=0.63
c515 ( 67 0 ) capacitor c=0.0064899f //x=1.515 //y=0.715
c516 ( 62 0 ) capacitor c=0.00590583f //x=1.12 //y=0.63
c517 ( 53 0 ) capacitor c=0.0278993f //x=11.657 //y=1.005
c518 ( 52 0 ) capacitor c=0.0140988f //x=11.66 //y=1.135
c519 ( 50 0 ) capacitor c=0.00509083f //x=6.11 //y=0.175
c520 ( 48 0 ) capacitor c=0.0278993f //x=6.107 //y=1.005
c521 ( 47 0 ) capacitor c=0.0137658f //x=6.11 //y=1.135
c522 ( 44 0 ) capacitor c=0.400933f //x=22.32 //y=0.18
c523 ( 14 0 ) capacitor c=0.188145f //x=11.575 //y=0.175
c524 ( 2 0 ) capacitor c=0.231717f //x=6.025 //y=0.175
c525 ( 1 0 ) capacitor c=0.00509083f //x=11.59 //y=0.175
r526 (  311 312 ) resistor r=4.18529 //w=0.367 //l=0.12 //layer=li \
 //thickness=0.1 //x=15.29 //y=0.175 //x2=15.41 //y2=0.175
r527 (  309 311 ) resistor r=12.9046 //w=0.367 //l=0.37 //layer=li \
 //thickness=0.1 //x=14.92 //y=0.175 //x2=15.29 //y2=0.175
r528 (  308 309 ) resistor r=16.7411 //w=0.367 //l=0.48 //layer=li \
 //thickness=0.1 //x=14.44 //y=0.175 //x2=14.92 //y2=0.175
r529 (  298 299 ) resistor r=17.0899 //w=0.367 //l=0.49 //layer=li \
 //thickness=0.1 //x=9.37 //y=0.175 //x2=9.86 //y2=0.175
r530 (  297 298 ) resistor r=12.9046 //w=0.367 //l=0.37 //layer=li \
 //thickness=0.1 //x=9 //y=0.175 //x2=9.37 //y2=0.175
r531 (  295 297 ) resistor r=3.83651 //w=0.367 //l=0.11 //layer=li \
 //thickness=0.1 //x=8.89 //y=0.175 //x2=9 //y2=0.175
r532 (  285 286 ) resistor r=17.0899 //w=0.367 //l=0.49 //layer=li \
 //thickness=0.1 //x=3.82 //y=0.175 //x2=4.31 //y2=0.175
r533 (  283 285 ) resistor r=16.7411 //w=0.367 //l=0.48 //layer=li \
 //thickness=0.1 //x=3.34 //y=0.175 //x2=3.82 //y2=0.175
r534 (  274 275 ) resistor r=17.0899 //w=0.367 //l=0.49 //layer=li \
 //thickness=0.1 //x=1.6 //y=0.175 //x2=2.09 //y2=0.175
r535 (  273 274 ) resistor r=12.9046 //w=0.367 //l=0.37 //layer=li \
 //thickness=0.1 //x=1.23 //y=0.175 //x2=1.6 //y2=0.175
r536 (  271 273 ) resistor r=3.83651 //w=0.367 //l=0.11 //layer=li \
 //thickness=0.1 //x=1.12 //y=0.175 //x2=1.23 //y2=0.175
r537 (  266 337 ) resistor r=2.87058 //w=0.35 //l=0.085 //layer=li \
 //thickness=0.1 //x=22.08 //y=0.175 //x2=21.995 //y2=0.175
r538 (  266 268 ) resistor r=8.37057 //w=0.367 //l=0.24 //layer=li \
 //thickness=0.1 //x=22.08 //y=0.175 //x2=22.32 //y2=0.175
r539 (  261 347 ) resistor r=5.4201 //w=0.17 //l=0.085 //layer=li \
 //thickness=0.1 //x=21.995 //y=0.795 //x2=21.995 //y2=0.71
r540 (  261 347 ) resistor r=18.139 //w=0.187 //l=0.265 //layer=li \
 //thickness=0.1 //x=21.995 //y=0.795 //x2=21.995 //y2=1.06
r541 (  260 347 ) resistor r=5.4201 //w=0.17 //l=0.085 //layer=li \
 //thickness=0.1 //x=21.995 //y=0.625 //x2=21.995 //y2=0.71
r542 (  259 337 ) resistor r=4.23183 //w=0.7 //l=0.175 //layer=li \
 //thickness=0.1 //x=21.995 //y=0.35 //x2=21.995 //y2=0.175
r543 (  259 260 ) resistor r=18.8235 //w=0.187 //l=0.275 //layer=li \
 //thickness=0.1 //x=21.995 //y=0.35 //x2=21.995 //y2=0.625
r544 (  256 347 ) resistor r=6.4 //w=0.17 //l=0.085 //layer=li //thickness=0.1 \
 //x=21.11 //y=0.71 //x2=21.025 //y2=0.71
r545 (  256 347 ) resistor r=27.3797 //w=0.187 //l=0.4 //layer=li \
 //thickness=0.1 //x=21.11 //y=0.71 //x2=21.51 //y2=0.71
r546 (  255 347 ) resistor r=1.40859 //w=0.34 //l=0.085 //layer=li \
 //thickness=0.1 //x=21.91 //y=0.71 //x2=21.995 //y2=0.71
r547 (  255 347 ) resistor r=27.3797 //w=0.187 //l=0.4 //layer=li \
 //thickness=0.1 //x=21.91 //y=0.71 //x2=21.51 //y2=0.71
r548 (  252 334 ) resistor r=2.87058 //w=0.35 //l=0.085 //layer=li \
 //thickness=0.1 //x=21.11 //y=0.175 //x2=21.025 //y2=0.175
r549 (  252 254 ) resistor r=16.3924 //w=0.367 //l=0.47 //layer=li \
 //thickness=0.1 //x=21.11 //y=0.175 //x2=21.58 //y2=0.175
r550 (  251 337 ) resistor r=2.87058 //w=0.35 //l=0.085 //layer=li \
 //thickness=0.1 //x=21.91 //y=0.175 //x2=21.995 //y2=0.175
r551 (  251 254 ) resistor r=11.5095 //w=0.367 //l=0.33 //layer=li \
 //thickness=0.1 //x=21.91 //y=0.175 //x2=21.58 //y2=0.175
r552 (  247 347 ) resistor r=6.4 //w=0.17 //l=0.085 //layer=li //thickness=0.1 \
 //x=21.025 //y=0.795 //x2=21.025 //y2=0.71
r553 (  247 347 ) resistor r=18.139 //w=0.187 //l=0.265 //layer=li \
 //thickness=0.1 //x=21.025 //y=0.795 //x2=21.025 //y2=1.06
r554 (  246 347 ) resistor r=6.4 //w=0.17 //l=0.085 //layer=li //thickness=0.1 \
 //x=21.025 //y=0.625 //x2=21.025 //y2=0.71
r555 (  245 334 ) resistor r=4.23183 //w=0.7 //l=0.175 //layer=li \
 //thickness=0.1 //x=21.025 //y=0.35 //x2=21.025 //y2=0.175
r556 (  245 246 ) resistor r=18.8235 //w=0.187 //l=0.275 //layer=li \
 //thickness=0.1 //x=21.025 //y=0.35 //x2=21.025 //y2=0.625
r557 (  242 347 ) resistor r=1.40859 //w=0.34 //l=0.085 //layer=li \
 //thickness=0.1 //x=20.14 //y=0.71 //x2=20.055 //y2=0.71
r558 (  242 347 ) resistor r=27.3797 //w=0.187 //l=0.4 //layer=li \
 //thickness=0.1 //x=20.14 //y=0.71 //x2=20.54 //y2=0.71
r559 (  241 347 ) resistor r=6.4 //w=0.17 //l=0.085 //layer=li //thickness=0.1 \
 //x=20.94 //y=0.71 //x2=21.025 //y2=0.71
r560 (  241 347 ) resistor r=27.3797 //w=0.187 //l=0.4 //layer=li \
 //thickness=0.1 //x=20.94 //y=0.71 //x2=20.54 //y2=0.71
r561 (  238 331 ) resistor r=2.87058 //w=0.35 //l=0.085 //layer=li \
 //thickness=0.1 //x=20.14 //y=0.175 //x2=20.055 //y2=0.175
r562 (  238 240 ) resistor r=11.5095 //w=0.367 //l=0.33 //layer=li \
 //thickness=0.1 //x=20.14 //y=0.175 //x2=20.47 //y2=0.175
r563 (  237 334 ) resistor r=2.87058 //w=0.35 //l=0.085 //layer=li \
 //thickness=0.1 //x=20.94 //y=0.175 //x2=21.025 //y2=0.175
r564 (  237 240 ) resistor r=16.3924 //w=0.367 //l=0.47 //layer=li \
 //thickness=0.1 //x=20.94 //y=0.175 //x2=20.47 //y2=0.175
r565 (  233 347 ) resistor r=5.4201 //w=0.17 //l=0.085 //layer=li \
 //thickness=0.1 //x=20.055 //y=0.795 //x2=20.055 //y2=0.71
r566 (  233 347 ) resistor r=41.4118 //w=0.187 //l=0.605 //layer=li \
 //thickness=0.1 //x=20.055 //y=0.795 //x2=20.055 //y2=1.4
r567 (  232 347 ) resistor r=5.4201 //w=0.17 //l=0.085 //layer=li \
 //thickness=0.1 //x=20.055 //y=0.625 //x2=20.055 //y2=0.71
r568 (  231 331 ) resistor r=4.23183 //w=0.7 //l=0.175 //layer=li \
 //thickness=0.1 //x=20.055 //y=0.35 //x2=20.055 //y2=0.175
r569 (  231 232 ) resistor r=18.8235 //w=0.187 //l=0.275 //layer=li \
 //thickness=0.1 //x=20.055 //y=0.35 //x2=20.055 //y2=0.625
r570 (  230 330 ) resistor r=5.29055 //w=0.35 //l=0.17 //layer=li \
 //thickness=0.1 //x=19.53 //y=0.175 //x2=19.36 //y2=0.175
r571 (  229 331 ) resistor r=2.87058 //w=0.35 //l=0.085 //layer=li \
 //thickness=0.1 //x=19.97 //y=0.175 //x2=20.055 //y2=0.175
r572 (  229 230 ) resistor r=15.346 //w=0.367 //l=0.44 //layer=li \
 //thickness=0.1 //x=19.97 //y=0.175 //x2=19.53 //y2=0.175
r573 (  224 327 ) resistor r=2.87058 //w=0.35 //l=0.085 //layer=li \
 //thickness=0.1 //x=18.75 //y=0.175 //x2=18.665 //y2=0.175
r574 (  224 226 ) resistor r=8.37057 //w=0.367 //l=0.24 //layer=li \
 //thickness=0.1 //x=18.75 //y=0.175 //x2=18.99 //y2=0.175
r575 (  223 330 ) resistor r=5.29055 //w=0.35 //l=0.17 //layer=li \
 //thickness=0.1 //x=19.19 //y=0.175 //x2=19.36 //y2=0.175
r576 (  223 226 ) resistor r=6.97548 //w=0.367 //l=0.2 //layer=li \
 //thickness=0.1 //x=19.19 //y=0.175 //x2=18.99 //y2=0.175
r577 (  219 346 ) resistor r=5.4201 //w=0.17 //l=0.085 //layer=li \
 //thickness=0.1 //x=18.665 //y=0.795 //x2=18.665 //y2=0.71
r578 (  219 346 ) resistor r=18.139 //w=0.187 //l=0.265 //layer=li \
 //thickness=0.1 //x=18.665 //y=0.795 //x2=18.665 //y2=1.06
r579 (  218 346 ) resistor r=5.4201 //w=0.17 //l=0.085 //layer=li \
 //thickness=0.1 //x=18.665 //y=0.625 //x2=18.665 //y2=0.71
r580 (  217 327 ) resistor r=4.23183 //w=0.7 //l=0.175 //layer=li \
 //thickness=0.1 //x=18.665 //y=0.35 //x2=18.665 //y2=0.175
r581 (  217 218 ) resistor r=18.8235 //w=0.187 //l=0.275 //layer=li \
 //thickness=0.1 //x=18.665 //y=0.35 //x2=18.665 //y2=0.625
r582 (  214 346 ) resistor r=6.4 //w=0.17 //l=0.085 //layer=li //thickness=0.1 \
 //x=17.78 //y=0.71 //x2=17.695 //y2=0.71
r583 (  214 346 ) resistor r=27.3797 //w=0.187 //l=0.4 //layer=li \
 //thickness=0.1 //x=17.78 //y=0.71 //x2=18.18 //y2=0.71
r584 (  213 346 ) resistor r=1.40859 //w=0.34 //l=0.085 //layer=li \
 //thickness=0.1 //x=18.58 //y=0.71 //x2=18.665 //y2=0.71
r585 (  213 346 ) resistor r=27.3797 //w=0.187 //l=0.4 //layer=li \
 //thickness=0.1 //x=18.58 //y=0.71 //x2=18.18 //y2=0.71
r586 (  210 324 ) resistor r=2.87058 //w=0.35 //l=0.085 //layer=li \
 //thickness=0.1 //x=17.78 //y=0.175 //x2=17.695 //y2=0.175
r587 (  210 212 ) resistor r=3.48774 //w=0.367 //l=0.1 //layer=li \
 //thickness=0.1 //x=17.78 //y=0.175 //x2=17.88 //y2=0.175
r588 (  209 327 ) resistor r=2.87058 //w=0.35 //l=0.085 //layer=li \
 //thickness=0.1 //x=18.58 //y=0.175 //x2=18.665 //y2=0.175
r589 (  209 212 ) resistor r=24.4142 //w=0.367 //l=0.7 //layer=li \
 //thickness=0.1 //x=18.58 //y=0.175 //x2=17.88 //y2=0.175
r590 (  205 346 ) resistor r=6.4 //w=0.17 //l=0.085 //layer=li //thickness=0.1 \
 //x=17.695 //y=0.795 //x2=17.695 //y2=0.71
r591 (  205 346 ) resistor r=18.139 //w=0.187 //l=0.265 //layer=li \
 //thickness=0.1 //x=17.695 //y=0.795 //x2=17.695 //y2=1.06
r592 (  204 346 ) resistor r=6.4 //w=0.17 //l=0.085 //layer=li //thickness=0.1 \
 //x=17.695 //y=0.625 //x2=17.695 //y2=0.71
r593 (  203 324 ) resistor r=4.23183 //w=0.7 //l=0.175 //layer=li \
 //thickness=0.1 //x=17.695 //y=0.35 //x2=17.695 //y2=0.175
r594 (  203 204 ) resistor r=18.8235 //w=0.187 //l=0.275 //layer=li \
 //thickness=0.1 //x=17.695 //y=0.35 //x2=17.695 //y2=0.625
r595 (  200 346 ) resistor r=1.40859 //w=0.34 //l=0.085 //layer=li \
 //thickness=0.1 //x=16.81 //y=0.71 //x2=16.725 //y2=0.71
r596 (  200 346 ) resistor r=27.3797 //w=0.187 //l=0.4 //layer=li \
 //thickness=0.1 //x=16.81 //y=0.71 //x2=17.21 //y2=0.71
r597 (  199 346 ) resistor r=6.4 //w=0.17 //l=0.085 //layer=li //thickness=0.1 \
 //x=17.61 //y=0.71 //x2=17.695 //y2=0.71
r598 (  199 346 ) resistor r=27.3797 //w=0.187 //l=0.4 //layer=li \
 //thickness=0.1 //x=17.61 //y=0.71 //x2=17.21 //y2=0.71
r599 (  198 321 ) resistor r=2.87058 //w=0.35 //l=0.085 //layer=li \
 //thickness=0.1 //x=16.81 //y=0.175 //x2=16.725 //y2=0.175
r600 (  197 324 ) resistor r=2.87058 //w=0.35 //l=0.085 //layer=li \
 //thickness=0.1 //x=17.61 //y=0.175 //x2=17.695 //y2=0.175
r601 (  197 198 ) resistor r=27.9019 //w=0.367 //l=0.8 //layer=li \
 //thickness=0.1 //x=17.61 //y=0.175 //x2=16.81 //y2=0.175
r602 (  193 346 ) resistor r=5.4201 //w=0.17 //l=0.085 //layer=li \
 //thickness=0.1 //x=16.725 //y=0.795 //x2=16.725 //y2=0.71
r603 (  193 346 ) resistor r=41.4118 //w=0.187 //l=0.605 //layer=li \
 //thickness=0.1 //x=16.725 //y=0.795 //x2=16.725 //y2=1.4
r604 (  192 346 ) resistor r=5.4201 //w=0.17 //l=0.085 //layer=li \
 //thickness=0.1 //x=16.725 //y=0.625 //x2=16.725 //y2=0.71
r605 (  191 321 ) resistor r=4.23183 //w=0.7 //l=0.175 //layer=li \
 //thickness=0.1 //x=16.725 //y=0.35 //x2=16.725 //y2=0.175
r606 (  191 192 ) resistor r=18.8235 //w=0.187 //l=0.275 //layer=li \
 //thickness=0.1 //x=16.725 //y=0.35 //x2=16.725 //y2=0.625
r607 (  190 319 ) resistor r=5.29055 //w=0.35 //l=0.17 //layer=li \
 //thickness=0.1 //x=16.2 //y=0.175 //x2=16.03 //y2=0.175
r608 (  189 321 ) resistor r=2.87058 //w=0.35 //l=0.085 //layer=li \
 //thickness=0.1 //x=16.64 //y=0.175 //x2=16.725 //y2=0.175
r609 (  189 190 ) resistor r=15.346 //w=0.367 //l=0.44 //layer=li \
 //thickness=0.1 //x=16.64 //y=0.175 //x2=16.2 //y2=0.175
r610 (  186 312 ) resistor r=2.96458 //w=0.367 //l=0.085 //layer=li \
 //thickness=0.1 //x=15.495 //y=0.175 //x2=15.41 //y2=0.175
r611 (  185 319 ) resistor r=5.29055 //w=0.35 //l=0.17 //layer=li \
 //thickness=0.1 //x=15.86 //y=0.175 //x2=16.03 //y2=0.175
r612 (  185 186 ) resistor r=12.7302 //w=0.367 //l=0.365 //layer=li \
 //thickness=0.1 //x=15.86 //y=0.175 //x2=15.495 //y2=0.175
r613 (  181 345 ) resistor r=5.4201 //w=0.17 //l=0.085 //layer=li \
 //thickness=0.1 //x=15.41 //y=0.8 //x2=15.41 //y2=0.715
r614 (  181 345 ) resistor r=41.4118 //w=0.187 //l=0.605 //layer=li \
 //thickness=0.1 //x=15.41 //y=0.8 //x2=15.41 //y2=1.405
r615 (  180 345 ) resistor r=5.4201 //w=0.17 //l=0.085 //layer=li \
 //thickness=0.1 //x=15.41 //y=0.63 //x2=15.41 //y2=0.715
r616 (  179 312 ) resistor r=5.21862 //w=0.35 //l=0.175 //layer=li \
 //thickness=0.1 //x=15.41 //y=0.35 //x2=15.41 //y2=0.175
r617 (  179 180 ) resistor r=19.1658 //w=0.187 //l=0.28 //layer=li \
 //thickness=0.1 //x=15.41 //y=0.35 //x2=15.41 //y2=0.63
r618 (  178 345 ) resistor r=5.4201 //w=0.17 //l=0.085 //layer=li \
 //thickness=0.1 //x=15.005 //y=0.715 //x2=14.92 //y2=0.715
r619 (  177 345 ) resistor r=1.40859 //w=0.34 //l=0.085 //layer=li \
 //thickness=0.1 //x=15.325 //y=0.715 //x2=15.41 //y2=0.715
r620 (  177 178 ) resistor r=21.9037 //w=0.187 //l=0.32 //layer=li \
 //thickness=0.1 //x=15.325 //y=0.715 //x2=15.005 //y2=0.715
r621 (  176 345 ) resistor r=1.40859 //w=0.34 //l=0.085 //layer=li \
 //thickness=0.1 //x=14.92 //y=0.63 //x2=14.92 //y2=0.715
r622 (  175 309 ) resistor r=5.21862 //w=0.35 //l=0.175 //layer=li \
 //thickness=0.1 //x=14.92 //y=0.35 //x2=14.92 //y2=0.175
r623 (  175 176 ) resistor r=19.1658 //w=0.187 //l=0.28 //layer=li \
 //thickness=0.1 //x=14.92 //y=0.35 //x2=14.92 //y2=0.63
r624 (  174 345 ) resistor r=1.40859 //w=0.34 //l=0.085 //layer=li \
 //thickness=0.1 //x=14.525 //y=0.715 //x2=14.44 //y2=0.715
r625 (  173 345 ) resistor r=5.4201 //w=0.17 //l=0.085 //layer=li \
 //thickness=0.1 //x=14.835 //y=0.715 //x2=14.92 //y2=0.715
r626 (  173 174 ) resistor r=21.2193 //w=0.187 //l=0.31 //layer=li \
 //thickness=0.1 //x=14.835 //y=0.715 //x2=14.525 //y2=0.715
r627 (  169 345 ) resistor r=5.4201 //w=0.17 //l=0.085 //layer=li \
 //thickness=0.1 //x=14.44 //y=0.8 //x2=14.44 //y2=0.715
r628 (  169 345 ) resistor r=41.4118 //w=0.187 //l=0.605 //layer=li \
 //thickness=0.1 //x=14.44 //y=0.8 //x2=14.44 //y2=1.405
r629 (  168 345 ) resistor r=5.4201 //w=0.17 //l=0.085 //layer=li \
 //thickness=0.1 //x=14.44 //y=0.63 //x2=14.44 //y2=0.715
r630 (  167 308 ) resistor r=5.21862 //w=0.35 //l=0.175 //layer=li \
 //thickness=0.1 //x=14.44 //y=0.35 //x2=14.44 //y2=0.175
r631 (  167 168 ) resistor r=19.1658 //w=0.187 //l=0.28 //layer=li \
 //thickness=0.1 //x=14.44 //y=0.35 //x2=14.44 //y2=0.63
r632 (  164 307 ) resistor r=5.29055 //w=0.35 //l=0.17 //layer=li \
 //thickness=0.1 //x=13.98 //y=0.175 //x2=13.81 //y2=0.175
r633 (  164 166 ) resistor r=6.97548 //w=0.367 //l=0.2 //layer=li \
 //thickness=0.1 //x=13.98 //y=0.175 //x2=14.18 //y2=0.175
r634 (  163 308 ) resistor r=2.96458 //w=0.367 //l=0.085 //layer=li \
 //thickness=0.1 //x=14.355 //y=0.175 //x2=14.44 //y2=0.175
r635 (  163 166 ) resistor r=6.10354 //w=0.367 //l=0.175 //layer=li \
 //thickness=0.1 //x=14.355 //y=0.175 //x2=14.18 //y2=0.175
r636 (  153 155 ) resistor r=38.7139 //w=0.367 //l=1.11 //layer=li \
 //thickness=0.1 //x=11.59 //y=0.175 //x2=12.7 //y2=0.175
r637 (  151 306 ) resistor r=5.29055 //w=0.35 //l=0.17 //layer=li \
 //thickness=0.1 //x=10.65 //y=0.175 //x2=10.48 //y2=0.175
r638 (  151 153 ) resistor r=32.7847 //w=0.367 //l=0.94 //layer=li \
 //thickness=0.1 //x=10.65 //y=0.175 //x2=11.59 //y2=0.175
r639 (  150 307 ) resistor r=5.29055 //w=0.35 //l=0.17 //layer=li \
 //thickness=0.1 //x=13.64 //y=0.175 //x2=13.81 //y2=0.175
r640 (  150 155 ) resistor r=32.7847 //w=0.367 //l=0.94 //layer=li \
 //thickness=0.1 //x=13.64 //y=0.175 //x2=12.7 //y2=0.175
r641 (  145 299 ) resistor r=2.96458 //w=0.367 //l=0.085 //layer=li \
 //thickness=0.1 //x=9.945 //y=0.175 //x2=9.86 //y2=0.175
r642 (  145 147 ) resistor r=5.75477 //w=0.367 //l=0.165 //layer=li \
 //thickness=0.1 //x=9.945 //y=0.175 //x2=10.11 //y2=0.175
r643 (  144 306 ) resistor r=5.29055 //w=0.35 //l=0.17 //layer=li \
 //thickness=0.1 //x=10.31 //y=0.175 //x2=10.48 //y2=0.175
r644 (  144 147 ) resistor r=6.97548 //w=0.367 //l=0.2 //layer=li \
 //thickness=0.1 //x=10.31 //y=0.175 //x2=10.11 //y2=0.175
r645 (  140 343 ) resistor r=5.4201 //w=0.17 //l=0.085 //layer=li \
 //thickness=0.1 //x=9.86 //y=0.8 //x2=9.86 //y2=0.715
r646 (  140 343 ) resistor r=41.4118 //w=0.187 //l=0.605 //layer=li \
 //thickness=0.1 //x=9.86 //y=0.8 //x2=9.86 //y2=1.405
r647 (  139 343 ) resistor r=5.4201 //w=0.17 //l=0.085 //layer=li \
 //thickness=0.1 //x=9.86 //y=0.63 //x2=9.86 //y2=0.715
r648 (  138 299 ) resistor r=5.21862 //w=0.35 //l=0.175 //layer=li \
 //thickness=0.1 //x=9.86 //y=0.35 //x2=9.86 //y2=0.175
r649 (  138 139 ) resistor r=19.1658 //w=0.187 //l=0.28 //layer=li \
 //thickness=0.1 //x=9.86 //y=0.35 //x2=9.86 //y2=0.63
r650 (  137 343 ) resistor r=5.4201 //w=0.17 //l=0.085 //layer=li \
 //thickness=0.1 //x=9.455 //y=0.715 //x2=9.37 //y2=0.715
r651 (  136 343 ) resistor r=1.40859 //w=0.34 //l=0.085 //layer=li \
 //thickness=0.1 //x=9.775 //y=0.715 //x2=9.86 //y2=0.715
r652 (  136 137 ) resistor r=21.9037 //w=0.187 //l=0.32 //layer=li \
 //thickness=0.1 //x=9.775 //y=0.715 //x2=9.455 //y2=0.715
r653 (  135 343 ) resistor r=1.40859 //w=0.34 //l=0.085 //layer=li \
 //thickness=0.1 //x=9.37 //y=0.63 //x2=9.37 //y2=0.715
r654 (  134 298 ) resistor r=5.21862 //w=0.35 //l=0.175 //layer=li \
 //thickness=0.1 //x=9.37 //y=0.35 //x2=9.37 //y2=0.175
r655 (  134 135 ) resistor r=19.1658 //w=0.187 //l=0.28 //layer=li \
 //thickness=0.1 //x=9.37 //y=0.35 //x2=9.37 //y2=0.63
r656 (  133 343 ) resistor r=1.40859 //w=0.34 //l=0.085 //layer=li \
 //thickness=0.1 //x=8.975 //y=0.715 //x2=8.89 //y2=0.715
r657 (  132 343 ) resistor r=5.4201 //w=0.17 //l=0.085 //layer=li \
 //thickness=0.1 //x=9.285 //y=0.715 //x2=9.37 //y2=0.715
r658 (  132 133 ) resistor r=21.2193 //w=0.187 //l=0.31 //layer=li \
 //thickness=0.1 //x=9.285 //y=0.715 //x2=8.975 //y2=0.715
r659 (  128 343 ) resistor r=5.4201 //w=0.17 //l=0.085 //layer=li \
 //thickness=0.1 //x=8.89 //y=0.8 //x2=8.89 //y2=0.715
r660 (  128 343 ) resistor r=41.4118 //w=0.187 //l=0.605 //layer=li \
 //thickness=0.1 //x=8.89 //y=0.8 //x2=8.89 //y2=1.405
r661 (  127 343 ) resistor r=5.4201 //w=0.17 //l=0.085 //layer=li \
 //thickness=0.1 //x=8.89 //y=0.63 //x2=8.89 //y2=0.715
r662 (  126 295 ) resistor r=5.21862 //w=0.35 //l=0.175 //layer=li \
 //thickness=0.1 //x=8.89 //y=0.35 //x2=8.89 //y2=0.175
r663 (  126 127 ) resistor r=19.1658 //w=0.187 //l=0.28 //layer=li \
 //thickness=0.1 //x=8.89 //y=0.35 //x2=8.89 //y2=0.63
r664 (  125 294 ) resistor r=5.29055 //w=0.35 //l=0.17 //layer=li \
 //thickness=0.1 //x=8.43 //y=0.175 //x2=8.26 //y2=0.175
r665 (  124 295 ) resistor r=2.96458 //w=0.367 //l=0.085 //layer=li \
 //thickness=0.1 //x=8.805 //y=0.175 //x2=8.89 //y2=0.175
r666 (  124 125 ) resistor r=13.079 //w=0.367 //l=0.375 //layer=li \
 //thickness=0.1 //x=8.805 //y=0.175 //x2=8.43 //y2=0.175
r667 (  114 116 ) resistor r=38.7139 //w=0.367 //l=1.11 //layer=li \
 //thickness=0.1 //x=6.41 //y=0.175 //x2=7.52 //y2=0.175
r668 (  112 114 ) resistor r=38.7139 //w=0.367 //l=1.11 //layer=li \
 //thickness=0.1 //x=5.3 //y=0.175 //x2=6.41 //y2=0.175
r669 (  110 293 ) resistor r=5.29055 //w=0.35 //l=0.17 //layer=li \
 //thickness=0.1 //x=5.1 //y=0.175 //x2=4.93 //y2=0.175
r670 (  110 112 ) resistor r=6.97548 //w=0.367 //l=0.2 //layer=li \
 //thickness=0.1 //x=5.1 //y=0.175 //x2=5.3 //y2=0.175
r671 (  109 294 ) resistor r=5.29055 //w=0.35 //l=0.17 //layer=li \
 //thickness=0.1 //x=8.09 //y=0.175 //x2=8.26 //y2=0.175
r672 (  109 116 ) resistor r=19.8801 //w=0.367 //l=0.57 //layer=li \
 //thickness=0.1 //x=8.09 //y=0.175 //x2=7.52 //y2=0.175
r673 (  106 286 ) resistor r=2.96458 //w=0.367 //l=0.085 //layer=li \
 //thickness=0.1 //x=4.395 //y=0.175 //x2=4.31 //y2=0.175
r674 (  105 293 ) resistor r=5.29055 //w=0.35 //l=0.17 //layer=li \
 //thickness=0.1 //x=4.76 //y=0.175 //x2=4.93 //y2=0.175
r675 (  105 106 ) resistor r=12.7302 //w=0.367 //l=0.365 //layer=li \
 //thickness=0.1 //x=4.76 //y=0.175 //x2=4.395 //y2=0.175
r676 (  101 341 ) resistor r=5.4201 //w=0.17 //l=0.085 //layer=li \
 //thickness=0.1 //x=4.31 //y=0.8 //x2=4.31 //y2=0.715
r677 (  101 341 ) resistor r=41.4118 //w=0.187 //l=0.605 //layer=li \
 //thickness=0.1 //x=4.31 //y=0.8 //x2=4.31 //y2=1.405
r678 (  100 341 ) resistor r=5.4201 //w=0.17 //l=0.085 //layer=li \
 //thickness=0.1 //x=4.31 //y=0.63 //x2=4.31 //y2=0.715
r679 (  99 286 ) resistor r=5.21862 //w=0.35 //l=0.175 //layer=li \
 //thickness=0.1 //x=4.31 //y=0.35 //x2=4.31 //y2=0.175
r680 (  99 100 ) resistor r=19.1658 //w=0.187 //l=0.28 //layer=li \
 //thickness=0.1 //x=4.31 //y=0.35 //x2=4.31 //y2=0.63
r681 (  98 341 ) resistor r=5.4201 //w=0.17 //l=0.085 //layer=li \
 //thickness=0.1 //x=3.905 //y=0.715 //x2=3.82 //y2=0.715
r682 (  97 341 ) resistor r=1.40859 //w=0.34 //l=0.085 //layer=li \
 //thickness=0.1 //x=4.225 //y=0.715 //x2=4.31 //y2=0.715
r683 (  97 98 ) resistor r=21.9037 //w=0.187 //l=0.32 //layer=li \
 //thickness=0.1 //x=4.225 //y=0.715 //x2=3.905 //y2=0.715
r684 (  96 341 ) resistor r=1.40859 //w=0.34 //l=0.085 //layer=li \
 //thickness=0.1 //x=3.82 //y=0.63 //x2=3.82 //y2=0.715
r685 (  95 285 ) resistor r=5.21862 //w=0.35 //l=0.175 //layer=li \
 //thickness=0.1 //x=3.82 //y=0.35 //x2=3.82 //y2=0.175
r686 (  95 96 ) resistor r=19.1658 //w=0.187 //l=0.28 //layer=li \
 //thickness=0.1 //x=3.82 //y=0.35 //x2=3.82 //y2=0.63
r687 (  94 341 ) resistor r=1.40859 //w=0.34 //l=0.085 //layer=li \
 //thickness=0.1 //x=3.425 //y=0.715 //x2=3.34 //y2=0.715
r688 (  93 341 ) resistor r=5.4201 //w=0.17 //l=0.085 //layer=li \
 //thickness=0.1 //x=3.735 //y=0.715 //x2=3.82 //y2=0.715
r689 (  93 94 ) resistor r=21.2193 //w=0.187 //l=0.31 //layer=li \
 //thickness=0.1 //x=3.735 //y=0.715 //x2=3.425 //y2=0.715
r690 (  89 341 ) resistor r=5.4201 //w=0.17 //l=0.085 //layer=li \
 //thickness=0.1 //x=3.34 //y=0.8 //x2=3.34 //y2=0.715
r691 (  89 341 ) resistor r=41.4118 //w=0.187 //l=0.605 //layer=li \
 //thickness=0.1 //x=3.34 //y=0.8 //x2=3.34 //y2=1.405
r692 (  88 341 ) resistor r=5.4201 //w=0.17 //l=0.085 //layer=li \
 //thickness=0.1 //x=3.34 //y=0.63 //x2=3.34 //y2=0.715
r693 (  87 283 ) resistor r=5.21862 //w=0.35 //l=0.175 //layer=li \
 //thickness=0.1 //x=3.34 //y=0.35 //x2=3.34 //y2=0.175
r694 (  87 88 ) resistor r=19.1658 //w=0.187 //l=0.28 //layer=li \
 //thickness=0.1 //x=3.34 //y=0.35 //x2=3.34 //y2=0.63
r695 (  86 282 ) resistor r=5.29055 //w=0.35 //l=0.17 //layer=li \
 //thickness=0.1 //x=2.88 //y=0.175 //x2=2.71 //y2=0.175
r696 (  85 283 ) resistor r=2.96458 //w=0.367 //l=0.085 //layer=li \
 //thickness=0.1 //x=3.255 //y=0.175 //x2=3.34 //y2=0.175
r697 (  85 86 ) resistor r=13.079 //w=0.367 //l=0.375 //layer=li \
 //thickness=0.1 //x=3.255 //y=0.175 //x2=2.88 //y2=0.175
r698 (  80 275 ) resistor r=2.96458 //w=0.367 //l=0.085 //layer=li \
 //thickness=0.1 //x=2.175 //y=0.175 //x2=2.09 //y2=0.175
r699 (  80 82 ) resistor r=5.75477 //w=0.367 //l=0.165 //layer=li \
 //thickness=0.1 //x=2.175 //y=0.175 //x2=2.34 //y2=0.175
r700 (  79 282 ) resistor r=5.29055 //w=0.35 //l=0.17 //layer=li \
 //thickness=0.1 //x=2.54 //y=0.175 //x2=2.71 //y2=0.175
r701 (  79 82 ) resistor r=6.97548 //w=0.367 //l=0.2 //layer=li \
 //thickness=0.1 //x=2.54 //y=0.175 //x2=2.34 //y2=0.175
r702 (  75 340 ) resistor r=5.4201 //w=0.17 //l=0.085 //layer=li \
 //thickness=0.1 //x=2.09 //y=0.8 //x2=2.09 //y2=0.715
r703 (  75 340 ) resistor r=41.4118 //w=0.187 //l=0.605 //layer=li \
 //thickness=0.1 //x=2.09 //y=0.8 //x2=2.09 //y2=1.405
r704 (  74 340 ) resistor r=5.4201 //w=0.17 //l=0.085 //layer=li \
 //thickness=0.1 //x=2.09 //y=0.63 //x2=2.09 //y2=0.715
r705 (  73 275 ) resistor r=5.21862 //w=0.35 //l=0.175 //layer=li \
 //thickness=0.1 //x=2.09 //y=0.35 //x2=2.09 //y2=0.175
r706 (  73 74 ) resistor r=19.1658 //w=0.187 //l=0.28 //layer=li \
 //thickness=0.1 //x=2.09 //y=0.35 //x2=2.09 //y2=0.63
r707 (  72 340 ) resistor r=5.4201 //w=0.17 //l=0.085 //layer=li \
 //thickness=0.1 //x=1.685 //y=0.715 //x2=1.6 //y2=0.715
r708 (  71 340 ) resistor r=1.40859 //w=0.34 //l=0.085 //layer=li \
 //thickness=0.1 //x=2.005 //y=0.715 //x2=2.09 //y2=0.715
r709 (  71 72 ) resistor r=21.9037 //w=0.187 //l=0.32 //layer=li \
 //thickness=0.1 //x=2.005 //y=0.715 //x2=1.685 //y2=0.715
r710 (  70 340 ) resistor r=1.40859 //w=0.34 //l=0.085 //layer=li \
 //thickness=0.1 //x=1.6 //y=0.63 //x2=1.6 //y2=0.715
r711 (  69 274 ) resistor r=5.21862 //w=0.35 //l=0.175 //layer=li \
 //thickness=0.1 //x=1.6 //y=0.35 //x2=1.6 //y2=0.175
r712 (  69 70 ) resistor r=19.1658 //w=0.187 //l=0.28 //layer=li \
 //thickness=0.1 //x=1.6 //y=0.35 //x2=1.6 //y2=0.63
r713 (  68 340 ) resistor r=1.40859 //w=0.34 //l=0.085 //layer=li \
 //thickness=0.1 //x=1.205 //y=0.715 //x2=1.12 //y2=0.715
r714 (  67 340 ) resistor r=5.4201 //w=0.17 //l=0.085 //layer=li \
 //thickness=0.1 //x=1.515 //y=0.715 //x2=1.6 //y2=0.715
r715 (  67 68 ) resistor r=21.2193 //w=0.187 //l=0.31 //layer=li \
 //thickness=0.1 //x=1.515 //y=0.715 //x2=1.205 //y2=0.715
r716 (  63 340 ) resistor r=5.4201 //w=0.17 //l=0.085 //layer=li \
 //thickness=0.1 //x=1.12 //y=0.8 //x2=1.12 //y2=0.715
r717 (  63 340 ) resistor r=41.4118 //w=0.187 //l=0.605 //layer=li \
 //thickness=0.1 //x=1.12 //y=0.8 //x2=1.12 //y2=1.405
r718 (  62 340 ) resistor r=5.4201 //w=0.17 //l=0.085 //layer=li \
 //thickness=0.1 //x=1.12 //y=0.63 //x2=1.12 //y2=0.715
r719 (  61 271 ) resistor r=5.21862 //w=0.35 //l=0.175 //layer=li \
 //thickness=0.1 //x=1.12 //y=0.35 //x2=1.12 //y2=0.175
r720 (  61 62 ) resistor r=19.1658 //w=0.187 //l=0.28 //layer=li \
 //thickness=0.1 //x=1.12 //y=0.35 //x2=1.12 //y2=0.63
r721 (  52 344 ) resistor r=9.3 //w=0.17 //l=0.17 //layer=mcon //count=1 \
 //x=11.66 //y=1.135 //x2=11.66 //y2=1.135
r722 (  52 53 ) resistor r=0.0939994 //w=0.226 //l=0.13 //layer=m1 \
 //thickness=0.36 //x=11.657 //y=1.135 //x2=11.657 //y2=1.005
r723 (  47 342 ) resistor r=9.3 //w=0.17 //l=0.17 //layer=mcon //count=1 \
 //x=6.11 //y=1.135 //x2=6.11 //y2=1.135
r724 (  47 48 ) resistor r=0.0939994 //w=0.226 //l=0.13 //layer=m1 \
 //thickness=0.36 //x=6.107 //y=1.135 //x2=6.107 //y2=1.005
r725 (  44 268 ) resistor r=9.3 //w=0.17 //l=0.17 //layer=mcon //count=1 \
 //x=22.32 //y=0.18 //x2=22.32 //y2=0.18
r726 (  42 254 ) resistor r=3.1 //w=0.17 //l=0.51 //layer=mcon //count=3 \
 //x=21.58 //y=0.18 //x2=21.58 //y2=0.18
r727 (  42 44 ) resistor r=0.297428 //w=0.311 //l=0.74 //layer=m1 \
 //thickness=0.36 //x=21.58 //y=0.175 //x2=22.32 //y2=0.175
r728 (  40 240 ) resistor r=3.1 //w=0.17 //l=0.51 //layer=mcon //count=3 \
 //x=20.47 //y=0.18 //x2=20.47 //y2=0.18
r729 (  40 42 ) resistor r=0.446141 //w=0.311 //l=1.11 //layer=m1 \
 //thickness=0.36 //x=20.47 //y=0.175 //x2=21.58 //y2=0.175
r730 (  38 226 ) resistor r=3.1 //w=0.17 //l=0.51 //layer=mcon //count=3 \
 //x=18.99 //y=0.18 //x2=18.99 //y2=0.18
r731 (  38 40 ) resistor r=0.594855 //w=0.311 //l=1.48 //layer=m1 \
 //thickness=0.36 //x=18.99 //y=0.175 //x2=20.47 //y2=0.175
r732 (  36 212 ) resistor r=3.1 //w=0.17 //l=0.51 //layer=mcon //count=3 \
 //x=17.88 //y=0.18 //x2=17.88 //y2=0.18
r733 (  36 38 ) resistor r=0.446141 //w=0.311 //l=1.11 //layer=m1 \
 //thickness=0.36 //x=17.88 //y=0.175 //x2=18.99 //y2=0.175
r734 (  34 321 ) resistor r=3.1 //w=0.17 //l=0.51 //layer=mcon //count=3 \
 //x=16.77 //y=0.18 //x2=16.77 //y2=0.18
r735 (  34 36 ) resistor r=0.446141 //w=0.311 //l=1.11 //layer=m1 \
 //thickness=0.36 //x=16.77 //y=0.175 //x2=17.88 //y2=0.175
r736 (  32 311 ) resistor r=3.1 //w=0.17 //l=0.51 //layer=mcon //count=3 \
 //x=15.29 //y=0.18 //x2=15.29 //y2=0.18
r737 (  32 34 ) resistor r=0.594855 //w=0.311 //l=1.48 //layer=m1 \
 //thickness=0.36 //x=15.29 //y=0.175 //x2=16.77 //y2=0.175
r738 (  30 166 ) resistor r=3.1 //w=0.17 //l=0.51 //layer=mcon //count=3 \
 //x=14.18 //y=0.18 //x2=14.18 //y2=0.18
r739 (  30 32 ) resistor r=0.446141 //w=0.311 //l=1.11 //layer=m1 \
 //thickness=0.36 //x=14.18 //y=0.175 //x2=15.29 //y2=0.175
r740 (  28 155 ) resistor r=3.1 //w=0.17 //l=0.51 //layer=mcon //count=3 \
 //x=12.7 //y=0.18 //x2=12.7 //y2=0.18
r741 (  28 30 ) resistor r=0.594855 //w=0.311 //l=1.48 //layer=m1 \
 //thickness=0.36 //x=12.7 //y=0.175 //x2=14.18 //y2=0.175
r742 (  26 28 ) resistor r=0.383842 //w=0.311 //l=0.955 //layer=m1 \
 //thickness=0.36 //x=11.745 //y=0.175 //x2=12.7 //y2=0.175
r743 (  24 53 ) resistor r=0.625 //w=0.131 //l=0.655 //layer=m1 \
 //thickness=0.36 //x=11.66 //y=0.35 //x2=11.66 //y2=1.005
r744 (  23 147 ) resistor r=3.1 //w=0.17 //l=0.51 //layer=mcon //count=3 \
 //x=10.11 //y=0.18 //x2=10.11 //y2=0.18
r745 (  21 297 ) resistor r=3.1 //w=0.17 //l=0.51 //layer=mcon //count=3 //x=9 \
 //y=0.18 //x2=9 //y2=0.18
r746 (  21 23 ) resistor r=0.446141 //w=0.311 //l=1.11 //layer=m1 \
 //thickness=0.36 //x=9 //y=0.175 //x2=10.11 //y2=0.175
r747 (  19 116 ) resistor r=3.1 //w=0.17 //l=0.51 //layer=mcon //count=3 \
 //x=7.52 //y=0.18 //x2=7.52 //y2=0.18
r748 (  19 21 ) resistor r=0.594855 //w=0.311 //l=1.48 //layer=m1 \
 //thickness=0.36 //x=7.52 //y=0.175 //x2=9 //y2=0.175
r749 (  17 114 ) resistor r=3.1 //w=0.17 //l=0.51 //layer=mcon //count=3 \
 //x=6.41 //y=0.18 //x2=6.41 //y2=0.18
r750 (  17 19 ) resistor r=0.446141 //w=0.311 //l=1.11 //layer=m1 \
 //thickness=0.36 //x=6.41 //y=0.175 //x2=7.52 //y2=0.175
r751 (  15 50 ) resistor r=0.028033 //w=0.35 //l=0.085 //layer=m1 \
 //thickness=0.36 //x=6.195 //y=0.175 //x2=6.11 //y2=0.175
r752 (  15 17 ) resistor r=0.0864148 //w=0.311 //l=0.215 //layer=m1 \
 //thickness=0.36 //x=6.195 //y=0.175 //x2=6.41 //y2=0.175
r753 (  14 23 ) resistor r=0.588826 //w=0.311 //l=1.465 //layer=m1 \
 //thickness=0.36 //x=11.575 //y=0.175 //x2=10.11 //y2=0.175
r754 (  12 50 ) resistor r=0.0413265 //w=0.7 //l=0.175 //layer=m1 \
 //thickness=0.36 //x=6.11 //y=0.35 //x2=6.11 //y2=0.175
r755 (  12 48 ) resistor r=0.625 //w=0.131 //l=0.655 //layer=m1 \
 //thickness=0.36 //x=6.11 //y=0.35 //x2=6.11 //y2=1.005
r756 (  11 112 ) resistor r=3.1 //w=0.17 //l=0.51 //layer=mcon //count=3 \
 //x=5.3 //y=0.18 //x2=5.3 //y2=0.18
r757 (  9 285 ) resistor r=3.1 //w=0.17 //l=0.51 //layer=mcon //count=3 \
 //x=3.82 //y=0.18 //x2=3.82 //y2=0.18
r758 (  9 11 ) resistor r=0.594855 //w=0.311 //l=1.48 //layer=m1 \
 //thickness=0.36 //x=3.82 //y=0.175 //x2=5.3 //y2=0.175
r759 (  7 82 ) resistor r=3.1 //w=0.17 //l=0.51 //layer=mcon //count=3 \
 //x=2.34 //y=0.18 //x2=2.34 //y2=0.18
r760 (  7 9 ) resistor r=0.594855 //w=0.311 //l=1.48 //layer=m1 \
 //thickness=0.36 //x=2.34 //y=0.175 //x2=3.82 //y2=0.175
r761 (  4 273 ) resistor r=3.1 //w=0.17 //l=0.51 //layer=mcon //count=3 \
 //x=1.23 //y=0.18 //x2=1.23 //y2=0.18
r762 (  4 7 ) resistor r=0.446141 //w=0.311 //l=1.11 //layer=m1 \
 //thickness=0.36 //x=1.23 //y=0.175 //x2=2.34 //y2=0.175
r763 (  2 50 ) resistor r=0.028033 //w=0.35 //l=0.085 //layer=m1 \
 //thickness=0.36 //x=6.025 //y=0.175 //x2=6.11 //y2=0.175
r764 (  2 11 ) resistor r=0.291399 //w=0.311 //l=0.725 //layer=m1 \
 //thickness=0.36 //x=6.025 //y=0.175 //x2=5.3 //y2=0.175
r765 (  1 153 ) resistor r=3.1 //w=0.17 //l=0.51 //layer=mcon //count=3 \
 //x=11.59 //y=0.18 //x2=11.59 //y2=0.18
r766 (  1 24 ) resistor r=0.0413265 //w=0.7 //l=0.175 //layer=m1 \
 //thickness=0.36 //x=11.66 //y=0.175 //x2=11.66 //y2=0.35
r767 (  1 14 ) resistor r=0.028033 //w=0.35 //l=0.085 //layer=m1 \
 //thickness=0.36 //x=11.66 //y=0.175 //x2=11.575 //y2=0.175
r768 (  1 26 ) resistor r=0.028033 //w=0.35 //l=0.085 //layer=m1 \
 //thickness=0.36 //x=11.66 //y=0.175 //x2=11.745 //y2=0.175
ends PM_DLATCHN\%GND

subckt PM_DLATCHN\%noxref_13 ( 1 3 5 10 14 17 20 30 46 47 48 )
c93 ( 48 0 ) capacitor c=0.0375089f //x=18.435 //y=5.205
c94 ( 46 0 ) capacitor c=0.0118024f //x=16.685 //y=5.205
c95 ( 30 0 ) capacitor c=0.0293159f //x=17.7 //y=5.56
c96 ( 20 0 ) capacitor c=0.0452975f //x=16.82 //y=5.56
c97 ( 17 0 ) capacitor c=0.0105999f //x=18.58 //y=6.92
c98 ( 14 0 ) capacitor c=0.00602515f //x=17.7 //y=6.92
c99 ( 10 0 ) capacitor c=0.0101589f //x=17.7 //y=5.39
c100 ( 5 0 ) capacitor c=0.010995f //x=16.82 //y=5.39
c101 ( 3 0 ) capacitor c=0.00691991f //x=18.45 //y=7.09
c102 ( 1 0 ) capacitor c=0.012265f //x=17.58 //y=5.39
r103 (  37 47 ) resistor r=23.2727 //w=0.187 //l=0.34 //layer=li \
 //thickness=0.1 //x=17.7 //y=6.92 //x2=17.7 //y2=6.58
r104 (  30 47 ) resistor r=23.2727 //w=0.187 //l=0.34 //layer=li \
 //thickness=0.1 //x=17.7 //y=5.56 //x2=17.7 //y2=5.9
r105 (  20 46 ) resistor r=23.2727 //w=0.187 //l=0.34 //layer=li \
 //thickness=0.1 //x=16.82 //y=5.56 //x2=16.82 //y2=5.9
r106 (  17 48 ) resistor r=9.3 //w=0.17 //l=0.17 //layer=mcon //count=1 \
 //x=18.58 //y=6.92 //x2=18.58 //y2=6.92
r107 (  17 18 ) resistor r=0.0932018 //w=0.228 //l=0.17 //layer=m1 \
 //thickness=0.36 //x=18.572 //y=6.92 //x2=18.572 //y2=7.09
r108 (  14 37 ) resistor r=9.3 //w=0.17 //l=0.17 //layer=mcon //count=1 \
 //x=17.7 //y=6.92 //x2=17.7 //y2=6.92
r109 (  14 15 ) resistor r=0.0992991 //w=0.214 //l=0.17 //layer=m1 \
 //thickness=0.36 //x=17.7 //y=6.92 //x2=17.7 //y2=7.09
r110 (  12 30 ) resistor r=9.3 //w=0.17 //l=0.17 //layer=mcon //count=1 \
 //x=17.7 //y=5.56 //x2=17.7 //y2=5.56
r111 (  10 12 ) resistor r=0.097032 //w=0.219 //l=0.17 //layer=m1 \
 //thickness=0.36 //x=17.7 //y=5.39 //x2=17.7 //y2=5.56
r112 (  7 20 ) resistor r=9.3 //w=0.17 //l=0.17 //layer=mcon //count=1 \
 //x=16.82 //y=5.56 //x2=16.82 //y2=5.56
r113 (  5 7 ) resistor r=0.0997653 //w=0.213 //l=0.17 //layer=m1 \
 //thickness=0.36 //x=16.82 //y=5.39 //x2=16.82 //y2=5.56
r114 (  4 15 ) resistor r=0.0213909 //w=0.214 //l=0.115 //layer=m1 \
 //thickness=0.36 //x=17.815 //y=7.09 //x2=17.7 //y2=7.09
r115 (  3 18 ) resistor r=0.0251868 //w=0.228 //l=0.122 //layer=m1 \
 //thickness=0.36 //x=18.45 //y=7.09 //x2=18.572 //y2=7.09
r116 (  3 4 ) resistor r=0.605916 //w=0.131 //l=0.635 //layer=m1 \
 //thickness=0.36 //x=18.45 //y=7.09 //x2=17.815 //y2=7.09
r117 (  2 5 ) resistor r=0.0211096 //w=0.213 //l=0.115 //layer=m1 \
 //thickness=0.36 //x=16.935 //y=5.39 //x2=16.82 //y2=5.39
r118 (  1 10 ) resistor r=0.0227762 //w=0.219 //l=0.12 //layer=m1 \
 //thickness=0.36 //x=17.58 //y=5.39 //x2=17.7 //y2=5.39
r119 (  1 2 ) resistor r=0.615458 //w=0.131 //l=0.645 //layer=m1 \
 //thickness=0.36 //x=17.58 //y=5.39 //x2=16.935 //y2=5.39
ends PM_DLATCHN\%noxref_13

subckt PM_DLATCHN\%noxref_14 ( 1 3 5 10 14 17 20 30 46 47 48 )
c91 ( 48 0 ) capacitor c=0.0347637f //x=21.765 //y=5.205
c92 ( 46 0 ) capacitor c=0.00778013f //x=20.015 //y=5.205
c93 ( 30 0 ) capacitor c=0.0293376f //x=21.03 //y=5.56
c94 ( 20 0 ) capacitor c=0.0487118f //x=20.15 //y=5.56
c95 ( 17 0 ) capacitor c=0.0163469f //x=21.91 //y=6.92
c96 ( 14 0 ) capacitor c=0.00601681f //x=21.03 //y=6.92
c97 ( 10 0 ) capacitor c=0.00854613f //x=21.03 //y=5.39
c98 ( 5 0 ) capacitor c=0.0114718f //x=20.15 //y=5.39
c99 ( 3 0 ) capacitor c=0.00691332f //x=21.78 //y=7.09
c100 ( 1 0 ) capacitor c=0.0120965f //x=20.91 //y=5.39
r101 (  37 47 ) resistor r=23.2727 //w=0.187 //l=0.34 //layer=li \
 //thickness=0.1 //x=21.03 //y=6.92 //x2=21.03 //y2=6.58
r102 (  30 47 ) resistor r=23.2727 //w=0.187 //l=0.34 //layer=li \
 //thickness=0.1 //x=21.03 //y=5.56 //x2=21.03 //y2=5.9
r103 (  20 46 ) resistor r=23.2727 //w=0.187 //l=0.34 //layer=li \
 //thickness=0.1 //x=20.15 //y=5.56 //x2=20.15 //y2=5.9
r104 (  17 48 ) resistor r=9.3 //w=0.17 //l=0.17 //layer=mcon //count=1 \
 //x=21.91 //y=6.92 //x2=21.91 //y2=6.92
r105 (  17 18 ) resistor r=0.0932018 //w=0.228 //l=0.17 //layer=m1 \
 //thickness=0.36 //x=21.902 //y=6.92 //x2=21.902 //y2=7.09
r106 (  14 37 ) resistor r=9.3 //w=0.17 //l=0.17 //layer=mcon //count=1 \
 //x=21.03 //y=6.92 //x2=21.03 //y2=6.92
r107 (  14 15 ) resistor r=0.0992991 //w=0.214 //l=0.17 //layer=m1 \
 //thickness=0.36 //x=21.03 //y=6.92 //x2=21.03 //y2=7.09
r108 (  12 30 ) resistor r=9.3 //w=0.17 //l=0.17 //layer=mcon //count=1 \
 //x=21.03 //y=5.56 //x2=21.03 //y2=5.56
r109 (  10 12 ) resistor r=0.097032 //w=0.219 //l=0.17 //layer=m1 \
 //thickness=0.36 //x=21.03 //y=5.39 //x2=21.03 //y2=5.56
r110 (  7 20 ) resistor r=9.3 //w=0.17 //l=0.17 //layer=mcon //count=1 \
 //x=20.15 //y=5.56 //x2=20.15 //y2=5.56
r111 (  5 7 ) resistor r=0.0997653 //w=0.213 //l=0.17 //layer=m1 \
 //thickness=0.36 //x=20.15 //y=5.39 //x2=20.15 //y2=5.56
r112 (  4 15 ) resistor r=0.0213909 //w=0.214 //l=0.115 //layer=m1 \
 //thickness=0.36 //x=21.145 //y=7.09 //x2=21.03 //y2=7.09
r113 (  3 18 ) resistor r=0.0251868 //w=0.228 //l=0.122 //layer=m1 \
 //thickness=0.36 //x=21.78 //y=7.09 //x2=21.902 //y2=7.09
r114 (  3 4 ) resistor r=0.605916 //w=0.131 //l=0.635 //layer=m1 \
 //thickness=0.36 //x=21.78 //y=7.09 //x2=21.145 //y2=7.09
r115 (  2 5 ) resistor r=0.0211096 //w=0.213 //l=0.115 //layer=m1 \
 //thickness=0.36 //x=20.265 //y=5.39 //x2=20.15 //y2=5.39
r116 (  1 10 ) resistor r=0.0227762 //w=0.219 //l=0.12 //layer=m1 \
 //thickness=0.36 //x=20.91 //y=5.39 //x2=21.03 //y2=5.39
r117 (  1 2 ) resistor r=0.615458 //w=0.131 //l=0.645 //layer=m1 \
 //thickness=0.36 //x=20.91 //y=5.39 //x2=20.265 //y2=5.39
ends PM_DLATCHN\%noxref_14

subckt PM_DLATCHN\%noxref_15 ( 1 5 9 10 13 17 29 )
c67 ( 29 0 ) capacitor c=0.0668358f //x=5.49 //y=0.545
c68 ( 17 0 ) capacitor c=0.00709791f //x=7.565 //y=0.795
c69 ( 13 0 ) capacitor c=0.0155329f //x=7.48 //y=0.71
c70 ( 10 0 ) capacitor c=0.0069948f //x=6.595 //y=1.675
c71 ( 9 0 ) capacitor c=0.00770028f //x=6.595 //y=0.795
c72 ( 5 0 ) capacitor c=0.0188344f //x=6.51 //y=1.76
c73 ( 1 0 ) capacitor c=0.00806643f //x=5.625 //y=1.675
r74 (  17 29 ) resistor r=3.57586 //w=0.17 //l=0.125 //layer=li \
 //thickness=0.1 //x=7.565 //y=0.795 //x2=7.565 //y2=0.67
r75 (  17 29 ) resistor r=18.139 //w=0.187 //l=0.265 //layer=li \
 //thickness=0.1 //x=7.565 //y=0.795 //x2=7.565 //y2=1.06
r76 (  14 29 ) resistor r=3.57586 //w=0.17 //l=0.103078 //layer=li \
 //thickness=0.1 //x=6.68 //y=0.71 //x2=6.595 //y2=0.67
r77 (  14 29 ) resistor r=27.3797 //w=0.187 //l=0.4 //layer=li //thickness=0.1 \
 //x=6.68 //y=0.71 //x2=7.08 //y2=0.71
r78 (  13 29 ) resistor r=3.57586 //w=0.17 //l=0.103078 //layer=li \
 //thickness=0.1 //x=7.48 //y=0.71 //x2=7.565 //y2=0.67
r79 (  13 29 ) resistor r=27.3797 //w=0.187 //l=0.4 //layer=li //thickness=0.1 \
 //x=7.48 //y=0.71 //x2=7.08 //y2=0.71
r80 (  10 29 ) resistor r=3.57586 //w=0.17 //l=0.125 //layer=li \
 //thickness=0.1 //x=6.595 //y=1.675 //x2=6.595 //y2=1.8
r81 (  10 29 ) resistor r=42.0963 //w=0.187 //l=0.615 //layer=li \
 //thickness=0.1 //x=6.595 //y=1.675 //x2=6.595 //y2=1.06
r82 (  9 29 ) resistor r=3.57586 //w=0.17 //l=0.125 //layer=li //thickness=0.1 \
 //x=6.595 //y=0.795 //x2=6.595 //y2=0.67
r83 (  9 29 ) resistor r=18.139 //w=0.187 //l=0.265 //layer=li //thickness=0.1 \
 //x=6.595 //y=0.795 //x2=6.595 //y2=1.06
r84 (  6 29 ) resistor r=3.57586 //w=0.17 //l=0.103078 //layer=li \
 //thickness=0.1 //x=5.71 //y=1.76 //x2=5.625 //y2=1.8
r85 (  6 29 ) resistor r=27.3797 //w=0.187 //l=0.4 //layer=li //thickness=0.1 \
 //x=5.71 //y=1.76 //x2=6.11 //y2=1.76
r86 (  5 29 ) resistor r=3.57586 //w=0.17 //l=0.103078 //layer=li \
 //thickness=0.1 //x=6.51 //y=1.76 //x2=6.595 //y2=1.8
r87 (  5 29 ) resistor r=27.3797 //w=0.187 //l=0.4 //layer=li //thickness=0.1 \
 //x=6.51 //y=1.76 //x2=6.11 //y2=1.76
r88 (  1 29 ) resistor r=3.57586 //w=0.17 //l=0.125 //layer=li //thickness=0.1 \
 //x=5.625 //y=1.675 //x2=5.625 //y2=1.8
r89 (  1 29 ) resistor r=42.0963 //w=0.187 //l=0.615 //layer=li \
 //thickness=0.1 //x=5.625 //y=1.675 //x2=5.625 //y2=1.06
ends PM_DLATCHN\%noxref_15

subckt PM_DLATCHN\%noxref_16 ( 1 5 9 10 13 17 29 )
c66 ( 29 0 ) capacitor c=0.0668459f //x=11.04 //y=0.545
c67 ( 17 0 ) capacitor c=0.00709791f //x=13.115 //y=0.795
c68 ( 13 0 ) capacitor c=0.0157877f //x=13.03 //y=0.71
c69 ( 10 0 ) capacitor c=0.00743655f //x=12.145 //y=1.675
c70 ( 9 0 ) capacitor c=0.00770028f //x=12.145 //y=0.795
c71 ( 5 0 ) capacitor c=0.0195351f //x=12.06 //y=1.76
c72 ( 1 0 ) capacitor c=0.00806643f //x=11.175 //y=1.675
r73 (  17 29 ) resistor r=3.57586 //w=0.17 //l=0.125 //layer=li \
 //thickness=0.1 //x=13.115 //y=0.795 //x2=13.115 //y2=0.67
r74 (  17 29 ) resistor r=18.139 //w=0.187 //l=0.265 //layer=li \
 //thickness=0.1 //x=13.115 //y=0.795 //x2=13.115 //y2=1.06
r75 (  14 29 ) resistor r=3.57586 //w=0.17 //l=0.103078 //layer=li \
 //thickness=0.1 //x=12.23 //y=0.71 //x2=12.145 //y2=0.67
r76 (  14 29 ) resistor r=27.3797 //w=0.187 //l=0.4 //layer=li //thickness=0.1 \
 //x=12.23 //y=0.71 //x2=12.63 //y2=0.71
r77 (  13 29 ) resistor r=3.57586 //w=0.17 //l=0.103078 //layer=li \
 //thickness=0.1 //x=13.03 //y=0.71 //x2=13.115 //y2=0.67
r78 (  13 29 ) resistor r=27.3797 //w=0.187 //l=0.4 //layer=li //thickness=0.1 \
 //x=13.03 //y=0.71 //x2=12.63 //y2=0.71
r79 (  10 29 ) resistor r=3.57586 //w=0.17 //l=0.125 //layer=li \
 //thickness=0.1 //x=12.145 //y=1.675 //x2=12.145 //y2=1.8
r80 (  10 29 ) resistor r=42.0963 //w=0.187 //l=0.615 //layer=li \
 //thickness=0.1 //x=12.145 //y=1.675 //x2=12.145 //y2=1.06
r81 (  9 29 ) resistor r=3.57586 //w=0.17 //l=0.125 //layer=li //thickness=0.1 \
 //x=12.145 //y=0.795 //x2=12.145 //y2=0.67
r82 (  9 29 ) resistor r=18.139 //w=0.187 //l=0.265 //layer=li //thickness=0.1 \
 //x=12.145 //y=0.795 //x2=12.145 //y2=1.06
r83 (  6 29 ) resistor r=3.57586 //w=0.17 //l=0.103078 //layer=li \
 //thickness=0.1 //x=11.26 //y=1.76 //x2=11.175 //y2=1.8
r84 (  6 29 ) resistor r=27.3797 //w=0.187 //l=0.4 //layer=li //thickness=0.1 \
 //x=11.26 //y=1.76 //x2=11.66 //y2=1.76
r85 (  5 29 ) resistor r=3.57586 //w=0.17 //l=0.103078 //layer=li \
 //thickness=0.1 //x=12.06 //y=1.76 //x2=12.145 //y2=1.8
r86 (  5 29 ) resistor r=27.3797 //w=0.187 //l=0.4 //layer=li //thickness=0.1 \
 //x=12.06 //y=1.76 //x2=11.66 //y2=1.76
r87 (  1 29 ) resistor r=3.57586 //w=0.17 //l=0.125 //layer=li //thickness=0.1 \
 //x=11.175 //y=1.675 //x2=11.175 //y2=1.8
r88 (  1 29 ) resistor r=42.0963 //w=0.187 //l=0.615 //layer=li \
 //thickness=0.1 //x=11.175 //y=1.675 //x2=11.175 //y2=1.06
ends PM_DLATCHN\%noxref_16
