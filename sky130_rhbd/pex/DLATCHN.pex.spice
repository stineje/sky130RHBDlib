// File: DLATCHN.spi.pex
// Created: Tue Apr 29 10:42:06 2025
// Program "Calibre xRC"
// Version "v2023.2_27.15"
// Nominal Temperature: 30C
// Circuit Temperature: 30C
//
simulator lang=spectre
subckt PM_DLATCHN\%GND ( 1 38 50 54 62 68 76 80 83 88 92 100 108 111 116 120 \
 123 128 134 140 146 151 156 160 180 184 192 196 204 210 218 222 230 234 245 \
 248 259 271 273 285 288 300 320 340 341 342 343 344 345 346 347 )
c307 ( 347 0 ) capacitor c=0.0706784f //x=19.92 //y=0.545
c308 ( 346 0 ) capacitor c=0.0706548f //x=16.59 //y=0.545
c309 ( 345 0 ) capacitor c=0.057872f //x=14.305 //y=0.55
c310 ( 344 0 ) capacitor c=0.0207878f //x=11.47 //y=1.045
c311 ( 343 0 ) capacitor c=0.0572698f //x=8.755 //y=0.55
c312 ( 342 0 ) capacitor c=0.0207874f //x=5.92 //y=1.045
c313 ( 341 0 ) capacitor c=0.0572698f //x=3.205 //y=0.55
c314 ( 340 0 ) capacitor c=0.0589341f //x=0.985 //y=0.55
c315 ( 320 0 ) capacitor c=0.105466f //x=19.36 //y=0.175
c316 ( 300 0 ) capacitor c=0.103937f //x=16.03 //y=0.175
c317 ( 288 0 ) capacitor c=0.101616f //x=13.81 //y=0.175
c318 ( 287 0 ) capacitor c=0.00446416f //x=11.59 //y=0.18
c319 ( 285 0 ) capacitor c=0.102357f //x=10.48 //y=0.175
c320 ( 273 0 ) capacitor c=0.101096f //x=8.26 //y=0.175
c321 ( 272 0 ) capacitor c=0.00446416f //x=6.11 //y=0.175
c322 ( 271 0 ) capacitor c=0.102357f //x=4.93 //y=0.175
c323 ( 259 0 ) capacitor c=0.0967837f //x=2.71 //y=0.175
c324 ( 248 0 ) capacitor c=0.211791f //x=1.12 //y=0.175
c325 ( 245 0 ) capacitor c=0.223357f //x=22.32 //y=0.18
c326 ( 243 0 ) capacitor c=0.0671134f //x=22.08 //y=0.175
c327 ( 237 0 ) capacitor c=0.00609805f //x=21.995 //y=0.625
c328 ( 234 0 ) capacitor c=0.00505641f //x=21.91 //y=0.71
c329 ( 233 0 ) capacitor c=0.00468234f //x=21.51 //y=0.625
c330 ( 230 0 ) capacitor c=0.00537084f //x=21.425 //y=0.71
c331 ( 225 0 ) capacitor c=0.00468234f //x=21.025 //y=0.625
c332 ( 222 0 ) capacitor c=0.00537084f //x=20.94 //y=0.71
c333 ( 221 0 ) capacitor c=0.00468234f //x=20.54 //y=0.625
c334 ( 218 0 ) capacitor c=0.00634508f //x=20.455 //y=0.71
c335 ( 213 0 ) capacitor c=0.00609805f //x=20.055 //y=0.625
c336 ( 210 0 ) capacitor c=0.0197476f //x=19.97 //y=0.175
c337 ( 205 0 ) capacitor c=0.0671134f //x=18.75 //y=0.175
c338 ( 204 0 ) capacitor c=0.0197476f //x=19.19 //y=0.175
c339 ( 199 0 ) capacitor c=0.00609805f //x=18.665 //y=0.625
c340 ( 196 0 ) capacitor c=0.00505131f //x=18.58 //y=0.71
c341 ( 195 0 ) capacitor c=0.00468234f //x=18.18 //y=0.625
c342 ( 192 0 ) capacitor c=0.00537002f //x=18.095 //y=0.71
c343 ( 187 0 ) capacitor c=0.00468234f //x=17.695 //y=0.625
c344 ( 184 0 ) capacitor c=0.00556167f //x=17.61 //y=0.71
c345 ( 183 0 ) capacitor c=0.00468234f //x=17.21 //y=0.625
c346 ( 180 0 ) capacitor c=0.00642897f //x=17.125 //y=0.71
c347 ( 175 0 ) capacitor c=0.00609805f //x=16.725 //y=0.625
c348 ( 172 0 ) capacitor c=0.0229116f //x=16.64 //y=0.175
c349 ( 169 0 ) capacitor c=0.036681f //x=15.495 //y=0.175
c350 ( 168 0 ) capacitor c=0.0186173f //x=15.86 //y=0.175
c351 ( 163 0 ) capacitor c=0.00583665f //x=15.41 //y=0.63
c352 ( 160 0 ) capacitor c=0.00536924f //x=15.325 //y=0.715
c353 ( 159 0 ) capacitor c=0.00479856f //x=14.925 //y=0.63
c354 ( 156 0 ) capacitor c=0.00640467f //x=14.84 //y=0.715
c355 ( 151 0 ) capacitor c=0.00588377f //x=14.44 //y=0.63
c356 ( 146 0 ) capacitor c=0.0166308f //x=14.355 //y=0.175
c357 ( 140 0 ) capacitor c=0.0729464f //x=13.64 //y=0.175
c358 ( 134 0 ) capacitor c=0.0392687f //x=11.575 //y=0.175
c359 ( 129 0 ) capacitor c=0.0367f //x=9.945 //y=0.175
c360 ( 128 0 ) capacitor c=0.0161513f //x=10.31 //y=0.175
c361 ( 123 0 ) capacitor c=0.00583665f //x=9.86 //y=0.63
c362 ( 120 0 ) capacitor c=0.00531815f //x=9.775 //y=0.715
c363 ( 119 0 ) capacitor c=0.00479856f //x=9.375 //y=0.63
c364 ( 116 0 ) capacitor c=0.006266f //x=9.29 //y=0.715
c365 ( 111 0 ) capacitor c=0.00588377f //x=8.89 //y=0.63
c366 ( 108 0 ) capacitor c=0.0166308f //x=8.805 //y=0.175
c367 ( 100 0 ) capacitor c=0.072975f //x=8.09 //y=0.175
c368 ( 92 0 ) capacitor c=0.0392687f //x=6.025 //y=0.175
c369 ( 89 0 ) capacitor c=0.0367f //x=4.395 //y=0.175
c370 ( 88 0 ) capacitor c=0.0161513f //x=4.76 //y=0.175
c371 ( 83 0 ) capacitor c=0.00583665f //x=4.31 //y=0.63
c372 ( 80 0 ) capacitor c=0.00531815f //x=4.225 //y=0.715
c373 ( 79 0 ) capacitor c=0.00479856f //x=3.825 //y=0.63
c374 ( 76 0 ) capacitor c=0.006266f //x=3.74 //y=0.715
c375 ( 71 0 ) capacitor c=0.00592191f //x=3.34 //y=0.63
c376 ( 68 0 ) capacitor c=0.0166308f //x=3.255 //y=0.175
c377 ( 63 0 ) capacitor c=0.0366803f //x=2.175 //y=0.175
c378 ( 62 0 ) capacitor c=0.0161513f //x=2.54 //y=0.175
c379 ( 57 0 ) capacitor c=0.00587411f //x=2.09 //y=0.63
c380 ( 54 0 ) capacitor c=0.00536611f //x=2.005 //y=0.715
c381 ( 53 0 ) capacitor c=0.00479856f //x=1.605 //y=0.63
c382 ( 50 0 ) capacitor c=0.00707849f //x=1.52 //y=0.715
c383 ( 45 0 ) capacitor c=0.00592191f //x=1.12 //y=0.63
c384 ( 38 0 ) capacitor c=0.784894f //x=22.32 //y=0.18
r385 (  328 329 ) resistor r=14.4741 //w=0.367 //l=0.415 //layer=li \
 //thickness=0.1 //x=21.58 //y=0.175 //x2=21.995 //y2=0.175
r386 (  326 328 ) resistor r=2.44142 //w=0.367 //l=0.07 //layer=li \
 //thickness=0.1 //x=21.51 //y=0.175 //x2=21.58 //y2=0.175
r387 (  325 326 ) resistor r=16.9155 //w=0.367 //l=0.485 //layer=li \
 //thickness=0.1 //x=21.025 //y=0.175 //x2=21.51 //y2=0.175
r388 (  324 325 ) resistor r=16.9155 //w=0.367 //l=0.485 //layer=li \
 //thickness=0.1 //x=20.54 //y=0.175 //x2=21.025 //y2=0.175
r389 (  323 324 ) resistor r=2.44142 //w=0.367 //l=0.07 //layer=li \
 //thickness=0.1 //x=20.47 //y=0.175 //x2=20.54 //y2=0.175
r390 (  321 323 ) resistor r=14.4741 //w=0.367 //l=0.415 //layer=li \
 //thickness=0.1 //x=20.055 //y=0.175 //x2=20.47 //y2=0.175
r391 (  308 309 ) resistor r=16.9155 //w=0.367 //l=0.485 //layer=li \
 //thickness=0.1 //x=18.18 //y=0.175 //x2=18.665 //y2=0.175
r392 (  307 308 ) resistor r=10.4632 //w=0.367 //l=0.3 //layer=li \
 //thickness=0.1 //x=17.88 //y=0.175 //x2=18.18 //y2=0.175
r393 (  305 307 ) resistor r=6.45232 //w=0.367 //l=0.185 //layer=li \
 //thickness=0.1 //x=17.695 //y=0.175 //x2=17.88 //y2=0.175
r394 (  304 305 ) resistor r=16.9155 //w=0.367 //l=0.485 //layer=li \
 //thickness=0.1 //x=17.21 //y=0.175 //x2=17.695 //y2=0.175
r395 (  303 304 ) resistor r=15.346 //w=0.367 //l=0.44 //layer=li \
 //thickness=0.1 //x=16.77 //y=0.175 //x2=17.21 //y2=0.175
r396 (  301 303 ) resistor r=1.56948 //w=0.367 //l=0.045 //layer=li \
 //thickness=0.1 //x=16.725 //y=0.175 //x2=16.77 //y2=0.175
r397 (  292 293 ) resistor r=4.18529 //w=0.367 //l=0.12 //layer=li \
 //thickness=0.1 //x=15.29 //y=0.175 //x2=15.41 //y2=0.175
r398 (  290 292 ) resistor r=12.7302 //w=0.367 //l=0.365 //layer=li \
 //thickness=0.1 //x=14.925 //y=0.175 //x2=15.29 //y2=0.175
r399 (  289 290 ) resistor r=16.9155 //w=0.367 //l=0.485 //layer=li \
 //thickness=0.1 //x=14.44 //y=0.175 //x2=14.925 //y2=0.175
r400 (  277 278 ) resistor r=16.9155 //w=0.367 //l=0.485 //layer=li \
 //thickness=0.1 //x=9.375 //y=0.175 //x2=9.86 //y2=0.175
r401 (  276 277 ) resistor r=13.079 //w=0.367 //l=0.375 //layer=li \
 //thickness=0.1 //x=9 //y=0.175 //x2=9.375 //y2=0.175
r402 (  274 276 ) resistor r=3.83651 //w=0.367 //l=0.11 //layer=li \
 //thickness=0.1 //x=8.89 //y=0.175 //x2=9 //y2=0.175
r403 (  263 264 ) resistor r=16.9155 //w=0.367 //l=0.485 //layer=li \
 //thickness=0.1 //x=3.825 //y=0.175 //x2=4.31 //y2=0.175
r404 (  262 263 ) resistor r=0.174387 //w=0.367 //l=0.005 //layer=li \
 //thickness=0.1 //x=3.82 //y=0.175 //x2=3.825 //y2=0.175
r405 (  260 262 ) resistor r=16.7411 //w=0.367 //l=0.48 //layer=li \
 //thickness=0.1 //x=3.34 //y=0.175 //x2=3.82 //y2=0.175
r406 (  251 252 ) resistor r=16.9155 //w=0.367 //l=0.485 //layer=li \
 //thickness=0.1 //x=1.605 //y=0.175 //x2=2.09 //y2=0.175
r407 (  250 251 ) resistor r=13.079 //w=0.367 //l=0.375 //layer=li \
 //thickness=0.1 //x=1.23 //y=0.175 //x2=1.605 //y2=0.175
r408 (  248 250 ) resistor r=3.83651 //w=0.367 //l=0.11 //layer=li \
 //thickness=0.1 //x=1.12 //y=0.175 //x2=1.23 //y2=0.175
r409 (  243 329 ) resistor r=2.96458 //w=0.367 //l=0.085 //layer=li \
 //thickness=0.1 //x=22.08 //y=0.175 //x2=21.995 //y2=0.175
r410 (  243 245 ) resistor r=8.37057 //w=0.367 //l=0.24 //layer=li \
 //thickness=0.1 //x=22.08 //y=0.175 //x2=22.32 //y2=0.175
r411 (  238 347 ) resistor r=5.4201 //w=0.17 //l=0.085 //layer=li \
 //thickness=0.1 //x=21.995 //y=0.795 //x2=21.995 //y2=0.71
r412 (  238 347 ) resistor r=18.139 //w=0.187 //l=0.265 //layer=li \
 //thickness=0.1 //x=21.995 //y=0.795 //x2=21.995 //y2=1.06
r413 (  237 347 ) resistor r=5.4201 //w=0.17 //l=0.085 //layer=li \
 //thickness=0.1 //x=21.995 //y=0.625 //x2=21.995 //y2=0.71
r414 (  236 329 ) resistor r=5.21862 //w=0.35 //l=0.175 //layer=li \
 //thickness=0.1 //x=21.995 //y=0.35 //x2=21.995 //y2=0.175
r415 (  236 237 ) resistor r=18.8235 //w=0.187 //l=0.275 //layer=li \
 //thickness=0.1 //x=21.995 //y=0.35 //x2=21.995 //y2=0.625
r416 (  235 347 ) resistor r=5.4201 //w=0.17 //l=0.085 //layer=li \
 //thickness=0.1 //x=21.595 //y=0.71 //x2=21.51 //y2=0.71
r417 (  234 347 ) resistor r=1.40859 //w=0.34 //l=0.085 //layer=li \
 //thickness=0.1 //x=21.91 //y=0.71 //x2=21.995 //y2=0.71
r418 (  234 235 ) resistor r=21.5615 //w=0.187 //l=0.315 //layer=li \
 //thickness=0.1 //x=21.91 //y=0.71 //x2=21.595 //y2=0.71
r419 (  233 347 ) resistor r=1.40859 //w=0.34 //l=0.085 //layer=li \
 //thickness=0.1 //x=21.51 //y=0.625 //x2=21.51 //y2=0.71
r420 (  232 326 ) resistor r=5.21862 //w=0.35 //l=0.175 //layer=li \
 //thickness=0.1 //x=21.51 //y=0.35 //x2=21.51 //y2=0.175
r421 (  232 233 ) resistor r=18.8235 //w=0.187 //l=0.275 //layer=li \
 //thickness=0.1 //x=21.51 //y=0.35 //x2=21.51 //y2=0.625
r422 (  231 347 ) resistor r=6.4 //w=0.17 //l=0.085 //layer=li //thickness=0.1 \
 //x=21.11 //y=0.71 //x2=21.025 //y2=0.71
r423 (  230 347 ) resistor r=5.4201 //w=0.17 //l=0.085 //layer=li \
 //thickness=0.1 //x=21.425 //y=0.71 //x2=21.51 //y2=0.71
r424 (  230 231 ) resistor r=21.5615 //w=0.187 //l=0.315 //layer=li \
 //thickness=0.1 //x=21.425 //y=0.71 //x2=21.11 //y2=0.71
r425 (  226 347 ) resistor r=6.4 //w=0.17 //l=0.085 //layer=li //thickness=0.1 \
 //x=21.025 //y=0.795 //x2=21.025 //y2=0.71
r426 (  226 347 ) resistor r=18.139 //w=0.187 //l=0.265 //layer=li \
 //thickness=0.1 //x=21.025 //y=0.795 //x2=21.025 //y2=1.06
r427 (  225 347 ) resistor r=6.4 //w=0.17 //l=0.085 //layer=li //thickness=0.1 \
 //x=21.025 //y=0.625 //x2=21.025 //y2=0.71
r428 (  224 325 ) resistor r=5.21862 //w=0.35 //l=0.175 //layer=li \
 //thickness=0.1 //x=21.025 //y=0.35 //x2=21.025 //y2=0.175
r429 (  224 225 ) resistor r=18.8235 //w=0.187 //l=0.275 //layer=li \
 //thickness=0.1 //x=21.025 //y=0.35 //x2=21.025 //y2=0.625
r430 (  223 347 ) resistor r=5.4201 //w=0.17 //l=0.085 //layer=li \
 //thickness=0.1 //x=20.625 //y=0.71 //x2=20.54 //y2=0.71
r431 (  222 347 ) resistor r=6.4 //w=0.17 //l=0.085 //layer=li //thickness=0.1 \
 //x=20.94 //y=0.71 //x2=21.025 //y2=0.71
r432 (  222 223 ) resistor r=21.5615 //w=0.187 //l=0.315 //layer=li \
 //thickness=0.1 //x=20.94 //y=0.71 //x2=20.625 //y2=0.71
r433 (  221 347 ) resistor r=1.40859 //w=0.34 //l=0.085 //layer=li \
 //thickness=0.1 //x=20.54 //y=0.625 //x2=20.54 //y2=0.71
r434 (  220 324 ) resistor r=5.21862 //w=0.35 //l=0.175 //layer=li \
 //thickness=0.1 //x=20.54 //y=0.35 //x2=20.54 //y2=0.175
r435 (  220 221 ) resistor r=18.8235 //w=0.187 //l=0.275 //layer=li \
 //thickness=0.1 //x=20.54 //y=0.35 //x2=20.54 //y2=0.625
r436 (  219 347 ) resistor r=1.40859 //w=0.34 //l=0.085 //layer=li \
 //thickness=0.1 //x=20.14 //y=0.71 //x2=20.055 //y2=0.71
r437 (  218 347 ) resistor r=5.4201 //w=0.17 //l=0.085 //layer=li \
 //thickness=0.1 //x=20.455 //y=0.71 //x2=20.54 //y2=0.71
r438 (  218 219 ) resistor r=21.5615 //w=0.187 //l=0.315 //layer=li \
 //thickness=0.1 //x=20.455 //y=0.71 //x2=20.14 //y2=0.71
r439 (  214 347 ) resistor r=5.4201 //w=0.17 //l=0.085 //layer=li \
 //thickness=0.1 //x=20.055 //y=0.795 //x2=20.055 //y2=0.71
r440 (  214 347 ) resistor r=41.4118 //w=0.187 //l=0.605 //layer=li \
 //thickness=0.1 //x=20.055 //y=0.795 //x2=20.055 //y2=1.4
r441 (  213 347 ) resistor r=5.4201 //w=0.17 //l=0.085 //layer=li \
 //thickness=0.1 //x=20.055 //y=0.625 //x2=20.055 //y2=0.71
r442 (  212 321 ) resistor r=5.21862 //w=0.35 //l=0.175 //layer=li \
 //thickness=0.1 //x=20.055 //y=0.35 //x2=20.055 //y2=0.175
r443 (  212 213 ) resistor r=18.8235 //w=0.187 //l=0.275 //layer=li \
 //thickness=0.1 //x=20.055 //y=0.35 //x2=20.055 //y2=0.625
r444 (  211 320 ) resistor r=5.29055 //w=0.35 //l=0.17 //layer=li \
 //thickness=0.1 //x=19.53 //y=0.175 //x2=19.36 //y2=0.175
r445 (  210 321 ) resistor r=2.96458 //w=0.367 //l=0.085 //layer=li \
 //thickness=0.1 //x=19.97 //y=0.175 //x2=20.055 //y2=0.175
r446 (  210 211 ) resistor r=15.346 //w=0.367 //l=0.44 //layer=li \
 //thickness=0.1 //x=19.97 //y=0.175 //x2=19.53 //y2=0.175
r447 (  205 309 ) resistor r=2.96458 //w=0.367 //l=0.085 //layer=li \
 //thickness=0.1 //x=18.75 //y=0.175 //x2=18.665 //y2=0.175
r448 (  205 207 ) resistor r=8.37057 //w=0.367 //l=0.24 //layer=li \
 //thickness=0.1 //x=18.75 //y=0.175 //x2=18.99 //y2=0.175
r449 (  204 320 ) resistor r=5.29055 //w=0.35 //l=0.17 //layer=li \
 //thickness=0.1 //x=19.19 //y=0.175 //x2=19.36 //y2=0.175
r450 (  204 207 ) resistor r=6.97548 //w=0.367 //l=0.2 //layer=li \
 //thickness=0.1 //x=19.19 //y=0.175 //x2=18.99 //y2=0.175
r451 (  200 346 ) resistor r=5.4201 //w=0.17 //l=0.085 //layer=li \
 //thickness=0.1 //x=18.665 //y=0.795 //x2=18.665 //y2=0.71
r452 (  200 346 ) resistor r=18.139 //w=0.187 //l=0.265 //layer=li \
 //thickness=0.1 //x=18.665 //y=0.795 //x2=18.665 //y2=1.06
r453 (  199 346 ) resistor r=5.4201 //w=0.17 //l=0.085 //layer=li \
 //thickness=0.1 //x=18.665 //y=0.625 //x2=18.665 //y2=0.71
r454 (  198 309 ) resistor r=5.21862 //w=0.35 //l=0.175 //layer=li \
 //thickness=0.1 //x=18.665 //y=0.35 //x2=18.665 //y2=0.175
r455 (  198 199 ) resistor r=18.8235 //w=0.187 //l=0.275 //layer=li \
 //thickness=0.1 //x=18.665 //y=0.35 //x2=18.665 //y2=0.625
r456 (  197 346 ) resistor r=5.4201 //w=0.17 //l=0.085 //layer=li \
 //thickness=0.1 //x=18.265 //y=0.71 //x2=18.18 //y2=0.71
r457 (  196 346 ) resistor r=1.40859 //w=0.34 //l=0.085 //layer=li \
 //thickness=0.1 //x=18.58 //y=0.71 //x2=18.665 //y2=0.71
r458 (  196 197 ) resistor r=21.5615 //w=0.187 //l=0.315 //layer=li \
 //thickness=0.1 //x=18.58 //y=0.71 //x2=18.265 //y2=0.71
r459 (  195 346 ) resistor r=1.40859 //w=0.34 //l=0.085 //layer=li \
 //thickness=0.1 //x=18.18 //y=0.625 //x2=18.18 //y2=0.71
r460 (  194 308 ) resistor r=5.21862 //w=0.35 //l=0.175 //layer=li \
 //thickness=0.1 //x=18.18 //y=0.35 //x2=18.18 //y2=0.175
r461 (  194 195 ) resistor r=18.8235 //w=0.187 //l=0.275 //layer=li \
 //thickness=0.1 //x=18.18 //y=0.35 //x2=18.18 //y2=0.625
r462 (  193 346 ) resistor r=6.4 //w=0.17 //l=0.085 //layer=li //thickness=0.1 \
 //x=17.78 //y=0.71 //x2=17.695 //y2=0.71
r463 (  192 346 ) resistor r=5.4201 //w=0.17 //l=0.085 //layer=li \
 //thickness=0.1 //x=18.095 //y=0.71 //x2=18.18 //y2=0.71
r464 (  192 193 ) resistor r=21.5615 //w=0.187 //l=0.315 //layer=li \
 //thickness=0.1 //x=18.095 //y=0.71 //x2=17.78 //y2=0.71
r465 (  188 346 ) resistor r=6.4 //w=0.17 //l=0.085 //layer=li //thickness=0.1 \
 //x=17.695 //y=0.795 //x2=17.695 //y2=0.71
r466 (  188 346 ) resistor r=18.139 //w=0.187 //l=0.265 //layer=li \
 //thickness=0.1 //x=17.695 //y=0.795 //x2=17.695 //y2=1.06
r467 (  187 346 ) resistor r=6.4 //w=0.17 //l=0.085 //layer=li //thickness=0.1 \
 //x=17.695 //y=0.625 //x2=17.695 //y2=0.71
r468 (  186 305 ) resistor r=5.21862 //w=0.35 //l=0.175 //layer=li \
 //thickness=0.1 //x=17.695 //y=0.35 //x2=17.695 //y2=0.175
r469 (  186 187 ) resistor r=18.8235 //w=0.187 //l=0.275 //layer=li \
 //thickness=0.1 //x=17.695 //y=0.35 //x2=17.695 //y2=0.625
r470 (  185 346 ) resistor r=5.4201 //w=0.17 //l=0.085 //layer=li \
 //thickness=0.1 //x=17.295 //y=0.71 //x2=17.21 //y2=0.71
r471 (  184 346 ) resistor r=6.4 //w=0.17 //l=0.085 //layer=li //thickness=0.1 \
 //x=17.61 //y=0.71 //x2=17.695 //y2=0.71
r472 (  184 185 ) resistor r=21.5615 //w=0.187 //l=0.315 //layer=li \
 //thickness=0.1 //x=17.61 //y=0.71 //x2=17.295 //y2=0.71
r473 (  183 346 ) resistor r=1.40859 //w=0.34 //l=0.085 //layer=li \
 //thickness=0.1 //x=17.21 //y=0.625 //x2=17.21 //y2=0.71
r474 (  182 304 ) resistor r=5.21862 //w=0.35 //l=0.175 //layer=li \
 //thickness=0.1 //x=17.21 //y=0.35 //x2=17.21 //y2=0.175
r475 (  182 183 ) resistor r=18.8235 //w=0.187 //l=0.275 //layer=li \
 //thickness=0.1 //x=17.21 //y=0.35 //x2=17.21 //y2=0.625
r476 (  181 346 ) resistor r=1.40859 //w=0.34 //l=0.085 //layer=li \
 //thickness=0.1 //x=16.81 //y=0.71 //x2=16.725 //y2=0.71
r477 (  180 346 ) resistor r=5.4201 //w=0.17 //l=0.085 //layer=li \
 //thickness=0.1 //x=17.125 //y=0.71 //x2=17.21 //y2=0.71
r478 (  180 181 ) resistor r=21.5615 //w=0.187 //l=0.315 //layer=li \
 //thickness=0.1 //x=17.125 //y=0.71 //x2=16.81 //y2=0.71
r479 (  176 346 ) resistor r=5.4201 //w=0.17 //l=0.085 //layer=li \
 //thickness=0.1 //x=16.725 //y=0.795 //x2=16.725 //y2=0.71
r480 (  176 346 ) resistor r=41.4118 //w=0.187 //l=0.605 //layer=li \
 //thickness=0.1 //x=16.725 //y=0.795 //x2=16.725 //y2=1.4
r481 (  175 346 ) resistor r=5.4201 //w=0.17 //l=0.085 //layer=li \
 //thickness=0.1 //x=16.725 //y=0.625 //x2=16.725 //y2=0.71
r482 (  174 301 ) resistor r=5.21862 //w=0.35 //l=0.175 //layer=li \
 //thickness=0.1 //x=16.725 //y=0.35 //x2=16.725 //y2=0.175
r483 (  174 175 ) resistor r=18.8235 //w=0.187 //l=0.275 //layer=li \
 //thickness=0.1 //x=16.725 //y=0.35 //x2=16.725 //y2=0.625
r484 (  173 300 ) resistor r=5.29055 //w=0.35 //l=0.17 //layer=li \
 //thickness=0.1 //x=16.2 //y=0.175 //x2=16.03 //y2=0.175
r485 (  172 301 ) resistor r=2.96458 //w=0.367 //l=0.085 //layer=li \
 //thickness=0.1 //x=16.64 //y=0.175 //x2=16.725 //y2=0.175
r486 (  172 173 ) resistor r=15.346 //w=0.367 //l=0.44 //layer=li \
 //thickness=0.1 //x=16.64 //y=0.175 //x2=16.2 //y2=0.175
r487 (  169 293 ) resistor r=2.96458 //w=0.367 //l=0.085 //layer=li \
 //thickness=0.1 //x=15.495 //y=0.175 //x2=15.41 //y2=0.175
r488 (  168 300 ) resistor r=5.29055 //w=0.35 //l=0.17 //layer=li \
 //thickness=0.1 //x=15.86 //y=0.175 //x2=16.03 //y2=0.175
r489 (  168 169 ) resistor r=12.7302 //w=0.367 //l=0.365 //layer=li \
 //thickness=0.1 //x=15.86 //y=0.175 //x2=15.495 //y2=0.175
r490 (  164 345 ) resistor r=5.4201 //w=0.17 //l=0.085 //layer=li \
 //thickness=0.1 //x=15.41 //y=0.8 //x2=15.41 //y2=0.715
r491 (  164 345 ) resistor r=41.4118 //w=0.187 //l=0.605 //layer=li \
 //thickness=0.1 //x=15.41 //y=0.8 //x2=15.41 //y2=1.405
r492 (  163 345 ) resistor r=5.4201 //w=0.17 //l=0.085 //layer=li \
 //thickness=0.1 //x=15.41 //y=0.63 //x2=15.41 //y2=0.715
r493 (  162 293 ) resistor r=5.21862 //w=0.35 //l=0.175 //layer=li \
 //thickness=0.1 //x=15.41 //y=0.35 //x2=15.41 //y2=0.175
r494 (  162 163 ) resistor r=19.1658 //w=0.187 //l=0.28 //layer=li \
 //thickness=0.1 //x=15.41 //y=0.35 //x2=15.41 //y2=0.63
r495 (  161 345 ) resistor r=5.4201 //w=0.17 //l=0.085 //layer=li \
 //thickness=0.1 //x=15.01 //y=0.715 //x2=14.925 //y2=0.715
r496 (  160 345 ) resistor r=1.40859 //w=0.34 //l=0.085 //layer=li \
 //thickness=0.1 //x=15.325 //y=0.715 //x2=15.41 //y2=0.715
r497 (  160 161 ) resistor r=21.5615 //w=0.187 //l=0.315 //layer=li \
 //thickness=0.1 //x=15.325 //y=0.715 //x2=15.01 //y2=0.715
r498 (  159 345 ) resistor r=1.40859 //w=0.34 //l=0.085 //layer=li \
 //thickness=0.1 //x=14.925 //y=0.63 //x2=14.925 //y2=0.715
r499 (  158 290 ) resistor r=5.21862 //w=0.35 //l=0.175 //layer=li \
 //thickness=0.1 //x=14.925 //y=0.35 //x2=14.925 //y2=0.175
r500 (  158 159 ) resistor r=19.1658 //w=0.187 //l=0.28 //layer=li \
 //thickness=0.1 //x=14.925 //y=0.35 //x2=14.925 //y2=0.63
r501 (  157 345 ) resistor r=1.40859 //w=0.34 //l=0.085 //layer=li \
 //thickness=0.1 //x=14.525 //y=0.715 //x2=14.44 //y2=0.715
r502 (  156 345 ) resistor r=5.4201 //w=0.17 //l=0.085 //layer=li \
 //thickness=0.1 //x=14.84 //y=0.715 //x2=14.925 //y2=0.715
r503 (  156 157 ) resistor r=21.5615 //w=0.187 //l=0.315 //layer=li \
 //thickness=0.1 //x=14.84 //y=0.715 //x2=14.525 //y2=0.715
r504 (  152 345 ) resistor r=5.4201 //w=0.17 //l=0.085 //layer=li \
 //thickness=0.1 //x=14.44 //y=0.8 //x2=14.44 //y2=0.715
r505 (  152 345 ) resistor r=41.4118 //w=0.187 //l=0.605 //layer=li \
 //thickness=0.1 //x=14.44 //y=0.8 //x2=14.44 //y2=1.405
r506 (  151 345 ) resistor r=5.4201 //w=0.17 //l=0.085 //layer=li \
 //thickness=0.1 //x=14.44 //y=0.63 //x2=14.44 //y2=0.715
r507 (  150 289 ) resistor r=5.21862 //w=0.35 //l=0.175 //layer=li \
 //thickness=0.1 //x=14.44 //y=0.35 //x2=14.44 //y2=0.175
r508 (  150 151 ) resistor r=19.1658 //w=0.187 //l=0.28 //layer=li \
 //thickness=0.1 //x=14.44 //y=0.35 //x2=14.44 //y2=0.63
r509 (  147 288 ) resistor r=5.29055 //w=0.35 //l=0.17 //layer=li \
 //thickness=0.1 //x=13.98 //y=0.175 //x2=13.81 //y2=0.175
r510 (  147 149 ) resistor r=6.97548 //w=0.367 //l=0.2 //layer=li \
 //thickness=0.1 //x=13.98 //y=0.175 //x2=14.18 //y2=0.175
r511 (  146 289 ) resistor r=2.96458 //w=0.367 //l=0.085 //layer=li \
 //thickness=0.1 //x=14.355 //y=0.175 //x2=14.44 //y2=0.175
r512 (  146 149 ) resistor r=6.10354 //w=0.367 //l=0.175 //layer=li \
 //thickness=0.1 //x=14.355 //y=0.175 //x2=14.18 //y2=0.175
r513 (  141 287 ) resistor r=2.87058 //w=0.35 //l=0.085 //layer=li \
 //thickness=0.1 //x=11.745 //y=0.175 //x2=11.66 //y2=0.175
r514 (  141 143 ) resistor r=33.3079 //w=0.367 //l=0.955 //layer=li \
 //thickness=0.1 //x=11.745 //y=0.175 //x2=12.7 //y2=0.175
r515 (  140 288 ) resistor r=5.29055 //w=0.35 //l=0.17 //layer=li \
 //thickness=0.1 //x=13.64 //y=0.175 //x2=13.81 //y2=0.175
r516 (  140 143 ) resistor r=32.7847 //w=0.367 //l=0.94 //layer=li \
 //thickness=0.1 //x=13.64 //y=0.175 //x2=12.7 //y2=0.175
r517 (  136 287 ) resistor r=4.23183 //w=0.7 //l=0.175 //layer=li \
 //thickness=0.1 //x=11.66 //y=0.35 //x2=11.66 //y2=0.175
r518 (  136 344 ) resistor r=53.7326 //w=0.187 //l=0.785 //layer=li \
 //thickness=0.1 //x=11.66 //y=0.35 //x2=11.66 //y2=1.135
r519 (  135 285 ) resistor r=5.29055 //w=0.35 //l=0.17 //layer=li \
 //thickness=0.1 //x=10.65 //y=0.175 //x2=10.48 //y2=0.175
r520 (  134 287 ) resistor r=2.87058 //w=0.35 //l=0.085 //layer=li \
 //thickness=0.1 //x=11.575 //y=0.175 //x2=11.66 //y2=0.175
r521 (  134 135 ) resistor r=32.2616 //w=0.367 //l=0.925 //layer=li \
 //thickness=0.1 //x=11.575 //y=0.175 //x2=10.65 //y2=0.175
r522 (  129 278 ) resistor r=2.96458 //w=0.367 //l=0.085 //layer=li \
 //thickness=0.1 //x=9.945 //y=0.175 //x2=9.86 //y2=0.175
r523 (  129 131 ) resistor r=5.75477 //w=0.367 //l=0.165 //layer=li \
 //thickness=0.1 //x=9.945 //y=0.175 //x2=10.11 //y2=0.175
r524 (  128 285 ) resistor r=5.29055 //w=0.35 //l=0.17 //layer=li \
 //thickness=0.1 //x=10.31 //y=0.175 //x2=10.48 //y2=0.175
r525 (  128 131 ) resistor r=6.97548 //w=0.367 //l=0.2 //layer=li \
 //thickness=0.1 //x=10.31 //y=0.175 //x2=10.11 //y2=0.175
r526 (  124 343 ) resistor r=5.4201 //w=0.17 //l=0.085 //layer=li \
 //thickness=0.1 //x=9.86 //y=0.8 //x2=9.86 //y2=0.715
r527 (  124 343 ) resistor r=41.4118 //w=0.187 //l=0.605 //layer=li \
 //thickness=0.1 //x=9.86 //y=0.8 //x2=9.86 //y2=1.405
r528 (  123 343 ) resistor r=5.4201 //w=0.17 //l=0.085 //layer=li \
 //thickness=0.1 //x=9.86 //y=0.63 //x2=9.86 //y2=0.715
r529 (  122 278 ) resistor r=5.21862 //w=0.35 //l=0.175 //layer=li \
 //thickness=0.1 //x=9.86 //y=0.35 //x2=9.86 //y2=0.175
r530 (  122 123 ) resistor r=19.1658 //w=0.187 //l=0.28 //layer=li \
 //thickness=0.1 //x=9.86 //y=0.35 //x2=9.86 //y2=0.63
r531 (  121 343 ) resistor r=5.4201 //w=0.17 //l=0.085 //layer=li \
 //thickness=0.1 //x=9.46 //y=0.715 //x2=9.375 //y2=0.715
r532 (  120 343 ) resistor r=1.40859 //w=0.34 //l=0.085 //layer=li \
 //thickness=0.1 //x=9.775 //y=0.715 //x2=9.86 //y2=0.715
r533 (  120 121 ) resistor r=21.5615 //w=0.187 //l=0.315 //layer=li \
 //thickness=0.1 //x=9.775 //y=0.715 //x2=9.46 //y2=0.715
r534 (  119 343 ) resistor r=1.40859 //w=0.34 //l=0.085 //layer=li \
 //thickness=0.1 //x=9.375 //y=0.63 //x2=9.375 //y2=0.715
r535 (  118 277 ) resistor r=5.21862 //w=0.35 //l=0.175 //layer=li \
 //thickness=0.1 //x=9.375 //y=0.35 //x2=9.375 //y2=0.175
r536 (  118 119 ) resistor r=19.1658 //w=0.187 //l=0.28 //layer=li \
 //thickness=0.1 //x=9.375 //y=0.35 //x2=9.375 //y2=0.63
r537 (  117 343 ) resistor r=1.40859 //w=0.34 //l=0.085 //layer=li \
 //thickness=0.1 //x=8.975 //y=0.715 //x2=8.89 //y2=0.715
r538 (  116 343 ) resistor r=5.4201 //w=0.17 //l=0.085 //layer=li \
 //thickness=0.1 //x=9.29 //y=0.715 //x2=9.375 //y2=0.715
r539 (  116 117 ) resistor r=21.5615 //w=0.187 //l=0.315 //layer=li \
 //thickness=0.1 //x=9.29 //y=0.715 //x2=8.975 //y2=0.715
r540 (  112 343 ) resistor r=5.4201 //w=0.17 //l=0.085 //layer=li \
 //thickness=0.1 //x=8.89 //y=0.8 //x2=8.89 //y2=0.715
r541 (  112 343 ) resistor r=41.4118 //w=0.187 //l=0.605 //layer=li \
 //thickness=0.1 //x=8.89 //y=0.8 //x2=8.89 //y2=1.405
r542 (  111 343 ) resistor r=5.4201 //w=0.17 //l=0.085 //layer=li \
 //thickness=0.1 //x=8.89 //y=0.63 //x2=8.89 //y2=0.715
r543 (  110 274 ) resistor r=5.21862 //w=0.35 //l=0.175 //layer=li \
 //thickness=0.1 //x=8.89 //y=0.35 //x2=8.89 //y2=0.175
r544 (  110 111 ) resistor r=19.1658 //w=0.187 //l=0.28 //layer=li \
 //thickness=0.1 //x=8.89 //y=0.35 //x2=8.89 //y2=0.63
r545 (  109 273 ) resistor r=5.29055 //w=0.35 //l=0.17 //layer=li \
 //thickness=0.1 //x=8.43 //y=0.175 //x2=8.26 //y2=0.175
r546 (  108 274 ) resistor r=2.96458 //w=0.367 //l=0.085 //layer=li \
 //thickness=0.1 //x=8.805 //y=0.175 //x2=8.89 //y2=0.175
r547 (  108 109 ) resistor r=13.079 //w=0.367 //l=0.375 //layer=li \
 //thickness=0.1 //x=8.805 //y=0.175 //x2=8.43 //y2=0.175
r548 (  103 105 ) resistor r=38.7139 //w=0.367 //l=1.11 //layer=li \
 //thickness=0.1 //x=6.41 //y=0.175 //x2=7.52 //y2=0.175
r549 (  101 272 ) resistor r=2.87058 //w=0.35 //l=0.085 //layer=li \
 //thickness=0.1 //x=6.195 //y=0.175 //x2=6.11 //y2=0.175
r550 (  101 103 ) resistor r=7.49864 //w=0.367 //l=0.215 //layer=li \
 //thickness=0.1 //x=6.195 //y=0.175 //x2=6.41 //y2=0.175
r551 (  100 273 ) resistor r=5.29055 //w=0.35 //l=0.17 //layer=li \
 //thickness=0.1 //x=8.09 //y=0.175 //x2=8.26 //y2=0.175
r552 (  100 105 ) resistor r=19.8801 //w=0.367 //l=0.57 //layer=li \
 //thickness=0.1 //x=8.09 //y=0.175 //x2=7.52 //y2=0.175
r553 (  96 272 ) resistor r=4.23183 //w=0.7 //l=0.175 //layer=li \
 //thickness=0.1 //x=6.11 //y=0.35 //x2=6.11 //y2=0.175
r554 (  96 342 ) resistor r=53.7326 //w=0.187 //l=0.785 //layer=li \
 //thickness=0.1 //x=6.11 //y=0.35 //x2=6.11 //y2=1.135
r555 (  93 271 ) resistor r=5.29055 //w=0.35 //l=0.17 //layer=li \
 //thickness=0.1 //x=5.1 //y=0.175 //x2=4.93 //y2=0.175
r556 (  93 95 ) resistor r=6.97548 //w=0.367 //l=0.2 //layer=li \
 //thickness=0.1 //x=5.1 //y=0.175 //x2=5.3 //y2=0.175
r557 (  92 272 ) resistor r=2.87058 //w=0.35 //l=0.085 //layer=li \
 //thickness=0.1 //x=6.025 //y=0.175 //x2=6.11 //y2=0.175
r558 (  92 95 ) resistor r=25.2861 //w=0.367 //l=0.725 //layer=li \
 //thickness=0.1 //x=6.025 //y=0.175 //x2=5.3 //y2=0.175
r559 (  89 264 ) resistor r=2.96458 //w=0.367 //l=0.085 //layer=li \
 //thickness=0.1 //x=4.395 //y=0.175 //x2=4.31 //y2=0.175
r560 (  88 271 ) resistor r=5.29055 //w=0.35 //l=0.17 //layer=li \
 //thickness=0.1 //x=4.76 //y=0.175 //x2=4.93 //y2=0.175
r561 (  88 89 ) resistor r=12.7302 //w=0.367 //l=0.365 //layer=li \
 //thickness=0.1 //x=4.76 //y=0.175 //x2=4.395 //y2=0.175
r562 (  84 341 ) resistor r=5.4201 //w=0.17 //l=0.085 //layer=li \
 //thickness=0.1 //x=4.31 //y=0.8 //x2=4.31 //y2=0.715
r563 (  84 341 ) resistor r=41.4118 //w=0.187 //l=0.605 //layer=li \
 //thickness=0.1 //x=4.31 //y=0.8 //x2=4.31 //y2=1.405
r564 (  83 341 ) resistor r=5.4201 //w=0.17 //l=0.085 //layer=li \
 //thickness=0.1 //x=4.31 //y=0.63 //x2=4.31 //y2=0.715
r565 (  82 264 ) resistor r=5.21862 //w=0.35 //l=0.175 //layer=li \
 //thickness=0.1 //x=4.31 //y=0.35 //x2=4.31 //y2=0.175
r566 (  82 83 ) resistor r=19.1658 //w=0.187 //l=0.28 //layer=li \
 //thickness=0.1 //x=4.31 //y=0.35 //x2=4.31 //y2=0.63
r567 (  81 341 ) resistor r=5.4201 //w=0.17 //l=0.085 //layer=li \
 //thickness=0.1 //x=3.91 //y=0.715 //x2=3.825 //y2=0.715
r568 (  80 341 ) resistor r=1.40859 //w=0.34 //l=0.085 //layer=li \
 //thickness=0.1 //x=4.225 //y=0.715 //x2=4.31 //y2=0.715
r569 (  80 81 ) resistor r=21.5615 //w=0.187 //l=0.315 //layer=li \
 //thickness=0.1 //x=4.225 //y=0.715 //x2=3.91 //y2=0.715
r570 (  79 341 ) resistor r=1.40859 //w=0.34 //l=0.085 //layer=li \
 //thickness=0.1 //x=3.825 //y=0.63 //x2=3.825 //y2=0.715
r571 (  78 263 ) resistor r=5.21862 //w=0.35 //l=0.175 //layer=li \
 //thickness=0.1 //x=3.825 //y=0.35 //x2=3.825 //y2=0.175
r572 (  78 79 ) resistor r=19.1658 //w=0.187 //l=0.28 //layer=li \
 //thickness=0.1 //x=3.825 //y=0.35 //x2=3.825 //y2=0.63
r573 (  77 341 ) resistor r=1.40859 //w=0.34 //l=0.085 //layer=li \
 //thickness=0.1 //x=3.425 //y=0.715 //x2=3.34 //y2=0.715
r574 (  76 341 ) resistor r=5.4201 //w=0.17 //l=0.085 //layer=li \
 //thickness=0.1 //x=3.74 //y=0.715 //x2=3.825 //y2=0.715
r575 (  76 77 ) resistor r=21.5615 //w=0.187 //l=0.315 //layer=li \
 //thickness=0.1 //x=3.74 //y=0.715 //x2=3.425 //y2=0.715
r576 (  72 341 ) resistor r=5.4201 //w=0.17 //l=0.085 //layer=li \
 //thickness=0.1 //x=3.34 //y=0.8 //x2=3.34 //y2=0.715
r577 (  72 341 ) resistor r=41.4118 //w=0.187 //l=0.605 //layer=li \
 //thickness=0.1 //x=3.34 //y=0.8 //x2=3.34 //y2=1.405
r578 (  71 341 ) resistor r=5.4201 //w=0.17 //l=0.085 //layer=li \
 //thickness=0.1 //x=3.34 //y=0.63 //x2=3.34 //y2=0.715
r579 (  70 260 ) resistor r=5.21862 //w=0.35 //l=0.175 //layer=li \
 //thickness=0.1 //x=3.34 //y=0.35 //x2=3.34 //y2=0.175
r580 (  70 71 ) resistor r=19.1658 //w=0.187 //l=0.28 //layer=li \
 //thickness=0.1 //x=3.34 //y=0.35 //x2=3.34 //y2=0.63
r581 (  69 259 ) resistor r=5.29055 //w=0.35 //l=0.17 //layer=li \
 //thickness=0.1 //x=2.88 //y=0.175 //x2=2.71 //y2=0.175
r582 (  68 260 ) resistor r=2.96458 //w=0.367 //l=0.085 //layer=li \
 //thickness=0.1 //x=3.255 //y=0.175 //x2=3.34 //y2=0.175
r583 (  68 69 ) resistor r=13.079 //w=0.367 //l=0.375 //layer=li \
 //thickness=0.1 //x=3.255 //y=0.175 //x2=2.88 //y2=0.175
r584 (  63 252 ) resistor r=2.96458 //w=0.367 //l=0.085 //layer=li \
 //thickness=0.1 //x=2.175 //y=0.175 //x2=2.09 //y2=0.175
r585 (  63 65 ) resistor r=5.75477 //w=0.367 //l=0.165 //layer=li \
 //thickness=0.1 //x=2.175 //y=0.175 //x2=2.34 //y2=0.175
r586 (  62 259 ) resistor r=5.29055 //w=0.35 //l=0.17 //layer=li \
 //thickness=0.1 //x=2.54 //y=0.175 //x2=2.71 //y2=0.175
r587 (  62 65 ) resistor r=6.97548 //w=0.367 //l=0.2 //layer=li \
 //thickness=0.1 //x=2.54 //y=0.175 //x2=2.34 //y2=0.175
r588 (  58 340 ) resistor r=5.4201 //w=0.17 //l=0.085 //layer=li \
 //thickness=0.1 //x=2.09 //y=0.8 //x2=2.09 //y2=0.715
r589 (  58 340 ) resistor r=41.4118 //w=0.187 //l=0.605 //layer=li \
 //thickness=0.1 //x=2.09 //y=0.8 //x2=2.09 //y2=1.405
r590 (  57 340 ) resistor r=5.4201 //w=0.17 //l=0.085 //layer=li \
 //thickness=0.1 //x=2.09 //y=0.63 //x2=2.09 //y2=0.715
r591 (  56 252 ) resistor r=5.21862 //w=0.35 //l=0.175 //layer=li \
 //thickness=0.1 //x=2.09 //y=0.35 //x2=2.09 //y2=0.175
r592 (  56 57 ) resistor r=19.1658 //w=0.187 //l=0.28 //layer=li \
 //thickness=0.1 //x=2.09 //y=0.35 //x2=2.09 //y2=0.63
r593 (  55 340 ) resistor r=5.4201 //w=0.17 //l=0.085 //layer=li \
 //thickness=0.1 //x=1.69 //y=0.715 //x2=1.605 //y2=0.715
r594 (  54 340 ) resistor r=1.40859 //w=0.34 //l=0.085 //layer=li \
 //thickness=0.1 //x=2.005 //y=0.715 //x2=2.09 //y2=0.715
r595 (  54 55 ) resistor r=21.5615 //w=0.187 //l=0.315 //layer=li \
 //thickness=0.1 //x=2.005 //y=0.715 //x2=1.69 //y2=0.715
r596 (  53 340 ) resistor r=1.40859 //w=0.34 //l=0.085 //layer=li \
 //thickness=0.1 //x=1.605 //y=0.63 //x2=1.605 //y2=0.715
r597 (  52 251 ) resistor r=5.21862 //w=0.35 //l=0.175 //layer=li \
 //thickness=0.1 //x=1.605 //y=0.35 //x2=1.605 //y2=0.175
r598 (  52 53 ) resistor r=19.1658 //w=0.187 //l=0.28 //layer=li \
 //thickness=0.1 //x=1.605 //y=0.35 //x2=1.605 //y2=0.63
r599 (  51 340 ) resistor r=1.40859 //w=0.34 //l=0.085 //layer=li \
 //thickness=0.1 //x=1.205 //y=0.715 //x2=1.12 //y2=0.715
r600 (  50 340 ) resistor r=5.4201 //w=0.17 //l=0.085 //layer=li \
 //thickness=0.1 //x=1.52 //y=0.715 //x2=1.605 //y2=0.715
r601 (  50 51 ) resistor r=21.5615 //w=0.187 //l=0.315 //layer=li \
 //thickness=0.1 //x=1.52 //y=0.715 //x2=1.205 //y2=0.715
r602 (  46 340 ) resistor r=5.4201 //w=0.17 //l=0.085 //layer=li \
 //thickness=0.1 //x=1.12 //y=0.8 //x2=1.12 //y2=0.715
r603 (  46 340 ) resistor r=41.4118 //w=0.187 //l=0.605 //layer=li \
 //thickness=0.1 //x=1.12 //y=0.8 //x2=1.12 //y2=1.405
r604 (  45 340 ) resistor r=5.4201 //w=0.17 //l=0.085 //layer=li \
 //thickness=0.1 //x=1.12 //y=0.63 //x2=1.12 //y2=0.715
r605 (  44 248 ) resistor r=5.21862 //w=0.35 //l=0.175 //layer=li \
 //thickness=0.1 //x=1.12 //y=0.35 //x2=1.12 //y2=0.175
r606 (  44 45 ) resistor r=19.1658 //w=0.187 //l=0.28 //layer=li \
 //thickness=0.1 //x=1.12 //y=0.35 //x2=1.12 //y2=0.63
r607 (  38 245 ) resistor r=9.3 //w=0.17 //l=0.17 //layer=mcon //count=1 \
 //x=22.32 //y=0.18 //x2=22.32 //y2=0.18
r608 (  36 328 ) resistor r=3.1 //w=0.17 //l=0.51 //layer=mcon //count=3 \
 //x=21.58 //y=0.18 //x2=21.58 //y2=0.18
r609 (  36 38 ) resistor r=0.297428 //w=0.311 //l=0.74 //layer=m1 \
 //thickness=0.36 //x=21.58 //y=0.175 //x2=22.32 //y2=0.175
r610 (  34 323 ) resistor r=3.1 //w=0.17 //l=0.51 //layer=mcon //count=3 \
 //x=20.47 //y=0.18 //x2=20.47 //y2=0.18
r611 (  34 36 ) resistor r=0.446141 //w=0.311 //l=1.11 //layer=m1 \
 //thickness=0.36 //x=20.47 //y=0.175 //x2=21.58 //y2=0.175
r612 (  32 207 ) resistor r=3.1 //w=0.17 //l=0.51 //layer=mcon //count=3 \
 //x=18.99 //y=0.18 //x2=18.99 //y2=0.18
r613 (  32 34 ) resistor r=0.594855 //w=0.311 //l=1.48 //layer=m1 \
 //thickness=0.36 //x=18.99 //y=0.175 //x2=20.47 //y2=0.175
r614 (  30 307 ) resistor r=3.1 //w=0.17 //l=0.51 //layer=mcon //count=3 \
 //x=17.88 //y=0.18 //x2=17.88 //y2=0.18
r615 (  30 32 ) resistor r=0.446141 //w=0.311 //l=1.11 //layer=m1 \
 //thickness=0.36 //x=17.88 //y=0.175 //x2=18.99 //y2=0.175
r616 (  28 303 ) resistor r=3.1 //w=0.17 //l=0.51 //layer=mcon //count=3 \
 //x=16.77 //y=0.18 //x2=16.77 //y2=0.18
r617 (  28 30 ) resistor r=0.446141 //w=0.311 //l=1.11 //layer=m1 \
 //thickness=0.36 //x=16.77 //y=0.175 //x2=17.88 //y2=0.175
r618 (  26 292 ) resistor r=3.1 //w=0.17 //l=0.51 //layer=mcon //count=3 \
 //x=15.29 //y=0.18 //x2=15.29 //y2=0.18
r619 (  26 28 ) resistor r=0.594855 //w=0.311 //l=1.48 //layer=m1 \
 //thickness=0.36 //x=15.29 //y=0.175 //x2=16.77 //y2=0.175
r620 (  24 149 ) resistor r=3.1 //w=0.17 //l=0.51 //layer=mcon //count=3 \
 //x=14.18 //y=0.18 //x2=14.18 //y2=0.18
r621 (  24 26 ) resistor r=0.446141 //w=0.311 //l=1.11 //layer=m1 \
 //thickness=0.36 //x=14.18 //y=0.175 //x2=15.29 //y2=0.175
r622 (  22 143 ) resistor r=3.1 //w=0.17 //l=0.51 //layer=mcon //count=3 \
 //x=12.7 //y=0.18 //x2=12.7 //y2=0.18
r623 (  22 24 ) resistor r=0.594855 //w=0.311 //l=1.48 //layer=m1 \
 //thickness=0.36 //x=12.7 //y=0.175 //x2=14.18 //y2=0.175
r624 (  18 131 ) resistor r=3.1 //w=0.17 //l=0.51 //layer=mcon //count=3 \
 //x=10.11 //y=0.18 //x2=10.11 //y2=0.18
r625 (  16 276 ) resistor r=3.1 //w=0.17 //l=0.51 //layer=mcon //count=3 //x=9 \
 //y=0.18 //x2=9 //y2=0.18
r626 (  16 18 ) resistor r=0.446141 //w=0.311 //l=1.11 //layer=m1 \
 //thickness=0.36 //x=9 //y=0.175 //x2=10.11 //y2=0.175
r627 (  14 105 ) resistor r=3.1 //w=0.17 //l=0.51 //layer=mcon //count=3 \
 //x=7.52 //y=0.18 //x2=7.52 //y2=0.18
r628 (  14 16 ) resistor r=0.594855 //w=0.311 //l=1.48 //layer=m1 \
 //thickness=0.36 //x=7.52 //y=0.175 //x2=9 //y2=0.175
r629 (  12 103 ) resistor r=3.1 //w=0.17 //l=0.51 //layer=mcon //count=3 \
 //x=6.41 //y=0.18 //x2=6.41 //y2=0.18
r630 (  12 14 ) resistor r=0.446141 //w=0.311 //l=1.11 //layer=m1 \
 //thickness=0.36 //x=6.41 //y=0.175 //x2=7.52 //y2=0.175
r631 (  10 95 ) resistor r=3.1 //w=0.17 //l=0.51 //layer=mcon //count=3 \
 //x=5.3 //y=0.18 //x2=5.3 //y2=0.18
r632 (  10 12 ) resistor r=0.446141 //w=0.311 //l=1.11 //layer=m1 \
 //thickness=0.36 //x=5.3 //y=0.175 //x2=6.41 //y2=0.175
r633 (  8 262 ) resistor r=3.1 //w=0.17 //l=0.51 //layer=mcon //count=3 \
 //x=3.82 //y=0.18 //x2=3.82 //y2=0.18
r634 (  8 10 ) resistor r=0.594855 //w=0.311 //l=1.48 //layer=m1 \
 //thickness=0.36 //x=3.82 //y=0.175 //x2=5.3 //y2=0.175
r635 (  6 65 ) resistor r=3.1 //w=0.17 //l=0.51 //layer=mcon //count=3 \
 //x=2.34 //y=0.18 //x2=2.34 //y2=0.18
r636 (  6 8 ) resistor r=0.594855 //w=0.311 //l=1.48 //layer=m1 \
 //thickness=0.36 //x=2.34 //y=0.175 //x2=3.82 //y2=0.175
r637 (  3 250 ) resistor r=3.1 //w=0.17 //l=0.51 //layer=mcon //count=3 \
 //x=1.23 //y=0.18 //x2=1.23 //y2=0.18
r638 (  3 6 ) resistor r=0.446141 //w=0.311 //l=1.11 //layer=m1 \
 //thickness=0.36 //x=1.23 //y=0.175 //x2=2.34 //y2=0.175
r639 (  1 287 ) resistor r=3.1 //w=0.17 //l=0.51 //layer=mcon //count=3 \
 //x=11.59 //y=0.18 //x2=11.59 //y2=0.18
r640 (  1 22 ) resistor r=0.446141 //w=0.311 //l=1.11 //layer=m1 \
 //thickness=0.36 //x=11.59 //y=0.175 //x2=12.7 //y2=0.175
r641 (  1 18 ) resistor r=0.594855 //w=0.311 //l=1.48 //layer=m1 \
 //thickness=0.36 //x=11.59 //y=0.175 //x2=10.11 //y2=0.175
ends PM_DLATCHN\%GND

subckt PM_DLATCHN\%VDD ( 1 38 50 72 82 86 96 106 114 118 126 134 140 148 158 \
 182 190 194 204 212 227 231 233 236 241 245 249 253 255 257 258 259 260 261 \
 262 263 264 265 266 267 268 269 270 271 272 )
c295 ( 272 0 ) capacitor c=0.0255389f //x=20.445 //y=5.205
c296 ( 271 0 ) capacitor c=0.025574f //x=17.115 //y=5.205
c297 ( 270 0 ) capacitor c=0.0433931f //x=15.22 //y=5.2
c298 ( 269 0 ) capacitor c=0.0422979f //x=14.35 //y=5.2
c299 ( 268 0 ) capacitor c=0.0382118f //x=12.885 //y=5.2
c300 ( 267 0 ) capacitor c=0.0240874f //x=12.005 //y=5.2
c301 ( 266 0 ) capacitor c=0.0494572f //x=11.135 //y=5.2
c302 ( 265 0 ) capacitor c=0.0432965f //x=9.67 //y=5.2
c303 ( 264 0 ) capacitor c=0.0422219f //x=8.8 //y=5.2
c304 ( 263 0 ) capacitor c=0.0381506f //x=7.335 //y=5.2
c305 ( 262 0 ) capacitor c=0.0240879f //x=6.455 //y=5.2
c306 ( 261 0 ) capacitor c=0.0494572f //x=5.585 //y=5.2
c307 ( 260 0 ) capacitor c=0.0432965f //x=4.12 //y=5.2
c308 ( 259 0 ) capacitor c=0.0421597f //x=3.25 //y=5.2
c309 ( 258 0 ) capacitor c=0.043811f //x=1.9 //y=5.2
c310 ( 257 0 ) capacitor c=0.0427418f //x=1.03 //y=5.2
c311 ( 256 0 ) capacitor c=0.00597439f //x=20.59 //y=7.585
c312 ( 255 0 ) capacitor c=0.111498f //x=19.36 //y=7.585
c313 ( 254 0 ) capacitor c=0.00597439f //x=17.26 //y=7.585
c314 ( 253 0 ) capacitor c=0.110007f //x=16.03 //y=7.585
c315 ( 252 0 ) capacitor c=0.00597439f //x=15.29 //y=7.58
c316 ( 250 0 ) capacitor c=0.00597439f //x=14.485 //y=7.585
c317 ( 249 0 ) capacitor c=0.110046f //x=13.81 //y=7.585
c318 ( 248 0 ) capacitor c=0.00597439f //x=13.03 //y=7.585
c319 ( 247 0 ) capacitor c=0.00597439f //x=12.15 //y=7.585
c320 ( 246 0 ) capacitor c=0.00597439f //x=11.27 //y=7.585
c321 ( 245 0 ) capacitor c=0.114352f //x=10.48 //y=7.585
c322 ( 244 0 ) capacitor c=0.00597439f //x=9.815 //y=7.585
c323 ( 243 0 ) capacitor c=0.00597439f //x=9 //y=7.58
c324 ( 241 0 ) capacitor c=0.108466f //x=8.26 //y=7.585
c325 ( 240 0 ) capacitor c=0.00597439f //x=7.52 //y=7.58
c326 ( 238 0 ) capacitor c=0.00597439f //x=6.6 //y=7.585
c327 ( 237 0 ) capacitor c=0.00597439f //x=5.72 //y=7.585
c328 ( 236 0 ) capacitor c=0.11435f //x=4.93 //y=7.585
c329 ( 235 0 ) capacitor c=0.00597439f //x=4.265 //y=7.585
c330 ( 234 0 ) capacitor c=0.00597439f //x=3.385 //y=7.585
c331 ( 233 0 ) capacitor c=0.108668f //x=2.71 //y=7.585
c332 ( 232 0 ) capacitor c=0.00597439f //x=2.045 //y=7.585
c333 ( 231 0 ) capacitor c=0.252113f //x=1.23 //y=7.58
c334 ( 227 0 ) capacitor c=0.306601f //x=22.32 //y=7.58
c335 ( 212 0 ) capacitor c=0.0431573f //x=20.505 //y=7.585
c336 ( 204 0 ) capacitor c=0.0754212f //x=19.19 //y=7.585
c337 ( 194 0 ) capacitor c=0.0431573f //x=17.175 //y=7.585
c338 ( 190 0 ) capacitor c=0.0183091f //x=15.86 //y=7.585
c339 ( 182 0 ) capacitor c=0.0291131f //x=15.28 //y=7.585
c340 ( 172 0 ) capacitor c=0.0217664f //x=14.4 //y=7.585
c341 ( 168 0 ) capacitor c=0.0277785f //x=13.64 //y=7.585
c342 ( 158 0 ) capacitor c=0.028702f //x=12.945 //y=7.585
c343 ( 148 0 ) capacitor c=0.0291291f //x=12.065 //y=7.585
c344 ( 140 0 ) capacitor c=0.024303f //x=11.185 //y=7.585
c345 ( 134 0 ) capacitor c=0.0183091f //x=10.31 //y=7.585
c346 ( 126 0 ) capacitor c=0.0292288f //x=9.73 //y=7.585
c347 ( 118 0 ) capacitor c=0.0187886f //x=8.85 //y=7.585
c348 ( 114 0 ) capacitor c=0.0238235f //x=8.09 //y=7.585
c349 ( 106 0 ) capacitor c=0.0291288f //x=7.395 //y=7.585
c350 ( 96 0 ) capacitor c=0.0291291f //x=6.515 //y=7.585
c351 ( 86 0 ) capacitor c=0.024303f //x=5.635 //y=7.585
c352 ( 82 0 ) capacitor c=0.0183091f //x=4.76 //y=7.585
c353 ( 72 0 ) capacitor c=0.0293728f //x=4.18 //y=7.585
c354 ( 64 0 ) capacitor c=0.0217664f //x=3.3 //y=7.585
c355 ( 58 0 ) capacitor c=0.0211939f //x=2.54 //y=7.585
c356 ( 50 0 ) capacitor c=0.0289916f //x=1.96 //y=7.585
c357 ( 38 0 ) capacitor c=0.804965f //x=22.32 //y=7.58
r358 (  225 227 ) resistor r=25.8093 //w=0.367 //l=0.74 //layer=li \
 //thickness=0.1 //x=21.58 //y=7.585 //x2=22.32 //y2=7.585
r359 (  223 256 ) resistor r=2.87058 //w=0.35 //l=0.085 //layer=li \
 //thickness=0.1 //x=20.675 //y=7.585 //x2=20.59 //y2=7.585
r360 (  223 225 ) resistor r=31.564 //w=0.367 //l=0.905 //layer=li \
 //thickness=0.1 //x=20.675 //y=7.585 //x2=21.58 //y2=7.585
r361 (  216 256 ) resistor r=4.23183 //w=0.7 //l=0.175 //layer=li \
 //thickness=0.1 //x=20.59 //y=7.41 //x2=20.59 //y2=7.585
r362 (  216 272 ) resistor r=33.5401 //w=0.187 //l=0.49 //layer=li \
 //thickness=0.1 //x=20.59 //y=7.41 //x2=20.59 //y2=6.92
r363 (  213 255 ) resistor r=5.29055 //w=0.35 //l=0.17 //layer=li \
 //thickness=0.1 //x=19.53 //y=7.585 //x2=19.36 //y2=7.585
r364 (  213 215 ) resistor r=32.7847 //w=0.367 //l=0.94 //layer=li \
 //thickness=0.1 //x=19.53 //y=7.585 //x2=20.47 //y2=7.585
r365 (  212 256 ) resistor r=2.87058 //w=0.35 //l=0.085 //layer=li \
 //thickness=0.1 //x=20.505 //y=7.585 //x2=20.59 //y2=7.585
r366 (  212 215 ) resistor r=1.22071 //w=0.367 //l=0.035 //layer=li \
 //thickness=0.1 //x=20.505 //y=7.585 //x2=20.47 //y2=7.585
r367 (  207 209 ) resistor r=38.7139 //w=0.367 //l=1.11 //layer=li \
 //thickness=0.1 //x=17.88 //y=7.585 //x2=18.99 //y2=7.585
r368 (  205 254 ) resistor r=2.87058 //w=0.35 //l=0.085 //layer=li \
 //thickness=0.1 //x=17.345 //y=7.585 //x2=17.26 //y2=7.585
r369 (  205 207 ) resistor r=18.6594 //w=0.367 //l=0.535 //layer=li \
 //thickness=0.1 //x=17.345 //y=7.585 //x2=17.88 //y2=7.585
r370 (  204 255 ) resistor r=5.29055 //w=0.35 //l=0.17 //layer=li \
 //thickness=0.1 //x=19.19 //y=7.585 //x2=19.36 //y2=7.585
r371 (  204 209 ) resistor r=6.97548 //w=0.367 //l=0.2 //layer=li \
 //thickness=0.1 //x=19.19 //y=7.585 //x2=18.99 //y2=7.585
r372 (  198 254 ) resistor r=4.23183 //w=0.7 //l=0.175 //layer=li \
 //thickness=0.1 //x=17.26 //y=7.41 //x2=17.26 //y2=7.585
r373 (  198 271 ) resistor r=33.5401 //w=0.187 //l=0.49 //layer=li \
 //thickness=0.1 //x=17.26 //y=7.41 //x2=17.26 //y2=6.92
r374 (  195 253 ) resistor r=5.29055 //w=0.35 //l=0.17 //layer=li \
 //thickness=0.1 //x=16.2 //y=7.585 //x2=16.03 //y2=7.585
r375 (  195 197 ) resistor r=19.8801 //w=0.367 //l=0.57 //layer=li \
 //thickness=0.1 //x=16.2 //y=7.585 //x2=16.77 //y2=7.585
r376 (  194 254 ) resistor r=2.87058 //w=0.35 //l=0.085 //layer=li \
 //thickness=0.1 //x=17.175 //y=7.585 //x2=17.26 //y2=7.585
r377 (  194 197 ) resistor r=14.1253 //w=0.367 //l=0.405 //layer=li \
 //thickness=0.1 //x=17.175 //y=7.585 //x2=16.77 //y2=7.585
r378 (  191 252 ) resistor r=2.87058 //w=0.35 //l=0.085 //layer=li \
 //thickness=0.1 //x=15.45 //y=7.585 //x2=15.365 //y2=7.585
r379 (  190 253 ) resistor r=5.29055 //w=0.35 //l=0.17 //layer=li \
 //thickness=0.1 //x=15.86 //y=7.585 //x2=16.03 //y2=7.585
r380 (  190 191 ) resistor r=14.2997 //w=0.367 //l=0.41 //layer=li \
 //thickness=0.1 //x=15.86 //y=7.585 //x2=15.45 //y2=7.585
r381 (  184 252 ) resistor r=4.23183 //w=0.7 //l=0.175 //layer=li \
 //thickness=0.1 //x=15.365 //y=7.41 //x2=15.365 //y2=7.585
r382 (  184 270 ) resistor r=56.4706 //w=0.187 //l=0.825 //layer=li \
 //thickness=0.1 //x=15.365 //y=7.41 //x2=15.365 //y2=6.585
r383 (  183 250 ) resistor r=2.87058 //w=0.35 //l=0.085 //layer=li \
 //thickness=0.1 //x=14.57 //y=7.585 //x2=14.485 //y2=7.585
r384 (  182 252 ) resistor r=2.87058 //w=0.35 //l=0.085 //layer=li \
 //thickness=0.1 //x=15.28 //y=7.585 //x2=15.365 //y2=7.585
r385 (  182 183 ) resistor r=24.7629 //w=0.367 //l=0.71 //layer=li \
 //thickness=0.1 //x=15.28 //y=7.585 //x2=14.57 //y2=7.585
r386 (  176 250 ) resistor r=4.23183 //w=0.7 //l=0.175 //layer=li \
 //thickness=0.1 //x=14.485 //y=7.41 //x2=14.485 //y2=7.585
r387 (  176 269 ) resistor r=56.4706 //w=0.187 //l=0.825 //layer=li \
 //thickness=0.1 //x=14.485 //y=7.41 //x2=14.485 //y2=6.585
r388 (  173 249 ) resistor r=5.29055 //w=0.35 //l=0.17 //layer=li \
 //thickness=0.1 //x=13.98 //y=7.585 //x2=13.81 //y2=7.585
r389 (  173 175 ) resistor r=6.97548 //w=0.367 //l=0.2 //layer=li \
 //thickness=0.1 //x=13.98 //y=7.585 //x2=14.18 //y2=7.585
r390 (  172 250 ) resistor r=2.87058 //w=0.35 //l=0.085 //layer=li \
 //thickness=0.1 //x=14.4 //y=7.585 //x2=14.485 //y2=7.585
r391 (  172 175 ) resistor r=7.67302 //w=0.367 //l=0.22 //layer=li \
 //thickness=0.1 //x=14.4 //y=7.585 //x2=14.18 //y2=7.585
r392 (  169 248 ) resistor r=2.87058 //w=0.35 //l=0.085 //layer=li \
 //thickness=0.1 //x=13.115 //y=7.585 //x2=13.03 //y2=7.585
r393 (  168 249 ) resistor r=5.29055 //w=0.35 //l=0.17 //layer=li \
 //thickness=0.1 //x=13.64 //y=7.585 //x2=13.81 //y2=7.585
r394 (  168 169 ) resistor r=18.3106 //w=0.367 //l=0.525 //layer=li \
 //thickness=0.1 //x=13.64 //y=7.585 //x2=13.115 //y2=7.585
r395 (  162 248 ) resistor r=4.23183 //w=0.7 //l=0.175 //layer=li \
 //thickness=0.1 //x=13.03 //y=7.41 //x2=13.03 //y2=7.585
r396 (  162 268 ) resistor r=33.1979 //w=0.187 //l=0.485 //layer=li \
 //thickness=0.1 //x=13.03 //y=7.41 //x2=13.03 //y2=6.925
r397 (  159 247 ) resistor r=2.87058 //w=0.35 //l=0.085 //layer=li \
 //thickness=0.1 //x=12.235 //y=7.585 //x2=12.15 //y2=7.585
r398 (  159 161 ) resistor r=16.218 //w=0.367 //l=0.465 //layer=li \
 //thickness=0.1 //x=12.235 //y=7.585 //x2=12.7 //y2=7.585
r399 (  158 248 ) resistor r=2.87058 //w=0.35 //l=0.085 //layer=li \
 //thickness=0.1 //x=12.945 //y=7.585 //x2=13.03 //y2=7.585
r400 (  158 161 ) resistor r=8.54496 //w=0.367 //l=0.245 //layer=li \
 //thickness=0.1 //x=12.945 //y=7.585 //x2=12.7 //y2=7.585
r401 (  152 247 ) resistor r=4.23183 //w=0.7 //l=0.175 //layer=li \
 //thickness=0.1 //x=12.15 //y=7.41 //x2=12.15 //y2=7.585
r402 (  152 267 ) resistor r=33.1979 //w=0.187 //l=0.485 //layer=li \
 //thickness=0.1 //x=12.15 //y=7.41 //x2=12.15 //y2=6.925
r403 (  149 246 ) resistor r=2.87058 //w=0.35 //l=0.085 //layer=li \
 //thickness=0.1 //x=11.355 //y=7.585 //x2=11.27 //y2=7.585
r404 (  149 151 ) resistor r=8.19619 //w=0.367 //l=0.235 //layer=li \
 //thickness=0.1 //x=11.355 //y=7.585 //x2=11.59 //y2=7.585
r405 (  148 247 ) resistor r=2.87058 //w=0.35 //l=0.085 //layer=li \
 //thickness=0.1 //x=12.065 //y=7.585 //x2=12.15 //y2=7.585
r406 (  148 151 ) resistor r=16.5668 //w=0.367 //l=0.475 //layer=li \
 //thickness=0.1 //x=12.065 //y=7.585 //x2=11.59 //y2=7.585
r407 (  142 246 ) resistor r=4.23183 //w=0.7 //l=0.175 //layer=li \
 //thickness=0.1 //x=11.27 //y=7.41 //x2=11.27 //y2=7.585
r408 (  142 266 ) resistor r=56.4706 //w=0.187 //l=0.825 //layer=li \
 //thickness=0.1 //x=11.27 //y=7.41 //x2=11.27 //y2=6.585
r409 (  141 245 ) resistor r=5.29055 //w=0.35 //l=0.17 //layer=li \
 //thickness=0.1 //x=10.65 //y=7.585 //x2=10.48 //y2=7.585
r410 (  140 246 ) resistor r=2.87058 //w=0.35 //l=0.085 //layer=li \
 //thickness=0.1 //x=11.185 //y=7.585 //x2=11.27 //y2=7.585
r411 (  140 141 ) resistor r=18.6594 //w=0.367 //l=0.535 //layer=li \
 //thickness=0.1 //x=11.185 //y=7.585 //x2=10.65 //y2=7.585
r412 (  135 244 ) resistor r=2.87058 //w=0.35 //l=0.085 //layer=li \
 //thickness=0.1 //x=9.9 //y=7.585 //x2=9.815 //y2=7.585
r413 (  135 137 ) resistor r=7.32425 //w=0.367 //l=0.21 //layer=li \
 //thickness=0.1 //x=9.9 //y=7.585 //x2=10.11 //y2=7.585
r414 (  134 245 ) resistor r=5.29055 //w=0.35 //l=0.17 //layer=li \
 //thickness=0.1 //x=10.31 //y=7.585 //x2=10.48 //y2=7.585
r415 (  134 137 ) resistor r=6.97548 //w=0.367 //l=0.2 //layer=li \
 //thickness=0.1 //x=10.31 //y=7.585 //x2=10.11 //y2=7.585
r416 (  128 244 ) resistor r=4.23183 //w=0.7 //l=0.175 //layer=li \
 //thickness=0.1 //x=9.815 //y=7.41 //x2=9.815 //y2=7.585
r417 (  128 265 ) resistor r=56.4706 //w=0.187 //l=0.825 //layer=li \
 //thickness=0.1 //x=9.815 //y=7.41 //x2=9.815 //y2=6.585
r418 (  127 243 ) resistor r=2.87058 //w=0.35 //l=0.085 //layer=li \
 //thickness=0.1 //x=9.02 //y=7.585 //x2=8.935 //y2=7.585
r419 (  126 244 ) resistor r=2.87058 //w=0.35 //l=0.085 //layer=li \
 //thickness=0.1 //x=9.73 //y=7.585 //x2=9.815 //y2=7.585
r420 (  126 127 ) resistor r=24.7629 //w=0.367 //l=0.71 //layer=li \
 //thickness=0.1 //x=9.73 //y=7.585 //x2=9.02 //y2=7.585
r421 (  120 243 ) resistor r=4.23183 //w=0.7 //l=0.175 //layer=li \
 //thickness=0.1 //x=8.935 //y=7.41 //x2=8.935 //y2=7.585
r422 (  120 264 ) resistor r=56.4706 //w=0.187 //l=0.825 //layer=li \
 //thickness=0.1 //x=8.935 //y=7.41 //x2=8.935 //y2=6.585
r423 (  119 241 ) resistor r=5.29055 //w=0.35 //l=0.17 //layer=li \
 //thickness=0.1 //x=8.43 //y=7.585 //x2=8.26 //y2=7.585
r424 (  118 243 ) resistor r=2.87058 //w=0.35 //l=0.085 //layer=li \
 //thickness=0.1 //x=8.85 //y=7.585 //x2=8.935 //y2=7.585
r425 (  118 119 ) resistor r=14.6485 //w=0.367 //l=0.42 //layer=li \
 //thickness=0.1 //x=8.85 //y=7.585 //x2=8.43 //y2=7.585
r426 (  115 240 ) resistor r=2.87058 //w=0.35 //l=0.085 //layer=li \
 //thickness=0.1 //x=7.565 //y=7.585 //x2=7.48 //y2=7.585
r427 (  114 241 ) resistor r=5.29055 //w=0.35 //l=0.17 //layer=li \
 //thickness=0.1 //x=8.09 //y=7.585 //x2=8.26 //y2=7.585
r428 (  114 115 ) resistor r=18.3106 //w=0.367 //l=0.525 //layer=li \
 //thickness=0.1 //x=8.09 //y=7.585 //x2=7.565 //y2=7.585
r429 (  108 240 ) resistor r=4.23183 //w=0.7 //l=0.175 //layer=li \
 //thickness=0.1 //x=7.48 //y=7.41 //x2=7.48 //y2=7.585
r430 (  108 263 ) resistor r=33.1979 //w=0.187 //l=0.485 //layer=li \
 //thickness=0.1 //x=7.48 //y=7.41 //x2=7.48 //y2=6.925
r431 (  107 238 ) resistor r=2.87058 //w=0.35 //l=0.085 //layer=li \
 //thickness=0.1 //x=6.685 //y=7.585 //x2=6.6 //y2=7.585
r432 (  106 240 ) resistor r=2.87058 //w=0.35 //l=0.085 //layer=li \
 //thickness=0.1 //x=7.395 //y=7.585 //x2=7.48 //y2=7.585
r433 (  106 107 ) resistor r=24.7629 //w=0.367 //l=0.71 //layer=li \
 //thickness=0.1 //x=7.395 //y=7.585 //x2=6.685 //y2=7.585
r434 (  100 238 ) resistor r=4.23183 //w=0.7 //l=0.175 //layer=li \
 //thickness=0.1 //x=6.6 //y=7.41 //x2=6.6 //y2=7.585
r435 (  100 262 ) resistor r=33.1979 //w=0.187 //l=0.485 //layer=li \
 //thickness=0.1 //x=6.6 //y=7.41 //x2=6.6 //y2=6.925
r436 (  97 237 ) resistor r=2.87058 //w=0.35 //l=0.085 //layer=li \
 //thickness=0.1 //x=5.805 //y=7.585 //x2=5.72 //y2=7.585
r437 (  97 99 ) resistor r=21.1008 //w=0.367 //l=0.605 //layer=li \
 //thickness=0.1 //x=5.805 //y=7.585 //x2=6.41 //y2=7.585
r438 (  96 238 ) resistor r=2.87058 //w=0.35 //l=0.085 //layer=li \
 //thickness=0.1 //x=6.515 //y=7.585 //x2=6.6 //y2=7.585
r439 (  96 99 ) resistor r=3.66213 //w=0.367 //l=0.105 //layer=li \
 //thickness=0.1 //x=6.515 //y=7.585 //x2=6.41 //y2=7.585
r440 (  90 237 ) resistor r=4.23183 //w=0.7 //l=0.175 //layer=li \
 //thickness=0.1 //x=5.72 //y=7.41 //x2=5.72 //y2=7.585
r441 (  90 261 ) resistor r=56.4706 //w=0.187 //l=0.825 //layer=li \
 //thickness=0.1 //x=5.72 //y=7.41 //x2=5.72 //y2=6.585
r442 (  87 236 ) resistor r=5.29055 //w=0.35 //l=0.17 //layer=li \
 //thickness=0.1 //x=5.1 //y=7.585 //x2=4.93 //y2=7.585
r443 (  87 89 ) resistor r=6.97548 //w=0.367 //l=0.2 //layer=li \
 //thickness=0.1 //x=5.1 //y=7.585 //x2=5.3 //y2=7.585
r444 (  86 237 ) resistor r=2.87058 //w=0.35 //l=0.085 //layer=li \
 //thickness=0.1 //x=5.635 //y=7.585 //x2=5.72 //y2=7.585
r445 (  86 89 ) resistor r=11.6839 //w=0.367 //l=0.335 //layer=li \
 //thickness=0.1 //x=5.635 //y=7.585 //x2=5.3 //y2=7.585
r446 (  83 235 ) resistor r=2.87058 //w=0.35 //l=0.085 //layer=li \
 //thickness=0.1 //x=4.35 //y=7.585 //x2=4.265 //y2=7.585
r447 (  82 236 ) resistor r=5.29055 //w=0.35 //l=0.17 //layer=li \
 //thickness=0.1 //x=4.76 //y=7.585 //x2=4.93 //y2=7.585
r448 (  82 83 ) resistor r=14.2997 //w=0.367 //l=0.41 //layer=li \
 //thickness=0.1 //x=4.76 //y=7.585 //x2=4.35 //y2=7.585
r449 (  76 235 ) resistor r=4.23183 //w=0.7 //l=0.175 //layer=li \
 //thickness=0.1 //x=4.265 //y=7.41 //x2=4.265 //y2=7.585
r450 (  76 260 ) resistor r=56.4706 //w=0.187 //l=0.825 //layer=li \
 //thickness=0.1 //x=4.265 //y=7.41 //x2=4.265 //y2=6.585
r451 (  73 234 ) resistor r=2.87058 //w=0.35 //l=0.085 //layer=li \
 //thickness=0.1 //x=3.47 //y=7.585 //x2=3.385 //y2=7.585
r452 (  73 75 ) resistor r=12.2071 //w=0.367 //l=0.35 //layer=li \
 //thickness=0.1 //x=3.47 //y=7.585 //x2=3.82 //y2=7.585
r453 (  72 235 ) resistor r=2.87058 //w=0.35 //l=0.085 //layer=li \
 //thickness=0.1 //x=4.18 //y=7.585 //x2=4.265 //y2=7.585
r454 (  72 75 ) resistor r=12.5559 //w=0.367 //l=0.36 //layer=li \
 //thickness=0.1 //x=4.18 //y=7.585 //x2=3.82 //y2=7.585
r455 (  66 234 ) resistor r=4.23183 //w=0.7 //l=0.175 //layer=li \
 //thickness=0.1 //x=3.385 //y=7.41 //x2=3.385 //y2=7.585
r456 (  66 259 ) resistor r=56.4706 //w=0.187 //l=0.825 //layer=li \
 //thickness=0.1 //x=3.385 //y=7.41 //x2=3.385 //y2=6.585
r457 (  65 233 ) resistor r=5.29055 //w=0.35 //l=0.17 //layer=li \
 //thickness=0.1 //x=2.88 //y=7.585 //x2=2.71 //y2=7.585
r458 (  64 234 ) resistor r=2.87058 //w=0.35 //l=0.085 //layer=li \
 //thickness=0.1 //x=3.3 //y=7.585 //x2=3.385 //y2=7.585
r459 (  64 65 ) resistor r=14.6485 //w=0.367 //l=0.42 //layer=li \
 //thickness=0.1 //x=3.3 //y=7.585 //x2=2.88 //y2=7.585
r460 (  59 232 ) resistor r=2.87058 //w=0.35 //l=0.085 //layer=li \
 //thickness=0.1 //x=2.13 //y=7.585 //x2=2.045 //y2=7.585
r461 (  59 61 ) resistor r=7.32425 //w=0.367 //l=0.21 //layer=li \
 //thickness=0.1 //x=2.13 //y=7.585 //x2=2.34 //y2=7.585
r462 (  58 233 ) resistor r=5.29055 //w=0.35 //l=0.17 //layer=li \
 //thickness=0.1 //x=2.54 //y=7.585 //x2=2.71 //y2=7.585
r463 (  58 61 ) resistor r=6.97548 //w=0.367 //l=0.2 //layer=li \
 //thickness=0.1 //x=2.54 //y=7.585 //x2=2.34 //y2=7.585
r464 (  52 232 ) resistor r=4.23183 //w=0.7 //l=0.175 //layer=li \
 //thickness=0.1 //x=2.045 //y=7.41 //x2=2.045 //y2=7.585
r465 (  52 258 ) resistor r=56.4706 //w=0.187 //l=0.825 //layer=li \
 //thickness=0.1 //x=2.045 //y=7.41 //x2=2.045 //y2=6.585
r466 (  51 231 ) resistor r=2.87058 //w=0.35 //l=0.085 //layer=li \
 //thickness=0.1 //x=1.25 //y=7.585 //x2=1.165 //y2=7.585
r467 (  50 232 ) resistor r=2.87058 //w=0.35 //l=0.085 //layer=li \
 //thickness=0.1 //x=1.96 //y=7.585 //x2=2.045 //y2=7.585
r468 (  50 51 ) resistor r=24.7629 //w=0.367 //l=0.71 //layer=li \
 //thickness=0.1 //x=1.96 //y=7.585 //x2=1.25 //y2=7.585
r469 (  44 231 ) resistor r=4.23183 //w=0.7 //l=0.175 //layer=li \
 //thickness=0.1 //x=1.165 //y=7.41 //x2=1.165 //y2=7.585
r470 (  44 257 ) resistor r=56.4706 //w=0.187 //l=0.825 //layer=li \
 //thickness=0.1 //x=1.165 //y=7.41 //x2=1.165 //y2=6.585
r471 (  38 227 ) resistor r=9.3 //w=0.17 //l=0.17 //layer=mcon //count=1 \
 //x=22.32 //y=7.58 //x2=22.32 //y2=7.58
r472 (  36 225 ) resistor r=3.1 //w=0.17 //l=0.51 //layer=mcon //count=3 \
 //x=21.58 //y=7.58 //x2=21.58 //y2=7.58
r473 (  36 38 ) resistor r=0.297428 //w=0.311 //l=0.74 //layer=m1 \
 //thickness=0.36 //x=21.58 //y=7.585 //x2=22.32 //y2=7.585
r474 (  34 215 ) resistor r=3.1 //w=0.17 //l=0.51 //layer=mcon //count=3 \
 //x=20.47 //y=7.58 //x2=20.47 //y2=7.58
r475 (  34 36 ) resistor r=0.446141 //w=0.311 //l=1.11 //layer=m1 \
 //thickness=0.36 //x=20.47 //y=7.585 //x2=21.58 //y2=7.585
r476 (  32 209 ) resistor r=3.1 //w=0.17 //l=0.51 //layer=mcon //count=3 \
 //x=18.99 //y=7.58 //x2=18.99 //y2=7.58
r477 (  32 34 ) resistor r=0.594855 //w=0.311 //l=1.48 //layer=m1 \
 //thickness=0.36 //x=18.99 //y=7.585 //x2=20.47 //y2=7.585
r478 (  30 207 ) resistor r=3.1 //w=0.17 //l=0.51 //layer=mcon //count=3 \
 //x=17.88 //y=7.58 //x2=17.88 //y2=7.58
r479 (  30 32 ) resistor r=0.446141 //w=0.311 //l=1.11 //layer=m1 \
 //thickness=0.36 //x=17.88 //y=7.585 //x2=18.99 //y2=7.585
r480 (  28 197 ) resistor r=3.1 //w=0.17 //l=0.51 //layer=mcon //count=3 \
 //x=16.77 //y=7.58 //x2=16.77 //y2=7.58
r481 (  28 30 ) resistor r=0.446141 //w=0.311 //l=1.11 //layer=m1 \
 //thickness=0.36 //x=16.77 //y=7.585 //x2=17.88 //y2=7.585
r482 (  26 252 ) resistor r=3.1 //w=0.17 //l=0.51 //layer=mcon //count=3 \
 //x=15.29 //y=7.58 //x2=15.29 //y2=7.58
r483 (  26 28 ) resistor r=0.594855 //w=0.311 //l=1.48 //layer=m1 \
 //thickness=0.36 //x=15.29 //y=7.585 //x2=16.77 //y2=7.585
r484 (  24 175 ) resistor r=3.1 //w=0.17 //l=0.51 //layer=mcon //count=3 \
 //x=14.18 //y=7.58 //x2=14.18 //y2=7.58
r485 (  24 26 ) resistor r=0.446141 //w=0.311 //l=1.11 //layer=m1 \
 //thickness=0.36 //x=14.18 //y=7.585 //x2=15.29 //y2=7.585
r486 (  22 161 ) resistor r=3.1 //w=0.17 //l=0.51 //layer=mcon //count=3 \
 //x=12.7 //y=7.58 //x2=12.7 //y2=7.58
r487 (  22 24 ) resistor r=0.594855 //w=0.311 //l=1.48 //layer=m1 \
 //thickness=0.36 //x=12.7 //y=7.585 //x2=14.18 //y2=7.585
r488 (  18 137 ) resistor r=3.1 //w=0.17 //l=0.51 //layer=mcon //count=3 \
 //x=10.11 //y=7.58 //x2=10.11 //y2=7.58
r489 (  16 243 ) resistor r=3.1 //w=0.17 //l=0.51 //layer=mcon //count=3 //x=9 \
 //y=7.58 //x2=9 //y2=7.58
r490 (  16 18 ) resistor r=0.446141 //w=0.311 //l=1.11 //layer=m1 \
 //thickness=0.36 //x=9 //y=7.585 //x2=10.11 //y2=7.585
r491 (  14 240 ) resistor r=3.1 //w=0.17 //l=0.51 //layer=mcon //count=3 \
 //x=7.52 //y=7.58 //x2=7.52 //y2=7.58
r492 (  14 16 ) resistor r=0.594855 //w=0.311 //l=1.48 //layer=m1 \
 //thickness=0.36 //x=7.52 //y=7.585 //x2=9 //y2=7.585
r493 (  12 99 ) resistor r=3.1 //w=0.17 //l=0.51 //layer=mcon //count=3 \
 //x=6.41 //y=7.58 //x2=6.41 //y2=7.58
r494 (  12 14 ) resistor r=0.446141 //w=0.311 //l=1.11 //layer=m1 \
 //thickness=0.36 //x=6.41 //y=7.585 //x2=7.52 //y2=7.585
r495 (  10 89 ) resistor r=3.1 //w=0.17 //l=0.51 //layer=mcon //count=3 \
 //x=5.3 //y=7.58 //x2=5.3 //y2=7.58
r496 (  10 12 ) resistor r=0.446141 //w=0.311 //l=1.11 //layer=m1 \
 //thickness=0.36 //x=5.3 //y=7.585 //x2=6.41 //y2=7.585
r497 (  8 75 ) resistor r=3.1 //w=0.17 //l=0.51 //layer=mcon //count=3 \
 //x=3.82 //y=7.58 //x2=3.82 //y2=7.58
r498 (  8 10 ) resistor r=0.594855 //w=0.311 //l=1.48 //layer=m1 \
 //thickness=0.36 //x=3.82 //y=7.585 //x2=5.3 //y2=7.585
r499 (  6 61 ) resistor r=3.1 //w=0.17 //l=0.51 //layer=mcon //count=3 \
 //x=2.34 //y=7.58 //x2=2.34 //y2=7.58
r500 (  6 8 ) resistor r=0.594855 //w=0.311 //l=1.48 //layer=m1 \
 //thickness=0.36 //x=2.34 //y=7.585 //x2=3.82 //y2=7.585
r501 (  3 231 ) resistor r=3.1 //w=0.17 //l=0.51 //layer=mcon //count=3 \
 //x=1.23 //y=7.58 //x2=1.23 //y2=7.58
r502 (  3 6 ) resistor r=0.446141 //w=0.311 //l=1.11 //layer=m1 \
 //thickness=0.36 //x=1.23 //y=7.585 //x2=2.34 //y2=7.585
r503 (  1 151 ) resistor r=3.1 //w=0.17 //l=0.51 //layer=mcon //count=3 \
 //x=11.59 //y=7.58 //x2=11.59 //y2=7.58
r504 (  1 22 ) resistor r=0.446141 //w=0.311 //l=1.11 //layer=m1 \
 //thickness=0.36 //x=11.59 //y=7.585 //x2=12.7 //y2=7.585
r505 (  1 18 ) resistor r=0.594855 //w=0.311 //l=1.48 //layer=m1 \
 //thickness=0.36 //x=11.59 //y=7.585 //x2=10.11 //y2=7.585
ends PM_DLATCHN\%VDD

subckt PM_DLATCHN\%noxref_3 ( 1 2 17 18 19 20 24 26 33 34 35 36 37 38 39 43 45 \
 48 49 59 62 64 )
c117 ( 64 0 ) capacitor c=0.0288745f //x=3.68 //y=5.2
c118 ( 62 0 ) capacitor c=0.0173218f //x=3.635 //y=1.09
c119 ( 59 0 ) capacitor c=0.0593152f //x=6.04 //y=4.88
c120 ( 49 0 ) capacitor c=0.0318948f //x=6.375 //y=1.39
c121 ( 48 0 ) capacitor c=0.0187384f //x=6.375 //y=1.045
c122 ( 45 0 ) capacitor c=0.0141798f //x=6.22 //y=1.545
c123 ( 43 0 ) capacitor c=0.0149844f //x=6.22 //y=0.89
c124 ( 39 0 ) capacitor c=0.0819799f //x=5.845 //y=2.095
c125 ( 38 0 ) capacitor c=0.0229722f //x=5.845 //y=1.7
c126 ( 37 0 ) capacitor c=0.0234352f //x=5.845 //y=1.39
c127 ( 36 0 ) capacitor c=0.0199343f //x=5.845 //y=1.045
c128 ( 35 0 ) capacitor c=0.110275f //x=6.38 //y=6.2
c129 ( 34 0 ) capacitor c=0.154305f //x=5.94 //y=6.2
c130 ( 26 0 ) capacitor c=0.0930091f //x=6.04 //y=2.26
c131 ( 24 0 ) capacitor c=0.083023f //x=4.19 //y=3.88
c132 ( 20 0 ) capacitor c=0.00417404f //x=3.91 //y=4.76
c133 ( 19 0 ) capacitor c=0.0118896f //x=4.105 //y=4.76
c134 ( 18 0 ) capacitor c=0.00549299f //x=3.905 //y=2.26
c135 ( 17 0 ) capacitor c=0.013178f //x=4.105 //y=2.26
c136 ( 2 0 ) capacitor c=0.0123469f //x=4.305 //y=3.88
c137 ( 1 0 ) capacitor c=0.0440072f //x=5.925 //y=3.88
r138 (  57 59 ) resistor r=20.6867 //w=0.233 //l=0.1 //layer=ply \
 //thickness=0.18 //x=5.94 //y=4.88 //x2=6.04 //y2=4.88
r139 (  50 59 ) resistor r=70.3348 //w=0.233 //l=0.414367 //layer=ply \
 //thickness=0.18 //x=6.38 //y=5.045 //x2=6.04 //y2=4.88
r140 (  49 61 ) resistor r=45.1352 //w=0.168 //l=0.173853 //layer=ply \
 //thickness=0.18 //x=6.375 //y=1.39 //x2=6.335 //y2=1.545
r141 (  48 60 ) resistor r=45.1352 //w=0.168 //l=0.173853 //layer=ply \
 //thickness=0.18 //x=6.375 //y=1.045 //x2=6.335 //y2=0.89
r142 (  48 49 ) resistor r=176.904 //w=0.094 //l=0.345 //layer=ply \
 //thickness=0.18 //x=6.375 //y=1.045 //x2=6.375 //y2=1.39
r143 (  46 56 ) resistor r=10.701 //w=0.21 //l=0.115 //layer=ply \
 //thickness=0.18 //x=6 //y=1.545 //x2=5.885 //y2=1.545
r144 (  45 61 ) resistor r=5.52526 //w=0.168 //l=0.115 //layer=ply \
 //thickness=0.18 //x=6.22 //y=1.545 //x2=6.335 //y2=1.545
r145 (  44 55 ) resistor r=5.52526 //w=0.168 //l=0.115 //layer=ply \
 //thickness=0.18 //x=6 //y=0.89 //x2=5.885 //y2=0.89
r146 (  43 60 ) resistor r=5.52526 //w=0.168 //l=0.115 //layer=ply \
 //thickness=0.18 //x=6.22 //y=0.89 //x2=6.335 //y2=0.89
r147 (  43 44 ) resistor r=112.809 //w=0.094 //l=0.22 //layer=ply \
 //thickness=0.18 //x=6.22 //y=0.89 //x2=6 //y2=0.89
r148 (  40 57 ) resistor r=13.0941 //w=0.233 //l=0.165 //layer=ply \
 //thickness=0.18 //x=5.94 //y=5.045 //x2=5.94 //y2=4.88
r149 (  39 54 ) resistor r=34.8111 //w=0.27 //l=0.264953 //layer=ply \
 //thickness=0.18 //x=5.845 //y=2.095 //x2=6.04 //y2=2.26
r150 (  38 56 ) resistor r=39.5823 //w=0.21 //l=0.173853 //layer=ply \
 //thickness=0.18 //x=5.845 //y=1.7 //x2=5.885 //y2=1.545
r151 (  38 39 ) resistor r=202.543 //w=0.094 //l=0.395 //layer=ply \
 //thickness=0.18 //x=5.845 //y=1.7 //x2=5.845 //y2=2.095
r152 (  37 56 ) resistor r=39.5823 //w=0.21 //l=0.173853 //layer=ply \
 //thickness=0.18 //x=5.845 //y=1.39 //x2=5.885 //y2=1.545
r153 (  36 55 ) resistor r=45.1352 //w=0.168 //l=0.173853 //layer=ply \
 //thickness=0.18 //x=5.845 //y=1.045 //x2=5.885 //y2=0.89
r154 (  36 37 ) resistor r=176.904 //w=0.094 //l=0.345 //layer=ply \
 //thickness=0.18 //x=5.845 //y=1.045 //x2=5.845 //y2=1.39
r155 (  35 50 ) resistor r=592.245 //w=0.094 //l=1.155 //layer=ply \
 //thickness=0.18 //x=6.38 //y=6.2 //x2=6.38 //y2=5.045
r156 (  34 40 ) resistor r=592.245 //w=0.094 //l=1.155 //layer=ply \
 //thickness=0.18 //x=5.94 //y=6.2 //x2=5.94 //y2=5.045
r157 (  33 45 ) resistor r=56.4043 //w=0.094 //l=0.11 //layer=ply \
 //thickness=0.18 //x=6.11 //y=1.545 //x2=6.22 //y2=1.545
r158 (  33 46 ) resistor r=56.4043 //w=0.094 //l=0.11 //layer=ply \
 //thickness=0.18 //x=6.11 //y=1.545 //x2=6 //y2=1.545
r159 (  31 59 ) resistor r=152 //w=0.17 //l=0.17 //layer=licon //count=1 \
 //x=6.04 //y=4.88 //x2=6.04 //y2=4.88
r160 (  29 31 ) resistor r=68.4492 //w=0.187 //l=1 //layer=li //thickness=0.1 \
 //x=6.04 //y=3.88 //x2=6.04 //y2=4.88
r161 (  26 54 ) resistor r=152 //w=0.17 //l=0.17 //layer=licon //count=1 \
 //x=6.04 //y=2.26 //x2=6.04 //y2=2.26
r162 (  26 29 ) resistor r=110.888 //w=0.187 //l=1.62 //layer=li \
 //thickness=0.1 //x=6.04 //y=2.26 //x2=6.04 //y2=3.88
r163 (  22 24 ) resistor r=54.4171 //w=0.187 //l=0.795 //layer=li \
 //thickness=0.1 //x=4.19 //y=4.675 //x2=4.19 //y2=3.88
r164 (  21 24 ) resistor r=105.07 //w=0.187 //l=1.535 //layer=li \
 //thickness=0.1 //x=4.19 //y=2.345 //x2=4.19 //y2=3.88
r165 (  19 22 ) resistor r=7.15173 //w=0.17 //l=0.120208 //layer=li \
 //thickness=0.1 //x=4.105 //y=4.76 //x2=4.19 //y2=4.675
r166 (  19 20 ) resistor r=13.3476 //w=0.187 //l=0.195 //layer=li \
 //thickness=0.1 //x=4.105 //y=4.76 //x2=3.91 //y2=4.76
r167 (  17 21 ) resistor r=7.15173 //w=0.17 //l=0.120208 //layer=li \
 //thickness=0.1 //x=4.105 //y=2.26 //x2=4.19 //y2=2.345
r168 (  17 18 ) resistor r=13.6898 //w=0.187 //l=0.2 //layer=li \
 //thickness=0.1 //x=4.105 //y=2.26 //x2=3.905 //y2=2.26
r169 (  11 20 ) resistor r=7.15173 //w=0.17 //l=0.120208 //layer=li \
 //thickness=0.1 //x=3.825 //y=4.845 //x2=3.91 //y2=4.76
r170 (  11 64 ) resistor r=72.5562 //w=0.187 //l=1.06 //layer=li \
 //thickness=0.1 //x=3.825 //y=4.845 //x2=3.825 //y2=5.905
r171 (  7 18 ) resistor r=7.15173 //w=0.17 //l=0.120208 //layer=li \
 //thickness=0.1 //x=3.82 //y=2.175 //x2=3.905 //y2=2.26
r172 (  7 62 ) resistor r=67.7647 //w=0.187 //l=0.99 //layer=li \
 //thickness=0.1 //x=3.82 //y=2.175 //x2=3.82 //y2=1.185
r173 (  6 29 ) resistor r=9.3 //w=0.17 //l=0.17 //layer=mcon //count=1 \
 //x=6.04 //y=3.88 //x2=6.04 //y2=3.88
r174 (  4 24 ) resistor r=9.3 //w=0.17 //l=0.17 //layer=mcon //count=1 \
 //x=4.19 //y=3.88 //x2=4.19 //y2=3.88
r175 (  2 4 ) resistor r=0.0717383 //w=0.224 //l=0.115 //layer=m1 \
 //thickness=0.36 //x=4.305 //y=3.88 //x2=4.19 //y2=3.88
r176 (  1 6 ) resistor r=0.0717383 //w=0.224 //l=0.115 //layer=m1 \
 //thickness=0.36 //x=5.925 //y=3.88 //x2=6.04 //y2=3.88
r177 (  1 2 ) resistor r=1.5458 //w=0.131 //l=1.62 //layer=m1 //thickness=0.36 \
 //x=5.925 //y=3.88 //x2=4.305 //y2=3.88
ends PM_DLATCHN\%noxref_3

subckt PM_DLATCHN\%noxref_4 ( 1 2 13 14 25 27 28 32 34 41 42 43 44 45 46 47 48 \
 52 53 54 56 62 63 65 73 75 76 )
c134 ( 76 0 ) capacitor c=0.0220291f //x=6.895 //y=5.2
c135 ( 75 0 ) capacitor c=0.0217503f //x=6.015 //y=5.2
c136 ( 73 0 ) capacitor c=0.0084702f //x=6.89 //y=1.085
c137 ( 65 0 ) capacitor c=0.0511458f //x=9 //y=2.265
c138 ( 63 0 ) capacitor c=0.0435629f //x=9.64 //y=1.435
c139 ( 62 0 ) capacitor c=0.0200386f //x=9.64 //y=1.09
c140 ( 56 0 ) capacitor c=0.0152946f //x=9.485 //y=1.59
c141 ( 54 0 ) capacitor c=0.0157804f //x=9.485 //y=0.935
c142 ( 53 0 ) capacitor c=0.0490829f //x=9.23 //y=4.97
c143 ( 52 0 ) capacitor c=0.0303096f //x=9.52 //y=4.97
c144 ( 48 0 ) capacitor c=0.0290017f //x=9.11 //y=2.1
c145 ( 47 0 ) capacitor c=0.0250027f //x=9.11 //y=1.745
c146 ( 46 0 ) capacitor c=0.0234316f //x=9.11 //y=1.435
c147 ( 45 0 ) capacitor c=0.0200596f //x=9.11 //y=1.09
c148 ( 44 0 ) capacitor c=0.154218f //x=9.595 //y=6.2
c149 ( 43 0 ) capacitor c=0.154243f //x=9.155 //y=6.2
c150 ( 41 0 ) capacitor c=0.0023043f //x=7.04 //y=5.38
c151 ( 34 0 ) capacitor c=0.0884605f //x=9 //y=2.265
c152 ( 32 0 ) capacitor c=0.10682f //x=7.52 //y=3.51
c153 ( 28 0 ) capacitor c=0.00468667f //x=7.165 //y=1.835
c154 ( 27 0 ) capacitor c=0.0131863f //x=7.435 //y=1.835
c155 ( 25 0 ) capacitor c=0.0141863f //x=7.435 //y=5.38
c156 ( 14 0 ) capacitor c=0.00265825f //x=6.245 //y=5.38
c157 ( 13 0 ) capacitor c=0.0149089f //x=6.955 //y=5.38
c158 ( 2 0 ) capacitor c=0.0120846f //x=7.635 //y=3.51
c159 ( 1 0 ) capacitor c=0.0361557f //x=8.885 //y=3.51
r160 (  65 66 ) resistor r=17.5563 //w=0.302 //l=0.11 //layer=ply \
 //thickness=0.18 //x=9 //y=2.265 //x2=9.11 //y2=2.265
r161 (  63 72 ) resistor r=45.1352 //w=0.168 //l=0.173853 //layer=ply \
 //thickness=0.18 //x=9.64 //y=1.435 //x2=9.6 //y2=1.59
r162 (  62 71 ) resistor r=45.1352 //w=0.168 //l=0.173853 //layer=ply \
 //thickness=0.18 //x=9.64 //y=1.09 //x2=9.6 //y2=0.935
r163 (  62 63 ) resistor r=176.904 //w=0.094 //l=0.345 //layer=ply \
 //thickness=0.18 //x=9.64 //y=1.09 //x2=9.64 //y2=1.435
r164 (  57 70 ) resistor r=10.701 //w=0.21 //l=0.115 //layer=ply \
 //thickness=0.18 //x=9.265 //y=1.59 //x2=9.15 //y2=1.59
r165 (  56 72 ) resistor r=5.52526 //w=0.168 //l=0.115 //layer=ply \
 //thickness=0.18 //x=9.485 //y=1.59 //x2=9.6 //y2=1.59
r166 (  55 69 ) resistor r=5.52526 //w=0.168 //l=0.115 //layer=ply \
 //thickness=0.18 //x=9.265 //y=0.935 //x2=9.15 //y2=0.935
r167 (  54 71 ) resistor r=5.52526 //w=0.168 //l=0.115 //layer=ply \
 //thickness=0.18 //x=9.485 //y=0.935 //x2=9.6 //y2=0.935
r168 (  54 55 ) resistor r=112.809 //w=0.094 //l=0.22 //layer=ply \
 //thickness=0.18 //x=9.485 //y=0.935 //x2=9.265 //y2=0.935
r169 (  52 59 ) resistor r=26.9307 //w=0.15 //l=0.106066 //layer=ply \
 //thickness=0.18 //x=9.52 //y=4.97 //x2=9.595 //y2=5.045
r170 (  52 53 ) resistor r=148.702 //w=0.094 //l=0.29 //layer=ply \
 //thickness=0.18 //x=9.52 //y=4.97 //x2=9.23 //y2=4.97
r171 (  49 53 ) resistor r=23.403 //w=0.284 //l=0.106066 //layer=ply \
 //thickness=0.18 //x=9.155 //y=5.045 //x2=9.23 //y2=4.97
r172 (  49 68 ) resistor r=26.3063 //w=0.284 //l=0.229783 //layer=ply \
 //thickness=0.18 //x=9.155 //y=5.045 //x2=9 //y2=4.88
r173 (  48 66 ) resistor r=19.1248 //w=0.302 //l=0.165 //layer=ply \
 //thickness=0.18 //x=9.11 //y=2.1 //x2=9.11 //y2=2.265
r174 (  47 70 ) resistor r=39.5823 //w=0.21 //l=0.173853 //layer=ply \
 //thickness=0.18 //x=9.11 //y=1.745 //x2=9.15 //y2=1.59
r175 (  47 48 ) resistor r=182.032 //w=0.094 //l=0.355 //layer=ply \
 //thickness=0.18 //x=9.11 //y=1.745 //x2=9.11 //y2=2.1
r176 (  46 70 ) resistor r=39.5823 //w=0.21 //l=0.173853 //layer=ply \
 //thickness=0.18 //x=9.11 //y=1.435 //x2=9.15 //y2=1.59
r177 (  45 69 ) resistor r=45.1352 //w=0.168 //l=0.173853 //layer=ply \
 //thickness=0.18 //x=9.11 //y=1.09 //x2=9.15 //y2=0.935
r178 (  45 46 ) resistor r=176.904 //w=0.094 //l=0.345 //layer=ply \
 //thickness=0.18 //x=9.11 //y=1.09 //x2=9.11 //y2=1.435
r179 (  44 59 ) resistor r=592.245 //w=0.094 //l=1.155 //layer=ply \
 //thickness=0.18 //x=9.595 //y=6.2 //x2=9.595 //y2=5.045
r180 (  43 49 ) resistor r=592.245 //w=0.094 //l=1.155 //layer=ply \
 //thickness=0.18 //x=9.155 //y=6.2 //x2=9.155 //y2=5.045
r181 (  42 56 ) resistor r=56.4043 //w=0.094 //l=0.11 //layer=ply \
 //thickness=0.18 //x=9.375 //y=1.59 //x2=9.485 //y2=1.59
r182 (  42 57 ) resistor r=56.4043 //w=0.094 //l=0.11 //layer=ply \
 //thickness=0.18 //x=9.375 //y=1.59 //x2=9.265 //y2=1.59
r183 (  39 68 ) resistor r=152 //w=0.17 //l=0.17 //layer=licon //count=1 //x=9 \
 //y=4.88 //x2=9 //y2=4.88
r184 (  37 39 ) resistor r=93.7754 //w=0.187 //l=1.37 //layer=li \
 //thickness=0.1 //x=9 //y=3.51 //x2=9 //y2=4.88
r185 (  34 65 ) resistor r=152 //w=0.17 //l=0.17 //layer=licon //count=1 //x=9 \
 //y=2.265 //x2=9 //y2=2.265
r186 (  34 37 ) resistor r=85.2193 //w=0.187 //l=1.245 //layer=li \
 //thickness=0.1 //x=9 //y=2.265 //x2=9 //y2=3.51
r187 (  30 32 ) resistor r=122.182 //w=0.187 //l=1.785 //layer=li \
 //thickness=0.1 //x=7.52 //y=5.295 //x2=7.52 //y2=3.51
r188 (  29 32 ) resistor r=108.834 //w=0.187 //l=1.59 //layer=li \
 //thickness=0.1 //x=7.52 //y=1.92 //x2=7.52 //y2=3.51
r189 (  27 29 ) resistor r=7.15173 //w=0.17 //l=0.120208 //layer=li \
 //thickness=0.1 //x=7.435 //y=1.835 //x2=7.52 //y2=1.92
r190 (  27 28 ) resistor r=18.4813 //w=0.187 //l=0.27 //layer=li \
 //thickness=0.1 //x=7.435 //y=1.835 //x2=7.165 //y2=1.835
r191 (  26 41 ) resistor r=5.4201 //w=0.17 //l=0.085 //layer=li \
 //thickness=0.1 //x=7.125 //y=5.38 //x2=7.04 //y2=5.38
r192 (  25 30 ) resistor r=7.15173 //w=0.17 //l=0.120208 //layer=li \
 //thickness=0.1 //x=7.435 //y=5.38 //x2=7.52 //y2=5.295
r193 (  25 26 ) resistor r=21.2193 //w=0.187 //l=0.31 //layer=li \
 //thickness=0.1 //x=7.435 //y=5.38 //x2=7.125 //y2=5.38
r194 (  21 28 ) resistor r=7.15173 //w=0.17 //l=0.120208 //layer=li \
 //thickness=0.1 //x=7.08 //y=1.75 //x2=7.165 //y2=1.835
r195 (  21 73 ) resistor r=39.016 //w=0.187 //l=0.57 //layer=li \
 //thickness=0.1 //x=7.08 //y=1.75 //x2=7.08 //y2=1.18
r196 (  15 41 ) resistor r=1.40859 //w=0.34 //l=0.085 //layer=li \
 //thickness=0.1 //x=7.04 //y=5.465 //x2=7.04 //y2=5.38
r197 (  15 76 ) resistor r=30.1176 //w=0.187 //l=0.44 //layer=li \
 //thickness=0.1 //x=7.04 //y=5.465 //x2=7.04 //y2=5.905
r198 (  13 41 ) resistor r=5.4201 //w=0.17 //l=0.085 //layer=li \
 //thickness=0.1 //x=6.955 //y=5.38 //x2=7.04 //y2=5.38
r199 (  13 14 ) resistor r=48.5989 //w=0.187 //l=0.71 //layer=li \
 //thickness=0.1 //x=6.955 //y=5.38 //x2=6.245 //y2=5.38
r200 (  7 14 ) resistor r=7.15173 //w=0.17 //l=0.120208 //layer=li \
 //thickness=0.1 //x=6.16 //y=5.465 //x2=6.245 //y2=5.38
r201 (  7 75 ) resistor r=30.1176 //w=0.187 //l=0.44 //layer=li \
 //thickness=0.1 //x=6.16 //y=5.465 //x2=6.16 //y2=5.905
r202 (  6 37 ) resistor r=9.3 //w=0.17 //l=0.17 //layer=mcon //count=1 //x=9 \
 //y=3.51 //x2=9 //y2=3.51
r203 (  4 32 ) resistor r=9.3 //w=0.17 //l=0.17 //layer=mcon //count=1 \
 //x=7.52 //y=3.51 //x2=7.52 //y2=3.51
r204 (  2 4 ) resistor r=0.0717383 //w=0.224 //l=0.115 //layer=m1 \
 //thickness=0.36 //x=7.635 //y=3.51 //x2=7.52 //y2=3.51
r205 (  1 6 ) resistor r=0.0717383 //w=0.224 //l=0.115 //layer=m1 \
 //thickness=0.36 //x=8.885 //y=3.51 //x2=9 //y2=3.51
r206 (  1 2 ) resistor r=1.19275 //w=0.131 //l=1.25 //layer=m1 \
 //thickness=0.36 //x=8.885 //y=3.51 //x2=7.635 //y2=3.51
ends PM_DLATCHN\%noxref_4

subckt PM_DLATCHN\%noxref_5 ( 1 2 3 4 21 22 23 24 28 29 31 36 45 46 47 48 49 \
 50 51 52 53 58 60 62 68 69 70 71 72 73 77 79 82 83 88 89 92 106 109 111 )
c238 ( 111 0 ) capacitor c=0.028734f //x=1.46 //y=5.2
c239 ( 109 0 ) capacitor c=0.0173218f //x=1.415 //y=1.09
c240 ( 106 0 ) capacitor c=0.0593152f //x=11.59 //y=4.88
c241 ( 92 0 ) capacitor c=0.0331552f //x=6.81 //y=4.88
c242 ( 89 0 ) capacitor c=0.0279499f //x=6.78 //y=2.095
c243 ( 88 0 ) capacitor c=0.0422509f //x=6.78 //y=2.26
c244 ( 83 0 ) capacitor c=0.0318948f //x=11.925 //y=1.39
c245 ( 82 0 ) capacitor c=0.0187384f //x=11.925 //y=1.045
c246 ( 79 0 ) capacitor c=0.0141798f //x=11.77 //y=1.545
c247 ( 77 0 ) capacitor c=0.0149844f //x=11.77 //y=0.89
c248 ( 73 0 ) capacitor c=0.0819722f //x=11.395 //y=2.095
c249 ( 72 0 ) capacitor c=0.0229722f //x=11.395 //y=1.7
c250 ( 71 0 ) capacitor c=0.0234352f //x=11.395 //y=1.39
c251 ( 70 0 ) capacitor c=0.0199343f //x=11.395 //y=1.045
c252 ( 69 0 ) capacitor c=0.0429696f //x=7.345 //y=1.43
c253 ( 68 0 ) capacitor c=0.0192208f //x=7.345 //y=1.085
c254 ( 62 0 ) capacitor c=0.0158629f //x=7.19 //y=1.585
c255 ( 60 0 ) capacitor c=0.0157803f //x=7.19 //y=0.93
c256 ( 58 0 ) capacitor c=0.0300505f //x=7.185 //y=4.97
c257 ( 53 0 ) capacitor c=0.0205163f //x=6.815 //y=1.74
c258 ( 52 0 ) capacitor c=0.0168481f //x=6.815 //y=1.43
c259 ( 51 0 ) capacitor c=0.0174783f //x=6.815 //y=1.085
c260 ( 50 0 ) capacitor c=0.110275f //x=11.93 //y=6.2
c261 ( 49 0 ) capacitor c=0.154305f //x=11.49 //y=6.2
c262 ( 48 0 ) capacitor c=0.15358f //x=7.26 //y=6.2
c263 ( 47 0 ) capacitor c=0.110281f //x=6.82 //y=6.2
c264 ( 36 0 ) capacitor c=0.0925986f //x=11.59 //y=2.26
c265 ( 31 0 ) capacitor c=0.0756836f //x=6.78 //y=2.26
c266 ( 29 0 ) capacitor c=0.00453889f //x=6.78 //y=4.715
c267 ( 28 0 ) capacitor c=0.0850308f //x=1.97 //y=3.14
c268 ( 24 0 ) capacitor c=0.00575887f //x=1.69 //y=4.76
c269 ( 23 0 ) capacitor c=0.0136332f //x=1.885 //y=4.76
c270 ( 22 0 ) capacitor c=0.00636159f //x=1.685 //y=2.26
c271 ( 21 0 ) capacitor c=0.0137907f //x=1.885 //y=2.26
c272 ( 4 0 ) capacitor c=0.00779107f //x=6.895 //y=3.14
c273 ( 3 0 ) capacitor c=0.14924f //x=11.475 //y=3.14
c274 ( 2 0 ) capacitor c=0.0176065f //x=2.085 //y=3.14
c275 ( 1 0 ) capacitor c=0.158168f //x=6.665 //y=3.14
r276 (  104 106 ) resistor r=20.6867 //w=0.233 //l=0.1 //layer=ply \
 //thickness=0.18 //x=11.49 //y=4.88 //x2=11.59 //y2=4.88
r277 (  94 95 ) resistor r=32.4568 //w=0.214 //l=0.075 //layer=ply \
 //thickness=0.18 //x=6.81 //y=4.97 //x2=6.81 //y2=5.045
r278 (  92 94 ) resistor r=20.271 //w=0.214 //l=0.09 //layer=ply \
 //thickness=0.18 //x=6.81 //y=4.88 //x2=6.81 //y2=4.97
r279 (  88 89 ) resistor r=52.7279 //w=0.214 //l=0.165 //layer=ply \
 //thickness=0.18 //x=6.78 //y=2.26 //x2=6.78 //y2=2.095
r280 (  84 106 ) resistor r=70.3348 //w=0.233 //l=0.414367 //layer=ply \
 //thickness=0.18 //x=11.93 //y=5.045 //x2=11.59 //y2=4.88
r281 (  83 108 ) resistor r=45.1352 //w=0.168 //l=0.173853 //layer=ply \
 //thickness=0.18 //x=11.925 //y=1.39 //x2=11.885 //y2=1.545
r282 (  82 107 ) resistor r=45.1352 //w=0.168 //l=0.173853 //layer=ply \
 //thickness=0.18 //x=11.925 //y=1.045 //x2=11.885 //y2=0.89
r283 (  82 83 ) resistor r=176.904 //w=0.094 //l=0.345 //layer=ply \
 //thickness=0.18 //x=11.925 //y=1.045 //x2=11.925 //y2=1.39
r284 (  80 103 ) resistor r=10.701 //w=0.21 //l=0.115 //layer=ply \
 //thickness=0.18 //x=11.55 //y=1.545 //x2=11.435 //y2=1.545
r285 (  79 108 ) resistor r=5.52526 //w=0.168 //l=0.115 //layer=ply \
 //thickness=0.18 //x=11.77 //y=1.545 //x2=11.885 //y2=1.545
r286 (  78 102 ) resistor r=5.52526 //w=0.168 //l=0.115 //layer=ply \
 //thickness=0.18 //x=11.55 //y=0.89 //x2=11.435 //y2=0.89
r287 (  77 107 ) resistor r=5.52526 //w=0.168 //l=0.115 //layer=ply \
 //thickness=0.18 //x=11.77 //y=0.89 //x2=11.885 //y2=0.89
r288 (  77 78 ) resistor r=112.809 //w=0.094 //l=0.22 //layer=ply \
 //thickness=0.18 //x=11.77 //y=0.89 //x2=11.55 //y2=0.89
r289 (  74 104 ) resistor r=13.0941 //w=0.233 //l=0.165 //layer=ply \
 //thickness=0.18 //x=11.49 //y=5.045 //x2=11.49 //y2=4.88
r290 (  73 101 ) resistor r=34.8111 //w=0.27 //l=0.264953 //layer=ply \
 //thickness=0.18 //x=11.395 //y=2.095 //x2=11.59 //y2=2.26
r291 (  72 103 ) resistor r=39.5823 //w=0.21 //l=0.173853 //layer=ply \
 //thickness=0.18 //x=11.395 //y=1.7 //x2=11.435 //y2=1.545
r292 (  72 73 ) resistor r=202.543 //w=0.094 //l=0.395 //layer=ply \
 //thickness=0.18 //x=11.395 //y=1.7 //x2=11.395 //y2=2.095
r293 (  71 103 ) resistor r=39.5823 //w=0.21 //l=0.173853 //layer=ply \
 //thickness=0.18 //x=11.395 //y=1.39 //x2=11.435 //y2=1.545
r294 (  70 102 ) resistor r=45.1352 //w=0.168 //l=0.173853 //layer=ply \
 //thickness=0.18 //x=11.395 //y=1.045 //x2=11.435 //y2=0.89
r295 (  70 71 ) resistor r=176.904 //w=0.094 //l=0.345 //layer=ply \
 //thickness=0.18 //x=11.395 //y=1.045 //x2=11.395 //y2=1.39
r296 (  69 99 ) resistor r=45.1352 //w=0.168 //l=0.173853 //layer=ply \
 //thickness=0.18 //x=7.345 //y=1.43 //x2=7.305 //y2=1.585
r297 (  68 98 ) resistor r=45.1352 //w=0.168 //l=0.173853 //layer=ply \
 //thickness=0.18 //x=7.345 //y=1.085 //x2=7.305 //y2=0.93
r298 (  68 69 ) resistor r=176.904 //w=0.094 //l=0.345 //layer=ply \
 //thickness=0.18 //x=7.345 //y=1.085 //x2=7.345 //y2=1.43
r299 (  63 97 ) resistor r=10.701 //w=0.21 //l=0.115 //layer=ply \
 //thickness=0.18 //x=6.97 //y=1.585 //x2=6.855 //y2=1.585
r300 (  62 99 ) resistor r=5.52526 //w=0.168 //l=0.115 //layer=ply \
 //thickness=0.18 //x=7.19 //y=1.585 //x2=7.305 //y2=1.585
r301 (  61 96 ) resistor r=5.52526 //w=0.168 //l=0.115 //layer=ply \
 //thickness=0.18 //x=6.97 //y=0.93 //x2=6.855 //y2=0.93
r302 (  60 98 ) resistor r=5.52526 //w=0.168 //l=0.115 //layer=ply \
 //thickness=0.18 //x=7.19 //y=0.93 //x2=7.305 //y2=0.93
r303 (  60 61 ) resistor r=112.809 //w=0.094 //l=0.22 //layer=ply \
 //thickness=0.18 //x=7.19 //y=0.93 //x2=6.97 //y2=0.93
r304 (  59 94 ) resistor r=16.5046 //w=0.27 //l=0.135 //layer=ply \
 //thickness=0.18 //x=6.945 //y=4.97 //x2=6.81 //y2=4.97
r305 (  58 65 ) resistor r=26.9307 //w=0.15 //l=0.106066 //layer=ply \
 //thickness=0.18 //x=7.185 //y=4.97 //x2=7.26 //y2=5.045
r306 (  58 59 ) resistor r=123.064 //w=0.094 //l=0.24 //layer=ply \
 //thickness=0.18 //x=7.185 //y=4.97 //x2=6.945 //y2=4.97
r307 (  53 97 ) resistor r=39.5823 //w=0.21 //l=0.173853 //layer=ply \
 //thickness=0.18 //x=6.815 //y=1.74 //x2=6.855 //y2=1.585
r308 (  53 89 ) resistor r=182.032 //w=0.094 //l=0.355 //layer=ply \
 //thickness=0.18 //x=6.815 //y=1.74 //x2=6.815 //y2=2.095
r309 (  52 97 ) resistor r=39.5823 //w=0.21 //l=0.173853 //layer=ply \
 //thickness=0.18 //x=6.815 //y=1.43 //x2=6.855 //y2=1.585
r310 (  51 96 ) resistor r=45.1352 //w=0.168 //l=0.173853 //layer=ply \
 //thickness=0.18 //x=6.815 //y=1.085 //x2=6.855 //y2=0.93
r311 (  51 52 ) resistor r=176.904 //w=0.094 //l=0.345 //layer=ply \
 //thickness=0.18 //x=6.815 //y=1.085 //x2=6.815 //y2=1.43
r312 (  50 84 ) resistor r=592.245 //w=0.094 //l=1.155 //layer=ply \
 //thickness=0.18 //x=11.93 //y=6.2 //x2=11.93 //y2=5.045
r313 (  49 74 ) resistor r=592.245 //w=0.094 //l=1.155 //layer=ply \
 //thickness=0.18 //x=11.49 //y=6.2 //x2=11.49 //y2=5.045
r314 (  48 65 ) resistor r=592.245 //w=0.094 //l=1.155 //layer=ply \
 //thickness=0.18 //x=7.26 //y=6.2 //x2=7.26 //y2=5.045
r315 (  47 95 ) resistor r=592.245 //w=0.094 //l=1.155 //layer=ply \
 //thickness=0.18 //x=6.82 //y=6.2 //x2=6.82 //y2=5.045
r316 (  46 79 ) resistor r=56.4043 //w=0.094 //l=0.11 //layer=ply \
 //thickness=0.18 //x=11.66 //y=1.545 //x2=11.77 //y2=1.545
r317 (  46 80 ) resistor r=56.4043 //w=0.094 //l=0.11 //layer=ply \
 //thickness=0.18 //x=11.66 //y=1.545 //x2=11.55 //y2=1.545
r318 (  45 62 ) resistor r=56.4043 //w=0.094 //l=0.11 //layer=ply \
 //thickness=0.18 //x=7.08 //y=1.585 //x2=7.19 //y2=1.585
r319 (  45 63 ) resistor r=56.4043 //w=0.094 //l=0.11 //layer=ply \
 //thickness=0.18 //x=7.08 //y=1.585 //x2=6.97 //y2=1.585
r320 (  44 92 ) resistor r=152 //w=0.17 //l=0.17 //layer=licon //count=1 \
 //x=6.81 //y=4.88 //x2=6.81 //y2=4.88
r321 (  41 106 ) resistor r=152 //w=0.17 //l=0.17 //layer=licon //count=1 \
 //x=11.59 //y=4.88 //x2=11.59 //y2=4.88
r322 (  39 41 ) resistor r=119.102 //w=0.187 //l=1.74 //layer=li \
 //thickness=0.1 //x=11.59 //y=3.14 //x2=11.59 //y2=4.88
r323 (  36 101 ) resistor r=152 //w=0.17 //l=0.17 //layer=licon //count=1 \
 //x=11.59 //y=2.26 //x2=11.59 //y2=2.26
r324 (  36 39 ) resistor r=60.2353 //w=0.187 //l=0.88 //layer=li \
 //thickness=0.1 //x=11.59 //y=2.26 //x2=11.59 //y2=3.14
r325 (  31 88 ) resistor r=152 //w=0.17 //l=0.17 //layer=licon //count=1 \
 //x=6.78 //y=2.26 //x2=6.78 //y2=2.26
r326 (  31 34 ) resistor r=60.2353 //w=0.187 //l=0.88 //layer=li \
 //thickness=0.1 //x=6.78 //y=2.26 //x2=6.78 //y2=3.14
r327 (  29 44 ) resistor r=11.4737 //w=0.186 //l=0.172337 //layer=li \
 //thickness=0.1 //x=6.78 //y=4.715 //x2=6.795 //y2=4.88
r328 (  29 34 ) resistor r=107.807 //w=0.187 //l=1.575 //layer=li \
 //thickness=0.1 //x=6.78 //y=4.715 //x2=6.78 //y2=3.14
r329 (  26 28 ) resistor r=105.07 //w=0.187 //l=1.535 //layer=li \
 //thickness=0.1 //x=1.97 //y=4.675 //x2=1.97 //y2=3.14
r330 (  25 28 ) resistor r=54.4171 //w=0.187 //l=0.795 //layer=li \
 //thickness=0.1 //x=1.97 //y=2.345 //x2=1.97 //y2=3.14
r331 (  23 26 ) resistor r=7.15173 //w=0.17 //l=0.120208 //layer=li \
 //thickness=0.1 //x=1.885 //y=4.76 //x2=1.97 //y2=4.675
r332 (  23 24 ) resistor r=13.3476 //w=0.187 //l=0.195 //layer=li \
 //thickness=0.1 //x=1.885 //y=4.76 //x2=1.69 //y2=4.76
r333 (  21 25 ) resistor r=7.15173 //w=0.17 //l=0.120208 //layer=li \
 //thickness=0.1 //x=1.885 //y=2.26 //x2=1.97 //y2=2.345
r334 (  21 22 ) resistor r=13.6898 //w=0.187 //l=0.2 //layer=li \
 //thickness=0.1 //x=1.885 //y=2.26 //x2=1.685 //y2=2.26
r335 (  15 24 ) resistor r=7.15173 //w=0.17 //l=0.120208 //layer=li \
 //thickness=0.1 //x=1.605 //y=4.845 //x2=1.69 //y2=4.76
r336 (  15 111 ) resistor r=72.5562 //w=0.187 //l=1.06 //layer=li \
 //thickness=0.1 //x=1.605 //y=4.845 //x2=1.605 //y2=5.905
r337 (  11 22 ) resistor r=7.15173 //w=0.17 //l=0.120208 //layer=li \
 //thickness=0.1 //x=1.6 //y=2.175 //x2=1.685 //y2=2.26
r338 (  11 109 ) resistor r=67.7647 //w=0.187 //l=0.99 //layer=li \
 //thickness=0.1 //x=1.6 //y=2.175 //x2=1.6 //y2=1.185
r339 (  10 39 ) resistor r=9.3 //w=0.17 //l=0.17 //layer=mcon //count=1 \
 //x=11.59 //y=3.14 //x2=11.59 //y2=3.14
r340 (  8 34 ) resistor r=9.3 //w=0.17 //l=0.17 //layer=mcon //count=1 \
 //x=6.78 //y=3.14 //x2=6.78 //y2=3.14
r341 (  6 28 ) resistor r=9.3 //w=0.17 //l=0.17 //layer=mcon //count=1 \
 //x=1.97 //y=3.14 //x2=1.97 //y2=3.14
r342 (  4 8 ) resistor r=0.0880901 //w=0.191 //l=0.115 //layer=m1 \
 //thickness=0.36 //x=6.895 //y=3.14 //x2=6.78 //y2=3.14
r343 (  3 10 ) resistor r=0.0717383 //w=0.224 //l=0.115 //layer=m1 \
 //thickness=0.36 //x=11.475 //y=3.14 //x2=11.59 //y2=3.14
r344 (  3 4 ) resistor r=4.37023 //w=0.131 //l=4.58 //layer=m1 \
 //thickness=0.36 //x=11.475 //y=3.14 //x2=6.895 //y2=3.14
r345 (  2 6 ) resistor r=0.0717383 //w=0.224 //l=0.115 //layer=m1 \
 //thickness=0.36 //x=2.085 //y=3.14 //x2=1.97 //y2=3.14
r346 (  1 8 ) resistor r=0.0880901 //w=0.191 //l=0.115 //layer=m1 \
 //thickness=0.36 //x=6.665 //y=3.14 //x2=6.78 //y2=3.14
r347 (  1 2 ) resistor r=4.37023 //w=0.131 //l=4.58 //layer=m1 \
 //thickness=0.36 //x=6.665 //y=3.14 //x2=2.085 //y2=3.14
ends PM_DLATCHN\%noxref_5

subckt PM_DLATCHN\%D ( 1 2 7 8 9 10 11 12 13 14 15 16 18 29 31 41 42 43 44 45 \
 46 47 48 49 50 54 55 56 58 64 65 66 67 68 73 75 77 83 84 86 95 96 99 )
c179 ( 99 0 ) capacitor c=0.0331844f //x=12.36 //y=4.88
c180 ( 96 0 ) capacitor c=0.0279499f //x=12.33 //y=2.095
c181 ( 95 0 ) capacitor c=0.0437302f //x=12.33 //y=2.26
c182 ( 86 0 ) capacitor c=0.0511458f //x=3.45 //y=2.265
c183 ( 84 0 ) capacitor c=0.0429696f //x=12.895 //y=1.43
c184 ( 83 0 ) capacitor c=0.0192208f //x=12.895 //y=1.085
c185 ( 77 0 ) capacitor c=0.0158629f //x=12.74 //y=1.585
c186 ( 75 0 ) capacitor c=0.0157803f //x=12.74 //y=0.93
c187 ( 73 0 ) capacitor c=0.0307199f //x=12.735 //y=4.97
c188 ( 68 0 ) capacitor c=0.0205163f //x=12.365 //y=1.74
c189 ( 67 0 ) capacitor c=0.0168481f //x=12.365 //y=1.43
c190 ( 66 0 ) capacitor c=0.0174783f //x=12.365 //y=1.085
c191 ( 65 0 ) capacitor c=0.0435629f //x=4.09 //y=1.435
c192 ( 64 0 ) capacitor c=0.0200386f //x=4.09 //y=1.09
c193 ( 58 0 ) capacitor c=0.0152946f //x=3.935 //y=1.59
c194 ( 56 0 ) capacitor c=0.0157804f //x=3.935 //y=0.935
c195 ( 55 0 ) capacitor c=0.0490957f //x=3.68 //y=4.97
c196 ( 54 0 ) capacitor c=0.0303096f //x=3.97 //y=4.97
c197 ( 50 0 ) capacitor c=0.0290017f //x=3.56 //y=2.1
c198 ( 49 0 ) capacitor c=0.0250027f //x=3.56 //y=1.745
c199 ( 48 0 ) capacitor c=0.0234316f //x=3.56 //y=1.435
c200 ( 47 0 ) capacitor c=0.0200596f //x=3.56 //y=1.09
c201 ( 46 0 ) capacitor c=0.15358f //x=12.81 //y=6.2
c202 ( 45 0 ) capacitor c=0.110281f //x=12.37 //y=6.2
c203 ( 44 0 ) capacitor c=0.154218f //x=4.045 //y=6.2
c204 ( 43 0 ) capacitor c=0.154243f //x=3.605 //y=6.2
c205 ( 31 0 ) capacitor c=0.0762219f //x=12.33 //y=2.26
c206 ( 29 0 ) capacitor c=0.00453889f //x=12.33 //y=4.715
c207 ( 18 0 ) capacitor c=0.0910567f //x=3.45 //y=2.265
c208 ( 2 0 ) capacitor c=0.0168127f //x=3.565 //y=4.25
c209 ( 1 0 ) capacitor c=0.246212f //x=12.215 //y=4.25
r210 (  101 102 ) resistor r=32.4568 //w=0.214 //l=0.075 //layer=ply \
 //thickness=0.18 //x=12.36 //y=4.97 //x2=12.36 //y2=5.045
r211 (  99 101 ) resistor r=20.271 //w=0.214 //l=0.09 //layer=ply \
 //thickness=0.18 //x=12.36 //y=4.88 //x2=12.36 //y2=4.97
r212 (  95 96 ) resistor r=52.7279 //w=0.214 //l=0.165 //layer=ply \
 //thickness=0.18 //x=12.33 //y=2.26 //x2=12.33 //y2=2.095
r213 (  86 87 ) resistor r=17.5563 //w=0.302 //l=0.11 //layer=ply \
 //thickness=0.18 //x=3.45 //y=2.265 //x2=3.56 //y2=2.265
r214 (  84 106 ) resistor r=45.1352 //w=0.168 //l=0.173853 //layer=ply \
 //thickness=0.18 //x=12.895 //y=1.43 //x2=12.855 //y2=1.585
r215 (  83 105 ) resistor r=45.1352 //w=0.168 //l=0.173853 //layer=ply \
 //thickness=0.18 //x=12.895 //y=1.085 //x2=12.855 //y2=0.93
r216 (  83 84 ) resistor r=176.904 //w=0.094 //l=0.345 //layer=ply \
 //thickness=0.18 //x=12.895 //y=1.085 //x2=12.895 //y2=1.43
r217 (  78 104 ) resistor r=10.701 //w=0.21 //l=0.115 //layer=ply \
 //thickness=0.18 //x=12.52 //y=1.585 //x2=12.405 //y2=1.585
r218 (  77 106 ) resistor r=5.52526 //w=0.168 //l=0.115 //layer=ply \
 //thickness=0.18 //x=12.74 //y=1.585 //x2=12.855 //y2=1.585
r219 (  76 103 ) resistor r=5.52526 //w=0.168 //l=0.115 //layer=ply \
 //thickness=0.18 //x=12.52 //y=0.93 //x2=12.405 //y2=0.93
r220 (  75 105 ) resistor r=5.52526 //w=0.168 //l=0.115 //layer=ply \
 //thickness=0.18 //x=12.74 //y=0.93 //x2=12.855 //y2=0.93
r221 (  75 76 ) resistor r=112.809 //w=0.094 //l=0.22 //layer=ply \
 //thickness=0.18 //x=12.74 //y=0.93 //x2=12.52 //y2=0.93
r222 (  74 101 ) resistor r=16.5046 //w=0.27 //l=0.135 //layer=ply \
 //thickness=0.18 //x=12.495 //y=4.97 //x2=12.36 //y2=4.97
r223 (  73 80 ) resistor r=26.9307 //w=0.15 //l=0.106066 //layer=ply \
 //thickness=0.18 //x=12.735 //y=4.97 //x2=12.81 //y2=5.045
r224 (  73 74 ) resistor r=123.064 //w=0.094 //l=0.24 //layer=ply \
 //thickness=0.18 //x=12.735 //y=4.97 //x2=12.495 //y2=4.97
r225 (  68 104 ) resistor r=39.5823 //w=0.21 //l=0.173853 //layer=ply \
 //thickness=0.18 //x=12.365 //y=1.74 //x2=12.405 //y2=1.585
r226 (  68 96 ) resistor r=182.032 //w=0.094 //l=0.355 //layer=ply \
 //thickness=0.18 //x=12.365 //y=1.74 //x2=12.365 //y2=2.095
r227 (  67 104 ) resistor r=39.5823 //w=0.21 //l=0.173853 //layer=ply \
 //thickness=0.18 //x=12.365 //y=1.43 //x2=12.405 //y2=1.585
r228 (  66 103 ) resistor r=45.1352 //w=0.168 //l=0.173853 //layer=ply \
 //thickness=0.18 //x=12.365 //y=1.085 //x2=12.405 //y2=0.93
r229 (  66 67 ) resistor r=176.904 //w=0.094 //l=0.345 //layer=ply \
 //thickness=0.18 //x=12.365 //y=1.085 //x2=12.365 //y2=1.43
r230 (  65 93 ) resistor r=45.1352 //w=0.168 //l=0.173853 //layer=ply \
 //thickness=0.18 //x=4.09 //y=1.435 //x2=4.05 //y2=1.59
r231 (  64 92 ) resistor r=45.1352 //w=0.168 //l=0.173853 //layer=ply \
 //thickness=0.18 //x=4.09 //y=1.09 //x2=4.05 //y2=0.935
r232 (  64 65 ) resistor r=176.904 //w=0.094 //l=0.345 //layer=ply \
 //thickness=0.18 //x=4.09 //y=1.09 //x2=4.09 //y2=1.435
r233 (  59 91 ) resistor r=10.701 //w=0.21 //l=0.115 //layer=ply \
 //thickness=0.18 //x=3.715 //y=1.59 //x2=3.6 //y2=1.59
r234 (  58 93 ) resistor r=5.52526 //w=0.168 //l=0.115 //layer=ply \
 //thickness=0.18 //x=3.935 //y=1.59 //x2=4.05 //y2=1.59
r235 (  57 90 ) resistor r=5.52526 //w=0.168 //l=0.115 //layer=ply \
 //thickness=0.18 //x=3.715 //y=0.935 //x2=3.6 //y2=0.935
r236 (  56 92 ) resistor r=5.52526 //w=0.168 //l=0.115 //layer=ply \
 //thickness=0.18 //x=3.935 //y=0.935 //x2=4.05 //y2=0.935
r237 (  56 57 ) resistor r=112.809 //w=0.094 //l=0.22 //layer=ply \
 //thickness=0.18 //x=3.935 //y=0.935 //x2=3.715 //y2=0.935
r238 (  54 61 ) resistor r=26.9307 //w=0.15 //l=0.106066 //layer=ply \
 //thickness=0.18 //x=3.97 //y=4.97 //x2=4.045 //y2=5.045
r239 (  54 55 ) resistor r=148.702 //w=0.094 //l=0.29 //layer=ply \
 //thickness=0.18 //x=3.97 //y=4.97 //x2=3.68 //y2=4.97
r240 (  51 55 ) resistor r=23.403 //w=0.284 //l=0.106066 //layer=ply \
 //thickness=0.18 //x=3.605 //y=5.045 //x2=3.68 //y2=4.97
r241 (  51 89 ) resistor r=26.3063 //w=0.284 //l=0.229783 //layer=ply \
 //thickness=0.18 //x=3.605 //y=5.045 //x2=3.45 //y2=4.88
r242 (  50 87 ) resistor r=19.1248 //w=0.302 //l=0.165 //layer=ply \
 //thickness=0.18 //x=3.56 //y=2.1 //x2=3.56 //y2=2.265
r243 (  49 91 ) resistor r=39.5823 //w=0.21 //l=0.173853 //layer=ply \
 //thickness=0.18 //x=3.56 //y=1.745 //x2=3.6 //y2=1.59
r244 (  49 50 ) resistor r=182.032 //w=0.094 //l=0.355 //layer=ply \
 //thickness=0.18 //x=3.56 //y=1.745 //x2=3.56 //y2=2.1
r245 (  48 91 ) resistor r=39.5823 //w=0.21 //l=0.173853 //layer=ply \
 //thickness=0.18 //x=3.56 //y=1.435 //x2=3.6 //y2=1.59
r246 (  47 90 ) resistor r=45.1352 //w=0.168 //l=0.173853 //layer=ply \
 //thickness=0.18 //x=3.56 //y=1.09 //x2=3.6 //y2=0.935
r247 (  47 48 ) resistor r=176.904 //w=0.094 //l=0.345 //layer=ply \
 //thickness=0.18 //x=3.56 //y=1.09 //x2=3.56 //y2=1.435
r248 (  46 80 ) resistor r=592.245 //w=0.094 //l=1.155 //layer=ply \
 //thickness=0.18 //x=12.81 //y=6.2 //x2=12.81 //y2=5.045
r249 (  45 102 ) resistor r=592.245 //w=0.094 //l=1.155 //layer=ply \
 //thickness=0.18 //x=12.37 //y=6.2 //x2=12.37 //y2=5.045
r250 (  44 61 ) resistor r=592.245 //w=0.094 //l=1.155 //layer=ply \
 //thickness=0.18 //x=4.045 //y=6.2 //x2=4.045 //y2=5.045
r251 (  43 51 ) resistor r=592.245 //w=0.094 //l=1.155 //layer=ply \
 //thickness=0.18 //x=3.605 //y=6.2 //x2=3.605 //y2=5.045
r252 (  42 77 ) resistor r=56.4043 //w=0.094 //l=0.11 //layer=ply \
 //thickness=0.18 //x=12.63 //y=1.585 //x2=12.74 //y2=1.585
r253 (  42 78 ) resistor r=56.4043 //w=0.094 //l=0.11 //layer=ply \
 //thickness=0.18 //x=12.63 //y=1.585 //x2=12.52 //y2=1.585
r254 (  41 58 ) resistor r=56.4043 //w=0.094 //l=0.11 //layer=ply \
 //thickness=0.18 //x=3.825 //y=1.59 //x2=3.935 //y2=1.59
r255 (  41 59 ) resistor r=56.4043 //w=0.094 //l=0.11 //layer=ply \
 //thickness=0.18 //x=3.825 //y=1.59 //x2=3.715 //y2=1.59
r256 (  40 99 ) resistor r=152 //w=0.17 //l=0.17 //layer=licon //count=1 \
 //x=12.36 //y=4.88 //x2=12.36 //y2=4.88
r257 (  31 95 ) resistor r=152 //w=0.17 //l=0.17 //layer=licon //count=1 \
 //x=12.33 //y=2.26 //x2=12.33 //y2=2.26
r258 (  29 40 ) resistor r=11.4737 //w=0.186 //l=0.172337 //layer=li \
 //thickness=0.1 //x=12.33 //y=4.715 //x2=12.345 //y2=4.88
r259 (  27 89 ) resistor r=152 //w=0.17 //l=0.17 //layer=licon //count=1 \
 //x=3.45 //y=4.88 //x2=3.45 //y2=4.88
r260 (  18 86 ) resistor r=152 //w=0.17 //l=0.17 //layer=licon //count=1 \
 //x=3.45 //y=2.265 //x2=3.45 //y2=2.265
r261 (  16 29 ) resistor r=6.50267 //w=0.187 //l=0.095 //layer=li \
 //thickness=0.1 //x=12.33 //y=4.62 //x2=12.33 //y2=4.715
r262 (  15 16 ) resistor r=25.3262 //w=0.187 //l=0.37 //layer=li \
 //thickness=0.1 //x=12.33 //y=4.25 //x2=12.33 //y2=4.62
r263 (  14 15 ) resistor r=50.6524 //w=0.187 //l=0.74 //layer=li \
 //thickness=0.1 //x=12.33 //y=3.51 //x2=12.33 //y2=4.25
r264 (  13 14 ) resistor r=25.3262 //w=0.187 //l=0.37 //layer=li \
 //thickness=0.1 //x=12.33 //y=3.14 //x2=12.33 //y2=3.51
r265 (  12 13 ) resistor r=25.3262 //w=0.187 //l=0.37 //layer=li \
 //thickness=0.1 //x=12.33 //y=2.77 //x2=12.33 //y2=3.14
r266 (  12 31 ) resistor r=34.9091 //w=0.187 //l=0.51 //layer=li \
 //thickness=0.1 //x=12.33 //y=2.77 //x2=12.33 //y2=2.26
r267 (  11 27 ) resistor r=17.7968 //w=0.187 //l=0.26 //layer=li \
 //thickness=0.1 //x=3.45 //y=4.62 //x2=3.45 //y2=4.88
r268 (  10 11 ) resistor r=25.3262 //w=0.187 //l=0.37 //layer=li \
 //thickness=0.1 //x=3.45 //y=4.25 //x2=3.45 //y2=4.62
r269 (  9 10 ) resistor r=25.3262 //w=0.187 //l=0.37 //layer=li \
 //thickness=0.1 //x=3.45 //y=3.88 //x2=3.45 //y2=4.25
r270 (  8 9 ) resistor r=25.3262 //w=0.187 //l=0.37 //layer=li //thickness=0.1 \
 //x=3.45 //y=3.51 //x2=3.45 //y2=3.88
r271 (  7 8 ) resistor r=50.6524 //w=0.187 //l=0.74 //layer=li //thickness=0.1 \
 //x=3.45 //y=2.77 //x2=3.45 //y2=3.51
r272 (  7 18 ) resistor r=34.5668 //w=0.187 //l=0.505 //layer=li \
 //thickness=0.1 //x=3.45 //y=2.77 //x2=3.45 //y2=2.265
r273 (  6 15 ) resistor r=9.3 //w=0.17 //l=0.17 //layer=mcon //count=1 \
 //x=12.33 //y=4.25 //x2=12.33 //y2=4.25
r274 (  4 10 ) resistor r=9.3 //w=0.17 //l=0.17 //layer=mcon //count=1 \
 //x=3.45 //y=4.25 //x2=3.45 //y2=4.25
r275 (  2 4 ) resistor r=0.0717383 //w=0.224 //l=0.115 //layer=m1 \
 //thickness=0.36 //x=3.565 //y=4.25 //x2=3.45 //y2=4.25
r276 (  1 6 ) resistor r=0.0717383 //w=0.224 //l=0.115 //layer=m1 \
 //thickness=0.36 //x=12.215 //y=4.25 //x2=12.33 //y2=4.25
r277 (  1 2 ) resistor r=8.25382 //w=0.131 //l=8.65 //layer=m1 \
 //thickness=0.36 //x=12.215 //y=4.25 //x2=3.565 //y2=4.25
ends PM_DLATCHN\%D

subckt PM_DLATCHN\%noxref_7 ( 1 2 13 14 25 27 28 32 34 41 42 43 44 45 46 47 48 \
 52 53 54 56 62 63 65 73 75 76 )
c139 ( 76 0 ) capacitor c=0.0220291f //x=12.445 //y=5.2
c140 ( 75 0 ) capacitor c=0.0217503f //x=11.565 //y=5.2
c141 ( 73 0 ) capacitor c=0.0084702f //x=12.44 //y=1.085
c142 ( 65 0 ) capacitor c=0.0528806f //x=14.55 //y=2.265
c143 ( 63 0 ) capacitor c=0.0435629f //x=15.19 //y=1.435
c144 ( 62 0 ) capacitor c=0.0200386f //x=15.19 //y=1.09
c145 ( 56 0 ) capacitor c=0.0152946f //x=15.035 //y=1.59
c146 ( 54 0 ) capacitor c=0.0157804f //x=15.035 //y=0.935
c147 ( 53 0 ) capacitor c=0.0493989f //x=14.78 //y=4.97
c148 ( 52 0 ) capacitor c=0.0304843f //x=15.07 //y=4.97
c149 ( 48 0 ) capacitor c=0.0290017f //x=14.66 //y=2.1
c150 ( 47 0 ) capacitor c=0.0250027f //x=14.66 //y=1.745
c151 ( 46 0 ) capacitor c=0.0234316f //x=14.66 //y=1.435
c152 ( 45 0 ) capacitor c=0.0200596f //x=14.66 //y=1.09
c153 ( 44 0 ) capacitor c=0.154218f //x=15.145 //y=6.2
c154 ( 43 0 ) capacitor c=0.154243f //x=14.705 //y=6.2
c155 ( 41 0 ) capacitor c=0.0024826f //x=12.59 //y=5.38
c156 ( 34 0 ) capacitor c=0.0908494f //x=14.55 //y=2.265
c157 ( 32 0 ) capacitor c=0.108527f //x=13.07 //y=3.51
c158 ( 28 0 ) capacitor c=0.00525782f //x=12.715 //y=1.835
c159 ( 27 0 ) capacitor c=0.0139525f //x=12.985 //y=1.835
c160 ( 25 0 ) capacitor c=0.0144648f //x=12.985 //y=5.38
c161 ( 14 0 ) capacitor c=0.00265825f //x=11.795 //y=5.38
c162 ( 13 0 ) capacitor c=0.0150834f //x=12.505 //y=5.38
c163 ( 2 0 ) capacitor c=0.0111323f //x=13.185 //y=3.51
c164 ( 1 0 ) capacitor c=0.0522233f //x=14.435 //y=3.51
r165 (  65 66 ) resistor r=17.5563 //w=0.302 //l=0.11 //layer=ply \
 //thickness=0.18 //x=14.55 //y=2.265 //x2=14.66 //y2=2.265
r166 (  63 72 ) resistor r=45.1352 //w=0.168 //l=0.173853 //layer=ply \
 //thickness=0.18 //x=15.19 //y=1.435 //x2=15.15 //y2=1.59
r167 (  62 71 ) resistor r=45.1352 //w=0.168 //l=0.173853 //layer=ply \
 //thickness=0.18 //x=15.19 //y=1.09 //x2=15.15 //y2=0.935
r168 (  62 63 ) resistor r=176.904 //w=0.094 //l=0.345 //layer=ply \
 //thickness=0.18 //x=15.19 //y=1.09 //x2=15.19 //y2=1.435
r169 (  57 70 ) resistor r=10.701 //w=0.21 //l=0.115 //layer=ply \
 //thickness=0.18 //x=14.815 //y=1.59 //x2=14.7 //y2=1.59
r170 (  56 72 ) resistor r=5.52526 //w=0.168 //l=0.115 //layer=ply \
 //thickness=0.18 //x=15.035 //y=1.59 //x2=15.15 //y2=1.59
r171 (  55 69 ) resistor r=5.52526 //w=0.168 //l=0.115 //layer=ply \
 //thickness=0.18 //x=14.815 //y=0.935 //x2=14.7 //y2=0.935
r172 (  54 71 ) resistor r=5.52526 //w=0.168 //l=0.115 //layer=ply \
 //thickness=0.18 //x=15.035 //y=0.935 //x2=15.15 //y2=0.935
r173 (  54 55 ) resistor r=112.809 //w=0.094 //l=0.22 //layer=ply \
 //thickness=0.18 //x=15.035 //y=0.935 //x2=14.815 //y2=0.935
r174 (  52 59 ) resistor r=26.9307 //w=0.15 //l=0.106066 //layer=ply \
 //thickness=0.18 //x=15.07 //y=4.97 //x2=15.145 //y2=5.045
r175 (  52 53 ) resistor r=148.702 //w=0.094 //l=0.29 //layer=ply \
 //thickness=0.18 //x=15.07 //y=4.97 //x2=14.78 //y2=4.97
r176 (  49 53 ) resistor r=23.403 //w=0.284 //l=0.106066 //layer=ply \
 //thickness=0.18 //x=14.705 //y=5.045 //x2=14.78 //y2=4.97
r177 (  49 68 ) resistor r=26.3063 //w=0.284 //l=0.229783 //layer=ply \
 //thickness=0.18 //x=14.705 //y=5.045 //x2=14.55 //y2=4.88
r178 (  48 66 ) resistor r=19.1248 //w=0.302 //l=0.165 //layer=ply \
 //thickness=0.18 //x=14.66 //y=2.1 //x2=14.66 //y2=2.265
r179 (  47 70 ) resistor r=39.5823 //w=0.21 //l=0.173853 //layer=ply \
 //thickness=0.18 //x=14.66 //y=1.745 //x2=14.7 //y2=1.59
r180 (  47 48 ) resistor r=182.032 //w=0.094 //l=0.355 //layer=ply \
 //thickness=0.18 //x=14.66 //y=1.745 //x2=14.66 //y2=2.1
r181 (  46 70 ) resistor r=39.5823 //w=0.21 //l=0.173853 //layer=ply \
 //thickness=0.18 //x=14.66 //y=1.435 //x2=14.7 //y2=1.59
r182 (  45 69 ) resistor r=45.1352 //w=0.168 //l=0.173853 //layer=ply \
 //thickness=0.18 //x=14.66 //y=1.09 //x2=14.7 //y2=0.935
r183 (  45 46 ) resistor r=176.904 //w=0.094 //l=0.345 //layer=ply \
 //thickness=0.18 //x=14.66 //y=1.09 //x2=14.66 //y2=1.435
r184 (  44 59 ) resistor r=592.245 //w=0.094 //l=1.155 //layer=ply \
 //thickness=0.18 //x=15.145 //y=6.2 //x2=15.145 //y2=5.045
r185 (  43 49 ) resistor r=592.245 //w=0.094 //l=1.155 //layer=ply \
 //thickness=0.18 //x=14.705 //y=6.2 //x2=14.705 //y2=5.045
r186 (  42 56 ) resistor r=56.4043 //w=0.094 //l=0.11 //layer=ply \
 //thickness=0.18 //x=14.925 //y=1.59 //x2=15.035 //y2=1.59
r187 (  42 57 ) resistor r=56.4043 //w=0.094 //l=0.11 //layer=ply \
 //thickness=0.18 //x=14.925 //y=1.59 //x2=14.815 //y2=1.59
r188 (  39 68 ) resistor r=152 //w=0.17 //l=0.17 //layer=licon //count=1 \
 //x=14.55 //y=4.88 //x2=14.55 //y2=4.88
r189 (  37 39 ) resistor r=93.7754 //w=0.187 //l=1.37 //layer=li \
 //thickness=0.1 //x=14.55 //y=3.51 //x2=14.55 //y2=4.88
r190 (  34 65 ) resistor r=152 //w=0.17 //l=0.17 //layer=licon //count=1 \
 //x=14.55 //y=2.265 //x2=14.55 //y2=2.265
r191 (  34 37 ) resistor r=85.2193 //w=0.187 //l=1.245 //layer=li \
 //thickness=0.1 //x=14.55 //y=2.265 //x2=14.55 //y2=3.51
r192 (  30 32 ) resistor r=122.182 //w=0.187 //l=1.785 //layer=li \
 //thickness=0.1 //x=13.07 //y=5.295 //x2=13.07 //y2=3.51
r193 (  29 32 ) resistor r=108.834 //w=0.187 //l=1.59 //layer=li \
 //thickness=0.1 //x=13.07 //y=1.92 //x2=13.07 //y2=3.51
r194 (  27 29 ) resistor r=7.15173 //w=0.17 //l=0.120208 //layer=li \
 //thickness=0.1 //x=12.985 //y=1.835 //x2=13.07 //y2=1.92
r195 (  27 28 ) resistor r=18.4813 //w=0.187 //l=0.27 //layer=li \
 //thickness=0.1 //x=12.985 //y=1.835 //x2=12.715 //y2=1.835
r196 (  26 41 ) resistor r=5.4201 //w=0.17 //l=0.085 //layer=li \
 //thickness=0.1 //x=12.675 //y=5.38 //x2=12.59 //y2=5.38
r197 (  25 30 ) resistor r=7.15173 //w=0.17 //l=0.120208 //layer=li \
 //thickness=0.1 //x=12.985 //y=5.38 //x2=13.07 //y2=5.295
r198 (  25 26 ) resistor r=21.2193 //w=0.187 //l=0.31 //layer=li \
 //thickness=0.1 //x=12.985 //y=5.38 //x2=12.675 //y2=5.38
r199 (  21 28 ) resistor r=7.15173 //w=0.17 //l=0.120208 //layer=li \
 //thickness=0.1 //x=12.63 //y=1.75 //x2=12.715 //y2=1.835
r200 (  21 73 ) resistor r=39.016 //w=0.187 //l=0.57 //layer=li \
 //thickness=0.1 //x=12.63 //y=1.75 //x2=12.63 //y2=1.18
r201 (  15 41 ) resistor r=1.40859 //w=0.34 //l=0.085 //layer=li \
 //thickness=0.1 //x=12.59 //y=5.465 //x2=12.59 //y2=5.38
r202 (  15 76 ) resistor r=30.1176 //w=0.187 //l=0.44 //layer=li \
 //thickness=0.1 //x=12.59 //y=5.465 //x2=12.59 //y2=5.905
r203 (  13 41 ) resistor r=5.4201 //w=0.17 //l=0.085 //layer=li \
 //thickness=0.1 //x=12.505 //y=5.38 //x2=12.59 //y2=5.38
r204 (  13 14 ) resistor r=48.5989 //w=0.187 //l=0.71 //layer=li \
 //thickness=0.1 //x=12.505 //y=5.38 //x2=11.795 //y2=5.38
r205 (  7 14 ) resistor r=7.15173 //w=0.17 //l=0.120208 //layer=li \
 //thickness=0.1 //x=11.71 //y=5.465 //x2=11.795 //y2=5.38
r206 (  7 75 ) resistor r=30.1176 //w=0.187 //l=0.44 //layer=li \
 //thickness=0.1 //x=11.71 //y=5.465 //x2=11.71 //y2=5.905
r207 (  6 37 ) resistor r=9.3 //w=0.17 //l=0.17 //layer=mcon //count=1 \
 //x=14.55 //y=3.51 //x2=14.55 //y2=3.51
r208 (  4 32 ) resistor r=9.3 //w=0.17 //l=0.17 //layer=mcon //count=1 \
 //x=13.07 //y=3.51 //x2=13.07 //y2=3.51
r209 (  2 4 ) resistor r=0.0717383 //w=0.224 //l=0.115 //layer=m1 \
 //thickness=0.36 //x=13.185 //y=3.51 //x2=13.07 //y2=3.51
r210 (  1 6 ) resistor r=0.0717383 //w=0.224 //l=0.115 //layer=m1 \
 //thickness=0.36 //x=14.435 //y=3.51 //x2=14.55 //y2=3.51
r211 (  1 2 ) resistor r=1.19275 //w=0.131 //l=1.25 //layer=m1 \
 //thickness=0.36 //x=14.435 //y=3.51 //x2=13.185 //y2=3.51
ends PM_DLATCHN\%noxref_7

subckt PM_DLATCHN\%noxref_8 ( 1 2 17 18 19 20 24 27 32 34 35 36 37 38 39 40 44 \
 46 49 51 52 57 67 69 )
c164 ( 69 0 ) capacitor c=0.0288745f //x=9.23 //y=5.2
c165 ( 67 0 ) capacitor c=0.0173218f //x=9.185 //y=1.09
c166 ( 57 0 ) capacitor c=0.0403405f //x=16.985 //y=4.885
c167 ( 52 0 ) capacitor c=0.0321911f //x=17.475 //y=1.43
c168 ( 51 0 ) capacitor c=0.0185201f //x=17.475 //y=1.085
c169 ( 49 0 ) capacitor c=0.0288104f //x=17.405 //y=4.975
c170 ( 46 0 ) capacitor c=0.0133656f //x=17.32 //y=1.585
c171 ( 44 0 ) capacitor c=0.0157804f //x=17.32 //y=0.93
c172 ( 40 0 ) capacitor c=0.0828832f //x=16.945 //y=2.095
c173 ( 39 0 ) capacitor c=0.022867f //x=16.945 //y=1.74
c174 ( 38 0 ) capacitor c=0.0234318f //x=16.945 //y=1.43
c175 ( 37 0 ) capacitor c=0.0192004f //x=16.945 //y=1.085
c176 ( 36 0 ) capacitor c=0.110795f //x=17.48 //y=6.205
c177 ( 35 0 ) capacitor c=0.153847f //x=17.04 //y=6.205
c178 ( 32 0 ) capacitor c=0.00993392f //x=16.985 //y=4.885
c179 ( 27 0 ) capacitor c=0.0921227f //x=17.14 //y=2.26
c180 ( 24 0 ) capacitor c=0.0820607f //x=9.74 //y=3.88
c181 ( 20 0 ) capacitor c=0.00417404f //x=9.46 //y=4.76
c182 ( 19 0 ) capacitor c=0.0118896f //x=9.655 //y=4.76
c183 ( 18 0 ) capacitor c=0.00549299f //x=9.455 //y=2.26
c184 ( 17 0 ) capacitor c=0.013178f //x=9.655 //y=2.26
c185 ( 2 0 ) capacitor c=0.0108199f //x=9.855 //y=3.88
c186 ( 1 0 ) capacitor c=0.214055f //x=17.025 //y=3.88
r187 (  59 60 ) resistor r=32.4568 //w=0.214 //l=0.075 //layer=ply \
 //thickness=0.18 //x=16.985 //y=4.975 //x2=16.985 //y2=5.05
r188 (  57 59 ) resistor r=20.271 //w=0.214 //l=0.09 //layer=ply \
 //thickness=0.18 //x=16.985 //y=4.885 //x2=16.985 //y2=4.975
r189 (  52 66 ) resistor r=45.1352 //w=0.168 //l=0.173853 //layer=ply \
 //thickness=0.18 //x=17.475 //y=1.43 //x2=17.435 //y2=1.585
r190 (  51 65 ) resistor r=45.1352 //w=0.168 //l=0.173853 //layer=ply \
 //thickness=0.18 //x=17.475 //y=1.085 //x2=17.435 //y2=0.93
r191 (  51 52 ) resistor r=176.904 //w=0.094 //l=0.345 //layer=ply \
 //thickness=0.18 //x=17.475 //y=1.085 //x2=17.475 //y2=1.43
r192 (  50 59 ) resistor r=16.5046 //w=0.27 //l=0.135 //layer=ply \
 //thickness=0.18 //x=17.12 //y=4.975 //x2=16.985 //y2=4.975
r193 (  49 53 ) resistor r=26.9307 //w=0.15 //l=0.106066 //layer=ply \
 //thickness=0.18 //x=17.405 //y=4.975 //x2=17.48 //y2=5.05
r194 (  49 50 ) resistor r=146.138 //w=0.094 //l=0.285 //layer=ply \
 //thickness=0.18 //x=17.405 //y=4.975 //x2=17.12 //y2=4.975
r195 (  47 64 ) resistor r=10.701 //w=0.21 //l=0.115 //layer=ply \
 //thickness=0.18 //x=17.1 //y=1.585 //x2=16.985 //y2=1.585
r196 (  46 66 ) resistor r=5.52526 //w=0.168 //l=0.115 //layer=ply \
 //thickness=0.18 //x=17.32 //y=1.585 //x2=17.435 //y2=1.585
r197 (  45 63 ) resistor r=5.52526 //w=0.168 //l=0.115 //layer=ply \
 //thickness=0.18 //x=17.1 //y=0.93 //x2=16.985 //y2=0.93
r198 (  44 65 ) resistor r=5.52526 //w=0.168 //l=0.115 //layer=ply \
 //thickness=0.18 //x=17.32 //y=0.93 //x2=17.435 //y2=0.93
r199 (  44 45 ) resistor r=112.809 //w=0.094 //l=0.22 //layer=ply \
 //thickness=0.18 //x=17.32 //y=0.93 //x2=17.1 //y2=0.93
r200 (  40 62 ) resistor r=34.8111 //w=0.27 //l=0.264953 //layer=ply \
 //thickness=0.18 //x=16.945 //y=2.095 //x2=17.14 //y2=2.26
r201 (  39 64 ) resistor r=39.5823 //w=0.21 //l=0.173853 //layer=ply \
 //thickness=0.18 //x=16.945 //y=1.74 //x2=16.985 //y2=1.585
r202 (  39 40 ) resistor r=182.032 //w=0.094 //l=0.355 //layer=ply \
 //thickness=0.18 //x=16.945 //y=1.74 //x2=16.945 //y2=2.095
r203 (  38 64 ) resistor r=39.5823 //w=0.21 //l=0.173853 //layer=ply \
 //thickness=0.18 //x=16.945 //y=1.43 //x2=16.985 //y2=1.585
r204 (  37 63 ) resistor r=45.1352 //w=0.168 //l=0.173853 //layer=ply \
 //thickness=0.18 //x=16.945 //y=1.085 //x2=16.985 //y2=0.93
r205 (  37 38 ) resistor r=176.904 //w=0.094 //l=0.345 //layer=ply \
 //thickness=0.18 //x=16.945 //y=1.085 //x2=16.945 //y2=1.43
r206 (  36 53 ) resistor r=592.245 //w=0.094 //l=1.155 //layer=ply \
 //thickness=0.18 //x=17.48 //y=6.205 //x2=17.48 //y2=5.05
r207 (  35 60 ) resistor r=592.245 //w=0.094 //l=1.155 //layer=ply \
 //thickness=0.18 //x=17.04 //y=6.205 //x2=17.04 //y2=5.05
r208 (  34 46 ) resistor r=56.4043 //w=0.094 //l=0.11 //layer=ply \
 //thickness=0.18 //x=17.21 //y=1.585 //x2=17.32 //y2=1.585
r209 (  34 47 ) resistor r=56.4043 //w=0.094 //l=0.11 //layer=ply \
 //thickness=0.18 //x=17.21 //y=1.585 //x2=17.1 //y2=1.585
r210 (  32 57 ) resistor r=152 //w=0.17 //l=0.17 //layer=licon //count=1 \
 //x=16.985 //y=4.885 //x2=16.985 //y2=4.885
r211 (  32 33 ) resistor r=7.81102 //w=0.254 //l=0.155 //layer=li \
 //thickness=0.1 //x=16.985 //y=4.885 //x2=17.14 //y2=4.885
r212 (  27 62 ) resistor r=152 //w=0.17 //l=0.17 //layer=licon //count=1 \
 //x=17.14 //y=2.26 //x2=17.14 //y2=2.26
r213 (  27 30 ) resistor r=110.888 //w=0.187 //l=1.62 //layer=li \
 //thickness=0.1 //x=17.14 //y=2.26 //x2=17.14 //y2=3.88
r214 (  25 33 ) resistor r=3.23951 //w=0.254 //l=0.165 //layer=li \
 //thickness=0.1 //x=17.14 //y=4.72 //x2=17.14 //y2=4.885
r215 (  25 30 ) resistor r=57.4973 //w=0.187 //l=0.84 //layer=li \
 //thickness=0.1 //x=17.14 //y=4.72 //x2=17.14 //y2=3.88
r216 (  22 24 ) resistor r=54.4171 //w=0.187 //l=0.795 //layer=li \
 //thickness=0.1 //x=9.74 //y=4.675 //x2=9.74 //y2=3.88
r217 (  21 24 ) resistor r=105.07 //w=0.187 //l=1.535 //layer=li \
 //thickness=0.1 //x=9.74 //y=2.345 //x2=9.74 //y2=3.88
r218 (  19 22 ) resistor r=7.15173 //w=0.17 //l=0.120208 //layer=li \
 //thickness=0.1 //x=9.655 //y=4.76 //x2=9.74 //y2=4.675
r219 (  19 20 ) resistor r=13.3476 //w=0.187 //l=0.195 //layer=li \
 //thickness=0.1 //x=9.655 //y=4.76 //x2=9.46 //y2=4.76
r220 (  17 21 ) resistor r=7.15173 //w=0.17 //l=0.120208 //layer=li \
 //thickness=0.1 //x=9.655 //y=2.26 //x2=9.74 //y2=2.345
r221 (  17 18 ) resistor r=13.6898 //w=0.187 //l=0.2 //layer=li \
 //thickness=0.1 //x=9.655 //y=2.26 //x2=9.455 //y2=2.26
r222 (  11 20 ) resistor r=7.15173 //w=0.17 //l=0.120208 //layer=li \
 //thickness=0.1 //x=9.375 //y=4.845 //x2=9.46 //y2=4.76
r223 (  11 69 ) resistor r=72.5562 //w=0.187 //l=1.06 //layer=li \
 //thickness=0.1 //x=9.375 //y=4.845 //x2=9.375 //y2=5.905
r224 (  7 18 ) resistor r=7.15173 //w=0.17 //l=0.120208 //layer=li \
 //thickness=0.1 //x=9.37 //y=2.175 //x2=9.455 //y2=2.26
r225 (  7 67 ) resistor r=67.7647 //w=0.187 //l=0.99 //layer=li \
 //thickness=0.1 //x=9.37 //y=2.175 //x2=9.37 //y2=1.185
r226 (  6 30 ) resistor r=9.3 //w=0.17 //l=0.17 //layer=mcon //count=1 \
 //x=17.14 //y=3.88 //x2=17.14 //y2=3.88
r227 (  4 24 ) resistor r=9.3 //w=0.17 //l=0.17 //layer=mcon //count=1 \
 //x=9.74 //y=3.88 //x2=9.74 //y2=3.88
r228 (  2 4 ) resistor r=0.0717383 //w=0.224 //l=0.115 //layer=m1 \
 //thickness=0.36 //x=9.855 //y=3.88 //x2=9.74 //y2=3.88
r229 (  1 6 ) resistor r=0.0717383 //w=0.224 //l=0.115 //layer=m1 \
 //thickness=0.36 //x=17.025 //y=3.88 //x2=17.14 //y2=3.88
r230 (  1 2 ) resistor r=6.8416 //w=0.131 //l=7.17 //layer=m1 //thickness=0.36 \
 //x=17.025 //y=3.88 //x2=9.855 //y2=3.88
ends PM_DLATCHN\%noxref_8

subckt PM_DLATCHN\%Q ( 1 2 7 8 9 10 11 12 13 14 15 16 21 22 33 34 35 47 57 59 \
 60 61 62 63 64 65 69 71 74 76 77 82 92 93 96 )
c167 ( 96 0 ) capacitor c=0.0159573f //x=17.995 //y=5.205
c168 ( 93 0 ) capacitor c=0.00923651f //x=17.99 //y=1.085
c169 ( 92 0 ) capacitor c=0.007684f //x=17.02 //y=1.085
c170 ( 82 0 ) capacitor c=0.0402699f //x=20.315 //y=4.885
c171 ( 77 0 ) capacitor c=0.0321911f //x=20.805 //y=1.43
c172 ( 76 0 ) capacitor c=0.0185201f //x=20.805 //y=1.085
c173 ( 74 0 ) capacitor c=0.0288104f //x=20.735 //y=4.975
c174 ( 71 0 ) capacitor c=0.0133656f //x=20.65 //y=1.585
c175 ( 69 0 ) capacitor c=0.0157804f //x=20.65 //y=0.93
c176 ( 65 0 ) capacitor c=0.0822075f //x=20.275 //y=2.095
c177 ( 64 0 ) capacitor c=0.022867f //x=20.275 //y=1.74
c178 ( 63 0 ) capacitor c=0.0234318f //x=20.275 //y=1.43
c179 ( 62 0 ) capacitor c=0.0192004f //x=20.275 //y=1.085
c180 ( 61 0 ) capacitor c=0.110795f //x=20.81 //y=6.205
c181 ( 60 0 ) capacitor c=0.153847f //x=20.37 //y=6.205
c182 ( 57 0 ) capacitor c=0.00993392f //x=20.315 //y=4.885
c183 ( 55 0 ) capacitor c=0.00454201f //x=18.18 //y=1.835
c184 ( 47 0 ) capacitor c=0.0893171f //x=20.47 //y=2.26
c185 ( 35 0 ) capacitor c=0.0140918f //x=18.535 //y=1.835
c186 ( 34 0 ) capacitor c=0.00308317f //x=18.225 //y=5.39
c187 ( 33 0 ) capacitor c=0.0137261f //x=18.535 //y=5.39
c188 ( 22 0 ) capacitor c=0.00224268f //x=17.295 //y=1.835
c189 ( 21 0 ) capacitor c=0.0218623f //x=18.095 //y=1.835
c190 ( 7 0 ) capacitor c=0.110461f //x=18.62 //y=2.4
c191 ( 2 0 ) capacitor c=0.0112178f //x=18.735 //y=3.51
c192 ( 1 0 ) capacitor c=0.0678125f //x=20.355 //y=3.51
r193 (  84 85 ) resistor r=32.4568 //w=0.214 //l=0.075 //layer=ply \
 //thickness=0.18 //x=20.315 //y=4.975 //x2=20.315 //y2=5.05
r194 (  82 84 ) resistor r=20.271 //w=0.214 //l=0.09 //layer=ply \
 //thickness=0.18 //x=20.315 //y=4.885 //x2=20.315 //y2=4.975
r195 (  77 91 ) resistor r=45.1352 //w=0.168 //l=0.173853 //layer=ply \
 //thickness=0.18 //x=20.805 //y=1.43 //x2=20.765 //y2=1.585
r196 (  76 90 ) resistor r=45.1352 //w=0.168 //l=0.173853 //layer=ply \
 //thickness=0.18 //x=20.805 //y=1.085 //x2=20.765 //y2=0.93
r197 (  76 77 ) resistor r=176.904 //w=0.094 //l=0.345 //layer=ply \
 //thickness=0.18 //x=20.805 //y=1.085 //x2=20.805 //y2=1.43
r198 (  75 84 ) resistor r=16.5046 //w=0.27 //l=0.135 //layer=ply \
 //thickness=0.18 //x=20.45 //y=4.975 //x2=20.315 //y2=4.975
r199 (  74 78 ) resistor r=26.9307 //w=0.15 //l=0.106066 //layer=ply \
 //thickness=0.18 //x=20.735 //y=4.975 //x2=20.81 //y2=5.05
r200 (  74 75 ) resistor r=146.138 //w=0.094 //l=0.285 //layer=ply \
 //thickness=0.18 //x=20.735 //y=4.975 //x2=20.45 //y2=4.975
r201 (  72 89 ) resistor r=10.701 //w=0.21 //l=0.115 //layer=ply \
 //thickness=0.18 //x=20.43 //y=1.585 //x2=20.315 //y2=1.585
r202 (  71 91 ) resistor r=5.52526 //w=0.168 //l=0.115 //layer=ply \
 //thickness=0.18 //x=20.65 //y=1.585 //x2=20.765 //y2=1.585
r203 (  70 88 ) resistor r=5.52526 //w=0.168 //l=0.115 //layer=ply \
 //thickness=0.18 //x=20.43 //y=0.93 //x2=20.315 //y2=0.93
r204 (  69 90 ) resistor r=5.52526 //w=0.168 //l=0.115 //layer=ply \
 //thickness=0.18 //x=20.65 //y=0.93 //x2=20.765 //y2=0.93
r205 (  69 70 ) resistor r=112.809 //w=0.094 //l=0.22 //layer=ply \
 //thickness=0.18 //x=20.65 //y=0.93 //x2=20.43 //y2=0.93
r206 (  65 87 ) resistor r=34.8111 //w=0.27 //l=0.264953 //layer=ply \
 //thickness=0.18 //x=20.275 //y=2.095 //x2=20.47 //y2=2.26
r207 (  64 89 ) resistor r=39.5823 //w=0.21 //l=0.173853 //layer=ply \
 //thickness=0.18 //x=20.275 //y=1.74 //x2=20.315 //y2=1.585
r208 (  64 65 ) resistor r=182.032 //w=0.094 //l=0.355 //layer=ply \
 //thickness=0.18 //x=20.275 //y=1.74 //x2=20.275 //y2=2.095
r209 (  63 89 ) resistor r=39.5823 //w=0.21 //l=0.173853 //layer=ply \
 //thickness=0.18 //x=20.275 //y=1.43 //x2=20.315 //y2=1.585
r210 (  62 88 ) resistor r=45.1352 //w=0.168 //l=0.173853 //layer=ply \
 //thickness=0.18 //x=20.275 //y=1.085 //x2=20.315 //y2=0.93
r211 (  62 63 ) resistor r=176.904 //w=0.094 //l=0.345 //layer=ply \
 //thickness=0.18 //x=20.275 //y=1.085 //x2=20.275 //y2=1.43
r212 (  61 78 ) resistor r=592.245 //w=0.094 //l=1.155 //layer=ply \
 //thickness=0.18 //x=20.81 //y=6.205 //x2=20.81 //y2=5.05
r213 (  60 85 ) resistor r=592.245 //w=0.094 //l=1.155 //layer=ply \
 //thickness=0.18 //x=20.37 //y=6.205 //x2=20.37 //y2=5.05
r214 (  59 71 ) resistor r=56.4043 //w=0.094 //l=0.11 //layer=ply \
 //thickness=0.18 //x=20.54 //y=1.585 //x2=20.65 //y2=1.585
r215 (  59 72 ) resistor r=56.4043 //w=0.094 //l=0.11 //layer=ply \
 //thickness=0.18 //x=20.54 //y=1.585 //x2=20.43 //y2=1.585
r216 (  57 82 ) resistor r=152 //w=0.17 //l=0.17 //layer=licon //count=1 \
 //x=20.315 //y=4.885 //x2=20.315 //y2=4.885
r217 (  57 58 ) resistor r=7.81102 //w=0.254 //l=0.155 //layer=li \
 //thickness=0.1 //x=20.315 //y=4.885 //x2=20.47 //y2=4.885
r218 (  47 87 ) resistor r=152 //w=0.17 //l=0.17 //layer=licon //count=1 \
 //x=20.47 //y=2.26 //x2=20.47 //y2=2.26
r219 (  45 58 ) resistor r=3.23951 //w=0.254 //l=0.165 //layer=li \
 //thickness=0.1 //x=20.47 //y=4.72 //x2=20.47 //y2=4.885
r220 (  36 55 ) resistor r=5.4201 //w=0.17 //l=0.085 //layer=li \
 //thickness=0.1 //x=18.265 //y=1.835 //x2=18.18 //y2=1.835
r221 (  35 37 ) resistor r=7.15173 //w=0.17 //l=0.120208 //layer=li \
 //thickness=0.1 //x=18.535 //y=1.835 //x2=18.62 //y2=1.92
r222 (  35 36 ) resistor r=18.4813 //w=0.187 //l=0.27 //layer=li \
 //thickness=0.1 //x=18.535 //y=1.835 //x2=18.265 //y2=1.835
r223 (  33 38 ) resistor r=7.15173 //w=0.17 //l=0.120208 //layer=li \
 //thickness=0.1 //x=18.535 //y=5.39 //x2=18.62 //y2=5.305
r224 (  33 34 ) resistor r=21.2193 //w=0.187 //l=0.31 //layer=li \
 //thickness=0.1 //x=18.535 //y=5.39 //x2=18.225 //y2=5.39
r225 (  29 55 ) resistor r=1.40859 //w=0.34 //l=0.085 //layer=li \
 //thickness=0.1 //x=18.18 //y=1.75 //x2=18.18 //y2=1.835
r226 (  29 93 ) resistor r=39.016 //w=0.187 //l=0.57 //layer=li \
 //thickness=0.1 //x=18.18 //y=1.75 //x2=18.18 //y2=1.18
r227 (  23 34 ) resistor r=7.15173 //w=0.17 //l=0.120208 //layer=li \
 //thickness=0.1 //x=18.14 //y=5.475 //x2=18.225 //y2=5.39
r228 (  23 96 ) resistor r=29.0909 //w=0.187 //l=0.425 //layer=li \
 //thickness=0.1 //x=18.14 //y=5.475 //x2=18.14 //y2=5.9
r229 (  21 55 ) resistor r=5.4201 //w=0.17 //l=0.085 //layer=li \
 //thickness=0.1 //x=18.095 //y=1.835 //x2=18.18 //y2=1.835
r230 (  21 22 ) resistor r=54.7594 //w=0.187 //l=0.8 //layer=li \
 //thickness=0.1 //x=18.095 //y=1.835 //x2=17.295 //y2=1.835
r231 (  17 22 ) resistor r=7.15173 //w=0.17 //l=0.120208 //layer=li \
 //thickness=0.1 //x=17.21 //y=1.75 //x2=17.295 //y2=1.835
r232 (  17 92 ) resistor r=39.016 //w=0.187 //l=0.57 //layer=li \
 //thickness=0.1 //x=17.21 //y=1.75 //x2=17.21 //y2=1.18
r233 (  16 45 ) resistor r=6.84492 //w=0.187 //l=0.1 //layer=li \
 //thickness=0.1 //x=20.47 //y=4.62 //x2=20.47 //y2=4.72
r234 (  15 16 ) resistor r=75.9786 //w=0.187 //l=1.11 //layer=li \
 //thickness=0.1 //x=20.47 //y=3.51 //x2=20.47 //y2=4.62
r235 (  14 15 ) resistor r=25.3262 //w=0.187 //l=0.37 //layer=li \
 //thickness=0.1 //x=20.47 //y=3.14 //x2=20.47 //y2=3.51
r236 (  13 14 ) resistor r=25.3262 //w=0.187 //l=0.37 //layer=li \
 //thickness=0.1 //x=20.47 //y=2.77 //x2=20.47 //y2=3.14
r237 (  12 13 ) resistor r=25.3262 //w=0.187 //l=0.37 //layer=li \
 //thickness=0.1 //x=20.47 //y=2.4 //x2=20.47 //y2=2.77
r238 (  12 47 ) resistor r=9.58289 //w=0.187 //l=0.14 //layer=li \
 //thickness=0.1 //x=20.47 //y=2.4 //x2=20.47 //y2=2.26
r239 (  11 38 ) resistor r=46.8877 //w=0.187 //l=0.685 //layer=li \
 //thickness=0.1 //x=18.62 //y=4.62 //x2=18.62 //y2=5.305
r240 (  10 11 ) resistor r=75.9786 //w=0.187 //l=1.11 //layer=li \
 //thickness=0.1 //x=18.62 //y=3.51 //x2=18.62 //y2=4.62
r241 (  9 10 ) resistor r=25.3262 //w=0.187 //l=0.37 //layer=li \
 //thickness=0.1 //x=18.62 //y=3.14 //x2=18.62 //y2=3.51
r242 (  8 9 ) resistor r=25.3262 //w=0.187 //l=0.37 //layer=li //thickness=0.1 \
 //x=18.62 //y=2.77 //x2=18.62 //y2=3.14
r243 (  7 8 ) resistor r=25.3262 //w=0.187 //l=0.37 //layer=li //thickness=0.1 \
 //x=18.62 //y=2.4 //x2=18.62 //y2=2.77
r244 (  7 37 ) resistor r=32.8556 //w=0.187 //l=0.48 //layer=li \
 //thickness=0.1 //x=18.62 //y=2.4 //x2=18.62 //y2=1.92
r245 (  6 15 ) resistor r=9.3 //w=0.17 //l=0.17 //layer=mcon //count=1 \
 //x=20.47 //y=3.51 //x2=20.47 //y2=3.51
r246 (  4 10 ) resistor r=9.3 //w=0.17 //l=0.17 //layer=mcon //count=1 \
 //x=18.62 //y=3.51 //x2=18.62 //y2=3.51
r247 (  2 4 ) resistor r=0.0717383 //w=0.224 //l=0.115 //layer=m1 \
 //thickness=0.36 //x=18.735 //y=3.51 //x2=18.62 //y2=3.51
r248 (  1 6 ) resistor r=0.0717383 //w=0.224 //l=0.115 //layer=m1 \
 //thickness=0.36 //x=20.355 //y=3.51 //x2=20.47 //y2=3.51
r249 (  1 2 ) resistor r=1.5458 //w=0.131 //l=1.62 //layer=m1 //thickness=0.36 \
 //x=20.355 //y=3.51 //x2=18.735 //y2=3.51
ends PM_DLATCHN\%Q

subckt PM_DLATCHN\%noxref_10 ( 1 2 17 18 19 20 24 25 27 33 34 35 36 37 38 43 \
 45 47 53 54 56 57 60 68 70 )
c162 ( 70 0 ) capacitor c=0.028853f //x=14.78 //y=5.2
c163 ( 68 0 ) capacitor c=0.0173218f //x=14.735 //y=1.09
c164 ( 60 0 ) capacitor c=0.0354945f //x=21.245 //y=4.885
c165 ( 57 0 ) capacitor c=0.0279572f //x=21.21 //y=2.095
c166 ( 56 0 ) capacitor c=0.0422144f //x=21.21 //y=2.26
c167 ( 54 0 ) capacitor c=0.0237734f //x=21.775 //y=1.435
c168 ( 53 0 ) capacitor c=0.0191782f //x=21.775 //y=1.085
c169 ( 47 0 ) capacitor c=0.0346941f //x=21.62 //y=1.585
c170 ( 45 0 ) capacitor c=0.0157803f //x=21.62 //y=0.93
c171 ( 43 0 ) capacitor c=0.030194f //x=21.615 //y=4.975
c172 ( 38 0 ) capacitor c=0.0199921f //x=21.245 //y=1.74
c173 ( 37 0 ) capacitor c=0.0169608f //x=21.245 //y=1.435
c174 ( 36 0 ) capacitor c=0.0185462f //x=21.245 //y=1.085
c175 ( 35 0 ) capacitor c=0.15325f //x=21.69 //y=6.205
c176 ( 34 0 ) capacitor c=0.110232f //x=21.25 //y=6.205
c177 ( 27 0 ) capacitor c=0.0760752f //x=21.21 //y=2.26
c178 ( 25 0 ) capacitor c=0.00514985f //x=21.21 //y=4.72
c179 ( 24 0 ) capacitor c=0.0855616f //x=15.29 //y=4.25
c180 ( 20 0 ) capacitor c=0.00497659f //x=15.01 //y=4.76
c181 ( 19 0 ) capacitor c=0.012509f //x=15.205 //y=4.76
c182 ( 18 0 ) capacitor c=0.00612032f //x=15.005 //y=2.26
c183 ( 17 0 ) capacitor c=0.0138937f //x=15.205 //y=2.26
c184 ( 2 0 ) capacitor c=0.0119147f //x=15.405 //y=4.25
c185 ( 1 0 ) capacitor c=0.169542f //x=21.095 //y=4.25
r186 (  62 63 ) resistor r=32.4568 //w=0.214 //l=0.075 //layer=ply \
 //thickness=0.18 //x=21.245 //y=4.975 //x2=21.245 //y2=5.05
r187 (  60 62 ) resistor r=20.271 //w=0.214 //l=0.09 //layer=ply \
 //thickness=0.18 //x=21.245 //y=4.885 //x2=21.245 //y2=4.975
r188 (  56 57 ) resistor r=52.7279 //w=0.214 //l=0.165 //layer=ply \
 //thickness=0.18 //x=21.21 //y=2.26 //x2=21.21 //y2=2.095
r189 (  54 67 ) resistor r=4.95774 //w=0.164 //l=0.112 //layer=ply \
 //thickness=0.18 //x=21.775 //y=1.435 //x2=21.775 //y2=1.547
r190 (  53 66 ) resistor r=45.1352 //w=0.168 //l=0.173853 //layer=ply \
 //thickness=0.18 //x=21.775 //y=1.085 //x2=21.735 //y2=0.93
r191 (  53 54 ) resistor r=179.468 //w=0.094 //l=0.35 //layer=ply \
 //thickness=0.18 //x=21.775 //y=1.085 //x2=21.775 //y2=1.435
r192 (  48 65 ) resistor r=10.8103 //w=0.211 //l=0.115 //layer=ply \
 //thickness=0.18 //x=21.4 //y=1.585 //x2=21.285 //y2=1.585
r193 (  47 67 ) resistor r=45.9962 //w=0.164 //l=0.17296 //layer=ply \
 //thickness=0.18 //x=21.62 //y=1.585 //x2=21.775 //y2=1.547
r194 (  46 64 ) resistor r=5.52526 //w=0.168 //l=0.115 //layer=ply \
 //thickness=0.18 //x=21.4 //y=0.93 //x2=21.285 //y2=0.93
r195 (  45 66 ) resistor r=5.52526 //w=0.168 //l=0.115 //layer=ply \
 //thickness=0.18 //x=21.62 //y=0.93 //x2=21.735 //y2=0.93
r196 (  45 46 ) resistor r=112.809 //w=0.094 //l=0.22 //layer=ply \
 //thickness=0.18 //x=21.62 //y=0.93 //x2=21.4 //y2=0.93
r197 (  44 62 ) resistor r=16.5046 //w=0.27 //l=0.135 //layer=ply \
 //thickness=0.18 //x=21.38 //y=4.975 //x2=21.245 //y2=4.975
r198 (  43 50 ) resistor r=26.9307 //w=0.15 //l=0.106066 //layer=ply \
 //thickness=0.18 //x=21.615 //y=4.975 //x2=21.69 //y2=5.05
r199 (  43 44 ) resistor r=120.5 //w=0.094 //l=0.235 //layer=ply \
 //thickness=0.18 //x=21.615 //y=4.975 //x2=21.38 //y2=4.975
r200 (  38 65 ) resistor r=39.5036 //w=0.211 //l=0.173853 //layer=ply \
 //thickness=0.18 //x=21.245 //y=1.74 //x2=21.285 //y2=1.585
r201 (  38 57 ) resistor r=182.032 //w=0.094 //l=0.355 //layer=ply \
 //thickness=0.18 //x=21.245 //y=1.74 //x2=21.245 //y2=2.095
r202 (  37 65 ) resistor r=38.3614 //w=0.211 //l=0.168819 //layer=ply \
 //thickness=0.18 //x=21.245 //y=1.435 //x2=21.285 //y2=1.585
r203 (  36 64 ) resistor r=45.1352 //w=0.168 //l=0.173853 //layer=ply \
 //thickness=0.18 //x=21.245 //y=1.085 //x2=21.285 //y2=0.93
r204 (  36 37 ) resistor r=179.468 //w=0.094 //l=0.35 //layer=ply \
 //thickness=0.18 //x=21.245 //y=1.085 //x2=21.245 //y2=1.435
r205 (  35 50 ) resistor r=592.245 //w=0.094 //l=1.155 //layer=ply \
 //thickness=0.18 //x=21.69 //y=6.205 //x2=21.69 //y2=5.05
r206 (  34 63 ) resistor r=592.245 //w=0.094 //l=1.155 //layer=ply \
 //thickness=0.18 //x=21.25 //y=6.205 //x2=21.25 //y2=5.05
r207 (  33 47 ) resistor r=56.4043 //w=0.094 //l=0.11 //layer=ply \
 //thickness=0.18 //x=21.51 //y=1.585 //x2=21.62 //y2=1.585
r208 (  33 48 ) resistor r=56.4043 //w=0.094 //l=0.11 //layer=ply \
 //thickness=0.18 //x=21.51 //y=1.585 //x2=21.4 //y2=1.585
r209 (  32 60 ) resistor r=152 //w=0.17 //l=0.17 //layer=licon //count=1 \
 //x=21.245 //y=4.885 //x2=21.245 //y2=4.885
r210 (  27 56 ) resistor r=152 //w=0.17 //l=0.17 //layer=licon //count=1 \
 //x=21.21 //y=2.26 //x2=21.21 //y2=2.26
r211 (  27 30 ) resistor r=136.214 //w=0.187 //l=1.99 //layer=li \
 //thickness=0.1 //x=21.21 //y=2.26 //x2=21.21 //y2=4.25
r212 (  25 32 ) resistor r=11.332 //w=0.189 //l=0.173292 //layer=li \
 //thickness=0.1 //x=21.21 //y=4.72 //x2=21.227 //y2=4.885
r213 (  25 30 ) resistor r=32.1711 //w=0.187 //l=0.47 //layer=li \
 //thickness=0.1 //x=21.21 //y=4.72 //x2=21.21 //y2=4.25
r214 (  22 24 ) resistor r=29.0909 //w=0.187 //l=0.425 //layer=li \
 //thickness=0.1 //x=15.29 //y=4.675 //x2=15.29 //y2=4.25
r215 (  21 24 ) resistor r=130.396 //w=0.187 //l=1.905 //layer=li \
 //thickness=0.1 //x=15.29 //y=2.345 //x2=15.29 //y2=4.25
r216 (  19 22 ) resistor r=7.15173 //w=0.17 //l=0.120208 //layer=li \
 //thickness=0.1 //x=15.205 //y=4.76 //x2=15.29 //y2=4.675
r217 (  19 20 ) resistor r=13.3476 //w=0.187 //l=0.195 //layer=li \
 //thickness=0.1 //x=15.205 //y=4.76 //x2=15.01 //y2=4.76
r218 (  17 21 ) resistor r=7.15173 //w=0.17 //l=0.120208 //layer=li \
 //thickness=0.1 //x=15.205 //y=2.26 //x2=15.29 //y2=2.345
r219 (  17 18 ) resistor r=13.6898 //w=0.187 //l=0.2 //layer=li \
 //thickness=0.1 //x=15.205 //y=2.26 //x2=15.005 //y2=2.26
r220 (  11 20 ) resistor r=7.15173 //w=0.17 //l=0.120208 //layer=li \
 //thickness=0.1 //x=14.925 //y=4.845 //x2=15.01 //y2=4.76
r221 (  11 70 ) resistor r=72.5562 //w=0.187 //l=1.06 //layer=li \
 //thickness=0.1 //x=14.925 //y=4.845 //x2=14.925 //y2=5.905
r222 (  7 18 ) resistor r=7.15173 //w=0.17 //l=0.120208 //layer=li \
 //thickness=0.1 //x=14.92 //y=2.175 //x2=15.005 //y2=2.26
r223 (  7 68 ) resistor r=67.7647 //w=0.187 //l=0.99 //layer=li \
 //thickness=0.1 //x=14.92 //y=2.175 //x2=14.92 //y2=1.185
r224 (  6 30 ) resistor r=9.3 //w=0.17 //l=0.17 //layer=mcon //count=1 \
 //x=21.21 //y=4.25 //x2=21.21 //y2=4.25
r225 (  4 24 ) resistor r=9.3 //w=0.17 //l=0.17 //layer=mcon //count=1 \
 //x=15.29 //y=4.25 //x2=15.29 //y2=4.25
r226 (  2 4 ) resistor r=0.0717383 //w=0.224 //l=0.115 //layer=m1 \
 //thickness=0.36 //x=15.405 //y=4.25 //x2=15.29 //y2=4.25
r227 (  1 6 ) resistor r=0.0717383 //w=0.224 //l=0.115 //layer=m1 \
 //thickness=0.36 //x=21.095 //y=4.25 //x2=21.21 //y2=4.25
r228 (  1 2 ) resistor r=5.42939 //w=0.131 //l=5.69 //layer=m1 \
 //thickness=0.36 //x=21.095 //y=4.25 //x2=15.405 //y2=4.25
ends PM_DLATCHN\%noxref_10

subckt PM_DLATCHN\%noxref_11 ( 1 2 7 9 17 18 29 30 31 36 40 41 42 43 44 45 50 \
 52 54 60 61 63 64 67 75 76 79 )
c162 ( 79 0 ) capacitor c=0.0159573f //x=21.325 //y=5.205
c163 ( 76 0 ) capacitor c=0.00905936f //x=21.32 //y=1.085
c164 ( 75 0 ) capacitor c=0.007684f //x=20.35 //y=1.085
c165 ( 67 0 ) capacitor c=0.0354569f //x=17.915 //y=4.885
c166 ( 64 0 ) capacitor c=0.0279572f //x=17.88 //y=2.095
c167 ( 63 0 ) capacitor c=0.0422144f //x=17.88 //y=2.26
c168 ( 61 0 ) capacitor c=0.0237734f //x=18.445 //y=1.435
c169 ( 60 0 ) capacitor c=0.0191782f //x=18.445 //y=1.085
c170 ( 54 0 ) capacitor c=0.0346941f //x=18.29 //y=1.585
c171 ( 52 0 ) capacitor c=0.0157803f //x=18.29 //y=0.93
c172 ( 50 0 ) capacitor c=0.0295389f //x=18.285 //y=4.975
c173 ( 45 0 ) capacitor c=0.0199921f //x=17.915 //y=1.74
c174 ( 44 0 ) capacitor c=0.0169608f //x=17.915 //y=1.435
c175 ( 43 0 ) capacitor c=0.0185462f //x=17.915 //y=1.085
c176 ( 42 0 ) capacitor c=0.15325f //x=18.36 //y=6.205
c177 ( 41 0 ) capacitor c=0.110232f //x=17.92 //y=6.205
c178 ( 39 0 ) capacitor c=0.00454201f //x=21.51 //y=1.835
c179 ( 36 0 ) capacitor c=0.128643f //x=21.95 //y=3.88
c180 ( 31 0 ) capacitor c=0.0141769f //x=21.865 //y=1.835
c181 ( 30 0 ) capacitor c=0.00326058f //x=21.555 //y=5.39
c182 ( 29 0 ) capacitor c=0.014f //x=21.865 //y=5.39
c183 ( 18 0 ) capacitor c=0.00217843f //x=20.625 //y=1.835
c184 ( 17 0 ) capacitor c=0.0212471f //x=21.425 //y=1.835
c185 ( 9 0 ) capacitor c=0.0762833f //x=17.88 //y=2.26
c186 ( 7 0 ) capacitor c=0.00514991f //x=17.88 //y=4.72
c187 ( 2 0 ) capacitor c=0.00669602f //x=17.995 //y=3.88
c188 ( 1 0 ) capacitor c=0.100901f //x=21.835 //y=3.88
r189 (  69 70 ) resistor r=32.4568 //w=0.214 //l=0.075 //layer=ply \
 //thickness=0.18 //x=17.915 //y=4.975 //x2=17.915 //y2=5.05
r190 (  67 69 ) resistor r=20.271 //w=0.214 //l=0.09 //layer=ply \
 //thickness=0.18 //x=17.915 //y=4.885 //x2=17.915 //y2=4.975
r191 (  63 64 ) resistor r=52.7279 //w=0.214 //l=0.165 //layer=ply \
 //thickness=0.18 //x=17.88 //y=2.26 //x2=17.88 //y2=2.095
r192 (  61 74 ) resistor r=4.95774 //w=0.164 //l=0.112 //layer=ply \
 //thickness=0.18 //x=18.445 //y=1.435 //x2=18.445 //y2=1.547
r193 (  60 73 ) resistor r=45.1352 //w=0.168 //l=0.173853 //layer=ply \
 //thickness=0.18 //x=18.445 //y=1.085 //x2=18.405 //y2=0.93
r194 (  60 61 ) resistor r=179.468 //w=0.094 //l=0.35 //layer=ply \
 //thickness=0.18 //x=18.445 //y=1.085 //x2=18.445 //y2=1.435
r195 (  55 72 ) resistor r=10.8103 //w=0.211 //l=0.115 //layer=ply \
 //thickness=0.18 //x=18.07 //y=1.585 //x2=17.955 //y2=1.585
r196 (  54 74 ) resistor r=45.9962 //w=0.164 //l=0.17296 //layer=ply \
 //thickness=0.18 //x=18.29 //y=1.585 //x2=18.445 //y2=1.547
r197 (  53 71 ) resistor r=5.52526 //w=0.168 //l=0.115 //layer=ply \
 //thickness=0.18 //x=18.07 //y=0.93 //x2=17.955 //y2=0.93
r198 (  52 73 ) resistor r=5.52526 //w=0.168 //l=0.115 //layer=ply \
 //thickness=0.18 //x=18.29 //y=0.93 //x2=18.405 //y2=0.93
r199 (  52 53 ) resistor r=112.809 //w=0.094 //l=0.22 //layer=ply \
 //thickness=0.18 //x=18.29 //y=0.93 //x2=18.07 //y2=0.93
r200 (  51 69 ) resistor r=16.5046 //w=0.27 //l=0.135 //layer=ply \
 //thickness=0.18 //x=18.05 //y=4.975 //x2=17.915 //y2=4.975
r201 (  50 57 ) resistor r=26.9307 //w=0.15 //l=0.106066 //layer=ply \
 //thickness=0.18 //x=18.285 //y=4.975 //x2=18.36 //y2=5.05
r202 (  50 51 ) resistor r=120.5 //w=0.094 //l=0.235 //layer=ply \
 //thickness=0.18 //x=18.285 //y=4.975 //x2=18.05 //y2=4.975
r203 (  45 72 ) resistor r=39.5036 //w=0.211 //l=0.173853 //layer=ply \
 //thickness=0.18 //x=17.915 //y=1.74 //x2=17.955 //y2=1.585
r204 (  45 64 ) resistor r=182.032 //w=0.094 //l=0.355 //layer=ply \
 //thickness=0.18 //x=17.915 //y=1.74 //x2=17.915 //y2=2.095
r205 (  44 72 ) resistor r=38.3614 //w=0.211 //l=0.168819 //layer=ply \
 //thickness=0.18 //x=17.915 //y=1.435 //x2=17.955 //y2=1.585
r206 (  43 71 ) resistor r=45.1352 //w=0.168 //l=0.173853 //layer=ply \
 //thickness=0.18 //x=17.915 //y=1.085 //x2=17.955 //y2=0.93
r207 (  43 44 ) resistor r=179.468 //w=0.094 //l=0.35 //layer=ply \
 //thickness=0.18 //x=17.915 //y=1.085 //x2=17.915 //y2=1.435
r208 (  42 57 ) resistor r=592.245 //w=0.094 //l=1.155 //layer=ply \
 //thickness=0.18 //x=18.36 //y=6.205 //x2=18.36 //y2=5.05
r209 (  41 70 ) resistor r=592.245 //w=0.094 //l=1.155 //layer=ply \
 //thickness=0.18 //x=17.92 //y=6.205 //x2=17.92 //y2=5.05
r210 (  40 54 ) resistor r=56.4043 //w=0.094 //l=0.11 //layer=ply \
 //thickness=0.18 //x=18.18 //y=1.585 //x2=18.29 //y2=1.585
r211 (  40 55 ) resistor r=56.4043 //w=0.094 //l=0.11 //layer=ply \
 //thickness=0.18 //x=18.18 //y=1.585 //x2=18.07 //y2=1.585
r212 (  38 67 ) resistor r=152 //w=0.17 //l=0.17 //layer=licon //count=1 \
 //x=17.915 //y=4.885 //x2=17.915 //y2=4.885
r213 (  34 36 ) resistor r=97.5401 //w=0.187 //l=1.425 //layer=li \
 //thickness=0.1 //x=21.95 //y=5.305 //x2=21.95 //y2=3.88
r214 (  33 36 ) resistor r=134.16 //w=0.187 //l=1.96 //layer=li \
 //thickness=0.1 //x=21.95 //y=1.92 //x2=21.95 //y2=3.88
r215 (  32 39 ) resistor r=5.4201 //w=0.17 //l=0.085 //layer=li \
 //thickness=0.1 //x=21.595 //y=1.835 //x2=21.51 //y2=1.835
r216 (  31 33 ) resistor r=7.15173 //w=0.17 //l=0.120208 //layer=li \
 //thickness=0.1 //x=21.865 //y=1.835 //x2=21.95 //y2=1.92
r217 (  31 32 ) resistor r=18.4813 //w=0.187 //l=0.27 //layer=li \
 //thickness=0.1 //x=21.865 //y=1.835 //x2=21.595 //y2=1.835
r218 (  29 34 ) resistor r=7.15173 //w=0.17 //l=0.120208 //layer=li \
 //thickness=0.1 //x=21.865 //y=5.39 //x2=21.95 //y2=5.305
r219 (  29 30 ) resistor r=21.2193 //w=0.187 //l=0.31 //layer=li \
 //thickness=0.1 //x=21.865 //y=5.39 //x2=21.555 //y2=5.39
r220 (  25 39 ) resistor r=1.40859 //w=0.34 //l=0.085 //layer=li \
 //thickness=0.1 //x=21.51 //y=1.75 //x2=21.51 //y2=1.835
r221 (  25 76 ) resistor r=39.016 //w=0.187 //l=0.57 //layer=li \
 //thickness=0.1 //x=21.51 //y=1.75 //x2=21.51 //y2=1.18
r222 (  19 30 ) resistor r=7.15173 //w=0.17 //l=0.120208 //layer=li \
 //thickness=0.1 //x=21.47 //y=5.475 //x2=21.555 //y2=5.39
r223 (  19 79 ) resistor r=29.0909 //w=0.187 //l=0.425 //layer=li \
 //thickness=0.1 //x=21.47 //y=5.475 //x2=21.47 //y2=5.9
r224 (  17 39 ) resistor r=5.4201 //w=0.17 //l=0.085 //layer=li \
 //thickness=0.1 //x=21.425 //y=1.835 //x2=21.51 //y2=1.835
r225 (  17 18 ) resistor r=54.7594 //w=0.187 //l=0.8 //layer=li \
 //thickness=0.1 //x=21.425 //y=1.835 //x2=20.625 //y2=1.835
r226 (  13 18 ) resistor r=7.15173 //w=0.17 //l=0.120208 //layer=li \
 //thickness=0.1 //x=20.54 //y=1.75 //x2=20.625 //y2=1.835
r227 (  13 75 ) resistor r=39.016 //w=0.187 //l=0.57 //layer=li \
 //thickness=0.1 //x=20.54 //y=1.75 //x2=20.54 //y2=1.18
r228 (  9 63 ) resistor r=152 //w=0.17 //l=0.17 //layer=licon //count=1 \
 //x=17.88 //y=2.26 //x2=17.88 //y2=2.26
r229 (  9 12 ) resistor r=110.888 //w=0.187 //l=1.62 //layer=li \
 //thickness=0.1 //x=17.88 //y=2.26 //x2=17.88 //y2=3.88
r230 (  7 38 ) resistor r=11.332 //w=0.189 //l=0.173292 //layer=li \
 //thickness=0.1 //x=17.88 //y=4.72 //x2=17.897 //y2=4.885
r231 (  7 12 ) resistor r=57.4973 //w=0.187 //l=0.84 //layer=li \
 //thickness=0.1 //x=17.88 //y=4.72 //x2=17.88 //y2=3.88
r232 (  6 36 ) resistor r=9.3 //w=0.17 //l=0.17 //layer=mcon //count=1 \
 //x=21.95 //y=3.88 //x2=21.95 //y2=3.88
r233 (  4 12 ) resistor r=9.3 //w=0.17 //l=0.17 //layer=mcon //count=1 \
 //x=17.88 //y=3.88 //x2=17.88 //y2=3.88
r234 (  2 4 ) resistor r=0.0717383 //w=0.224 //l=0.115 //layer=m1 \
 //thickness=0.36 //x=17.995 //y=3.88 //x2=17.88 //y2=3.88
r235 (  1 6 ) resistor r=0.0717383 //w=0.224 //l=0.115 //layer=m1 \
 //thickness=0.36 //x=21.835 //y=3.88 //x2=21.95 //y2=3.88
r236 (  1 2 ) resistor r=3.66412 //w=0.131 //l=3.84 //layer=m1 \
 //thickness=0.36 //x=21.835 //y=3.88 //x2=17.995 //y2=3.88
ends PM_DLATCHN\%noxref_11

subckt PM_DLATCHN\%GATE_N ( 1 2 3 4 5 6 8 19 20 21 22 23 24 25 29 30 31 33 39 \
 40 42 )
c49 ( 42 0 ) capacitor c=0.0537799f //x=1.23 //y=2.265
c50 ( 40 0 ) capacitor c=0.0435629f //x=1.87 //y=1.435
c51 ( 39 0 ) capacitor c=0.0200386f //x=1.87 //y=1.09
c52 ( 33 0 ) capacitor c=0.0152946f //x=1.715 //y=1.59
c53 ( 31 0 ) capacitor c=0.0157804f //x=1.715 //y=0.935
c54 ( 30 0 ) capacitor c=0.0524167f //x=1.46 //y=4.97
c55 ( 29 0 ) capacitor c=0.0323991f //x=1.75 //y=4.97
c56 ( 25 0 ) capacitor c=0.0290017f //x=1.34 //y=2.1
c57 ( 24 0 ) capacitor c=0.0250027f //x=1.34 //y=1.745
c58 ( 23 0 ) capacitor c=0.0234316f //x=1.34 //y=1.435
c59 ( 22 0 ) capacitor c=0.0200596f //x=1.34 //y=1.09
c60 ( 21 0 ) capacitor c=0.154218f //x=1.825 //y=6.2
c61 ( 20 0 ) capacitor c=0.154243f //x=1.385 //y=6.2
c62 ( 8 0 ) capacitor c=0.114231f //x=1.23 //y=2.265
r63 (  42 43 ) resistor r=17.5563 //w=0.302 //l=0.11 //layer=ply \
 //thickness=0.18 //x=1.23 //y=2.265 //x2=1.34 //y2=2.265
r64 (  40 49 ) resistor r=45.1352 //w=0.168 //l=0.173853 //layer=ply \
 //thickness=0.18 //x=1.87 //y=1.435 //x2=1.83 //y2=1.59
r65 (  39 48 ) resistor r=45.1352 //w=0.168 //l=0.173853 //layer=ply \
 //thickness=0.18 //x=1.87 //y=1.09 //x2=1.83 //y2=0.935
r66 (  39 40 ) resistor r=176.904 //w=0.094 //l=0.345 //layer=ply \
 //thickness=0.18 //x=1.87 //y=1.09 //x2=1.87 //y2=1.435
r67 (  34 47 ) resistor r=10.701 //w=0.21 //l=0.115 //layer=ply \
 //thickness=0.18 //x=1.495 //y=1.59 //x2=1.38 //y2=1.59
r68 (  33 49 ) resistor r=5.52526 //w=0.168 //l=0.115 //layer=ply \
 //thickness=0.18 //x=1.715 //y=1.59 //x2=1.83 //y2=1.59
r69 (  32 46 ) resistor r=5.52526 //w=0.168 //l=0.115 //layer=ply \
 //thickness=0.18 //x=1.495 //y=0.935 //x2=1.38 //y2=0.935
r70 (  31 48 ) resistor r=5.52526 //w=0.168 //l=0.115 //layer=ply \
 //thickness=0.18 //x=1.715 //y=0.935 //x2=1.83 //y2=0.935
r71 (  31 32 ) resistor r=112.809 //w=0.094 //l=0.22 //layer=ply \
 //thickness=0.18 //x=1.715 //y=0.935 //x2=1.495 //y2=0.935
r72 (  29 36 ) resistor r=26.9307 //w=0.15 //l=0.106066 //layer=ply \
 //thickness=0.18 //x=1.75 //y=4.97 //x2=1.825 //y2=5.045
r73 (  29 30 ) resistor r=148.702 //w=0.094 //l=0.29 //layer=ply \
 //thickness=0.18 //x=1.75 //y=4.97 //x2=1.46 //y2=4.97
r74 (  26 30 ) resistor r=23.403 //w=0.284 //l=0.106066 //layer=ply \
 //thickness=0.18 //x=1.385 //y=5.045 //x2=1.46 //y2=4.97
r75 (  26 45 ) resistor r=26.3063 //w=0.284 //l=0.229783 //layer=ply \
 //thickness=0.18 //x=1.385 //y=5.045 //x2=1.23 //y2=4.88
r76 (  25 43 ) resistor r=19.1248 //w=0.302 //l=0.165 //layer=ply \
 //thickness=0.18 //x=1.34 //y=2.1 //x2=1.34 //y2=2.265
r77 (  24 47 ) resistor r=39.5823 //w=0.21 //l=0.173853 //layer=ply \
 //thickness=0.18 //x=1.34 //y=1.745 //x2=1.38 //y2=1.59
r78 (  24 25 ) resistor r=182.032 //w=0.094 //l=0.355 //layer=ply \
 //thickness=0.18 //x=1.34 //y=1.745 //x2=1.34 //y2=2.1
r79 (  23 47 ) resistor r=39.5823 //w=0.21 //l=0.173853 //layer=ply \
 //thickness=0.18 //x=1.34 //y=1.435 //x2=1.38 //y2=1.59
r80 (  22 46 ) resistor r=45.1352 //w=0.168 //l=0.173853 //layer=ply \
 //thickness=0.18 //x=1.34 //y=1.09 //x2=1.38 //y2=0.935
r81 (  22 23 ) resistor r=176.904 //w=0.094 //l=0.345 //layer=ply \
 //thickness=0.18 //x=1.34 //y=1.09 //x2=1.34 //y2=1.435
r82 (  21 36 ) resistor r=592.245 //w=0.094 //l=1.155 //layer=ply \
 //thickness=0.18 //x=1.825 //y=6.2 //x2=1.825 //y2=5.045
r83 (  20 26 ) resistor r=592.245 //w=0.094 //l=1.155 //layer=ply \
 //thickness=0.18 //x=1.385 //y=6.2 //x2=1.385 //y2=5.045
r84 (  19 33 ) resistor r=56.4043 //w=0.094 //l=0.11 //layer=ply \
 //thickness=0.18 //x=1.605 //y=1.59 //x2=1.715 //y2=1.59
r85 (  19 34 ) resistor r=56.4043 //w=0.094 //l=0.11 //layer=ply \
 //thickness=0.18 //x=1.605 //y=1.59 //x2=1.495 //y2=1.59
r86 (  17 45 ) resistor r=152 //w=0.17 //l=0.17 //layer=licon //count=1 \
 //x=1.23 //y=4.88 //x2=1.23 //y2=4.88
r87 (  8 42 ) resistor r=152 //w=0.17 //l=0.17 //layer=licon //count=1 \
 //x=1.23 //y=2.265 //x2=1.23 //y2=2.265
r88 (  6 17 ) resistor r=17.7968 //w=0.187 //l=0.26 //layer=li //thickness=0.1 \
 //x=1.23 //y=4.62 //x2=1.23 //y2=4.88
r89 (  5 6 ) resistor r=25.3262 //w=0.187 //l=0.37 //layer=li //thickness=0.1 \
 //x=1.23 //y=4.25 //x2=1.23 //y2=4.62
r90 (  4 5 ) resistor r=25.3262 //w=0.187 //l=0.37 //layer=li //thickness=0.1 \
 //x=1.23 //y=3.88 //x2=1.23 //y2=4.25
r91 (  3 4 ) resistor r=25.3262 //w=0.187 //l=0.37 //layer=li //thickness=0.1 \
 //x=1.23 //y=3.51 //x2=1.23 //y2=3.88
r92 (  2 3 ) resistor r=25.3262 //w=0.187 //l=0.37 //layer=li //thickness=0.1 \
 //x=1.23 //y=3.14 //x2=1.23 //y2=3.51
r93 (  1 2 ) resistor r=25.3262 //w=0.187 //l=0.37 //layer=li //thickness=0.1 \
 //x=1.23 //y=2.77 //x2=1.23 //y2=3.14
r94 (  1 8 ) resistor r=34.5668 //w=0.187 //l=0.505 //layer=li //thickness=0.1 \
 //x=1.23 //y=2.77 //x2=1.23 //y2=2.265
ends PM_DLATCHN\%GATE_N

subckt PM_DLATCHN\%noxref_13 ( 1 5 9 10 13 17 29 )
c54 ( 29 0 ) capacitor c=0.0631306f //x=5.49 //y=0.545
c55 ( 17 0 ) capacitor c=0.00722223f //x=7.565 //y=0.795
c56 ( 13 0 ) capacitor c=0.0149611f //x=7.48 //y=0.71
c57 ( 10 0 ) capacitor c=0.00638024f //x=6.595 //y=1.675
c58 ( 9 0 ) capacitor c=0.006761f //x=6.595 //y=0.795
c59 ( 5 0 ) capacitor c=0.0189075f //x=6.51 //y=1.76
c60 ( 1 0 ) capacitor c=0.00798521f //x=5.625 //y=1.675
r61 (  17 29 ) resistor r=3.57586 //w=0.17 //l=0.125 //layer=li \
 //thickness=0.1 //x=7.565 //y=0.795 //x2=7.565 //y2=0.67
r62 (  17 29 ) resistor r=18.139 //w=0.187 //l=0.265 //layer=li \
 //thickness=0.1 //x=7.565 //y=0.795 //x2=7.565 //y2=1.06
r63 (  14 29 ) resistor r=3.57586 //w=0.17 //l=0.103078 //layer=li \
 //thickness=0.1 //x=6.68 //y=0.71 //x2=6.595 //y2=0.67
r64 (  14 29 ) resistor r=27.3797 //w=0.187 //l=0.4 //layer=li //thickness=0.1 \
 //x=6.68 //y=0.71 //x2=7.08 //y2=0.71
r65 (  13 29 ) resistor r=3.57586 //w=0.17 //l=0.103078 //layer=li \
 //thickness=0.1 //x=7.48 //y=0.71 //x2=7.565 //y2=0.67
r66 (  13 29 ) resistor r=27.3797 //w=0.187 //l=0.4 //layer=li //thickness=0.1 \
 //x=7.48 //y=0.71 //x2=7.08 //y2=0.71
r67 (  10 29 ) resistor r=3.57586 //w=0.17 //l=0.125 //layer=li \
 //thickness=0.1 //x=6.595 //y=1.675 //x2=6.595 //y2=1.8
r68 (  10 29 ) resistor r=42.0963 //w=0.187 //l=0.615 //layer=li \
 //thickness=0.1 //x=6.595 //y=1.675 //x2=6.595 //y2=1.06
r69 (  9 29 ) resistor r=3.57586 //w=0.17 //l=0.125 //layer=li //thickness=0.1 \
 //x=6.595 //y=0.795 //x2=6.595 //y2=0.67
r70 (  9 29 ) resistor r=18.139 //w=0.187 //l=0.265 //layer=li //thickness=0.1 \
 //x=6.595 //y=0.795 //x2=6.595 //y2=1.06
r71 (  6 29 ) resistor r=3.57586 //w=0.17 //l=0.103078 //layer=li \
 //thickness=0.1 //x=5.71 //y=1.76 //x2=5.625 //y2=1.8
r72 (  6 29 ) resistor r=27.3797 //w=0.187 //l=0.4 //layer=li //thickness=0.1 \
 //x=5.71 //y=1.76 //x2=6.11 //y2=1.76
r73 (  5 29 ) resistor r=3.57586 //w=0.17 //l=0.103078 //layer=li \
 //thickness=0.1 //x=6.51 //y=1.76 //x2=6.595 //y2=1.8
r74 (  5 29 ) resistor r=27.3797 //w=0.187 //l=0.4 //layer=li //thickness=0.1 \
 //x=6.51 //y=1.76 //x2=6.11 //y2=1.76
r75 (  1 29 ) resistor r=3.57586 //w=0.17 //l=0.125 //layer=li //thickness=0.1 \
 //x=5.625 //y=1.675 //x2=5.625 //y2=1.8
r76 (  1 29 ) resistor r=42.0963 //w=0.187 //l=0.615 //layer=li \
 //thickness=0.1 //x=5.625 //y=1.675 //x2=5.625 //y2=1.06
ends PM_DLATCHN\%noxref_13

subckt PM_DLATCHN\%noxref_14 ( 1 5 9 10 13 17 29 )
c54 ( 29 0 ) capacitor c=0.0633899f //x=11.04 //y=0.545
c55 ( 17 0 ) capacitor c=0.00722223f //x=13.115 //y=0.795
c56 ( 13 0 ) capacitor c=0.0149613f //x=13.03 //y=0.71
c57 ( 10 0 ) capacitor c=0.00687696f //x=12.145 //y=1.675
c58 ( 9 0 ) capacitor c=0.006761f //x=12.145 //y=0.795
c59 ( 5 0 ) capacitor c=0.0199444f //x=12.06 //y=1.76
c60 ( 1 0 ) capacitor c=0.00798521f //x=11.175 //y=1.675
r61 (  17 29 ) resistor r=3.57586 //w=0.17 //l=0.125 //layer=li \
 //thickness=0.1 //x=13.115 //y=0.795 //x2=13.115 //y2=0.67
r62 (  17 29 ) resistor r=18.139 //w=0.187 //l=0.265 //layer=li \
 //thickness=0.1 //x=13.115 //y=0.795 //x2=13.115 //y2=1.06
r63 (  14 29 ) resistor r=3.57586 //w=0.17 //l=0.103078 //layer=li \
 //thickness=0.1 //x=12.23 //y=0.71 //x2=12.145 //y2=0.67
r64 (  14 29 ) resistor r=27.3797 //w=0.187 //l=0.4 //layer=li //thickness=0.1 \
 //x=12.23 //y=0.71 //x2=12.63 //y2=0.71
r65 (  13 29 ) resistor r=3.57586 //w=0.17 //l=0.103078 //layer=li \
 //thickness=0.1 //x=13.03 //y=0.71 //x2=13.115 //y2=0.67
r66 (  13 29 ) resistor r=27.3797 //w=0.187 //l=0.4 //layer=li //thickness=0.1 \
 //x=13.03 //y=0.71 //x2=12.63 //y2=0.71
r67 (  10 29 ) resistor r=3.57586 //w=0.17 //l=0.125 //layer=li \
 //thickness=0.1 //x=12.145 //y=1.675 //x2=12.145 //y2=1.8
r68 (  10 29 ) resistor r=42.0963 //w=0.187 //l=0.615 //layer=li \
 //thickness=0.1 //x=12.145 //y=1.675 //x2=12.145 //y2=1.06
r69 (  9 29 ) resistor r=3.57586 //w=0.17 //l=0.125 //layer=li //thickness=0.1 \
 //x=12.145 //y=0.795 //x2=12.145 //y2=0.67
r70 (  9 29 ) resistor r=18.139 //w=0.187 //l=0.265 //layer=li //thickness=0.1 \
 //x=12.145 //y=0.795 //x2=12.145 //y2=1.06
r71 (  6 29 ) resistor r=3.57586 //w=0.17 //l=0.103078 //layer=li \
 //thickness=0.1 //x=11.26 //y=1.76 //x2=11.175 //y2=1.8
r72 (  6 29 ) resistor r=27.3797 //w=0.187 //l=0.4 //layer=li //thickness=0.1 \
 //x=11.26 //y=1.76 //x2=11.66 //y2=1.76
r73 (  5 29 ) resistor r=3.57586 //w=0.17 //l=0.103078 //layer=li \
 //thickness=0.1 //x=12.06 //y=1.76 //x2=12.145 //y2=1.8
r74 (  5 29 ) resistor r=27.3797 //w=0.187 //l=0.4 //layer=li //thickness=0.1 \
 //x=12.06 //y=1.76 //x2=11.66 //y2=1.76
r75 (  1 29 ) resistor r=3.57586 //w=0.17 //l=0.125 //layer=li //thickness=0.1 \
 //x=11.175 //y=1.675 //x2=11.175 //y2=1.8
r76 (  1 29 ) resistor r=42.0963 //w=0.187 //l=0.615 //layer=li \
 //thickness=0.1 //x=11.175 //y=1.675 //x2=11.175 //y2=1.06
ends PM_DLATCHN\%noxref_14

subckt PM_DLATCHN\%noxref_15 ( 7 8 15 16 23 24 25 )
c43 ( 25 0 ) capacitor c=0.0306628f //x=18.435 //y=5.205
c44 ( 24 0 ) capacitor c=0.0185379f //x=17.555 //y=5.205
c45 ( 23 0 ) capacitor c=0.0409962f //x=16.685 //y=5.205
c46 ( 16 0 ) capacitor c=0.00193672f //x=17.785 //y=7.09
c47 ( 15 0 ) capacitor c=0.0129692f //x=18.495 //y=7.09
c48 ( 8 0 ) capacitor c=0.00576007f //x=16.905 //y=5.39
c49 ( 7 0 ) capacitor c=0.0170172f //x=17.615 //y=5.39
r50 (  17 25 ) resistor r=5.81818 //w=0.187 //l=0.085 //layer=li \
 //thickness=0.1 //x=18.58 //y=7.005 //x2=18.58 //y2=6.92
r51 (  15 17 ) resistor r=7.15173 //w=0.17 //l=0.120208 //layer=li \
 //thickness=0.1 //x=18.495 //y=7.09 //x2=18.58 //y2=7.005
r52 (  15 16 ) resistor r=48.5989 //w=0.187 //l=0.71 //layer=li \
 //thickness=0.1 //x=18.495 //y=7.09 //x2=17.785 //y2=7.09
r53 (  10 16 ) resistor r=7.15173 //w=0.17 //l=0.120208 //layer=li \
 //thickness=0.1 //x=17.7 //y=7.005 //x2=17.785 //y2=7.09
r54 (  10 24 ) resistor r=29.0909 //w=0.187 //l=0.425 //layer=li \
 //thickness=0.1 //x=17.7 //y=7.005 //x2=17.7 //y2=6.58
r55 (  9 24 ) resistor r=29.0909 //w=0.187 //l=0.425 //layer=li \
 //thickness=0.1 //x=17.7 //y=5.475 //x2=17.7 //y2=5.9
r56 (  7 9 ) resistor r=7.15173 //w=0.17 //l=0.120208 //layer=li \
 //thickness=0.1 //x=17.615 //y=5.39 //x2=17.7 //y2=5.475
r57 (  7 8 ) resistor r=48.5989 //w=0.187 //l=0.71 //layer=li //thickness=0.1 \
 //x=17.615 //y=5.39 //x2=16.905 //y2=5.39
r58 (  1 8 ) resistor r=7.15173 //w=0.17 //l=0.120208 //layer=li \
 //thickness=0.1 //x=16.82 //y=5.475 //x2=16.905 //y2=5.39
r59 (  1 23 ) resistor r=29.0909 //w=0.187 //l=0.425 //layer=li \
 //thickness=0.1 //x=16.82 //y=5.475 //x2=16.82 //y2=5.9
ends PM_DLATCHN\%noxref_15

subckt PM_DLATCHN\%noxref_16 ( 7 8 15 16 23 24 25 )
c42 ( 25 0 ) capacitor c=0.0307189f //x=21.765 //y=5.205
c43 ( 24 0 ) capacitor c=0.0185379f //x=20.885 //y=5.205
c44 ( 23 0 ) capacitor c=0.0410313f //x=20.015 //y=5.205
c45 ( 16 0 ) capacitor c=0.00193672f //x=21.115 //y=7.09
c46 ( 15 0 ) capacitor c=0.0132919f //x=21.825 //y=7.09
c47 ( 8 0 ) capacitor c=0.0056411f //x=20.235 //y=5.39
c48 ( 7 0 ) capacitor c=0.0169676f //x=20.945 //y=5.39
r49 (  17 25 ) resistor r=5.81818 //w=0.187 //l=0.085 //layer=li \
 //thickness=0.1 //x=21.91 //y=7.005 //x2=21.91 //y2=6.92
r50 (  15 17 ) resistor r=7.15173 //w=0.17 //l=0.120208 //layer=li \
 //thickness=0.1 //x=21.825 //y=7.09 //x2=21.91 //y2=7.005
r51 (  15 16 ) resistor r=48.5989 //w=0.187 //l=0.71 //layer=li \
 //thickness=0.1 //x=21.825 //y=7.09 //x2=21.115 //y2=7.09
r52 (  10 16 ) resistor r=7.15173 //w=0.17 //l=0.120208 //layer=li \
 //thickness=0.1 //x=21.03 //y=7.005 //x2=21.115 //y2=7.09
r53 (  10 24 ) resistor r=29.0909 //w=0.187 //l=0.425 //layer=li \
 //thickness=0.1 //x=21.03 //y=7.005 //x2=21.03 //y2=6.58
r54 (  9 24 ) resistor r=29.0909 //w=0.187 //l=0.425 //layer=li \
 //thickness=0.1 //x=21.03 //y=5.475 //x2=21.03 //y2=5.9
r55 (  7 9 ) resistor r=7.15173 //w=0.17 //l=0.120208 //layer=li \
 //thickness=0.1 //x=20.945 //y=5.39 //x2=21.03 //y2=5.475
r56 (  7 8 ) resistor r=48.5989 //w=0.187 //l=0.71 //layer=li //thickness=0.1 \
 //x=20.945 //y=5.39 //x2=20.235 //y2=5.39
r57 (  1 8 ) resistor r=7.15173 //w=0.17 //l=0.120208 //layer=li \
 //thickness=0.1 //x=20.15 //y=5.475 //x2=20.235 //y2=5.39
r58 (  1 23 ) resistor r=29.0909 //w=0.187 //l=0.425 //layer=li \
 //thickness=0.1 //x=20.15 //y=5.475 //x2=20.15 //y2=5.9
ends PM_DLATCHN\%noxref_16
