// File: nmos_top.spi.pex
// Created: Sun Mar 15 12:51:07 2026
// Program "Calibre xRC"
// Version "v2023.2_27.15"
// Nominal Temperature: 30C
// Circuit Temperature: 30C
//
simulator lang=spectre
