// File: aoi3x1_pcell.spi.AOI3X1_PCELL.pxi
// Created: Sun Apr 12 08:39:33 2026
//
simulator lang=spectre
x_PM_AOI3X1_PCELL\%noxref_1 ( N_noxref_1_c_1_p N_noxref_1_c_88_p \
 N_noxref_1_c_2_p N_noxref_1_c_67_p N_noxref_1_c_252_p N_noxref_1_c_56_p \
 N_noxref_1_c_68_p N_noxref_1_c_25_p N_noxref_1_c_91_p N_noxref_1_c_69_p \
 N_noxref_1_c_29_p N_noxref_1_c_3_p N_noxref_1_c_4_p N_noxref_1_c_5_p \
 N_noxref_1_c_70_p N_noxref_1_c_48_p N_noxref_1_c_50_p N_noxref_1_c_71_p \
 N_noxref_1_c_32_p N_noxref_1_c_33_p N_noxref_1_c_111_p N_noxref_1_c_182_p \
 N_noxref_1_c_6_p N_noxref_1_c_7_p N_noxref_1_c_22_p N_noxref_1_c_82_p \
 N_noxref_1_M2_noxref_g N_noxref_1_M8_noxref_g N_noxref_1_M9_noxref_g \
 N_noxref_1_c_83_p N_noxref_1_c_197_p N_noxref_1_c_198_p N_noxref_1_c_84_p \
 N_noxref_1_c_219_p N_noxref_1_c_220_p N_noxref_1_c_53_p N_noxref_1_c_85_p \
 N_noxref_1_c_103_p N_noxref_1_c_37_p N_noxref_1_M1_noxref_d \
 N_noxref_1_M4_noxref_d N_noxref_1_M6_noxref_d )  PM_AOI3X1_PCELL\%noxref_1
x_PM_AOI3X1_PCELL\%noxref_2 ( N_noxref_2_c_262_n N_noxref_2_c_269_n \
 N_noxref_2_c_271_n N_noxref_2_c_339_p N_noxref_2_c_273_n N_noxref_2_c_276_n \
 N_noxref_2_c_281_n N_noxref_2_c_286_n N_noxref_2_c_289_n \
 N_noxref_2_M4_noxref_s N_noxref_2_M5_noxref_d N_noxref_2_M7_noxref_d \
 N_noxref_2_M8_noxref_d )  PM_AOI3X1_PCELL\%noxref_2
x_PM_AOI3X1_PCELL\%noxref_3 ( N_noxref_3_c_409_p N_noxref_3_c_385_n \
 N_noxref_3_c_387_n N_noxref_3_c_411_p N_noxref_3_c_389_n \
 N_noxref_3_M0_noxref_g N_noxref_3_M4_noxref_g N_noxref_3_M5_noxref_g \
 N_noxref_3_c_412_p N_noxref_3_c_413_p N_noxref_3_c_414_p N_noxref_3_c_427_p \
 N_noxref_3_c_415_p N_noxref_3_c_416_p N_noxref_3_c_417_p N_noxref_3_c_418_p \
 N_noxref_3_c_396_n )  PM_AOI3X1_PCELL\%noxref_3
x_PM_AOI3X1_PCELL\%noxref_4 ( N_noxref_4_c_521_n N_noxref_4_c_481_n \
 N_noxref_4_c_487_n N_noxref_4_c_531_n N_noxref_4_c_490_n N_noxref_4_c_492_n \
 N_noxref_4_c_607_p N_noxref_4_c_494_n N_noxref_4_c_552_p N_noxref_4_c_500_n \
 N_noxref_4_c_502_n N_noxref_4_M0_noxref_d N_noxref_4_M2_noxref_s )  \
 PM_AOI3X1_PCELL\%noxref_4
x_PM_AOI3X1_PCELL\%noxref_5 ( N_noxref_5_c_619_n N_noxref_5_c_627_n \
 N_noxref_5_c_629_n N_noxref_5_c_630_n N_noxref_5_M1_noxref_g \
 N_noxref_5_M6_noxref_g N_noxref_5_M7_noxref_g N_noxref_5_c_638_n \
 N_noxref_5_c_640_n N_noxref_5_c_643_n N_noxref_5_c_644_n N_noxref_5_c_647_n \
 N_noxref_5_c_649_n N_noxref_5_c_653_n N_noxref_5_c_655_n N_noxref_5_c_659_n \
 N_noxref_5_c_660_n N_noxref_5_c_662_n )  PM_AOI3X1_PCELL\%noxref_5
x_PM_AOI3X1_PCELL\%noxref_6 ( N_noxref_6_c_723_n N_noxref_6_c_749_n \
 N_noxref_6_c_729_n N_noxref_6_c_736_n N_noxref_6_c_737_n N_noxref_6_c_757_n \
 N_noxref_6_c_738_n N_noxref_6_c_742_n N_noxref_6_M8_noxref_s \
 N_noxref_6_M9_noxref_d N_noxref_6_M11_noxref_d )  PM_AOI3X1_PCELL\%noxref_6
x_PM_AOI3X1_PCELL\%noxref_7 ( N_noxref_7_c_806_n N_noxref_7_c_809_n \
 N_noxref_7_c_812_n N_noxref_7_c_820_n N_noxref_7_c_824_n \
 N_noxref_7_M3_noxref_g N_noxref_7_M10_noxref_g N_noxref_7_M11_noxref_g \
 N_noxref_7_c_831_n N_noxref_7_c_833_n N_noxref_7_c_836_n N_noxref_7_c_853_n \
 N_noxref_7_c_887_p N_noxref_7_c_838_n N_noxref_7_c_839_n N_noxref_7_c_840_n \
 N_noxref_7_c_841_n N_noxref_7_c_844_n N_noxref_7_c_845_n )  \
 PM_AOI3X1_PCELL\%noxref_7
x_PM_AOI3X1_PCELL\%noxref_8 ( N_noxref_8_c_918_n N_noxref_8_c_927_n \
 N_noxref_8_c_933_n N_noxref_8_c_934_n N_noxref_8_c_973_n N_noxref_8_c_940_n \
 N_noxref_8_c_956_n N_noxref_8_c_979_n N_noxref_8_c_942_n N_noxref_8_c_946_n \
 N_noxref_8_c_961_n N_noxref_8_M2_noxref_d N_noxref_8_M3_noxref_d \
 N_noxref_8_M10_noxref_d )  PM_AOI3X1_PCELL\%noxref_8
x_PM_AOI3X1_PCELL\%noxref_9 ( N_noxref_9_c_1052_n N_noxref_9_c_1053_n \
 N_noxref_9_c_1068_n N_noxref_9_c_1042_n N_noxref_9_c_1043_n \
 N_noxref_9_c_1078_n N_noxref_9_M0_noxref_s )  PM_AOI3X1_PCELL\%noxref_9
cc_1 ( N_noxref_1_c_1_p N_noxref_2_c_262_n ) capacitor c=0.00647565f //x=1.995 \
 //y=5.2 //x2=4.475 //y2=7.4
cc_2 ( N_noxref_1_c_2_p N_noxref_2_c_262_n ) capacitor c=0.0048744f //x=2.505 \
 //y=5.2 //x2=4.475 //y2=7.4
cc_3 ( N_noxref_1_c_3_p N_noxref_2_c_262_n ) capacitor c=0.00368144f //x=1.23 \
 //y=5.38 //x2=4.475 //y2=7.4
cc_4 ( N_noxref_1_c_4_p N_noxref_2_c_262_n ) capacitor c=8.41206e-19 //x=2.11 \
 //y=5.2 //x2=4.475 //y2=7.4
cc_5 ( N_noxref_1_c_5_p N_noxref_2_c_262_n ) capacitor c=0.00285294f //x=2.11 \
 //y=5.38 //x2=4.475 //y2=7.4
cc_6 ( N_noxref_1_c_6_p N_noxref_2_c_262_n ) capacitor c=0.00224727f //x=1.23 \
 //y=5.38 //x2=4.475 //y2=7.4
cc_7 ( N_noxref_1_c_7_p N_noxref_2_c_262_n ) capacitor c=0.00224727f //x=2.11 \
 //y=5.38 //x2=4.475 //y2=7.4
cc_8 ( N_noxref_1_M8_noxref_g N_noxref_2_c_269_n ) capacitor c=0.00122608f \
 //x=4.34 //y=6.025 //x2=4.56 //y2=6.855
cc_9 ( N_noxref_1_M9_noxref_g N_noxref_2_c_269_n ) capacitor c=0.00122608f \
 //x=4.78 //y=6.025 //x2=4.56 //y2=6.855
cc_10 ( N_noxref_1_M8_noxref_g N_noxref_2_c_271_n ) capacitor c=0.00205385f \
 //x=4.34 //y=6.025 //x2=4.56 //y2=7.23
cc_11 ( N_noxref_1_M9_noxref_g N_noxref_2_c_271_n ) capacitor c=0.00294739f \
 //x=4.78 //y=6.025 //x2=4.56 //y2=7.23
cc_12 ( N_noxref_1_c_1_p N_noxref_2_c_273_n ) capacitor c=0.00213214f \
 //x=1.995 //y=5.2 //x2=1.585 //y2=7.4
cc_13 ( N_noxref_1_c_3_p N_noxref_2_c_273_n ) capacitor c=9.98713e-19 //x=1.23 \
 //y=5.38 //x2=1.585 //y2=7.4
cc_14 ( N_noxref_1_c_6_p N_noxref_2_c_273_n ) capacitor c=0.0136475f //x=1.23 \
 //y=5.38 //x2=1.585 //y2=7.4
cc_15 ( N_noxref_1_c_1_p N_noxref_2_c_276_n ) capacitor c=0.00184538f \
 //x=1.995 //y=5.2 //x2=2.465 //y2=7.4
cc_16 ( N_noxref_1_c_2_p N_noxref_2_c_276_n ) capacitor c=0.00213214f \
 //x=2.505 //y=5.2 //x2=2.465 //y2=7.4
cc_17 ( N_noxref_1_c_4_p N_noxref_2_c_276_n ) capacitor c=5.38567e-19 //x=2.11 \
 //y=5.2 //x2=2.465 //y2=7.4
cc_18 ( N_noxref_1_c_5_p N_noxref_2_c_276_n ) capacitor c=5.78261e-19 //x=2.11 \
 //y=5.38 //x2=2.465 //y2=7.4
cc_19 ( N_noxref_1_c_7_p N_noxref_2_c_276_n ) capacitor c=0.0136475f //x=2.11 \
 //y=5.38 //x2=2.465 //y2=7.4
cc_20 ( N_noxref_1_c_6_p N_noxref_2_c_281_n ) capacitor c=0.00135089f //x=1.23 \
 //y=5.38 //x2=6.29 //y2=7.4
cc_21 ( N_noxref_1_c_7_p N_noxref_2_c_281_n ) capacitor c=0.00135089f //x=2.11 \
 //y=5.38 //x2=6.29 //y2=7.4
cc_22 ( N_noxref_1_c_22_p N_noxref_2_c_281_n ) capacitor c=3.49022e-19 \
 //x=4.285 //y=4.705 //x2=6.29 //y2=7.4
cc_23 ( N_noxref_1_M8_noxref_g N_noxref_2_c_281_n ) capacitor c=0.00715024f \
 //x=4.34 //y=6.025 //x2=6.29 //y2=7.4
cc_24 ( N_noxref_1_M9_noxref_g N_noxref_2_c_281_n ) capacitor c=0.00754867f \
 //x=4.78 //y=6.025 //x2=6.29 //y2=7.4
cc_25 ( N_noxref_1_c_25_p N_noxref_2_c_286_n ) capacitor c=0.00197052f \
 //x=2.59 //y=5.115 //x2=0.74 //y2=7.4
cc_26 ( N_noxref_1_c_3_p N_noxref_2_c_286_n ) capacitor c=6.39392e-19 //x=1.23 \
 //y=5.38 //x2=0.74 //y2=7.4
cc_27 ( N_noxref_1_c_6_p N_noxref_2_c_286_n ) capacitor c=0.0064135f //x=1.23 \
 //y=5.38 //x2=0.74 //y2=7.4
cc_28 ( N_noxref_1_c_25_p N_noxref_2_c_289_n ) capacitor c=0.031064f //x=2.59 \
 //y=5.115 //x2=3.33 //y2=7.4
cc_29 ( N_noxref_1_c_29_p N_noxref_2_c_289_n ) capacitor c=0.00722719f \
 //x=4.44 //y=4.585 //x2=3.33 //y2=7.4
cc_30 ( N_noxref_1_c_4_p N_noxref_2_c_289_n ) capacitor c=0.00240948f //x=2.11 \
 //y=5.2 //x2=3.33 //y2=7.4
cc_31 ( N_noxref_1_c_5_p N_noxref_2_c_289_n ) capacitor c=4.09141e-19 //x=2.11 \
 //y=5.38 //x2=3.33 //y2=7.4
cc_32 ( N_noxref_1_c_32_p N_noxref_2_c_289_n ) capacitor c=0.00344941f \
 //x=4.285 //y=4.705 //x2=3.33 //y2=7.4
cc_33 ( N_noxref_1_c_33_p N_noxref_2_c_289_n ) capacitor c=0.00259238f \
 //x=4.275 //y=2.59 //x2=3.33 //y2=7.4
cc_34 ( N_noxref_1_c_7_p N_noxref_2_c_289_n ) capacitor c=0.0101448f //x=2.11 \
 //y=5.38 //x2=3.33 //y2=7.4
cc_35 ( N_noxref_1_c_22_p N_noxref_2_c_289_n ) capacitor c=0.00643194f \
 //x=4.285 //y=4.705 //x2=3.33 //y2=7.4
cc_36 ( N_noxref_1_M8_noxref_g N_noxref_2_c_289_n ) capacitor c=0.00898416f \
 //x=4.34 //y=6.025 //x2=3.33 //y2=7.4
cc_37 ( N_noxref_1_c_37_p N_noxref_2_c_289_n ) capacitor c=0.00438848f \
 //x=4.285 //y=4.705 //x2=3.33 //y2=7.4
cc_38 ( N_noxref_1_c_3_p N_noxref_2_M4_noxref_s ) capacitor c=0.062494f \
 //x=1.23 //y=5.38 //x2=0.655 //y2=5.02
cc_39 ( N_noxref_1_c_4_p N_noxref_2_M4_noxref_s ) capacitor c=6.52457e-19 \
 //x=2.11 //y=5.2 //x2=0.655 //y2=5.02
cc_40 ( N_noxref_1_c_6_p N_noxref_2_M4_noxref_s ) capacitor c=0.0906034f \
 //x=1.23 //y=5.38 //x2=0.655 //y2=5.02
cc_41 ( N_noxref_1_c_1_p N_noxref_2_M5_noxref_d ) capacitor c=0.00810167f \
 //x=1.995 //y=5.2 //x2=1.525 //y2=5.02
cc_42 ( N_noxref_1_c_3_p N_noxref_2_M5_noxref_d ) capacitor c=0.0043528f \
 //x=1.23 //y=5.38 //x2=1.525 //y2=5.02
cc_43 ( N_noxref_1_c_5_p N_noxref_2_M5_noxref_d ) capacitor c=0.0043528f \
 //x=2.11 //y=5.38 //x2=1.525 //y2=5.02
cc_44 ( N_noxref_1_c_6_p N_noxref_2_M5_noxref_d ) capacitor c=0.0654258f \
 //x=1.23 //y=5.38 //x2=1.525 //y2=5.02
cc_45 ( N_noxref_1_c_7_p N_noxref_2_M5_noxref_d ) capacitor c=0.0653553f \
 //x=2.11 //y=5.38 //x2=1.525 //y2=5.02
cc_46 ( N_noxref_1_c_2_p N_noxref_2_M7_noxref_d ) capacitor c=0.0100422f \
 //x=2.505 //y=5.2 //x2=2.405 //y2=5.02
cc_47 ( N_noxref_1_c_5_p N_noxref_2_M7_noxref_d ) capacitor c=0.00979407f \
 //x=2.11 //y=5.38 //x2=2.405 //y2=5.02
cc_48 ( N_noxref_1_c_48_p N_noxref_2_M7_noxref_d ) capacitor c=6.87188e-19 \
 //x=2.59 //y=2.59 //x2=2.405 //y2=5.02
cc_49 ( N_noxref_1_c_7_p N_noxref_2_M7_noxref_d ) capacitor c=0.0651828f \
 //x=2.11 //y=5.38 //x2=2.405 //y2=5.02
cc_50 ( N_noxref_1_c_50_p N_noxref_2_M8_noxref_d ) capacitor c=3.55297e-19 \
 //x=4.435 //y=2.59 //x2=4.415 //y2=5.025
cc_51 ( N_noxref_1_M8_noxref_g N_noxref_2_M8_noxref_d ) capacitor c=0.0130453f \
 //x=4.34 //y=6.025 //x2=4.415 //y2=5.025
cc_52 ( N_noxref_1_M9_noxref_g N_noxref_2_M8_noxref_d ) capacitor c=0.0142727f \
 //x=4.78 //y=6.025 //x2=4.415 //y2=5.025
cc_53 ( N_noxref_1_c_53_p N_noxref_2_M8_noxref_d ) capacitor c=0.00241874f \
 //x=4.705 //y=4.795 //x2=4.415 //y2=5.025
cc_54 ( N_noxref_1_c_3_p N_noxref_3_c_385_n ) capacitor c=0.0118546f //x=1.23 \
 //y=5.38 //x2=1.11 //y2=4.7
cc_55 ( N_noxref_1_c_6_p N_noxref_3_c_385_n ) capacitor c=0.00165549f //x=1.23 \
 //y=5.38 //x2=1.11 //y2=4.7
cc_56 ( N_noxref_1_c_56_p N_noxref_3_c_387_n ) capacitor c=0.00102483f \
 //x=2.59 //y=2.43 //x2=1.112 //y2=4.56
cc_57 ( N_noxref_1_c_25_p N_noxref_3_c_387_n ) capacitor c=0.00451861f \
 //x=2.59 //y=5.115 //x2=1.112 //y2=4.56
cc_58 ( N_noxref_1_c_3_p N_noxref_3_c_389_n ) capacitor c=0.00277154f //x=1.23 \
 //y=5.38 //x2=1.11 //y2=4.7
cc_59 ( N_noxref_1_c_6_p N_noxref_3_c_389_n ) capacitor c=0.00377369f //x=1.23 \
 //y=5.38 //x2=1.11 //y2=4.7
cc_60 ( N_noxref_1_c_3_p N_noxref_3_M4_noxref_g ) capacitor c=0.0020878f \
 //x=1.23 //y=5.38 //x2=1.01 //y2=6.02
cc_61 ( N_noxref_1_c_6_p N_noxref_3_M4_noxref_g ) capacitor c=0.0158358f \
 //x=1.23 //y=5.38 //x2=1.01 //y2=6.02
cc_62 ( N_noxref_1_c_1_p N_noxref_3_M5_noxref_g ) capacitor c=0.0129249f \
 //x=1.995 //y=5.2 //x2=1.45 //y2=6.02
cc_63 ( N_noxref_1_c_3_p N_noxref_3_M5_noxref_g ) capacitor c=0.00192712f \
 //x=1.23 //y=5.38 //x2=1.45 //y2=6.02
cc_64 ( N_noxref_1_c_6_p N_noxref_3_M5_noxref_g ) capacitor c=0.0178987f \
 //x=1.23 //y=5.38 //x2=1.45 //y2=6.02
cc_65 ( N_noxref_1_c_3_p N_noxref_3_c_396_n ) capacitor c=0.00207241f //x=1.23 \
 //y=5.38 //x2=1.11 //y2=4.7
cc_66 ( N_noxref_1_c_6_p N_noxref_3_c_396_n ) capacitor c=0.0043218f //x=1.23 \
 //y=5.38 //x2=1.11 //y2=4.7
cc_67 ( N_noxref_1_c_67_p N_noxref_4_c_481_n ) capacitor c=0.00653239f \
 //x=2.505 //y=1.655 //x2=6.29 //y2=0
cc_68 ( N_noxref_1_c_68_p N_noxref_4_c_481_n ) capacitor c=5.97638e-19 \
 //x=2.59 //y=2.75 //x2=6.29 //y2=0
cc_69 ( N_noxref_1_c_69_p N_noxref_4_c_481_n ) capacitor c=3.68082e-19 \
 //x=4.44 //y=2.75 //x2=6.29 //y2=0
cc_70 ( N_noxref_1_c_70_p N_noxref_4_c_481_n ) capacitor c=0.00963092f \
 //x=2.15 //y=1 //x2=6.29 //y2=0
cc_71 ( N_noxref_1_c_71_p N_noxref_4_c_481_n ) capacitor c=8.82978e-19 \
 //x=4.44 //y=2.08 //x2=6.29 //y2=0
cc_72 ( N_noxref_1_M1_noxref_d N_noxref_4_c_481_n ) capacitor c=3.01654e-19 \
 //x=1.96 //y=0.905 //x2=6.29 //y2=0
cc_73 ( N_noxref_1_c_3_p N_noxref_4_c_487_n ) capacitor c=9.64329e-19 //x=1.23 \
 //y=5.38 //x2=1.18 //y2=0.955
cc_74 ( N_noxref_1_c_70_p N_noxref_4_c_487_n ) capacitor c=0.0141894f //x=2.15 \
 //y=1 //x2=1.18 //y2=0.955
cc_75 ( N_noxref_1_M1_noxref_d N_noxref_4_c_487_n ) capacitor c=2.93544e-19 \
 //x=1.96 //y=0.905 //x2=1.18 //y2=0.955
cc_76 ( N_noxref_1_c_67_p N_noxref_4_c_490_n ) capacitor c=7.76556e-19 \
 //x=2.505 //y=1.655 //x2=3.16 //y2=0
cc_77 ( N_noxref_1_c_68_p N_noxref_4_c_490_n ) capacitor c=4.78557e-19 \
 //x=2.59 //y=2.75 //x2=3.16 //y2=0
cc_78 ( N_noxref_1_c_56_p N_noxref_4_c_492_n ) capacitor c=0.00139243f \
 //x=2.59 //y=2.43 //x2=0.74 //y2=0
cc_79 ( N_noxref_1_c_48_p N_noxref_4_c_492_n ) capacitor c=0.00133285f \
 //x=2.59 //y=2.59 //x2=0.74 //y2=0
cc_80 ( N_noxref_1_c_69_p N_noxref_4_c_494_n ) capacitor c=9.53261e-19 \
 //x=4.44 //y=2.75 //x2=4.91 //y2=0.53
cc_81 ( N_noxref_1_c_71_p N_noxref_4_c_494_n ) capacitor c=0.0010437f //x=4.44 \
 //y=2.08 //x2=4.91 //y2=0.53
cc_82 ( N_noxref_1_c_82_p N_noxref_4_c_494_n ) capacitor c=6.77674e-19 \
 //x=4.44 //y=2.08 //x2=4.91 //y2=0.53
cc_83 ( N_noxref_1_c_83_p N_noxref_4_c_494_n ) capacitor c=0.0211758f \
 //x=4.245 //y=0.905 //x2=4.91 //y2=0.53
cc_84 ( N_noxref_1_c_84_p N_noxref_4_c_494_n ) capacitor c=2.1838e-19 \
 //x=4.245 //y=1.915 //x2=4.91 //y2=0.53
cc_85 ( N_noxref_1_c_85_p N_noxref_4_c_494_n ) capacitor c=0.00805599f \
 //x=4.775 //y=0.905 //x2=4.91 //y2=0.53
cc_86 ( N_noxref_1_c_70_p N_noxref_4_c_500_n ) capacitor c=2.83275e-19 \
 //x=2.15 //y=1 //x2=6.29 //y2=0
cc_87 ( N_noxref_1_c_50_p N_noxref_4_c_500_n ) capacitor c=0.00159554f \
 //x=4.435 //y=2.59 //x2=6.29 //y2=0
cc_88 ( N_noxref_1_c_88_p N_noxref_4_c_502_n ) capacitor c=0.00271975f \
 //x=2.15 //y=1.57 //x2=3.33 //y2=0
cc_89 ( N_noxref_1_c_67_p N_noxref_4_c_502_n ) capacitor c=0.0223629f \
 //x=2.505 //y=1.655 //x2=3.33 //y2=0
cc_90 ( N_noxref_1_c_68_p N_noxref_4_c_502_n ) capacitor c=0.00422283f \
 //x=2.59 //y=2.75 //x2=3.33 //y2=0
cc_91 ( N_noxref_1_c_91_p N_noxref_4_c_502_n ) capacitor c=0.00329573f \
 //x=4.44 //y=2.43 //x2=3.33 //y2=0
cc_92 ( N_noxref_1_c_69_p N_noxref_4_c_502_n ) capacitor c=0.00307096f \
 //x=4.44 //y=2.75 //x2=3.33 //y2=0
cc_93 ( N_noxref_1_c_48_p N_noxref_4_c_502_n ) capacitor c=0.0101451f //x=2.59 \
 //y=2.59 //x2=3.33 //y2=0
cc_94 ( N_noxref_1_c_50_p N_noxref_4_c_502_n ) capacitor c=0.00512549f \
 //x=4.435 //y=2.59 //x2=3.33 //y2=0
cc_95 ( N_noxref_1_c_71_p N_noxref_4_c_502_n ) capacitor c=0.00446799f \
 //x=4.44 //y=2.08 //x2=3.33 //y2=0
cc_96 ( N_noxref_1_c_33_p N_noxref_4_c_502_n ) capacitor c=0.0239533f \
 //x=4.275 //y=2.59 //x2=3.33 //y2=0
cc_97 ( N_noxref_1_c_82_p N_noxref_4_c_502_n ) capacitor c=0.00369203f \
 //x=4.44 //y=2.08 //x2=3.33 //y2=0
cc_98 ( N_noxref_1_c_84_p N_noxref_4_c_502_n ) capacitor c=0.0101915f \
 //x=4.245 //y=1.915 //x2=3.33 //y2=0
cc_99 ( N_noxref_1_c_70_p N_noxref_4_M0_noxref_d ) capacitor c=2.82748e-19 \
 //x=2.15 //y=1 //x2=0.99 //y2=0.865
cc_100 ( N_noxref_1_c_33_p N_noxref_4_M2_noxref_s ) capacitor c=0.00355145f \
 //x=4.275 //y=2.59 //x2=3.89 //y2=0.365
cc_101 ( N_noxref_1_c_83_p N_noxref_4_M2_noxref_s ) capacitor c=0.0329097f \
 //x=4.245 //y=0.905 //x2=3.89 //y2=0.365
cc_102 ( N_noxref_1_c_85_p N_noxref_4_M2_noxref_s ) capacitor c=0.00605785f \
 //x=4.775 //y=0.905 //x2=3.89 //y2=0.365
cc_103 ( N_noxref_1_c_103_p N_noxref_4_M2_noxref_s ) capacitor c=0.00120103f \
 //x=4.775 //y=1.25 //x2=3.89 //y2=0.365
cc_104 ( N_noxref_1_c_1_p N_noxref_5_c_619_n ) capacitor c=0.0228479f \
 //x=1.995 //y=5.2 //x2=1.85 //y2=4.555
cc_105 ( N_noxref_1_c_56_p N_noxref_5_c_619_n ) capacitor c=0.0092434f \
 //x=2.59 //y=2.43 //x2=1.85 //y2=4.555
cc_106 ( N_noxref_1_c_68_p N_noxref_5_c_619_n ) capacitor c=0.0148501f \
 //x=2.59 //y=2.75 //x2=1.85 //y2=4.555
cc_107 ( N_noxref_1_c_25_p N_noxref_5_c_619_n ) capacitor c=0.100437f //x=2.59 \
 //y=5.115 //x2=1.85 //y2=4.555
cc_108 ( N_noxref_1_c_91_p N_noxref_5_c_619_n ) capacitor c=6.36091e-19 \
 //x=4.44 //y=2.43 //x2=1.85 //y2=4.555
cc_109 ( N_noxref_1_c_29_p N_noxref_5_c_619_n ) capacitor c=0.00287531f \
 //x=4.44 //y=4.585 //x2=1.85 //y2=4.555
cc_110 ( N_noxref_1_c_48_p N_noxref_5_c_619_n ) capacitor c=5.82756e-19 \
 //x=2.59 //y=2.59 //x2=1.85 //y2=4.555
cc_111 ( N_noxref_1_c_111_p N_noxref_5_c_619_n ) capacitor c=0.00687503f \
 //x=2.75 //y=2.59 //x2=1.85 //y2=4.555
cc_112 ( N_noxref_1_c_1_p N_noxref_5_c_627_n ) capacitor c=2.77624e-19 \
 //x=1.995 //y=5.2 //x2=1.85 //y2=2.08
cc_113 ( N_noxref_1_c_56_p N_noxref_5_c_627_n ) capacitor c=0.015397f //x=2.59 \
 //y=2.43 //x2=1.85 //y2=2.08
cc_114 ( N_noxref_1_c_56_p N_noxref_5_c_629_n ) capacitor c=9.90728e-19 \
 //x=2.59 //y=2.43 //x2=1.85 //y2=2.08
cc_115 ( N_noxref_1_c_1_p N_noxref_5_c_630_n ) capacitor c=0.00469257f \
 //x=1.995 //y=5.2 //x2=1.88 //y2=4.7
cc_116 ( N_noxref_1_c_25_p N_noxref_5_c_630_n ) capacitor c=0.00342433f \
 //x=2.59 //y=5.115 //x2=1.88 //y2=4.7
cc_117 ( N_noxref_1_c_1_p N_noxref_5_M6_noxref_g ) capacitor c=0.00842859f \
 //x=1.995 //y=5.2 //x2=1.89 //y2=6.02
cc_118 ( N_noxref_1_c_4_p N_noxref_5_M6_noxref_g ) capacitor c=0.00192712f \
 //x=2.11 //y=5.2 //x2=1.89 //y2=6.02
cc_119 ( N_noxref_1_c_7_p N_noxref_5_M6_noxref_g ) capacitor c=0.0178987f \
 //x=2.11 //y=5.38 //x2=1.89 //y2=6.02
cc_120 ( N_noxref_1_c_2_p N_noxref_5_M7_noxref_g ) capacitor c=0.0115937f \
 //x=2.505 //y=5.2 //x2=2.33 //y2=6.02
cc_121 ( N_noxref_1_c_4_p N_noxref_5_M7_noxref_g ) capacitor c=0.00298276f \
 //x=2.11 //y=5.2 //x2=2.33 //y2=6.02
cc_122 ( N_noxref_1_c_7_p N_noxref_5_M7_noxref_g ) capacitor c=0.0178506f \
 //x=2.11 //y=5.38 //x2=2.33 //y2=6.02
cc_123 ( N_noxref_1_c_70_p N_noxref_5_c_638_n ) capacitor c=0.00120406f \
 //x=2.15 //y=1 //x2=1.885 //y2=0.905
cc_124 ( N_noxref_1_M1_noxref_d N_noxref_5_c_638_n ) capacitor c=0.00137165f \
 //x=1.96 //y=0.905 //x2=1.885 //y2=0.905
cc_125 ( N_noxref_1_c_88_p N_noxref_5_c_640_n ) capacitor c=0.00127432f \
 //x=2.15 //y=1.57 //x2=1.885 //y2=1.25
cc_126 ( N_noxref_1_c_70_p N_noxref_5_c_640_n ) capacitor c=0.00220847f \
 //x=2.15 //y=1 //x2=1.885 //y2=1.25
cc_127 ( N_noxref_1_M1_noxref_d N_noxref_5_c_640_n ) capacitor c=0.00237422f \
 //x=1.96 //y=0.905 //x2=1.885 //y2=1.25
cc_128 ( N_noxref_1_c_88_p N_noxref_5_c_643_n ) capacitor c=0.00454577f \
 //x=2.15 //y=1.57 //x2=1.885 //y2=1.56
cc_129 ( N_noxref_1_c_25_p N_noxref_5_c_644_n ) capacitor c=0.00874009f \
 //x=2.59 //y=5.115 //x2=2.255 //y2=4.79
cc_130 ( N_noxref_1_c_4_p N_noxref_5_c_644_n ) capacitor c=0.0020909f //x=2.11 \
 //y=5.2 //x2=2.255 //y2=4.79
cc_131 ( N_noxref_1_c_7_p N_noxref_5_c_644_n ) capacitor c=0.00291714f \
 //x=2.11 //y=5.38 //x2=2.255 //y2=4.79
cc_132 ( N_noxref_1_c_70_p N_noxref_5_c_647_n ) capacitor c=5.50523e-19 \
 //x=2.15 //y=1 //x2=2.26 //y2=0.75
cc_133 ( N_noxref_1_M1_noxref_d N_noxref_5_c_647_n ) capacitor c=0.0020782f \
 //x=1.96 //y=0.905 //x2=2.26 //y2=0.75
cc_134 ( N_noxref_1_c_88_p N_noxref_5_c_649_n ) capacitor c=0.00912818f \
 //x=2.15 //y=1.57 //x2=2.26 //y2=1.405
cc_135 ( N_noxref_1_c_67_p N_noxref_5_c_649_n ) capacitor c=0.00194324f \
 //x=2.505 //y=1.655 //x2=2.26 //y2=1.405
cc_136 ( N_noxref_1_c_70_p N_noxref_5_c_649_n ) capacitor c=5.67071e-19 \
 //x=2.15 //y=1 //x2=2.26 //y2=1.405
cc_137 ( N_noxref_1_M1_noxref_d N_noxref_5_c_649_n ) capacitor c=0.00356097f \
 //x=1.96 //y=0.905 //x2=2.26 //y2=1.405
cc_138 ( N_noxref_1_c_70_p N_noxref_5_c_653_n ) capacitor c=0.0010954f \
 //x=2.15 //y=1 //x2=2.415 //y2=0.905
cc_139 ( N_noxref_1_M1_noxref_d N_noxref_5_c_653_n ) capacitor c=8.50095e-19 \
 //x=1.96 //y=0.905 //x2=2.415 //y2=0.905
cc_140 ( N_noxref_1_c_88_p N_noxref_5_c_655_n ) capacitor c=0.00305472f \
 //x=2.15 //y=1.57 //x2=2.415 //y2=1.25
cc_141 ( N_noxref_1_c_67_p N_noxref_5_c_655_n ) capacitor c=0.00323005f \
 //x=2.505 //y=1.655 //x2=2.415 //y2=1.25
cc_142 ( N_noxref_1_c_70_p N_noxref_5_c_655_n ) capacitor c=0.00314842f \
 //x=2.15 //y=1 //x2=2.415 //y2=1.25
cc_143 ( N_noxref_1_M1_noxref_d N_noxref_5_c_655_n ) capacitor c=0.00237422f \
 //x=1.96 //y=0.905 //x2=2.415 //y2=1.25
cc_144 ( N_noxref_1_c_56_p N_noxref_5_c_659_n ) capacitor c=0.00285392f \
 //x=2.59 //y=2.43 //x2=1.85 //y2=2.08
cc_145 ( N_noxref_1_c_88_p N_noxref_5_c_660_n ) capacitor c=0.00371023f \
 //x=2.15 //y=1.57 //x2=1.85 //y2=1.915
cc_146 ( N_noxref_1_c_56_p N_noxref_5_c_660_n ) capacitor c=0.00341496f \
 //x=2.59 //y=2.43 //x2=1.85 //y2=1.915
cc_147 ( N_noxref_1_c_1_p N_noxref_5_c_662_n ) capacitor c=9.8107e-19 \
 //x=1.995 //y=5.2 //x2=1.88 //y2=4.7
cc_148 ( N_noxref_1_c_25_p N_noxref_5_c_662_n ) capacitor c=0.00142201f \
 //x=2.59 //y=5.115 //x2=1.88 //y2=4.7
cc_149 ( N_noxref_1_c_69_p N_noxref_6_c_723_n ) capacitor c=4.99553e-19 \
 //x=4.44 //y=2.75 //x2=4.88 //y2=5.21
cc_150 ( N_noxref_1_c_32_p N_noxref_6_c_723_n ) capacitor c=0.0078395f \
 //x=4.285 //y=4.705 //x2=4.88 //y2=5.21
cc_151 ( N_noxref_1_c_22_p N_noxref_6_c_723_n ) capacitor c=0.00104675f \
 //x=4.285 //y=4.705 //x2=4.88 //y2=5.21
cc_152 ( N_noxref_1_M8_noxref_g N_noxref_6_c_723_n ) capacitor c=0.00996264f \
 //x=4.34 //y=6.025 //x2=4.88 //y2=5.21
cc_153 ( N_noxref_1_M9_noxref_g N_noxref_6_c_723_n ) capacitor c=0.00967241f \
 //x=4.78 //y=6.025 //x2=4.88 //y2=5.21
cc_154 ( N_noxref_1_c_53_p N_noxref_6_c_723_n ) capacitor c=0.00189892f \
 //x=4.705 //y=4.795 //x2=4.88 //y2=5.21
cc_155 ( N_noxref_1_c_2_p N_noxref_6_c_729_n ) capacitor c=0.00408808f \
 //x=2.505 //y=5.2 //x2=4.12 //y2=5.21
cc_156 ( N_noxref_1_c_4_p N_noxref_6_c_729_n ) capacitor c=0.00518363f \
 //x=2.11 //y=5.2 //x2=4.12 //y2=5.21
cc_157 ( N_noxref_1_c_5_p N_noxref_6_c_729_n ) capacitor c=3.28075e-19 \
 //x=2.11 //y=5.38 //x2=4.12 //y2=5.21
cc_158 ( N_noxref_1_c_32_p N_noxref_6_c_729_n ) capacitor c=0.0243045f \
 //x=4.285 //y=4.705 //x2=4.12 //y2=5.21
cc_159 ( N_noxref_1_c_22_p N_noxref_6_c_729_n ) capacitor c=0.00565356f \
 //x=4.285 //y=4.705 //x2=4.12 //y2=5.21
cc_160 ( N_noxref_1_M8_noxref_g N_noxref_6_c_729_n ) capacitor c=0.00403872f \
 //x=4.34 //y=6.025 //x2=4.12 //y2=5.21
cc_161 ( N_noxref_1_c_37_p N_noxref_6_c_729_n ) capacitor c=9.12041e-19 \
 //x=4.285 //y=4.705 //x2=4.12 //y2=5.21
cc_162 ( N_noxref_1_M9_noxref_g N_noxref_6_c_736_n ) capacitor c=0.0018094f \
 //x=4.78 //y=6.025 //x2=5 //y2=5.21
cc_163 ( N_noxref_1_M9_noxref_g N_noxref_6_c_737_n ) capacitor c=0.00180782f \
 //x=4.78 //y=6.025 //x2=5 //y2=6.74
cc_164 ( N_noxref_1_c_32_p N_noxref_6_c_738_n ) capacitor c=0.00154424f \
 //x=4.285 //y=4.705 //x2=4.12 //y2=5.38
cc_165 ( N_noxref_1_c_22_p N_noxref_6_c_738_n ) capacitor c=0.00126834f \
 //x=4.285 //y=4.705 //x2=4.12 //y2=5.38
cc_166 ( N_noxref_1_M8_noxref_g N_noxref_6_c_738_n ) capacitor c=0.0483843f \
 //x=4.34 //y=6.025 //x2=4.12 //y2=5.38
cc_167 ( N_noxref_1_c_37_p N_noxref_6_c_738_n ) capacitor c=0.00297041f \
 //x=4.285 //y=4.705 //x2=4.12 //y2=5.38
cc_168 ( N_noxref_1_M9_noxref_g N_noxref_6_c_742_n ) capacitor c=0.0170175f \
 //x=4.78 //y=6.025 //x2=5 //y2=5.38
cc_169 ( N_noxref_1_M8_noxref_g N_noxref_6_M8_noxref_s ) capacitor \
 c=0.00378422f //x=4.34 //y=6.025 //x2=3.985 //y2=5.025
cc_170 ( N_noxref_1_c_71_p N_noxref_7_c_806_n ) capacitor c=0.0217252f \
 //x=4.44 //y=2.08 //x2=5.18 //y2=2.08
cc_171 ( N_noxref_1_c_82_p N_noxref_7_c_806_n ) capacitor c=5.41079e-19 \
 //x=4.44 //y=2.08 //x2=5.18 //y2=2.08
cc_172 ( N_noxref_1_c_84_p N_noxref_7_c_806_n ) capacitor c=0.00178181f \
 //x=4.245 //y=1.915 //x2=5.18 //y2=2.08
cc_173 ( N_noxref_1_c_32_p N_noxref_7_c_809_n ) capacitor c=0.0485095f \
 //x=4.285 //y=4.705 //x2=5.215 //y2=4.705
cc_174 ( N_noxref_1_c_22_p N_noxref_7_c_809_n ) capacitor c=0.00105182f \
 //x=4.285 //y=4.705 //x2=5.215 //y2=4.705
cc_175 ( N_noxref_1_c_53_p N_noxref_7_c_809_n ) capacitor c=0.00107587f \
 //x=4.705 //y=4.795 //x2=5.215 //y2=4.705
cc_176 ( N_noxref_1_c_56_p N_noxref_7_c_812_n ) capacitor c=6.64067e-19 \
 //x=2.59 //y=2.43 //x2=5.215 //y2=4.56
cc_177 ( N_noxref_1_c_25_p N_noxref_7_c_812_n ) capacitor c=0.00350333f \
 //x=2.59 //y=5.115 //x2=5.215 //y2=4.56
cc_178 ( N_noxref_1_c_91_p N_noxref_7_c_812_n ) capacitor c=0.00883199f \
 //x=4.44 //y=2.43 //x2=5.215 //y2=4.56
cc_179 ( N_noxref_1_c_69_p N_noxref_7_c_812_n ) capacitor c=0.0146933f \
 //x=4.44 //y=2.75 //x2=5.215 //y2=4.56
cc_180 ( N_noxref_1_c_29_p N_noxref_7_c_812_n ) capacitor c=0.0472907f \
 //x=4.44 //y=4.585 //x2=5.215 //y2=4.56
cc_181 ( N_noxref_1_c_50_p N_noxref_7_c_812_n ) capacitor c=5.81276e-19 \
 //x=4.435 //y=2.59 //x2=5.215 //y2=4.56
cc_182 ( N_noxref_1_c_182_p N_noxref_7_c_812_n ) capacitor c=0.00684101f \
 //x=4.435 //y=2.59 //x2=5.215 //y2=4.56
cc_183 ( N_noxref_1_c_82_p N_noxref_7_c_812_n ) capacitor c=2.61947e-19 \
 //x=4.44 //y=2.08 //x2=5.215 //y2=4.56
cc_184 ( N_noxref_1_c_91_p N_noxref_7_c_820_n ) capacitor c=2.61947e-19 \
 //x=4.44 //y=2.43 //x2=5.18 //y2=2.08
cc_185 ( N_noxref_1_c_71_p N_noxref_7_c_820_n ) capacitor c=5.24865e-19 \
 //x=4.44 //y=2.08 //x2=5.18 //y2=2.08
cc_186 ( N_noxref_1_c_82_p N_noxref_7_c_820_n ) capacitor c=0.00445529f \
 //x=4.44 //y=2.08 //x2=5.18 //y2=2.08
cc_187 ( N_noxref_1_c_84_p N_noxref_7_c_820_n ) capacitor c=0.00267961f \
 //x=4.245 //y=1.915 //x2=5.18 //y2=2.08
cc_188 ( N_noxref_1_c_32_p N_noxref_7_c_824_n ) capacitor c=4.32488e-19 \
 //x=4.285 //y=4.705 //x2=5.215 //y2=4.705
cc_189 ( N_noxref_1_c_22_p N_noxref_7_c_824_n ) capacitor c=0.00242589f \
 //x=4.285 //y=4.705 //x2=5.215 //y2=4.705
cc_190 ( N_noxref_1_c_53_p N_noxref_7_c_824_n ) capacitor c=0.00116837f \
 //x=4.705 //y=4.795 //x2=5.215 //y2=4.705
cc_191 ( N_noxref_1_c_37_p N_noxref_7_c_824_n ) capacitor c=0.00121814f \
 //x=4.285 //y=4.705 //x2=5.215 //y2=4.705
cc_192 ( N_noxref_1_M8_noxref_g N_noxref_7_M10_noxref_g ) capacitor \
 c=0.0101077f //x=4.34 //y=6.025 //x2=5.22 //y2=6.025
cc_193 ( N_noxref_1_M9_noxref_g N_noxref_7_M10_noxref_g ) capacitor \
 c=0.109254f //x=4.78 //y=6.025 //x2=5.22 //y2=6.025
cc_194 ( N_noxref_1_M9_noxref_g N_noxref_7_M11_noxref_g ) capacitor \
 c=0.00945018f //x=4.78 //y=6.025 //x2=5.66 //y2=6.025
cc_195 ( N_noxref_1_c_83_p N_noxref_7_c_831_n ) capacitor c=0.00125788f \
 //x=4.245 //y=0.905 //x2=5.215 //y2=0.905
cc_196 ( N_noxref_1_c_85_p N_noxref_7_c_831_n ) capacitor c=0.0126654f \
 //x=4.775 //y=0.905 //x2=5.215 //y2=0.905
cc_197 ( N_noxref_1_c_197_p N_noxref_7_c_833_n ) capacitor c=0.00149727f \
 //x=4.245 //y=1.25 //x2=5.215 //y2=1.255
cc_198 ( N_noxref_1_c_198_p N_noxref_7_c_833_n ) capacitor c=0.00111802f \
 //x=4.245 //y=1.56 //x2=5.215 //y2=1.255
cc_199 ( N_noxref_1_c_103_p N_noxref_7_c_833_n ) capacitor c=0.0126654f \
 //x=4.775 //y=1.25 //x2=5.215 //y2=1.255
cc_200 ( N_noxref_1_c_198_p N_noxref_7_c_836_n ) capacitor c=0.00116305f \
 //x=4.245 //y=1.56 //x2=5.215 //y2=1.56
cc_201 ( N_noxref_1_c_103_p N_noxref_7_c_836_n ) capacitor c=0.00938322f \
 //x=4.775 //y=1.25 //x2=5.215 //y2=1.56
cc_202 ( N_noxref_1_c_103_p N_noxref_7_c_838_n ) capacitor c=0.00131492f \
 //x=4.775 //y=1.25 //x2=5.59 //y2=1.405
cc_203 ( N_noxref_1_c_85_p N_noxref_7_c_839_n ) capacitor c=0.00132934f \
 //x=4.775 //y=0.905 //x2=5.745 //y2=0.905
cc_204 ( N_noxref_1_c_103_p N_noxref_7_c_840_n ) capacitor c=0.00151998f \
 //x=4.775 //y=1.25 //x2=5.745 //y2=1.255
cc_205 ( N_noxref_1_c_71_p N_noxref_7_c_841_n ) capacitor c=0.00173144f \
 //x=4.44 //y=2.08 //x2=5.18 //y2=2.08
cc_206 ( N_noxref_1_c_82_p N_noxref_7_c_841_n ) capacitor c=0.00266443f \
 //x=4.44 //y=2.08 //x2=5.18 //y2=2.08
cc_207 ( N_noxref_1_c_84_p N_noxref_7_c_841_n ) capacitor c=0.0181449f \
 //x=4.245 //y=1.915 //x2=5.18 //y2=2.08
cc_208 ( N_noxref_1_c_84_p N_noxref_7_c_844_n ) capacitor c=0.00636965f \
 //x=4.245 //y=1.915 //x2=5.18 //y2=1.915
cc_209 ( N_noxref_1_c_29_p N_noxref_7_c_845_n ) capacitor c=0.00117265f \
 //x=4.44 //y=4.585 //x2=5.215 //y2=4.705
cc_210 ( N_noxref_1_c_32_p N_noxref_7_c_845_n ) capacitor c=4.8456e-19 \
 //x=4.285 //y=4.705 //x2=5.215 //y2=4.705
cc_211 ( N_noxref_1_c_22_p N_noxref_7_c_845_n ) capacitor c=0.00211373f \
 //x=4.285 //y=4.705 //x2=5.215 //y2=4.705
cc_212 ( N_noxref_1_c_53_p N_noxref_7_c_845_n ) capacitor c=0.0203928f \
 //x=4.705 //y=4.795 //x2=5.215 //y2=4.705
cc_213 ( N_noxref_1_c_37_p N_noxref_7_c_845_n ) capacitor c=0.00590438f \
 //x=4.285 //y=4.705 //x2=5.215 //y2=4.705
cc_214 ( N_noxref_1_c_70_p N_noxref_8_c_918_n ) capacitor c=0.00604284f \
 //x=2.15 //y=1 //x2=4.51 //y2=1.125
cc_215 ( N_noxref_1_c_71_p N_noxref_8_c_918_n ) capacitor c=0.00116632f \
 //x=4.44 //y=2.08 //x2=4.51 //y2=1.125
cc_216 ( N_noxref_1_c_82_p N_noxref_8_c_918_n ) capacitor c=7.02188e-19 \
 //x=4.44 //y=2.08 //x2=4.51 //y2=1.125
cc_217 ( N_noxref_1_c_83_p N_noxref_8_c_918_n ) capacitor c=6.06305e-19 \
 //x=4.245 //y=0.905 //x2=4.51 //y2=1.125
cc_218 ( N_noxref_1_c_197_p N_noxref_8_c_918_n ) capacitor c=0.00328491f \
 //x=4.245 //y=1.25 //x2=4.51 //y2=1.125
cc_219 ( N_noxref_1_c_219_p N_noxref_8_c_918_n ) capacitor c=5.29726e-19 \
 //x=4.62 //y=0.75 //x2=4.51 //y2=1.125
cc_220 ( N_noxref_1_c_220_p N_noxref_8_c_918_n ) capacitor c=6.14781e-19 \
 //x=4.62 //y=1.405 //x2=4.51 //y2=1.125
cc_221 ( N_noxref_1_c_85_p N_noxref_8_c_918_n ) capacitor c=5.57259e-19 \
 //x=4.775 //y=0.905 //x2=4.51 //y2=1.125
cc_222 ( N_noxref_1_c_103_p N_noxref_8_c_918_n ) capacitor c=0.00212774f \
 //x=4.775 //y=1.25 //x2=4.51 //y2=1.125
cc_223 ( N_noxref_1_c_88_p N_noxref_8_c_927_n ) capacitor c=0.00445584f \
 //x=2.15 //y=1.57 //x2=4.51 //y2=1.57
cc_224 ( N_noxref_1_c_197_p N_noxref_8_c_927_n ) capacitor c=0.00109347f \
 //x=4.245 //y=1.25 //x2=4.51 //y2=1.57
cc_225 ( N_noxref_1_c_198_p N_noxref_8_c_927_n ) capacitor c=0.00314841f \
 //x=4.245 //y=1.56 //x2=4.51 //y2=1.57
cc_226 ( N_noxref_1_c_84_p N_noxref_8_c_927_n ) capacitor c=0.00309965f \
 //x=4.245 //y=1.915 //x2=4.51 //y2=1.57
cc_227 ( N_noxref_1_c_220_p N_noxref_8_c_927_n ) capacitor c=0.00674367f \
 //x=4.62 //y=1.405 //x2=4.51 //y2=1.57
cc_228 ( N_noxref_1_c_103_p N_noxref_8_c_927_n ) capacitor c=0.00253555f \
 //x=4.775 //y=1.25 //x2=4.51 //y2=1.57
cc_229 ( N_noxref_1_c_103_p N_noxref_8_c_933_n ) capacitor c=7.25274e-19 \
 //x=4.775 //y=1.25 //x2=5.395 //y2=1.655
cc_230 ( N_noxref_1_c_67_p N_noxref_8_c_934_n ) capacitor c=0.00351497f \
 //x=2.505 //y=1.655 //x2=4.595 //y2=1.655
cc_231 ( N_noxref_1_c_69_p N_noxref_8_c_934_n ) capacitor c=0.00126129f \
 //x=4.44 //y=2.75 //x2=4.595 //y2=1.655
cc_232 ( N_noxref_1_c_71_p N_noxref_8_c_934_n ) capacitor c=0.016131f //x=4.44 \
 //y=2.08 //x2=4.595 //y2=1.655
cc_233 ( N_noxref_1_c_182_p N_noxref_8_c_934_n ) capacitor c=6.57311e-19 \
 //x=4.435 //y=2.59 //x2=4.595 //y2=1.655
cc_234 ( N_noxref_1_c_82_p N_noxref_8_c_934_n ) capacitor c=0.00293572f \
 //x=4.44 //y=2.08 //x2=4.595 //y2=1.655
cc_235 ( N_noxref_1_c_84_p N_noxref_8_c_934_n ) capacitor c=0.00107144f \
 //x=4.245 //y=1.915 //x2=4.595 //y2=1.655
cc_236 ( N_noxref_1_c_88_p N_noxref_8_c_940_n ) capacitor c=6.26629e-19 \
 //x=2.15 //y=1.57 //x2=5.48 //y2=1.57
cc_237 ( N_noxref_1_c_103_p N_noxref_8_c_940_n ) capacitor c=6.29838e-19 \
 //x=4.775 //y=1.25 //x2=5.48 //y2=1.57
cc_238 ( N_noxref_1_c_25_p N_noxref_8_c_942_n ) capacitor c=0.00105886f \
 //x=2.59 //y=5.115 //x2=5.92 //y2=5.125
cc_239 ( N_noxref_1_c_91_p N_noxref_8_c_942_n ) capacitor c=0.00100094f \
 //x=4.44 //y=2.43 //x2=5.92 //y2=5.125
cc_240 ( N_noxref_1_c_29_p N_noxref_8_c_942_n ) capacitor c=0.00560211f \
 //x=4.44 //y=4.585 //x2=5.92 //y2=5.125
cc_241 ( N_noxref_1_c_22_p N_noxref_8_c_942_n ) capacitor c=2.44646e-19 \
 //x=4.285 //y=4.705 //x2=5.92 //y2=5.125
cc_242 ( N_noxref_1_c_2_p N_noxref_8_c_946_n ) capacitor c=7.34073e-19 \
 //x=2.505 //y=5.2 //x2=5.435 //y2=5.21
cc_243 ( N_noxref_1_c_69_p N_noxref_8_M2_noxref_d ) capacitor c=3.24005e-19 \
 //x=4.44 //y=2.75 //x2=4.32 //y2=0.905
cc_244 ( N_noxref_1_c_71_p N_noxref_8_M2_noxref_d ) capacitor c=7.18966e-19 \
 //x=4.44 //y=2.08 //x2=4.32 //y2=0.905
cc_245 ( N_noxref_1_c_82_p N_noxref_8_M2_noxref_d ) capacitor c=0.00150225f \
 //x=4.44 //y=2.08 //x2=4.32 //y2=0.905
cc_246 ( N_noxref_1_c_83_p N_noxref_8_M2_noxref_d ) capacitor c=0.00124139f \
 //x=4.245 //y=0.905 //x2=4.32 //y2=0.905
cc_247 ( N_noxref_1_c_197_p N_noxref_8_M2_noxref_d ) capacitor c=0.00237422f \
 //x=4.245 //y=1.25 //x2=4.32 //y2=0.905
cc_248 ( N_noxref_1_c_219_p N_noxref_8_M2_noxref_d ) capacitor c=0.00213893f \
 //x=4.62 //y=0.75 //x2=4.32 //y2=0.905
cc_249 ( N_noxref_1_c_220_p N_noxref_8_M2_noxref_d ) capacitor c=0.00345753f \
 //x=4.62 //y=1.405 //x2=4.32 //y2=0.905
cc_250 ( N_noxref_1_c_85_p N_noxref_8_M2_noxref_d ) capacitor c=0.00211919f \
 //x=4.775 //y=0.905 //x2=4.32 //y2=0.905
cc_251 ( N_noxref_1_c_103_p N_noxref_8_M2_noxref_d ) capacitor c=0.00237422f \
 //x=4.775 //y=1.25 //x2=4.32 //y2=0.905
cc_252 ( N_noxref_1_c_252_p N_noxref_9_c_1042_n ) capacitor c=0.0103386f \
 //x=2.235 //y=1.655 //x2=1.665 //y2=1.495
cc_253 ( N_noxref_1_c_67_p N_noxref_9_c_1043_n ) capacitor c=0.00373013f \
 //x=2.505 //y=1.655 //x2=2.55 //y2=0.53
cc_254 ( N_noxref_1_c_70_p N_noxref_9_c_1043_n ) capacitor c=0.00367971f \
 //x=2.15 //y=1 //x2=2.55 //y2=0.53
cc_255 ( N_noxref_1_M1_noxref_d N_noxref_9_c_1043_n ) capacitor c=0.00910163f \
 //x=1.96 //y=0.905 //x2=2.55 //y2=0.53
cc_256 ( N_noxref_1_c_88_p N_noxref_9_M0_noxref_s ) capacitor c=0.0173667f \
 //x=2.15 //y=1.57 //x2=0.56 //y2=0.365
cc_257 ( N_noxref_1_c_67_p N_noxref_9_M0_noxref_s ) capacitor c=0.0055349f \
 //x=2.505 //y=1.655 //x2=0.56 //y2=0.365
cc_258 ( N_noxref_1_c_68_p N_noxref_9_M0_noxref_s ) capacitor c=7.86324e-19 \
 //x=2.59 //y=2.75 //x2=0.56 //y2=0.365
cc_259 ( N_noxref_1_c_70_p N_noxref_9_M0_noxref_s ) capacitor c=0.00907053f \
 //x=2.15 //y=1 //x2=0.56 //y2=0.365
cc_260 ( N_noxref_1_c_48_p N_noxref_9_M0_noxref_s ) capacitor c=0.00202552f \
 //x=2.59 //y=2.59 //x2=0.56 //y2=0.365
cc_261 ( N_noxref_1_M1_noxref_d N_noxref_9_M0_noxref_s ) capacitor \
 c=0.0275552f //x=1.96 //y=0.905 //x2=0.56 //y2=0.365
cc_262 ( N_noxref_2_c_262_n N_noxref_3_c_385_n ) capacitor c=9.05427e-19 \
 //x=4.475 //y=7.4 //x2=1.11 //y2=4.7
cc_263 ( N_noxref_2_c_273_n N_noxref_3_c_385_n ) capacitor c=6.28732e-19 \
 //x=1.585 //y=7.4 //x2=1.11 //y2=4.7
cc_264 ( N_noxref_2_c_286_n N_noxref_3_c_385_n ) capacitor c=0.00867681f \
 //x=0.74 //y=7.4 //x2=1.11 //y2=4.7
cc_265 ( N_noxref_2_c_286_n N_noxref_3_c_387_n ) capacitor c=0.0104242f \
 //x=0.74 //y=7.4 //x2=1.112 //y2=4.56
cc_266 ( N_noxref_2_c_262_n N_noxref_3_c_389_n ) capacitor c=6.23118e-19 \
 //x=4.475 //y=7.4 //x2=1.11 //y2=4.7
cc_267 ( N_noxref_2_c_286_n N_noxref_3_c_389_n ) capacitor c=0.00370735f \
 //x=0.74 //y=7.4 //x2=1.11 //y2=4.7
cc_268 ( N_noxref_2_c_273_n N_noxref_3_M4_noxref_g ) capacitor c=0.0072715f \
 //x=1.585 //y=7.4 //x2=1.01 //y2=6.02
cc_269 ( N_noxref_2_M4_noxref_s N_noxref_3_M4_noxref_g ) capacitor \
 c=0.0567929f //x=0.655 //y=5.02 //x2=1.01 //y2=6.02
cc_270 ( N_noxref_2_c_273_n N_noxref_3_M5_noxref_g ) capacitor c=0.00749619f \
 //x=1.585 //y=7.4 //x2=1.45 //y2=6.02
cc_271 ( N_noxref_2_M5_noxref_d N_noxref_3_M5_noxref_g ) capacitor c=0.015318f \
 //x=1.525 //y=5.02 //x2=1.45 //y2=6.02
cc_272 ( N_noxref_2_c_286_n N_noxref_3_c_396_n ) capacitor c=0.0234764f \
 //x=0.74 //y=7.4 //x2=1.11 //y2=4.7
cc_273 ( N_noxref_2_c_286_n N_noxref_4_c_492_n ) capacitor c=0.00989031f \
 //x=0.74 //y=7.4 //x2=0.74 //y2=0
cc_274 ( N_noxref_2_c_281_n N_noxref_4_c_500_n ) capacitor c=0.00989031f \
 //x=6.29 //y=7.4 //x2=6.29 //y2=0
cc_275 ( N_noxref_2_c_289_n N_noxref_4_c_502_n ) capacitor c=0.00969948f \
 //x=3.33 //y=7.4 //x2=3.33 //y2=0
cc_276 ( N_noxref_2_c_289_n N_noxref_5_c_630_n ) capacitor c=0.00226427f \
 //x=3.33 //y=7.4 //x2=1.88 //y2=4.7
cc_277 ( N_noxref_2_c_276_n N_noxref_5_M6_noxref_g ) capacitor c=0.00692597f \
 //x=2.465 //y=7.4 //x2=1.89 //y2=6.02
cc_278 ( N_noxref_2_M5_noxref_d N_noxref_5_M6_noxref_g ) capacitor c=0.015318f \
 //x=1.525 //y=5.02 //x2=1.89 //y2=6.02
cc_279 ( N_noxref_2_c_276_n N_noxref_5_M7_noxref_g ) capacitor c=0.00749619f \
 //x=2.465 //y=7.4 //x2=2.33 //y2=6.02
cc_280 ( N_noxref_2_M7_noxref_d N_noxref_5_M7_noxref_g ) capacitor \
 c=0.0430452f //x=2.405 //y=5.02 //x2=2.33 //y2=6.02
cc_281 ( N_noxref_2_c_289_n N_noxref_5_c_644_n ) capacitor c=0.0132232f \
 //x=3.33 //y=7.4 //x2=2.255 //y2=4.79
cc_282 ( N_noxref_2_c_289_n N_noxref_5_c_662_n ) capacitor c=2.73429e-19 \
 //x=3.33 //y=7.4 //x2=1.88 //y2=4.7
cc_283 ( N_noxref_2_M5_noxref_d N_noxref_5_c_662_n ) capacitor c=3.32274e-19 \
 //x=1.525 //y=5.02 //x2=1.88 //y2=4.7
cc_284 ( N_noxref_2_c_262_n N_noxref_6_c_723_n ) capacitor c=0.0019855f \
 //x=4.475 //y=7.4 //x2=4.88 //y2=5.21
cc_285 ( N_noxref_2_c_269_n N_noxref_6_c_723_n ) capacitor c=0.00495337f \
 //x=4.56 //y=6.855 //x2=4.88 //y2=5.21
cc_286 ( N_noxref_2_c_339_p N_noxref_6_c_723_n ) capacitor c=0.00192602f \
 //x=6.29 //y=7.4 //x2=4.88 //y2=5.21
cc_287 ( N_noxref_2_c_281_n N_noxref_6_c_723_n ) capacitor c=0.00433483f \
 //x=6.29 //y=7.4 //x2=4.88 //y2=5.21
cc_288 ( N_noxref_2_M8_noxref_d N_noxref_6_c_723_n ) capacitor c=0.00655495f \
 //x=4.415 //y=5.025 //x2=4.88 //y2=5.21
cc_289 ( N_noxref_2_c_281_n N_noxref_6_c_749_n ) capacitor c=0.00221967f \
 //x=6.29 //y=7.4 //x2=5.75 //y2=6.91
cc_290 ( N_noxref_2_c_289_n N_noxref_6_c_729_n ) capacitor c=0.00766391f \
 //x=3.33 //y=7.4 //x2=4.12 //y2=5.21
cc_291 ( N_noxref_2_M4_noxref_s N_noxref_6_c_729_n ) capacitor c=5.03296e-19 \
 //x=0.655 //y=5.02 //x2=4.12 //y2=5.21
cc_292 ( N_noxref_2_c_269_n N_noxref_6_c_737_n ) capacitor c=0.0377581f \
 //x=4.56 //y=6.855 //x2=5 //y2=6.74
cc_293 ( N_noxref_2_c_271_n N_noxref_6_c_737_n ) capacitor c=0.0104317f \
 //x=4.56 //y=7.23 //x2=5 //y2=6.74
cc_294 ( N_noxref_2_c_339_p N_noxref_6_c_737_n ) capacitor c=0.0973955f \
 //x=6.29 //y=7.4 //x2=5 //y2=6.74
cc_295 ( N_noxref_2_c_281_n N_noxref_6_c_737_n ) capacitor c=0.0216166f \
 //x=6.29 //y=7.4 //x2=5 //y2=6.74
cc_296 ( N_noxref_2_M8_noxref_d N_noxref_6_c_737_n ) capacitor c=0.00510287f \
 //x=4.415 //y=5.025 //x2=5 //y2=6.74
cc_297 ( N_noxref_2_c_269_n N_noxref_6_c_757_n ) capacitor c=6.1128e-19 \
 //x=4.56 //y=6.855 //x2=5.88 //y2=6.74
cc_298 ( N_noxref_2_c_339_p N_noxref_6_c_757_n ) capacitor c=0.00192921f \
 //x=6.29 //y=7.4 //x2=5.88 //y2=6.74
cc_299 ( N_noxref_2_c_281_n N_noxref_6_c_757_n ) capacitor c=0.0115285f \
 //x=6.29 //y=7.4 //x2=5.88 //y2=6.74
cc_300 ( N_noxref_2_c_262_n N_noxref_6_c_738_n ) capacitor c=0.00240599f \
 //x=4.475 //y=7.4 //x2=4.12 //y2=5.38
cc_301 ( N_noxref_2_c_269_n N_noxref_6_c_738_n ) capacitor c=0.00220777f \
 //x=4.56 //y=6.855 //x2=4.12 //y2=5.38
cc_302 ( N_noxref_2_c_271_n N_noxref_6_c_738_n ) capacitor c=0.00154298f \
 //x=4.56 //y=7.23 //x2=4.12 //y2=5.38
cc_303 ( N_noxref_2_c_281_n N_noxref_6_c_738_n ) capacitor c=0.0142846f \
 //x=6.29 //y=7.4 //x2=4.12 //y2=5.38
cc_304 ( N_noxref_2_c_289_n N_noxref_6_c_738_n ) capacitor c=0.0552885f \
 //x=3.33 //y=7.4 //x2=4.12 //y2=5.38
cc_305 ( N_noxref_2_M7_noxref_d N_noxref_6_c_738_n ) capacitor c=0.00271974f \
 //x=2.405 //y=5.02 //x2=4.12 //y2=5.38
cc_306 ( N_noxref_2_M8_noxref_d N_noxref_6_c_738_n ) capacitor c=0.0736177f \
 //x=4.415 //y=5.025 //x2=4.12 //y2=5.38
cc_307 ( N_noxref_2_c_269_n N_noxref_6_c_742_n ) capacitor c=0.00211426f \
 //x=4.56 //y=6.855 //x2=5 //y2=5.38
cc_308 ( N_noxref_2_c_271_n N_noxref_6_c_742_n ) capacitor c=4.62894e-19 \
 //x=4.56 //y=7.23 //x2=5 //y2=5.38
cc_309 ( N_noxref_2_c_339_p N_noxref_6_c_742_n ) capacitor c=0.0020548f \
 //x=6.29 //y=7.4 //x2=5 //y2=5.38
cc_310 ( N_noxref_2_c_281_n N_noxref_6_c_742_n ) capacitor c=0.0095667f \
 //x=6.29 //y=7.4 //x2=5 //y2=5.38
cc_311 ( N_noxref_2_M8_noxref_d N_noxref_6_c_742_n ) capacitor c=0.0673401f \
 //x=4.415 //y=5.025 //x2=5 //y2=5.38
cc_312 ( N_noxref_2_c_262_n N_noxref_6_M8_noxref_s ) capacitor c=0.0245587f \
 //x=4.475 //y=7.4 //x2=3.985 //y2=5.025
cc_313 ( N_noxref_2_c_269_n N_noxref_6_M8_noxref_s ) capacitor c=0.0378001f \
 //x=4.56 //y=6.855 //x2=3.985 //y2=5.025
cc_314 ( N_noxref_2_c_271_n N_noxref_6_M8_noxref_s ) capacitor c=0.0124823f \
 //x=4.56 //y=7.23 //x2=3.985 //y2=5.025
cc_315 ( N_noxref_2_c_281_n N_noxref_6_M8_noxref_s ) capacitor c=0.00422395f \
 //x=6.29 //y=7.4 //x2=3.985 //y2=5.025
cc_316 ( N_noxref_2_c_289_n N_noxref_6_M8_noxref_s ) capacitor c=0.00933367f \
 //x=3.33 //y=7.4 //x2=3.985 //y2=5.025
cc_317 ( N_noxref_2_M8_noxref_d N_noxref_6_M8_noxref_s ) capacitor \
 c=0.00566597f //x=4.415 //y=5.025 //x2=3.985 //y2=5.025
cc_318 ( N_noxref_2_c_339_p N_noxref_6_M11_noxref_d ) capacitor c=0.00206634f \
 //x=6.29 //y=7.4 //x2=5.735 //y2=5.025
cc_319 ( N_noxref_2_c_281_n N_noxref_6_M11_noxref_d ) capacitor c=0.0548315f \
 //x=6.29 //y=7.4 //x2=5.735 //y2=5.025
cc_320 ( N_noxref_2_c_281_n N_noxref_7_c_824_n ) capacitor c=0.00231379f \
 //x=6.29 //y=7.4 //x2=5.215 //y2=4.705
cc_321 ( N_noxref_2_c_281_n N_noxref_7_M10_noxref_g ) capacitor c=0.00720064f \
 //x=6.29 //y=7.4 //x2=5.22 //y2=6.025
cc_322 ( N_noxref_2_c_281_n N_noxref_7_M11_noxref_g ) capacitor c=0.00776897f \
 //x=6.29 //y=7.4 //x2=5.66 //y2=6.025
cc_323 ( N_noxref_2_c_281_n N_noxref_7_c_853_n ) capacitor c=0.026151f \
 //x=6.29 //y=7.4 //x2=5.585 //y2=4.795
cc_324 ( N_noxref_2_c_281_n N_noxref_7_c_845_n ) capacitor c=2.75092e-19 \
 //x=6.29 //y=7.4 //x2=5.215 //y2=4.705
cc_325 ( N_noxref_2_c_339_p N_noxref_8_c_956_n ) capacitor c=2.8973e-19 \
 //x=6.29 //y=7.4 //x2=5.835 //y2=5.21
cc_326 ( N_noxref_2_c_281_n N_noxref_8_c_956_n ) capacitor c=0.00162142f \
 //x=6.29 //y=7.4 //x2=5.835 //y2=5.21
cc_327 ( N_noxref_2_c_281_n N_noxref_8_c_942_n ) capacitor c=0.0391003f \
 //x=6.29 //y=7.4 //x2=5.92 //y2=5.125
cc_328 ( N_noxref_2_c_289_n N_noxref_8_c_942_n ) capacitor c=6.33429e-19 \
 //x=3.33 //y=7.4 //x2=5.92 //y2=5.125
cc_329 ( N_noxref_2_c_281_n N_noxref_8_c_946_n ) capacitor c=0.00422052f \
 //x=6.29 //y=7.4 //x2=5.435 //y2=5.21
cc_330 ( N_noxref_2_c_281_n N_noxref_8_c_961_n ) capacitor c=0.0145895f \
 //x=6.29 //y=7.4 //x2=5.44 //y2=5.38
cc_331 ( N_noxref_2_M8_noxref_d N_noxref_8_c_961_n ) capacitor c=0.00560411f \
 //x=4.415 //y=5.025 //x2=5.44 //y2=5.38
cc_332 ( N_noxref_3_c_409_p N_noxref_4_c_521_n ) capacitor c=6.60635e-19 \
 //x=1.11 //y=2.08 //x2=1.095 //y2=0
cc_333 ( N_noxref_3_c_409_p N_noxref_4_c_487_n ) capacitor c=0.00709452f \
 //x=1.11 //y=2.08 //x2=1.18 //y2=0.955
cc_334 ( N_noxref_3_c_411_p N_noxref_4_c_487_n ) capacitor c=2.13705e-19 \
 //x=1.11 //y=2.08 //x2=1.18 //y2=0.955
cc_335 ( N_noxref_3_c_412_p N_noxref_4_c_487_n ) capacitor c=0.00156094f \
 //x=0.915 //y=0.865 //x2=1.18 //y2=0.955
cc_336 ( N_noxref_3_c_413_p N_noxref_4_c_487_n ) capacitor c=0.00413828f \
 //x=0.915 //y=1.21 //x2=1.18 //y2=0.955
cc_337 ( N_noxref_3_c_414_p N_noxref_4_c_487_n ) capacitor c=4.2764e-19 \
 //x=0.915 //y=1.52 //x2=1.18 //y2=0.955
cc_338 ( N_noxref_3_c_415_p N_noxref_4_c_487_n ) capacitor c=5.3458e-19 \
 //x=1.29 //y=0.71 //x2=1.18 //y2=0.955
cc_339 ( N_noxref_3_c_416_p N_noxref_4_c_487_n ) capacitor c=6.38426e-19 \
 //x=1.29 //y=1.365 //x2=1.18 //y2=0.955
cc_340 ( N_noxref_3_c_417_p N_noxref_4_c_487_n ) capacitor c=0.00156575f \
 //x=1.445 //y=0.865 //x2=1.18 //y2=0.955
cc_341 ( N_noxref_3_c_418_p N_noxref_4_c_487_n ) capacitor c=0.00296337f \
 //x=1.445 //y=1.21 //x2=1.18 //y2=0.955
cc_342 ( N_noxref_3_c_412_p N_noxref_4_c_531_n ) capacitor c=3.51399e-19 \
 //x=0.915 //y=0.865 //x2=1.177 //y2=0.825
cc_343 ( N_noxref_3_c_415_p N_noxref_4_c_531_n ) capacitor c=0.00864436f \
 //x=1.29 //y=0.71 //x2=1.177 //y2=0.825
cc_344 ( N_noxref_3_c_417_p N_noxref_4_c_531_n ) capacitor c=4.45447e-19 \
 //x=1.445 //y=0.865 //x2=1.177 //y2=0.825
cc_345 ( N_noxref_3_c_412_p N_noxref_4_c_490_n ) capacitor c=0.0069219f \
 //x=0.915 //y=0.865 //x2=3.16 //y2=0
cc_346 ( N_noxref_3_c_409_p N_noxref_4_c_492_n ) capacitor c=0.0082376f \
 //x=1.11 //y=2.08 //x2=0.74 //y2=0
cc_347 ( N_noxref_3_c_387_n N_noxref_4_c_492_n ) capacitor c=0.0113215f \
 //x=1.112 //y=4.56 //x2=0.74 //y2=0
cc_348 ( N_noxref_3_c_411_p N_noxref_4_c_492_n ) capacitor c=0.00369668f \
 //x=1.11 //y=2.08 //x2=0.74 //y2=0
cc_349 ( N_noxref_3_c_414_p N_noxref_4_c_492_n ) capacitor c=0.0015404f \
 //x=0.915 //y=1.52 //x2=0.74 //y2=0
cc_350 ( N_noxref_3_c_427_p N_noxref_4_c_492_n ) capacitor c=0.00950704f \
 //x=0.915 //y=1.915 //x2=0.74 //y2=0
cc_351 ( N_noxref_3_c_409_p N_noxref_4_M0_noxref_d ) capacitor c=2.20438e-19 \
 //x=1.11 //y=2.08 //x2=0.99 //y2=0.865
cc_352 ( N_noxref_3_c_412_p N_noxref_4_M0_noxref_d ) capacitor c=0.00192399f \
 //x=0.915 //y=0.865 //x2=0.99 //y2=0.865
cc_353 ( N_noxref_3_c_413_p N_noxref_4_M0_noxref_d ) capacitor c=0.00210798f \
 //x=0.915 //y=1.21 //x2=0.99 //y2=0.865
cc_354 ( N_noxref_3_c_415_p N_noxref_4_M0_noxref_d ) capacitor c=0.00472259f \
 //x=1.29 //y=0.71 //x2=0.99 //y2=0.865
cc_355 ( N_noxref_3_c_416_p N_noxref_4_M0_noxref_d ) capacitor c=0.00166857f \
 //x=1.29 //y=1.365 //x2=0.99 //y2=0.865
cc_356 ( N_noxref_3_c_417_p N_noxref_4_M0_noxref_d ) capacitor c=0.00230174f \
 //x=1.445 //y=0.865 //x2=0.99 //y2=0.865
cc_357 ( N_noxref_3_c_418_p N_noxref_4_M0_noxref_d ) capacitor c=0.00210798f \
 //x=1.445 //y=1.21 //x2=0.99 //y2=0.865
cc_358 ( N_noxref_3_c_385_n N_noxref_5_c_619_n ) capacitor c=0.0172939f \
 //x=1.11 //y=4.7 //x2=1.85 //y2=4.555
cc_359 ( N_noxref_3_c_387_n N_noxref_5_c_619_n ) capacitor c=0.109381f \
 //x=1.112 //y=4.56 //x2=1.85 //y2=4.555
cc_360 ( N_noxref_3_c_411_p N_noxref_5_c_619_n ) capacitor c=3.49899e-19 \
 //x=1.11 //y=2.08 //x2=1.85 //y2=4.555
cc_361 ( N_noxref_3_c_389_n N_noxref_5_c_619_n ) capacitor c=7.76143e-19 \
 //x=1.11 //y=4.7 //x2=1.85 //y2=4.555
cc_362 ( N_noxref_3_c_396_n N_noxref_5_c_619_n ) capacitor c=0.00201171f \
 //x=1.11 //y=4.7 //x2=1.85 //y2=4.555
cc_363 ( N_noxref_3_c_409_p N_noxref_5_c_627_n ) capacitor c=0.0205342f \
 //x=1.11 //y=2.08 //x2=1.85 //y2=2.08
cc_364 ( N_noxref_3_c_411_p N_noxref_5_c_627_n ) capacitor c=5.16867e-19 \
 //x=1.11 //y=2.08 //x2=1.85 //y2=2.08
cc_365 ( N_noxref_3_c_427_p N_noxref_5_c_627_n ) capacitor c=0.00167888f \
 //x=0.915 //y=1.915 //x2=1.85 //y2=2.08
cc_366 ( N_noxref_3_c_409_p N_noxref_5_c_629_n ) capacitor c=0.00370824f \
 //x=1.11 //y=2.08 //x2=1.85 //y2=2.08
cc_367 ( N_noxref_3_c_387_n N_noxref_5_c_629_n ) capacitor c=3.49899e-19 \
 //x=1.112 //y=4.56 //x2=1.85 //y2=2.08
cc_368 ( N_noxref_3_c_411_p N_noxref_5_c_629_n ) capacitor c=0.00445529f \
 //x=1.11 //y=2.08 //x2=1.85 //y2=2.08
cc_369 ( N_noxref_3_c_427_p N_noxref_5_c_629_n ) capacitor c=0.00267961f \
 //x=0.915 //y=1.915 //x2=1.85 //y2=2.08
cc_370 ( N_noxref_3_c_385_n N_noxref_5_c_630_n ) capacitor c=0.00389735f \
 //x=1.11 //y=4.7 //x2=1.88 //y2=4.7
cc_371 ( N_noxref_3_c_387_n N_noxref_5_c_630_n ) capacitor c=2.1563e-19 \
 //x=1.112 //y=4.56 //x2=1.88 //y2=4.7
cc_372 ( N_noxref_3_c_389_n N_noxref_5_c_630_n ) capacitor c=0.00397338f \
 //x=1.11 //y=4.7 //x2=1.88 //y2=4.7
cc_373 ( N_noxref_3_c_396_n N_noxref_5_c_630_n ) capacitor c=0.00283894f \
 //x=1.11 //y=4.7 //x2=1.88 //y2=4.7
cc_374 ( N_noxref_3_M4_noxref_g N_noxref_5_M6_noxref_g ) capacitor \
 c=0.0104892f //x=1.01 //y=6.02 //x2=1.89 //y2=6.02
cc_375 ( N_noxref_3_M5_noxref_g N_noxref_5_M6_noxref_g ) capacitor c=0.107636f \
 //x=1.45 //y=6.02 //x2=1.89 //y2=6.02
cc_376 ( N_noxref_3_M5_noxref_g N_noxref_5_M7_noxref_g ) capacitor \
 c=0.0100341f //x=1.45 //y=6.02 //x2=2.33 //y2=6.02
cc_377 ( N_noxref_3_c_412_p N_noxref_5_c_638_n ) capacitor c=4.86545e-19 \
 //x=0.915 //y=0.865 //x2=1.885 //y2=0.905
cc_378 ( N_noxref_3_c_413_p N_noxref_5_c_638_n ) capacitor c=0.00152405f \
 //x=0.915 //y=1.21 //x2=1.885 //y2=0.905
cc_379 ( N_noxref_3_c_417_p N_noxref_5_c_638_n ) capacitor c=0.0151475f \
 //x=1.445 //y=0.865 //x2=1.885 //y2=0.905
cc_380 ( N_noxref_3_c_414_p N_noxref_5_c_640_n ) capacitor c=0.00109982f \
 //x=0.915 //y=1.52 //x2=1.885 //y2=1.25
cc_381 ( N_noxref_3_c_418_p N_noxref_5_c_640_n ) capacitor c=0.0111064f \
 //x=1.445 //y=1.21 //x2=1.885 //y2=1.25
cc_382 ( N_noxref_3_c_414_p N_noxref_5_c_643_n ) capacitor c=9.58243e-19 \
 //x=0.915 //y=1.52 //x2=1.885 //y2=1.56
cc_383 ( N_noxref_3_c_427_p N_noxref_5_c_643_n ) capacitor c=0.00662747f \
 //x=0.915 //y=1.915 //x2=1.885 //y2=1.56
cc_384 ( N_noxref_3_c_418_p N_noxref_5_c_643_n ) capacitor c=0.00862358f \
 //x=1.445 //y=1.21 //x2=1.885 //y2=1.56
cc_385 ( N_noxref_3_c_417_p N_noxref_5_c_653_n ) capacitor c=0.00127211f \
 //x=1.445 //y=0.865 //x2=2.415 //y2=0.905
cc_386 ( N_noxref_3_c_418_p N_noxref_5_c_655_n ) capacitor c=0.00204774f \
 //x=1.445 //y=1.21 //x2=2.415 //y2=1.25
cc_387 ( N_noxref_3_c_409_p N_noxref_5_c_659_n ) capacitor c=0.00167305f \
 //x=1.11 //y=2.08 //x2=1.85 //y2=2.08
cc_388 ( N_noxref_3_c_411_p N_noxref_5_c_659_n ) capacitor c=0.00266443f \
 //x=1.11 //y=2.08 //x2=1.85 //y2=2.08
cc_389 ( N_noxref_3_c_427_p N_noxref_5_c_659_n ) capacitor c=0.0181449f \
 //x=0.915 //y=1.915 //x2=1.85 //y2=2.08
cc_390 ( N_noxref_3_c_385_n N_noxref_5_c_662_n ) capacitor c=0.00158715f \
 //x=1.11 //y=4.7 //x2=1.88 //y2=4.7
cc_391 ( N_noxref_3_c_389_n N_noxref_5_c_662_n ) capacitor c=0.00237977f \
 //x=1.11 //y=4.7 //x2=1.88 //y2=4.7
cc_392 ( N_noxref_3_c_396_n N_noxref_5_c_662_n ) capacitor c=0.0297875f \
 //x=1.11 //y=4.7 //x2=1.88 //y2=4.7
cc_393 ( N_noxref_3_c_427_p N_noxref_9_c_1052_n ) capacitor c=0.00262672f \
 //x=0.915 //y=1.915 //x2=0.695 //y2=1.495
cc_394 ( N_noxref_3_c_409_p N_noxref_9_c_1053_n ) capacitor c=0.00459552f \
 //x=1.11 //y=2.08 //x2=1.58 //y2=1.58
cc_395 ( N_noxref_3_c_411_p N_noxref_9_c_1053_n ) capacitor c=0.00763108f \
 //x=1.11 //y=2.08 //x2=1.58 //y2=1.58
cc_396 ( N_noxref_3_c_414_p N_noxref_9_c_1053_n ) capacitor c=0.00695869f \
 //x=0.915 //y=1.52 //x2=1.58 //y2=1.58
cc_397 ( N_noxref_3_c_427_p N_noxref_9_c_1053_n ) capacitor c=0.0194861f \
 //x=0.915 //y=1.915 //x2=1.58 //y2=1.58
cc_398 ( N_noxref_3_c_416_p N_noxref_9_c_1053_n ) capacitor c=0.00723574f \
 //x=1.29 //y=1.365 //x2=1.58 //y2=1.58
cc_399 ( N_noxref_3_c_418_p N_noxref_9_c_1053_n ) capacitor c=0.00339872f \
 //x=1.445 //y=1.21 //x2=1.58 //y2=1.58
cc_400 ( N_noxref_3_c_427_p N_noxref_9_c_1042_n ) capacitor c=6.71402e-19 \
 //x=0.915 //y=1.915 //x2=1.665 //y2=1.495
cc_401 ( N_noxref_3_c_412_p N_noxref_9_M0_noxref_s ) capacitor c=0.0294925f \
 //x=0.915 //y=0.865 //x2=0.56 //y2=0.365
cc_402 ( N_noxref_3_c_414_p N_noxref_9_M0_noxref_s ) capacitor c=3.48408e-19 \
 //x=0.915 //y=1.52 //x2=0.56 //y2=0.365
cc_403 ( N_noxref_3_c_417_p N_noxref_9_M0_noxref_s ) capacitor c=0.0125442f \
 //x=1.445 //y=0.865 //x2=0.56 //y2=0.365
cc_404 ( N_noxref_4_c_481_n N_noxref_5_c_627_n ) capacitor c=0.00234099f \
 //x=6.29 //y=0 //x2=1.85 //y2=2.08
cc_405 ( N_noxref_4_c_490_n N_noxref_5_c_627_n ) capacitor c=3.77673e-19 \
 //x=3.16 //y=0 //x2=1.85 //y2=2.08
cc_406 ( N_noxref_4_c_502_n N_noxref_5_c_629_n ) capacitor c=0.00224736f \
 //x=3.33 //y=0 //x2=1.85 //y2=2.08
cc_407 ( N_noxref_4_c_502_n N_noxref_5_c_655_n ) capacitor c=0.00275184f \
 //x=3.33 //y=0 //x2=2.415 //y2=1.25
cc_408 ( N_noxref_4_c_502_n N_noxref_5_c_659_n ) capacitor c=2.63786e-19 \
 //x=3.33 //y=0 //x2=1.85 //y2=2.08
cc_409 ( N_noxref_4_c_552_p N_noxref_7_c_806_n ) capacitor c=6.61292e-19 \
 //x=5.88 //y=0.53 //x2=5.18 //y2=2.08
cc_410 ( N_noxref_4_c_552_p N_noxref_7_c_820_n ) capacitor c=8.64363e-19 \
 //x=5.88 //y=0.53 //x2=5.18 //y2=2.08
cc_411 ( N_noxref_4_c_500_n N_noxref_7_c_820_n ) capacitor c=0.00224736f \
 //x=6.29 //y=0 //x2=5.18 //y2=2.08
cc_412 ( N_noxref_4_c_552_p N_noxref_7_c_831_n ) capacitor c=0.0210318f \
 //x=5.88 //y=0.53 //x2=5.215 //y2=0.905
cc_413 ( N_noxref_4_M2_noxref_s N_noxref_7_c_831_n ) capacitor c=0.00720961f \
 //x=3.89 //y=0.365 //x2=5.215 //y2=0.905
cc_414 ( N_noxref_4_c_500_n N_noxref_7_c_838_n ) capacitor c=0.00300407f \
 //x=6.29 //y=0 //x2=5.59 //y2=1.405
cc_415 ( N_noxref_4_M2_noxref_s N_noxref_7_c_838_n ) capacitor c=0.00271091f \
 //x=3.89 //y=0.365 //x2=5.59 //y2=1.405
cc_416 ( N_noxref_4_c_552_p N_noxref_7_c_839_n ) capacitor c=0.00825432f \
 //x=5.88 //y=0.53 //x2=5.745 //y2=0.905
cc_417 ( N_noxref_4_M2_noxref_s N_noxref_7_c_839_n ) capacitor c=0.0151996f \
 //x=3.89 //y=0.365 //x2=5.745 //y2=0.905
cc_418 ( N_noxref_4_c_552_p N_noxref_7_c_841_n ) capacitor c=2.1838e-19 \
 //x=5.88 //y=0.53 //x2=5.18 //y2=2.08
cc_419 ( N_noxref_4_c_500_n N_noxref_7_c_841_n ) capacitor c=2.63786e-19 \
 //x=6.29 //y=0 //x2=5.18 //y2=2.08
cc_420 ( N_noxref_4_M2_noxref_s N_noxref_7_c_841_n ) capacitor c=0.00119118f \
 //x=3.89 //y=0.365 //x2=5.18 //y2=2.08
cc_421 ( N_noxref_4_c_481_n N_noxref_8_c_918_n ) capacitor c=0.00994852f \
 //x=6.29 //y=0 //x2=4.51 //y2=1.125
cc_422 ( N_noxref_4_c_487_n N_noxref_8_c_918_n ) capacitor c=4.59693e-19 \
 //x=1.18 //y=0.955 //x2=4.51 //y2=1.125
cc_423 ( N_noxref_4_c_494_n N_noxref_8_c_918_n ) capacitor c=0.00372564f \
 //x=4.91 //y=0.53 //x2=4.51 //y2=1.125
cc_424 ( N_noxref_4_c_500_n N_noxref_8_c_918_n ) capacitor c=3.01913e-19 \
 //x=6.29 //y=0 //x2=4.51 //y2=1.125
cc_425 ( N_noxref_4_M2_noxref_s N_noxref_8_c_918_n ) capacitor c=0.00926082f \
 //x=3.89 //y=0.365 //x2=4.51 //y2=1.125
cc_426 ( N_noxref_4_M2_noxref_s N_noxref_8_c_927_n ) capacitor c=0.0225586f \
 //x=3.89 //y=0.365 //x2=4.51 //y2=1.57
cc_427 ( N_noxref_4_c_481_n N_noxref_8_c_933_n ) capacitor c=0.00677162f \
 //x=6.29 //y=0 //x2=5.395 //y2=1.655
cc_428 ( N_noxref_4_c_494_n N_noxref_8_c_933_n ) capacitor c=0.00128856f \
 //x=4.91 //y=0.53 //x2=5.395 //y2=1.655
cc_429 ( N_noxref_4_c_552_p N_noxref_8_c_933_n ) capacitor c=0.00105223f \
 //x=5.88 //y=0.53 //x2=5.395 //y2=1.655
cc_430 ( N_noxref_4_M2_noxref_s N_noxref_8_c_933_n ) capacitor c=0.00857479f \
 //x=3.89 //y=0.365 //x2=5.395 //y2=1.655
cc_431 ( N_noxref_4_c_481_n N_noxref_8_c_973_n ) capacitor c=0.0106127f \
 //x=6.29 //y=0 //x2=5.48 //y2=1.12
cc_432 ( N_noxref_4_c_552_p N_noxref_8_c_973_n ) capacitor c=0.00469733f \
 //x=5.88 //y=0.53 //x2=5.48 //y2=1.12
cc_433 ( N_noxref_4_c_500_n N_noxref_8_c_973_n ) capacitor c=3.01913e-19 \
 //x=6.29 //y=0 //x2=5.48 //y2=1.12
cc_434 ( N_noxref_4_M2_noxref_s N_noxref_8_c_973_n ) capacitor c=0.0110093f \
 //x=3.89 //y=0.365 //x2=5.48 //y2=1.12
cc_435 ( N_noxref_4_c_500_n N_noxref_8_c_940_n ) capacitor c=0.00532028f \
 //x=6.29 //y=0 //x2=5.48 //y2=1.57
cc_436 ( N_noxref_4_M2_noxref_s N_noxref_8_c_940_n ) capacitor c=0.0124822f \
 //x=3.89 //y=0.365 //x2=5.48 //y2=1.57
cc_437 ( N_noxref_4_c_481_n N_noxref_8_c_979_n ) capacitor c=0.0066335f \
 //x=6.29 //y=0 //x2=5.835 //y2=1.655
cc_438 ( N_noxref_4_c_552_p N_noxref_8_c_979_n ) capacitor c=0.00342061f \
 //x=5.88 //y=0.53 //x2=5.835 //y2=1.655
cc_439 ( N_noxref_4_c_500_n N_noxref_8_c_979_n ) capacitor c=0.0393366f \
 //x=6.29 //y=0 //x2=5.835 //y2=1.655
cc_440 ( N_noxref_4_M2_noxref_s N_noxref_8_c_979_n ) capacitor c=0.0105928f \
 //x=3.89 //y=0.365 //x2=5.835 //y2=1.655
cc_441 ( N_noxref_4_c_481_n N_noxref_8_M2_noxref_d ) capacitor c=3.01654e-19 \
 //x=6.29 //y=0 //x2=4.32 //y2=0.905
cc_442 ( N_noxref_4_c_494_n N_noxref_8_M2_noxref_d ) capacitor c=0.0124264f \
 //x=4.91 //y=0.53 //x2=4.32 //y2=0.905
cc_443 ( N_noxref_4_M2_noxref_s N_noxref_8_M2_noxref_d ) capacitor \
 c=0.0297221f //x=3.89 //y=0.365 //x2=4.32 //y2=0.905
cc_444 ( N_noxref_4_c_481_n N_noxref_8_M3_noxref_d ) capacitor c=3.01654e-19 \
 //x=6.29 //y=0 //x2=5.29 //y2=0.905
cc_445 ( N_noxref_4_c_552_p N_noxref_8_M3_noxref_d ) capacitor c=0.0122548f \
 //x=5.88 //y=0.53 //x2=5.29 //y2=0.905
cc_446 ( N_noxref_4_M2_noxref_s N_noxref_8_M3_noxref_d ) capacitor c=0.029747f \
 //x=3.89 //y=0.365 //x2=5.29 //y2=0.905
cc_447 ( N_noxref_4_c_521_n N_noxref_9_c_1053_n ) capacitor c=0.00275882f \
 //x=1.095 //y=0 //x2=1.58 //y2=1.58
cc_448 ( N_noxref_4_c_481_n N_noxref_9_c_1053_n ) capacitor c=0.00203715f \
 //x=6.29 //y=0 //x2=1.58 //y2=1.58
cc_449 ( N_noxref_4_c_487_n N_noxref_9_c_1053_n ) capacitor c=0.00407704f \
 //x=1.18 //y=0.955 //x2=1.58 //y2=1.58
cc_450 ( N_noxref_4_c_490_n N_noxref_9_c_1053_n ) capacitor c=0.00369095f \
 //x=3.16 //y=0 //x2=1.58 //y2=1.58
cc_451 ( N_noxref_4_M0_noxref_d N_noxref_9_c_1053_n ) capacitor c=0.00578453f \
 //x=0.99 //y=0.865 //x2=1.58 //y2=1.58
cc_452 ( N_noxref_4_c_481_n N_noxref_9_c_1068_n ) capacitor c=0.00681952f \
 //x=6.29 //y=0 //x2=1.665 //y2=0.615
cc_453 ( N_noxref_4_c_531_n N_noxref_9_c_1068_n ) capacitor c=0.0167642f \
 //x=1.177 //y=0.825 //x2=1.665 //y2=0.615
cc_454 ( N_noxref_4_c_490_n N_noxref_9_c_1068_n ) capacitor c=0.0146219f \
 //x=3.16 //y=0 //x2=1.665 //y2=0.615
cc_455 ( N_noxref_4_c_492_n N_noxref_9_c_1068_n ) capacitor c=0.00283128f \
 //x=0.74 //y=0 //x2=1.665 //y2=0.615
cc_456 ( N_noxref_4_c_500_n N_noxref_9_c_1068_n ) capacitor c=0.00145873f \
 //x=6.29 //y=0 //x2=1.665 //y2=0.615
cc_457 ( N_noxref_4_c_502_n N_noxref_9_c_1068_n ) capacitor c=2.21767e-19 \
 //x=3.33 //y=0 //x2=1.665 //y2=0.615
cc_458 ( N_noxref_4_c_492_n N_noxref_9_c_1042_n ) capacitor c=2.85935e-19 \
 //x=0.74 //y=0 //x2=1.665 //y2=1.495
cc_459 ( N_noxref_4_c_481_n N_noxref_9_c_1043_n ) capacitor c=0.0100359f \
 //x=6.29 //y=0 //x2=2.55 //y2=0.53
cc_460 ( N_noxref_4_c_490_n N_noxref_9_c_1043_n ) capacitor c=0.0374415f \
 //x=3.16 //y=0 //x2=2.55 //y2=0.53
cc_461 ( N_noxref_4_c_500_n N_noxref_9_c_1043_n ) capacitor c=0.002964f \
 //x=6.29 //y=0 //x2=2.55 //y2=0.53
cc_462 ( N_noxref_4_c_481_n N_noxref_9_c_1078_n ) capacitor c=0.00244943f \
 //x=6.29 //y=0 //x2=2.635 //y2=0.615
cc_463 ( N_noxref_4_c_490_n N_noxref_9_c_1078_n ) capacitor c=0.0145161f \
 //x=3.16 //y=0 //x2=2.635 //y2=0.615
cc_464 ( N_noxref_4_c_607_p N_noxref_9_c_1078_n ) capacitor c=0.0019997f \
 //x=4.025 //y=0.445 //x2=2.635 //y2=0.615
cc_465 ( N_noxref_4_c_500_n N_noxref_9_c_1078_n ) capacitor c=0.00145015f \
 //x=6.29 //y=0 //x2=2.635 //y2=0.615
cc_466 ( N_noxref_4_c_502_n N_noxref_9_c_1078_n ) capacitor c=0.0401922f \
 //x=3.33 //y=0 //x2=2.635 //y2=0.615
cc_467 ( N_noxref_4_c_521_n N_noxref_9_M0_noxref_s ) capacitor c=0.00723598f \
 //x=1.095 //y=0 //x2=0.56 //y2=0.365
cc_468 ( N_noxref_4_c_487_n N_noxref_9_M0_noxref_s ) capacitor c=0.0113988f \
 //x=1.18 //y=0.955 //x2=0.56 //y2=0.365
cc_469 ( N_noxref_4_c_531_n N_noxref_9_M0_noxref_s ) capacitor c=0.0173062f \
 //x=1.177 //y=0.825 //x2=0.56 //y2=0.365
cc_470 ( N_noxref_4_c_490_n N_noxref_9_M0_noxref_s ) capacitor c=0.0146208f \
 //x=3.16 //y=0 //x2=0.56 //y2=0.365
cc_471 ( N_noxref_4_c_492_n N_noxref_9_M0_noxref_s ) capacitor c=0.0559891f \
 //x=0.74 //y=0 //x2=0.56 //y2=0.365
cc_472 ( N_noxref_4_c_500_n N_noxref_9_M0_noxref_s ) capacitor c=0.00145873f \
 //x=6.29 //y=0 //x2=0.56 //y2=0.365
cc_473 ( N_noxref_4_c_502_n N_noxref_9_M0_noxref_s ) capacitor c=0.00642623f \
 //x=3.33 //y=0 //x2=0.56 //y2=0.365
cc_474 ( N_noxref_4_M0_noxref_d N_noxref_9_M0_noxref_s ) capacitor \
 c=0.0271276f //x=0.99 //y=0.865 //x2=0.56 //y2=0.365
cc_475 ( N_noxref_4_M2_noxref_s N_noxref_9_M0_noxref_s ) capacitor \
 c=0.00298769f //x=3.89 //y=0.365 //x2=0.56 //y2=0.365
cc_476 ( N_noxref_5_c_627_n N_noxref_9_c_1042_n ) capacitor c=7.471e-19 \
 //x=1.85 //y=2.08 //x2=1.665 //y2=1.495
cc_477 ( N_noxref_5_c_643_n N_noxref_9_c_1042_n ) capacitor c=0.00888238f \
 //x=1.885 //y=1.56 //x2=1.665 //y2=1.495
cc_478 ( N_noxref_5_c_659_n N_noxref_9_c_1042_n ) capacitor c=0.00173073f \
 //x=1.85 //y=2.08 //x2=1.665 //y2=1.495
cc_479 ( N_noxref_5_c_627_n N_noxref_9_c_1043_n ) capacitor c=0.00141156f \
 //x=1.85 //y=2.08 //x2=2.55 //y2=0.53
cc_480 ( N_noxref_5_c_629_n N_noxref_9_c_1043_n ) capacitor c=8.82141e-19 \
 //x=1.85 //y=2.08 //x2=2.55 //y2=0.53
cc_481 ( N_noxref_5_c_638_n N_noxref_9_c_1043_n ) capacitor c=0.0199501f \
 //x=1.885 //y=0.905 //x2=2.55 //y2=0.53
cc_482 ( N_noxref_5_c_653_n N_noxref_9_c_1043_n ) capacitor c=0.00825432f \
 //x=2.415 //y=0.905 //x2=2.55 //y2=0.53
cc_483 ( N_noxref_5_c_659_n N_noxref_9_c_1043_n ) capacitor c=2.1838e-19 \
 //x=1.85 //y=2.08 //x2=2.55 //y2=0.53
cc_484 ( N_noxref_5_c_638_n N_noxref_9_M0_noxref_s ) capacitor c=0.00888238f \
 //x=1.885 //y=0.905 //x2=0.56 //y2=0.365
cc_485 ( N_noxref_5_c_653_n N_noxref_9_M0_noxref_s ) capacitor c=0.015333f \
 //x=2.415 //y=0.905 //x2=0.56 //y2=0.365
cc_486 ( N_noxref_5_c_655_n N_noxref_9_M0_noxref_s ) capacitor c=0.00248746f \
 //x=2.415 //y=1.25 //x2=0.56 //y2=0.365
cc_487 ( N_noxref_6_c_736_n N_noxref_7_c_806_n ) capacitor c=7.31659e-19 //x=5 \
 //y=5.21 //x2=5.18 //y2=2.08
cc_488 ( N_noxref_6_c_749_n N_noxref_7_c_809_n ) capacitor c=0.00213985f \
 //x=5.75 //y=6.91 //x2=5.215 //y2=4.705
cc_489 ( N_noxref_6_c_736_n N_noxref_7_c_809_n ) capacitor c=0.00262304f //x=5 \
 //y=5.21 //x2=5.215 //y2=4.705
cc_490 ( N_noxref_6_c_749_n N_noxref_7_c_824_n ) capacitor c=0.00233585f \
 //x=5.75 //y=6.91 //x2=5.215 //y2=4.705
cc_491 ( N_noxref_6_c_749_n N_noxref_7_M10_noxref_g ) capacitor c=0.00777443f \
 //x=5.75 //y=6.91 //x2=5.22 //y2=6.025
cc_492 ( N_noxref_6_c_736_n N_noxref_7_M10_noxref_g ) capacitor c=0.00176767f \
 //x=5 //y=5.21 //x2=5.22 //y2=6.025
cc_493 ( N_noxref_6_c_737_n N_noxref_7_M10_noxref_g ) capacitor c=0.00186228f \
 //x=5 //y=6.74 //x2=5.22 //y2=6.025
cc_494 ( N_noxref_6_c_742_n N_noxref_7_M10_noxref_g ) capacitor c=0.0170175f \
 //x=5 //y=5.38 //x2=5.22 //y2=6.025
cc_495 ( N_noxref_6_c_749_n N_noxref_7_M11_noxref_g ) capacitor c=0.0093887f \
 //x=5.75 //y=6.91 //x2=5.66 //y2=6.025
cc_496 ( N_noxref_6_c_757_n N_noxref_7_M11_noxref_g ) capacitor c=0.00410728f \
 //x=5.88 //y=6.74 //x2=5.66 //y2=6.025
cc_497 ( N_noxref_6_M11_noxref_d N_noxref_7_M11_noxref_g ) capacitor \
 c=0.0365939f //x=5.735 //y=5.025 //x2=5.66 //y2=6.025
cc_498 ( N_noxref_6_c_736_n N_noxref_7_c_845_n ) capacitor c=6.45633e-19 //x=5 \
 //y=5.21 //x2=5.215 //y2=4.705
cc_499 ( N_noxref_6_c_723_n N_noxref_8_c_918_n ) capacitor c=2.92511e-19 \
 //x=4.88 //y=5.21 //x2=4.51 //y2=1.125
cc_500 ( N_noxref_6_c_736_n N_noxref_8_c_933_n ) capacitor c=0.00270044f //x=5 \
 //y=5.21 //x2=5.395 //y2=1.655
cc_501 ( N_noxref_6_c_723_n N_noxref_8_c_934_n ) capacitor c=0.00244331f \
 //x=4.88 //y=5.21 //x2=4.595 //y2=1.655
cc_502 ( N_noxref_6_c_749_n N_noxref_8_c_956_n ) capacitor c=0.00301289f \
 //x=5.75 //y=6.91 //x2=5.835 //y2=5.21
cc_503 ( N_noxref_6_c_757_n N_noxref_8_c_956_n ) capacitor c=0.00569638f \
 //x=5.88 //y=6.74 //x2=5.835 //y2=5.21
cc_504 ( N_noxref_6_M11_noxref_d N_noxref_8_c_956_n ) capacitor c=0.00936897f \
 //x=5.735 //y=5.025 //x2=5.835 //y2=5.21
cc_505 ( N_noxref_6_c_749_n N_noxref_8_c_946_n ) capacitor c=0.00513934f \
 //x=5.75 //y=6.91 //x2=5.435 //y2=5.21
cc_506 ( N_noxref_6_c_729_n N_noxref_8_c_946_n ) capacitor c=5.08928e-19 \
 //x=4.12 //y=5.21 //x2=5.435 //y2=5.21
cc_507 ( N_noxref_6_c_736_n N_noxref_8_c_946_n ) capacitor c=0.0529958f //x=5 \
 //y=5.21 //x2=5.435 //y2=5.21
cc_508 ( N_noxref_6_c_742_n N_noxref_8_c_946_n ) capacitor c=0.00464132f //x=5 \
 //y=5.38 //x2=5.435 //y2=5.21
cc_509 ( N_noxref_6_c_749_n N_noxref_8_c_961_n ) capacitor c=0.00406191f \
 //x=5.75 //y=6.91 //x2=5.44 //y2=5.38
cc_510 ( N_noxref_6_c_736_n N_noxref_8_c_961_n ) capacitor c=0.00398527f //x=5 \
 //y=5.21 //x2=5.44 //y2=5.38
cc_511 ( N_noxref_6_c_742_n N_noxref_8_c_961_n ) capacitor c=0.0684306f //x=5 \
 //y=5.38 //x2=5.44 //y2=5.38
cc_512 ( N_noxref_6_M11_noxref_d N_noxref_8_c_961_n ) capacitor c=0.0479141f \
 //x=5.735 //y=5.025 //x2=5.44 //y2=5.38
cc_513 ( N_noxref_7_c_836_n N_noxref_8_c_927_n ) capacitor c=0.00120307f \
 //x=5.215 //y=1.56 //x2=4.51 //y2=1.57
cc_514 ( N_noxref_7_c_806_n N_noxref_8_c_933_n ) capacitor c=0.0306206f \
 //x=5.18 //y=2.08 //x2=5.395 //y2=1.655
cc_515 ( N_noxref_7_c_809_n N_noxref_8_c_933_n ) capacitor c=4.30382e-19 \
 //x=5.215 //y=4.705 //x2=5.395 //y2=1.655
cc_516 ( N_noxref_7_c_820_n N_noxref_8_c_933_n ) capacitor c=0.00491852f \
 //x=5.18 //y=2.08 //x2=5.395 //y2=1.655
cc_517 ( N_noxref_7_c_841_n N_noxref_8_c_933_n ) capacitor c=0.00161541f \
 //x=5.18 //y=2.08 //x2=5.395 //y2=1.655
cc_518 ( N_noxref_7_c_844_n N_noxref_8_c_933_n ) capacitor c=0.00817459f \
 //x=5.18 //y=1.915 //x2=5.395 //y2=1.655
cc_519 ( N_noxref_7_c_831_n N_noxref_8_c_973_n ) capacitor c=0.00112851f \
 //x=5.215 //y=0.905 //x2=5.48 //y2=1.12
cc_520 ( N_noxref_7_c_833_n N_noxref_8_c_973_n ) capacitor c=0.0021447f \
 //x=5.215 //y=1.255 //x2=5.48 //y2=1.12
cc_521 ( N_noxref_7_c_887_p N_noxref_8_c_973_n ) capacitor c=5.32053e-19 \
 //x=5.59 //y=0.75 //x2=5.48 //y2=1.12
cc_522 ( N_noxref_7_c_838_n N_noxref_8_c_973_n ) capacitor c=5.60411e-19 \
 //x=5.59 //y=1.405 //x2=5.48 //y2=1.12
cc_523 ( N_noxref_7_c_839_n N_noxref_8_c_973_n ) capacitor c=8.66912e-19 \
 //x=5.745 //y=0.905 //x2=5.48 //y2=1.12
cc_524 ( N_noxref_7_c_840_n N_noxref_8_c_973_n ) capacitor c=0.00377102f \
 //x=5.745 //y=1.255 //x2=5.48 //y2=1.12
cc_525 ( N_noxref_7_c_833_n N_noxref_8_c_940_n ) capacitor c=7.7986e-19 \
 //x=5.215 //y=1.255 //x2=5.48 //y2=1.57
cc_526 ( N_noxref_7_c_836_n N_noxref_8_c_940_n ) capacitor c=0.00364979f \
 //x=5.215 //y=1.56 //x2=5.48 //y2=1.57
cc_527 ( N_noxref_7_c_838_n N_noxref_8_c_940_n ) capacitor c=0.0100338f \
 //x=5.59 //y=1.405 //x2=5.48 //y2=1.57
cc_528 ( N_noxref_7_c_840_n N_noxref_8_c_940_n ) capacitor c=0.00135417f \
 //x=5.745 //y=1.255 //x2=5.48 //y2=1.57
cc_529 ( N_noxref_7_M11_noxref_g N_noxref_8_c_956_n ) capacitor c=0.0110031f \
 //x=5.66 //y=6.025 //x2=5.835 //y2=5.21
cc_530 ( N_noxref_7_c_838_n N_noxref_8_c_979_n ) capacitor c=0.00500113f \
 //x=5.59 //y=1.405 //x2=5.835 //y2=1.655
cc_531 ( N_noxref_7_c_806_n N_noxref_8_c_942_n ) capacitor c=0.0160491f \
 //x=5.18 //y=2.08 //x2=5.92 //y2=5.125
cc_532 ( N_noxref_7_c_809_n N_noxref_8_c_942_n ) capacitor c=0.0175188f \
 //x=5.215 //y=4.705 //x2=5.92 //y2=5.125
cc_533 ( N_noxref_7_c_812_n N_noxref_8_c_942_n ) capacitor c=0.108843f \
 //x=5.215 //y=4.56 //x2=5.92 //y2=5.125
cc_534 ( N_noxref_7_c_820_n N_noxref_8_c_942_n ) capacitor c=0.0043954f \
 //x=5.18 //y=2.08 //x2=5.92 //y2=5.125
cc_535 ( N_noxref_7_c_824_n N_noxref_8_c_942_n ) capacitor c=0.00454427f \
 //x=5.215 //y=4.705 //x2=5.92 //y2=5.125
cc_536 ( N_noxref_7_c_853_n N_noxref_8_c_942_n ) capacitor c=0.00468558f \
 //x=5.585 //y=4.795 //x2=5.92 //y2=5.125
cc_537 ( N_noxref_7_c_841_n N_noxref_8_c_942_n ) capacitor c=0.00270674f \
 //x=5.18 //y=2.08 //x2=5.92 //y2=5.125
cc_538 ( N_noxref_7_c_845_n N_noxref_8_c_942_n ) capacitor c=0.00141757f \
 //x=5.215 //y=4.705 //x2=5.92 //y2=5.125
cc_539 ( N_noxref_7_c_809_n N_noxref_8_c_946_n ) capacitor c=0.00207961f \
 //x=5.215 //y=4.705 //x2=5.435 //y2=5.21
cc_540 ( N_noxref_7_M10_noxref_g N_noxref_8_c_946_n ) capacitor c=0.00184899f \
 //x=5.22 //y=6.025 //x2=5.435 //y2=5.21
cc_541 ( N_noxref_7_M11_noxref_g N_noxref_8_c_946_n ) capacitor c=0.00339097f \
 //x=5.66 //y=6.025 //x2=5.435 //y2=5.21
cc_542 ( N_noxref_7_c_853_n N_noxref_8_c_946_n ) capacitor c=0.00213157f \
 //x=5.585 //y=4.795 //x2=5.435 //y2=5.21
cc_543 ( N_noxref_7_M10_noxref_g N_noxref_8_c_961_n ) capacitor c=0.0120591f \
 //x=5.22 //y=6.025 //x2=5.44 //y2=5.38
cc_544 ( N_noxref_7_M11_noxref_g N_noxref_8_c_961_n ) capacitor c=0.0140704f \
 //x=5.66 //y=6.025 //x2=5.44 //y2=5.38
cc_545 ( N_noxref_7_c_853_n N_noxref_8_c_961_n ) capacitor c=0.00293135f \
 //x=5.585 //y=4.795 //x2=5.44 //y2=5.38
cc_546 ( N_noxref_7_c_831_n N_noxref_8_M3_noxref_d ) capacitor c=0.00218694f \
 //x=5.215 //y=0.905 //x2=5.29 //y2=0.905
cc_547 ( N_noxref_7_c_833_n N_noxref_8_M3_noxref_d ) capacitor c=0.00237422f \
 //x=5.215 //y=1.255 //x2=5.29 //y2=0.905
cc_548 ( N_noxref_7_c_887_p N_noxref_8_M3_noxref_d ) capacitor c=0.00213893f \
 //x=5.59 //y=0.75 //x2=5.29 //y2=0.905
cc_549 ( N_noxref_7_c_838_n N_noxref_8_M3_noxref_d ) capacitor c=0.00357974f \
 //x=5.59 //y=1.405 //x2=5.29 //y2=0.905
cc_550 ( N_noxref_7_c_839_n N_noxref_8_M3_noxref_d ) capacitor c=0.0012513f \
 //x=5.745 //y=0.905 //x2=5.29 //y2=0.905
cc_551 ( N_noxref_7_c_840_n N_noxref_8_M3_noxref_d ) capacitor c=0.00237422f \
 //x=5.745 //y=1.255 //x2=5.29 //y2=0.905
