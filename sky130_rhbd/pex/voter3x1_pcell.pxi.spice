// File: voter3x1_pcell.spi.VOTER3X1_PCELL.pxi
// Created: Sun Apr 12 08:44:04 2026
//
simulator lang=spectre
x_PM_VOTER3X1_PCELL\%noxref_1 ( N_noxref_1_c_36_p N_noxref_1_c_40_p \
 N_noxref_1_c_1_p N_noxref_1_c_2_p N_noxref_1_c_48_p N_noxref_1_c_5_p \
 N_noxref_1_c_50_p N_noxref_1_c_6_p N_noxref_1_c_45_p N_noxref_1_c_38_p \
 N_noxref_1_c_53_p N_noxref_1_c_3_p N_noxref_1_c_7_p N_noxref_1_M0_noxref_g \
 N_noxref_1_M2_noxref_g N_noxref_1_M7_noxref_g N_noxref_1_M8_noxref_g \
 N_noxref_1_M11_noxref_g N_noxref_1_M12_noxref_g N_noxref_1_c_76_p \
 N_noxref_1_c_77_p N_noxref_1_c_79_p N_noxref_1_c_82_p N_noxref_1_c_171_p \
 N_noxref_1_c_172_p N_noxref_1_c_54_p N_noxref_1_c_55_p N_noxref_1_c_78_p \
 N_noxref_1_c_80_p N_noxref_1_c_22_p N_noxref_1_c_23_p N_noxref_1_c_25_p \
 N_noxref_1_c_15_p N_noxref_1_c_180_p N_noxref_1_c_181_p N_noxref_1_c_24_p \
 N_noxref_1_c_26_p N_noxref_1_c_39_p N_noxref_1_c_8_p )  \
 PM_VOTER3X1_PCELL\%noxref_1
x_PM_VOTER3X1_PCELL\%noxref_2 ( N_noxref_2_c_237_n N_noxref_2_c_240_n \
 N_noxref_2_c_274_p N_noxref_2_c_245_n N_noxref_2_c_246_n N_noxref_2_c_275_p \
 N_noxref_2_c_296_p N_noxref_2_c_248_n N_noxref_2_c_252_n N_noxref_2_c_276_p \
 N_noxref_2_c_285_p N_noxref_2_M3_noxref_g N_noxref_2_M4_noxref_g \
 N_noxref_2_M13_noxref_g N_noxref_2_M14_noxref_g N_noxref_2_M15_noxref_g \
 N_noxref_2_M16_noxref_g N_noxref_2_c_258_n N_noxref_2_c_261_n \
 N_noxref_2_c_397_p N_noxref_2_c_263_n N_noxref_2_c_331_p N_noxref_2_c_332_p \
 N_noxref_2_c_265_n N_noxref_2_c_267_n N_noxref_2_c_268_n N_noxref_2_c_269_n \
 N_noxref_2_c_270_n N_noxref_2_c_307_p N_noxref_2_c_308_p N_noxref_2_c_310_p \
 N_noxref_2_c_313_p N_noxref_2_c_411_p N_noxref_2_c_412_p N_noxref_2_c_286_p \
 N_noxref_2_c_287_p N_noxref_2_c_309_p N_noxref_2_c_311_p N_noxref_2_c_277_p ) \
 PM_VOTER3X1_PCELL\%noxref_2
x_PM_VOTER3X1_PCELL\%noxref_3 ( N_noxref_3_c_464_n N_noxref_3_c_468_n \
 N_noxref_3_c_471_n N_noxref_3_c_474_n N_noxref_3_c_523_n N_noxref_3_c_527_n \
 N_noxref_3_c_531_n N_noxref_3_c_532_n N_noxref_3_c_484_n N_noxref_3_c_537_n \
 N_noxref_3_c_485_n N_noxref_3_c_538_n N_noxref_3_c_488_n N_noxref_3_c_493_n \
 N_noxref_3_c_497_n N_noxref_3_c_546_n N_noxref_3_c_549_n \
 N_noxref_3_M1_noxref_g N_noxref_3_M5_noxref_g N_noxref_3_M9_noxref_g \
 N_noxref_3_M10_noxref_g N_noxref_3_M17_noxref_g N_noxref_3_M18_noxref_g \
 N_noxref_3_c_504_n N_noxref_3_c_507_n N_noxref_3_c_509_n N_noxref_3_c_668_p \
 N_noxref_3_c_616_p N_noxref_3_c_617_p N_noxref_3_c_512_n N_noxref_3_c_513_n \
 N_noxref_3_c_556_n N_noxref_3_c_559_n N_noxref_3_c_561_n N_noxref_3_c_609_p \
 N_noxref_3_c_586_p N_noxref_3_c_564_n N_noxref_3_c_565_n N_noxref_3_c_566_n \
 N_noxref_3_c_514_n N_noxref_3_c_735_p N_noxref_3_c_517_n N_noxref_3_c_567_n \
 N_noxref_3_c_595_p N_noxref_3_c_570_n )  PM_VOTER3X1_PCELL\%noxref_3
x_PM_VOTER3X1_PCELL\%noxref_4 ( N_noxref_4_c_756_n N_noxref_4_c_798_n \
 N_noxref_4_c_808_n N_noxref_4_c_810_n N_noxref_4_c_811_n N_noxref_4_c_812_n \
 N_noxref_4_c_757_n N_noxref_4_c_820_n N_noxref_4_c_759_n N_noxref_4_c_828_n \
 N_noxref_4_c_872_p N_noxref_4_c_829_n N_noxref_4_c_830_n N_noxref_4_c_760_n \
 N_noxref_4_c_767_n N_noxref_4_c_838_n N_noxref_4_c_842_n N_noxref_4_c_890_p \
 N_noxref_4_c_966_p N_noxref_4_c_940_p N_noxref_4_c_752_n N_noxref_4_c_953_p \
 N_noxref_4_c_845_n N_noxref_4_c_771_n N_noxref_4_c_850_n N_noxref_4_c_906_p \
 N_noxref_4_c_891_p N_noxref_4_c_781_n N_noxref_4_c_853_n N_noxref_4_c_969_p \
 N_noxref_4_c_874_p N_noxref_4_M6_noxref_g N_noxref_4_M19_noxref_g \
 N_noxref_4_M20_noxref_g N_noxref_4_c_974_p N_noxref_4_c_1009_p \
 N_noxref_4_c_999_p N_noxref_4_c_988_p N_noxref_4_c_900_p N_noxref_4_c_895_p \
 N_noxref_4_c_1001_p N_noxref_4_c_1012_p N_noxref_4_c_976_p \
 N_noxref_4_c_1003_p N_noxref_4_c_975_p N_noxref_4_M1_noxref_d \
 N_noxref_4_M3_noxref_d N_noxref_4_M5_noxref_d N_noxref_4_M15_noxref_d \
 N_noxref_4_M17_noxref_d )  PM_VOTER3X1_PCELL\%noxref_4
x_PM_VOTER3X1_PCELL\%noxref_5 ( N_noxref_5_c_1085_n N_noxref_5_c_1086_n \
 N_noxref_5_c_1194_p N_noxref_5_c_1087_n N_noxref_5_c_1088_n \
 N_noxref_5_c_1196_p N_noxref_5_c_1128_n N_noxref_5_c_1129_n \
 N_noxref_5_c_1152_n N_noxref_5_c_1089_n N_noxref_5_c_1090_n \
 N_noxref_5_c_1093_n N_noxref_5_c_1098_n N_noxref_5_c_1116_n \
 N_noxref_5_c_1161_n N_noxref_5_c_1101_n N_noxref_5_c_1107_n \
 N_noxref_5_c_1147_n N_noxref_5_c_1178_n N_noxref_5_M7_noxref_s \
 N_noxref_5_M8_noxref_d N_noxref_5_M10_noxref_d N_noxref_5_M19_noxref_s \
 N_noxref_5_M20_noxref_d )  PM_VOTER3X1_PCELL\%noxref_5
x_PM_VOTER3X1_PCELL\%noxref_6 ( N_noxref_6_c_1336_n N_noxref_6_c_1338_n \
 N_noxref_6_c_1341_n N_noxref_6_c_1342_n N_noxref_6_c_1364_n \
 N_noxref_6_c_1348_n N_noxref_6_c_1352_n N_noxref_6_c_1353_n \
 N_noxref_6_c_1367_n N_noxref_6_c_1354_n N_noxref_6_c_1357_n \
 N_noxref_6_c_1358_n N_noxref_6_M7_noxref_d N_noxref_6_M9_noxref_d \
 N_noxref_6_M11_noxref_s N_noxref_6_M12_noxref_d N_noxref_6_M14_noxref_d )  \
 PM_VOTER3X1_PCELL\%noxref_6
x_PM_VOTER3X1_PCELL\%noxref_7 ( N_noxref_7_c_1502_n N_noxref_7_c_1515_n \
 N_noxref_7_c_1525_n N_noxref_7_c_1527_n N_noxref_7_c_1541_n \
 N_noxref_7_c_1503_n N_noxref_7_c_1529_n N_noxref_7_c_1532_n \
 N_noxref_7_c_1533_n N_noxref_7_c_1546_n N_noxref_7_c_1509_n \
 N_noxref_7_c_1534_n N_noxref_7_M11_noxref_d N_noxref_7_M15_noxref_s \
 N_noxref_7_M16_noxref_d N_noxref_7_M18_noxref_d )  PM_VOTER3X1_PCELL\%noxref_7
x_PM_VOTER3X1_PCELL\%noxref_8 ( N_noxref_8_c_1639_n N_noxref_8_c_1641_n \
 N_noxref_8_c_1713_n N_noxref_8_c_1648_n N_noxref_8_c_1682_n \
 N_noxref_8_c_1685_n N_noxref_8_c_1714_n N_noxref_8_c_1657_n \
 N_noxref_8_c_1658_n N_noxref_8_c_1664_n N_noxref_8_c_1693_n \
 N_noxref_8_c_1886_p N_noxref_8_c_1759_n N_noxref_8_c_1763_n \
 N_noxref_8_c_1665_n N_noxref_8_c_1696_n N_noxref_8_c_1706_n \
 N_noxref_8_c_1778_n N_noxref_8_M0_noxref_d N_noxref_8_M2_noxref_d \
 N_noxref_8_M4_noxref_d N_noxref_8_M6_noxref_s )  PM_VOTER3X1_PCELL\%noxref_8
x_PM_VOTER3X1_PCELL\%noxref_9 ( N_noxref_9_c_1897_n N_noxref_9_c_1906_n \
 N_noxref_9_c_1910_n N_noxref_9_c_1911_n N_noxref_9_c_1913_n \
 N_noxref_9_c_1914_n N_noxref_9_c_1917_n N_noxref_9_c_1930_n \
 N_noxref_9_c_1938_n N_noxref_9_M6_noxref_d N_noxref_9_M19_noxref_d )  \
 PM_VOTER3X1_PCELL\%noxref_9
x_PM_VOTER3X1_PCELL\%noxref_10 ( N_noxref_10_c_1979_n N_noxref_10_c_1983_n \
 N_noxref_10_c_2021_n N_noxref_10_c_1991_n N_noxref_10_c_1999_n \
 N_noxref_10_c_2031_n N_noxref_10_M0_noxref_s )  PM_VOTER3X1_PCELL\%noxref_10
x_PM_VOTER3X1_PCELL\%noxref_12 ( N_noxref_12_c_2055_n N_noxref_12_c_2056_n \
 N_noxref_12_c_2096_n N_noxref_12_c_2063_n N_noxref_12_c_2068_n \
 N_noxref_12_c_2106_n N_noxref_12_M2_noxref_s )  PM_VOTER3X1_PCELL\%noxref_12
x_PM_VOTER3X1_PCELL\%noxref_13 ( N_noxref_13_c_2121_n N_noxref_13_c_2125_n \
 N_noxref_13_c_2169_n N_noxref_13_c_2132_n N_noxref_13_c_2141_n \
 N_noxref_13_c_2179_n N_noxref_13_M4_noxref_s )  PM_VOTER3X1_PCELL\%noxref_13
cc_1 ( N_noxref_1_c_1_p N_noxref_2_c_237_n ) capacitor c=0.0033801f //x=4.44 \
 //y=2.205 //x2=5.92 //y2=2.25
cc_2 ( N_noxref_1_c_2_p N_noxref_2_c_237_n ) capacitor c=5.52227e-19 //x=4.44 \
 //y=4.295 //x2=5.92 //y2=2.25
cc_3 ( N_noxref_1_c_3_p N_noxref_2_c_237_n ) capacitor c=5.86738e-19 //x=4.44 \
 //y=2.08 //x2=5.92 //y2=2.25
cc_4 ( N_noxref_1_c_2_p N_noxref_2_c_240_n ) capacitor c=0.0454386f //x=4.44 \
 //y=4.295 //x2=5.92 //y2=4.58
cc_5 ( N_noxref_1_c_5_p N_noxref_2_c_240_n ) capacitor c=0.0047666f //x=4.44 \
 //y=4.44 //x2=5.92 //y2=4.58
cc_6 ( N_noxref_1_c_6_p N_noxref_2_c_240_n ) capacitor c=0.00487887f //x=4.445 \
 //y=4.46 //x2=5.92 //y2=4.58
cc_7 ( N_noxref_1_c_7_p N_noxref_2_c_240_n ) capacitor c=0.00414268f //x=4.44 \
 //y=4.44 //x2=5.92 //y2=4.58
cc_8 ( N_noxref_1_c_8_p N_noxref_2_c_240_n ) capacitor c=5.58186e-19 //x=4.44 \
 //y=4.705 //x2=5.92 //y2=4.58
cc_9 ( N_noxref_1_c_2_p N_noxref_2_c_245_n ) capacitor c=0.00213544f //x=4.44 \
 //y=4.295 //x2=7.4 //y2=4.575
cc_10 ( N_noxref_1_c_1_p N_noxref_2_c_246_n ) capacitor c=0.00564826f //x=4.44 \
 //y=2.205 //x2=6.085 //y2=2.09
cc_11 ( N_noxref_1_c_2_p N_noxref_2_c_246_n ) capacitor c=8.70657e-19 //x=4.44 \
 //y=4.295 //x2=6.085 //y2=2.09
cc_12 ( N_noxref_1_c_1_p N_noxref_2_c_248_n ) capacitor c=0.00362942f //x=4.44 \
 //y=2.205 //x2=5.92 //y2=2.08
cc_13 ( N_noxref_1_c_2_p N_noxref_2_c_248_n ) capacitor c=3.10803e-19 //x=4.44 \
 //y=4.295 //x2=5.92 //y2=2.08
cc_14 ( N_noxref_1_c_3_p N_noxref_2_c_248_n ) capacitor c=3.19688e-19 //x=4.44 \
 //y=2.08 //x2=5.92 //y2=2.08
cc_15 ( N_noxref_1_c_15_p N_noxref_2_c_248_n ) capacitor c=2.35599e-19 \
 //x=4.245 //y=1.915 //x2=5.92 //y2=2.08
cc_16 ( N_noxref_1_c_5_p N_noxref_2_c_252_n ) capacitor c=5.34267e-19 //x=4.44 \
 //y=4.44 //x2=5.92 //y2=4.705
cc_17 ( N_noxref_1_c_7_p N_noxref_2_c_252_n ) capacitor c=8.5191e-19 //x=4.44 \
 //y=4.44 //x2=5.92 //y2=4.705
cc_18 ( N_noxref_1_c_8_p N_noxref_2_c_252_n ) capacitor c=2.35599e-19 //x=4.44 \
 //y=4.705 //x2=5.92 //y2=4.705
cc_19 ( N_noxref_1_M11_noxref_g N_noxref_2_M13_noxref_g ) capacitor \
 c=0.00948424f //x=4.33 //y=6.025 //x2=5.21 //y2=6.025
cc_20 ( N_noxref_1_M12_noxref_g N_noxref_2_M13_noxref_g ) capacitor \
 c=0.0638434f //x=4.77 //y=6.025 //x2=5.21 //y2=6.025
cc_21 ( N_noxref_1_M12_noxref_g N_noxref_2_M14_noxref_g ) capacitor \
 c=0.00878567f //x=4.77 //y=6.025 //x2=5.65 //y2=6.025
cc_22 ( N_noxref_1_c_22_p N_noxref_2_c_258_n ) capacitor c=4.86545e-19 \
 //x=4.245 //y=0.865 //x2=5.215 //y2=0.905
cc_23 ( N_noxref_1_c_23_p N_noxref_2_c_258_n ) capacitor c=0.00152104f \
 //x=4.245 //y=1.21 //x2=5.215 //y2=0.905
cc_24 ( N_noxref_1_c_24_p N_noxref_2_c_258_n ) capacitor c=0.0159151f \
 //x=4.775 //y=0.865 //x2=5.215 //y2=0.905
cc_25 ( N_noxref_1_c_25_p N_noxref_2_c_261_n ) capacitor c=0.00109982f \
 //x=4.245 //y=1.52 //x2=5.215 //y2=1.25
cc_26 ( N_noxref_1_c_26_p N_noxref_2_c_261_n ) capacitor c=0.0158526f \
 //x=4.775 //y=1.21 //x2=5.215 //y2=1.25
cc_27 ( N_noxref_1_c_7_p N_noxref_2_c_263_n ) capacitor c=0.00110488f //x=4.44 \
 //y=4.44 //x2=5.285 //y2=4.795
cc_28 ( N_noxref_1_c_8_p N_noxref_2_c_263_n ) capacitor c=0.064577f //x=4.44 \
 //y=4.705 //x2=5.285 //y2=4.795
cc_29 ( N_noxref_1_c_7_p N_noxref_2_c_265_n ) capacitor c=2.35599e-19 //x=4.44 \
 //y=4.44 //x2=5.65 //y2=4.87
cc_30 ( N_noxref_1_c_8_p N_noxref_2_c_265_n ) capacitor c=5.35364e-19 //x=4.44 \
 //y=4.705 //x2=5.65 //y2=4.87
cc_31 ( N_noxref_1_c_24_p N_noxref_2_c_267_n ) capacitor c=0.00124821f \
 //x=4.775 //y=0.865 //x2=5.745 //y2=0.905
cc_32 ( N_noxref_1_c_26_p N_noxref_2_c_268_n ) capacitor c=0.00150765f \
 //x=4.775 //y=1.21 //x2=5.745 //y2=1.25
cc_33 ( N_noxref_1_c_26_p N_noxref_2_c_269_n ) capacitor c=4.38654e-19 \
 //x=4.775 //y=1.21 //x2=5.745 //y2=1.56
cc_34 ( N_noxref_1_c_3_p N_noxref_2_c_270_n ) capacitor c=2.35599e-19 //x=4.44 \
 //y=2.08 //x2=5.745 //y2=1.915
cc_35 ( N_noxref_1_c_15_p N_noxref_2_c_270_n ) capacitor c=4.61972e-19 \
 //x=4.245 //y=1.915 //x2=5.745 //y2=1.915
cc_36 ( N_noxref_1_c_36_p N_noxref_3_c_464_n ) capacitor c=0.0110499f //x=0.74 \
 //y=2.195 //x2=1.85 //y2=2.195
cc_37 ( N_noxref_1_c_1_p N_noxref_3_c_464_n ) capacitor c=0.00273775f //x=4.44 \
 //y=2.205 //x2=1.85 //y2=2.195
cc_38 ( N_noxref_1_c_38_p N_noxref_3_c_464_n ) capacitor c=0.00353903f \
 //x=0.74 //y=2.08 //x2=1.85 //y2=2.195
cc_39 ( N_noxref_1_c_39_p N_noxref_3_c_464_n ) capacitor c=0.00140055f \
 //x=0.74 //y=2.08 //x2=1.85 //y2=2.195
cc_40 ( N_noxref_1_c_40_p N_noxref_3_c_468_n ) capacitor c=0.0532443f //x=0.74 \
 //y=4.28 //x2=1.85 //y2=3.865
cc_41 ( N_noxref_1_c_2_p N_noxref_3_c_468_n ) capacitor c=0.0220468f //x=4.44 \
 //y=4.295 //x2=1.85 //y2=3.865
cc_42 ( N_noxref_1_c_38_p N_noxref_3_c_468_n ) capacitor c=4.16726e-19 \
 //x=0.74 //y=2.08 //x2=1.85 //y2=3.865
cc_43 ( N_noxref_1_c_40_p N_noxref_3_c_471_n ) capacitor c=0.00785479f \
 //x=0.74 //y=4.28 //x2=1.85 //y2=4.185
cc_44 ( N_noxref_1_c_2_p N_noxref_3_c_471_n ) capacitor c=0.00149249f //x=4.44 \
 //y=4.295 //x2=1.85 //y2=4.185
cc_45 ( N_noxref_1_c_45_p N_noxref_3_c_471_n ) capacitor c=0.00452722f \
 //x=4.285 //y=4.46 //x2=1.85 //y2=4.185
cc_46 ( N_noxref_1_c_40_p N_noxref_3_c_474_n ) capacitor c=0.00241857f \
 //x=0.74 //y=4.28 //x2=1.85 //y2=4.53
cc_47 ( N_noxref_1_c_2_p N_noxref_3_c_474_n ) capacitor c=0.00106529f //x=4.44 \
 //y=4.295 //x2=1.85 //y2=4.53
cc_48 ( N_noxref_1_c_48_p N_noxref_3_c_474_n ) capacitor c=0.0102434f //x=0.74 \
 //y=4.44 //x2=1.85 //y2=4.53
cc_49 ( N_noxref_1_c_5_p N_noxref_3_c_474_n ) capacitor c=0.00146299f //x=4.44 \
 //y=4.44 //x2=1.85 //y2=4.53
cc_50 ( N_noxref_1_c_50_p N_noxref_3_c_474_n ) capacitor c=0.00282641f \
 //x=0.905 //y=4.44 //x2=1.85 //y2=4.53
cc_51 ( N_noxref_1_c_6_p N_noxref_3_c_474_n ) capacitor c=0.00206738f \
 //x=4.445 //y=4.46 //x2=1.85 //y2=4.53
cc_52 ( N_noxref_1_c_45_p N_noxref_3_c_474_n ) capacitor c=0.0312701f \
 //x=4.285 //y=4.46 //x2=1.85 //y2=4.53
cc_53 ( N_noxref_1_c_53_p N_noxref_3_c_474_n ) capacitor c=0.00868816f \
 //x=0.74 //y=4.44 //x2=1.85 //y2=4.53
cc_54 ( N_noxref_1_c_54_p N_noxref_3_c_474_n ) capacitor c=0.00144251f \
 //x=1.375 //y=4.795 //x2=1.85 //y2=4.53
cc_55 ( N_noxref_1_c_55_p N_noxref_3_c_474_n ) capacitor c=0.00105471f \
 //x=1.085 //y=4.795 //x2=1.85 //y2=4.53
cc_56 ( N_noxref_1_c_40_p N_noxref_3_c_484_n ) capacitor c=0.00334158f \
 //x=0.74 //y=4.28 //x2=1.85 //y2=4.07
cc_57 ( N_noxref_1_c_40_p N_noxref_3_c_485_n ) capacitor c=0.00529413f \
 //x=0.74 //y=4.28 //x2=2.01 //y2=4.025
cc_58 ( N_noxref_1_c_2_p N_noxref_3_c_485_n ) capacitor c=0.00110824f //x=4.44 \
 //y=4.295 //x2=2.01 //y2=4.025
cc_59 ( N_noxref_1_c_45_p N_noxref_3_c_485_n ) capacitor c=0.0345719f \
 //x=4.285 //y=4.46 //x2=2.01 //y2=4.025
cc_60 ( N_noxref_1_c_1_p N_noxref_3_c_488_n ) capacitor c=0.00179095f //x=4.44 \
 //y=2.205 //x2=8.365 //y2=4.03
cc_61 ( N_noxref_1_c_2_p N_noxref_3_c_488_n ) capacitor c=0.0312902f //x=4.44 \
 //y=4.295 //x2=8.365 //y2=4.03
cc_62 ( N_noxref_1_c_5_p N_noxref_3_c_488_n ) capacitor c=0.0102464f //x=4.44 \
 //y=4.44 //x2=8.365 //y2=4.03
cc_63 ( N_noxref_1_c_6_p N_noxref_3_c_488_n ) capacitor c=0.0375626f //x=4.445 \
 //y=4.46 //x2=8.365 //y2=4.03
cc_64 ( N_noxref_1_c_45_p N_noxref_3_c_488_n ) capacitor c=0.215316f //x=4.285 \
 //y=4.46 //x2=8.365 //y2=4.03
cc_65 ( N_noxref_1_c_36_p N_noxref_3_c_493_n ) capacitor c=0.00353903f \
 //x=0.74 //y=2.195 //x2=1.85 //y2=2.08
cc_66 ( N_noxref_1_c_40_p N_noxref_3_c_493_n ) capacitor c=4.16726e-19 \
 //x=0.74 //y=4.28 //x2=1.85 //y2=2.08
cc_67 ( N_noxref_1_c_38_p N_noxref_3_c_493_n ) capacitor c=0.0012665f //x=0.74 \
 //y=2.08 //x2=1.85 //y2=2.08
cc_68 ( N_noxref_1_c_39_p N_noxref_3_c_493_n ) capacitor c=0.00163906f \
 //x=0.74 //y=2.08 //x2=1.85 //y2=2.08
cc_69 ( N_noxref_1_c_48_p N_noxref_3_c_497_n ) capacitor c=0.00154972f \
 //x=0.74 //y=4.44 //x2=1.89 //y2=4.705
cc_70 ( N_noxref_1_c_53_p N_noxref_3_c_497_n ) capacitor c=0.00133991f \
 //x=0.74 //y=4.44 //x2=1.89 //y2=4.705
cc_71 ( N_noxref_1_c_54_p N_noxref_3_c_497_n ) capacitor c=0.00122675f \
 //x=1.375 //y=4.795 //x2=1.89 //y2=4.705
cc_72 ( N_noxref_1_c_55_p N_noxref_3_c_497_n ) capacitor c=0.00114302f \
 //x=1.085 //y=4.795 //x2=1.89 //y2=4.705
cc_73 ( N_noxref_1_M7_noxref_g N_noxref_3_M9_noxref_g ) capacitor c=0.0106808f \
 //x=1.01 //y=6.025 //x2=1.89 //y2=6.025
cc_74 ( N_noxref_1_M8_noxref_g N_noxref_3_M9_noxref_g ) capacitor c=0.108153f \
 //x=1.45 //y=6.025 //x2=1.89 //y2=6.025
cc_75 ( N_noxref_1_M8_noxref_g N_noxref_3_M10_noxref_g ) capacitor \
 c=0.0103194f //x=1.45 //y=6.025 //x2=2.33 //y2=6.025
cc_76 ( N_noxref_1_c_76_p N_noxref_3_c_504_n ) capacitor c=4.86545e-19 \
 //x=0.915 //y=0.865 //x2=1.885 //y2=0.905
cc_77 ( N_noxref_1_c_77_p N_noxref_3_c_504_n ) capacitor c=0.00152405f \
 //x=0.915 //y=1.21 //x2=1.885 //y2=0.905
cc_78 ( N_noxref_1_c_78_p N_noxref_3_c_504_n ) capacitor c=0.0151475f \
 //x=1.445 //y=0.865 //x2=1.885 //y2=0.905
cc_79 ( N_noxref_1_c_79_p N_noxref_3_c_507_n ) capacitor c=0.00109982f \
 //x=0.915 //y=1.52 //x2=1.885 //y2=1.25
cc_80 ( N_noxref_1_c_80_p N_noxref_3_c_507_n ) capacitor c=0.0111064f \
 //x=1.445 //y=1.21 //x2=1.885 //y2=1.25
cc_81 ( N_noxref_1_c_79_p N_noxref_3_c_509_n ) capacitor c=0.00179029f \
 //x=0.915 //y=1.52 //x2=1.885 //y2=1.56
cc_82 ( N_noxref_1_c_82_p N_noxref_3_c_509_n ) capacitor c=0.00662747f \
 //x=0.915 //y=1.915 //x2=1.885 //y2=1.56
cc_83 ( N_noxref_1_c_80_p N_noxref_3_c_509_n ) capacitor c=0.00862358f \
 //x=1.445 //y=1.21 //x2=1.885 //y2=1.56
cc_84 ( N_noxref_1_c_78_p N_noxref_3_c_512_n ) capacitor c=0.00124846f \
 //x=1.445 //y=0.865 //x2=2.415 //y2=0.905
cc_85 ( N_noxref_1_c_80_p N_noxref_3_c_513_n ) capacitor c=0.00161183f \
 //x=1.445 //y=1.21 //x2=2.415 //y2=1.25
cc_86 ( N_noxref_1_c_36_p N_noxref_3_c_514_n ) capacitor c=0.00130136f \
 //x=0.74 //y=2.195 //x2=1.85 //y2=2.08
cc_87 ( N_noxref_1_c_38_p N_noxref_3_c_514_n ) capacitor c=0.00191372f \
 //x=0.74 //y=2.08 //x2=1.85 //y2=2.08
cc_88 ( N_noxref_1_c_39_p N_noxref_3_c_514_n ) capacitor c=0.00949697f \
 //x=0.74 //y=2.08 //x2=1.85 //y2=2.08
cc_89 ( N_noxref_1_c_48_p N_noxref_3_c_517_n ) capacitor c=2.84639e-19 \
 //x=0.74 //y=4.44 //x2=1.89 //y2=4.705
cc_90 ( N_noxref_1_c_53_p N_noxref_3_c_517_n ) capacitor c=0.00197201f \
 //x=0.74 //y=4.44 //x2=1.89 //y2=4.705
cc_91 ( N_noxref_1_c_54_p N_noxref_3_c_517_n ) capacitor c=0.0203213f \
 //x=1.375 //y=4.795 //x2=1.89 //y2=4.705
cc_92 ( N_noxref_1_c_55_p N_noxref_3_c_517_n ) capacitor c=0.00427779f \
 //x=1.085 //y=4.795 //x2=1.89 //y2=4.705
cc_93 ( N_noxref_1_c_1_p N_noxref_4_c_752_n ) capacitor c=0.0108541f //x=4.44 \
 //y=2.205 //x2=5.35 //y2=1.225
cc_94 ( N_noxref_1_c_23_p N_noxref_4_c_752_n ) capacitor c=0.00242807f \
 //x=4.245 //y=1.21 //x2=5.35 //y2=1.225
cc_95 ( N_noxref_1_c_25_p N_noxref_4_c_752_n ) capacitor c=0.0026623f \
 //x=4.245 //y=1.52 //x2=5.35 //y2=1.225
cc_96 ( N_noxref_1_c_26_p N_noxref_4_c_752_n ) capacitor c=0.00413582f \
 //x=4.775 //y=1.21 //x2=5.35 //y2=1.225
cc_97 ( N_noxref_1_M7_noxref_g N_noxref_5_c_1085_n ) capacitor c=0.00374549f \
 //x=1.01 //y=6.025 //x2=0.79 //y2=6.855
cc_98 ( N_noxref_1_M7_noxref_g N_noxref_5_c_1086_n ) capacitor c=0.00441594f \
 //x=1.01 //y=6.025 //x2=0.79 //y2=7.23
cc_99 ( N_noxref_1_M8_noxref_g N_noxref_5_c_1087_n ) capacitor c=0.00123273f \
 //x=1.45 //y=6.025 //x2=1.67 //y2=6.855
cc_100 ( N_noxref_1_M8_noxref_g N_noxref_5_c_1088_n ) capacitor c=0.00137209f \
 //x=1.45 //y=6.025 //x2=1.67 //y2=7.23
cc_101 ( N_noxref_1_c_48_p N_noxref_5_c_1089_n ) capacitor c=2.89425e-19 \
 //x=0.74 //y=4.44 //x2=0.74 //y2=7.4
cc_102 ( N_noxref_1_c_48_p N_noxref_5_c_1090_n ) capacitor c=5.3581e-19 \
 //x=0.74 //y=4.44 //x2=3.16 //y2=7.4
cc_103 ( N_noxref_1_M7_noxref_g N_noxref_5_c_1090_n ) capacitor c=0.00772491f \
 //x=1.01 //y=6.025 //x2=3.16 //y2=7.4
cc_104 ( N_noxref_1_M8_noxref_g N_noxref_5_c_1090_n ) capacitor c=0.00772491f \
 //x=1.45 //y=6.025 //x2=3.16 //y2=7.4
cc_105 ( N_noxref_1_c_40_p N_noxref_5_c_1093_n ) capacitor c=0.00519253f \
 //x=0.74 //y=4.28 //x2=0.74 //y2=7.4
cc_106 ( N_noxref_1_c_48_p N_noxref_5_c_1093_n ) capacitor c=0.008788f \
 //x=0.74 //y=4.44 //x2=0.74 //y2=7.4
cc_107 ( N_noxref_1_c_53_p N_noxref_5_c_1093_n ) capacitor c=0.0174085f \
 //x=0.74 //y=4.44 //x2=0.74 //y2=7.4
cc_108 ( N_noxref_1_M7_noxref_g N_noxref_5_c_1093_n ) capacitor c=0.0191171f \
 //x=1.01 //y=6.025 //x2=0.74 //y2=7.4
cc_109 ( N_noxref_1_c_55_p N_noxref_5_c_1093_n ) capacitor c=0.0079396f \
 //x=1.085 //y=4.795 //x2=0.74 //y2=7.4
cc_110 ( N_noxref_1_c_7_p N_noxref_5_c_1098_n ) capacitor c=2.10893e-19 \
 //x=4.44 //y=4.44 //x2=6.49 //y2=7.4
cc_111 ( N_noxref_1_M11_noxref_g N_noxref_5_c_1098_n ) capacitor c=0.00758111f \
 //x=4.33 //y=6.025 //x2=6.49 //y2=7.4
cc_112 ( N_noxref_1_M12_noxref_g N_noxref_5_c_1098_n ) capacitor c=0.00776897f \
 //x=4.77 //y=6.025 //x2=6.49 //y2=7.4
cc_113 ( N_noxref_1_c_2_p N_noxref_5_c_1101_n ) capacitor c=0.00285166f \
 //x=4.44 //y=4.295 //x2=3.33 //y2=7.4
cc_114 ( N_noxref_1_c_5_p N_noxref_5_c_1101_n ) capacitor c=0.00331684f \
 //x=4.44 //y=4.44 //x2=3.33 //y2=7.4
cc_115 ( N_noxref_1_c_45_p N_noxref_5_c_1101_n ) capacitor c=0.0167947f \
 //x=4.285 //y=4.46 //x2=3.33 //y2=7.4
cc_116 ( N_noxref_1_c_53_p N_noxref_5_c_1101_n ) capacitor c=0.00117386f \
 //x=0.74 //y=4.44 //x2=3.33 //y2=7.4
cc_117 ( N_noxref_1_c_7_p N_noxref_5_c_1101_n ) capacitor c=0.0104424f \
 //x=4.44 //y=4.44 //x2=3.33 //y2=7.4
cc_118 ( N_noxref_1_c_8_p N_noxref_5_c_1101_n ) capacitor c=0.0137051f \
 //x=4.44 //y=4.705 //x2=3.33 //y2=7.4
cc_119 ( N_noxref_1_c_7_p N_noxref_5_c_1107_n ) capacitor c=0.00221916f \
 //x=4.44 //y=4.44 //x2=6.66 //y2=7.4
cc_120 ( N_noxref_1_c_48_p N_noxref_5_M7_noxref_s ) capacitor c=0.0166208f \
 //x=0.74 //y=4.44 //x2=0.655 //y2=5.025
cc_121 ( N_noxref_1_c_50_p N_noxref_5_M7_noxref_s ) capacitor c=0.00180521f \
 //x=0.905 //y=4.44 //x2=0.655 //y2=5.025
cc_122 ( N_noxref_1_c_53_p N_noxref_5_M7_noxref_s ) capacitor c=0.0122195f \
 //x=0.74 //y=4.44 //x2=0.655 //y2=5.025
cc_123 ( N_noxref_1_M7_noxref_g N_noxref_5_M7_noxref_s ) capacitor \
 c=0.0510401f //x=1.01 //y=6.025 //x2=0.655 //y2=5.025
cc_124 ( N_noxref_1_c_55_p N_noxref_5_M7_noxref_s ) capacitor c=0.00621646f \
 //x=1.085 //y=4.795 //x2=0.655 //y2=5.025
cc_125 ( N_noxref_1_M8_noxref_g N_noxref_5_M8_noxref_d ) capacitor \
 c=0.0127979f //x=1.45 //y=6.025 //x2=1.525 //y2=5.025
cc_126 ( N_noxref_1_c_45_p N_noxref_6_c_1336_n ) capacitor c=0.00314988f \
 //x=4.285 //y=4.46 //x2=1.995 //y2=5.21
cc_127 ( N_noxref_1_M8_noxref_g N_noxref_6_c_1336_n ) capacitor c=0.00962216f \
 //x=1.45 //y=6.025 //x2=1.995 //y2=5.21
cc_128 ( N_noxref_1_c_5_p N_noxref_6_c_1338_n ) capacitor c=0.00378061f \
 //x=4.44 //y=4.44 //x2=3.995 //y2=5.21
cc_129 ( N_noxref_1_c_45_p N_noxref_6_c_1338_n ) capacitor c=0.0894443f \
 //x=4.285 //y=4.46 //x2=3.995 //y2=5.21
cc_130 ( N_noxref_1_M11_noxref_g N_noxref_6_c_1338_n ) capacitor c=0.00366801f \
 //x=4.33 //y=6.025 //x2=3.995 //y2=5.21
cc_131 ( N_noxref_1_c_45_p N_noxref_6_c_1341_n ) capacitor c=0.00878121f \
 //x=4.285 //y=4.46 //x2=2.225 //y2=5.21
cc_132 ( N_noxref_1_c_5_p N_noxref_6_c_1342_n ) capacitor c=8.16607e-19 \
 //x=4.44 //y=4.44 //x2=4.87 //y2=6.91
cc_133 ( N_noxref_1_c_6_p N_noxref_6_c_1342_n ) capacitor c=0.00566393f \
 //x=4.445 //y=4.46 //x2=4.87 //y2=6.91
cc_134 ( N_noxref_1_c_45_p N_noxref_6_c_1342_n ) capacitor c=5.18143e-19 \
 //x=4.285 //y=4.46 //x2=4.87 //y2=6.91
cc_135 ( N_noxref_1_c_7_p N_noxref_6_c_1342_n ) capacitor c=0.00134225f \
 //x=4.44 //y=4.44 //x2=4.87 //y2=6.91
cc_136 ( N_noxref_1_M11_noxref_g N_noxref_6_c_1342_n ) capacitor c=0.00985075f \
 //x=4.33 //y=6.025 //x2=4.87 //y2=6.91
cc_137 ( N_noxref_1_M12_noxref_g N_noxref_6_c_1342_n ) capacitor c=0.00814026f \
 //x=4.77 //y=6.025 //x2=4.87 //y2=6.91
cc_138 ( N_noxref_1_c_45_p N_noxref_6_c_1348_n ) capacitor c=0.0271892f \
 //x=4.285 //y=4.46 //x2=1.232 //y2=5.21
cc_139 ( N_noxref_1_M7_noxref_g N_noxref_6_c_1348_n ) capacitor c=0.0018075f \
 //x=1.01 //y=6.025 //x2=1.232 //y2=5.21
cc_140 ( N_noxref_1_M8_noxref_g N_noxref_6_c_1348_n ) capacitor c=0.00310294f \
 //x=1.45 //y=6.025 //x2=1.232 //y2=5.21
cc_141 ( N_noxref_1_c_54_p N_noxref_6_c_1348_n ) capacitor c=0.00218288f \
 //x=1.375 //y=4.795 //x2=1.232 //y2=5.21
cc_142 ( N_noxref_1_M11_noxref_g N_noxref_6_c_1352_n ) capacitor c=0.00395967f \
 //x=4.33 //y=6.025 //x2=4.11 //y2=6.74
cc_143 ( N_noxref_1_M12_noxref_g N_noxref_6_c_1353_n ) capacitor c=0.00179771f \
 //x=4.77 //y=6.025 //x2=4.987 //y2=6.91
cc_144 ( N_noxref_1_M7_noxref_g N_noxref_6_c_1354_n ) capacitor c=0.0161645f \
 //x=1.01 //y=6.025 //x2=1.23 //y2=5.38
cc_145 ( N_noxref_1_M8_noxref_g N_noxref_6_c_1354_n ) capacitor c=0.0177598f \
 //x=1.45 //y=6.025 //x2=1.23 //y2=5.38
cc_146 ( N_noxref_1_c_54_p N_noxref_6_c_1354_n ) capacitor c=0.00293723f \
 //x=1.375 //y=4.795 //x2=1.23 //y2=5.38
cc_147 ( N_noxref_1_c_45_p N_noxref_6_c_1357_n ) capacitor c=0.00371683f \
 //x=4.285 //y=4.46 //x2=2.11 //y2=5.21
cc_148 ( N_noxref_1_c_5_p N_noxref_6_c_1358_n ) capacitor c=8.93089e-19 \
 //x=4.44 //y=4.44 //x2=4.11 //y2=5.21
cc_149 ( N_noxref_1_c_45_p N_noxref_6_c_1358_n ) capacitor c=0.00277723f \
 //x=4.285 //y=4.46 //x2=4.11 //y2=5.21
cc_150 ( N_noxref_1_M11_noxref_g N_noxref_6_c_1358_n ) capacitor c=0.0503042f \
 //x=4.33 //y=6.025 //x2=4.11 //y2=5.21
cc_151 ( N_noxref_1_M7_noxref_g N_noxref_6_M7_noxref_d ) capacitor \
 c=0.00124621f //x=1.01 //y=6.025 //x2=1.085 //y2=5.025
cc_152 ( N_noxref_1_M8_noxref_g N_noxref_6_M7_noxref_d ) capacitor \
 c=0.00125665f //x=1.45 //y=6.025 //x2=1.085 //y2=5.025
cc_153 ( N_noxref_1_M12_noxref_g N_noxref_6_M12_noxref_d ) capacitor \
 c=0.0142133f //x=4.77 //y=6.025 //x2=4.845 //y2=5.025
cc_154 ( N_noxref_1_M12_noxref_g N_noxref_7_c_1502_n ) capacitor c=0.00969072f \
 //x=4.77 //y=6.025 //x2=5.315 //y2=5.21
cc_155 ( N_noxref_1_c_5_p N_noxref_7_c_1503_n ) capacitor c=0.00879697f \
 //x=4.44 //y=4.44 //x2=4.55 //y2=5.21
cc_156 ( N_noxref_1_c_6_p N_noxref_7_c_1503_n ) capacitor c=0.00708476f \
 //x=4.445 //y=4.46 //x2=4.55 //y2=5.21
cc_157 ( N_noxref_1_c_7_p N_noxref_7_c_1503_n ) capacitor c=0.00212816f \
 //x=4.44 //y=4.44 //x2=4.55 //y2=5.21
cc_158 ( N_noxref_1_M11_noxref_g N_noxref_7_c_1503_n ) capacitor c=0.00349804f \
 //x=4.33 //y=6.025 //x2=4.55 //y2=5.21
cc_159 ( N_noxref_1_M12_noxref_g N_noxref_7_c_1503_n ) capacitor c=0.00297228f \
 //x=4.77 //y=6.025 //x2=4.55 //y2=5.21
cc_160 ( N_noxref_1_c_8_p N_noxref_7_c_1503_n ) capacitor c=0.00149603f \
 //x=4.44 //y=4.705 //x2=4.55 //y2=5.21
cc_161 ( N_noxref_1_c_5_p N_noxref_7_c_1509_n ) capacitor c=0.0012994f \
 //x=4.44 //y=4.44 //x2=4.55 //y2=5.38
cc_162 ( N_noxref_1_c_7_p N_noxref_7_c_1509_n ) capacitor c=0.00447469f \
 //x=4.44 //y=4.44 //x2=4.55 //y2=5.38
cc_163 ( N_noxref_1_M11_noxref_g N_noxref_7_c_1509_n ) capacitor c=0.0120591f \
 //x=4.33 //y=6.025 //x2=4.55 //y2=5.38
cc_164 ( N_noxref_1_M12_noxref_g N_noxref_7_c_1509_n ) capacitor c=0.015288f \
 //x=4.77 //y=6.025 //x2=4.55 //y2=5.38
cc_165 ( N_noxref_1_c_8_p N_noxref_7_c_1509_n ) capacitor c=0.00417478f \
 //x=4.44 //y=4.705 //x2=4.55 //y2=5.38
cc_166 ( N_noxref_1_c_36_p N_noxref_8_c_1639_n ) capacitor c=0.00181159f \
 //x=0.74 //y=2.195 //x2=1.095 //y2=0
cc_167 ( N_noxref_1_c_48_p N_noxref_8_c_1639_n ) capacitor c=3.47657e-19 \
 //x=0.74 //y=4.44 //x2=1.095 //y2=0
cc_168 ( N_noxref_1_c_76_p N_noxref_8_c_1641_n ) capacitor c=0.00166913f \
 //x=0.915 //y=0.865 //x2=1.18 //y2=0.835
cc_169 ( N_noxref_1_c_77_p N_noxref_8_c_1641_n ) capacitor c=0.00373916f \
 //x=0.915 //y=1.21 //x2=1.18 //y2=0.835
cc_170 ( N_noxref_1_c_79_p N_noxref_8_c_1641_n ) capacitor c=3.46977e-19 \
 //x=0.915 //y=1.52 //x2=1.18 //y2=0.835
cc_171 ( N_noxref_1_c_171_p N_noxref_8_c_1641_n ) capacitor c=0.00924003f \
 //x=1.29 //y=0.71 //x2=1.18 //y2=0.835
cc_172 ( N_noxref_1_c_172_p N_noxref_8_c_1641_n ) capacitor c=7.91264e-19 \
 //x=1.29 //y=1.365 //x2=1.18 //y2=0.835
cc_173 ( N_noxref_1_c_78_p N_noxref_8_c_1641_n ) capacitor c=0.00205853f \
 //x=1.445 //y=0.865 //x2=1.18 //y2=0.835
cc_174 ( N_noxref_1_c_80_p N_noxref_8_c_1641_n ) capacitor c=0.00402706f \
 //x=1.445 //y=1.21 //x2=1.18 //y2=0.835
cc_175 ( N_noxref_1_c_1_p N_noxref_8_c_1648_n ) capacitor c=0.00456784f \
 //x=4.44 //y=2.205 //x2=4.51 //y2=0.835
cc_176 ( N_noxref_1_c_3_p N_noxref_8_c_1648_n ) capacitor c=4.35063e-19 \
 //x=4.44 //y=2.08 //x2=4.51 //y2=0.835
cc_177 ( N_noxref_1_c_22_p N_noxref_8_c_1648_n ) capacitor c=0.00174776f \
 //x=4.245 //y=0.865 //x2=4.51 //y2=0.835
cc_178 ( N_noxref_1_c_23_p N_noxref_8_c_1648_n ) capacitor c=0.00349898f \
 //x=4.245 //y=1.21 //x2=4.51 //y2=0.835
cc_179 ( N_noxref_1_c_25_p N_noxref_8_c_1648_n ) capacitor c=2.39384e-19 \
 //x=4.245 //y=1.52 //x2=4.51 //y2=0.835
cc_180 ( N_noxref_1_c_180_p N_noxref_8_c_1648_n ) capacitor c=0.00936795f \
 //x=4.62 //y=0.71 //x2=4.51 //y2=0.835
cc_181 ( N_noxref_1_c_181_p N_noxref_8_c_1648_n ) capacitor c=0.00220527f \
 //x=4.62 //y=1.365 //x2=4.51 //y2=0.835
cc_182 ( N_noxref_1_c_24_p N_noxref_8_c_1648_n ) capacitor c=0.00190243f \
 //x=4.775 //y=0.865 //x2=4.51 //y2=0.835
cc_183 ( N_noxref_1_c_26_p N_noxref_8_c_1648_n ) capacitor c=0.00369501f \
 //x=4.775 //y=1.21 //x2=4.51 //y2=0.835
cc_184 ( N_noxref_1_c_76_p N_noxref_8_c_1657_n ) capacitor c=0.00693467f \
 //x=0.915 //y=0.865 //x2=3.16 //y2=0
cc_185 ( N_noxref_1_c_36_p N_noxref_8_c_1658_n ) capacitor c=0.00793669f \
 //x=0.74 //y=2.195 //x2=0.74 //y2=0
cc_186 ( N_noxref_1_c_40_p N_noxref_8_c_1658_n ) capacitor c=0.0172054f \
 //x=0.74 //y=4.28 //x2=0.74 //y2=0
cc_187 ( N_noxref_1_c_38_p N_noxref_8_c_1658_n ) capacitor c=0.00791319f \
 //x=0.74 //y=2.08 //x2=0.74 //y2=0
cc_188 ( N_noxref_1_c_79_p N_noxref_8_c_1658_n ) capacitor c=0.00264481f \
 //x=0.915 //y=1.52 //x2=0.74 //y2=0
cc_189 ( N_noxref_1_c_82_p N_noxref_8_c_1658_n ) capacitor c=0.00440632f \
 //x=0.915 //y=1.915 //x2=0.74 //y2=0
cc_190 ( N_noxref_1_c_39_p N_noxref_8_c_1658_n ) capacitor c=0.00706746f \
 //x=0.74 //y=2.08 //x2=0.74 //y2=0
cc_191 ( N_noxref_1_c_22_p N_noxref_8_c_1664_n ) capacitor c=0.00685588f \
 //x=4.245 //y=0.865 //x2=6.49 //y2=0
cc_192 ( N_noxref_1_c_1_p N_noxref_8_c_1665_n ) capacitor c=0.00537602f \
 //x=4.44 //y=2.205 //x2=3.33 //y2=0
cc_193 ( N_noxref_1_c_2_p N_noxref_8_c_1665_n ) capacitor c=0.00917348f \
 //x=4.44 //y=4.295 //x2=3.33 //y2=0
cc_194 ( N_noxref_1_c_3_p N_noxref_8_c_1665_n ) capacitor c=0.00369534f \
 //x=4.44 //y=2.08 //x2=3.33 //y2=0
cc_195 ( N_noxref_1_c_15_p N_noxref_8_c_1665_n ) capacitor c=0.00956283f \
 //x=4.245 //y=1.915 //x2=3.33 //y2=0
cc_196 ( N_noxref_1_c_76_p N_noxref_8_M0_noxref_d ) capacitor c=0.00192399f \
 //x=0.915 //y=0.865 //x2=0.99 //y2=0.865
cc_197 ( N_noxref_1_c_77_p N_noxref_8_M0_noxref_d ) capacitor c=0.00210798f \
 //x=0.915 //y=1.21 //x2=0.99 //y2=0.865
cc_198 ( N_noxref_1_c_171_p N_noxref_8_M0_noxref_d ) capacitor c=0.00472259f \
 //x=1.29 //y=0.71 //x2=0.99 //y2=0.865
cc_199 ( N_noxref_1_c_172_p N_noxref_8_M0_noxref_d ) capacitor c=0.00166857f \
 //x=1.29 //y=1.365 //x2=0.99 //y2=0.865
cc_200 ( N_noxref_1_c_78_p N_noxref_8_M0_noxref_d ) capacitor c=0.00230174f \
 //x=1.445 //y=0.865 //x2=0.99 //y2=0.865
cc_201 ( N_noxref_1_c_80_p N_noxref_8_M0_noxref_d ) capacitor c=0.00210798f \
 //x=1.445 //y=1.21 //x2=0.99 //y2=0.865
cc_202 ( N_noxref_1_c_1_p N_noxref_8_M2_noxref_d ) capacitor c=4.20217e-19 \
 //x=4.44 //y=2.205 //x2=4.32 //y2=0.865
cc_203 ( N_noxref_1_c_22_p N_noxref_8_M2_noxref_d ) capacitor c=0.00192399f \
 //x=4.245 //y=0.865 //x2=4.32 //y2=0.865
cc_204 ( N_noxref_1_c_23_p N_noxref_8_M2_noxref_d ) capacitor c=0.00228784f \
 //x=4.245 //y=1.21 //x2=4.32 //y2=0.865
cc_205 ( N_noxref_1_c_180_p N_noxref_8_M2_noxref_d ) capacitor c=0.0047434f \
 //x=4.62 //y=0.71 //x2=4.32 //y2=0.865
cc_206 ( N_noxref_1_c_181_p N_noxref_8_M2_noxref_d ) capacitor c=0.00172481f \
 //x=4.62 //y=1.365 //x2=4.32 //y2=0.865
cc_207 ( N_noxref_1_c_24_p N_noxref_8_M2_noxref_d ) capacitor c=0.00230174f \
 //x=4.775 //y=0.865 //x2=4.32 //y2=0.865
cc_208 ( N_noxref_1_c_26_p N_noxref_8_M2_noxref_d ) capacitor c=0.00228784f \
 //x=4.775 //y=1.21 //x2=4.32 //y2=0.865
cc_209 ( N_noxref_1_c_36_p N_noxref_10_c_1979_n ) capacitor c=0.0033606f \
 //x=0.74 //y=2.195 //x2=0.695 //y2=1.495
cc_210 ( N_noxref_1_c_38_p N_noxref_10_c_1979_n ) capacitor c=0.0101841f \
 //x=0.74 //y=2.08 //x2=0.695 //y2=1.495
cc_211 ( N_noxref_1_c_82_p N_noxref_10_c_1979_n ) capacitor c=0.0034165f \
 //x=0.915 //y=1.915 //x2=0.695 //y2=1.495
cc_212 ( N_noxref_1_c_39_p N_noxref_10_c_1979_n ) capacitor c=0.00545516f \
 //x=0.74 //y=2.08 //x2=0.695 //y2=1.495
cc_213 ( N_noxref_1_c_36_p N_noxref_10_c_1983_n ) capacitor c=0.00202162f \
 //x=0.74 //y=2.195 //x2=1.58 //y2=1.58
cc_214 ( N_noxref_1_c_48_p N_noxref_10_c_1983_n ) capacitor c=0.00272432f \
 //x=0.74 //y=4.44 //x2=1.58 //y2=1.58
cc_215 ( N_noxref_1_c_38_p N_noxref_10_c_1983_n ) capacitor c=0.00302337f \
 //x=0.74 //y=2.08 //x2=1.58 //y2=1.58
cc_216 ( N_noxref_1_c_79_p N_noxref_10_c_1983_n ) capacitor c=0.00720513f \
 //x=0.915 //y=1.52 //x2=1.58 //y2=1.58
cc_217 ( N_noxref_1_c_82_p N_noxref_10_c_1983_n ) capacitor c=0.0151009f \
 //x=0.915 //y=1.915 //x2=1.58 //y2=1.58
cc_218 ( N_noxref_1_c_172_p N_noxref_10_c_1983_n ) capacitor c=0.0094838f \
 //x=1.29 //y=1.365 //x2=1.58 //y2=1.58
cc_219 ( N_noxref_1_c_80_p N_noxref_10_c_1983_n ) capacitor c=0.00399755f \
 //x=1.445 //y=1.21 //x2=1.58 //y2=1.58
cc_220 ( N_noxref_1_c_39_p N_noxref_10_c_1983_n ) capacitor c=0.00168953f \
 //x=0.74 //y=2.08 //x2=1.58 //y2=1.58
cc_221 ( N_noxref_1_c_82_p N_noxref_10_c_1991_n ) capacitor c=6.71402e-19 \
 //x=0.915 //y=1.915 //x2=1.665 //y2=1.495
cc_222 ( N_noxref_1_c_76_p N_noxref_10_M0_noxref_s ) capacitor c=0.030618f \
 //x=0.915 //y=0.865 //x2=0.56 //y2=0.365
cc_223 ( N_noxref_1_c_79_p N_noxref_10_M0_noxref_s ) capacitor c=0.00110192f \
 //x=0.915 //y=1.52 //x2=0.56 //y2=0.365
cc_224 ( N_noxref_1_c_78_p N_noxref_10_M0_noxref_s ) capacitor c=0.0125442f \
 //x=1.445 //y=0.865 //x2=0.56 //y2=0.365
cc_225 ( N_noxref_1_c_15_p N_noxref_12_c_2055_n ) capacitor c=0.0034165f \
 //x=4.245 //y=1.915 //x2=4.025 //y2=1.495
cc_226 ( N_noxref_1_c_1_p N_noxref_12_c_2056_n ) capacitor c=0.00541004f \
 //x=4.44 //y=2.205 //x2=4.91 //y2=1.58
cc_227 ( N_noxref_1_c_5_p N_noxref_12_c_2056_n ) capacitor c=0.00299239f \
 //x=4.44 //y=4.44 //x2=4.91 //y2=1.58
cc_228 ( N_noxref_1_c_3_p N_noxref_12_c_2056_n ) capacitor c=0.00763108f \
 //x=4.44 //y=2.08 //x2=4.91 //y2=1.58
cc_229 ( N_noxref_1_c_25_p N_noxref_12_c_2056_n ) capacitor c=0.00688171f \
 //x=4.245 //y=1.52 //x2=4.91 //y2=1.58
cc_230 ( N_noxref_1_c_15_p N_noxref_12_c_2056_n ) capacitor c=0.0192505f \
 //x=4.245 //y=1.915 //x2=4.91 //y2=1.58
cc_231 ( N_noxref_1_c_181_p N_noxref_12_c_2056_n ) capacitor c=0.00720053f \
 //x=4.62 //y=1.365 //x2=4.91 //y2=1.58
cc_232 ( N_noxref_1_c_26_p N_noxref_12_c_2056_n ) capacitor c=0.0059368f \
 //x=4.775 //y=1.21 //x2=4.91 //y2=1.58
cc_233 ( N_noxref_1_c_15_p N_noxref_12_c_2063_n ) capacitor c=0.00122123f \
 //x=4.245 //y=1.915 //x2=4.995 //y2=1.495
cc_234 ( N_noxref_1_c_22_p N_noxref_12_M2_noxref_s ) capacitor c=0.0303347f \
 //x=4.245 //y=0.865 //x2=3.89 //y2=0.365
cc_235 ( N_noxref_1_c_25_p N_noxref_12_M2_noxref_s ) capacitor c=3.48408e-19 \
 //x=4.245 //y=1.52 //x2=3.89 //y2=0.365
cc_236 ( N_noxref_1_c_24_p N_noxref_12_M2_noxref_s ) capacitor c=0.012348f \
 //x=4.775 //y=0.865 //x2=3.89 //y2=0.365
cc_237 ( N_noxref_2_c_240_n N_noxref_3_c_468_n ) capacitor c=0.0013225f \
 //x=5.92 //y=4.58 //x2=1.85 //y2=3.865
cc_238 ( N_noxref_2_c_240_n N_noxref_3_c_474_n ) capacitor c=0.00166637f \
 //x=5.92 //y=4.58 //x2=1.85 //y2=4.53
cc_239 ( N_noxref_2_c_274_p N_noxref_3_c_523_n ) capacitor c=0.0061363f \
 //x=7.4 //y=2.25 //x2=8.51 //y2=2.2
cc_240 ( N_noxref_2_c_275_p N_noxref_3_c_523_n ) capacitor c=0.00602448f \
 //x=7.395 //y=2.09 //x2=8.51 //y2=2.2
cc_241 ( N_noxref_2_c_276_p N_noxref_3_c_523_n ) capacitor c=2.06418e-19 \
 //x=7.4 //y=2.08 //x2=8.51 //y2=2.2
cc_242 ( N_noxref_2_c_277_p N_noxref_3_c_523_n ) capacitor c=6.73725e-19 \
 //x=7.4 //y=2.08 //x2=8.51 //y2=2.2
cc_243 ( N_noxref_2_c_240_n N_noxref_3_c_527_n ) capacitor c=0.0021622f \
 //x=5.92 //y=4.58 //x2=8.51 //y2=3.87
cc_244 ( N_noxref_2_c_274_p N_noxref_3_c_527_n ) capacitor c=0.0011922f \
 //x=7.4 //y=2.25 //x2=8.51 //y2=3.87
cc_245 ( N_noxref_2_c_245_n N_noxref_3_c_527_n ) capacitor c=0.0512448f \
 //x=7.4 //y=4.575 //x2=8.51 //y2=3.87
cc_246 ( N_noxref_2_c_275_p N_noxref_3_c_527_n ) capacitor c=0.00107415f \
 //x=7.395 //y=2.09 //x2=8.51 //y2=3.87
cc_247 ( N_noxref_2_c_245_n N_noxref_3_c_531_n ) capacitor c=0.00771726f \
 //x=7.4 //y=4.575 //x2=8.51 //y2=4.19
cc_248 ( N_noxref_2_c_240_n N_noxref_3_c_532_n ) capacitor c=9.13182e-19 \
 //x=5.92 //y=4.58 //x2=8.51 //y2=4.56
cc_249 ( N_noxref_2_c_245_n N_noxref_3_c_532_n ) capacitor c=0.021848f //x=7.4 \
 //y=4.575 //x2=8.51 //y2=4.56
cc_250 ( N_noxref_2_c_285_p N_noxref_3_c_532_n ) capacitor c=8.06413e-19 \
 //x=7.4 //y=4.705 //x2=8.51 //y2=4.56
cc_251 ( N_noxref_2_c_286_p N_noxref_3_c_532_n ) capacitor c=0.00125146f \
 //x=8.035 //y=4.795 //x2=8.51 //y2=4.56
cc_252 ( N_noxref_2_c_287_p N_noxref_3_c_532_n ) capacitor c=0.00103195f \
 //x=7.745 //y=4.795 //x2=8.51 //y2=4.56
cc_253 ( N_noxref_2_c_245_n N_noxref_3_c_537_n ) capacitor c=5.15538e-19 \
 //x=7.4 //y=4.575 //x2=8.51 //y2=4.07
cc_254 ( N_noxref_2_c_245_n N_noxref_3_c_538_n ) capacitor c=0.00250167f \
 //x=7.4 //y=4.575 //x2=8.525 //y2=4.03
cc_255 ( N_noxref_2_c_237_n N_noxref_3_c_488_n ) capacitor c=0.00231224f \
 //x=5.92 //y=2.25 //x2=8.365 //y2=4.03
cc_256 ( N_noxref_2_c_240_n N_noxref_3_c_488_n ) capacitor c=0.0405308f \
 //x=5.92 //y=4.58 //x2=8.365 //y2=4.03
cc_257 ( N_noxref_2_c_274_p N_noxref_3_c_488_n ) capacitor c=0.00231693f \
 //x=7.4 //y=2.25 //x2=8.365 //y2=4.03
cc_258 ( N_noxref_2_c_245_n N_noxref_3_c_488_n ) capacitor c=0.0387859f \
 //x=7.4 //y=4.575 //x2=8.365 //y2=4.03
cc_259 ( N_noxref_2_c_246_n N_noxref_3_c_488_n ) capacitor c=0.00472291f \
 //x=6.085 //y=2.09 //x2=8.365 //y2=4.03
cc_260 ( N_noxref_2_c_275_p N_noxref_3_c_488_n ) capacitor c=0.00472291f \
 //x=7.395 //y=2.09 //x2=8.365 //y2=4.03
cc_261 ( N_noxref_2_c_296_p N_noxref_3_c_488_n ) capacitor c=0.0202481f \
 //x=7.235 //y=2.09 //x2=8.365 //y2=4.03
cc_262 ( N_noxref_2_c_274_p N_noxref_3_c_546_n ) capacitor c=7.58956e-19 \
 //x=7.4 //y=2.25 //x2=8.51 //y2=2.08
cc_263 ( N_noxref_2_c_276_p N_noxref_3_c_546_n ) capacitor c=0.00113671f \
 //x=7.4 //y=2.08 //x2=8.51 //y2=2.08
cc_264 ( N_noxref_2_c_277_p N_noxref_3_c_546_n ) capacitor c=0.00169858f \
 //x=7.4 //y=2.08 //x2=8.51 //y2=2.08
cc_265 ( N_noxref_2_c_245_n N_noxref_3_c_549_n ) capacitor c=2.02321e-19 \
 //x=7.4 //y=4.575 //x2=8.53 //y2=4.705
cc_266 ( N_noxref_2_c_285_p N_noxref_3_c_549_n ) capacitor c=0.00106454f \
 //x=7.4 //y=4.705 //x2=8.53 //y2=4.705
cc_267 ( N_noxref_2_c_286_p N_noxref_3_c_549_n ) capacitor c=0.00147609f \
 //x=8.035 //y=4.795 //x2=8.53 //y2=4.705
cc_268 ( N_noxref_2_c_287_p N_noxref_3_c_549_n ) capacitor c=0.00127381f \
 //x=7.745 //y=4.795 //x2=8.53 //y2=4.705
cc_269 ( N_noxref_2_M15_noxref_g N_noxref_3_M17_noxref_g ) capacitor \
 c=0.00935155f //x=7.67 //y=6.025 //x2=8.55 //y2=6.025
cc_270 ( N_noxref_2_M16_noxref_g N_noxref_3_M17_noxref_g ) capacitor \
 c=0.111828f //x=8.11 //y=6.025 //x2=8.55 //y2=6.025
cc_271 ( N_noxref_2_M16_noxref_g N_noxref_3_M18_noxref_g ) capacitor \
 c=0.00876656f //x=8.11 //y=6.025 //x2=8.99 //y2=6.025
cc_272 ( N_noxref_2_c_307_p N_noxref_3_c_556_n ) capacitor c=4.86545e-19 \
 //x=7.575 //y=0.865 //x2=8.545 //y2=0.905
cc_273 ( N_noxref_2_c_308_p N_noxref_3_c_556_n ) capacitor c=0.00152405f \
 //x=7.575 //y=1.21 //x2=8.545 //y2=0.905
cc_274 ( N_noxref_2_c_309_p N_noxref_3_c_556_n ) capacitor c=0.0151424f \
 //x=8.105 //y=0.865 //x2=8.545 //y2=0.905
cc_275 ( N_noxref_2_c_310_p N_noxref_3_c_559_n ) capacitor c=0.00109722f \
 //x=7.575 //y=1.52 //x2=8.545 //y2=1.255
cc_276 ( N_noxref_2_c_311_p N_noxref_3_c_559_n ) capacitor c=0.0111013f \
 //x=8.105 //y=1.21 //x2=8.545 //y2=1.255
cc_277 ( N_noxref_2_c_310_p N_noxref_3_c_561_n ) capacitor c=0.00179029f \
 //x=7.575 //y=1.52 //x2=8.545 //y2=1.56
cc_278 ( N_noxref_2_c_313_p N_noxref_3_c_561_n ) capacitor c=0.00662747f \
 //x=7.575 //y=1.915 //x2=8.545 //y2=1.56
cc_279 ( N_noxref_2_c_311_p N_noxref_3_c_561_n ) capacitor c=0.00862358f \
 //x=8.105 //y=1.21 //x2=8.545 //y2=1.56
cc_280 ( N_noxref_2_c_311_p N_noxref_3_c_564_n ) capacitor c=4.75927e-19 \
 //x=8.105 //y=1.21 //x2=8.92 //y2=1.405
cc_281 ( N_noxref_2_c_309_p N_noxref_3_c_565_n ) capacitor c=0.00130607f \
 //x=8.105 //y=0.865 //x2=9.075 //y2=0.905
cc_282 ( N_noxref_2_c_311_p N_noxref_3_c_566_n ) capacitor c=0.00153205f \
 //x=8.105 //y=1.21 //x2=9.075 //y2=1.255
cc_283 ( N_noxref_2_c_274_p N_noxref_3_c_567_n ) capacitor c=0.00157228f \
 //x=7.4 //y=2.25 //x2=8.51 //y2=2.08
cc_284 ( N_noxref_2_c_276_p N_noxref_3_c_567_n ) capacitor c=0.00194209f \
 //x=7.4 //y=2.08 //x2=8.51 //y2=2.08
cc_285 ( N_noxref_2_c_277_p N_noxref_3_c_567_n ) capacitor c=0.00887988f \
 //x=7.4 //y=2.08 //x2=8.51 //y2=2.08
cc_286 ( N_noxref_2_c_245_n N_noxref_3_c_570_n ) capacitor c=0.00132485f \
 //x=7.4 //y=4.575 //x2=8.53 //y2=4.705
cc_287 ( N_noxref_2_c_285_p N_noxref_3_c_570_n ) capacitor c=0.00167042f \
 //x=7.4 //y=4.705 //x2=8.53 //y2=4.705
cc_288 ( N_noxref_2_c_286_p N_noxref_3_c_570_n ) capacitor c=0.022796f \
 //x=8.035 //y=4.795 //x2=8.53 //y2=4.705
cc_289 ( N_noxref_2_c_287_p N_noxref_3_c_570_n ) capacitor c=0.00470299f \
 //x=7.745 //y=4.795 //x2=8.53 //y2=4.705
cc_290 ( N_noxref_2_M16_noxref_g N_noxref_4_c_756_n ) capacitor c=0.00969448f \
 //x=8.11 //y=6.025 //x2=8.645 //y2=5.21
cc_291 ( N_noxref_2_c_274_p N_noxref_4_c_757_n ) capacitor c=8.05281e-19 \
 //x=7.4 //y=2.25 //x2=9.25 //y2=3.915
cc_292 ( N_noxref_2_c_245_n N_noxref_4_c_757_n ) capacitor c=0.00363479f \
 //x=7.4 //y=4.575 //x2=9.25 //y2=3.915
cc_293 ( N_noxref_2_c_245_n N_noxref_4_c_759_n ) capacitor c=0.00136963f \
 //x=7.4 //y=4.575 //x2=9.25 //y2=5.125
cc_294 ( N_noxref_2_c_258_n N_noxref_4_c_760_n ) capacitor c=5.10033e-19 \
 //x=5.215 //y=0.905 //x2=5.48 //y2=1.18
cc_295 ( N_noxref_2_c_261_n N_noxref_4_c_760_n ) capacitor c=0.00606934f \
 //x=5.215 //y=1.25 //x2=5.48 //y2=1.18
cc_296 ( N_noxref_2_c_331_p N_noxref_4_c_760_n ) capacitor c=4.65567e-19 \
 //x=5.59 //y=0.75 //x2=5.48 //y2=1.18
cc_297 ( N_noxref_2_c_332_p N_noxref_4_c_760_n ) capacitor c=0.00247382f \
 //x=5.59 //y=1.405 //x2=5.48 //y2=1.18
cc_298 ( N_noxref_2_c_267_n N_noxref_4_c_760_n ) capacitor c=2.15736e-19 \
 //x=5.745 //y=0.905 //x2=5.48 //y2=1.18
cc_299 ( N_noxref_2_c_268_n N_noxref_4_c_760_n ) capacitor c=0.00259159f \
 //x=5.745 //y=1.25 //x2=5.48 //y2=1.18
cc_300 ( N_noxref_2_c_269_n N_noxref_4_c_760_n ) capacitor c=0.00150348f \
 //x=5.745 //y=1.56 //x2=5.48 //y2=1.18
cc_301 ( N_noxref_2_M15_noxref_g N_noxref_4_c_767_n ) capacitor c=0.00363978f \
 //x=7.67 //y=6.025 //x2=7.89 //y2=5.21
cc_302 ( N_noxref_2_M16_noxref_g N_noxref_4_c_767_n ) capacitor c=0.00185829f \
 //x=8.11 //y=6.025 //x2=7.89 //y2=5.21
cc_303 ( N_noxref_2_c_286_p N_noxref_4_c_767_n ) capacitor c=0.0021827f \
 //x=8.035 //y=4.795 //x2=7.89 //y2=5.21
cc_304 ( N_noxref_2_c_261_n N_noxref_4_c_752_n ) capacitor c=0.00147665f \
 //x=5.215 //y=1.25 //x2=5.35 //y2=1.225
cc_305 ( N_noxref_2_c_237_n N_noxref_4_c_771_n ) capacitor c=0.00831552f \
 //x=5.92 //y=2.25 //x2=8.645 //y2=1.225
cc_306 ( N_noxref_2_c_274_p N_noxref_4_c_771_n ) capacitor c=0.00831552f \
 //x=7.4 //y=2.25 //x2=8.645 //y2=1.225
cc_307 ( N_noxref_2_c_246_n N_noxref_4_c_771_n ) capacitor c=0.0128605f \
 //x=6.085 //y=2.09 //x2=8.645 //y2=1.225
cc_308 ( N_noxref_2_c_275_p N_noxref_4_c_771_n ) capacitor c=0.0128597f \
 //x=7.395 //y=2.09 //x2=8.645 //y2=1.225
cc_309 ( N_noxref_2_c_296_p N_noxref_4_c_771_n ) capacitor c=0.0434154f \
 //x=7.235 //y=2.09 //x2=8.645 //y2=1.225
cc_310 ( N_noxref_2_c_268_n N_noxref_4_c_771_n ) capacitor c=0.00215337f \
 //x=5.745 //y=1.25 //x2=8.645 //y2=1.225
cc_311 ( N_noxref_2_c_269_n N_noxref_4_c_771_n ) capacitor c=0.00349699f \
 //x=5.745 //y=1.56 //x2=8.645 //y2=1.225
cc_312 ( N_noxref_2_c_308_p N_noxref_4_c_771_n ) capacitor c=0.00277413f \
 //x=7.575 //y=1.21 //x2=8.645 //y2=1.225
cc_313 ( N_noxref_2_c_310_p N_noxref_4_c_771_n ) capacitor c=0.00245466f \
 //x=7.575 //y=1.52 //x2=8.645 //y2=1.225
cc_314 ( N_noxref_2_c_311_p N_noxref_4_c_771_n ) capacitor c=0.00460244f \
 //x=8.105 //y=1.21 //x2=8.645 //y2=1.225
cc_315 ( N_noxref_2_M15_noxref_g N_noxref_4_c_781_n ) capacitor c=0.0120591f \
 //x=7.67 //y=6.025 //x2=7.89 //y2=5.38
cc_316 ( N_noxref_2_M16_noxref_g N_noxref_4_c_781_n ) capacitor c=0.0142133f \
 //x=8.11 //y=6.025 //x2=7.89 //y2=5.38
cc_317 ( N_noxref_2_c_286_p N_noxref_4_c_781_n ) capacitor c=0.00293135f \
 //x=8.035 //y=4.795 //x2=7.89 //y2=5.38
cc_318 ( N_noxref_2_c_258_n N_noxref_4_M3_noxref_d ) capacitor c=0.00217566f \
 //x=5.215 //y=0.905 //x2=5.29 //y2=0.905
cc_319 ( N_noxref_2_c_261_n N_noxref_4_M3_noxref_d ) capacitor c=0.00693963f \
 //x=5.215 //y=1.25 //x2=5.29 //y2=0.905
cc_320 ( N_noxref_2_c_331_p N_noxref_4_M3_noxref_d ) capacitor c=0.00234223f \
 //x=5.59 //y=0.75 //x2=5.29 //y2=0.905
cc_321 ( N_noxref_2_c_332_p N_noxref_4_M3_noxref_d ) capacitor c=0.00513213f \
 //x=5.59 //y=1.405 //x2=5.29 //y2=0.905
cc_322 ( N_noxref_2_c_267_n N_noxref_4_M3_noxref_d ) capacitor c=0.00132245f \
 //x=5.745 //y=0.905 //x2=5.29 //y2=0.905
cc_323 ( N_noxref_2_c_268_n N_noxref_4_M3_noxref_d ) capacitor c=0.00326247f \
 //x=5.745 //y=1.25 //x2=5.29 //y2=0.905
cc_324 ( N_noxref_2_c_269_n N_noxref_4_M3_noxref_d ) capacitor c=0.00231463f \
 //x=5.745 //y=1.56 //x2=5.29 //y2=0.905
cc_325 ( N_noxref_2_M13_noxref_g N_noxref_5_c_1098_n ) capacitor c=0.00776897f \
 //x=5.21 //y=6.025 //x2=6.49 //y2=7.4
cc_326 ( N_noxref_2_M14_noxref_g N_noxref_5_c_1098_n ) capacitor c=0.00776897f \
 //x=5.65 //y=6.025 //x2=6.49 //y2=7.4
cc_327 ( N_noxref_2_M15_noxref_g N_noxref_5_c_1116_n ) capacitor c=0.00776897f \
 //x=7.67 //y=6.025 //x2=9.82 //y2=7.4
cc_328 ( N_noxref_2_M16_noxref_g N_noxref_5_c_1116_n ) capacitor c=0.00776897f \
 //x=8.11 //y=6.025 //x2=9.82 //y2=7.4
cc_329 ( N_noxref_2_c_240_n N_noxref_5_c_1107_n ) capacitor c=0.0156004f \
 //x=5.92 //y=4.58 //x2=6.66 //y2=7.4
cc_330 ( N_noxref_2_c_245_n N_noxref_5_c_1107_n ) capacitor c=0.0163412f \
 //x=7.4 //y=4.575 //x2=6.66 //y2=7.4
cc_331 ( N_noxref_2_c_252_n N_noxref_5_c_1107_n ) capacitor c=0.00790417f \
 //x=5.92 //y=4.705 //x2=6.66 //y2=7.4
cc_332 ( N_noxref_2_c_285_p N_noxref_5_c_1107_n ) capacitor c=0.00790205f \
 //x=7.4 //y=4.705 //x2=6.66 //y2=7.4
cc_333 ( N_noxref_2_M14_noxref_g N_noxref_5_c_1107_n ) capacitor c=0.0138263f \
 //x=5.65 //y=6.025 //x2=6.66 //y2=7.4
cc_334 ( N_noxref_2_M15_noxref_g N_noxref_5_c_1107_n ) capacitor c=0.00855037f \
 //x=7.67 //y=6.025 //x2=6.66 //y2=7.4
cc_335 ( N_noxref_2_c_265_n N_noxref_5_c_1107_n ) capacitor c=0.00722671f \
 //x=5.65 //y=4.87 //x2=6.66 //y2=7.4
cc_336 ( N_noxref_2_c_287_p N_noxref_5_c_1107_n ) capacitor c=0.00720105f \
 //x=7.745 //y=4.795 //x2=6.66 //y2=7.4
cc_337 ( N_noxref_2_M13_noxref_g N_noxref_6_c_1364_n ) capacitor c=0.00814026f \
 //x=5.21 //y=6.025 //x2=5.755 //y2=6.91
cc_338 ( N_noxref_2_M14_noxref_g N_noxref_6_c_1364_n ) capacitor c=0.00937408f \
 //x=5.65 //y=6.025 //x2=5.755 //y2=6.91
cc_339 ( N_noxref_2_M13_noxref_g N_noxref_6_c_1353_n ) capacitor c=0.0017976f \
 //x=5.21 //y=6.025 //x2=4.987 //y2=6.91
cc_340 ( N_noxref_2_M14_noxref_g N_noxref_6_c_1367_n ) capacitor c=0.00395674f \
 //x=5.65 //y=6.025 //x2=5.87 //y2=6.74
cc_341 ( N_noxref_2_M13_noxref_g N_noxref_6_M12_noxref_d ) capacitor \
 c=0.0142133f //x=5.21 //y=6.025 //x2=4.845 //y2=5.025
cc_342 ( N_noxref_2_c_252_n N_noxref_6_M14_noxref_d ) capacitor c=0.00256087f \
 //x=5.92 //y=4.705 //x2=5.725 //y2=5.025
cc_343 ( N_noxref_2_M14_noxref_g N_noxref_6_M14_noxref_d ) capacitor \
 c=0.0365939f //x=5.65 //y=6.025 //x2=5.725 //y2=5.025
cc_344 ( N_noxref_2_c_265_n N_noxref_6_M14_noxref_d ) capacitor c=0.00447202f \
 //x=5.65 //y=4.87 //x2=5.725 //y2=5.025
cc_345 ( N_noxref_2_M13_noxref_g N_noxref_7_c_1502_n ) capacitor c=0.00998198f \
 //x=5.21 //y=6.025 //x2=5.315 //y2=5.21
cc_346 ( N_noxref_2_c_237_n N_noxref_7_c_1515_n ) capacitor c=0.00143791f \
 //x=5.92 //y=2.25 //x2=7.335 //y2=5.21
cc_347 ( N_noxref_2_c_240_n N_noxref_7_c_1515_n ) capacitor c=0.0227143f \
 //x=5.92 //y=4.58 //x2=7.335 //y2=5.21
cc_348 ( N_noxref_2_c_274_p N_noxref_7_c_1515_n ) capacitor c=0.00141341f \
 //x=7.4 //y=2.25 //x2=7.335 //y2=5.21
cc_349 ( N_noxref_2_c_245_n N_noxref_7_c_1515_n ) capacitor c=0.0274606f \
 //x=7.4 //y=4.575 //x2=7.335 //y2=5.21
cc_350 ( N_noxref_2_c_252_n N_noxref_7_c_1515_n ) capacitor c=0.0035251f \
 //x=5.92 //y=4.705 //x2=7.335 //y2=5.21
cc_351 ( N_noxref_2_c_285_p N_noxref_7_c_1515_n ) capacitor c=0.00429429f \
 //x=7.4 //y=4.705 //x2=7.335 //y2=5.21
cc_352 ( N_noxref_2_M14_noxref_g N_noxref_7_c_1515_n ) capacitor c=0.0119434f \
 //x=5.65 //y=6.025 //x2=7.335 //y2=5.21
cc_353 ( N_noxref_2_M15_noxref_g N_noxref_7_c_1515_n ) capacitor c=0.00372569f \
 //x=7.67 //y=6.025 //x2=7.335 //y2=5.21
cc_354 ( N_noxref_2_c_265_n N_noxref_7_c_1515_n ) capacitor c=0.00500633f \
 //x=5.65 //y=4.87 //x2=7.335 //y2=5.21
cc_355 ( N_noxref_2_c_287_p N_noxref_7_c_1515_n ) capacitor c=0.00243015f \
 //x=7.745 //y=4.795 //x2=7.335 //y2=5.21
cc_356 ( N_noxref_2_M13_noxref_g N_noxref_7_c_1525_n ) capacitor c=6.12451e-19 \
 //x=5.21 //y=6.025 //x2=5.545 //y2=5.21
cc_357 ( N_noxref_2_M14_noxref_g N_noxref_7_c_1525_n ) capacitor c=8.33934e-19 \
 //x=5.65 //y=6.025 //x2=5.545 //y2=5.21
cc_358 ( N_noxref_2_M15_noxref_g N_noxref_7_c_1527_n ) capacitor c=0.0109238f \
 //x=7.67 //y=6.025 //x2=8.215 //y2=6.91
cc_359 ( N_noxref_2_M16_noxref_g N_noxref_7_c_1527_n ) capacitor c=0.00814026f \
 //x=8.11 //y=6.025 //x2=8.215 //y2=6.91
cc_360 ( N_noxref_2_M13_noxref_g N_noxref_7_c_1529_n ) capacitor c=0.00610004f \
 //x=5.21 //y=6.025 //x2=5.43 //y2=5.21
cc_361 ( N_noxref_2_M14_noxref_g N_noxref_7_c_1529_n ) capacitor c=0.00485827f \
 //x=5.65 //y=6.025 //x2=5.43 //y2=5.21
cc_362 ( N_noxref_2_c_397_p N_noxref_7_c_1529_n ) capacitor c=0.00435703f \
 //x=5.575 //y=4.795 //x2=5.43 //y2=5.21
cc_363 ( N_noxref_2_M15_noxref_g N_noxref_7_c_1532_n ) capacitor c=0.00394587f \
 //x=7.67 //y=6.025 //x2=7.45 //y2=6.74
cc_364 ( N_noxref_2_M16_noxref_g N_noxref_7_c_1533_n ) capacitor c=0.00179267f \
 //x=8.11 //y=6.025 //x2=8.33 //y2=6.91
cc_365 ( N_noxref_2_c_245_n N_noxref_7_c_1534_n ) capacitor c=0.00533094f \
 //x=7.4 //y=4.575 //x2=7.45 //y2=5.21
cc_366 ( N_noxref_2_c_285_p N_noxref_7_c_1534_n ) capacitor c=0.013929f \
 //x=7.4 //y=4.705 //x2=7.45 //y2=5.21
cc_367 ( N_noxref_2_M15_noxref_g N_noxref_7_c_1534_n ) capacitor c=0.0510602f \
 //x=7.67 //y=6.025 //x2=7.45 //y2=5.21
cc_368 ( N_noxref_2_c_287_p N_noxref_7_c_1534_n ) capacitor c=0.00827092f \
 //x=7.745 //y=4.795 //x2=7.45 //y2=5.21
cc_369 ( N_noxref_2_M16_noxref_g N_noxref_7_M16_noxref_d ) capacitor \
 c=0.0142133f //x=8.11 //y=6.025 //x2=8.185 //y2=5.025
cc_370 ( N_noxref_2_c_237_n N_noxref_8_c_1682_n ) capacitor c=9.60839e-19 \
 //x=5.92 //y=2.25 //x2=7.755 //y2=0
cc_371 ( N_noxref_2_c_274_p N_noxref_8_c_1682_n ) capacitor c=0.00100305f \
 //x=7.4 //y=2.25 //x2=7.755 //y2=0
cc_372 ( N_noxref_2_c_276_p N_noxref_8_c_1682_n ) capacitor c=2.64897e-19 \
 //x=7.4 //y=2.08 //x2=7.755 //y2=0
cc_373 ( N_noxref_2_c_307_p N_noxref_8_c_1685_n ) capacitor c=0.00175529f \
 //x=7.575 //y=0.865 //x2=7.84 //y2=0.84
cc_374 ( N_noxref_2_c_308_p N_noxref_8_c_1685_n ) capacitor c=0.00373063f \
 //x=7.575 //y=1.21 //x2=7.84 //y2=0.84
cc_375 ( N_noxref_2_c_310_p N_noxref_8_c_1685_n ) capacitor c=3.99385e-19 \
 //x=7.575 //y=1.52 //x2=7.84 //y2=0.84
cc_376 ( N_noxref_2_c_411_p N_noxref_8_c_1685_n ) capacitor c=0.00924059f \
 //x=7.95 //y=0.71 //x2=7.84 //y2=0.84
cc_377 ( N_noxref_2_c_412_p N_noxref_8_c_1685_n ) capacitor c=6.20182e-19 \
 //x=7.95 //y=1.365 //x2=7.84 //y2=0.84
cc_378 ( N_noxref_2_c_309_p N_noxref_8_c_1685_n ) capacitor c=0.00181395f \
 //x=8.105 //y=0.865 //x2=7.84 //y2=0.84
cc_379 ( N_noxref_2_c_311_p N_noxref_8_c_1685_n ) capacitor c=0.00394995f \
 //x=8.105 //y=1.21 //x2=7.84 //y2=0.84
cc_380 ( N_noxref_2_c_237_n N_noxref_8_c_1664_n ) capacitor c=9.42373e-19 \
 //x=5.92 //y=2.25 //x2=6.49 //y2=0
cc_381 ( N_noxref_2_c_274_p N_noxref_8_c_1693_n ) capacitor c=6.59659e-19 \
 //x=7.4 //y=2.25 //x2=9.82 //y2=0
cc_382 ( N_noxref_2_c_307_p N_noxref_8_c_1693_n ) capacitor c=0.0069573f \
 //x=7.575 //y=0.865 //x2=9.82 //y2=0
cc_383 ( N_noxref_2_c_248_n N_noxref_8_c_1665_n ) capacitor c=3.88707e-19 \
 //x=5.92 //y=2.08 //x2=3.33 //y2=0
cc_384 ( N_noxref_2_c_237_n N_noxref_8_c_1696_n ) capacitor c=0.00414357f \
 //x=5.92 //y=2.25 //x2=6.66 //y2=0
cc_385 ( N_noxref_2_c_240_n N_noxref_8_c_1696_n ) capacitor c=0.0117547f \
 //x=5.92 //y=4.58 //x2=6.66 //y2=0
cc_386 ( N_noxref_2_c_274_p N_noxref_8_c_1696_n ) capacitor c=0.00414357f \
 //x=7.4 //y=2.25 //x2=6.66 //y2=0
cc_387 ( N_noxref_2_c_245_n N_noxref_8_c_1696_n ) capacitor c=0.0117547f \
 //x=7.4 //y=4.575 //x2=6.66 //y2=0
cc_388 ( N_noxref_2_c_296_p N_noxref_8_c_1696_n ) capacitor c=0.0153655f \
 //x=7.235 //y=2.09 //x2=6.66 //y2=0
cc_389 ( N_noxref_2_c_248_n N_noxref_8_c_1696_n ) capacitor c=0.00780676f \
 //x=5.92 //y=2.08 //x2=6.66 //y2=0
cc_390 ( N_noxref_2_c_276_p N_noxref_8_c_1696_n ) capacitor c=0.00780676f \
 //x=7.4 //y=2.08 //x2=6.66 //y2=0
cc_391 ( N_noxref_2_c_270_n N_noxref_8_c_1696_n ) capacitor c=0.00967557f \
 //x=5.745 //y=1.915 //x2=6.66 //y2=0
cc_392 ( N_noxref_2_c_313_p N_noxref_8_c_1696_n ) capacitor c=0.00347725f \
 //x=7.575 //y=1.915 //x2=6.66 //y2=0
cc_393 ( N_noxref_2_c_277_p N_noxref_8_c_1696_n ) capacitor c=0.00619832f \
 //x=7.4 //y=2.08 //x2=6.66 //y2=0
cc_394 ( N_noxref_2_c_276_p N_noxref_8_c_1706_n ) capacitor c=2.74348e-19 \
 //x=7.4 //y=2.08 //x2=9.99 //y2=0
cc_395 ( N_noxref_2_c_307_p N_noxref_8_M4_noxref_d ) capacitor c=0.00192399f \
 //x=7.575 //y=0.865 //x2=7.65 //y2=0.865
cc_396 ( N_noxref_2_c_308_p N_noxref_8_M4_noxref_d ) capacitor c=0.00210798f \
 //x=7.575 //y=1.21 //x2=7.65 //y2=0.865
cc_397 ( N_noxref_2_c_411_p N_noxref_8_M4_noxref_d ) capacitor c=0.00472259f \
 //x=7.95 //y=0.71 //x2=7.65 //y2=0.865
cc_398 ( N_noxref_2_c_412_p N_noxref_8_M4_noxref_d ) capacitor c=0.00166857f \
 //x=7.95 //y=1.365 //x2=7.65 //y2=0.865
cc_399 ( N_noxref_2_c_309_p N_noxref_8_M4_noxref_d ) capacitor c=0.00230174f \
 //x=8.105 //y=0.865 //x2=7.65 //y2=0.865
cc_400 ( N_noxref_2_c_311_p N_noxref_8_M4_noxref_d ) capacitor c=0.00210798f \
 //x=8.105 //y=1.21 //x2=7.65 //y2=0.865
cc_401 ( N_noxref_2_M13_noxref_g noxref_11 ) capacitor c=0.00925495f //x=5.21 \
 //y=6.025 //x2=5.285 //y2=5.025
cc_402 ( N_noxref_2_M14_noxref_g noxref_11 ) capacitor c=0.00925495f //x=5.65 \
 //y=6.025 //x2=5.285 //y2=5.025
cc_403 ( N_noxref_2_c_270_n N_noxref_12_c_2063_n ) capacitor c=0.0028747f \
 //x=5.745 //y=1.915 //x2=4.995 //y2=1.495
cc_404 ( N_noxref_2_c_237_n N_noxref_12_c_2068_n ) capacitor c=7.24043e-19 \
 //x=5.92 //y=2.25 //x2=5.88 //y2=0.53
cc_405 ( N_noxref_2_c_258_n N_noxref_12_c_2068_n ) capacitor c=0.0214576f \
 //x=5.215 //y=0.905 //x2=5.88 //y2=0.53
cc_406 ( N_noxref_2_c_267_n N_noxref_12_c_2068_n ) capacitor c=0.00781103f \
 //x=5.745 //y=0.905 //x2=5.88 //y2=0.53
cc_407 ( N_noxref_2_c_237_n N_noxref_12_M2_noxref_s ) capacitor c=0.00472586f \
 //x=5.92 //y=2.25 //x2=3.89 //y2=0.365
cc_408 ( N_noxref_2_c_248_n N_noxref_12_M2_noxref_s ) capacitor c=0.010408f \
 //x=5.92 //y=2.08 //x2=3.89 //y2=0.365
cc_409 ( N_noxref_2_c_258_n N_noxref_12_M2_noxref_s ) capacitor c=0.00506846f \
 //x=5.215 //y=0.905 //x2=3.89 //y2=0.365
cc_410 ( N_noxref_2_c_261_n N_noxref_12_M2_noxref_s ) capacitor c=0.00602248f \
 //x=5.215 //y=1.25 //x2=3.89 //y2=0.365
cc_411 ( N_noxref_2_c_267_n N_noxref_12_M2_noxref_s ) capacitor c=0.028957f \
 //x=5.745 //y=0.905 //x2=3.89 //y2=0.365
cc_412 ( N_noxref_2_c_269_n N_noxref_12_M2_noxref_s ) capacitor c=0.00369225f \
 //x=5.745 //y=1.56 //x2=3.89 //y2=0.365
cc_413 ( N_noxref_2_c_270_n N_noxref_12_M2_noxref_s ) capacitor c=0.00797698f \
 //x=5.745 //y=1.915 //x2=3.89 //y2=0.365
cc_414 ( N_noxref_2_c_274_p N_noxref_13_c_2121_n ) capacitor c=0.00472586f \
 //x=7.4 //y=2.25 //x2=7.355 //y2=1.495
cc_415 ( N_noxref_2_c_276_p N_noxref_13_c_2121_n ) capacitor c=0.010408f \
 //x=7.4 //y=2.08 //x2=7.355 //y2=1.495
cc_416 ( N_noxref_2_c_313_p N_noxref_13_c_2121_n ) capacitor c=0.00262672f \
 //x=7.575 //y=1.915 //x2=7.355 //y2=1.495
cc_417 ( N_noxref_2_c_277_p N_noxref_13_c_2121_n ) capacitor c=0.00544234f \
 //x=7.4 //y=2.08 //x2=7.355 //y2=1.495
cc_418 ( N_noxref_2_c_274_p N_noxref_13_c_2125_n ) capacitor c=0.00350492f \
 //x=7.4 //y=2.25 //x2=8.24 //y2=1.58
cc_419 ( N_noxref_2_c_276_p N_noxref_13_c_2125_n ) capacitor c=0.00305793f \
 //x=7.4 //y=2.08 //x2=8.24 //y2=1.58
cc_420 ( N_noxref_2_c_310_p N_noxref_13_c_2125_n ) capacitor c=0.00712798f \
 //x=7.575 //y=1.52 //x2=8.24 //y2=1.58
cc_421 ( N_noxref_2_c_313_p N_noxref_13_c_2125_n ) capacitor c=0.013968f \
 //x=7.575 //y=1.915 //x2=8.24 //y2=1.58
cc_422 ( N_noxref_2_c_412_p N_noxref_13_c_2125_n ) capacitor c=0.00948889f \
 //x=7.95 //y=1.365 //x2=8.24 //y2=1.58
cc_423 ( N_noxref_2_c_311_p N_noxref_13_c_2125_n ) capacitor c=0.00339872f \
 //x=8.105 //y=1.21 //x2=8.24 //y2=1.58
cc_424 ( N_noxref_2_c_277_p N_noxref_13_c_2125_n ) capacitor c=0.00168631f \
 //x=7.4 //y=2.08 //x2=8.24 //y2=1.58
cc_425 ( N_noxref_2_c_313_p N_noxref_13_c_2132_n ) capacitor c=6.71402e-19 \
 //x=7.575 //y=1.915 //x2=8.325 //y2=1.495
cc_426 ( N_noxref_2_c_307_p N_noxref_13_M4_noxref_s ) capacitor c=0.0293163f \
 //x=7.575 //y=0.865 //x2=7.22 //y2=0.365
cc_427 ( N_noxref_2_c_310_p N_noxref_13_M4_noxref_s ) capacitor c=0.00110192f \
 //x=7.575 //y=1.52 //x2=7.22 //y2=0.365
cc_428 ( N_noxref_2_c_309_p N_noxref_13_M4_noxref_s ) capacitor c=0.0123625f \
 //x=8.105 //y=0.865 //x2=7.22 //y2=0.365
cc_429 ( N_noxref_3_c_531_n N_noxref_4_c_756_n ) capacitor c=0.00435926f \
 //x=8.51 //y=4.19 //x2=8.645 //y2=5.21
cc_430 ( N_noxref_3_c_532_n N_noxref_4_c_756_n ) capacitor c=0.0223378f \
 //x=8.51 //y=4.56 //x2=8.645 //y2=5.21
cc_431 ( N_noxref_3_c_538_n N_noxref_4_c_756_n ) capacitor c=7.70643e-19 \
 //x=8.525 //y=4.03 //x2=8.645 //y2=5.21
cc_432 ( N_noxref_3_c_488_n N_noxref_4_c_756_n ) capacitor c=0.0017832f \
 //x=8.365 //y=4.03 //x2=8.645 //y2=5.21
cc_433 ( N_noxref_3_c_549_n N_noxref_4_c_756_n ) capacitor c=0.00459858f \
 //x=8.53 //y=4.705 //x2=8.645 //y2=5.21
cc_434 ( N_noxref_3_M17_noxref_g N_noxref_4_c_756_n ) capacitor c=0.00846675f \
 //x=8.55 //y=6.025 //x2=8.645 //y2=5.21
cc_435 ( N_noxref_3_c_570_n N_noxref_4_c_756_n ) capacitor c=7.28626e-19 \
 //x=8.53 //y=4.705 //x2=8.645 //y2=5.21
cc_436 ( N_noxref_3_c_523_n N_noxref_4_c_798_n ) capacitor c=0.00233055f \
 //x=8.51 //y=2.2 //x2=8.81 //y2=1.355
cc_437 ( N_noxref_3_c_546_n N_noxref_4_c_798_n ) capacitor c=8.15893e-19 \
 //x=8.51 //y=2.08 //x2=8.81 //y2=1.355
cc_438 ( N_noxref_3_c_556_n N_noxref_4_c_798_n ) capacitor c=5.01861e-19 \
 //x=8.545 //y=0.905 //x2=8.81 //y2=1.355
cc_439 ( N_noxref_3_c_559_n N_noxref_4_c_798_n ) capacitor c=0.00397521f \
 //x=8.545 //y=1.255 //x2=8.81 //y2=1.355
cc_440 ( N_noxref_3_c_561_n N_noxref_4_c_798_n ) capacitor c=0.00205332f \
 //x=8.545 //y=1.56 //x2=8.81 //y2=1.355
cc_441 ( N_noxref_3_c_586_p N_noxref_4_c_798_n ) capacitor c=3.72732e-19 \
 //x=8.92 //y=0.75 //x2=8.81 //y2=1.355
cc_442 ( N_noxref_3_c_564_n N_noxref_4_c_798_n ) capacitor c=0.00187911f \
 //x=8.92 //y=1.405 //x2=8.81 //y2=1.355
cc_443 ( N_noxref_3_c_565_n N_noxref_4_c_798_n ) capacitor c=2.0901e-19 \
 //x=9.075 //y=0.905 //x2=8.81 //y2=1.355
cc_444 ( N_noxref_3_c_566_n N_noxref_4_c_798_n ) capacitor c=0.00241403f \
 //x=9.075 //y=1.255 //x2=8.81 //y2=1.355
cc_445 ( N_noxref_3_c_567_n N_noxref_4_c_798_n ) capacitor c=2.48891e-19 \
 //x=8.51 //y=2.08 //x2=8.81 //y2=1.355
cc_446 ( N_noxref_3_c_561_n N_noxref_4_c_808_n ) capacitor c=0.0018678f \
 //x=8.545 //y=1.56 //x2=8.81 //y2=1.56
cc_447 ( N_noxref_3_c_564_n N_noxref_4_c_808_n ) capacitor c=0.00592669f \
 //x=8.92 //y=1.405 //x2=8.81 //y2=1.56
cc_448 ( N_noxref_3_M18_noxref_g N_noxref_4_c_810_n ) capacitor c=0.0116091f \
 //x=8.99 //y=6.025 //x2=9.165 //y2=5.21
cc_449 ( N_noxref_3_c_564_n N_noxref_4_c_811_n ) capacitor c=0.0048413f \
 //x=8.92 //y=1.405 //x2=9.165 //y2=1.645
cc_450 ( N_noxref_3_c_595_p N_noxref_4_c_812_n ) capacitor c=0.00368358f \
 //x=8.51 //y=1.915 //x2=8.895 //y2=1.645
cc_451 ( N_noxref_3_c_523_n N_noxref_4_c_757_n ) capacitor c=0.0146548f \
 //x=8.51 //y=2.2 //x2=9.25 //y2=3.915
cc_452 ( N_noxref_3_c_527_n N_noxref_4_c_757_n ) capacitor c=0.0765587f \
 //x=8.51 //y=3.87 //x2=9.25 //y2=3.915
cc_453 ( N_noxref_3_c_531_n N_noxref_4_c_757_n ) capacitor c=0.0029642f \
 //x=8.51 //y=4.19 //x2=9.25 //y2=3.915
cc_454 ( N_noxref_3_c_538_n N_noxref_4_c_757_n ) capacitor c=0.00136148f \
 //x=8.525 //y=4.03 //x2=9.25 //y2=3.915
cc_455 ( N_noxref_3_c_546_n N_noxref_4_c_757_n ) capacitor c=0.00137695f \
 //x=8.51 //y=2.08 //x2=9.25 //y2=3.915
cc_456 ( N_noxref_3_c_567_n N_noxref_4_c_757_n ) capacitor c=0.00284078f \
 //x=8.51 //y=2.08 //x2=9.25 //y2=3.915
cc_457 ( N_noxref_3_c_595_p N_noxref_4_c_757_n ) capacitor c=0.00356275f \
 //x=8.51 //y=1.915 //x2=9.25 //y2=3.915
cc_458 ( N_noxref_3_c_531_n N_noxref_4_c_820_n ) capacitor c=0.0169977f \
 //x=8.51 //y=4.19 //x2=9.25 //y2=4.235
cc_459 ( N_noxref_3_c_532_n N_noxref_4_c_820_n ) capacitor c=0.00262509f \
 //x=8.51 //y=4.56 //x2=9.25 //y2=4.235
cc_460 ( N_noxref_3_c_537_n N_noxref_4_c_820_n ) capacitor c=8.95907e-19 \
 //x=8.51 //y=4.07 //x2=9.25 //y2=4.235
cc_461 ( N_noxref_3_c_538_n N_noxref_4_c_820_n ) capacitor c=0.00288053f \
 //x=8.525 //y=4.03 //x2=9.25 //y2=4.235
cc_462 ( N_noxref_3_c_532_n N_noxref_4_c_759_n ) capacitor c=0.0305973f \
 //x=8.51 //y=4.56 //x2=9.25 //y2=5.125
cc_463 ( N_noxref_3_c_549_n N_noxref_4_c_759_n ) capacitor c=0.00179503f \
 //x=8.53 //y=4.705 //x2=9.25 //y2=5.125
cc_464 ( N_noxref_3_c_609_p N_noxref_4_c_759_n ) capacitor c=0.00864287f \
 //x=8.915 //y=4.795 //x2=9.25 //y2=5.125
cc_465 ( N_noxref_3_c_570_n N_noxref_4_c_759_n ) capacitor c=0.00141883f \
 //x=8.53 //y=4.705 //x2=9.25 //y2=5.125
cc_466 ( N_noxref_3_c_527_n N_noxref_4_c_828_n ) capacitor c=0.00300359f \
 //x=8.51 //y=3.87 //x2=10.73 //y2=3.915
cc_467 ( N_noxref_3_c_532_n N_noxref_4_c_829_n ) capacitor c=0.00111022f \
 //x=8.51 //y=4.56 //x2=10.73 //y2=4.58
cc_468 ( N_noxref_3_c_504_n N_noxref_4_c_830_n ) capacitor c=3.77121e-19 \
 //x=1.885 //y=0.905 //x2=2.15 //y2=1.18
cc_469 ( N_noxref_3_c_507_n N_noxref_4_c_830_n ) capacitor c=0.00250809f \
 //x=1.885 //y=1.25 //x2=2.15 //y2=1.18
cc_470 ( N_noxref_3_c_509_n N_noxref_4_c_830_n ) capacitor c=0.00152089f \
 //x=1.885 //y=1.56 //x2=2.15 //y2=1.18
cc_471 ( N_noxref_3_c_616_p N_noxref_4_c_830_n ) capacitor c=3.38306e-19 \
 //x=2.26 //y=0.75 //x2=2.15 //y2=1.18
cc_472 ( N_noxref_3_c_617_p N_noxref_4_c_830_n ) capacitor c=0.0022369f \
 //x=2.26 //y=1.405 //x2=2.15 //y2=1.18
cc_473 ( N_noxref_3_c_512_n N_noxref_4_c_830_n ) capacitor c=3.16128e-19 \
 //x=2.415 //y=0.905 //x2=2.15 //y2=1.18
cc_474 ( N_noxref_3_c_513_n N_noxref_4_c_830_n ) capacitor c=0.00792546f \
 //x=2.415 //y=1.25 //x2=2.15 //y2=1.18
cc_475 ( N_noxref_3_c_488_n N_noxref_4_c_767_n ) capacitor c=0.0169094f \
 //x=8.365 //y=4.03 //x2=7.89 //y2=5.21
cc_476 ( N_noxref_3_c_538_n N_noxref_4_c_838_n ) capacitor c=6.25661e-19 \
 //x=8.525 //y=4.03 //x2=8.767 //y2=5.21
cc_477 ( N_noxref_3_M17_noxref_g N_noxref_4_c_838_n ) capacitor c=0.00180711f \
 //x=8.55 //y=6.025 //x2=8.767 //y2=5.21
cc_478 ( N_noxref_3_M18_noxref_g N_noxref_4_c_838_n ) capacitor c=0.0027483f \
 //x=8.99 //y=6.025 //x2=8.767 //y2=5.21
cc_479 ( N_noxref_3_c_609_p N_noxref_4_c_838_n ) capacitor c=0.00216603f \
 //x=8.915 //y=4.795 //x2=8.767 //y2=5.21
cc_480 ( N_noxref_3_c_531_n N_noxref_4_c_842_n ) capacitor c=6.9092e-19 \
 //x=8.51 //y=4.19 //x2=9.25 //y2=4.07
cc_481 ( N_noxref_3_c_537_n N_noxref_4_c_842_n ) capacitor c=0.0102219f \
 //x=8.51 //y=4.07 //x2=9.25 //y2=4.07
cc_482 ( N_noxref_3_c_513_n N_noxref_4_c_752_n ) capacitor c=0.00147665f \
 //x=2.415 //y=1.25 //x2=5.35 //y2=1.225
cc_483 ( N_noxref_3_c_561_n N_noxref_4_c_845_n ) capacitor c=0.00131018f \
 //x=8.545 //y=1.56 //x2=8.805 //y2=1.225
cc_484 ( N_noxref_3_c_564_n N_noxref_4_c_845_n ) capacitor c=0.00184285f \
 //x=8.92 //y=1.405 //x2=8.805 //y2=1.225
cc_485 ( N_noxref_3_c_523_n N_noxref_4_c_771_n ) capacitor c=0.00997796f \
 //x=8.51 //y=2.2 //x2=8.645 //y2=1.225
cc_486 ( N_noxref_3_c_559_n N_noxref_4_c_771_n ) capacitor c=0.00107668f \
 //x=8.545 //y=1.255 //x2=8.645 //y2=1.225
cc_487 ( N_noxref_3_c_561_n N_noxref_4_c_771_n ) capacitor c=8.64037e-19 \
 //x=8.545 //y=1.56 //x2=8.645 //y2=1.225
cc_488 ( N_noxref_3_c_531_n N_noxref_4_c_850_n ) capacitor c=0.0028493f \
 //x=8.51 //y=4.19 //x2=9.41 //y2=4.075
cc_489 ( N_noxref_3_c_532_n N_noxref_4_c_850_n ) capacitor c=0.00114496f \
 //x=8.51 //y=4.56 //x2=9.41 //y2=4.075
cc_490 ( N_noxref_3_c_538_n N_noxref_4_c_850_n ) capacitor c=0.018987f \
 //x=8.525 //y=4.03 //x2=9.41 //y2=4.075
cc_491 ( N_noxref_3_M17_noxref_g N_noxref_4_c_853_n ) capacitor c=0.0141401f \
 //x=8.55 //y=6.025 //x2=8.77 //y2=5.38
cc_492 ( N_noxref_3_M18_noxref_g N_noxref_4_c_853_n ) capacitor c=0.0139971f \
 //x=8.99 //y=6.025 //x2=8.77 //y2=5.38
cc_493 ( N_noxref_3_c_609_p N_noxref_4_c_853_n ) capacitor c=0.00293135f \
 //x=8.915 //y=4.795 //x2=8.77 //y2=5.38
cc_494 ( N_noxref_3_c_504_n N_noxref_4_M1_noxref_d ) capacitor c=0.00218556f \
 //x=1.885 //y=0.905 //x2=1.96 //y2=0.905
cc_495 ( N_noxref_3_c_507_n N_noxref_4_M1_noxref_d ) capacitor c=0.00327871f \
 //x=1.885 //y=1.25 //x2=1.96 //y2=0.905
cc_496 ( N_noxref_3_c_509_n N_noxref_4_M1_noxref_d ) capacitor c=0.00254845f \
 //x=1.885 //y=1.56 //x2=1.96 //y2=0.905
cc_497 ( N_noxref_3_c_616_p N_noxref_4_M1_noxref_d ) capacitor c=0.00235569f \
 //x=2.26 //y=0.75 //x2=1.96 //y2=0.905
cc_498 ( N_noxref_3_c_617_p N_noxref_4_M1_noxref_d ) capacitor c=0.00523156f \
 //x=2.26 //y=1.405 //x2=1.96 //y2=0.905
cc_499 ( N_noxref_3_c_512_n N_noxref_4_M1_noxref_d ) capacitor c=0.00131413f \
 //x=2.415 //y=0.905 //x2=1.96 //y2=0.905
cc_500 ( N_noxref_3_c_513_n N_noxref_4_M1_noxref_d ) capacitor c=0.0065758f \
 //x=2.415 //y=1.25 //x2=1.96 //y2=0.905
cc_501 ( N_noxref_3_c_556_n N_noxref_4_M5_noxref_d ) capacitor c=0.00226395f \
 //x=8.545 //y=0.905 //x2=8.62 //y2=0.905
cc_502 ( N_noxref_3_c_559_n N_noxref_4_M5_noxref_d ) capacitor c=0.004517f \
 //x=8.545 //y=1.255 //x2=8.62 //y2=0.905
cc_503 ( N_noxref_3_c_561_n N_noxref_4_M5_noxref_d ) capacitor c=0.00275912f \
 //x=8.545 //y=1.56 //x2=8.62 //y2=0.905
cc_504 ( N_noxref_3_c_586_p N_noxref_4_M5_noxref_d ) capacitor c=0.00234223f \
 //x=8.92 //y=0.75 //x2=8.62 //y2=0.905
cc_505 ( N_noxref_3_c_564_n N_noxref_4_M5_noxref_d ) capacitor c=0.00707878f \
 //x=8.92 //y=1.405 //x2=8.62 //y2=0.905
cc_506 ( N_noxref_3_c_565_n N_noxref_4_M5_noxref_d ) capacitor c=0.00132831f \
 //x=9.075 //y=0.905 //x2=8.62 //y2=0.905
cc_507 ( N_noxref_3_c_566_n N_noxref_4_M5_noxref_d ) capacitor c=0.00330743f \
 //x=9.075 //y=1.255 //x2=8.62 //y2=0.905
cc_508 ( N_noxref_3_M9_noxref_g N_noxref_5_c_1087_n ) capacitor c=0.00125343f \
 //x=1.89 //y=6.025 //x2=1.67 //y2=6.855
cc_509 ( N_noxref_3_M9_noxref_g N_noxref_5_c_1088_n ) capacitor c=0.00137209f \
 //x=1.89 //y=6.025 //x2=1.67 //y2=7.23
cc_510 ( N_noxref_3_M10_noxref_g N_noxref_5_c_1128_n ) capacitor c=0.00373588f \
 //x=2.33 //y=6.025 //x2=2.55 //y2=6.855
cc_511 ( N_noxref_3_M10_noxref_g N_noxref_5_c_1129_n ) capacitor c=0.00300944f \
 //x=2.33 //y=6.025 //x2=2.55 //y2=7.23
cc_512 ( N_noxref_3_M9_noxref_g N_noxref_5_c_1090_n ) capacitor c=0.00715838f \
 //x=1.89 //y=6.025 //x2=3.16 //y2=7.4
cc_513 ( N_noxref_3_M10_noxref_g N_noxref_5_c_1090_n ) capacitor c=0.00772491f \
 //x=2.33 //y=6.025 //x2=3.16 //y2=7.4
cc_514 ( N_noxref_3_c_474_n N_noxref_5_c_1093_n ) capacitor c=2.16363e-19 \
 //x=1.85 //y=4.53 //x2=0.74 //y2=7.4
cc_515 ( N_noxref_3_c_484_n N_noxref_5_c_1093_n ) capacitor c=9.52781e-19 \
 //x=1.85 //y=4.07 //x2=0.74 //y2=7.4
cc_516 ( N_noxref_3_M17_noxref_g N_noxref_5_c_1116_n ) capacitor c=0.00723513f \
 //x=8.55 //y=6.025 //x2=9.82 //y2=7.4
cc_517 ( N_noxref_3_M18_noxref_g N_noxref_5_c_1116_n ) capacitor c=0.00776897f \
 //x=8.99 //y=6.025 //x2=9.82 //y2=7.4
cc_518 ( N_noxref_3_c_471_n N_noxref_5_c_1101_n ) capacitor c=5.31543e-19 \
 //x=1.85 //y=4.185 //x2=3.33 //y2=7.4
cc_519 ( N_noxref_3_c_474_n N_noxref_5_c_1101_n ) capacitor c=0.00746843f \
 //x=1.85 //y=4.53 //x2=3.33 //y2=7.4
cc_520 ( N_noxref_3_c_484_n N_noxref_5_c_1101_n ) capacitor c=0.00144593f \
 //x=1.85 //y=4.07 //x2=3.33 //y2=7.4
cc_521 ( N_noxref_3_c_488_n N_noxref_5_c_1101_n ) capacitor c=0.00801328f \
 //x=8.365 //y=4.03 //x2=3.33 //y2=7.4
cc_522 ( N_noxref_3_c_497_n N_noxref_5_c_1101_n ) capacitor c=0.00250302f \
 //x=1.89 //y=4.705 //x2=3.33 //y2=7.4
cc_523 ( N_noxref_3_c_668_p N_noxref_5_c_1101_n ) capacitor c=0.0117152f \
 //x=2.255 //y=4.795 //x2=3.33 //y2=7.4
cc_524 ( N_noxref_3_c_517_n N_noxref_5_c_1101_n ) capacitor c=2.76772e-19 \
 //x=1.89 //y=4.705 //x2=3.33 //y2=7.4
cc_525 ( N_noxref_3_c_532_n N_noxref_5_c_1107_n ) capacitor c=5.18027e-19 \
 //x=8.51 //y=4.56 //x2=6.66 //y2=7.4
cc_526 ( N_noxref_3_c_537_n N_noxref_5_c_1107_n ) capacitor c=8.21577e-19 \
 //x=8.51 //y=4.07 //x2=6.66 //y2=7.4
cc_527 ( N_noxref_3_c_488_n N_noxref_5_c_1107_n ) capacitor c=0.0135112f \
 //x=8.365 //y=4.03 //x2=6.66 //y2=7.4
cc_528 ( N_noxref_3_c_549_n N_noxref_5_c_1107_n ) capacitor c=6.64651e-19 \
 //x=8.53 //y=4.705 //x2=6.66 //y2=7.4
cc_529 ( N_noxref_3_c_549_n N_noxref_5_c_1147_n ) capacitor c=0.00237807f \
 //x=8.53 //y=4.705 //x2=9.99 //y2=7.4
cc_530 ( N_noxref_3_c_609_p N_noxref_5_c_1147_n ) capacitor c=0.0170421f \
 //x=8.915 //y=4.795 //x2=9.99 //y2=7.4
cc_531 ( N_noxref_3_c_570_n N_noxref_5_c_1147_n ) capacitor c=2.70151e-19 \
 //x=8.53 //y=4.705 //x2=9.99 //y2=7.4
cc_532 ( N_noxref_3_M9_noxref_g N_noxref_5_M8_noxref_d ) capacitor \
 c=0.0127979f //x=1.89 //y=6.025 //x2=1.525 //y2=5.025
cc_533 ( N_noxref_3_M10_noxref_g N_noxref_5_M10_noxref_d ) capacitor \
 c=0.0463918f //x=2.33 //y=6.025 //x2=2.405 //y2=5.025
cc_534 ( N_noxref_3_c_471_n N_noxref_6_c_1336_n ) capacitor c=0.00150537f \
 //x=1.85 //y=4.185 //x2=1.995 //y2=5.21
cc_535 ( N_noxref_3_c_474_n N_noxref_6_c_1336_n ) capacitor c=0.0211744f \
 //x=1.85 //y=4.53 //x2=1.995 //y2=5.21
cc_536 ( N_noxref_3_c_484_n N_noxref_6_c_1336_n ) capacitor c=3.71828e-19 \
 //x=1.85 //y=4.07 //x2=1.995 //y2=5.21
cc_537 ( N_noxref_3_c_497_n N_noxref_6_c_1336_n ) capacitor c=0.004587f \
 //x=1.89 //y=4.705 //x2=1.995 //y2=5.21
cc_538 ( N_noxref_3_M9_noxref_g N_noxref_6_c_1336_n ) capacitor c=0.00913391f \
 //x=1.89 //y=6.025 //x2=1.995 //y2=5.21
cc_539 ( N_noxref_3_c_517_n N_noxref_6_c_1336_n ) capacitor c=6.87087e-19 \
 //x=1.89 //y=4.705 //x2=1.995 //y2=5.21
cc_540 ( N_noxref_3_M10_noxref_g N_noxref_6_c_1338_n ) capacitor c=0.011434f \
 //x=2.33 //y=6.025 //x2=3.995 //y2=5.21
cc_541 ( N_noxref_3_c_471_n N_noxref_6_c_1341_n ) capacitor c=0.00145195f \
 //x=1.85 //y=4.185 //x2=2.225 //y2=5.21
cc_542 ( N_noxref_3_c_474_n N_noxref_6_c_1341_n ) capacitor c=0.00252287f \
 //x=1.85 //y=4.53 //x2=2.225 //y2=5.21
cc_543 ( N_noxref_3_M9_noxref_g N_noxref_6_c_1341_n ) capacitor c=7.72756e-19 \
 //x=1.89 //y=6.025 //x2=2.225 //y2=5.21
cc_544 ( N_noxref_3_M10_noxref_g N_noxref_6_c_1341_n ) capacitor c=8.30848e-19 \
 //x=2.33 //y=6.025 //x2=2.225 //y2=5.21
cc_545 ( N_noxref_3_c_471_n N_noxref_6_c_1357_n ) capacitor c=0.00167023f \
 //x=1.85 //y=4.185 //x2=2.11 //y2=5.21
cc_546 ( N_noxref_3_M9_noxref_g N_noxref_6_c_1357_n ) capacitor c=0.021802f \
 //x=1.89 //y=6.025 //x2=2.11 //y2=5.21
cc_547 ( N_noxref_3_M10_noxref_g N_noxref_6_c_1357_n ) capacitor c=0.0189969f \
 //x=2.33 //y=6.025 //x2=2.11 //y2=5.21
cc_548 ( N_noxref_3_c_668_p N_noxref_6_c_1357_n ) capacitor c=0.00449628f \
 //x=2.255 //y=4.795 //x2=2.11 //y2=5.21
cc_549 ( N_noxref_3_M9_noxref_g N_noxref_6_M9_noxref_d ) capacitor \
 c=0.00122946f //x=1.89 //y=6.025 //x2=1.965 //y2=5.025
cc_550 ( N_noxref_3_M10_noxref_g N_noxref_6_M9_noxref_d ) capacitor \
 c=0.00123972f //x=2.33 //y=6.025 //x2=1.965 //y2=5.025
cc_551 ( N_noxref_3_c_488_n N_noxref_7_c_1515_n ) capacitor c=0.0620335f \
 //x=8.365 //y=4.03 //x2=7.335 //y2=5.21
cc_552 ( N_noxref_3_c_488_n N_noxref_7_c_1525_n ) capacitor c=0.00869836f \
 //x=8.365 //y=4.03 //x2=5.545 //y2=5.21
cc_553 ( N_noxref_3_M17_noxref_g N_noxref_7_c_1541_n ) capacitor c=0.00793695f \
 //x=8.55 //y=6.025 //x2=9.08 //y2=6.91
cc_554 ( N_noxref_3_M18_noxref_g N_noxref_7_c_1541_n ) capacitor c=0.00937408f \
 //x=8.99 //y=6.025 //x2=9.08 //y2=6.91
cc_555 ( N_noxref_3_c_488_n N_noxref_7_c_1503_n ) capacitor c=0.0270459f \
 //x=8.365 //y=4.03 //x2=4.55 //y2=5.21
cc_556 ( N_noxref_3_c_488_n N_noxref_7_c_1529_n ) capacitor c=0.00166893f \
 //x=8.365 //y=4.03 //x2=5.43 //y2=5.21
cc_557 ( N_noxref_3_M17_noxref_g N_noxref_7_c_1533_n ) capacitor c=0.00177216f \
 //x=8.55 //y=6.025 //x2=8.33 //y2=6.91
cc_558 ( N_noxref_3_M18_noxref_g N_noxref_7_c_1546_n ) capacitor c=0.00422002f \
 //x=8.99 //y=6.025 //x2=9.21 //y2=6.74
cc_559 ( N_noxref_3_c_488_n N_noxref_7_c_1534_n ) capacitor c=2.11035e-19 \
 //x=8.365 //y=4.03 //x2=7.45 //y2=5.21
cc_560 ( N_noxref_3_M17_noxref_g N_noxref_7_M16_noxref_d ) capacitor \
 c=0.0142133f //x=8.55 //y=6.025 //x2=8.185 //y2=5.025
cc_561 ( N_noxref_3_c_570_n N_noxref_7_M16_noxref_d ) capacitor c=6.61209e-19 \
 //x=8.53 //y=4.705 //x2=8.185 //y2=5.025
cc_562 ( N_noxref_3_M18_noxref_g N_noxref_7_M18_noxref_d ) capacitor \
 c=0.0365939f //x=8.99 //y=6.025 //x2=9.065 //y2=5.025
cc_563 ( N_noxref_3_c_464_n N_noxref_8_c_1713_n ) capacitor c=0.00214362f \
 //x=1.85 //y=2.195 //x2=4.425 //y2=0
cc_564 ( N_noxref_3_c_523_n N_noxref_8_c_1714_n ) capacitor c=4.62041e-19 \
 //x=8.51 //y=2.2 //x2=11.47 //y2=0
cc_565 ( N_noxref_3_c_464_n N_noxref_8_c_1657_n ) capacitor c=3.77289e-19 \
 //x=1.85 //y=2.195 //x2=3.16 //y2=0
cc_566 ( N_noxref_3_c_523_n N_noxref_8_c_1693_n ) capacitor c=3.29261e-19 \
 //x=8.51 //y=2.2 //x2=9.82 //y2=0
cc_567 ( N_noxref_3_c_464_n N_noxref_8_c_1665_n ) capacitor c=0.00295886f \
 //x=1.85 //y=2.195 //x2=3.33 //y2=0
cc_568 ( N_noxref_3_c_468_n N_noxref_8_c_1665_n ) capacitor c=0.00617359f \
 //x=1.85 //y=3.865 //x2=3.33 //y2=0
cc_569 ( N_noxref_3_c_488_n N_noxref_8_c_1665_n ) capacitor c=0.00357334f \
 //x=8.365 //y=4.03 //x2=3.33 //y2=0
cc_570 ( N_noxref_3_c_493_n N_noxref_8_c_1665_n ) capacitor c=0.00245228f \
 //x=1.85 //y=2.08 //x2=3.33 //y2=0
cc_571 ( N_noxref_3_c_514_n N_noxref_8_c_1665_n ) capacitor c=2.63786e-19 \
 //x=1.85 //y=2.08 //x2=3.33 //y2=0
cc_572 ( N_noxref_3_c_488_n N_noxref_8_c_1696_n ) capacitor c=0.00254502f \
 //x=8.365 //y=4.03 //x2=6.66 //y2=0
cc_573 ( N_noxref_3_c_546_n N_noxref_8_c_1706_n ) capacitor c=0.00224736f \
 //x=8.51 //y=2.08 //x2=9.99 //y2=0
cc_574 ( N_noxref_3_c_564_n N_noxref_8_c_1706_n ) capacitor c=0.00264662f \
 //x=8.92 //y=1.405 //x2=9.99 //y2=0
cc_575 ( N_noxref_3_c_567_n N_noxref_8_c_1706_n ) capacitor c=2.63786e-19 \
 //x=8.51 //y=2.08 //x2=9.99 //y2=0
cc_576 ( N_noxref_3_c_464_n N_noxref_10_c_1991_n ) capacitor c=7.20375e-19 \
 //x=1.85 //y=2.195 //x2=1.665 //y2=1.495
cc_577 ( N_noxref_3_c_471_n N_noxref_10_c_1991_n ) capacitor c=3.32532e-19 \
 //x=1.85 //y=4.185 //x2=1.665 //y2=1.495
cc_578 ( N_noxref_3_c_509_n N_noxref_10_c_1991_n ) capacitor c=0.00746306f \
 //x=1.885 //y=1.56 //x2=1.665 //y2=1.495
cc_579 ( N_noxref_3_c_514_n N_noxref_10_c_1991_n ) capacitor c=0.00175173f \
 //x=1.85 //y=2.08 //x2=1.665 //y2=1.495
cc_580 ( N_noxref_3_c_464_n N_noxref_10_c_1999_n ) capacitor c=0.00135256f \
 //x=1.85 //y=2.195 //x2=2.55 //y2=0.53
cc_581 ( N_noxref_3_c_493_n N_noxref_10_c_1999_n ) capacitor c=8.82141e-19 \
 //x=1.85 //y=2.08 //x2=2.55 //y2=0.53
cc_582 ( N_noxref_3_c_504_n N_noxref_10_c_1999_n ) capacitor c=0.0200392f \
 //x=1.885 //y=0.905 //x2=2.55 //y2=0.53
cc_583 ( N_noxref_3_c_512_n N_noxref_10_c_1999_n ) capacitor c=0.00825432f \
 //x=2.415 //y=0.905 //x2=2.55 //y2=0.53
cc_584 ( N_noxref_3_c_514_n N_noxref_10_c_1999_n ) capacitor c=2.1838e-19 \
 //x=1.85 //y=2.08 //x2=2.55 //y2=0.53
cc_585 ( N_noxref_3_c_488_n N_noxref_10_M0_noxref_s ) capacitor c=0.00170283f \
 //x=8.365 //y=4.03 //x2=0.56 //y2=0.365
cc_586 ( N_noxref_3_c_504_n N_noxref_10_M0_noxref_s ) capacitor c=0.00746306f \
 //x=1.885 //y=0.905 //x2=0.56 //y2=0.365
cc_587 ( N_noxref_3_c_509_n N_noxref_10_M0_noxref_s ) capacitor c=0.00211573f \
 //x=1.885 //y=1.56 //x2=0.56 //y2=0.365
cc_588 ( N_noxref_3_c_512_n N_noxref_10_M0_noxref_s ) capacitor c=0.014227f \
 //x=2.415 //y=0.905 //x2=0.56 //y2=0.365
cc_589 ( N_noxref_3_c_513_n N_noxref_10_M0_noxref_s ) capacitor c=0.00733269f \
 //x=2.415 //y=1.25 //x2=0.56 //y2=0.365
cc_590 ( N_noxref_3_c_735_p N_noxref_10_M0_noxref_s ) capacitor c=0.00392195f \
 //x=1.85 //y=1.915 //x2=0.56 //y2=0.365
cc_591 ( N_noxref_3_c_488_n N_noxref_12_c_2055_n ) capacitor c=0.00155386f \
 //x=8.365 //y=4.03 //x2=4.025 //y2=1.495
cc_592 ( N_noxref_3_c_488_n N_noxref_12_c_2056_n ) capacitor c=0.00692346f \
 //x=8.365 //y=4.03 //x2=4.91 //y2=1.58
cc_593 ( N_noxref_3_c_488_n N_noxref_12_c_2063_n ) capacitor c=0.00170283f \
 //x=8.365 //y=4.03 //x2=4.995 //y2=1.495
cc_594 ( N_noxref_3_c_488_n N_noxref_13_c_2125_n ) capacitor c=0.00782785f \
 //x=8.365 //y=4.03 //x2=8.24 //y2=1.58
cc_595 ( N_noxref_3_c_523_n N_noxref_13_c_2132_n ) capacitor c=7.26555e-19 \
 //x=8.51 //y=2.2 //x2=8.325 //y2=1.495
cc_596 ( N_noxref_3_c_531_n N_noxref_13_c_2132_n ) capacitor c=9.42734e-19 \
 //x=8.51 //y=4.19 //x2=8.325 //y2=1.495
cc_597 ( N_noxref_3_c_561_n N_noxref_13_c_2132_n ) capacitor c=0.00830822f \
 //x=8.545 //y=1.56 //x2=8.325 //y2=1.495
cc_598 ( N_noxref_3_c_567_n N_noxref_13_c_2132_n ) capacitor c=0.00175172f \
 //x=8.51 //y=2.08 //x2=8.325 //y2=1.495
cc_599 ( N_noxref_3_c_523_n N_noxref_13_c_2141_n ) capacitor c=5.72205e-19 \
 //x=8.51 //y=2.2 //x2=9.21 //y2=0.53
cc_600 ( N_noxref_3_c_546_n N_noxref_13_c_2141_n ) capacitor c=8.37879e-19 \
 //x=8.51 //y=2.08 //x2=9.21 //y2=0.53
cc_601 ( N_noxref_3_c_556_n N_noxref_13_c_2141_n ) capacitor c=0.0202024f \
 //x=8.545 //y=0.905 //x2=9.21 //y2=0.53
cc_602 ( N_noxref_3_c_565_n N_noxref_13_c_2141_n ) capacitor c=0.00825432f \
 //x=9.075 //y=0.905 //x2=9.21 //y2=0.53
cc_603 ( N_noxref_3_c_567_n N_noxref_13_c_2141_n ) capacitor c=2.1838e-19 \
 //x=8.51 //y=2.08 //x2=9.21 //y2=0.53
cc_604 ( N_noxref_3_c_556_n N_noxref_13_M4_noxref_s ) capacitor c=0.00830822f \
 //x=8.545 //y=0.905 //x2=7.22 //y2=0.365
cc_605 ( N_noxref_3_c_564_n N_noxref_13_M4_noxref_s ) capacitor c=0.00271091f \
 //x=8.92 //y=1.405 //x2=7.22 //y2=0.365
cc_606 ( N_noxref_3_c_565_n N_noxref_13_M4_noxref_s ) capacitor c=0.0142835f \
 //x=9.075 //y=0.905 //x2=7.22 //y2=0.365
cc_607 ( N_noxref_4_c_810_n N_noxref_5_c_1152_n ) capacitor c=2.26e-19 \
 //x=9.165 //y=5.21 //x2=11.47 //y2=7.4
cc_608 ( N_noxref_4_c_820_n N_noxref_5_c_1152_n ) capacitor c=4.99297e-19 \
 //x=9.25 //y=4.235 //x2=11.47 //y2=7.4
cc_609 ( N_noxref_4_c_872_p N_noxref_5_c_1152_n ) capacitor c=3.04256e-19 \
 //x=10.73 //y=4.235 //x2=11.47 //y2=7.4
cc_610 ( N_noxref_4_c_829_n N_noxref_5_c_1152_n ) capacitor c=5.72118e-19 \
 //x=10.73 //y=4.58 //x2=11.47 //y2=7.4
cc_611 ( N_noxref_4_c_874_p N_noxref_5_c_1152_n ) capacitor c=3.40875e-19 \
 //x=10.73 //y=4.7 //x2=11.47 //y2=7.4
cc_612 ( N_noxref_4_c_810_n N_noxref_5_c_1116_n ) capacitor c=0.00135422f \
 //x=9.165 //y=5.21 //x2=9.82 //y2=7.4
cc_613 ( N_noxref_4_c_820_n N_noxref_5_c_1116_n ) capacitor c=4.03413e-19 \
 //x=9.25 //y=4.235 //x2=9.82 //y2=7.4
cc_614 ( N_noxref_4_c_781_n N_noxref_5_c_1116_n ) capacitor c=0.0048777f \
 //x=7.89 //y=5.38 //x2=9.82 //y2=7.4
cc_615 ( N_noxref_4_c_853_n N_noxref_5_c_1116_n ) capacitor c=0.00512314f \
 //x=8.77 //y=5.38 //x2=9.82 //y2=7.4
cc_616 ( N_noxref_4_c_829_n N_noxref_5_c_1161_n ) capacitor c=5.4912e-19 \
 //x=10.73 //y=4.58 //x2=11.46 //y2=7.4
cc_617 ( N_noxref_4_M19_noxref_g N_noxref_5_c_1161_n ) capacitor c=0.00748034f \
 //x=10.885 //y=6.02 //x2=11.46 //y2=7.4
cc_618 ( N_noxref_4_M20_noxref_g N_noxref_5_c_1161_n ) capacitor c=0.00749619f \
 //x=11.325 //y=6.02 //x2=11.46 //y2=7.4
cc_619 ( N_noxref_4_c_759_n N_noxref_5_c_1107_n ) capacitor c=0.00128037f \
 //x=9.25 //y=5.125 //x2=6.66 //y2=7.4
cc_620 ( N_noxref_4_c_781_n N_noxref_5_c_1107_n ) capacitor c=0.00535462f \
 //x=7.89 //y=5.38 //x2=6.66 //y2=7.4
cc_621 ( N_noxref_4_c_820_n N_noxref_5_c_1147_n ) capacitor c=0.0019054f \
 //x=9.25 //y=4.235 //x2=9.99 //y2=7.4
cc_622 ( N_noxref_4_c_759_n N_noxref_5_c_1147_n ) capacitor c=0.0249794f \
 //x=9.25 //y=5.125 //x2=9.99 //y2=7.4
cc_623 ( N_noxref_4_c_872_p N_noxref_5_c_1147_n ) capacitor c=0.0019054f \
 //x=10.73 //y=4.235 //x2=9.99 //y2=7.4
cc_624 ( N_noxref_4_c_829_n N_noxref_5_c_1147_n ) capacitor c=0.0128286f \
 //x=10.73 //y=4.58 //x2=9.99 //y2=7.4
cc_625 ( N_noxref_4_c_838_n N_noxref_5_c_1147_n ) capacitor c=0.00265362f \
 //x=8.767 //y=5.21 //x2=9.99 //y2=7.4
cc_626 ( N_noxref_4_c_842_n N_noxref_5_c_1147_n ) capacitor c=0.00486566f \
 //x=9.25 //y=4.07 //x2=9.99 //y2=7.4
cc_627 ( N_noxref_4_c_890_p N_noxref_5_c_1147_n ) capacitor c=0.00486566f \
 //x=10.73 //y=4.07 //x2=9.99 //y2=7.4
cc_628 ( N_noxref_4_c_891_p N_noxref_5_c_1147_n ) capacitor c=0.0183218f \
 //x=10.57 //y=4.075 //x2=9.99 //y2=7.4
cc_629 ( N_noxref_4_c_853_n N_noxref_5_c_1147_n ) capacitor c=0.00899475f \
 //x=8.77 //y=5.38 //x2=9.99 //y2=7.4
cc_630 ( N_noxref_4_c_874_p N_noxref_5_c_1147_n ) capacitor c=0.0079528f \
 //x=10.73 //y=4.7 //x2=9.99 //y2=7.4
cc_631 ( N_noxref_4_M19_noxref_g N_noxref_5_c_1147_n ) capacitor c=0.00873815f \
 //x=10.885 //y=6.02 //x2=9.99 //y2=7.4
cc_632 ( N_noxref_4_c_895_p N_noxref_5_c_1147_n ) capacitor c=0.00799922f \
 //x=10.96 //y=4.79 //x2=9.99 //y2=7.4
cc_633 ( N_noxref_4_c_890_p N_noxref_5_c_1178_n ) capacitor c=0.00143727f \
 //x=10.73 //y=4.07 //x2=11.47 //y2=7.4
cc_634 ( N_noxref_4_c_781_n N_noxref_5_c_1178_n ) capacitor c=2.32853e-19 \
 //x=7.89 //y=5.38 //x2=11.47 //y2=7.4
cc_635 ( N_noxref_4_c_853_n N_noxref_5_c_1178_n ) capacitor c=2.32853e-19 \
 //x=8.77 //y=5.38 //x2=11.47 //y2=7.4
cc_636 ( N_noxref_4_c_874_p N_noxref_5_c_1178_n ) capacitor c=0.00235165f \
 //x=10.73 //y=4.7 //x2=11.47 //y2=7.4
cc_637 ( N_noxref_4_c_900_p N_noxref_5_c_1178_n ) capacitor c=0.0195827f \
 //x=11.25 //y=4.79 //x2=11.47 //y2=7.4
cc_638 ( N_noxref_4_c_895_p N_noxref_5_c_1178_n ) capacitor c=2.63786e-19 \
 //x=10.96 //y=4.79 //x2=11.47 //y2=7.4
cc_639 ( N_noxref_4_c_810_n N_noxref_5_M19_noxref_s ) capacitor c=0.00343522f \
 //x=9.165 //y=5.21 //x2=10.53 //y2=5.02
cc_640 ( N_noxref_4_c_872_p N_noxref_5_M19_noxref_s ) capacitor c=0.00247637f \
 //x=10.73 //y=4.235 //x2=10.53 //y2=5.02
cc_641 ( N_noxref_4_c_829_n N_noxref_5_M19_noxref_s ) capacitor c=0.0208735f \
 //x=10.73 //y=4.58 //x2=10.53 //y2=5.02
cc_642 ( N_noxref_4_c_838_n N_noxref_5_M19_noxref_s ) capacitor c=0.00575207f \
 //x=8.767 //y=5.21 //x2=10.53 //y2=5.02
cc_643 ( N_noxref_4_c_906_p N_noxref_5_M19_noxref_s ) capacitor c=6.60267e-19 \
 //x=10.73 //y=4.075 //x2=10.53 //y2=5.02
cc_644 ( N_noxref_4_c_891_p N_noxref_5_M19_noxref_s ) capacitor c=3.46335e-19 \
 //x=10.57 //y=4.075 //x2=10.53 //y2=5.02
cc_645 ( N_noxref_4_c_874_p N_noxref_5_M19_noxref_s ) capacitor c=0.00986151f \
 //x=10.73 //y=4.7 //x2=10.53 //y2=5.02
cc_646 ( N_noxref_4_M19_noxref_g N_noxref_5_M19_noxref_s ) capacitor \
 c=0.0573441f //x=10.885 //y=6.02 //x2=10.53 //y2=5.02
cc_647 ( N_noxref_4_c_895_p N_noxref_5_M19_noxref_s ) capacitor c=0.0053171f \
 //x=10.96 //y=4.79 //x2=10.53 //y2=5.02
cc_648 ( N_noxref_4_M20_noxref_g N_noxref_5_M20_noxref_d ) capacitor \
 c=0.0572684f //x=11.325 //y=6.02 //x2=11.4 //y2=5.02
cc_649 ( N_noxref_4_c_830_n N_noxref_6_c_1338_n ) capacitor c=2.92364e-19 \
 //x=2.15 //y=1.18 //x2=3.995 //y2=5.21
cc_650 ( N_noxref_4_c_830_n N_noxref_6_c_1341_n ) capacitor c=3.81263e-19 \
 //x=2.15 //y=1.18 //x2=2.225 //y2=5.21
cc_651 ( N_noxref_4_c_759_n N_noxref_7_c_1515_n ) capacitor c=5.76261e-19 \
 //x=9.25 //y=5.125 //x2=7.335 //y2=5.21
cc_652 ( N_noxref_4_c_767_n N_noxref_7_c_1515_n ) capacitor c=0.0327245f \
 //x=7.89 //y=5.21 //x2=7.335 //y2=5.21
cc_653 ( N_noxref_4_c_781_n N_noxref_7_c_1515_n ) capacitor c=0.00238429f \
 //x=7.89 //y=5.38 //x2=7.335 //y2=5.21
cc_654 ( N_noxref_4_c_760_n N_noxref_7_c_1525_n ) capacitor c=7.85501e-19 \
 //x=5.48 //y=1.18 //x2=5.545 //y2=5.21
cc_655 ( N_noxref_4_c_756_n N_noxref_7_c_1527_n ) capacitor c=0.00311493f \
 //x=8.645 //y=5.21 //x2=8.215 //y2=6.91
cc_656 ( N_noxref_4_c_767_n N_noxref_7_c_1527_n ) capacitor c=0.00538798f \
 //x=7.89 //y=5.21 //x2=8.215 //y2=6.91
cc_657 ( N_noxref_4_c_781_n N_noxref_7_c_1527_n ) capacitor c=0.00406191f \
 //x=7.89 //y=5.38 //x2=8.215 //y2=6.91
cc_658 ( N_noxref_4_c_756_n N_noxref_7_c_1541_n ) capacitor c=0.00305195f \
 //x=8.645 //y=5.21 //x2=9.08 //y2=6.91
cc_659 ( N_noxref_4_c_810_n N_noxref_7_c_1541_n ) capacitor c=0.00291085f \
 //x=9.165 //y=5.21 //x2=9.08 //y2=6.91
cc_660 ( N_noxref_4_c_838_n N_noxref_7_c_1541_n ) capacitor c=0.00559082f \
 //x=8.767 //y=5.21 //x2=9.08 //y2=6.91
cc_661 ( N_noxref_4_c_853_n N_noxref_7_c_1541_n ) capacitor c=0.00396177f \
 //x=8.77 //y=5.38 //x2=9.08 //y2=6.91
cc_662 ( N_noxref_4_c_767_n N_noxref_7_c_1503_n ) capacitor c=0.00240034f \
 //x=7.89 //y=5.21 //x2=4.55 //y2=5.21
cc_663 ( N_noxref_4_c_756_n N_noxref_7_c_1533_n ) capacitor c=0.00459659f \
 //x=8.645 //y=5.21 //x2=8.33 //y2=6.91
cc_664 ( N_noxref_4_c_810_n N_noxref_7_c_1546_n ) capacitor c=0.00536247f \
 //x=9.165 //y=5.21 //x2=9.21 //y2=6.74
cc_665 ( N_noxref_4_c_759_n N_noxref_7_c_1534_n ) capacitor c=5.23099e-19 \
 //x=9.25 //y=5.125 //x2=7.45 //y2=5.21
cc_666 ( N_noxref_4_c_767_n N_noxref_7_c_1534_n ) capacitor c=0.010446f \
 //x=7.89 //y=5.21 //x2=7.45 //y2=5.21
cc_667 ( N_noxref_4_c_781_n N_noxref_7_c_1534_n ) capacitor c=0.0649815f \
 //x=7.89 //y=5.38 //x2=7.45 //y2=5.21
cc_668 ( N_noxref_4_c_756_n N_noxref_7_M16_noxref_d ) capacitor c=0.00678641f \
 //x=8.645 //y=5.21 //x2=8.185 //y2=5.025
cc_669 ( N_noxref_4_c_838_n N_noxref_7_M16_noxref_d ) capacitor c=0.00184359f \
 //x=8.767 //y=5.21 //x2=8.185 //y2=5.025
cc_670 ( N_noxref_4_c_781_n N_noxref_7_M16_noxref_d ) capacitor c=0.0476949f \
 //x=7.89 //y=5.38 //x2=8.185 //y2=5.025
cc_671 ( N_noxref_4_c_853_n N_noxref_7_M16_noxref_d ) capacitor c=0.0473507f \
 //x=8.77 //y=5.38 //x2=8.185 //y2=5.025
cc_672 ( N_noxref_4_c_810_n N_noxref_7_M18_noxref_d ) capacitor c=0.00735506f \
 //x=9.165 //y=5.21 //x2=9.065 //y2=5.025
cc_673 ( N_noxref_4_c_838_n N_noxref_7_M18_noxref_d ) capacitor c=0.0012641f \
 //x=8.767 //y=5.21 //x2=9.065 //y2=5.025
cc_674 ( N_noxref_4_c_842_n N_noxref_7_M18_noxref_d ) capacitor c=0.00165396f \
 //x=9.25 //y=4.07 //x2=9.065 //y2=5.025
cc_675 ( N_noxref_4_c_853_n N_noxref_7_M18_noxref_d ) capacitor c=0.0473507f \
 //x=8.77 //y=5.38 //x2=9.065 //y2=5.025
cc_676 ( N_noxref_4_c_830_n N_noxref_8_c_1641_n ) capacitor c=0.00185513f \
 //x=2.15 //y=1.18 //x2=1.18 //y2=0.835
cc_677 ( N_noxref_4_c_940_p N_noxref_8_c_1641_n ) capacitor c=7.42708e-19 \
 //x=2.315 //y=1.225 //x2=1.18 //y2=0.835
cc_678 ( N_noxref_4_M1_noxref_d N_noxref_8_c_1641_n ) capacitor c=2.62581e-19 \
 //x=1.96 //y=0.905 //x2=1.18 //y2=0.835
cc_679 ( N_noxref_4_c_830_n N_noxref_8_c_1713_n ) capacitor c=0.00560202f \
 //x=2.15 //y=1.18 //x2=4.425 //y2=0
cc_680 ( N_noxref_4_c_940_p N_noxref_8_c_1713_n ) capacitor c=0.0070205f \
 //x=2.315 //y=1.225 //x2=4.425 //y2=0
cc_681 ( N_noxref_4_c_752_n N_noxref_8_c_1713_n ) capacitor c=0.113148f \
 //x=5.35 //y=1.225 //x2=4.425 //y2=0
cc_682 ( N_noxref_4_M1_noxref_d N_noxref_8_c_1713_n ) capacitor c=2.00936e-19 \
 //x=1.96 //y=0.905 //x2=4.425 //y2=0
cc_683 ( N_noxref_4_c_830_n N_noxref_8_c_1648_n ) capacitor c=3.05541e-19 \
 //x=2.15 //y=1.18 //x2=4.51 //y2=0.835
cc_684 ( N_noxref_4_c_760_n N_noxref_8_c_1648_n ) capacitor c=0.00263562f \
 //x=5.48 //y=1.18 //x2=4.51 //y2=0.835
cc_685 ( N_noxref_4_c_940_p N_noxref_8_c_1648_n ) capacitor c=4.33523e-19 \
 //x=2.315 //y=1.225 //x2=4.51 //y2=0.835
cc_686 ( N_noxref_4_c_752_n N_noxref_8_c_1648_n ) capacitor c=0.0203963f \
 //x=5.35 //y=1.225 //x2=4.51 //y2=0.835
cc_687 ( N_noxref_4_M3_noxref_d N_noxref_8_c_1648_n ) capacitor c=2.62581e-19 \
 //x=5.29 //y=0.905 //x2=4.51 //y2=0.835
cc_688 ( N_noxref_4_c_760_n N_noxref_8_c_1682_n ) capacitor c=0.00847114f \
 //x=5.48 //y=1.18 //x2=7.755 //y2=0
cc_689 ( N_noxref_4_c_752_n N_noxref_8_c_1682_n ) capacitor c=0.0330873f \
 //x=5.35 //y=1.225 //x2=7.755 //y2=0
cc_690 ( N_noxref_4_c_953_p N_noxref_8_c_1682_n ) capacitor c=0.00561635f \
 //x=5.61 //y=1.225 //x2=7.755 //y2=0
cc_691 ( N_noxref_4_c_771_n N_noxref_8_c_1682_n ) capacitor c=0.105591f \
 //x=8.645 //y=1.225 //x2=7.755 //y2=0
cc_692 ( N_noxref_4_M3_noxref_d N_noxref_8_c_1682_n ) capacitor c=2.00936e-19 \
 //x=5.29 //y=0.905 //x2=7.755 //y2=0
cc_693 ( N_noxref_4_c_798_n N_noxref_8_c_1685_n ) capacitor c=0.00195467f \
 //x=8.81 //y=1.355 //x2=7.84 //y2=0.84
cc_694 ( N_noxref_4_c_760_n N_noxref_8_c_1685_n ) capacitor c=8.32974e-19 \
 //x=5.48 //y=1.18 //x2=7.84 //y2=0.84
cc_695 ( N_noxref_4_c_767_n N_noxref_8_c_1685_n ) capacitor c=9.01285e-19 \
 //x=7.89 //y=5.21 //x2=7.84 //y2=0.84
cc_696 ( N_noxref_4_c_845_n N_noxref_8_c_1685_n ) capacitor c=8.08914e-19 \
 //x=8.805 //y=1.225 //x2=7.84 //y2=0.84
cc_697 ( N_noxref_4_c_771_n N_noxref_8_c_1685_n ) capacitor c=0.0204798f \
 //x=8.645 //y=1.225 //x2=7.84 //y2=0.84
cc_698 ( N_noxref_4_M5_noxref_d N_noxref_8_c_1685_n ) capacitor c=2.62581e-19 \
 //x=8.62 //y=0.905 //x2=7.84 //y2=0.84
cc_699 ( N_noxref_4_c_798_n N_noxref_8_c_1714_n ) capacitor c=0.00523793f \
 //x=8.81 //y=1.355 //x2=11.47 //y2=0
cc_700 ( N_noxref_4_c_811_n N_noxref_8_c_1714_n ) capacitor c=0.00622931f \
 //x=9.165 //y=1.645 //x2=11.47 //y2=0
cc_701 ( N_noxref_4_c_820_n N_noxref_8_c_1714_n ) capacitor c=3.81275e-19 \
 //x=9.25 //y=4.235 //x2=11.47 //y2=0
cc_702 ( N_noxref_4_c_872_p N_noxref_8_c_1714_n ) capacitor c=3.80171e-19 \
 //x=10.73 //y=4.235 //x2=11.47 //y2=0
cc_703 ( N_noxref_4_c_966_p N_noxref_8_c_1714_n ) capacitor c=0.00248634f \
 //x=10.73 //y=2.085 //x2=11.47 //y2=0
cc_704 ( N_noxref_4_c_845_n N_noxref_8_c_1714_n ) capacitor c=0.00777614f \
 //x=8.805 //y=1.225 //x2=11.47 //y2=0
cc_705 ( N_noxref_4_c_771_n N_noxref_8_c_1714_n ) capacitor c=0.0382113f \
 //x=8.645 //y=1.225 //x2=11.47 //y2=0
cc_706 ( N_noxref_4_c_969_p N_noxref_8_c_1714_n ) capacitor c=7.53892e-19 \
 //x=10.73 //y=2.085 //x2=11.47 //y2=0
cc_707 ( N_noxref_4_M5_noxref_d N_noxref_8_c_1714_n ) capacitor c=2.00936e-19 \
 //x=8.62 //y=0.905 //x2=11.47 //y2=0
cc_708 ( N_noxref_4_c_811_n N_noxref_8_c_1693_n ) capacitor c=7.45707e-19 \
 //x=9.165 //y=1.645 //x2=9.82 //y2=0
cc_709 ( N_noxref_4_c_966_p N_noxref_8_c_1759_n ) capacitor c=0.00114179f \
 //x=10.73 //y=2.085 //x2=11.015 //y2=0.535
cc_710 ( N_noxref_4_c_969_p N_noxref_8_c_1759_n ) capacitor c=3.95714e-19 \
 //x=10.73 //y=2.085 //x2=11.015 //y2=0.535
cc_711 ( N_noxref_4_c_974_p N_noxref_8_c_1759_n ) capacitor c=0.0125519f \
 //x=10.84 //y=0.91 //x2=11.015 //y2=0.535
cc_712 ( N_noxref_4_c_975_p N_noxref_8_c_1759_n ) capacitor c=2.1838e-19 \
 //x=10.73 //y=2.085 //x2=11.015 //y2=0.535
cc_713 ( N_noxref_4_c_976_p N_noxref_8_c_1763_n ) capacitor c=0.0134259f \
 //x=11.37 //y=0.91 //x2=11.505 //y2=0.535
cc_714 ( N_noxref_4_c_752_n N_noxref_8_c_1665_n ) capacitor c=0.0248964f \
 //x=5.35 //y=1.225 //x2=3.33 //y2=0
cc_715 ( N_noxref_4_M1_noxref_d N_noxref_8_c_1665_n ) capacitor c=0.00128657f \
 //x=1.96 //y=0.905 //x2=3.33 //y2=0
cc_716 ( N_noxref_4_c_757_n N_noxref_8_c_1696_n ) capacitor c=0.00135353f \
 //x=9.25 //y=3.915 //x2=6.66 //y2=0
cc_717 ( N_noxref_4_c_771_n N_noxref_8_c_1696_n ) capacitor c=0.0183315f \
 //x=8.645 //y=1.225 //x2=6.66 //y2=0
cc_718 ( N_noxref_4_M3_noxref_d N_noxref_8_c_1696_n ) capacitor c=0.00129152f \
 //x=5.29 //y=0.905 //x2=6.66 //y2=0
cc_719 ( N_noxref_4_c_808_n N_noxref_8_c_1706_n ) capacitor c=0.00248396f \
 //x=8.81 //y=1.56 //x2=9.99 //y2=0
cc_720 ( N_noxref_4_c_811_n N_noxref_8_c_1706_n ) capacitor c=0.0274191f \
 //x=9.165 //y=1.645 //x2=9.99 //y2=0
cc_721 ( N_noxref_4_c_828_n N_noxref_8_c_1706_n ) capacitor c=0.0103129f \
 //x=10.73 //y=3.915 //x2=9.99 //y2=0
cc_722 ( N_noxref_4_c_966_p N_noxref_8_c_1706_n ) capacitor c=0.00682461f \
 //x=10.73 //y=2.085 //x2=9.99 //y2=0
cc_723 ( N_noxref_4_c_891_p N_noxref_8_c_1706_n ) capacitor c=0.00353812f \
 //x=10.57 //y=4.075 //x2=9.99 //y2=0
cc_724 ( N_noxref_4_c_969_p N_noxref_8_c_1706_n ) capacitor c=0.00733236f \
 //x=10.73 //y=2.085 //x2=9.99 //y2=0
cc_725 ( N_noxref_4_c_988_p N_noxref_8_c_1706_n ) capacitor c=0.00427116f \
 //x=10.84 //y=1.92 //x2=9.99 //y2=0
cc_726 ( N_noxref_4_c_975_p N_noxref_8_c_1706_n ) capacitor c=0.00786308f \
 //x=10.73 //y=2.085 //x2=9.99 //y2=0
cc_727 ( N_noxref_4_M5_noxref_d N_noxref_8_c_1706_n ) capacitor c=0.00165161f \
 //x=8.62 //y=0.905 //x2=9.99 //y2=0
cc_728 ( N_noxref_4_c_798_n N_noxref_8_c_1778_n ) capacitor c=3.45583e-19 \
 //x=8.81 //y=1.355 //x2=11.59 //y2=0
cc_729 ( N_noxref_4_c_760_n N_noxref_8_c_1778_n ) capacitor c=3.45583e-19 \
 //x=5.48 //y=1.18 //x2=11.59 //y2=0
cc_730 ( N_noxref_4_c_969_p N_noxref_8_c_1778_n ) capacitor c=0.0022444f \
 //x=10.73 //y=2.085 //x2=11.59 //y2=0
cc_731 ( N_noxref_4_c_975_p N_noxref_8_c_1778_n ) capacitor c=2.63786e-19 \
 //x=10.73 //y=2.085 //x2=11.59 //y2=0
cc_732 ( N_noxref_4_c_872_p N_noxref_8_M6_noxref_s ) capacitor c=4.66299e-19 \
 //x=10.73 //y=4.235 //x2=10.485 //y2=0.37
cc_733 ( N_noxref_4_c_966_p N_noxref_8_M6_noxref_s ) capacitor c=0.00297844f \
 //x=10.73 //y=2.085 //x2=10.485 //y2=0.37
cc_734 ( N_noxref_4_c_969_p N_noxref_8_M6_noxref_s ) capacitor c=0.00651272f \
 //x=10.73 //y=2.085 //x2=10.485 //y2=0.37
cc_735 ( N_noxref_4_c_974_p N_noxref_8_M6_noxref_s ) capacitor c=0.0301091f \
 //x=10.84 //y=0.91 //x2=10.485 //y2=0.37
cc_736 ( N_noxref_4_c_999_p N_noxref_8_M6_noxref_s ) capacitor c=0.002132f \
 //x=10.84 //y=1.565 //x2=10.485 //y2=0.37
cc_737 ( N_noxref_4_c_988_p N_noxref_8_M6_noxref_s ) capacitor c=0.00304786f \
 //x=10.84 //y=1.92 //x2=10.485 //y2=0.37
cc_738 ( N_noxref_4_c_1001_p N_noxref_8_M6_noxref_s ) capacitor c=0.00517157f \
 //x=11.215 //y=0.755 //x2=10.485 //y2=0.37
cc_739 ( N_noxref_4_c_976_p N_noxref_8_M6_noxref_s ) capacitor c=0.0153553f \
 //x=11.37 //y=0.91 //x2=10.485 //y2=0.37
cc_740 ( N_noxref_4_c_1003_p N_noxref_8_M6_noxref_s ) capacitor c=0.00629878f \
 //x=11.37 //y=1.255 //x2=10.485 //y2=0.37
cc_741 ( N_noxref_4_c_975_p N_noxref_8_M6_noxref_s ) capacitor c=0.00660494f \
 //x=10.73 //y=2.085 //x2=10.485 //y2=0.37
cc_742 ( N_noxref_4_c_798_n N_noxref_9_c_1897_n ) capacitor c=0.00149649f \
 //x=8.81 //y=1.355 //x2=11.1 //y2=1.755
cc_743 ( N_noxref_4_c_808_n N_noxref_9_c_1897_n ) capacitor c=0.00189939f \
 //x=8.81 //y=1.56 //x2=11.1 //y2=1.755
cc_744 ( N_noxref_4_c_811_n N_noxref_9_c_1897_n ) capacitor c=0.00329389f \
 //x=9.165 //y=1.645 //x2=11.1 //y2=1.755
cc_745 ( N_noxref_4_c_845_n N_noxref_9_c_1897_n ) capacitor c=0.00587899f \
 //x=8.805 //y=1.225 //x2=11.1 //y2=1.755
cc_746 ( N_noxref_4_c_1009_p N_noxref_9_c_1897_n ) capacitor c=0.0010801f \
 //x=10.84 //y=1.255 //x2=11.1 //y2=1.755
cc_747 ( N_noxref_4_c_999_p N_noxref_9_c_1897_n ) capacitor c=0.00523499f \
 //x=10.84 //y=1.565 //x2=11.1 //y2=1.755
cc_748 ( N_noxref_4_c_988_p N_noxref_9_c_1897_n ) capacitor c=0.00376062f \
 //x=10.84 //y=1.92 //x2=11.1 //y2=1.755
cc_749 ( N_noxref_4_c_1012_p N_noxref_9_c_1897_n ) capacitor c=0.00934105f \
 //x=11.215 //y=1.41 //x2=11.1 //y2=1.755
cc_750 ( N_noxref_4_c_1003_p N_noxref_9_c_1897_n ) capacitor c=0.00362207f \
 //x=11.37 //y=1.255 //x2=11.1 //y2=1.755
cc_751 ( N_noxref_4_c_810_n N_noxref_9_c_1906_n ) capacitor c=0.00315048f \
 //x=9.165 //y=5.21 //x2=11.105 //y2=5.24
cc_752 ( N_noxref_4_c_838_n N_noxref_9_c_1906_n ) capacitor c=5.82161e-19 \
 //x=8.767 //y=5.21 //x2=11.105 //y2=5.24
cc_753 ( N_noxref_4_M19_noxref_g N_noxref_9_c_1906_n ) capacitor c=0.00141266f \
 //x=10.885 //y=6.02 //x2=11.105 //y2=5.24
cc_754 ( N_noxref_4_M20_noxref_g N_noxref_9_c_1906_n ) capacitor c=0.00377331f \
 //x=11.325 //y=6.02 //x2=11.105 //y2=5.24
cc_755 ( N_noxref_4_c_1012_p N_noxref_9_c_1910_n ) capacitor c=0.00180253f \
 //x=11.215 //y=1.41 //x2=11.385 //y2=1.84
cc_756 ( N_noxref_4_c_757_n N_noxref_9_c_1911_n ) capacitor c=0.00329389f \
 //x=9.25 //y=3.915 //x2=11.185 //y2=1.84
cc_757 ( N_noxref_4_c_975_p N_noxref_9_c_1911_n ) capacitor c=0.00376062f \
 //x=10.73 //y=2.085 //x2=11.185 //y2=1.84
cc_758 ( N_noxref_4_M20_noxref_g N_noxref_9_c_1913_n ) capacitor c=0.00966342f \
 //x=11.325 //y=6.02 //x2=11.385 //y2=4.96
cc_759 ( N_noxref_4_c_759_n N_noxref_9_c_1914_n ) capacitor c=0.00293539f \
 //x=9.25 //y=5.125 //x2=11.19 //y2=4.96
cc_760 ( N_noxref_4_M19_noxref_g N_noxref_9_c_1914_n ) capacitor c=0.00427521f \
 //x=10.885 //y=6.02 //x2=11.19 //y2=4.96
cc_761 ( N_noxref_4_c_900_p N_noxref_9_c_1914_n ) capacitor c=0.00262283f \
 //x=11.25 //y=4.79 //x2=11.19 //y2=4.96
cc_762 ( N_noxref_4_c_757_n N_noxref_9_c_1917_n ) capacitor c=0.00353207f \
 //x=9.25 //y=3.915 //x2=11.47 //y2=4.875
cc_763 ( N_noxref_4_c_759_n N_noxref_9_c_1917_n ) capacitor c=0.00159336f \
 //x=9.25 //y=5.125 //x2=11.47 //y2=4.875
cc_764 ( N_noxref_4_c_828_n N_noxref_9_c_1917_n ) capacitor c=0.078466f \
 //x=10.73 //y=3.915 //x2=11.47 //y2=4.875
cc_765 ( N_noxref_4_c_872_p N_noxref_9_c_1917_n ) capacitor c=0.0149195f \
 //x=10.73 //y=4.235 //x2=11.47 //y2=4.875
cc_766 ( N_noxref_4_c_829_n N_noxref_9_c_1917_n ) capacitor c=0.0217291f \
 //x=10.73 //y=4.58 //x2=11.47 //y2=4.875
cc_767 ( N_noxref_4_c_890_p N_noxref_9_c_1917_n ) capacitor c=0.00459089f \
 //x=10.73 //y=4.07 //x2=11.47 //y2=4.875
cc_768 ( N_noxref_4_c_966_p N_noxref_9_c_1917_n ) capacitor c=0.00825076f \
 //x=10.73 //y=2.085 //x2=11.47 //y2=4.875
cc_769 ( N_noxref_4_c_906_p N_noxref_9_c_1917_n ) capacitor c=0.00699818f \
 //x=10.73 //y=4.075 //x2=11.47 //y2=4.875
cc_770 ( N_noxref_4_c_969_p N_noxref_9_c_1917_n ) capacitor c=0.0023016f \
 //x=10.73 //y=2.085 //x2=11.47 //y2=4.875
cc_771 ( N_noxref_4_c_874_p N_noxref_9_c_1917_n ) capacitor c=0.00250262f \
 //x=10.73 //y=4.7 //x2=11.47 //y2=4.875
cc_772 ( N_noxref_4_c_900_p N_noxref_9_c_1917_n ) capacitor c=4.08297e-19 \
 //x=11.25 //y=4.79 //x2=11.47 //y2=4.875
cc_773 ( N_noxref_4_c_895_p N_noxref_9_c_1917_n ) capacitor c=0.00124564f \
 //x=10.96 //y=4.79 //x2=11.47 //y2=4.875
cc_774 ( N_noxref_4_c_975_p N_noxref_9_c_1917_n ) capacitor c=0.00112403f \
 //x=10.73 //y=2.085 //x2=11.47 //y2=4.875
cc_775 ( N_noxref_4_c_798_n N_noxref_9_c_1930_n ) capacitor c=0.00142298f \
 //x=8.81 //y=1.355 //x2=11.1 //y2=1.005
cc_776 ( N_noxref_4_c_845_n N_noxref_9_c_1930_n ) capacitor c=0.00109769f \
 //x=8.805 //y=1.225 //x2=11.1 //y2=1.005
cc_777 ( N_noxref_4_c_974_p N_noxref_9_c_1930_n ) capacitor c=0.0018223f \
 //x=10.84 //y=0.91 //x2=11.1 //y2=1.005
cc_778 ( N_noxref_4_c_1009_p N_noxref_9_c_1930_n ) capacitor c=0.00375161f \
 //x=10.84 //y=1.255 //x2=11.1 //y2=1.005
cc_779 ( N_noxref_4_c_1001_p N_noxref_9_c_1930_n ) capacitor c=5.57924e-19 \
 //x=11.215 //y=0.755 //x2=11.1 //y2=1.005
cc_780 ( N_noxref_4_c_1012_p N_noxref_9_c_1930_n ) capacitor c=5.75878e-19 \
 //x=11.215 //y=1.41 //x2=11.1 //y2=1.005
cc_781 ( N_noxref_4_c_976_p N_noxref_9_c_1930_n ) capacitor c=0.00160969f \
 //x=11.37 //y=0.91 //x2=11.1 //y2=1.005
cc_782 ( N_noxref_4_c_1003_p N_noxref_9_c_1930_n ) capacitor c=0.00411132f \
 //x=11.37 //y=1.255 //x2=11.1 //y2=1.005
cc_783 ( N_noxref_4_M19_noxref_g N_noxref_9_c_1938_n ) capacitor c=0.0162066f \
 //x=10.885 //y=6.02 //x2=11.105 //y2=5.38
cc_784 ( N_noxref_4_M20_noxref_g N_noxref_9_c_1938_n ) capacitor c=0.0162066f \
 //x=11.325 //y=6.02 //x2=11.105 //y2=5.38
cc_785 ( N_noxref_4_c_900_p N_noxref_9_c_1938_n ) capacitor c=0.00290963f \
 //x=11.25 //y=4.79 //x2=11.105 //y2=5.38
cc_786 ( N_noxref_4_c_974_p N_noxref_9_M6_noxref_d ) capacitor c=0.00137914f \
 //x=10.84 //y=0.91 //x2=10.915 //y2=0.91
cc_787 ( N_noxref_4_c_1009_p N_noxref_9_M6_noxref_d ) capacitor c=0.0023891f \
 //x=10.84 //y=1.255 //x2=10.915 //y2=0.91
cc_788 ( N_noxref_4_c_1001_p N_noxref_9_M6_noxref_d ) capacitor c=0.0020782f \
 //x=11.215 //y=0.755 //x2=10.915 //y2=0.91
cc_789 ( N_noxref_4_c_1012_p N_noxref_9_M6_noxref_d ) capacitor c=0.00356097f \
 //x=11.215 //y=1.41 //x2=10.915 //y2=0.91
cc_790 ( N_noxref_4_c_976_p N_noxref_9_M6_noxref_d ) capacitor c=0.00138452f \
 //x=11.37 //y=0.91 //x2=10.915 //y2=0.91
cc_791 ( N_noxref_4_c_1003_p N_noxref_9_M6_noxref_d ) capacitor c=0.00235934f \
 //x=11.37 //y=1.255 //x2=10.915 //y2=0.91
cc_792 ( N_noxref_4_c_830_n N_noxref_10_c_1999_n ) capacitor c=0.00587436f \
 //x=2.15 //y=1.18 //x2=2.55 //y2=0.53
cc_793 ( N_noxref_4_c_752_n N_noxref_10_c_1999_n ) capacitor c=0.00185906f \
 //x=5.35 //y=1.225 //x2=2.55 //y2=0.53
cc_794 ( N_noxref_4_M1_noxref_d N_noxref_10_c_1999_n ) capacitor c=0.0136817f \
 //x=1.96 //y=0.905 //x2=2.55 //y2=0.53
cc_795 ( N_noxref_4_c_830_n N_noxref_10_M0_noxref_s ) capacitor c=0.0131763f \
 //x=2.15 //y=1.18 //x2=0.56 //y2=0.365
cc_796 ( N_noxref_4_c_752_n N_noxref_10_M0_noxref_s ) capacitor c=0.0123961f \
 //x=5.35 //y=1.225 //x2=0.56 //y2=0.365
cc_797 ( N_noxref_4_M1_noxref_d N_noxref_10_M0_noxref_s ) capacitor \
 c=0.0446285f //x=1.96 //y=0.905 //x2=0.56 //y2=0.365
cc_798 ( N_noxref_4_c_752_n N_noxref_12_c_2056_n ) capacitor c=0.0151405f \
 //x=5.35 //y=1.225 //x2=4.91 //y2=1.58
cc_799 ( N_noxref_4_c_760_n N_noxref_12_c_2068_n ) capacitor c=0.0057298f \
 //x=5.48 //y=1.18 //x2=5.88 //y2=0.53
cc_800 ( N_noxref_4_c_752_n N_noxref_12_c_2068_n ) capacitor c=0.00185906f \
 //x=5.35 //y=1.225 //x2=5.88 //y2=0.53
cc_801 ( N_noxref_4_c_771_n N_noxref_12_c_2068_n ) capacitor c=0.00454743f \
 //x=8.645 //y=1.225 //x2=5.88 //y2=0.53
cc_802 ( N_noxref_4_M3_noxref_d N_noxref_12_c_2068_n ) capacitor c=0.0130616f \
 //x=5.29 //y=0.905 //x2=5.88 //y2=0.53
cc_803 ( N_noxref_4_c_760_n N_noxref_12_M2_noxref_s ) capacitor c=0.0103808f \
 //x=5.48 //y=1.18 //x2=3.89 //y2=0.365
cc_804 ( N_noxref_4_c_752_n N_noxref_12_M2_noxref_s ) capacitor c=0.0271564f \
 //x=5.35 //y=1.225 //x2=3.89 //y2=0.365
cc_805 ( N_noxref_4_c_771_n N_noxref_12_M2_noxref_s ) capacitor c=0.00742061f \
 //x=8.645 //y=1.225 //x2=3.89 //y2=0.365
cc_806 ( N_noxref_4_M3_noxref_d N_noxref_12_M2_noxref_s ) capacitor \
 c=0.0441243f //x=5.29 //y=0.905 //x2=3.89 //y2=0.365
cc_807 ( N_noxref_4_c_771_n N_noxref_13_c_2125_n ) capacitor c=0.0135245f \
 //x=8.645 //y=1.225 //x2=8.24 //y2=1.58
cc_808 ( N_noxref_4_c_812_n N_noxref_13_c_2132_n ) capacitor c=0.00714695f \
 //x=8.895 //y=1.645 //x2=8.325 //y2=1.495
cc_809 ( N_noxref_4_c_757_n N_noxref_13_c_2132_n ) capacitor c=2.92748e-19 \
 //x=9.25 //y=3.915 //x2=8.325 //y2=1.495
cc_810 ( N_noxref_4_c_798_n N_noxref_13_c_2141_n ) capacitor c=0.00515582f \
 //x=8.81 //y=1.355 //x2=9.21 //y2=0.53
cc_811 ( N_noxref_4_c_811_n N_noxref_13_c_2141_n ) capacitor c=0.00332518f \
 //x=9.165 //y=1.645 //x2=9.21 //y2=0.53
cc_812 ( N_noxref_4_c_845_n N_noxref_13_c_2141_n ) capacitor c=0.00224828f \
 //x=8.805 //y=1.225 //x2=9.21 //y2=0.53
cc_813 ( N_noxref_4_c_771_n N_noxref_13_c_2141_n ) capacitor c=0.00185838f \
 //x=8.645 //y=1.225 //x2=9.21 //y2=0.53
cc_814 ( N_noxref_4_M5_noxref_d N_noxref_13_c_2141_n ) capacitor c=0.0135038f \
 //x=8.62 //y=0.905 //x2=9.21 //y2=0.53
cc_815 ( N_noxref_4_c_798_n N_noxref_13_M4_noxref_s ) capacitor c=0.010254f \
 //x=8.81 //y=1.355 //x2=7.22 //y2=0.365
cc_816 ( N_noxref_4_c_808_n N_noxref_13_M4_noxref_s ) capacitor c=0.00775201f \
 //x=8.81 //y=1.56 //x2=7.22 //y2=0.365
cc_817 ( N_noxref_4_c_811_n N_noxref_13_M4_noxref_s ) capacitor c=0.00706721f \
 //x=9.165 //y=1.645 //x2=7.22 //y2=0.365
cc_818 ( N_noxref_4_c_842_n N_noxref_13_M4_noxref_s ) capacitor c=7.05604e-19 \
 //x=9.25 //y=4.07 //x2=7.22 //y2=0.365
cc_819 ( N_noxref_4_c_845_n N_noxref_13_M4_noxref_s ) capacitor c=0.0090031f \
 //x=8.805 //y=1.225 //x2=7.22 //y2=0.365
cc_820 ( N_noxref_4_c_771_n N_noxref_13_M4_noxref_s ) capacitor c=0.0219823f \
 //x=8.645 //y=1.225 //x2=7.22 //y2=0.365
cc_821 ( N_noxref_4_M5_noxref_d N_noxref_13_M4_noxref_s ) capacitor \
 c=0.0431094f //x=8.62 //y=0.905 //x2=7.22 //y2=0.365
cc_822 ( N_noxref_5_c_1194_p N_noxref_6_c_1336_n ) capacitor c=4.7818e-19 \
 //x=1.585 //y=7.4 //x2=1.995 //y2=5.21
cc_823 ( N_noxref_5_c_1087_n N_noxref_6_c_1336_n ) capacitor c=0.00476295f \
 //x=1.67 //y=6.855 //x2=1.995 //y2=5.21
cc_824 ( N_noxref_5_c_1196_p N_noxref_6_c_1336_n ) capacitor c=5.97403e-19 \
 //x=2.465 //y=7.4 //x2=1.995 //y2=5.21
cc_825 ( N_noxref_5_c_1090_n N_noxref_6_c_1336_n ) capacitor c=0.00734586f \
 //x=3.16 //y=7.4 //x2=1.995 //y2=5.21
cc_826 ( N_noxref_5_M8_noxref_d N_noxref_6_c_1336_n ) capacitor c=0.00679741f \
 //x=1.525 //y=5.025 //x2=1.995 //y2=5.21
cc_827 ( N_noxref_5_c_1196_p N_noxref_6_c_1338_n ) capacitor c=5.51483e-19 \
 //x=2.465 //y=7.4 //x2=3.995 //y2=5.21
cc_828 ( N_noxref_5_c_1128_n N_noxref_6_c_1338_n ) capacitor c=0.00404817f \
 //x=2.55 //y=6.855 //x2=3.995 //y2=5.21
cc_829 ( N_noxref_5_c_1152_n N_noxref_6_c_1338_n ) capacitor c=0.0140048f \
 //x=11.47 //y=7.4 //x2=3.995 //y2=5.21
cc_830 ( N_noxref_5_c_1090_n N_noxref_6_c_1338_n ) capacitor c=0.007032f \
 //x=3.16 //y=7.4 //x2=3.995 //y2=5.21
cc_831 ( N_noxref_5_c_1098_n N_noxref_6_c_1338_n ) capacitor c=0.00273011f \
 //x=6.49 //y=7.4 //x2=3.995 //y2=5.21
cc_832 ( N_noxref_5_c_1101_n N_noxref_6_c_1338_n ) capacitor c=0.039327f \
 //x=3.33 //y=7.4 //x2=3.995 //y2=5.21
cc_833 ( N_noxref_5_M10_noxref_d N_noxref_6_c_1338_n ) capacitor c=0.0138307f \
 //x=2.405 //y=5.025 //x2=3.995 //y2=5.21
cc_834 ( N_noxref_5_c_1093_n N_noxref_6_c_1341_n ) capacitor c=2.89592e-19 \
 //x=0.74 //y=7.4 //x2=2.225 //y2=5.21
cc_835 ( N_noxref_5_c_1101_n N_noxref_6_c_1341_n ) capacitor c=3.35418e-19 \
 //x=3.33 //y=7.4 //x2=2.225 //y2=5.21
cc_836 ( N_noxref_5_M10_noxref_d N_noxref_6_c_1341_n ) capacitor c=6.02701e-19 \
 //x=2.405 //y=5.025 //x2=2.225 //y2=5.21
cc_837 ( N_noxref_5_c_1178_n N_noxref_6_c_1342_n ) capacitor c=0.00223213f \
 //x=11.47 //y=7.4 //x2=4.87 //y2=6.91
cc_838 ( N_noxref_5_c_1178_n N_noxref_6_c_1364_n ) capacitor c=0.00223213f \
 //x=11.47 //y=7.4 //x2=5.755 //y2=6.91
cc_839 ( N_noxref_5_M7_noxref_s N_noxref_6_c_1348_n ) capacitor c=0.0567031f \
 //x=0.655 //y=5.025 //x2=1.232 //y2=5.21
cc_840 ( N_noxref_5_c_1128_n N_noxref_6_c_1352_n ) capacitor c=0.00979658f \
 //x=2.55 //y=6.855 //x2=4.11 //y2=6.74
cc_841 ( N_noxref_5_c_1129_n N_noxref_6_c_1352_n ) capacitor c=0.00197255f \
 //x=2.55 //y=7.23 //x2=4.11 //y2=6.74
cc_842 ( N_noxref_5_c_1152_n N_noxref_6_c_1352_n ) capacitor c=0.171882f \
 //x=11.47 //y=7.4 //x2=4.11 //y2=6.74
cc_843 ( N_noxref_5_c_1098_n N_noxref_6_c_1352_n ) capacitor c=0.0401205f \
 //x=6.49 //y=7.4 //x2=4.11 //y2=6.74
cc_844 ( N_noxref_5_c_1101_n N_noxref_6_c_1352_n ) capacitor c=0.00739076f \
 //x=3.33 //y=7.4 //x2=4.11 //y2=6.74
cc_845 ( N_noxref_5_c_1178_n N_noxref_6_c_1352_n ) capacitor c=0.00112916f \
 //x=11.47 //y=7.4 //x2=4.11 //y2=6.74
cc_846 ( N_noxref_5_c_1178_n N_noxref_6_c_1353_n ) capacitor c=0.00112693f \
 //x=11.47 //y=7.4 //x2=4.987 //y2=6.91
cc_847 ( N_noxref_5_c_1152_n N_noxref_6_c_1367_n ) capacitor c=0.00214414f \
 //x=11.47 //y=7.4 //x2=5.87 //y2=6.74
cc_848 ( N_noxref_5_c_1098_n N_noxref_6_c_1367_n ) capacitor c=4.35496e-19 \
 //x=6.49 //y=7.4 //x2=5.87 //y2=6.74
cc_849 ( N_noxref_5_c_1107_n N_noxref_6_c_1367_n ) capacitor c=0.00733935f \
 //x=6.66 //y=7.4 //x2=5.87 //y2=6.74
cc_850 ( N_noxref_5_c_1178_n N_noxref_6_c_1367_n ) capacitor c=0.00112693f \
 //x=11.47 //y=7.4 //x2=5.87 //y2=6.74
cc_851 ( N_noxref_5_c_1085_n N_noxref_6_c_1354_n ) capacitor c=0.0041288f \
 //x=0.79 //y=6.855 //x2=1.23 //y2=5.38
cc_852 ( N_noxref_5_c_1086_n N_noxref_6_c_1354_n ) capacitor c=0.00145923f \
 //x=0.79 //y=7.23 //x2=1.23 //y2=5.38
cc_853 ( N_noxref_5_c_1194_p N_noxref_6_c_1354_n ) capacitor c=0.00233781f \
 //x=1.585 //y=7.4 //x2=1.23 //y2=5.38
cc_854 ( N_noxref_5_c_1087_n N_noxref_6_c_1354_n ) capacitor c=0.00220869f \
 //x=1.67 //y=6.855 //x2=1.23 //y2=5.38
cc_855 ( N_noxref_5_c_1088_n N_noxref_6_c_1354_n ) capacitor c=0.00130452f \
 //x=1.67 //y=7.23 //x2=1.23 //y2=5.38
cc_856 ( N_noxref_5_c_1090_n N_noxref_6_c_1354_n ) capacitor c=0.0112796f \
 //x=3.16 //y=7.4 //x2=1.23 //y2=5.38
cc_857 ( N_noxref_5_c_1093_n N_noxref_6_c_1354_n ) capacitor c=0.00724623f \
 //x=0.74 //y=7.4 //x2=1.23 //y2=5.38
cc_858 ( N_noxref_5_c_1178_n N_noxref_6_c_1354_n ) capacitor c=0.00141431f \
 //x=11.47 //y=7.4 //x2=1.23 //y2=5.38
cc_859 ( N_noxref_5_M7_noxref_s N_noxref_6_c_1354_n ) capacitor c=0.0916487f \
 //x=0.655 //y=5.025 //x2=1.23 //y2=5.38
cc_860 ( N_noxref_5_M8_noxref_d N_noxref_6_c_1354_n ) capacitor c=0.0724825f \
 //x=1.525 //y=5.025 //x2=1.23 //y2=5.38
cc_861 ( N_noxref_5_c_1087_n N_noxref_6_c_1357_n ) capacitor c=0.00230229f \
 //x=1.67 //y=6.855 //x2=2.11 //y2=5.21
cc_862 ( N_noxref_5_c_1088_n N_noxref_6_c_1357_n ) capacitor c=0.00130452f \
 //x=1.67 //y=7.23 //x2=2.11 //y2=5.21
cc_863 ( N_noxref_5_c_1196_p N_noxref_6_c_1357_n ) capacitor c=0.00233634f \
 //x=2.465 //y=7.4 //x2=2.11 //y2=5.21
cc_864 ( N_noxref_5_c_1128_n N_noxref_6_c_1357_n ) capacitor c=0.00225444f \
 //x=2.55 //y=6.855 //x2=2.11 //y2=5.21
cc_865 ( N_noxref_5_c_1129_n N_noxref_6_c_1357_n ) capacitor c=0.00130452f \
 //x=2.55 //y=7.23 //x2=2.11 //y2=5.21
cc_866 ( N_noxref_5_c_1090_n N_noxref_6_c_1357_n ) capacitor c=0.0112689f \
 //x=3.16 //y=7.4 //x2=2.11 //y2=5.21
cc_867 ( N_noxref_5_c_1093_n N_noxref_6_c_1357_n ) capacitor c=0.00105746f \
 //x=0.74 //y=7.4 //x2=2.11 //y2=5.21
cc_868 ( N_noxref_5_c_1101_n N_noxref_6_c_1357_n ) capacitor c=0.00924237f \
 //x=3.33 //y=7.4 //x2=2.11 //y2=5.21
cc_869 ( N_noxref_5_c_1178_n N_noxref_6_c_1357_n ) capacitor c=0.00141642f \
 //x=11.47 //y=7.4 //x2=2.11 //y2=5.21
cc_870 ( N_noxref_5_M7_noxref_s N_noxref_6_c_1357_n ) capacitor c=0.00151756f \
 //x=0.655 //y=5.025 //x2=2.11 //y2=5.21
cc_871 ( N_noxref_5_M8_noxref_d N_noxref_6_c_1357_n ) capacitor c=0.0724825f \
 //x=1.525 //y=5.025 //x2=2.11 //y2=5.21
cc_872 ( N_noxref_5_M10_noxref_d N_noxref_6_c_1357_n ) capacitor c=0.0886704f \
 //x=2.405 //y=5.025 //x2=2.11 //y2=5.21
cc_873 ( N_noxref_5_c_1152_n N_noxref_6_c_1358_n ) capacitor c=0.00205002f \
 //x=11.47 //y=7.4 //x2=4.11 //y2=5.21
cc_874 ( N_noxref_5_c_1098_n N_noxref_6_c_1358_n ) capacitor c=0.00854973f \
 //x=6.49 //y=7.4 //x2=4.11 //y2=5.21
cc_875 ( N_noxref_5_c_1101_n N_noxref_6_c_1358_n ) capacitor c=0.0602194f \
 //x=3.33 //y=7.4 //x2=4.11 //y2=5.21
cc_876 ( N_noxref_5_c_1107_n N_noxref_6_c_1358_n ) capacitor c=6.42159e-19 \
 //x=6.66 //y=7.4 //x2=4.11 //y2=5.21
cc_877 ( N_noxref_5_c_1178_n N_noxref_6_c_1358_n ) capacitor c=0.00100974f \
 //x=11.47 //y=7.4 //x2=4.11 //y2=5.21
cc_878 ( N_noxref_5_M10_noxref_d N_noxref_6_c_1358_n ) capacitor c=0.00230512f \
 //x=2.405 //y=5.025 //x2=4.11 //y2=5.21
cc_879 ( N_noxref_5_c_1085_n N_noxref_6_M7_noxref_d ) capacitor c=0.0391448f \
 //x=0.79 //y=6.855 //x2=1.085 //y2=5.025
cc_880 ( N_noxref_5_c_1086_n N_noxref_6_M7_noxref_d ) capacitor c=0.00985747f \
 //x=0.79 //y=7.23 //x2=1.085 //y2=5.025
cc_881 ( N_noxref_5_c_1194_p N_noxref_6_M7_noxref_d ) capacitor c=0.023854f \
 //x=1.585 //y=7.4 //x2=1.085 //y2=5.025
cc_882 ( N_noxref_5_c_1087_n N_noxref_6_M7_noxref_d ) capacitor c=0.0380657f \
 //x=1.67 //y=6.855 //x2=1.085 //y2=5.025
cc_883 ( N_noxref_5_c_1088_n N_noxref_6_M7_noxref_d ) capacitor c=0.0100015f \
 //x=1.67 //y=7.23 //x2=1.085 //y2=5.025
cc_884 ( N_noxref_5_c_1090_n N_noxref_6_M7_noxref_d ) capacitor c=0.00302852f \
 //x=3.16 //y=7.4 //x2=1.085 //y2=5.025
cc_885 ( N_noxref_5_c_1178_n N_noxref_6_M7_noxref_d ) capacitor c=0.00112916f \
 //x=11.47 //y=7.4 //x2=1.085 //y2=5.025
cc_886 ( N_noxref_5_M7_noxref_s N_noxref_6_M7_noxref_d ) capacitor \
 c=0.00271779f //x=0.655 //y=5.025 //x2=1.085 //y2=5.025
cc_887 ( N_noxref_5_M8_noxref_d N_noxref_6_M7_noxref_d ) capacitor \
 c=0.00360728f //x=1.525 //y=5.025 //x2=1.085 //y2=5.025
cc_888 ( N_noxref_5_c_1087_n N_noxref_6_M9_noxref_d ) capacitor c=0.0379915f \
 //x=1.67 //y=6.855 //x2=1.965 //y2=5.025
cc_889 ( N_noxref_5_c_1088_n N_noxref_6_M9_noxref_d ) capacitor c=0.0100015f \
 //x=1.67 //y=7.23 //x2=1.965 //y2=5.025
cc_890 ( N_noxref_5_c_1196_p N_noxref_6_M9_noxref_d ) capacitor c=0.0230314f \
 //x=2.465 //y=7.4 //x2=1.965 //y2=5.025
cc_891 ( N_noxref_5_c_1128_n N_noxref_6_M9_noxref_d ) capacitor c=0.0379915f \
 //x=2.55 //y=6.855 //x2=1.965 //y2=5.025
cc_892 ( N_noxref_5_c_1129_n N_noxref_6_M9_noxref_d ) capacitor c=0.0100015f \
 //x=2.55 //y=7.23 //x2=1.965 //y2=5.025
cc_893 ( N_noxref_5_c_1090_n N_noxref_6_M9_noxref_d ) capacitor c=0.00283476f \
 //x=3.16 //y=7.4 //x2=1.965 //y2=5.025
cc_894 ( N_noxref_5_c_1178_n N_noxref_6_M9_noxref_d ) capacitor c=0.00112916f \
 //x=11.47 //y=7.4 //x2=1.965 //y2=5.025
cc_895 ( N_noxref_5_M8_noxref_d N_noxref_6_M9_noxref_d ) capacitor \
 c=0.00351276f //x=1.525 //y=5.025 //x2=1.965 //y2=5.025
cc_896 ( N_noxref_5_M10_noxref_d N_noxref_6_M9_noxref_d ) capacitor \
 c=0.00355849f //x=2.405 //y=5.025 //x2=1.965 //y2=5.025
cc_897 ( N_noxref_5_c_1152_n N_noxref_6_M12_noxref_d ) capacitor c=0.00206634f \
 //x=11.47 //y=7.4 //x2=4.845 //y2=5.025
cc_898 ( N_noxref_5_c_1098_n N_noxref_6_M12_noxref_d ) capacitor c=0.00858175f \
 //x=6.49 //y=7.4 //x2=4.845 //y2=5.025
cc_899 ( N_noxref_5_c_1178_n N_noxref_6_M12_noxref_d ) capacitor c=0.00100487f \
 //x=11.47 //y=7.4 //x2=4.845 //y2=5.025
cc_900 ( N_noxref_5_c_1152_n N_noxref_6_M14_noxref_d ) capacitor c=0.00206634f \
 //x=11.47 //y=7.4 //x2=5.725 //y2=5.025
cc_901 ( N_noxref_5_c_1098_n N_noxref_6_M14_noxref_d ) capacitor c=0.00858175f \
 //x=6.49 //y=7.4 //x2=5.725 //y2=5.025
cc_902 ( N_noxref_5_c_1107_n N_noxref_6_M14_noxref_d ) capacitor c=0.0448255f \
 //x=6.66 //y=7.4 //x2=5.725 //y2=5.025
cc_903 ( N_noxref_5_c_1178_n N_noxref_6_M14_noxref_d ) capacitor c=0.00100487f \
 //x=11.47 //y=7.4 //x2=5.725 //y2=5.025
cc_904 ( N_noxref_5_c_1152_n N_noxref_7_c_1515_n ) capacitor c=0.0143454f \
 //x=11.47 //y=7.4 //x2=7.335 //y2=5.21
cc_905 ( N_noxref_5_c_1098_n N_noxref_7_c_1515_n ) capacitor c=0.00397871f \
 //x=6.49 //y=7.4 //x2=7.335 //y2=5.21
cc_906 ( N_noxref_5_c_1116_n N_noxref_7_c_1515_n ) capacitor c=0.00275709f \
 //x=9.82 //y=7.4 //x2=7.335 //y2=5.21
cc_907 ( N_noxref_5_c_1107_n N_noxref_7_c_1515_n ) capacitor c=0.042287f \
 //x=6.66 //y=7.4 //x2=7.335 //y2=5.21
cc_908 ( N_noxref_5_c_1107_n N_noxref_7_c_1525_n ) capacitor c=6.67754e-19 \
 //x=6.66 //y=7.4 //x2=5.545 //y2=5.21
cc_909 ( N_noxref_5_c_1178_n N_noxref_7_c_1527_n ) capacitor c=0.00223213f \
 //x=11.47 //y=7.4 //x2=8.215 //y2=6.91
cc_910 ( N_noxref_5_c_1178_n N_noxref_7_c_1541_n ) capacitor c=0.00223213f \
 //x=11.47 //y=7.4 //x2=9.08 //y2=6.91
cc_911 ( N_noxref_5_c_1107_n N_noxref_7_c_1503_n ) capacitor c=0.00108821f \
 //x=6.66 //y=7.4 //x2=4.55 //y2=5.21
cc_912 ( N_noxref_5_M7_noxref_s N_noxref_7_c_1503_n ) capacitor c=4.98377e-19 \
 //x=0.655 //y=5.025 //x2=4.55 //y2=5.21
cc_913 ( N_noxref_5_c_1107_n N_noxref_7_c_1529_n ) capacitor c=0.00456697f \
 //x=6.66 //y=7.4 //x2=5.43 //y2=5.21
cc_914 ( N_noxref_5_c_1152_n N_noxref_7_c_1532_n ) capacitor c=0.172031f \
 //x=11.47 //y=7.4 //x2=7.45 //y2=6.74
cc_915 ( N_noxref_5_c_1116_n N_noxref_7_c_1532_n ) capacitor c=0.0392254f \
 //x=9.82 //y=7.4 //x2=7.45 //y2=6.74
cc_916 ( N_noxref_5_c_1107_n N_noxref_7_c_1532_n ) capacitor c=0.00730382f \
 //x=6.66 //y=7.4 //x2=7.45 //y2=6.74
cc_917 ( N_noxref_5_c_1178_n N_noxref_7_c_1532_n ) capacitor c=0.00112916f \
 //x=11.47 //y=7.4 //x2=7.45 //y2=6.74
cc_918 ( N_noxref_5_c_1178_n N_noxref_7_c_1533_n ) capacitor c=0.00112693f \
 //x=11.47 //y=7.4 //x2=8.33 //y2=6.91
cc_919 ( N_noxref_5_c_1152_n N_noxref_7_c_1546_n ) capacitor c=0.00215013f \
 //x=11.47 //y=7.4 //x2=9.21 //y2=6.74
cc_920 ( N_noxref_5_c_1116_n N_noxref_7_c_1546_n ) capacitor c=4.60635e-19 \
 //x=9.82 //y=7.4 //x2=9.21 //y2=6.74
cc_921 ( N_noxref_5_c_1147_n N_noxref_7_c_1546_n ) capacitor c=0.0114263f \
 //x=9.99 //y=7.4 //x2=9.21 //y2=6.74
cc_922 ( N_noxref_5_c_1178_n N_noxref_7_c_1546_n ) capacitor c=0.00112732f \
 //x=11.47 //y=7.4 //x2=9.21 //y2=6.74
cc_923 ( N_noxref_5_c_1098_n N_noxref_7_c_1509_n ) capacitor c=0.00474713f \
 //x=6.49 //y=7.4 //x2=4.55 //y2=5.38
cc_924 ( N_noxref_5_c_1101_n N_noxref_7_c_1509_n ) capacitor c=0.00539528f \
 //x=3.33 //y=7.4 //x2=4.55 //y2=5.38
cc_925 ( N_noxref_5_c_1107_n N_noxref_7_c_1509_n ) capacitor c=0.00106566f \
 //x=6.66 //y=7.4 //x2=4.55 //y2=5.38
cc_926 ( N_noxref_5_c_1178_n N_noxref_7_c_1509_n ) capacitor c=2.32853e-19 \
 //x=11.47 //y=7.4 //x2=4.55 //y2=5.38
cc_927 ( N_noxref_5_c_1152_n N_noxref_7_c_1534_n ) capacitor c=0.00205002f \
 //x=11.47 //y=7.4 //x2=7.45 //y2=5.21
cc_928 ( N_noxref_5_c_1116_n N_noxref_7_c_1534_n ) capacitor c=0.00854973f \
 //x=9.82 //y=7.4 //x2=7.45 //y2=5.21
cc_929 ( N_noxref_5_c_1107_n N_noxref_7_c_1534_n ) capacitor c=0.0592438f \
 //x=6.66 //y=7.4 //x2=7.45 //y2=5.21
cc_930 ( N_noxref_5_c_1147_n N_noxref_7_c_1534_n ) capacitor c=0.00100394f \
 //x=9.99 //y=7.4 //x2=7.45 //y2=5.21
cc_931 ( N_noxref_5_c_1178_n N_noxref_7_c_1534_n ) capacitor c=0.00100974f \
 //x=11.47 //y=7.4 //x2=7.45 //y2=5.21
cc_932 ( N_noxref_5_c_1152_n N_noxref_7_M16_noxref_d ) capacitor c=0.00206634f \
 //x=11.47 //y=7.4 //x2=8.185 //y2=5.025
cc_933 ( N_noxref_5_c_1116_n N_noxref_7_M16_noxref_d ) capacitor c=0.00858175f \
 //x=9.82 //y=7.4 //x2=8.185 //y2=5.025
cc_934 ( N_noxref_5_c_1178_n N_noxref_7_M16_noxref_d ) capacitor c=0.00100487f \
 //x=11.47 //y=7.4 //x2=8.185 //y2=5.025
cc_935 ( N_noxref_5_c_1152_n N_noxref_7_M18_noxref_d ) capacitor c=0.00206634f \
 //x=11.47 //y=7.4 //x2=9.065 //y2=5.025
cc_936 ( N_noxref_5_c_1116_n N_noxref_7_M18_noxref_d ) capacitor c=0.00858175f \
 //x=9.82 //y=7.4 //x2=9.065 //y2=5.025
cc_937 ( N_noxref_5_c_1147_n N_noxref_7_M18_noxref_d ) capacitor c=0.0443649f \
 //x=9.99 //y=7.4 //x2=9.065 //y2=5.025
cc_938 ( N_noxref_5_c_1178_n N_noxref_7_M18_noxref_d ) capacitor c=0.00100487f \
 //x=11.47 //y=7.4 //x2=9.065 //y2=5.025
cc_939 ( N_noxref_5_M19_noxref_s N_noxref_7_M18_noxref_d ) capacitor \
 c=0.00249451f //x=10.53 //y=5.02 //x2=9.065 //y2=5.025
cc_940 ( N_noxref_5_c_1093_n N_noxref_8_c_1658_n ) capacitor c=0.00989031f \
 //x=0.74 //y=7.4 //x2=0.74 //y2=0
cc_941 ( N_noxref_5_c_1101_n N_noxref_8_c_1665_n ) capacitor c=0.00654903f \
 //x=3.33 //y=7.4 //x2=3.33 //y2=0
cc_942 ( N_noxref_5_c_1107_n N_noxref_8_c_1696_n ) capacitor c=0.00684113f \
 //x=6.66 //y=7.4 //x2=6.66 //y2=0
cc_943 ( N_noxref_5_c_1147_n N_noxref_8_c_1706_n ) capacitor c=0.00654903f \
 //x=9.99 //y=7.4 //x2=9.99 //y2=0
cc_944 ( N_noxref_5_c_1178_n N_noxref_8_c_1778_n ) capacitor c=0.00989031f \
 //x=11.47 //y=7.4 //x2=11.59 //y2=0
cc_945 ( N_noxref_5_c_1152_n N_noxref_9_c_1906_n ) capacitor c=0.00259275f \
 //x=11.47 //y=7.4 //x2=11.105 //y2=5.24
cc_946 ( N_noxref_5_c_1161_n N_noxref_9_c_1906_n ) capacitor c=0.0010065f \
 //x=11.46 //y=7.4 //x2=11.105 //y2=5.24
cc_947 ( N_noxref_5_c_1178_n N_noxref_9_c_1906_n ) capacitor c=0.00295945f \
 //x=11.47 //y=7.4 //x2=11.105 //y2=5.24
cc_948 ( N_noxref_5_M19_noxref_s N_noxref_9_c_1906_n ) capacitor c=0.0465774f \
 //x=10.53 //y=5.02 //x2=11.105 //y2=5.24
cc_949 ( N_noxref_5_M20_noxref_d N_noxref_9_c_1906_n ) capacitor c=0.0486749f \
 //x=11.4 //y=5.02 //x2=11.105 //y2=5.24
cc_950 ( N_noxref_5_c_1152_n N_noxref_9_c_1913_n ) capacitor c=0.00199455f \
 //x=11.47 //y=7.4 //x2=11.385 //y2=4.96
cc_951 ( N_noxref_5_c_1161_n N_noxref_9_c_1913_n ) capacitor c=0.00207359f \
 //x=11.46 //y=7.4 //x2=11.385 //y2=4.96
cc_952 ( N_noxref_5_M20_noxref_d N_noxref_9_c_1913_n ) capacitor c=0.0235605f \
 //x=11.4 //y=5.02 //x2=11.385 //y2=4.96
cc_953 ( N_noxref_5_c_1147_n N_noxref_9_c_1914_n ) capacitor c=0.00484013f \
 //x=9.99 //y=7.4 //x2=11.19 //y2=4.96
cc_954 ( N_noxref_5_c_1178_n N_noxref_9_c_1917_n ) capacitor c=0.0293824f \
 //x=11.47 //y=7.4 //x2=11.47 //y2=4.875
cc_955 ( N_noxref_5_c_1152_n N_noxref_9_c_1938_n ) capacitor c=0.0024144f \
 //x=11.47 //y=7.4 //x2=11.105 //y2=5.38
cc_956 ( N_noxref_5_c_1161_n N_noxref_9_c_1938_n ) capacitor c=0.0137788f \
 //x=11.46 //y=7.4 //x2=11.105 //y2=5.38
cc_957 ( N_noxref_5_c_1147_n N_noxref_9_c_1938_n ) capacitor c=0.00819514f \
 //x=9.99 //y=7.4 //x2=11.105 //y2=5.38
cc_958 ( N_noxref_5_c_1178_n N_noxref_9_c_1938_n ) capacitor c=0.00960934f \
 //x=11.47 //y=7.4 //x2=11.105 //y2=5.38
cc_959 ( N_noxref_5_M19_noxref_s N_noxref_9_c_1938_n ) capacitor c=0.0897898f \
 //x=10.53 //y=5.02 //x2=11.105 //y2=5.38
cc_960 ( N_noxref_5_M20_noxref_d N_noxref_9_c_1938_n ) capacitor c=0.0929254f \
 //x=11.4 //y=5.02 //x2=11.105 //y2=5.38
cc_961 ( N_noxref_5_c_1098_n noxref_11 ) capacitor c=0.00484882f //x=6.49 \
 //y=7.4 //x2=5.285 //y2=5.025
cc_962 ( N_noxref_5_c_1107_n noxref_11 ) capacitor c=0.00487712f //x=6.66 \
 //y=7.4 //x2=5.285 //y2=5.025
cc_963 ( N_noxref_5_c_1178_n noxref_11 ) capacitor c=2.31538e-19 //x=11.47 \
 //y=7.4 //x2=5.285 //y2=5.025
cc_964 ( N_noxref_6_c_1342_n N_noxref_7_c_1502_n ) capacitor c=0.00321697f \
 //x=4.87 //y=6.91 //x2=5.315 //y2=5.21
cc_965 ( N_noxref_6_c_1364_n N_noxref_7_c_1502_n ) capacitor c=0.00331901f \
 //x=5.755 //y=6.91 //x2=5.315 //y2=5.21
cc_966 ( N_noxref_6_c_1353_n N_noxref_7_c_1502_n ) capacitor c=0.0047685f \
 //x=4.987 //y=6.91 //x2=5.315 //y2=5.21
cc_967 ( N_noxref_6_M12_noxref_d N_noxref_7_c_1502_n ) capacitor c=0.00678641f \
 //x=4.845 //y=5.025 //x2=5.315 //y2=5.21
cc_968 ( N_noxref_6_c_1364_n N_noxref_7_c_1515_n ) capacitor c=0.00331901f \
 //x=5.755 //y=6.91 //x2=7.335 //y2=5.21
cc_969 ( N_noxref_6_c_1367_n N_noxref_7_c_1515_n ) capacitor c=0.00466077f \
 //x=5.87 //y=6.74 //x2=7.335 //y2=5.21
cc_970 ( N_noxref_6_M14_noxref_d N_noxref_7_c_1515_n ) capacitor c=0.00491419f \
 //x=5.725 //y=5.025 //x2=7.335 //y2=5.21
cc_971 ( N_noxref_6_c_1338_n N_noxref_7_c_1525_n ) capacitor c=9.81e-19 \
 //x=3.995 //y=5.21 //x2=5.545 //y2=5.21
cc_972 ( N_noxref_6_c_1364_n N_noxref_7_c_1525_n ) capacitor c=0.00439275f \
 //x=5.755 //y=6.91 //x2=5.545 //y2=5.21
cc_973 ( N_noxref_6_c_1338_n N_noxref_7_c_1503_n ) capacitor c=0.033638f \
 //x=3.995 //y=5.21 //x2=4.55 //y2=5.21
cc_974 ( N_noxref_6_c_1342_n N_noxref_7_c_1503_n ) capacitor c=0.0048075f \
 //x=4.87 //y=6.91 //x2=4.55 //y2=5.21
cc_975 ( N_noxref_6_c_1348_n N_noxref_7_c_1503_n ) capacitor c=0.00241473f \
 //x=1.232 //y=5.21 //x2=4.55 //y2=5.21
cc_976 ( N_noxref_6_c_1358_n N_noxref_7_c_1503_n ) capacitor c=0.0100239f \
 //x=4.11 //y=5.21 //x2=4.55 //y2=5.21
cc_977 ( N_noxref_6_c_1338_n N_noxref_7_c_1529_n ) capacitor c=5.61108e-19 \
 //x=3.995 //y=5.21 //x2=5.43 //y2=5.21
cc_978 ( N_noxref_6_c_1358_n N_noxref_7_c_1529_n ) capacitor c=0.00225426f \
 //x=4.11 //y=5.21 //x2=5.43 //y2=5.21
cc_979 ( N_noxref_6_c_1353_n N_noxref_7_c_1532_n ) capacitor c=2.01993e-19 \
 //x=4.987 //y=6.91 //x2=7.45 //y2=6.74
cc_980 ( N_noxref_6_c_1367_n N_noxref_7_c_1532_n ) capacitor c=0.0130503f \
 //x=5.87 //y=6.74 //x2=7.45 //y2=6.74
cc_981 ( N_noxref_6_c_1367_n N_noxref_7_c_1533_n ) capacitor c=2.01769e-19 \
 //x=5.87 //y=6.74 //x2=8.33 //y2=6.91
cc_982 ( N_noxref_6_c_1338_n N_noxref_7_c_1509_n ) capacitor c=0.00238961f \
 //x=3.995 //y=5.21 //x2=4.55 //y2=5.38
cc_983 ( N_noxref_6_c_1342_n N_noxref_7_c_1509_n ) capacitor c=0.00406191f \
 //x=4.87 //y=6.91 //x2=4.55 //y2=5.38
cc_984 ( N_noxref_6_c_1358_n N_noxref_7_c_1509_n ) capacitor c=0.0651197f \
 //x=4.11 //y=5.21 //x2=4.55 //y2=5.38
cc_985 ( N_noxref_6_M12_noxref_d N_noxref_7_c_1509_n ) capacitor c=0.0479141f \
 //x=4.845 //y=5.025 //x2=4.55 //y2=5.38
cc_986 ( N_noxref_6_M14_noxref_d N_noxref_7_c_1534_n ) capacitor c=0.00143256f \
 //x=5.725 //y=5.025 //x2=7.45 //y2=5.21
cc_987 ( N_noxref_6_c_1348_n N_noxref_8_c_1641_n ) capacitor c=0.0013323f \
 //x=1.232 //y=5.21 //x2=1.18 //y2=0.835
cc_988 ( N_noxref_6_c_1338_n N_noxref_8_c_1665_n ) capacitor c=0.00146425f \
 //x=3.995 //y=5.21 //x2=3.33 //y2=0
cc_989 ( N_noxref_6_c_1364_n noxref_11 ) capacitor c=0.00419873f //x=5.755 \
 //y=6.91 //x2=5.285 //y2=5.025
cc_990 ( N_noxref_6_M12_noxref_d noxref_11 ) capacitor c=0.0489565f //x=4.845 \
 //y=5.025 //x2=5.285 //y2=5.025
cc_991 ( N_noxref_6_M14_noxref_d noxref_11 ) capacitor c=0.0489382f //x=5.725 \
 //y=5.025 //x2=5.285 //y2=5.025
cc_992 ( N_noxref_6_c_1358_n N_noxref_12_c_2055_n ) capacitor c=0.00112302f \
 //x=4.11 //y=5.21 //x2=4.025 //y2=1.495
cc_993 ( N_noxref_7_c_1503_n N_noxref_8_c_1648_n ) capacitor c=2.10485e-19 \
 //x=4.55 //y=5.21 //x2=4.51 //y2=0.835
cc_994 ( N_noxref_7_c_1515_n N_noxref_8_c_1696_n ) capacitor c=0.00146425f \
 //x=7.335 //y=5.21 //x2=6.66 //y2=0
cc_995 ( N_noxref_7_c_1529_n noxref_11 ) capacitor c=0.0218948f //x=5.43 \
 //y=5.21 //x2=5.285 //y2=5.025
cc_996 ( N_noxref_7_c_1509_n noxref_11 ) capacitor c=0.00561178f //x=4.55 \
 //y=5.38 //x2=5.285 //y2=5.025
cc_997 ( N_noxref_8_c_1706_n N_noxref_9_c_1897_n ) capacitor c=0.00272952f \
 //x=9.99 //y=0 //x2=11.1 //y2=1.755
cc_998 ( N_noxref_8_c_1778_n N_noxref_9_c_1897_n ) capacitor c=0.00122336f \
 //x=11.59 //y=0 //x2=11.1 //y2=1.755
cc_999 ( N_noxref_8_M6_noxref_s N_noxref_9_c_1897_n ) capacitor c=0.0325498f \
 //x=10.485 //y=0.37 //x2=11.1 //y2=1.755
cc_1000 ( N_noxref_8_c_1714_n N_noxref_9_c_1910_n ) capacitor c=0.00496359f \
 //x=11.47 //y=0 //x2=11.385 //y2=1.84
cc_1001 ( N_noxref_8_c_1763_n N_noxref_9_c_1910_n ) capacitor c=0.00321677f \
 //x=11.505 //y=0.535 //x2=11.385 //y2=1.84
cc_1002 ( N_noxref_8_c_1778_n N_noxref_9_c_1910_n ) capacitor c=0.030726f \
 //x=11.59 //y=0 //x2=11.385 //y2=1.84
cc_1003 ( N_noxref_8_M6_noxref_s N_noxref_9_c_1910_n ) capacitor c=0.00565313f \
 //x=10.485 //y=0.37 //x2=11.385 //y2=1.84
cc_1004 ( N_noxref_8_c_1685_n N_noxref_9_c_1930_n ) capacitor c=0.00306788f \
 //x=7.84 //y=0.84 //x2=11.1 //y2=1.005
cc_1005 ( N_noxref_8_c_1714_n N_noxref_9_c_1930_n ) capacitor c=0.00996824f \
 //x=11.47 //y=0 //x2=11.1 //y2=1.005
cc_1006 ( N_noxref_8_c_1759_n N_noxref_9_c_1930_n ) capacitor c=0.00124697f \
 //x=11.015 //y=0.535 //x2=11.1 //y2=1.005
cc_1007 ( N_noxref_8_c_1763_n N_noxref_9_c_1930_n ) capacitor c=0.00130436f \
 //x=11.505 //y=0.535 //x2=11.1 //y2=1.005
cc_1008 ( N_noxref_8_c_1778_n N_noxref_9_c_1930_n ) capacitor c=2.8029e-19 \
 //x=11.59 //y=0 //x2=11.1 //y2=1.005
cc_1009 ( N_noxref_8_M6_noxref_s N_noxref_9_c_1930_n ) capacitor c=0.0161647f \
 //x=10.485 //y=0.37 //x2=11.1 //y2=1.005
cc_1010 ( N_noxref_8_c_1714_n N_noxref_9_M6_noxref_d ) capacitor c=0.00119583f \
 //x=11.47 //y=0 //x2=10.915 //y2=0.91
cc_1011 ( N_noxref_8_c_1778_n N_noxref_9_M6_noxref_d ) capacitor c=2.70835e-19 \
 //x=11.59 //y=0 //x2=10.915 //y2=0.91
cc_1012 ( N_noxref_8_M6_noxref_s N_noxref_9_M6_noxref_d ) capacitor \
 c=0.0377604f //x=10.485 //y=0.37 //x2=10.915 //y2=0.91
cc_1013 ( N_noxref_8_c_1639_n N_noxref_10_c_1983_n ) capacitor c=0.00260675f \
 //x=1.095 //y=0 //x2=1.58 //y2=1.58
cc_1014 ( N_noxref_8_c_1641_n N_noxref_10_c_1983_n ) capacitor c=0.00492403f \
 //x=1.18 //y=0.835 //x2=1.58 //y2=1.58
cc_1015 ( N_noxref_8_c_1713_n N_noxref_10_c_1983_n ) capacitor c=7.73914e-19 \
 //x=4.425 //y=0 //x2=1.58 //y2=1.58
cc_1016 ( N_noxref_8_c_1657_n N_noxref_10_c_1983_n ) capacitor c=0.00407949f \
 //x=3.16 //y=0 //x2=1.58 //y2=1.58
cc_1017 ( N_noxref_8_M0_noxref_d N_noxref_10_c_1983_n ) capacitor \
 c=0.00579662f //x=0.99 //y=0.865 //x2=1.58 //y2=1.58
cc_1018 ( N_noxref_8_c_1641_n N_noxref_10_c_2021_n ) capacitor c=0.0120153f \
 //x=1.18 //y=0.835 //x2=1.665 //y2=0.615
cc_1019 ( N_noxref_8_c_1713_n N_noxref_10_c_2021_n ) capacitor c=0.00644502f \
 //x=4.425 //y=0 //x2=1.665 //y2=0.615
cc_1020 ( N_noxref_8_c_1657_n N_noxref_10_c_2021_n ) capacitor c=0.0146227f \
 //x=3.16 //y=0 //x2=1.665 //y2=0.615
cc_1021 ( N_noxref_8_c_1658_n N_noxref_10_c_2021_n ) capacitor c=0.00283732f \
 //x=0.74 //y=0 //x2=1.665 //y2=0.615
cc_1022 ( N_noxref_8_c_1665_n N_noxref_10_c_2021_n ) capacitor c=2.99356e-19 \
 //x=3.33 //y=0 //x2=1.665 //y2=0.615
cc_1023 ( N_noxref_8_c_1778_n N_noxref_10_c_2021_n ) capacitor c=0.00145873f \
 //x=11.59 //y=0 //x2=1.665 //y2=0.615
cc_1024 ( N_noxref_8_c_1658_n N_noxref_10_c_1991_n ) capacitor c=2.91423e-19 \
 //x=0.74 //y=0 //x2=1.665 //y2=1.495
cc_1025 ( N_noxref_8_c_1713_n N_noxref_10_c_1999_n ) capacitor c=0.0109797f \
 //x=4.425 //y=0 //x2=2.55 //y2=0.53
cc_1026 ( N_noxref_8_c_1657_n N_noxref_10_c_1999_n ) capacitor c=0.0375067f \
 //x=3.16 //y=0 //x2=2.55 //y2=0.53
cc_1027 ( N_noxref_8_c_1778_n N_noxref_10_c_1999_n ) capacitor c=0.00199095f \
 //x=11.59 //y=0 //x2=2.55 //y2=0.53
cc_1028 ( N_noxref_8_c_1713_n N_noxref_10_c_2031_n ) capacitor c=0.00451005f \
 //x=4.425 //y=0 //x2=2.635 //y2=0.615
cc_1029 ( N_noxref_8_c_1657_n N_noxref_10_c_2031_n ) capacitor c=0.0144766f \
 //x=3.16 //y=0 //x2=2.635 //y2=0.615
cc_1030 ( N_noxref_8_c_1665_n N_noxref_10_c_2031_n ) capacitor c=0.0540895f \
 //x=3.33 //y=0 //x2=2.635 //y2=0.615
cc_1031 ( N_noxref_8_c_1778_n N_noxref_10_c_2031_n ) capacitor c=0.00145873f \
 //x=11.59 //y=0 //x2=2.635 //y2=0.615
cc_1032 ( N_noxref_8_c_1639_n N_noxref_10_M0_noxref_s ) capacitor \
 c=0.00281794f //x=1.095 //y=0 //x2=0.56 //y2=0.365
cc_1033 ( N_noxref_8_c_1641_n N_noxref_10_M0_noxref_s ) capacitor c=0.0302994f \
 //x=1.18 //y=0.835 //x2=0.56 //y2=0.365
cc_1034 ( N_noxref_8_c_1657_n N_noxref_10_M0_noxref_s ) capacitor c=0.0146339f \
 //x=3.16 //y=0 //x2=0.56 //y2=0.365
cc_1035 ( N_noxref_8_c_1658_n N_noxref_10_M0_noxref_s ) capacitor c=0.0568002f \
 //x=0.74 //y=0 //x2=0.56 //y2=0.365
cc_1036 ( N_noxref_8_c_1665_n N_noxref_10_M0_noxref_s ) capacitor \
 c=0.00250794f //x=3.33 //y=0 //x2=0.56 //y2=0.365
cc_1037 ( N_noxref_8_c_1778_n N_noxref_10_M0_noxref_s ) capacitor \
 c=0.00145873f //x=11.59 //y=0 //x2=0.56 //y2=0.365
cc_1038 ( N_noxref_8_M0_noxref_d N_noxref_10_M0_noxref_s ) capacitor \
 c=0.0271433f //x=0.99 //y=0.865 //x2=0.56 //y2=0.365
cc_1039 ( N_noxref_8_c_1713_n N_noxref_12_c_2056_n ) capacitor c=0.00100664f \
 //x=4.425 //y=0 //x2=4.91 //y2=1.58
cc_1040 ( N_noxref_8_c_1648_n N_noxref_12_c_2056_n ) capacitor c=0.00375843f \
 //x=4.51 //y=0.835 //x2=4.91 //y2=1.58
cc_1041 ( N_noxref_8_c_1682_n N_noxref_12_c_2056_n ) capacitor c=7.45312e-19 \
 //x=7.755 //y=0 //x2=4.91 //y2=1.58
cc_1042 ( N_noxref_8_c_1664_n N_noxref_12_c_2056_n ) capacitor c=0.00357827f \
 //x=6.49 //y=0 //x2=4.91 //y2=1.58
cc_1043 ( N_noxref_8_M2_noxref_d N_noxref_12_c_2056_n ) capacitor \
 c=0.00750663f //x=4.32 //y=0.865 //x2=4.91 //y2=1.58
cc_1044 ( N_noxref_8_c_1648_n N_noxref_12_c_2096_n ) capacitor c=0.0120153f \
 //x=4.51 //y=0.835 //x2=4.995 //y2=0.615
cc_1045 ( N_noxref_8_c_1682_n N_noxref_12_c_2096_n ) capacitor c=0.00451005f \
 //x=7.755 //y=0 //x2=4.995 //y2=0.615
cc_1046 ( N_noxref_8_c_1664_n N_noxref_12_c_2096_n ) capacitor c=0.0144766f \
 //x=6.49 //y=0 //x2=4.995 //y2=0.615
cc_1047 ( N_noxref_8_c_1665_n N_noxref_12_c_2096_n ) capacitor c=0.00226009f \
 //x=3.33 //y=0 //x2=4.995 //y2=0.615
cc_1048 ( N_noxref_8_c_1696_n N_noxref_12_c_2096_n ) capacitor c=2.99356e-19 \
 //x=6.66 //y=0 //x2=4.995 //y2=0.615
cc_1049 ( N_noxref_8_c_1778_n N_noxref_12_c_2096_n ) capacitor c=0.00145873f \
 //x=11.59 //y=0 //x2=4.995 //y2=0.615
cc_1050 ( N_noxref_8_c_1665_n N_noxref_12_c_2063_n ) capacitor c=2.91423e-19 \
 //x=3.33 //y=0 //x2=4.995 //y2=1.495
cc_1051 ( N_noxref_8_c_1682_n N_noxref_12_c_2068_n ) capacitor c=0.012271f \
 //x=7.755 //y=0 //x2=5.88 //y2=0.53
cc_1052 ( N_noxref_8_c_1664_n N_noxref_12_c_2068_n ) capacitor c=0.0374549f \
 //x=6.49 //y=0 //x2=5.88 //y2=0.53
cc_1053 ( N_noxref_8_c_1778_n N_noxref_12_c_2068_n ) capacitor c=0.00199095f \
 //x=11.59 //y=0 //x2=5.88 //y2=0.53
cc_1054 ( N_noxref_8_c_1682_n N_noxref_12_c_2106_n ) capacitor c=0.00251419f \
 //x=7.755 //y=0 //x2=5.965 //y2=0.615
cc_1055 ( N_noxref_8_c_1664_n N_noxref_12_c_2106_n ) capacitor c=0.0144766f \
 //x=6.49 //y=0 //x2=5.965 //y2=0.615
cc_1056 ( N_noxref_8_c_1696_n N_noxref_12_c_2106_n ) capacitor c=0.0528155f \
 //x=6.66 //y=0 //x2=5.965 //y2=0.615
cc_1057 ( N_noxref_8_c_1778_n N_noxref_12_c_2106_n ) capacitor c=0.00145873f \
 //x=11.59 //y=0 //x2=5.965 //y2=0.615
cc_1058 ( N_noxref_8_c_1713_n N_noxref_12_M2_noxref_s ) capacitor \
 c=0.00451005f //x=4.425 //y=0 //x2=3.89 //y2=0.365
cc_1059 ( N_noxref_8_c_1648_n N_noxref_12_M2_noxref_s ) capacitor c=0.0251079f \
 //x=4.51 //y=0.835 //x2=3.89 //y2=0.365
cc_1060 ( N_noxref_8_c_1664_n N_noxref_12_M2_noxref_s ) capacitor c=0.0144766f \
 //x=6.49 //y=0 //x2=3.89 //y2=0.365
cc_1061 ( N_noxref_8_c_1665_n N_noxref_12_M2_noxref_s ) capacitor c=0.0536459f \
 //x=3.33 //y=0 //x2=3.89 //y2=0.365
cc_1062 ( N_noxref_8_c_1696_n N_noxref_12_M2_noxref_s ) capacitor \
 c=0.00291802f //x=6.66 //y=0 //x2=3.89 //y2=0.365
cc_1063 ( N_noxref_8_c_1778_n N_noxref_12_M2_noxref_s ) capacitor \
 c=0.00145873f //x=11.59 //y=0 //x2=3.89 //y2=0.365
cc_1064 ( N_noxref_8_M2_noxref_d N_noxref_12_M2_noxref_s ) capacitor \
 c=0.0296569f //x=4.32 //y=0.865 //x2=3.89 //y2=0.365
cc_1065 ( N_noxref_8_c_1682_n N_noxref_13_c_2125_n ) capacitor c=9.52266e-19 \
 //x=7.755 //y=0 //x2=8.24 //y2=1.58
cc_1066 ( N_noxref_8_c_1685_n N_noxref_13_c_2125_n ) capacitor c=0.00481976f \
 //x=7.84 //y=0.84 //x2=8.24 //y2=1.58
cc_1067 ( N_noxref_8_c_1714_n N_noxref_13_c_2125_n ) capacitor c=0.00204395f \
 //x=11.47 //y=0 //x2=8.24 //y2=1.58
cc_1068 ( N_noxref_8_c_1693_n N_noxref_13_c_2125_n ) capacitor c=0.0035712f \
 //x=9.82 //y=0 //x2=8.24 //y2=1.58
cc_1069 ( N_noxref_8_M4_noxref_d N_noxref_13_c_2125_n ) capacitor \
 c=0.00579662f //x=7.65 //y=0.865 //x2=8.24 //y2=1.58
cc_1070 ( N_noxref_8_c_1685_n N_noxref_13_c_2169_n ) capacitor c=0.0167642f \
 //x=7.84 //y=0.84 //x2=8.325 //y2=0.615
cc_1071 ( N_noxref_8_c_1714_n N_noxref_13_c_2169_n ) capacitor c=0.00310367f \
 //x=11.47 //y=0 //x2=8.325 //y2=0.615
cc_1072 ( N_noxref_8_c_1693_n N_noxref_13_c_2169_n ) capacitor c=0.0144766f \
 //x=9.82 //y=0 //x2=8.325 //y2=0.615
cc_1073 ( N_noxref_8_c_1696_n N_noxref_13_c_2169_n ) capacitor c=0.00225073f \
 //x=6.66 //y=0 //x2=8.325 //y2=0.615
cc_1074 ( N_noxref_8_c_1706_n N_noxref_13_c_2169_n ) capacitor c=2.21767e-19 \
 //x=9.99 //y=0 //x2=8.325 //y2=0.615
cc_1075 ( N_noxref_8_c_1778_n N_noxref_13_c_2169_n ) capacitor c=0.00145873f \
 //x=11.59 //y=0 //x2=8.325 //y2=0.615
cc_1076 ( N_noxref_8_c_1696_n N_noxref_13_c_2132_n ) capacitor c=2.86225e-19 \
 //x=6.66 //y=0 //x2=8.325 //y2=1.495
cc_1077 ( N_noxref_8_c_1714_n N_noxref_13_c_2141_n ) capacitor c=0.00939019f \
 //x=11.47 //y=0 //x2=9.21 //y2=0.53
cc_1078 ( N_noxref_8_c_1693_n N_noxref_13_c_2141_n ) capacitor c=0.0374751f \
 //x=9.82 //y=0 //x2=9.21 //y2=0.53
cc_1079 ( N_noxref_8_c_1778_n N_noxref_13_c_2141_n ) capacitor c=0.00199095f \
 //x=11.59 //y=0 //x2=9.21 //y2=0.53
cc_1080 ( N_noxref_8_c_1714_n N_noxref_13_c_2179_n ) capacitor c=0.00326514f \
 //x=11.47 //y=0 //x2=9.295 //y2=0.615
cc_1081 ( N_noxref_8_c_1693_n N_noxref_13_c_2179_n ) capacitor c=0.0144628f \
 //x=9.82 //y=0 //x2=9.295 //y2=0.615
cc_1082 ( N_noxref_8_c_1886_p N_noxref_13_c_2179_n ) capacitor c=0.00211385f \
 //x=10.62 //y=0.45 //x2=9.295 //y2=0.615
cc_1083 ( N_noxref_8_c_1706_n N_noxref_13_c_2179_n ) capacitor c=0.0406122f \
 //x=9.99 //y=0 //x2=9.295 //y2=0.615
cc_1084 ( N_noxref_8_c_1778_n N_noxref_13_c_2179_n ) capacitor c=0.00145029f \
 //x=11.59 //y=0 //x2=9.295 //y2=0.615
cc_1085 ( N_noxref_8_c_1682_n N_noxref_13_M4_noxref_s ) capacitor \
 c=0.00251419f //x=7.755 //y=0 //x2=7.22 //y2=0.365
cc_1086 ( N_noxref_8_c_1685_n N_noxref_13_M4_noxref_s ) capacitor c=0.0250671f \
 //x=7.84 //y=0.84 //x2=7.22 //y2=0.365
cc_1087 ( N_noxref_8_c_1693_n N_noxref_13_M4_noxref_s ) capacitor c=0.0144766f \
 //x=9.82 //y=0 //x2=7.22 //y2=0.365
cc_1088 ( N_noxref_8_c_1696_n N_noxref_13_M4_noxref_s ) capacitor c=0.0528929f \
 //x=6.66 //y=0 //x2=7.22 //y2=0.365
cc_1089 ( N_noxref_8_c_1706_n N_noxref_13_M4_noxref_s ) capacitor \
 c=0.00580588f //x=9.99 //y=0 //x2=7.22 //y2=0.365
cc_1090 ( N_noxref_8_c_1778_n N_noxref_13_M4_noxref_s ) capacitor \
 c=0.00145873f //x=11.59 //y=0 //x2=7.22 //y2=0.365
cc_1091 ( N_noxref_8_M4_noxref_d N_noxref_13_M4_noxref_s ) capacitor \
 c=0.0272383f //x=7.65 //y=0.865 //x2=7.22 //y2=0.365
cc_1092 ( N_noxref_8_M6_noxref_s N_noxref_13_M4_noxref_s ) capacitor \
 c=0.00317066f //x=10.485 //y=0.37 //x2=7.22 //y2=0.365
cc_1093 ( N_noxref_10_M0_noxref_s N_noxref_12_c_2055_n ) capacitor \
 c=0.00220044f //x=0.56 //y=0.365 //x2=4.025 //y2=1.495
cc_1094 ( N_noxref_10_c_2031_n N_noxref_12_M2_noxref_s ) capacitor \
 c=0.00220044f //x=2.635 //y=0.615 //x2=3.89 //y2=0.365
cc_1095 ( N_noxref_12_M2_noxref_s N_noxref_13_c_2121_n ) capacitor \
 c=0.00244935f //x=3.89 //y=0.365 //x2=7.355 //y2=1.495
cc_1096 ( N_noxref_12_c_2106_n N_noxref_13_M4_noxref_s ) capacitor \
 c=0.00244935f //x=5.965 //y=0.615 //x2=7.22 //y2=0.365
